* G1_BGR standalone capacitance-PEX qualification
.lib /foss/pdks/ihp-sg13g2/libs.tech/ngspice/models/cornerHBT.lib hbt_typ
.lib /foss/pdks/ihp-sg13g2/libs.tech/ngspice/models/cornerMOShv.lib mos_tt
.lib /foss/pdks/ihp-sg13g2/libs.tech/ngspice/models/cornerRES.lib res_typ
.include conditional_metal.spice
.option seed=44001 gmin=1e-15 abstol=1e-14 reltol=1e-5 vntol=1e-7
.global sub!
Vsub sub! 0 0
Vdd vdd 0 3.3
Vr4 r4 0 0
Xbgr vdd 0 r4 vref iptat pbias pcasc vbe dvbe g1_bgr
Vload iptat 0 1
Cload vref 0 1e-12
.control
set num_threads=1
set numdgt=15
set wr_singlescale
set wr_vecnames
op
echo RAW_CURRENT_LEDGER_BEGIN
print @n.xbgr.xr1.nr1[ibody]
print @n.xbgr.xr2.nr1[ibody]
print @n.xbgr.xr3.nr1[ibody]
print @n.xbgr.xr4.nr1[ibody]
print @n.xbgr.xr5.nr1[ibody]
print @n.xbgr.xr6.nr1[ibody]
print @n.xbgr.xr7.nr1[ibody]
print @n.xbgr.xr8.nr1[ibody]
print @n.xbgr.xr9.nr1[ibody]
print @n.xbgr.xr10.nr1[ibody]
print @n.xbgr.xr11.nr1[ibody]
print @n.xbgr.xr12.nr1[ibody]
print @n.xbgr.xr13.nr1[ibody]
print @n.xbgr.xr14.nr1[ibody]
print @n.xbgr.xr15.nr1[ibody]
print @n.xbgr.xr16.nr1[ibody]
print @n.xbgr.xr17.nr1[ibody]
print @n.xbgr.xr18.nr1[ibody]
print @n.xbgr.xr19.nr1[ibody]
print @n.xbgr.xr20.nr1[ibody]
print @n.xbgr.xr21.nr1[ibody]
print @n.xbgr.xr22.nr1[ibody]
print @n.xbgr.xr23.nr1[ibody]
print @n.xbgr.xr24.nr1[ibody]
print @n.xbgr.xr25.nr1[ibody]
print @n.xbgr.xr26.nr1[ibody]
print @n.xbgr.xm27.nsg13_hv_pmos[ide]
print @n.xbgr.xm27.nsg13_hv_pmos[ige]
print @n.xbgr.xm27.nsg13_hv_pmos[ise]
print @n.xbgr.xm27.nsg13_hv_pmos[ibe]
print @n.xbgr.xm27.nsg13_hv_pmos[ctype]
print @n.xbgr.xm28.nsg13_hv_pmos[ide]
print @n.xbgr.xm28.nsg13_hv_pmos[ige]
print @n.xbgr.xm28.nsg13_hv_pmos[ise]
print @n.xbgr.xm28.nsg13_hv_pmos[ibe]
print @n.xbgr.xm28.nsg13_hv_pmos[ctype]
print @n.xbgr.xm29.nsg13_hv_nmos[ide]
print @n.xbgr.xm29.nsg13_hv_nmos[ige]
print @n.xbgr.xm29.nsg13_hv_nmos[ise]
print @n.xbgr.xm29.nsg13_hv_nmos[ibe]
print @n.xbgr.xm29.nsg13_hv_nmos[ctype]
print @n.xbgr.xm30.nsg13_hv_nmos[ide]
print @n.xbgr.xm30.nsg13_hv_nmos[ige]
print @n.xbgr.xm30.nsg13_hv_nmos[ise]
print @n.xbgr.xm30.nsg13_hv_nmos[ibe]
print @n.xbgr.xm30.nsg13_hv_nmos[ctype]
print @n.xbgr.xm31.nsg13_hv_nmos[ide]
print @n.xbgr.xm31.nsg13_hv_nmos[ige]
print @n.xbgr.xm31.nsg13_hv_nmos[ise]
print @n.xbgr.xm31.nsg13_hv_nmos[ibe]
print @n.xbgr.xm31.nsg13_hv_nmos[ctype]
print @n.xbgr.xm32.nsg13_hv_nmos[ide]
print @n.xbgr.xm32.nsg13_hv_nmos[ige]
print @n.xbgr.xm32.nsg13_hv_nmos[ise]
print @n.xbgr.xm32.nsg13_hv_nmos[ibe]
print @n.xbgr.xm32.nsg13_hv_nmos[ctype]
print @n.xbgr.xm33.nsg13_hv_nmos[ide]
print @n.xbgr.xm33.nsg13_hv_nmos[ige]
print @n.xbgr.xm33.nsg13_hv_nmos[ise]
print @n.xbgr.xm33.nsg13_hv_nmos[ibe]
print @n.xbgr.xm33.nsg13_hv_nmos[ctype]
print @n.xbgr.xm34.nsg13_hv_nmos[ide]
print @n.xbgr.xm34.nsg13_hv_nmos[ige]
print @n.xbgr.xm34.nsg13_hv_nmos[ise]
print @n.xbgr.xm34.nsg13_hv_nmos[ibe]
print @n.xbgr.xm34.nsg13_hv_nmos[ctype]
print @n.xbgr.xm35.nsg13_hv_nmos[ide]
print @n.xbgr.xm35.nsg13_hv_nmos[ige]
print @n.xbgr.xm35.nsg13_hv_nmos[ise]
print @n.xbgr.xm35.nsg13_hv_nmos[ibe]
print @n.xbgr.xm35.nsg13_hv_nmos[ctype]
print @n.xbgr.xm36.nsg13_hv_nmos[ide]
print @n.xbgr.xm36.nsg13_hv_nmos[ige]
print @n.xbgr.xm36.nsg13_hv_nmos[ise]
print @n.xbgr.xm36.nsg13_hv_nmos[ibe]
print @n.xbgr.xm36.nsg13_hv_nmos[ctype]
print @n.xbgr.xm37.nsg13_hv_nmos[ide]
print @n.xbgr.xm37.nsg13_hv_nmos[ige]
print @n.xbgr.xm37.nsg13_hv_nmos[ise]
print @n.xbgr.xm37.nsg13_hv_nmos[ibe]
print @n.xbgr.xm37.nsg13_hv_nmos[ctype]
print @n.xbgr.xm38.nsg13_hv_pmos[ide]
print @n.xbgr.xm38.nsg13_hv_pmos[ige]
print @n.xbgr.xm38.nsg13_hv_pmos[ise]
print @n.xbgr.xm38.nsg13_hv_pmos[ibe]
print @n.xbgr.xm38.nsg13_hv_pmos[ctype]
print @n.xbgr.xm39.nsg13_hv_pmos[ide]
print @n.xbgr.xm39.nsg13_hv_pmos[ige]
print @n.xbgr.xm39.nsg13_hv_pmos[ise]
print @n.xbgr.xm39.nsg13_hv_pmos[ibe]
print @n.xbgr.xm39.nsg13_hv_pmos[ctype]
print @n.xbgr.xm40.nsg13_hv_pmos[ide]
print @n.xbgr.xm40.nsg13_hv_pmos[ige]
print @n.xbgr.xm40.nsg13_hv_pmos[ise]
print @n.xbgr.xm40.nsg13_hv_pmos[ibe]
print @n.xbgr.xm40.nsg13_hv_pmos[ctype]
print @n.xbgr.xm41.nsg13_hv_pmos[ide]
print @n.xbgr.xm41.nsg13_hv_pmos[ige]
print @n.xbgr.xm41.nsg13_hv_pmos[ise]
print @n.xbgr.xm41.nsg13_hv_pmos[ibe]
print @n.xbgr.xm41.nsg13_hv_pmos[ctype]
print @n.xbgr.xm42.nsg13_hv_pmos[ide]
print @n.xbgr.xm42.nsg13_hv_pmos[ige]
print @n.xbgr.xm42.nsg13_hv_pmos[ise]
print @n.xbgr.xm42.nsg13_hv_pmos[ibe]
print @n.xbgr.xm42.nsg13_hv_pmos[ctype]
print @n.xbgr.xm43.nsg13_hv_pmos[ide]
print @n.xbgr.xm43.nsg13_hv_pmos[ige]
print @n.xbgr.xm43.nsg13_hv_pmos[ise]
print @n.xbgr.xm43.nsg13_hv_pmos[ibe]
print @n.xbgr.xm43.nsg13_hv_pmos[ctype]
print @n.xbgr.xm44.nsg13_hv_pmos[ide]
print @n.xbgr.xm44.nsg13_hv_pmos[ige]
print @n.xbgr.xm44.nsg13_hv_pmos[ise]
print @n.xbgr.xm44.nsg13_hv_pmos[ibe]
print @n.xbgr.xm44.nsg13_hv_pmos[ctype]
print @n.xbgr.xm45.nsg13_hv_pmos[ide]
print @n.xbgr.xm45.nsg13_hv_pmos[ige]
print @n.xbgr.xm45.nsg13_hv_pmos[ise]
print @n.xbgr.xm45.nsg13_hv_pmos[ibe]
print @n.xbgr.xm45.nsg13_hv_pmos[ctype]
print @n.xbgr.xm46.nsg13_hv_pmos[ide]
print @n.xbgr.xm46.nsg13_hv_pmos[ige]
print @n.xbgr.xm46.nsg13_hv_pmos[ise]
print @n.xbgr.xm46.nsg13_hv_pmos[ibe]
print @n.xbgr.xm46.nsg13_hv_pmos[ctype]
print @n.xbgr.xm47.nsg13_hv_pmos[ide]
print @n.xbgr.xm47.nsg13_hv_pmos[ige]
print @n.xbgr.xm47.nsg13_hv_pmos[ise]
print @n.xbgr.xm47.nsg13_hv_pmos[ibe]
print @n.xbgr.xm47.nsg13_hv_pmos[ctype]
print @n.xbgr.xm48.nsg13_hv_pmos[ide]
print @n.xbgr.xm48.nsg13_hv_pmos[ige]
print @n.xbgr.xm48.nsg13_hv_pmos[ise]
print @n.xbgr.xm48.nsg13_hv_pmos[ibe]
print @n.xbgr.xm48.nsg13_hv_pmos[ctype]
print @n.xbgr.xm49.nsg13_hv_pmos[ide]
print @n.xbgr.xm49.nsg13_hv_pmos[ige]
print @n.xbgr.xm49.nsg13_hv_pmos[ise]
print @n.xbgr.xm49.nsg13_hv_pmos[ibe]
print @n.xbgr.xm49.nsg13_hv_pmos[ctype]
print @n.xbgr.xm50.nsg13_hv_pmos[ide]
print @n.xbgr.xm50.nsg13_hv_pmos[ige]
print @n.xbgr.xm50.nsg13_hv_pmos[ise]
print @n.xbgr.xm50.nsg13_hv_pmos[ibe]
print @n.xbgr.xm50.nsg13_hv_pmos[ctype]
print @n.xbgr.xm51.nsg13_hv_pmos[ide]
print @n.xbgr.xm51.nsg13_hv_pmos[ige]
print @n.xbgr.xm51.nsg13_hv_pmos[ise]
print @n.xbgr.xm51.nsg13_hv_pmos[ibe]
print @n.xbgr.xm51.nsg13_hv_pmos[ctype]
print @n.xbgr.xm52.nsg13_hv_pmos[ide]
print @n.xbgr.xm52.nsg13_hv_pmos[ige]
print @n.xbgr.xm52.nsg13_hv_pmos[ise]
print @n.xbgr.xm52.nsg13_hv_pmos[ibe]
print @n.xbgr.xm52.nsg13_hv_pmos[ctype]
print @n.xbgr.xm53.nsg13_hv_pmos[ide]
print @n.xbgr.xm53.nsg13_hv_pmos[ige]
print @n.xbgr.xm53.nsg13_hv_pmos[ise]
print @n.xbgr.xm53.nsg13_hv_pmos[ibe]
print @n.xbgr.xm53.nsg13_hv_pmos[ctype]
print @n.xbgr.xm54.nsg13_hv_pmos[ide]
print @n.xbgr.xm54.nsg13_hv_pmos[ige]
print @n.xbgr.xm54.nsg13_hv_pmos[ise]
print @n.xbgr.xm54.nsg13_hv_pmos[ibe]
print @n.xbgr.xm54.nsg13_hv_pmos[ctype]
print @q.xbgr.xq55.qnpn13g2[ic]
print @q.xbgr.xq55.qnpn13g2[ib]
print @q.xbgr.xq55.qnpn13g2[ie]
print @q.xbgr.xq55.qnpn13g2[is]
print @r.xbgr.xq55.rsub[i]
print @c.xbgr.xq55.csub[i]
print @q.xbgr.xq56.qnpn13g2[ic]
print @q.xbgr.xq56.qnpn13g2[ib]
print @q.xbgr.xq56.qnpn13g2[ie]
print @q.xbgr.xq56.qnpn13g2[is]
print @r.xbgr.xq56.rsub[i]
print @c.xbgr.xq56.csub[i]
print @q.xbgr.xq57.qnpn13g2[ic]
print @q.xbgr.xq57.qnpn13g2[ib]
print @q.xbgr.xq57.qnpn13g2[ie]
print @q.xbgr.xq57.qnpn13g2[is]
print @r.xbgr.xq57.rsub[i]
print @c.xbgr.xq57.csub[i]
print @q.xbgr.xq58.qnpn13g2[ic]
print @q.xbgr.xq58.qnpn13g2[ib]
print @q.xbgr.xq58.qnpn13g2[ie]
print @q.xbgr.xq58.qnpn13g2[is]
print @r.xbgr.xq58.rsub[i]
print @c.xbgr.xq58.csub[i]
print @q.xbgr.xq59.qnpn13g2[ic]
print @q.xbgr.xq59.qnpn13g2[ib]
print @q.xbgr.xq59.qnpn13g2[ie]
print @q.xbgr.xq59.qnpn13g2[is]
print @r.xbgr.xq59.rsub[i]
print @c.xbgr.xq59.csub[i]
print @q.xbgr.xq60.qnpn13g2[ic]
print @q.xbgr.xq60.qnpn13g2[ib]
print @q.xbgr.xq60.qnpn13g2[ie]
print @q.xbgr.xq60.qnpn13g2[is]
print @r.xbgr.xq60.rsub[i]
print @c.xbgr.xq60.csub[i]
print @q.xbgr.xq61.qnpn13g2[ic]
print @q.xbgr.xq61.qnpn13g2[ib]
print @q.xbgr.xq61.qnpn13g2[ie]
print @q.xbgr.xq61.qnpn13g2[is]
print @r.xbgr.xq61.rsub[i]
print @c.xbgr.xq61.csub[i]
print @q.xbgr.xq62.qnpn13g2[ic]
print @q.xbgr.xq62.qnpn13g2[ib]
print @q.xbgr.xq62.qnpn13g2[ie]
print @q.xbgr.xq62.qnpn13g2[is]
print @r.xbgr.xq62.rsub[i]
print @c.xbgr.xq62.csub[i]
print @q.xbgr.xq63.qnpn13g2[ic]
print @q.xbgr.xq63.qnpn13g2[ib]
print @q.xbgr.xq63.qnpn13g2[ie]
print @q.xbgr.xq63.qnpn13g2[is]
print @r.xbgr.xq63.rsub[i]
print @c.xbgr.xq63.csub[i]
print @q.xbgr.xq64.qnpn13g2[ic]
print @q.xbgr.xq64.qnpn13g2[ib]
print @q.xbgr.xq64.qnpn13g2[ie]
print @q.xbgr.xq64.qnpn13g2[is]
print @r.xbgr.xq64.rsub[i]
print @c.xbgr.xq64.csub[i]
print @q.xbgr.xq65.qnpn13g2[ic]
print @q.xbgr.xq65.qnpn13g2[ib]
print @q.xbgr.xq65.qnpn13g2[ie]
print @q.xbgr.xq65.qnpn13g2[is]
print @r.xbgr.xq65.rsub[i]
print @c.xbgr.xq65.csub[i]
print @q.xbgr.xq66.qnpn13g2[ic]
print @q.xbgr.xq66.qnpn13g2[ib]
print @q.xbgr.xq66.qnpn13g2[ie]
print @q.xbgr.xq66.qnpn13g2[is]
print @r.xbgr.xq66.rsub[i]
print @c.xbgr.xq66.csub[i]
print @q.xbgr.xq67.qnpn13g2[ic]
print @q.xbgr.xq67.qnpn13g2[ib]
print @q.xbgr.xq67.qnpn13g2[ie]
print @q.xbgr.xq67.qnpn13g2[is]
print @r.xbgr.xq67.rsub[i]
print @c.xbgr.xq67.csub[i]
print @q.xbgr.xq68.qnpn13g2[ic]
print @q.xbgr.xq68.qnpn13g2[ib]
print @q.xbgr.xq68.qnpn13g2[ie]
print @q.xbgr.xq68.qnpn13g2[is]
print @r.xbgr.xq68.rsub[i]
print @c.xbgr.xq68.csub[i]
print @q.xbgr.xq69.qnpn13g2[ic]
print @q.xbgr.xq69.qnpn13g2[ib]
print @q.xbgr.xq69.qnpn13g2[ie]
print @q.xbgr.xq69.qnpn13g2[is]
print @r.xbgr.xq69.rsub[i]
print @c.xbgr.xq69.csub[i]
print @q.xbgr.xq70.qnpn13g2[ic]
print @q.xbgr.xq70.qnpn13g2[ib]
print @q.xbgr.xq70.qnpn13g2[ie]
print @q.xbgr.xq70.qnpn13g2[is]
print @r.xbgr.xq70.rsub[i]
print @c.xbgr.xq70.csub[i]
print @q.xbgr.xq71.qnpn13g2[ic]
print @q.xbgr.xq71.qnpn13g2[ib]
print @q.xbgr.xq71.qnpn13g2[ie]
print @q.xbgr.xq71.qnpn13g2[is]
print @r.xbgr.xq71.rsub[i]
print @c.xbgr.xq71.csub[i]
print @q.xbgr.xq72.qnpn13g2[ic]
print @q.xbgr.xq72.qnpn13g2[ib]
print @q.xbgr.xq72.qnpn13g2[ie]
print @q.xbgr.xq72.qnpn13g2[is]
print @r.xbgr.xq72.rsub[i]
print @c.xbgr.xq72.csub[i]
print @q.xbgr.xq73.qnpn13g2[ic]
print @q.xbgr.xq73.qnpn13g2[ib]
print @q.xbgr.xq73.qnpn13g2[ie]
print @q.xbgr.xq73.qnpn13g2[is]
print @r.xbgr.xq73.rsub[i]
print @c.xbgr.xq73.csub[i]
print @q.xbgr.xq74.qnpn13g2[ic]
print @q.xbgr.xq74.qnpn13g2[ib]
print @q.xbgr.xq74.qnpn13g2[ie]
print @q.xbgr.xq74.qnpn13g2[is]
print @r.xbgr.xq74.rsub[i]
print @c.xbgr.xq74.csub[i]
print @q.xbgr.xq75.qnpn13g2[ic]
print @q.xbgr.xq75.qnpn13g2[ib]
print @q.xbgr.xq75.qnpn13g2[ie]
print @q.xbgr.xq75.qnpn13g2[is]
print @r.xbgr.xq75.rsub[i]
print @c.xbgr.xq75.csub[i]
print @q.xbgr.xq76.qnpn13g2[ic]
print @q.xbgr.xq76.qnpn13g2[ib]
print @q.xbgr.xq76.qnpn13g2[ie]
print @q.xbgr.xq76.qnpn13g2[is]
print @r.xbgr.xq76.rsub[i]
print @c.xbgr.xq76.csub[i]
print @n.xbgr.xr77.nr1[ibody]
print @n.xbgr.xr78.nr1[ibody]
print @n.xbgr.xr79.nr1[ibody]
print @n.xbgr.xr80.nr1[ibody]
print @n.xbgr.xr81.nr1[ibody]
print @n.xbgr.xr82.nr1[ibody]
print @n.xbgr.xr83.nr1[ibody]
print @n.xbgr.xr84.nr1[ibody]
print @n.xbgr.xr85.nr1[ibody]
print @n.xbgr.xr86.nr1[ibody]
print @n.xbgr.xr16_u2.nr1[ibody]
print @n.xbgr.xr16_u3.nr1[ibody]
print @n.xbgr.xr16_u4.nr1[ibody]
print @n.xbgr.xr16_u5.nr1[ibody]
print @n.xbgr.xr16_u6.nr1[ibody]
print @n.xbgr.xr16_u7.nr1[ibody]
print @n.xbgr.xr16_u8.nr1[ibody]
print @n.xbgr.xr16_u9.nr1[ibody]
print @n.xbgr.xr16_u10.nr1[ibody]
print @n.xbgr.xr16_u11.nr1[ibody]
print @n.xbgr.xr16_u12.nr1[ibody]
print @n.xbgr.xr16_u13.nr1[ibody]
print @n.xbgr.xr16_u14.nr1[ibody]
print @n.xbgr.xr16_u15.nr1[ibody]
print @n.xbgr.xr16_u16.nr1[ibody]
print @n.xbgr.xr16_u17.nr1[ibody]
print @n.xbgr.xr16_u18.nr1[ibody]
print @n.xbgr.xr16_u19.nr1[ibody]
print @n.xbgr.xr16_u20.nr1[ibody]
print @n.xbgr.xr16_u21.nr1[ibody]
print @n.xbgr.xr16_u22.nr1[ibody]
print @n.xbgr.xr16_u23.nr1[ibody]
print @n.xbgr.xr16_u24.nr1[ibody]
print @n.xbgr.xr17_u2.nr1[ibody]
print @n.xbgr.xr17_u3.nr1[ibody]
print @n.xbgr.xr17_u4.nr1[ibody]
print @n.xbgr.xr18_u2.nr1[ibody]
print @n.xbgr.xr18_u3.nr1[ibody]
print @n.xbgr.xr18_u4.nr1[ibody]
print @n.xbgr.xr19_u2.nr1[ibody]
print @n.xbgr.xr19_u3.nr1[ibody]
print @n.xbgr.xr19_u4.nr1[ibody]
print @n.xbgr.xr20_u2.nr1[ibody]
print @n.xbgr.xr20_u3.nr1[ibody]
print @n.xbgr.xr20_u4.nr1[ibody]
print @n.xbgr.xr21_u2.nr1[ibody]
print @n.xbgr.xr21_u3.nr1[ibody]
print @n.xbgr.xr21_u4.nr1[ibody]
print @n.xbgr.xr22_u2.nr1[ibody]
print @n.xbgr.xr22_u3.nr1[ibody]
print @n.xbgr.xr22_u4.nr1[ibody]
print @n.xbgr.xr23_u2.nr1[ibody]
print @n.xbgr.xr23_u3.nr1[ibody]
print @n.xbgr.xr23_u4.nr1[ibody]
print @n.xbgr.xr23_u5.nr1[ibody]
print @n.xbgr.xr23_u6.nr1[ibody]
print @n.xbgr.xr23_u7.nr1[ibody]
print @n.xbgr.xr23_u8.nr1[ibody]
print @n.xbgr.xr23_u9.nr1[ibody]
print @n.xbgr.xr23_u10.nr1[ibody]
print @n.xbgr.xr23_u11.nr1[ibody]
print @n.xbgr.xr23_u12.nr1[ibody]
print @n.xbgr.xr23_u13.nr1[ibody]
print @n.xbgr.xr23_u14.nr1[ibody]
print @n.xbgr.xr23_u15.nr1[ibody]
print @n.xbgr.xr23_u16.nr1[ibody]
print @n.xbgr.xr23_u17.nr1[ibody]
print @n.xbgr.xr23_u18.nr1[ibody]
print @n.xbgr.xr23_u19.nr1[ibody]
print @n.xbgr.xr23_u20.nr1[ibody]
print @n.xbgr.xr23_u21.nr1[ibody]
print @n.xbgr.xr23_u22.nr1[ibody]
print @n.xbgr.xr23_u23.nr1[ibody]
print @n.xbgr.xr23_u24.nr1[ibody]
print @n.xbgr.xr24_u2.nr1[ibody]
print @n.xbgr.xr24_u3.nr1[ibody]
print @n.xbgr.xr24_u4.nr1[ibody]
print @n.xbgr.xr24_u5.nr1[ibody]
print @n.xbgr.xr24_u6.nr1[ibody]
print @n.xbgr.xr24_u7.nr1[ibody]
print @n.xbgr.xr24_u8.nr1[ibody]
print @n.xbgr.xr24_u9.nr1[ibody]
print @n.xbgr.xr24_u10.nr1[ibody]
print @n.xbgr.xr24_u11.nr1[ibody]
print @n.xbgr.xr24_u12.nr1[ibody]
print @n.xbgr.xr24_u13.nr1[ibody]
print @n.xbgr.xr24_u14.nr1[ibody]
print @n.xbgr.xr24_u15.nr1[ibody]
print @n.xbgr.xr24_u16.nr1[ibody]
print @n.xbgr.xr24_u17.nr1[ibody]
print @n.xbgr.xr24_u18.nr1[ibody]
print @n.xbgr.xr24_u19.nr1[ibody]
print @n.xbgr.xr24_u20.nr1[ibody]
print @n.xbgr.xr24_u21.nr1[ibody]
print @n.xbgr.xr24_u22.nr1[ibody]
print @n.xbgr.xr24_u23.nr1[ibody]
print @n.xbgr.xr24_u24.nr1[ibody]
print @n.xbgr.xr25_u2.nr1[ibody]
print @n.xbgr.xr25_u3.nr1[ibody]
print @n.xbgr.xr25_u4.nr1[ibody]
print @n.xbgr.xr25_u5.nr1[ibody]
print @n.xbgr.xr25_u6.nr1[ibody]
print @n.xbgr.xr25_u7.nr1[ibody]
print @n.xbgr.xr25_u8.nr1[ibody]
print @n.xbgr.xr25_u9.nr1[ibody]
print @n.xbgr.xr25_u10.nr1[ibody]
print @n.xbgr.xr25_u11.nr1[ibody]
print @n.xbgr.xr25_u12.nr1[ibody]
print @n.xbgr.xr25_u13.nr1[ibody]
print @n.xbgr.xr25_u14.nr1[ibody]
print @n.xbgr.xr25_u15.nr1[ibody]
print @n.xbgr.xr25_u16.nr1[ibody]
print @n.xbgr.xr25_u17.nr1[ibody]
print @n.xbgr.xr25_u18.nr1[ibody]
print @n.xbgr.xr25_u19.nr1[ibody]
print @n.xbgr.xr25_u20.nr1[ibody]
print @n.xbgr.xr25_u21.nr1[ibody]
print @n.xbgr.xr25_u22.nr1[ibody]
print @n.xbgr.xr25_u23.nr1[ibody]
print @n.xbgr.xr25_u24.nr1[ibody]
print @n.xbgr.xr26_u2.nr1[ibody]
print @n.xbgr.xr26_u3.nr1[ibody]
print @n.xbgr.xr26_u4.nr1[ibody]
print @n.xbgr.xr26_u5.nr1[ibody]
print @n.xbgr.xr26_u6.nr1[ibody]
print @n.xbgr.xr26_u7.nr1[ibody]
print @n.xbgr.xr26_u8.nr1[ibody]
print @n.xbgr.xr26_u9.nr1[ibody]
print @n.xbgr.xr26_u10.nr1[ibody]
print @n.xbgr.xr26_u11.nr1[ibody]
print @n.xbgr.xr26_u12.nr1[ibody]
print @n.xbgr.xr26_u13.nr1[ibody]
print @n.xbgr.xr26_u14.nr1[ibody]
print @n.xbgr.xr26_u15.nr1[ibody]
print @n.xbgr.xr26_u16.nr1[ibody]
print @n.xbgr.xr26_u17.nr1[ibody]
print @n.xbgr.xr26_u18.nr1[ibody]
print @n.xbgr.xr26_u19.nr1[ibody]
print @n.xbgr.xr26_u20.nr1[ibody]
print @n.xbgr.xr26_u21.nr1[ibody]
print @n.xbgr.xr26_u22.nr1[ibody]
print @n.xbgr.xr26_u23.nr1[ibody]
print @n.xbgr.xr26_u24.nr1[ibody]
print @n.xbgr.xm34_u2.nsg13_hv_nmos[ide]
print @n.xbgr.xm34_u2.nsg13_hv_nmos[ige]
print @n.xbgr.xm34_u2.nsg13_hv_nmos[ise]
print @n.xbgr.xm34_u2.nsg13_hv_nmos[ibe]
print @n.xbgr.xm34_u2.nsg13_hv_nmos[ctype]
print @n.xbgr.xm34_u3.nsg13_hv_nmos[ide]
print @n.xbgr.xm34_u3.nsg13_hv_nmos[ige]
print @n.xbgr.xm34_u3.nsg13_hv_nmos[ise]
print @n.xbgr.xm34_u3.nsg13_hv_nmos[ibe]
print @n.xbgr.xm34_u3.nsg13_hv_nmos[ctype]
print @n.xbgr.xm34_u4.nsg13_hv_nmos[ide]
print @n.xbgr.xm34_u4.nsg13_hv_nmos[ige]
print @n.xbgr.xm34_u4.nsg13_hv_nmos[ise]
print @n.xbgr.xm34_u4.nsg13_hv_nmos[ibe]
print @n.xbgr.xm34_u4.nsg13_hv_nmos[ctype]
print @n.xbgr.xm34_u5.nsg13_hv_nmos[ide]
print @n.xbgr.xm34_u5.nsg13_hv_nmos[ige]
print @n.xbgr.xm34_u5.nsg13_hv_nmos[ise]
print @n.xbgr.xm34_u5.nsg13_hv_nmos[ibe]
print @n.xbgr.xm34_u5.nsg13_hv_nmos[ctype]
print @n.xbgr.xm34_u6.nsg13_hv_nmos[ide]
print @n.xbgr.xm34_u6.nsg13_hv_nmos[ige]
print @n.xbgr.xm34_u6.nsg13_hv_nmos[ise]
print @n.xbgr.xm34_u6.nsg13_hv_nmos[ibe]
print @n.xbgr.xm34_u6.nsg13_hv_nmos[ctype]
print @n.xbgr.xm34_u7.nsg13_hv_nmos[ide]
print @n.xbgr.xm34_u7.nsg13_hv_nmos[ige]
print @n.xbgr.xm34_u7.nsg13_hv_nmos[ise]
print @n.xbgr.xm34_u7.nsg13_hv_nmos[ibe]
print @n.xbgr.xm34_u7.nsg13_hv_nmos[ctype]
print @n.xbgr.xm34_u8.nsg13_hv_nmos[ide]
print @n.xbgr.xm34_u8.nsg13_hv_nmos[ige]
print @n.xbgr.xm34_u8.nsg13_hv_nmos[ise]
print @n.xbgr.xm34_u8.nsg13_hv_nmos[ibe]
print @n.xbgr.xm34_u8.nsg13_hv_nmos[ctype]
print @n.xbgr.xm34_u9.nsg13_hv_nmos[ide]
print @n.xbgr.xm34_u9.nsg13_hv_nmos[ige]
print @n.xbgr.xm34_u9.nsg13_hv_nmos[ise]
print @n.xbgr.xm34_u9.nsg13_hv_nmos[ibe]
print @n.xbgr.xm34_u9.nsg13_hv_nmos[ctype]
print @n.xbgr.xm34_u10.nsg13_hv_nmos[ide]
print @n.xbgr.xm34_u10.nsg13_hv_nmos[ige]
print @n.xbgr.xm34_u10.nsg13_hv_nmos[ise]
print @n.xbgr.xm34_u10.nsg13_hv_nmos[ibe]
print @n.xbgr.xm34_u10.nsg13_hv_nmos[ctype]
print @n.xbgr.xm34_u11.nsg13_hv_nmos[ide]
print @n.xbgr.xm34_u11.nsg13_hv_nmos[ige]
print @n.xbgr.xm34_u11.nsg13_hv_nmos[ise]
print @n.xbgr.xm34_u11.nsg13_hv_nmos[ibe]
print @n.xbgr.xm34_u11.nsg13_hv_nmos[ctype]
print @n.xbgr.xm34_u12.nsg13_hv_nmos[ide]
print @n.xbgr.xm34_u12.nsg13_hv_nmos[ige]
print @n.xbgr.xm34_u12.nsg13_hv_nmos[ise]
print @n.xbgr.xm34_u12.nsg13_hv_nmos[ibe]
print @n.xbgr.xm34_u12.nsg13_hv_nmos[ctype]
print @n.xbgr.xm34_u13.nsg13_hv_nmos[ide]
print @n.xbgr.xm34_u13.nsg13_hv_nmos[ige]
print @n.xbgr.xm34_u13.nsg13_hv_nmos[ise]
print @n.xbgr.xm34_u13.nsg13_hv_nmos[ibe]
print @n.xbgr.xm34_u13.nsg13_hv_nmos[ctype]
print @n.xbgr.xm34_u14.nsg13_hv_nmos[ide]
print @n.xbgr.xm34_u14.nsg13_hv_nmos[ige]
print @n.xbgr.xm34_u14.nsg13_hv_nmos[ise]
print @n.xbgr.xm34_u14.nsg13_hv_nmos[ibe]
print @n.xbgr.xm34_u14.nsg13_hv_nmos[ctype]
print @n.xbgr.xm34_u15.nsg13_hv_nmos[ide]
print @n.xbgr.xm34_u15.nsg13_hv_nmos[ige]
print @n.xbgr.xm34_u15.nsg13_hv_nmos[ise]
print @n.xbgr.xm34_u15.nsg13_hv_nmos[ibe]
print @n.xbgr.xm34_u15.nsg13_hv_nmos[ctype]
print @n.xbgr.xm34_u16.nsg13_hv_nmos[ide]
print @n.xbgr.xm34_u16.nsg13_hv_nmos[ige]
print @n.xbgr.xm34_u16.nsg13_hv_nmos[ise]
print @n.xbgr.xm34_u16.nsg13_hv_nmos[ibe]
print @n.xbgr.xm34_u16.nsg13_hv_nmos[ctype]
print @n.xbgr.xm34_u17.nsg13_hv_nmos[ide]
print @n.xbgr.xm34_u17.nsg13_hv_nmos[ige]
print @n.xbgr.xm34_u17.nsg13_hv_nmos[ise]
print @n.xbgr.xm34_u17.nsg13_hv_nmos[ibe]
print @n.xbgr.xm34_u17.nsg13_hv_nmos[ctype]
print @n.xbgr.xm34_u18.nsg13_hv_nmos[ide]
print @n.xbgr.xm34_u18.nsg13_hv_nmos[ige]
print @n.xbgr.xm34_u18.nsg13_hv_nmos[ise]
print @n.xbgr.xm34_u18.nsg13_hv_nmos[ibe]
print @n.xbgr.xm34_u18.nsg13_hv_nmos[ctype]
print @n.xbgr.xm34_u19.nsg13_hv_nmos[ide]
print @n.xbgr.xm34_u19.nsg13_hv_nmos[ige]
print @n.xbgr.xm34_u19.nsg13_hv_nmos[ise]
print @n.xbgr.xm34_u19.nsg13_hv_nmos[ibe]
print @n.xbgr.xm34_u19.nsg13_hv_nmos[ctype]
print @n.xbgr.xm34_u20.nsg13_hv_nmos[ide]
print @n.xbgr.xm34_u20.nsg13_hv_nmos[ige]
print @n.xbgr.xm34_u20.nsg13_hv_nmos[ise]
print @n.xbgr.xm34_u20.nsg13_hv_nmos[ibe]
print @n.xbgr.xm34_u20.nsg13_hv_nmos[ctype]
print @n.xbgr.xm34_u21.nsg13_hv_nmos[ide]
print @n.xbgr.xm34_u21.nsg13_hv_nmos[ige]
print @n.xbgr.xm34_u21.nsg13_hv_nmos[ise]
print @n.xbgr.xm34_u21.nsg13_hv_nmos[ibe]
print @n.xbgr.xm34_u21.nsg13_hv_nmos[ctype]
print @n.xbgr.xm34_u22.nsg13_hv_nmos[ide]
print @n.xbgr.xm34_u22.nsg13_hv_nmos[ige]
print @n.xbgr.xm34_u22.nsg13_hv_nmos[ise]
print @n.xbgr.xm34_u22.nsg13_hv_nmos[ibe]
print @n.xbgr.xm34_u22.nsg13_hv_nmos[ctype]
print @n.xbgr.xm34_u23.nsg13_hv_nmos[ide]
print @n.xbgr.xm34_u23.nsg13_hv_nmos[ige]
print @n.xbgr.xm34_u23.nsg13_hv_nmos[ise]
print @n.xbgr.xm34_u23.nsg13_hv_nmos[ibe]
print @n.xbgr.xm34_u23.nsg13_hv_nmos[ctype]
print @n.xbgr.xm34_u24.nsg13_hv_nmos[ide]
print @n.xbgr.xm34_u24.nsg13_hv_nmos[ige]
print @n.xbgr.xm34_u24.nsg13_hv_nmos[ise]
print @n.xbgr.xm34_u24.nsg13_hv_nmos[ibe]
print @n.xbgr.xm34_u24.nsg13_hv_nmos[ctype]
print @n.xbgr.xm35_u2.nsg13_hv_nmos[ide]
print @n.xbgr.xm35_u2.nsg13_hv_nmos[ige]
print @n.xbgr.xm35_u2.nsg13_hv_nmos[ise]
print @n.xbgr.xm35_u2.nsg13_hv_nmos[ibe]
print @n.xbgr.xm35_u2.nsg13_hv_nmos[ctype]
print @n.xbgr.xm35_u3.nsg13_hv_nmos[ide]
print @n.xbgr.xm35_u3.nsg13_hv_nmos[ige]
print @n.xbgr.xm35_u3.nsg13_hv_nmos[ise]
print @n.xbgr.xm35_u3.nsg13_hv_nmos[ibe]
print @n.xbgr.xm35_u3.nsg13_hv_nmos[ctype]
print @n.xbgr.xm35_u4.nsg13_hv_nmos[ide]
print @n.xbgr.xm35_u4.nsg13_hv_nmos[ige]
print @n.xbgr.xm35_u4.nsg13_hv_nmos[ise]
print @n.xbgr.xm35_u4.nsg13_hv_nmos[ibe]
print @n.xbgr.xm35_u4.nsg13_hv_nmos[ctype]
print @n.xbgr.xm35_u5.nsg13_hv_nmos[ide]
print @n.xbgr.xm35_u5.nsg13_hv_nmos[ige]
print @n.xbgr.xm35_u5.nsg13_hv_nmos[ise]
print @n.xbgr.xm35_u5.nsg13_hv_nmos[ibe]
print @n.xbgr.xm35_u5.nsg13_hv_nmos[ctype]
print @n.xbgr.xm35_u6.nsg13_hv_nmos[ide]
print @n.xbgr.xm35_u6.nsg13_hv_nmos[ige]
print @n.xbgr.xm35_u6.nsg13_hv_nmos[ise]
print @n.xbgr.xm35_u6.nsg13_hv_nmos[ibe]
print @n.xbgr.xm35_u6.nsg13_hv_nmos[ctype]
print @n.xbgr.xm35_u7.nsg13_hv_nmos[ide]
print @n.xbgr.xm35_u7.nsg13_hv_nmos[ige]
print @n.xbgr.xm35_u7.nsg13_hv_nmos[ise]
print @n.xbgr.xm35_u7.nsg13_hv_nmos[ibe]
print @n.xbgr.xm35_u7.nsg13_hv_nmos[ctype]
print @n.xbgr.xm35_u8.nsg13_hv_nmos[ide]
print @n.xbgr.xm35_u8.nsg13_hv_nmos[ige]
print @n.xbgr.xm35_u8.nsg13_hv_nmos[ise]
print @n.xbgr.xm35_u8.nsg13_hv_nmos[ibe]
print @n.xbgr.xm35_u8.nsg13_hv_nmos[ctype]
print @n.xbgr.xm35_u9.nsg13_hv_nmos[ide]
print @n.xbgr.xm35_u9.nsg13_hv_nmos[ige]
print @n.xbgr.xm35_u9.nsg13_hv_nmos[ise]
print @n.xbgr.xm35_u9.nsg13_hv_nmos[ibe]
print @n.xbgr.xm35_u9.nsg13_hv_nmos[ctype]
print @n.xbgr.xm35_u10.nsg13_hv_nmos[ide]
print @n.xbgr.xm35_u10.nsg13_hv_nmos[ige]
print @n.xbgr.xm35_u10.nsg13_hv_nmos[ise]
print @n.xbgr.xm35_u10.nsg13_hv_nmos[ibe]
print @n.xbgr.xm35_u10.nsg13_hv_nmos[ctype]
print @n.xbgr.xm35_u11.nsg13_hv_nmos[ide]
print @n.xbgr.xm35_u11.nsg13_hv_nmos[ige]
print @n.xbgr.xm35_u11.nsg13_hv_nmos[ise]
print @n.xbgr.xm35_u11.nsg13_hv_nmos[ibe]
print @n.xbgr.xm35_u11.nsg13_hv_nmos[ctype]
print @n.xbgr.xm35_u12.nsg13_hv_nmos[ide]
print @n.xbgr.xm35_u12.nsg13_hv_nmos[ige]
print @n.xbgr.xm35_u12.nsg13_hv_nmos[ise]
print @n.xbgr.xm35_u12.nsg13_hv_nmos[ibe]
print @n.xbgr.xm35_u12.nsg13_hv_nmos[ctype]
print @n.xbgr.xm35_u13.nsg13_hv_nmos[ide]
print @n.xbgr.xm35_u13.nsg13_hv_nmos[ige]
print @n.xbgr.xm35_u13.nsg13_hv_nmos[ise]
print @n.xbgr.xm35_u13.nsg13_hv_nmos[ibe]
print @n.xbgr.xm35_u13.nsg13_hv_nmos[ctype]
print @n.xbgr.xm35_u14.nsg13_hv_nmos[ide]
print @n.xbgr.xm35_u14.nsg13_hv_nmos[ige]
print @n.xbgr.xm35_u14.nsg13_hv_nmos[ise]
print @n.xbgr.xm35_u14.nsg13_hv_nmos[ibe]
print @n.xbgr.xm35_u14.nsg13_hv_nmos[ctype]
print @n.xbgr.xm35_u15.nsg13_hv_nmos[ide]
print @n.xbgr.xm35_u15.nsg13_hv_nmos[ige]
print @n.xbgr.xm35_u15.nsg13_hv_nmos[ise]
print @n.xbgr.xm35_u15.nsg13_hv_nmos[ibe]
print @n.xbgr.xm35_u15.nsg13_hv_nmos[ctype]
print @n.xbgr.xm35_u16.nsg13_hv_nmos[ide]
print @n.xbgr.xm35_u16.nsg13_hv_nmos[ige]
print @n.xbgr.xm35_u16.nsg13_hv_nmos[ise]
print @n.xbgr.xm35_u16.nsg13_hv_nmos[ibe]
print @n.xbgr.xm35_u16.nsg13_hv_nmos[ctype]
print @n.xbgr.xm35_u17.nsg13_hv_nmos[ide]
print @n.xbgr.xm35_u17.nsg13_hv_nmos[ige]
print @n.xbgr.xm35_u17.nsg13_hv_nmos[ise]
print @n.xbgr.xm35_u17.nsg13_hv_nmos[ibe]
print @n.xbgr.xm35_u17.nsg13_hv_nmos[ctype]
print @n.xbgr.xm35_u18.nsg13_hv_nmos[ide]
print @n.xbgr.xm35_u18.nsg13_hv_nmos[ige]
print @n.xbgr.xm35_u18.nsg13_hv_nmos[ise]
print @n.xbgr.xm35_u18.nsg13_hv_nmos[ibe]
print @n.xbgr.xm35_u18.nsg13_hv_nmos[ctype]
print @n.xbgr.xm35_u19.nsg13_hv_nmos[ide]
print @n.xbgr.xm35_u19.nsg13_hv_nmos[ige]
print @n.xbgr.xm35_u19.nsg13_hv_nmos[ise]
print @n.xbgr.xm35_u19.nsg13_hv_nmos[ibe]
print @n.xbgr.xm35_u19.nsg13_hv_nmos[ctype]
print @n.xbgr.xm35_u20.nsg13_hv_nmos[ide]
print @n.xbgr.xm35_u20.nsg13_hv_nmos[ige]
print @n.xbgr.xm35_u20.nsg13_hv_nmos[ise]
print @n.xbgr.xm35_u20.nsg13_hv_nmos[ibe]
print @n.xbgr.xm35_u20.nsg13_hv_nmos[ctype]
print @n.xbgr.xm35_u21.nsg13_hv_nmos[ide]
print @n.xbgr.xm35_u21.nsg13_hv_nmos[ige]
print @n.xbgr.xm35_u21.nsg13_hv_nmos[ise]
print @n.xbgr.xm35_u21.nsg13_hv_nmos[ibe]
print @n.xbgr.xm35_u21.nsg13_hv_nmos[ctype]
print @n.xbgr.xm35_u22.nsg13_hv_nmos[ide]
print @n.xbgr.xm35_u22.nsg13_hv_nmos[ige]
print @n.xbgr.xm35_u22.nsg13_hv_nmos[ise]
print @n.xbgr.xm35_u22.nsg13_hv_nmos[ibe]
print @n.xbgr.xm35_u22.nsg13_hv_nmos[ctype]
print @n.xbgr.xm35_u23.nsg13_hv_nmos[ide]
print @n.xbgr.xm35_u23.nsg13_hv_nmos[ige]
print @n.xbgr.xm35_u23.nsg13_hv_nmos[ise]
print @n.xbgr.xm35_u23.nsg13_hv_nmos[ibe]
print @n.xbgr.xm35_u23.nsg13_hv_nmos[ctype]
print @n.xbgr.xm35_u24.nsg13_hv_nmos[ide]
print @n.xbgr.xm35_u24.nsg13_hv_nmos[ige]
print @n.xbgr.xm35_u24.nsg13_hv_nmos[ise]
print @n.xbgr.xm35_u24.nsg13_hv_nmos[ibe]
print @n.xbgr.xm35_u24.nsg13_hv_nmos[ctype]
print @n.xbgr.xm36_u2.nsg13_hv_nmos[ide]
print @n.xbgr.xm36_u2.nsg13_hv_nmos[ige]
print @n.xbgr.xm36_u2.nsg13_hv_nmos[ise]
print @n.xbgr.xm36_u2.nsg13_hv_nmos[ibe]
print @n.xbgr.xm36_u2.nsg13_hv_nmos[ctype]
print @n.xbgr.xm36_u3.nsg13_hv_nmos[ide]
print @n.xbgr.xm36_u3.nsg13_hv_nmos[ige]
print @n.xbgr.xm36_u3.nsg13_hv_nmos[ise]
print @n.xbgr.xm36_u3.nsg13_hv_nmos[ibe]
print @n.xbgr.xm36_u3.nsg13_hv_nmos[ctype]
print @n.xbgr.xm36_u4.nsg13_hv_nmos[ide]
print @n.xbgr.xm36_u4.nsg13_hv_nmos[ige]
print @n.xbgr.xm36_u4.nsg13_hv_nmos[ise]
print @n.xbgr.xm36_u4.nsg13_hv_nmos[ibe]
print @n.xbgr.xm36_u4.nsg13_hv_nmos[ctype]
print @n.xbgr.xm36_u5.nsg13_hv_nmos[ide]
print @n.xbgr.xm36_u5.nsg13_hv_nmos[ige]
print @n.xbgr.xm36_u5.nsg13_hv_nmos[ise]
print @n.xbgr.xm36_u5.nsg13_hv_nmos[ibe]
print @n.xbgr.xm36_u5.nsg13_hv_nmos[ctype]
print @n.xbgr.xm36_u6.nsg13_hv_nmos[ide]
print @n.xbgr.xm36_u6.nsg13_hv_nmos[ige]
print @n.xbgr.xm36_u6.nsg13_hv_nmos[ise]
print @n.xbgr.xm36_u6.nsg13_hv_nmos[ibe]
print @n.xbgr.xm36_u6.nsg13_hv_nmos[ctype]
print @n.xbgr.xm36_u7.nsg13_hv_nmos[ide]
print @n.xbgr.xm36_u7.nsg13_hv_nmos[ige]
print @n.xbgr.xm36_u7.nsg13_hv_nmos[ise]
print @n.xbgr.xm36_u7.nsg13_hv_nmos[ibe]
print @n.xbgr.xm36_u7.nsg13_hv_nmos[ctype]
print @n.xbgr.xm36_u8.nsg13_hv_nmos[ide]
print @n.xbgr.xm36_u8.nsg13_hv_nmos[ige]
print @n.xbgr.xm36_u8.nsg13_hv_nmos[ise]
print @n.xbgr.xm36_u8.nsg13_hv_nmos[ibe]
print @n.xbgr.xm36_u8.nsg13_hv_nmos[ctype]
print @n.xbgr.xm36_u9.nsg13_hv_nmos[ide]
print @n.xbgr.xm36_u9.nsg13_hv_nmos[ige]
print @n.xbgr.xm36_u9.nsg13_hv_nmos[ise]
print @n.xbgr.xm36_u9.nsg13_hv_nmos[ibe]
print @n.xbgr.xm36_u9.nsg13_hv_nmos[ctype]
print @n.xbgr.xm36_u10.nsg13_hv_nmos[ide]
print @n.xbgr.xm36_u10.nsg13_hv_nmos[ige]
print @n.xbgr.xm36_u10.nsg13_hv_nmos[ise]
print @n.xbgr.xm36_u10.nsg13_hv_nmos[ibe]
print @n.xbgr.xm36_u10.nsg13_hv_nmos[ctype]
print @n.xbgr.xm36_u11.nsg13_hv_nmos[ide]
print @n.xbgr.xm36_u11.nsg13_hv_nmos[ige]
print @n.xbgr.xm36_u11.nsg13_hv_nmos[ise]
print @n.xbgr.xm36_u11.nsg13_hv_nmos[ibe]
print @n.xbgr.xm36_u11.nsg13_hv_nmos[ctype]
print @n.xbgr.xm36_u12.nsg13_hv_nmos[ide]
print @n.xbgr.xm36_u12.nsg13_hv_nmos[ige]
print @n.xbgr.xm36_u12.nsg13_hv_nmos[ise]
print @n.xbgr.xm36_u12.nsg13_hv_nmos[ibe]
print @n.xbgr.xm36_u12.nsg13_hv_nmos[ctype]
print @n.xbgr.xm36_u13.nsg13_hv_nmos[ide]
print @n.xbgr.xm36_u13.nsg13_hv_nmos[ige]
print @n.xbgr.xm36_u13.nsg13_hv_nmos[ise]
print @n.xbgr.xm36_u13.nsg13_hv_nmos[ibe]
print @n.xbgr.xm36_u13.nsg13_hv_nmos[ctype]
print @n.xbgr.xm36_u14.nsg13_hv_nmos[ide]
print @n.xbgr.xm36_u14.nsg13_hv_nmos[ige]
print @n.xbgr.xm36_u14.nsg13_hv_nmos[ise]
print @n.xbgr.xm36_u14.nsg13_hv_nmos[ibe]
print @n.xbgr.xm36_u14.nsg13_hv_nmos[ctype]
print @n.xbgr.xm36_u15.nsg13_hv_nmos[ide]
print @n.xbgr.xm36_u15.nsg13_hv_nmos[ige]
print @n.xbgr.xm36_u15.nsg13_hv_nmos[ise]
print @n.xbgr.xm36_u15.nsg13_hv_nmos[ibe]
print @n.xbgr.xm36_u15.nsg13_hv_nmos[ctype]
print @n.xbgr.xm36_u16.nsg13_hv_nmos[ide]
print @n.xbgr.xm36_u16.nsg13_hv_nmos[ige]
print @n.xbgr.xm36_u16.nsg13_hv_nmos[ise]
print @n.xbgr.xm36_u16.nsg13_hv_nmos[ibe]
print @n.xbgr.xm36_u16.nsg13_hv_nmos[ctype]
print @n.xbgr.xm36_u17.nsg13_hv_nmos[ide]
print @n.xbgr.xm36_u17.nsg13_hv_nmos[ige]
print @n.xbgr.xm36_u17.nsg13_hv_nmos[ise]
print @n.xbgr.xm36_u17.nsg13_hv_nmos[ibe]
print @n.xbgr.xm36_u17.nsg13_hv_nmos[ctype]
print @n.xbgr.xm36_u18.nsg13_hv_nmos[ide]
print @n.xbgr.xm36_u18.nsg13_hv_nmos[ige]
print @n.xbgr.xm36_u18.nsg13_hv_nmos[ise]
print @n.xbgr.xm36_u18.nsg13_hv_nmos[ibe]
print @n.xbgr.xm36_u18.nsg13_hv_nmos[ctype]
print @n.xbgr.xm36_u19.nsg13_hv_nmos[ide]
print @n.xbgr.xm36_u19.nsg13_hv_nmos[ige]
print @n.xbgr.xm36_u19.nsg13_hv_nmos[ise]
print @n.xbgr.xm36_u19.nsg13_hv_nmos[ibe]
print @n.xbgr.xm36_u19.nsg13_hv_nmos[ctype]
print @n.xbgr.xm36_u20.nsg13_hv_nmos[ide]
print @n.xbgr.xm36_u20.nsg13_hv_nmos[ige]
print @n.xbgr.xm36_u20.nsg13_hv_nmos[ise]
print @n.xbgr.xm36_u20.nsg13_hv_nmos[ibe]
print @n.xbgr.xm36_u20.nsg13_hv_nmos[ctype]
print @n.xbgr.xm36_u21.nsg13_hv_nmos[ide]
print @n.xbgr.xm36_u21.nsg13_hv_nmos[ige]
print @n.xbgr.xm36_u21.nsg13_hv_nmos[ise]
print @n.xbgr.xm36_u21.nsg13_hv_nmos[ibe]
print @n.xbgr.xm36_u21.nsg13_hv_nmos[ctype]
print @n.xbgr.xm36_u22.nsg13_hv_nmos[ide]
print @n.xbgr.xm36_u22.nsg13_hv_nmos[ige]
print @n.xbgr.xm36_u22.nsg13_hv_nmos[ise]
print @n.xbgr.xm36_u22.nsg13_hv_nmos[ibe]
print @n.xbgr.xm36_u22.nsg13_hv_nmos[ctype]
print @n.xbgr.xm36_u23.nsg13_hv_nmos[ide]
print @n.xbgr.xm36_u23.nsg13_hv_nmos[ige]
print @n.xbgr.xm36_u23.nsg13_hv_nmos[ise]
print @n.xbgr.xm36_u23.nsg13_hv_nmos[ibe]
print @n.xbgr.xm36_u23.nsg13_hv_nmos[ctype]
print @n.xbgr.xm36_u24.nsg13_hv_nmos[ide]
print @n.xbgr.xm36_u24.nsg13_hv_nmos[ige]
print @n.xbgr.xm36_u24.nsg13_hv_nmos[ise]
print @n.xbgr.xm36_u24.nsg13_hv_nmos[ibe]
print @n.xbgr.xm36_u24.nsg13_hv_nmos[ctype]
print @n.xbgr.xm37_u2.nsg13_hv_nmos[ide]
print @n.xbgr.xm37_u2.nsg13_hv_nmos[ige]
print @n.xbgr.xm37_u2.nsg13_hv_nmos[ise]
print @n.xbgr.xm37_u2.nsg13_hv_nmos[ibe]
print @n.xbgr.xm37_u2.nsg13_hv_nmos[ctype]
print @n.xbgr.xm37_u3.nsg13_hv_nmos[ide]
print @n.xbgr.xm37_u3.nsg13_hv_nmos[ige]
print @n.xbgr.xm37_u3.nsg13_hv_nmos[ise]
print @n.xbgr.xm37_u3.nsg13_hv_nmos[ibe]
print @n.xbgr.xm37_u3.nsg13_hv_nmos[ctype]
print @n.xbgr.xm37_u4.nsg13_hv_nmos[ide]
print @n.xbgr.xm37_u4.nsg13_hv_nmos[ige]
print @n.xbgr.xm37_u4.nsg13_hv_nmos[ise]
print @n.xbgr.xm37_u4.nsg13_hv_nmos[ibe]
print @n.xbgr.xm37_u4.nsg13_hv_nmos[ctype]
print @n.xbgr.xm37_u5.nsg13_hv_nmos[ide]
print @n.xbgr.xm37_u5.nsg13_hv_nmos[ige]
print @n.xbgr.xm37_u5.nsg13_hv_nmos[ise]
print @n.xbgr.xm37_u5.nsg13_hv_nmos[ibe]
print @n.xbgr.xm37_u5.nsg13_hv_nmos[ctype]
print @n.xbgr.xm37_u6.nsg13_hv_nmos[ide]
print @n.xbgr.xm37_u6.nsg13_hv_nmos[ige]
print @n.xbgr.xm37_u6.nsg13_hv_nmos[ise]
print @n.xbgr.xm37_u6.nsg13_hv_nmos[ibe]
print @n.xbgr.xm37_u6.nsg13_hv_nmos[ctype]
print @n.xbgr.xm37_u7.nsg13_hv_nmos[ide]
print @n.xbgr.xm37_u7.nsg13_hv_nmos[ige]
print @n.xbgr.xm37_u7.nsg13_hv_nmos[ise]
print @n.xbgr.xm37_u7.nsg13_hv_nmos[ibe]
print @n.xbgr.xm37_u7.nsg13_hv_nmos[ctype]
print @n.xbgr.xm37_u8.nsg13_hv_nmos[ide]
print @n.xbgr.xm37_u8.nsg13_hv_nmos[ige]
print @n.xbgr.xm37_u8.nsg13_hv_nmos[ise]
print @n.xbgr.xm37_u8.nsg13_hv_nmos[ibe]
print @n.xbgr.xm37_u8.nsg13_hv_nmos[ctype]
print @n.xbgr.xm37_u9.nsg13_hv_nmos[ide]
print @n.xbgr.xm37_u9.nsg13_hv_nmos[ige]
print @n.xbgr.xm37_u9.nsg13_hv_nmos[ise]
print @n.xbgr.xm37_u9.nsg13_hv_nmos[ibe]
print @n.xbgr.xm37_u9.nsg13_hv_nmos[ctype]
print @n.xbgr.xm37_u10.nsg13_hv_nmos[ide]
print @n.xbgr.xm37_u10.nsg13_hv_nmos[ige]
print @n.xbgr.xm37_u10.nsg13_hv_nmos[ise]
print @n.xbgr.xm37_u10.nsg13_hv_nmos[ibe]
print @n.xbgr.xm37_u10.nsg13_hv_nmos[ctype]
print @n.xbgr.xm37_u11.nsg13_hv_nmos[ide]
print @n.xbgr.xm37_u11.nsg13_hv_nmos[ige]
print @n.xbgr.xm37_u11.nsg13_hv_nmos[ise]
print @n.xbgr.xm37_u11.nsg13_hv_nmos[ibe]
print @n.xbgr.xm37_u11.nsg13_hv_nmos[ctype]
print @n.xbgr.xm37_u12.nsg13_hv_nmos[ide]
print @n.xbgr.xm37_u12.nsg13_hv_nmos[ige]
print @n.xbgr.xm37_u12.nsg13_hv_nmos[ise]
print @n.xbgr.xm37_u12.nsg13_hv_nmos[ibe]
print @n.xbgr.xm37_u12.nsg13_hv_nmos[ctype]
print @n.xbgr.xm37_u13.nsg13_hv_nmos[ide]
print @n.xbgr.xm37_u13.nsg13_hv_nmos[ige]
print @n.xbgr.xm37_u13.nsg13_hv_nmos[ise]
print @n.xbgr.xm37_u13.nsg13_hv_nmos[ibe]
print @n.xbgr.xm37_u13.nsg13_hv_nmos[ctype]
print @n.xbgr.xm37_u14.nsg13_hv_nmos[ide]
print @n.xbgr.xm37_u14.nsg13_hv_nmos[ige]
print @n.xbgr.xm37_u14.nsg13_hv_nmos[ise]
print @n.xbgr.xm37_u14.nsg13_hv_nmos[ibe]
print @n.xbgr.xm37_u14.nsg13_hv_nmos[ctype]
print @n.xbgr.xm37_u15.nsg13_hv_nmos[ide]
print @n.xbgr.xm37_u15.nsg13_hv_nmos[ige]
print @n.xbgr.xm37_u15.nsg13_hv_nmos[ise]
print @n.xbgr.xm37_u15.nsg13_hv_nmos[ibe]
print @n.xbgr.xm37_u15.nsg13_hv_nmos[ctype]
print @n.xbgr.xm37_u16.nsg13_hv_nmos[ide]
print @n.xbgr.xm37_u16.nsg13_hv_nmos[ige]
print @n.xbgr.xm37_u16.nsg13_hv_nmos[ise]
print @n.xbgr.xm37_u16.nsg13_hv_nmos[ibe]
print @n.xbgr.xm37_u16.nsg13_hv_nmos[ctype]
print @n.xbgr.xm37_u17.nsg13_hv_nmos[ide]
print @n.xbgr.xm37_u17.nsg13_hv_nmos[ige]
print @n.xbgr.xm37_u17.nsg13_hv_nmos[ise]
print @n.xbgr.xm37_u17.nsg13_hv_nmos[ibe]
print @n.xbgr.xm37_u17.nsg13_hv_nmos[ctype]
print @n.xbgr.xm37_u18.nsg13_hv_nmos[ide]
print @n.xbgr.xm37_u18.nsg13_hv_nmos[ige]
print @n.xbgr.xm37_u18.nsg13_hv_nmos[ise]
print @n.xbgr.xm37_u18.nsg13_hv_nmos[ibe]
print @n.xbgr.xm37_u18.nsg13_hv_nmos[ctype]
print @n.xbgr.xm37_u19.nsg13_hv_nmos[ide]
print @n.xbgr.xm37_u19.nsg13_hv_nmos[ige]
print @n.xbgr.xm37_u19.nsg13_hv_nmos[ise]
print @n.xbgr.xm37_u19.nsg13_hv_nmos[ibe]
print @n.xbgr.xm37_u19.nsg13_hv_nmos[ctype]
print @n.xbgr.xm37_u20.nsg13_hv_nmos[ide]
print @n.xbgr.xm37_u20.nsg13_hv_nmos[ige]
print @n.xbgr.xm37_u20.nsg13_hv_nmos[ise]
print @n.xbgr.xm37_u20.nsg13_hv_nmos[ibe]
print @n.xbgr.xm37_u20.nsg13_hv_nmos[ctype]
print @n.xbgr.xm37_u21.nsg13_hv_nmos[ide]
print @n.xbgr.xm37_u21.nsg13_hv_nmos[ige]
print @n.xbgr.xm37_u21.nsg13_hv_nmos[ise]
print @n.xbgr.xm37_u21.nsg13_hv_nmos[ibe]
print @n.xbgr.xm37_u21.nsg13_hv_nmos[ctype]
print @n.xbgr.xm37_u22.nsg13_hv_nmos[ide]
print @n.xbgr.xm37_u22.nsg13_hv_nmos[ige]
print @n.xbgr.xm37_u22.nsg13_hv_nmos[ise]
print @n.xbgr.xm37_u22.nsg13_hv_nmos[ibe]
print @n.xbgr.xm37_u22.nsg13_hv_nmos[ctype]
print @n.xbgr.xm37_u23.nsg13_hv_nmos[ide]
print @n.xbgr.xm37_u23.nsg13_hv_nmos[ige]
print @n.xbgr.xm37_u23.nsg13_hv_nmos[ise]
print @n.xbgr.xm37_u23.nsg13_hv_nmos[ibe]
print @n.xbgr.xm37_u23.nsg13_hv_nmos[ctype]
print @n.xbgr.xm37_u24.nsg13_hv_nmos[ide]
print @n.xbgr.xm37_u24.nsg13_hv_nmos[ige]
print @n.xbgr.xm37_u24.nsg13_hv_nmos[ise]
print @n.xbgr.xm37_u24.nsg13_hv_nmos[ibe]
print @n.xbgr.xm37_u24.nsg13_hv_nmos[ctype]
print @n.xbgr.xm38_u2.nsg13_hv_pmos[ide]
print @n.xbgr.xm38_u2.nsg13_hv_pmos[ige]
print @n.xbgr.xm38_u2.nsg13_hv_pmos[ise]
print @n.xbgr.xm38_u2.nsg13_hv_pmos[ibe]
print @n.xbgr.xm38_u2.nsg13_hv_pmos[ctype]
print @n.xbgr.xm38_u3.nsg13_hv_pmos[ide]
print @n.xbgr.xm38_u3.nsg13_hv_pmos[ige]
print @n.xbgr.xm38_u3.nsg13_hv_pmos[ise]
print @n.xbgr.xm38_u3.nsg13_hv_pmos[ibe]
print @n.xbgr.xm38_u3.nsg13_hv_pmos[ctype]
print @n.xbgr.xm38_u4.nsg13_hv_pmos[ide]
print @n.xbgr.xm38_u4.nsg13_hv_pmos[ige]
print @n.xbgr.xm38_u4.nsg13_hv_pmos[ise]
print @n.xbgr.xm38_u4.nsg13_hv_pmos[ibe]
print @n.xbgr.xm38_u4.nsg13_hv_pmos[ctype]
print @n.xbgr.xm38_u5.nsg13_hv_pmos[ide]
print @n.xbgr.xm38_u5.nsg13_hv_pmos[ige]
print @n.xbgr.xm38_u5.nsg13_hv_pmos[ise]
print @n.xbgr.xm38_u5.nsg13_hv_pmos[ibe]
print @n.xbgr.xm38_u5.nsg13_hv_pmos[ctype]
print @n.xbgr.xm38_u6.nsg13_hv_pmos[ide]
print @n.xbgr.xm38_u6.nsg13_hv_pmos[ige]
print @n.xbgr.xm38_u6.nsg13_hv_pmos[ise]
print @n.xbgr.xm38_u6.nsg13_hv_pmos[ibe]
print @n.xbgr.xm38_u6.nsg13_hv_pmos[ctype]
print @n.xbgr.xm38_u7.nsg13_hv_pmos[ide]
print @n.xbgr.xm38_u7.nsg13_hv_pmos[ige]
print @n.xbgr.xm38_u7.nsg13_hv_pmos[ise]
print @n.xbgr.xm38_u7.nsg13_hv_pmos[ibe]
print @n.xbgr.xm38_u7.nsg13_hv_pmos[ctype]
print @n.xbgr.xm38_u8.nsg13_hv_pmos[ide]
print @n.xbgr.xm38_u8.nsg13_hv_pmos[ige]
print @n.xbgr.xm38_u8.nsg13_hv_pmos[ise]
print @n.xbgr.xm38_u8.nsg13_hv_pmos[ibe]
print @n.xbgr.xm38_u8.nsg13_hv_pmos[ctype]
print @n.xbgr.xm38_u9.nsg13_hv_pmos[ide]
print @n.xbgr.xm38_u9.nsg13_hv_pmos[ige]
print @n.xbgr.xm38_u9.nsg13_hv_pmos[ise]
print @n.xbgr.xm38_u9.nsg13_hv_pmos[ibe]
print @n.xbgr.xm38_u9.nsg13_hv_pmos[ctype]
print @n.xbgr.xm38_u10.nsg13_hv_pmos[ide]
print @n.xbgr.xm38_u10.nsg13_hv_pmos[ige]
print @n.xbgr.xm38_u10.nsg13_hv_pmos[ise]
print @n.xbgr.xm38_u10.nsg13_hv_pmos[ibe]
print @n.xbgr.xm38_u10.nsg13_hv_pmos[ctype]
print @n.xbgr.xm38_u11.nsg13_hv_pmos[ide]
print @n.xbgr.xm38_u11.nsg13_hv_pmos[ige]
print @n.xbgr.xm38_u11.nsg13_hv_pmos[ise]
print @n.xbgr.xm38_u11.nsg13_hv_pmos[ibe]
print @n.xbgr.xm38_u11.nsg13_hv_pmos[ctype]
print @n.xbgr.xm38_u12.nsg13_hv_pmos[ide]
print @n.xbgr.xm38_u12.nsg13_hv_pmos[ige]
print @n.xbgr.xm38_u12.nsg13_hv_pmos[ise]
print @n.xbgr.xm38_u12.nsg13_hv_pmos[ibe]
print @n.xbgr.xm38_u12.nsg13_hv_pmos[ctype]
print @n.xbgr.xm38_u13.nsg13_hv_pmos[ide]
print @n.xbgr.xm38_u13.nsg13_hv_pmos[ige]
print @n.xbgr.xm38_u13.nsg13_hv_pmos[ise]
print @n.xbgr.xm38_u13.nsg13_hv_pmos[ibe]
print @n.xbgr.xm38_u13.nsg13_hv_pmos[ctype]
print @n.xbgr.xm38_u14.nsg13_hv_pmos[ide]
print @n.xbgr.xm38_u14.nsg13_hv_pmos[ige]
print @n.xbgr.xm38_u14.nsg13_hv_pmos[ise]
print @n.xbgr.xm38_u14.nsg13_hv_pmos[ibe]
print @n.xbgr.xm38_u14.nsg13_hv_pmos[ctype]
print @n.xbgr.xm38_u15.nsg13_hv_pmos[ide]
print @n.xbgr.xm38_u15.nsg13_hv_pmos[ige]
print @n.xbgr.xm38_u15.nsg13_hv_pmos[ise]
print @n.xbgr.xm38_u15.nsg13_hv_pmos[ibe]
print @n.xbgr.xm38_u15.nsg13_hv_pmos[ctype]
print @n.xbgr.xm38_u16.nsg13_hv_pmos[ide]
print @n.xbgr.xm38_u16.nsg13_hv_pmos[ige]
print @n.xbgr.xm38_u16.nsg13_hv_pmos[ise]
print @n.xbgr.xm38_u16.nsg13_hv_pmos[ibe]
print @n.xbgr.xm38_u16.nsg13_hv_pmos[ctype]
print @n.xbgr.xm38_u17.nsg13_hv_pmos[ide]
print @n.xbgr.xm38_u17.nsg13_hv_pmos[ige]
print @n.xbgr.xm38_u17.nsg13_hv_pmos[ise]
print @n.xbgr.xm38_u17.nsg13_hv_pmos[ibe]
print @n.xbgr.xm38_u17.nsg13_hv_pmos[ctype]
print @n.xbgr.xm38_u18.nsg13_hv_pmos[ide]
print @n.xbgr.xm38_u18.nsg13_hv_pmos[ige]
print @n.xbgr.xm38_u18.nsg13_hv_pmos[ise]
print @n.xbgr.xm38_u18.nsg13_hv_pmos[ibe]
print @n.xbgr.xm38_u18.nsg13_hv_pmos[ctype]
print @n.xbgr.xm38_u19.nsg13_hv_pmos[ide]
print @n.xbgr.xm38_u19.nsg13_hv_pmos[ige]
print @n.xbgr.xm38_u19.nsg13_hv_pmos[ise]
print @n.xbgr.xm38_u19.nsg13_hv_pmos[ibe]
print @n.xbgr.xm38_u19.nsg13_hv_pmos[ctype]
print @n.xbgr.xm38_u20.nsg13_hv_pmos[ide]
print @n.xbgr.xm38_u20.nsg13_hv_pmos[ige]
print @n.xbgr.xm38_u20.nsg13_hv_pmos[ise]
print @n.xbgr.xm38_u20.nsg13_hv_pmos[ibe]
print @n.xbgr.xm38_u20.nsg13_hv_pmos[ctype]
print @n.xbgr.xm38_u21.nsg13_hv_pmos[ide]
print @n.xbgr.xm38_u21.nsg13_hv_pmos[ige]
print @n.xbgr.xm38_u21.nsg13_hv_pmos[ise]
print @n.xbgr.xm38_u21.nsg13_hv_pmos[ibe]
print @n.xbgr.xm38_u21.nsg13_hv_pmos[ctype]
print @n.xbgr.xm38_u22.nsg13_hv_pmos[ide]
print @n.xbgr.xm38_u22.nsg13_hv_pmos[ige]
print @n.xbgr.xm38_u22.nsg13_hv_pmos[ise]
print @n.xbgr.xm38_u22.nsg13_hv_pmos[ibe]
print @n.xbgr.xm38_u22.nsg13_hv_pmos[ctype]
print @n.xbgr.xm38_u23.nsg13_hv_pmos[ide]
print @n.xbgr.xm38_u23.nsg13_hv_pmos[ige]
print @n.xbgr.xm38_u23.nsg13_hv_pmos[ise]
print @n.xbgr.xm38_u23.nsg13_hv_pmos[ibe]
print @n.xbgr.xm38_u23.nsg13_hv_pmos[ctype]
print @n.xbgr.xm38_u24.nsg13_hv_pmos[ide]
print @n.xbgr.xm38_u24.nsg13_hv_pmos[ige]
print @n.xbgr.xm38_u24.nsg13_hv_pmos[ise]
print @n.xbgr.xm38_u24.nsg13_hv_pmos[ibe]
print @n.xbgr.xm38_u24.nsg13_hv_pmos[ctype]
print @n.xbgr.xm39_u2.nsg13_hv_pmos[ide]
print @n.xbgr.xm39_u2.nsg13_hv_pmos[ige]
print @n.xbgr.xm39_u2.nsg13_hv_pmos[ise]
print @n.xbgr.xm39_u2.nsg13_hv_pmos[ibe]
print @n.xbgr.xm39_u2.nsg13_hv_pmos[ctype]
print @n.xbgr.xm39_u3.nsg13_hv_pmos[ide]
print @n.xbgr.xm39_u3.nsg13_hv_pmos[ige]
print @n.xbgr.xm39_u3.nsg13_hv_pmos[ise]
print @n.xbgr.xm39_u3.nsg13_hv_pmos[ibe]
print @n.xbgr.xm39_u3.nsg13_hv_pmos[ctype]
print @n.xbgr.xm39_u4.nsg13_hv_pmos[ide]
print @n.xbgr.xm39_u4.nsg13_hv_pmos[ige]
print @n.xbgr.xm39_u4.nsg13_hv_pmos[ise]
print @n.xbgr.xm39_u4.nsg13_hv_pmos[ibe]
print @n.xbgr.xm39_u4.nsg13_hv_pmos[ctype]
print @n.xbgr.xm39_u5.nsg13_hv_pmos[ide]
print @n.xbgr.xm39_u5.nsg13_hv_pmos[ige]
print @n.xbgr.xm39_u5.nsg13_hv_pmos[ise]
print @n.xbgr.xm39_u5.nsg13_hv_pmos[ibe]
print @n.xbgr.xm39_u5.nsg13_hv_pmos[ctype]
print @n.xbgr.xm39_u6.nsg13_hv_pmos[ide]
print @n.xbgr.xm39_u6.nsg13_hv_pmos[ige]
print @n.xbgr.xm39_u6.nsg13_hv_pmos[ise]
print @n.xbgr.xm39_u6.nsg13_hv_pmos[ibe]
print @n.xbgr.xm39_u6.nsg13_hv_pmos[ctype]
print @n.xbgr.xm39_u7.nsg13_hv_pmos[ide]
print @n.xbgr.xm39_u7.nsg13_hv_pmos[ige]
print @n.xbgr.xm39_u7.nsg13_hv_pmos[ise]
print @n.xbgr.xm39_u7.nsg13_hv_pmos[ibe]
print @n.xbgr.xm39_u7.nsg13_hv_pmos[ctype]
print @n.xbgr.xm39_u8.nsg13_hv_pmos[ide]
print @n.xbgr.xm39_u8.nsg13_hv_pmos[ige]
print @n.xbgr.xm39_u8.nsg13_hv_pmos[ise]
print @n.xbgr.xm39_u8.nsg13_hv_pmos[ibe]
print @n.xbgr.xm39_u8.nsg13_hv_pmos[ctype]
print @n.xbgr.xm39_u9.nsg13_hv_pmos[ide]
print @n.xbgr.xm39_u9.nsg13_hv_pmos[ige]
print @n.xbgr.xm39_u9.nsg13_hv_pmos[ise]
print @n.xbgr.xm39_u9.nsg13_hv_pmos[ibe]
print @n.xbgr.xm39_u9.nsg13_hv_pmos[ctype]
print @n.xbgr.xm39_u10.nsg13_hv_pmos[ide]
print @n.xbgr.xm39_u10.nsg13_hv_pmos[ige]
print @n.xbgr.xm39_u10.nsg13_hv_pmos[ise]
print @n.xbgr.xm39_u10.nsg13_hv_pmos[ibe]
print @n.xbgr.xm39_u10.nsg13_hv_pmos[ctype]
print @n.xbgr.xm39_u11.nsg13_hv_pmos[ide]
print @n.xbgr.xm39_u11.nsg13_hv_pmos[ige]
print @n.xbgr.xm39_u11.nsg13_hv_pmos[ise]
print @n.xbgr.xm39_u11.nsg13_hv_pmos[ibe]
print @n.xbgr.xm39_u11.nsg13_hv_pmos[ctype]
print @n.xbgr.xm39_u12.nsg13_hv_pmos[ide]
print @n.xbgr.xm39_u12.nsg13_hv_pmos[ige]
print @n.xbgr.xm39_u12.nsg13_hv_pmos[ise]
print @n.xbgr.xm39_u12.nsg13_hv_pmos[ibe]
print @n.xbgr.xm39_u12.nsg13_hv_pmos[ctype]
print @n.xbgr.xm39_u13.nsg13_hv_pmos[ide]
print @n.xbgr.xm39_u13.nsg13_hv_pmos[ige]
print @n.xbgr.xm39_u13.nsg13_hv_pmos[ise]
print @n.xbgr.xm39_u13.nsg13_hv_pmos[ibe]
print @n.xbgr.xm39_u13.nsg13_hv_pmos[ctype]
print @n.xbgr.xm39_u14.nsg13_hv_pmos[ide]
print @n.xbgr.xm39_u14.nsg13_hv_pmos[ige]
print @n.xbgr.xm39_u14.nsg13_hv_pmos[ise]
print @n.xbgr.xm39_u14.nsg13_hv_pmos[ibe]
print @n.xbgr.xm39_u14.nsg13_hv_pmos[ctype]
print @n.xbgr.xm39_u15.nsg13_hv_pmos[ide]
print @n.xbgr.xm39_u15.nsg13_hv_pmos[ige]
print @n.xbgr.xm39_u15.nsg13_hv_pmos[ise]
print @n.xbgr.xm39_u15.nsg13_hv_pmos[ibe]
print @n.xbgr.xm39_u15.nsg13_hv_pmos[ctype]
print @n.xbgr.xm39_u16.nsg13_hv_pmos[ide]
print @n.xbgr.xm39_u16.nsg13_hv_pmos[ige]
print @n.xbgr.xm39_u16.nsg13_hv_pmos[ise]
print @n.xbgr.xm39_u16.nsg13_hv_pmos[ibe]
print @n.xbgr.xm39_u16.nsg13_hv_pmos[ctype]
print @n.xbgr.xm39_u17.nsg13_hv_pmos[ide]
print @n.xbgr.xm39_u17.nsg13_hv_pmos[ige]
print @n.xbgr.xm39_u17.nsg13_hv_pmos[ise]
print @n.xbgr.xm39_u17.nsg13_hv_pmos[ibe]
print @n.xbgr.xm39_u17.nsg13_hv_pmos[ctype]
print @n.xbgr.xm39_u18.nsg13_hv_pmos[ide]
print @n.xbgr.xm39_u18.nsg13_hv_pmos[ige]
print @n.xbgr.xm39_u18.nsg13_hv_pmos[ise]
print @n.xbgr.xm39_u18.nsg13_hv_pmos[ibe]
print @n.xbgr.xm39_u18.nsg13_hv_pmos[ctype]
print @n.xbgr.xm39_u19.nsg13_hv_pmos[ide]
print @n.xbgr.xm39_u19.nsg13_hv_pmos[ige]
print @n.xbgr.xm39_u19.nsg13_hv_pmos[ise]
print @n.xbgr.xm39_u19.nsg13_hv_pmos[ibe]
print @n.xbgr.xm39_u19.nsg13_hv_pmos[ctype]
print @n.xbgr.xm39_u20.nsg13_hv_pmos[ide]
print @n.xbgr.xm39_u20.nsg13_hv_pmos[ige]
print @n.xbgr.xm39_u20.nsg13_hv_pmos[ise]
print @n.xbgr.xm39_u20.nsg13_hv_pmos[ibe]
print @n.xbgr.xm39_u20.nsg13_hv_pmos[ctype]
print @n.xbgr.xm39_u21.nsg13_hv_pmos[ide]
print @n.xbgr.xm39_u21.nsg13_hv_pmos[ige]
print @n.xbgr.xm39_u21.nsg13_hv_pmos[ise]
print @n.xbgr.xm39_u21.nsg13_hv_pmos[ibe]
print @n.xbgr.xm39_u21.nsg13_hv_pmos[ctype]
print @n.xbgr.xm39_u22.nsg13_hv_pmos[ide]
print @n.xbgr.xm39_u22.nsg13_hv_pmos[ige]
print @n.xbgr.xm39_u22.nsg13_hv_pmos[ise]
print @n.xbgr.xm39_u22.nsg13_hv_pmos[ibe]
print @n.xbgr.xm39_u22.nsg13_hv_pmos[ctype]
print @n.xbgr.xm39_u23.nsg13_hv_pmos[ide]
print @n.xbgr.xm39_u23.nsg13_hv_pmos[ige]
print @n.xbgr.xm39_u23.nsg13_hv_pmos[ise]
print @n.xbgr.xm39_u23.nsg13_hv_pmos[ibe]
print @n.xbgr.xm39_u23.nsg13_hv_pmos[ctype]
print @n.xbgr.xm39_u24.nsg13_hv_pmos[ide]
print @n.xbgr.xm39_u24.nsg13_hv_pmos[ige]
print @n.xbgr.xm39_u24.nsg13_hv_pmos[ise]
print @n.xbgr.xm39_u24.nsg13_hv_pmos[ibe]
print @n.xbgr.xm39_u24.nsg13_hv_pmos[ctype]
print @n.xbgr.xm41_u2.nsg13_hv_pmos[ide]
print @n.xbgr.xm41_u2.nsg13_hv_pmos[ige]
print @n.xbgr.xm41_u2.nsg13_hv_pmos[ise]
print @n.xbgr.xm41_u2.nsg13_hv_pmos[ibe]
print @n.xbgr.xm41_u2.nsg13_hv_pmos[ctype]
print @n.xbgr.xm41_u3.nsg13_hv_pmos[ide]
print @n.xbgr.xm41_u3.nsg13_hv_pmos[ige]
print @n.xbgr.xm41_u3.nsg13_hv_pmos[ise]
print @n.xbgr.xm41_u3.nsg13_hv_pmos[ibe]
print @n.xbgr.xm41_u3.nsg13_hv_pmos[ctype]
print @n.xbgr.xm41_u4.nsg13_hv_pmos[ide]
print @n.xbgr.xm41_u4.nsg13_hv_pmos[ige]
print @n.xbgr.xm41_u4.nsg13_hv_pmos[ise]
print @n.xbgr.xm41_u4.nsg13_hv_pmos[ibe]
print @n.xbgr.xm41_u4.nsg13_hv_pmos[ctype]
print @n.xbgr.xm41_u5.nsg13_hv_pmos[ide]
print @n.xbgr.xm41_u5.nsg13_hv_pmos[ige]
print @n.xbgr.xm41_u5.nsg13_hv_pmos[ise]
print @n.xbgr.xm41_u5.nsg13_hv_pmos[ibe]
print @n.xbgr.xm41_u5.nsg13_hv_pmos[ctype]
print @n.xbgr.xm41_u6.nsg13_hv_pmos[ide]
print @n.xbgr.xm41_u6.nsg13_hv_pmos[ige]
print @n.xbgr.xm41_u6.nsg13_hv_pmos[ise]
print @n.xbgr.xm41_u6.nsg13_hv_pmos[ibe]
print @n.xbgr.xm41_u6.nsg13_hv_pmos[ctype]
print @n.xbgr.xm41_u7.nsg13_hv_pmos[ide]
print @n.xbgr.xm41_u7.nsg13_hv_pmos[ige]
print @n.xbgr.xm41_u7.nsg13_hv_pmos[ise]
print @n.xbgr.xm41_u7.nsg13_hv_pmos[ibe]
print @n.xbgr.xm41_u7.nsg13_hv_pmos[ctype]
print @n.xbgr.xm41_u8.nsg13_hv_pmos[ide]
print @n.xbgr.xm41_u8.nsg13_hv_pmos[ige]
print @n.xbgr.xm41_u8.nsg13_hv_pmos[ise]
print @n.xbgr.xm41_u8.nsg13_hv_pmos[ibe]
print @n.xbgr.xm41_u8.nsg13_hv_pmos[ctype]
print @n.xbgr.xm41_u9.nsg13_hv_pmos[ide]
print @n.xbgr.xm41_u9.nsg13_hv_pmos[ige]
print @n.xbgr.xm41_u9.nsg13_hv_pmos[ise]
print @n.xbgr.xm41_u9.nsg13_hv_pmos[ibe]
print @n.xbgr.xm41_u9.nsg13_hv_pmos[ctype]
print @n.xbgr.xm41_u10.nsg13_hv_pmos[ide]
print @n.xbgr.xm41_u10.nsg13_hv_pmos[ige]
print @n.xbgr.xm41_u10.nsg13_hv_pmos[ise]
print @n.xbgr.xm41_u10.nsg13_hv_pmos[ibe]
print @n.xbgr.xm41_u10.nsg13_hv_pmos[ctype]
print @n.xbgr.xm41_u11.nsg13_hv_pmos[ide]
print @n.xbgr.xm41_u11.nsg13_hv_pmos[ige]
print @n.xbgr.xm41_u11.nsg13_hv_pmos[ise]
print @n.xbgr.xm41_u11.nsg13_hv_pmos[ibe]
print @n.xbgr.xm41_u11.nsg13_hv_pmos[ctype]
print @n.xbgr.xm41_u12.nsg13_hv_pmos[ide]
print @n.xbgr.xm41_u12.nsg13_hv_pmos[ige]
print @n.xbgr.xm41_u12.nsg13_hv_pmos[ise]
print @n.xbgr.xm41_u12.nsg13_hv_pmos[ibe]
print @n.xbgr.xm41_u12.nsg13_hv_pmos[ctype]
print @n.xbgr.xm41_u13.nsg13_hv_pmos[ide]
print @n.xbgr.xm41_u13.nsg13_hv_pmos[ige]
print @n.xbgr.xm41_u13.nsg13_hv_pmos[ise]
print @n.xbgr.xm41_u13.nsg13_hv_pmos[ibe]
print @n.xbgr.xm41_u13.nsg13_hv_pmos[ctype]
print @n.xbgr.xm41_u14.nsg13_hv_pmos[ide]
print @n.xbgr.xm41_u14.nsg13_hv_pmos[ige]
print @n.xbgr.xm41_u14.nsg13_hv_pmos[ise]
print @n.xbgr.xm41_u14.nsg13_hv_pmos[ibe]
print @n.xbgr.xm41_u14.nsg13_hv_pmos[ctype]
print @n.xbgr.xm41_u15.nsg13_hv_pmos[ide]
print @n.xbgr.xm41_u15.nsg13_hv_pmos[ige]
print @n.xbgr.xm41_u15.nsg13_hv_pmos[ise]
print @n.xbgr.xm41_u15.nsg13_hv_pmos[ibe]
print @n.xbgr.xm41_u15.nsg13_hv_pmos[ctype]
print @n.xbgr.xm41_u16.nsg13_hv_pmos[ide]
print @n.xbgr.xm41_u16.nsg13_hv_pmos[ige]
print @n.xbgr.xm41_u16.nsg13_hv_pmos[ise]
print @n.xbgr.xm41_u16.nsg13_hv_pmos[ibe]
print @n.xbgr.xm41_u16.nsg13_hv_pmos[ctype]
print @n.xbgr.xm41_u17.nsg13_hv_pmos[ide]
print @n.xbgr.xm41_u17.nsg13_hv_pmos[ige]
print @n.xbgr.xm41_u17.nsg13_hv_pmos[ise]
print @n.xbgr.xm41_u17.nsg13_hv_pmos[ibe]
print @n.xbgr.xm41_u17.nsg13_hv_pmos[ctype]
print @n.xbgr.xm41_u18.nsg13_hv_pmos[ide]
print @n.xbgr.xm41_u18.nsg13_hv_pmos[ige]
print @n.xbgr.xm41_u18.nsg13_hv_pmos[ise]
print @n.xbgr.xm41_u18.nsg13_hv_pmos[ibe]
print @n.xbgr.xm41_u18.nsg13_hv_pmos[ctype]
print @n.xbgr.xm41_u19.nsg13_hv_pmos[ide]
print @n.xbgr.xm41_u19.nsg13_hv_pmos[ige]
print @n.xbgr.xm41_u19.nsg13_hv_pmos[ise]
print @n.xbgr.xm41_u19.nsg13_hv_pmos[ibe]
print @n.xbgr.xm41_u19.nsg13_hv_pmos[ctype]
print @n.xbgr.xm41_u20.nsg13_hv_pmos[ide]
print @n.xbgr.xm41_u20.nsg13_hv_pmos[ige]
print @n.xbgr.xm41_u20.nsg13_hv_pmos[ise]
print @n.xbgr.xm41_u20.nsg13_hv_pmos[ibe]
print @n.xbgr.xm41_u20.nsg13_hv_pmos[ctype]
print @n.xbgr.xm41_u21.nsg13_hv_pmos[ide]
print @n.xbgr.xm41_u21.nsg13_hv_pmos[ige]
print @n.xbgr.xm41_u21.nsg13_hv_pmos[ise]
print @n.xbgr.xm41_u21.nsg13_hv_pmos[ibe]
print @n.xbgr.xm41_u21.nsg13_hv_pmos[ctype]
print @n.xbgr.xm41_u22.nsg13_hv_pmos[ide]
print @n.xbgr.xm41_u22.nsg13_hv_pmos[ige]
print @n.xbgr.xm41_u22.nsg13_hv_pmos[ise]
print @n.xbgr.xm41_u22.nsg13_hv_pmos[ibe]
print @n.xbgr.xm41_u22.nsg13_hv_pmos[ctype]
print @n.xbgr.xm41_u23.nsg13_hv_pmos[ide]
print @n.xbgr.xm41_u23.nsg13_hv_pmos[ige]
print @n.xbgr.xm41_u23.nsg13_hv_pmos[ise]
print @n.xbgr.xm41_u23.nsg13_hv_pmos[ibe]
print @n.xbgr.xm41_u23.nsg13_hv_pmos[ctype]
print @n.xbgr.xm41_u24.nsg13_hv_pmos[ide]
print @n.xbgr.xm41_u24.nsg13_hv_pmos[ige]
print @n.xbgr.xm41_u24.nsg13_hv_pmos[ise]
print @n.xbgr.xm41_u24.nsg13_hv_pmos[ibe]
print @n.xbgr.xm41_u24.nsg13_hv_pmos[ctype]
print @n.xbgr.xm43_u2.nsg13_hv_pmos[ide]
print @n.xbgr.xm43_u2.nsg13_hv_pmos[ige]
print @n.xbgr.xm43_u2.nsg13_hv_pmos[ise]
print @n.xbgr.xm43_u2.nsg13_hv_pmos[ibe]
print @n.xbgr.xm43_u2.nsg13_hv_pmos[ctype]
print @n.xbgr.xm43_u3.nsg13_hv_pmos[ide]
print @n.xbgr.xm43_u3.nsg13_hv_pmos[ige]
print @n.xbgr.xm43_u3.nsg13_hv_pmos[ise]
print @n.xbgr.xm43_u3.nsg13_hv_pmos[ibe]
print @n.xbgr.xm43_u3.nsg13_hv_pmos[ctype]
print @n.xbgr.xm43_u4.nsg13_hv_pmos[ide]
print @n.xbgr.xm43_u4.nsg13_hv_pmos[ige]
print @n.xbgr.xm43_u4.nsg13_hv_pmos[ise]
print @n.xbgr.xm43_u4.nsg13_hv_pmos[ibe]
print @n.xbgr.xm43_u4.nsg13_hv_pmos[ctype]
print @n.xbgr.xm44_u2.nsg13_hv_pmos[ide]
print @n.xbgr.xm44_u2.nsg13_hv_pmos[ige]
print @n.xbgr.xm44_u2.nsg13_hv_pmos[ise]
print @n.xbgr.xm44_u2.nsg13_hv_pmos[ibe]
print @n.xbgr.xm44_u2.nsg13_hv_pmos[ctype]
print @n.xbgr.xm44_u3.nsg13_hv_pmos[ide]
print @n.xbgr.xm44_u3.nsg13_hv_pmos[ige]
print @n.xbgr.xm44_u3.nsg13_hv_pmos[ise]
print @n.xbgr.xm44_u3.nsg13_hv_pmos[ibe]
print @n.xbgr.xm44_u3.nsg13_hv_pmos[ctype]
print @n.xbgr.xm44_u4.nsg13_hv_pmos[ide]
print @n.xbgr.xm44_u4.nsg13_hv_pmos[ige]
print @n.xbgr.xm44_u4.nsg13_hv_pmos[ise]
print @n.xbgr.xm44_u4.nsg13_hv_pmos[ibe]
print @n.xbgr.xm44_u4.nsg13_hv_pmos[ctype]
print @n.xbgr.xm45_u2.nsg13_hv_pmos[ide]
print @n.xbgr.xm45_u2.nsg13_hv_pmos[ige]
print @n.xbgr.xm45_u2.nsg13_hv_pmos[ise]
print @n.xbgr.xm45_u2.nsg13_hv_pmos[ibe]
print @n.xbgr.xm45_u2.nsg13_hv_pmos[ctype]
print @n.xbgr.xm45_u3.nsg13_hv_pmos[ide]
print @n.xbgr.xm45_u3.nsg13_hv_pmos[ige]
print @n.xbgr.xm45_u3.nsg13_hv_pmos[ise]
print @n.xbgr.xm45_u3.nsg13_hv_pmos[ibe]
print @n.xbgr.xm45_u3.nsg13_hv_pmos[ctype]
print @n.xbgr.xm45_u4.nsg13_hv_pmos[ide]
print @n.xbgr.xm45_u4.nsg13_hv_pmos[ige]
print @n.xbgr.xm45_u4.nsg13_hv_pmos[ise]
print @n.xbgr.xm45_u4.nsg13_hv_pmos[ibe]
print @n.xbgr.xm45_u4.nsg13_hv_pmos[ctype]
print @n.xbgr.xm45_u5.nsg13_hv_pmos[ide]
print @n.xbgr.xm45_u5.nsg13_hv_pmos[ige]
print @n.xbgr.xm45_u5.nsg13_hv_pmos[ise]
print @n.xbgr.xm45_u5.nsg13_hv_pmos[ibe]
print @n.xbgr.xm45_u5.nsg13_hv_pmos[ctype]
print @n.xbgr.xm45_u6.nsg13_hv_pmos[ide]
print @n.xbgr.xm45_u6.nsg13_hv_pmos[ige]
print @n.xbgr.xm45_u6.nsg13_hv_pmos[ise]
print @n.xbgr.xm45_u6.nsg13_hv_pmos[ibe]
print @n.xbgr.xm45_u6.nsg13_hv_pmos[ctype]
print @n.xbgr.xm45_u7.nsg13_hv_pmos[ide]
print @n.xbgr.xm45_u7.nsg13_hv_pmos[ige]
print @n.xbgr.xm45_u7.nsg13_hv_pmos[ise]
print @n.xbgr.xm45_u7.nsg13_hv_pmos[ibe]
print @n.xbgr.xm45_u7.nsg13_hv_pmos[ctype]
print @n.xbgr.xm45_u8.nsg13_hv_pmos[ide]
print @n.xbgr.xm45_u8.nsg13_hv_pmos[ige]
print @n.xbgr.xm45_u8.nsg13_hv_pmos[ise]
print @n.xbgr.xm45_u8.nsg13_hv_pmos[ibe]
print @n.xbgr.xm45_u8.nsg13_hv_pmos[ctype]
print @n.xbgr.xm45_u9.nsg13_hv_pmos[ide]
print @n.xbgr.xm45_u9.nsg13_hv_pmos[ige]
print @n.xbgr.xm45_u9.nsg13_hv_pmos[ise]
print @n.xbgr.xm45_u9.nsg13_hv_pmos[ibe]
print @n.xbgr.xm45_u9.nsg13_hv_pmos[ctype]
print @n.xbgr.xm45_u10.nsg13_hv_pmos[ide]
print @n.xbgr.xm45_u10.nsg13_hv_pmos[ige]
print @n.xbgr.xm45_u10.nsg13_hv_pmos[ise]
print @n.xbgr.xm45_u10.nsg13_hv_pmos[ibe]
print @n.xbgr.xm45_u10.nsg13_hv_pmos[ctype]
print @n.xbgr.xm45_u11.nsg13_hv_pmos[ide]
print @n.xbgr.xm45_u11.nsg13_hv_pmos[ige]
print @n.xbgr.xm45_u11.nsg13_hv_pmos[ise]
print @n.xbgr.xm45_u11.nsg13_hv_pmos[ibe]
print @n.xbgr.xm45_u11.nsg13_hv_pmos[ctype]
print @n.xbgr.xm45_u12.nsg13_hv_pmos[ide]
print @n.xbgr.xm45_u12.nsg13_hv_pmos[ige]
print @n.xbgr.xm45_u12.nsg13_hv_pmos[ise]
print @n.xbgr.xm45_u12.nsg13_hv_pmos[ibe]
print @n.xbgr.xm45_u12.nsg13_hv_pmos[ctype]
print @n.xbgr.xm45_u13.nsg13_hv_pmos[ide]
print @n.xbgr.xm45_u13.nsg13_hv_pmos[ige]
print @n.xbgr.xm45_u13.nsg13_hv_pmos[ise]
print @n.xbgr.xm45_u13.nsg13_hv_pmos[ibe]
print @n.xbgr.xm45_u13.nsg13_hv_pmos[ctype]
print @n.xbgr.xm45_u14.nsg13_hv_pmos[ide]
print @n.xbgr.xm45_u14.nsg13_hv_pmos[ige]
print @n.xbgr.xm45_u14.nsg13_hv_pmos[ise]
print @n.xbgr.xm45_u14.nsg13_hv_pmos[ibe]
print @n.xbgr.xm45_u14.nsg13_hv_pmos[ctype]
print @n.xbgr.xm45_u15.nsg13_hv_pmos[ide]
print @n.xbgr.xm45_u15.nsg13_hv_pmos[ige]
print @n.xbgr.xm45_u15.nsg13_hv_pmos[ise]
print @n.xbgr.xm45_u15.nsg13_hv_pmos[ibe]
print @n.xbgr.xm45_u15.nsg13_hv_pmos[ctype]
print @n.xbgr.xm45_u16.nsg13_hv_pmos[ide]
print @n.xbgr.xm45_u16.nsg13_hv_pmos[ige]
print @n.xbgr.xm45_u16.nsg13_hv_pmos[ise]
print @n.xbgr.xm45_u16.nsg13_hv_pmos[ibe]
print @n.xbgr.xm45_u16.nsg13_hv_pmos[ctype]
print @n.xbgr.xm45_u17.nsg13_hv_pmos[ide]
print @n.xbgr.xm45_u17.nsg13_hv_pmos[ige]
print @n.xbgr.xm45_u17.nsg13_hv_pmos[ise]
print @n.xbgr.xm45_u17.nsg13_hv_pmos[ibe]
print @n.xbgr.xm45_u17.nsg13_hv_pmos[ctype]
print @n.xbgr.xm45_u18.nsg13_hv_pmos[ide]
print @n.xbgr.xm45_u18.nsg13_hv_pmos[ige]
print @n.xbgr.xm45_u18.nsg13_hv_pmos[ise]
print @n.xbgr.xm45_u18.nsg13_hv_pmos[ibe]
print @n.xbgr.xm45_u18.nsg13_hv_pmos[ctype]
print @n.xbgr.xm45_u19.nsg13_hv_pmos[ide]
print @n.xbgr.xm45_u19.nsg13_hv_pmos[ige]
print @n.xbgr.xm45_u19.nsg13_hv_pmos[ise]
print @n.xbgr.xm45_u19.nsg13_hv_pmos[ibe]
print @n.xbgr.xm45_u19.nsg13_hv_pmos[ctype]
print @n.xbgr.xm45_u20.nsg13_hv_pmos[ide]
print @n.xbgr.xm45_u20.nsg13_hv_pmos[ige]
print @n.xbgr.xm45_u20.nsg13_hv_pmos[ise]
print @n.xbgr.xm45_u20.nsg13_hv_pmos[ibe]
print @n.xbgr.xm45_u20.nsg13_hv_pmos[ctype]
print @n.xbgr.xm45_u21.nsg13_hv_pmos[ide]
print @n.xbgr.xm45_u21.nsg13_hv_pmos[ige]
print @n.xbgr.xm45_u21.nsg13_hv_pmos[ise]
print @n.xbgr.xm45_u21.nsg13_hv_pmos[ibe]
print @n.xbgr.xm45_u21.nsg13_hv_pmos[ctype]
print @n.xbgr.xm45_u22.nsg13_hv_pmos[ide]
print @n.xbgr.xm45_u22.nsg13_hv_pmos[ige]
print @n.xbgr.xm45_u22.nsg13_hv_pmos[ise]
print @n.xbgr.xm45_u22.nsg13_hv_pmos[ibe]
print @n.xbgr.xm45_u22.nsg13_hv_pmos[ctype]
print @n.xbgr.xm45_u23.nsg13_hv_pmos[ide]
print @n.xbgr.xm45_u23.nsg13_hv_pmos[ige]
print @n.xbgr.xm45_u23.nsg13_hv_pmos[ise]
print @n.xbgr.xm45_u23.nsg13_hv_pmos[ibe]
print @n.xbgr.xm45_u23.nsg13_hv_pmos[ctype]
print @n.xbgr.xm45_u24.nsg13_hv_pmos[ide]
print @n.xbgr.xm45_u24.nsg13_hv_pmos[ige]
print @n.xbgr.xm45_u24.nsg13_hv_pmos[ise]
print @n.xbgr.xm45_u24.nsg13_hv_pmos[ibe]
print @n.xbgr.xm45_u24.nsg13_hv_pmos[ctype]
print @n.xbgr.xm47_u2.nsg13_hv_pmos[ide]
print @n.xbgr.xm47_u2.nsg13_hv_pmos[ige]
print @n.xbgr.xm47_u2.nsg13_hv_pmos[ise]
print @n.xbgr.xm47_u2.nsg13_hv_pmos[ibe]
print @n.xbgr.xm47_u2.nsg13_hv_pmos[ctype]
print @n.xbgr.xm47_u3.nsg13_hv_pmos[ide]
print @n.xbgr.xm47_u3.nsg13_hv_pmos[ige]
print @n.xbgr.xm47_u3.nsg13_hv_pmos[ise]
print @n.xbgr.xm47_u3.nsg13_hv_pmos[ibe]
print @n.xbgr.xm47_u3.nsg13_hv_pmos[ctype]
print @n.xbgr.xm47_u4.nsg13_hv_pmos[ide]
print @n.xbgr.xm47_u4.nsg13_hv_pmos[ige]
print @n.xbgr.xm47_u4.nsg13_hv_pmos[ise]
print @n.xbgr.xm47_u4.nsg13_hv_pmos[ibe]
print @n.xbgr.xm47_u4.nsg13_hv_pmos[ctype]
print @n.xbgr.xm47_u5.nsg13_hv_pmos[ide]
print @n.xbgr.xm47_u5.nsg13_hv_pmos[ige]
print @n.xbgr.xm47_u5.nsg13_hv_pmos[ise]
print @n.xbgr.xm47_u5.nsg13_hv_pmos[ibe]
print @n.xbgr.xm47_u5.nsg13_hv_pmos[ctype]
print @n.xbgr.xm47_u6.nsg13_hv_pmos[ide]
print @n.xbgr.xm47_u6.nsg13_hv_pmos[ige]
print @n.xbgr.xm47_u6.nsg13_hv_pmos[ise]
print @n.xbgr.xm47_u6.nsg13_hv_pmos[ibe]
print @n.xbgr.xm47_u6.nsg13_hv_pmos[ctype]
print @n.xbgr.xm47_u7.nsg13_hv_pmos[ide]
print @n.xbgr.xm47_u7.nsg13_hv_pmos[ige]
print @n.xbgr.xm47_u7.nsg13_hv_pmos[ise]
print @n.xbgr.xm47_u7.nsg13_hv_pmos[ibe]
print @n.xbgr.xm47_u7.nsg13_hv_pmos[ctype]
print @n.xbgr.xm47_u8.nsg13_hv_pmos[ide]
print @n.xbgr.xm47_u8.nsg13_hv_pmos[ige]
print @n.xbgr.xm47_u8.nsg13_hv_pmos[ise]
print @n.xbgr.xm47_u8.nsg13_hv_pmos[ibe]
print @n.xbgr.xm47_u8.nsg13_hv_pmos[ctype]
print @n.xbgr.xm47_u9.nsg13_hv_pmos[ide]
print @n.xbgr.xm47_u9.nsg13_hv_pmos[ige]
print @n.xbgr.xm47_u9.nsg13_hv_pmos[ise]
print @n.xbgr.xm47_u9.nsg13_hv_pmos[ibe]
print @n.xbgr.xm47_u9.nsg13_hv_pmos[ctype]
print @n.xbgr.xm47_u10.nsg13_hv_pmos[ide]
print @n.xbgr.xm47_u10.nsg13_hv_pmos[ige]
print @n.xbgr.xm47_u10.nsg13_hv_pmos[ise]
print @n.xbgr.xm47_u10.nsg13_hv_pmos[ibe]
print @n.xbgr.xm47_u10.nsg13_hv_pmos[ctype]
print @n.xbgr.xm47_u11.nsg13_hv_pmos[ide]
print @n.xbgr.xm47_u11.nsg13_hv_pmos[ige]
print @n.xbgr.xm47_u11.nsg13_hv_pmos[ise]
print @n.xbgr.xm47_u11.nsg13_hv_pmos[ibe]
print @n.xbgr.xm47_u11.nsg13_hv_pmos[ctype]
print @n.xbgr.xm47_u12.nsg13_hv_pmos[ide]
print @n.xbgr.xm47_u12.nsg13_hv_pmos[ige]
print @n.xbgr.xm47_u12.nsg13_hv_pmos[ise]
print @n.xbgr.xm47_u12.nsg13_hv_pmos[ibe]
print @n.xbgr.xm47_u12.nsg13_hv_pmos[ctype]
print @n.xbgr.xm47_u13.nsg13_hv_pmos[ide]
print @n.xbgr.xm47_u13.nsg13_hv_pmos[ige]
print @n.xbgr.xm47_u13.nsg13_hv_pmos[ise]
print @n.xbgr.xm47_u13.nsg13_hv_pmos[ibe]
print @n.xbgr.xm47_u13.nsg13_hv_pmos[ctype]
print @n.xbgr.xm47_u14.nsg13_hv_pmos[ide]
print @n.xbgr.xm47_u14.nsg13_hv_pmos[ige]
print @n.xbgr.xm47_u14.nsg13_hv_pmos[ise]
print @n.xbgr.xm47_u14.nsg13_hv_pmos[ibe]
print @n.xbgr.xm47_u14.nsg13_hv_pmos[ctype]
print @n.xbgr.xm47_u15.nsg13_hv_pmos[ide]
print @n.xbgr.xm47_u15.nsg13_hv_pmos[ige]
print @n.xbgr.xm47_u15.nsg13_hv_pmos[ise]
print @n.xbgr.xm47_u15.nsg13_hv_pmos[ibe]
print @n.xbgr.xm47_u15.nsg13_hv_pmos[ctype]
print @n.xbgr.xm47_u16.nsg13_hv_pmos[ide]
print @n.xbgr.xm47_u16.nsg13_hv_pmos[ige]
print @n.xbgr.xm47_u16.nsg13_hv_pmos[ise]
print @n.xbgr.xm47_u16.nsg13_hv_pmos[ibe]
print @n.xbgr.xm47_u16.nsg13_hv_pmos[ctype]
print @n.xbgr.xm47_u17.nsg13_hv_pmos[ide]
print @n.xbgr.xm47_u17.nsg13_hv_pmos[ige]
print @n.xbgr.xm47_u17.nsg13_hv_pmos[ise]
print @n.xbgr.xm47_u17.nsg13_hv_pmos[ibe]
print @n.xbgr.xm47_u17.nsg13_hv_pmos[ctype]
print @n.xbgr.xm47_u18.nsg13_hv_pmos[ide]
print @n.xbgr.xm47_u18.nsg13_hv_pmos[ige]
print @n.xbgr.xm47_u18.nsg13_hv_pmos[ise]
print @n.xbgr.xm47_u18.nsg13_hv_pmos[ibe]
print @n.xbgr.xm47_u18.nsg13_hv_pmos[ctype]
print @n.xbgr.xm47_u19.nsg13_hv_pmos[ide]
print @n.xbgr.xm47_u19.nsg13_hv_pmos[ige]
print @n.xbgr.xm47_u19.nsg13_hv_pmos[ise]
print @n.xbgr.xm47_u19.nsg13_hv_pmos[ibe]
print @n.xbgr.xm47_u19.nsg13_hv_pmos[ctype]
print @n.xbgr.xm47_u20.nsg13_hv_pmos[ide]
print @n.xbgr.xm47_u20.nsg13_hv_pmos[ige]
print @n.xbgr.xm47_u20.nsg13_hv_pmos[ise]
print @n.xbgr.xm47_u20.nsg13_hv_pmos[ibe]
print @n.xbgr.xm47_u20.nsg13_hv_pmos[ctype]
print @n.xbgr.xm47_u21.nsg13_hv_pmos[ide]
print @n.xbgr.xm47_u21.nsg13_hv_pmos[ige]
print @n.xbgr.xm47_u21.nsg13_hv_pmos[ise]
print @n.xbgr.xm47_u21.nsg13_hv_pmos[ibe]
print @n.xbgr.xm47_u21.nsg13_hv_pmos[ctype]
print @n.xbgr.xm47_u22.nsg13_hv_pmos[ide]
print @n.xbgr.xm47_u22.nsg13_hv_pmos[ige]
print @n.xbgr.xm47_u22.nsg13_hv_pmos[ise]
print @n.xbgr.xm47_u22.nsg13_hv_pmos[ibe]
print @n.xbgr.xm47_u22.nsg13_hv_pmos[ctype]
print @n.xbgr.xm47_u23.nsg13_hv_pmos[ide]
print @n.xbgr.xm47_u23.nsg13_hv_pmos[ige]
print @n.xbgr.xm47_u23.nsg13_hv_pmos[ise]
print @n.xbgr.xm47_u23.nsg13_hv_pmos[ibe]
print @n.xbgr.xm47_u23.nsg13_hv_pmos[ctype]
print @n.xbgr.xm47_u24.nsg13_hv_pmos[ide]
print @n.xbgr.xm47_u24.nsg13_hv_pmos[ige]
print @n.xbgr.xm47_u24.nsg13_hv_pmos[ise]
print @n.xbgr.xm47_u24.nsg13_hv_pmos[ibe]
print @n.xbgr.xm47_u24.nsg13_hv_pmos[ctype]
print @n.xbgr.xm48_u2.nsg13_hv_pmos[ide]
print @n.xbgr.xm48_u2.nsg13_hv_pmos[ige]
print @n.xbgr.xm48_u2.nsg13_hv_pmos[ise]
print @n.xbgr.xm48_u2.nsg13_hv_pmos[ibe]
print @n.xbgr.xm48_u2.nsg13_hv_pmos[ctype]
print @n.xbgr.xm48_u3.nsg13_hv_pmos[ide]
print @n.xbgr.xm48_u3.nsg13_hv_pmos[ige]
print @n.xbgr.xm48_u3.nsg13_hv_pmos[ise]
print @n.xbgr.xm48_u3.nsg13_hv_pmos[ibe]
print @n.xbgr.xm48_u3.nsg13_hv_pmos[ctype]
print @n.xbgr.xm48_u4.nsg13_hv_pmos[ide]
print @n.xbgr.xm48_u4.nsg13_hv_pmos[ige]
print @n.xbgr.xm48_u4.nsg13_hv_pmos[ise]
print @n.xbgr.xm48_u4.nsg13_hv_pmos[ibe]
print @n.xbgr.xm48_u4.nsg13_hv_pmos[ctype]
print @n.xbgr.xm48_u5.nsg13_hv_pmos[ide]
print @n.xbgr.xm48_u5.nsg13_hv_pmos[ige]
print @n.xbgr.xm48_u5.nsg13_hv_pmos[ise]
print @n.xbgr.xm48_u5.nsg13_hv_pmos[ibe]
print @n.xbgr.xm48_u5.nsg13_hv_pmos[ctype]
print @n.xbgr.xm48_u6.nsg13_hv_pmos[ide]
print @n.xbgr.xm48_u6.nsg13_hv_pmos[ige]
print @n.xbgr.xm48_u6.nsg13_hv_pmos[ise]
print @n.xbgr.xm48_u6.nsg13_hv_pmos[ibe]
print @n.xbgr.xm48_u6.nsg13_hv_pmos[ctype]
print @n.xbgr.xm48_u7.nsg13_hv_pmos[ide]
print @n.xbgr.xm48_u7.nsg13_hv_pmos[ige]
print @n.xbgr.xm48_u7.nsg13_hv_pmos[ise]
print @n.xbgr.xm48_u7.nsg13_hv_pmos[ibe]
print @n.xbgr.xm48_u7.nsg13_hv_pmos[ctype]
print @n.xbgr.xm48_u8.nsg13_hv_pmos[ide]
print @n.xbgr.xm48_u8.nsg13_hv_pmos[ige]
print @n.xbgr.xm48_u8.nsg13_hv_pmos[ise]
print @n.xbgr.xm48_u8.nsg13_hv_pmos[ibe]
print @n.xbgr.xm48_u8.nsg13_hv_pmos[ctype]
print @n.xbgr.xm48_u9.nsg13_hv_pmos[ide]
print @n.xbgr.xm48_u9.nsg13_hv_pmos[ige]
print @n.xbgr.xm48_u9.nsg13_hv_pmos[ise]
print @n.xbgr.xm48_u9.nsg13_hv_pmos[ibe]
print @n.xbgr.xm48_u9.nsg13_hv_pmos[ctype]
print @n.xbgr.xm48_u10.nsg13_hv_pmos[ide]
print @n.xbgr.xm48_u10.nsg13_hv_pmos[ige]
print @n.xbgr.xm48_u10.nsg13_hv_pmos[ise]
print @n.xbgr.xm48_u10.nsg13_hv_pmos[ibe]
print @n.xbgr.xm48_u10.nsg13_hv_pmos[ctype]
print @n.xbgr.xm48_u11.nsg13_hv_pmos[ide]
print @n.xbgr.xm48_u11.nsg13_hv_pmos[ige]
print @n.xbgr.xm48_u11.nsg13_hv_pmos[ise]
print @n.xbgr.xm48_u11.nsg13_hv_pmos[ibe]
print @n.xbgr.xm48_u11.nsg13_hv_pmos[ctype]
print @n.xbgr.xm48_u12.nsg13_hv_pmos[ide]
print @n.xbgr.xm48_u12.nsg13_hv_pmos[ige]
print @n.xbgr.xm48_u12.nsg13_hv_pmos[ise]
print @n.xbgr.xm48_u12.nsg13_hv_pmos[ibe]
print @n.xbgr.xm48_u12.nsg13_hv_pmos[ctype]
print @n.xbgr.xm48_u13.nsg13_hv_pmos[ide]
print @n.xbgr.xm48_u13.nsg13_hv_pmos[ige]
print @n.xbgr.xm48_u13.nsg13_hv_pmos[ise]
print @n.xbgr.xm48_u13.nsg13_hv_pmos[ibe]
print @n.xbgr.xm48_u13.nsg13_hv_pmos[ctype]
print @n.xbgr.xm48_u14.nsg13_hv_pmos[ide]
print @n.xbgr.xm48_u14.nsg13_hv_pmos[ige]
print @n.xbgr.xm48_u14.nsg13_hv_pmos[ise]
print @n.xbgr.xm48_u14.nsg13_hv_pmos[ibe]
print @n.xbgr.xm48_u14.nsg13_hv_pmos[ctype]
print @n.xbgr.xm48_u15.nsg13_hv_pmos[ide]
print @n.xbgr.xm48_u15.nsg13_hv_pmos[ige]
print @n.xbgr.xm48_u15.nsg13_hv_pmos[ise]
print @n.xbgr.xm48_u15.nsg13_hv_pmos[ibe]
print @n.xbgr.xm48_u15.nsg13_hv_pmos[ctype]
print @n.xbgr.xm48_u16.nsg13_hv_pmos[ide]
print @n.xbgr.xm48_u16.nsg13_hv_pmos[ige]
print @n.xbgr.xm48_u16.nsg13_hv_pmos[ise]
print @n.xbgr.xm48_u16.nsg13_hv_pmos[ibe]
print @n.xbgr.xm48_u16.nsg13_hv_pmos[ctype]
print @n.xbgr.xm48_u17.nsg13_hv_pmos[ide]
print @n.xbgr.xm48_u17.nsg13_hv_pmos[ige]
print @n.xbgr.xm48_u17.nsg13_hv_pmos[ise]
print @n.xbgr.xm48_u17.nsg13_hv_pmos[ibe]
print @n.xbgr.xm48_u17.nsg13_hv_pmos[ctype]
print @n.xbgr.xm48_u18.nsg13_hv_pmos[ide]
print @n.xbgr.xm48_u18.nsg13_hv_pmos[ige]
print @n.xbgr.xm48_u18.nsg13_hv_pmos[ise]
print @n.xbgr.xm48_u18.nsg13_hv_pmos[ibe]
print @n.xbgr.xm48_u18.nsg13_hv_pmos[ctype]
print @n.xbgr.xm48_u19.nsg13_hv_pmos[ide]
print @n.xbgr.xm48_u19.nsg13_hv_pmos[ige]
print @n.xbgr.xm48_u19.nsg13_hv_pmos[ise]
print @n.xbgr.xm48_u19.nsg13_hv_pmos[ibe]
print @n.xbgr.xm48_u19.nsg13_hv_pmos[ctype]
print @n.xbgr.xm48_u20.nsg13_hv_pmos[ide]
print @n.xbgr.xm48_u20.nsg13_hv_pmos[ige]
print @n.xbgr.xm48_u20.nsg13_hv_pmos[ise]
print @n.xbgr.xm48_u20.nsg13_hv_pmos[ibe]
print @n.xbgr.xm48_u20.nsg13_hv_pmos[ctype]
print @n.xbgr.xm48_u21.nsg13_hv_pmos[ide]
print @n.xbgr.xm48_u21.nsg13_hv_pmos[ige]
print @n.xbgr.xm48_u21.nsg13_hv_pmos[ise]
print @n.xbgr.xm48_u21.nsg13_hv_pmos[ibe]
print @n.xbgr.xm48_u21.nsg13_hv_pmos[ctype]
print @n.xbgr.xm48_u22.nsg13_hv_pmos[ide]
print @n.xbgr.xm48_u22.nsg13_hv_pmos[ige]
print @n.xbgr.xm48_u22.nsg13_hv_pmos[ise]
print @n.xbgr.xm48_u22.nsg13_hv_pmos[ibe]
print @n.xbgr.xm48_u22.nsg13_hv_pmos[ctype]
print @n.xbgr.xm48_u23.nsg13_hv_pmos[ide]
print @n.xbgr.xm48_u23.nsg13_hv_pmos[ige]
print @n.xbgr.xm48_u23.nsg13_hv_pmos[ise]
print @n.xbgr.xm48_u23.nsg13_hv_pmos[ibe]
print @n.xbgr.xm48_u23.nsg13_hv_pmos[ctype]
print @n.xbgr.xm48_u24.nsg13_hv_pmos[ide]
print @n.xbgr.xm48_u24.nsg13_hv_pmos[ige]
print @n.xbgr.xm48_u24.nsg13_hv_pmos[ise]
print @n.xbgr.xm48_u24.nsg13_hv_pmos[ibe]
print @n.xbgr.xm48_u24.nsg13_hv_pmos[ctype]
print @n.xbgr.xm50_u2.nsg13_hv_pmos[ide]
print @n.xbgr.xm50_u2.nsg13_hv_pmos[ige]
print @n.xbgr.xm50_u2.nsg13_hv_pmos[ise]
print @n.xbgr.xm50_u2.nsg13_hv_pmos[ibe]
print @n.xbgr.xm50_u2.nsg13_hv_pmos[ctype]
print @n.xbgr.xm50_u3.nsg13_hv_pmos[ide]
print @n.xbgr.xm50_u3.nsg13_hv_pmos[ige]
print @n.xbgr.xm50_u3.nsg13_hv_pmos[ise]
print @n.xbgr.xm50_u3.nsg13_hv_pmos[ibe]
print @n.xbgr.xm50_u3.nsg13_hv_pmos[ctype]
print @n.xbgr.xm50_u4.nsg13_hv_pmos[ide]
print @n.xbgr.xm50_u4.nsg13_hv_pmos[ige]
print @n.xbgr.xm50_u4.nsg13_hv_pmos[ise]
print @n.xbgr.xm50_u4.nsg13_hv_pmos[ibe]
print @n.xbgr.xm50_u4.nsg13_hv_pmos[ctype]
print @n.xbgr.xm50_u5.nsg13_hv_pmos[ide]
print @n.xbgr.xm50_u5.nsg13_hv_pmos[ige]
print @n.xbgr.xm50_u5.nsg13_hv_pmos[ise]
print @n.xbgr.xm50_u5.nsg13_hv_pmos[ibe]
print @n.xbgr.xm50_u5.nsg13_hv_pmos[ctype]
print @n.xbgr.xm50_u6.nsg13_hv_pmos[ide]
print @n.xbgr.xm50_u6.nsg13_hv_pmos[ige]
print @n.xbgr.xm50_u6.nsg13_hv_pmos[ise]
print @n.xbgr.xm50_u6.nsg13_hv_pmos[ibe]
print @n.xbgr.xm50_u6.nsg13_hv_pmos[ctype]
print @n.xbgr.xm50_u7.nsg13_hv_pmos[ide]
print @n.xbgr.xm50_u7.nsg13_hv_pmos[ige]
print @n.xbgr.xm50_u7.nsg13_hv_pmos[ise]
print @n.xbgr.xm50_u7.nsg13_hv_pmos[ibe]
print @n.xbgr.xm50_u7.nsg13_hv_pmos[ctype]
print @n.xbgr.xm50_u8.nsg13_hv_pmos[ide]
print @n.xbgr.xm50_u8.nsg13_hv_pmos[ige]
print @n.xbgr.xm50_u8.nsg13_hv_pmos[ise]
print @n.xbgr.xm50_u8.nsg13_hv_pmos[ibe]
print @n.xbgr.xm50_u8.nsg13_hv_pmos[ctype]
print @n.xbgr.xm50_u9.nsg13_hv_pmos[ide]
print @n.xbgr.xm50_u9.nsg13_hv_pmos[ige]
print @n.xbgr.xm50_u9.nsg13_hv_pmos[ise]
print @n.xbgr.xm50_u9.nsg13_hv_pmos[ibe]
print @n.xbgr.xm50_u9.nsg13_hv_pmos[ctype]
print @n.xbgr.xm50_u10.nsg13_hv_pmos[ide]
print @n.xbgr.xm50_u10.nsg13_hv_pmos[ige]
print @n.xbgr.xm50_u10.nsg13_hv_pmos[ise]
print @n.xbgr.xm50_u10.nsg13_hv_pmos[ibe]
print @n.xbgr.xm50_u10.nsg13_hv_pmos[ctype]
print @n.xbgr.xm50_u11.nsg13_hv_pmos[ide]
print @n.xbgr.xm50_u11.nsg13_hv_pmos[ige]
print @n.xbgr.xm50_u11.nsg13_hv_pmos[ise]
print @n.xbgr.xm50_u11.nsg13_hv_pmos[ibe]
print @n.xbgr.xm50_u11.nsg13_hv_pmos[ctype]
print @n.xbgr.xm50_u12.nsg13_hv_pmos[ide]
print @n.xbgr.xm50_u12.nsg13_hv_pmos[ige]
print @n.xbgr.xm50_u12.nsg13_hv_pmos[ise]
print @n.xbgr.xm50_u12.nsg13_hv_pmos[ibe]
print @n.xbgr.xm50_u12.nsg13_hv_pmos[ctype]
print @n.xbgr.xm50_u13.nsg13_hv_pmos[ide]
print @n.xbgr.xm50_u13.nsg13_hv_pmos[ige]
print @n.xbgr.xm50_u13.nsg13_hv_pmos[ise]
print @n.xbgr.xm50_u13.nsg13_hv_pmos[ibe]
print @n.xbgr.xm50_u13.nsg13_hv_pmos[ctype]
print @n.xbgr.xm50_u14.nsg13_hv_pmos[ide]
print @n.xbgr.xm50_u14.nsg13_hv_pmos[ige]
print @n.xbgr.xm50_u14.nsg13_hv_pmos[ise]
print @n.xbgr.xm50_u14.nsg13_hv_pmos[ibe]
print @n.xbgr.xm50_u14.nsg13_hv_pmos[ctype]
print @n.xbgr.xm50_u15.nsg13_hv_pmos[ide]
print @n.xbgr.xm50_u15.nsg13_hv_pmos[ige]
print @n.xbgr.xm50_u15.nsg13_hv_pmos[ise]
print @n.xbgr.xm50_u15.nsg13_hv_pmos[ibe]
print @n.xbgr.xm50_u15.nsg13_hv_pmos[ctype]
print @n.xbgr.xm50_u16.nsg13_hv_pmos[ide]
print @n.xbgr.xm50_u16.nsg13_hv_pmos[ige]
print @n.xbgr.xm50_u16.nsg13_hv_pmos[ise]
print @n.xbgr.xm50_u16.nsg13_hv_pmos[ibe]
print @n.xbgr.xm50_u16.nsg13_hv_pmos[ctype]
print @n.xbgr.xm50_u17.nsg13_hv_pmos[ide]
print @n.xbgr.xm50_u17.nsg13_hv_pmos[ige]
print @n.xbgr.xm50_u17.nsg13_hv_pmos[ise]
print @n.xbgr.xm50_u17.nsg13_hv_pmos[ibe]
print @n.xbgr.xm50_u17.nsg13_hv_pmos[ctype]
print @n.xbgr.xm50_u18.nsg13_hv_pmos[ide]
print @n.xbgr.xm50_u18.nsg13_hv_pmos[ige]
print @n.xbgr.xm50_u18.nsg13_hv_pmos[ise]
print @n.xbgr.xm50_u18.nsg13_hv_pmos[ibe]
print @n.xbgr.xm50_u18.nsg13_hv_pmos[ctype]
print @n.xbgr.xm50_u19.nsg13_hv_pmos[ide]
print @n.xbgr.xm50_u19.nsg13_hv_pmos[ige]
print @n.xbgr.xm50_u19.nsg13_hv_pmos[ise]
print @n.xbgr.xm50_u19.nsg13_hv_pmos[ibe]
print @n.xbgr.xm50_u19.nsg13_hv_pmos[ctype]
print @n.xbgr.xm50_u20.nsg13_hv_pmos[ide]
print @n.xbgr.xm50_u20.nsg13_hv_pmos[ige]
print @n.xbgr.xm50_u20.nsg13_hv_pmos[ise]
print @n.xbgr.xm50_u20.nsg13_hv_pmos[ibe]
print @n.xbgr.xm50_u20.nsg13_hv_pmos[ctype]
print @n.xbgr.xm50_u21.nsg13_hv_pmos[ide]
print @n.xbgr.xm50_u21.nsg13_hv_pmos[ige]
print @n.xbgr.xm50_u21.nsg13_hv_pmos[ise]
print @n.xbgr.xm50_u21.nsg13_hv_pmos[ibe]
print @n.xbgr.xm50_u21.nsg13_hv_pmos[ctype]
print @n.xbgr.xm50_u22.nsg13_hv_pmos[ide]
print @n.xbgr.xm50_u22.nsg13_hv_pmos[ige]
print @n.xbgr.xm50_u22.nsg13_hv_pmos[ise]
print @n.xbgr.xm50_u22.nsg13_hv_pmos[ibe]
print @n.xbgr.xm50_u22.nsg13_hv_pmos[ctype]
print @n.xbgr.xm50_u23.nsg13_hv_pmos[ide]
print @n.xbgr.xm50_u23.nsg13_hv_pmos[ige]
print @n.xbgr.xm50_u23.nsg13_hv_pmos[ise]
print @n.xbgr.xm50_u23.nsg13_hv_pmos[ibe]
print @n.xbgr.xm50_u23.nsg13_hv_pmos[ctype]
print @n.xbgr.xm50_u24.nsg13_hv_pmos[ide]
print @n.xbgr.xm50_u24.nsg13_hv_pmos[ige]
print @n.xbgr.xm50_u24.nsg13_hv_pmos[ise]
print @n.xbgr.xm50_u24.nsg13_hv_pmos[ibe]
print @n.xbgr.xm50_u24.nsg13_hv_pmos[ctype]
print @n.xbgr.xm51_u2.nsg13_hv_pmos[ide]
print @n.xbgr.xm51_u2.nsg13_hv_pmos[ige]
print @n.xbgr.xm51_u2.nsg13_hv_pmos[ise]
print @n.xbgr.xm51_u2.nsg13_hv_pmos[ibe]
print @n.xbgr.xm51_u2.nsg13_hv_pmos[ctype]
print @n.xbgr.xm51_u3.nsg13_hv_pmos[ide]
print @n.xbgr.xm51_u3.nsg13_hv_pmos[ige]
print @n.xbgr.xm51_u3.nsg13_hv_pmos[ise]
print @n.xbgr.xm51_u3.nsg13_hv_pmos[ibe]
print @n.xbgr.xm51_u3.nsg13_hv_pmos[ctype]
print @n.xbgr.xm51_u4.nsg13_hv_pmos[ide]
print @n.xbgr.xm51_u4.nsg13_hv_pmos[ige]
print @n.xbgr.xm51_u4.nsg13_hv_pmos[ise]
print @n.xbgr.xm51_u4.nsg13_hv_pmos[ibe]
print @n.xbgr.xm51_u4.nsg13_hv_pmos[ctype]
print @n.xbgr.xm52_u2.nsg13_hv_pmos[ide]
print @n.xbgr.xm52_u2.nsg13_hv_pmos[ige]
print @n.xbgr.xm52_u2.nsg13_hv_pmos[ise]
print @n.xbgr.xm52_u2.nsg13_hv_pmos[ibe]
print @n.xbgr.xm52_u2.nsg13_hv_pmos[ctype]
print @n.xbgr.xm52_u3.nsg13_hv_pmos[ide]
print @n.xbgr.xm52_u3.nsg13_hv_pmos[ige]
print @n.xbgr.xm52_u3.nsg13_hv_pmos[ise]
print @n.xbgr.xm52_u3.nsg13_hv_pmos[ibe]
print @n.xbgr.xm52_u3.nsg13_hv_pmos[ctype]
print @n.xbgr.xm52_u4.nsg13_hv_pmos[ide]
print @n.xbgr.xm52_u4.nsg13_hv_pmos[ige]
print @n.xbgr.xm52_u4.nsg13_hv_pmos[ise]
print @n.xbgr.xm52_u4.nsg13_hv_pmos[ibe]
print @n.xbgr.xm52_u4.nsg13_hv_pmos[ctype]
print @n.xbgr.xm52_u5.nsg13_hv_pmos[ide]
print @n.xbgr.xm52_u5.nsg13_hv_pmos[ige]
print @n.xbgr.xm52_u5.nsg13_hv_pmos[ise]
print @n.xbgr.xm52_u5.nsg13_hv_pmos[ibe]
print @n.xbgr.xm52_u5.nsg13_hv_pmos[ctype]
print @n.xbgr.xm52_u6.nsg13_hv_pmos[ide]
print @n.xbgr.xm52_u6.nsg13_hv_pmos[ige]
print @n.xbgr.xm52_u6.nsg13_hv_pmos[ise]
print @n.xbgr.xm52_u6.nsg13_hv_pmos[ibe]
print @n.xbgr.xm52_u6.nsg13_hv_pmos[ctype]
print @n.xbgr.xm52_u7.nsg13_hv_pmos[ide]
print @n.xbgr.xm52_u7.nsg13_hv_pmos[ige]
print @n.xbgr.xm52_u7.nsg13_hv_pmos[ise]
print @n.xbgr.xm52_u7.nsg13_hv_pmos[ibe]
print @n.xbgr.xm52_u7.nsg13_hv_pmos[ctype]
print @n.xbgr.xm52_u8.nsg13_hv_pmos[ide]
print @n.xbgr.xm52_u8.nsg13_hv_pmos[ige]
print @n.xbgr.xm52_u8.nsg13_hv_pmos[ise]
print @n.xbgr.xm52_u8.nsg13_hv_pmos[ibe]
print @n.xbgr.xm52_u8.nsg13_hv_pmos[ctype]
print @n.xbgr.xm52_u9.nsg13_hv_pmos[ide]
print @n.xbgr.xm52_u9.nsg13_hv_pmos[ige]
print @n.xbgr.xm52_u9.nsg13_hv_pmos[ise]
print @n.xbgr.xm52_u9.nsg13_hv_pmos[ibe]
print @n.xbgr.xm52_u9.nsg13_hv_pmos[ctype]
print @n.xbgr.xm52_u10.nsg13_hv_pmos[ide]
print @n.xbgr.xm52_u10.nsg13_hv_pmos[ige]
print @n.xbgr.xm52_u10.nsg13_hv_pmos[ise]
print @n.xbgr.xm52_u10.nsg13_hv_pmos[ibe]
print @n.xbgr.xm52_u10.nsg13_hv_pmos[ctype]
print @n.xbgr.xm52_u11.nsg13_hv_pmos[ide]
print @n.xbgr.xm52_u11.nsg13_hv_pmos[ige]
print @n.xbgr.xm52_u11.nsg13_hv_pmos[ise]
print @n.xbgr.xm52_u11.nsg13_hv_pmos[ibe]
print @n.xbgr.xm52_u11.nsg13_hv_pmos[ctype]
print @n.xbgr.xm52_u12.nsg13_hv_pmos[ide]
print @n.xbgr.xm52_u12.nsg13_hv_pmos[ige]
print @n.xbgr.xm52_u12.nsg13_hv_pmos[ise]
print @n.xbgr.xm52_u12.nsg13_hv_pmos[ibe]
print @n.xbgr.xm52_u12.nsg13_hv_pmos[ctype]
print @n.xbgr.xm52_u13.nsg13_hv_pmos[ide]
print @n.xbgr.xm52_u13.nsg13_hv_pmos[ige]
print @n.xbgr.xm52_u13.nsg13_hv_pmos[ise]
print @n.xbgr.xm52_u13.nsg13_hv_pmos[ibe]
print @n.xbgr.xm52_u13.nsg13_hv_pmos[ctype]
print @n.xbgr.xm52_u14.nsg13_hv_pmos[ide]
print @n.xbgr.xm52_u14.nsg13_hv_pmos[ige]
print @n.xbgr.xm52_u14.nsg13_hv_pmos[ise]
print @n.xbgr.xm52_u14.nsg13_hv_pmos[ibe]
print @n.xbgr.xm52_u14.nsg13_hv_pmos[ctype]
print @n.xbgr.xm52_u15.nsg13_hv_pmos[ide]
print @n.xbgr.xm52_u15.nsg13_hv_pmos[ige]
print @n.xbgr.xm52_u15.nsg13_hv_pmos[ise]
print @n.xbgr.xm52_u15.nsg13_hv_pmos[ibe]
print @n.xbgr.xm52_u15.nsg13_hv_pmos[ctype]
print @n.xbgr.xm52_u16.nsg13_hv_pmos[ide]
print @n.xbgr.xm52_u16.nsg13_hv_pmos[ige]
print @n.xbgr.xm52_u16.nsg13_hv_pmos[ise]
print @n.xbgr.xm52_u16.nsg13_hv_pmos[ibe]
print @n.xbgr.xm52_u16.nsg13_hv_pmos[ctype]
print @n.xbgr.xm52_u17.nsg13_hv_pmos[ide]
print @n.xbgr.xm52_u17.nsg13_hv_pmos[ige]
print @n.xbgr.xm52_u17.nsg13_hv_pmos[ise]
print @n.xbgr.xm52_u17.nsg13_hv_pmos[ibe]
print @n.xbgr.xm52_u17.nsg13_hv_pmos[ctype]
print @n.xbgr.xm52_u18.nsg13_hv_pmos[ide]
print @n.xbgr.xm52_u18.nsg13_hv_pmos[ige]
print @n.xbgr.xm52_u18.nsg13_hv_pmos[ise]
print @n.xbgr.xm52_u18.nsg13_hv_pmos[ibe]
print @n.xbgr.xm52_u18.nsg13_hv_pmos[ctype]
print @n.xbgr.xm52_u19.nsg13_hv_pmos[ide]
print @n.xbgr.xm52_u19.nsg13_hv_pmos[ige]
print @n.xbgr.xm52_u19.nsg13_hv_pmos[ise]
print @n.xbgr.xm52_u19.nsg13_hv_pmos[ibe]
print @n.xbgr.xm52_u19.nsg13_hv_pmos[ctype]
print @n.xbgr.xm52_u20.nsg13_hv_pmos[ide]
print @n.xbgr.xm52_u20.nsg13_hv_pmos[ige]
print @n.xbgr.xm52_u20.nsg13_hv_pmos[ise]
print @n.xbgr.xm52_u20.nsg13_hv_pmos[ibe]
print @n.xbgr.xm52_u20.nsg13_hv_pmos[ctype]
print @n.xbgr.xm52_u21.nsg13_hv_pmos[ide]
print @n.xbgr.xm52_u21.nsg13_hv_pmos[ige]
print @n.xbgr.xm52_u21.nsg13_hv_pmos[ise]
print @n.xbgr.xm52_u21.nsg13_hv_pmos[ibe]
print @n.xbgr.xm52_u21.nsg13_hv_pmos[ctype]
print @n.xbgr.xm52_u22.nsg13_hv_pmos[ide]
print @n.xbgr.xm52_u22.nsg13_hv_pmos[ige]
print @n.xbgr.xm52_u22.nsg13_hv_pmos[ise]
print @n.xbgr.xm52_u22.nsg13_hv_pmos[ibe]
print @n.xbgr.xm52_u22.nsg13_hv_pmos[ctype]
print @n.xbgr.xm52_u23.nsg13_hv_pmos[ide]
print @n.xbgr.xm52_u23.nsg13_hv_pmos[ige]
print @n.xbgr.xm52_u23.nsg13_hv_pmos[ise]
print @n.xbgr.xm52_u23.nsg13_hv_pmos[ibe]
print @n.xbgr.xm52_u23.nsg13_hv_pmos[ctype]
print @n.xbgr.xm52_u24.nsg13_hv_pmos[ide]
print @n.xbgr.xm52_u24.nsg13_hv_pmos[ige]
print @n.xbgr.xm52_u24.nsg13_hv_pmos[ise]
print @n.xbgr.xm52_u24.nsg13_hv_pmos[ibe]
print @n.xbgr.xm52_u24.nsg13_hv_pmos[ctype]
print @n.xbgr.xm54_u2.nsg13_hv_pmos[ide]
print @n.xbgr.xm54_u2.nsg13_hv_pmos[ige]
print @n.xbgr.xm54_u2.nsg13_hv_pmos[ise]
print @n.xbgr.xm54_u2.nsg13_hv_pmos[ibe]
print @n.xbgr.xm54_u2.nsg13_hv_pmos[ctype]
print @n.xbgr.xm54_u3.nsg13_hv_pmos[ide]
print @n.xbgr.xm54_u3.nsg13_hv_pmos[ige]
print @n.xbgr.xm54_u3.nsg13_hv_pmos[ise]
print @n.xbgr.xm54_u3.nsg13_hv_pmos[ibe]
print @n.xbgr.xm54_u3.nsg13_hv_pmos[ctype]
print @n.xbgr.xm54_u4.nsg13_hv_pmos[ide]
print @n.xbgr.xm54_u4.nsg13_hv_pmos[ige]
print @n.xbgr.xm54_u4.nsg13_hv_pmos[ise]
print @n.xbgr.xm54_u4.nsg13_hv_pmos[ibe]
print @n.xbgr.xm54_u4.nsg13_hv_pmos[ctype]
print @n.xbgr.xm54_u5.nsg13_hv_pmos[ide]
print @n.xbgr.xm54_u5.nsg13_hv_pmos[ige]
print @n.xbgr.xm54_u5.nsg13_hv_pmos[ise]
print @n.xbgr.xm54_u5.nsg13_hv_pmos[ibe]
print @n.xbgr.xm54_u5.nsg13_hv_pmos[ctype]
print @n.xbgr.xm54_u6.nsg13_hv_pmos[ide]
print @n.xbgr.xm54_u6.nsg13_hv_pmos[ige]
print @n.xbgr.xm54_u6.nsg13_hv_pmos[ise]
print @n.xbgr.xm54_u6.nsg13_hv_pmos[ibe]
print @n.xbgr.xm54_u6.nsg13_hv_pmos[ctype]
print @n.xbgr.xm54_u7.nsg13_hv_pmos[ide]
print @n.xbgr.xm54_u7.nsg13_hv_pmos[ige]
print @n.xbgr.xm54_u7.nsg13_hv_pmos[ise]
print @n.xbgr.xm54_u7.nsg13_hv_pmos[ibe]
print @n.xbgr.xm54_u7.nsg13_hv_pmos[ctype]
print @n.xbgr.xm54_u8.nsg13_hv_pmos[ide]
print @n.xbgr.xm54_u8.nsg13_hv_pmos[ige]
print @n.xbgr.xm54_u8.nsg13_hv_pmos[ise]
print @n.xbgr.xm54_u8.nsg13_hv_pmos[ibe]
print @n.xbgr.xm54_u8.nsg13_hv_pmos[ctype]
print @n.xbgr.xm54_u9.nsg13_hv_pmos[ide]
print @n.xbgr.xm54_u9.nsg13_hv_pmos[ige]
print @n.xbgr.xm54_u9.nsg13_hv_pmos[ise]
print @n.xbgr.xm54_u9.nsg13_hv_pmos[ibe]
print @n.xbgr.xm54_u9.nsg13_hv_pmos[ctype]
print @n.xbgr.xm54_u10.nsg13_hv_pmos[ide]
print @n.xbgr.xm54_u10.nsg13_hv_pmos[ige]
print @n.xbgr.xm54_u10.nsg13_hv_pmos[ise]
print @n.xbgr.xm54_u10.nsg13_hv_pmos[ibe]
print @n.xbgr.xm54_u10.nsg13_hv_pmos[ctype]
print @n.xbgr.xm54_u11.nsg13_hv_pmos[ide]
print @n.xbgr.xm54_u11.nsg13_hv_pmos[ige]
print @n.xbgr.xm54_u11.nsg13_hv_pmos[ise]
print @n.xbgr.xm54_u11.nsg13_hv_pmos[ibe]
print @n.xbgr.xm54_u11.nsg13_hv_pmos[ctype]
print @n.xbgr.xm54_u12.nsg13_hv_pmos[ide]
print @n.xbgr.xm54_u12.nsg13_hv_pmos[ige]
print @n.xbgr.xm54_u12.nsg13_hv_pmos[ise]
print @n.xbgr.xm54_u12.nsg13_hv_pmos[ibe]
print @n.xbgr.xm54_u12.nsg13_hv_pmos[ctype]
print @n.xbgr.xm54_u13.nsg13_hv_pmos[ide]
print @n.xbgr.xm54_u13.nsg13_hv_pmos[ige]
print @n.xbgr.xm54_u13.nsg13_hv_pmos[ise]
print @n.xbgr.xm54_u13.nsg13_hv_pmos[ibe]
print @n.xbgr.xm54_u13.nsg13_hv_pmos[ctype]
print @n.xbgr.xm54_u14.nsg13_hv_pmos[ide]
print @n.xbgr.xm54_u14.nsg13_hv_pmos[ige]
print @n.xbgr.xm54_u14.nsg13_hv_pmos[ise]
print @n.xbgr.xm54_u14.nsg13_hv_pmos[ibe]
print @n.xbgr.xm54_u14.nsg13_hv_pmos[ctype]
print @n.xbgr.xm54_u15.nsg13_hv_pmos[ide]
print @n.xbgr.xm54_u15.nsg13_hv_pmos[ige]
print @n.xbgr.xm54_u15.nsg13_hv_pmos[ise]
print @n.xbgr.xm54_u15.nsg13_hv_pmos[ibe]
print @n.xbgr.xm54_u15.nsg13_hv_pmos[ctype]
print @n.xbgr.xm54_u16.nsg13_hv_pmos[ide]
print @n.xbgr.xm54_u16.nsg13_hv_pmos[ige]
print @n.xbgr.xm54_u16.nsg13_hv_pmos[ise]
print @n.xbgr.xm54_u16.nsg13_hv_pmos[ibe]
print @n.xbgr.xm54_u16.nsg13_hv_pmos[ctype]
print @n.xbgr.xm54_u17.nsg13_hv_pmos[ide]
print @n.xbgr.xm54_u17.nsg13_hv_pmos[ige]
print @n.xbgr.xm54_u17.nsg13_hv_pmos[ise]
print @n.xbgr.xm54_u17.nsg13_hv_pmos[ibe]
print @n.xbgr.xm54_u17.nsg13_hv_pmos[ctype]
print @n.xbgr.xm54_u18.nsg13_hv_pmos[ide]
print @n.xbgr.xm54_u18.nsg13_hv_pmos[ige]
print @n.xbgr.xm54_u18.nsg13_hv_pmos[ise]
print @n.xbgr.xm54_u18.nsg13_hv_pmos[ibe]
print @n.xbgr.xm54_u18.nsg13_hv_pmos[ctype]
print @n.xbgr.xm54_u19.nsg13_hv_pmos[ide]
print @n.xbgr.xm54_u19.nsg13_hv_pmos[ige]
print @n.xbgr.xm54_u19.nsg13_hv_pmos[ise]
print @n.xbgr.xm54_u19.nsg13_hv_pmos[ibe]
print @n.xbgr.xm54_u19.nsg13_hv_pmos[ctype]
print @n.xbgr.xm54_u20.nsg13_hv_pmos[ide]
print @n.xbgr.xm54_u20.nsg13_hv_pmos[ige]
print @n.xbgr.xm54_u20.nsg13_hv_pmos[ise]
print @n.xbgr.xm54_u20.nsg13_hv_pmos[ibe]
print @n.xbgr.xm54_u20.nsg13_hv_pmos[ctype]
print @n.xbgr.xm54_u21.nsg13_hv_pmos[ide]
print @n.xbgr.xm54_u21.nsg13_hv_pmos[ige]
print @n.xbgr.xm54_u21.nsg13_hv_pmos[ise]
print @n.xbgr.xm54_u21.nsg13_hv_pmos[ibe]
print @n.xbgr.xm54_u21.nsg13_hv_pmos[ctype]
print @n.xbgr.xm54_u22.nsg13_hv_pmos[ide]
print @n.xbgr.xm54_u22.nsg13_hv_pmos[ige]
print @n.xbgr.xm54_u22.nsg13_hv_pmos[ise]
print @n.xbgr.xm54_u22.nsg13_hv_pmos[ibe]
print @n.xbgr.xm54_u22.nsg13_hv_pmos[ctype]
print @n.xbgr.xm54_u23.nsg13_hv_pmos[ide]
print @n.xbgr.xm54_u23.nsg13_hv_pmos[ige]
print @n.xbgr.xm54_u23.nsg13_hv_pmos[ise]
print @n.xbgr.xm54_u23.nsg13_hv_pmos[ibe]
print @n.xbgr.xm54_u23.nsg13_hv_pmos[ctype]
print @n.xbgr.xm54_u24.nsg13_hv_pmos[ide]
print @n.xbgr.xm54_u24.nsg13_hv_pmos[ige]
print @n.xbgr.xm54_u24.nsg13_hv_pmos[ise]
print @n.xbgr.xm54_u24.nsg13_hv_pmos[ibe]
print @n.xbgr.xm54_u24.nsg13_hv_pmos[ctype]
print @q.xbgr.xq56_u2.qnpn13g2[ic]
print @q.xbgr.xq56_u2.qnpn13g2[ib]
print @q.xbgr.xq56_u2.qnpn13g2[ie]
print @q.xbgr.xq56_u2.qnpn13g2[is]
print @r.xbgr.xq56_u2.rsub[i]
print @c.xbgr.xq56_u2.csub[i]
print @q.xbgr.xq56_u3.qnpn13g2[ic]
print @q.xbgr.xq56_u3.qnpn13g2[ib]
print @q.xbgr.xq56_u3.qnpn13g2[ie]
print @q.xbgr.xq56_u3.qnpn13g2[is]
print @r.xbgr.xq56_u3.rsub[i]
print @c.xbgr.xq56_u3.csub[i]
print @q.xbgr.xq56_u4.qnpn13g2[ic]
print @q.xbgr.xq56_u4.qnpn13g2[ib]
print @q.xbgr.xq56_u4.qnpn13g2[ie]
print @q.xbgr.xq56_u4.qnpn13g2[is]
print @r.xbgr.xq56_u4.rsub[i]
print @c.xbgr.xq56_u4.csub[i]
print @q.xbgr.xq56_u5.qnpn13g2[ic]
print @q.xbgr.xq56_u5.qnpn13g2[ib]
print @q.xbgr.xq56_u5.qnpn13g2[ie]
print @q.xbgr.xq56_u5.qnpn13g2[is]
print @r.xbgr.xq56_u5.rsub[i]
print @c.xbgr.xq56_u5.csub[i]
print @q.xbgr.xq56_u6.qnpn13g2[ic]
print @q.xbgr.xq56_u6.qnpn13g2[ib]
print @q.xbgr.xq56_u6.qnpn13g2[ie]
print @q.xbgr.xq56_u6.qnpn13g2[is]
print @r.xbgr.xq56_u6.rsub[i]
print @c.xbgr.xq56_u6.csub[i]
print @q.xbgr.xq56_u7.qnpn13g2[ic]
print @q.xbgr.xq56_u7.qnpn13g2[ib]
print @q.xbgr.xq56_u7.qnpn13g2[ie]
print @q.xbgr.xq56_u7.qnpn13g2[is]
print @r.xbgr.xq56_u7.rsub[i]
print @c.xbgr.xq56_u7.csub[i]
print @q.xbgr.xq56_u8.qnpn13g2[ic]
print @q.xbgr.xq56_u8.qnpn13g2[ib]
print @q.xbgr.xq56_u8.qnpn13g2[ie]
print @q.xbgr.xq56_u8.qnpn13g2[is]
print @r.xbgr.xq56_u8.rsub[i]
print @c.xbgr.xq56_u8.csub[i]
print @q.xbgr.xq56_u9.qnpn13g2[ic]
print @q.xbgr.xq56_u9.qnpn13g2[ib]
print @q.xbgr.xq56_u9.qnpn13g2[ie]
print @q.xbgr.xq56_u9.qnpn13g2[is]
print @r.xbgr.xq56_u9.rsub[i]
print @c.xbgr.xq56_u9.csub[i]
print @q.xbgr.xq56_u10.qnpn13g2[ic]
print @q.xbgr.xq56_u10.qnpn13g2[ib]
print @q.xbgr.xq56_u10.qnpn13g2[ie]
print @q.xbgr.xq56_u10.qnpn13g2[is]
print @r.xbgr.xq56_u10.rsub[i]
print @c.xbgr.xq56_u10.csub[i]
print @q.xbgr.xq56_u11.qnpn13g2[ic]
print @q.xbgr.xq56_u11.qnpn13g2[ib]
print @q.xbgr.xq56_u11.qnpn13g2[ie]
print @q.xbgr.xq56_u11.qnpn13g2[is]
print @r.xbgr.xq56_u11.rsub[i]
print @c.xbgr.xq56_u11.csub[i]
print @q.xbgr.xq56_u12.qnpn13g2[ic]
print @q.xbgr.xq56_u12.qnpn13g2[ib]
print @q.xbgr.xq56_u12.qnpn13g2[ie]
print @q.xbgr.xq56_u12.qnpn13g2[is]
print @r.xbgr.xq56_u12.rsub[i]
print @c.xbgr.xq56_u12.csub[i]
print @q.xbgr.xq56_u13.qnpn13g2[ic]
print @q.xbgr.xq56_u13.qnpn13g2[ib]
print @q.xbgr.xq56_u13.qnpn13g2[ie]
print @q.xbgr.xq56_u13.qnpn13g2[is]
print @r.xbgr.xq56_u13.rsub[i]
print @c.xbgr.xq56_u13.csub[i]
print @q.xbgr.xq56_u14.qnpn13g2[ic]
print @q.xbgr.xq56_u14.qnpn13g2[ib]
print @q.xbgr.xq56_u14.qnpn13g2[ie]
print @q.xbgr.xq56_u14.qnpn13g2[is]
print @r.xbgr.xq56_u14.rsub[i]
print @c.xbgr.xq56_u14.csub[i]
print @q.xbgr.xq56_u15.qnpn13g2[ic]
print @q.xbgr.xq56_u15.qnpn13g2[ib]
print @q.xbgr.xq56_u15.qnpn13g2[ie]
print @q.xbgr.xq56_u15.qnpn13g2[is]
print @r.xbgr.xq56_u15.rsub[i]
print @c.xbgr.xq56_u15.csub[i]
print @q.xbgr.xq56_u16.qnpn13g2[ic]
print @q.xbgr.xq56_u16.qnpn13g2[ib]
print @q.xbgr.xq56_u16.qnpn13g2[ie]
print @q.xbgr.xq56_u16.qnpn13g2[is]
print @r.xbgr.xq56_u16.rsub[i]
print @c.xbgr.xq56_u16.csub[i]
print @q.xbgr.xq56_u17.qnpn13g2[ic]
print @q.xbgr.xq56_u17.qnpn13g2[ib]
print @q.xbgr.xq56_u17.qnpn13g2[ie]
print @q.xbgr.xq56_u17.qnpn13g2[is]
print @r.xbgr.xq56_u17.rsub[i]
print @c.xbgr.xq56_u17.csub[i]
print @q.xbgr.xq56_u18.qnpn13g2[ic]
print @q.xbgr.xq56_u18.qnpn13g2[ib]
print @q.xbgr.xq56_u18.qnpn13g2[ie]
print @q.xbgr.xq56_u18.qnpn13g2[is]
print @r.xbgr.xq56_u18.rsub[i]
print @c.xbgr.xq56_u18.csub[i]
print @q.xbgr.xq56_u19.qnpn13g2[ic]
print @q.xbgr.xq56_u19.qnpn13g2[ib]
print @q.xbgr.xq56_u19.qnpn13g2[ie]
print @q.xbgr.xq56_u19.qnpn13g2[is]
print @r.xbgr.xq56_u19.rsub[i]
print @c.xbgr.xq56_u19.csub[i]
print @q.xbgr.xq56_u20.qnpn13g2[ic]
print @q.xbgr.xq56_u20.qnpn13g2[ib]
print @q.xbgr.xq56_u20.qnpn13g2[ie]
print @q.xbgr.xq56_u20.qnpn13g2[is]
print @r.xbgr.xq56_u20.rsub[i]
print @c.xbgr.xq56_u20.csub[i]
print @q.xbgr.xq56_u21.qnpn13g2[ic]
print @q.xbgr.xq56_u21.qnpn13g2[ib]
print @q.xbgr.xq56_u21.qnpn13g2[ie]
print @q.xbgr.xq56_u21.qnpn13g2[is]
print @r.xbgr.xq56_u21.rsub[i]
print @c.xbgr.xq56_u21.csub[i]
print @q.xbgr.xq56_u22.qnpn13g2[ic]
print @q.xbgr.xq56_u22.qnpn13g2[ib]
print @q.xbgr.xq56_u22.qnpn13g2[ie]
print @q.xbgr.xq56_u22.qnpn13g2[is]
print @r.xbgr.xq56_u22.rsub[i]
print @c.xbgr.xq56_u22.csub[i]
print @q.xbgr.xq56_u23.qnpn13g2[ic]
print @q.xbgr.xq56_u23.qnpn13g2[ib]
print @q.xbgr.xq56_u23.qnpn13g2[ie]
print @q.xbgr.xq56_u23.qnpn13g2[is]
print @r.xbgr.xq56_u23.rsub[i]
print @c.xbgr.xq56_u23.csub[i]
print @q.xbgr.xq56_u24.qnpn13g2[ic]
print @q.xbgr.xq56_u24.qnpn13g2[ib]
print @q.xbgr.xq56_u24.qnpn13g2[ie]
print @q.xbgr.xq56_u24.qnpn13g2[is]
print @r.xbgr.xq56_u24.rsub[i]
print @c.xbgr.xq56_u24.csub[i]
print @q.xbgr.xq60_u2.qnpn13g2[ic]
print @q.xbgr.xq60_u2.qnpn13g2[ib]
print @q.xbgr.xq60_u2.qnpn13g2[ie]
print @q.xbgr.xq60_u2.qnpn13g2[is]
print @r.xbgr.xq60_u2.rsub[i]
print @c.xbgr.xq60_u2.csub[i]
print @q.xbgr.xq60_u3.qnpn13g2[ic]
print @q.xbgr.xq60_u3.qnpn13g2[ib]
print @q.xbgr.xq60_u3.qnpn13g2[ie]
print @q.xbgr.xq60_u3.qnpn13g2[is]
print @r.xbgr.xq60_u3.rsub[i]
print @c.xbgr.xq60_u3.csub[i]
print @q.xbgr.xq60_u4.qnpn13g2[ic]
print @q.xbgr.xq60_u4.qnpn13g2[ib]
print @q.xbgr.xq60_u4.qnpn13g2[ie]
print @q.xbgr.xq60_u4.qnpn13g2[is]
print @r.xbgr.xq60_u4.rsub[i]
print @c.xbgr.xq60_u4.csub[i]
print @q.xbgr.xq62_u2.qnpn13g2[ic]
print @q.xbgr.xq62_u2.qnpn13g2[ib]
print @q.xbgr.xq62_u2.qnpn13g2[ie]
print @q.xbgr.xq62_u2.qnpn13g2[is]
print @r.xbgr.xq62_u2.rsub[i]
print @c.xbgr.xq62_u2.csub[i]
print @q.xbgr.xq62_u3.qnpn13g2[ic]
print @q.xbgr.xq62_u3.qnpn13g2[ib]
print @q.xbgr.xq62_u3.qnpn13g2[ie]
print @q.xbgr.xq62_u3.qnpn13g2[is]
print @r.xbgr.xq62_u3.rsub[i]
print @c.xbgr.xq62_u3.csub[i]
print @q.xbgr.xq62_u4.qnpn13g2[ic]
print @q.xbgr.xq62_u4.qnpn13g2[ib]
print @q.xbgr.xq62_u4.qnpn13g2[ie]
print @q.xbgr.xq62_u4.qnpn13g2[is]
print @r.xbgr.xq62_u4.rsub[i]
print @c.xbgr.xq62_u4.csub[i]
print @q.xbgr.xq62_u5.qnpn13g2[ic]
print @q.xbgr.xq62_u5.qnpn13g2[ib]
print @q.xbgr.xq62_u5.qnpn13g2[ie]
print @q.xbgr.xq62_u5.qnpn13g2[is]
print @r.xbgr.xq62_u5.rsub[i]
print @c.xbgr.xq62_u5.csub[i]
print @q.xbgr.xq62_u6.qnpn13g2[ic]
print @q.xbgr.xq62_u6.qnpn13g2[ib]
print @q.xbgr.xq62_u6.qnpn13g2[ie]
print @q.xbgr.xq62_u6.qnpn13g2[is]
print @r.xbgr.xq62_u6.rsub[i]
print @c.xbgr.xq62_u6.csub[i]
print @q.xbgr.xq62_u7.qnpn13g2[ic]
print @q.xbgr.xq62_u7.qnpn13g2[ib]
print @q.xbgr.xq62_u7.qnpn13g2[ie]
print @q.xbgr.xq62_u7.qnpn13g2[is]
print @r.xbgr.xq62_u7.rsub[i]
print @c.xbgr.xq62_u7.csub[i]
print @q.xbgr.xq62_u8.qnpn13g2[ic]
print @q.xbgr.xq62_u8.qnpn13g2[ib]
print @q.xbgr.xq62_u8.qnpn13g2[ie]
print @q.xbgr.xq62_u8.qnpn13g2[is]
print @r.xbgr.xq62_u8.rsub[i]
print @c.xbgr.xq62_u8.csub[i]
print @q.xbgr.xq62_u9.qnpn13g2[ic]
print @q.xbgr.xq62_u9.qnpn13g2[ib]
print @q.xbgr.xq62_u9.qnpn13g2[ie]
print @q.xbgr.xq62_u9.qnpn13g2[is]
print @r.xbgr.xq62_u9.rsub[i]
print @c.xbgr.xq62_u9.csub[i]
print @q.xbgr.xq62_u10.qnpn13g2[ic]
print @q.xbgr.xq62_u10.qnpn13g2[ib]
print @q.xbgr.xq62_u10.qnpn13g2[ie]
print @q.xbgr.xq62_u10.qnpn13g2[is]
print @r.xbgr.xq62_u10.rsub[i]
print @c.xbgr.xq62_u10.csub[i]
print @q.xbgr.xq62_u11.qnpn13g2[ic]
print @q.xbgr.xq62_u11.qnpn13g2[ib]
print @q.xbgr.xq62_u11.qnpn13g2[ie]
print @q.xbgr.xq62_u11.qnpn13g2[is]
print @r.xbgr.xq62_u11.rsub[i]
print @c.xbgr.xq62_u11.csub[i]
print @q.xbgr.xq62_u12.qnpn13g2[ic]
print @q.xbgr.xq62_u12.qnpn13g2[ib]
print @q.xbgr.xq62_u12.qnpn13g2[ie]
print @q.xbgr.xq62_u12.qnpn13g2[is]
print @r.xbgr.xq62_u12.rsub[i]
print @c.xbgr.xq62_u12.csub[i]
print @q.xbgr.xq62_u13.qnpn13g2[ic]
print @q.xbgr.xq62_u13.qnpn13g2[ib]
print @q.xbgr.xq62_u13.qnpn13g2[ie]
print @q.xbgr.xq62_u13.qnpn13g2[is]
print @r.xbgr.xq62_u13.rsub[i]
print @c.xbgr.xq62_u13.csub[i]
print @q.xbgr.xq62_u14.qnpn13g2[ic]
print @q.xbgr.xq62_u14.qnpn13g2[ib]
print @q.xbgr.xq62_u14.qnpn13g2[ie]
print @q.xbgr.xq62_u14.qnpn13g2[is]
print @r.xbgr.xq62_u14.rsub[i]
print @c.xbgr.xq62_u14.csub[i]
print @q.xbgr.xq62_u15.qnpn13g2[ic]
print @q.xbgr.xq62_u15.qnpn13g2[ib]
print @q.xbgr.xq62_u15.qnpn13g2[ie]
print @q.xbgr.xq62_u15.qnpn13g2[is]
print @r.xbgr.xq62_u15.rsub[i]
print @c.xbgr.xq62_u15.csub[i]
print @q.xbgr.xq62_u16.qnpn13g2[ic]
print @q.xbgr.xq62_u16.qnpn13g2[ib]
print @q.xbgr.xq62_u16.qnpn13g2[ie]
print @q.xbgr.xq62_u16.qnpn13g2[is]
print @r.xbgr.xq62_u16.rsub[i]
print @c.xbgr.xq62_u16.csub[i]
print @q.xbgr.xq62_u17.qnpn13g2[ic]
print @q.xbgr.xq62_u17.qnpn13g2[ib]
print @q.xbgr.xq62_u17.qnpn13g2[ie]
print @q.xbgr.xq62_u17.qnpn13g2[is]
print @r.xbgr.xq62_u17.rsub[i]
print @c.xbgr.xq62_u17.csub[i]
print @q.xbgr.xq62_u18.qnpn13g2[ic]
print @q.xbgr.xq62_u18.qnpn13g2[ib]
print @q.xbgr.xq62_u18.qnpn13g2[ie]
print @q.xbgr.xq62_u18.qnpn13g2[is]
print @r.xbgr.xq62_u18.rsub[i]
print @c.xbgr.xq62_u18.csub[i]
print @q.xbgr.xq62_u19.qnpn13g2[ic]
print @q.xbgr.xq62_u19.qnpn13g2[ib]
print @q.xbgr.xq62_u19.qnpn13g2[ie]
print @q.xbgr.xq62_u19.qnpn13g2[is]
print @r.xbgr.xq62_u19.rsub[i]
print @c.xbgr.xq62_u19.csub[i]
print @q.xbgr.xq62_u20.qnpn13g2[ic]
print @q.xbgr.xq62_u20.qnpn13g2[ib]
print @q.xbgr.xq62_u20.qnpn13g2[ie]
print @q.xbgr.xq62_u20.qnpn13g2[is]
print @r.xbgr.xq62_u20.rsub[i]
print @c.xbgr.xq62_u20.csub[i]
print @q.xbgr.xq62_u21.qnpn13g2[ic]
print @q.xbgr.xq62_u21.qnpn13g2[ib]
print @q.xbgr.xq62_u21.qnpn13g2[ie]
print @q.xbgr.xq62_u21.qnpn13g2[is]
print @r.xbgr.xq62_u21.rsub[i]
print @c.xbgr.xq62_u21.csub[i]
print @q.xbgr.xq62_u22.qnpn13g2[ic]
print @q.xbgr.xq62_u22.qnpn13g2[ib]
print @q.xbgr.xq62_u22.qnpn13g2[ie]
print @q.xbgr.xq62_u22.qnpn13g2[is]
print @r.xbgr.xq62_u22.rsub[i]
print @c.xbgr.xq62_u22.csub[i]
print @q.xbgr.xq62_u23.qnpn13g2[ic]
print @q.xbgr.xq62_u23.qnpn13g2[ib]
print @q.xbgr.xq62_u23.qnpn13g2[ie]
print @q.xbgr.xq62_u23.qnpn13g2[is]
print @r.xbgr.xq62_u23.rsub[i]
print @c.xbgr.xq62_u23.csub[i]
print @q.xbgr.xq62_u24.qnpn13g2[ic]
print @q.xbgr.xq62_u24.qnpn13g2[ib]
print @q.xbgr.xq62_u24.qnpn13g2[ie]
print @q.xbgr.xq62_u24.qnpn13g2[is]
print @r.xbgr.xq62_u24.rsub[i]
print @c.xbgr.xq62_u24.csub[i]
print @q.xbgr.xq67_u2.qnpn13g2[ic]
print @q.xbgr.xq67_u2.qnpn13g2[ib]
print @q.xbgr.xq67_u2.qnpn13g2[ie]
print @q.xbgr.xq67_u2.qnpn13g2[is]
print @r.xbgr.xq67_u2.rsub[i]
print @c.xbgr.xq67_u2.csub[i]
print @q.xbgr.xq67_u3.qnpn13g2[ic]
print @q.xbgr.xq67_u3.qnpn13g2[ib]
print @q.xbgr.xq67_u3.qnpn13g2[ie]
print @q.xbgr.xq67_u3.qnpn13g2[is]
print @r.xbgr.xq67_u3.rsub[i]
print @c.xbgr.xq67_u3.csub[i]
print @q.xbgr.xq67_u4.qnpn13g2[ic]
print @q.xbgr.xq67_u4.qnpn13g2[ib]
print @q.xbgr.xq67_u4.qnpn13g2[ie]
print @q.xbgr.xq67_u4.qnpn13g2[is]
print @r.xbgr.xq67_u4.rsub[i]
print @c.xbgr.xq67_u4.csub[i]
print @q.xbgr.xq67_u5.qnpn13g2[ic]
print @q.xbgr.xq67_u5.qnpn13g2[ib]
print @q.xbgr.xq67_u5.qnpn13g2[ie]
print @q.xbgr.xq67_u5.qnpn13g2[is]
print @r.xbgr.xq67_u5.rsub[i]
print @c.xbgr.xq67_u5.csub[i]
print @q.xbgr.xq67_u6.qnpn13g2[ic]
print @q.xbgr.xq67_u6.qnpn13g2[ib]
print @q.xbgr.xq67_u6.qnpn13g2[ie]
print @q.xbgr.xq67_u6.qnpn13g2[is]
print @r.xbgr.xq67_u6.rsub[i]
print @c.xbgr.xq67_u6.csub[i]
print @q.xbgr.xq67_u7.qnpn13g2[ic]
print @q.xbgr.xq67_u7.qnpn13g2[ib]
print @q.xbgr.xq67_u7.qnpn13g2[ie]
print @q.xbgr.xq67_u7.qnpn13g2[is]
print @r.xbgr.xq67_u7.rsub[i]
print @c.xbgr.xq67_u7.csub[i]
print @q.xbgr.xq67_u8.qnpn13g2[ic]
print @q.xbgr.xq67_u8.qnpn13g2[ib]
print @q.xbgr.xq67_u8.qnpn13g2[ie]
print @q.xbgr.xq67_u8.qnpn13g2[is]
print @r.xbgr.xq67_u8.rsub[i]
print @c.xbgr.xq67_u8.csub[i]
print @q.xbgr.xq67_u9.qnpn13g2[ic]
print @q.xbgr.xq67_u9.qnpn13g2[ib]
print @q.xbgr.xq67_u9.qnpn13g2[ie]
print @q.xbgr.xq67_u9.qnpn13g2[is]
print @r.xbgr.xq67_u9.rsub[i]
print @c.xbgr.xq67_u9.csub[i]
print @q.xbgr.xq67_u10.qnpn13g2[ic]
print @q.xbgr.xq67_u10.qnpn13g2[ib]
print @q.xbgr.xq67_u10.qnpn13g2[ie]
print @q.xbgr.xq67_u10.qnpn13g2[is]
print @r.xbgr.xq67_u10.rsub[i]
print @c.xbgr.xq67_u10.csub[i]
print @q.xbgr.xq67_u11.qnpn13g2[ic]
print @q.xbgr.xq67_u11.qnpn13g2[ib]
print @q.xbgr.xq67_u11.qnpn13g2[ie]
print @q.xbgr.xq67_u11.qnpn13g2[is]
print @r.xbgr.xq67_u11.rsub[i]
print @c.xbgr.xq67_u11.csub[i]
print @q.xbgr.xq67_u12.qnpn13g2[ic]
print @q.xbgr.xq67_u12.qnpn13g2[ib]
print @q.xbgr.xq67_u12.qnpn13g2[ie]
print @q.xbgr.xq67_u12.qnpn13g2[is]
print @r.xbgr.xq67_u12.rsub[i]
print @c.xbgr.xq67_u12.csub[i]
print @q.xbgr.xq67_u13.qnpn13g2[ic]
print @q.xbgr.xq67_u13.qnpn13g2[ib]
print @q.xbgr.xq67_u13.qnpn13g2[ie]
print @q.xbgr.xq67_u13.qnpn13g2[is]
print @r.xbgr.xq67_u13.rsub[i]
print @c.xbgr.xq67_u13.csub[i]
print @q.xbgr.xq67_u14.qnpn13g2[ic]
print @q.xbgr.xq67_u14.qnpn13g2[ib]
print @q.xbgr.xq67_u14.qnpn13g2[ie]
print @q.xbgr.xq67_u14.qnpn13g2[is]
print @r.xbgr.xq67_u14.rsub[i]
print @c.xbgr.xq67_u14.csub[i]
print @q.xbgr.xq67_u15.qnpn13g2[ic]
print @q.xbgr.xq67_u15.qnpn13g2[ib]
print @q.xbgr.xq67_u15.qnpn13g2[ie]
print @q.xbgr.xq67_u15.qnpn13g2[is]
print @r.xbgr.xq67_u15.rsub[i]
print @c.xbgr.xq67_u15.csub[i]
print @q.xbgr.xq67_u16.qnpn13g2[ic]
print @q.xbgr.xq67_u16.qnpn13g2[ib]
print @q.xbgr.xq67_u16.qnpn13g2[ie]
print @q.xbgr.xq67_u16.qnpn13g2[is]
print @r.xbgr.xq67_u16.rsub[i]
print @c.xbgr.xq67_u16.csub[i]
print @q.xbgr.xq67_u17.qnpn13g2[ic]
print @q.xbgr.xq67_u17.qnpn13g2[ib]
print @q.xbgr.xq67_u17.qnpn13g2[ie]
print @q.xbgr.xq67_u17.qnpn13g2[is]
print @r.xbgr.xq67_u17.rsub[i]
print @c.xbgr.xq67_u17.csub[i]
print @q.xbgr.xq67_u18.qnpn13g2[ic]
print @q.xbgr.xq67_u18.qnpn13g2[ib]
print @q.xbgr.xq67_u18.qnpn13g2[ie]
print @q.xbgr.xq67_u18.qnpn13g2[is]
print @r.xbgr.xq67_u18.rsub[i]
print @c.xbgr.xq67_u18.csub[i]
print @q.xbgr.xq67_u19.qnpn13g2[ic]
print @q.xbgr.xq67_u19.qnpn13g2[ib]
print @q.xbgr.xq67_u19.qnpn13g2[ie]
print @q.xbgr.xq67_u19.qnpn13g2[is]
print @r.xbgr.xq67_u19.rsub[i]
print @c.xbgr.xq67_u19.csub[i]
print @q.xbgr.xq67_u20.qnpn13g2[ic]
print @q.xbgr.xq67_u20.qnpn13g2[ib]
print @q.xbgr.xq67_u20.qnpn13g2[ie]
print @q.xbgr.xq67_u20.qnpn13g2[is]
print @r.xbgr.xq67_u20.rsub[i]
print @c.xbgr.xq67_u20.csub[i]
print @q.xbgr.xq67_u21.qnpn13g2[ic]
print @q.xbgr.xq67_u21.qnpn13g2[ib]
print @q.xbgr.xq67_u21.qnpn13g2[ie]
print @q.xbgr.xq67_u21.qnpn13g2[is]
print @r.xbgr.xq67_u21.rsub[i]
print @c.xbgr.xq67_u21.csub[i]
print @q.xbgr.xq67_u22.qnpn13g2[ic]
print @q.xbgr.xq67_u22.qnpn13g2[ib]
print @q.xbgr.xq67_u22.qnpn13g2[ie]
print @q.xbgr.xq67_u22.qnpn13g2[is]
print @r.xbgr.xq67_u22.rsub[i]
print @c.xbgr.xq67_u22.csub[i]
print @q.xbgr.xq67_u23.qnpn13g2[ic]
print @q.xbgr.xq67_u23.qnpn13g2[ib]
print @q.xbgr.xq67_u23.qnpn13g2[ie]
print @q.xbgr.xq67_u23.qnpn13g2[is]
print @r.xbgr.xq67_u23.rsub[i]
print @c.xbgr.xq67_u23.csub[i]
print @q.xbgr.xq67_u24.qnpn13g2[ic]
print @q.xbgr.xq67_u24.qnpn13g2[ib]
print @q.xbgr.xq67_u24.qnpn13g2[ie]
print @q.xbgr.xq67_u24.qnpn13g2[is]
print @r.xbgr.xq67_u24.rsub[i]
print @c.xbgr.xq67_u24.csub[i]
print @q.xbgr.xq68_u2.qnpn13g2[ic]
print @q.xbgr.xq68_u2.qnpn13g2[ib]
print @q.xbgr.xq68_u2.qnpn13g2[ie]
print @q.xbgr.xq68_u2.qnpn13g2[is]
print @r.xbgr.xq68_u2.rsub[i]
print @c.xbgr.xq68_u2.csub[i]
print @q.xbgr.xq68_u3.qnpn13g2[ic]
print @q.xbgr.xq68_u3.qnpn13g2[ib]
print @q.xbgr.xq68_u3.qnpn13g2[ie]
print @q.xbgr.xq68_u3.qnpn13g2[is]
print @r.xbgr.xq68_u3.rsub[i]
print @c.xbgr.xq68_u3.csub[i]
print @q.xbgr.xq68_u4.qnpn13g2[ic]
print @q.xbgr.xq68_u4.qnpn13g2[ib]
print @q.xbgr.xq68_u4.qnpn13g2[ie]
print @q.xbgr.xq68_u4.qnpn13g2[is]
print @r.xbgr.xq68_u4.rsub[i]
print @c.xbgr.xq68_u4.csub[i]
print @q.xbgr.xq68_u5.qnpn13g2[ic]
print @q.xbgr.xq68_u5.qnpn13g2[ib]
print @q.xbgr.xq68_u5.qnpn13g2[ie]
print @q.xbgr.xq68_u5.qnpn13g2[is]
print @r.xbgr.xq68_u5.rsub[i]
print @c.xbgr.xq68_u5.csub[i]
print @q.xbgr.xq68_u6.qnpn13g2[ic]
print @q.xbgr.xq68_u6.qnpn13g2[ib]
print @q.xbgr.xq68_u6.qnpn13g2[ie]
print @q.xbgr.xq68_u6.qnpn13g2[is]
print @r.xbgr.xq68_u6.rsub[i]
print @c.xbgr.xq68_u6.csub[i]
print @q.xbgr.xq68_u7.qnpn13g2[ic]
print @q.xbgr.xq68_u7.qnpn13g2[ib]
print @q.xbgr.xq68_u7.qnpn13g2[ie]
print @q.xbgr.xq68_u7.qnpn13g2[is]
print @r.xbgr.xq68_u7.rsub[i]
print @c.xbgr.xq68_u7.csub[i]
print @q.xbgr.xq68_u8.qnpn13g2[ic]
print @q.xbgr.xq68_u8.qnpn13g2[ib]
print @q.xbgr.xq68_u8.qnpn13g2[ie]
print @q.xbgr.xq68_u8.qnpn13g2[is]
print @r.xbgr.xq68_u8.rsub[i]
print @c.xbgr.xq68_u8.csub[i]
print @q.xbgr.xq68_u9.qnpn13g2[ic]
print @q.xbgr.xq68_u9.qnpn13g2[ib]
print @q.xbgr.xq68_u9.qnpn13g2[ie]
print @q.xbgr.xq68_u9.qnpn13g2[is]
print @r.xbgr.xq68_u9.rsub[i]
print @c.xbgr.xq68_u9.csub[i]
print @q.xbgr.xq68_u10.qnpn13g2[ic]
print @q.xbgr.xq68_u10.qnpn13g2[ib]
print @q.xbgr.xq68_u10.qnpn13g2[ie]
print @q.xbgr.xq68_u10.qnpn13g2[is]
print @r.xbgr.xq68_u10.rsub[i]
print @c.xbgr.xq68_u10.csub[i]
print @q.xbgr.xq68_u11.qnpn13g2[ic]
print @q.xbgr.xq68_u11.qnpn13g2[ib]
print @q.xbgr.xq68_u11.qnpn13g2[ie]
print @q.xbgr.xq68_u11.qnpn13g2[is]
print @r.xbgr.xq68_u11.rsub[i]
print @c.xbgr.xq68_u11.csub[i]
print @q.xbgr.xq68_u12.qnpn13g2[ic]
print @q.xbgr.xq68_u12.qnpn13g2[ib]
print @q.xbgr.xq68_u12.qnpn13g2[ie]
print @q.xbgr.xq68_u12.qnpn13g2[is]
print @r.xbgr.xq68_u12.rsub[i]
print @c.xbgr.xq68_u12.csub[i]
print @q.xbgr.xq68_u13.qnpn13g2[ic]
print @q.xbgr.xq68_u13.qnpn13g2[ib]
print @q.xbgr.xq68_u13.qnpn13g2[ie]
print @q.xbgr.xq68_u13.qnpn13g2[is]
print @r.xbgr.xq68_u13.rsub[i]
print @c.xbgr.xq68_u13.csub[i]
print @q.xbgr.xq68_u14.qnpn13g2[ic]
print @q.xbgr.xq68_u14.qnpn13g2[ib]
print @q.xbgr.xq68_u14.qnpn13g2[ie]
print @q.xbgr.xq68_u14.qnpn13g2[is]
print @r.xbgr.xq68_u14.rsub[i]
print @c.xbgr.xq68_u14.csub[i]
print @q.xbgr.xq68_u15.qnpn13g2[ic]
print @q.xbgr.xq68_u15.qnpn13g2[ib]
print @q.xbgr.xq68_u15.qnpn13g2[ie]
print @q.xbgr.xq68_u15.qnpn13g2[is]
print @r.xbgr.xq68_u15.rsub[i]
print @c.xbgr.xq68_u15.csub[i]
print @q.xbgr.xq68_u16.qnpn13g2[ic]
print @q.xbgr.xq68_u16.qnpn13g2[ib]
print @q.xbgr.xq68_u16.qnpn13g2[ie]
print @q.xbgr.xq68_u16.qnpn13g2[is]
print @r.xbgr.xq68_u16.rsub[i]
print @c.xbgr.xq68_u16.csub[i]
print @q.xbgr.xq68_u17.qnpn13g2[ic]
print @q.xbgr.xq68_u17.qnpn13g2[ib]
print @q.xbgr.xq68_u17.qnpn13g2[ie]
print @q.xbgr.xq68_u17.qnpn13g2[is]
print @r.xbgr.xq68_u17.rsub[i]
print @c.xbgr.xq68_u17.csub[i]
print @q.xbgr.xq68_u18.qnpn13g2[ic]
print @q.xbgr.xq68_u18.qnpn13g2[ib]
print @q.xbgr.xq68_u18.qnpn13g2[ie]
print @q.xbgr.xq68_u18.qnpn13g2[is]
print @r.xbgr.xq68_u18.rsub[i]
print @c.xbgr.xq68_u18.csub[i]
print @q.xbgr.xq68_u19.qnpn13g2[ic]
print @q.xbgr.xq68_u19.qnpn13g2[ib]
print @q.xbgr.xq68_u19.qnpn13g2[ie]
print @q.xbgr.xq68_u19.qnpn13g2[is]
print @r.xbgr.xq68_u19.rsub[i]
print @c.xbgr.xq68_u19.csub[i]
print @q.xbgr.xq68_u20.qnpn13g2[ic]
print @q.xbgr.xq68_u20.qnpn13g2[ib]
print @q.xbgr.xq68_u20.qnpn13g2[ie]
print @q.xbgr.xq68_u20.qnpn13g2[is]
print @r.xbgr.xq68_u20.rsub[i]
print @c.xbgr.xq68_u20.csub[i]
print @q.xbgr.xq68_u21.qnpn13g2[ic]
print @q.xbgr.xq68_u21.qnpn13g2[ib]
print @q.xbgr.xq68_u21.qnpn13g2[ie]
print @q.xbgr.xq68_u21.qnpn13g2[is]
print @r.xbgr.xq68_u21.rsub[i]
print @c.xbgr.xq68_u21.csub[i]
print @q.xbgr.xq68_u22.qnpn13g2[ic]
print @q.xbgr.xq68_u22.qnpn13g2[ib]
print @q.xbgr.xq68_u22.qnpn13g2[ie]
print @q.xbgr.xq68_u22.qnpn13g2[is]
print @r.xbgr.xq68_u22.rsub[i]
print @c.xbgr.xq68_u22.csub[i]
print @q.xbgr.xq68_u23.qnpn13g2[ic]
print @q.xbgr.xq68_u23.qnpn13g2[ib]
print @q.xbgr.xq68_u23.qnpn13g2[ie]
print @q.xbgr.xq68_u23.qnpn13g2[is]
print @r.xbgr.xq68_u23.rsub[i]
print @c.xbgr.xq68_u23.csub[i]
print @q.xbgr.xq68_u24.qnpn13g2[ic]
print @q.xbgr.xq68_u24.qnpn13g2[ib]
print @q.xbgr.xq68_u24.qnpn13g2[ie]
print @q.xbgr.xq68_u24.qnpn13g2[is]
print @r.xbgr.xq68_u24.rsub[i]
print @c.xbgr.xq68_u24.csub[i]
print @q.xbgr.xq69_u2.qnpn13g2[ic]
print @q.xbgr.xq69_u2.qnpn13g2[ib]
print @q.xbgr.xq69_u2.qnpn13g2[ie]
print @q.xbgr.xq69_u2.qnpn13g2[is]
print @r.xbgr.xq69_u2.rsub[i]
print @c.xbgr.xq69_u2.csub[i]
print @q.xbgr.xq69_u3.qnpn13g2[ic]
print @q.xbgr.xq69_u3.qnpn13g2[ib]
print @q.xbgr.xq69_u3.qnpn13g2[ie]
print @q.xbgr.xq69_u3.qnpn13g2[is]
print @r.xbgr.xq69_u3.rsub[i]
print @c.xbgr.xq69_u3.csub[i]
print @q.xbgr.xq69_u4.qnpn13g2[ic]
print @q.xbgr.xq69_u4.qnpn13g2[ib]
print @q.xbgr.xq69_u4.qnpn13g2[ie]
print @q.xbgr.xq69_u4.qnpn13g2[is]
print @r.xbgr.xq69_u4.rsub[i]
print @c.xbgr.xq69_u4.csub[i]
print @q.xbgr.xq69_u5.qnpn13g2[ic]
print @q.xbgr.xq69_u5.qnpn13g2[ib]
print @q.xbgr.xq69_u5.qnpn13g2[ie]
print @q.xbgr.xq69_u5.qnpn13g2[is]
print @r.xbgr.xq69_u5.rsub[i]
print @c.xbgr.xq69_u5.csub[i]
print @q.xbgr.xq69_u6.qnpn13g2[ic]
print @q.xbgr.xq69_u6.qnpn13g2[ib]
print @q.xbgr.xq69_u6.qnpn13g2[ie]
print @q.xbgr.xq69_u6.qnpn13g2[is]
print @r.xbgr.xq69_u6.rsub[i]
print @c.xbgr.xq69_u6.csub[i]
print @q.xbgr.xq69_u7.qnpn13g2[ic]
print @q.xbgr.xq69_u7.qnpn13g2[ib]
print @q.xbgr.xq69_u7.qnpn13g2[ie]
print @q.xbgr.xq69_u7.qnpn13g2[is]
print @r.xbgr.xq69_u7.rsub[i]
print @c.xbgr.xq69_u7.csub[i]
print @q.xbgr.xq69_u8.qnpn13g2[ic]
print @q.xbgr.xq69_u8.qnpn13g2[ib]
print @q.xbgr.xq69_u8.qnpn13g2[ie]
print @q.xbgr.xq69_u8.qnpn13g2[is]
print @r.xbgr.xq69_u8.rsub[i]
print @c.xbgr.xq69_u8.csub[i]
print @q.xbgr.xq69_u9.qnpn13g2[ic]
print @q.xbgr.xq69_u9.qnpn13g2[ib]
print @q.xbgr.xq69_u9.qnpn13g2[ie]
print @q.xbgr.xq69_u9.qnpn13g2[is]
print @r.xbgr.xq69_u9.rsub[i]
print @c.xbgr.xq69_u9.csub[i]
print @q.xbgr.xq69_u10.qnpn13g2[ic]
print @q.xbgr.xq69_u10.qnpn13g2[ib]
print @q.xbgr.xq69_u10.qnpn13g2[ie]
print @q.xbgr.xq69_u10.qnpn13g2[is]
print @r.xbgr.xq69_u10.rsub[i]
print @c.xbgr.xq69_u10.csub[i]
print @q.xbgr.xq69_u11.qnpn13g2[ic]
print @q.xbgr.xq69_u11.qnpn13g2[ib]
print @q.xbgr.xq69_u11.qnpn13g2[ie]
print @q.xbgr.xq69_u11.qnpn13g2[is]
print @r.xbgr.xq69_u11.rsub[i]
print @c.xbgr.xq69_u11.csub[i]
print @q.xbgr.xq69_u12.qnpn13g2[ic]
print @q.xbgr.xq69_u12.qnpn13g2[ib]
print @q.xbgr.xq69_u12.qnpn13g2[ie]
print @q.xbgr.xq69_u12.qnpn13g2[is]
print @r.xbgr.xq69_u12.rsub[i]
print @c.xbgr.xq69_u12.csub[i]
print @q.xbgr.xq69_u13.qnpn13g2[ic]
print @q.xbgr.xq69_u13.qnpn13g2[ib]
print @q.xbgr.xq69_u13.qnpn13g2[ie]
print @q.xbgr.xq69_u13.qnpn13g2[is]
print @r.xbgr.xq69_u13.rsub[i]
print @c.xbgr.xq69_u13.csub[i]
print @q.xbgr.xq69_u14.qnpn13g2[ic]
print @q.xbgr.xq69_u14.qnpn13g2[ib]
print @q.xbgr.xq69_u14.qnpn13g2[ie]
print @q.xbgr.xq69_u14.qnpn13g2[is]
print @r.xbgr.xq69_u14.rsub[i]
print @c.xbgr.xq69_u14.csub[i]
print @q.xbgr.xq69_u15.qnpn13g2[ic]
print @q.xbgr.xq69_u15.qnpn13g2[ib]
print @q.xbgr.xq69_u15.qnpn13g2[ie]
print @q.xbgr.xq69_u15.qnpn13g2[is]
print @r.xbgr.xq69_u15.rsub[i]
print @c.xbgr.xq69_u15.csub[i]
print @q.xbgr.xq69_u16.qnpn13g2[ic]
print @q.xbgr.xq69_u16.qnpn13g2[ib]
print @q.xbgr.xq69_u16.qnpn13g2[ie]
print @q.xbgr.xq69_u16.qnpn13g2[is]
print @r.xbgr.xq69_u16.rsub[i]
print @c.xbgr.xq69_u16.csub[i]
print @q.xbgr.xq69_u17.qnpn13g2[ic]
print @q.xbgr.xq69_u17.qnpn13g2[ib]
print @q.xbgr.xq69_u17.qnpn13g2[ie]
print @q.xbgr.xq69_u17.qnpn13g2[is]
print @r.xbgr.xq69_u17.rsub[i]
print @c.xbgr.xq69_u17.csub[i]
print @q.xbgr.xq69_u18.qnpn13g2[ic]
print @q.xbgr.xq69_u18.qnpn13g2[ib]
print @q.xbgr.xq69_u18.qnpn13g2[ie]
print @q.xbgr.xq69_u18.qnpn13g2[is]
print @r.xbgr.xq69_u18.rsub[i]
print @c.xbgr.xq69_u18.csub[i]
print @q.xbgr.xq69_u19.qnpn13g2[ic]
print @q.xbgr.xq69_u19.qnpn13g2[ib]
print @q.xbgr.xq69_u19.qnpn13g2[ie]
print @q.xbgr.xq69_u19.qnpn13g2[is]
print @r.xbgr.xq69_u19.rsub[i]
print @c.xbgr.xq69_u19.csub[i]
print @q.xbgr.xq69_u20.qnpn13g2[ic]
print @q.xbgr.xq69_u20.qnpn13g2[ib]
print @q.xbgr.xq69_u20.qnpn13g2[ie]
print @q.xbgr.xq69_u20.qnpn13g2[is]
print @r.xbgr.xq69_u20.rsub[i]
print @c.xbgr.xq69_u20.csub[i]
print @q.xbgr.xq69_u21.qnpn13g2[ic]
print @q.xbgr.xq69_u21.qnpn13g2[ib]
print @q.xbgr.xq69_u21.qnpn13g2[ie]
print @q.xbgr.xq69_u21.qnpn13g2[is]
print @r.xbgr.xq69_u21.rsub[i]
print @c.xbgr.xq69_u21.csub[i]
print @q.xbgr.xq69_u22.qnpn13g2[ic]
print @q.xbgr.xq69_u22.qnpn13g2[ib]
print @q.xbgr.xq69_u22.qnpn13g2[ie]
print @q.xbgr.xq69_u22.qnpn13g2[is]
print @r.xbgr.xq69_u22.rsub[i]
print @c.xbgr.xq69_u22.csub[i]
print @q.xbgr.xq69_u23.qnpn13g2[ic]
print @q.xbgr.xq69_u23.qnpn13g2[ib]
print @q.xbgr.xq69_u23.qnpn13g2[ie]
print @q.xbgr.xq69_u23.qnpn13g2[is]
print @r.xbgr.xq69_u23.rsub[i]
print @c.xbgr.xq69_u23.csub[i]
print @q.xbgr.xq69_u24.qnpn13g2[ic]
print @q.xbgr.xq69_u24.qnpn13g2[ib]
print @q.xbgr.xq69_u24.qnpn13g2[ie]
print @q.xbgr.xq69_u24.qnpn13g2[is]
print @r.xbgr.xq69_u24.rsub[i]
print @c.xbgr.xq69_u24.csub[i]
print @q.xbgr.xq70_u2.qnpn13g2[ic]
print @q.xbgr.xq70_u2.qnpn13g2[ib]
print @q.xbgr.xq70_u2.qnpn13g2[ie]
print @q.xbgr.xq70_u2.qnpn13g2[is]
print @r.xbgr.xq70_u2.rsub[i]
print @c.xbgr.xq70_u2.csub[i]
print @q.xbgr.xq70_u3.qnpn13g2[ic]
print @q.xbgr.xq70_u3.qnpn13g2[ib]
print @q.xbgr.xq70_u3.qnpn13g2[ie]
print @q.xbgr.xq70_u3.qnpn13g2[is]
print @r.xbgr.xq70_u3.rsub[i]
print @c.xbgr.xq70_u3.csub[i]
print @q.xbgr.xq70_u4.qnpn13g2[ic]
print @q.xbgr.xq70_u4.qnpn13g2[ib]
print @q.xbgr.xq70_u4.qnpn13g2[ie]
print @q.xbgr.xq70_u4.qnpn13g2[is]
print @r.xbgr.xq70_u4.rsub[i]
print @c.xbgr.xq70_u4.csub[i]
print @q.xbgr.xq70_u5.qnpn13g2[ic]
print @q.xbgr.xq70_u5.qnpn13g2[ib]
print @q.xbgr.xq70_u5.qnpn13g2[ie]
print @q.xbgr.xq70_u5.qnpn13g2[is]
print @r.xbgr.xq70_u5.rsub[i]
print @c.xbgr.xq70_u5.csub[i]
print @q.xbgr.xq70_u6.qnpn13g2[ic]
print @q.xbgr.xq70_u6.qnpn13g2[ib]
print @q.xbgr.xq70_u6.qnpn13g2[ie]
print @q.xbgr.xq70_u6.qnpn13g2[is]
print @r.xbgr.xq70_u6.rsub[i]
print @c.xbgr.xq70_u6.csub[i]
print @q.xbgr.xq70_u7.qnpn13g2[ic]
print @q.xbgr.xq70_u7.qnpn13g2[ib]
print @q.xbgr.xq70_u7.qnpn13g2[ie]
print @q.xbgr.xq70_u7.qnpn13g2[is]
print @r.xbgr.xq70_u7.rsub[i]
print @c.xbgr.xq70_u7.csub[i]
print @q.xbgr.xq70_u8.qnpn13g2[ic]
print @q.xbgr.xq70_u8.qnpn13g2[ib]
print @q.xbgr.xq70_u8.qnpn13g2[ie]
print @q.xbgr.xq70_u8.qnpn13g2[is]
print @r.xbgr.xq70_u8.rsub[i]
print @c.xbgr.xq70_u8.csub[i]
print @q.xbgr.xq70_u9.qnpn13g2[ic]
print @q.xbgr.xq70_u9.qnpn13g2[ib]
print @q.xbgr.xq70_u9.qnpn13g2[ie]
print @q.xbgr.xq70_u9.qnpn13g2[is]
print @r.xbgr.xq70_u9.rsub[i]
print @c.xbgr.xq70_u9.csub[i]
print @q.xbgr.xq70_u10.qnpn13g2[ic]
print @q.xbgr.xq70_u10.qnpn13g2[ib]
print @q.xbgr.xq70_u10.qnpn13g2[ie]
print @q.xbgr.xq70_u10.qnpn13g2[is]
print @r.xbgr.xq70_u10.rsub[i]
print @c.xbgr.xq70_u10.csub[i]
print @q.xbgr.xq70_u11.qnpn13g2[ic]
print @q.xbgr.xq70_u11.qnpn13g2[ib]
print @q.xbgr.xq70_u11.qnpn13g2[ie]
print @q.xbgr.xq70_u11.qnpn13g2[is]
print @r.xbgr.xq70_u11.rsub[i]
print @c.xbgr.xq70_u11.csub[i]
print @q.xbgr.xq70_u12.qnpn13g2[ic]
print @q.xbgr.xq70_u12.qnpn13g2[ib]
print @q.xbgr.xq70_u12.qnpn13g2[ie]
print @q.xbgr.xq70_u12.qnpn13g2[is]
print @r.xbgr.xq70_u12.rsub[i]
print @c.xbgr.xq70_u12.csub[i]
print @q.xbgr.xq70_u13.qnpn13g2[ic]
print @q.xbgr.xq70_u13.qnpn13g2[ib]
print @q.xbgr.xq70_u13.qnpn13g2[ie]
print @q.xbgr.xq70_u13.qnpn13g2[is]
print @r.xbgr.xq70_u13.rsub[i]
print @c.xbgr.xq70_u13.csub[i]
print @q.xbgr.xq70_u14.qnpn13g2[ic]
print @q.xbgr.xq70_u14.qnpn13g2[ib]
print @q.xbgr.xq70_u14.qnpn13g2[ie]
print @q.xbgr.xq70_u14.qnpn13g2[is]
print @r.xbgr.xq70_u14.rsub[i]
print @c.xbgr.xq70_u14.csub[i]
print @q.xbgr.xq70_u15.qnpn13g2[ic]
print @q.xbgr.xq70_u15.qnpn13g2[ib]
print @q.xbgr.xq70_u15.qnpn13g2[ie]
print @q.xbgr.xq70_u15.qnpn13g2[is]
print @r.xbgr.xq70_u15.rsub[i]
print @c.xbgr.xq70_u15.csub[i]
print @q.xbgr.xq70_u16.qnpn13g2[ic]
print @q.xbgr.xq70_u16.qnpn13g2[ib]
print @q.xbgr.xq70_u16.qnpn13g2[ie]
print @q.xbgr.xq70_u16.qnpn13g2[is]
print @r.xbgr.xq70_u16.rsub[i]
print @c.xbgr.xq70_u16.csub[i]
print @q.xbgr.xq70_u17.qnpn13g2[ic]
print @q.xbgr.xq70_u17.qnpn13g2[ib]
print @q.xbgr.xq70_u17.qnpn13g2[ie]
print @q.xbgr.xq70_u17.qnpn13g2[is]
print @r.xbgr.xq70_u17.rsub[i]
print @c.xbgr.xq70_u17.csub[i]
print @q.xbgr.xq70_u18.qnpn13g2[ic]
print @q.xbgr.xq70_u18.qnpn13g2[ib]
print @q.xbgr.xq70_u18.qnpn13g2[ie]
print @q.xbgr.xq70_u18.qnpn13g2[is]
print @r.xbgr.xq70_u18.rsub[i]
print @c.xbgr.xq70_u18.csub[i]
print @q.xbgr.xq70_u19.qnpn13g2[ic]
print @q.xbgr.xq70_u19.qnpn13g2[ib]
print @q.xbgr.xq70_u19.qnpn13g2[ie]
print @q.xbgr.xq70_u19.qnpn13g2[is]
print @r.xbgr.xq70_u19.rsub[i]
print @c.xbgr.xq70_u19.csub[i]
print @q.xbgr.xq70_u20.qnpn13g2[ic]
print @q.xbgr.xq70_u20.qnpn13g2[ib]
print @q.xbgr.xq70_u20.qnpn13g2[ie]
print @q.xbgr.xq70_u20.qnpn13g2[is]
print @r.xbgr.xq70_u20.rsub[i]
print @c.xbgr.xq70_u20.csub[i]
print @q.xbgr.xq70_u21.qnpn13g2[ic]
print @q.xbgr.xq70_u21.qnpn13g2[ib]
print @q.xbgr.xq70_u21.qnpn13g2[ie]
print @q.xbgr.xq70_u21.qnpn13g2[is]
print @r.xbgr.xq70_u21.rsub[i]
print @c.xbgr.xq70_u21.csub[i]
print @q.xbgr.xq70_u22.qnpn13g2[ic]
print @q.xbgr.xq70_u22.qnpn13g2[ib]
print @q.xbgr.xq70_u22.qnpn13g2[ie]
print @q.xbgr.xq70_u22.qnpn13g2[is]
print @r.xbgr.xq70_u22.rsub[i]
print @c.xbgr.xq70_u22.csub[i]
print @q.xbgr.xq70_u23.qnpn13g2[ic]
print @q.xbgr.xq70_u23.qnpn13g2[ib]
print @q.xbgr.xq70_u23.qnpn13g2[ie]
print @q.xbgr.xq70_u23.qnpn13g2[is]
print @r.xbgr.xq70_u23.rsub[i]
print @c.xbgr.xq70_u23.csub[i]
print @q.xbgr.xq70_u24.qnpn13g2[ic]
print @q.xbgr.xq70_u24.qnpn13g2[ib]
print @q.xbgr.xq70_u24.qnpn13g2[ie]
print @q.xbgr.xq70_u24.qnpn13g2[is]
print @r.xbgr.xq70_u24.rsub[i]
print @c.xbgr.xq70_u24.csub[i]
print @q.xbgr.xq71_u2.qnpn13g2[ic]
print @q.xbgr.xq71_u2.qnpn13g2[ib]
print @q.xbgr.xq71_u2.qnpn13g2[ie]
print @q.xbgr.xq71_u2.qnpn13g2[is]
print @r.xbgr.xq71_u2.rsub[i]
print @c.xbgr.xq71_u2.csub[i]
print @q.xbgr.xq71_u3.qnpn13g2[ic]
print @q.xbgr.xq71_u3.qnpn13g2[ib]
print @q.xbgr.xq71_u3.qnpn13g2[ie]
print @q.xbgr.xq71_u3.qnpn13g2[is]
print @r.xbgr.xq71_u3.rsub[i]
print @c.xbgr.xq71_u3.csub[i]
print @q.xbgr.xq71_u4.qnpn13g2[ic]
print @q.xbgr.xq71_u4.qnpn13g2[ib]
print @q.xbgr.xq71_u4.qnpn13g2[ie]
print @q.xbgr.xq71_u4.qnpn13g2[is]
print @r.xbgr.xq71_u4.rsub[i]
print @c.xbgr.xq71_u4.csub[i]
print @q.xbgr.xq71_u5.qnpn13g2[ic]
print @q.xbgr.xq71_u5.qnpn13g2[ib]
print @q.xbgr.xq71_u5.qnpn13g2[ie]
print @q.xbgr.xq71_u5.qnpn13g2[is]
print @r.xbgr.xq71_u5.rsub[i]
print @c.xbgr.xq71_u5.csub[i]
print @q.xbgr.xq71_u6.qnpn13g2[ic]
print @q.xbgr.xq71_u6.qnpn13g2[ib]
print @q.xbgr.xq71_u6.qnpn13g2[ie]
print @q.xbgr.xq71_u6.qnpn13g2[is]
print @r.xbgr.xq71_u6.rsub[i]
print @c.xbgr.xq71_u6.csub[i]
print @q.xbgr.xq71_u7.qnpn13g2[ic]
print @q.xbgr.xq71_u7.qnpn13g2[ib]
print @q.xbgr.xq71_u7.qnpn13g2[ie]
print @q.xbgr.xq71_u7.qnpn13g2[is]
print @r.xbgr.xq71_u7.rsub[i]
print @c.xbgr.xq71_u7.csub[i]
print @q.xbgr.xq71_u8.qnpn13g2[ic]
print @q.xbgr.xq71_u8.qnpn13g2[ib]
print @q.xbgr.xq71_u8.qnpn13g2[ie]
print @q.xbgr.xq71_u8.qnpn13g2[is]
print @r.xbgr.xq71_u8.rsub[i]
print @c.xbgr.xq71_u8.csub[i]
print @q.xbgr.xq71_u9.qnpn13g2[ic]
print @q.xbgr.xq71_u9.qnpn13g2[ib]
print @q.xbgr.xq71_u9.qnpn13g2[ie]
print @q.xbgr.xq71_u9.qnpn13g2[is]
print @r.xbgr.xq71_u9.rsub[i]
print @c.xbgr.xq71_u9.csub[i]
print @q.xbgr.xq71_u10.qnpn13g2[ic]
print @q.xbgr.xq71_u10.qnpn13g2[ib]
print @q.xbgr.xq71_u10.qnpn13g2[ie]
print @q.xbgr.xq71_u10.qnpn13g2[is]
print @r.xbgr.xq71_u10.rsub[i]
print @c.xbgr.xq71_u10.csub[i]
print @q.xbgr.xq71_u11.qnpn13g2[ic]
print @q.xbgr.xq71_u11.qnpn13g2[ib]
print @q.xbgr.xq71_u11.qnpn13g2[ie]
print @q.xbgr.xq71_u11.qnpn13g2[is]
print @r.xbgr.xq71_u11.rsub[i]
print @c.xbgr.xq71_u11.csub[i]
print @q.xbgr.xq71_u12.qnpn13g2[ic]
print @q.xbgr.xq71_u12.qnpn13g2[ib]
print @q.xbgr.xq71_u12.qnpn13g2[ie]
print @q.xbgr.xq71_u12.qnpn13g2[is]
print @r.xbgr.xq71_u12.rsub[i]
print @c.xbgr.xq71_u12.csub[i]
print @q.xbgr.xq71_u13.qnpn13g2[ic]
print @q.xbgr.xq71_u13.qnpn13g2[ib]
print @q.xbgr.xq71_u13.qnpn13g2[ie]
print @q.xbgr.xq71_u13.qnpn13g2[is]
print @r.xbgr.xq71_u13.rsub[i]
print @c.xbgr.xq71_u13.csub[i]
print @q.xbgr.xq71_u14.qnpn13g2[ic]
print @q.xbgr.xq71_u14.qnpn13g2[ib]
print @q.xbgr.xq71_u14.qnpn13g2[ie]
print @q.xbgr.xq71_u14.qnpn13g2[is]
print @r.xbgr.xq71_u14.rsub[i]
print @c.xbgr.xq71_u14.csub[i]
print @q.xbgr.xq71_u15.qnpn13g2[ic]
print @q.xbgr.xq71_u15.qnpn13g2[ib]
print @q.xbgr.xq71_u15.qnpn13g2[ie]
print @q.xbgr.xq71_u15.qnpn13g2[is]
print @r.xbgr.xq71_u15.rsub[i]
print @c.xbgr.xq71_u15.csub[i]
print @q.xbgr.xq71_u16.qnpn13g2[ic]
print @q.xbgr.xq71_u16.qnpn13g2[ib]
print @q.xbgr.xq71_u16.qnpn13g2[ie]
print @q.xbgr.xq71_u16.qnpn13g2[is]
print @r.xbgr.xq71_u16.rsub[i]
print @c.xbgr.xq71_u16.csub[i]
print @q.xbgr.xq71_u17.qnpn13g2[ic]
print @q.xbgr.xq71_u17.qnpn13g2[ib]
print @q.xbgr.xq71_u17.qnpn13g2[ie]
print @q.xbgr.xq71_u17.qnpn13g2[is]
print @r.xbgr.xq71_u17.rsub[i]
print @c.xbgr.xq71_u17.csub[i]
print @q.xbgr.xq71_u18.qnpn13g2[ic]
print @q.xbgr.xq71_u18.qnpn13g2[ib]
print @q.xbgr.xq71_u18.qnpn13g2[ie]
print @q.xbgr.xq71_u18.qnpn13g2[is]
print @r.xbgr.xq71_u18.rsub[i]
print @c.xbgr.xq71_u18.csub[i]
print @q.xbgr.xq71_u19.qnpn13g2[ic]
print @q.xbgr.xq71_u19.qnpn13g2[ib]
print @q.xbgr.xq71_u19.qnpn13g2[ie]
print @q.xbgr.xq71_u19.qnpn13g2[is]
print @r.xbgr.xq71_u19.rsub[i]
print @c.xbgr.xq71_u19.csub[i]
print @q.xbgr.xq71_u20.qnpn13g2[ic]
print @q.xbgr.xq71_u20.qnpn13g2[ib]
print @q.xbgr.xq71_u20.qnpn13g2[ie]
print @q.xbgr.xq71_u20.qnpn13g2[is]
print @r.xbgr.xq71_u20.rsub[i]
print @c.xbgr.xq71_u20.csub[i]
print @q.xbgr.xq71_u21.qnpn13g2[ic]
print @q.xbgr.xq71_u21.qnpn13g2[ib]
print @q.xbgr.xq71_u21.qnpn13g2[ie]
print @q.xbgr.xq71_u21.qnpn13g2[is]
print @r.xbgr.xq71_u21.rsub[i]
print @c.xbgr.xq71_u21.csub[i]
print @q.xbgr.xq71_u22.qnpn13g2[ic]
print @q.xbgr.xq71_u22.qnpn13g2[ib]
print @q.xbgr.xq71_u22.qnpn13g2[ie]
print @q.xbgr.xq71_u22.qnpn13g2[is]
print @r.xbgr.xq71_u22.rsub[i]
print @c.xbgr.xq71_u22.csub[i]
print @q.xbgr.xq71_u23.qnpn13g2[ic]
print @q.xbgr.xq71_u23.qnpn13g2[ib]
print @q.xbgr.xq71_u23.qnpn13g2[ie]
print @q.xbgr.xq71_u23.qnpn13g2[is]
print @r.xbgr.xq71_u23.rsub[i]
print @c.xbgr.xq71_u23.csub[i]
print @q.xbgr.xq71_u24.qnpn13g2[ic]
print @q.xbgr.xq71_u24.qnpn13g2[ib]
print @q.xbgr.xq71_u24.qnpn13g2[ie]
print @q.xbgr.xq71_u24.qnpn13g2[is]
print @r.xbgr.xq71_u24.rsub[i]
print @c.xbgr.xq71_u24.csub[i]
print @q.xbgr.xq72_u2.qnpn13g2[ic]
print @q.xbgr.xq72_u2.qnpn13g2[ib]
print @q.xbgr.xq72_u2.qnpn13g2[ie]
print @q.xbgr.xq72_u2.qnpn13g2[is]
print @r.xbgr.xq72_u2.rsub[i]
print @c.xbgr.xq72_u2.csub[i]
print @q.xbgr.xq72_u3.qnpn13g2[ic]
print @q.xbgr.xq72_u3.qnpn13g2[ib]
print @q.xbgr.xq72_u3.qnpn13g2[ie]
print @q.xbgr.xq72_u3.qnpn13g2[is]
print @r.xbgr.xq72_u3.rsub[i]
print @c.xbgr.xq72_u3.csub[i]
print @q.xbgr.xq72_u4.qnpn13g2[ic]
print @q.xbgr.xq72_u4.qnpn13g2[ib]
print @q.xbgr.xq72_u4.qnpn13g2[ie]
print @q.xbgr.xq72_u4.qnpn13g2[is]
print @r.xbgr.xq72_u4.rsub[i]
print @c.xbgr.xq72_u4.csub[i]
print @q.xbgr.xq72_u5.qnpn13g2[ic]
print @q.xbgr.xq72_u5.qnpn13g2[ib]
print @q.xbgr.xq72_u5.qnpn13g2[ie]
print @q.xbgr.xq72_u5.qnpn13g2[is]
print @r.xbgr.xq72_u5.rsub[i]
print @c.xbgr.xq72_u5.csub[i]
print @q.xbgr.xq72_u6.qnpn13g2[ic]
print @q.xbgr.xq72_u6.qnpn13g2[ib]
print @q.xbgr.xq72_u6.qnpn13g2[ie]
print @q.xbgr.xq72_u6.qnpn13g2[is]
print @r.xbgr.xq72_u6.rsub[i]
print @c.xbgr.xq72_u6.csub[i]
print @q.xbgr.xq72_u7.qnpn13g2[ic]
print @q.xbgr.xq72_u7.qnpn13g2[ib]
print @q.xbgr.xq72_u7.qnpn13g2[ie]
print @q.xbgr.xq72_u7.qnpn13g2[is]
print @r.xbgr.xq72_u7.rsub[i]
print @c.xbgr.xq72_u7.csub[i]
print @q.xbgr.xq72_u8.qnpn13g2[ic]
print @q.xbgr.xq72_u8.qnpn13g2[ib]
print @q.xbgr.xq72_u8.qnpn13g2[ie]
print @q.xbgr.xq72_u8.qnpn13g2[is]
print @r.xbgr.xq72_u8.rsub[i]
print @c.xbgr.xq72_u8.csub[i]
print @q.xbgr.xq72_u9.qnpn13g2[ic]
print @q.xbgr.xq72_u9.qnpn13g2[ib]
print @q.xbgr.xq72_u9.qnpn13g2[ie]
print @q.xbgr.xq72_u9.qnpn13g2[is]
print @r.xbgr.xq72_u9.rsub[i]
print @c.xbgr.xq72_u9.csub[i]
print @q.xbgr.xq72_u10.qnpn13g2[ic]
print @q.xbgr.xq72_u10.qnpn13g2[ib]
print @q.xbgr.xq72_u10.qnpn13g2[ie]
print @q.xbgr.xq72_u10.qnpn13g2[is]
print @r.xbgr.xq72_u10.rsub[i]
print @c.xbgr.xq72_u10.csub[i]
print @q.xbgr.xq72_u11.qnpn13g2[ic]
print @q.xbgr.xq72_u11.qnpn13g2[ib]
print @q.xbgr.xq72_u11.qnpn13g2[ie]
print @q.xbgr.xq72_u11.qnpn13g2[is]
print @r.xbgr.xq72_u11.rsub[i]
print @c.xbgr.xq72_u11.csub[i]
print @q.xbgr.xq72_u12.qnpn13g2[ic]
print @q.xbgr.xq72_u12.qnpn13g2[ib]
print @q.xbgr.xq72_u12.qnpn13g2[ie]
print @q.xbgr.xq72_u12.qnpn13g2[is]
print @r.xbgr.xq72_u12.rsub[i]
print @c.xbgr.xq72_u12.csub[i]
print @q.xbgr.xq72_u13.qnpn13g2[ic]
print @q.xbgr.xq72_u13.qnpn13g2[ib]
print @q.xbgr.xq72_u13.qnpn13g2[ie]
print @q.xbgr.xq72_u13.qnpn13g2[is]
print @r.xbgr.xq72_u13.rsub[i]
print @c.xbgr.xq72_u13.csub[i]
print @q.xbgr.xq72_u14.qnpn13g2[ic]
print @q.xbgr.xq72_u14.qnpn13g2[ib]
print @q.xbgr.xq72_u14.qnpn13g2[ie]
print @q.xbgr.xq72_u14.qnpn13g2[is]
print @r.xbgr.xq72_u14.rsub[i]
print @c.xbgr.xq72_u14.csub[i]
print @q.xbgr.xq72_u15.qnpn13g2[ic]
print @q.xbgr.xq72_u15.qnpn13g2[ib]
print @q.xbgr.xq72_u15.qnpn13g2[ie]
print @q.xbgr.xq72_u15.qnpn13g2[is]
print @r.xbgr.xq72_u15.rsub[i]
print @c.xbgr.xq72_u15.csub[i]
print @q.xbgr.xq72_u16.qnpn13g2[ic]
print @q.xbgr.xq72_u16.qnpn13g2[ib]
print @q.xbgr.xq72_u16.qnpn13g2[ie]
print @q.xbgr.xq72_u16.qnpn13g2[is]
print @r.xbgr.xq72_u16.rsub[i]
print @c.xbgr.xq72_u16.csub[i]
print @q.xbgr.xq72_u17.qnpn13g2[ic]
print @q.xbgr.xq72_u17.qnpn13g2[ib]
print @q.xbgr.xq72_u17.qnpn13g2[ie]
print @q.xbgr.xq72_u17.qnpn13g2[is]
print @r.xbgr.xq72_u17.rsub[i]
print @c.xbgr.xq72_u17.csub[i]
print @q.xbgr.xq72_u18.qnpn13g2[ic]
print @q.xbgr.xq72_u18.qnpn13g2[ib]
print @q.xbgr.xq72_u18.qnpn13g2[ie]
print @q.xbgr.xq72_u18.qnpn13g2[is]
print @r.xbgr.xq72_u18.rsub[i]
print @c.xbgr.xq72_u18.csub[i]
print @q.xbgr.xq72_u19.qnpn13g2[ic]
print @q.xbgr.xq72_u19.qnpn13g2[ib]
print @q.xbgr.xq72_u19.qnpn13g2[ie]
print @q.xbgr.xq72_u19.qnpn13g2[is]
print @r.xbgr.xq72_u19.rsub[i]
print @c.xbgr.xq72_u19.csub[i]
print @q.xbgr.xq72_u20.qnpn13g2[ic]
print @q.xbgr.xq72_u20.qnpn13g2[ib]
print @q.xbgr.xq72_u20.qnpn13g2[ie]
print @q.xbgr.xq72_u20.qnpn13g2[is]
print @r.xbgr.xq72_u20.rsub[i]
print @c.xbgr.xq72_u20.csub[i]
print @q.xbgr.xq72_u21.qnpn13g2[ic]
print @q.xbgr.xq72_u21.qnpn13g2[ib]
print @q.xbgr.xq72_u21.qnpn13g2[ie]
print @q.xbgr.xq72_u21.qnpn13g2[is]
print @r.xbgr.xq72_u21.rsub[i]
print @c.xbgr.xq72_u21.csub[i]
print @q.xbgr.xq72_u22.qnpn13g2[ic]
print @q.xbgr.xq72_u22.qnpn13g2[ib]
print @q.xbgr.xq72_u22.qnpn13g2[ie]
print @q.xbgr.xq72_u22.qnpn13g2[is]
print @r.xbgr.xq72_u22.rsub[i]
print @c.xbgr.xq72_u22.csub[i]
print @q.xbgr.xq72_u23.qnpn13g2[ic]
print @q.xbgr.xq72_u23.qnpn13g2[ib]
print @q.xbgr.xq72_u23.qnpn13g2[ie]
print @q.xbgr.xq72_u23.qnpn13g2[is]
print @r.xbgr.xq72_u23.rsub[i]
print @c.xbgr.xq72_u23.csub[i]
print @q.xbgr.xq72_u24.qnpn13g2[ic]
print @q.xbgr.xq72_u24.qnpn13g2[ib]
print @q.xbgr.xq72_u24.qnpn13g2[ie]
print @q.xbgr.xq72_u24.qnpn13g2[is]
print @r.xbgr.xq72_u24.rsub[i]
print @c.xbgr.xq72_u24.csub[i]
print @q.xbgr.xq73_u2.qnpn13g2[ic]
print @q.xbgr.xq73_u2.qnpn13g2[ib]
print @q.xbgr.xq73_u2.qnpn13g2[ie]
print @q.xbgr.xq73_u2.qnpn13g2[is]
print @r.xbgr.xq73_u2.rsub[i]
print @c.xbgr.xq73_u2.csub[i]
print @q.xbgr.xq73_u3.qnpn13g2[ic]
print @q.xbgr.xq73_u3.qnpn13g2[ib]
print @q.xbgr.xq73_u3.qnpn13g2[ie]
print @q.xbgr.xq73_u3.qnpn13g2[is]
print @r.xbgr.xq73_u3.rsub[i]
print @c.xbgr.xq73_u3.csub[i]
print @q.xbgr.xq73_u4.qnpn13g2[ic]
print @q.xbgr.xq73_u4.qnpn13g2[ib]
print @q.xbgr.xq73_u4.qnpn13g2[ie]
print @q.xbgr.xq73_u4.qnpn13g2[is]
print @r.xbgr.xq73_u4.rsub[i]
print @c.xbgr.xq73_u4.csub[i]
print @q.xbgr.xq73_u5.qnpn13g2[ic]
print @q.xbgr.xq73_u5.qnpn13g2[ib]
print @q.xbgr.xq73_u5.qnpn13g2[ie]
print @q.xbgr.xq73_u5.qnpn13g2[is]
print @r.xbgr.xq73_u5.rsub[i]
print @c.xbgr.xq73_u5.csub[i]
print @q.xbgr.xq73_u6.qnpn13g2[ic]
print @q.xbgr.xq73_u6.qnpn13g2[ib]
print @q.xbgr.xq73_u6.qnpn13g2[ie]
print @q.xbgr.xq73_u6.qnpn13g2[is]
print @r.xbgr.xq73_u6.rsub[i]
print @c.xbgr.xq73_u6.csub[i]
print @q.xbgr.xq73_u7.qnpn13g2[ic]
print @q.xbgr.xq73_u7.qnpn13g2[ib]
print @q.xbgr.xq73_u7.qnpn13g2[ie]
print @q.xbgr.xq73_u7.qnpn13g2[is]
print @r.xbgr.xq73_u7.rsub[i]
print @c.xbgr.xq73_u7.csub[i]
print @q.xbgr.xq73_u8.qnpn13g2[ic]
print @q.xbgr.xq73_u8.qnpn13g2[ib]
print @q.xbgr.xq73_u8.qnpn13g2[ie]
print @q.xbgr.xq73_u8.qnpn13g2[is]
print @r.xbgr.xq73_u8.rsub[i]
print @c.xbgr.xq73_u8.csub[i]
print @q.xbgr.xq73_u9.qnpn13g2[ic]
print @q.xbgr.xq73_u9.qnpn13g2[ib]
print @q.xbgr.xq73_u9.qnpn13g2[ie]
print @q.xbgr.xq73_u9.qnpn13g2[is]
print @r.xbgr.xq73_u9.rsub[i]
print @c.xbgr.xq73_u9.csub[i]
print @q.xbgr.xq73_u10.qnpn13g2[ic]
print @q.xbgr.xq73_u10.qnpn13g2[ib]
print @q.xbgr.xq73_u10.qnpn13g2[ie]
print @q.xbgr.xq73_u10.qnpn13g2[is]
print @r.xbgr.xq73_u10.rsub[i]
print @c.xbgr.xq73_u10.csub[i]
print @q.xbgr.xq73_u11.qnpn13g2[ic]
print @q.xbgr.xq73_u11.qnpn13g2[ib]
print @q.xbgr.xq73_u11.qnpn13g2[ie]
print @q.xbgr.xq73_u11.qnpn13g2[is]
print @r.xbgr.xq73_u11.rsub[i]
print @c.xbgr.xq73_u11.csub[i]
print @q.xbgr.xq73_u12.qnpn13g2[ic]
print @q.xbgr.xq73_u12.qnpn13g2[ib]
print @q.xbgr.xq73_u12.qnpn13g2[ie]
print @q.xbgr.xq73_u12.qnpn13g2[is]
print @r.xbgr.xq73_u12.rsub[i]
print @c.xbgr.xq73_u12.csub[i]
print @q.xbgr.xq73_u13.qnpn13g2[ic]
print @q.xbgr.xq73_u13.qnpn13g2[ib]
print @q.xbgr.xq73_u13.qnpn13g2[ie]
print @q.xbgr.xq73_u13.qnpn13g2[is]
print @r.xbgr.xq73_u13.rsub[i]
print @c.xbgr.xq73_u13.csub[i]
print @q.xbgr.xq73_u14.qnpn13g2[ic]
print @q.xbgr.xq73_u14.qnpn13g2[ib]
print @q.xbgr.xq73_u14.qnpn13g2[ie]
print @q.xbgr.xq73_u14.qnpn13g2[is]
print @r.xbgr.xq73_u14.rsub[i]
print @c.xbgr.xq73_u14.csub[i]
print @q.xbgr.xq73_u15.qnpn13g2[ic]
print @q.xbgr.xq73_u15.qnpn13g2[ib]
print @q.xbgr.xq73_u15.qnpn13g2[ie]
print @q.xbgr.xq73_u15.qnpn13g2[is]
print @r.xbgr.xq73_u15.rsub[i]
print @c.xbgr.xq73_u15.csub[i]
print @q.xbgr.xq73_u16.qnpn13g2[ic]
print @q.xbgr.xq73_u16.qnpn13g2[ib]
print @q.xbgr.xq73_u16.qnpn13g2[ie]
print @q.xbgr.xq73_u16.qnpn13g2[is]
print @r.xbgr.xq73_u16.rsub[i]
print @c.xbgr.xq73_u16.csub[i]
print @q.xbgr.xq73_u17.qnpn13g2[ic]
print @q.xbgr.xq73_u17.qnpn13g2[ib]
print @q.xbgr.xq73_u17.qnpn13g2[ie]
print @q.xbgr.xq73_u17.qnpn13g2[is]
print @r.xbgr.xq73_u17.rsub[i]
print @c.xbgr.xq73_u17.csub[i]
print @q.xbgr.xq73_u18.qnpn13g2[ic]
print @q.xbgr.xq73_u18.qnpn13g2[ib]
print @q.xbgr.xq73_u18.qnpn13g2[ie]
print @q.xbgr.xq73_u18.qnpn13g2[is]
print @r.xbgr.xq73_u18.rsub[i]
print @c.xbgr.xq73_u18.csub[i]
print @q.xbgr.xq73_u19.qnpn13g2[ic]
print @q.xbgr.xq73_u19.qnpn13g2[ib]
print @q.xbgr.xq73_u19.qnpn13g2[ie]
print @q.xbgr.xq73_u19.qnpn13g2[is]
print @r.xbgr.xq73_u19.rsub[i]
print @c.xbgr.xq73_u19.csub[i]
print @q.xbgr.xq73_u20.qnpn13g2[ic]
print @q.xbgr.xq73_u20.qnpn13g2[ib]
print @q.xbgr.xq73_u20.qnpn13g2[ie]
print @q.xbgr.xq73_u20.qnpn13g2[is]
print @r.xbgr.xq73_u20.rsub[i]
print @c.xbgr.xq73_u20.csub[i]
print @q.xbgr.xq73_u21.qnpn13g2[ic]
print @q.xbgr.xq73_u21.qnpn13g2[ib]
print @q.xbgr.xq73_u21.qnpn13g2[ie]
print @q.xbgr.xq73_u21.qnpn13g2[is]
print @r.xbgr.xq73_u21.rsub[i]
print @c.xbgr.xq73_u21.csub[i]
print @q.xbgr.xq73_u22.qnpn13g2[ic]
print @q.xbgr.xq73_u22.qnpn13g2[ib]
print @q.xbgr.xq73_u22.qnpn13g2[ie]
print @q.xbgr.xq73_u22.qnpn13g2[is]
print @r.xbgr.xq73_u22.rsub[i]
print @c.xbgr.xq73_u22.csub[i]
print @q.xbgr.xq73_u23.qnpn13g2[ic]
print @q.xbgr.xq73_u23.qnpn13g2[ib]
print @q.xbgr.xq73_u23.qnpn13g2[ie]
print @q.xbgr.xq73_u23.qnpn13g2[is]
print @r.xbgr.xq73_u23.rsub[i]
print @c.xbgr.xq73_u23.csub[i]
print @q.xbgr.xq73_u24.qnpn13g2[ic]
print @q.xbgr.xq73_u24.qnpn13g2[ib]
print @q.xbgr.xq73_u24.qnpn13g2[ie]
print @q.xbgr.xq73_u24.qnpn13g2[is]
print @r.xbgr.xq73_u24.rsub[i]
print @c.xbgr.xq73_u24.csub[i]
print @q.xbgr.xq74_u2.qnpn13g2[ic]
print @q.xbgr.xq74_u2.qnpn13g2[ib]
print @q.xbgr.xq74_u2.qnpn13g2[ie]
print @q.xbgr.xq74_u2.qnpn13g2[is]
print @r.xbgr.xq74_u2.rsub[i]
print @c.xbgr.xq74_u2.csub[i]
print @q.xbgr.xq74_u3.qnpn13g2[ic]
print @q.xbgr.xq74_u3.qnpn13g2[ib]
print @q.xbgr.xq74_u3.qnpn13g2[ie]
print @q.xbgr.xq74_u3.qnpn13g2[is]
print @r.xbgr.xq74_u3.rsub[i]
print @c.xbgr.xq74_u3.csub[i]
print @q.xbgr.xq74_u4.qnpn13g2[ic]
print @q.xbgr.xq74_u4.qnpn13g2[ib]
print @q.xbgr.xq74_u4.qnpn13g2[ie]
print @q.xbgr.xq74_u4.qnpn13g2[is]
print @r.xbgr.xq74_u4.rsub[i]
print @c.xbgr.xq74_u4.csub[i]
print @q.xbgr.xq74_u5.qnpn13g2[ic]
print @q.xbgr.xq74_u5.qnpn13g2[ib]
print @q.xbgr.xq74_u5.qnpn13g2[ie]
print @q.xbgr.xq74_u5.qnpn13g2[is]
print @r.xbgr.xq74_u5.rsub[i]
print @c.xbgr.xq74_u5.csub[i]
print @q.xbgr.xq74_u6.qnpn13g2[ic]
print @q.xbgr.xq74_u6.qnpn13g2[ib]
print @q.xbgr.xq74_u6.qnpn13g2[ie]
print @q.xbgr.xq74_u6.qnpn13g2[is]
print @r.xbgr.xq74_u6.rsub[i]
print @c.xbgr.xq74_u6.csub[i]
print @q.xbgr.xq74_u7.qnpn13g2[ic]
print @q.xbgr.xq74_u7.qnpn13g2[ib]
print @q.xbgr.xq74_u7.qnpn13g2[ie]
print @q.xbgr.xq74_u7.qnpn13g2[is]
print @r.xbgr.xq74_u7.rsub[i]
print @c.xbgr.xq74_u7.csub[i]
print @q.xbgr.xq74_u8.qnpn13g2[ic]
print @q.xbgr.xq74_u8.qnpn13g2[ib]
print @q.xbgr.xq74_u8.qnpn13g2[ie]
print @q.xbgr.xq74_u8.qnpn13g2[is]
print @r.xbgr.xq74_u8.rsub[i]
print @c.xbgr.xq74_u8.csub[i]
print @q.xbgr.xq74_u9.qnpn13g2[ic]
print @q.xbgr.xq74_u9.qnpn13g2[ib]
print @q.xbgr.xq74_u9.qnpn13g2[ie]
print @q.xbgr.xq74_u9.qnpn13g2[is]
print @r.xbgr.xq74_u9.rsub[i]
print @c.xbgr.xq74_u9.csub[i]
print @q.xbgr.xq74_u10.qnpn13g2[ic]
print @q.xbgr.xq74_u10.qnpn13g2[ib]
print @q.xbgr.xq74_u10.qnpn13g2[ie]
print @q.xbgr.xq74_u10.qnpn13g2[is]
print @r.xbgr.xq74_u10.rsub[i]
print @c.xbgr.xq74_u10.csub[i]
print @q.xbgr.xq74_u11.qnpn13g2[ic]
print @q.xbgr.xq74_u11.qnpn13g2[ib]
print @q.xbgr.xq74_u11.qnpn13g2[ie]
print @q.xbgr.xq74_u11.qnpn13g2[is]
print @r.xbgr.xq74_u11.rsub[i]
print @c.xbgr.xq74_u11.csub[i]
print @q.xbgr.xq74_u12.qnpn13g2[ic]
print @q.xbgr.xq74_u12.qnpn13g2[ib]
print @q.xbgr.xq74_u12.qnpn13g2[ie]
print @q.xbgr.xq74_u12.qnpn13g2[is]
print @r.xbgr.xq74_u12.rsub[i]
print @c.xbgr.xq74_u12.csub[i]
print @q.xbgr.xq74_u13.qnpn13g2[ic]
print @q.xbgr.xq74_u13.qnpn13g2[ib]
print @q.xbgr.xq74_u13.qnpn13g2[ie]
print @q.xbgr.xq74_u13.qnpn13g2[is]
print @r.xbgr.xq74_u13.rsub[i]
print @c.xbgr.xq74_u13.csub[i]
print @q.xbgr.xq74_u14.qnpn13g2[ic]
print @q.xbgr.xq74_u14.qnpn13g2[ib]
print @q.xbgr.xq74_u14.qnpn13g2[ie]
print @q.xbgr.xq74_u14.qnpn13g2[is]
print @r.xbgr.xq74_u14.rsub[i]
print @c.xbgr.xq74_u14.csub[i]
print @q.xbgr.xq74_u15.qnpn13g2[ic]
print @q.xbgr.xq74_u15.qnpn13g2[ib]
print @q.xbgr.xq74_u15.qnpn13g2[ie]
print @q.xbgr.xq74_u15.qnpn13g2[is]
print @r.xbgr.xq74_u15.rsub[i]
print @c.xbgr.xq74_u15.csub[i]
print @q.xbgr.xq74_u16.qnpn13g2[ic]
print @q.xbgr.xq74_u16.qnpn13g2[ib]
print @q.xbgr.xq74_u16.qnpn13g2[ie]
print @q.xbgr.xq74_u16.qnpn13g2[is]
print @r.xbgr.xq74_u16.rsub[i]
print @c.xbgr.xq74_u16.csub[i]
print @q.xbgr.xq74_u17.qnpn13g2[ic]
print @q.xbgr.xq74_u17.qnpn13g2[ib]
print @q.xbgr.xq74_u17.qnpn13g2[ie]
print @q.xbgr.xq74_u17.qnpn13g2[is]
print @r.xbgr.xq74_u17.rsub[i]
print @c.xbgr.xq74_u17.csub[i]
print @q.xbgr.xq74_u18.qnpn13g2[ic]
print @q.xbgr.xq74_u18.qnpn13g2[ib]
print @q.xbgr.xq74_u18.qnpn13g2[ie]
print @q.xbgr.xq74_u18.qnpn13g2[is]
print @r.xbgr.xq74_u18.rsub[i]
print @c.xbgr.xq74_u18.csub[i]
print @q.xbgr.xq74_u19.qnpn13g2[ic]
print @q.xbgr.xq74_u19.qnpn13g2[ib]
print @q.xbgr.xq74_u19.qnpn13g2[ie]
print @q.xbgr.xq74_u19.qnpn13g2[is]
print @r.xbgr.xq74_u19.rsub[i]
print @c.xbgr.xq74_u19.csub[i]
print @q.xbgr.xq74_u20.qnpn13g2[ic]
print @q.xbgr.xq74_u20.qnpn13g2[ib]
print @q.xbgr.xq74_u20.qnpn13g2[ie]
print @q.xbgr.xq74_u20.qnpn13g2[is]
print @r.xbgr.xq74_u20.rsub[i]
print @c.xbgr.xq74_u20.csub[i]
print @q.xbgr.xq74_u21.qnpn13g2[ic]
print @q.xbgr.xq74_u21.qnpn13g2[ib]
print @q.xbgr.xq74_u21.qnpn13g2[ie]
print @q.xbgr.xq74_u21.qnpn13g2[is]
print @r.xbgr.xq74_u21.rsub[i]
print @c.xbgr.xq74_u21.csub[i]
print @q.xbgr.xq74_u22.qnpn13g2[ic]
print @q.xbgr.xq74_u22.qnpn13g2[ib]
print @q.xbgr.xq74_u22.qnpn13g2[ie]
print @q.xbgr.xq74_u22.qnpn13g2[is]
print @r.xbgr.xq74_u22.rsub[i]
print @c.xbgr.xq74_u22.csub[i]
print @q.xbgr.xq74_u23.qnpn13g2[ic]
print @q.xbgr.xq74_u23.qnpn13g2[ib]
print @q.xbgr.xq74_u23.qnpn13g2[ie]
print @q.xbgr.xq74_u23.qnpn13g2[is]
print @r.xbgr.xq74_u23.rsub[i]
print @c.xbgr.xq74_u23.csub[i]
print @q.xbgr.xq74_u24.qnpn13g2[ic]
print @q.xbgr.xq74_u24.qnpn13g2[ib]
print @q.xbgr.xq74_u24.qnpn13g2[ie]
print @q.xbgr.xq74_u24.qnpn13g2[is]
print @r.xbgr.xq74_u24.rsub[i]
print @c.xbgr.xq74_u24.csub[i]
print @q.xbgr.xq75_u2.qnpn13g2[ic]
print @q.xbgr.xq75_u2.qnpn13g2[ib]
print @q.xbgr.xq75_u2.qnpn13g2[ie]
print @q.xbgr.xq75_u2.qnpn13g2[is]
print @r.xbgr.xq75_u2.rsub[i]
print @c.xbgr.xq75_u2.csub[i]
print @q.xbgr.xq75_u3.qnpn13g2[ic]
print @q.xbgr.xq75_u3.qnpn13g2[ib]
print @q.xbgr.xq75_u3.qnpn13g2[ie]
print @q.xbgr.xq75_u3.qnpn13g2[is]
print @r.xbgr.xq75_u3.rsub[i]
print @c.xbgr.xq75_u3.csub[i]
print @q.xbgr.xq75_u4.qnpn13g2[ic]
print @q.xbgr.xq75_u4.qnpn13g2[ib]
print @q.xbgr.xq75_u4.qnpn13g2[ie]
print @q.xbgr.xq75_u4.qnpn13g2[is]
print @r.xbgr.xq75_u4.rsub[i]
print @c.xbgr.xq75_u4.csub[i]
print @q.xbgr.xq75_u5.qnpn13g2[ic]
print @q.xbgr.xq75_u5.qnpn13g2[ib]
print @q.xbgr.xq75_u5.qnpn13g2[ie]
print @q.xbgr.xq75_u5.qnpn13g2[is]
print @r.xbgr.xq75_u5.rsub[i]
print @c.xbgr.xq75_u5.csub[i]
print @q.xbgr.xq75_u6.qnpn13g2[ic]
print @q.xbgr.xq75_u6.qnpn13g2[ib]
print @q.xbgr.xq75_u6.qnpn13g2[ie]
print @q.xbgr.xq75_u6.qnpn13g2[is]
print @r.xbgr.xq75_u6.rsub[i]
print @c.xbgr.xq75_u6.csub[i]
print @q.xbgr.xq75_u7.qnpn13g2[ic]
print @q.xbgr.xq75_u7.qnpn13g2[ib]
print @q.xbgr.xq75_u7.qnpn13g2[ie]
print @q.xbgr.xq75_u7.qnpn13g2[is]
print @r.xbgr.xq75_u7.rsub[i]
print @c.xbgr.xq75_u7.csub[i]
print @q.xbgr.xq75_u8.qnpn13g2[ic]
print @q.xbgr.xq75_u8.qnpn13g2[ib]
print @q.xbgr.xq75_u8.qnpn13g2[ie]
print @q.xbgr.xq75_u8.qnpn13g2[is]
print @r.xbgr.xq75_u8.rsub[i]
print @c.xbgr.xq75_u8.csub[i]
print @q.xbgr.xq75_u9.qnpn13g2[ic]
print @q.xbgr.xq75_u9.qnpn13g2[ib]
print @q.xbgr.xq75_u9.qnpn13g2[ie]
print @q.xbgr.xq75_u9.qnpn13g2[is]
print @r.xbgr.xq75_u9.rsub[i]
print @c.xbgr.xq75_u9.csub[i]
print @q.xbgr.xq75_u10.qnpn13g2[ic]
print @q.xbgr.xq75_u10.qnpn13g2[ib]
print @q.xbgr.xq75_u10.qnpn13g2[ie]
print @q.xbgr.xq75_u10.qnpn13g2[is]
print @r.xbgr.xq75_u10.rsub[i]
print @c.xbgr.xq75_u10.csub[i]
print @q.xbgr.xq75_u11.qnpn13g2[ic]
print @q.xbgr.xq75_u11.qnpn13g2[ib]
print @q.xbgr.xq75_u11.qnpn13g2[ie]
print @q.xbgr.xq75_u11.qnpn13g2[is]
print @r.xbgr.xq75_u11.rsub[i]
print @c.xbgr.xq75_u11.csub[i]
print @q.xbgr.xq75_u12.qnpn13g2[ic]
print @q.xbgr.xq75_u12.qnpn13g2[ib]
print @q.xbgr.xq75_u12.qnpn13g2[ie]
print @q.xbgr.xq75_u12.qnpn13g2[is]
print @r.xbgr.xq75_u12.rsub[i]
print @c.xbgr.xq75_u12.csub[i]
print @q.xbgr.xq75_u13.qnpn13g2[ic]
print @q.xbgr.xq75_u13.qnpn13g2[ib]
print @q.xbgr.xq75_u13.qnpn13g2[ie]
print @q.xbgr.xq75_u13.qnpn13g2[is]
print @r.xbgr.xq75_u13.rsub[i]
print @c.xbgr.xq75_u13.csub[i]
print @q.xbgr.xq75_u14.qnpn13g2[ic]
print @q.xbgr.xq75_u14.qnpn13g2[ib]
print @q.xbgr.xq75_u14.qnpn13g2[ie]
print @q.xbgr.xq75_u14.qnpn13g2[is]
print @r.xbgr.xq75_u14.rsub[i]
print @c.xbgr.xq75_u14.csub[i]
print @q.xbgr.xq75_u15.qnpn13g2[ic]
print @q.xbgr.xq75_u15.qnpn13g2[ib]
print @q.xbgr.xq75_u15.qnpn13g2[ie]
print @q.xbgr.xq75_u15.qnpn13g2[is]
print @r.xbgr.xq75_u15.rsub[i]
print @c.xbgr.xq75_u15.csub[i]
print @q.xbgr.xq75_u16.qnpn13g2[ic]
print @q.xbgr.xq75_u16.qnpn13g2[ib]
print @q.xbgr.xq75_u16.qnpn13g2[ie]
print @q.xbgr.xq75_u16.qnpn13g2[is]
print @r.xbgr.xq75_u16.rsub[i]
print @c.xbgr.xq75_u16.csub[i]
print @q.xbgr.xq75_u17.qnpn13g2[ic]
print @q.xbgr.xq75_u17.qnpn13g2[ib]
print @q.xbgr.xq75_u17.qnpn13g2[ie]
print @q.xbgr.xq75_u17.qnpn13g2[is]
print @r.xbgr.xq75_u17.rsub[i]
print @c.xbgr.xq75_u17.csub[i]
print @q.xbgr.xq75_u18.qnpn13g2[ic]
print @q.xbgr.xq75_u18.qnpn13g2[ib]
print @q.xbgr.xq75_u18.qnpn13g2[ie]
print @q.xbgr.xq75_u18.qnpn13g2[is]
print @r.xbgr.xq75_u18.rsub[i]
print @c.xbgr.xq75_u18.csub[i]
print @q.xbgr.xq75_u19.qnpn13g2[ic]
print @q.xbgr.xq75_u19.qnpn13g2[ib]
print @q.xbgr.xq75_u19.qnpn13g2[ie]
print @q.xbgr.xq75_u19.qnpn13g2[is]
print @r.xbgr.xq75_u19.rsub[i]
print @c.xbgr.xq75_u19.csub[i]
print @q.xbgr.xq75_u20.qnpn13g2[ic]
print @q.xbgr.xq75_u20.qnpn13g2[ib]
print @q.xbgr.xq75_u20.qnpn13g2[ie]
print @q.xbgr.xq75_u20.qnpn13g2[is]
print @r.xbgr.xq75_u20.rsub[i]
print @c.xbgr.xq75_u20.csub[i]
print @q.xbgr.xq75_u21.qnpn13g2[ic]
print @q.xbgr.xq75_u21.qnpn13g2[ib]
print @q.xbgr.xq75_u21.qnpn13g2[ie]
print @q.xbgr.xq75_u21.qnpn13g2[is]
print @r.xbgr.xq75_u21.rsub[i]
print @c.xbgr.xq75_u21.csub[i]
print @q.xbgr.xq75_u22.qnpn13g2[ic]
print @q.xbgr.xq75_u22.qnpn13g2[ib]
print @q.xbgr.xq75_u22.qnpn13g2[ie]
print @q.xbgr.xq75_u22.qnpn13g2[is]
print @r.xbgr.xq75_u22.rsub[i]
print @c.xbgr.xq75_u22.csub[i]
print @q.xbgr.xq75_u23.qnpn13g2[ic]
print @q.xbgr.xq75_u23.qnpn13g2[ib]
print @q.xbgr.xq75_u23.qnpn13g2[ie]
print @q.xbgr.xq75_u23.qnpn13g2[is]
print @r.xbgr.xq75_u23.rsub[i]
print @c.xbgr.xq75_u23.csub[i]
print @q.xbgr.xq75_u24.qnpn13g2[ic]
print @q.xbgr.xq75_u24.qnpn13g2[ib]
print @q.xbgr.xq75_u24.qnpn13g2[ie]
print @q.xbgr.xq75_u24.qnpn13g2[is]
print @r.xbgr.xq75_u24.rsub[i]
print @c.xbgr.xq75_u24.csub[i]
print @q.xbgr.xq76_u2.qnpn13g2[ic]
print @q.xbgr.xq76_u2.qnpn13g2[ib]
print @q.xbgr.xq76_u2.qnpn13g2[ie]
print @q.xbgr.xq76_u2.qnpn13g2[is]
print @r.xbgr.xq76_u2.rsub[i]
print @c.xbgr.xq76_u2.csub[i]
print @q.xbgr.xq76_u3.qnpn13g2[ic]
print @q.xbgr.xq76_u3.qnpn13g2[ib]
print @q.xbgr.xq76_u3.qnpn13g2[ie]
print @q.xbgr.xq76_u3.qnpn13g2[is]
print @r.xbgr.xq76_u3.rsub[i]
print @c.xbgr.xq76_u3.csub[i]
print @q.xbgr.xq76_u4.qnpn13g2[ic]
print @q.xbgr.xq76_u4.qnpn13g2[ib]
print @q.xbgr.xq76_u4.qnpn13g2[ie]
print @q.xbgr.xq76_u4.qnpn13g2[is]
print @r.xbgr.xq76_u4.rsub[i]
print @c.xbgr.xq76_u4.csub[i]
print @q.xbgr.xq76_u5.qnpn13g2[ic]
print @q.xbgr.xq76_u5.qnpn13g2[ib]
print @q.xbgr.xq76_u5.qnpn13g2[ie]
print @q.xbgr.xq76_u5.qnpn13g2[is]
print @r.xbgr.xq76_u5.rsub[i]
print @c.xbgr.xq76_u5.csub[i]
print @q.xbgr.xq76_u6.qnpn13g2[ic]
print @q.xbgr.xq76_u6.qnpn13g2[ib]
print @q.xbgr.xq76_u6.qnpn13g2[ie]
print @q.xbgr.xq76_u6.qnpn13g2[is]
print @r.xbgr.xq76_u6.rsub[i]
print @c.xbgr.xq76_u6.csub[i]
print @q.xbgr.xq76_u7.qnpn13g2[ic]
print @q.xbgr.xq76_u7.qnpn13g2[ib]
print @q.xbgr.xq76_u7.qnpn13g2[ie]
print @q.xbgr.xq76_u7.qnpn13g2[is]
print @r.xbgr.xq76_u7.rsub[i]
print @c.xbgr.xq76_u7.csub[i]
print @q.xbgr.xq76_u8.qnpn13g2[ic]
print @q.xbgr.xq76_u8.qnpn13g2[ib]
print @q.xbgr.xq76_u8.qnpn13g2[ie]
print @q.xbgr.xq76_u8.qnpn13g2[is]
print @r.xbgr.xq76_u8.rsub[i]
print @c.xbgr.xq76_u8.csub[i]
print @q.xbgr.xq76_u9.qnpn13g2[ic]
print @q.xbgr.xq76_u9.qnpn13g2[ib]
print @q.xbgr.xq76_u9.qnpn13g2[ie]
print @q.xbgr.xq76_u9.qnpn13g2[is]
print @r.xbgr.xq76_u9.rsub[i]
print @c.xbgr.xq76_u9.csub[i]
print @q.xbgr.xq76_u10.qnpn13g2[ic]
print @q.xbgr.xq76_u10.qnpn13g2[ib]
print @q.xbgr.xq76_u10.qnpn13g2[ie]
print @q.xbgr.xq76_u10.qnpn13g2[is]
print @r.xbgr.xq76_u10.rsub[i]
print @c.xbgr.xq76_u10.csub[i]
print @q.xbgr.xq76_u11.qnpn13g2[ic]
print @q.xbgr.xq76_u11.qnpn13g2[ib]
print @q.xbgr.xq76_u11.qnpn13g2[ie]
print @q.xbgr.xq76_u11.qnpn13g2[is]
print @r.xbgr.xq76_u11.rsub[i]
print @c.xbgr.xq76_u11.csub[i]
print @q.xbgr.xq76_u12.qnpn13g2[ic]
print @q.xbgr.xq76_u12.qnpn13g2[ib]
print @q.xbgr.xq76_u12.qnpn13g2[ie]
print @q.xbgr.xq76_u12.qnpn13g2[is]
print @r.xbgr.xq76_u12.rsub[i]
print @c.xbgr.xq76_u12.csub[i]
print @q.xbgr.xq76_u13.qnpn13g2[ic]
print @q.xbgr.xq76_u13.qnpn13g2[ib]
print @q.xbgr.xq76_u13.qnpn13g2[ie]
print @q.xbgr.xq76_u13.qnpn13g2[is]
print @r.xbgr.xq76_u13.rsub[i]
print @c.xbgr.xq76_u13.csub[i]
print @q.xbgr.xq76_u14.qnpn13g2[ic]
print @q.xbgr.xq76_u14.qnpn13g2[ib]
print @q.xbgr.xq76_u14.qnpn13g2[ie]
print @q.xbgr.xq76_u14.qnpn13g2[is]
print @r.xbgr.xq76_u14.rsub[i]
print @c.xbgr.xq76_u14.csub[i]
print @q.xbgr.xq76_u15.qnpn13g2[ic]
print @q.xbgr.xq76_u15.qnpn13g2[ib]
print @q.xbgr.xq76_u15.qnpn13g2[ie]
print @q.xbgr.xq76_u15.qnpn13g2[is]
print @r.xbgr.xq76_u15.rsub[i]
print @c.xbgr.xq76_u15.csub[i]
print @q.xbgr.xq76_u16.qnpn13g2[ic]
print @q.xbgr.xq76_u16.qnpn13g2[ib]
print @q.xbgr.xq76_u16.qnpn13g2[ie]
print @q.xbgr.xq76_u16.qnpn13g2[is]
print @r.xbgr.xq76_u16.rsub[i]
print @c.xbgr.xq76_u16.csub[i]
print @q.xbgr.xq76_u17.qnpn13g2[ic]
print @q.xbgr.xq76_u17.qnpn13g2[ib]
print @q.xbgr.xq76_u17.qnpn13g2[ie]
print @q.xbgr.xq76_u17.qnpn13g2[is]
print @r.xbgr.xq76_u17.rsub[i]
print @c.xbgr.xq76_u17.csub[i]
print @q.xbgr.xq76_u18.qnpn13g2[ic]
print @q.xbgr.xq76_u18.qnpn13g2[ib]
print @q.xbgr.xq76_u18.qnpn13g2[ie]
print @q.xbgr.xq76_u18.qnpn13g2[is]
print @r.xbgr.xq76_u18.rsub[i]
print @c.xbgr.xq76_u18.csub[i]
print @q.xbgr.xq76_u19.qnpn13g2[ic]
print @q.xbgr.xq76_u19.qnpn13g2[ib]
print @q.xbgr.xq76_u19.qnpn13g2[ie]
print @q.xbgr.xq76_u19.qnpn13g2[is]
print @r.xbgr.xq76_u19.rsub[i]
print @c.xbgr.xq76_u19.csub[i]
print @q.xbgr.xq76_u20.qnpn13g2[ic]
print @q.xbgr.xq76_u20.qnpn13g2[ib]
print @q.xbgr.xq76_u20.qnpn13g2[ie]
print @q.xbgr.xq76_u20.qnpn13g2[is]
print @r.xbgr.xq76_u20.rsub[i]
print @c.xbgr.xq76_u20.csub[i]
print @q.xbgr.xq76_u21.qnpn13g2[ic]
print @q.xbgr.xq76_u21.qnpn13g2[ib]
print @q.xbgr.xq76_u21.qnpn13g2[ie]
print @q.xbgr.xq76_u21.qnpn13g2[is]
print @r.xbgr.xq76_u21.rsub[i]
print @c.xbgr.xq76_u21.csub[i]
print @q.xbgr.xq76_u22.qnpn13g2[ic]
print @q.xbgr.xq76_u22.qnpn13g2[ib]
print @q.xbgr.xq76_u22.qnpn13g2[ie]
print @q.xbgr.xq76_u22.qnpn13g2[is]
print @r.xbgr.xq76_u22.rsub[i]
print @c.xbgr.xq76_u22.csub[i]
print @q.xbgr.xq76_u23.qnpn13g2[ic]
print @q.xbgr.xq76_u23.qnpn13g2[ib]
print @q.xbgr.xq76_u23.qnpn13g2[ie]
print @q.xbgr.xq76_u23.qnpn13g2[is]
print @r.xbgr.xq76_u23.rsub[i]
print @c.xbgr.xq76_u23.csub[i]
print @q.xbgr.xq76_u24.qnpn13g2[ic]
print @q.xbgr.xq76_u24.qnpn13g2[ib]
print @q.xbgr.xq76_u24.qnpn13g2[ie]
print @q.xbgr.xq76_u24.qnpn13g2[is]
print @r.xbgr.xq76_u24.rsub[i]
print @c.xbgr.xq76_u24.csub[i]
print @n.xbgr.xr77_u2.nr1[ibody]
print @n.xbgr.xr77_u3.nr1[ibody]
print @n.xbgr.xr77_u4.nr1[ibody]
print @n.xbgr.xr77_u5.nr1[ibody]
print @n.xbgr.xr77_u6.nr1[ibody]
print @n.xbgr.xr77_u7.nr1[ibody]
print @n.xbgr.xr77_u8.nr1[ibody]
print @n.xbgr.xr77_u9.nr1[ibody]
print @n.xbgr.xr77_u10.nr1[ibody]
print @n.xbgr.xr77_u11.nr1[ibody]
print @n.xbgr.xr77_u12.nr1[ibody]
print @n.xbgr.xr77_u13.nr1[ibody]
print @n.xbgr.xr77_u14.nr1[ibody]
print @n.xbgr.xr77_u15.nr1[ibody]
print @n.xbgr.xr77_u16.nr1[ibody]
print @n.xbgr.xr77_u17.nr1[ibody]
print @n.xbgr.xr77_u18.nr1[ibody]
print @n.xbgr.xr77_u19.nr1[ibody]
print @n.xbgr.xr77_u20.nr1[ibody]
print @n.xbgr.xr77_u21.nr1[ibody]
print @n.xbgr.xr77_u22.nr1[ibody]
print @n.xbgr.xr77_u23.nr1[ibody]
print @n.xbgr.xr77_u24.nr1[ibody]
print @n.xbgr.xr78_u2.nr1[ibody]
print @n.xbgr.xr78_u3.nr1[ibody]
print @n.xbgr.xr78_u4.nr1[ibody]
print @n.xbgr.xr78_u5.nr1[ibody]
print @n.xbgr.xr78_u6.nr1[ibody]
print @n.xbgr.xr78_u7.nr1[ibody]
print @n.xbgr.xr78_u8.nr1[ibody]
print @n.xbgr.xr78_u9.nr1[ibody]
print @n.xbgr.xr78_u10.nr1[ibody]
print @n.xbgr.xr78_u11.nr1[ibody]
print @n.xbgr.xr78_u12.nr1[ibody]
print @n.xbgr.xr78_u13.nr1[ibody]
print @n.xbgr.xr78_u14.nr1[ibody]
print @n.xbgr.xr78_u15.nr1[ibody]
print @n.xbgr.xr78_u16.nr1[ibody]
print @n.xbgr.xr78_u17.nr1[ibody]
print @n.xbgr.xr78_u18.nr1[ibody]
print @n.xbgr.xr78_u19.nr1[ibody]
print @n.xbgr.xr78_u20.nr1[ibody]
print @n.xbgr.xr78_u21.nr1[ibody]
print @n.xbgr.xr78_u22.nr1[ibody]
print @n.xbgr.xr78_u23.nr1[ibody]
print @n.xbgr.xr78_u24.nr1[ibody]
print @n.xbgr.xr79_u2.nr1[ibody]
print @n.xbgr.xr79_u3.nr1[ibody]
print @n.xbgr.xr79_u4.nr1[ibody]
print @n.xbgr.xr79_u5.nr1[ibody]
print @n.xbgr.xr79_u6.nr1[ibody]
print @n.xbgr.xr79_u7.nr1[ibody]
print @n.xbgr.xr79_u8.nr1[ibody]
print @n.xbgr.xr79_u9.nr1[ibody]
print @n.xbgr.xr79_u10.nr1[ibody]
print @n.xbgr.xr79_u11.nr1[ibody]
print @n.xbgr.xr79_u12.nr1[ibody]
print @n.xbgr.xr79_u13.nr1[ibody]
print @n.xbgr.xr79_u14.nr1[ibody]
print @n.xbgr.xr79_u15.nr1[ibody]
print @n.xbgr.xr79_u16.nr1[ibody]
print @n.xbgr.xr79_u17.nr1[ibody]
print @n.xbgr.xr79_u18.nr1[ibody]
print @n.xbgr.xr79_u19.nr1[ibody]
print @n.xbgr.xr79_u20.nr1[ibody]
print @n.xbgr.xr79_u21.nr1[ibody]
print @n.xbgr.xr79_u22.nr1[ibody]
print @n.xbgr.xr79_u23.nr1[ibody]
print @n.xbgr.xr79_u24.nr1[ibody]
print @n.xbgr.xr80_u2.nr1[ibody]
print @n.xbgr.xr80_u3.nr1[ibody]
print @n.xbgr.xr80_u4.nr1[ibody]
print @n.xbgr.xr80_u5.nr1[ibody]
print @n.xbgr.xr80_u6.nr1[ibody]
print @n.xbgr.xr80_u7.nr1[ibody]
print @n.xbgr.xr80_u8.nr1[ibody]
print @n.xbgr.xr80_u9.nr1[ibody]
print @n.xbgr.xr80_u10.nr1[ibody]
print @n.xbgr.xr80_u11.nr1[ibody]
print @n.xbgr.xr80_u12.nr1[ibody]
print @n.xbgr.xr80_u13.nr1[ibody]
print @n.xbgr.xr80_u14.nr1[ibody]
print @n.xbgr.xr80_u15.nr1[ibody]
print @n.xbgr.xr80_u16.nr1[ibody]
print @n.xbgr.xr80_u17.nr1[ibody]
print @n.xbgr.xr80_u18.nr1[ibody]
print @n.xbgr.xr80_u19.nr1[ibody]
print @n.xbgr.xr80_u20.nr1[ibody]
print @n.xbgr.xr80_u21.nr1[ibody]
print @n.xbgr.xr80_u22.nr1[ibody]
print @n.xbgr.xr80_u23.nr1[ibody]
print @n.xbgr.xr80_u24.nr1[ibody]
print @n.xbgr.xr81_u2.nr1[ibody]
print @n.xbgr.xr81_u3.nr1[ibody]
print @n.xbgr.xr81_u4.nr1[ibody]
print @n.xbgr.xr81_u5.nr1[ibody]
print @n.xbgr.xr81_u6.nr1[ibody]
print @n.xbgr.xr81_u7.nr1[ibody]
print @n.xbgr.xr81_u8.nr1[ibody]
print @n.xbgr.xr81_u9.nr1[ibody]
print @n.xbgr.xr81_u10.nr1[ibody]
print @n.xbgr.xr81_u11.nr1[ibody]
print @n.xbgr.xr81_u12.nr1[ibody]
print @n.xbgr.xr81_u13.nr1[ibody]
print @n.xbgr.xr81_u14.nr1[ibody]
print @n.xbgr.xr81_u15.nr1[ibody]
print @n.xbgr.xr81_u16.nr1[ibody]
print @n.xbgr.xr81_u17.nr1[ibody]
print @n.xbgr.xr81_u18.nr1[ibody]
print @n.xbgr.xr81_u19.nr1[ibody]
print @n.xbgr.xr81_u20.nr1[ibody]
print @n.xbgr.xr81_u21.nr1[ibody]
print @n.xbgr.xr81_u22.nr1[ibody]
print @n.xbgr.xr81_u23.nr1[ibody]
print @n.xbgr.xr81_u24.nr1[ibody]
print @n.xbgr.xr82_u2.nr1[ibody]
print @n.xbgr.xr82_u3.nr1[ibody]
print @n.xbgr.xr82_u4.nr1[ibody]
print @n.xbgr.xr82_u5.nr1[ibody]
print @n.xbgr.xr82_u6.nr1[ibody]
print @n.xbgr.xr82_u7.nr1[ibody]
print @n.xbgr.xr82_u8.nr1[ibody]
print @n.xbgr.xr82_u9.nr1[ibody]
print @n.xbgr.xr82_u10.nr1[ibody]
print @n.xbgr.xr82_u11.nr1[ibody]
print @n.xbgr.xr82_u12.nr1[ibody]
print @n.xbgr.xr82_u13.nr1[ibody]
print @n.xbgr.xr82_u14.nr1[ibody]
print @n.xbgr.xr82_u15.nr1[ibody]
print @n.xbgr.xr82_u16.nr1[ibody]
print @n.xbgr.xr82_u17.nr1[ibody]
print @n.xbgr.xr82_u18.nr1[ibody]
print @n.xbgr.xr82_u19.nr1[ibody]
print @n.xbgr.xr82_u20.nr1[ibody]
print @n.xbgr.xr82_u21.nr1[ibody]
print @n.xbgr.xr82_u22.nr1[ibody]
print @n.xbgr.xr82_u23.nr1[ibody]
print @n.xbgr.xr82_u24.nr1[ibody]
print @n.xbgr.xr83_u2.nr1[ibody]
print @n.xbgr.xr83_u3.nr1[ibody]
print @n.xbgr.xr83_u4.nr1[ibody]
print @n.xbgr.xr83_u5.nr1[ibody]
print @n.xbgr.xr83_u6.nr1[ibody]
print @n.xbgr.xr83_u7.nr1[ibody]
print @n.xbgr.xr83_u8.nr1[ibody]
print @n.xbgr.xr83_u9.nr1[ibody]
print @n.xbgr.xr83_u10.nr1[ibody]
print @n.xbgr.xr83_u11.nr1[ibody]
print @n.xbgr.xr83_u12.nr1[ibody]
print @n.xbgr.xr83_u13.nr1[ibody]
print @n.xbgr.xr83_u14.nr1[ibody]
print @n.xbgr.xr83_u15.nr1[ibody]
print @n.xbgr.xr83_u16.nr1[ibody]
print @n.xbgr.xr83_u17.nr1[ibody]
print @n.xbgr.xr83_u18.nr1[ibody]
print @n.xbgr.xr83_u19.nr1[ibody]
print @n.xbgr.xr83_u20.nr1[ibody]
print @n.xbgr.xr83_u21.nr1[ibody]
print @n.xbgr.xr83_u22.nr1[ibody]
print @n.xbgr.xr83_u23.nr1[ibody]
print @n.xbgr.xr83_u24.nr1[ibody]
print @n.xbgr.xr84_u2.nr1[ibody]
print @n.xbgr.xr84_u3.nr1[ibody]
print @n.xbgr.xr84_u4.nr1[ibody]
print @n.xbgr.xr84_u5.nr1[ibody]
print @n.xbgr.xr84_u6.nr1[ibody]
print @n.xbgr.xr84_u7.nr1[ibody]
print @n.xbgr.xr84_u8.nr1[ibody]
print @n.xbgr.xr84_u9.nr1[ibody]
print @n.xbgr.xr84_u10.nr1[ibody]
print @n.xbgr.xr84_u11.nr1[ibody]
print @n.xbgr.xr84_u12.nr1[ibody]
print @n.xbgr.xr84_u13.nr1[ibody]
print @n.xbgr.xr84_u14.nr1[ibody]
print @n.xbgr.xr84_u15.nr1[ibody]
print @n.xbgr.xr84_u16.nr1[ibody]
print @n.xbgr.xr84_u17.nr1[ibody]
print @n.xbgr.xr84_u18.nr1[ibody]
print @n.xbgr.xr84_u19.nr1[ibody]
print @n.xbgr.xr84_u20.nr1[ibody]
print @n.xbgr.xr84_u21.nr1[ibody]
print @n.xbgr.xr84_u22.nr1[ibody]
print @n.xbgr.xr84_u23.nr1[ibody]
print @n.xbgr.xr84_u24.nr1[ibody]
print @n.xbgr.xr85_u2.nr1[ibody]
print @n.xbgr.xr85_u3.nr1[ibody]
print @n.xbgr.xr85_u4.nr1[ibody]
print @n.xbgr.xr85_u5.nr1[ibody]
print @n.xbgr.xr85_u6.nr1[ibody]
print @n.xbgr.xr85_u7.nr1[ibody]
print @n.xbgr.xr85_u8.nr1[ibody]
print @n.xbgr.xr85_u9.nr1[ibody]
print @n.xbgr.xr85_u10.nr1[ibody]
print @n.xbgr.xr85_u11.nr1[ibody]
print @n.xbgr.xr85_u12.nr1[ibody]
print @n.xbgr.xr85_u13.nr1[ibody]
print @n.xbgr.xr85_u14.nr1[ibody]
print @n.xbgr.xr85_u15.nr1[ibody]
print @n.xbgr.xr85_u16.nr1[ibody]
print @n.xbgr.xr85_u17.nr1[ibody]
print @n.xbgr.xr85_u18.nr1[ibody]
print @n.xbgr.xr85_u19.nr1[ibody]
print @n.xbgr.xr85_u20.nr1[ibody]
print @n.xbgr.xr85_u21.nr1[ibody]
print @n.xbgr.xr85_u22.nr1[ibody]
print @n.xbgr.xr85_u23.nr1[ibody]
print @n.xbgr.xr85_u24.nr1[ibody]
print @n.xbgr.xr86_u2.nr1[ibody]
print @n.xbgr.xr86_u3.nr1[ibody]
print @n.xbgr.xr86_u4.nr1[ibody]
print @n.xbgr.xr86_u5.nr1[ibody]
print @n.xbgr.xr86_u6.nr1[ibody]
print @n.xbgr.xr86_u7.nr1[ibody]
print @n.xbgr.xr86_u8.nr1[ibody]
print @n.xbgr.xr86_u9.nr1[ibody]
print @n.xbgr.xr86_u10.nr1[ibody]
print @n.xbgr.xr86_u11.nr1[ibody]
print @n.xbgr.xr86_u12.nr1[ibody]
print @n.xbgr.xr86_u13.nr1[ibody]
print @n.xbgr.xr86_u14.nr1[ibody]
print @n.xbgr.xr86_u15.nr1[ibody]
print @n.xbgr.xr86_u16.nr1[ibody]
print @n.xbgr.xr86_u17.nr1[ibody]
print @n.xbgr.xr86_u18.nr1[ibody]
print @n.xbgr.xr86_u19.nr1[ibody]
print @n.xbgr.xr86_u20.nr1[ibody]
print @n.xbgr.xr86_u21.nr1[ibody]
print @n.xbgr.xr86_u22.nr1[ibody]
print @n.xbgr.xr86_u23.nr1[ibody]
print @n.xbgr.xr86_u24.nr1[ibody]
echo RAW_CURRENT_LEDGER_END
wrdata op_nodes.dat v(xbgr.b1b) v(xbgr.c2) v(xbgr.d1) v(xbgr.d2) v(xbgr.d3) v(xbgr.d4) v(xbgr.d5) v(xbgr.det) v(dvbe) v(iptat) v(xbgr.kick) v(xbgr.n1) v(xbgr.n_10) v(xbgr.n_11) v(xbgr.n_12) v(xbgr.n_13) v(xbgr.n_14) v(xbgr.n_15) v(xbgr.n_16) v(xbgr.n_17) v(xbgr.n_18) v(xbgr.n_19) v(xbgr.n_2) v(xbgr.n_21) v(xbgr.n_22) v(xbgr.n_23) v(xbgr.n_24) v(xbgr.n_25) v(xbgr.n_26) v(xbgr.n_27) v(xbgr.n_3) v(xbgr.n_30) v(xbgr.n_31) v(xbgr.n_33) v(xbgr.n_34) v(xbgr.n_36) v(xbgr.n_37) v(xbgr.n_4) v(xbgr.n_5) v(xbgr.n_6) v(xbgr.n_7) v(xbgr.n_8) v(xbgr.n_9) v(pbias) v(pcasc) v(r4) v(xbgr.r4n) v(xbgr.vb2) v(vbe) v(xbgr.vbe3) v(xbgr.vd1) v(xbgr.vd2) v(vdd) v(vref) v(vdd)-v(vdd) i(vdd) i(vload) i(vr4) i(vsub)
print @n.xbgr.xr1.nr1[nsmm_rsh]
print @n.xbgr.xr1.nr1[nsmm_w]
print @n.xbgr.xr1.nr1[nsmm_l]
print @n.xbgr.xr2.nr1[nsmm_rsh]
print @n.xbgr.xr2.nr1[nsmm_w]
print @n.xbgr.xr2.nr1[nsmm_l]
print @n.xbgr.xr3.nr1[nsmm_rsh]
print @n.xbgr.xr3.nr1[nsmm_w]
print @n.xbgr.xr3.nr1[nsmm_l]
print @n.xbgr.xr4.nr1[nsmm_rsh]
print @n.xbgr.xr4.nr1[nsmm_w]
print @n.xbgr.xr4.nr1[nsmm_l]
print @n.xbgr.xr5.nr1[nsmm_rsh]
print @n.xbgr.xr5.nr1[nsmm_w]
print @n.xbgr.xr5.nr1[nsmm_l]
print @n.xbgr.xr6.nr1[nsmm_rsh]
print @n.xbgr.xr6.nr1[nsmm_w]
print @n.xbgr.xr6.nr1[nsmm_l]
print @n.xbgr.xr7.nr1[nsmm_rsh]
print @n.xbgr.xr7.nr1[nsmm_w]
print @n.xbgr.xr7.nr1[nsmm_l]
print @n.xbgr.xr8.nr1[nsmm_rsh]
print @n.xbgr.xr8.nr1[nsmm_w]
print @n.xbgr.xr8.nr1[nsmm_l]
print @n.xbgr.xr9.nr1[nsmm_rsh]
print @n.xbgr.xr9.nr1[nsmm_w]
print @n.xbgr.xr9.nr1[nsmm_l]
print @n.xbgr.xr10.nr1[nsmm_rsh]
print @n.xbgr.xr10.nr1[nsmm_w]
print @n.xbgr.xr10.nr1[nsmm_l]
print @n.xbgr.xr11.nr1[nsmm_rsh]
print @n.xbgr.xr11.nr1[nsmm_w]
print @n.xbgr.xr11.nr1[nsmm_l]
print @n.xbgr.xr12.nr1[nsmm_rsh]
print @n.xbgr.xr12.nr1[nsmm_w]
print @n.xbgr.xr12.nr1[nsmm_l]
print @n.xbgr.xr13.nr1[nsmm_rsh]
print @n.xbgr.xr13.nr1[nsmm_w]
print @n.xbgr.xr13.nr1[nsmm_l]
print @n.xbgr.xr14.nr1[nsmm_rsh]
print @n.xbgr.xr14.nr1[nsmm_w]
print @n.xbgr.xr14.nr1[nsmm_l]
print @n.xbgr.xr15.nr1[nsmm_rsh]
print @n.xbgr.xr15.nr1[nsmm_w]
print @n.xbgr.xr15.nr1[nsmm_l]
print @n.xbgr.xr16.nr1[nsmm_rsh]
print @n.xbgr.xr16.nr1[nsmm_w]
print @n.xbgr.xr16.nr1[nsmm_l]
print @n.xbgr.xr17.nr1[nsmm_rsh]
print @n.xbgr.xr17.nr1[nsmm_w]
print @n.xbgr.xr17.nr1[nsmm_l]
print @n.xbgr.xr18.nr1[nsmm_rsh]
print @n.xbgr.xr18.nr1[nsmm_w]
print @n.xbgr.xr18.nr1[nsmm_l]
print @n.xbgr.xr19.nr1[nsmm_rsh]
print @n.xbgr.xr19.nr1[nsmm_w]
print @n.xbgr.xr19.nr1[nsmm_l]
print @n.xbgr.xr20.nr1[nsmm_rsh]
print @n.xbgr.xr20.nr1[nsmm_w]
print @n.xbgr.xr20.nr1[nsmm_l]
print @n.xbgr.xr21.nr1[nsmm_rsh]
print @n.xbgr.xr21.nr1[nsmm_w]
print @n.xbgr.xr21.nr1[nsmm_l]
print @n.xbgr.xr22.nr1[nsmm_rsh]
print @n.xbgr.xr22.nr1[nsmm_w]
print @n.xbgr.xr22.nr1[nsmm_l]
print @n.xbgr.xr23.nr1[nsmm_rsh]
print @n.xbgr.xr23.nr1[nsmm_w]
print @n.xbgr.xr23.nr1[nsmm_l]
print @n.xbgr.xr24.nr1[nsmm_rsh]
print @n.xbgr.xr24.nr1[nsmm_w]
print @n.xbgr.xr24.nr1[nsmm_l]
print @n.xbgr.xr25.nr1[nsmm_rsh]
print @n.xbgr.xr25.nr1[nsmm_w]
print @n.xbgr.xr25.nr1[nsmm_l]
print @n.xbgr.xr26.nr1[nsmm_rsh]
print @n.xbgr.xr26.nr1[nsmm_w]
print @n.xbgr.xr26.nr1[nsmm_l]
print @n.xbgr.xm27.nsg13_hv_pmos[w]
print @n.xbgr.xm27.nsg13_hv_pmos[l]
print @n.xbgr.xm27.nsg13_hv_pmos[delvto]
print @n.xbgr.xm27.nsg13_hv_pmos[factuo]
print @n.xbgr.xm28.nsg13_hv_pmos[w]
print @n.xbgr.xm28.nsg13_hv_pmos[l]
print @n.xbgr.xm28.nsg13_hv_pmos[delvto]
print @n.xbgr.xm28.nsg13_hv_pmos[factuo]
print @n.xbgr.xm29.nsg13_hv_nmos[w]
print @n.xbgr.xm29.nsg13_hv_nmos[l]
print @n.xbgr.xm29.nsg13_hv_nmos[delvto]
print @n.xbgr.xm29.nsg13_hv_nmos[factuo]
print @n.xbgr.xm30.nsg13_hv_nmos[w]
print @n.xbgr.xm30.nsg13_hv_nmos[l]
print @n.xbgr.xm30.nsg13_hv_nmos[delvto]
print @n.xbgr.xm30.nsg13_hv_nmos[factuo]
print @n.xbgr.xm31.nsg13_hv_nmos[w]
print @n.xbgr.xm31.nsg13_hv_nmos[l]
print @n.xbgr.xm31.nsg13_hv_nmos[delvto]
print @n.xbgr.xm31.nsg13_hv_nmos[factuo]
print @n.xbgr.xm32.nsg13_hv_nmos[w]
print @n.xbgr.xm32.nsg13_hv_nmos[l]
print @n.xbgr.xm32.nsg13_hv_nmos[delvto]
print @n.xbgr.xm32.nsg13_hv_nmos[factuo]
print @n.xbgr.xm33.nsg13_hv_nmos[w]
print @n.xbgr.xm33.nsg13_hv_nmos[l]
print @n.xbgr.xm33.nsg13_hv_nmos[delvto]
print @n.xbgr.xm33.nsg13_hv_nmos[factuo]
print @n.xbgr.xm34.nsg13_hv_nmos[w]
print @n.xbgr.xm34.nsg13_hv_nmos[l]
print @n.xbgr.xm34.nsg13_hv_nmos[delvto]
print @n.xbgr.xm34.nsg13_hv_nmos[factuo]
print @n.xbgr.xm35.nsg13_hv_nmos[w]
print @n.xbgr.xm35.nsg13_hv_nmos[l]
print @n.xbgr.xm35.nsg13_hv_nmos[delvto]
print @n.xbgr.xm35.nsg13_hv_nmos[factuo]
print @n.xbgr.xm36.nsg13_hv_nmos[w]
print @n.xbgr.xm36.nsg13_hv_nmos[l]
print @n.xbgr.xm36.nsg13_hv_nmos[delvto]
print @n.xbgr.xm36.nsg13_hv_nmos[factuo]
print @n.xbgr.xm37.nsg13_hv_nmos[w]
print @n.xbgr.xm37.nsg13_hv_nmos[l]
print @n.xbgr.xm37.nsg13_hv_nmos[delvto]
print @n.xbgr.xm37.nsg13_hv_nmos[factuo]
print @n.xbgr.xm38.nsg13_hv_pmos[w]
print @n.xbgr.xm38.nsg13_hv_pmos[l]
print @n.xbgr.xm38.nsg13_hv_pmos[delvto]
print @n.xbgr.xm38.nsg13_hv_pmos[factuo]
print @n.xbgr.xm39.nsg13_hv_pmos[w]
print @n.xbgr.xm39.nsg13_hv_pmos[l]
print @n.xbgr.xm39.nsg13_hv_pmos[delvto]
print @n.xbgr.xm39.nsg13_hv_pmos[factuo]
print @n.xbgr.xm40.nsg13_hv_pmos[w]
print @n.xbgr.xm40.nsg13_hv_pmos[l]
print @n.xbgr.xm40.nsg13_hv_pmos[delvto]
print @n.xbgr.xm40.nsg13_hv_pmos[factuo]
print @n.xbgr.xm41.nsg13_hv_pmos[w]
print @n.xbgr.xm41.nsg13_hv_pmos[l]
print @n.xbgr.xm41.nsg13_hv_pmos[delvto]
print @n.xbgr.xm41.nsg13_hv_pmos[factuo]
print @n.xbgr.xm42.nsg13_hv_pmos[w]
print @n.xbgr.xm42.nsg13_hv_pmos[l]
print @n.xbgr.xm42.nsg13_hv_pmos[delvto]
print @n.xbgr.xm42.nsg13_hv_pmos[factuo]
print @n.xbgr.xm43.nsg13_hv_pmos[w]
print @n.xbgr.xm43.nsg13_hv_pmos[l]
print @n.xbgr.xm43.nsg13_hv_pmos[delvto]
print @n.xbgr.xm43.nsg13_hv_pmos[factuo]
print @n.xbgr.xm44.nsg13_hv_pmos[w]
print @n.xbgr.xm44.nsg13_hv_pmos[l]
print @n.xbgr.xm44.nsg13_hv_pmos[delvto]
print @n.xbgr.xm44.nsg13_hv_pmos[factuo]
print @n.xbgr.xm45.nsg13_hv_pmos[w]
print @n.xbgr.xm45.nsg13_hv_pmos[l]
print @n.xbgr.xm45.nsg13_hv_pmos[delvto]
print @n.xbgr.xm45.nsg13_hv_pmos[factuo]
print @n.xbgr.xm46.nsg13_hv_pmos[w]
print @n.xbgr.xm46.nsg13_hv_pmos[l]
print @n.xbgr.xm46.nsg13_hv_pmos[delvto]
print @n.xbgr.xm46.nsg13_hv_pmos[factuo]
print @n.xbgr.xm47.nsg13_hv_pmos[w]
print @n.xbgr.xm47.nsg13_hv_pmos[l]
print @n.xbgr.xm47.nsg13_hv_pmos[delvto]
print @n.xbgr.xm47.nsg13_hv_pmos[factuo]
print @n.xbgr.xm48.nsg13_hv_pmos[w]
print @n.xbgr.xm48.nsg13_hv_pmos[l]
print @n.xbgr.xm48.nsg13_hv_pmos[delvto]
print @n.xbgr.xm48.nsg13_hv_pmos[factuo]
print @n.xbgr.xm49.nsg13_hv_pmos[w]
print @n.xbgr.xm49.nsg13_hv_pmos[l]
print @n.xbgr.xm49.nsg13_hv_pmos[delvto]
print @n.xbgr.xm49.nsg13_hv_pmos[factuo]
print @n.xbgr.xm50.nsg13_hv_pmos[w]
print @n.xbgr.xm50.nsg13_hv_pmos[l]
print @n.xbgr.xm50.nsg13_hv_pmos[delvto]
print @n.xbgr.xm50.nsg13_hv_pmos[factuo]
print @n.xbgr.xm51.nsg13_hv_pmos[w]
print @n.xbgr.xm51.nsg13_hv_pmos[l]
print @n.xbgr.xm51.nsg13_hv_pmos[delvto]
print @n.xbgr.xm51.nsg13_hv_pmos[factuo]
print @n.xbgr.xm52.nsg13_hv_pmos[w]
print @n.xbgr.xm52.nsg13_hv_pmos[l]
print @n.xbgr.xm52.nsg13_hv_pmos[delvto]
print @n.xbgr.xm52.nsg13_hv_pmos[factuo]
print @n.xbgr.xm53.nsg13_hv_pmos[w]
print @n.xbgr.xm53.nsg13_hv_pmos[l]
print @n.xbgr.xm53.nsg13_hv_pmos[delvto]
print @n.xbgr.xm53.nsg13_hv_pmos[factuo]
print @n.xbgr.xm54.nsg13_hv_pmos[w]
print @n.xbgr.xm54.nsg13_hv_pmos[l]
print @n.xbgr.xm54.nsg13_hv_pmos[delvto]
print @n.xbgr.xm54.nsg13_hv_pmos[factuo]
print @q.xbgr.xq55.qnpn13g2[area]
print @q.xbgr.xq56.qnpn13g2[area]
print @q.xbgr.xq57.qnpn13g2[area]
print @q.xbgr.xq58.qnpn13g2[area]
print @q.xbgr.xq59.qnpn13g2[area]
print @q.xbgr.xq60.qnpn13g2[area]
print @q.xbgr.xq61.qnpn13g2[area]
print @q.xbgr.xq62.qnpn13g2[area]
print @q.xbgr.xq63.qnpn13g2[area]
print @q.xbgr.xq64.qnpn13g2[area]
print @q.xbgr.xq65.qnpn13g2[area]
print @q.xbgr.xq66.qnpn13g2[area]
print @q.xbgr.xq67.qnpn13g2[area]
print @q.xbgr.xq68.qnpn13g2[area]
print @q.xbgr.xq69.qnpn13g2[area]
print @q.xbgr.xq70.qnpn13g2[area]
print @q.xbgr.xq71.qnpn13g2[area]
print @q.xbgr.xq72.qnpn13g2[area]
print @q.xbgr.xq73.qnpn13g2[area]
print @q.xbgr.xq74.qnpn13g2[area]
print @q.xbgr.xq75.qnpn13g2[area]
print @q.xbgr.xq76.qnpn13g2[area]
print @n.xbgr.xr77.nr1[nsmm_rsh]
print @n.xbgr.xr77.nr1[nsmm_w]
print @n.xbgr.xr77.nr1[nsmm_l]
print @n.xbgr.xr78.nr1[nsmm_rsh]
print @n.xbgr.xr78.nr1[nsmm_w]
print @n.xbgr.xr78.nr1[nsmm_l]
print @n.xbgr.xr79.nr1[nsmm_rsh]
print @n.xbgr.xr79.nr1[nsmm_w]
print @n.xbgr.xr79.nr1[nsmm_l]
print @n.xbgr.xr80.nr1[nsmm_rsh]
print @n.xbgr.xr80.nr1[nsmm_w]
print @n.xbgr.xr80.nr1[nsmm_l]
print @n.xbgr.xr81.nr1[nsmm_rsh]
print @n.xbgr.xr81.nr1[nsmm_w]
print @n.xbgr.xr81.nr1[nsmm_l]
print @n.xbgr.xr82.nr1[nsmm_rsh]
print @n.xbgr.xr82.nr1[nsmm_w]
print @n.xbgr.xr82.nr1[nsmm_l]
print @n.xbgr.xr83.nr1[nsmm_rsh]
print @n.xbgr.xr83.nr1[nsmm_w]
print @n.xbgr.xr83.nr1[nsmm_l]
print @n.xbgr.xr84.nr1[nsmm_rsh]
print @n.xbgr.xr84.nr1[nsmm_w]
print @n.xbgr.xr84.nr1[nsmm_l]
print @n.xbgr.xr85.nr1[nsmm_rsh]
print @n.xbgr.xr85.nr1[nsmm_w]
print @n.xbgr.xr85.nr1[nsmm_l]
print @n.xbgr.xr86.nr1[nsmm_rsh]
print @n.xbgr.xr86.nr1[nsmm_w]
print @n.xbgr.xr86.nr1[nsmm_l]
print @n.xbgr.xr16_u2.nr1[nsmm_rsh]
print @n.xbgr.xr16_u2.nr1[nsmm_w]
print @n.xbgr.xr16_u2.nr1[nsmm_l]
print @n.xbgr.xr16_u3.nr1[nsmm_rsh]
print @n.xbgr.xr16_u3.nr1[nsmm_w]
print @n.xbgr.xr16_u3.nr1[nsmm_l]
print @n.xbgr.xr16_u4.nr1[nsmm_rsh]
print @n.xbgr.xr16_u4.nr1[nsmm_w]
print @n.xbgr.xr16_u4.nr1[nsmm_l]
print @n.xbgr.xr16_u5.nr1[nsmm_rsh]
print @n.xbgr.xr16_u5.nr1[nsmm_w]
print @n.xbgr.xr16_u5.nr1[nsmm_l]
print @n.xbgr.xr16_u6.nr1[nsmm_rsh]
print @n.xbgr.xr16_u6.nr1[nsmm_w]
print @n.xbgr.xr16_u6.nr1[nsmm_l]
print @n.xbgr.xr16_u7.nr1[nsmm_rsh]
print @n.xbgr.xr16_u7.nr1[nsmm_w]
print @n.xbgr.xr16_u7.nr1[nsmm_l]
print @n.xbgr.xr16_u8.nr1[nsmm_rsh]
print @n.xbgr.xr16_u8.nr1[nsmm_w]
print @n.xbgr.xr16_u8.nr1[nsmm_l]
print @n.xbgr.xr16_u9.nr1[nsmm_rsh]
print @n.xbgr.xr16_u9.nr1[nsmm_w]
print @n.xbgr.xr16_u9.nr1[nsmm_l]
print @n.xbgr.xr16_u10.nr1[nsmm_rsh]
print @n.xbgr.xr16_u10.nr1[nsmm_w]
print @n.xbgr.xr16_u10.nr1[nsmm_l]
print @n.xbgr.xr16_u11.nr1[nsmm_rsh]
print @n.xbgr.xr16_u11.nr1[nsmm_w]
print @n.xbgr.xr16_u11.nr1[nsmm_l]
print @n.xbgr.xr16_u12.nr1[nsmm_rsh]
print @n.xbgr.xr16_u12.nr1[nsmm_w]
print @n.xbgr.xr16_u12.nr1[nsmm_l]
print @n.xbgr.xr16_u13.nr1[nsmm_rsh]
print @n.xbgr.xr16_u13.nr1[nsmm_w]
print @n.xbgr.xr16_u13.nr1[nsmm_l]
print @n.xbgr.xr16_u14.nr1[nsmm_rsh]
print @n.xbgr.xr16_u14.nr1[nsmm_w]
print @n.xbgr.xr16_u14.nr1[nsmm_l]
print @n.xbgr.xr16_u15.nr1[nsmm_rsh]
print @n.xbgr.xr16_u15.nr1[nsmm_w]
print @n.xbgr.xr16_u15.nr1[nsmm_l]
print @n.xbgr.xr16_u16.nr1[nsmm_rsh]
print @n.xbgr.xr16_u16.nr1[nsmm_w]
print @n.xbgr.xr16_u16.nr1[nsmm_l]
print @n.xbgr.xr16_u17.nr1[nsmm_rsh]
print @n.xbgr.xr16_u17.nr1[nsmm_w]
print @n.xbgr.xr16_u17.nr1[nsmm_l]
print @n.xbgr.xr16_u18.nr1[nsmm_rsh]
print @n.xbgr.xr16_u18.nr1[nsmm_w]
print @n.xbgr.xr16_u18.nr1[nsmm_l]
print @n.xbgr.xr16_u19.nr1[nsmm_rsh]
print @n.xbgr.xr16_u19.nr1[nsmm_w]
print @n.xbgr.xr16_u19.nr1[nsmm_l]
print @n.xbgr.xr16_u20.nr1[nsmm_rsh]
print @n.xbgr.xr16_u20.nr1[nsmm_w]
print @n.xbgr.xr16_u20.nr1[nsmm_l]
print @n.xbgr.xr16_u21.nr1[nsmm_rsh]
print @n.xbgr.xr16_u21.nr1[nsmm_w]
print @n.xbgr.xr16_u21.nr1[nsmm_l]
print @n.xbgr.xr16_u22.nr1[nsmm_rsh]
print @n.xbgr.xr16_u22.nr1[nsmm_w]
print @n.xbgr.xr16_u22.nr1[nsmm_l]
print @n.xbgr.xr16_u23.nr1[nsmm_rsh]
print @n.xbgr.xr16_u23.nr1[nsmm_w]
print @n.xbgr.xr16_u23.nr1[nsmm_l]
print @n.xbgr.xr16_u24.nr1[nsmm_rsh]
print @n.xbgr.xr16_u24.nr1[nsmm_w]
print @n.xbgr.xr16_u24.nr1[nsmm_l]
print @n.xbgr.xr17_u2.nr1[nsmm_rsh]
print @n.xbgr.xr17_u2.nr1[nsmm_w]
print @n.xbgr.xr17_u2.nr1[nsmm_l]
print @n.xbgr.xr17_u3.nr1[nsmm_rsh]
print @n.xbgr.xr17_u3.nr1[nsmm_w]
print @n.xbgr.xr17_u3.nr1[nsmm_l]
print @n.xbgr.xr17_u4.nr1[nsmm_rsh]
print @n.xbgr.xr17_u4.nr1[nsmm_w]
print @n.xbgr.xr17_u4.nr1[nsmm_l]
print @n.xbgr.xr18_u2.nr1[nsmm_rsh]
print @n.xbgr.xr18_u2.nr1[nsmm_w]
print @n.xbgr.xr18_u2.nr1[nsmm_l]
print @n.xbgr.xr18_u3.nr1[nsmm_rsh]
print @n.xbgr.xr18_u3.nr1[nsmm_w]
print @n.xbgr.xr18_u3.nr1[nsmm_l]
print @n.xbgr.xr18_u4.nr1[nsmm_rsh]
print @n.xbgr.xr18_u4.nr1[nsmm_w]
print @n.xbgr.xr18_u4.nr1[nsmm_l]
print @n.xbgr.xr19_u2.nr1[nsmm_rsh]
print @n.xbgr.xr19_u2.nr1[nsmm_w]
print @n.xbgr.xr19_u2.nr1[nsmm_l]
print @n.xbgr.xr19_u3.nr1[nsmm_rsh]
print @n.xbgr.xr19_u3.nr1[nsmm_w]
print @n.xbgr.xr19_u3.nr1[nsmm_l]
print @n.xbgr.xr19_u4.nr1[nsmm_rsh]
print @n.xbgr.xr19_u4.nr1[nsmm_w]
print @n.xbgr.xr19_u4.nr1[nsmm_l]
print @n.xbgr.xr20_u2.nr1[nsmm_rsh]
print @n.xbgr.xr20_u2.nr1[nsmm_w]
print @n.xbgr.xr20_u2.nr1[nsmm_l]
print @n.xbgr.xr20_u3.nr1[nsmm_rsh]
print @n.xbgr.xr20_u3.nr1[nsmm_w]
print @n.xbgr.xr20_u3.nr1[nsmm_l]
print @n.xbgr.xr20_u4.nr1[nsmm_rsh]
print @n.xbgr.xr20_u4.nr1[nsmm_w]
print @n.xbgr.xr20_u4.nr1[nsmm_l]
print @n.xbgr.xr21_u2.nr1[nsmm_rsh]
print @n.xbgr.xr21_u2.nr1[nsmm_w]
print @n.xbgr.xr21_u2.nr1[nsmm_l]
print @n.xbgr.xr21_u3.nr1[nsmm_rsh]
print @n.xbgr.xr21_u3.nr1[nsmm_w]
print @n.xbgr.xr21_u3.nr1[nsmm_l]
print @n.xbgr.xr21_u4.nr1[nsmm_rsh]
print @n.xbgr.xr21_u4.nr1[nsmm_w]
print @n.xbgr.xr21_u4.nr1[nsmm_l]
print @n.xbgr.xr22_u2.nr1[nsmm_rsh]
print @n.xbgr.xr22_u2.nr1[nsmm_w]
print @n.xbgr.xr22_u2.nr1[nsmm_l]
print @n.xbgr.xr22_u3.nr1[nsmm_rsh]
print @n.xbgr.xr22_u3.nr1[nsmm_w]
print @n.xbgr.xr22_u3.nr1[nsmm_l]
print @n.xbgr.xr22_u4.nr1[nsmm_rsh]
print @n.xbgr.xr22_u4.nr1[nsmm_w]
print @n.xbgr.xr22_u4.nr1[nsmm_l]
print @n.xbgr.xr23_u2.nr1[nsmm_rsh]
print @n.xbgr.xr23_u2.nr1[nsmm_w]
print @n.xbgr.xr23_u2.nr1[nsmm_l]
print @n.xbgr.xr23_u3.nr1[nsmm_rsh]
print @n.xbgr.xr23_u3.nr1[nsmm_w]
print @n.xbgr.xr23_u3.nr1[nsmm_l]
print @n.xbgr.xr23_u4.nr1[nsmm_rsh]
print @n.xbgr.xr23_u4.nr1[nsmm_w]
print @n.xbgr.xr23_u4.nr1[nsmm_l]
print @n.xbgr.xr23_u5.nr1[nsmm_rsh]
print @n.xbgr.xr23_u5.nr1[nsmm_w]
print @n.xbgr.xr23_u5.nr1[nsmm_l]
print @n.xbgr.xr23_u6.nr1[nsmm_rsh]
print @n.xbgr.xr23_u6.nr1[nsmm_w]
print @n.xbgr.xr23_u6.nr1[nsmm_l]
print @n.xbgr.xr23_u7.nr1[nsmm_rsh]
print @n.xbgr.xr23_u7.nr1[nsmm_w]
print @n.xbgr.xr23_u7.nr1[nsmm_l]
print @n.xbgr.xr23_u8.nr1[nsmm_rsh]
print @n.xbgr.xr23_u8.nr1[nsmm_w]
print @n.xbgr.xr23_u8.nr1[nsmm_l]
print @n.xbgr.xr23_u9.nr1[nsmm_rsh]
print @n.xbgr.xr23_u9.nr1[nsmm_w]
print @n.xbgr.xr23_u9.nr1[nsmm_l]
print @n.xbgr.xr23_u10.nr1[nsmm_rsh]
print @n.xbgr.xr23_u10.nr1[nsmm_w]
print @n.xbgr.xr23_u10.nr1[nsmm_l]
print @n.xbgr.xr23_u11.nr1[nsmm_rsh]
print @n.xbgr.xr23_u11.nr1[nsmm_w]
print @n.xbgr.xr23_u11.nr1[nsmm_l]
print @n.xbgr.xr23_u12.nr1[nsmm_rsh]
print @n.xbgr.xr23_u12.nr1[nsmm_w]
print @n.xbgr.xr23_u12.nr1[nsmm_l]
print @n.xbgr.xr23_u13.nr1[nsmm_rsh]
print @n.xbgr.xr23_u13.nr1[nsmm_w]
print @n.xbgr.xr23_u13.nr1[nsmm_l]
print @n.xbgr.xr23_u14.nr1[nsmm_rsh]
print @n.xbgr.xr23_u14.nr1[nsmm_w]
print @n.xbgr.xr23_u14.nr1[nsmm_l]
print @n.xbgr.xr23_u15.nr1[nsmm_rsh]
print @n.xbgr.xr23_u15.nr1[nsmm_w]
print @n.xbgr.xr23_u15.nr1[nsmm_l]
print @n.xbgr.xr23_u16.nr1[nsmm_rsh]
print @n.xbgr.xr23_u16.nr1[nsmm_w]
print @n.xbgr.xr23_u16.nr1[nsmm_l]
print @n.xbgr.xr23_u17.nr1[nsmm_rsh]
print @n.xbgr.xr23_u17.nr1[nsmm_w]
print @n.xbgr.xr23_u17.nr1[nsmm_l]
print @n.xbgr.xr23_u18.nr1[nsmm_rsh]
print @n.xbgr.xr23_u18.nr1[nsmm_w]
print @n.xbgr.xr23_u18.nr1[nsmm_l]
print @n.xbgr.xr23_u19.nr1[nsmm_rsh]
print @n.xbgr.xr23_u19.nr1[nsmm_w]
print @n.xbgr.xr23_u19.nr1[nsmm_l]
print @n.xbgr.xr23_u20.nr1[nsmm_rsh]
print @n.xbgr.xr23_u20.nr1[nsmm_w]
print @n.xbgr.xr23_u20.nr1[nsmm_l]
print @n.xbgr.xr23_u21.nr1[nsmm_rsh]
print @n.xbgr.xr23_u21.nr1[nsmm_w]
print @n.xbgr.xr23_u21.nr1[nsmm_l]
print @n.xbgr.xr23_u22.nr1[nsmm_rsh]
print @n.xbgr.xr23_u22.nr1[nsmm_w]
print @n.xbgr.xr23_u22.nr1[nsmm_l]
print @n.xbgr.xr23_u23.nr1[nsmm_rsh]
print @n.xbgr.xr23_u23.nr1[nsmm_w]
print @n.xbgr.xr23_u23.nr1[nsmm_l]
print @n.xbgr.xr23_u24.nr1[nsmm_rsh]
print @n.xbgr.xr23_u24.nr1[nsmm_w]
print @n.xbgr.xr23_u24.nr1[nsmm_l]
print @n.xbgr.xr24_u2.nr1[nsmm_rsh]
print @n.xbgr.xr24_u2.nr1[nsmm_w]
print @n.xbgr.xr24_u2.nr1[nsmm_l]
print @n.xbgr.xr24_u3.nr1[nsmm_rsh]
print @n.xbgr.xr24_u3.nr1[nsmm_w]
print @n.xbgr.xr24_u3.nr1[nsmm_l]
print @n.xbgr.xr24_u4.nr1[nsmm_rsh]
print @n.xbgr.xr24_u4.nr1[nsmm_w]
print @n.xbgr.xr24_u4.nr1[nsmm_l]
print @n.xbgr.xr24_u5.nr1[nsmm_rsh]
print @n.xbgr.xr24_u5.nr1[nsmm_w]
print @n.xbgr.xr24_u5.nr1[nsmm_l]
print @n.xbgr.xr24_u6.nr1[nsmm_rsh]
print @n.xbgr.xr24_u6.nr1[nsmm_w]
print @n.xbgr.xr24_u6.nr1[nsmm_l]
print @n.xbgr.xr24_u7.nr1[nsmm_rsh]
print @n.xbgr.xr24_u7.nr1[nsmm_w]
print @n.xbgr.xr24_u7.nr1[nsmm_l]
print @n.xbgr.xr24_u8.nr1[nsmm_rsh]
print @n.xbgr.xr24_u8.nr1[nsmm_w]
print @n.xbgr.xr24_u8.nr1[nsmm_l]
print @n.xbgr.xr24_u9.nr1[nsmm_rsh]
print @n.xbgr.xr24_u9.nr1[nsmm_w]
print @n.xbgr.xr24_u9.nr1[nsmm_l]
print @n.xbgr.xr24_u10.nr1[nsmm_rsh]
print @n.xbgr.xr24_u10.nr1[nsmm_w]
print @n.xbgr.xr24_u10.nr1[nsmm_l]
print @n.xbgr.xr24_u11.nr1[nsmm_rsh]
print @n.xbgr.xr24_u11.nr1[nsmm_w]
print @n.xbgr.xr24_u11.nr1[nsmm_l]
print @n.xbgr.xr24_u12.nr1[nsmm_rsh]
print @n.xbgr.xr24_u12.nr1[nsmm_w]
print @n.xbgr.xr24_u12.nr1[nsmm_l]
print @n.xbgr.xr24_u13.nr1[nsmm_rsh]
print @n.xbgr.xr24_u13.nr1[nsmm_w]
print @n.xbgr.xr24_u13.nr1[nsmm_l]
print @n.xbgr.xr24_u14.nr1[nsmm_rsh]
print @n.xbgr.xr24_u14.nr1[nsmm_w]
print @n.xbgr.xr24_u14.nr1[nsmm_l]
print @n.xbgr.xr24_u15.nr1[nsmm_rsh]
print @n.xbgr.xr24_u15.nr1[nsmm_w]
print @n.xbgr.xr24_u15.nr1[nsmm_l]
print @n.xbgr.xr24_u16.nr1[nsmm_rsh]
print @n.xbgr.xr24_u16.nr1[nsmm_w]
print @n.xbgr.xr24_u16.nr1[nsmm_l]
print @n.xbgr.xr24_u17.nr1[nsmm_rsh]
print @n.xbgr.xr24_u17.nr1[nsmm_w]
print @n.xbgr.xr24_u17.nr1[nsmm_l]
print @n.xbgr.xr24_u18.nr1[nsmm_rsh]
print @n.xbgr.xr24_u18.nr1[nsmm_w]
print @n.xbgr.xr24_u18.nr1[nsmm_l]
print @n.xbgr.xr24_u19.nr1[nsmm_rsh]
print @n.xbgr.xr24_u19.nr1[nsmm_w]
print @n.xbgr.xr24_u19.nr1[nsmm_l]
print @n.xbgr.xr24_u20.nr1[nsmm_rsh]
print @n.xbgr.xr24_u20.nr1[nsmm_w]
print @n.xbgr.xr24_u20.nr1[nsmm_l]
print @n.xbgr.xr24_u21.nr1[nsmm_rsh]
print @n.xbgr.xr24_u21.nr1[nsmm_w]
print @n.xbgr.xr24_u21.nr1[nsmm_l]
print @n.xbgr.xr24_u22.nr1[nsmm_rsh]
print @n.xbgr.xr24_u22.nr1[nsmm_w]
print @n.xbgr.xr24_u22.nr1[nsmm_l]
print @n.xbgr.xr24_u23.nr1[nsmm_rsh]
print @n.xbgr.xr24_u23.nr1[nsmm_w]
print @n.xbgr.xr24_u23.nr1[nsmm_l]
print @n.xbgr.xr24_u24.nr1[nsmm_rsh]
print @n.xbgr.xr24_u24.nr1[nsmm_w]
print @n.xbgr.xr24_u24.nr1[nsmm_l]
print @n.xbgr.xr25_u2.nr1[nsmm_rsh]
print @n.xbgr.xr25_u2.nr1[nsmm_w]
print @n.xbgr.xr25_u2.nr1[nsmm_l]
print @n.xbgr.xr25_u3.nr1[nsmm_rsh]
print @n.xbgr.xr25_u3.nr1[nsmm_w]
print @n.xbgr.xr25_u3.nr1[nsmm_l]
print @n.xbgr.xr25_u4.nr1[nsmm_rsh]
print @n.xbgr.xr25_u4.nr1[nsmm_w]
print @n.xbgr.xr25_u4.nr1[nsmm_l]
print @n.xbgr.xr25_u5.nr1[nsmm_rsh]
print @n.xbgr.xr25_u5.nr1[nsmm_w]
print @n.xbgr.xr25_u5.nr1[nsmm_l]
print @n.xbgr.xr25_u6.nr1[nsmm_rsh]
print @n.xbgr.xr25_u6.nr1[nsmm_w]
print @n.xbgr.xr25_u6.nr1[nsmm_l]
print @n.xbgr.xr25_u7.nr1[nsmm_rsh]
print @n.xbgr.xr25_u7.nr1[nsmm_w]
print @n.xbgr.xr25_u7.nr1[nsmm_l]
print @n.xbgr.xr25_u8.nr1[nsmm_rsh]
print @n.xbgr.xr25_u8.nr1[nsmm_w]
print @n.xbgr.xr25_u8.nr1[nsmm_l]
print @n.xbgr.xr25_u9.nr1[nsmm_rsh]
print @n.xbgr.xr25_u9.nr1[nsmm_w]
print @n.xbgr.xr25_u9.nr1[nsmm_l]
print @n.xbgr.xr25_u10.nr1[nsmm_rsh]
print @n.xbgr.xr25_u10.nr1[nsmm_w]
print @n.xbgr.xr25_u10.nr1[nsmm_l]
print @n.xbgr.xr25_u11.nr1[nsmm_rsh]
print @n.xbgr.xr25_u11.nr1[nsmm_w]
print @n.xbgr.xr25_u11.nr1[nsmm_l]
print @n.xbgr.xr25_u12.nr1[nsmm_rsh]
print @n.xbgr.xr25_u12.nr1[nsmm_w]
print @n.xbgr.xr25_u12.nr1[nsmm_l]
print @n.xbgr.xr25_u13.nr1[nsmm_rsh]
print @n.xbgr.xr25_u13.nr1[nsmm_w]
print @n.xbgr.xr25_u13.nr1[nsmm_l]
print @n.xbgr.xr25_u14.nr1[nsmm_rsh]
print @n.xbgr.xr25_u14.nr1[nsmm_w]
print @n.xbgr.xr25_u14.nr1[nsmm_l]
print @n.xbgr.xr25_u15.nr1[nsmm_rsh]
print @n.xbgr.xr25_u15.nr1[nsmm_w]
print @n.xbgr.xr25_u15.nr1[nsmm_l]
print @n.xbgr.xr25_u16.nr1[nsmm_rsh]
print @n.xbgr.xr25_u16.nr1[nsmm_w]
print @n.xbgr.xr25_u16.nr1[nsmm_l]
print @n.xbgr.xr25_u17.nr1[nsmm_rsh]
print @n.xbgr.xr25_u17.nr1[nsmm_w]
print @n.xbgr.xr25_u17.nr1[nsmm_l]
print @n.xbgr.xr25_u18.nr1[nsmm_rsh]
print @n.xbgr.xr25_u18.nr1[nsmm_w]
print @n.xbgr.xr25_u18.nr1[nsmm_l]
print @n.xbgr.xr25_u19.nr1[nsmm_rsh]
print @n.xbgr.xr25_u19.nr1[nsmm_w]
print @n.xbgr.xr25_u19.nr1[nsmm_l]
print @n.xbgr.xr25_u20.nr1[nsmm_rsh]
print @n.xbgr.xr25_u20.nr1[nsmm_w]
print @n.xbgr.xr25_u20.nr1[nsmm_l]
print @n.xbgr.xr25_u21.nr1[nsmm_rsh]
print @n.xbgr.xr25_u21.nr1[nsmm_w]
print @n.xbgr.xr25_u21.nr1[nsmm_l]
print @n.xbgr.xr25_u22.nr1[nsmm_rsh]
print @n.xbgr.xr25_u22.nr1[nsmm_w]
print @n.xbgr.xr25_u22.nr1[nsmm_l]
print @n.xbgr.xr25_u23.nr1[nsmm_rsh]
print @n.xbgr.xr25_u23.nr1[nsmm_w]
print @n.xbgr.xr25_u23.nr1[nsmm_l]
print @n.xbgr.xr25_u24.nr1[nsmm_rsh]
print @n.xbgr.xr25_u24.nr1[nsmm_w]
print @n.xbgr.xr25_u24.nr1[nsmm_l]
print @n.xbgr.xr26_u2.nr1[nsmm_rsh]
print @n.xbgr.xr26_u2.nr1[nsmm_w]
print @n.xbgr.xr26_u2.nr1[nsmm_l]
print @n.xbgr.xr26_u3.nr1[nsmm_rsh]
print @n.xbgr.xr26_u3.nr1[nsmm_w]
print @n.xbgr.xr26_u3.nr1[nsmm_l]
print @n.xbgr.xr26_u4.nr1[nsmm_rsh]
print @n.xbgr.xr26_u4.nr1[nsmm_w]
print @n.xbgr.xr26_u4.nr1[nsmm_l]
print @n.xbgr.xr26_u5.nr1[nsmm_rsh]
print @n.xbgr.xr26_u5.nr1[nsmm_w]
print @n.xbgr.xr26_u5.nr1[nsmm_l]
print @n.xbgr.xr26_u6.nr1[nsmm_rsh]
print @n.xbgr.xr26_u6.nr1[nsmm_w]
print @n.xbgr.xr26_u6.nr1[nsmm_l]
print @n.xbgr.xr26_u7.nr1[nsmm_rsh]
print @n.xbgr.xr26_u7.nr1[nsmm_w]
print @n.xbgr.xr26_u7.nr1[nsmm_l]
print @n.xbgr.xr26_u8.nr1[nsmm_rsh]
print @n.xbgr.xr26_u8.nr1[nsmm_w]
print @n.xbgr.xr26_u8.nr1[nsmm_l]
print @n.xbgr.xr26_u9.nr1[nsmm_rsh]
print @n.xbgr.xr26_u9.nr1[nsmm_w]
print @n.xbgr.xr26_u9.nr1[nsmm_l]
print @n.xbgr.xr26_u10.nr1[nsmm_rsh]
print @n.xbgr.xr26_u10.nr1[nsmm_w]
print @n.xbgr.xr26_u10.nr1[nsmm_l]
print @n.xbgr.xr26_u11.nr1[nsmm_rsh]
print @n.xbgr.xr26_u11.nr1[nsmm_w]
print @n.xbgr.xr26_u11.nr1[nsmm_l]
print @n.xbgr.xr26_u12.nr1[nsmm_rsh]
print @n.xbgr.xr26_u12.nr1[nsmm_w]
print @n.xbgr.xr26_u12.nr1[nsmm_l]
print @n.xbgr.xr26_u13.nr1[nsmm_rsh]
print @n.xbgr.xr26_u13.nr1[nsmm_w]
print @n.xbgr.xr26_u13.nr1[nsmm_l]
print @n.xbgr.xr26_u14.nr1[nsmm_rsh]
print @n.xbgr.xr26_u14.nr1[nsmm_w]
print @n.xbgr.xr26_u14.nr1[nsmm_l]
print @n.xbgr.xr26_u15.nr1[nsmm_rsh]
print @n.xbgr.xr26_u15.nr1[nsmm_w]
print @n.xbgr.xr26_u15.nr1[nsmm_l]
print @n.xbgr.xr26_u16.nr1[nsmm_rsh]
print @n.xbgr.xr26_u16.nr1[nsmm_w]
print @n.xbgr.xr26_u16.nr1[nsmm_l]
print @n.xbgr.xr26_u17.nr1[nsmm_rsh]
print @n.xbgr.xr26_u17.nr1[nsmm_w]
print @n.xbgr.xr26_u17.nr1[nsmm_l]
print @n.xbgr.xr26_u18.nr1[nsmm_rsh]
print @n.xbgr.xr26_u18.nr1[nsmm_w]
print @n.xbgr.xr26_u18.nr1[nsmm_l]
print @n.xbgr.xr26_u19.nr1[nsmm_rsh]
print @n.xbgr.xr26_u19.nr1[nsmm_w]
print @n.xbgr.xr26_u19.nr1[nsmm_l]
print @n.xbgr.xr26_u20.nr1[nsmm_rsh]
print @n.xbgr.xr26_u20.nr1[nsmm_w]
print @n.xbgr.xr26_u20.nr1[nsmm_l]
print @n.xbgr.xr26_u21.nr1[nsmm_rsh]
print @n.xbgr.xr26_u21.nr1[nsmm_w]
print @n.xbgr.xr26_u21.nr1[nsmm_l]
print @n.xbgr.xr26_u22.nr1[nsmm_rsh]
print @n.xbgr.xr26_u22.nr1[nsmm_w]
print @n.xbgr.xr26_u22.nr1[nsmm_l]
print @n.xbgr.xr26_u23.nr1[nsmm_rsh]
print @n.xbgr.xr26_u23.nr1[nsmm_w]
print @n.xbgr.xr26_u23.nr1[nsmm_l]
print @n.xbgr.xr26_u24.nr1[nsmm_rsh]
print @n.xbgr.xr26_u24.nr1[nsmm_w]
print @n.xbgr.xr26_u24.nr1[nsmm_l]
print @n.xbgr.xm34_u2.nsg13_hv_nmos[w]
print @n.xbgr.xm34_u2.nsg13_hv_nmos[l]
print @n.xbgr.xm34_u2.nsg13_hv_nmos[delvto]
print @n.xbgr.xm34_u2.nsg13_hv_nmos[factuo]
print @n.xbgr.xm34_u3.nsg13_hv_nmos[w]
print @n.xbgr.xm34_u3.nsg13_hv_nmos[l]
print @n.xbgr.xm34_u3.nsg13_hv_nmos[delvto]
print @n.xbgr.xm34_u3.nsg13_hv_nmos[factuo]
print @n.xbgr.xm34_u4.nsg13_hv_nmos[w]
print @n.xbgr.xm34_u4.nsg13_hv_nmos[l]
print @n.xbgr.xm34_u4.nsg13_hv_nmos[delvto]
print @n.xbgr.xm34_u4.nsg13_hv_nmos[factuo]
print @n.xbgr.xm34_u5.nsg13_hv_nmos[w]
print @n.xbgr.xm34_u5.nsg13_hv_nmos[l]
print @n.xbgr.xm34_u5.nsg13_hv_nmos[delvto]
print @n.xbgr.xm34_u5.nsg13_hv_nmos[factuo]
print @n.xbgr.xm34_u6.nsg13_hv_nmos[w]
print @n.xbgr.xm34_u6.nsg13_hv_nmos[l]
print @n.xbgr.xm34_u6.nsg13_hv_nmos[delvto]
print @n.xbgr.xm34_u6.nsg13_hv_nmos[factuo]
print @n.xbgr.xm34_u7.nsg13_hv_nmos[w]
print @n.xbgr.xm34_u7.nsg13_hv_nmos[l]
print @n.xbgr.xm34_u7.nsg13_hv_nmos[delvto]
print @n.xbgr.xm34_u7.nsg13_hv_nmos[factuo]
print @n.xbgr.xm34_u8.nsg13_hv_nmos[w]
print @n.xbgr.xm34_u8.nsg13_hv_nmos[l]
print @n.xbgr.xm34_u8.nsg13_hv_nmos[delvto]
print @n.xbgr.xm34_u8.nsg13_hv_nmos[factuo]
print @n.xbgr.xm34_u9.nsg13_hv_nmos[w]
print @n.xbgr.xm34_u9.nsg13_hv_nmos[l]
print @n.xbgr.xm34_u9.nsg13_hv_nmos[delvto]
print @n.xbgr.xm34_u9.nsg13_hv_nmos[factuo]
print @n.xbgr.xm34_u10.nsg13_hv_nmos[w]
print @n.xbgr.xm34_u10.nsg13_hv_nmos[l]
print @n.xbgr.xm34_u10.nsg13_hv_nmos[delvto]
print @n.xbgr.xm34_u10.nsg13_hv_nmos[factuo]
print @n.xbgr.xm34_u11.nsg13_hv_nmos[w]
print @n.xbgr.xm34_u11.nsg13_hv_nmos[l]
print @n.xbgr.xm34_u11.nsg13_hv_nmos[delvto]
print @n.xbgr.xm34_u11.nsg13_hv_nmos[factuo]
print @n.xbgr.xm34_u12.nsg13_hv_nmos[w]
print @n.xbgr.xm34_u12.nsg13_hv_nmos[l]
print @n.xbgr.xm34_u12.nsg13_hv_nmos[delvto]
print @n.xbgr.xm34_u12.nsg13_hv_nmos[factuo]
print @n.xbgr.xm34_u13.nsg13_hv_nmos[w]
print @n.xbgr.xm34_u13.nsg13_hv_nmos[l]
print @n.xbgr.xm34_u13.nsg13_hv_nmos[delvto]
print @n.xbgr.xm34_u13.nsg13_hv_nmos[factuo]
print @n.xbgr.xm34_u14.nsg13_hv_nmos[w]
print @n.xbgr.xm34_u14.nsg13_hv_nmos[l]
print @n.xbgr.xm34_u14.nsg13_hv_nmos[delvto]
print @n.xbgr.xm34_u14.nsg13_hv_nmos[factuo]
print @n.xbgr.xm34_u15.nsg13_hv_nmos[w]
print @n.xbgr.xm34_u15.nsg13_hv_nmos[l]
print @n.xbgr.xm34_u15.nsg13_hv_nmos[delvto]
print @n.xbgr.xm34_u15.nsg13_hv_nmos[factuo]
print @n.xbgr.xm34_u16.nsg13_hv_nmos[w]
print @n.xbgr.xm34_u16.nsg13_hv_nmos[l]
print @n.xbgr.xm34_u16.nsg13_hv_nmos[delvto]
print @n.xbgr.xm34_u16.nsg13_hv_nmos[factuo]
print @n.xbgr.xm34_u17.nsg13_hv_nmos[w]
print @n.xbgr.xm34_u17.nsg13_hv_nmos[l]
print @n.xbgr.xm34_u17.nsg13_hv_nmos[delvto]
print @n.xbgr.xm34_u17.nsg13_hv_nmos[factuo]
print @n.xbgr.xm34_u18.nsg13_hv_nmos[w]
print @n.xbgr.xm34_u18.nsg13_hv_nmos[l]
print @n.xbgr.xm34_u18.nsg13_hv_nmos[delvto]
print @n.xbgr.xm34_u18.nsg13_hv_nmos[factuo]
print @n.xbgr.xm34_u19.nsg13_hv_nmos[w]
print @n.xbgr.xm34_u19.nsg13_hv_nmos[l]
print @n.xbgr.xm34_u19.nsg13_hv_nmos[delvto]
print @n.xbgr.xm34_u19.nsg13_hv_nmos[factuo]
print @n.xbgr.xm34_u20.nsg13_hv_nmos[w]
print @n.xbgr.xm34_u20.nsg13_hv_nmos[l]
print @n.xbgr.xm34_u20.nsg13_hv_nmos[delvto]
print @n.xbgr.xm34_u20.nsg13_hv_nmos[factuo]
print @n.xbgr.xm34_u21.nsg13_hv_nmos[w]
print @n.xbgr.xm34_u21.nsg13_hv_nmos[l]
print @n.xbgr.xm34_u21.nsg13_hv_nmos[delvto]
print @n.xbgr.xm34_u21.nsg13_hv_nmos[factuo]
print @n.xbgr.xm34_u22.nsg13_hv_nmos[w]
print @n.xbgr.xm34_u22.nsg13_hv_nmos[l]
print @n.xbgr.xm34_u22.nsg13_hv_nmos[delvto]
print @n.xbgr.xm34_u22.nsg13_hv_nmos[factuo]
print @n.xbgr.xm34_u23.nsg13_hv_nmos[w]
print @n.xbgr.xm34_u23.nsg13_hv_nmos[l]
print @n.xbgr.xm34_u23.nsg13_hv_nmos[delvto]
print @n.xbgr.xm34_u23.nsg13_hv_nmos[factuo]
print @n.xbgr.xm34_u24.nsg13_hv_nmos[w]
print @n.xbgr.xm34_u24.nsg13_hv_nmos[l]
print @n.xbgr.xm34_u24.nsg13_hv_nmos[delvto]
print @n.xbgr.xm34_u24.nsg13_hv_nmos[factuo]
print @n.xbgr.xm35_u2.nsg13_hv_nmos[w]
print @n.xbgr.xm35_u2.nsg13_hv_nmos[l]
print @n.xbgr.xm35_u2.nsg13_hv_nmos[delvto]
print @n.xbgr.xm35_u2.nsg13_hv_nmos[factuo]
print @n.xbgr.xm35_u3.nsg13_hv_nmos[w]
print @n.xbgr.xm35_u3.nsg13_hv_nmos[l]
print @n.xbgr.xm35_u3.nsg13_hv_nmos[delvto]
print @n.xbgr.xm35_u3.nsg13_hv_nmos[factuo]
print @n.xbgr.xm35_u4.nsg13_hv_nmos[w]
print @n.xbgr.xm35_u4.nsg13_hv_nmos[l]
print @n.xbgr.xm35_u4.nsg13_hv_nmos[delvto]
print @n.xbgr.xm35_u4.nsg13_hv_nmos[factuo]
print @n.xbgr.xm35_u5.nsg13_hv_nmos[w]
print @n.xbgr.xm35_u5.nsg13_hv_nmos[l]
print @n.xbgr.xm35_u5.nsg13_hv_nmos[delvto]
print @n.xbgr.xm35_u5.nsg13_hv_nmos[factuo]
print @n.xbgr.xm35_u6.nsg13_hv_nmos[w]
print @n.xbgr.xm35_u6.nsg13_hv_nmos[l]
print @n.xbgr.xm35_u6.nsg13_hv_nmos[delvto]
print @n.xbgr.xm35_u6.nsg13_hv_nmos[factuo]
print @n.xbgr.xm35_u7.nsg13_hv_nmos[w]
print @n.xbgr.xm35_u7.nsg13_hv_nmos[l]
print @n.xbgr.xm35_u7.nsg13_hv_nmos[delvto]
print @n.xbgr.xm35_u7.nsg13_hv_nmos[factuo]
print @n.xbgr.xm35_u8.nsg13_hv_nmos[w]
print @n.xbgr.xm35_u8.nsg13_hv_nmos[l]
print @n.xbgr.xm35_u8.nsg13_hv_nmos[delvto]
print @n.xbgr.xm35_u8.nsg13_hv_nmos[factuo]
print @n.xbgr.xm35_u9.nsg13_hv_nmos[w]
print @n.xbgr.xm35_u9.nsg13_hv_nmos[l]
print @n.xbgr.xm35_u9.nsg13_hv_nmos[delvto]
print @n.xbgr.xm35_u9.nsg13_hv_nmos[factuo]
print @n.xbgr.xm35_u10.nsg13_hv_nmos[w]
print @n.xbgr.xm35_u10.nsg13_hv_nmos[l]
print @n.xbgr.xm35_u10.nsg13_hv_nmos[delvto]
print @n.xbgr.xm35_u10.nsg13_hv_nmos[factuo]
print @n.xbgr.xm35_u11.nsg13_hv_nmos[w]
print @n.xbgr.xm35_u11.nsg13_hv_nmos[l]
print @n.xbgr.xm35_u11.nsg13_hv_nmos[delvto]
print @n.xbgr.xm35_u11.nsg13_hv_nmos[factuo]
print @n.xbgr.xm35_u12.nsg13_hv_nmos[w]
print @n.xbgr.xm35_u12.nsg13_hv_nmos[l]
print @n.xbgr.xm35_u12.nsg13_hv_nmos[delvto]
print @n.xbgr.xm35_u12.nsg13_hv_nmos[factuo]
print @n.xbgr.xm35_u13.nsg13_hv_nmos[w]
print @n.xbgr.xm35_u13.nsg13_hv_nmos[l]
print @n.xbgr.xm35_u13.nsg13_hv_nmos[delvto]
print @n.xbgr.xm35_u13.nsg13_hv_nmos[factuo]
print @n.xbgr.xm35_u14.nsg13_hv_nmos[w]
print @n.xbgr.xm35_u14.nsg13_hv_nmos[l]
print @n.xbgr.xm35_u14.nsg13_hv_nmos[delvto]
print @n.xbgr.xm35_u14.nsg13_hv_nmos[factuo]
print @n.xbgr.xm35_u15.nsg13_hv_nmos[w]
print @n.xbgr.xm35_u15.nsg13_hv_nmos[l]
print @n.xbgr.xm35_u15.nsg13_hv_nmos[delvto]
print @n.xbgr.xm35_u15.nsg13_hv_nmos[factuo]
print @n.xbgr.xm35_u16.nsg13_hv_nmos[w]
print @n.xbgr.xm35_u16.nsg13_hv_nmos[l]
print @n.xbgr.xm35_u16.nsg13_hv_nmos[delvto]
print @n.xbgr.xm35_u16.nsg13_hv_nmos[factuo]
print @n.xbgr.xm35_u17.nsg13_hv_nmos[w]
print @n.xbgr.xm35_u17.nsg13_hv_nmos[l]
print @n.xbgr.xm35_u17.nsg13_hv_nmos[delvto]
print @n.xbgr.xm35_u17.nsg13_hv_nmos[factuo]
print @n.xbgr.xm35_u18.nsg13_hv_nmos[w]
print @n.xbgr.xm35_u18.nsg13_hv_nmos[l]
print @n.xbgr.xm35_u18.nsg13_hv_nmos[delvto]
print @n.xbgr.xm35_u18.nsg13_hv_nmos[factuo]
print @n.xbgr.xm35_u19.nsg13_hv_nmos[w]
print @n.xbgr.xm35_u19.nsg13_hv_nmos[l]
print @n.xbgr.xm35_u19.nsg13_hv_nmos[delvto]
print @n.xbgr.xm35_u19.nsg13_hv_nmos[factuo]
print @n.xbgr.xm35_u20.nsg13_hv_nmos[w]
print @n.xbgr.xm35_u20.nsg13_hv_nmos[l]
print @n.xbgr.xm35_u20.nsg13_hv_nmos[delvto]
print @n.xbgr.xm35_u20.nsg13_hv_nmos[factuo]
print @n.xbgr.xm35_u21.nsg13_hv_nmos[w]
print @n.xbgr.xm35_u21.nsg13_hv_nmos[l]
print @n.xbgr.xm35_u21.nsg13_hv_nmos[delvto]
print @n.xbgr.xm35_u21.nsg13_hv_nmos[factuo]
print @n.xbgr.xm35_u22.nsg13_hv_nmos[w]
print @n.xbgr.xm35_u22.nsg13_hv_nmos[l]
print @n.xbgr.xm35_u22.nsg13_hv_nmos[delvto]
print @n.xbgr.xm35_u22.nsg13_hv_nmos[factuo]
print @n.xbgr.xm35_u23.nsg13_hv_nmos[w]
print @n.xbgr.xm35_u23.nsg13_hv_nmos[l]
print @n.xbgr.xm35_u23.nsg13_hv_nmos[delvto]
print @n.xbgr.xm35_u23.nsg13_hv_nmos[factuo]
print @n.xbgr.xm35_u24.nsg13_hv_nmos[w]
print @n.xbgr.xm35_u24.nsg13_hv_nmos[l]
print @n.xbgr.xm35_u24.nsg13_hv_nmos[delvto]
print @n.xbgr.xm35_u24.nsg13_hv_nmos[factuo]
print @n.xbgr.xm36_u2.nsg13_hv_nmos[w]
print @n.xbgr.xm36_u2.nsg13_hv_nmos[l]
print @n.xbgr.xm36_u2.nsg13_hv_nmos[delvto]
print @n.xbgr.xm36_u2.nsg13_hv_nmos[factuo]
print @n.xbgr.xm36_u3.nsg13_hv_nmos[w]
print @n.xbgr.xm36_u3.nsg13_hv_nmos[l]
print @n.xbgr.xm36_u3.nsg13_hv_nmos[delvto]
print @n.xbgr.xm36_u3.nsg13_hv_nmos[factuo]
print @n.xbgr.xm36_u4.nsg13_hv_nmos[w]
print @n.xbgr.xm36_u4.nsg13_hv_nmos[l]
print @n.xbgr.xm36_u4.nsg13_hv_nmos[delvto]
print @n.xbgr.xm36_u4.nsg13_hv_nmos[factuo]
print @n.xbgr.xm36_u5.nsg13_hv_nmos[w]
print @n.xbgr.xm36_u5.nsg13_hv_nmos[l]
print @n.xbgr.xm36_u5.nsg13_hv_nmos[delvto]
print @n.xbgr.xm36_u5.nsg13_hv_nmos[factuo]
print @n.xbgr.xm36_u6.nsg13_hv_nmos[w]
print @n.xbgr.xm36_u6.nsg13_hv_nmos[l]
print @n.xbgr.xm36_u6.nsg13_hv_nmos[delvto]
print @n.xbgr.xm36_u6.nsg13_hv_nmos[factuo]
print @n.xbgr.xm36_u7.nsg13_hv_nmos[w]
print @n.xbgr.xm36_u7.nsg13_hv_nmos[l]
print @n.xbgr.xm36_u7.nsg13_hv_nmos[delvto]
print @n.xbgr.xm36_u7.nsg13_hv_nmos[factuo]
print @n.xbgr.xm36_u8.nsg13_hv_nmos[w]
print @n.xbgr.xm36_u8.nsg13_hv_nmos[l]
print @n.xbgr.xm36_u8.nsg13_hv_nmos[delvto]
print @n.xbgr.xm36_u8.nsg13_hv_nmos[factuo]
print @n.xbgr.xm36_u9.nsg13_hv_nmos[w]
print @n.xbgr.xm36_u9.nsg13_hv_nmos[l]
print @n.xbgr.xm36_u9.nsg13_hv_nmos[delvto]
print @n.xbgr.xm36_u9.nsg13_hv_nmos[factuo]
print @n.xbgr.xm36_u10.nsg13_hv_nmos[w]
print @n.xbgr.xm36_u10.nsg13_hv_nmos[l]
print @n.xbgr.xm36_u10.nsg13_hv_nmos[delvto]
print @n.xbgr.xm36_u10.nsg13_hv_nmos[factuo]
print @n.xbgr.xm36_u11.nsg13_hv_nmos[w]
print @n.xbgr.xm36_u11.nsg13_hv_nmos[l]
print @n.xbgr.xm36_u11.nsg13_hv_nmos[delvto]
print @n.xbgr.xm36_u11.nsg13_hv_nmos[factuo]
print @n.xbgr.xm36_u12.nsg13_hv_nmos[w]
print @n.xbgr.xm36_u12.nsg13_hv_nmos[l]
print @n.xbgr.xm36_u12.nsg13_hv_nmos[delvto]
print @n.xbgr.xm36_u12.nsg13_hv_nmos[factuo]
print @n.xbgr.xm36_u13.nsg13_hv_nmos[w]
print @n.xbgr.xm36_u13.nsg13_hv_nmos[l]
print @n.xbgr.xm36_u13.nsg13_hv_nmos[delvto]
print @n.xbgr.xm36_u13.nsg13_hv_nmos[factuo]
print @n.xbgr.xm36_u14.nsg13_hv_nmos[w]
print @n.xbgr.xm36_u14.nsg13_hv_nmos[l]
print @n.xbgr.xm36_u14.nsg13_hv_nmos[delvto]
print @n.xbgr.xm36_u14.nsg13_hv_nmos[factuo]
print @n.xbgr.xm36_u15.nsg13_hv_nmos[w]
print @n.xbgr.xm36_u15.nsg13_hv_nmos[l]
print @n.xbgr.xm36_u15.nsg13_hv_nmos[delvto]
print @n.xbgr.xm36_u15.nsg13_hv_nmos[factuo]
print @n.xbgr.xm36_u16.nsg13_hv_nmos[w]
print @n.xbgr.xm36_u16.nsg13_hv_nmos[l]
print @n.xbgr.xm36_u16.nsg13_hv_nmos[delvto]
print @n.xbgr.xm36_u16.nsg13_hv_nmos[factuo]
print @n.xbgr.xm36_u17.nsg13_hv_nmos[w]
print @n.xbgr.xm36_u17.nsg13_hv_nmos[l]
print @n.xbgr.xm36_u17.nsg13_hv_nmos[delvto]
print @n.xbgr.xm36_u17.nsg13_hv_nmos[factuo]
print @n.xbgr.xm36_u18.nsg13_hv_nmos[w]
print @n.xbgr.xm36_u18.nsg13_hv_nmos[l]
print @n.xbgr.xm36_u18.nsg13_hv_nmos[delvto]
print @n.xbgr.xm36_u18.nsg13_hv_nmos[factuo]
print @n.xbgr.xm36_u19.nsg13_hv_nmos[w]
print @n.xbgr.xm36_u19.nsg13_hv_nmos[l]
print @n.xbgr.xm36_u19.nsg13_hv_nmos[delvto]
print @n.xbgr.xm36_u19.nsg13_hv_nmos[factuo]
print @n.xbgr.xm36_u20.nsg13_hv_nmos[w]
print @n.xbgr.xm36_u20.nsg13_hv_nmos[l]
print @n.xbgr.xm36_u20.nsg13_hv_nmos[delvto]
print @n.xbgr.xm36_u20.nsg13_hv_nmos[factuo]
print @n.xbgr.xm36_u21.nsg13_hv_nmos[w]
print @n.xbgr.xm36_u21.nsg13_hv_nmos[l]
print @n.xbgr.xm36_u21.nsg13_hv_nmos[delvto]
print @n.xbgr.xm36_u21.nsg13_hv_nmos[factuo]
print @n.xbgr.xm36_u22.nsg13_hv_nmos[w]
print @n.xbgr.xm36_u22.nsg13_hv_nmos[l]
print @n.xbgr.xm36_u22.nsg13_hv_nmos[delvto]
print @n.xbgr.xm36_u22.nsg13_hv_nmos[factuo]
print @n.xbgr.xm36_u23.nsg13_hv_nmos[w]
print @n.xbgr.xm36_u23.nsg13_hv_nmos[l]
print @n.xbgr.xm36_u23.nsg13_hv_nmos[delvto]
print @n.xbgr.xm36_u23.nsg13_hv_nmos[factuo]
print @n.xbgr.xm36_u24.nsg13_hv_nmos[w]
print @n.xbgr.xm36_u24.nsg13_hv_nmos[l]
print @n.xbgr.xm36_u24.nsg13_hv_nmos[delvto]
print @n.xbgr.xm36_u24.nsg13_hv_nmos[factuo]
print @n.xbgr.xm37_u2.nsg13_hv_nmos[w]
print @n.xbgr.xm37_u2.nsg13_hv_nmos[l]
print @n.xbgr.xm37_u2.nsg13_hv_nmos[delvto]
print @n.xbgr.xm37_u2.nsg13_hv_nmos[factuo]
print @n.xbgr.xm37_u3.nsg13_hv_nmos[w]
print @n.xbgr.xm37_u3.nsg13_hv_nmos[l]
print @n.xbgr.xm37_u3.nsg13_hv_nmos[delvto]
print @n.xbgr.xm37_u3.nsg13_hv_nmos[factuo]
print @n.xbgr.xm37_u4.nsg13_hv_nmos[w]
print @n.xbgr.xm37_u4.nsg13_hv_nmos[l]
print @n.xbgr.xm37_u4.nsg13_hv_nmos[delvto]
print @n.xbgr.xm37_u4.nsg13_hv_nmos[factuo]
print @n.xbgr.xm37_u5.nsg13_hv_nmos[w]
print @n.xbgr.xm37_u5.nsg13_hv_nmos[l]
print @n.xbgr.xm37_u5.nsg13_hv_nmos[delvto]
print @n.xbgr.xm37_u5.nsg13_hv_nmos[factuo]
print @n.xbgr.xm37_u6.nsg13_hv_nmos[w]
print @n.xbgr.xm37_u6.nsg13_hv_nmos[l]
print @n.xbgr.xm37_u6.nsg13_hv_nmos[delvto]
print @n.xbgr.xm37_u6.nsg13_hv_nmos[factuo]
print @n.xbgr.xm37_u7.nsg13_hv_nmos[w]
print @n.xbgr.xm37_u7.nsg13_hv_nmos[l]
print @n.xbgr.xm37_u7.nsg13_hv_nmos[delvto]
print @n.xbgr.xm37_u7.nsg13_hv_nmos[factuo]
print @n.xbgr.xm37_u8.nsg13_hv_nmos[w]
print @n.xbgr.xm37_u8.nsg13_hv_nmos[l]
print @n.xbgr.xm37_u8.nsg13_hv_nmos[delvto]
print @n.xbgr.xm37_u8.nsg13_hv_nmos[factuo]
print @n.xbgr.xm37_u9.nsg13_hv_nmos[w]
print @n.xbgr.xm37_u9.nsg13_hv_nmos[l]
print @n.xbgr.xm37_u9.nsg13_hv_nmos[delvto]
print @n.xbgr.xm37_u9.nsg13_hv_nmos[factuo]
print @n.xbgr.xm37_u10.nsg13_hv_nmos[w]
print @n.xbgr.xm37_u10.nsg13_hv_nmos[l]
print @n.xbgr.xm37_u10.nsg13_hv_nmos[delvto]
print @n.xbgr.xm37_u10.nsg13_hv_nmos[factuo]
print @n.xbgr.xm37_u11.nsg13_hv_nmos[w]
print @n.xbgr.xm37_u11.nsg13_hv_nmos[l]
print @n.xbgr.xm37_u11.nsg13_hv_nmos[delvto]
print @n.xbgr.xm37_u11.nsg13_hv_nmos[factuo]
print @n.xbgr.xm37_u12.nsg13_hv_nmos[w]
print @n.xbgr.xm37_u12.nsg13_hv_nmos[l]
print @n.xbgr.xm37_u12.nsg13_hv_nmos[delvto]
print @n.xbgr.xm37_u12.nsg13_hv_nmos[factuo]
print @n.xbgr.xm37_u13.nsg13_hv_nmos[w]
print @n.xbgr.xm37_u13.nsg13_hv_nmos[l]
print @n.xbgr.xm37_u13.nsg13_hv_nmos[delvto]
print @n.xbgr.xm37_u13.nsg13_hv_nmos[factuo]
print @n.xbgr.xm37_u14.nsg13_hv_nmos[w]
print @n.xbgr.xm37_u14.nsg13_hv_nmos[l]
print @n.xbgr.xm37_u14.nsg13_hv_nmos[delvto]
print @n.xbgr.xm37_u14.nsg13_hv_nmos[factuo]
print @n.xbgr.xm37_u15.nsg13_hv_nmos[w]
print @n.xbgr.xm37_u15.nsg13_hv_nmos[l]
print @n.xbgr.xm37_u15.nsg13_hv_nmos[delvto]
print @n.xbgr.xm37_u15.nsg13_hv_nmos[factuo]
print @n.xbgr.xm37_u16.nsg13_hv_nmos[w]
print @n.xbgr.xm37_u16.nsg13_hv_nmos[l]
print @n.xbgr.xm37_u16.nsg13_hv_nmos[delvto]
print @n.xbgr.xm37_u16.nsg13_hv_nmos[factuo]
print @n.xbgr.xm37_u17.nsg13_hv_nmos[w]
print @n.xbgr.xm37_u17.nsg13_hv_nmos[l]
print @n.xbgr.xm37_u17.nsg13_hv_nmos[delvto]
print @n.xbgr.xm37_u17.nsg13_hv_nmos[factuo]
print @n.xbgr.xm37_u18.nsg13_hv_nmos[w]
print @n.xbgr.xm37_u18.nsg13_hv_nmos[l]
print @n.xbgr.xm37_u18.nsg13_hv_nmos[delvto]
print @n.xbgr.xm37_u18.nsg13_hv_nmos[factuo]
print @n.xbgr.xm37_u19.nsg13_hv_nmos[w]
print @n.xbgr.xm37_u19.nsg13_hv_nmos[l]
print @n.xbgr.xm37_u19.nsg13_hv_nmos[delvto]
print @n.xbgr.xm37_u19.nsg13_hv_nmos[factuo]
print @n.xbgr.xm37_u20.nsg13_hv_nmos[w]
print @n.xbgr.xm37_u20.nsg13_hv_nmos[l]
print @n.xbgr.xm37_u20.nsg13_hv_nmos[delvto]
print @n.xbgr.xm37_u20.nsg13_hv_nmos[factuo]
print @n.xbgr.xm37_u21.nsg13_hv_nmos[w]
print @n.xbgr.xm37_u21.nsg13_hv_nmos[l]
print @n.xbgr.xm37_u21.nsg13_hv_nmos[delvto]
print @n.xbgr.xm37_u21.nsg13_hv_nmos[factuo]
print @n.xbgr.xm37_u22.nsg13_hv_nmos[w]
print @n.xbgr.xm37_u22.nsg13_hv_nmos[l]
print @n.xbgr.xm37_u22.nsg13_hv_nmos[delvto]
print @n.xbgr.xm37_u22.nsg13_hv_nmos[factuo]
print @n.xbgr.xm37_u23.nsg13_hv_nmos[w]
print @n.xbgr.xm37_u23.nsg13_hv_nmos[l]
print @n.xbgr.xm37_u23.nsg13_hv_nmos[delvto]
print @n.xbgr.xm37_u23.nsg13_hv_nmos[factuo]
print @n.xbgr.xm37_u24.nsg13_hv_nmos[w]
print @n.xbgr.xm37_u24.nsg13_hv_nmos[l]
print @n.xbgr.xm37_u24.nsg13_hv_nmos[delvto]
print @n.xbgr.xm37_u24.nsg13_hv_nmos[factuo]
print @n.xbgr.xm38_u2.nsg13_hv_pmos[w]
print @n.xbgr.xm38_u2.nsg13_hv_pmos[l]
print @n.xbgr.xm38_u2.nsg13_hv_pmos[delvto]
print @n.xbgr.xm38_u2.nsg13_hv_pmos[factuo]
print @n.xbgr.xm38_u3.nsg13_hv_pmos[w]
print @n.xbgr.xm38_u3.nsg13_hv_pmos[l]
print @n.xbgr.xm38_u3.nsg13_hv_pmos[delvto]
print @n.xbgr.xm38_u3.nsg13_hv_pmos[factuo]
print @n.xbgr.xm38_u4.nsg13_hv_pmos[w]
print @n.xbgr.xm38_u4.nsg13_hv_pmos[l]
print @n.xbgr.xm38_u4.nsg13_hv_pmos[delvto]
print @n.xbgr.xm38_u4.nsg13_hv_pmos[factuo]
print @n.xbgr.xm38_u5.nsg13_hv_pmos[w]
print @n.xbgr.xm38_u5.nsg13_hv_pmos[l]
print @n.xbgr.xm38_u5.nsg13_hv_pmos[delvto]
print @n.xbgr.xm38_u5.nsg13_hv_pmos[factuo]
print @n.xbgr.xm38_u6.nsg13_hv_pmos[w]
print @n.xbgr.xm38_u6.nsg13_hv_pmos[l]
print @n.xbgr.xm38_u6.nsg13_hv_pmos[delvto]
print @n.xbgr.xm38_u6.nsg13_hv_pmos[factuo]
print @n.xbgr.xm38_u7.nsg13_hv_pmos[w]
print @n.xbgr.xm38_u7.nsg13_hv_pmos[l]
print @n.xbgr.xm38_u7.nsg13_hv_pmos[delvto]
print @n.xbgr.xm38_u7.nsg13_hv_pmos[factuo]
print @n.xbgr.xm38_u8.nsg13_hv_pmos[w]
print @n.xbgr.xm38_u8.nsg13_hv_pmos[l]
print @n.xbgr.xm38_u8.nsg13_hv_pmos[delvto]
print @n.xbgr.xm38_u8.nsg13_hv_pmos[factuo]
print @n.xbgr.xm38_u9.nsg13_hv_pmos[w]
print @n.xbgr.xm38_u9.nsg13_hv_pmos[l]
print @n.xbgr.xm38_u9.nsg13_hv_pmos[delvto]
print @n.xbgr.xm38_u9.nsg13_hv_pmos[factuo]
print @n.xbgr.xm38_u10.nsg13_hv_pmos[w]
print @n.xbgr.xm38_u10.nsg13_hv_pmos[l]
print @n.xbgr.xm38_u10.nsg13_hv_pmos[delvto]
print @n.xbgr.xm38_u10.nsg13_hv_pmos[factuo]
print @n.xbgr.xm38_u11.nsg13_hv_pmos[w]
print @n.xbgr.xm38_u11.nsg13_hv_pmos[l]
print @n.xbgr.xm38_u11.nsg13_hv_pmos[delvto]
print @n.xbgr.xm38_u11.nsg13_hv_pmos[factuo]
print @n.xbgr.xm38_u12.nsg13_hv_pmos[w]
print @n.xbgr.xm38_u12.nsg13_hv_pmos[l]
print @n.xbgr.xm38_u12.nsg13_hv_pmos[delvto]
print @n.xbgr.xm38_u12.nsg13_hv_pmos[factuo]
print @n.xbgr.xm38_u13.nsg13_hv_pmos[w]
print @n.xbgr.xm38_u13.nsg13_hv_pmos[l]
print @n.xbgr.xm38_u13.nsg13_hv_pmos[delvto]
print @n.xbgr.xm38_u13.nsg13_hv_pmos[factuo]
print @n.xbgr.xm38_u14.nsg13_hv_pmos[w]
print @n.xbgr.xm38_u14.nsg13_hv_pmos[l]
print @n.xbgr.xm38_u14.nsg13_hv_pmos[delvto]
print @n.xbgr.xm38_u14.nsg13_hv_pmos[factuo]
print @n.xbgr.xm38_u15.nsg13_hv_pmos[w]
print @n.xbgr.xm38_u15.nsg13_hv_pmos[l]
print @n.xbgr.xm38_u15.nsg13_hv_pmos[delvto]
print @n.xbgr.xm38_u15.nsg13_hv_pmos[factuo]
print @n.xbgr.xm38_u16.nsg13_hv_pmos[w]
print @n.xbgr.xm38_u16.nsg13_hv_pmos[l]
print @n.xbgr.xm38_u16.nsg13_hv_pmos[delvto]
print @n.xbgr.xm38_u16.nsg13_hv_pmos[factuo]
print @n.xbgr.xm38_u17.nsg13_hv_pmos[w]
print @n.xbgr.xm38_u17.nsg13_hv_pmos[l]
print @n.xbgr.xm38_u17.nsg13_hv_pmos[delvto]
print @n.xbgr.xm38_u17.nsg13_hv_pmos[factuo]
print @n.xbgr.xm38_u18.nsg13_hv_pmos[w]
print @n.xbgr.xm38_u18.nsg13_hv_pmos[l]
print @n.xbgr.xm38_u18.nsg13_hv_pmos[delvto]
print @n.xbgr.xm38_u18.nsg13_hv_pmos[factuo]
print @n.xbgr.xm38_u19.nsg13_hv_pmos[w]
print @n.xbgr.xm38_u19.nsg13_hv_pmos[l]
print @n.xbgr.xm38_u19.nsg13_hv_pmos[delvto]
print @n.xbgr.xm38_u19.nsg13_hv_pmos[factuo]
print @n.xbgr.xm38_u20.nsg13_hv_pmos[w]
print @n.xbgr.xm38_u20.nsg13_hv_pmos[l]
print @n.xbgr.xm38_u20.nsg13_hv_pmos[delvto]
print @n.xbgr.xm38_u20.nsg13_hv_pmos[factuo]
print @n.xbgr.xm38_u21.nsg13_hv_pmos[w]
print @n.xbgr.xm38_u21.nsg13_hv_pmos[l]
print @n.xbgr.xm38_u21.nsg13_hv_pmos[delvto]
print @n.xbgr.xm38_u21.nsg13_hv_pmos[factuo]
print @n.xbgr.xm38_u22.nsg13_hv_pmos[w]
print @n.xbgr.xm38_u22.nsg13_hv_pmos[l]
print @n.xbgr.xm38_u22.nsg13_hv_pmos[delvto]
print @n.xbgr.xm38_u22.nsg13_hv_pmos[factuo]
print @n.xbgr.xm38_u23.nsg13_hv_pmos[w]
print @n.xbgr.xm38_u23.nsg13_hv_pmos[l]
print @n.xbgr.xm38_u23.nsg13_hv_pmos[delvto]
print @n.xbgr.xm38_u23.nsg13_hv_pmos[factuo]
print @n.xbgr.xm38_u24.nsg13_hv_pmos[w]
print @n.xbgr.xm38_u24.nsg13_hv_pmos[l]
print @n.xbgr.xm38_u24.nsg13_hv_pmos[delvto]
print @n.xbgr.xm38_u24.nsg13_hv_pmos[factuo]
print @n.xbgr.xm39_u2.nsg13_hv_pmos[w]
print @n.xbgr.xm39_u2.nsg13_hv_pmos[l]
print @n.xbgr.xm39_u2.nsg13_hv_pmos[delvto]
print @n.xbgr.xm39_u2.nsg13_hv_pmos[factuo]
print @n.xbgr.xm39_u3.nsg13_hv_pmos[w]
print @n.xbgr.xm39_u3.nsg13_hv_pmos[l]
print @n.xbgr.xm39_u3.nsg13_hv_pmos[delvto]
print @n.xbgr.xm39_u3.nsg13_hv_pmos[factuo]
print @n.xbgr.xm39_u4.nsg13_hv_pmos[w]
print @n.xbgr.xm39_u4.nsg13_hv_pmos[l]
print @n.xbgr.xm39_u4.nsg13_hv_pmos[delvto]
print @n.xbgr.xm39_u4.nsg13_hv_pmos[factuo]
print @n.xbgr.xm39_u5.nsg13_hv_pmos[w]
print @n.xbgr.xm39_u5.nsg13_hv_pmos[l]
print @n.xbgr.xm39_u5.nsg13_hv_pmos[delvto]
print @n.xbgr.xm39_u5.nsg13_hv_pmos[factuo]
print @n.xbgr.xm39_u6.nsg13_hv_pmos[w]
print @n.xbgr.xm39_u6.nsg13_hv_pmos[l]
print @n.xbgr.xm39_u6.nsg13_hv_pmos[delvto]
print @n.xbgr.xm39_u6.nsg13_hv_pmos[factuo]
print @n.xbgr.xm39_u7.nsg13_hv_pmos[w]
print @n.xbgr.xm39_u7.nsg13_hv_pmos[l]
print @n.xbgr.xm39_u7.nsg13_hv_pmos[delvto]
print @n.xbgr.xm39_u7.nsg13_hv_pmos[factuo]
print @n.xbgr.xm39_u8.nsg13_hv_pmos[w]
print @n.xbgr.xm39_u8.nsg13_hv_pmos[l]
print @n.xbgr.xm39_u8.nsg13_hv_pmos[delvto]
print @n.xbgr.xm39_u8.nsg13_hv_pmos[factuo]
print @n.xbgr.xm39_u9.nsg13_hv_pmos[w]
print @n.xbgr.xm39_u9.nsg13_hv_pmos[l]
print @n.xbgr.xm39_u9.nsg13_hv_pmos[delvto]
print @n.xbgr.xm39_u9.nsg13_hv_pmos[factuo]
print @n.xbgr.xm39_u10.nsg13_hv_pmos[w]
print @n.xbgr.xm39_u10.nsg13_hv_pmos[l]
print @n.xbgr.xm39_u10.nsg13_hv_pmos[delvto]
print @n.xbgr.xm39_u10.nsg13_hv_pmos[factuo]
print @n.xbgr.xm39_u11.nsg13_hv_pmos[w]
print @n.xbgr.xm39_u11.nsg13_hv_pmos[l]
print @n.xbgr.xm39_u11.nsg13_hv_pmos[delvto]
print @n.xbgr.xm39_u11.nsg13_hv_pmos[factuo]
print @n.xbgr.xm39_u12.nsg13_hv_pmos[w]
print @n.xbgr.xm39_u12.nsg13_hv_pmos[l]
print @n.xbgr.xm39_u12.nsg13_hv_pmos[delvto]
print @n.xbgr.xm39_u12.nsg13_hv_pmos[factuo]
print @n.xbgr.xm39_u13.nsg13_hv_pmos[w]
print @n.xbgr.xm39_u13.nsg13_hv_pmos[l]
print @n.xbgr.xm39_u13.nsg13_hv_pmos[delvto]
print @n.xbgr.xm39_u13.nsg13_hv_pmos[factuo]
print @n.xbgr.xm39_u14.nsg13_hv_pmos[w]
print @n.xbgr.xm39_u14.nsg13_hv_pmos[l]
print @n.xbgr.xm39_u14.nsg13_hv_pmos[delvto]
print @n.xbgr.xm39_u14.nsg13_hv_pmos[factuo]
print @n.xbgr.xm39_u15.nsg13_hv_pmos[w]
print @n.xbgr.xm39_u15.nsg13_hv_pmos[l]
print @n.xbgr.xm39_u15.nsg13_hv_pmos[delvto]
print @n.xbgr.xm39_u15.nsg13_hv_pmos[factuo]
print @n.xbgr.xm39_u16.nsg13_hv_pmos[w]
print @n.xbgr.xm39_u16.nsg13_hv_pmos[l]
print @n.xbgr.xm39_u16.nsg13_hv_pmos[delvto]
print @n.xbgr.xm39_u16.nsg13_hv_pmos[factuo]
print @n.xbgr.xm39_u17.nsg13_hv_pmos[w]
print @n.xbgr.xm39_u17.nsg13_hv_pmos[l]
print @n.xbgr.xm39_u17.nsg13_hv_pmos[delvto]
print @n.xbgr.xm39_u17.nsg13_hv_pmos[factuo]
print @n.xbgr.xm39_u18.nsg13_hv_pmos[w]
print @n.xbgr.xm39_u18.nsg13_hv_pmos[l]
print @n.xbgr.xm39_u18.nsg13_hv_pmos[delvto]
print @n.xbgr.xm39_u18.nsg13_hv_pmos[factuo]
print @n.xbgr.xm39_u19.nsg13_hv_pmos[w]
print @n.xbgr.xm39_u19.nsg13_hv_pmos[l]
print @n.xbgr.xm39_u19.nsg13_hv_pmos[delvto]
print @n.xbgr.xm39_u19.nsg13_hv_pmos[factuo]
print @n.xbgr.xm39_u20.nsg13_hv_pmos[w]
print @n.xbgr.xm39_u20.nsg13_hv_pmos[l]
print @n.xbgr.xm39_u20.nsg13_hv_pmos[delvto]
print @n.xbgr.xm39_u20.nsg13_hv_pmos[factuo]
print @n.xbgr.xm39_u21.nsg13_hv_pmos[w]
print @n.xbgr.xm39_u21.nsg13_hv_pmos[l]
print @n.xbgr.xm39_u21.nsg13_hv_pmos[delvto]
print @n.xbgr.xm39_u21.nsg13_hv_pmos[factuo]
print @n.xbgr.xm39_u22.nsg13_hv_pmos[w]
print @n.xbgr.xm39_u22.nsg13_hv_pmos[l]
print @n.xbgr.xm39_u22.nsg13_hv_pmos[delvto]
print @n.xbgr.xm39_u22.nsg13_hv_pmos[factuo]
print @n.xbgr.xm39_u23.nsg13_hv_pmos[w]
print @n.xbgr.xm39_u23.nsg13_hv_pmos[l]
print @n.xbgr.xm39_u23.nsg13_hv_pmos[delvto]
print @n.xbgr.xm39_u23.nsg13_hv_pmos[factuo]
print @n.xbgr.xm39_u24.nsg13_hv_pmos[w]
print @n.xbgr.xm39_u24.nsg13_hv_pmos[l]
print @n.xbgr.xm39_u24.nsg13_hv_pmos[delvto]
print @n.xbgr.xm39_u24.nsg13_hv_pmos[factuo]
print @n.xbgr.xm41_u2.nsg13_hv_pmos[w]
print @n.xbgr.xm41_u2.nsg13_hv_pmos[l]
print @n.xbgr.xm41_u2.nsg13_hv_pmos[delvto]
print @n.xbgr.xm41_u2.nsg13_hv_pmos[factuo]
print @n.xbgr.xm41_u3.nsg13_hv_pmos[w]
print @n.xbgr.xm41_u3.nsg13_hv_pmos[l]
print @n.xbgr.xm41_u3.nsg13_hv_pmos[delvto]
print @n.xbgr.xm41_u3.nsg13_hv_pmos[factuo]
print @n.xbgr.xm41_u4.nsg13_hv_pmos[w]
print @n.xbgr.xm41_u4.nsg13_hv_pmos[l]
print @n.xbgr.xm41_u4.nsg13_hv_pmos[delvto]
print @n.xbgr.xm41_u4.nsg13_hv_pmos[factuo]
print @n.xbgr.xm41_u5.nsg13_hv_pmos[w]
print @n.xbgr.xm41_u5.nsg13_hv_pmos[l]
print @n.xbgr.xm41_u5.nsg13_hv_pmos[delvto]
print @n.xbgr.xm41_u5.nsg13_hv_pmos[factuo]
print @n.xbgr.xm41_u6.nsg13_hv_pmos[w]
print @n.xbgr.xm41_u6.nsg13_hv_pmos[l]
print @n.xbgr.xm41_u6.nsg13_hv_pmos[delvto]
print @n.xbgr.xm41_u6.nsg13_hv_pmos[factuo]
print @n.xbgr.xm41_u7.nsg13_hv_pmos[w]
print @n.xbgr.xm41_u7.nsg13_hv_pmos[l]
print @n.xbgr.xm41_u7.nsg13_hv_pmos[delvto]
print @n.xbgr.xm41_u7.nsg13_hv_pmos[factuo]
print @n.xbgr.xm41_u8.nsg13_hv_pmos[w]
print @n.xbgr.xm41_u8.nsg13_hv_pmos[l]
print @n.xbgr.xm41_u8.nsg13_hv_pmos[delvto]
print @n.xbgr.xm41_u8.nsg13_hv_pmos[factuo]
print @n.xbgr.xm41_u9.nsg13_hv_pmos[w]
print @n.xbgr.xm41_u9.nsg13_hv_pmos[l]
print @n.xbgr.xm41_u9.nsg13_hv_pmos[delvto]
print @n.xbgr.xm41_u9.nsg13_hv_pmos[factuo]
print @n.xbgr.xm41_u10.nsg13_hv_pmos[w]
print @n.xbgr.xm41_u10.nsg13_hv_pmos[l]
print @n.xbgr.xm41_u10.nsg13_hv_pmos[delvto]
print @n.xbgr.xm41_u10.nsg13_hv_pmos[factuo]
print @n.xbgr.xm41_u11.nsg13_hv_pmos[w]
print @n.xbgr.xm41_u11.nsg13_hv_pmos[l]
print @n.xbgr.xm41_u11.nsg13_hv_pmos[delvto]
print @n.xbgr.xm41_u11.nsg13_hv_pmos[factuo]
print @n.xbgr.xm41_u12.nsg13_hv_pmos[w]
print @n.xbgr.xm41_u12.nsg13_hv_pmos[l]
print @n.xbgr.xm41_u12.nsg13_hv_pmos[delvto]
print @n.xbgr.xm41_u12.nsg13_hv_pmos[factuo]
print @n.xbgr.xm41_u13.nsg13_hv_pmos[w]
print @n.xbgr.xm41_u13.nsg13_hv_pmos[l]
print @n.xbgr.xm41_u13.nsg13_hv_pmos[delvto]
print @n.xbgr.xm41_u13.nsg13_hv_pmos[factuo]
print @n.xbgr.xm41_u14.nsg13_hv_pmos[w]
print @n.xbgr.xm41_u14.nsg13_hv_pmos[l]
print @n.xbgr.xm41_u14.nsg13_hv_pmos[delvto]
print @n.xbgr.xm41_u14.nsg13_hv_pmos[factuo]
print @n.xbgr.xm41_u15.nsg13_hv_pmos[w]
print @n.xbgr.xm41_u15.nsg13_hv_pmos[l]
print @n.xbgr.xm41_u15.nsg13_hv_pmos[delvto]
print @n.xbgr.xm41_u15.nsg13_hv_pmos[factuo]
print @n.xbgr.xm41_u16.nsg13_hv_pmos[w]
print @n.xbgr.xm41_u16.nsg13_hv_pmos[l]
print @n.xbgr.xm41_u16.nsg13_hv_pmos[delvto]
print @n.xbgr.xm41_u16.nsg13_hv_pmos[factuo]
print @n.xbgr.xm41_u17.nsg13_hv_pmos[w]
print @n.xbgr.xm41_u17.nsg13_hv_pmos[l]
print @n.xbgr.xm41_u17.nsg13_hv_pmos[delvto]
print @n.xbgr.xm41_u17.nsg13_hv_pmos[factuo]
print @n.xbgr.xm41_u18.nsg13_hv_pmos[w]
print @n.xbgr.xm41_u18.nsg13_hv_pmos[l]
print @n.xbgr.xm41_u18.nsg13_hv_pmos[delvto]
print @n.xbgr.xm41_u18.nsg13_hv_pmos[factuo]
print @n.xbgr.xm41_u19.nsg13_hv_pmos[w]
print @n.xbgr.xm41_u19.nsg13_hv_pmos[l]
print @n.xbgr.xm41_u19.nsg13_hv_pmos[delvto]
print @n.xbgr.xm41_u19.nsg13_hv_pmos[factuo]
print @n.xbgr.xm41_u20.nsg13_hv_pmos[w]
print @n.xbgr.xm41_u20.nsg13_hv_pmos[l]
print @n.xbgr.xm41_u20.nsg13_hv_pmos[delvto]
print @n.xbgr.xm41_u20.nsg13_hv_pmos[factuo]
print @n.xbgr.xm41_u21.nsg13_hv_pmos[w]
print @n.xbgr.xm41_u21.nsg13_hv_pmos[l]
print @n.xbgr.xm41_u21.nsg13_hv_pmos[delvto]
print @n.xbgr.xm41_u21.nsg13_hv_pmos[factuo]
print @n.xbgr.xm41_u22.nsg13_hv_pmos[w]
print @n.xbgr.xm41_u22.nsg13_hv_pmos[l]
print @n.xbgr.xm41_u22.nsg13_hv_pmos[delvto]
print @n.xbgr.xm41_u22.nsg13_hv_pmos[factuo]
print @n.xbgr.xm41_u23.nsg13_hv_pmos[w]
print @n.xbgr.xm41_u23.nsg13_hv_pmos[l]
print @n.xbgr.xm41_u23.nsg13_hv_pmos[delvto]
print @n.xbgr.xm41_u23.nsg13_hv_pmos[factuo]
print @n.xbgr.xm41_u24.nsg13_hv_pmos[w]
print @n.xbgr.xm41_u24.nsg13_hv_pmos[l]
print @n.xbgr.xm41_u24.nsg13_hv_pmos[delvto]
print @n.xbgr.xm41_u24.nsg13_hv_pmos[factuo]
print @n.xbgr.xm43_u2.nsg13_hv_pmos[w]
print @n.xbgr.xm43_u2.nsg13_hv_pmos[l]
print @n.xbgr.xm43_u2.nsg13_hv_pmos[delvto]
print @n.xbgr.xm43_u2.nsg13_hv_pmos[factuo]
print @n.xbgr.xm43_u3.nsg13_hv_pmos[w]
print @n.xbgr.xm43_u3.nsg13_hv_pmos[l]
print @n.xbgr.xm43_u3.nsg13_hv_pmos[delvto]
print @n.xbgr.xm43_u3.nsg13_hv_pmos[factuo]
print @n.xbgr.xm43_u4.nsg13_hv_pmos[w]
print @n.xbgr.xm43_u4.nsg13_hv_pmos[l]
print @n.xbgr.xm43_u4.nsg13_hv_pmos[delvto]
print @n.xbgr.xm43_u4.nsg13_hv_pmos[factuo]
print @n.xbgr.xm44_u2.nsg13_hv_pmos[w]
print @n.xbgr.xm44_u2.nsg13_hv_pmos[l]
print @n.xbgr.xm44_u2.nsg13_hv_pmos[delvto]
print @n.xbgr.xm44_u2.nsg13_hv_pmos[factuo]
print @n.xbgr.xm44_u3.nsg13_hv_pmos[w]
print @n.xbgr.xm44_u3.nsg13_hv_pmos[l]
print @n.xbgr.xm44_u3.nsg13_hv_pmos[delvto]
print @n.xbgr.xm44_u3.nsg13_hv_pmos[factuo]
print @n.xbgr.xm44_u4.nsg13_hv_pmos[w]
print @n.xbgr.xm44_u4.nsg13_hv_pmos[l]
print @n.xbgr.xm44_u4.nsg13_hv_pmos[delvto]
print @n.xbgr.xm44_u4.nsg13_hv_pmos[factuo]
print @n.xbgr.xm45_u2.nsg13_hv_pmos[w]
print @n.xbgr.xm45_u2.nsg13_hv_pmos[l]
print @n.xbgr.xm45_u2.nsg13_hv_pmos[delvto]
print @n.xbgr.xm45_u2.nsg13_hv_pmos[factuo]
print @n.xbgr.xm45_u3.nsg13_hv_pmos[w]
print @n.xbgr.xm45_u3.nsg13_hv_pmos[l]
print @n.xbgr.xm45_u3.nsg13_hv_pmos[delvto]
print @n.xbgr.xm45_u3.nsg13_hv_pmos[factuo]
print @n.xbgr.xm45_u4.nsg13_hv_pmos[w]
print @n.xbgr.xm45_u4.nsg13_hv_pmos[l]
print @n.xbgr.xm45_u4.nsg13_hv_pmos[delvto]
print @n.xbgr.xm45_u4.nsg13_hv_pmos[factuo]
print @n.xbgr.xm45_u5.nsg13_hv_pmos[w]
print @n.xbgr.xm45_u5.nsg13_hv_pmos[l]
print @n.xbgr.xm45_u5.nsg13_hv_pmos[delvto]
print @n.xbgr.xm45_u5.nsg13_hv_pmos[factuo]
print @n.xbgr.xm45_u6.nsg13_hv_pmos[w]
print @n.xbgr.xm45_u6.nsg13_hv_pmos[l]
print @n.xbgr.xm45_u6.nsg13_hv_pmos[delvto]
print @n.xbgr.xm45_u6.nsg13_hv_pmos[factuo]
print @n.xbgr.xm45_u7.nsg13_hv_pmos[w]
print @n.xbgr.xm45_u7.nsg13_hv_pmos[l]
print @n.xbgr.xm45_u7.nsg13_hv_pmos[delvto]
print @n.xbgr.xm45_u7.nsg13_hv_pmos[factuo]
print @n.xbgr.xm45_u8.nsg13_hv_pmos[w]
print @n.xbgr.xm45_u8.nsg13_hv_pmos[l]
print @n.xbgr.xm45_u8.nsg13_hv_pmos[delvto]
print @n.xbgr.xm45_u8.nsg13_hv_pmos[factuo]
print @n.xbgr.xm45_u9.nsg13_hv_pmos[w]
print @n.xbgr.xm45_u9.nsg13_hv_pmos[l]
print @n.xbgr.xm45_u9.nsg13_hv_pmos[delvto]
print @n.xbgr.xm45_u9.nsg13_hv_pmos[factuo]
print @n.xbgr.xm45_u10.nsg13_hv_pmos[w]
print @n.xbgr.xm45_u10.nsg13_hv_pmos[l]
print @n.xbgr.xm45_u10.nsg13_hv_pmos[delvto]
print @n.xbgr.xm45_u10.nsg13_hv_pmos[factuo]
print @n.xbgr.xm45_u11.nsg13_hv_pmos[w]
print @n.xbgr.xm45_u11.nsg13_hv_pmos[l]
print @n.xbgr.xm45_u11.nsg13_hv_pmos[delvto]
print @n.xbgr.xm45_u11.nsg13_hv_pmos[factuo]
print @n.xbgr.xm45_u12.nsg13_hv_pmos[w]
print @n.xbgr.xm45_u12.nsg13_hv_pmos[l]
print @n.xbgr.xm45_u12.nsg13_hv_pmos[delvto]
print @n.xbgr.xm45_u12.nsg13_hv_pmos[factuo]
print @n.xbgr.xm45_u13.nsg13_hv_pmos[w]
print @n.xbgr.xm45_u13.nsg13_hv_pmos[l]
print @n.xbgr.xm45_u13.nsg13_hv_pmos[delvto]
print @n.xbgr.xm45_u13.nsg13_hv_pmos[factuo]
print @n.xbgr.xm45_u14.nsg13_hv_pmos[w]
print @n.xbgr.xm45_u14.nsg13_hv_pmos[l]
print @n.xbgr.xm45_u14.nsg13_hv_pmos[delvto]
print @n.xbgr.xm45_u14.nsg13_hv_pmos[factuo]
print @n.xbgr.xm45_u15.nsg13_hv_pmos[w]
print @n.xbgr.xm45_u15.nsg13_hv_pmos[l]
print @n.xbgr.xm45_u15.nsg13_hv_pmos[delvto]
print @n.xbgr.xm45_u15.nsg13_hv_pmos[factuo]
print @n.xbgr.xm45_u16.nsg13_hv_pmos[w]
print @n.xbgr.xm45_u16.nsg13_hv_pmos[l]
print @n.xbgr.xm45_u16.nsg13_hv_pmos[delvto]
print @n.xbgr.xm45_u16.nsg13_hv_pmos[factuo]
print @n.xbgr.xm45_u17.nsg13_hv_pmos[w]
print @n.xbgr.xm45_u17.nsg13_hv_pmos[l]
print @n.xbgr.xm45_u17.nsg13_hv_pmos[delvto]
print @n.xbgr.xm45_u17.nsg13_hv_pmos[factuo]
print @n.xbgr.xm45_u18.nsg13_hv_pmos[w]
print @n.xbgr.xm45_u18.nsg13_hv_pmos[l]
print @n.xbgr.xm45_u18.nsg13_hv_pmos[delvto]
print @n.xbgr.xm45_u18.nsg13_hv_pmos[factuo]
print @n.xbgr.xm45_u19.nsg13_hv_pmos[w]
print @n.xbgr.xm45_u19.nsg13_hv_pmos[l]
print @n.xbgr.xm45_u19.nsg13_hv_pmos[delvto]
print @n.xbgr.xm45_u19.nsg13_hv_pmos[factuo]
print @n.xbgr.xm45_u20.nsg13_hv_pmos[w]
print @n.xbgr.xm45_u20.nsg13_hv_pmos[l]
print @n.xbgr.xm45_u20.nsg13_hv_pmos[delvto]
print @n.xbgr.xm45_u20.nsg13_hv_pmos[factuo]
print @n.xbgr.xm45_u21.nsg13_hv_pmos[w]
print @n.xbgr.xm45_u21.nsg13_hv_pmos[l]
print @n.xbgr.xm45_u21.nsg13_hv_pmos[delvto]
print @n.xbgr.xm45_u21.nsg13_hv_pmos[factuo]
print @n.xbgr.xm45_u22.nsg13_hv_pmos[w]
print @n.xbgr.xm45_u22.nsg13_hv_pmos[l]
print @n.xbgr.xm45_u22.nsg13_hv_pmos[delvto]
print @n.xbgr.xm45_u22.nsg13_hv_pmos[factuo]
print @n.xbgr.xm45_u23.nsg13_hv_pmos[w]
print @n.xbgr.xm45_u23.nsg13_hv_pmos[l]
print @n.xbgr.xm45_u23.nsg13_hv_pmos[delvto]
print @n.xbgr.xm45_u23.nsg13_hv_pmos[factuo]
print @n.xbgr.xm45_u24.nsg13_hv_pmos[w]
print @n.xbgr.xm45_u24.nsg13_hv_pmos[l]
print @n.xbgr.xm45_u24.nsg13_hv_pmos[delvto]
print @n.xbgr.xm45_u24.nsg13_hv_pmos[factuo]
print @n.xbgr.xm47_u2.nsg13_hv_pmos[w]
print @n.xbgr.xm47_u2.nsg13_hv_pmos[l]
print @n.xbgr.xm47_u2.nsg13_hv_pmos[delvto]
print @n.xbgr.xm47_u2.nsg13_hv_pmos[factuo]
print @n.xbgr.xm47_u3.nsg13_hv_pmos[w]
print @n.xbgr.xm47_u3.nsg13_hv_pmos[l]
print @n.xbgr.xm47_u3.nsg13_hv_pmos[delvto]
print @n.xbgr.xm47_u3.nsg13_hv_pmos[factuo]
print @n.xbgr.xm47_u4.nsg13_hv_pmos[w]
print @n.xbgr.xm47_u4.nsg13_hv_pmos[l]
print @n.xbgr.xm47_u4.nsg13_hv_pmos[delvto]
print @n.xbgr.xm47_u4.nsg13_hv_pmos[factuo]
print @n.xbgr.xm47_u5.nsg13_hv_pmos[w]
print @n.xbgr.xm47_u5.nsg13_hv_pmos[l]
print @n.xbgr.xm47_u5.nsg13_hv_pmos[delvto]
print @n.xbgr.xm47_u5.nsg13_hv_pmos[factuo]
print @n.xbgr.xm47_u6.nsg13_hv_pmos[w]
print @n.xbgr.xm47_u6.nsg13_hv_pmos[l]
print @n.xbgr.xm47_u6.nsg13_hv_pmos[delvto]
print @n.xbgr.xm47_u6.nsg13_hv_pmos[factuo]
print @n.xbgr.xm47_u7.nsg13_hv_pmos[w]
print @n.xbgr.xm47_u7.nsg13_hv_pmos[l]
print @n.xbgr.xm47_u7.nsg13_hv_pmos[delvto]
print @n.xbgr.xm47_u7.nsg13_hv_pmos[factuo]
print @n.xbgr.xm47_u8.nsg13_hv_pmos[w]
print @n.xbgr.xm47_u8.nsg13_hv_pmos[l]
print @n.xbgr.xm47_u8.nsg13_hv_pmos[delvto]
print @n.xbgr.xm47_u8.nsg13_hv_pmos[factuo]
print @n.xbgr.xm47_u9.nsg13_hv_pmos[w]
print @n.xbgr.xm47_u9.nsg13_hv_pmos[l]
print @n.xbgr.xm47_u9.nsg13_hv_pmos[delvto]
print @n.xbgr.xm47_u9.nsg13_hv_pmos[factuo]
print @n.xbgr.xm47_u10.nsg13_hv_pmos[w]
print @n.xbgr.xm47_u10.nsg13_hv_pmos[l]
print @n.xbgr.xm47_u10.nsg13_hv_pmos[delvto]
print @n.xbgr.xm47_u10.nsg13_hv_pmos[factuo]
print @n.xbgr.xm47_u11.nsg13_hv_pmos[w]
print @n.xbgr.xm47_u11.nsg13_hv_pmos[l]
print @n.xbgr.xm47_u11.nsg13_hv_pmos[delvto]
print @n.xbgr.xm47_u11.nsg13_hv_pmos[factuo]
print @n.xbgr.xm47_u12.nsg13_hv_pmos[w]
print @n.xbgr.xm47_u12.nsg13_hv_pmos[l]
print @n.xbgr.xm47_u12.nsg13_hv_pmos[delvto]
print @n.xbgr.xm47_u12.nsg13_hv_pmos[factuo]
print @n.xbgr.xm47_u13.nsg13_hv_pmos[w]
print @n.xbgr.xm47_u13.nsg13_hv_pmos[l]
print @n.xbgr.xm47_u13.nsg13_hv_pmos[delvto]
print @n.xbgr.xm47_u13.nsg13_hv_pmos[factuo]
print @n.xbgr.xm47_u14.nsg13_hv_pmos[w]
print @n.xbgr.xm47_u14.nsg13_hv_pmos[l]
print @n.xbgr.xm47_u14.nsg13_hv_pmos[delvto]
print @n.xbgr.xm47_u14.nsg13_hv_pmos[factuo]
print @n.xbgr.xm47_u15.nsg13_hv_pmos[w]
print @n.xbgr.xm47_u15.nsg13_hv_pmos[l]
print @n.xbgr.xm47_u15.nsg13_hv_pmos[delvto]
print @n.xbgr.xm47_u15.nsg13_hv_pmos[factuo]
print @n.xbgr.xm47_u16.nsg13_hv_pmos[w]
print @n.xbgr.xm47_u16.nsg13_hv_pmos[l]
print @n.xbgr.xm47_u16.nsg13_hv_pmos[delvto]
print @n.xbgr.xm47_u16.nsg13_hv_pmos[factuo]
print @n.xbgr.xm47_u17.nsg13_hv_pmos[w]
print @n.xbgr.xm47_u17.nsg13_hv_pmos[l]
print @n.xbgr.xm47_u17.nsg13_hv_pmos[delvto]
print @n.xbgr.xm47_u17.nsg13_hv_pmos[factuo]
print @n.xbgr.xm47_u18.nsg13_hv_pmos[w]
print @n.xbgr.xm47_u18.nsg13_hv_pmos[l]
print @n.xbgr.xm47_u18.nsg13_hv_pmos[delvto]
print @n.xbgr.xm47_u18.nsg13_hv_pmos[factuo]
print @n.xbgr.xm47_u19.nsg13_hv_pmos[w]
print @n.xbgr.xm47_u19.nsg13_hv_pmos[l]
print @n.xbgr.xm47_u19.nsg13_hv_pmos[delvto]
print @n.xbgr.xm47_u19.nsg13_hv_pmos[factuo]
print @n.xbgr.xm47_u20.nsg13_hv_pmos[w]
print @n.xbgr.xm47_u20.nsg13_hv_pmos[l]
print @n.xbgr.xm47_u20.nsg13_hv_pmos[delvto]
print @n.xbgr.xm47_u20.nsg13_hv_pmos[factuo]
print @n.xbgr.xm47_u21.nsg13_hv_pmos[w]
print @n.xbgr.xm47_u21.nsg13_hv_pmos[l]
print @n.xbgr.xm47_u21.nsg13_hv_pmos[delvto]
print @n.xbgr.xm47_u21.nsg13_hv_pmos[factuo]
print @n.xbgr.xm47_u22.nsg13_hv_pmos[w]
print @n.xbgr.xm47_u22.nsg13_hv_pmos[l]
print @n.xbgr.xm47_u22.nsg13_hv_pmos[delvto]
print @n.xbgr.xm47_u22.nsg13_hv_pmos[factuo]
print @n.xbgr.xm47_u23.nsg13_hv_pmos[w]
print @n.xbgr.xm47_u23.nsg13_hv_pmos[l]
print @n.xbgr.xm47_u23.nsg13_hv_pmos[delvto]
print @n.xbgr.xm47_u23.nsg13_hv_pmos[factuo]
print @n.xbgr.xm47_u24.nsg13_hv_pmos[w]
print @n.xbgr.xm47_u24.nsg13_hv_pmos[l]
print @n.xbgr.xm47_u24.nsg13_hv_pmos[delvto]
print @n.xbgr.xm47_u24.nsg13_hv_pmos[factuo]
print @n.xbgr.xm48_u2.nsg13_hv_pmos[w]
print @n.xbgr.xm48_u2.nsg13_hv_pmos[l]
print @n.xbgr.xm48_u2.nsg13_hv_pmos[delvto]
print @n.xbgr.xm48_u2.nsg13_hv_pmos[factuo]
print @n.xbgr.xm48_u3.nsg13_hv_pmos[w]
print @n.xbgr.xm48_u3.nsg13_hv_pmos[l]
print @n.xbgr.xm48_u3.nsg13_hv_pmos[delvto]
print @n.xbgr.xm48_u3.nsg13_hv_pmos[factuo]
print @n.xbgr.xm48_u4.nsg13_hv_pmos[w]
print @n.xbgr.xm48_u4.nsg13_hv_pmos[l]
print @n.xbgr.xm48_u4.nsg13_hv_pmos[delvto]
print @n.xbgr.xm48_u4.nsg13_hv_pmos[factuo]
print @n.xbgr.xm48_u5.nsg13_hv_pmos[w]
print @n.xbgr.xm48_u5.nsg13_hv_pmos[l]
print @n.xbgr.xm48_u5.nsg13_hv_pmos[delvto]
print @n.xbgr.xm48_u5.nsg13_hv_pmos[factuo]
print @n.xbgr.xm48_u6.nsg13_hv_pmos[w]
print @n.xbgr.xm48_u6.nsg13_hv_pmos[l]
print @n.xbgr.xm48_u6.nsg13_hv_pmos[delvto]
print @n.xbgr.xm48_u6.nsg13_hv_pmos[factuo]
print @n.xbgr.xm48_u7.nsg13_hv_pmos[w]
print @n.xbgr.xm48_u7.nsg13_hv_pmos[l]
print @n.xbgr.xm48_u7.nsg13_hv_pmos[delvto]
print @n.xbgr.xm48_u7.nsg13_hv_pmos[factuo]
print @n.xbgr.xm48_u8.nsg13_hv_pmos[w]
print @n.xbgr.xm48_u8.nsg13_hv_pmos[l]
print @n.xbgr.xm48_u8.nsg13_hv_pmos[delvto]
print @n.xbgr.xm48_u8.nsg13_hv_pmos[factuo]
print @n.xbgr.xm48_u9.nsg13_hv_pmos[w]
print @n.xbgr.xm48_u9.nsg13_hv_pmos[l]
print @n.xbgr.xm48_u9.nsg13_hv_pmos[delvto]
print @n.xbgr.xm48_u9.nsg13_hv_pmos[factuo]
print @n.xbgr.xm48_u10.nsg13_hv_pmos[w]
print @n.xbgr.xm48_u10.nsg13_hv_pmos[l]
print @n.xbgr.xm48_u10.nsg13_hv_pmos[delvto]
print @n.xbgr.xm48_u10.nsg13_hv_pmos[factuo]
print @n.xbgr.xm48_u11.nsg13_hv_pmos[w]
print @n.xbgr.xm48_u11.nsg13_hv_pmos[l]
print @n.xbgr.xm48_u11.nsg13_hv_pmos[delvto]
print @n.xbgr.xm48_u11.nsg13_hv_pmos[factuo]
print @n.xbgr.xm48_u12.nsg13_hv_pmos[w]
print @n.xbgr.xm48_u12.nsg13_hv_pmos[l]
print @n.xbgr.xm48_u12.nsg13_hv_pmos[delvto]
print @n.xbgr.xm48_u12.nsg13_hv_pmos[factuo]
print @n.xbgr.xm48_u13.nsg13_hv_pmos[w]
print @n.xbgr.xm48_u13.nsg13_hv_pmos[l]
print @n.xbgr.xm48_u13.nsg13_hv_pmos[delvto]
print @n.xbgr.xm48_u13.nsg13_hv_pmos[factuo]
print @n.xbgr.xm48_u14.nsg13_hv_pmos[w]
print @n.xbgr.xm48_u14.nsg13_hv_pmos[l]
print @n.xbgr.xm48_u14.nsg13_hv_pmos[delvto]
print @n.xbgr.xm48_u14.nsg13_hv_pmos[factuo]
print @n.xbgr.xm48_u15.nsg13_hv_pmos[w]
print @n.xbgr.xm48_u15.nsg13_hv_pmos[l]
print @n.xbgr.xm48_u15.nsg13_hv_pmos[delvto]
print @n.xbgr.xm48_u15.nsg13_hv_pmos[factuo]
print @n.xbgr.xm48_u16.nsg13_hv_pmos[w]
print @n.xbgr.xm48_u16.nsg13_hv_pmos[l]
print @n.xbgr.xm48_u16.nsg13_hv_pmos[delvto]
print @n.xbgr.xm48_u16.nsg13_hv_pmos[factuo]
print @n.xbgr.xm48_u17.nsg13_hv_pmos[w]
print @n.xbgr.xm48_u17.nsg13_hv_pmos[l]
print @n.xbgr.xm48_u17.nsg13_hv_pmos[delvto]
print @n.xbgr.xm48_u17.nsg13_hv_pmos[factuo]
print @n.xbgr.xm48_u18.nsg13_hv_pmos[w]
print @n.xbgr.xm48_u18.nsg13_hv_pmos[l]
print @n.xbgr.xm48_u18.nsg13_hv_pmos[delvto]
print @n.xbgr.xm48_u18.nsg13_hv_pmos[factuo]
print @n.xbgr.xm48_u19.nsg13_hv_pmos[w]
print @n.xbgr.xm48_u19.nsg13_hv_pmos[l]
print @n.xbgr.xm48_u19.nsg13_hv_pmos[delvto]
print @n.xbgr.xm48_u19.nsg13_hv_pmos[factuo]
print @n.xbgr.xm48_u20.nsg13_hv_pmos[w]
print @n.xbgr.xm48_u20.nsg13_hv_pmos[l]
print @n.xbgr.xm48_u20.nsg13_hv_pmos[delvto]
print @n.xbgr.xm48_u20.nsg13_hv_pmos[factuo]
print @n.xbgr.xm48_u21.nsg13_hv_pmos[w]
print @n.xbgr.xm48_u21.nsg13_hv_pmos[l]
print @n.xbgr.xm48_u21.nsg13_hv_pmos[delvto]
print @n.xbgr.xm48_u21.nsg13_hv_pmos[factuo]
print @n.xbgr.xm48_u22.nsg13_hv_pmos[w]
print @n.xbgr.xm48_u22.nsg13_hv_pmos[l]
print @n.xbgr.xm48_u22.nsg13_hv_pmos[delvto]
print @n.xbgr.xm48_u22.nsg13_hv_pmos[factuo]
print @n.xbgr.xm48_u23.nsg13_hv_pmos[w]
print @n.xbgr.xm48_u23.nsg13_hv_pmos[l]
print @n.xbgr.xm48_u23.nsg13_hv_pmos[delvto]
print @n.xbgr.xm48_u23.nsg13_hv_pmos[factuo]
print @n.xbgr.xm48_u24.nsg13_hv_pmos[w]
print @n.xbgr.xm48_u24.nsg13_hv_pmos[l]
print @n.xbgr.xm48_u24.nsg13_hv_pmos[delvto]
print @n.xbgr.xm48_u24.nsg13_hv_pmos[factuo]
print @n.xbgr.xm50_u2.nsg13_hv_pmos[w]
print @n.xbgr.xm50_u2.nsg13_hv_pmos[l]
print @n.xbgr.xm50_u2.nsg13_hv_pmos[delvto]
print @n.xbgr.xm50_u2.nsg13_hv_pmos[factuo]
print @n.xbgr.xm50_u3.nsg13_hv_pmos[w]
print @n.xbgr.xm50_u3.nsg13_hv_pmos[l]
print @n.xbgr.xm50_u3.nsg13_hv_pmos[delvto]
print @n.xbgr.xm50_u3.nsg13_hv_pmos[factuo]
print @n.xbgr.xm50_u4.nsg13_hv_pmos[w]
print @n.xbgr.xm50_u4.nsg13_hv_pmos[l]
print @n.xbgr.xm50_u4.nsg13_hv_pmos[delvto]
print @n.xbgr.xm50_u4.nsg13_hv_pmos[factuo]
print @n.xbgr.xm50_u5.nsg13_hv_pmos[w]
print @n.xbgr.xm50_u5.nsg13_hv_pmos[l]
print @n.xbgr.xm50_u5.nsg13_hv_pmos[delvto]
print @n.xbgr.xm50_u5.nsg13_hv_pmos[factuo]
print @n.xbgr.xm50_u6.nsg13_hv_pmos[w]
print @n.xbgr.xm50_u6.nsg13_hv_pmos[l]
print @n.xbgr.xm50_u6.nsg13_hv_pmos[delvto]
print @n.xbgr.xm50_u6.nsg13_hv_pmos[factuo]
print @n.xbgr.xm50_u7.nsg13_hv_pmos[w]
print @n.xbgr.xm50_u7.nsg13_hv_pmos[l]
print @n.xbgr.xm50_u7.nsg13_hv_pmos[delvto]
print @n.xbgr.xm50_u7.nsg13_hv_pmos[factuo]
print @n.xbgr.xm50_u8.nsg13_hv_pmos[w]
print @n.xbgr.xm50_u8.nsg13_hv_pmos[l]
print @n.xbgr.xm50_u8.nsg13_hv_pmos[delvto]
print @n.xbgr.xm50_u8.nsg13_hv_pmos[factuo]
print @n.xbgr.xm50_u9.nsg13_hv_pmos[w]
print @n.xbgr.xm50_u9.nsg13_hv_pmos[l]
print @n.xbgr.xm50_u9.nsg13_hv_pmos[delvto]
print @n.xbgr.xm50_u9.nsg13_hv_pmos[factuo]
print @n.xbgr.xm50_u10.nsg13_hv_pmos[w]
print @n.xbgr.xm50_u10.nsg13_hv_pmos[l]
print @n.xbgr.xm50_u10.nsg13_hv_pmos[delvto]
print @n.xbgr.xm50_u10.nsg13_hv_pmos[factuo]
print @n.xbgr.xm50_u11.nsg13_hv_pmos[w]
print @n.xbgr.xm50_u11.nsg13_hv_pmos[l]
print @n.xbgr.xm50_u11.nsg13_hv_pmos[delvto]
print @n.xbgr.xm50_u11.nsg13_hv_pmos[factuo]
print @n.xbgr.xm50_u12.nsg13_hv_pmos[w]
print @n.xbgr.xm50_u12.nsg13_hv_pmos[l]
print @n.xbgr.xm50_u12.nsg13_hv_pmos[delvto]
print @n.xbgr.xm50_u12.nsg13_hv_pmos[factuo]
print @n.xbgr.xm50_u13.nsg13_hv_pmos[w]
print @n.xbgr.xm50_u13.nsg13_hv_pmos[l]
print @n.xbgr.xm50_u13.nsg13_hv_pmos[delvto]
print @n.xbgr.xm50_u13.nsg13_hv_pmos[factuo]
print @n.xbgr.xm50_u14.nsg13_hv_pmos[w]
print @n.xbgr.xm50_u14.nsg13_hv_pmos[l]
print @n.xbgr.xm50_u14.nsg13_hv_pmos[delvto]
print @n.xbgr.xm50_u14.nsg13_hv_pmos[factuo]
print @n.xbgr.xm50_u15.nsg13_hv_pmos[w]
print @n.xbgr.xm50_u15.nsg13_hv_pmos[l]
print @n.xbgr.xm50_u15.nsg13_hv_pmos[delvto]
print @n.xbgr.xm50_u15.nsg13_hv_pmos[factuo]
print @n.xbgr.xm50_u16.nsg13_hv_pmos[w]
print @n.xbgr.xm50_u16.nsg13_hv_pmos[l]
print @n.xbgr.xm50_u16.nsg13_hv_pmos[delvto]
print @n.xbgr.xm50_u16.nsg13_hv_pmos[factuo]
print @n.xbgr.xm50_u17.nsg13_hv_pmos[w]
print @n.xbgr.xm50_u17.nsg13_hv_pmos[l]
print @n.xbgr.xm50_u17.nsg13_hv_pmos[delvto]
print @n.xbgr.xm50_u17.nsg13_hv_pmos[factuo]
print @n.xbgr.xm50_u18.nsg13_hv_pmos[w]
print @n.xbgr.xm50_u18.nsg13_hv_pmos[l]
print @n.xbgr.xm50_u18.nsg13_hv_pmos[delvto]
print @n.xbgr.xm50_u18.nsg13_hv_pmos[factuo]
print @n.xbgr.xm50_u19.nsg13_hv_pmos[w]
print @n.xbgr.xm50_u19.nsg13_hv_pmos[l]
print @n.xbgr.xm50_u19.nsg13_hv_pmos[delvto]
print @n.xbgr.xm50_u19.nsg13_hv_pmos[factuo]
print @n.xbgr.xm50_u20.nsg13_hv_pmos[w]
print @n.xbgr.xm50_u20.nsg13_hv_pmos[l]
print @n.xbgr.xm50_u20.nsg13_hv_pmos[delvto]
print @n.xbgr.xm50_u20.nsg13_hv_pmos[factuo]
print @n.xbgr.xm50_u21.nsg13_hv_pmos[w]
print @n.xbgr.xm50_u21.nsg13_hv_pmos[l]
print @n.xbgr.xm50_u21.nsg13_hv_pmos[delvto]
print @n.xbgr.xm50_u21.nsg13_hv_pmos[factuo]
print @n.xbgr.xm50_u22.nsg13_hv_pmos[w]
print @n.xbgr.xm50_u22.nsg13_hv_pmos[l]
print @n.xbgr.xm50_u22.nsg13_hv_pmos[delvto]
print @n.xbgr.xm50_u22.nsg13_hv_pmos[factuo]
print @n.xbgr.xm50_u23.nsg13_hv_pmos[w]
print @n.xbgr.xm50_u23.nsg13_hv_pmos[l]
print @n.xbgr.xm50_u23.nsg13_hv_pmos[delvto]
print @n.xbgr.xm50_u23.nsg13_hv_pmos[factuo]
print @n.xbgr.xm50_u24.nsg13_hv_pmos[w]
print @n.xbgr.xm50_u24.nsg13_hv_pmos[l]
print @n.xbgr.xm50_u24.nsg13_hv_pmos[delvto]
print @n.xbgr.xm50_u24.nsg13_hv_pmos[factuo]
print @n.xbgr.xm51_u2.nsg13_hv_pmos[w]
print @n.xbgr.xm51_u2.nsg13_hv_pmos[l]
print @n.xbgr.xm51_u2.nsg13_hv_pmos[delvto]
print @n.xbgr.xm51_u2.nsg13_hv_pmos[factuo]
print @n.xbgr.xm51_u3.nsg13_hv_pmos[w]
print @n.xbgr.xm51_u3.nsg13_hv_pmos[l]
print @n.xbgr.xm51_u3.nsg13_hv_pmos[delvto]
print @n.xbgr.xm51_u3.nsg13_hv_pmos[factuo]
print @n.xbgr.xm51_u4.nsg13_hv_pmos[w]
print @n.xbgr.xm51_u4.nsg13_hv_pmos[l]
print @n.xbgr.xm51_u4.nsg13_hv_pmos[delvto]
print @n.xbgr.xm51_u4.nsg13_hv_pmos[factuo]
print @n.xbgr.xm52_u2.nsg13_hv_pmos[w]
print @n.xbgr.xm52_u2.nsg13_hv_pmos[l]
print @n.xbgr.xm52_u2.nsg13_hv_pmos[delvto]
print @n.xbgr.xm52_u2.nsg13_hv_pmos[factuo]
print @n.xbgr.xm52_u3.nsg13_hv_pmos[w]
print @n.xbgr.xm52_u3.nsg13_hv_pmos[l]
print @n.xbgr.xm52_u3.nsg13_hv_pmos[delvto]
print @n.xbgr.xm52_u3.nsg13_hv_pmos[factuo]
print @n.xbgr.xm52_u4.nsg13_hv_pmos[w]
print @n.xbgr.xm52_u4.nsg13_hv_pmos[l]
print @n.xbgr.xm52_u4.nsg13_hv_pmos[delvto]
print @n.xbgr.xm52_u4.nsg13_hv_pmos[factuo]
print @n.xbgr.xm52_u5.nsg13_hv_pmos[w]
print @n.xbgr.xm52_u5.nsg13_hv_pmos[l]
print @n.xbgr.xm52_u5.nsg13_hv_pmos[delvto]
print @n.xbgr.xm52_u5.nsg13_hv_pmos[factuo]
print @n.xbgr.xm52_u6.nsg13_hv_pmos[w]
print @n.xbgr.xm52_u6.nsg13_hv_pmos[l]
print @n.xbgr.xm52_u6.nsg13_hv_pmos[delvto]
print @n.xbgr.xm52_u6.nsg13_hv_pmos[factuo]
print @n.xbgr.xm52_u7.nsg13_hv_pmos[w]
print @n.xbgr.xm52_u7.nsg13_hv_pmos[l]
print @n.xbgr.xm52_u7.nsg13_hv_pmos[delvto]
print @n.xbgr.xm52_u7.nsg13_hv_pmos[factuo]
print @n.xbgr.xm52_u8.nsg13_hv_pmos[w]
print @n.xbgr.xm52_u8.nsg13_hv_pmos[l]
print @n.xbgr.xm52_u8.nsg13_hv_pmos[delvto]
print @n.xbgr.xm52_u8.nsg13_hv_pmos[factuo]
print @n.xbgr.xm52_u9.nsg13_hv_pmos[w]
print @n.xbgr.xm52_u9.nsg13_hv_pmos[l]
print @n.xbgr.xm52_u9.nsg13_hv_pmos[delvto]
print @n.xbgr.xm52_u9.nsg13_hv_pmos[factuo]
print @n.xbgr.xm52_u10.nsg13_hv_pmos[w]
print @n.xbgr.xm52_u10.nsg13_hv_pmos[l]
print @n.xbgr.xm52_u10.nsg13_hv_pmos[delvto]
print @n.xbgr.xm52_u10.nsg13_hv_pmos[factuo]
print @n.xbgr.xm52_u11.nsg13_hv_pmos[w]
print @n.xbgr.xm52_u11.nsg13_hv_pmos[l]
print @n.xbgr.xm52_u11.nsg13_hv_pmos[delvto]
print @n.xbgr.xm52_u11.nsg13_hv_pmos[factuo]
print @n.xbgr.xm52_u12.nsg13_hv_pmos[w]
print @n.xbgr.xm52_u12.nsg13_hv_pmos[l]
print @n.xbgr.xm52_u12.nsg13_hv_pmos[delvto]
print @n.xbgr.xm52_u12.nsg13_hv_pmos[factuo]
print @n.xbgr.xm52_u13.nsg13_hv_pmos[w]
print @n.xbgr.xm52_u13.nsg13_hv_pmos[l]
print @n.xbgr.xm52_u13.nsg13_hv_pmos[delvto]
print @n.xbgr.xm52_u13.nsg13_hv_pmos[factuo]
print @n.xbgr.xm52_u14.nsg13_hv_pmos[w]
print @n.xbgr.xm52_u14.nsg13_hv_pmos[l]
print @n.xbgr.xm52_u14.nsg13_hv_pmos[delvto]
print @n.xbgr.xm52_u14.nsg13_hv_pmos[factuo]
print @n.xbgr.xm52_u15.nsg13_hv_pmos[w]
print @n.xbgr.xm52_u15.nsg13_hv_pmos[l]
print @n.xbgr.xm52_u15.nsg13_hv_pmos[delvto]
print @n.xbgr.xm52_u15.nsg13_hv_pmos[factuo]
print @n.xbgr.xm52_u16.nsg13_hv_pmos[w]
print @n.xbgr.xm52_u16.nsg13_hv_pmos[l]
print @n.xbgr.xm52_u16.nsg13_hv_pmos[delvto]
print @n.xbgr.xm52_u16.nsg13_hv_pmos[factuo]
print @n.xbgr.xm52_u17.nsg13_hv_pmos[w]
print @n.xbgr.xm52_u17.nsg13_hv_pmos[l]
print @n.xbgr.xm52_u17.nsg13_hv_pmos[delvto]
print @n.xbgr.xm52_u17.nsg13_hv_pmos[factuo]
print @n.xbgr.xm52_u18.nsg13_hv_pmos[w]
print @n.xbgr.xm52_u18.nsg13_hv_pmos[l]
print @n.xbgr.xm52_u18.nsg13_hv_pmos[delvto]
print @n.xbgr.xm52_u18.nsg13_hv_pmos[factuo]
print @n.xbgr.xm52_u19.nsg13_hv_pmos[w]
print @n.xbgr.xm52_u19.nsg13_hv_pmos[l]
print @n.xbgr.xm52_u19.nsg13_hv_pmos[delvto]
print @n.xbgr.xm52_u19.nsg13_hv_pmos[factuo]
print @n.xbgr.xm52_u20.nsg13_hv_pmos[w]
print @n.xbgr.xm52_u20.nsg13_hv_pmos[l]
print @n.xbgr.xm52_u20.nsg13_hv_pmos[delvto]
print @n.xbgr.xm52_u20.nsg13_hv_pmos[factuo]
print @n.xbgr.xm52_u21.nsg13_hv_pmos[w]
print @n.xbgr.xm52_u21.nsg13_hv_pmos[l]
print @n.xbgr.xm52_u21.nsg13_hv_pmos[delvto]
print @n.xbgr.xm52_u21.nsg13_hv_pmos[factuo]
print @n.xbgr.xm52_u22.nsg13_hv_pmos[w]
print @n.xbgr.xm52_u22.nsg13_hv_pmos[l]
print @n.xbgr.xm52_u22.nsg13_hv_pmos[delvto]
print @n.xbgr.xm52_u22.nsg13_hv_pmos[factuo]
print @n.xbgr.xm52_u23.nsg13_hv_pmos[w]
print @n.xbgr.xm52_u23.nsg13_hv_pmos[l]
print @n.xbgr.xm52_u23.nsg13_hv_pmos[delvto]
print @n.xbgr.xm52_u23.nsg13_hv_pmos[factuo]
print @n.xbgr.xm52_u24.nsg13_hv_pmos[w]
print @n.xbgr.xm52_u24.nsg13_hv_pmos[l]
print @n.xbgr.xm52_u24.nsg13_hv_pmos[delvto]
print @n.xbgr.xm52_u24.nsg13_hv_pmos[factuo]
print @n.xbgr.xm54_u2.nsg13_hv_pmos[w]
print @n.xbgr.xm54_u2.nsg13_hv_pmos[l]
print @n.xbgr.xm54_u2.nsg13_hv_pmos[delvto]
print @n.xbgr.xm54_u2.nsg13_hv_pmos[factuo]
print @n.xbgr.xm54_u3.nsg13_hv_pmos[w]
print @n.xbgr.xm54_u3.nsg13_hv_pmos[l]
print @n.xbgr.xm54_u3.nsg13_hv_pmos[delvto]
print @n.xbgr.xm54_u3.nsg13_hv_pmos[factuo]
print @n.xbgr.xm54_u4.nsg13_hv_pmos[w]
print @n.xbgr.xm54_u4.nsg13_hv_pmos[l]
print @n.xbgr.xm54_u4.nsg13_hv_pmos[delvto]
print @n.xbgr.xm54_u4.nsg13_hv_pmos[factuo]
print @n.xbgr.xm54_u5.nsg13_hv_pmos[w]
print @n.xbgr.xm54_u5.nsg13_hv_pmos[l]
print @n.xbgr.xm54_u5.nsg13_hv_pmos[delvto]
print @n.xbgr.xm54_u5.nsg13_hv_pmos[factuo]
print @n.xbgr.xm54_u6.nsg13_hv_pmos[w]
print @n.xbgr.xm54_u6.nsg13_hv_pmos[l]
print @n.xbgr.xm54_u6.nsg13_hv_pmos[delvto]
print @n.xbgr.xm54_u6.nsg13_hv_pmos[factuo]
print @n.xbgr.xm54_u7.nsg13_hv_pmos[w]
print @n.xbgr.xm54_u7.nsg13_hv_pmos[l]
print @n.xbgr.xm54_u7.nsg13_hv_pmos[delvto]
print @n.xbgr.xm54_u7.nsg13_hv_pmos[factuo]
print @n.xbgr.xm54_u8.nsg13_hv_pmos[w]
print @n.xbgr.xm54_u8.nsg13_hv_pmos[l]
print @n.xbgr.xm54_u8.nsg13_hv_pmos[delvto]
print @n.xbgr.xm54_u8.nsg13_hv_pmos[factuo]
print @n.xbgr.xm54_u9.nsg13_hv_pmos[w]
print @n.xbgr.xm54_u9.nsg13_hv_pmos[l]
print @n.xbgr.xm54_u9.nsg13_hv_pmos[delvto]
print @n.xbgr.xm54_u9.nsg13_hv_pmos[factuo]
print @n.xbgr.xm54_u10.nsg13_hv_pmos[w]
print @n.xbgr.xm54_u10.nsg13_hv_pmos[l]
print @n.xbgr.xm54_u10.nsg13_hv_pmos[delvto]
print @n.xbgr.xm54_u10.nsg13_hv_pmos[factuo]
print @n.xbgr.xm54_u11.nsg13_hv_pmos[w]
print @n.xbgr.xm54_u11.nsg13_hv_pmos[l]
print @n.xbgr.xm54_u11.nsg13_hv_pmos[delvto]
print @n.xbgr.xm54_u11.nsg13_hv_pmos[factuo]
print @n.xbgr.xm54_u12.nsg13_hv_pmos[w]
print @n.xbgr.xm54_u12.nsg13_hv_pmos[l]
print @n.xbgr.xm54_u12.nsg13_hv_pmos[delvto]
print @n.xbgr.xm54_u12.nsg13_hv_pmos[factuo]
print @n.xbgr.xm54_u13.nsg13_hv_pmos[w]
print @n.xbgr.xm54_u13.nsg13_hv_pmos[l]
print @n.xbgr.xm54_u13.nsg13_hv_pmos[delvto]
print @n.xbgr.xm54_u13.nsg13_hv_pmos[factuo]
print @n.xbgr.xm54_u14.nsg13_hv_pmos[w]
print @n.xbgr.xm54_u14.nsg13_hv_pmos[l]
print @n.xbgr.xm54_u14.nsg13_hv_pmos[delvto]
print @n.xbgr.xm54_u14.nsg13_hv_pmos[factuo]
print @n.xbgr.xm54_u15.nsg13_hv_pmos[w]
print @n.xbgr.xm54_u15.nsg13_hv_pmos[l]
print @n.xbgr.xm54_u15.nsg13_hv_pmos[delvto]
print @n.xbgr.xm54_u15.nsg13_hv_pmos[factuo]
print @n.xbgr.xm54_u16.nsg13_hv_pmos[w]
print @n.xbgr.xm54_u16.nsg13_hv_pmos[l]
print @n.xbgr.xm54_u16.nsg13_hv_pmos[delvto]
print @n.xbgr.xm54_u16.nsg13_hv_pmos[factuo]
print @n.xbgr.xm54_u17.nsg13_hv_pmos[w]
print @n.xbgr.xm54_u17.nsg13_hv_pmos[l]
print @n.xbgr.xm54_u17.nsg13_hv_pmos[delvto]
print @n.xbgr.xm54_u17.nsg13_hv_pmos[factuo]
print @n.xbgr.xm54_u18.nsg13_hv_pmos[w]
print @n.xbgr.xm54_u18.nsg13_hv_pmos[l]
print @n.xbgr.xm54_u18.nsg13_hv_pmos[delvto]
print @n.xbgr.xm54_u18.nsg13_hv_pmos[factuo]
print @n.xbgr.xm54_u19.nsg13_hv_pmos[w]
print @n.xbgr.xm54_u19.nsg13_hv_pmos[l]
print @n.xbgr.xm54_u19.nsg13_hv_pmos[delvto]
print @n.xbgr.xm54_u19.nsg13_hv_pmos[factuo]
print @n.xbgr.xm54_u20.nsg13_hv_pmos[w]
print @n.xbgr.xm54_u20.nsg13_hv_pmos[l]
print @n.xbgr.xm54_u20.nsg13_hv_pmos[delvto]
print @n.xbgr.xm54_u20.nsg13_hv_pmos[factuo]
print @n.xbgr.xm54_u21.nsg13_hv_pmos[w]
print @n.xbgr.xm54_u21.nsg13_hv_pmos[l]
print @n.xbgr.xm54_u21.nsg13_hv_pmos[delvto]
print @n.xbgr.xm54_u21.nsg13_hv_pmos[factuo]
print @n.xbgr.xm54_u22.nsg13_hv_pmos[w]
print @n.xbgr.xm54_u22.nsg13_hv_pmos[l]
print @n.xbgr.xm54_u22.nsg13_hv_pmos[delvto]
print @n.xbgr.xm54_u22.nsg13_hv_pmos[factuo]
print @n.xbgr.xm54_u23.nsg13_hv_pmos[w]
print @n.xbgr.xm54_u23.nsg13_hv_pmos[l]
print @n.xbgr.xm54_u23.nsg13_hv_pmos[delvto]
print @n.xbgr.xm54_u23.nsg13_hv_pmos[factuo]
print @n.xbgr.xm54_u24.nsg13_hv_pmos[w]
print @n.xbgr.xm54_u24.nsg13_hv_pmos[l]
print @n.xbgr.xm54_u24.nsg13_hv_pmos[delvto]
print @n.xbgr.xm54_u24.nsg13_hv_pmos[factuo]
print @q.xbgr.xq56_u2.qnpn13g2[area]
print @q.xbgr.xq56_u3.qnpn13g2[area]
print @q.xbgr.xq56_u4.qnpn13g2[area]
print @q.xbgr.xq56_u5.qnpn13g2[area]
print @q.xbgr.xq56_u6.qnpn13g2[area]
print @q.xbgr.xq56_u7.qnpn13g2[area]
print @q.xbgr.xq56_u8.qnpn13g2[area]
print @q.xbgr.xq56_u9.qnpn13g2[area]
print @q.xbgr.xq56_u10.qnpn13g2[area]
print @q.xbgr.xq56_u11.qnpn13g2[area]
print @q.xbgr.xq56_u12.qnpn13g2[area]
print @q.xbgr.xq56_u13.qnpn13g2[area]
print @q.xbgr.xq56_u14.qnpn13g2[area]
print @q.xbgr.xq56_u15.qnpn13g2[area]
print @q.xbgr.xq56_u16.qnpn13g2[area]
print @q.xbgr.xq56_u17.qnpn13g2[area]
print @q.xbgr.xq56_u18.qnpn13g2[area]
print @q.xbgr.xq56_u19.qnpn13g2[area]
print @q.xbgr.xq56_u20.qnpn13g2[area]
print @q.xbgr.xq56_u21.qnpn13g2[area]
print @q.xbgr.xq56_u22.qnpn13g2[area]
print @q.xbgr.xq56_u23.qnpn13g2[area]
print @q.xbgr.xq56_u24.qnpn13g2[area]
print @q.xbgr.xq60_u2.qnpn13g2[area]
print @q.xbgr.xq60_u3.qnpn13g2[area]
print @q.xbgr.xq60_u4.qnpn13g2[area]
print @q.xbgr.xq62_u2.qnpn13g2[area]
print @q.xbgr.xq62_u3.qnpn13g2[area]
print @q.xbgr.xq62_u4.qnpn13g2[area]
print @q.xbgr.xq62_u5.qnpn13g2[area]
print @q.xbgr.xq62_u6.qnpn13g2[area]
print @q.xbgr.xq62_u7.qnpn13g2[area]
print @q.xbgr.xq62_u8.qnpn13g2[area]
print @q.xbgr.xq62_u9.qnpn13g2[area]
print @q.xbgr.xq62_u10.qnpn13g2[area]
print @q.xbgr.xq62_u11.qnpn13g2[area]
print @q.xbgr.xq62_u12.qnpn13g2[area]
print @q.xbgr.xq62_u13.qnpn13g2[area]
print @q.xbgr.xq62_u14.qnpn13g2[area]
print @q.xbgr.xq62_u15.qnpn13g2[area]
print @q.xbgr.xq62_u16.qnpn13g2[area]
print @q.xbgr.xq62_u17.qnpn13g2[area]
print @q.xbgr.xq62_u18.qnpn13g2[area]
print @q.xbgr.xq62_u19.qnpn13g2[area]
print @q.xbgr.xq62_u20.qnpn13g2[area]
print @q.xbgr.xq62_u21.qnpn13g2[area]
print @q.xbgr.xq62_u22.qnpn13g2[area]
print @q.xbgr.xq62_u23.qnpn13g2[area]
print @q.xbgr.xq62_u24.qnpn13g2[area]
print @q.xbgr.xq67_u2.qnpn13g2[area]
print @q.xbgr.xq67_u3.qnpn13g2[area]
print @q.xbgr.xq67_u4.qnpn13g2[area]
print @q.xbgr.xq67_u5.qnpn13g2[area]
print @q.xbgr.xq67_u6.qnpn13g2[area]
print @q.xbgr.xq67_u7.qnpn13g2[area]
print @q.xbgr.xq67_u8.qnpn13g2[area]
print @q.xbgr.xq67_u9.qnpn13g2[area]
print @q.xbgr.xq67_u10.qnpn13g2[area]
print @q.xbgr.xq67_u11.qnpn13g2[area]
print @q.xbgr.xq67_u12.qnpn13g2[area]
print @q.xbgr.xq67_u13.qnpn13g2[area]
print @q.xbgr.xq67_u14.qnpn13g2[area]
print @q.xbgr.xq67_u15.qnpn13g2[area]
print @q.xbgr.xq67_u16.qnpn13g2[area]
print @q.xbgr.xq67_u17.qnpn13g2[area]
print @q.xbgr.xq67_u18.qnpn13g2[area]
print @q.xbgr.xq67_u19.qnpn13g2[area]
print @q.xbgr.xq67_u20.qnpn13g2[area]
print @q.xbgr.xq67_u21.qnpn13g2[area]
print @q.xbgr.xq67_u22.qnpn13g2[area]
print @q.xbgr.xq67_u23.qnpn13g2[area]
print @q.xbgr.xq67_u24.qnpn13g2[area]
print @q.xbgr.xq68_u2.qnpn13g2[area]
print @q.xbgr.xq68_u3.qnpn13g2[area]
print @q.xbgr.xq68_u4.qnpn13g2[area]
print @q.xbgr.xq68_u5.qnpn13g2[area]
print @q.xbgr.xq68_u6.qnpn13g2[area]
print @q.xbgr.xq68_u7.qnpn13g2[area]
print @q.xbgr.xq68_u8.qnpn13g2[area]
print @q.xbgr.xq68_u9.qnpn13g2[area]
print @q.xbgr.xq68_u10.qnpn13g2[area]
print @q.xbgr.xq68_u11.qnpn13g2[area]
print @q.xbgr.xq68_u12.qnpn13g2[area]
print @q.xbgr.xq68_u13.qnpn13g2[area]
print @q.xbgr.xq68_u14.qnpn13g2[area]
print @q.xbgr.xq68_u15.qnpn13g2[area]
print @q.xbgr.xq68_u16.qnpn13g2[area]
print @q.xbgr.xq68_u17.qnpn13g2[area]
print @q.xbgr.xq68_u18.qnpn13g2[area]
print @q.xbgr.xq68_u19.qnpn13g2[area]
print @q.xbgr.xq68_u20.qnpn13g2[area]
print @q.xbgr.xq68_u21.qnpn13g2[area]
print @q.xbgr.xq68_u22.qnpn13g2[area]
print @q.xbgr.xq68_u23.qnpn13g2[area]
print @q.xbgr.xq68_u24.qnpn13g2[area]
print @q.xbgr.xq69_u2.qnpn13g2[area]
print @q.xbgr.xq69_u3.qnpn13g2[area]
print @q.xbgr.xq69_u4.qnpn13g2[area]
print @q.xbgr.xq69_u5.qnpn13g2[area]
print @q.xbgr.xq69_u6.qnpn13g2[area]
print @q.xbgr.xq69_u7.qnpn13g2[area]
print @q.xbgr.xq69_u8.qnpn13g2[area]
print @q.xbgr.xq69_u9.qnpn13g2[area]
print @q.xbgr.xq69_u10.qnpn13g2[area]
print @q.xbgr.xq69_u11.qnpn13g2[area]
print @q.xbgr.xq69_u12.qnpn13g2[area]
print @q.xbgr.xq69_u13.qnpn13g2[area]
print @q.xbgr.xq69_u14.qnpn13g2[area]
print @q.xbgr.xq69_u15.qnpn13g2[area]
print @q.xbgr.xq69_u16.qnpn13g2[area]
print @q.xbgr.xq69_u17.qnpn13g2[area]
print @q.xbgr.xq69_u18.qnpn13g2[area]
print @q.xbgr.xq69_u19.qnpn13g2[area]
print @q.xbgr.xq69_u20.qnpn13g2[area]
print @q.xbgr.xq69_u21.qnpn13g2[area]
print @q.xbgr.xq69_u22.qnpn13g2[area]
print @q.xbgr.xq69_u23.qnpn13g2[area]
print @q.xbgr.xq69_u24.qnpn13g2[area]
print @q.xbgr.xq70_u2.qnpn13g2[area]
print @q.xbgr.xq70_u3.qnpn13g2[area]
print @q.xbgr.xq70_u4.qnpn13g2[area]
print @q.xbgr.xq70_u5.qnpn13g2[area]
print @q.xbgr.xq70_u6.qnpn13g2[area]
print @q.xbgr.xq70_u7.qnpn13g2[area]
print @q.xbgr.xq70_u8.qnpn13g2[area]
print @q.xbgr.xq70_u9.qnpn13g2[area]
print @q.xbgr.xq70_u10.qnpn13g2[area]
print @q.xbgr.xq70_u11.qnpn13g2[area]
print @q.xbgr.xq70_u12.qnpn13g2[area]
print @q.xbgr.xq70_u13.qnpn13g2[area]
print @q.xbgr.xq70_u14.qnpn13g2[area]
print @q.xbgr.xq70_u15.qnpn13g2[area]
print @q.xbgr.xq70_u16.qnpn13g2[area]
print @q.xbgr.xq70_u17.qnpn13g2[area]
print @q.xbgr.xq70_u18.qnpn13g2[area]
print @q.xbgr.xq70_u19.qnpn13g2[area]
print @q.xbgr.xq70_u20.qnpn13g2[area]
print @q.xbgr.xq70_u21.qnpn13g2[area]
print @q.xbgr.xq70_u22.qnpn13g2[area]
print @q.xbgr.xq70_u23.qnpn13g2[area]
print @q.xbgr.xq70_u24.qnpn13g2[area]
print @q.xbgr.xq71_u2.qnpn13g2[area]
print @q.xbgr.xq71_u3.qnpn13g2[area]
print @q.xbgr.xq71_u4.qnpn13g2[area]
print @q.xbgr.xq71_u5.qnpn13g2[area]
print @q.xbgr.xq71_u6.qnpn13g2[area]
print @q.xbgr.xq71_u7.qnpn13g2[area]
print @q.xbgr.xq71_u8.qnpn13g2[area]
print @q.xbgr.xq71_u9.qnpn13g2[area]
print @q.xbgr.xq71_u10.qnpn13g2[area]
print @q.xbgr.xq71_u11.qnpn13g2[area]
print @q.xbgr.xq71_u12.qnpn13g2[area]
print @q.xbgr.xq71_u13.qnpn13g2[area]
print @q.xbgr.xq71_u14.qnpn13g2[area]
print @q.xbgr.xq71_u15.qnpn13g2[area]
print @q.xbgr.xq71_u16.qnpn13g2[area]
print @q.xbgr.xq71_u17.qnpn13g2[area]
print @q.xbgr.xq71_u18.qnpn13g2[area]
print @q.xbgr.xq71_u19.qnpn13g2[area]
print @q.xbgr.xq71_u20.qnpn13g2[area]
print @q.xbgr.xq71_u21.qnpn13g2[area]
print @q.xbgr.xq71_u22.qnpn13g2[area]
print @q.xbgr.xq71_u23.qnpn13g2[area]
print @q.xbgr.xq71_u24.qnpn13g2[area]
print @q.xbgr.xq72_u2.qnpn13g2[area]
print @q.xbgr.xq72_u3.qnpn13g2[area]
print @q.xbgr.xq72_u4.qnpn13g2[area]
print @q.xbgr.xq72_u5.qnpn13g2[area]
print @q.xbgr.xq72_u6.qnpn13g2[area]
print @q.xbgr.xq72_u7.qnpn13g2[area]
print @q.xbgr.xq72_u8.qnpn13g2[area]
print @q.xbgr.xq72_u9.qnpn13g2[area]
print @q.xbgr.xq72_u10.qnpn13g2[area]
print @q.xbgr.xq72_u11.qnpn13g2[area]
print @q.xbgr.xq72_u12.qnpn13g2[area]
print @q.xbgr.xq72_u13.qnpn13g2[area]
print @q.xbgr.xq72_u14.qnpn13g2[area]
print @q.xbgr.xq72_u15.qnpn13g2[area]
print @q.xbgr.xq72_u16.qnpn13g2[area]
print @q.xbgr.xq72_u17.qnpn13g2[area]
print @q.xbgr.xq72_u18.qnpn13g2[area]
print @q.xbgr.xq72_u19.qnpn13g2[area]
print @q.xbgr.xq72_u20.qnpn13g2[area]
print @q.xbgr.xq72_u21.qnpn13g2[area]
print @q.xbgr.xq72_u22.qnpn13g2[area]
print @q.xbgr.xq72_u23.qnpn13g2[area]
print @q.xbgr.xq72_u24.qnpn13g2[area]
print @q.xbgr.xq73_u2.qnpn13g2[area]
print @q.xbgr.xq73_u3.qnpn13g2[area]
print @q.xbgr.xq73_u4.qnpn13g2[area]
print @q.xbgr.xq73_u5.qnpn13g2[area]
print @q.xbgr.xq73_u6.qnpn13g2[area]
print @q.xbgr.xq73_u7.qnpn13g2[area]
print @q.xbgr.xq73_u8.qnpn13g2[area]
print @q.xbgr.xq73_u9.qnpn13g2[area]
print @q.xbgr.xq73_u10.qnpn13g2[area]
print @q.xbgr.xq73_u11.qnpn13g2[area]
print @q.xbgr.xq73_u12.qnpn13g2[area]
print @q.xbgr.xq73_u13.qnpn13g2[area]
print @q.xbgr.xq73_u14.qnpn13g2[area]
print @q.xbgr.xq73_u15.qnpn13g2[area]
print @q.xbgr.xq73_u16.qnpn13g2[area]
print @q.xbgr.xq73_u17.qnpn13g2[area]
print @q.xbgr.xq73_u18.qnpn13g2[area]
print @q.xbgr.xq73_u19.qnpn13g2[area]
print @q.xbgr.xq73_u20.qnpn13g2[area]
print @q.xbgr.xq73_u21.qnpn13g2[area]
print @q.xbgr.xq73_u22.qnpn13g2[area]
print @q.xbgr.xq73_u23.qnpn13g2[area]
print @q.xbgr.xq73_u24.qnpn13g2[area]
print @q.xbgr.xq74_u2.qnpn13g2[area]
print @q.xbgr.xq74_u3.qnpn13g2[area]
print @q.xbgr.xq74_u4.qnpn13g2[area]
print @q.xbgr.xq74_u5.qnpn13g2[area]
print @q.xbgr.xq74_u6.qnpn13g2[area]
print @q.xbgr.xq74_u7.qnpn13g2[area]
print @q.xbgr.xq74_u8.qnpn13g2[area]
print @q.xbgr.xq74_u9.qnpn13g2[area]
print @q.xbgr.xq74_u10.qnpn13g2[area]
print @q.xbgr.xq74_u11.qnpn13g2[area]
print @q.xbgr.xq74_u12.qnpn13g2[area]
print @q.xbgr.xq74_u13.qnpn13g2[area]
print @q.xbgr.xq74_u14.qnpn13g2[area]
print @q.xbgr.xq74_u15.qnpn13g2[area]
print @q.xbgr.xq74_u16.qnpn13g2[area]
print @q.xbgr.xq74_u17.qnpn13g2[area]
print @q.xbgr.xq74_u18.qnpn13g2[area]
print @q.xbgr.xq74_u19.qnpn13g2[area]
print @q.xbgr.xq74_u20.qnpn13g2[area]
print @q.xbgr.xq74_u21.qnpn13g2[area]
print @q.xbgr.xq74_u22.qnpn13g2[area]
print @q.xbgr.xq74_u23.qnpn13g2[area]
print @q.xbgr.xq74_u24.qnpn13g2[area]
print @q.xbgr.xq75_u2.qnpn13g2[area]
print @q.xbgr.xq75_u3.qnpn13g2[area]
print @q.xbgr.xq75_u4.qnpn13g2[area]
print @q.xbgr.xq75_u5.qnpn13g2[area]
print @q.xbgr.xq75_u6.qnpn13g2[area]
print @q.xbgr.xq75_u7.qnpn13g2[area]
print @q.xbgr.xq75_u8.qnpn13g2[area]
print @q.xbgr.xq75_u9.qnpn13g2[area]
print @q.xbgr.xq75_u10.qnpn13g2[area]
print @q.xbgr.xq75_u11.qnpn13g2[area]
print @q.xbgr.xq75_u12.qnpn13g2[area]
print @q.xbgr.xq75_u13.qnpn13g2[area]
print @q.xbgr.xq75_u14.qnpn13g2[area]
print @q.xbgr.xq75_u15.qnpn13g2[area]
print @q.xbgr.xq75_u16.qnpn13g2[area]
print @q.xbgr.xq75_u17.qnpn13g2[area]
print @q.xbgr.xq75_u18.qnpn13g2[area]
print @q.xbgr.xq75_u19.qnpn13g2[area]
print @q.xbgr.xq75_u20.qnpn13g2[area]
print @q.xbgr.xq75_u21.qnpn13g2[area]
print @q.xbgr.xq75_u22.qnpn13g2[area]
print @q.xbgr.xq75_u23.qnpn13g2[area]
print @q.xbgr.xq75_u24.qnpn13g2[area]
print @q.xbgr.xq76_u2.qnpn13g2[area]
print @q.xbgr.xq76_u3.qnpn13g2[area]
print @q.xbgr.xq76_u4.qnpn13g2[area]
print @q.xbgr.xq76_u5.qnpn13g2[area]
print @q.xbgr.xq76_u6.qnpn13g2[area]
print @q.xbgr.xq76_u7.qnpn13g2[area]
print @q.xbgr.xq76_u8.qnpn13g2[area]
print @q.xbgr.xq76_u9.qnpn13g2[area]
print @q.xbgr.xq76_u10.qnpn13g2[area]
print @q.xbgr.xq76_u11.qnpn13g2[area]
print @q.xbgr.xq76_u12.qnpn13g2[area]
print @q.xbgr.xq76_u13.qnpn13g2[area]
print @q.xbgr.xq76_u14.qnpn13g2[area]
print @q.xbgr.xq76_u15.qnpn13g2[area]
print @q.xbgr.xq76_u16.qnpn13g2[area]
print @q.xbgr.xq76_u17.qnpn13g2[area]
print @q.xbgr.xq76_u18.qnpn13g2[area]
print @q.xbgr.xq76_u19.qnpn13g2[area]
print @q.xbgr.xq76_u20.qnpn13g2[area]
print @q.xbgr.xq76_u21.qnpn13g2[area]
print @q.xbgr.xq76_u22.qnpn13g2[area]
print @q.xbgr.xq76_u23.qnpn13g2[area]
print @q.xbgr.xq76_u24.qnpn13g2[area]
print @n.xbgr.xr77_u2.nr1[nsmm_rsh]
print @n.xbgr.xr77_u2.nr1[nsmm_w]
print @n.xbgr.xr77_u2.nr1[nsmm_l]
print @n.xbgr.xr77_u3.nr1[nsmm_rsh]
print @n.xbgr.xr77_u3.nr1[nsmm_w]
print @n.xbgr.xr77_u3.nr1[nsmm_l]
print @n.xbgr.xr77_u4.nr1[nsmm_rsh]
print @n.xbgr.xr77_u4.nr1[nsmm_w]
print @n.xbgr.xr77_u4.nr1[nsmm_l]
print @n.xbgr.xr77_u5.nr1[nsmm_rsh]
print @n.xbgr.xr77_u5.nr1[nsmm_w]
print @n.xbgr.xr77_u5.nr1[nsmm_l]
print @n.xbgr.xr77_u6.nr1[nsmm_rsh]
print @n.xbgr.xr77_u6.nr1[nsmm_w]
print @n.xbgr.xr77_u6.nr1[nsmm_l]
print @n.xbgr.xr77_u7.nr1[nsmm_rsh]
print @n.xbgr.xr77_u7.nr1[nsmm_w]
print @n.xbgr.xr77_u7.nr1[nsmm_l]
print @n.xbgr.xr77_u8.nr1[nsmm_rsh]
print @n.xbgr.xr77_u8.nr1[nsmm_w]
print @n.xbgr.xr77_u8.nr1[nsmm_l]
print @n.xbgr.xr77_u9.nr1[nsmm_rsh]
print @n.xbgr.xr77_u9.nr1[nsmm_w]
print @n.xbgr.xr77_u9.nr1[nsmm_l]
print @n.xbgr.xr77_u10.nr1[nsmm_rsh]
print @n.xbgr.xr77_u10.nr1[nsmm_w]
print @n.xbgr.xr77_u10.nr1[nsmm_l]
print @n.xbgr.xr77_u11.nr1[nsmm_rsh]
print @n.xbgr.xr77_u11.nr1[nsmm_w]
print @n.xbgr.xr77_u11.nr1[nsmm_l]
print @n.xbgr.xr77_u12.nr1[nsmm_rsh]
print @n.xbgr.xr77_u12.nr1[nsmm_w]
print @n.xbgr.xr77_u12.nr1[nsmm_l]
print @n.xbgr.xr77_u13.nr1[nsmm_rsh]
print @n.xbgr.xr77_u13.nr1[nsmm_w]
print @n.xbgr.xr77_u13.nr1[nsmm_l]
print @n.xbgr.xr77_u14.nr1[nsmm_rsh]
print @n.xbgr.xr77_u14.nr1[nsmm_w]
print @n.xbgr.xr77_u14.nr1[nsmm_l]
print @n.xbgr.xr77_u15.nr1[nsmm_rsh]
print @n.xbgr.xr77_u15.nr1[nsmm_w]
print @n.xbgr.xr77_u15.nr1[nsmm_l]
print @n.xbgr.xr77_u16.nr1[nsmm_rsh]
print @n.xbgr.xr77_u16.nr1[nsmm_w]
print @n.xbgr.xr77_u16.nr1[nsmm_l]
print @n.xbgr.xr77_u17.nr1[nsmm_rsh]
print @n.xbgr.xr77_u17.nr1[nsmm_w]
print @n.xbgr.xr77_u17.nr1[nsmm_l]
print @n.xbgr.xr77_u18.nr1[nsmm_rsh]
print @n.xbgr.xr77_u18.nr1[nsmm_w]
print @n.xbgr.xr77_u18.nr1[nsmm_l]
print @n.xbgr.xr77_u19.nr1[nsmm_rsh]
print @n.xbgr.xr77_u19.nr1[nsmm_w]
print @n.xbgr.xr77_u19.nr1[nsmm_l]
print @n.xbgr.xr77_u20.nr1[nsmm_rsh]
print @n.xbgr.xr77_u20.nr1[nsmm_w]
print @n.xbgr.xr77_u20.nr1[nsmm_l]
print @n.xbgr.xr77_u21.nr1[nsmm_rsh]
print @n.xbgr.xr77_u21.nr1[nsmm_w]
print @n.xbgr.xr77_u21.nr1[nsmm_l]
print @n.xbgr.xr77_u22.nr1[nsmm_rsh]
print @n.xbgr.xr77_u22.nr1[nsmm_w]
print @n.xbgr.xr77_u22.nr1[nsmm_l]
print @n.xbgr.xr77_u23.nr1[nsmm_rsh]
print @n.xbgr.xr77_u23.nr1[nsmm_w]
print @n.xbgr.xr77_u23.nr1[nsmm_l]
print @n.xbgr.xr77_u24.nr1[nsmm_rsh]
print @n.xbgr.xr77_u24.nr1[nsmm_w]
print @n.xbgr.xr77_u24.nr1[nsmm_l]
print @n.xbgr.xr78_u2.nr1[nsmm_rsh]
print @n.xbgr.xr78_u2.nr1[nsmm_w]
print @n.xbgr.xr78_u2.nr1[nsmm_l]
print @n.xbgr.xr78_u3.nr1[nsmm_rsh]
print @n.xbgr.xr78_u3.nr1[nsmm_w]
print @n.xbgr.xr78_u3.nr1[nsmm_l]
print @n.xbgr.xr78_u4.nr1[nsmm_rsh]
print @n.xbgr.xr78_u4.nr1[nsmm_w]
print @n.xbgr.xr78_u4.nr1[nsmm_l]
print @n.xbgr.xr78_u5.nr1[nsmm_rsh]
print @n.xbgr.xr78_u5.nr1[nsmm_w]
print @n.xbgr.xr78_u5.nr1[nsmm_l]
print @n.xbgr.xr78_u6.nr1[nsmm_rsh]
print @n.xbgr.xr78_u6.nr1[nsmm_w]
print @n.xbgr.xr78_u6.nr1[nsmm_l]
print @n.xbgr.xr78_u7.nr1[nsmm_rsh]
print @n.xbgr.xr78_u7.nr1[nsmm_w]
print @n.xbgr.xr78_u7.nr1[nsmm_l]
print @n.xbgr.xr78_u8.nr1[nsmm_rsh]
print @n.xbgr.xr78_u8.nr1[nsmm_w]
print @n.xbgr.xr78_u8.nr1[nsmm_l]
print @n.xbgr.xr78_u9.nr1[nsmm_rsh]
print @n.xbgr.xr78_u9.nr1[nsmm_w]
print @n.xbgr.xr78_u9.nr1[nsmm_l]
print @n.xbgr.xr78_u10.nr1[nsmm_rsh]
print @n.xbgr.xr78_u10.nr1[nsmm_w]
print @n.xbgr.xr78_u10.nr1[nsmm_l]
print @n.xbgr.xr78_u11.nr1[nsmm_rsh]
print @n.xbgr.xr78_u11.nr1[nsmm_w]
print @n.xbgr.xr78_u11.nr1[nsmm_l]
print @n.xbgr.xr78_u12.nr1[nsmm_rsh]
print @n.xbgr.xr78_u12.nr1[nsmm_w]
print @n.xbgr.xr78_u12.nr1[nsmm_l]
print @n.xbgr.xr78_u13.nr1[nsmm_rsh]
print @n.xbgr.xr78_u13.nr1[nsmm_w]
print @n.xbgr.xr78_u13.nr1[nsmm_l]
print @n.xbgr.xr78_u14.nr1[nsmm_rsh]
print @n.xbgr.xr78_u14.nr1[nsmm_w]
print @n.xbgr.xr78_u14.nr1[nsmm_l]
print @n.xbgr.xr78_u15.nr1[nsmm_rsh]
print @n.xbgr.xr78_u15.nr1[nsmm_w]
print @n.xbgr.xr78_u15.nr1[nsmm_l]
print @n.xbgr.xr78_u16.nr1[nsmm_rsh]
print @n.xbgr.xr78_u16.nr1[nsmm_w]
print @n.xbgr.xr78_u16.nr1[nsmm_l]
print @n.xbgr.xr78_u17.nr1[nsmm_rsh]
print @n.xbgr.xr78_u17.nr1[nsmm_w]
print @n.xbgr.xr78_u17.nr1[nsmm_l]
print @n.xbgr.xr78_u18.nr1[nsmm_rsh]
print @n.xbgr.xr78_u18.nr1[nsmm_w]
print @n.xbgr.xr78_u18.nr1[nsmm_l]
print @n.xbgr.xr78_u19.nr1[nsmm_rsh]
print @n.xbgr.xr78_u19.nr1[nsmm_w]
print @n.xbgr.xr78_u19.nr1[nsmm_l]
print @n.xbgr.xr78_u20.nr1[nsmm_rsh]
print @n.xbgr.xr78_u20.nr1[nsmm_w]
print @n.xbgr.xr78_u20.nr1[nsmm_l]
print @n.xbgr.xr78_u21.nr1[nsmm_rsh]
print @n.xbgr.xr78_u21.nr1[nsmm_w]
print @n.xbgr.xr78_u21.nr1[nsmm_l]
print @n.xbgr.xr78_u22.nr1[nsmm_rsh]
print @n.xbgr.xr78_u22.nr1[nsmm_w]
print @n.xbgr.xr78_u22.nr1[nsmm_l]
print @n.xbgr.xr78_u23.nr1[nsmm_rsh]
print @n.xbgr.xr78_u23.nr1[nsmm_w]
print @n.xbgr.xr78_u23.nr1[nsmm_l]
print @n.xbgr.xr78_u24.nr1[nsmm_rsh]
print @n.xbgr.xr78_u24.nr1[nsmm_w]
print @n.xbgr.xr78_u24.nr1[nsmm_l]
print @n.xbgr.xr79_u2.nr1[nsmm_rsh]
print @n.xbgr.xr79_u2.nr1[nsmm_w]
print @n.xbgr.xr79_u2.nr1[nsmm_l]
print @n.xbgr.xr79_u3.nr1[nsmm_rsh]
print @n.xbgr.xr79_u3.nr1[nsmm_w]
print @n.xbgr.xr79_u3.nr1[nsmm_l]
print @n.xbgr.xr79_u4.nr1[nsmm_rsh]
print @n.xbgr.xr79_u4.nr1[nsmm_w]
print @n.xbgr.xr79_u4.nr1[nsmm_l]
print @n.xbgr.xr79_u5.nr1[nsmm_rsh]
print @n.xbgr.xr79_u5.nr1[nsmm_w]
print @n.xbgr.xr79_u5.nr1[nsmm_l]
print @n.xbgr.xr79_u6.nr1[nsmm_rsh]
print @n.xbgr.xr79_u6.nr1[nsmm_w]
print @n.xbgr.xr79_u6.nr1[nsmm_l]
print @n.xbgr.xr79_u7.nr1[nsmm_rsh]
print @n.xbgr.xr79_u7.nr1[nsmm_w]
print @n.xbgr.xr79_u7.nr1[nsmm_l]
print @n.xbgr.xr79_u8.nr1[nsmm_rsh]
print @n.xbgr.xr79_u8.nr1[nsmm_w]
print @n.xbgr.xr79_u8.nr1[nsmm_l]
print @n.xbgr.xr79_u9.nr1[nsmm_rsh]
print @n.xbgr.xr79_u9.nr1[nsmm_w]
print @n.xbgr.xr79_u9.nr1[nsmm_l]
print @n.xbgr.xr79_u10.nr1[nsmm_rsh]
print @n.xbgr.xr79_u10.nr1[nsmm_w]
print @n.xbgr.xr79_u10.nr1[nsmm_l]
print @n.xbgr.xr79_u11.nr1[nsmm_rsh]
print @n.xbgr.xr79_u11.nr1[nsmm_w]
print @n.xbgr.xr79_u11.nr1[nsmm_l]
print @n.xbgr.xr79_u12.nr1[nsmm_rsh]
print @n.xbgr.xr79_u12.nr1[nsmm_w]
print @n.xbgr.xr79_u12.nr1[nsmm_l]
print @n.xbgr.xr79_u13.nr1[nsmm_rsh]
print @n.xbgr.xr79_u13.nr1[nsmm_w]
print @n.xbgr.xr79_u13.nr1[nsmm_l]
print @n.xbgr.xr79_u14.nr1[nsmm_rsh]
print @n.xbgr.xr79_u14.nr1[nsmm_w]
print @n.xbgr.xr79_u14.nr1[nsmm_l]
print @n.xbgr.xr79_u15.nr1[nsmm_rsh]
print @n.xbgr.xr79_u15.nr1[nsmm_w]
print @n.xbgr.xr79_u15.nr1[nsmm_l]
print @n.xbgr.xr79_u16.nr1[nsmm_rsh]
print @n.xbgr.xr79_u16.nr1[nsmm_w]
print @n.xbgr.xr79_u16.nr1[nsmm_l]
print @n.xbgr.xr79_u17.nr1[nsmm_rsh]
print @n.xbgr.xr79_u17.nr1[nsmm_w]
print @n.xbgr.xr79_u17.nr1[nsmm_l]
print @n.xbgr.xr79_u18.nr1[nsmm_rsh]
print @n.xbgr.xr79_u18.nr1[nsmm_w]
print @n.xbgr.xr79_u18.nr1[nsmm_l]
print @n.xbgr.xr79_u19.nr1[nsmm_rsh]
print @n.xbgr.xr79_u19.nr1[nsmm_w]
print @n.xbgr.xr79_u19.nr1[nsmm_l]
print @n.xbgr.xr79_u20.nr1[nsmm_rsh]
print @n.xbgr.xr79_u20.nr1[nsmm_w]
print @n.xbgr.xr79_u20.nr1[nsmm_l]
print @n.xbgr.xr79_u21.nr1[nsmm_rsh]
print @n.xbgr.xr79_u21.nr1[nsmm_w]
print @n.xbgr.xr79_u21.nr1[nsmm_l]
print @n.xbgr.xr79_u22.nr1[nsmm_rsh]
print @n.xbgr.xr79_u22.nr1[nsmm_w]
print @n.xbgr.xr79_u22.nr1[nsmm_l]
print @n.xbgr.xr79_u23.nr1[nsmm_rsh]
print @n.xbgr.xr79_u23.nr1[nsmm_w]
print @n.xbgr.xr79_u23.nr1[nsmm_l]
print @n.xbgr.xr79_u24.nr1[nsmm_rsh]
print @n.xbgr.xr79_u24.nr1[nsmm_w]
print @n.xbgr.xr79_u24.nr1[nsmm_l]
print @n.xbgr.xr80_u2.nr1[nsmm_rsh]
print @n.xbgr.xr80_u2.nr1[nsmm_w]
print @n.xbgr.xr80_u2.nr1[nsmm_l]
print @n.xbgr.xr80_u3.nr1[nsmm_rsh]
print @n.xbgr.xr80_u3.nr1[nsmm_w]
print @n.xbgr.xr80_u3.nr1[nsmm_l]
print @n.xbgr.xr80_u4.nr1[nsmm_rsh]
print @n.xbgr.xr80_u4.nr1[nsmm_w]
print @n.xbgr.xr80_u4.nr1[nsmm_l]
print @n.xbgr.xr80_u5.nr1[nsmm_rsh]
print @n.xbgr.xr80_u5.nr1[nsmm_w]
print @n.xbgr.xr80_u5.nr1[nsmm_l]
print @n.xbgr.xr80_u6.nr1[nsmm_rsh]
print @n.xbgr.xr80_u6.nr1[nsmm_w]
print @n.xbgr.xr80_u6.nr1[nsmm_l]
print @n.xbgr.xr80_u7.nr1[nsmm_rsh]
print @n.xbgr.xr80_u7.nr1[nsmm_w]
print @n.xbgr.xr80_u7.nr1[nsmm_l]
print @n.xbgr.xr80_u8.nr1[nsmm_rsh]
print @n.xbgr.xr80_u8.nr1[nsmm_w]
print @n.xbgr.xr80_u8.nr1[nsmm_l]
print @n.xbgr.xr80_u9.nr1[nsmm_rsh]
print @n.xbgr.xr80_u9.nr1[nsmm_w]
print @n.xbgr.xr80_u9.nr1[nsmm_l]
print @n.xbgr.xr80_u10.nr1[nsmm_rsh]
print @n.xbgr.xr80_u10.nr1[nsmm_w]
print @n.xbgr.xr80_u10.nr1[nsmm_l]
print @n.xbgr.xr80_u11.nr1[nsmm_rsh]
print @n.xbgr.xr80_u11.nr1[nsmm_w]
print @n.xbgr.xr80_u11.nr1[nsmm_l]
print @n.xbgr.xr80_u12.nr1[nsmm_rsh]
print @n.xbgr.xr80_u12.nr1[nsmm_w]
print @n.xbgr.xr80_u12.nr1[nsmm_l]
print @n.xbgr.xr80_u13.nr1[nsmm_rsh]
print @n.xbgr.xr80_u13.nr1[nsmm_w]
print @n.xbgr.xr80_u13.nr1[nsmm_l]
print @n.xbgr.xr80_u14.nr1[nsmm_rsh]
print @n.xbgr.xr80_u14.nr1[nsmm_w]
print @n.xbgr.xr80_u14.nr1[nsmm_l]
print @n.xbgr.xr80_u15.nr1[nsmm_rsh]
print @n.xbgr.xr80_u15.nr1[nsmm_w]
print @n.xbgr.xr80_u15.nr1[nsmm_l]
print @n.xbgr.xr80_u16.nr1[nsmm_rsh]
print @n.xbgr.xr80_u16.nr1[nsmm_w]
print @n.xbgr.xr80_u16.nr1[nsmm_l]
print @n.xbgr.xr80_u17.nr1[nsmm_rsh]
print @n.xbgr.xr80_u17.nr1[nsmm_w]
print @n.xbgr.xr80_u17.nr1[nsmm_l]
print @n.xbgr.xr80_u18.nr1[nsmm_rsh]
print @n.xbgr.xr80_u18.nr1[nsmm_w]
print @n.xbgr.xr80_u18.nr1[nsmm_l]
print @n.xbgr.xr80_u19.nr1[nsmm_rsh]
print @n.xbgr.xr80_u19.nr1[nsmm_w]
print @n.xbgr.xr80_u19.nr1[nsmm_l]
print @n.xbgr.xr80_u20.nr1[nsmm_rsh]
print @n.xbgr.xr80_u20.nr1[nsmm_w]
print @n.xbgr.xr80_u20.nr1[nsmm_l]
print @n.xbgr.xr80_u21.nr1[nsmm_rsh]
print @n.xbgr.xr80_u21.nr1[nsmm_w]
print @n.xbgr.xr80_u21.nr1[nsmm_l]
print @n.xbgr.xr80_u22.nr1[nsmm_rsh]
print @n.xbgr.xr80_u22.nr1[nsmm_w]
print @n.xbgr.xr80_u22.nr1[nsmm_l]
print @n.xbgr.xr80_u23.nr1[nsmm_rsh]
print @n.xbgr.xr80_u23.nr1[nsmm_w]
print @n.xbgr.xr80_u23.nr1[nsmm_l]
print @n.xbgr.xr80_u24.nr1[nsmm_rsh]
print @n.xbgr.xr80_u24.nr1[nsmm_w]
print @n.xbgr.xr80_u24.nr1[nsmm_l]
print @n.xbgr.xr81_u2.nr1[nsmm_rsh]
print @n.xbgr.xr81_u2.nr1[nsmm_w]
print @n.xbgr.xr81_u2.nr1[nsmm_l]
print @n.xbgr.xr81_u3.nr1[nsmm_rsh]
print @n.xbgr.xr81_u3.nr1[nsmm_w]
print @n.xbgr.xr81_u3.nr1[nsmm_l]
print @n.xbgr.xr81_u4.nr1[nsmm_rsh]
print @n.xbgr.xr81_u4.nr1[nsmm_w]
print @n.xbgr.xr81_u4.nr1[nsmm_l]
print @n.xbgr.xr81_u5.nr1[nsmm_rsh]
print @n.xbgr.xr81_u5.nr1[nsmm_w]
print @n.xbgr.xr81_u5.nr1[nsmm_l]
print @n.xbgr.xr81_u6.nr1[nsmm_rsh]
print @n.xbgr.xr81_u6.nr1[nsmm_w]
print @n.xbgr.xr81_u6.nr1[nsmm_l]
print @n.xbgr.xr81_u7.nr1[nsmm_rsh]
print @n.xbgr.xr81_u7.nr1[nsmm_w]
print @n.xbgr.xr81_u7.nr1[nsmm_l]
print @n.xbgr.xr81_u8.nr1[nsmm_rsh]
print @n.xbgr.xr81_u8.nr1[nsmm_w]
print @n.xbgr.xr81_u8.nr1[nsmm_l]
print @n.xbgr.xr81_u9.nr1[nsmm_rsh]
print @n.xbgr.xr81_u9.nr1[nsmm_w]
print @n.xbgr.xr81_u9.nr1[nsmm_l]
print @n.xbgr.xr81_u10.nr1[nsmm_rsh]
print @n.xbgr.xr81_u10.nr1[nsmm_w]
print @n.xbgr.xr81_u10.nr1[nsmm_l]
print @n.xbgr.xr81_u11.nr1[nsmm_rsh]
print @n.xbgr.xr81_u11.nr1[nsmm_w]
print @n.xbgr.xr81_u11.nr1[nsmm_l]
print @n.xbgr.xr81_u12.nr1[nsmm_rsh]
print @n.xbgr.xr81_u12.nr1[nsmm_w]
print @n.xbgr.xr81_u12.nr1[nsmm_l]
print @n.xbgr.xr81_u13.nr1[nsmm_rsh]
print @n.xbgr.xr81_u13.nr1[nsmm_w]
print @n.xbgr.xr81_u13.nr1[nsmm_l]
print @n.xbgr.xr81_u14.nr1[nsmm_rsh]
print @n.xbgr.xr81_u14.nr1[nsmm_w]
print @n.xbgr.xr81_u14.nr1[nsmm_l]
print @n.xbgr.xr81_u15.nr1[nsmm_rsh]
print @n.xbgr.xr81_u15.nr1[nsmm_w]
print @n.xbgr.xr81_u15.nr1[nsmm_l]
print @n.xbgr.xr81_u16.nr1[nsmm_rsh]
print @n.xbgr.xr81_u16.nr1[nsmm_w]
print @n.xbgr.xr81_u16.nr1[nsmm_l]
print @n.xbgr.xr81_u17.nr1[nsmm_rsh]
print @n.xbgr.xr81_u17.nr1[nsmm_w]
print @n.xbgr.xr81_u17.nr1[nsmm_l]
print @n.xbgr.xr81_u18.nr1[nsmm_rsh]
print @n.xbgr.xr81_u18.nr1[nsmm_w]
print @n.xbgr.xr81_u18.nr1[nsmm_l]
print @n.xbgr.xr81_u19.nr1[nsmm_rsh]
print @n.xbgr.xr81_u19.nr1[nsmm_w]
print @n.xbgr.xr81_u19.nr1[nsmm_l]
print @n.xbgr.xr81_u20.nr1[nsmm_rsh]
print @n.xbgr.xr81_u20.nr1[nsmm_w]
print @n.xbgr.xr81_u20.nr1[nsmm_l]
print @n.xbgr.xr81_u21.nr1[nsmm_rsh]
print @n.xbgr.xr81_u21.nr1[nsmm_w]
print @n.xbgr.xr81_u21.nr1[nsmm_l]
print @n.xbgr.xr81_u22.nr1[nsmm_rsh]
print @n.xbgr.xr81_u22.nr1[nsmm_w]
print @n.xbgr.xr81_u22.nr1[nsmm_l]
print @n.xbgr.xr81_u23.nr1[nsmm_rsh]
print @n.xbgr.xr81_u23.nr1[nsmm_w]
print @n.xbgr.xr81_u23.nr1[nsmm_l]
print @n.xbgr.xr81_u24.nr1[nsmm_rsh]
print @n.xbgr.xr81_u24.nr1[nsmm_w]
print @n.xbgr.xr81_u24.nr1[nsmm_l]
print @n.xbgr.xr82_u2.nr1[nsmm_rsh]
print @n.xbgr.xr82_u2.nr1[nsmm_w]
print @n.xbgr.xr82_u2.nr1[nsmm_l]
print @n.xbgr.xr82_u3.nr1[nsmm_rsh]
print @n.xbgr.xr82_u3.nr1[nsmm_w]
print @n.xbgr.xr82_u3.nr1[nsmm_l]
print @n.xbgr.xr82_u4.nr1[nsmm_rsh]
print @n.xbgr.xr82_u4.nr1[nsmm_w]
print @n.xbgr.xr82_u4.nr1[nsmm_l]
print @n.xbgr.xr82_u5.nr1[nsmm_rsh]
print @n.xbgr.xr82_u5.nr1[nsmm_w]
print @n.xbgr.xr82_u5.nr1[nsmm_l]
print @n.xbgr.xr82_u6.nr1[nsmm_rsh]
print @n.xbgr.xr82_u6.nr1[nsmm_w]
print @n.xbgr.xr82_u6.nr1[nsmm_l]
print @n.xbgr.xr82_u7.nr1[nsmm_rsh]
print @n.xbgr.xr82_u7.nr1[nsmm_w]
print @n.xbgr.xr82_u7.nr1[nsmm_l]
print @n.xbgr.xr82_u8.nr1[nsmm_rsh]
print @n.xbgr.xr82_u8.nr1[nsmm_w]
print @n.xbgr.xr82_u8.nr1[nsmm_l]
print @n.xbgr.xr82_u9.nr1[nsmm_rsh]
print @n.xbgr.xr82_u9.nr1[nsmm_w]
print @n.xbgr.xr82_u9.nr1[nsmm_l]
print @n.xbgr.xr82_u10.nr1[nsmm_rsh]
print @n.xbgr.xr82_u10.nr1[nsmm_w]
print @n.xbgr.xr82_u10.nr1[nsmm_l]
print @n.xbgr.xr82_u11.nr1[nsmm_rsh]
print @n.xbgr.xr82_u11.nr1[nsmm_w]
print @n.xbgr.xr82_u11.nr1[nsmm_l]
print @n.xbgr.xr82_u12.nr1[nsmm_rsh]
print @n.xbgr.xr82_u12.nr1[nsmm_w]
print @n.xbgr.xr82_u12.nr1[nsmm_l]
print @n.xbgr.xr82_u13.nr1[nsmm_rsh]
print @n.xbgr.xr82_u13.nr1[nsmm_w]
print @n.xbgr.xr82_u13.nr1[nsmm_l]
print @n.xbgr.xr82_u14.nr1[nsmm_rsh]
print @n.xbgr.xr82_u14.nr1[nsmm_w]
print @n.xbgr.xr82_u14.nr1[nsmm_l]
print @n.xbgr.xr82_u15.nr1[nsmm_rsh]
print @n.xbgr.xr82_u15.nr1[nsmm_w]
print @n.xbgr.xr82_u15.nr1[nsmm_l]
print @n.xbgr.xr82_u16.nr1[nsmm_rsh]
print @n.xbgr.xr82_u16.nr1[nsmm_w]
print @n.xbgr.xr82_u16.nr1[nsmm_l]
print @n.xbgr.xr82_u17.nr1[nsmm_rsh]
print @n.xbgr.xr82_u17.nr1[nsmm_w]
print @n.xbgr.xr82_u17.nr1[nsmm_l]
print @n.xbgr.xr82_u18.nr1[nsmm_rsh]
print @n.xbgr.xr82_u18.nr1[nsmm_w]
print @n.xbgr.xr82_u18.nr1[nsmm_l]
print @n.xbgr.xr82_u19.nr1[nsmm_rsh]
print @n.xbgr.xr82_u19.nr1[nsmm_w]
print @n.xbgr.xr82_u19.nr1[nsmm_l]
print @n.xbgr.xr82_u20.nr1[nsmm_rsh]
print @n.xbgr.xr82_u20.nr1[nsmm_w]
print @n.xbgr.xr82_u20.nr1[nsmm_l]
print @n.xbgr.xr82_u21.nr1[nsmm_rsh]
print @n.xbgr.xr82_u21.nr1[nsmm_w]
print @n.xbgr.xr82_u21.nr1[nsmm_l]
print @n.xbgr.xr82_u22.nr1[nsmm_rsh]
print @n.xbgr.xr82_u22.nr1[nsmm_w]
print @n.xbgr.xr82_u22.nr1[nsmm_l]
print @n.xbgr.xr82_u23.nr1[nsmm_rsh]
print @n.xbgr.xr82_u23.nr1[nsmm_w]
print @n.xbgr.xr82_u23.nr1[nsmm_l]
print @n.xbgr.xr82_u24.nr1[nsmm_rsh]
print @n.xbgr.xr82_u24.nr1[nsmm_w]
print @n.xbgr.xr82_u24.nr1[nsmm_l]
print @n.xbgr.xr83_u2.nr1[nsmm_rsh]
print @n.xbgr.xr83_u2.nr1[nsmm_w]
print @n.xbgr.xr83_u2.nr1[nsmm_l]
print @n.xbgr.xr83_u3.nr1[nsmm_rsh]
print @n.xbgr.xr83_u3.nr1[nsmm_w]
print @n.xbgr.xr83_u3.nr1[nsmm_l]
print @n.xbgr.xr83_u4.nr1[nsmm_rsh]
print @n.xbgr.xr83_u4.nr1[nsmm_w]
print @n.xbgr.xr83_u4.nr1[nsmm_l]
print @n.xbgr.xr83_u5.nr1[nsmm_rsh]
print @n.xbgr.xr83_u5.nr1[nsmm_w]
print @n.xbgr.xr83_u5.nr1[nsmm_l]
print @n.xbgr.xr83_u6.nr1[nsmm_rsh]
print @n.xbgr.xr83_u6.nr1[nsmm_w]
print @n.xbgr.xr83_u6.nr1[nsmm_l]
print @n.xbgr.xr83_u7.nr1[nsmm_rsh]
print @n.xbgr.xr83_u7.nr1[nsmm_w]
print @n.xbgr.xr83_u7.nr1[nsmm_l]
print @n.xbgr.xr83_u8.nr1[nsmm_rsh]
print @n.xbgr.xr83_u8.nr1[nsmm_w]
print @n.xbgr.xr83_u8.nr1[nsmm_l]
print @n.xbgr.xr83_u9.nr1[nsmm_rsh]
print @n.xbgr.xr83_u9.nr1[nsmm_w]
print @n.xbgr.xr83_u9.nr1[nsmm_l]
print @n.xbgr.xr83_u10.nr1[nsmm_rsh]
print @n.xbgr.xr83_u10.nr1[nsmm_w]
print @n.xbgr.xr83_u10.nr1[nsmm_l]
print @n.xbgr.xr83_u11.nr1[nsmm_rsh]
print @n.xbgr.xr83_u11.nr1[nsmm_w]
print @n.xbgr.xr83_u11.nr1[nsmm_l]
print @n.xbgr.xr83_u12.nr1[nsmm_rsh]
print @n.xbgr.xr83_u12.nr1[nsmm_w]
print @n.xbgr.xr83_u12.nr1[nsmm_l]
print @n.xbgr.xr83_u13.nr1[nsmm_rsh]
print @n.xbgr.xr83_u13.nr1[nsmm_w]
print @n.xbgr.xr83_u13.nr1[nsmm_l]
print @n.xbgr.xr83_u14.nr1[nsmm_rsh]
print @n.xbgr.xr83_u14.nr1[nsmm_w]
print @n.xbgr.xr83_u14.nr1[nsmm_l]
print @n.xbgr.xr83_u15.nr1[nsmm_rsh]
print @n.xbgr.xr83_u15.nr1[nsmm_w]
print @n.xbgr.xr83_u15.nr1[nsmm_l]
print @n.xbgr.xr83_u16.nr1[nsmm_rsh]
print @n.xbgr.xr83_u16.nr1[nsmm_w]
print @n.xbgr.xr83_u16.nr1[nsmm_l]
print @n.xbgr.xr83_u17.nr1[nsmm_rsh]
print @n.xbgr.xr83_u17.nr1[nsmm_w]
print @n.xbgr.xr83_u17.nr1[nsmm_l]
print @n.xbgr.xr83_u18.nr1[nsmm_rsh]
print @n.xbgr.xr83_u18.nr1[nsmm_w]
print @n.xbgr.xr83_u18.nr1[nsmm_l]
print @n.xbgr.xr83_u19.nr1[nsmm_rsh]
print @n.xbgr.xr83_u19.nr1[nsmm_w]
print @n.xbgr.xr83_u19.nr1[nsmm_l]
print @n.xbgr.xr83_u20.nr1[nsmm_rsh]
print @n.xbgr.xr83_u20.nr1[nsmm_w]
print @n.xbgr.xr83_u20.nr1[nsmm_l]
print @n.xbgr.xr83_u21.nr1[nsmm_rsh]
print @n.xbgr.xr83_u21.nr1[nsmm_w]
print @n.xbgr.xr83_u21.nr1[nsmm_l]
print @n.xbgr.xr83_u22.nr1[nsmm_rsh]
print @n.xbgr.xr83_u22.nr1[nsmm_w]
print @n.xbgr.xr83_u22.nr1[nsmm_l]
print @n.xbgr.xr83_u23.nr1[nsmm_rsh]
print @n.xbgr.xr83_u23.nr1[nsmm_w]
print @n.xbgr.xr83_u23.nr1[nsmm_l]
print @n.xbgr.xr83_u24.nr1[nsmm_rsh]
print @n.xbgr.xr83_u24.nr1[nsmm_w]
print @n.xbgr.xr83_u24.nr1[nsmm_l]
print @n.xbgr.xr84_u2.nr1[nsmm_rsh]
print @n.xbgr.xr84_u2.nr1[nsmm_w]
print @n.xbgr.xr84_u2.nr1[nsmm_l]
print @n.xbgr.xr84_u3.nr1[nsmm_rsh]
print @n.xbgr.xr84_u3.nr1[nsmm_w]
print @n.xbgr.xr84_u3.nr1[nsmm_l]
print @n.xbgr.xr84_u4.nr1[nsmm_rsh]
print @n.xbgr.xr84_u4.nr1[nsmm_w]
print @n.xbgr.xr84_u4.nr1[nsmm_l]
print @n.xbgr.xr84_u5.nr1[nsmm_rsh]
print @n.xbgr.xr84_u5.nr1[nsmm_w]
print @n.xbgr.xr84_u5.nr1[nsmm_l]
print @n.xbgr.xr84_u6.nr1[nsmm_rsh]
print @n.xbgr.xr84_u6.nr1[nsmm_w]
print @n.xbgr.xr84_u6.nr1[nsmm_l]
print @n.xbgr.xr84_u7.nr1[nsmm_rsh]
print @n.xbgr.xr84_u7.nr1[nsmm_w]
print @n.xbgr.xr84_u7.nr1[nsmm_l]
print @n.xbgr.xr84_u8.nr1[nsmm_rsh]
print @n.xbgr.xr84_u8.nr1[nsmm_w]
print @n.xbgr.xr84_u8.nr1[nsmm_l]
print @n.xbgr.xr84_u9.nr1[nsmm_rsh]
print @n.xbgr.xr84_u9.nr1[nsmm_w]
print @n.xbgr.xr84_u9.nr1[nsmm_l]
print @n.xbgr.xr84_u10.nr1[nsmm_rsh]
print @n.xbgr.xr84_u10.nr1[nsmm_w]
print @n.xbgr.xr84_u10.nr1[nsmm_l]
print @n.xbgr.xr84_u11.nr1[nsmm_rsh]
print @n.xbgr.xr84_u11.nr1[nsmm_w]
print @n.xbgr.xr84_u11.nr1[nsmm_l]
print @n.xbgr.xr84_u12.nr1[nsmm_rsh]
print @n.xbgr.xr84_u12.nr1[nsmm_w]
print @n.xbgr.xr84_u12.nr1[nsmm_l]
print @n.xbgr.xr84_u13.nr1[nsmm_rsh]
print @n.xbgr.xr84_u13.nr1[nsmm_w]
print @n.xbgr.xr84_u13.nr1[nsmm_l]
print @n.xbgr.xr84_u14.nr1[nsmm_rsh]
print @n.xbgr.xr84_u14.nr1[nsmm_w]
print @n.xbgr.xr84_u14.nr1[nsmm_l]
print @n.xbgr.xr84_u15.nr1[nsmm_rsh]
print @n.xbgr.xr84_u15.nr1[nsmm_w]
print @n.xbgr.xr84_u15.nr1[nsmm_l]
print @n.xbgr.xr84_u16.nr1[nsmm_rsh]
print @n.xbgr.xr84_u16.nr1[nsmm_w]
print @n.xbgr.xr84_u16.nr1[nsmm_l]
print @n.xbgr.xr84_u17.nr1[nsmm_rsh]
print @n.xbgr.xr84_u17.nr1[nsmm_w]
print @n.xbgr.xr84_u17.nr1[nsmm_l]
print @n.xbgr.xr84_u18.nr1[nsmm_rsh]
print @n.xbgr.xr84_u18.nr1[nsmm_w]
print @n.xbgr.xr84_u18.nr1[nsmm_l]
print @n.xbgr.xr84_u19.nr1[nsmm_rsh]
print @n.xbgr.xr84_u19.nr1[nsmm_w]
print @n.xbgr.xr84_u19.nr1[nsmm_l]
print @n.xbgr.xr84_u20.nr1[nsmm_rsh]
print @n.xbgr.xr84_u20.nr1[nsmm_w]
print @n.xbgr.xr84_u20.nr1[nsmm_l]
print @n.xbgr.xr84_u21.nr1[nsmm_rsh]
print @n.xbgr.xr84_u21.nr1[nsmm_w]
print @n.xbgr.xr84_u21.nr1[nsmm_l]
print @n.xbgr.xr84_u22.nr1[nsmm_rsh]
print @n.xbgr.xr84_u22.nr1[nsmm_w]
print @n.xbgr.xr84_u22.nr1[nsmm_l]
print @n.xbgr.xr84_u23.nr1[nsmm_rsh]
print @n.xbgr.xr84_u23.nr1[nsmm_w]
print @n.xbgr.xr84_u23.nr1[nsmm_l]
print @n.xbgr.xr84_u24.nr1[nsmm_rsh]
print @n.xbgr.xr84_u24.nr1[nsmm_w]
print @n.xbgr.xr84_u24.nr1[nsmm_l]
print @n.xbgr.xr85_u2.nr1[nsmm_rsh]
print @n.xbgr.xr85_u2.nr1[nsmm_w]
print @n.xbgr.xr85_u2.nr1[nsmm_l]
print @n.xbgr.xr85_u3.nr1[nsmm_rsh]
print @n.xbgr.xr85_u3.nr1[nsmm_w]
print @n.xbgr.xr85_u3.nr1[nsmm_l]
print @n.xbgr.xr85_u4.nr1[nsmm_rsh]
print @n.xbgr.xr85_u4.nr1[nsmm_w]
print @n.xbgr.xr85_u4.nr1[nsmm_l]
print @n.xbgr.xr85_u5.nr1[nsmm_rsh]
print @n.xbgr.xr85_u5.nr1[nsmm_w]
print @n.xbgr.xr85_u5.nr1[nsmm_l]
print @n.xbgr.xr85_u6.nr1[nsmm_rsh]
print @n.xbgr.xr85_u6.nr1[nsmm_w]
print @n.xbgr.xr85_u6.nr1[nsmm_l]
print @n.xbgr.xr85_u7.nr1[nsmm_rsh]
print @n.xbgr.xr85_u7.nr1[nsmm_w]
print @n.xbgr.xr85_u7.nr1[nsmm_l]
print @n.xbgr.xr85_u8.nr1[nsmm_rsh]
print @n.xbgr.xr85_u8.nr1[nsmm_w]
print @n.xbgr.xr85_u8.nr1[nsmm_l]
print @n.xbgr.xr85_u9.nr1[nsmm_rsh]
print @n.xbgr.xr85_u9.nr1[nsmm_w]
print @n.xbgr.xr85_u9.nr1[nsmm_l]
print @n.xbgr.xr85_u10.nr1[nsmm_rsh]
print @n.xbgr.xr85_u10.nr1[nsmm_w]
print @n.xbgr.xr85_u10.nr1[nsmm_l]
print @n.xbgr.xr85_u11.nr1[nsmm_rsh]
print @n.xbgr.xr85_u11.nr1[nsmm_w]
print @n.xbgr.xr85_u11.nr1[nsmm_l]
print @n.xbgr.xr85_u12.nr1[nsmm_rsh]
print @n.xbgr.xr85_u12.nr1[nsmm_w]
print @n.xbgr.xr85_u12.nr1[nsmm_l]
print @n.xbgr.xr85_u13.nr1[nsmm_rsh]
print @n.xbgr.xr85_u13.nr1[nsmm_w]
print @n.xbgr.xr85_u13.nr1[nsmm_l]
print @n.xbgr.xr85_u14.nr1[nsmm_rsh]
print @n.xbgr.xr85_u14.nr1[nsmm_w]
print @n.xbgr.xr85_u14.nr1[nsmm_l]
print @n.xbgr.xr85_u15.nr1[nsmm_rsh]
print @n.xbgr.xr85_u15.nr1[nsmm_w]
print @n.xbgr.xr85_u15.nr1[nsmm_l]
print @n.xbgr.xr85_u16.nr1[nsmm_rsh]
print @n.xbgr.xr85_u16.nr1[nsmm_w]
print @n.xbgr.xr85_u16.nr1[nsmm_l]
print @n.xbgr.xr85_u17.nr1[nsmm_rsh]
print @n.xbgr.xr85_u17.nr1[nsmm_w]
print @n.xbgr.xr85_u17.nr1[nsmm_l]
print @n.xbgr.xr85_u18.nr1[nsmm_rsh]
print @n.xbgr.xr85_u18.nr1[nsmm_w]
print @n.xbgr.xr85_u18.nr1[nsmm_l]
print @n.xbgr.xr85_u19.nr1[nsmm_rsh]
print @n.xbgr.xr85_u19.nr1[nsmm_w]
print @n.xbgr.xr85_u19.nr1[nsmm_l]
print @n.xbgr.xr85_u20.nr1[nsmm_rsh]
print @n.xbgr.xr85_u20.nr1[nsmm_w]
print @n.xbgr.xr85_u20.nr1[nsmm_l]
print @n.xbgr.xr85_u21.nr1[nsmm_rsh]
print @n.xbgr.xr85_u21.nr1[nsmm_w]
print @n.xbgr.xr85_u21.nr1[nsmm_l]
print @n.xbgr.xr85_u22.nr1[nsmm_rsh]
print @n.xbgr.xr85_u22.nr1[nsmm_w]
print @n.xbgr.xr85_u22.nr1[nsmm_l]
print @n.xbgr.xr85_u23.nr1[nsmm_rsh]
print @n.xbgr.xr85_u23.nr1[nsmm_w]
print @n.xbgr.xr85_u23.nr1[nsmm_l]
print @n.xbgr.xr85_u24.nr1[nsmm_rsh]
print @n.xbgr.xr85_u24.nr1[nsmm_w]
print @n.xbgr.xr85_u24.nr1[nsmm_l]
print @n.xbgr.xr86_u2.nr1[nsmm_rsh]
print @n.xbgr.xr86_u2.nr1[nsmm_w]
print @n.xbgr.xr86_u2.nr1[nsmm_l]
print @n.xbgr.xr86_u3.nr1[nsmm_rsh]
print @n.xbgr.xr86_u3.nr1[nsmm_w]
print @n.xbgr.xr86_u3.nr1[nsmm_l]
print @n.xbgr.xr86_u4.nr1[nsmm_rsh]
print @n.xbgr.xr86_u4.nr1[nsmm_w]
print @n.xbgr.xr86_u4.nr1[nsmm_l]
print @n.xbgr.xr86_u5.nr1[nsmm_rsh]
print @n.xbgr.xr86_u5.nr1[nsmm_w]
print @n.xbgr.xr86_u5.nr1[nsmm_l]
print @n.xbgr.xr86_u6.nr1[nsmm_rsh]
print @n.xbgr.xr86_u6.nr1[nsmm_w]
print @n.xbgr.xr86_u6.nr1[nsmm_l]
print @n.xbgr.xr86_u7.nr1[nsmm_rsh]
print @n.xbgr.xr86_u7.nr1[nsmm_w]
print @n.xbgr.xr86_u7.nr1[nsmm_l]
print @n.xbgr.xr86_u8.nr1[nsmm_rsh]
print @n.xbgr.xr86_u8.nr1[nsmm_w]
print @n.xbgr.xr86_u8.nr1[nsmm_l]
print @n.xbgr.xr86_u9.nr1[nsmm_rsh]
print @n.xbgr.xr86_u9.nr1[nsmm_w]
print @n.xbgr.xr86_u9.nr1[nsmm_l]
print @n.xbgr.xr86_u10.nr1[nsmm_rsh]
print @n.xbgr.xr86_u10.nr1[nsmm_w]
print @n.xbgr.xr86_u10.nr1[nsmm_l]
print @n.xbgr.xr86_u11.nr1[nsmm_rsh]
print @n.xbgr.xr86_u11.nr1[nsmm_w]
print @n.xbgr.xr86_u11.nr1[nsmm_l]
print @n.xbgr.xr86_u12.nr1[nsmm_rsh]
print @n.xbgr.xr86_u12.nr1[nsmm_w]
print @n.xbgr.xr86_u12.nr1[nsmm_l]
print @n.xbgr.xr86_u13.nr1[nsmm_rsh]
print @n.xbgr.xr86_u13.nr1[nsmm_w]
print @n.xbgr.xr86_u13.nr1[nsmm_l]
print @n.xbgr.xr86_u14.nr1[nsmm_rsh]
print @n.xbgr.xr86_u14.nr1[nsmm_w]
print @n.xbgr.xr86_u14.nr1[nsmm_l]
print @n.xbgr.xr86_u15.nr1[nsmm_rsh]
print @n.xbgr.xr86_u15.nr1[nsmm_w]
print @n.xbgr.xr86_u15.nr1[nsmm_l]
print @n.xbgr.xr86_u16.nr1[nsmm_rsh]
print @n.xbgr.xr86_u16.nr1[nsmm_w]
print @n.xbgr.xr86_u16.nr1[nsmm_l]
print @n.xbgr.xr86_u17.nr1[nsmm_rsh]
print @n.xbgr.xr86_u17.nr1[nsmm_w]
print @n.xbgr.xr86_u17.nr1[nsmm_l]
print @n.xbgr.xr86_u18.nr1[nsmm_rsh]
print @n.xbgr.xr86_u18.nr1[nsmm_w]
print @n.xbgr.xr86_u18.nr1[nsmm_l]
print @n.xbgr.xr86_u19.nr1[nsmm_rsh]
print @n.xbgr.xr86_u19.nr1[nsmm_w]
print @n.xbgr.xr86_u19.nr1[nsmm_l]
print @n.xbgr.xr86_u20.nr1[nsmm_rsh]
print @n.xbgr.xr86_u20.nr1[nsmm_w]
print @n.xbgr.xr86_u20.nr1[nsmm_l]
print @n.xbgr.xr86_u21.nr1[nsmm_rsh]
print @n.xbgr.xr86_u21.nr1[nsmm_w]
print @n.xbgr.xr86_u21.nr1[nsmm_l]
print @n.xbgr.xr86_u22.nr1[nsmm_rsh]
print @n.xbgr.xr86_u22.nr1[nsmm_w]
print @n.xbgr.xr86_u22.nr1[nsmm_l]
print @n.xbgr.xr86_u23.nr1[nsmm_rsh]
print @n.xbgr.xr86_u23.nr1[nsmm_w]
print @n.xbgr.xr86_u23.nr1[nsmm_l]
print @n.xbgr.xr86_u24.nr1[nsmm_rsh]
print @n.xbgr.xr86_u24.nr1[nsmm_w]
print @n.xbgr.xr86_u24.nr1[nsmm_l]
set numdgt=17
echo METALLIC_POINT_VOLTAGES_BEGIN
print v(xbgr.mr_n76259552)
print v(xbgr.vd2)
print v(xbgr.mr_n75770928)
print v(xbgr.c2)
print v(xbgr.mr_n76549616)
print v(xbgr.mr_n76651360)
print v(xbgr.mr_n76766016)
print v(xbgr.mr_n76822848)
print v(xbgr.mr_n77001216)
print v(xbgr.mr_n77137552)
print v(xbgr.mr_n77310128)
print v(xbgr.mr_n77434672)
print v(xbgr.mr_n77600928)
print v(xbgr.mr_n77728976)
print v(xbgr.mr_n77749968)
print v(xbgr.mr_n78039856)
print v(xbgr.mr_n78132288)
print v(xbgr.mr_n78195472)
print v(xbgr.mr_n78661312)
print v(xbgr.mr_n78810576)
print v(xbgr.mr_n78980368)
print v(xbgr.mr_n79178432)
print v(xbgr.mr_n79344192)
print v(xbgr.mr_n79483168)
print v(xbgr.mr_n79715856)
print v(xbgr.mr_n79891904)
print v(xbgr.mr_n80102928)
print v(xbgr.mr_n77149056)
print v(xbgr.mr_n80188832)
print v(xbgr.mr_n80481360)
print v(xbgr.mr_n80664368)
print v(xbgr.mr_n80881296)
print v(xbgr.mr_n81062816)
print v(xbgr.mr_n81363696)
print v(xbgr.mr_n81557424)
print v(xbgr.mr_n81784864)
print v(xbgr.mr_n82140704)
print v(xbgr.mr_n76260000)
print v(xbgr.mr_n76323440)
print v(xbgr.b1b)
print v(xbgr.mr_n76412432)
print v(xbgr.mr_n76506688)
print v(xbgr.mr_n76602848)
print v(xbgr.mr_n76694176)
print v(xbgr.mr_n76826480)
print v(xbgr.mr_n76939552)
print v(xbgr.mr_n77279632)
print v(xbgr.mr_n77397072)
print v(xbgr.mr_n77529168)
print v(xbgr.mr_n77634400)
print v(xbgr.mr_n77804064)
print v(xbgr.mr_n77917424)
print v(xbgr.mr_n78070960)
print v(xbgr.mr_n78319552)
print v(xbgr.mr_n76294816)
print v(xbgr.mr_n76356320)
print v(xbgr.mr_n75540400)
print v(xbgr.mr_n76495056)
print v(xbgr.mr_n76595392)
print v(xbgr.mr_n76712352)
print v(xbgr.mr_n76765344)
print v(xbgr.mr_n76917312)
print v(xbgr.mr_n77021904)
print v(xbgr.mr_n77137216)
print v(xbgr.mr_n77324784)
print v(xbgr.mr_n77369696)
print v(xbgr.mr_n77607216)
print v(xbgr.mr_n77725568)
print v(xbgr.mr_n77925936)
print v(xbgr.mr_n78042752)
print v(xbgr.mr_n78150688)
print v(xbgr.mr_n78321520)
print v(xbgr.mr_n75527936)
print v(xbgr.mr_n75791456)
print v(xbgr.n_13)
print v(xbgr.n_24)
print v(xbgr.mr_n75526064)
print v(xbgr.mr_n75793760)
print v(xbgr.n_14)
print v(xbgr.mr_n76136672)
print v(xbgr.mr_n76253552)
print v(xbgr.mr_n76323632)
print v(xbgr.mr_n75780624)
print v(xbgr.mr_n76474768)
print v(xbgr.mr_n76552288)
print v(xbgr.mr_n76629888)
print v(xbgr.mr_n76768512)
print v(xbgr.vd1)
print v(xbgr.mr_n77004896)
print v(xbgr.mr_n77137888)
print v(xbgr.mr_n77248064)
print v(xbgr.mr_n77435120)
print v(xbgr.mr_n77607744)
print v(xbgr.mr_n77730208)
print v(xbgr.mr_n77838800)
print v(xbgr.mr_n77973264)
print v(xbgr.mr_n78131696)
print v(xbgr.mr_n78320224)
print v(xbgr.mr_n78666720)
print v(xbgr.mr_n78808048)
print v(xbgr.mr_n78984512)
print v(xbgr.mr_n79178624)
print v(xbgr.mr_n79345184)
print v(xbgr.mr_n79528992)
print v(xbgr.mr_n79730960)
print v(xbgr.mr_n79893008)
print v(xbgr.mr_n80107376)
print v(xbgr.mr_n77152736)
print v(xbgr.mr_n80194368)
print v(xbgr.mr_n80449792)
print v(xbgr.mr_n80663984)
print v(xbgr.mr_n80882560)
print v(xbgr.mr_n81070368)
print v(xbgr.mr_n81179824)
print v(xbgr.mr_n81556480)
print v(xbgr.mr_n81806112)
print v(xbgr.mr_n82143536)
print v(xbgr.mr_n76260576)
print v(xbgr.mr_n76324576)
print v(xbgr.mr_n76113376)
print v(xbgr.mr_n76434976)
print v(xbgr.mr_n76508080)
print v(xbgr.mr_n76603120)
print v(xbgr.mr_n76636720)
print v(xbgr.mr_n76883088)
print v(xbgr.mr_n76941552)
print v(xbgr.mr_n77281024)
print v(xbgr.mr_n77398464)
print v(xbgr.mr_n77530560)
print v(xbgr.mr_n77678816)
print v(xbgr.mr_n77805520)
print v(xbgr.mr_n77917072)
print v(xbgr.mr_n78061920)
print v(xbgr.mr_n78196016)
print v(xbgr.mr_n75528864)
print v(xbgr.mr_n75681424)
print v(xbgr.mr_n76021728)
print v(xbgr.n_26)
print v(xbgr.mr_n75528400)
print v(xbgr.mr_n75520368)
print v(xbgr.n_15)
print v(xbgr.mr_n76138112)
print v(xbgr.mr_n76296272)
print v(xbgr.mr_n76356960)
print v(xbgr.mr_n75558608)
print v(xbgr.mr_n76496576)
print v(xbgr.mr_n76596192)
print v(xbgr.mr_n76713120)
print v(xbgr.mr_n76766496)
print v(xbgr.mr_n76918576)
print v(xbgr.mr_n77001520)
print v(xbgr.mr_n77147520)
print v(xbgr.mr_n77326864)
print v(xbgr.mr_n77445488)
print v(xbgr.mr_n77622576)
print v(xbgr.mr_n77742944)
print v(xbgr.mr_n77927008)
print v(xbgr.mr_n78040528)
print v(xbgr.mr_n78149696)
print v(xbgr.mr_n78196560)
print v(xbgr.mr_n75529792)
print v(xbgr.mr_n75791104)
print v(xbgr.mr_n76022656)
print v(xbgr.n_27)
print v(xbgr.mr_n75529328)
print v(xbgr.mr_n75796128)
print v(xbgr.n_16)
print v(xbgr.mr_n76139552)
print v(xbgr.mr_n75530720)
print v(xbgr.mr_n75796720)
print v(xbgr.mr_n76023120)
print v(xbgr.n_21)
print v(xbgr.mr_n76266336)
print v(xbgr.mr_n76323248)
print v(xbgr.mr_n75726624)
print v(xbgr.mr_n76495840)
print v(xbgr.mr_n76424112)
print v(xbgr.mr_n76652064)
print v(xbgr.mr_n76707360)
print v(xbgr.mr_n76880608)
print v(xbgr.mr_n76940544)
print v(xbgr.mr_n77312800)
print v(xbgr.mr_n77443808)
print v(xbgr.mr_n77604336)
print v(xbgr.mr_n77714688)
print v(xbgr.mr_n77836384)
print v(xbgr.mr_n77979216)
print v(xbgr.mr_n78132880)
print v(xbgr.mr_n78193376)
print v(xbgr.mr_n75530256)
print v(xbgr.mr_n75797312)
print v(xbgr.mr_n78674352)
print v(xbgr.mr_n78787152)
print v(xbgr.mr_n79057872)
print v(xbgr.mr_n79191856)
print v(xbgr.mr_n79357680)
print v(xbgr.mr_n79516896)
print v(xbgr.mr_n79622672)
print v(xbgr.mr_n79857968)
print v(xbgr.mr_n80119904)
print v(xbgr.mr_n80488080)
print v(xbgr.mr_n80679792)
print v(xbgr.mr_n80888016)
print v(xbgr.mr_n81075344)
print v(xbgr.mr_n81380864)
print v(xbgr.mr_n81572688)
print v(xbgr.mr_n81786128)
print v(xbgr.mr_n82154752)
print v(xbgr.mr_n76232944)
print v(xbgr.mr_n76342896)
print v(xbgr.mr_n75473648)
print v(xbgr.mr_n76436368)
print v(xbgr.mr_n76509472)
print v(xbgr.mr_n76623760)
print v(xbgr.mr_n76750144)
print v(xbgr.mr_n76904416)
print v(xbgr.mr_n76955344)
print v(xbgr.mr_n77280560)
print v(xbgr.mr_n77399856)
print v(xbgr.mr_n77531952)
print v(xbgr.mr_n77680592)
print v(xbgr.mr_n77807296)
print v(xbgr.mr_n77928016)
print v(xbgr.mr_n78099344)
print v(xbgr.mr_n78322112)
print v(xbgr.mr_n75531648)
print v(xbgr.mr_n75739504)
print v(xbgr.n_8)
print v(xbgr.vbe3)
print v(xbgr.mr_n76297648)
print v(xbgr.mr_n76357360)
print v(xbgr.mr_n75948176)
print v(xbgr.mr_n76179488)
print v(xbgr.mr_n76596992)
print v(xbgr.mr_n76713520)
print v(xbgr.mr_n76773920)
print v(xbgr.mr_n76919456)
print v(xbgr.mr_n77024512)
print v(xbgr.mr_n77328672)
print v(xbgr.mr_n77448544)
print v(xbgr.mr_n77623376)
print v(xbgr.mr_n77743744)
print v(xbgr.mr_n77928528)
print v(xbgr.mr_n77996704)
print v(xbgr.mr_n78128736)
print v(xbgr.mr_n78320560)
print v(xbgr.mr_n75531184)
print v(xbgr.mr_n75799008)
print v(xbgr.mr_n75872608)
print v(xbgr.mr_n76184592)
print v(xbgr.mr_n75532576)
print v(xbgr.mr_n75800864)
print v(xbgr.mr_n75840992)
print v(xbgr.n_37)
print v(xbgr.mr_n75532112)
print v(xbgr.mr_n75802640)
print v(xbgr.mr_n75873408)
print v(xbgr.mr_n76185520)
print v(xbgr.n_6)
print v(xbgr.vb2)
print v(xbgr.n_2)
print v(xbgr.mr_n76185984)
print v(xbgr.mr_n76265280)
print v(xbgr.mr_n76343600)
print v(xbgr.mr_n75747520)
print v(xbgr.mr_n75549184)
print v(xbgr.mr_n76556032)
print v(xbgr.mr_n76678688)
print v(xbgr.mr_n76770256)
print v(xbgr.mr_n76904304)
print v(xbgr.mr_n77005648)
print v(xbgr.mr_n77251024)
print v(xbgr.mr_n77372656)
print v(xbgr.mr_n77608448)
print v(xbgr.mr_n77726096)
print v(xbgr.mr_n77904832)
print v(xbgr.mr_n78045536)
print v(xbgr.mr_n78131104)
print v(xbgr.mr_n78322224)
print v(xbgr.mr_n78661504)
print v(xbgr.mr_n78845840)
print v(xbgr.mr_n79052768)
print v(xbgr.mr_n79171088)
print v(xbgr.mr_n79362592)
print v(xbgr.mr_n79546864)
print v(xbgr.mr_n79730496)
print v(xbgr.mr_n79892096)
print v(xbgr.mr_n80117008)
print v(xbgr.mr_n80467920)
print v(xbgr.mr_n80637824)
print v(xbgr.mr_n80892880)
print v(xbgr.mr_n81080320)
print v(xbgr.mr_n81380976)
print v(xbgr.mr_n81563360)
print v(xbgr.mr_n81806496)
print v(xbgr.mr_n82142592)
print v(xbgr.mr_n75634992)
print v(xbgr.mr_n75648112)
print v(xbgr.mr_n75874208)
print v(xbgr.mr_n76034144)
print v(xbgr.mr_n76267248)
print v(xbgr.mr_n76343952)
print v(xbgr.mr_n75652160)
print v(xbgr.mr_n76437760)
print v(xbgr.mr_n76510864)
print v(xbgr.mr_n76604544)
print v(xbgr.mr_n76751296)
print v(xbgr.mr_n76905344)
print v(xbgr.mr_n76956736)
print v(xbgr.mr_n77280096)
print v(xbgr.mr_n77401568)
print v(xbgr.mr_n77533664)
print v(xbgr.mr_n77682368)
print v(xbgr.mr_n77809072)
print v(xbgr.mr_n77924352)
print v(xbgr.mr_n78100736)
print v(xbgr.mr_n78319888)
print v(xbgr.mr_n75635840)
print v(xbgr.mr_n75670336)
print v(xbgr.n_7)
print v(xbgr.n_36)
print v(xbgr.mr_n76298784)
print v(xbgr.mr_n76357760)
print v(xbgr.mr_n76364208)
print v(xbgr.mr_n76474192)
print v(xbgr.mr_n76597792)
print v(xbgr.mr_n76713920)
print v(xbgr.mr_n76770896)
print v(xbgr.mr_n76920016)
print v(xbgr.mr_n77025312)
print v(xbgr.mr_n77330480)
print v(xbgr.mr_n77450352)
print v(xbgr.mr_n77624176)
print v(xbgr.mr_n77744544)
print v(xbgr.mr_n77929952)
print v(xbgr.mr_n78040864)
print v(xbgr.mr_n78129920)
print v(xbgr.mr_n78322336)
print v(xbgr.mr_n75636576)
print v(xbgr.mr_n75670864)
print v(xbgr.mr_n75875008)
print v(xbgr.mr_n76187504)
print v(xbgr.mr_n75637312)
print v(xbgr.mr_n75671360)
print v(xbgr.mr_n75875408)
print v(xbgr.mr_n76188096)
print v(xbgr.mr_n75638048)
print v(xbgr.mr_n75671952)
print v(xbgr.mr_n75875808)
print v(xbgr.mr_n76188688)
print v(xbgr.mr_n75638784)
print v(xbgr.mr_n75672544)
print v(xbgr.mr_n75876208)
print v(xbgr.mr_n76189280)
print v(xbgr.mr_n76260384)
print v(xbgr.mr_n76344656)
print v(xbgr.mr_n75948288)
print v(xbgr.mr_n76496208)
print v(xbgr.mr_n76557360)
print v(xbgr.mr_n76679488)
print v(xbgr.mr_n76709312)
print v(xbgr.mr_n76827696)
print v(xbgr.mr_n77024336)
print v(xbgr.mr_n77310832)
print v(xbgr.mr_n77434864)
print v(xbgr.mr_n77604224)
print v(xbgr.mr_n77744368)
print v(xbgr.mr_n77906016)
print v(xbgr.mr_n78045648)
print v(xbgr.mr_n78151200)
print v(xbgr.mr_n78324288)
print v(xbgr.mr_n78674160)
print v(xbgr.mr_n78840736)
print v(xbgr.mr_n74936960)
print v(xbgr.mr_n79184416)
print v(xbgr.mr_n79287456)
print v(xbgr.mr_n79534688)
print v(xbgr.mr_n79743152)
print v(xbgr.mr_n79913296)
print v(xbgr.mr_n80122096)
print v(xbgr.mr_n80476608)
print v(xbgr.mr_n80687344)
print v(xbgr.mr_n80897392)
print v(xbgr.mr_n81085296)
print v(xbgr.mr_n81388400)
print v(xbgr.mr_n81574656)
print v(xbgr.mr_n81810208)
print v(xbgr.mr_n82154304)
print v(xbgr.mr_n76271328)
print v(xbgr.mr_n76345008)
print v(xbgr.mr_n75705696)
print v(xbgr.mr_n76439152)
print v(xbgr.mr_n76512256)
print v(xbgr.mr_n76619712)
print v(xbgr.mr_n76752688)
print v(xbgr.mr_n76907136)
print v(xbgr.mr_n76958128)
print v(xbgr.mr_n77310320)
print v(xbgr.mr_n77403344)
print v(xbgr.mr_n77535440)
print v(xbgr.mr_n77684144)
print v(xbgr.mr_n77810848)
print v(xbgr.mr_n77910752)
print v(xbgr.mr_n78102256)
print v(xbgr.mr_n78326240)
print v(xbgr.mr_n75639296)
print v(xbgr.mr_n75673136)
print v(xbgr.mr_n75876608)
print v(xbgr.mr_n76190464)
print v(xbgr.mr_n75639840)
print v(xbgr.mr_n75673728)
print v(xbgr.n_11)
print v(xbgr.mr_n76189872)
print v(xbgr.mr_n76299296)
print v(xbgr.mr_n76358160)
print v(xbgr.mr_n76367584)
print v(xbgr.mr_n76427552)
print v(xbgr.mr_n76598592)
print v(xbgr.mr_n76714320)
print v(xbgr.mr_n76778832)
print v(xbgr.mr_n76920832)
print v(xbgr.mr_n77026112)
print v(xbgr.mr_n77332544)
print v(xbgr.mr_n77452160)
print v(xbgr.mr_n77624976)
print v(xbgr.mr_n77745344)
print v(xbgr.mr_n77932016)
print v(xbgr.mr_n78043536)
print v(xbgr.mr_n78154816)
print v(xbgr.mr_n78324176)
print v(xbgr.mr_n75640336)
print v(xbgr.mr_n75674320)
print v(xbgr.mr_n75955408)
print v(xbgr.mr_n76191056)
print v(xbgr.mr_n75641392)
print v(xbgr.mr_n75674912)
print v(xbgr.mr_n75956000)
print v(xbgr.mr_n76191648)
print v(xbgr.mr_n75641664)
print v(xbgr.mr_n75675504)
print v(xbgr.mr_n75820400)
print v(xbgr.mr_n76192240)
print v(xbgr.mr_n76265584)
print v(xbgr.mr_n76345712)
print v(xbgr.mr_n75765760)
print v(xbgr.mr_n76452112)
print v(xbgr.mr_n76562176)
print v(xbgr.mr_n76680288)
print v(xbgr.mr_n76779616)
print v(xbgr.mr_n76906144)
print v(xbgr.mr_n77002272)
print v(xbgr.mr_n77327376)
print v(xbgr.mr_n77443696)
print v(xbgr.mr_n77622400)
print v(xbgr.mr_n77729392)
print v(xbgr.mr_n77907200)
print v(xbgr.mr_n78047456)
print v(xbgr.mr_n78156736)
print v(xbgr.mr_n78326352)
print v(xbgr.n_9)
print v(xbgr.mr_n75676096)
print v(xbgr.mr_n75713376)
print v(xbgr.mr_n76083904)
print v(xbgr.mr_n78678512)
print v(xbgr.mr_n78853872)
print v(xbgr.mr_n79062176)
print v(xbgr.mr_n79181504)
print v(xbgr.mr_n79344384)
print v(xbgr.mr_n79558000)
print v(xbgr.mr_n79752272)
print v(xbgr.mr_n79893120)
print v(xbgr.mr_n80135088)
print v(xbgr.mr_n80498144)
print v(xbgr.mr_n80702144)
print v(xbgr.mr_n80902288)
print v(xbgr.mr_n81092400)
print v(xbgr.mr_n81411088)
print v(xbgr.mr_n81589088)
print v(xbgr.mr_n81834016)
print v(xbgr.mr_n82054784)
print v(xbgr.mr_n76272240)
print v(xbgr.mr_n76346064)
print v(xbgr.mr_n75722720)
print v(xbgr.mr_n76440544)
print v(xbgr.mr_n76513648)
print v(xbgr.mr_n76624800)
print v(xbgr.mr_n76754080)
print v(xbgr.mr_n76908448)
print v(xbgr.mr_n76959520)
print v(xbgr.mr_n77310576)
print v(xbgr.mr_n77405120)
print v(xbgr.mr_n77537216)
print v(xbgr.mr_n77685920)
print v(xbgr.mr_n77812624)
print v(xbgr.mr_n77930688)
print v(xbgr.mr_n78104032)
print v(xbgr.mr_n78328304)
print v(xbgr.mr_n75642752)
print v(xbgr.mr_n75649040)
print v(xbgr.mr_n75869408)
print v(xbgr.mr_n76193360)
print v(xbgr.mr_n76301696)
print v(xbgr.mr_n76358560)
print v(xbgr.mr_n76369312)
print v(xbgr.mr_n76431664)
print v(xbgr.mr_n76599392)
print v(xbgr.mr_n76714720)
print v(xbgr.mr_n76776592)
print v(xbgr.mr_n76921712)
print v(xbgr.mr_n77026912)
print v(xbgr.mr_n77334528)
print v(xbgr.mr_n77453888)
print v(xbgr.mr_n77625776)
print v(xbgr.mr_n77746144)
print v(xbgr.mr_n77933616)
print v(xbgr.mr_n78040192)
print v(xbgr.mr_n78153120)
print v(xbgr.mr_n78326464)
print v(xbgr.mr_n75643296)
print v(xbgr.mr_n75677216)
print v(xbgr.mr_n75426256)
print v(xbgr.mr_n76194016)
print v(xbgr.mr_n75643840)
print v(xbgr.mr_n75677872)
print v(xbgr.mr_n75873008)
print v(xbgr.mr_n76194608)
print v(xbgr.mr_n75644384)
print v(xbgr.mr_n75678464)
print v(xbgr.mr_n75958528)
print v(xbgr.mr_n76195200)
print v(xbgr.mr_n75644928)
print v(xbgr.mr_n75679056)
print v(xbgr.mr_n75958000)
print v(xbgr.mr_n76192832)
print v(xbgr.mr_n76270272)
print v(xbgr.mr_n76346768)
print v(xbgr.mr_n75783648)
print v(xbgr.mr_n75503680)
print v(xbgr.mr_n76563504)
print v(xbgr.mr_n76681152)
print v(xbgr.mr_n76774560)
print v(xbgr.mr_n76907616)
print v(xbgr.mr_n77025936)
print v(xbgr.mr_n77333056)
print v(xbgr.mr_n77435376)
print v(xbgr.mr_n77624000)
print v(xbgr.mr_n77729504)
print v(xbgr.mr_n77908384)
print v(xbgr.mr_n78043648)
print v(xbgr.mr_n78158544)
print v(xbgr.mr_n78330592)
print v(xbgr.mr_n78682448)
print v(xbgr.mr_n78849728)
print v(xbgr.mr_n79061424)
print v(xbgr.mr_n79205616)
print v(xbgr.mr_n79240800)
print v(xbgr.mr_n79539936)
print v(xbgr.mr_n79743264)
print v(xbgr.mr_n79922800)
print v(xbgr.mr_n80132096)
print v(xbgr.mr_n80502976)
print v(xbgr.mr_n80701632)
print v(xbgr.mr_n80907184)
print v(xbgr.mr_n81092720)
print v(xbgr.mr_n81400880)
print v(xbgr.mr_n81564304)
print v(xbgr.mr_n81680624)
print v(xbgr.mr_n82048864)
print v(xbgr.mr_n75645472)
print v(xbgr.mr_n75679648)
print v(xbgr.mr_n75959776)
print v(xbgr.mr_n76196304)
print v(xbgr.mr_n76276320)
print v(xbgr.mr_n76347120)
print v(xbgr.mr_n75910112)
print v(xbgr.mr_n76441936)
print v(xbgr.mr_n76513184)
print v(xbgr.mr_n76625824)
print v(xbgr.mr_n76753616)
print v(xbgr.mr_n76909760)
print v(xbgr.mr_n76960912)
print v(xbgr.mr_n77333952)
print v(xbgr.mr_n77404528)
print v(xbgr.mr_n77536624)
print v(xbgr.mr_n77687696)
print v(xbgr.mr_n77812032)
print v(xbgr.mr_n77934208)
print v(xbgr.mr_n78105808)
print v(xbgr.mr_n78328416)
print v(xbgr.mr_n75640848)
print v(xbgr.mr_n75680240)
print v(xbgr.mr_n75868224)
print v(xbgr.mr_n76196976)
print v(xbgr.mr_n76303552)
print v(xbgr.mr_n76358960)
print v(xbgr.mr_n76371120)
print v(xbgr.mr_n76361712)
print v(xbgr.mr_n76600192)
print v(xbgr.mr_n76715120)
print v(xbgr.mr_n76783888)
print v(xbgr.mr_n76922688)
print v(xbgr.mr_n77027712)
print v(xbgr.mr_n77336672)
print v(xbgr.mr_n77449056)
print v(xbgr.mr_n77626576)
print v(xbgr.mr_n77746944)
print v(xbgr.mr_n77933104)
print v(xbgr.mr_n78050960)
print v(xbgr.mr_n78153008)
print v(xbgr.mr_n78328528)
print v(xbgr.mr_n75646560)
print v(xbgr.mr_n75680832)
print v(xbgr.n_3)
print v(xbgr.n_33)
print v(xbgr.mr_n75647104)
print v(xbgr.mr_n75649968)
print v(xbgr.mr_n75955664)
print v(xbgr.mr_n76198096)
print v(xbgr.mr_n75646288)
print v(xbgr.mr_n75681952)
print v(xbgr.mr_n75962144)
print v(xbgr.mr_n76198752)
print v(xbgr.mr_n75643568)
print v(xbgr.mr_n75682608)
print v(xbgr.mr_n75857568)
print v(xbgr.mr_n76199344)
print v(xbgr.mr_n76268000)
print v(xbgr.mr_n76354992)
print v(xbgr.mr_n76235344)
print v(xbgr.mr_n75537936)
print v(xbgr.mr_n76568320)
print v(xbgr.mr_n76682336)
print v(xbgr.mr_n76781648)
print v(xbgr.mr_n76908928)
print v(xbgr.mr_n77026736)
print v(xbgr.mr_n77195392)
print v(xbgr.mr_n77329184)
print v(xbgr.mr_n77446192)
print v(xbgr.mr_n77605040)
print v(xbgr.mr_n77743568)
print v(xbgr.mr_n77909568)
print v(xbgr.mr_n77978400)
print v(xbgr.mr_n78150032)
print v(xbgr.mr_n78330480)
print v(xbgr.mr_n78680192)
print v(xbgr.mr_n78875376)
print v(xbgr.mr_n79079184)
print v(xbgr.mr_n79219360)
print v(xbgr.mr_n79359984)
print v(xbgr.mr_n79562400)
print v(xbgr.mr_n79763328)
print v(xbgr.mr_n79927328)
print v(xbgr.mr_n80137024)
print v(xbgr.mr_n80307568)
print v(xbgr.mr_n80500336)
print v(xbgr.mr_n80681536)
print v(xbgr.mr_n80909632)
print v(xbgr.mr_n81097472)
print v(xbgr.mr_n81408384)
print v(xbgr.mr_n81571376)
print v(xbgr.mr_n81809472)
print v(xbgr.mr_n82003984)
print v(xbgr.mr_n76277232)
print v(xbgr.mr_n76322624)
print v(xbgr.mr_n75752496)
print v(xbgr.mr_n76442400)
print v(xbgr.mr_n76512720)
print v(xbgr.mr_n76633184)
print v(xbgr.mr_n76753152)
print v(xbgr.mr_n76911072)
print v(xbgr.mr_n76962304)
print v(xbgr.mr_n77195584)
print v(xbgr.mr_n77330992)
print v(xbgr.mr_n77403936)
print v(xbgr.mr_n77536032)
print v(xbgr.mr_n77689472)
print v(xbgr.mr_n77811440)
print v(xbgr.mr_n77932608)
print v(xbgr.mr_n78107584)
print v(xbgr.mr_n78324400)
print v(xbgr.mr_n75649440)
print v(xbgr.n_19)
print v(xbgr.mr_n75963328)
print v(xbgr.mr_n76072064)
print v(xbgr.mr_n76305008)
print v(xbgr.mr_n76359360)
print v(xbgr.mr_n76372928)
print v(xbgr.mr_n76133088)
print v(xbgr.mr_n76600992)
print v(xbgr.mr_n76715520)
print v(xbgr.mr_n76786752)
print v(xbgr.mr_n76924144)
print v(xbgr.mr_n77028512)
print v(xbgr.mr_n77205568)
print v(xbgr.mr_n77338736)
print v(xbgr.mr_n77457584)
print v(xbgr.mr_n77627376)
print v(xbgr.mr_n77747744)
print v(xbgr.mr_n77936640)
print v(xbgr.mr_n78049264)
print v(xbgr.mr_n78158432)
print v(xbgr.mr_n78332432)
print v(xbgr.mr_n75650368)
print v(xbgr.mr_n75683792)
print v(xbgr.mr_n75865856)
print v(xbgr.mr_n76200448)
print v(xbgr.mr_n75651360)
print v(xbgr.mr_n75684384)
print v(xbgr.mr_n75964512)
print v(xbgr.mr_n76201120)
print v(xbgr.mr_n75645744)
print v(xbgr.mr_n75684976)
print v(xbgr.mr_n75956416)
print v(xbgr.mr_n76201712)
print v(xbgr.mr_n75652288)
print v(xbgr.mr_n75685568)
print v(xbgr.mr_n75965696)
print v(xbgr.mr_n76202304)
print v(xbgr.mr_n76275264)
print v(xbgr.mr_n76347824)
print v(xbgr.mr_n76362352)
print v(xbgr.mr_n75549856)
print v(xbgr.mr_n76569648)
print v(xbgr.mr_n76683520)
print v(xbgr.mr_n76786048)
print v(xbgr.mr_n76909584)
print v(xbgr.mr_n76966208)
print v(xbgr.mr_n77196288)
print v(xbgr.mr_n77336016)
print v(xbgr.mr_n77437536)
print v(xbgr.mr_n77625600)
print v(xbgr.mr_n77745168)
print v(xbgr.mr_n77910160)
print v(xbgr.mr_n78052768)
print v(xbgr.mr_n78154928)
print v(xbgr.mr_n78332544)
print v(xbgr.mr_n75651824)
print v(xbgr.mr_n75474608)
print v(xbgr.mr_n75956304)
print v(xbgr.mr_n76182384)
print v(xbgr.mr_n78676896)
print v(xbgr.mr_n78880160)
print v(xbgr.mr_n79075664)
print v(xbgr.mr_n79203760)
print v(xbgr.mr_n79351984)
print v(xbgr.mr_n79534960)
print v(xbgr.mr_n79775120)
print v(xbgr.mr_n79917312)
print v(xbgr.mr_n80041888)
print v(xbgr.mr_n80310768)
print v(xbgr.mr_n80496192)
print v(xbgr.mr_n80712704)
print v(xbgr.mr_n80904736)
print v(xbgr.mr_n81103536)
print v(xbgr.mr_n81420672)
print v(xbgr.mr_n81593280)
print v(xbgr.mr_n81787392)
print v(xbgr.mr_n81901008)
print v(xbgr.mr_n76281312)
print v(xbgr.mr_n76322352)
print v(xbgr.mr_n75689888)
print v(xbgr.mr_n76441472)
print v(xbgr.mr_n76511792)
print v(xbgr.mr_n76627520)
print v(xbgr.mr_n76752224)
print v(xbgr.mr_n76911728)
print v(xbgr.mr_n76999152)
print v(xbgr.mr_n77167120)
print v(xbgr.mr_n77338080)
print v(xbgr.mr_n77402752)
print v(xbgr.mr_n77534848)
print v(xbgr.mr_n77691248)
print v(xbgr.mr_n77810256)
print v(xbgr.mr_n77937264)
print v(xbgr.mr_n78109360)
print v(xbgr.mr_n78330368)
print v(xbgr.mr_n75650896)
print v(xbgr.mr_n75490096)
print v(xbgr.mr_n75966880)
print v(xbgr.mr_n76203488)
print v(xbgr.mr_n76306064)
print v(xbgr.mr_n76360000)
print v(xbgr.mr_n76374736)
print v(xbgr.mr_n75479744)
print v(xbgr.mr_n76601392)
print v(xbgr.mr_n76715920)
print v(xbgr.mr_n76789008)
print v(xbgr.mr_n76925024)
print v(xbgr.mr_n77029312)
print v(xbgr.mr_n77209728)
print v(xbgr.mr_n77340720)
print v(xbgr.mr_n77459312)
print v(xbgr.mr_n77628176)
print v(xbgr.mr_n77748544)
print v(xbgr.mr_n77939728)
print v(xbgr.mr_n78047344)
print v(xbgr.mr_n78156624)
print v(xbgr.mr_n78334496)
print v(xbgr.mr_n75642480)
print v(xbgr.mr_n75501360)
print v(xbgr.mr_n75959184)
print v(xbgr.mr_n76204080)
print v(xbgr.mr_n75648576)
print v(xbgr.mr_n75512624)
print v(xbgr.n_4)
print v(xbgr.n_30)
print v(xbgr.mr_n75643024)
print v(xbgr.mr_n75476720)
print v(xbgr.mr_n75960368)
print v(xbgr.mr_n76205264)
print v(xbgr.mr_n75647376)
print v(xbgr.mr_n75495024)
print v(xbgr.mr_n75969248)
print v(xbgr.mr_n76205856)
print v(xbgr.mr_n76272992)
print v(xbgr.mr_n76346944)
print v(xbgr.mr_n76362464)
print v(xbgr.mr_n75571024)
print v(xbgr.mr_n76574464)
print v(xbgr.mr_n76684704)
print v(xbgr.mr_n76781920)
print v(xbgr.mr_n76908272)
print v(xbgr.mr_n76937376)
print v(xbgr.mr_n77168480)
print v(xbgr.mr_n77335120)
print v(xbgr.mr_n77455536)
print v(xbgr.mr_n77594112)
print v(xbgr.mr_n77722688)
print v(xbgr.mr_n77908976)
print v(xbgr.mr_n78049152)
print v(xbgr.mr_n78151312)
print v(xbgr.mr_n78332656)
print v(xbgr.mr_n78431264)
print v(xbgr.mr_n78885936)
print v(xbgr.mr_n79102224)
print v(xbgr.mr_n79217136)
print v(xbgr.mr_n79355168)
print v(xbgr.mr_n79580272)
print v(xbgr.mr_n79774608)
print v(xbgr.mr_n79882992)
print v(xbgr.mr_n80045312)
print v(xbgr.mr_n80329616)
print v(xbgr.mr_n80480656)
print v(xbgr.mr_n80667024)
print v(xbgr.mr_n80899840)
print v(xbgr.mr_n81108512)
print v(xbgr.mr_n81420784)
print v(xbgr.mr_n81579312)
print v(xbgr.mr_n81810896)
print v(xbgr.mr_n81985504)
print v(xbgr.mr_n75438192)
print v(xbgr.mr_n75640224)
print v(xbgr.mr_n75961552)
print v(xbgr.mr_n76206448)
print v(xbgr.mr_n76282224)
print v(xbgr.mr_n76322080)
print v(xbgr.mr_n75434256)
print v(xbgr.mr_n76441008)
print v(xbgr.mr_n76511328)
print v(xbgr.mr_n76637072)
print v(xbgr.mr_n76751760)
print v(xbgr.mr_n76910416)
print v(xbgr.mr_n76942608)
print v(xbgr.mr_n77120368)
print v(xbgr.mr_n77325568)
print v(xbgr.mr_n77402160)
print v(xbgr.mr_n77534256)
print v(xbgr.mr_n77693024)
print v(xbgr.mr_n77809664)
print v(xbgr.mr_n77929616)
print v(xbgr.mr_n78111136)
print v(xbgr.mr_n78336560)
print v(xbgr.mr_n75646016)
print v(xbgr.mr_n75647648)
print v(xbgr.mr_n75970432)
print v(xbgr.mr_n76207040)
print v(xbgr.mr_n76307840)
print v(xbgr.mr_n76360800)
print v(xbgr.mr_n76376544)
print v(xbgr.mr_n76418352)
print v(xbgr.mr_n76600592)
print v(xbgr.mr_n76716320)
print v(xbgr.mr_n76787392)
print v(xbgr.mr_n76926000)
print v(xbgr.mr_n77029872)
print v(xbgr.mr_n77211536)
print v(xbgr.mr_n77342864)
print v(xbgr.mr_n77461120)
print v(xbgr.mr_n77628976)
print v(xbgr.mr_n77749344)
print v(xbgr.mr_n77940608)
print v(xbgr.mr_n78056384)
print v(xbgr.mr_n78160352)
print v(xbgr.mr_n78334720)
print v(xbgr.mr_n75637936)
print v(xbgr.mr_n75491504)
print v(xbgr.mr_n75962736)
print v(xbgr.mr_n76207632)
print v(xbgr.mr_n75645200)
print v(xbgr.mr_n75507696)
print v(xbgr.mr_n75971616)
print v(xbgr.mr_n76208224)
print v(xbgr.mr_n75644656)
print v(xbgr.mr_n75426064)
print v(xbgr.mr_n75963920)
print v(xbgr.mr_n76202896)
print v(xbgr.mr_n76286304)
print v(xbgr.mr_n76354656)
print v(xbgr.mr_n76368096)
print v(xbgr.mr_n76472288)
print v(xbgr.mr_n76575792)
print v(xbgr.mr_n76685888)
print v(xbgr.mr_n76784672)
print v(xbgr.mr_n76906960)
print v(xbgr.mr_n77029136)
print v(xbgr.mr_n77206352)
print v(xbgr.mr_n77341312)
print v(xbgr.mr_n77450864)
print v(xbgr.mr_n77626400)
print v(xbgr.mr_n77725984)
print v(xbgr.mr_n77907792)
print v(xbgr.mr_n78051072)
print v(xbgr.mr_n78165664)
print v(xbgr.mr_n78336672)
print v(xbgr.mr_n75644112)
print v(xbgr.mr_n75506320)
print v(xbgr.mr_n75972800)
print v(xbgr.mr_n76140160)
print v(xbgr.mr_n78669840)
print v(xbgr.mr_n78878720)
print v(xbgr.mr_n79086864)
print v(xbgr.mr_n79210048)
print v(xbgr.mr_n79370608)
print v(xbgr.mr_n79568096)
print v(xbgr.mr_n79769104)
print v(xbgr.mr_n79926624)
print v(xbgr.mr_n77059808)
print v(xbgr.mr_n80045424)
print v(xbgr.mr_n80347312)
print v(xbgr.mr_n80485296)
print v(xbgr.mr_n80718400)
print v(xbgr.mr_n80894944)
print v(xbgr.mr_n81121360)
print v(xbgr.mr_n81443664)
print v(xbgr.mr_n81588624)
print v(xbgr.mr_n81814464)
print v(xbgr.mr_n81984832)
print v(xbgr.mr_n76280560)
print v(xbgr.mr_n76321808)
print v(xbgr.mr_n75655264)
print v(xbgr.mr_n76440080)
print v(xbgr.mr_n76510400)
print v(xbgr.mr_n76637840)
print v(xbgr.mr_n76750832)
print v(xbgr.mr_n76909104)
print v(xbgr.mr_n77070336)
print v(xbgr.mr_n77342208)
print v(xbgr.mr_n77400976)
print v(xbgr.mr_n77533072)
print v(xbgr.mr_n77692192)
print v(xbgr.mr_n77808480)
print v(xbgr.mr_n77940432)
print v(xbgr.mr_n78160240)
print v(xbgr.mr_n78340688)
print v(xbgr.mr_n75640112)
print v(xbgr.mr_n75492208)
print v(xbgr.mr_n75965104)
print v(xbgr.mr_n76209920)
print v(xbgr.mr_n76309296)
print v(xbgr.mr_n76361600)
print v(xbgr.mr_n76378432)
print v(xbgr.mr_n76415776)
print v(xbgr.mr_n76599792)
print v(xbgr.mr_n76716720)
print v(xbgr.mr_n76791536)
print v(xbgr.mr_n76926880)
print v(xbgr.mr_n77023120)
print v(xbgr.mr_n77213344)
print v(xbgr.mr_n77344848)
print v(xbgr.mr_n77463008)
print v(xbgr.mr_n77629776)
print v(xbgr.mr_n77750144)
print v(xbgr.mr_n77942992)
print v(xbgr.mr_n78054688)
print v(xbgr.mr_n78162048)
print v(xbgr.mr_n78338624)
print v(xbgr.mr_n75633216)
print v(xbgr.mr_n75518256)
print v(xbgr.mr_n75971024)
print v(xbgr.mr_n76210576)
print v(xbgr.mr_n75625792)
print v(xbgr.mr_n75669936)
print v(xbgr.mr_n75966288)
print v(xbgr.mr_n76199936)
print v(xbgr.mr_n75641936)
print v(xbgr.mr_n75469680)
print v(xbgr.n_5)
print v(xbgr.mr_n76211760)
print v(xbgr.mr_n75641120)
print v(xbgr.mr_n75510512)
print v(xbgr.mr_n75967472)
print v(xbgr.mr_n76212352)
print v(xbgr.mr_n76277984)
print v(xbgr.mr_n76355664)
print v(xbgr.mr_n76375328)
print v(xbgr.mr_n76362048)
print v(xbgr.mr_n76550064)
print v(xbgr.mr_n76687072)
print v(xbgr.mr_n76771168)
print v(xbgr.mr_n76905968)
print v(xbgr.mr_n77027536)
print v(xbgr.mr_n77195776)
print v(xbgr.mr_n77343376)
print v(xbgr.mr_n77458096)
print v(xbgr.mr_n77628000)
print v(xbgr.mr_n77746768)
print v(xbgr.mr_n77906608)
print v(xbgr.mr_n78052880)
print v(xbgr.mr_n78169504)
print v(xbgr.mr_n78338736)
print v(xbgr.mr_n74585856)
print v(xbgr.mr_n78789040)
print v(xbgr.mr_n79101520)
print v(xbgr.mr_n79229664)
print v(xbgr.mr_n79399584)
print v(xbgr.mr_n79546352)
print v(xbgr.mr_n79757968)
print v(xbgr.mr_n79944880)
print v(xbgr.mr_n77064448)
print v(xbgr.mr_n80034064)
print v(xbgr.mr_n80344416)
print v(xbgr.mr_n80487568)
print v(xbgr.mr_n80707264)
print v(xbgr.mr_n80891136)
print v(xbgr.mr_n81118464)
print v(xbgr.mr_n81440848)
print v(xbgr.mr_n81607248)
print v(xbgr.mr_n81809008)
print v(xbgr.mr_n82040544)
print v(xbgr.mr_n75639568)
print v(xbgr.mr_n75495728)
print v(xbgr.mr_n75976288)
print v(xbgr.mr_n76212944)
print v(xbgr.mr_n76285360)
print v(xbgr.mr_n76321536)
print v(xbgr.mr_n75665504)
print v(xbgr.mr_n76439616)
print v(xbgr.mr_n76509936)
print v(xbgr.mr_n76638768)
print v(xbgr.mr_n76750448)
print v(xbgr.mr_n76907792)
print v(xbgr.mr_n77120560)
print v(xbgr.mr_n77344272)
print v(xbgr.mr_n77400384)
print v(xbgr.mr_n77532480)
print v(xbgr.mr_n77696112)
print v(xbgr.mr_n77807888)
print v(xbgr.mr_n77942160)
print v(xbgr.mr_n78162160)
print v(xbgr.mr_n78340912)
print v(xbgr.mr_n75638560)
print v(xbgr.mr_n75434976)
print v(xbgr.mr_n75975760)
print v(xbgr.mr_n76213536)
print v(xbgr.mr_n76310832)
print v(xbgr.mr_n75479104)
print v(xbgr.mr_n76380160)
print v(xbgr.mr_n76422944)
print v(xbgr.mr_n76598992)
print v(xbgr.mr_n76717120)
print v(xbgr.mr_n76794496)
print v(xbgr.mr_n76927856)
print v(xbgr.mr_n77025136)
print v(xbgr.mr_n77215152)
print v(xbgr.mr_n77346992)
print v(xbgr.mr_n77464816)
print v(xbgr.mr_n77630576)
print v(xbgr.mr_n77750944)
print v(xbgr.mr_n77943952)
print v(xbgr.mr_n78056496)
print v(xbgr.mr_n78165776)
print v(xbgr.mr_n78336784)
print v(xbgr.mr_n75600736)
print v(xbgr.mr_n75798432)
print v(xbgr.mr_n75977536)
print v(xbgr.mr_n76214128)
print v(xbgr.mr_n75601200)
print v(xbgr.mr_n75807888)
print v(xbgr.mr_n75969840)
print v(xbgr.mr_n76214720)
print v(xbgr.mr_n75601664)
print v(xbgr.mr_n75808560)
print v(xbgr.mr_n75978720)
print v(xbgr.mr_n76215312)
print v(xbgr.mr_n75602128)
print v(xbgr.mr_n75809152)
print v(xbgr.mr_n75973984)
print v(xbgr.mr_n76215904)
print v(xbgr.mr_n76280256)
print v(xbgr.mr_n75761264)
print v(xbgr.mr_n76371712)
print v(xbgr.mr_n76473568)
print v(xbgr.mr_n76550320)
print v(xbgr.mr_n76688256)
print v(xbgr.mr_n76789728)
print v(xbgr.mr_n76905232)
print v(xbgr.mr_n77052384)
print v(xbgr.mr_n77212048)
print v(xbgr.mr_n77281488)
print v(xbgr.mr_n77454480)
print v(xbgr.mr_n77628800)
print v(xbgr.mr_n77748368)
print v(xbgr.mr_n77905424)
print v(xbgr.mr_n78054576)
print v(xbgr.mr_n78167472)
print v(xbgr.mr_n78342864)
print v(xbgr.mr_n78656960)
print v(xbgr.mr_n78829280)
print v(xbgr.mr_n79092640)
print v(xbgr.mr_n79223040)
print v(xbgr.mr_n79404240)
print v(xbgr.mr_n79553584)
print v(xbgr.mr_n79745008)
print v(xbgr.mr_n79940000)
print v(xbgr.mr_n77051920)
print v(xbgr.mr_n80039744)
print v(xbgr.mr_n80349392)
print v(xbgr.mr_n80503488)
print v(xbgr.mr_n80695040)
print v(xbgr.mr_n80883824)
print v(xbgr.mr_n81123440)
print v(xbgr.mr_n81424736)
print v(xbgr.mr_n81597936)
print v(xbgr.mr_n81809984)
print v(xbgr.mr_n82006704)
print v(xbgr.mr_n76280368)
print v(xbgr.mr_n76321264)
print v(xbgr.mr_n75710624)
print v(xbgr.mr_n76438688)
print v(xbgr.mr_n76509008)
print v(xbgr.mr_n76638304)
print v(xbgr.mr_n76749840)
print v(xbgr.mr_n76906320)
print v(xbgr.mr_n77026608)
print v(xbgr.mr_n77340144)
print v(xbgr.mr_n77399392)
print v(xbgr.mr_n77531488)
print v(xbgr.mr_n77696720)
print v(xbgr.mr_n77806704)
print v(xbgr.mr_n77944384)
print v(xbgr.mr_n78163968)
print v(xbgr.mr_n78342752)
print v(xbgr.mr_n75602592)
print v(xbgr.mr_n75809744)
print v(xbgr.mr_n75979904)
print v(xbgr.mr_n76216496)
print v(xbgr.mr_n75603056)
print v(xbgr.mr_n75810336)
print v(xbgr.mr_n75972208)
print v(xbgr.mr_n76217088)
print v(xbgr.mr_n76311888)
print v(xbgr.mr_n75461568)
print v(xbgr.mr_n76382048)
print v(xbgr.mr_n76495408)
print v(xbgr.mr_n76559408)
print v(xbgr.mr_n76717520)
print v(xbgr.mr_n76799120)
print v(xbgr.mr_n76928496)
print v(xbgr.mr_n77058528)
print v(xbgr.mr_n77198256)
print v(xbgr.mr_n77349056)
print v(xbgr.mr_n77466624)
print v(xbgr.mr_n77631376)
print v(xbgr.mr_n77751744)
print v(xbgr.mr_n77937488)
print v(xbgr.mr_n78058192)
print v(xbgr.mr_n78169280)
print v(xbgr.mr_n78338848)
print v(xbgr.mr_n75603520)
print v(xbgr.mr_n75803232)
print v(xbgr.mr_n75981088)
print v(xbgr.mr_n76197568)
print v(xbgr.mr_n75603984)
print v(xbgr.mr_n75811456)
print v(xbgr.mr_n75973392)
print v(xbgr.mr_n76218208)
print v(xbgr.mr_n75604448)
print v(xbgr.mr_n75791280)
print v(xbgr.mr_n75982272)
print v(xbgr.n_31)
print v(xbgr.mr_n76275376)
print v(xbgr.mr_n76361424)
print v(xbgr.mr_n76369904)
print v(xbgr.mr_n76470288)
print v(xbgr.mr_n75534656)
print v(xbgr.mr_n76689440)
print v(xbgr.mr_n76799840)
print v(xbgr.mr_n76905456)
print v(xbgr.mr_n77053824)
print v(xbgr.mr_n77204704)
print v(xbgr.mr_n77347504)
print v(xbgr.mr_n77456288)
print v(xbgr.mr_n77623200)
print v(xbgr.mr_n77745968)
print v(xbgr.mr_n77904240)
print v(xbgr.mr_n78060112)
print v(xbgr.mr_n78171456)
print v(xbgr.mr_n78345040)
print v(xbgr.mr_n75584176)
print v(xbgr.mr_n75812704)
print v(xbgr.mr_n75974576)
print v(xbgr.mr_n76219456)
print v(xbgr.mr_n78664000)
print v(xbgr.mr_n78809312)
print v(xbgr.mr_n79081504)
print v(xbgr.mr_n79211904)
print v(xbgr.mr_n79389232)
print v(xbgr.mr_n79535152)
print v(xbgr.mr_n79736656)
print v(xbgr.mr_n79940464)
print v(xbgr.mr_n77072432)
print v(xbgr.mr_n80042000)
print v(xbgr.mr_n80362240)
print v(xbgr.mr_n80483440)
print v(xbgr.mr_n80677472)
print v(xbgr.mr_n80863600)
print v(xbgr.mr_n81128416)
print v(xbgr.mr_n81400544)
print v(xbgr.mr_n81602592)
print v(xbgr.mr_n81810704)
print v(xbgr.mr_n81695072)
print v(xbgr.mr_n76275568)
print v(xbgr.mr_n76321072)
print v(xbgr.mr_n75703872)
print v(xbgr.mr_n76438224)
print v(xbgr.mr_n76508544)
print v(xbgr.mr_n76637376)
print v(xbgr.mr_n76749536)
print v(xbgr.mr_n76833216)
print v(xbgr.mr_n77129808)
print v(xbgr.mr_n77250144)
print v(xbgr.mr_n77398928)
print v(xbgr.mr_n77531024)
print v(xbgr.mr_n77696384)
print v(xbgr.mr_n77806112)
print v(xbgr.mr_n77946128)
print v(xbgr.mr_n78167584)
print v(xbgr.mr_n78342976)
print v(xbgr.mr_n75586960)
print v(xbgr.mr_n75813296)
print v(xbgr.mr_n75983456)
print v(xbgr.mr_n76220048)
print v(xbgr.mr_n76313344)
print v(xbgr.mr_n76359824)
print v(xbgr.mr_n76383776)
print v(xbgr.mr_n76425056)
print v(xbgr.mr_n76597392)
print v(xbgr.mr_n76717920)
print v(xbgr.mr_n76781536)
print v(xbgr.mr_n76929712)
print v(xbgr.mr_n77023296)
print v(xbgr.mr_n77218768)
print v(xbgr.mr_n77351120)
print v(xbgr.mr_n77468352)
print v(xbgr.mr_n77632176)
print v(xbgr.mr_n77752544)
print v(xbgr.mr_n77947280)
print v(xbgr.mr_n78063616)
print v(xbgr.mr_n78163856)
print v(xbgr.mr_n78344816)
print v(xbgr.mr_n75605840)
print v(xbgr.mr_n75813888)
print v(xbgr.mr_n75968656)
print v(xbgr.mr_n76220640)
print v(xbgr.mr_n75606304)
print v(xbgr.n_34)
print v(xbgr.mr_n75984640)
print v(xbgr.mr_n76221232)
print v(xbgr.mr_n75592992)
print v(xbgr.mr_n75812112)
print v(xbgr.mr_n75976944)
print v(xbgr.mr_n76221824)
print v(xbgr.mr_n75607232)
print v(xbgr.mr_n75806720)
print v(xbgr.mr_n75985824)
print v(xbgr.mr_n76208816)
print v(xbgr.mr_n76270384)
print v(xbgr.mr_n76085152)
print v(xbgr.mr_n76181648)
print v(xbgr.mr_n76450992)
print v(xbgr.mr_n76514112)
print v(xbgr.mr_n76690624)
print v(xbgr.mr_n76797616)
print v(xbgr.mr_n76904528)
print v(xbgr.mr_n77049536)
print v(xbgr.mr_n77213856)
print v(xbgr.mr_n77349568)
print v(xbgr.mr_n77405712)
print v(xbgr.mr_n77624800)
print v(xbgr.mr_n77742768)
print v(xbgr.mr_n77836640)
print v(xbgr.mr_n78061808)
print v(xbgr.mr_n78169392)
print v(xbgr.mr_n78340800)
print v(xbgr.mr_n78661040)
print v(xbgr.mr_n78844096)
print v(xbgr.mr_n79087376)
print v(xbgr.mr_n79200096)
print v(xbgr.mr_n79379920)
print v(xbgr.mr_n79523936)
print v(xbgr.mr_n79725520)
print v(xbgr.mr_n79952016)
print v(xbgr.mr_n77057840)
print v(xbgr.mr_n80039552)
print v(xbgr.mr_n80359344)
print v(xbgr.mr_n80483552)
print v(xbgr.mr_n80674352)
print v(xbgr.mr_n80874832)
print v(xbgr.mr_n81141264)
print v(xbgr.mr_n81380640)
print v(xbgr.mr_n81528288)
print v(xbgr.mr_n81519456)
print v(xbgr.mr_n82048288)
print v(xbgr.mr_n75607696)
print v(xbgr.mr_n75816176)
print v(xbgr.mr_n75978128)
print v(xbgr.mr_n76222944)
print v(xbgr.mr_n76270576)
print v(xbgr.mr_n76319408)
print v(xbgr.mr_n75761872)
print v(xbgr.mr_n76437296)
print v(xbgr.mr_n76507616)
print v(xbgr.mr_n76637184)
print v(xbgr.mr_n76709984)
print v(xbgr.mr_n76832912)
print v(xbgr.mr_n77080928)
print v(xbgr.mr_n77345440)
print v(xbgr.mr_n77398000)
print v(xbgr.mr_n77530096)
print v(xbgr.mr_n77695840)
print v(xbgr.mr_n77804992)
print v(xbgr.mr_n77947872)
print v(xbgr.mr_n78171568)
print v(xbgr.mr_n78334608)
print v(xbgr.mr_n75608160)
print v(xbgr.mr_n75816848)
print v(xbgr.mr_n75987008)
print v(xbgr.mr_n76195792)
print v(xbgr.mr_n76314800)
print v(xbgr.mr_n76360624)
print v(xbgr.mr_n76385584)
print v(xbgr.mr_n76427040)
print v(xbgr.mr_n76571696)
print v(xbgr.mr_n76718320)
print v(xbgr.mr_n76801648)
print v(xbgr.mr_n76929200)
print v(xbgr.mr_n77045056)
print v(xbgr.mr_n77220576)
print v(xbgr.mr_n77353184)
print v(xbgr.mr_n77470240)
print v(xbgr.mr_n77632976)
print v(xbgr.mr_n77753344)
print v(xbgr.mr_n77948880)
print v(xbgr.mr_n78060000)
print v(xbgr.mr_n78173408)
print v(xbgr.mr_n78346880)
print v(xbgr.mr_n75608624)
print v(xbgr.mr_n75817440)
print v(xbgr.mr_n75979312)
print v(xbgr.mr_n76224128)
print v(xbgr.mr_n75609088)
print v(xbgr.mr_n75818032)
print v(xbgr.mr_n75988192)
print v(xbgr.mr_n76224784)
print v(xbgr.mr_n75609552)
print v(xbgr.mr_n75818624)
print v(xbgr.mr_n75980496)
print v(xbgr.mr_n76225376)
print v(xbgr.mr_n75610016)
print v(xbgr.mr_n75819216)
print v(xbgr.n_10)
print v(xbgr.mr_n76225968)
print v(xbgr.mr_n76260192)
print v(xbgr.mr_n76351120)
print v(xbgr.mr_n76382560)
print v(xbgr.mr_n76412848)
print v(xbgr.mr_n76549808)
print v(xbgr.mr_n76691808)
print v(xbgr.mr_n76804416)
print v(xbgr.mr_n76824496)
print v(xbgr.mr_n77067024)
print v(xbgr.mr_n77215664)
print v(xbgr.mr_n77339248)
print v(xbgr.mr_n77461712)
print v(xbgr.mr_n77631200)
print v(xbgr.mr_n77749168)
print v(xbgr.mr_n77753968)
print v(xbgr.mr_n78065536)
print v(xbgr.mr_n78175584)
print v(xbgr.mr_n78354112)
print v(xbgr.mr_n74850384)
print v(xbgr.mr_n78841984)
print v(xbgr.mr_n79062976)
print v(xbgr.mr_n79189344)
print v(xbgr.mr_n79375264)
print v(xbgr.mr_n79514000)
print v(xbgr.mr_n79716928)
print v(xbgr.mr_n79964864)
print v(xbgr.mr_n77062656)
print v(xbgr.mr_n80038976)
print v(xbgr.mr_n80364432)
print v(xbgr.mr_n80485760)
print v(xbgr.mr_n80661088)
print v(xbgr.mr_n80876096)
print v(xbgr.mr_n81138560)
print v(xbgr.mr_n81274128)
print v(xbgr.mr_n81501056)
print v(xbgr.mr_n81651296)
print v(xbgr.mr_n82057696)
print v(xbgr.mr_n76265392)
print v(xbgr.mr_n76319680)
print v(xbgr.mr_n75502800)
print v(xbgr.mr_n76436832)
print v(xbgr.mr_n76507152)
print v(xbgr.mr_n76635264)
print v(xbgr.mr_n76710320)
print v(xbgr.mr_n76804304)
print v(xbgr.mr_n77129520)
print v(xbgr.mr_n77337184)
print v(xbgr.mr_n77397536)
print v(xbgr.mr_n77529632)
print v(xbgr.mr_n77676464)
print v(xbgr.mr_n77804528)
print v(xbgr.mr_n77941152)
print v(xbgr.mr_n78173632)
print v(xbgr.mr_n78346992)
print v(xbgr.mr_n75610480)
print v(xbgr.mr_n75819808)
print v(xbgr.mr_n75981680)
print v(xbgr.mr_n76179632)
print v(xbgr.mr_n75610944)
print v(xbgr.mr_n75807296)
print v(xbgr.mr_n75990560)
print v(xbgr.mr_n75522672)
print v(xbgr.mr_n76316576)
print v(xbgr.mr_n75495232)
print v(xbgr.mr_n76387472)
print v(xbgr.mr_n76442976)
print v(xbgr.mr_n76595792)
print v(xbgr.mr_n76718720)
print v(xbgr.mr_n76801760)
print v(xbgr.mr_n76931568)
print v(xbgr.mr_n77065744)
print v(xbgr.mr_n77222304)
print v(xbgr.mr_n77355248)
print v(xbgr.mr_n77472048)
print v(xbgr.mr_n77633776)
print v(xbgr.mr_n77754144)
print v(xbgr.mr_n77950304)
print v(xbgr.mr_n78067344)
print v(xbgr.mr_n78175472)
print v(xbgr.mr_n78344928)
print v(xbgr.mr_n75611408)
print v(xbgr.mr_n75786800)
print v(xbgr.mr_n75982864)
print v(xbgr.mr_n76182272)
print v(xbgr.mr_n75611872)
print v(xbgr.mr_n75784720)
print v(xbgr.mr_n75988784)
print v(xbgr.mr_n75786608)
print v(xbgr.mr_n75612336)
print v(xbgr.mr_n75483760)
print v(xbgr.mr_n75984048)
print v(xbgr.mr_n75947216)
print v(xbgr.mr_n76252352)
print v(xbgr.mr_n75748128)
print v(xbgr.mr_n76373520)
print v(xbgr.mr_n76447264)
print v(xbgr.mr_n75454880)
print v(xbgr.mr_n76692992)
print v(xbgr.mr_n76799952)
print v(xbgr.mr_n76880416)
print v(xbgr.mr_n77050928)
print v(xbgr.mr_n77209072)
print v(xbgr.mr_n77350464)
print v(xbgr.mr_n77465328)
print v(xbgr.mr_n77632000)
print v(xbgr.mr_n77751568)
print v(xbgr.mr_n77835936)
print v(xbgr.mr_n78067232)
print v(xbgr.mr_n78177760)
print v(xbgr.mr_n78347104)
print v(xbgr.mr_n75612800)
print v(xbgr.mr_n75738784)
print v(xbgr.mr_n75992928)
print v(xbgr.mr_n76135616)
print v(xbgr.mr_n74578576)
print v(xbgr.mr_n78832384)
print v(xbgr.mr_n79053456)
print v(xbgr.mr_n79186160)
print v(xbgr.mr_n79397072)
print v(xbgr.mr_n79480640)
print v(xbgr.mr_n79688016)
print v(xbgr.mr_n79961968)
print v(xbgr.mr_n77069632)
print v(xbgr.mr_n80039168)
print v(xbgr.mr_n80325024)
print v(xbgr.mr_n80448224)
print v(xbgr.mr_n80628336)
print v(xbgr.mr_n80880032)
print v(xbgr.mr_n81041776)
print v(xbgr.mr_n81277744)
print v(xbgr.mr_n81498928)
print v(xbgr.mr_n81783728)
print v(xbgr.mr_n81685760)
print v(xbgr.mr_n76261520)
print v(xbgr.mr_n76320608)
print v(xbgr.mr_n75535808)
print v(xbgr.mr_n76435904)
print v(xbgr.mr_n76417824)
print v(xbgr.mr_n76530896)
print v(xbgr.mr_n76709648)
print v(xbgr.mr_n76824912)
print v(xbgr.mr_n77171040)
print v(xbgr.mr_n77244752)
print v(xbgr.mr_n77372240)
print v(xbgr.mr_n77498448)
print v(xbgr.mr_n77693968)
print v(xbgr.mr_n77747568)
print v(xbgr.mr_n77946240)
print v(xbgr.mr_n78173520)
print v(xbgr.mr_n78349760)
print v(xbgr.mr_n75613264)
print v(xbgr.mr_n75781248)
print v(xbgr.mr_n75985232)
print v(xbgr.mr_n76183376)
print v(xbgr.mr_n76317712)
print v(xbgr.mr_n75774640)
print v(xbgr.mr_n76389280)
print v(xbgr.mr_n76496016)
print v(xbgr.mr_n76577840)
print v(xbgr.mr_n76719120)
print v(xbgr.mr_n76806640)
print v(xbgr.mr_n76932208)
print v(xbgr.mr_n77051568)
print v(xbgr.mr_n77224112)
print v(xbgr.mr_n77357056)
print v(xbgr.mr_n77473856)
print v(xbgr.mr_n77634576)
print v(xbgr.mr_n77754944)
print v(xbgr.mr_n77953248)
print v(xbgr.mr_n78058304)
print v(xbgr.mr_n78171344)
print v(xbgr.mr_n78353632)
print v(xbgr.mr_n75613728)
print v(xbgr.mr_n75815072)
print v(xbgr.mr_n75994112)
print v(xbgr.mr_n76217680)
print v(xbgr.mr_n75614192)
print v(xbgr.mr_n75731712)
print v(xbgr.mr_n75986416)
print v(xbgr.mr_n75570016)
print v(xbgr.mr_n75614656)
print v(xbgr.mr_n75533136)
print v(xbgr.mr_n75995296)
print v(xbgr.mr_n76211168)
print v(xbgr.mr_n75615120)
print v(xbgr.mr_n75676688)
print v(xbgr.mr_n75987600)
print v(xbgr.mr_n76186448)
print v(xbgr.mr_n75615584)
print v(xbgr.mr_n75810928)
print v(xbgr.mr_n75996480)
print v(xbgr.mr_n76226496)
print v(xbgr.mr_n75606768)
print v(xbgr.mr_n75785248)
print v(xbgr.mr_n75991744)
print v(xbgr.mr_n76226608)
print v(xbgr.mr_n75616512)
print v(xbgr.mr_n75821120)
print v(xbgr.mr_n75997664)
print v(xbgr.mr_n75523232)
print v(xbgr.mr_n75616976)
print v(xbgr.mr_n75821472)
print v(xbgr.mr_n75989968)
print v(xbgr.mr_n76228256)
print v(xbgr.mr_n76447440)
print v(xbgr.mr_n77949472)
print v(xbgr.mr_n78177536)
print v(xbgr.mr_n78358096)
print v(xbgr.mr_n75617440)
print v(xbgr.mr_n75822112)
print v(xbgr.mr_n75998848)
print v(xbgr.mr_n76228720)
print v(xbgr.d5)
print v(xbgr.d1)
print v(xbgr.mr_n76442864)
print v(xbgr.mr_n76806864)
print v(xbgr.mr_n76315312)
print v(xbgr.mr_n76362576)
print v(xbgr.mr_n76807136)
print v(xbgr.mr_n77952336)
print v(xbgr.n1)
print v(xbgr.mr_n78357728)
print v(xbgr.mr_n75617904)
print v(xbgr.mr_n75823088)
print v(xbgr.mr_n75991152)
print v(xbgr.mr_n76229184)
print v(xbgr.mr_n77753168)
print v(xbgr.mr_n77978144)
print v(xbgr.mr_n78194928)
print v(xbgr.mr_n76258736)
print v(xbgr.mr_n76350848)
print v(xbgr.kick)
print v(xbgr.mr_n76651552)
print v(xbgr.mr_n77950816)
print v(xbgr.mr_n78122816)
print v(xbgr.mr_n78349648)
print v(xbgr.mr_n75618368)
print v(xbgr.mr_n75823872)
print v(xbgr.mr_n76000032)
print v(xbgr.mr_n76231104)
print v(xbgr.mr_n75618832)
print v(xbgr.mr_n75784272)
print v(xbgr.mr_n75992336)
print v(xbgr.mr_n76209312)
print v(xbgr.mr_n76314288)
print v(xbgr.mr_n76389792)
print v(xbgr.mr_n76450848)
print v(xbgr.mr_n76804608)
print v(xbgr.mr_n77953760)
print v(xbgr.mr_n78181664)
print v(xbgr.mr_n78357616)
print v(xbgr.mr_n76911552)
print v(xbgr.mr_n77082288)
print v(xbgr.mr_n77142240)
print v(xbgr.mr_n77166304)
print v(xbgr.mr_n77452672)
print v(xbgr.mr_n77600400)
print v(xbgr.mr_n77718640)
print v(xbgr.mr_n76928768)
print v(xbgr.mr_n77082672)
print v(xbgr.mr_n77149168)
print v(xbgr.mr_n77222896)
print v(xbgr.mr_n77472560)
print v(xbgr.mr_n77603872)
print v(xbgr.mr_n77714128)
print v(xbgr.mr_n75619296)
print v(xbgr.mr_n75824992)
print v(xbgr.mr_n76001216)
print v(xbgr.mr_n76232416)
print v(xbgr.mr_n77948368)
print v(xbgr.mr_n78030128)
print v(xbgr.mr_n78361712)
print v(xbgr.mr_n76833600)
print v(xbgr.mr_n76963696)
print v(xbgr.mr_n77048192)
print v(xbgr.mr_n77163376)
print v(xbgr.mr_n77371088)
print v(xbgr.mr_n77497296)
print v(xbgr.mr_n77629600)
print v(xbgr.mr_n77767488)
print v(xbgr.mr_n77996240)
print v(xbgr.mr_n78198992)
print v(xbgr.mr_n75619760)
print v(xbgr.mr_n75825648)
print v(xbgr.mr_n75993520)
print v(xbgr.mr_n76178208)
print v(xbgr.mr_n77950928)
print v(xbgr.mr_n78123408)
print v(xbgr.mr_n78362080)
print v(xbgr.mr_n76473920)
print v(xbgr.mr_n76930416)
print v(xbgr.d2)
print v(xbgr.mr_n77152128)
print v(xbgr.mr_n77219280)
print v(xbgr.mr_n77470752)
print v(xbgr.mr_n77566816)
print v(xbgr.mr_n77676800)
print v(xbgr.mr_n76318560)
print v(xbgr.mr_n76389904)
print v(xbgr.mr_n76809360)
print v(xbgr.mr_n75620224)
print v(xbgr.mr_n75826176)
print v(xbgr.mr_n76002400)
print v(xbgr.mr_n76233472)
print v(xbgr.mr_n76318672)
print v(xbgr.mr_n76364848)
print v(xbgr.mr_n76810176)
print v(xbgr.mr_n77955152)
print v(xbgr.mr_n78177648)
print v(xbgr.mr_n78361600)
print v(xbgr.mr_n76473072)
print v(xbgr.mr_n75616048)
print v(xbgr.mr_n75788928)
print v(xbgr.mr_n75994704)
print v(xbgr.mr_n76223600)
print v(xbgr.mr_n76259280)
print v(xbgr.mr_n76350576)
print v(xbgr.mr_n76695248)
print v(xbgr.det)
print v(xbgr.mr_n77955952)
print v(xbgr.mr_n78124592)
print v(xbgr.mr_n78350128)
print v(xbgr.mr_n76411968)
print v(xbgr.mr_n75621152)
print v(xbgr.mr_n75827344)
print v(xbgr.mr_n76003584)
print v(xbgr.mr_n76234128)
print v(xbgr.mr_n77769264)
print v(xbgr.mr_n77995776)
print v(xbgr.mr_n78200848)
print v(xbgr.mr_n76318448)
print v(xbgr.mr_n76377136)
print v(xbgr.mr_n76801872)
print v(xbgr.mr_n77953872)
print v(xbgr.mr_n78032272)
print v(xbgr.mr_n78364784)
print v(xbgr.mr_n76932816)
print v(xbgr.mr_n77082480)
print v(xbgr.mr_n77150384)
print v(xbgr.mr_n77210240)
print v(xbgr.mr_n77467136)
print v(xbgr.mr_n77590704)
print v(xbgr.mr_n77726800)
print v(xbgr.mr_n76932592)
print v(xbgr.mr_n77041440)
print v(xbgr.mr_n77142128)
print v(xbgr.mr_n77224816)
print v(xbgr.mr_n77474592)
print v(xbgr.mr_n77597520)
print v(xbgr.mr_n77722576)
print v(xbgr.mr_n75621616)
print v(xbgr.mr_n75472496)
print v(xbgr.mr_n75995888)
print v(xbgr.mr_n76234720)
print v(xbgr.mr_n76856880)
print v(xbgr.mr_n76965616)
print v(xbgr.mr_n77048720)
print v(xbgr.mr_n77171856)
print v(xbgr.mr_n77375120)
print v(xbgr.mr_n77501328)
print v(xbgr.mr_n77635120)
print v(xbgr.mr_n77957312)
print v(xbgr.mr_n78184208)
print v(xbgr.mr_n78353744)
print v(xbgr.mr_n75622080)
print v(xbgr.mr_n75828592)
print v(xbgr.mr_n76004768)
print v(xbgr.mr_n76240368)
print v(xbgr.mr_n77955040)
print v(xbgr.mr_n78119344)
print v(xbgr.mr_n78366288)
print v(xbgr.mr_n75622544)
print v(xbgr.mr_n75829184)
print v(xbgr.mr_n75997072)
print v(xbgr.mr_n76181104)
print v(xbgr.mr_n76472096)
print v(xbgr.mr_n76932480)
print v(xbgr.mr_n77083632)
print v(xbgr.mr_n77081696)
print v(xbgr.mr_n77224928)
print v(xbgr.mr_n77475088)
print v(xbgr.mr_n77566224)
print v(xbgr.mr_n77692848)
print v(xbgr.mr_n76319296)
print v(xbgr.mr_n76390864)
print v(xbgr.mr_n76810864)
print v(xbgr.mr_n77771120)
print v(xbgr.mr_n77995312)
print v(xbgr.mr_n78202704)
print v(xbgr.mr_n76316160)
print v(xbgr.mr_n76378944)
print v(xbgr.mr_n76811488)
print v(xbgr.mr_n77957424)
print v(xbgr.mr_n78125184)
print v(xbgr.mr_n78368752)
print v(xbgr.mr_n75623008)
print v(xbgr.mr_n75829776)
print v(xbgr.mr_n76005952)
print v(xbgr.mr_n76240704)
print v(xbgr.mr_n76450256)
print v(xbgr.mr_n76259008)
print v(xbgr.mr_n76350304)
print v(xbgr.mr_n76410928)
print v(xbgr.mr_n76695520)
print v(xbgr.r4n)
print v(xbgr.mr_n75623472)
print v(xbgr.mr_n75830336)
print v(xbgr.mr_n75998256)
print v(xbgr.mr_n76240816)
print v(xbgr.mr_n77957984)
print v(xbgr.mr_n78185840)
print v(xbgr.mr_n78364672)
print v(xbgr.mr_n76317360)
print v(xbgr.mr_n76391600)
print v(xbgr.mr_n76812016)
print v(xbgr.mr_n76932704)
print v(xbgr.mr_n77071360)
print v(xbgr.mr_n77152544)
print v(xbgr.mr_n77217472)
print v(xbgr.mr_n77474480)
print v(xbgr.mr_n77579232)
print v(xbgr.mr_n77722160)
print v(xbgr.mr_n76933776)
print v(xbgr.mr_n76902576)
print v(xbgr.mr_n77150272)
print v(xbgr.mr_n77196032)
print v(xbgr.mr_n77474976)
print v(xbgr.mr_n77600816)
print v(xbgr.mr_n77713904)
print v(xbgr.mr_n75623936)
print v(xbgr.mr_n75830928)
print v(xbgr.mr_n76007136)
print v(xbgr.mr_n76231760)
print v(xbgr.mr_n77952160)
print v(xbgr.mr_n78128144)
print v(xbgr.mr_n78372128)
print v(xbgr.mr_n77772976)
print v(xbgr.mr_n77994848)
print v(xbgr.mr_n78204560)
print v(xbgr.mr_n76856416)
print v(xbgr.mr_n76965088)
print v(xbgr.mr_n77037728)
print v(xbgr.mr_n77107376)
print v(xbgr.mr_n77375936)
print v(xbgr.mr_n77502144)
print v(xbgr.mr_n77635536)
print v(xbgr.mr_n75624400)
print v(xbgr.mr_n75815584)
print v(xbgr.mr_n75999440)
print v(xbgr.mr_n76241040)
print v(xbgr.mr_n77959488)
print v(xbgr.mr_n78126960)
print v(xbgr.mr_n78369744)
print v(xbgr.mr_n75624864)
print v(xbgr.mr_n75832032)
print v(xbgr.mr_n76008320)
print v(xbgr.mr_n76241152)
print v(xbgr.mr_n76471200)
print v(xbgr.mr_n76934864)
print v(xbgr.mr_n77049648)
print v(xbgr.mr_n77149360)
print v(xbgr.mr_n77225344)
print v(xbgr.mr_n77475552)
print v(xbgr.mr_n77563856)
print v(xbgr.mr_n77690416)
print v(xbgr.mr_n77961456)
print v(xbgr.mr_n78183152)
print v(xbgr.mr_n78367008)
print v(xbgr.mr_n76320032)
print v(xbgr.mr_n76391712)
print v(xbgr.mr_n76809664)
print v(xbgr.mr_n76320272)
print v(xbgr.mr_n76392080)
print v(xbgr.mr_n76813056)
print v(xbgr.mr_n75625328)
print v(xbgr.mr_n75806192)
print v(xbgr.mr_n76000624)
print v(xbgr.mr_n76241616)
print v(xbgr.mr_n77962672)
print v(xbgr.mr_n78126368)
print v(xbgr.mr_n78371312)
print v(xbgr.mr_n76464992)
print v(xbgr.mr_n76258464)
print v(xbgr.mr_n76350032)
print v(xbgr.mr_n76695056)
print v(xbgr.mr_n76408832)
print v(xbgr.mr_n77774832)
print v(xbgr.mr_n77994384)
print v(xbgr.mr_n78206416)
print v(xbgr.mr_n75604912)
print v(xbgr.mr_n75833296)
print v(xbgr.mr_n76009504)
print v(xbgr.mr_n76241888)
print v(xbgr.mr_n76447936)
print v(xbgr.mr_n77963616)
print v(xbgr.mr_n78130512)
print v(xbgr.mr_n78373872)
print v(xbgr.mr_n76318336)
print v(xbgr.mr_n76391248)
print v(xbgr.mr_n76810512)
print v(xbgr.mr_n75626256)
print v(xbgr.mr_n75826832)
print v(xbgr.mr_n76001808)
print v(xbgr.mr_n76242160)
print v(xbgr.mr_n76932928)
print v(xbgr.mr_n77063792)
print v(xbgr.mr_n77154368)
print v(xbgr.mr_n77225152)
print v(xbgr.mr_n77374464)
print v(xbgr.mr_n77601632)
print v(xbgr.mr_n77718528)
print v(xbgr.mr_n76935584)
print v(xbgr.mr_n77083440)
print v(xbgr.mr_n77140944)
print v(xbgr.mr_n77225888)
print v(xbgr.mr_n77476656)
print v(xbgr.mr_n77597408)
print v(xbgr.mr_n77723392)
print v(xbgr.mr_n77964032)
print v(xbgr.mr_n78187936)
print v(xbgr.mr_n78369568)
print v(xbgr.mr_n75626720)
print v(xbgr.mr_n75834480)
print v(xbgr.mr_n76010688)
print v(xbgr.mr_n76242432)
print v(xbgr.mr_n76855952)
print v(xbgr.mr_n76964624)
print v(xbgr.mr_n77087440)
print v(xbgr.mr_n77131344)
print v(xbgr.mr_n77376752)
print v(xbgr.mr_n77502960)
print v(xbgr.mr_n77636352)
print v(xbgr.mr_n77964960)
print v(xbgr.mr_n78129328)
print v(xbgr.mr_n78372304)
print v(xbgr.mr_n75627184)
print v(xbgr.mr_n75828000)
print v(xbgr.mr_n76002992)
print v(xbgr.mr_n76242704)
print v(xbgr.mr_n77776688)
print v(xbgr.mr_n77993936)
print v(xbgr.mr_n78208304)
print v(xbgr.mr_n76933552)
print v(xbgr.mr_n77086112)
print v(xbgr.mr_n77138592)
print v(xbgr.mr_n77226160)
print v(xbgr.mr_n77478064)
print v(xbgr.mr_n77561488)
print v(xbgr.mr_n77689296)
print v(xbgr.mr_n77965904)
print v(xbgr.mr_n78127552)
print v(xbgr.mr_n78374864)
print v(xbgr.mr_n76317536)
print v(xbgr.mr_n76394032)
print v(xbgr.d3)
print v(xbgr.mr_n76809472)
print v(xbgr.mr_n76309040)
print v(xbgr.mr_n76393184)
print v(xbgr.mr_n76636224)
print v(xbgr.mr_n76795968)
print v(xbgr.mr_n75627648)
print v(xbgr.mr_n75835664)
print v(xbgr.mr_n76011808)
print v(xbgr.mr_n76227552)
print v(xbgr.mr_n76258192)
print v(xbgr.mr_n76349760)
print v(xbgr.mr_n76178544)
print v(xbgr.mr_n76693872)
print v(xbgr.mr_n77966432)
print v(xbgr.mr_n78190656)
print v(xbgr.mr_n78367184)
print v(xbgr.mr_n75628112)
print v(xbgr.mr_n75836256)
print v(xbgr.mr_n76011280)
print v(xbgr.mr_n76243168)
print v(xbgr.mr_n77964704)
print v(xbgr.mr_n78125776)
print v(xbgr.mr_n78379808)
print v(xbgr.mr_n75605376)
print v(xbgr.mr_n75836784)
print v(xbgr.mr_n76013056)
print v(xbgr.mr_n76243952)
print v(xbgr.mr_n76313856)
print v(xbgr.mr_n76390512)
print v(xbgr.mr_n76603936)
print v(xbgr.mr_n76815088)
print v(xbgr.mr_n76933200)
print v(xbgr.mr_n77050368)
print v(xbgr.mr_n77150160)
print v(xbgr.mr_n77225040)
print v(xbgr.mr_n77358176)
print v(xbgr.mr_n77477632)
print v(xbgr.mr_n77596992)
print v(xbgr.mr_n77719344)
print v(xbgr.mr_n76936880)
print v(xbgr.mr_n77076256)
print v(xbgr.mr_n77138816)
print v(xbgr.mr_n77226752)
print v(xbgr.mr_n77346336)
print v(xbgr.mr_n77479168)
print v(xbgr.mr_n77583888)
print v(xbgr.mr_n77718176)
print v(xbgr.mr_n77778544)
print v(xbgr.mr_n77993472)
print v(xbgr.mr_n78210672)
print v(xbgr.mr_n77967312)
print v(xbgr.mr_n78124000)
print v(xbgr.mr_n78378992)
print v(xbgr.mr_n75629040)
print v(xbgr.mr_n75831520)
print v(xbgr.mr_n76005360)
print v(xbgr.mr_n76244352)
print v(xbgr.mr_n76855488)
print v(xbgr.mr_n76964160)
print v(xbgr.mr_n77088256)
print v(xbgr.mr_n77118864)
print v(xbgr.mr_n77249456)
print v(xbgr.mr_n77377568)
print v(xbgr.mr_n77503776)
print v(xbgr.mr_n77637168)
print v(xbgr.mr_n75629504)
print v(xbgr.mr_n75837952)
print v(xbgr.mr_n76014240)
print v(xbgr.mr_n76244752)
print v(xbgr.mr_n77966544)
print v(xbgr.mr_n78191744)
print v(xbgr.mr_n78374688)
print v(xbgr.mr_n76936384)
print v(xbgr.mr_n77043248)
print v(xbgr.mr_n77149552)
print v(xbgr.mr_n77221088)
print v(xbgr.mr_n77357904)
print v(xbgr.mr_n77477152)
print v(xbgr.mr_n77564448)
print v(xbgr.mr_n77688640)
print v(xbgr.mr_n76299968)
print v(xbgr.mr_n76395600)
print v(xbgr.mr_n76633952)
print v(xbgr.mr_n76814624)
print v(xbgr.mr_n76315424)
print v(xbgr.mr_n76396288)
print v(xbgr.mr_n76634480)
print v(xbgr.mr_n76816192)
print v(xbgr.mr_n75620688)
print v(xbgr.mr_n75838624)
print v(xbgr.mr_n76006544)
print v(xbgr.mr_n76245152)
print v(xbgr.mr_n77966320)
print v(xbgr.mr_n78122224)
print v(xbgr.mr_n78377424)
print v(xbgr.mr_n77779472)
print v(xbgr.mr_n77993008)
print v(xbgr.mr_n78211856)
print v(xbgr.mr_n75630432)
print v(xbgr.mr_n75839216)
print v(xbgr.mr_n76015424)
print v(xbgr.mr_n76245952)
print v(xbgr.mr_n76257920)
print v(xbgr.mr_n76349488)
print v(xbgr.mr_n76133744)
print v(xbgr.mr_n76692688)
print v(xbgr.mr_n77970016)
print v(xbgr.mr_n78119232)
print v(xbgr.mr_n78379984)
print v(xbgr.mr_n75630896)
print v(xbgr.mr_n75839808)
print v(xbgr.mr_n76007728)
print v(xbgr.mr_n76246352)
print v(xbgr.mr_n76306576)
print v(xbgr.mr_n76395184)
print v(xbgr.mr_n76603664)
print v(xbgr.mr_n76812368)
print v(xbgr.mr_n77970864)
print v(xbgr.mr_n78187392)
print v(xbgr.mr_n78377248)
print v(xbgr.mr_n76935920)
print v(xbgr.mr_n77077024)
print v(xbgr.mr_n77139040)
print v(xbgr.mr_n77227504)
print v(xbgr.mr_n77353696)
print v(xbgr.mr_n77480048)
print v(xbgr.mr_n77594000)
print v(xbgr.mr_n77709792)
print v(xbgr.mr_n76935216)
print v(xbgr.mr_n77036544)
print v(xbgr.mr_n77147168)
print v(xbgr.mr_n77216720)
print v(xbgr.mr_n77358864)
print v(xbgr.mr_n77476288)
print v(xbgr.mr_n77598224)
print v(xbgr.mr_n77313216)
print v(xbgr.mr_n75631360)
print v(xbgr.mr_n75840400)
print v(xbgr.mr_n76016608)
print v(xbgr.mr_n76246752)
print v(xbgr.mr_n77971680)
print v(xbgr.mr_n78118896)
print v(xbgr.mr_n78384928)
print v(xbgr.mr_n76855024)
print v(xbgr.mr_n76963232)
print v(xbgr.mr_n77089200)
print v(xbgr.mr_n77172400)
print v(xbgr.mr_n77251920)
print v(xbgr.mr_n77378384)
print v(xbgr.mr_n77504592)
print v(xbgr.mr_n77637984)
print v(xbgr.mr_n77779008)
print v(xbgr.mr_n77992544)
print v(xbgr.mr_n78211264)
print v(xbgr.mr_n75631824)
print v(xbgr.mr_n75835072)
print v(xbgr.mr_n76008912)
print v(xbgr.mr_n76240928)
print v(xbgr.mr_n77972624)
print v(xbgr.mr_n78119008)
print v(xbgr.mr_n78382544)
print v(xbgr.mr_n76938752)
print v(xbgr.mr_n77032832)
print v(xbgr.mr_n77138704)
print v(xbgr.mr_n77230224)
print v(xbgr.mr_n77354592)
print v(xbgr.mr_n77482832)
print v(xbgr.mr_n77562080)
print v(xbgr.mr_n77685744)
print v(xbgr.mr_n75632288)
print v(xbgr.mr_n75841504)
print v(xbgr.mr_n76017792)
print v(xbgr.mr_n76247472)
print v(xbgr.mr_n76314464)
print v(xbgr.mr_n76397168)
print v(xbgr.mr_n76543760)
print v(xbgr.mr_n76813936)
print v(xbgr.mr_n76312400)
print v(xbgr.mr_n76393616)
print v(xbgr.mr_n76548528)
print v(xbgr.mr_n76817760)
print v(xbgr.mr_n77973152)
print v(xbgr.mr_n78194384)
print v(xbgr.mr_n78376432)
print v(xbgr.mr_n75632752)
print v(xbgr.mr_n75824464)
print v(xbgr.mr_n76010096)
print v(xbgr.mr_n76248352)
print v(xbgr.mr_n76257648)
print v(xbgr.mr_n76349216)
print v(xbgr.mr_n76431776)
print v(xbgr.mr_n76691504)
print v(xbgr.mr_n77968656)
print v(xbgr.mr_n78119120)
print v(xbgr.mr_n78384112)
print v(xbgr.mr_n75628576)
print v(xbgr.mr_n75842768)
print v(xbgr.mr_n76018976)
print v(xbgr.mr_n76245552)
print v(xbgr.mr_n77778080)
print v(xbgr.mr_n77992080)
print v(xbgr.mr_n78210080)
print v(xbgr.mr_n76313008)
print v(xbgr.mr_n76396816)
print v(xbgr.mr_n76603392)
print v(xbgr.mr_n76818288)
print v(xbgr.mr_n76939440)
print v(xbgr.mr_n77024704)
print v(xbgr.mr_n77139152)
print v(xbgr.mr_n77227936)
print v(xbgr.mr_n77358752)
print v(xbgr.mr_n77481168)
print v(xbgr.mr_n77594816)
print v(xbgr.mr_n77714016)
print v(xbgr.mr_n77968832)
print v(xbgr.mr_n78028176)
print v(xbgr.mr_n78386672)
print v(xbgr.mr_n76938032)
print v(xbgr.mr_n77079568)
print v(xbgr.mr_n77139968)
print v(xbgr.mr_n77229792)
print v(xbgr.mr_n77359776)
print v(xbgr.mr_n77478480)
print v(xbgr.mr_n77593584)
print v(xbgr.mr_n77717280)
print v(xbgr.mr_n75633680)
print v(xbgr.mr_n75837440)
print v(xbgr.mr_n76004176)
print v(xbgr.mr_n76249152)
print v(xbgr.mr_n76854560)
print v(xbgr.mr_n76962768)
print v(xbgr.mr_n77089664)
print v(xbgr.mr_n77172128)
print v(xbgr.mr_n77252736)
print v(xbgr.mr_n77379200)
print v(xbgr.mr_n77505408)
print v(xbgr.mr_n77638800)
print v(xbgr.mr_n75600272)
print v(xbgr.mr_n75843872)
print v(xbgr.mr_n76020160)
print v(xbgr.mr_n76249552)
print v(xbgr.mr_n77975184)
print v(xbgr.mr_n78192288)
print v(xbgr.mr_n78321216)
print v(xbgr.mr_n77976112)
print v(xbgr.mr_n78114448)
print v(xbgr.mr_n78320976)
print v(xbgr.mr_n75599872)
print v(xbgr.mr_n75732864)
print v(xbgr.mr_n75954224)
print v(xbgr.mr_n76249952)
print v(xbgr.mr_n76941200)
print v(xbgr.mr_n77063056)
print v(xbgr.mr_n77155200)
print v(xbgr.mr_n77231328)
print v(xbgr.mr_n77360672)
print v(xbgr.mr_n77481792)
print v(xbgr.mr_n77563264)
print v(xbgr.mr_n77686864)
print v(xbgr.mr_n76311712)
print v(xbgr.mr_n76398736)
print v(xbgr.mr_n76591200)
print v(xbgr.mr_n76815504)
print v(xbgr.mr_n76312832)
print v(xbgr.mr_n76399424)
print v(xbgr.mr_n76632000)
print v(xbgr.mr_n76819328)
print v(xbgr.mr_n77777616)
print v(xbgr.mr_n77991616)
print v(xbgr.mr_n78209488)
print v(xbgr.mr_n77974032)
print v(xbgr.mr_n78028320)
print v(xbgr.mr_n78387488)
print v(xbgr.mr_n75599472)
print v(xbgr.mr_n75845136)
print v(xbgr.mr_n75953632)
print v(xbgr.mr_n76248752)
print v(xbgr.mr_n76257376)
print v(xbgr.mr_n76348944)
print v(xbgr.mr_n76415328)
print v(xbgr.mr_n76690320)
print v(xbgr.mr_n75599008)
print v(xbgr.mr_n75845728)
print v(xbgr.mr_n75953040)
print v(xbgr.mr_n76251072)
print v(xbgr.mr_n77977472)
print v(xbgr.mr_n78192832)
print v(xbgr.mr_n78304432)
print v(xbgr.mr_n76309888)
print v(xbgr.mr_n76394720)
print v(xbgr.mr_n76602304)
print v(xbgr.mr_n76819856)
print v(xbgr.mr_n76941024)
print v(xbgr.mr_n77068464)
print v(xbgr.mr_n77156624)
print v(xbgr.mr_n77232208)
print v(xbgr.mr_n77361360)
print v(xbgr.mr_n77480480)
print v(xbgr.mr_n77587296)
print v(xbgr.mr_n77199504)
print v(xbgr.mr_n75598560)
print v(xbgr.mr_n75846320)
print v(xbgr.mr_n75952448)
print v(xbgr.mr_n76251552)
print v(xbgr.mr_n76941920)
print v(xbgr.mr_n77058720)
print v(xbgr.mr_n77140080)
print v(xbgr.mr_n77226512)
print v(xbgr.mr_n77359952)
print v(xbgr.mr_n77485872)
print v(xbgr.mr_n77590592)
print v(xbgr.mr_n77713200)
print v(xbgr.mr_n77975856)
print v(xbgr.mr_n78118592)
print v(xbgr.mr_n78381552)
print v(xbgr.mr_n77777152)
print v(xbgr.mr_n77991152)
print v(xbgr.mr_n78208896)
print v(xbgr.mr_n75598096)
print v(xbgr.mr_n75846912)
print v(xbgr.mr_n75842176)
print v(xbgr.mr_n76251952)
print v(xbgr.mr_n76854096)
print v(xbgr.mr_n76961840)
print v(xbgr.mr_n77088800)
print v(xbgr.mr_n77171584)
print v(xbgr.mr_n77253552)
print v(xbgr.mr_n77378928)
print v(xbgr.mr_n77505136)
print v(xbgr.mr_n77638528)
print v(xbgr.mr_n77979648)
print v(xbgr.mr_n78035184)
print v(xbgr.mr_n78382368)
print v(xbgr.mr_n75597632)
print v(xbgr.mr_n75847504)
print v(xbgr.mr_n75951264)
print v(xbgr.mr_n76240480)
print v(xbgr.mr_n76942256)
print v(xbgr.mr_n77033600)
print v(xbgr.mr_n77156320)
print v(xbgr.mr_n77234992)
print v(xbgr.mr_n77363120)
print v(xbgr.mr_n77483184)
print v(xbgr.mr_n77500672)
print v(xbgr.mr_n77687520)
print v(xbgr.mr_n76311536)
print v(xbgr.mr_n76400304)
print v(xbgr.mr_n76630912)
print v(xbgr.mr_n76813584)
print v(xbgr.mr_n77969408)
print v(xbgr.mr_n78190112)
print v(xbgr.mr_n78387664)
print v(xbgr.mr_n76310320)
print v(xbgr.mr_n76390400)
print v(xbgr.mr_n76548784)
print v(xbgr.mr_n76817072)
print v(xbgr.mr_n75597168)
print v(xbgr.mr_n75848096)
print v(xbgr.mr_n75949264)
print v(xbgr.mr_n76253072)
print v(xbgr.mr_n77977056)
print v(xbgr.mr_n77912432)
print v(xbgr.mr_n78305744)
print v(xbgr.mr_n76257104)
print v(xbgr.mr_n76348752)
print v(xbgr.mr_n76095328)
print v(xbgr.mr_n76689136)
print v(xbgr.mr_n75596704)
print v(xbgr.mr_n75848688)
print v(xbgr.mr_n76012464)
print v(xbgr.mr_n76090416)
print v(xbgr.mr_n77776224)
print v(xbgr.mr_n77990688)
print v(xbgr.mr_n78207808)
print v(xbgr.mr_n77974368)
print v(xbgr.mr_n78115040)
print v(xbgr.mr_n78275200)
print v(xbgr.mr_n76310496)
print v(xbgr.mr_n76399952)
print v(xbgr.mr_n76602112)
print v(xbgr.mr_n76821360)
print v(xbgr.mr_n75596240)
print v(xbgr.mr_n75849280)
print v(xbgr.mr_n76026544)
print v(xbgr.mr_n76089824)
print v(xbgr.mr_n76940048)
print v(xbgr.mr_n76951808)
print v(xbgr.mr_n77140432)
print v(xbgr.mr_n77230640)
print v(xbgr.mr_n77362944)
print v(xbgr.mr_n77487040)
print v(xbgr.mr_n77590176)
print v(xbgr.mr_n77712736)
print v(xbgr.mr_n76939088)
print v(xbgr.mr_n77044432)
print v(xbgr.mr_n77158816)
print v(xbgr.mr_n77236032)
print v(xbgr.mr_n77363840)
print v(xbgr.mr_n77488576)
print v(xbgr.mr_n77578448)
print v(xbgr.mr_n77313104)
print v(xbgr.mr_n77975296)
print v(xbgr.mr_n78191200)
print v(xbgr.mr_n78280688)
print v(xbgr.mr_n75595776)
print v(xbgr.mr_n75849872)
print v(xbgr.mr_n76019568)
print v(xbgr.mr_n76089232)
print v(xbgr.mr_n76853632)
print v(xbgr.mr_n76961376)
print v(xbgr.mr_n77088528)
print v(xbgr.mr_n77171312)
print v(xbgr.mr_n77254368)
print v(xbgr.mr_n77378656)
print v(xbgr.mr_n77504864)
print v(xbgr.mr_n77638256)
print v(xbgr.mr_n77973040)
print v(xbgr.mr_n78117408)
print v(xbgr.mr_n78385104)
print v(xbgr.mr_n75595312)
print v(xbgr.mr_n75843360)
print v(xbgr.mr_n76024512)
print v(xbgr.mr_n76088640)
print v(xbgr.mr_n77775760)
print v(xbgr.mr_n77990224)
print v(xbgr.mr_n78207344)
print v(xbgr.mr_n76936272)
print v(xbgr.mr_n77074096)
print v(xbgr.mr_n77155888)
print v(xbgr.mr_n77229248)
print v(xbgr.mr_n77359296)
print v(xbgr.mr_n77486560)
print v(xbgr.mr_n77558528)
print v(xbgr.mr_n77685088)
print v(xbgr.mr_n76307248)
print v(xbgr.mr_n76401872)
print v(xbgr.mr_n76631888)
print v(xbgr.mr_n76816720)
print v(xbgr.mr_n77969840)
print v(xbgr.mr_n78118000)
print v(xbgr.mr_n78308624)
print v(xbgr.mr_n76308864)
print v(xbgr.mr_n76400992)
print v(xbgr.mr_n76590432)
print v(xbgr.mr_n76820896)
print v(xbgr.mr_n75594848)
print v(xbgr.mr_n75851056)
print v(xbgr.mr_n76028944)
print v(xbgr.mr_n76088048)
print v(xbgr.mr_n76256832)
print v(xbgr.mr_n76348000)
print v(xbgr.mr_n76470160)
print v(xbgr.mr_n76687952)
print v(xbgr.mr_n75594384)
print v(xbgr.mr_n75844544)
print v(xbgr.mr_n76027744)
print v(xbgr.mr_n76087456)
print v(xbgr.mr_n77970752)
print v(xbgr.mr_n78309616)
print v(xbgr.mr_n75593920)
print v(xbgr.mr_n75852176)
print v(xbgr.mr_n76030544)
print v(xbgr.mr_n76086864)
print v(xbgr.mr_n77971424)
print v(xbgr.mr_n78265392)
print v(xbgr.mr_n76308432)
print v(xbgr.mr_n76397856)
print v(xbgr.mr_n76602000)
print v(xbgr.mr_n76820208)
print v(xbgr.mr_n76934208)
print v(xbgr.mr_n77045632)
print v(xbgr.mr_n77146672)
print v(xbgr.mr_n77233328)
print v(xbgr.mr_n77364528)
print v(xbgr.mr_n77489456)
print v(xbgr.mr_n77587184)
print v(xbgr.mr_n77713088)
print v(xbgr.mr_n76937856)
print v(xbgr.mr_n77071552)
print v(xbgr.mr_n77160368)
print v(xbgr.mr_n77238032)
print v(xbgr.mr_n77361472)
print v(xbgr.mr_n77485184)
print v(xbgr.mr_n77591408)
print v(xbgr.mr_n77694624)
print v(xbgr.mr_n77775296)
print v(xbgr.mr_n78206880)
print v(xbgr.mr_n75593456)
print v(xbgr.mr_n75852832)
print v(xbgr.mr_n76030944)
print v(xbgr.mr_n76086272)
print v(xbgr.mr_n77967648)
print v(xbgr.mr_n78315024)
print v(xbgr.mr_n76853168)
print v(xbgr.mr_n76960448)
print v(xbgr.mr_n77087984)
print v(xbgr.mr_n77170768)
print v(xbgr.mr_n77254912)
print v(xbgr.mr_n77378112)
print v(xbgr.mr_n77504320)
print v(xbgr.mr_n77637712)
print v(xbgr.mr_n75588352)
print v(xbgr.mr_n75853424)
print v(xbgr.mr_n76032144)
print v(xbgr.mr_n76085600)
print v(xbgr.mr_n77958240)
print v(xbgr.mr_n78284864)
print v(xbgr.mr_n76933664)
print v(xbgr.mr_n77066384)
print v(xbgr.mr_n77161776)
print v(xbgr.mr_n77237344)
print v(xbgr.mr_n77363472)
print v(xbgr.mr_n77492240)
print v(xbgr.mr_n77557936)
print v(xbgr.mr_n77607632)
print v(xbgr.mr_n76305888)
print v(xbgr.mr_n76403440)
print v(xbgr.mr_n76628304)
print v(xbgr.mr_n76818640)
print v(xbgr.mr_n75592528)
print v(xbgr.mr_n75854016)
print v(xbgr.mr_n76032944)
print v(xbgr.mr_n76076208)
print v(xbgr.mr_n76304064)
print v(xbgr.mr_n76402560)
print v(xbgr.mr_n76631392)
print v(xbgr.mr_n76822464)
print v(xbgr.mr_n77959664)
print v(xbgr.mr_n78309216)
print v(xbgr.mr_n77774368)
print v(xbgr.mr_n78205952)
print v(xbgr.mr_n75592064)
print v(xbgr.mr_n75854608)
print v(xbgr.mr_n76033344)
print v(xbgr.mr_n76084496)
print v(xbgr.mr_n76256560)
print v(xbgr.mr_n76345888)
print v(xbgr.mr_n76467536)
print v(xbgr.mr_n76686768)
print v(xbgr.mr_n77959056)
print v(xbgr.mr_n78291904)
print v(xbgr.mr_n75591600)
print v(xbgr.mr_n75832704)
print v(xbgr.mr_n76032544)
print v(xbgr.mr_n76041984)
print v(xbgr.mr_n76306688)
print v(xbgr.mr_n76403024)
print v(xbgr.mr_n76588080)
print v(xbgr.mr_n76821776)
print v(xbgr.mr_n76925824)
print v(xbgr.mr_n77078800)
print v(xbgr.mr_n77158032)
print v(xbgr.mr_n77235344)
print v(xbgr.mr_n77366112)
print v(xbgr.mr_n77490576)
print v(xbgr.mr_n77586768)
print v(xbgr.mr_n77710496)
print v(xbgr.mr_n77964144)
print v(xbgr.mr_n78390688)
print v(xbgr.mr_n76934688)
print v(xbgr.mr_n77058096)
print v(xbgr.mr_n77158384)
print v(xbgr.mr_n77240736)
print v(xbgr.mr_n77367072)
print v(xbgr.mr_n77487888)
print v(xbgr.mr_n77577504)
print v(xbgr.mr_n77203648)
print v(xbgr.mr_n75591136)
print v(xbgr.mr_n75855712)
print v(xbgr.mr_n76013648)
print v(xbgr.mr_n76083312)
print v(xbgr.mr_n77961344)
print v(xbgr.mr_n78389232)
print v(xbgr.mr_n76852704)
print v(xbgr.mr_n76959984)
print v(xbgr.mr_n77087712)
print v(xbgr.mr_n77170496)
print v(xbgr.mr_n77254640)
print v(xbgr.mr_n77377840)
print v(xbgr.mr_n77504048)
print v(xbgr.mr_n77637440)
print v(xbgr.mr_n75590672)
print v(xbgr.mr_n75856384)
print v(xbgr.mr_n76036144)
print v(xbgr.mr_n76082720)
print v(xbgr.mr_n77773904)
print v(xbgr.mr_n78205488)
print v(xbgr.mr_n77962336)
print v(xbgr.mr_n78390864)
print v(xbgr.mr_n75590208)
print v(xbgr.mr_n75856976)
print v(xbgr.mr_n76030144)
print v(xbgr.mr_n76082128)
print v(xbgr.mr_n76931392)
print v(xbgr.mr_n77046224)
print v(xbgr.mr_n77160992)
print v(xbgr.mr_n77236912)
print v(xbgr.mr_n77365632)
print v(xbgr.mr_n77491200)
print v(xbgr.mr_n77560896)
print v(xbgr.mr_n77683312)
print v(xbgr.mr_n76304672)
print v(xbgr.mr_n76405008)
print v(xbgr.mr_n76629344)
print v(xbgr.mr_n76824032)
print v(xbgr.mr_n76307424)
print v(xbgr.mr_n76405696)
print v(xbgr.mr_n76630064)
print v(xbgr.mr_n76825600)
print v(xbgr.mr_n77961568)
print v(xbgr.mr_n78189024)
print v(xbgr.mr_n78309440)
print v(xbgr.mr_n75589744)
print v(xbgr.mr_n75833888)
print v(xbgr.mr_n76026944)
print v(xbgr.mr_n76081536)
print v(xbgr.mr_n76256288)
print v(xbgr.mr_n76344832)
print v(xbgr.mr_n76101408)
print v(xbgr.mr_n76685584)
print v(xbgr.mr_n77960768)
print v(xbgr.mr_n78115632)
print v(xbgr.mr_n78393808)
print v(xbgr.mr_n75589280)
print v(xbgr.mr_n75858096)
print v(xbgr.mr_n76038544)
print v(xbgr.mr_n76080864)
print v(xbgr.mr_n77773440)
print v(xbgr.mr_n77989760)
print v(xbgr.mr_n78205024)
print v(xbgr.mr_n76304496)
print v(xbgr.mr_n76404592)
print v(xbgr.mr_n76583984)
print v(xbgr.mr_n76826128)
print v(xbgr.mr_n76922512)
print v(xbgr.mr_n77073360)
print v(xbgr.mr_n77160064)
print v(xbgr.mr_n77241616)
print v(xbgr.mr_n77367952)
print v(xbgr.mr_n77489888)
print v(xbgr.mr_n77583776)
print v(xbgr.mr_n77706384)
print v(xbgr.mr_n77960592)
print v(xbgr.mr_n78116816)
print v(xbgr.mr_n78265216)
print v(xbgr.mr_n76930592)
print v(xbgr.mr_n77074848)
print v(xbgr.mr_n77164112)
print v(xbgr.mr_n77236560)
print v(xbgr.mr_n77364640)
print v(xbgr.mr_n77495280)
print v(xbgr.mr_n77588000)
print v(xbgr.mr_n77691072)
print v(xbgr.mr_n75588816)
print v(xbgr.mr_n75858752)
print v(xbgr.mr_n76037344)
print v(xbgr.mr_n76036544)
print v(xbgr.mr_n76852240)
print v(xbgr.mr_n76959056)
print v(xbgr.mr_n77087168)
print v(xbgr.mr_n77170224)
print v(xbgr.mr_n77254096)
print v(xbgr.mr_n77377296)
print v(xbgr.mr_n77503504)
print v(xbgr.mr_n77636896)
print v(xbgr.mr_n75579072)
print v(xbgr.mr_n75859344)
print v(xbgr.mr_n76040144)
print v(xbgr.mr_n76076720)
print v(xbgr.mr_n77955616)
print v(xbgr.mr_n78189568)
print v(xbgr.mr_n78391728)
print v(xbgr.mr_n75587888)
print v(xbgr.mr_n75859936)
print v(xbgr.mr_n76040800)
print v(xbgr.mr_n76079168)
print v(xbgr.mr_n77956896)
print v(xbgr.mr_n78116224)
print v(xbgr.mr_n78393312)
print v(xbgr.mr_n76931216)
print v(xbgr.mr_n77060928)
print v(xbgr.mr_n77165520)
print v(xbgr.mr_n77240048)
print v(xbgr.mr_n77370736)
print v(xbgr.mr_n77496880)
print v(xbgr.mr_n77560304)
print v(xbgr.mr_n77683968)
print v(xbgr.mr_n76305712)
print v(xbgr.mr_n76406576)
print v(xbgr.mr_n76627344)
print v(xbgr.mr_n76823344)
print v(xbgr.mr_n76302880)
print v(xbgr.mr_n76407264)
print v(xbgr.mr_n76628848)
print v(xbgr.mr_n76827168)
print v(xbgr.mr_n77772512)
print v(xbgr.mr_n77989296)
print v(xbgr.mr_n78204096)
print v(xbgr.mr_n75587424)
print v(xbgr.mr_n75860528)
print v(xbgr.mr_n76042576)
print v(xbgr.mr_n76078576)
print v(xbgr.mr_n77954528)
print v(xbgr.mr_n78113856)
print v(xbgr.mr_n78396640)
print v(xbgr.mr_n76256016)
print v(xbgr.mr_n76343776)
print v(xbgr.mr_n76417056)
print v(xbgr.mr_n76684400)
print v(xbgr.mr_n75584640)
print v(xbgr.mr_n75861120)
print v(xbgr.mr_n76043760)
print v(xbgr.mr_n76077984)
print v(xbgr.mr_n77955264)
print v(xbgr.mr_n78188480)
print v(xbgr.mr_n78391616)
print v(xbgr.mr_n76303056)
print v(xbgr.mr_n76401456)
print v(xbgr.mr_n76601664)
print v(xbgr.mr_n76806752)
print v(xbgr.mr_n75586496)
print v(xbgr.mr_n75861648)
print v(xbgr.mr_n76044352)
print v(xbgr.mr_n76077312)
print v(xbgr.mr_n76923200)
print v(xbgr.mr_n77079760)
print v(xbgr.mr_n77162960)
print v(xbgr.mr_n77243904)
print v(xbgr.mr_n77369072)
print v(xbgr.mr_n77494592)
print v(xbgr.mr_n77584592)
print v(xbgr.mr_n77709264)
print v(xbgr.mr_n76929376)
print v(xbgr.mr_n77046912)
print v(xbgr.mr_n77162128)
print v(xbgr.mr_n77245440)
print v(xbgr.mr_n77366640)
print v(xbgr.mr_n77496448)
print v(xbgr.mr_n77583424)
print v(xbgr.mr_n77709680)
print v(xbgr.mr_n77954064)
print v(xbgr.mr_n78112912)
print v(xbgr.mr_n78400368)
print v(xbgr.mr_n77772048)
print v(xbgr.mr_n77988832)
print v(xbgr.mr_n78203632)
print v(xbgr.mr_n75586032)
print v(xbgr.mr_n75862304)
print v(xbgr.mr_n76023008)
print v(xbgr.mr_n76064960)
print v(xbgr.mr_n76851776)
print v(xbgr.mr_n76958592)
print v(xbgr.mr_n77086896)
print v(xbgr.mr_n77169952)
print v(xbgr.mr_n77253824)
print v(xbgr.mr_n77377024)
print v(xbgr.mr_n77503232)
print v(xbgr.mr_n77636624)
print v(xbgr.mr_n77954416)
print v(xbgr.mr_n78112080)
print v(xbgr.mr_n78397984)
print v(xbgr.mr_n75585568)
print v(xbgr.mr_n75862896)
print v(xbgr.mr_n76046128)
print v(xbgr.mr_n76034944)
print v(xbgr.mr_n76927504)
print v(xbgr.mr_n77043728)
print v(xbgr.mr_n77164736)
print v(xbgr.mr_n77243360)
print v(xbgr.mr_n77371776)
print v(xbgr.mr_n77497984)
print v(xbgr.mr_n77559712)
print v(xbgr.mr_n77681536)
print v(xbgr.mr_n76302320)
print v(xbgr.mr_n76408144)
print v(xbgr.mr_n76620736)
print v(xbgr.mr_n76802144)
print v(xbgr.mr_n76298608)
print v(xbgr.mr_n76404128)
print v(xbgr.mr_n76626800)
print v(xbgr.mr_n76791760)
print v(xbgr.mr_n77952592)
print v(xbgr.mr_n78184752)
print v(xbgr.mr_n77975968)
print v(xbgr.mr_n75585104)
print v(xbgr.mr_n75863488)
print v(xbgr.mr_n76044944)
print v(xbgr.mr_n76045536)
print v(xbgr.mr_n77951040)
print v(xbgr.mr_n78112736)
print v(xbgr.mr_n78402928)
print v(xbgr.mr_n76255744)
print v(xbgr.mr_n76342720)
print v(xbgr.mr_n76492624)
print v(xbgr.mr_n76683216)
print v(xbgr.mr_n75438496)
print v(xbgr.mr_n75864080)
print v(xbgr.mr_n76031744)
print v(xbgr.mr_n76075024)
print v(xbgr.mr_n77771584)
print v(xbgr.mr_n77988368)
print v(xbgr.mr_n78203168)
print v(xbgr.mr_n77948544)
print v(xbgr.mr_n78110304)
print v(xbgr.mr_n78397808)
print v(xbgr.mr_n75437968)
print v(xbgr.mr_n75864672)
print v(xbgr.mr_n76039744)
print v(xbgr.mr_n76074432)
print v(xbgr.mr_n76301520)
print v(xbgr.mr_n76406224)
print v(xbgr.mr_n76601888)
print v(xbgr.mr_n76794304)
print v(xbgr.mr_n76919280)
print v(xbgr.mr_n77040608)
print v(xbgr.mr_n77163808)
print v(xbgr.mr_n77246320)
print v(xbgr.mr_n77368384)
print v(xbgr.mr_n77492592)
print v(xbgr.mr_n77568592)
print v(xbgr.mr_n77702976)
print v(xbgr.mr_n76927680)
print v(xbgr.mr_n77072960)
print v(xbgr.mr_n77167856)
print v(xbgr.mr_n77242048)
print v(xbgr.mr_n77373776)
print v(xbgr.mr_n77499984)
print v(xbgr.mr_n77565632)
print v(xbgr.mr_n77706272)
print v(xbgr.mr_n75583712)
print v(xbgr.mr_n75865264)
print v(xbgr.mr_n76041392)
print v(xbgr.mr_n76073840)
print v(xbgr.mr_n77945456)
print v(xbgr.mr_n78186848)
print v(xbgr.mr_n78400544)
print v(xbgr.mr_n76851312)
print v(xbgr.mr_n76957664)
print v(xbgr.mr_n77037456)
print v(xbgr.mr_n77169680)
print v(xbgr.mr_n77253280)
print v(xbgr.mr_n77376480)
print v(xbgr.mr_n77502688)
print v(xbgr.mr_n77636080)
print v(xbgr.mr_n77949968)
print v(xbgr.mr_n78108528)
print v(xbgr.mr_n78405488)
print v(xbgr.mr_n75583248)
print v(xbgr.mr_n75855200)
print v(xbgr.mr_n76035344)
print v(xbgr.mr_n76073248)
print v(xbgr.mr_n77770656)
print v(xbgr.mr_n77987904)
print v(xbgr.mr_n78202240)
print v(xbgr.mr_n76926704)
print v(xbgr.mr_n77035872)
print v(xbgr.mr_n77166704)
print v(xbgr.mr_n77249040)
print v(xbgr.mr_n77362464)
print v(xbgr.mr_n77494160)
print v(xbgr.mr_n77559120)
print v(xbgr.mr_n77682192)
print v(xbgr.mr_n76302208)
print v(xbgr.mr_n76409712)
print v(xbgr.mr_n76623216)
print v(xbgr.mr_n76796304)
print v(xbgr.mr_n76300144)
print v(xbgr.mr_n76410400)
print v(xbgr.mr_n76626304)
print v(xbgr.mr_n76797504)
print v(xbgr.mr_n77944944)
print v(xbgr.mr_n78105632)
print v(xbgr.mr_n78403104)
print v(xbgr.mr_n75582784)
print v(xbgr.mr_n75866384)
print v(xbgr.mr_n76039344)
print v(xbgr.mr_n76072576)
print v(xbgr.mr_n76255472)
print v(xbgr.mr_n76318224)
print v(xbgr.mr_n75927728)
print v(xbgr.mr_n76682032)
print v(xbgr.mr_n75582320)
print v(xbgr.mr_n75867040)
print v(xbgr.mr_n76038144)
print v(xbgr.mr_n76038944)
print v(xbgr.mr_n77943776)
print v(xbgr.mr_n78186384)
print v(xbgr.mr_n78393920)
print v(xbgr.mr_n75581856)
print v(xbgr.mr_n75867568)
print v(xbgr.mr_n76037744)
print v(xbgr.mr_n76071472)
print v(xbgr.mr_n77946944)
print v(xbgr.mr_n78100160)
print v(xbgr.mr_n78404672)
print v(xbgr.mr_n76299408)
print v(xbgr.mr_n76409296)
print v(xbgr.mr_n76601776)
print v(xbgr.mr_n76794192)
print v(xbgr.mr_n76923632)
print v(xbgr.mr_n76902864)
print v(xbgr.mr_n77162560)
print v(xbgr.mr_n77246752)
print v(xbgr.mr_n77367600)
print v(xbgr.mr_n77484752)
print v(xbgr.mr_n77565040)
print v(xbgr.mr_n77707088)
print v(xbgr.mr_n76925648)
print v(xbgr.mr_n77051104)
print v(xbgr.mr_n77165088)
print v(xbgr.mr_n77248608)
print v(xbgr.mr_n77370240)
print v(xbgr.mr_n77493280)
print v(xbgr.mr_n77579040)
print v(xbgr.mr_n77705856)
print v(xbgr.mr_n77770192)
print v(xbgr.mr_n77987440)
print v(xbgr.mr_n78201776)
print v(xbgr.mr_n75581392)
print v(xbgr.mr_n75851648)
print v(xbgr.mr_n76036944)
print v(xbgr.mr_n76070880)
print v(xbgr.mr_n77945120)
print v(xbgr.mr_n78110960)
print v(xbgr.mr_n78407232)
print v(xbgr.mr_n76850848)
print v(xbgr.mr_n76957200)
print v(xbgr.mr_n77048912)
print v(xbgr.mr_n77169408)
print v(xbgr.mr_n77253008)
print v(xbgr.mr_n77376208)
print v(xbgr.mr_n77502416)
print v(xbgr.mr_n77635808)
print v(xbgr.mr_n75580928)
print v(xbgr.mr_n75868752)
print v(xbgr.mr_n76035744)
print v(xbgr.mr_n76070288)
print v(xbgr.mr_n77928192)
print v(xbgr.mr_n78185296)
print v(xbgr.mr_n78399552)
print v(xbgr.mr_n76923808)
print v(xbgr.mr_n77016112)
print v(xbgr.mr_n77159632)
print v(xbgr.mr_n77238720)
print v(xbgr.mr_n77366288)
print v(xbgr.mr_n77493744)
print v(xbgr.mr_n77555648)
print v(xbgr.mr_n77679760)
print v(xbgr.mr_n75580464)
print v(xbgr.mr_n75850464)
print v(xbgr.mr_n76029344)
print v(xbgr.mr_n76069696)
print v(xbgr.mr_n76300400)
print v(xbgr.mr_n76411280)
print v(xbgr.mr_n76624192)
print v(xbgr.mr_n76639232)
print v(xbgr.mr_n76297216)
print v(xbgr.mr_n76407792)
print v(xbgr.mr_n76624976)
print v(xbgr.mr_n76792032)
print v(xbgr.mr_n77942416)
print v(xbgr.mr_n78069152)
print v(xbgr.mr_n78410608)
print v(xbgr.mr_n75580000)
print v(xbgr.mr_n75870000)
print v(xbgr.mr_n76034544)
print v(xbgr.mr_n76069104)
print v(xbgr.mr_n77769728)
print v(xbgr.mr_n77986976)
print v(xbgr.mr_n78201312)
print v(xbgr.mr_n76255200)
print v(xbgr.mr_n76323824)
print v(xbgr.mr_n76091296)
print v(xbgr.mr_n76680848)
print v(xbgr.mr_n77941984)
print v(xbgr.mr_n78109184)
print v(xbgr.mr_n78409792)
print v(xbgr.mr_n75579536)
print v(xbgr.mr_n75870592)
print v(xbgr.mr_n76033744)
print v(xbgr.mr_n76068512)
print v(xbgr.mr_n76301344)
print v(xbgr.mr_n76398320)
print v(xbgr.mr_n76596592)
print v(xbgr.mr_n76791648)
print v(xbgr.mr_n76924848)
print v(xbgr.mr_n77057520)
print v(xbgr.mr_n77157248)
print v(xbgr.mr_n77247440)
print v(xbgr.mr_n77365136)
print v(xbgr.mr_n77487472)
print v(xbgr.mr_n77578224)
print v(xbgr.mr_n77698112)
print v(xbgr.mr_n76918400)
print v(xbgr.mr_n77033056)
print v(xbgr.mr_n77161344)
print v(xbgr.mr_n77244336)
print v(xbgr.mr_n77364176)
print v(xbgr.mr_n77491744)
print v(xbgr.mr_n77580176)
print v(xbgr.mr_n77702864)
print v(xbgr.mr_n77938976)
print v(xbgr.mr_n78183664)
print v(xbgr.mr_n78402112)
print v(xbgr.mr_n75438768)
print v(xbgr.mr_n75871184)
print v(xbgr.mr_n76028144)
print v(xbgr.mr_n76067856)
print v(xbgr.mr_n77936384)
print v(xbgr.mr_n78106752)
print v(xbgr.mr_n78408224)
print v(xbgr.mr_n76850384)
print v(xbgr.mr_n76956272)
print v(xbgr.mr_n77048368)
print v(xbgr.mr_n77169136)
print v(xbgr.mr_n77252464)
print v(xbgr.mr_n77375664)
print v(xbgr.mr_n77501872)
print v(xbgr.mr_n77635344)
print v(xbgr.mr_n75576960)
print v(xbgr.mr_n75871776)
print v(xbgr.mr_n76025104)
print v(xbgr.mr_n76067328)
print v(xbgr.mr_n77768800)
print v(xbgr.mr_n77986512)
print v(xbgr.mr_n78200384)
print v(xbgr.mr_n77941040)
print v(xbgr.mr_n78107408)
print v(xbgr.mr_n78412352)
print v(xbgr.mr_n75445792)
print v(xbgr.mr_n75797904)
print v(xbgr.mr_n76031344)
print v(xbgr.mr_n76066736)
print v(xbgr.mr_n76922336)
print v(xbgr.mr_n77015792)
print v(xbgr.mr_n77159280)
print v(xbgr.mr_n77245968)
print v(xbgr.mr_n77360304)
print v(xbgr.mr_n77489104)
print v(xbgr.mr_n77555824)
print v(xbgr.mr_n77680416)
print v(xbgr.mr_n76295328)
print v(xbgr.mr_n76390976)
print v(xbgr.mr_n76622432)
print v(xbgr.mr_n76787504)
print v(xbgr.mr_n76287968)
print v(xbgr.mr_n76390128)
print v(xbgr.mr_n76622256)
print v(xbgr.mr_n76789840)
print v(xbgr.mr_n75445328)
print v(xbgr.mr_n75794880)
print v(xbgr.mr_n76022544)
print v(xbgr.mr_n76066144)
print v(xbgr.mr_n77934944)
print v(xbgr.mr_n78175696)
print v(xbgr.mr_n78408048)
print v(xbgr.mr_n76255088)
print v(xbgr.mr_n76320960)
print v(xbgr.mr_n76102624)
print v(xbgr.mr_n76679984)
print v(xbgr.mr_n75444864)
print v(xbgr.mr_n75805600)
print v(xbgr.mr_n76029744)
print v(xbgr.mr_n76065472)
print v(xbgr.mr_n77937376)
print v(xbgr.mr_n78104976)
print v(xbgr.mr_n78410784)
print v(xbgr.mr_n77768336)
print v(xbgr.mr_n77986048)
print v(xbgr.mr_n78199920)
print v(xbgr.mr_n76296784)
print v(xbgr.mr_n76390016)
print v(xbgr.mr_n76586752)
print v(xbgr.mr_n76776864)
print v(xbgr.mr_n76920480)
print v(xbgr.mr_n77072544)
print v(xbgr.mr_n77139616)
print v(xbgr.mr_n77242736)
print v(xbgr.mr_n77361968)
print v(xbgr.mr_n77476176)
print v(xbgr.mr_n77567856)
print v(xbgr.mr_n77703680)
print v(xbgr.mr_n75444400)
print v(xbgr.mr_n75805008)
print v(xbgr.mr_n76028544)
print v(xbgr.mr_n76043168)
print v(xbgr.mr_n76913040)
print v(xbgr.mr_n77082864)
print v(xbgr.mr_n77157600)
print v(xbgr.mr_n77239696)
print v(xbgr.mr_n77358640)
print v(xbgr.mr_n77483872)
print v(xbgr.mr_n77578336)
print v(xbgr.mr_n77702512)
print v(xbgr.mr_n77939152)
print v(xbgr.mr_n78099232)
print v(xbgr.mr_n78413344)
print v(xbgr.mr_n75443936)
print v(xbgr.mr_n75804416)
print v(xbgr.mr_n76024768)
print v(xbgr.mr_n76064368)
print v(xbgr.mr_n76849920)
print v(xbgr.mr_n76955808)
print v(xbgr.mr_n77081968)
print v(xbgr.mr_n77168944)
print v(xbgr.mr_n77252192)
print v(xbgr.mr_n77375392)
print v(xbgr.mr_n77501600)
print v(xbgr.mr_n77635232)
print v(xbgr.mr_n77937152)
print v(xbgr.mr_n78179824)
print v(xbgr.mr_n78405664)
print v(xbgr.mr_n75443472)
print v(xbgr.mr_n75803744)
print v(xbgr.mr_n76027344)
print v(xbgr.mr_n76063776)
print v(xbgr.mr_n77936208)
print v(xbgr.mr_n78103200)
print v(xbgr.mr_n78414912)
print v(xbgr.mr_n76920656)
print v(xbgr.mr_n77064224)
print v(xbgr.mr_n77155472)
print v(xbgr.d4)
print v(xbgr.mr_n77361008)
print v(xbgr.mr_n77484336)
print v(xbgr.mr_n77556160)
print v(xbgr.mr_n77676288)
print v(xbgr.mr_n76298432)
print v(xbgr.mr_n76384368)
print v(xbgr.mr_n76604944)
print v(xbgr.mr_n76779728)
print v(xbgr.mr_n76297392)
print v(xbgr.mr_n76380752)
print v(xbgr.mr_n76621712)
print v(xbgr.mr_n76784784)
print v(xbgr.mr_n77767872)
print v(xbgr.mr_n77985584)
print v(xbgr.mr_n78199456)
print v(xbgr.mr_n75443008)
print v(xbgr.mr_n75794352)
print v(xbgr.mr_n76026144)
print v(xbgr.mr_n76063184)
print v(xbgr.mr_n77934768)
print v(xbgr.mr_n78103856)
print v(xbgr.mr_n78415904)
print v(xbgr.mr_n76247152)
print v(xbgr.mr_n76318944)
print v(xbgr.mr_n76443232)
print v(xbgr.mr_n76679184)
print v(xbgr.mr_n75442544)
print v(xbgr.mr_n75802048)
print v(xbgr.mr_n76025744)
print v(xbgr.mr_n76061504)
print v(xbgr.mr_n77935200)
print v(xbgr.mr_n78182800)
print v(xbgr.mr_n78413168)
print v(xbgr.mr_n76285552)
print v(xbgr.mr_n76387984)
print v(xbgr.mr_n76581936)
print v(xbgr.mr_n76781424)
print v(xbgr.mr_n75442080)
print v(xbgr.mr_n75801456)
print v(xbgr.mr_n75912144)
print v(xbgr.mr_n76254752)
print v(xbgr.mr_n76921536)
print v(xbgr.mr_n77068096)
print v(xbgr.mr_n77139264)
print v(xbgr.mr_n77233952)
print v(xbgr.mr_n77357680)
print v(xbgr.mr_n77475440)
print v(xbgr.mr_n77578048)
print v(xbgr.mr_n77697536)
print v(xbgr.mr_n76912208)
print v(xbgr.mr_n77083248)
print v(xbgr.mr_n77148912)
print v(xbgr.mr_n77239200)
print v(xbgr.mr_n77348400)
print v(xbgr.mr_n77482336)
print v(xbgr.mr_n77313584)
print v(xbgr.mr_n77697728)
print v(xbgr.mr_n77930576)
print v(xbgr.mr_n78101552)
print v(xbgr.mr_n78420848)
print v(xbgr.mr_n75441616)
print v(xbgr.mr_n75800272)
print v(xbgr.mr_n75912736)
print v(xbgr.mr_n76254352)
print v(xbgr.mr_n77767184)
print v(xbgr.mr_n77985120)
print v(xbgr.mr_n78198528)
print v(xbgr.mr_n76849456)
print v(xbgr.mr_n76954880)
print v(xbgr.mr_n77081584)
print v(xbgr.mr_n77168832)
print v(xbgr.mr_n77251648)
print v(xbgr.mr_n77374928)
print v(xbgr.mr_n77501136)
print v(xbgr.mr_n77635008)
print v(xbgr.mr_n77933280)
print v(xbgr.mr_n78102080)
print v(xbgr.mr_n78420032)
print v(xbgr.mr_n75441152)
print v(xbgr.mr_n75799680)
print v(xbgr.mr_n75910960)
print v(xbgr.mr_n76253872)
print v(xbgr.mr_n76916736)
print v(xbgr.mr_n77041056)
print v(xbgr.mr_n77138928)
print v(xbgr.mr_n77232640)
print v(xbgr.mr_n77358288)
print v(xbgr.mr_n77479696)
print v(xbgr.mr_n77498864)
print v(xbgr.mr_n77678640)
print v(xbgr.mr_n76295936)
print v(xbgr.mr_n76602576)
print v(xbgr.mr_n76774672)
print v(xbgr.mr_n76291296)
print v(xbgr.mr_n76621216)
print v(xbgr.mr_n76776480)
print v(xbgr.mr_n77931680)
print v(xbgr.mr_n78181776)
print v(xbgr.mr_n78415728)
print v(xbgr.mr_n75439040)
print v(xbgr.mr_n75795456)
print v(xbgr.mr_n75911552)
print v(xbgr.mr_n76242976)
print v(xbgr.mr_n75425632)
print v(xbgr.mr_n75458464)
print v(xbgr.mr_n77927520)
print v(xbgr.mr_n78070848)
print v(xbgr.mr_n78423408)
print v(xbgr.mr_n76222416)
print v(xbgr.mr_n76348176)
print v(xbgr.mr_n76428896)
print v(xbgr.mr_n76651808)
print v(xbgr.mr_n75637200)
print v(xbgr.n_23)
print v(xbgr.mr_n75909776)
print v(xbgr.mr_n76250752)
print v(xbgr.mr_n75484672)
print v(xbgr.mr_n77766880)
print v(xbgr.mr_n77984656)
print v(xbgr.mr_n78198144)
print v(xbgr.mr_n77930464)
print v(xbgr.mr_n78100624)
print v(xbgr.mr_n78422592)
print v(xbgr.n_12)
print v(xbgr.n_25)
print v(xbgr.mr_n75910368)
print v(xbgr.mr_n76250352)
print v(xbgr.mr_n76295760)
print v(xbgr.mr_n76598192)
print v(xbgr.mr_n76776368)
print v(xbgr.mr_n76912384)
print v(xbgr.mr_n77040304)
print v(xbgr.mr_n77153200)
print v(xbgr.mr_n77225776)
print v(xbgr.mr_n77351632)
print v(xbgr.mr_n77474368)
print v(xbgr.mr_n77575840)
print v(xbgr.mr_n77694800)
print v(xbgr.mr_n76916400)
print v(xbgr.mr_n77083056)
print v(xbgr.mr_n77138480)
print v(xbgr.mr_n77234496)
print v(xbgr.mr_n77357792)
print v(xbgr.mr_n77474704)
print v(xbgr.mr_n77562672)
print v(xbgr.mr_n77697920)
print v(xbgr.mr_n75438080)
print v(xbgr.mr_n75738176)
print v(xbgr.mr_n75908592)
print v(xbgr.mr_n76247952)
print v(xbgr.mr_n77929120)
print v(xbgr.mr_n78179600)
print v(xbgr.mr_n78418288)
print v(xbgr.mr_n76848992)
print v(xbgr.mr_n76954496)
print v(xbgr.mr_n77030144)
print v(xbgr.mr_n77165872)
print v(xbgr.mr_n77251456)
print v(xbgr.mr_n77374816)
print v(xbgr.mr_n77501024)
print v(xbgr.mr_n77633600)
print v(xbgr.n_17)
print v(xbgr.n_22)
print v(xbgr.mr_n75909184)
print v(xbgr.mr_n76180896)
print v(xbgr.mr_n77836128)
print v(xbgr.mr_n78098768)
print v(xbgr.mr_n78421024)
print v(xbgr.mr_n77766576)
print v(xbgr.mr_n77984192)
print v(xbgr.mr_n78197840)
print v(xbgr.mr_n76918224)
print v(xbgr.mr_n77037984)
print v(xbgr.mr_n77152928)
print v(xbgr.mr_n77231792)
print v(xbgr.mr_n77357568)
print v(xbgr.mr_n77475824)
print v(xbgr.mr_n77537808)
print v(xbgr.mr_n77630400)
print v(xbgr.mr_n76287216)
print v(xbgr.mr_n76619168)
print v(xbgr.mr_n76765488)
print v(xbgr.n_18)
print v(xbgr.mr_n75736736)
print v(xbgr.mr_n75907408)
print v(xbgr.mr_n76243552)
print v(xbgr.mr_n76290544)
print v(xbgr.mr_n76619888)
print v(xbgr.mr_n76765680)
print v(xbgr.mr_n77923680)
print v(xbgr.mr_n78065424)
print v(xbgr.mr_n78423584)
print v(xbgr.mr_n76355328)
print v(xbgr.mr_n75483968)
print v(xbgr.mr_n75634256)
print v(xbgr.mr_n75736016)
print v(xbgr.mr_n75908000)
print v(xbgr.mr_n76241344)
print v(xbgr.mr_n76252672)
print v(xbgr.mr_n75550400)
print v(xbgr.mr_n76098176)
print v(xbgr.mr_n76654032)
print v(xbgr.mr_n77926832)
print v(xbgr.mr_n78179712)
print v(xbgr.mr_n78417472)
print v(xbgr.mr_n75464368)
print v(xbgr.mr_n75437856)
print v(xbgr.mr_n75735296)
print v(xbgr.mr_n75906816)
print v(xbgr.mr_n76240592)
print v(xbgr.mr_n76290352)
print v(xbgr.mr_n76565552)
print v(xbgr.mr_n76766352)
print v(xbgr.mr_n77919216)
print v(xbgr.mr_n78072768)
print v(xbgr.mr_n78428528)
print v(xbgr.mr_n76910896)
print v(xbgr.mr_n76998640)
print v(xbgr.mr_n77141408)
print v(xbgr.mr_n77228624)
print v(xbgr.mr_n77355760)
print v(xbgr.mr_n77468944)
print v(xbgr.mr_n77568000)
print v(xbgr.mr_n77697184)
print v(xbgr.mr_n76912864)
print v(xbgr.mr_n77001328)
print v(xbgr.mr_n77142352)
print v(xbgr.mr_n77224704)
print v(xbgr.mr_n77352528)
print v(xbgr.mr_n77459904)
print v(xbgr.mr_n77567408)
print v(xbgr.mr_n77698864)
print v(xbgr.mr_n77750768)
print v(xbgr.mr_n77979824)
print v(xbgr.mr_n78193920)
print v(xbgr.mr_n75576768)
print v(xbgr.mr_n75734576)
print v(xbgr.mr_n75904912)
print v(xbgr.mr_n76230224)
print v(xbgr.mr_n77752368)
print v(xbgr.mr_n78072656)
print v(xbgr.mr_n78427712)
print v(xbgr.mr_n76848528)
print v(xbgr.mr_n76938384)
print v(xbgr.mr_n77075440)
print v(xbgr.mr_n77167552)
print v(xbgr.mr_n77250608)
print v(xbgr.mr_n77373088)
print v(xbgr.mr_n77499296)
print v(xbgr.mr_n77627200)
print v(xbgr.mr_n77924016)
print v(xbgr.mr_n78181888)
print v(xbgr.mr_n78418464)
print v(xbgr.mr_n75775648)
print v(xbgr.mr_n76910240)
print v(xbgr.mr_n76998816)
print v(xbgr.mr_n77140672)
print v(xbgr.mr_n77227152)
print v(xbgr.mr_n77331888)
print v(xbgr.mr_n77463520)
print v(xbgr.mr_n77495968)
print v(xbgr.mr_n77632800)
print v(xbgr.mr_n76290240)
print v(xbgr.mr_n76604208)
print v(xbgr.mr_n76758832)
print v(xbgr.mr_n76282976)
print v(xbgr.mr_n76617440)
print v(xbgr.mr_n76754544)
print v(xbgr.mr_n77917248)
print v(xbgr.mr_n78069040)
print v(xbgr.mr_n78426144)
print v(xbgr.mr_n75751536)
print v(xbgr.mr_n77754768)
print v(xbgr.mr_n77977584)
print v(xbgr.mr_n78197104)
print v(xbgr.mr_n76238816)
print v(xbgr.mr_n75545536)
print v(xbgr.mr_n76460880)
print v(xbgr.mr_n76634368)
print v(xbgr.mr_n75750928)
print v(xbgr.mr_n77813216)
print v(xbgr.mr_n78063728)
print v(xbgr.mr_n78428704)
print v(xbgr.mr_n76285248)
print v(xbgr.mr_n76580608)
print v(xbgr.mr_n76695984)
print v(dvbe)
print v(iptat)
print v(pbias)
print v(pcasc)
print v(r4)
print v(vbe)
print v(vdd)
print v(vref)
print v(vdd)-v(vdd)
echo METALLIC_POINT_VOLTAGES_END
echo METALLIC_ALL_NODE_VOLTAGES_BEGIN
print v(xbgr.b1b)
print v(xbgr.c2)
print v(xbgr.d1)
print v(xbgr.d2)
print v(xbgr.d3)
print v(xbgr.d4)
print v(xbgr.d5)
print v(xbgr.det)
print v(dvbe)
print v(iptat)
print v(xbgr.kick)
print v(xbgr.mr_n62318976)
print v(xbgr.mr_n62364592)
print v(xbgr.mr_n64058416)
print v(xbgr.mr_n64809040)
print v(xbgr.mr_n65724544)
print v(xbgr.mr_n65727296)
print v(xbgr.mr_n65727408)
print v(xbgr.mr_n65727824)
print v(xbgr.mr_n65727936)
print v(xbgr.mr_n65728256)
print v(xbgr.mr_n65728368)
print v(xbgr.mr_n65728800)
print v(xbgr.mr_n65729040)
print v(xbgr.mr_n65729152)
print v(xbgr.mr_n65729504)
print v(xbgr.mr_n65729824)
print v(xbgr.mr_n65729936)
print v(xbgr.mr_n65730368)
print v(xbgr.mr_n65730688)
print v(xbgr.mr_n65730800)
print v(xbgr.mr_n65731232)
print v(xbgr.mr_n65731552)
print v(xbgr.mr_n65731664)
print v(xbgr.mr_n65732096)
print v(xbgr.mr_n65732416)
print v(xbgr.mr_n65732528)
print v(xbgr.mr_n65732960)
print v(xbgr.mr_n65733280)
print v(xbgr.mr_n65733392)
print v(xbgr.mr_n65733824)
print v(xbgr.mr_n65734144)
print v(xbgr.mr_n65734256)
print v(xbgr.mr_n65734688)
print v(xbgr.mr_n65735008)
print v(xbgr.mr_n65735120)
print v(xbgr.mr_n65735552)
print v(xbgr.mr_n65735872)
print v(xbgr.mr_n65735984)
print v(xbgr.mr_n65736416)
print v(xbgr.mr_n65736736)
print v(xbgr.mr_n65736848)
print v(xbgr.mr_n65737280)
print v(xbgr.mr_n65737600)
print v(xbgr.mr_n65737712)
print v(xbgr.mr_n65738144)
print v(xbgr.mr_n65738464)
print v(xbgr.mr_n65738576)
print v(xbgr.mr_n65739008)
print v(xbgr.mr_n65739328)
print v(xbgr.mr_n65739440)
print v(xbgr.mr_n65739872)
print v(xbgr.mr_n65740192)
print v(xbgr.mr_n65740304)
print v(xbgr.mr_n65740736)
print v(xbgr.mr_n65741056)
print v(xbgr.mr_n65741168)
print v(xbgr.mr_n65741600)
print v(xbgr.mr_n65741920)
print v(xbgr.mr_n65742032)
print v(xbgr.mr_n65742464)
print v(xbgr.mr_n65742784)
print v(xbgr.mr_n65742896)
print v(xbgr.mr_n65743216)
print v(xbgr.mr_n65743328)
print v(xbgr.mr_n65743648)
print v(xbgr.mr_n65743760)
print v(xbgr.mr_n65744080)
print v(xbgr.mr_n65744192)
print v(xbgr.mr_n65744512)
print v(xbgr.mr_n65744624)
print v(xbgr.mr_n65744944)
print v(xbgr.mr_n65745056)
print v(xbgr.mr_n65745376)
print v(xbgr.mr_n65745488)
print v(xbgr.mr_n65745808)
print v(xbgr.mr_n65745920)
print v(xbgr.mr_n65746240)
print v(xbgr.mr_n65746352)
print v(xbgr.mr_n65746672)
print v(xbgr.mr_n65746784)
print v(xbgr.mr_n65747104)
print v(xbgr.mr_n65747216)
print v(xbgr.mr_n65747536)
print v(xbgr.mr_n65747648)
print v(xbgr.mr_n65747968)
print v(xbgr.mr_n65748080)
print v(xbgr.mr_n65748400)
print v(xbgr.mr_n65748512)
print v(xbgr.mr_n65748832)
print v(xbgr.mr_n65748944)
print v(xbgr.mr_n65749264)
print v(xbgr.mr_n65749376)
print v(xbgr.mr_n65749696)
print v(xbgr.mr_n65749808)
print v(xbgr.mr_n65750128)
print v(xbgr.mr_n65750240)
print v(xbgr.mr_n65750560)
print v(xbgr.mr_n65750672)
print v(xbgr.mr_n65750992)
print v(xbgr.mr_n65751104)
print v(xbgr.mr_n65751424)
print v(xbgr.mr_n65751536)
print v(xbgr.mr_n65751856)
print v(xbgr.mr_n65751968)
print v(xbgr.mr_n65752288)
print v(xbgr.mr_n65752400)
print v(xbgr.mr_n65752720)
print v(xbgr.mr_n65752832)
print v(xbgr.mr_n65753152)
print v(xbgr.mr_n65753264)
print v(xbgr.mr_n65753584)
print v(xbgr.mr_n65753696)
print v(xbgr.mr_n65754016)
print v(xbgr.mr_n65754128)
print v(xbgr.mr_n65754448)
print v(xbgr.mr_n65754560)
print v(xbgr.mr_n65754880)
print v(xbgr.mr_n65754992)
print v(xbgr.mr_n65755312)
print v(xbgr.mr_n65755424)
print v(xbgr.mr_n65755744)
print v(xbgr.mr_n65755856)
print v(xbgr.mr_n65756176)
print v(xbgr.mr_n65756288)
print v(xbgr.mr_n65756608)
print v(xbgr.mr_n65756720)
print v(xbgr.mr_n65757040)
print v(xbgr.mr_n65757152)
print v(xbgr.mr_n65757472)
print v(xbgr.mr_n65757584)
print v(xbgr.mr_n65757904)
print v(xbgr.mr_n65758016)
print v(xbgr.mr_n65758336)
print v(xbgr.mr_n65758448)
print v(xbgr.mr_n65758576)
print v(xbgr.mr_n65758688)
print v(xbgr.mr_n65759008)
print v(xbgr.mr_n65759120)
print v(xbgr.mr_n65759440)
print v(xbgr.mr_n65759552)
print v(xbgr.mr_n65759872)
print v(xbgr.mr_n65759984)
print v(xbgr.mr_n65760304)
print v(xbgr.mr_n65760416)
print v(xbgr.mr_n65760736)
print v(xbgr.mr_n65760848)
print v(xbgr.mr_n65761168)
print v(xbgr.mr_n65761280)
print v(xbgr.mr_n65761600)
print v(xbgr.mr_n65761712)
print v(xbgr.mr_n65762032)
print v(xbgr.mr_n65762144)
print v(xbgr.mr_n65762464)
print v(xbgr.mr_n65762576)
print v(xbgr.mr_n65762896)
print v(xbgr.mr_n65763008)
print v(xbgr.mr_n65763328)
print v(xbgr.mr_n65763440)
print v(xbgr.mr_n65763760)
print v(xbgr.mr_n65763872)
print v(xbgr.mr_n65764192)
print v(xbgr.mr_n65764304)
print v(xbgr.mr_n65764624)
print v(xbgr.mr_n65764736)
print v(xbgr.mr_n65765056)
print v(xbgr.mr_n65765168)
print v(xbgr.mr_n65765488)
print v(xbgr.mr_n65765600)
print v(xbgr.mr_n65765920)
print v(xbgr.mr_n65766032)
print v(xbgr.mr_n65766352)
print v(xbgr.mr_n65766464)
print v(xbgr.mr_n65766784)
print v(xbgr.mr_n65766896)
print v(xbgr.mr_n65767216)
print v(xbgr.mr_n65767328)
print v(xbgr.mr_n65767648)
print v(xbgr.mr_n65767760)
print v(xbgr.mr_n65768080)
print v(xbgr.mr_n65768192)
print v(xbgr.mr_n65768512)
print v(xbgr.mr_n65768624)
print v(xbgr.mr_n65768944)
print v(xbgr.mr_n65769056)
print v(xbgr.mr_n65769376)
print v(xbgr.mr_n65769488)
print v(xbgr.mr_n65769808)
print v(xbgr.mr_n65769920)
print v(xbgr.mr_n65770240)
print v(xbgr.mr_n65770352)
print v(xbgr.mr_n65770672)
print v(xbgr.mr_n65770784)
print v(xbgr.mr_n65771104)
print v(xbgr.mr_n65771216)
print v(xbgr.mr_n65771536)
print v(xbgr.mr_n65771648)
print v(xbgr.mr_n65771968)
print v(xbgr.mr_n65772080)
print v(xbgr.mr_n65772400)
print v(xbgr.mr_n65772512)
print v(xbgr.mr_n65772832)
print v(xbgr.mr_n65772944)
print v(xbgr.mr_n65773264)
print v(xbgr.mr_n65773376)
print v(xbgr.mr_n65773696)
print v(xbgr.mr_n65773808)
print v(xbgr.mr_n65774128)
print v(xbgr.mr_n65774240)
print v(xbgr.mr_n65774560)
print v(xbgr.mr_n65774672)
print v(xbgr.mr_n65774992)
print v(xbgr.mr_n65775104)
print v(xbgr.mr_n65775424)
print v(xbgr.mr_n65775536)
print v(xbgr.mr_n65775856)
print v(xbgr.mr_n65775968)
print v(xbgr.mr_n65776288)
print v(xbgr.mr_n65776400)
print v(xbgr.mr_n65776720)
print v(xbgr.mr_n65776832)
print v(xbgr.mr_n65777152)
print v(xbgr.mr_n65777264)
print v(xbgr.mr_n65777584)
print v(xbgr.mr_n65777696)
print v(xbgr.mr_n65778016)
print v(xbgr.mr_n65778128)
print v(xbgr.mr_n65778448)
print v(xbgr.mr_n65778560)
print v(xbgr.mr_n65778880)
print v(xbgr.mr_n65778992)
print v(xbgr.mr_n65779312)
print v(xbgr.mr_n65779424)
print v(xbgr.mr_n65779744)
print v(xbgr.mr_n65779856)
print v(xbgr.mr_n65780176)
print v(xbgr.mr_n65780288)
print v(xbgr.mr_n65780608)
print v(xbgr.mr_n65780720)
print v(xbgr.mr_n65781040)
print v(xbgr.mr_n65781152)
print v(xbgr.mr_n65781472)
print v(xbgr.mr_n65781584)
print v(xbgr.mr_n65781904)
print v(xbgr.mr_n65782016)
print v(xbgr.mr_n65782336)
print v(xbgr.mr_n65782448)
print v(xbgr.mr_n65782768)
print v(xbgr.mr_n65782880)
print v(xbgr.mr_n65783200)
print v(xbgr.mr_n65783312)
print v(xbgr.mr_n65783632)
print v(xbgr.mr_n65783744)
print v(xbgr.mr_n65784064)
print v(xbgr.mr_n65784176)
print v(xbgr.mr_n65784496)
print v(xbgr.mr_n65784608)
print v(xbgr.mr_n65784928)
print v(xbgr.mr_n65785040)
print v(xbgr.mr_n65785360)
print v(xbgr.mr_n65785472)
print v(xbgr.mr_n65785792)
print v(xbgr.mr_n65785904)
print v(xbgr.mr_n65786224)
print v(xbgr.mr_n65786336)
print v(xbgr.mr_n65786656)
print v(xbgr.mr_n65786768)
print v(xbgr.mr_n65787088)
print v(xbgr.mr_n65787200)
print v(xbgr.mr_n65787520)
print v(xbgr.mr_n65787632)
print v(xbgr.mr_n65787952)
print v(xbgr.mr_n65788064)
print v(xbgr.mr_n65788384)
print v(xbgr.mr_n65788496)
print v(xbgr.mr_n65788816)
print v(xbgr.mr_n65788928)
print v(xbgr.mr_n65789248)
print v(xbgr.mr_n65789360)
print v(xbgr.mr_n65789680)
print v(xbgr.mr_n65789792)
print v(xbgr.mr_n65790112)
print v(xbgr.mr_n65790224)
print v(xbgr.mr_n65790544)
print v(xbgr.mr_n65790656)
print v(xbgr.mr_n65790976)
print v(xbgr.mr_n65791088)
print v(xbgr.mr_n65791408)
print v(xbgr.mr_n65791520)
print v(xbgr.mr_n65791840)
print v(xbgr.mr_n65791952)
print v(xbgr.mr_n65792272)
print v(xbgr.mr_n65792384)
print v(xbgr.mr_n65792704)
print v(xbgr.mr_n65792816)
print v(xbgr.mr_n65793136)
print v(xbgr.mr_n65793248)
print v(xbgr.mr_n65793568)
print v(xbgr.mr_n65793680)
print v(xbgr.mr_n65794000)
print v(xbgr.mr_n65794112)
print v(xbgr.mr_n65794656)
print v(xbgr.mr_n65794768)
print v(xbgr.mr_n65795088)
print v(xbgr.mr_n65795200)
print v(xbgr.mr_n65795520)
print v(xbgr.mr_n65795632)
print v(xbgr.mr_n65795952)
print v(xbgr.mr_n65796064)
print v(xbgr.mr_n65796384)
print v(xbgr.mr_n65796496)
print v(xbgr.mr_n65796816)
print v(xbgr.mr_n65796928)
print v(xbgr.mr_n65797248)
print v(xbgr.mr_n65797360)
print v(xbgr.mr_n65797680)
print v(xbgr.mr_n65797792)
print v(xbgr.mr_n65798112)
print v(xbgr.mr_n65798224)
print v(xbgr.mr_n65798544)
print v(xbgr.mr_n65798656)
print v(xbgr.mr_n65798976)
print v(xbgr.mr_n65799088)
print v(xbgr.mr_n65799408)
print v(xbgr.mr_n65799520)
print v(xbgr.mr_n65799840)
print v(xbgr.mr_n65799952)
print v(xbgr.mr_n65800272)
print v(xbgr.mr_n65800384)
print v(xbgr.mr_n65800704)
print v(xbgr.mr_n65800816)
print v(xbgr.mr_n65801136)
print v(xbgr.mr_n65801248)
print v(xbgr.mr_n65801568)
print v(xbgr.mr_n65801680)
print v(xbgr.mr_n65802000)
print v(xbgr.mr_n65802112)
print v(xbgr.mr_n65802432)
print v(xbgr.mr_n65802544)
print v(xbgr.mr_n65802864)
print v(xbgr.mr_n65802976)
print v(xbgr.mr_n65803296)
print v(xbgr.mr_n65803408)
print v(xbgr.mr_n65803728)
print v(xbgr.mr_n65803840)
print v(xbgr.mr_n65804160)
print v(xbgr.mr_n65804272)
print v(xbgr.mr_n65804592)
print v(xbgr.mr_n65804704)
print v(xbgr.mr_n65805024)
print v(xbgr.mr_n65805136)
print v(xbgr.mr_n65805456)
print v(xbgr.mr_n65805568)
print v(xbgr.mr_n65805888)
print v(xbgr.mr_n65806000)
print v(xbgr.mr_n65806320)
print v(xbgr.mr_n65806432)
print v(xbgr.mr_n65806752)
print v(xbgr.mr_n65806864)
print v(xbgr.mr_n65807184)
print v(xbgr.mr_n65807296)
print v(xbgr.mr_n65807616)
print v(xbgr.mr_n65807728)
print v(xbgr.mr_n65808048)
print v(xbgr.mr_n65808160)
print v(xbgr.mr_n65808480)
print v(xbgr.mr_n65808592)
print v(xbgr.mr_n65808912)
print v(xbgr.mr_n65809024)
print v(xbgr.mr_n65809344)
print v(xbgr.mr_n65809456)
print v(xbgr.mr_n65809776)
print v(xbgr.mr_n65809888)
print v(xbgr.mr_n65810208)
print v(xbgr.mr_n65810320)
print v(xbgr.mr_n65810640)
print v(xbgr.mr_n65810752)
print v(xbgr.mr_n65811072)
print v(xbgr.mr_n65811184)
print v(xbgr.mr_n65811504)
print v(xbgr.mr_n65811616)
print v(xbgr.mr_n65811936)
print v(xbgr.mr_n65812048)
print v(xbgr.mr_n65812368)
print v(xbgr.mr_n65812480)
print v(xbgr.mr_n65812800)
print v(xbgr.mr_n65812912)
print v(xbgr.mr_n65813232)
print v(xbgr.mr_n65813344)
print v(xbgr.mr_n65813664)
print v(xbgr.mr_n65813776)
print v(xbgr.mr_n65814096)
print v(xbgr.mr_n65814208)
print v(xbgr.mr_n65814528)
print v(xbgr.mr_n65814640)
print v(xbgr.mr_n65814960)
print v(xbgr.mr_n65815072)
print v(xbgr.mr_n65815392)
print v(xbgr.mr_n65815504)
print v(xbgr.mr_n65815824)
print v(xbgr.mr_n65815936)
print v(xbgr.mr_n65816256)
print v(xbgr.mr_n65816368)
print v(xbgr.mr_n65816688)
print v(xbgr.mr_n65816800)
print v(xbgr.mr_n65817120)
print v(xbgr.mr_n65817232)
print v(xbgr.mr_n65817552)
print v(xbgr.mr_n65817664)
print v(xbgr.mr_n65817984)
print v(xbgr.mr_n65818096)
print v(xbgr.mr_n65818416)
print v(xbgr.mr_n65818528)
print v(xbgr.mr_n65818848)
print v(xbgr.mr_n65818960)
print v(xbgr.mr_n65819280)
print v(xbgr.mr_n65819392)
print v(xbgr.mr_n65819712)
print v(xbgr.mr_n65819824)
print v(xbgr.mr_n65820144)
print v(xbgr.mr_n65820256)
print v(xbgr.mr_n65820576)
print v(xbgr.mr_n65820688)
print v(xbgr.mr_n65821008)
print v(xbgr.mr_n65821120)
print v(xbgr.mr_n65821440)
print v(xbgr.mr_n65821552)
print v(xbgr.mr_n65821872)
print v(xbgr.mr_n65821984)
print v(xbgr.mr_n65822304)
print v(xbgr.mr_n65822416)
print v(xbgr.mr_n65822736)
print v(xbgr.mr_n65822848)
print v(xbgr.mr_n65823168)
print v(xbgr.mr_n65823280)
print v(xbgr.mr_n65823600)
print v(xbgr.mr_n65823712)
print v(xbgr.mr_n65824032)
print v(xbgr.mr_n65824144)
print v(xbgr.mr_n65824464)
print v(xbgr.mr_n65824576)
print v(xbgr.mr_n65824896)
print v(xbgr.mr_n65825008)
print v(xbgr.mr_n65825328)
print v(xbgr.mr_n65825440)
print v(xbgr.mr_n65825760)
print v(xbgr.mr_n65825872)
print v(xbgr.mr_n65826192)
print v(xbgr.mr_n65826304)
print v(xbgr.mr_n65826624)
print v(xbgr.mr_n65826736)
print v(xbgr.mr_n65827056)
print v(xbgr.mr_n65827168)
print v(xbgr.mr_n65827488)
print v(xbgr.mr_n65827600)
print v(xbgr.mr_n65827920)
print v(xbgr.mr_n65828032)
print v(xbgr.mr_n65828352)
print v(xbgr.mr_n65828464)
print v(xbgr.mr_n65828784)
print v(xbgr.mr_n65828896)
print v(xbgr.mr_n65829216)
print v(xbgr.mr_n65829328)
print v(xbgr.mr_n65829648)
print v(xbgr.mr_n65829760)
print v(xbgr.mr_n65830080)
print v(xbgr.mr_n65830192)
print v(xbgr.mr_n65830512)
print v(xbgr.mr_n65830624)
print v(xbgr.mr_n65830944)
print v(xbgr.mr_n65831056)
print v(xbgr.mr_n65831376)
print v(xbgr.mr_n65831488)
print v(xbgr.mr_n65831808)
print v(xbgr.mr_n65831920)
print v(xbgr.mr_n65832240)
print v(xbgr.mr_n65832352)
print v(xbgr.mr_n65832672)
print v(xbgr.mr_n65832784)
print v(xbgr.mr_n65833104)
print v(xbgr.mr_n65833216)
print v(xbgr.mr_n65833536)
print v(xbgr.mr_n65833648)
print v(xbgr.mr_n65833968)
print v(xbgr.mr_n65834080)
print v(xbgr.mr_n65834400)
print v(xbgr.mr_n65834512)
print v(xbgr.mr_n65834832)
print v(xbgr.mr_n65834944)
print v(xbgr.mr_n65835264)
print v(xbgr.mr_n65835376)
print v(xbgr.mr_n65835696)
print v(xbgr.mr_n65835808)
print v(xbgr.mr_n65836128)
print v(xbgr.mr_n65836240)
print v(xbgr.mr_n65836560)
print v(xbgr.mr_n65836672)
print v(xbgr.mr_n65836992)
print v(xbgr.mr_n65837104)
print v(xbgr.mr_n65837424)
print v(xbgr.mr_n65837536)
print v(xbgr.mr_n65837856)
print v(xbgr.mr_n65837968)
print v(xbgr.mr_n65838288)
print v(xbgr.mr_n65838400)
print v(xbgr.mr_n65838720)
print v(xbgr.mr_n65838832)
print v(xbgr.mr_n65839152)
print v(xbgr.mr_n65839264)
print v(xbgr.mr_n65839584)
print v(xbgr.mr_n65839696)
print v(xbgr.mr_n65840016)
print v(xbgr.mr_n65840128)
print v(xbgr.mr_n65840448)
print v(xbgr.mr_n65840560)
print v(xbgr.mr_n65840880)
print v(xbgr.mr_n65840992)
print v(xbgr.mr_n65841312)
print v(xbgr.mr_n65841424)
print v(xbgr.mr_n65841744)
print v(xbgr.mr_n65841856)
print v(xbgr.mr_n65842176)
print v(xbgr.mr_n65842288)
print v(xbgr.mr_n65842608)
print v(xbgr.mr_n65842720)
print v(xbgr.mr_n65843040)
print v(xbgr.mr_n65843152)
print v(xbgr.mr_n65843472)
print v(xbgr.mr_n65843584)
print v(xbgr.mr_n65843904)
print v(xbgr.mr_n65844016)
print v(xbgr.mr_n65844336)
print v(xbgr.mr_n65844448)
print v(xbgr.mr_n65844768)
print v(xbgr.mr_n65844880)
print v(xbgr.mr_n65845200)
print v(xbgr.mr_n65845312)
print v(xbgr.mr_n65845632)
print v(xbgr.mr_n65845744)
print v(xbgr.mr_n65846064)
print v(xbgr.mr_n65846176)
print v(xbgr.mr_n65846496)
print v(xbgr.mr_n65846608)
print v(xbgr.mr_n65846928)
print v(xbgr.mr_n65847040)
print v(xbgr.mr_n65847360)
print v(xbgr.mr_n65847472)
print v(xbgr.mr_n65847792)
print v(xbgr.mr_n65847904)
print v(xbgr.mr_n65848224)
print v(xbgr.mr_n65848336)
print v(xbgr.mr_n65848656)
print v(xbgr.mr_n65848768)
print v(xbgr.mr_n65849088)
print v(xbgr.mr_n65849200)
print v(xbgr.mr_n65849520)
print v(xbgr.mr_n65849632)
print v(xbgr.mr_n65849952)
print v(xbgr.mr_n65850064)
print v(xbgr.mr_n65850384)
print v(xbgr.mr_n65850496)
print v(xbgr.mr_n65850816)
print v(xbgr.mr_n65850928)
print v(xbgr.mr_n65851248)
print v(xbgr.mr_n65851360)
print v(xbgr.mr_n65851680)
print v(xbgr.mr_n65851792)
print v(xbgr.mr_n65852112)
print v(xbgr.mr_n65852224)
print v(xbgr.mr_n65852544)
print v(xbgr.mr_n65852656)
print v(xbgr.mr_n65852976)
print v(xbgr.mr_n65853088)
print v(xbgr.mr_n65853408)
print v(xbgr.mr_n65853520)
print v(xbgr.mr_n65853840)
print v(xbgr.mr_n65853952)
print v(xbgr.mr_n65854272)
print v(xbgr.mr_n65854384)
print v(xbgr.mr_n65854704)
print v(xbgr.mr_n65854816)
print v(xbgr.mr_n65855136)
print v(xbgr.mr_n65855248)
print v(xbgr.mr_n65855568)
print v(xbgr.mr_n65855680)
print v(xbgr.mr_n65856000)
print v(xbgr.mr_n65856112)
print v(xbgr.mr_n65856432)
print v(xbgr.mr_n65856544)
print v(xbgr.mr_n65856864)
print v(xbgr.mr_n65856976)
print v(xbgr.mr_n65857296)
print v(xbgr.mr_n65857408)
print v(xbgr.mr_n65857728)
print v(xbgr.mr_n65857840)
print v(xbgr.mr_n65858160)
print v(xbgr.mr_n65858272)
print v(xbgr.mr_n65858592)
print v(xbgr.mr_n65858704)
print v(xbgr.mr_n65859024)
print v(xbgr.mr_n65859136)
print v(xbgr.mr_n65859456)
print v(xbgr.mr_n65859568)
print v(xbgr.mr_n65859888)
print v(xbgr.mr_n65860000)
print v(xbgr.mr_n65860320)
print v(xbgr.mr_n65860432)
print v(xbgr.mr_n65860752)
print v(xbgr.mr_n65860864)
print v(xbgr.mr_n65861184)
print v(xbgr.mr_n65861296)
print v(xbgr.mr_n65861616)
print v(xbgr.mr_n65861728)
print v(xbgr.mr_n65862048)
print v(xbgr.mr_n65862160)
print v(xbgr.mr_n65862480)
print v(xbgr.mr_n65862592)
print v(xbgr.mr_n65862912)
print v(xbgr.mr_n65863024)
print v(xbgr.mr_n65863344)
print v(xbgr.mr_n65863456)
print v(xbgr.mr_n65863776)
print v(xbgr.mr_n65863888)
print v(xbgr.mr_n65864208)
print v(xbgr.mr_n65864320)
print v(xbgr.mr_n65864640)
print v(xbgr.mr_n65864752)
print v(xbgr.mr_n65865072)
print v(xbgr.mr_n65865184)
print v(xbgr.mr_n65865504)
print v(xbgr.mr_n65865616)
print v(xbgr.mr_n65865936)
print v(xbgr.mr_n65866048)
print v(xbgr.mr_n65866368)
print v(xbgr.mr_n65866480)
print v(xbgr.mr_n65866800)
print v(xbgr.mr_n65866912)
print v(xbgr.mr_n65867232)
print v(xbgr.mr_n65867344)
print v(xbgr.mr_n65867664)
print v(xbgr.mr_n65867776)
print v(xbgr.mr_n65868096)
print v(xbgr.mr_n65868208)
print v(xbgr.mr_n65868528)
print v(xbgr.mr_n65868640)
print v(xbgr.mr_n65868960)
print v(xbgr.mr_n65869072)
print v(xbgr.mr_n65869392)
print v(xbgr.mr_n65869504)
print v(xbgr.mr_n65869824)
print v(xbgr.mr_n65869936)
print v(xbgr.mr_n65870256)
print v(xbgr.mr_n65870368)
print v(xbgr.mr_n65870688)
print v(xbgr.mr_n65870800)
print v(xbgr.mr_n65871120)
print v(xbgr.mr_n65871232)
print v(xbgr.mr_n65871552)
print v(xbgr.mr_n65871664)
print v(xbgr.mr_n65871984)
print v(xbgr.mr_n65872096)
print v(xbgr.mr_n65872416)
print v(xbgr.mr_n65872528)
print v(xbgr.mr_n65872848)
print v(xbgr.mr_n65872960)
print v(xbgr.mr_n65873280)
print v(xbgr.mr_n65873392)
print v(xbgr.mr_n65873712)
print v(xbgr.mr_n65873824)
print v(xbgr.mr_n65874144)
print v(xbgr.mr_n65874256)
print v(xbgr.mr_n65874576)
print v(xbgr.mr_n65874688)
print v(xbgr.mr_n65875008)
print v(xbgr.mr_n65875120)
print v(xbgr.mr_n65875440)
print v(xbgr.mr_n65875552)
print v(xbgr.mr_n65875872)
print v(xbgr.mr_n65875984)
print v(xbgr.mr_n65876304)
print v(xbgr.mr_n65876416)
print v(xbgr.mr_n65876736)
print v(xbgr.mr_n65876848)
print v(xbgr.mr_n65877168)
print v(xbgr.mr_n65877280)
print v(xbgr.mr_n65877600)
print v(xbgr.mr_n65877712)
print v(xbgr.mr_n65878032)
print v(xbgr.mr_n65878144)
print v(xbgr.mr_n65878464)
print v(xbgr.mr_n65878576)
print v(xbgr.mr_n65878896)
print v(xbgr.mr_n65879008)
print v(xbgr.mr_n65879328)
print v(xbgr.mr_n65879440)
print v(xbgr.mr_n65879760)
print v(xbgr.mr_n65879872)
print v(xbgr.mr_n65880192)
print v(xbgr.mr_n65880304)
print v(xbgr.mr_n65880624)
print v(xbgr.mr_n65880736)
print v(xbgr.mr_n65881056)
print v(xbgr.mr_n65881168)
print v(xbgr.mr_n65881488)
print v(xbgr.mr_n65881600)
print v(xbgr.mr_n65881920)
print v(xbgr.mr_n65882032)
print v(xbgr.mr_n65882352)
print v(xbgr.mr_n65882464)
print v(xbgr.mr_n65882784)
print v(xbgr.mr_n65882896)
print v(xbgr.mr_n65883216)
print v(xbgr.mr_n65883328)
print v(xbgr.mr_n65883648)
print v(xbgr.mr_n65883760)
print v(xbgr.mr_n65884080)
print v(xbgr.mr_n65884192)
print v(xbgr.mr_n65884512)
print v(xbgr.mr_n65884624)
print v(xbgr.mr_n65884944)
print v(xbgr.mr_n65885056)
print v(xbgr.mr_n65885376)
print v(xbgr.mr_n65885488)
print v(xbgr.mr_n65885808)
print v(xbgr.mr_n65885920)
print v(xbgr.mr_n65886240)
print v(xbgr.mr_n65886352)
print v(xbgr.mr_n65886672)
print v(xbgr.mr_n65886784)
print v(xbgr.mr_n65887104)
print v(xbgr.mr_n65887216)
print v(xbgr.mr_n65887536)
print v(xbgr.mr_n65887648)
print v(xbgr.mr_n65887968)
print v(xbgr.mr_n65888080)
print v(xbgr.mr_n65888400)
print v(xbgr.mr_n65888512)
print v(xbgr.mr_n65888832)
print v(xbgr.mr_n65888944)
print v(xbgr.mr_n65889264)
print v(xbgr.mr_n65889376)
print v(xbgr.mr_n65889696)
print v(xbgr.mr_n65889808)
print v(xbgr.mr_n65890128)
print v(xbgr.mr_n65890240)
print v(xbgr.mr_n65890560)
print v(xbgr.mr_n65890672)
print v(xbgr.mr_n65890992)
print v(xbgr.mr_n65891104)
print v(xbgr.mr_n65891424)
print v(xbgr.mr_n65891536)
print v(xbgr.mr_n65891856)
print v(xbgr.mr_n65891968)
print v(xbgr.mr_n65892288)
print v(xbgr.mr_n65892400)
print v(xbgr.mr_n65892720)
print v(xbgr.mr_n66897424)
print v(xbgr.mr_n66897680)
print v(xbgr.mr_n66897792)
print v(xbgr.mr_n66898048)
print v(xbgr.mr_n66898160)
print v(xbgr.mr_n66898416)
print v(xbgr.mr_n66898528)
print v(xbgr.mr_n66898784)
print v(xbgr.mr_n66898896)
print v(xbgr.mr_n66899152)
print v(xbgr.mr_n66899264)
print v(xbgr.mr_n66899520)
print v(xbgr.mr_n66899632)
print v(xbgr.mr_n66899888)
print v(xbgr.mr_n66900000)
print v(xbgr.mr_n66900256)
print v(xbgr.mr_n66900368)
print v(xbgr.mr_n66900688)
print v(xbgr.mr_n66900800)
print v(xbgr.mr_n66901120)
print v(xbgr.mr_n66901232)
print v(xbgr.mr_n66901552)
print v(xbgr.mr_n66901664)
print v(xbgr.mr_n66901984)
print v(xbgr.mr_n66902096)
print v(xbgr.mr_n66902416)
print v(xbgr.mr_n66902528)
print v(xbgr.mr_n66902848)
print v(xbgr.mr_n66902960)
print v(xbgr.mr_n66903280)
print v(xbgr.mr_n66903392)
print v(xbgr.mr_n66903712)
print v(xbgr.mr_n66903824)
print v(xbgr.mr_n66904144)
print v(xbgr.mr_n66904256)
print v(xbgr.mr_n66904576)
print v(xbgr.mr_n66904688)
print v(xbgr.mr_n66905008)
print v(xbgr.mr_n66905120)
print v(xbgr.mr_n66905440)
print v(xbgr.mr_n66905552)
print v(xbgr.mr_n66905872)
print v(xbgr.mr_n66905984)
print v(xbgr.mr_n66906304)
print v(xbgr.mr_n66906416)
print v(xbgr.mr_n66906736)
print v(xbgr.mr_n66906848)
print v(xbgr.mr_n66907168)
print v(xbgr.mr_n66907280)
print v(xbgr.mr_n66907600)
print v(xbgr.mr_n66907712)
print v(xbgr.mr_n66908032)
print v(xbgr.mr_n66908144)
print v(xbgr.mr_n66908464)
print v(xbgr.mr_n66908576)
print v(xbgr.mr_n66908896)
print v(xbgr.mr_n66909008)
print v(xbgr.mr_n66909328)
print v(xbgr.mr_n66909440)
print v(xbgr.mr_n66909760)
print v(xbgr.mr_n66909872)
print v(xbgr.mr_n66910192)
print v(xbgr.mr_n66910304)
print v(xbgr.mr_n66910624)
print v(xbgr.mr_n66910736)
print v(xbgr.mr_n66911056)
print v(xbgr.mr_n66911168)
print v(xbgr.mr_n66911488)
print v(xbgr.mr_n66911600)
print v(xbgr.mr_n66911920)
print v(xbgr.mr_n66912032)
print v(xbgr.mr_n66912352)
print v(xbgr.mr_n66912464)
print v(xbgr.mr_n66912784)
print v(xbgr.mr_n66912896)
print v(xbgr.mr_n66913216)
print v(xbgr.mr_n66913328)
print v(xbgr.mr_n66913648)
print v(xbgr.mr_n66913760)
print v(xbgr.mr_n66914080)
print v(xbgr.mr_n66914192)
print v(xbgr.mr_n66914512)
print v(xbgr.mr_n66914624)
print v(xbgr.mr_n66914944)
print v(xbgr.mr_n66915056)
print v(xbgr.mr_n66915376)
print v(xbgr.mr_n66915488)
print v(xbgr.mr_n66915808)
print v(xbgr.mr_n66915920)
print v(xbgr.mr_n66916240)
print v(xbgr.mr_n66916352)
print v(xbgr.mr_n66916672)
print v(xbgr.mr_n66916784)
print v(xbgr.mr_n66917104)
print v(xbgr.mr_n66917216)
print v(xbgr.mr_n66917536)
print v(xbgr.mr_n66917648)
print v(xbgr.mr_n66917968)
print v(xbgr.mr_n66918080)
print v(xbgr.mr_n66918400)
print v(xbgr.mr_n66918512)
print v(xbgr.mr_n66918832)
print v(xbgr.mr_n66918944)
print v(xbgr.mr_n66919264)
print v(xbgr.mr_n66919376)
print v(xbgr.mr_n66919696)
print v(xbgr.mr_n66919808)
print v(xbgr.mr_n66920128)
print v(xbgr.mr_n66920240)
print v(xbgr.mr_n66920560)
print v(xbgr.mr_n66920672)
print v(xbgr.mr_n66920992)
print v(xbgr.mr_n66921104)
print v(xbgr.mr_n66921424)
print v(xbgr.mr_n66921536)
print v(xbgr.mr_n66921856)
print v(xbgr.mr_n66921968)
print v(xbgr.mr_n66922288)
print v(xbgr.mr_n66922400)
print v(xbgr.mr_n66922720)
print v(xbgr.mr_n66922832)
print v(xbgr.mr_n66923152)
print v(xbgr.mr_n66923264)
print v(xbgr.mr_n66923584)
print v(xbgr.mr_n66923696)
print v(xbgr.mr_n66924016)
print v(xbgr.mr_n66924128)
print v(xbgr.mr_n66924448)
print v(xbgr.mr_n66924560)
print v(xbgr.mr_n66924880)
print v(xbgr.mr_n66924992)
print v(xbgr.mr_n66925312)
print v(xbgr.mr_n66925424)
print v(xbgr.mr_n66925744)
print v(xbgr.mr_n66925856)
print v(xbgr.mr_n66926176)
print v(xbgr.mr_n66926288)
print v(xbgr.mr_n66926608)
print v(xbgr.mr_n66926720)
print v(xbgr.mr_n66927040)
print v(xbgr.mr_n66927152)
print v(xbgr.mr_n66927472)
print v(xbgr.mr_n66927584)
print v(xbgr.mr_n66927904)
print v(xbgr.mr_n66928016)
print v(xbgr.mr_n66928336)
print v(xbgr.mr_n66928448)
print v(xbgr.mr_n66928768)
print v(xbgr.mr_n66928880)
print v(xbgr.mr_n66929200)
print v(xbgr.mr_n66929312)
print v(xbgr.mr_n66929632)
print v(xbgr.mr_n66929744)
print v(xbgr.mr_n66930064)
print v(xbgr.mr_n66930176)
print v(xbgr.mr_n66930496)
print v(xbgr.mr_n66930608)
print v(xbgr.mr_n66930928)
print v(xbgr.mr_n66931040)
print v(xbgr.mr_n66931360)
print v(xbgr.mr_n66931472)
print v(xbgr.mr_n66931792)
print v(xbgr.mr_n66931904)
print v(xbgr.mr_n66932224)
print v(xbgr.mr_n66932336)
print v(xbgr.mr_n66932656)
print v(xbgr.mr_n66932768)
print v(xbgr.mr_n66933088)
print v(xbgr.mr_n66933200)
print v(xbgr.mr_n66933520)
print v(xbgr.mr_n66933632)
print v(xbgr.mr_n66933952)
print v(xbgr.mr_n66934064)
print v(xbgr.mr_n66934384)
print v(xbgr.mr_n66934496)
print v(xbgr.mr_n66934816)
print v(xbgr.mr_n66934928)
print v(xbgr.mr_n66935248)
print v(xbgr.mr_n66935360)
print v(xbgr.mr_n66935680)
print v(xbgr.mr_n66935792)
print v(xbgr.mr_n66936112)
print v(xbgr.mr_n66936224)
print v(xbgr.mr_n66936544)
print v(xbgr.mr_n66936656)
print v(xbgr.mr_n66936976)
print v(xbgr.mr_n66937088)
print v(xbgr.mr_n66937408)
print v(xbgr.mr_n66937520)
print v(xbgr.mr_n66937840)
print v(xbgr.mr_n66937952)
print v(xbgr.mr_n66938272)
print v(xbgr.mr_n66938384)
print v(xbgr.mr_n66938704)
print v(xbgr.mr_n66938816)
print v(xbgr.mr_n66939136)
print v(xbgr.mr_n66939248)
print v(xbgr.mr_n66939568)
print v(xbgr.mr_n66939680)
print v(xbgr.mr_n66940000)
print v(xbgr.mr_n66940112)
print v(xbgr.mr_n66940432)
print v(xbgr.mr_n66940544)
print v(xbgr.mr_n66940864)
print v(xbgr.mr_n66940976)
print v(xbgr.mr_n66941296)
print v(xbgr.mr_n66941408)
print v(xbgr.mr_n66941728)
print v(xbgr.mr_n66941840)
print v(xbgr.mr_n66942160)
print v(xbgr.mr_n66942272)
print v(xbgr.mr_n66942592)
print v(xbgr.mr_n66942704)
print v(xbgr.mr_n66943024)
print v(xbgr.mr_n66943136)
print v(xbgr.mr_n66943456)
print v(xbgr.mr_n66943568)
print v(xbgr.mr_n66943888)
print v(xbgr.mr_n66944000)
print v(xbgr.mr_n66944320)
print v(xbgr.mr_n66944432)
print v(xbgr.mr_n66944752)
print v(xbgr.mr_n66944864)
print v(xbgr.mr_n66945184)
print v(xbgr.mr_n66945296)
print v(xbgr.mr_n66945616)
print v(xbgr.mr_n66945728)
print v(xbgr.mr_n66946048)
print v(xbgr.mr_n66946160)
print v(xbgr.mr_n66946480)
print v(xbgr.mr_n66946592)
print v(xbgr.mr_n66946912)
print v(xbgr.mr_n66947024)
print v(xbgr.mr_n66947344)
print v(xbgr.mr_n66947456)
print v(xbgr.mr_n66947776)
print v(xbgr.mr_n66947888)
print v(xbgr.mr_n66948208)
print v(xbgr.mr_n66948320)
print v(xbgr.mr_n66948640)
print v(xbgr.mr_n66948752)
print v(xbgr.mr_n66949072)
print v(xbgr.mr_n66949184)
print v(xbgr.mr_n66949504)
print v(xbgr.mr_n66949616)
print v(xbgr.mr_n66949936)
print v(xbgr.mr_n66950048)
print v(xbgr.mr_n66950368)
print v(xbgr.mr_n66950480)
print v(xbgr.mr_n66950800)
print v(xbgr.mr_n66950912)
print v(xbgr.mr_n66951232)
print v(xbgr.mr_n66951344)
print v(xbgr.mr_n66951664)
print v(xbgr.mr_n66951776)
print v(xbgr.mr_n66952096)
print v(xbgr.mr_n66952208)
print v(xbgr.mr_n66952528)
print v(xbgr.mr_n66952640)
print v(xbgr.mr_n66952960)
print v(xbgr.mr_n66953072)
print v(xbgr.mr_n66953392)
print v(xbgr.mr_n66953504)
print v(xbgr.mr_n66953824)
print v(xbgr.mr_n66953936)
print v(xbgr.mr_n66954256)
print v(xbgr.mr_n66954368)
print v(xbgr.mr_n66954688)
print v(xbgr.mr_n66954800)
print v(xbgr.mr_n66955120)
print v(xbgr.mr_n66955232)
print v(xbgr.mr_n66955552)
print v(xbgr.mr_n66955664)
print v(xbgr.mr_n66955984)
print v(xbgr.mr_n66956096)
print v(xbgr.mr_n66956416)
print v(xbgr.mr_n66956528)
print v(xbgr.mr_n66956848)
print v(xbgr.mr_n66956960)
print v(xbgr.mr_n66957280)
print v(xbgr.mr_n66957392)
print v(xbgr.mr_n66957712)
print v(xbgr.mr_n66957824)
print v(xbgr.mr_n66958144)
print v(xbgr.mr_n66958256)
print v(xbgr.mr_n66958576)
print v(xbgr.mr_n66958688)
print v(xbgr.mr_n66959008)
print v(xbgr.mr_n66959120)
print v(xbgr.mr_n66959440)
print v(xbgr.mr_n66959552)
print v(xbgr.mr_n66959872)
print v(xbgr.mr_n66959984)
print v(xbgr.mr_n66960304)
print v(xbgr.mr_n66960416)
print v(xbgr.mr_n66960736)
print v(xbgr.mr_n66960848)
print v(xbgr.mr_n66961168)
print v(xbgr.mr_n66961280)
print v(xbgr.mr_n66961600)
print v(xbgr.mr_n66961712)
print v(xbgr.mr_n66962032)
print v(xbgr.mr_n66962144)
print v(xbgr.mr_n66962464)
print v(xbgr.mr_n66962576)
print v(xbgr.mr_n66962896)
print v(xbgr.mr_n66963008)
print v(xbgr.mr_n66963328)
print v(xbgr.mr_n66963440)
print v(xbgr.mr_n66963760)
print v(xbgr.mr_n66963872)
print v(xbgr.mr_n66964192)
print v(xbgr.mr_n66964304)
print v(xbgr.mr_n66964624)
print v(xbgr.mr_n66964736)
print v(xbgr.mr_n66965056)
print v(xbgr.mr_n66965168)
print v(xbgr.mr_n66965488)
print v(xbgr.mr_n66965600)
print v(xbgr.mr_n66965920)
print v(xbgr.mr_n66966032)
print v(xbgr.mr_n66966352)
print v(xbgr.mr_n66966464)
print v(xbgr.mr_n66966784)
print v(xbgr.mr_n66966896)
print v(xbgr.mr_n66967216)
print v(xbgr.mr_n66967328)
print v(xbgr.mr_n66967648)
print v(xbgr.mr_n66967760)
print v(xbgr.mr_n66968080)
print v(xbgr.mr_n66968192)
print v(xbgr.mr_n66968512)
print v(xbgr.mr_n66968624)
print v(xbgr.mr_n66968944)
print v(xbgr.mr_n66969056)
print v(xbgr.mr_n66969376)
print v(xbgr.mr_n66969488)
print v(xbgr.mr_n66969808)
print v(xbgr.mr_n66969920)
print v(xbgr.mr_n66970240)
print v(xbgr.mr_n66970352)
print v(xbgr.mr_n66970672)
print v(xbgr.mr_n66970784)
print v(xbgr.mr_n66971104)
print v(xbgr.mr_n66971216)
print v(xbgr.mr_n66971536)
print v(xbgr.mr_n66971648)
print v(xbgr.mr_n66971968)
print v(xbgr.mr_n66972080)
print v(xbgr.mr_n66972400)
print v(xbgr.mr_n66972512)
print v(xbgr.mr_n66972832)
print v(xbgr.mr_n66972944)
print v(xbgr.mr_n66973264)
print v(xbgr.mr_n66973376)
print v(xbgr.mr_n66973696)
print v(xbgr.mr_n66973808)
print v(xbgr.mr_n66974128)
print v(xbgr.mr_n66974240)
print v(xbgr.mr_n66974560)
print v(xbgr.mr_n66974672)
print v(xbgr.mr_n66974992)
print v(xbgr.mr_n66975104)
print v(xbgr.mr_n66975424)
print v(xbgr.mr_n66975536)
print v(xbgr.mr_n66975856)
print v(xbgr.mr_n66975968)
print v(xbgr.mr_n66976288)
print v(xbgr.mr_n66976400)
print v(xbgr.mr_n66976720)
print v(xbgr.mr_n66976832)
print v(xbgr.mr_n66977152)
print v(xbgr.mr_n66977264)
print v(xbgr.mr_n66977584)
print v(xbgr.mr_n66977696)
print v(xbgr.mr_n66978016)
print v(xbgr.mr_n66978128)
print v(xbgr.mr_n66978448)
print v(xbgr.mr_n66978560)
print v(xbgr.mr_n66978880)
print v(xbgr.mr_n66978992)
print v(xbgr.mr_n66979312)
print v(xbgr.mr_n66979424)
print v(xbgr.mr_n66979744)
print v(xbgr.mr_n66979856)
print v(xbgr.mr_n66980176)
print v(xbgr.mr_n66980288)
print v(xbgr.mr_n66980608)
print v(xbgr.mr_n66980720)
print v(xbgr.mr_n66981040)
print v(xbgr.mr_n66981152)
print v(xbgr.mr_n66981472)
print v(xbgr.mr_n66981584)
print v(xbgr.mr_n66981904)
print v(xbgr.mr_n66982016)
print v(xbgr.mr_n66982336)
print v(xbgr.mr_n66982448)
print v(xbgr.mr_n66982768)
print v(xbgr.mr_n66982880)
print v(xbgr.mr_n66983200)
print v(xbgr.mr_n66983312)
print v(xbgr.mr_n66983632)
print v(xbgr.mr_n66983744)
print v(xbgr.mr_n66984064)
print v(xbgr.mr_n66984176)
print v(xbgr.mr_n66984496)
print v(xbgr.mr_n66984608)
print v(xbgr.mr_n66984928)
print v(xbgr.mr_n66985040)
print v(xbgr.mr_n66985360)
print v(xbgr.mr_n66985472)
print v(xbgr.mr_n66985792)
print v(xbgr.mr_n66985904)
print v(xbgr.mr_n66986224)
print v(xbgr.mr_n66986336)
print v(xbgr.mr_n66986656)
print v(xbgr.mr_n66986768)
print v(xbgr.mr_n66987088)
print v(xbgr.mr_n66987200)
print v(xbgr.mr_n66987520)
print v(xbgr.mr_n66987632)
print v(xbgr.mr_n66987952)
print v(xbgr.mr_n66988064)
print v(xbgr.mr_n66988384)
print v(xbgr.mr_n66988496)
print v(xbgr.mr_n66988816)
print v(xbgr.mr_n66988928)
print v(xbgr.mr_n66989248)
print v(xbgr.mr_n66989360)
print v(xbgr.mr_n66989680)
print v(xbgr.mr_n66989792)
print v(xbgr.mr_n66990112)
print v(xbgr.mr_n66990224)
print v(xbgr.mr_n66990544)
print v(xbgr.mr_n66990656)
print v(xbgr.mr_n66990976)
print v(xbgr.mr_n66991088)
print v(xbgr.mr_n66991408)
print v(xbgr.mr_n66991520)
print v(xbgr.mr_n66991840)
print v(xbgr.mr_n66991952)
print v(xbgr.mr_n66992272)
print v(xbgr.mr_n66992384)
print v(xbgr.mr_n66992704)
print v(xbgr.mr_n66992816)
print v(xbgr.mr_n66993136)
print v(xbgr.mr_n66993248)
print v(xbgr.mr_n66993568)
print v(xbgr.mr_n66993680)
print v(xbgr.mr_n66994000)
print v(xbgr.mr_n66994112)
print v(xbgr.mr_n66994432)
print v(xbgr.mr_n66994544)
print v(xbgr.mr_n66994864)
print v(xbgr.mr_n66994976)
print v(xbgr.mr_n66995296)
print v(xbgr.mr_n66995408)
print v(xbgr.mr_n66995728)
print v(xbgr.mr_n66995840)
print v(xbgr.mr_n66996160)
print v(xbgr.mr_n66996272)
print v(xbgr.mr_n66996592)
print v(xbgr.mr_n66996704)
print v(xbgr.mr_n66997024)
print v(xbgr.mr_n66997136)
print v(xbgr.mr_n66997456)
print v(xbgr.mr_n66997568)
print v(xbgr.mr_n66997888)
print v(xbgr.mr_n66998000)
print v(xbgr.mr_n66998320)
print v(xbgr.mr_n66998432)
print v(xbgr.mr_n66998752)
print v(xbgr.mr_n66998864)
print v(xbgr.mr_n66999184)
print v(xbgr.mr_n66999296)
print v(xbgr.mr_n66999616)
print v(xbgr.mr_n66999728)
print v(xbgr.mr_n67000048)
print v(xbgr.mr_n67000160)
print v(xbgr.mr_n67000480)
print v(xbgr.mr_n67000592)
print v(xbgr.mr_n67000912)
print v(xbgr.mr_n67001024)
print v(xbgr.mr_n67001312)
print v(xbgr.mr_n67001424)
print v(xbgr.mr_n67001744)
print v(xbgr.mr_n67001856)
print v(xbgr.mr_n67002176)
print v(xbgr.mr_n67002288)
print v(xbgr.mr_n67002608)
print v(xbgr.mr_n67002720)
print v(xbgr.mr_n67003040)
print v(xbgr.mr_n67003152)
print v(xbgr.mr_n67003472)
print v(xbgr.mr_n67003584)
print v(xbgr.mr_n67003904)
print v(xbgr.mr_n67004016)
print v(xbgr.mr_n67004336)
print v(xbgr.mr_n67004448)
print v(xbgr.mr_n67004768)
print v(xbgr.mr_n67004880)
print v(xbgr.mr_n67005200)
print v(xbgr.mr_n67005312)
print v(xbgr.mr_n67005632)
print v(xbgr.mr_n67005744)
print v(xbgr.mr_n67006064)
print v(xbgr.mr_n67006176)
print v(xbgr.mr_n67006496)
print v(xbgr.mr_n67006608)
print v(xbgr.mr_n67006928)
print v(xbgr.mr_n67007040)
print v(xbgr.mr_n67007360)
print v(xbgr.mr_n67007472)
print v(xbgr.mr_n67007792)
print v(xbgr.mr_n67007904)
print v(xbgr.mr_n67008224)
print v(xbgr.mr_n67008336)
print v(xbgr.mr_n67008656)
print v(xbgr.mr_n67008768)
print v(xbgr.mr_n67009088)
print v(xbgr.mr_n67009200)
print v(xbgr.mr_n67009520)
print v(xbgr.mr_n67009632)
print v(xbgr.mr_n67009952)
print v(xbgr.mr_n67010064)
print v(xbgr.mr_n67010384)
print v(xbgr.mr_n67010496)
print v(xbgr.mr_n67010816)
print v(xbgr.mr_n67010928)
print v(xbgr.mr_n67011248)
print v(xbgr.mr_n67011360)
print v(xbgr.mr_n67011680)
print v(xbgr.mr_n67011792)
print v(xbgr.mr_n67012112)
print v(xbgr.mr_n67012224)
print v(xbgr.mr_n67012544)
print v(xbgr.mr_n67012656)
print v(xbgr.mr_n67012976)
print v(xbgr.mr_n67013088)
print v(xbgr.mr_n67013408)
print v(xbgr.mr_n67013520)
print v(xbgr.mr_n67013840)
print v(xbgr.mr_n67013952)
print v(xbgr.mr_n67014272)
print v(xbgr.mr_n67014384)
print v(xbgr.mr_n67014704)
print v(xbgr.mr_n67014816)
print v(xbgr.mr_n67015136)
print v(xbgr.mr_n67015248)
print v(xbgr.mr_n67015568)
print v(xbgr.mr_n67015680)
print v(xbgr.mr_n67016000)
print v(xbgr.mr_n67016112)
print v(xbgr.mr_n67016432)
print v(xbgr.mr_n67016544)
print v(xbgr.mr_n67016864)
print v(xbgr.mr_n67016976)
print v(xbgr.mr_n67017296)
print v(xbgr.mr_n67017408)
print v(xbgr.mr_n67017728)
print v(xbgr.mr_n67017840)
print v(xbgr.mr_n67018160)
print v(xbgr.mr_n67018272)
print v(xbgr.mr_n67018592)
print v(xbgr.mr_n67018704)
print v(xbgr.mr_n67019024)
print v(xbgr.mr_n67019136)
print v(xbgr.mr_n67019456)
print v(xbgr.mr_n67019568)
print v(xbgr.mr_n67019888)
print v(xbgr.mr_n67020000)
print v(xbgr.mr_n67020320)
print v(xbgr.mr_n67020432)
print v(xbgr.mr_n67020752)
print v(xbgr.mr_n67020864)
print v(xbgr.mr_n67021184)
print v(xbgr.mr_n67021296)
print v(xbgr.mr_n67021616)
print v(xbgr.mr_n67021728)
print v(xbgr.mr_n67022048)
print v(xbgr.mr_n67022160)
print v(xbgr.mr_n67022480)
print v(xbgr.mr_n67022592)
print v(xbgr.mr_n67022912)
print v(xbgr.mr_n67023024)
print v(xbgr.mr_n67023344)
print v(xbgr.mr_n67023456)
print v(xbgr.mr_n67023776)
print v(xbgr.mr_n67023888)
print v(xbgr.mr_n67024208)
print v(xbgr.mr_n67024320)
print v(xbgr.mr_n67024640)
print v(xbgr.mr_n67024752)
print v(xbgr.mr_n67025072)
print v(xbgr.mr_n67025184)
print v(xbgr.mr_n67025504)
print v(xbgr.mr_n67025616)
print v(xbgr.mr_n67025936)
print v(xbgr.mr_n67026048)
print v(xbgr.mr_n67026368)
print v(xbgr.mr_n67026480)
print v(xbgr.mr_n67026800)
print v(xbgr.mr_n67026912)
print v(xbgr.mr_n67027232)
print v(xbgr.mr_n67027344)
print v(xbgr.mr_n67027664)
print v(xbgr.mr_n67027776)
print v(xbgr.mr_n67028096)
print v(xbgr.mr_n67028208)
print v(xbgr.mr_n67028528)
print v(xbgr.mr_n67028640)
print v(xbgr.mr_n67028960)
print v(xbgr.mr_n67029072)
print v(xbgr.mr_n67029392)
print v(xbgr.mr_n67029504)
print v(xbgr.mr_n67029824)
print v(xbgr.mr_n67029936)
print v(xbgr.mr_n67030256)
print v(xbgr.mr_n67030368)
print v(xbgr.mr_n67030688)
print v(xbgr.mr_n67030800)
print v(xbgr.mr_n67031120)
print v(xbgr.mr_n67031232)
print v(xbgr.mr_n67031552)
print v(xbgr.mr_n67031664)
print v(xbgr.mr_n67031984)
print v(xbgr.mr_n67032096)
print v(xbgr.mr_n67032416)
print v(xbgr.mr_n67032528)
print v(xbgr.mr_n67032848)
print v(xbgr.mr_n67032960)
print v(xbgr.mr_n67033280)
print v(xbgr.mr_n67033392)
print v(xbgr.mr_n67033712)
print v(xbgr.mr_n67033824)
print v(xbgr.mr_n67034144)
print v(xbgr.mr_n67034256)
print v(xbgr.mr_n67034576)
print v(xbgr.mr_n67034688)
print v(xbgr.mr_n67035008)
print v(xbgr.mr_n67035120)
print v(xbgr.mr_n67035440)
print v(xbgr.mr_n67035552)
print v(xbgr.mr_n67035872)
print v(xbgr.mr_n67035984)
print v(xbgr.mr_n67036304)
print v(xbgr.mr_n67036416)
print v(xbgr.mr_n67036736)
print v(xbgr.mr_n67036848)
print v(xbgr.mr_n67037168)
print v(xbgr.mr_n67037280)
print v(xbgr.mr_n67037600)
print v(xbgr.mr_n67037712)
print v(xbgr.mr_n67038032)
print v(xbgr.mr_n67038144)
print v(xbgr.mr_n67038464)
print v(xbgr.mr_n67038576)
print v(xbgr.mr_n67038896)
print v(xbgr.mr_n67039008)
print v(xbgr.mr_n67039328)
print v(xbgr.mr_n67039440)
print v(xbgr.mr_n67039760)
print v(xbgr.mr_n67039872)
print v(xbgr.mr_n67040192)
print v(xbgr.mr_n67040304)
print v(xbgr.mr_n67040624)
print v(xbgr.mr_n67040736)
print v(xbgr.mr_n67041056)
print v(xbgr.mr_n67041168)
print v(xbgr.mr_n67041488)
print v(xbgr.mr_n67041600)
print v(xbgr.mr_n67041920)
print v(xbgr.mr_n67042032)
print v(xbgr.mr_n67042352)
print v(xbgr.mr_n67042464)
print v(xbgr.mr_n67042784)
print v(xbgr.mr_n67042896)
print v(xbgr.mr_n67043216)
print v(xbgr.mr_n67043328)
print v(xbgr.mr_n67043648)
print v(xbgr.mr_n67043760)
print v(xbgr.mr_n67044080)
print v(xbgr.mr_n67044192)
print v(xbgr.mr_n67044512)
print v(xbgr.mr_n67044624)
print v(xbgr.mr_n67044944)
print v(xbgr.mr_n67045056)
print v(xbgr.mr_n67045376)
print v(xbgr.mr_n67045488)
print v(xbgr.mr_n67045808)
print v(xbgr.mr_n67045920)
print v(xbgr.mr_n67046240)
print v(xbgr.mr_n67046352)
print v(xbgr.mr_n67046672)
print v(xbgr.mr_n67046784)
print v(xbgr.mr_n67047104)
print v(xbgr.mr_n67047216)
print v(xbgr.mr_n67047536)
print v(xbgr.mr_n67047648)
print v(xbgr.mr_n67047968)
print v(xbgr.mr_n67048080)
print v(xbgr.mr_n67048400)
print v(xbgr.mr_n67048512)
print v(xbgr.mr_n67048832)
print v(xbgr.mr_n67048944)
print v(xbgr.mr_n67049264)
print v(xbgr.mr_n67049376)
print v(xbgr.mr_n67049696)
print v(xbgr.mr_n67049808)
print v(xbgr.mr_n67050128)
print v(xbgr.mr_n67050240)
print v(xbgr.mr_n67050560)
print v(xbgr.mr_n67050672)
print v(xbgr.mr_n67050992)
print v(xbgr.mr_n67051104)
print v(xbgr.mr_n67051424)
print v(xbgr.mr_n67051536)
print v(xbgr.mr_n67051856)
print v(xbgr.mr_n67051968)
print v(xbgr.mr_n67052288)
print v(xbgr.mr_n67052400)
print v(xbgr.mr_n67052720)
print v(xbgr.mr_n67052832)
print v(xbgr.mr_n67053152)
print v(xbgr.mr_n67053264)
print v(xbgr.mr_n67053584)
print v(xbgr.mr_n67053696)
print v(xbgr.mr_n67054016)
print v(xbgr.mr_n67054128)
print v(xbgr.mr_n67054448)
print v(xbgr.mr_n67054560)
print v(xbgr.mr_n67054880)
print v(xbgr.mr_n67054992)
print v(xbgr.mr_n67055312)
print v(xbgr.mr_n67055424)
print v(xbgr.mr_n67055744)
print v(xbgr.mr_n67055856)
print v(xbgr.mr_n67056176)
print v(xbgr.mr_n67056288)
print v(xbgr.mr_n67056608)
print v(xbgr.mr_n67056720)
print v(xbgr.mr_n67057040)
print v(xbgr.mr_n67057152)
print v(xbgr.mr_n67057472)
print v(xbgr.mr_n67057584)
print v(xbgr.mr_n67057904)
print v(xbgr.mr_n67058016)
print v(xbgr.mr_n67058336)
print v(xbgr.mr_n67058448)
print v(xbgr.mr_n67058768)
print v(xbgr.mr_n67058880)
print v(xbgr.mr_n67059200)
print v(xbgr.mr_n67059312)
print v(xbgr.mr_n67059632)
print v(xbgr.mr_n67059744)
print v(xbgr.mr_n67060064)
print v(xbgr.mr_n67060176)
print v(xbgr.mr_n67060496)
print v(xbgr.mr_n67060608)
print v(xbgr.mr_n67060928)
print v(xbgr.mr_n67061040)
print v(xbgr.mr_n67061360)
print v(xbgr.mr_n67061472)
print v(xbgr.mr_n67061792)
print v(xbgr.mr_n67061904)
print v(xbgr.mr_n67062224)
print v(xbgr.mr_n67062336)
print v(xbgr.mr_n67062656)
print v(xbgr.mr_n67062768)
print v(xbgr.mr_n67063088)
print v(xbgr.mr_n67063200)
print v(xbgr.mr_n67063520)
print v(xbgr.mr_n67063632)
print v(xbgr.mr_n67063952)
print v(xbgr.mr_n67064064)
print v(xbgr.mr_n67064384)
print v(xbgr.mr_n67064496)
print v(xbgr.mr_n67064816)
print v(xbgr.mr_n67064928)
print v(xbgr.mr_n67065248)
print v(xbgr.mr_n67065360)
print v(xbgr.mr_n67065680)
print v(xbgr.mr_n67065792)
print v(xbgr.mr_n67066112)
print v(xbgr.mr_n67066224)
print v(xbgr.mr_n67066544)
print v(xbgr.mr_n67066656)
print v(xbgr.mr_n67066976)
print v(xbgr.mr_n67067088)
print v(xbgr.mr_n67067408)
print v(xbgr.mr_n67067520)
print v(xbgr.mr_n67067840)
print v(xbgr.mr_n67067952)
print v(xbgr.mr_n67068272)
print v(xbgr.mr_n67068384)
print v(xbgr.mr_n67068704)
print v(xbgr.mr_n67068816)
print v(xbgr.mr_n67069136)
print v(xbgr.mr_n67069248)
print v(xbgr.mr_n67069568)
print v(xbgr.mr_n67069680)
print v(xbgr.mr_n67070000)
print v(xbgr.mr_n67070112)
print v(xbgr.mr_n67070432)
print v(xbgr.mr_n67070544)
print v(xbgr.mr_n67070864)
print v(xbgr.mr_n67070976)
print v(xbgr.mr_n67071296)
print v(xbgr.mr_n67071408)
print v(xbgr.mr_n67071728)
print v(xbgr.mr_n67071840)
print v(xbgr.mr_n67072160)
print v(xbgr.mr_n67072272)
print v(xbgr.mr_n67072592)
print v(xbgr.mr_n67072704)
print v(xbgr.mr_n67073024)
print v(xbgr.mr_n67073136)
print v(xbgr.mr_n67073456)
print v(xbgr.mr_n67073568)
print v(xbgr.mr_n67073888)
print v(xbgr.mr_n67074000)
print v(xbgr.mr_n67074320)
print v(xbgr.mr_n67074432)
print v(xbgr.mr_n67074752)
print v(xbgr.mr_n67074864)
print v(xbgr.mr_n67075184)
print v(xbgr.mr_n67075296)
print v(xbgr.mr_n67075616)
print v(xbgr.mr_n67075728)
print v(xbgr.mr_n67076048)
print v(xbgr.mr_n67076160)
print v(xbgr.mr_n67076480)
print v(xbgr.mr_n67076592)
print v(xbgr.mr_n67076912)
print v(xbgr.mr_n67077024)
print v(xbgr.mr_n67077344)
print v(xbgr.mr_n67077456)
print v(xbgr.mr_n67077776)
print v(xbgr.mr_n67077888)
print v(xbgr.mr_n67078208)
print v(xbgr.mr_n67078320)
print v(xbgr.mr_n67078640)
print v(xbgr.mr_n67078752)
print v(xbgr.mr_n67079072)
print v(xbgr.mr_n67079184)
print v(xbgr.mr_n67079504)
print v(xbgr.mr_n67079616)
print v(xbgr.mr_n67079936)
print v(xbgr.mr_n67080048)
print v(xbgr.mr_n67080368)
print v(xbgr.mr_n67080480)
print v(xbgr.mr_n67080800)
print v(xbgr.mr_n67080912)
print v(xbgr.mr_n67081232)
print v(xbgr.mr_n67081344)
print v(xbgr.mr_n67081664)
print v(xbgr.mr_n67081776)
print v(xbgr.mr_n67082096)
print v(xbgr.mr_n67082208)
print v(xbgr.mr_n67082528)
print v(xbgr.mr_n67082640)
print v(xbgr.mr_n67082960)
print v(xbgr.mr_n67083072)
print v(xbgr.mr_n67083392)
print v(xbgr.mr_n67083504)
print v(xbgr.mr_n67083824)
print v(xbgr.mr_n67083936)
print v(xbgr.mr_n67084256)
print v(xbgr.mr_n67084368)
print v(xbgr.mr_n67084688)
print v(xbgr.mr_n67084800)
print v(xbgr.mr_n67085120)
print v(xbgr.mr_n67085232)
print v(xbgr.mr_n67085552)
print v(xbgr.mr_n67085664)
print v(xbgr.mr_n67085984)
print v(xbgr.mr_n67086096)
print v(xbgr.mr_n67086416)
print v(xbgr.mr_n67086528)
print v(xbgr.mr_n67086848)
print v(xbgr.mr_n67086960)
print v(xbgr.mr_n67087280)
print v(xbgr.mr_n67087392)
print v(xbgr.mr_n67087712)
print v(xbgr.mr_n67087824)
print v(xbgr.mr_n67088144)
print v(xbgr.mr_n67088256)
print v(xbgr.mr_n67088576)
print v(xbgr.mr_n67088688)
print v(xbgr.mr_n67089008)
print v(xbgr.mr_n67089120)
print v(xbgr.mr_n67089440)
print v(xbgr.mr_n67089552)
print v(xbgr.mr_n67089872)
print v(xbgr.mr_n67089984)
print v(xbgr.mr_n67090304)
print v(xbgr.mr_n67090416)
print v(xbgr.mr_n67090736)
print v(xbgr.mr_n67090848)
print v(xbgr.mr_n67091168)
print v(xbgr.mr_n67091280)
print v(xbgr.mr_n67091600)
print v(xbgr.mr_n67091712)
print v(xbgr.mr_n67092032)
print v(xbgr.mr_n67092144)
print v(xbgr.mr_n67092464)
print v(xbgr.mr_n67092576)
print v(xbgr.mr_n67092896)
print v(xbgr.mr_n67093008)
print v(xbgr.mr_n67093328)
print v(xbgr.mr_n67093440)
print v(xbgr.mr_n67093760)
print v(xbgr.mr_n67093872)
print v(xbgr.mr_n67094192)
print v(xbgr.mr_n67094304)
print v(xbgr.mr_n67094624)
print v(xbgr.mr_n67094736)
print v(xbgr.mr_n67095056)
print v(xbgr.mr_n67095168)
print v(xbgr.mr_n67095488)
print v(xbgr.mr_n67095600)
print v(xbgr.mr_n67095920)
print v(xbgr.mr_n67096032)
print v(xbgr.mr_n67096352)
print v(xbgr.mr_n67096464)
print v(xbgr.mr_n67096784)
print v(xbgr.mr_n67096896)
print v(xbgr.mr_n67097216)
print v(xbgr.mr_n67097328)
print v(xbgr.mr_n67097648)
print v(xbgr.mr_n67097760)
print v(xbgr.mr_n67098080)
print v(xbgr.mr_n67098192)
print v(xbgr.mr_n67098512)
print v(xbgr.mr_n67098624)
print v(xbgr.mr_n67098944)
print v(xbgr.mr_n67099056)
print v(xbgr.mr_n67099376)
print v(xbgr.mr_n67099488)
print v(xbgr.mr_n67099808)
print v(xbgr.mr_n67099920)
print v(xbgr.mr_n67100240)
print v(xbgr.mr_n67100352)
print v(xbgr.mr_n67100672)
print v(xbgr.mr_n67100784)
print v(xbgr.mr_n67101104)
print v(xbgr.mr_n67101216)
print v(xbgr.mr_n67101536)
print v(xbgr.mr_n67101648)
print v(xbgr.mr_n67101968)
print v(xbgr.mr_n67102080)
print v(xbgr.mr_n67102400)
print v(xbgr.mr_n67102512)
print v(xbgr.mr_n67102832)
print v(xbgr.mr_n67102944)
print v(xbgr.mr_n67103264)
print v(xbgr.mr_n67103376)
print v(xbgr.mr_n67103696)
print v(xbgr.mr_n67103808)
print v(xbgr.mr_n67104128)
print v(xbgr.mr_n67104240)
print v(xbgr.mr_n67104560)
print v(xbgr.mr_n67104672)
print v(xbgr.mr_n67104992)
print v(xbgr.mr_n67105104)
print v(xbgr.mr_n67105424)
print v(xbgr.mr_n67105536)
print v(xbgr.mr_n67105856)
print v(xbgr.mr_n67105968)
print v(xbgr.mr_n67106288)
print v(xbgr.mr_n67106400)
print v(xbgr.mr_n67106720)
print v(xbgr.mr_n67106832)
print v(xbgr.mr_n67107152)
print v(xbgr.mr_n67107264)
print v(xbgr.mr_n67107584)
print v(xbgr.mr_n67107696)
print v(xbgr.mr_n67108016)
print v(xbgr.mr_n67108128)
print v(xbgr.mr_n67108448)
print v(xbgr.mr_n67108560)
print v(xbgr.mr_n67108880)
print v(xbgr.mr_n67108992)
print v(xbgr.mr_n67109312)
print v(xbgr.mr_n67109424)
print v(xbgr.mr_n67109744)
print v(xbgr.mr_n67109856)
print v(xbgr.mr_n67110176)
print v(xbgr.mr_n67110288)
print v(xbgr.mr_n67110608)
print v(xbgr.mr_n67110720)
print v(xbgr.mr_n67111040)
print v(xbgr.mr_n67111152)
print v(xbgr.mr_n67111472)
print v(xbgr.mr_n67111584)
print v(xbgr.mr_n67111904)
print v(xbgr.mr_n67112016)
print v(xbgr.mr_n67112336)
print v(xbgr.mr_n67112448)
print v(xbgr.mr_n67112768)
print v(xbgr.mr_n67112880)
print v(xbgr.mr_n67113200)
print v(xbgr.mr_n67113312)
print v(xbgr.mr_n67113632)
print v(xbgr.mr_n67113744)
print v(xbgr.mr_n67114064)
print v(xbgr.mr_n67114176)
print v(xbgr.mr_n67114496)
print v(xbgr.mr_n67114608)
print v(xbgr.mr_n67114928)
print v(xbgr.mr_n67115040)
print v(xbgr.mr_n67115360)
print v(xbgr.mr_n67115472)
print v(xbgr.mr_n67115792)
print v(xbgr.mr_n67115904)
print v(xbgr.mr_n67116224)
print v(xbgr.mr_n67116336)
print v(xbgr.mr_n67116656)
print v(xbgr.mr_n67116768)
print v(xbgr.mr_n67117088)
print v(xbgr.mr_n67117200)
print v(xbgr.mr_n67117520)
print v(xbgr.mr_n67117632)
print v(xbgr.mr_n67117952)
print v(xbgr.mr_n67118064)
print v(xbgr.mr_n67118384)
print v(xbgr.mr_n67118496)
print v(xbgr.mr_n67118816)
print v(xbgr.mr_n67118928)
print v(xbgr.mr_n67119248)
print v(xbgr.mr_n67119360)
print v(xbgr.mr_n67119680)
print v(xbgr.mr_n67119792)
print v(xbgr.mr_n67120112)
print v(xbgr.mr_n67120224)
print v(xbgr.mr_n67120544)
print v(xbgr.mr_n67120656)
print v(xbgr.mr_n67120976)
print v(xbgr.mr_n67121088)
print v(xbgr.mr_n67121408)
print v(xbgr.mr_n67121520)
print v(xbgr.mr_n67121840)
print v(xbgr.mr_n67121952)
print v(xbgr.mr_n67122272)
print v(xbgr.mr_n67122384)
print v(xbgr.mr_n67122704)
print v(xbgr.mr_n67122816)
print v(xbgr.mr_n67123136)
print v(xbgr.mr_n67123248)
print v(xbgr.mr_n67123568)
print v(xbgr.mr_n67123680)
print v(xbgr.mr_n67124000)
print v(xbgr.mr_n67124112)
print v(xbgr.mr_n67124432)
print v(xbgr.mr_n67124544)
print v(xbgr.mr_n67124864)
print v(xbgr.mr_n67124976)
print v(xbgr.mr_n67125296)
print v(xbgr.mr_n67125408)
print v(xbgr.mr_n67125728)
print v(xbgr.mr_n67125840)
print v(xbgr.mr_n67126160)
print v(xbgr.mr_n67126272)
print v(xbgr.mr_n67126592)
print v(xbgr.mr_n67126704)
print v(xbgr.mr_n67127024)
print v(xbgr.mr_n67127136)
print v(xbgr.mr_n67127456)
print v(xbgr.mr_n67127568)
print v(xbgr.mr_n67127888)
print v(xbgr.mr_n67128000)
print v(xbgr.mr_n67128320)
print v(xbgr.mr_n67128432)
print v(xbgr.mr_n67128752)
print v(xbgr.mr_n67128864)
print v(xbgr.mr_n67129184)
print v(xbgr.mr_n67129296)
print v(xbgr.mr_n67129616)
print v(xbgr.mr_n67129728)
print v(xbgr.mr_n67130048)
print v(xbgr.mr_n67130160)
print v(xbgr.mr_n67130480)
print v(xbgr.mr_n67130592)
print v(xbgr.mr_n67130912)
print v(xbgr.mr_n67131024)
print v(xbgr.mr_n67131344)
print v(xbgr.mr_n67131456)
print v(xbgr.mr_n67131776)
print v(xbgr.mr_n67131888)
print v(xbgr.mr_n67132208)
print v(xbgr.mr_n67132320)
print v(xbgr.mr_n67132640)
print v(xbgr.mr_n67132752)
print v(xbgr.mr_n67133072)
print v(xbgr.mr_n67133184)
print v(xbgr.mr_n67133504)
print v(xbgr.mr_n67133616)
print v(xbgr.mr_n67133936)
print v(xbgr.mr_n67134048)
print v(xbgr.mr_n67134368)
print v(xbgr.mr_n67134480)
print v(xbgr.mr_n67134800)
print v(xbgr.mr_n67134912)
print v(xbgr.mr_n67135232)
print v(xbgr.mr_n67135344)
print v(xbgr.mr_n67135664)
print v(xbgr.mr_n67135776)
print v(xbgr.mr_n67136096)
print v(xbgr.mr_n67136208)
print v(xbgr.mr_n67136528)
print v(xbgr.mr_n67136640)
print v(xbgr.mr_n67136960)
print v(xbgr.mr_n67137072)
print v(xbgr.mr_n67137392)
print v(xbgr.mr_n67137504)
print v(xbgr.mr_n67137824)
print v(xbgr.mr_n67137936)
print v(xbgr.mr_n67138256)
print v(xbgr.mr_n67138368)
print v(xbgr.mr_n67138688)
print v(xbgr.mr_n67138800)
print v(xbgr.mr_n67139120)
print v(xbgr.mr_n67139232)
print v(xbgr.mr_n67139552)
print v(xbgr.mr_n67139664)
print v(xbgr.mr_n67139984)
print v(xbgr.mr_n67140096)
print v(xbgr.mr_n67140416)
print v(xbgr.mr_n67140528)
print v(xbgr.mr_n67140848)
print v(xbgr.mr_n67140960)
print v(xbgr.mr_n67141280)
print v(xbgr.mr_n67141392)
print v(xbgr.mr_n67141712)
print v(xbgr.mr_n67141824)
print v(xbgr.mr_n67142144)
print v(xbgr.mr_n67142256)
print v(xbgr.mr_n67142576)
print v(xbgr.mr_n67142688)
print v(xbgr.mr_n67143008)
print v(xbgr.mr_n67143120)
print v(xbgr.mr_n67143440)
print v(xbgr.mr_n67143552)
print v(xbgr.mr_n67143872)
print v(xbgr.mr_n67143984)
print v(xbgr.mr_n67144304)
print v(xbgr.mr_n67144416)
print v(xbgr.mr_n67144736)
print v(xbgr.mr_n67144848)
print v(xbgr.mr_n67145168)
print v(xbgr.mr_n67145280)
print v(xbgr.mr_n67145600)
print v(xbgr.mr_n67145712)
print v(xbgr.mr_n67146032)
print v(xbgr.mr_n67146144)
print v(xbgr.mr_n67146464)
print v(xbgr.mr_n67146576)
print v(xbgr.mr_n67146896)
print v(xbgr.mr_n67147008)
print v(xbgr.mr_n67147328)
print v(xbgr.mr_n67147440)
print v(xbgr.mr_n67147760)
print v(xbgr.mr_n67147872)
print v(xbgr.mr_n67148192)
print v(xbgr.mr_n67148304)
print v(xbgr.mr_n67148624)
print v(xbgr.mr_n67148736)
print v(xbgr.mr_n67149056)
print v(xbgr.mr_n67149168)
print v(xbgr.mr_n67149488)
print v(xbgr.mr_n67149600)
print v(xbgr.mr_n67149920)
print v(xbgr.mr_n67150032)
print v(xbgr.mr_n67150352)
print v(xbgr.mr_n67150464)
print v(xbgr.mr_n67150784)
print v(xbgr.mr_n67150896)
print v(xbgr.mr_n67151216)
print v(xbgr.mr_n67151328)
print v(xbgr.mr_n67151648)
print v(xbgr.mr_n67151760)
print v(xbgr.mr_n67152080)
print v(xbgr.mr_n67152192)
print v(xbgr.mr_n67152512)
print v(xbgr.mr_n67152624)
print v(xbgr.mr_n67152944)
print v(xbgr.mr_n67153056)
print v(xbgr.mr_n67153376)
print v(xbgr.mr_n67153488)
print v(xbgr.mr_n67153808)
print v(xbgr.mr_n67153920)
print v(xbgr.mr_n67154240)
print v(xbgr.mr_n67154352)
print v(xbgr.mr_n67154672)
print v(xbgr.mr_n67154784)
print v(xbgr.mr_n67155104)
print v(xbgr.mr_n67155216)
print v(xbgr.mr_n67155536)
print v(xbgr.mr_n67155648)
print v(xbgr.mr_n67155968)
print v(xbgr.mr_n67156080)
print v(xbgr.mr_n67156400)
print v(xbgr.mr_n67156512)
print v(xbgr.mr_n67156832)
print v(xbgr.mr_n67156944)
print v(xbgr.mr_n67157264)
print v(xbgr.mr_n67157376)
print v(xbgr.mr_n67157696)
print v(xbgr.mr_n67157808)
print v(xbgr.mr_n67158128)
print v(xbgr.mr_n67158240)
print v(xbgr.mr_n67158560)
print v(xbgr.mr_n67158672)
print v(xbgr.mr_n67158992)
print v(xbgr.mr_n67159104)
print v(xbgr.mr_n67159424)
print v(xbgr.mr_n67159536)
print v(xbgr.mr_n67159856)
print v(xbgr.mr_n67159968)
print v(xbgr.mr_n67160288)
print v(xbgr.mr_n67160400)
print v(xbgr.mr_n67160720)
print v(xbgr.mr_n67160832)
print v(xbgr.mr_n67161152)
print v(xbgr.mr_n67161264)
print v(xbgr.mr_n67161584)
print v(xbgr.mr_n67161696)
print v(xbgr.mr_n67162016)
print v(xbgr.mr_n67162128)
print v(xbgr.mr_n67162448)
print v(xbgr.mr_n67162560)
print v(xbgr.mr_n67162880)
print v(xbgr.mr_n67162992)
print v(xbgr.mr_n67163312)
print v(xbgr.mr_n67163424)
print v(xbgr.mr_n67163744)
print v(xbgr.mr_n67163856)
print v(xbgr.mr_n67164176)
print v(xbgr.mr_n67164288)
print v(xbgr.mr_n67164608)
print v(xbgr.mr_n67164720)
print v(xbgr.mr_n67165040)
print v(xbgr.mr_n67165152)
print v(xbgr.mr_n67165472)
print v(xbgr.mr_n67165584)
print v(xbgr.mr_n67165904)
print v(xbgr.mr_n67166016)
print v(xbgr.mr_n67166336)
print v(xbgr.mr_n67166448)
print v(xbgr.mr_n67166768)
print v(xbgr.mr_n67166880)
print v(xbgr.mr_n67167200)
print v(xbgr.mr_n67167312)
print v(xbgr.mr_n67167632)
print v(xbgr.mr_n67167744)
print v(xbgr.mr_n67168064)
print v(xbgr.mr_n67168176)
print v(xbgr.mr_n67168496)
print v(xbgr.mr_n67168608)
print v(xbgr.mr_n67168928)
print v(xbgr.mr_n67169040)
print v(xbgr.mr_n67169360)
print v(xbgr.mr_n67169472)
print v(xbgr.mr_n67169792)
print v(xbgr.mr_n67169904)
print v(xbgr.mr_n67170224)
print v(xbgr.mr_n67170336)
print v(xbgr.mr_n67170656)
print v(xbgr.mr_n67170768)
print v(xbgr.mr_n67171088)
print v(xbgr.mr_n67171200)
print v(xbgr.mr_n67171520)
print v(xbgr.mr_n67171632)
print v(xbgr.mr_n67171952)
print v(xbgr.mr_n67172064)
print v(xbgr.mr_n67172384)
print v(xbgr.mr_n67172496)
print v(xbgr.mr_n67172816)
print v(xbgr.mr_n67172928)
print v(xbgr.mr_n67173248)
print v(xbgr.mr_n67173360)
print v(xbgr.mr_n67173680)
print v(xbgr.mr_n67173792)
print v(xbgr.mr_n67174112)
print v(xbgr.mr_n67174224)
print v(xbgr.mr_n67174544)
print v(xbgr.mr_n67174656)
print v(xbgr.mr_n67174976)
print v(xbgr.mr_n67175088)
print v(xbgr.mr_n67175408)
print v(xbgr.mr_n67175520)
print v(xbgr.mr_n67175840)
print v(xbgr.mr_n67175952)
print v(xbgr.mr_n67176272)
print v(xbgr.mr_n67176384)
print v(xbgr.mr_n67176704)
print v(xbgr.mr_n67176816)
print v(xbgr.mr_n67177136)
print v(xbgr.mr_n67177248)
print v(xbgr.mr_n67177568)
print v(xbgr.mr_n67177680)
print v(xbgr.mr_n67178000)
print v(xbgr.mr_n67178112)
print v(xbgr.mr_n67178432)
print v(xbgr.mr_n67178544)
print v(xbgr.mr_n67178864)
print v(xbgr.mr_n67178976)
print v(xbgr.mr_n67179296)
print v(xbgr.mr_n67179408)
print v(xbgr.mr_n67179728)
print v(xbgr.mr_n67179840)
print v(xbgr.mr_n67180160)
print v(xbgr.mr_n67180272)
print v(xbgr.mr_n67180592)
print v(xbgr.mr_n67180704)
print v(xbgr.mr_n67181024)
print v(xbgr.mr_n67181136)
print v(xbgr.mr_n67181456)
print v(xbgr.mr_n67181568)
print v(xbgr.mr_n67181888)
print v(xbgr.mr_n67182000)
print v(xbgr.mr_n67182320)
print v(xbgr.mr_n67182432)
print v(xbgr.mr_n67182752)
print v(xbgr.mr_n67182864)
print v(xbgr.mr_n67183184)
print v(xbgr.mr_n67183296)
print v(xbgr.mr_n67183616)
print v(xbgr.mr_n67183728)
print v(xbgr.mr_n67184048)
print v(xbgr.mr_n67184160)
print v(xbgr.mr_n67184480)
print v(xbgr.mr_n67184592)
print v(xbgr.mr_n67184912)
print v(xbgr.mr_n67185024)
print v(xbgr.mr_n67185344)
print v(xbgr.mr_n67185456)
print v(xbgr.mr_n67185776)
print v(xbgr.mr_n67185888)
print v(xbgr.mr_n67186208)
print v(xbgr.mr_n67186320)
print v(xbgr.mr_n67186640)
print v(xbgr.mr_n67186752)
print v(xbgr.mr_n67187072)
print v(xbgr.mr_n67187184)
print v(xbgr.mr_n67187504)
print v(xbgr.mr_n67187616)
print v(xbgr.mr_n67187936)
print v(xbgr.mr_n67188048)
print v(xbgr.mr_n67188368)
print v(xbgr.mr_n67188480)
print v(xbgr.mr_n67188800)
print v(xbgr.mr_n67188912)
print v(xbgr.mr_n67189232)
print v(xbgr.mr_n67189344)
print v(xbgr.mr_n67189664)
print v(xbgr.mr_n67189776)
print v(xbgr.mr_n67190096)
print v(xbgr.mr_n67190208)
print v(xbgr.mr_n67190528)
print v(xbgr.mr_n67190640)
print v(xbgr.mr_n67190960)
print v(xbgr.mr_n67191072)
print v(xbgr.mr_n67191392)
print v(xbgr.mr_n67191504)
print v(xbgr.mr_n67191824)
print v(xbgr.mr_n67191936)
print v(xbgr.mr_n67192256)
print v(xbgr.mr_n67192368)
print v(xbgr.mr_n67192688)
print v(xbgr.mr_n67192800)
print v(xbgr.mr_n67193120)
print v(xbgr.mr_n67193232)
print v(xbgr.mr_n67193552)
print v(xbgr.mr_n67193664)
print v(xbgr.mr_n67193984)
print v(xbgr.mr_n67194096)
print v(xbgr.mr_n67194416)
print v(xbgr.mr_n67194528)
print v(xbgr.mr_n67194848)
print v(xbgr.mr_n67194960)
print v(xbgr.mr_n67195280)
print v(xbgr.mr_n67195392)
print v(xbgr.mr_n67195712)
print v(xbgr.mr_n67195824)
print v(xbgr.mr_n67196144)
print v(xbgr.mr_n67196256)
print v(xbgr.mr_n67196576)
print v(xbgr.mr_n67196688)
print v(xbgr.mr_n67197008)
print v(xbgr.mr_n67197120)
print v(xbgr.mr_n67197440)
print v(xbgr.mr_n67197552)
print v(xbgr.mr_n67197872)
print v(xbgr.mr_n67197984)
print v(xbgr.mr_n67198304)
print v(xbgr.mr_n67198416)
print v(xbgr.mr_n67198736)
print v(xbgr.mr_n67198848)
print v(xbgr.mr_n67199168)
print v(xbgr.mr_n67199280)
print v(xbgr.mr_n67199600)
print v(xbgr.mr_n67199712)
print v(xbgr.mr_n67200032)
print v(xbgr.mr_n67200144)
print v(xbgr.mr_n67200464)
print v(xbgr.mr_n67200576)
print v(xbgr.mr_n67200896)
print v(xbgr.mr_n67201008)
print v(xbgr.mr_n67201328)
print v(xbgr.mr_n67201440)
print v(xbgr.mr_n67201760)
print v(xbgr.mr_n67201872)
print v(xbgr.mr_n67202192)
print v(xbgr.mr_n67202304)
print v(xbgr.mr_n67202624)
print v(xbgr.mr_n67202736)
print v(xbgr.mr_n67203056)
print v(xbgr.mr_n67203168)
print v(xbgr.mr_n67203488)
print v(xbgr.mr_n67203600)
print v(xbgr.mr_n67203920)
print v(xbgr.mr_n67204032)
print v(xbgr.mr_n67204352)
print v(xbgr.mr_n67204464)
print v(xbgr.mr_n67204784)
print v(xbgr.mr_n67204896)
print v(xbgr.mr_n67205216)
print v(xbgr.mr_n67205328)
print v(xbgr.mr_n67205648)
print v(xbgr.mr_n67205760)
print v(xbgr.mr_n67206080)
print v(xbgr.mr_n67206192)
print v(xbgr.mr_n67206624)
print v(xbgr.mr_n67206944)
print v(xbgr.mr_n67207056)
print v(xbgr.mr_n67207488)
print v(xbgr.mr_n67207808)
print v(xbgr.mr_n67207920)
print v(xbgr.mr_n67208352)
print v(xbgr.mr_n67208672)
print v(xbgr.mr_n67209536)
print v(xbgr.mr_n67210400)
print v(xbgr.mr_n67211264)
print v(xbgr.mr_n67212128)
print v(xbgr.mr_n67212992)
print v(xbgr.mr_n67213856)
print v(xbgr.mr_n67213968)
print v(xbgr.mr_n67214288)
print v(xbgr.mr_n67214400)
print v(xbgr.mr_n67214720)
print v(xbgr.mr_n67214832)
print v(xbgr.mr_n67215152)
print v(xbgr.mr_n67215264)
print v(xbgr.mr_n67215584)
print v(xbgr.mr_n67216448)
print v(xbgr.mr_n67217312)
print v(xbgr.mr_n67218176)
print v(xbgr.mr_n67218288)
print v(xbgr.mr_n67218608)
print v(xbgr.mr_n67218720)
print v(xbgr.mr_n67219040)
print v(xbgr.mr_n67219152)
print v(xbgr.mr_n67219584)
print v(xbgr.mr_n67220016)
print v(xbgr.mr_n67220448)
print v(xbgr.mr_n67220768)
print v(xbgr.mr_n67220880)
print v(xbgr.mr_n67221200)
print v(xbgr.mr_n67221312)
print v(xbgr.mr_n67221632)
print v(xbgr.mr_n67221744)
print v(xbgr.mr_n67222064)
print v(xbgr.mr_n67222176)
print v(xbgr.mr_n67222496)
print v(xbgr.mr_n67222608)
print v(xbgr.mr_n67222928)
print v(xbgr.mr_n67223040)
print v(xbgr.mr_n67223360)
print v(xbgr.mr_n67223472)
print v(xbgr.mr_n67223792)
print v(xbgr.mr_n67223904)
print v(xbgr.mr_n67224224)
print v(xbgr.mr_n67224336)
print v(xbgr.mr_n67224656)
print v(xbgr.mr_n67224768)
print v(xbgr.mr_n67225088)
print v(xbgr.mr_n67225200)
print v(xbgr.mr_n67225520)
print v(xbgr.mr_n67225632)
print v(xbgr.mr_n67225952)
print v(xbgr.mr_n67226064)
print v(xbgr.mr_n67226384)
print v(xbgr.mr_n67226496)
print v(xbgr.mr_n67226816)
print v(xbgr.mr_n67226928)
print v(xbgr.mr_n67227248)
print v(xbgr.mr_n67227360)
print v(xbgr.mr_n67227680)
print v(xbgr.mr_n67227792)
print v(xbgr.mr_n67228112)
print v(xbgr.mr_n67228224)
print v(xbgr.mr_n67228544)
print v(xbgr.mr_n67228656)
print v(xbgr.mr_n67228976)
print v(xbgr.mr_n67229088)
print v(xbgr.mr_n67229408)
print v(xbgr.mr_n67229520)
print v(xbgr.mr_n67229840)
print v(xbgr.mr_n67229952)
print v(xbgr.mr_n67230272)
print v(xbgr.mr_n67230384)
print v(xbgr.mr_n67230704)
print v(xbgr.mr_n67230816)
print v(xbgr.mr_n67231136)
print v(xbgr.mr_n67231248)
print v(xbgr.mr_n67231568)
print v(xbgr.mr_n67231680)
print v(xbgr.mr_n67232000)
print v(xbgr.mr_n67232112)
print v(xbgr.mr_n67232432)
print v(xbgr.mr_n67232544)
print v(xbgr.mr_n67232864)
print v(xbgr.mr_n67232976)
print v(xbgr.mr_n67233296)
print v(xbgr.mr_n67233408)
print v(xbgr.mr_n67233728)
print v(xbgr.mr_n67233840)
print v(xbgr.mr_n67234272)
print v(xbgr.mr_n67234592)
print v(xbgr.mr_n67234704)
print v(xbgr.mr_n67235136)
print v(xbgr.mr_n67235456)
print v(xbgr.mr_n67236320)
print v(xbgr.mr_n67237184)
print v(xbgr.mr_n67238048)
print v(xbgr.mr_n67238912)
print v(xbgr.mr_n67239024)
print v(xbgr.mr_n67239344)
print v(xbgr.mr_n67239456)
print v(xbgr.mr_n67239776)
print v(xbgr.mr_n67239888)
print v(xbgr.mr_n67240208)
print v(xbgr.mr_n67240320)
print v(xbgr.mr_n67240640)
print v(xbgr.mr_n67241504)
print v(xbgr.mr_n67242368)
print v(xbgr.mr_n67242480)
print v(xbgr.mr_n67242800)
print v(xbgr.mr_n67242912)
print v(xbgr.mr_n67243232)
print v(xbgr.mr_n67243344)
print v(xbgr.mr_n67243664)
print v(xbgr.mr_n67243776)
print v(xbgr.mr_n67244096)
print v(xbgr.mr_n67244208)
print v(xbgr.mr_n67244640)
print v(xbgr.mr_n67244960)
print v(xbgr.mr_n67245072)
print v(xbgr.mr_n67245504)
print v(xbgr.mr_n67245824)
print v(xbgr.mr_n67246688)
print v(xbgr.mr_n67247552)
print v(xbgr.mr_n67248416)
print v(xbgr.mr_n67249280)
print v(xbgr.mr_n67249392)
print v(xbgr.mr_n67249712)
print v(xbgr.mr_n67249824)
print v(xbgr.mr_n67250144)
print v(xbgr.mr_n67250256)
print v(xbgr.mr_n67250576)
print v(xbgr.mr_n67250688)
print v(xbgr.mr_n67251008)
print v(xbgr.mr_n67251872)
print v(xbgr.mr_n67252736)
print v(xbgr.mr_n67252848)
print v(xbgr.mr_n67253280)
print v(xbgr.mr_n67253600)
print v(xbgr.mr_n67253712)
print v(xbgr.mr_n67254032)
print v(xbgr.mr_n67254144)
print v(xbgr.mr_n67254464)
print v(xbgr.mr_n67254576)
print v(xbgr.mr_n67254896)
print v(xbgr.mr_n67255008)
print v(xbgr.mr_n67255328)
print v(xbgr.mr_n67255440)
print v(xbgr.mr_n67255872)
print v(xbgr.mr_n67256192)
print v(xbgr.mr_n67257056)
print v(xbgr.mr_n67257168)
print v(xbgr.mr_n67257600)
print v(xbgr.mr_n67257920)
print v(xbgr.mr_n67258032)
print v(xbgr.mr_n67258464)
print v(xbgr.mr_n67258784)
print v(xbgr.mr_n67258896)
print v(xbgr.mr_n67259216)
print v(xbgr.mr_n67259328)
print v(xbgr.mr_n67259648)
print v(xbgr.mr_n67259760)
print v(xbgr.mr_n67260080)
print v(xbgr.mr_n67260192)
print v(xbgr.mr_n67260512)
print v(xbgr.mr_n67261376)
print v(xbgr.mr_n67262240)
print v(xbgr.mr_n67262352)
print v(xbgr.mr_n67262672)
print v(xbgr.mr_n67262784)
print v(xbgr.mr_n67263104)
print v(xbgr.mr_n67263216)
print v(xbgr.mr_n67263536)
print v(xbgr.mr_n67263648)
print v(xbgr.mr_n67263968)
print v(xbgr.mr_n67264832)
print v(xbgr.mr_n67265696)
print v(xbgr.mr_n67265808)
print v(xbgr.mr_n67266128)
print v(xbgr.mr_n67266240)
print v(xbgr.mr_n67266560)
print v(xbgr.mr_n67267424)
print v(xbgr.mr_n67267536)
print v(xbgr.mr_n67267856)
print v(xbgr.mr_n67267968)
print v(xbgr.mr_n67268288)
print v(xbgr.mr_n67268400)
print v(xbgr.mr_n67268720)
print v(xbgr.mr_n67268832)
print v(xbgr.mr_n67269152)
print v(xbgr.mr_n67269264)
print v(xbgr.mr_n67269584)
print v(xbgr.mr_n67269696)
print v(xbgr.mr_n67270016)
print v(xbgr.mr_n67270880)
print v(xbgr.mr_n67271680)
print v(xbgr.mr_n67271792)
print v(xbgr.mr_n67272112)
print v(xbgr.mr_n67272224)
print v(xbgr.mr_n67272544)
print v(xbgr.mr_n67272656)
print v(xbgr.mr_n67272976)
print v(xbgr.mr_n67273088)
print v(xbgr.mr_n67273408)
print v(xbgr.mr_n67273520)
print v(xbgr.mr_n67273840)
print v(xbgr.mr_n67273952)
print v(xbgr.mr_n67274272)
print v(xbgr.mr_n67274384)
print v(xbgr.mr_n67274704)
print v(xbgr.mr_n67274816)
print v(xbgr.mr_n67275136)
print v(xbgr.mr_n67275248)
print v(xbgr.mr_n67275568)
print v(xbgr.mr_n67275680)
print v(xbgr.mr_n67276000)
print v(xbgr.mr_n67276112)
print v(xbgr.mr_n67276432)
print v(xbgr.mr_n67276544)
print v(xbgr.mr_n67276864)
print v(xbgr.mr_n67276976)
print v(xbgr.mr_n67277296)
print v(xbgr.mr_n67277408)
print v(xbgr.mr_n67277728)
print v(xbgr.mr_n67277840)
print v(xbgr.mr_n67278160)
print v(xbgr.mr_n67278272)
print v(xbgr.mr_n67278592)
print v(xbgr.mr_n67278704)
print v(xbgr.mr_n67279024)
print v(xbgr.mr_n67279136)
print v(xbgr.mr_n67279456)
print v(xbgr.mr_n67279568)
print v(xbgr.mr_n67279888)
print v(xbgr.mr_n67280000)
print v(xbgr.mr_n67280320)
print v(xbgr.mr_n67280432)
print v(xbgr.mr_n67280752)
print v(xbgr.mr_n67280864)
print v(xbgr.mr_n67281184)
print v(xbgr.mr_n67281296)
print v(xbgr.mr_n67281616)
print v(xbgr.mr_n67281728)
print v(xbgr.mr_n67282048)
print v(xbgr.mr_n67282160)
print v(xbgr.mr_n67282480)
print v(xbgr.mr_n67282592)
print v(xbgr.mr_n67282912)
print v(xbgr.mr_n67283024)
print v(xbgr.mr_n67283344)
print v(xbgr.mr_n67283456)
print v(xbgr.mr_n67283776)
print v(xbgr.mr_n67283888)
print v(xbgr.mr_n67284208)
print v(xbgr.mr_n67284320)
print v(xbgr.mr_n67284640)
print v(xbgr.mr_n67284752)
print v(xbgr.mr_n67285072)
print v(xbgr.mr_n67285184)
print v(xbgr.mr_n67285504)
print v(xbgr.mr_n67285616)
print v(xbgr.mr_n67285936)
print v(xbgr.mr_n67286048)
print v(xbgr.mr_n67286368)
print v(xbgr.mr_n67286480)
print v(xbgr.mr_n67286800)
print v(xbgr.mr_n67286912)
print v(xbgr.mr_n67287232)
print v(xbgr.mr_n67287344)
print v(xbgr.mr_n67287664)
print v(xbgr.mr_n67287776)
print v(xbgr.mr_n67288096)
print v(xbgr.mr_n67288208)
print v(xbgr.mr_n67288528)
print v(xbgr.mr_n67288640)
print v(xbgr.mr_n67288960)
print v(xbgr.mr_n67289072)
print v(xbgr.mr_n67289392)
print v(xbgr.mr_n67289504)
print v(xbgr.mr_n67289824)
print v(xbgr.mr_n67289936)
print v(xbgr.mr_n67290256)
print v(xbgr.mr_n67290368)
print v(xbgr.mr_n67290688)
print v(xbgr.mr_n67290800)
print v(xbgr.mr_n67291120)
print v(xbgr.mr_n67291232)
print v(xbgr.mr_n67291552)
print v(xbgr.mr_n67291664)
print v(xbgr.mr_n67291984)
print v(xbgr.mr_n67292096)
print v(xbgr.mr_n67292416)
print v(xbgr.mr_n67292528)
print v(xbgr.mr_n67292848)
print v(xbgr.mr_n67292960)
print v(xbgr.mr_n67293280)
print v(xbgr.mr_n67293392)
print v(xbgr.mr_n67293712)
print v(xbgr.mr_n67293824)
print v(xbgr.mr_n67294144)
print v(xbgr.mr_n67294256)
print v(xbgr.mr_n67294576)
print v(xbgr.mr_n67294688)
print v(xbgr.mr_n67295008)
print v(xbgr.mr_n67295120)
print v(xbgr.mr_n67295440)
print v(xbgr.mr_n67295552)
print v(xbgr.mr_n67295872)
print v(xbgr.mr_n67295984)
print v(xbgr.mr_n67296304)
print v(xbgr.mr_n67296416)
print v(xbgr.mr_n67296736)
print v(xbgr.mr_n67296848)
print v(xbgr.mr_n67297168)
print v(xbgr.mr_n67297280)
print v(xbgr.mr_n67297600)
print v(xbgr.mr_n67297712)
print v(xbgr.mr_n67298032)
print v(xbgr.mr_n67298144)
print v(xbgr.mr_n67298464)
print v(xbgr.mr_n67298576)
print v(xbgr.mr_n67298896)
print v(xbgr.mr_n67299008)
print v(xbgr.mr_n67299328)
print v(xbgr.mr_n67299440)
print v(xbgr.mr_n67299760)
print v(xbgr.mr_n67299872)
print v(xbgr.mr_n67300192)
print v(xbgr.mr_n67300304)
print v(xbgr.mr_n67300624)
print v(xbgr.mr_n67300736)
print v(xbgr.mr_n67301056)
print v(xbgr.mr_n67301168)
print v(xbgr.mr_n67301488)
print v(xbgr.mr_n67301600)
print v(xbgr.mr_n67301920)
print v(xbgr.mr_n67302032)
print v(xbgr.mr_n67302352)
print v(xbgr.mr_n67302464)
print v(xbgr.mr_n67302784)
print v(xbgr.mr_n67302896)
print v(xbgr.mr_n67303216)
print v(xbgr.mr_n67303328)
print v(xbgr.mr_n67303648)
print v(xbgr.mr_n67303760)
print v(xbgr.mr_n67304080)
print v(xbgr.mr_n67304192)
print v(xbgr.mr_n67304512)
print v(xbgr.mr_n67304624)
print v(xbgr.mr_n67304944)
print v(xbgr.mr_n67305056)
print v(xbgr.mr_n67305376)
print v(xbgr.mr_n67305488)
print v(xbgr.mr_n67305808)
print v(xbgr.mr_n67305920)
print v(xbgr.mr_n67306240)
print v(xbgr.mr_n67306352)
print v(xbgr.mr_n67306672)
print v(xbgr.mr_n67306784)
print v(xbgr.mr_n67307104)
print v(xbgr.mr_n67307216)
print v(xbgr.mr_n67307536)
print v(xbgr.mr_n67307648)
print v(xbgr.mr_n67307968)
print v(xbgr.mr_n67308080)
print v(xbgr.mr_n67308400)
print v(xbgr.mr_n67308512)
print v(xbgr.mr_n67308832)
print v(xbgr.mr_n67308944)
print v(xbgr.mr_n67309264)
print v(xbgr.mr_n67309376)
print v(xbgr.mr_n67309696)
print v(xbgr.mr_n67309808)
print v(xbgr.mr_n67310128)
print v(xbgr.mr_n67310240)
print v(xbgr.mr_n67310560)
print v(xbgr.mr_n67310672)
print v(xbgr.mr_n67310992)
print v(xbgr.mr_n67311104)
print v(xbgr.mr_n67311424)
print v(xbgr.mr_n67311536)
print v(xbgr.mr_n67311856)
print v(xbgr.mr_n67311968)
print v(xbgr.mr_n67312288)
print v(xbgr.mr_n67312400)
print v(xbgr.mr_n67312720)
print v(xbgr.mr_n67312832)
print v(xbgr.mr_n67313152)
print v(xbgr.mr_n67313264)
print v(xbgr.mr_n67313584)
print v(xbgr.mr_n67313696)
print v(xbgr.mr_n67314016)
print v(xbgr.mr_n67314128)
print v(xbgr.mr_n67314448)
print v(xbgr.mr_n67314560)
print v(xbgr.mr_n67314880)
print v(xbgr.mr_n67314992)
print v(xbgr.mr_n67315312)
print v(xbgr.mr_n67315424)
print v(xbgr.mr_n67315744)
print v(xbgr.mr_n67315856)
print v(xbgr.mr_n67316176)
print v(xbgr.mr_n67316288)
print v(xbgr.mr_n67316608)
print v(xbgr.mr_n67316720)
print v(xbgr.mr_n67317040)
print v(xbgr.mr_n67317152)
print v(xbgr.mr_n67317472)
print v(xbgr.mr_n67317584)
print v(xbgr.mr_n67317904)
print v(xbgr.mr_n67318016)
print v(xbgr.mr_n67318336)
print v(xbgr.mr_n67318448)
print v(xbgr.mr_n67318768)
print v(xbgr.mr_n67318880)
print v(xbgr.mr_n67319200)
print v(xbgr.mr_n67319312)
print v(xbgr.mr_n67319632)
print v(xbgr.mr_n67319744)
print v(xbgr.mr_n67320064)
print v(xbgr.mr_n67320176)
print v(xbgr.mr_n67320496)
print v(xbgr.mr_n67320608)
print v(xbgr.mr_n67320928)
print v(xbgr.mr_n67321040)
print v(xbgr.mr_n67321360)
print v(xbgr.mr_n67321472)
print v(xbgr.mr_n67321792)
print v(xbgr.mr_n67321904)
print v(xbgr.mr_n67322224)
print v(xbgr.mr_n67322336)
print v(xbgr.mr_n67322656)
print v(xbgr.mr_n67322768)
print v(xbgr.mr_n67323088)
print v(xbgr.mr_n67323200)
print v(xbgr.mr_n67323520)
print v(xbgr.mr_n67323632)
print v(xbgr.mr_n67323952)
print v(xbgr.mr_n67324064)
print v(xbgr.mr_n67324384)
print v(xbgr.mr_n67324496)
print v(xbgr.mr_n67324816)
print v(xbgr.mr_n67324928)
print v(xbgr.mr_n67325248)
print v(xbgr.mr_n67325360)
print v(xbgr.mr_n67325680)
print v(xbgr.mr_n67325792)
print v(xbgr.mr_n67326112)
print v(xbgr.mr_n67326224)
print v(xbgr.mr_n67326544)
print v(xbgr.mr_n67326656)
print v(xbgr.mr_n67326976)
print v(xbgr.mr_n67327088)
print v(xbgr.mr_n67327408)
print v(xbgr.mr_n67327520)
print v(xbgr.mr_n67327840)
print v(xbgr.mr_n67327952)
print v(xbgr.mr_n67328272)
print v(xbgr.mr_n67328384)
print v(xbgr.mr_n67328704)
print v(xbgr.mr_n67328816)
print v(xbgr.mr_n67329136)
print v(xbgr.mr_n67329248)
print v(xbgr.mr_n67329568)
print v(xbgr.mr_n67329680)
print v(xbgr.mr_n67330000)
print v(xbgr.mr_n67330112)
print v(xbgr.mr_n67330432)
print v(xbgr.mr_n67330544)
print v(xbgr.mr_n67330864)
print v(xbgr.mr_n67330976)
print v(xbgr.mr_n67331296)
print v(xbgr.mr_n67331408)
print v(xbgr.mr_n67331728)
print v(xbgr.mr_n67331840)
print v(xbgr.mr_n67332160)
print v(xbgr.mr_n67332272)
print v(xbgr.mr_n67332592)
print v(xbgr.mr_n67332704)
print v(xbgr.mr_n67333024)
print v(xbgr.mr_n67333136)
print v(xbgr.mr_n67333456)
print v(xbgr.mr_n67333568)
print v(xbgr.mr_n67333888)
print v(xbgr.mr_n67334000)
print v(xbgr.mr_n67334320)
print v(xbgr.mr_n67334432)
print v(xbgr.mr_n67334752)
print v(xbgr.mr_n67334864)
print v(xbgr.mr_n67335184)
print v(xbgr.mr_n67335296)
print v(xbgr.mr_n67335616)
print v(xbgr.mr_n67335728)
print v(xbgr.mr_n67336048)
print v(xbgr.mr_n67336160)
print v(xbgr.mr_n67336480)
print v(xbgr.mr_n67336592)
print v(xbgr.mr_n67336912)
print v(xbgr.mr_n67337024)
print v(xbgr.mr_n67337344)
print v(xbgr.mr_n67337456)
print v(xbgr.mr_n67337776)
print v(xbgr.mr_n67337888)
print v(xbgr.mr_n67338208)
print v(xbgr.mr_n67338320)
print v(xbgr.mr_n67338640)
print v(xbgr.mr_n67338752)
print v(xbgr.mr_n67339072)
print v(xbgr.mr_n67339184)
print v(xbgr.mr_n67339504)
print v(xbgr.mr_n67339616)
print v(xbgr.mr_n67339936)
print v(xbgr.mr_n67340048)
print v(xbgr.mr_n67340368)
print v(xbgr.mr_n67340480)
print v(xbgr.mr_n67340800)
print v(xbgr.mr_n67340912)
print v(xbgr.mr_n67341232)
print v(xbgr.mr_n67341344)
print v(xbgr.mr_n67341664)
print v(xbgr.mr_n67341776)
print v(xbgr.mr_n67342096)
print v(xbgr.mr_n67342208)
print v(xbgr.mr_n67342528)
print v(xbgr.mr_n67342640)
print v(xbgr.mr_n67342960)
print v(xbgr.mr_n67343072)
print v(xbgr.mr_n67343392)
print v(xbgr.mr_n67343504)
print v(xbgr.mr_n67343824)
print v(xbgr.mr_n67343936)
print v(xbgr.mr_n67344256)
print v(xbgr.mr_n67344368)
print v(xbgr.mr_n67344688)
print v(xbgr.mr_n67344800)
print v(xbgr.mr_n67345120)
print v(xbgr.mr_n67345232)
print v(xbgr.mr_n67345552)
print v(xbgr.mr_n67345664)
print v(xbgr.mr_n67345984)
print v(xbgr.mr_n67346096)
print v(xbgr.mr_n67346416)
print v(xbgr.mr_n67346528)
print v(xbgr.mr_n67346848)
print v(xbgr.mr_n67346960)
print v(xbgr.mr_n67347280)
print v(xbgr.mr_n67347392)
print v(xbgr.mr_n67347712)
print v(xbgr.mr_n67347824)
print v(xbgr.mr_n67348144)
print v(xbgr.mr_n67348256)
print v(xbgr.mr_n67348576)
print v(xbgr.mr_n67348688)
print v(xbgr.mr_n67349008)
print v(xbgr.mr_n67349120)
print v(xbgr.mr_n67349440)
print v(xbgr.mr_n67349552)
print v(xbgr.mr_n67349872)
print v(xbgr.mr_n67349984)
print v(xbgr.mr_n67350304)
print v(xbgr.mr_n67350416)
print v(xbgr.mr_n67350736)
print v(xbgr.mr_n67350848)
print v(xbgr.mr_n67351168)
print v(xbgr.mr_n67351280)
print v(xbgr.mr_n67351600)
print v(xbgr.mr_n67351712)
print v(xbgr.mr_n67352032)
print v(xbgr.mr_n67352144)
print v(xbgr.mr_n67352464)
print v(xbgr.mr_n67352576)
print v(xbgr.mr_n67352896)
print v(xbgr.mr_n67353008)
print v(xbgr.mr_n67353328)
print v(xbgr.mr_n67353440)
print v(xbgr.mr_n67353760)
print v(xbgr.mr_n67353872)
print v(xbgr.mr_n67354192)
print v(xbgr.mr_n67354304)
print v(xbgr.mr_n67354624)
print v(xbgr.mr_n67354736)
print v(xbgr.mr_n67355056)
print v(xbgr.mr_n67355168)
print v(xbgr.mr_n67355488)
print v(xbgr.mr_n67355600)
print v(xbgr.mr_n67355920)
print v(xbgr.mr_n67356032)
print v(xbgr.mr_n67356352)
print v(xbgr.mr_n67356464)
print v(xbgr.mr_n67356784)
print v(xbgr.mr_n67356896)
print v(xbgr.mr_n67357216)
print v(xbgr.mr_n67357328)
print v(xbgr.mr_n67357648)
print v(xbgr.mr_n67357760)
print v(xbgr.mr_n67358080)
print v(xbgr.mr_n67358192)
print v(xbgr.mr_n67358512)
print v(xbgr.mr_n67358624)
print v(xbgr.mr_n67358944)
print v(xbgr.mr_n67359056)
print v(xbgr.mr_n67359376)
print v(xbgr.mr_n67359488)
print v(xbgr.mr_n67359808)
print v(xbgr.mr_n67359920)
print v(xbgr.mr_n67360240)
print v(xbgr.mr_n67360352)
print v(xbgr.mr_n67360672)
print v(xbgr.mr_n67360784)
print v(xbgr.mr_n67361104)
print v(xbgr.mr_n67361216)
print v(xbgr.mr_n67361536)
print v(xbgr.mr_n67361648)
print v(xbgr.mr_n67361968)
print v(xbgr.mr_n67362080)
print v(xbgr.mr_n67362400)
print v(xbgr.mr_n67362512)
print v(xbgr.mr_n67362832)
print v(xbgr.mr_n67362944)
print v(xbgr.mr_n67363264)
print v(xbgr.mr_n67363376)
print v(xbgr.mr_n67363696)
print v(xbgr.mr_n67363808)
print v(xbgr.mr_n67364128)
print v(xbgr.mr_n67364240)
print v(xbgr.mr_n67364560)
print v(xbgr.mr_n67364672)
print v(xbgr.mr_n67364992)
print v(xbgr.mr_n67365104)
print v(xbgr.mr_n67365424)
print v(xbgr.mr_n67365536)
print v(xbgr.mr_n67365856)
print v(xbgr.mr_n67365968)
print v(xbgr.mr_n67366288)
print v(xbgr.mr_n67366400)
print v(xbgr.mr_n67366720)
print v(xbgr.mr_n67366832)
print v(xbgr.mr_n67367152)
print v(xbgr.mr_n67367264)
print v(xbgr.mr_n67367584)
print v(xbgr.mr_n67367696)
print v(xbgr.mr_n67368016)
print v(xbgr.mr_n67368128)
print v(xbgr.mr_n67368448)
print v(xbgr.mr_n67368560)
print v(xbgr.mr_n67368880)
print v(xbgr.mr_n67368992)
print v(xbgr.mr_n67369312)
print v(xbgr.mr_n67369424)
print v(xbgr.mr_n67369744)
print v(xbgr.mr_n67369856)
print v(xbgr.mr_n67370176)
print v(xbgr.mr_n67370288)
print v(xbgr.mr_n67370608)
print v(xbgr.mr_n67370720)
print v(xbgr.mr_n67371040)
print v(xbgr.mr_n67371152)
print v(xbgr.mr_n67371472)
print v(xbgr.mr_n67371584)
print v(xbgr.mr_n67371904)
print v(xbgr.mr_n67372016)
print v(xbgr.mr_n67372336)
print v(xbgr.mr_n67372448)
print v(xbgr.mr_n67372768)
print v(xbgr.mr_n67372880)
print v(xbgr.mr_n67373200)
print v(xbgr.mr_n67373312)
print v(xbgr.mr_n67373632)
print v(xbgr.mr_n67373744)
print v(xbgr.mr_n67374064)
print v(xbgr.mr_n67374176)
print v(xbgr.mr_n67374496)
print v(xbgr.mr_n67374608)
print v(xbgr.mr_n67374928)
print v(xbgr.mr_n67375040)
print v(xbgr.mr_n67375360)
print v(xbgr.mr_n67375472)
print v(xbgr.mr_n67375792)
print v(xbgr.mr_n67375904)
print v(xbgr.mr_n67376224)
print v(xbgr.mr_n67376336)
print v(xbgr.mr_n67376656)
print v(xbgr.mr_n67376768)
print v(xbgr.mr_n67377088)
print v(xbgr.mr_n67377200)
print v(xbgr.mr_n67377520)
print v(xbgr.mr_n67377632)
print v(xbgr.mr_n67377952)
print v(xbgr.mr_n67378064)
print v(xbgr.mr_n67378384)
print v(xbgr.mr_n67378496)
print v(xbgr.mr_n67378816)
print v(xbgr.mr_n67378928)
print v(xbgr.mr_n67379248)
print v(xbgr.mr_n67379360)
print v(xbgr.mr_n67379680)
print v(xbgr.mr_n67379792)
print v(xbgr.mr_n67380112)
print v(xbgr.mr_n67380224)
print v(xbgr.mr_n67380544)
print v(xbgr.mr_n67380656)
print v(xbgr.mr_n67380976)
print v(xbgr.mr_n67381088)
print v(xbgr.mr_n67381408)
print v(xbgr.mr_n67381520)
print v(xbgr.mr_n67381840)
print v(xbgr.mr_n67381952)
print v(xbgr.mr_n67382272)
print v(xbgr.mr_n67382384)
print v(xbgr.mr_n67382704)
print v(xbgr.mr_n67382816)
print v(xbgr.mr_n67383136)
print v(xbgr.mr_n67383248)
print v(xbgr.mr_n67383568)
print v(xbgr.mr_n67383680)
print v(xbgr.mr_n67384000)
print v(xbgr.mr_n67384112)
print v(xbgr.mr_n67384432)
print v(xbgr.mr_n67384544)
print v(xbgr.mr_n67384864)
print v(xbgr.mr_n67384976)
print v(xbgr.mr_n67385296)
print v(xbgr.mr_n67385408)
print v(xbgr.mr_n67385728)
print v(xbgr.mr_n67385840)
print v(xbgr.mr_n67386160)
print v(xbgr.mr_n67386272)
print v(xbgr.mr_n67386592)
print v(xbgr.mr_n67386704)
print v(xbgr.mr_n67387024)
print v(xbgr.mr_n67387136)
print v(xbgr.mr_n67387456)
print v(xbgr.mr_n67387568)
print v(xbgr.mr_n67387888)
print v(xbgr.mr_n67388000)
print v(xbgr.mr_n67388320)
print v(xbgr.mr_n67388432)
print v(xbgr.mr_n67388752)
print v(xbgr.mr_n67388864)
print v(xbgr.mr_n67389184)
print v(xbgr.mr_n67389296)
print v(xbgr.mr_n67389616)
print v(xbgr.mr_n67389728)
print v(xbgr.mr_n67390048)
print v(xbgr.mr_n67390160)
print v(xbgr.mr_n67390480)
print v(xbgr.mr_n67390592)
print v(xbgr.mr_n67390912)
print v(xbgr.mr_n67391024)
print v(xbgr.mr_n67391344)
print v(xbgr.mr_n67391456)
print v(xbgr.mr_n67391776)
print v(xbgr.mr_n67391888)
print v(xbgr.mr_n67392208)
print v(xbgr.mr_n67392320)
print v(xbgr.mr_n67392640)
print v(xbgr.mr_n67392752)
print v(xbgr.mr_n67393072)
print v(xbgr.mr_n67393184)
print v(xbgr.mr_n67393504)
print v(xbgr.mr_n67393616)
print v(xbgr.mr_n67393936)
print v(xbgr.mr_n67394048)
print v(xbgr.mr_n67394368)
print v(xbgr.mr_n67394480)
print v(xbgr.mr_n67394800)
print v(xbgr.mr_n67394912)
print v(xbgr.mr_n67395232)
print v(xbgr.mr_n67395344)
print v(xbgr.mr_n67395664)
print v(xbgr.mr_n67395776)
print v(xbgr.mr_n67396096)
print v(xbgr.mr_n67396208)
print v(xbgr.mr_n67396528)
print v(xbgr.mr_n67396640)
print v(xbgr.mr_n67396960)
print v(xbgr.mr_n67397072)
print v(xbgr.mr_n67397392)
print v(xbgr.mr_n67397504)
print v(xbgr.mr_n67397824)
print v(xbgr.mr_n67397936)
print v(xbgr.mr_n67398256)
print v(xbgr.mr_n67398368)
print v(xbgr.mr_n67398688)
print v(xbgr.mr_n67398800)
print v(xbgr.mr_n67399120)
print v(xbgr.mr_n67399232)
print v(xbgr.mr_n67399552)
print v(xbgr.mr_n67399664)
print v(xbgr.mr_n67399984)
print v(xbgr.mr_n67400096)
print v(xbgr.mr_n67400416)
print v(xbgr.mr_n67400528)
print v(xbgr.mr_n67400848)
print v(xbgr.mr_n67400960)
print v(xbgr.mr_n67401280)
print v(xbgr.mr_n67401392)
print v(xbgr.mr_n67401712)
print v(xbgr.mr_n67401824)
print v(xbgr.mr_n67402144)
print v(xbgr.mr_n67402256)
print v(xbgr.mr_n67402576)
print v(xbgr.mr_n67402688)
print v(xbgr.mr_n67403008)
print v(xbgr.mr_n67403120)
print v(xbgr.mr_n67403440)
print v(xbgr.mr_n67403552)
print v(xbgr.mr_n67403872)
print v(xbgr.mr_n67403984)
print v(xbgr.mr_n67404304)
print v(xbgr.mr_n67404416)
print v(xbgr.mr_n67404736)
print v(xbgr.mr_n67404848)
print v(xbgr.mr_n67405168)
print v(xbgr.mr_n67405280)
print v(xbgr.mr_n67405600)
print v(xbgr.mr_n67405712)
print v(xbgr.mr_n67406032)
print v(xbgr.mr_n67406144)
print v(xbgr.mr_n67406464)
print v(xbgr.mr_n67406576)
print v(xbgr.mr_n67406896)
print v(xbgr.mr_n67407008)
print v(xbgr.mr_n67407328)
print v(xbgr.mr_n67407440)
print v(xbgr.mr_n67407760)
print v(xbgr.mr_n67407872)
print v(xbgr.mr_n67408192)
print v(xbgr.mr_n67408304)
print v(xbgr.mr_n67408624)
print v(xbgr.mr_n67408736)
print v(xbgr.mr_n67409056)
print v(xbgr.mr_n67409168)
print v(xbgr.mr_n67409488)
print v(xbgr.mr_n67409600)
print v(xbgr.mr_n67409920)
print v(xbgr.mr_n67410032)
print v(xbgr.mr_n67410352)
print v(xbgr.mr_n67410464)
print v(xbgr.mr_n67410784)
print v(xbgr.mr_n67410896)
print v(xbgr.mr_n67411216)
print v(xbgr.mr_n67411328)
print v(xbgr.mr_n67411648)
print v(xbgr.mr_n67411760)
print v(xbgr.mr_n67412080)
print v(xbgr.mr_n67412192)
print v(xbgr.mr_n67412512)
print v(xbgr.mr_n67412624)
print v(xbgr.mr_n67412944)
print v(xbgr.mr_n67413056)
print v(xbgr.mr_n67413376)
print v(xbgr.mr_n67413488)
print v(xbgr.mr_n67413808)
print v(xbgr.mr_n67413920)
print v(xbgr.mr_n67414240)
print v(xbgr.mr_n67414352)
print v(xbgr.mr_n67414672)
print v(xbgr.mr_n67414784)
print v(xbgr.mr_n67415104)
print v(xbgr.mr_n67415216)
print v(xbgr.mr_n67415536)
print v(xbgr.mr_n67415648)
print v(xbgr.mr_n67415968)
print v(xbgr.mr_n67416080)
print v(xbgr.mr_n67416400)
print v(xbgr.mr_n67416512)
print v(xbgr.mr_n67416832)
print v(xbgr.mr_n67416944)
print v(xbgr.mr_n67417264)
print v(xbgr.mr_n67417376)
print v(xbgr.mr_n67417696)
print v(xbgr.mr_n67417808)
print v(xbgr.mr_n67418128)
print v(xbgr.mr_n67418240)
print v(xbgr.mr_n67418560)
print v(xbgr.mr_n67418672)
print v(xbgr.mr_n67418992)
print v(xbgr.mr_n67419104)
print v(xbgr.mr_n67419424)
print v(xbgr.mr_n67419536)
print v(xbgr.mr_n67419856)
print v(xbgr.mr_n67419968)
print v(xbgr.mr_n67420288)
print v(xbgr.mr_n67420400)
print v(xbgr.mr_n67420720)
print v(xbgr.mr_n67420832)
print v(xbgr.mr_n67421152)
print v(xbgr.mr_n67421264)
print v(xbgr.mr_n67421584)
print v(xbgr.mr_n67421696)
print v(xbgr.mr_n67422016)
print v(xbgr.mr_n67422128)
print v(xbgr.mr_n67422448)
print v(xbgr.mr_n67422560)
print v(xbgr.mr_n67422880)
print v(xbgr.mr_n67422992)
print v(xbgr.mr_n67423312)
print v(xbgr.mr_n67423424)
print v(xbgr.mr_n67423744)
print v(xbgr.mr_n67423856)
print v(xbgr.mr_n67424176)
print v(xbgr.mr_n67424288)
print v(xbgr.mr_n67424608)
print v(xbgr.mr_n67424720)
print v(xbgr.mr_n67425040)
print v(xbgr.mr_n67425152)
print v(xbgr.mr_n67425472)
print v(xbgr.mr_n67425584)
print v(xbgr.mr_n67425904)
print v(xbgr.mr_n67426016)
print v(xbgr.mr_n67426336)
print v(xbgr.mr_n67426448)
print v(xbgr.mr_n67426768)
print v(xbgr.mr_n67426880)
print v(xbgr.mr_n67427200)
print v(xbgr.mr_n67427312)
print v(xbgr.mr_n67427632)
print v(xbgr.mr_n67427744)
print v(xbgr.mr_n67428064)
print v(xbgr.mr_n67428176)
print v(xbgr.mr_n67428496)
print v(xbgr.mr_n67428608)
print v(xbgr.mr_n67428928)
print v(xbgr.mr_n67429040)
print v(xbgr.mr_n67429360)
print v(xbgr.mr_n67429472)
print v(xbgr.mr_n67429792)
print v(xbgr.mr_n67429904)
print v(xbgr.mr_n67430224)
print v(xbgr.mr_n67430336)
print v(xbgr.mr_n67430656)
print v(xbgr.mr_n67430768)
print v(xbgr.mr_n67431088)
print v(xbgr.mr_n67431200)
print v(xbgr.mr_n67431520)
print v(xbgr.mr_n67431632)
print v(xbgr.mr_n67431952)
print v(xbgr.mr_n67432064)
print v(xbgr.mr_n67432384)
print v(xbgr.mr_n67432496)
print v(xbgr.mr_n67432816)
print v(xbgr.mr_n67433248)
print v(xbgr.mr_n67433360)
print v(xbgr.mr_n67433680)
print v(xbgr.mr_n67434112)
print v(xbgr.mr_n67434224)
print v(xbgr.mr_n67434544)
print v(xbgr.mr_n67434656)
print v(xbgr.mr_n67434976)
print v(xbgr.mr_n67435088)
print v(xbgr.mr_n67435408)
print v(xbgr.mr_n67435520)
print v(xbgr.mr_n67435840)
print v(xbgr.mr_n67435952)
print v(xbgr.mr_n67436272)
print v(xbgr.mr_n67436384)
print v(xbgr.mr_n67436704)
print v(xbgr.mr_n67436816)
print v(xbgr.mr_n67437136)
print v(xbgr.mr_n67437248)
print v(xbgr.mr_n67437568)
print v(xbgr.mr_n67437680)
print v(xbgr.mr_n67438000)
print v(xbgr.mr_n67438112)
print v(xbgr.mr_n67438432)
print v(xbgr.mr_n67438544)
print v(xbgr.mr_n67438864)
print v(xbgr.mr_n67438976)
print v(xbgr.mr_n67439296)
print v(xbgr.mr_n67439408)
print v(xbgr.mr_n67439728)
print v(xbgr.mr_n67439840)
print v(xbgr.mr_n67440160)
print v(xbgr.mr_n67440272)
print v(xbgr.mr_n67440592)
print v(xbgr.mr_n67440704)
print v(xbgr.mr_n67441024)
print v(xbgr.mr_n67441136)
print v(xbgr.mr_n67441456)
print v(xbgr.mr_n67441568)
print v(xbgr.mr_n67441888)
print v(xbgr.mr_n67442000)
print v(xbgr.mr_n67442320)
print v(xbgr.mr_n67442432)
print v(xbgr.mr_n67442752)
print v(xbgr.mr_n67442864)
print v(xbgr.mr_n67443184)
print v(xbgr.mr_n67443296)
print v(xbgr.mr_n67443616)
print v(xbgr.mr_n67444048)
print v(xbgr.mr_n67444160)
print v(xbgr.mr_n67444480)
print v(xbgr.mr_n67444912)
print v(xbgr.mr_n67445024)
print v(xbgr.mr_n67445344)
print v(xbgr.mr_n67445776)
print v(xbgr.mr_n67445888)
print v(xbgr.mr_n67446208)
print v(xbgr.mr_n67446640)
print v(xbgr.mr_n67446752)
print v(xbgr.mr_n67447072)
print v(xbgr.mr_n67447504)
print v(xbgr.mr_n67447616)
print v(xbgr.mr_n67447936)
print v(xbgr.mr_n67448048)
print v(xbgr.mr_n67448368)
print v(xbgr.mr_n67448480)
print v(xbgr.mr_n67448800)
print v(xbgr.mr_n67448912)
print v(xbgr.mr_n67449232)
print v(xbgr.mr_n67449344)
print v(xbgr.mr_n67449664)
print v(xbgr.mr_n67449776)
print v(xbgr.mr_n67450096)
print v(xbgr.mr_n67450208)
print v(xbgr.mr_n67450528)
print v(xbgr.mr_n67450640)
print v(xbgr.mr_n67450960)
print v(xbgr.mr_n67451072)
print v(xbgr.mr_n67451392)
print v(xbgr.mr_n67451504)
print v(xbgr.mr_n67451824)
print v(xbgr.mr_n67451936)
print v(xbgr.mr_n67452256)
print v(xbgr.mr_n67452368)
print v(xbgr.mr_n67452688)
print v(xbgr.mr_n67452800)
print v(xbgr.mr_n67453120)
print v(xbgr.mr_n67453232)
print v(xbgr.mr_n67453552)
print v(xbgr.mr_n67453664)
print v(xbgr.mr_n67453984)
print v(xbgr.mr_n67454096)
print v(xbgr.mr_n67454416)
print v(xbgr.mr_n67454528)
print v(xbgr.mr_n67454848)
print v(xbgr.mr_n67454960)
print v(xbgr.mr_n67455280)
print v(xbgr.mr_n67455392)
print v(xbgr.mr_n67455712)
print v(xbgr.mr_n67455824)
print v(xbgr.mr_n67456144)
print v(xbgr.mr_n67456256)
print v(xbgr.mr_n67456576)
print v(xbgr.mr_n67456688)
print v(xbgr.mr_n67457008)
print v(xbgr.mr_n67457120)
print v(xbgr.mr_n67457440)
print v(xbgr.mr_n67457552)
print v(xbgr.mr_n67457872)
print v(xbgr.mr_n67457984)
print v(xbgr.mr_n67458304)
print v(xbgr.mr_n67458416)
print v(xbgr.mr_n67458736)
print v(xbgr.mr_n67458848)
print v(xbgr.mr_n67459168)
print v(xbgr.mr_n67459280)
print v(xbgr.mr_n67459600)
print v(xbgr.mr_n67459712)
print v(xbgr.mr_n67460032)
print v(xbgr.mr_n67460144)
print v(xbgr.mr_n67460464)
print v(xbgr.mr_n67460576)
print v(xbgr.mr_n67460896)
print v(xbgr.mr_n67461008)
print v(xbgr.mr_n67461328)
print v(xbgr.mr_n67461440)
print v(xbgr.mr_n67461760)
print v(xbgr.mr_n67461872)
print v(xbgr.mr_n67462192)
print v(xbgr.mr_n67462304)
print v(xbgr.mr_n67462624)
print v(xbgr.mr_n67462736)
print v(xbgr.mr_n67463056)
print v(xbgr.mr_n67463168)
print v(xbgr.mr_n67463488)
print v(xbgr.mr_n67463600)
print v(xbgr.mr_n67463920)
print v(xbgr.mr_n67464032)
print v(xbgr.mr_n67464352)
print v(xbgr.mr_n67464464)
print v(xbgr.mr_n67464784)
print v(xbgr.mr_n67464896)
print v(xbgr.mr_n67465216)
print v(xbgr.mr_n67465328)
print v(xbgr.mr_n67465648)
print v(xbgr.mr_n67465760)
print v(xbgr.mr_n67466080)
print v(xbgr.mr_n67466192)
print v(xbgr.mr_n67466512)
print v(xbgr.mr_n67466624)
print v(xbgr.mr_n67466944)
print v(xbgr.mr_n67467056)
print v(xbgr.mr_n67467376)
print v(xbgr.mr_n67467808)
print v(xbgr.mr_n67467920)
print v(xbgr.mr_n67468240)
print v(xbgr.mr_n67468672)
print v(xbgr.mr_n67468784)
print v(xbgr.mr_n67469104)
print v(xbgr.mr_n67469536)
print v(xbgr.mr_n67469648)
print v(xbgr.mr_n67469968)
print v(xbgr.mr_n67470080)
print v(xbgr.mr_n67470400)
print v(xbgr.mr_n67470512)
print v(xbgr.mr_n67470832)
print v(xbgr.mr_n67470944)
print v(xbgr.mr_n67471264)
print v(xbgr.mr_n67471376)
print v(xbgr.mr_n67471696)
print v(xbgr.mr_n67471808)
print v(xbgr.mr_n67472128)
print v(xbgr.mr_n67472240)
print v(xbgr.mr_n67472560)
print v(xbgr.mr_n67472672)
print v(xbgr.mr_n67472992)
print v(xbgr.mr_n67473104)
print v(xbgr.mr_n67473424)
print v(xbgr.mr_n67473536)
print v(xbgr.mr_n67473856)
print v(xbgr.mr_n67473968)
print v(xbgr.mr_n67474288)
print v(xbgr.mr_n67474400)
print v(xbgr.mr_n67474720)
print v(xbgr.mr_n67474832)
print v(xbgr.mr_n67475152)
print v(xbgr.mr_n67475264)
print v(xbgr.mr_n67475584)
print v(xbgr.mr_n67475696)
print v(xbgr.mr_n67476016)
print v(xbgr.mr_n67476128)
print v(xbgr.mr_n67476448)
print v(xbgr.mr_n67476560)
print v(xbgr.mr_n67476880)
print v(xbgr.mr_n67476992)
print v(xbgr.mr_n67477312)
print v(xbgr.mr_n67477424)
print v(xbgr.mr_n67477744)
print v(xbgr.mr_n67477856)
print v(xbgr.mr_n67478176)
print v(xbgr.mr_n67478288)
print v(xbgr.mr_n67478608)
print v(xbgr.mr_n67478720)
print v(xbgr.mr_n67479040)
print v(xbgr.mr_n67479152)
print v(xbgr.mr_n67479472)
print v(xbgr.mr_n67479584)
print v(xbgr.mr_n67479904)
print v(xbgr.mr_n67480016)
print v(xbgr.mr_n67480336)
print v(xbgr.mr_n67480448)
print v(xbgr.mr_n67480768)
print v(xbgr.mr_n67480880)
print v(xbgr.mr_n67481200)
print v(xbgr.mr_n67481312)
print v(xbgr.mr_n67481632)
print v(xbgr.mr_n67481744)
print v(xbgr.mr_n67482064)
print v(xbgr.mr_n67482176)
print v(xbgr.mr_n67482496)
print v(xbgr.mr_n67482608)
print v(xbgr.mr_n67482928)
print v(xbgr.mr_n67483040)
print v(xbgr.mr_n67483360)
print v(xbgr.mr_n67483472)
print v(xbgr.mr_n67483792)
print v(xbgr.mr_n67483904)
print v(xbgr.mr_n67484224)
print v(xbgr.mr_n67484336)
print v(xbgr.mr_n67484656)
print v(xbgr.mr_n67484768)
print v(xbgr.mr_n67485088)
print v(xbgr.mr_n67485200)
print v(xbgr.mr_n67485520)
print v(xbgr.mr_n67485632)
print v(xbgr.mr_n67485952)
print v(xbgr.mr_n67486064)
print v(xbgr.mr_n67486384)
print v(xbgr.mr_n67486496)
print v(xbgr.mr_n67486816)
print v(xbgr.mr_n67486928)
print v(xbgr.mr_n67487248)
print v(xbgr.mr_n67487360)
print v(xbgr.mr_n67487680)
print v(xbgr.mr_n67487792)
print v(xbgr.mr_n67488112)
print v(xbgr.mr_n67488224)
print v(xbgr.mr_n67488544)
print v(xbgr.mr_n67488656)
print v(xbgr.mr_n67488976)
print v(xbgr.mr_n67489088)
print v(xbgr.mr_n67489408)
print v(xbgr.mr_n67489520)
print v(xbgr.mr_n67489840)
print v(xbgr.mr_n67489952)
print v(xbgr.mr_n67490272)
print v(xbgr.mr_n67490384)
print v(xbgr.mr_n67490704)
print v(xbgr.mr_n67490816)
print v(xbgr.mr_n67491136)
print v(xbgr.mr_n67491248)
print v(xbgr.mr_n67491568)
print v(xbgr.mr_n67491680)
print v(xbgr.mr_n67492000)
print v(xbgr.mr_n67492112)
print v(xbgr.mr_n67492432)
print v(xbgr.mr_n67492544)
print v(xbgr.mr_n67492864)
print v(xbgr.mr_n67492976)
print v(xbgr.mr_n67493296)
print v(xbgr.mr_n67493408)
print v(xbgr.mr_n67493728)
print v(xbgr.mr_n67493840)
print v(xbgr.mr_n67494160)
print v(xbgr.mr_n67494272)
print v(xbgr.mr_n67494592)
print v(xbgr.mr_n67494704)
print v(xbgr.mr_n67495024)
print v(xbgr.mr_n67495136)
print v(xbgr.mr_n67495456)
print v(xbgr.mr_n67495568)
print v(xbgr.mr_n67495888)
print v(xbgr.mr_n67496000)
print v(xbgr.mr_n67496320)
print v(xbgr.mr_n67496432)
print v(xbgr.mr_n67496752)
print v(xbgr.mr_n67496864)
print v(xbgr.mr_n67497184)
print v(xbgr.mr_n67497296)
print v(xbgr.mr_n67497616)
print v(xbgr.mr_n67497728)
print v(xbgr.mr_n67498048)
print v(xbgr.mr_n67498160)
print v(xbgr.mr_n67498480)
print v(xbgr.mr_n67498592)
print v(xbgr.mr_n67498912)
print v(xbgr.mr_n67499024)
print v(xbgr.mr_n67499344)
print v(xbgr.mr_n67499456)
print v(xbgr.mr_n67499776)
print v(xbgr.mr_n67499888)
print v(xbgr.mr_n67500208)
print v(xbgr.mr_n67500320)
print v(xbgr.mr_n67500640)
print v(xbgr.mr_n67500752)
print v(xbgr.mr_n67501072)
print v(xbgr.mr_n67501184)
print v(xbgr.mr_n67501504)
print v(xbgr.mr_n67501616)
print v(xbgr.mr_n67501936)
print v(xbgr.mr_n67502048)
print v(xbgr.mr_n67502368)
print v(xbgr.mr_n67502480)
print v(xbgr.mr_n67502800)
print v(xbgr.mr_n67502912)
print v(xbgr.mr_n67503232)
print v(xbgr.mr_n67503344)
print v(xbgr.mr_n67503664)
print v(xbgr.mr_n67503776)
print v(xbgr.mr_n67504096)
print v(xbgr.mr_n67504208)
print v(xbgr.mr_n67504528)
print v(xbgr.mr_n67504640)
print v(xbgr.mr_n67504960)
print v(xbgr.mr_n67505072)
print v(xbgr.mr_n67505392)
print v(xbgr.mr_n67505504)
print v(xbgr.mr_n67505824)
print v(xbgr.mr_n67505936)
print v(xbgr.mr_n67506256)
print v(xbgr.mr_n67506368)
print v(xbgr.mr_n67506688)
print v(xbgr.mr_n67506800)
print v(xbgr.mr_n67507120)
print v(xbgr.mr_n67507232)
print v(xbgr.mr_n67507552)
print v(xbgr.mr_n67507664)
print v(xbgr.mr_n67507984)
print v(xbgr.mr_n67508096)
print v(xbgr.mr_n67508416)
print v(xbgr.mr_n67508528)
print v(xbgr.mr_n67508848)
print v(xbgr.mr_n67508960)
print v(xbgr.mr_n67509280)
print v(xbgr.mr_n67509392)
print v(xbgr.mr_n67509712)
print v(xbgr.mr_n67509824)
print v(xbgr.mr_n67510144)
print v(xbgr.mr_n67510256)
print v(xbgr.mr_n67510576)
print v(xbgr.mr_n67510688)
print v(xbgr.mr_n67511008)
print v(xbgr.mr_n67511120)
print v(xbgr.mr_n67511440)
print v(xbgr.mr_n67511552)
print v(xbgr.mr_n67511872)
print v(xbgr.mr_n67511984)
print v(xbgr.mr_n67512304)
print v(xbgr.mr_n67512416)
print v(xbgr.mr_n67512736)
print v(xbgr.mr_n67512848)
print v(xbgr.mr_n67513168)
print v(xbgr.mr_n67513280)
print v(xbgr.mr_n67513600)
print v(xbgr.mr_n67513712)
print v(xbgr.mr_n67514032)
print v(xbgr.mr_n67514144)
print v(xbgr.mr_n67514464)
print v(xbgr.mr_n67514576)
print v(xbgr.mr_n67514896)
print v(xbgr.mr_n67515008)
print v(xbgr.mr_n67515328)
print v(xbgr.mr_n67515440)
print v(xbgr.mr_n67515760)
print v(xbgr.mr_n67515872)
print v(xbgr.mr_n67516192)
print v(xbgr.mr_n67516304)
print v(xbgr.mr_n67516624)
print v(xbgr.mr_n67516736)
print v(xbgr.mr_n67517056)
print v(xbgr.mr_n67517168)
print v(xbgr.mr_n67517488)
print v(xbgr.mr_n67517600)
print v(xbgr.mr_n67517920)
print v(xbgr.mr_n67518032)
print v(xbgr.mr_n67518352)
print v(xbgr.mr_n67518464)
print v(xbgr.mr_n67518784)
print v(xbgr.mr_n67518896)
print v(xbgr.mr_n67519216)
print v(xbgr.mr_n67519328)
print v(xbgr.mr_n67519648)
print v(xbgr.mr_n67519760)
print v(xbgr.mr_n67520080)
print v(xbgr.mr_n67520192)
print v(xbgr.mr_n67520512)
print v(xbgr.mr_n67520624)
print v(xbgr.mr_n67520944)
print v(xbgr.mr_n67521056)
print v(xbgr.mr_n67521376)
print v(xbgr.mr_n67521488)
print v(xbgr.mr_n67521808)
print v(xbgr.mr_n67521920)
print v(xbgr.mr_n67522240)
print v(xbgr.mr_n67522352)
print v(xbgr.mr_n67522672)
print v(xbgr.mr_n67522784)
print v(xbgr.mr_n67523104)
print v(xbgr.mr_n67523216)
print v(xbgr.mr_n67523536)
print v(xbgr.mr_n67523648)
print v(xbgr.mr_n67523968)
print v(xbgr.mr_n67524080)
print v(xbgr.mr_n67524400)
print v(xbgr.mr_n67524512)
print v(xbgr.mr_n67524832)
print v(xbgr.mr_n67524944)
print v(xbgr.mr_n67525264)
print v(xbgr.mr_n67525376)
print v(xbgr.mr_n67525696)
print v(xbgr.mr_n67525808)
print v(xbgr.mr_n67526128)
print v(xbgr.mr_n67526240)
print v(xbgr.mr_n67526560)
print v(xbgr.mr_n67526672)
print v(xbgr.mr_n67526992)
print v(xbgr.mr_n67527104)
print v(xbgr.mr_n67527424)
print v(xbgr.mr_n67527536)
print v(xbgr.mr_n67527856)
print v(xbgr.mr_n67527968)
print v(xbgr.mr_n67528288)
print v(xbgr.mr_n67528400)
print v(xbgr.mr_n67528720)
print v(xbgr.mr_n67528832)
print v(xbgr.mr_n67529152)
print v(xbgr.mr_n67529264)
print v(xbgr.mr_n67529584)
print v(xbgr.mr_n67529696)
print v(xbgr.mr_n67530016)
print v(xbgr.mr_n67530128)
print v(xbgr.mr_n67530448)
print v(xbgr.mr_n67530560)
print v(xbgr.mr_n67530880)
print v(xbgr.mr_n67530992)
print v(xbgr.mr_n67531312)
print v(xbgr.mr_n67531424)
print v(xbgr.mr_n67531744)
print v(xbgr.mr_n67531856)
print v(xbgr.mr_n67532176)
print v(xbgr.mr_n67532288)
print v(xbgr.mr_n67532608)
print v(xbgr.mr_n67532720)
print v(xbgr.mr_n67533040)
print v(xbgr.mr_n67533152)
print v(xbgr.mr_n67533472)
print v(xbgr.mr_n67533584)
print v(xbgr.mr_n67533904)
print v(xbgr.mr_n67534016)
print v(xbgr.mr_n67534336)
print v(xbgr.mr_n67534448)
print v(xbgr.mr_n67534768)
print v(xbgr.mr_n67534880)
print v(xbgr.mr_n67535200)
print v(xbgr.mr_n67535312)
print v(xbgr.mr_n67535632)
print v(xbgr.mr_n67535744)
print v(xbgr.mr_n67536064)
print v(xbgr.mr_n67536176)
print v(xbgr.mr_n67536496)
print v(xbgr.mr_n67536608)
print v(xbgr.mr_n67536928)
print v(xbgr.mr_n67537040)
print v(xbgr.mr_n67537360)
print v(xbgr.mr_n67537472)
print v(xbgr.mr_n67537792)
print v(xbgr.mr_n67537904)
print v(xbgr.mr_n67538224)
print v(xbgr.mr_n67538336)
print v(xbgr.mr_n67538656)
print v(xbgr.mr_n67538768)
print v(xbgr.mr_n67539088)
print v(xbgr.mr_n67539200)
print v(xbgr.mr_n67539520)
print v(xbgr.mr_n67539632)
print v(xbgr.mr_n67539952)
print v(xbgr.mr_n67540064)
print v(xbgr.mr_n67540384)
print v(xbgr.mr_n67540496)
print v(xbgr.mr_n67540816)
print v(xbgr.mr_n67540928)
print v(xbgr.mr_n67541248)
print v(xbgr.mr_n67541360)
print v(xbgr.mr_n67541680)
print v(xbgr.mr_n67541792)
print v(xbgr.mr_n67542112)
print v(xbgr.mr_n67542224)
print v(xbgr.mr_n67542544)
print v(xbgr.mr_n67542656)
print v(xbgr.mr_n67542976)
print v(xbgr.mr_n67543088)
print v(xbgr.mr_n67543408)
print v(xbgr.mr_n67543520)
print v(xbgr.mr_n67543840)
print v(xbgr.mr_n67543952)
print v(xbgr.mr_n67544272)
print v(xbgr.mr_n67544384)
print v(xbgr.mr_n67544704)
print v(xbgr.mr_n67544816)
print v(xbgr.mr_n67545136)
print v(xbgr.mr_n67545248)
print v(xbgr.mr_n67545568)
print v(xbgr.mr_n67545680)
print v(xbgr.mr_n67546000)
print v(xbgr.mr_n67546112)
print v(xbgr.mr_n67546432)
print v(xbgr.mr_n67546544)
print v(xbgr.mr_n67546864)
print v(xbgr.mr_n67546976)
print v(xbgr.mr_n67547296)
print v(xbgr.mr_n67547408)
print v(xbgr.mr_n67547728)
print v(xbgr.mr_n67547840)
print v(xbgr.mr_n67548160)
print v(xbgr.mr_n67548272)
print v(xbgr.mr_n67548592)
print v(xbgr.mr_n67548704)
print v(xbgr.mr_n67549024)
print v(xbgr.mr_n67549136)
print v(xbgr.mr_n67549456)
print v(xbgr.mr_n67549568)
print v(xbgr.mr_n67549888)
print v(xbgr.mr_n67550000)
print v(xbgr.mr_n67550320)
print v(xbgr.mr_n67550432)
print v(xbgr.mr_n67550752)
print v(xbgr.mr_n67550864)
print v(xbgr.mr_n67551184)
print v(xbgr.mr_n67551296)
print v(xbgr.mr_n67551616)
print v(xbgr.mr_n67551728)
print v(xbgr.mr_n67552048)
print v(xbgr.mr_n67552160)
print v(xbgr.mr_n67552480)
print v(xbgr.mr_n67552592)
print v(xbgr.mr_n67552912)
print v(xbgr.mr_n67553024)
print v(xbgr.mr_n67553344)
print v(xbgr.mr_n67553456)
print v(xbgr.mr_n67553776)
print v(xbgr.mr_n67553888)
print v(xbgr.mr_n67554208)
print v(xbgr.mr_n67554320)
print v(xbgr.mr_n67554640)
print v(xbgr.mr_n67554752)
print v(xbgr.mr_n67555072)
print v(xbgr.mr_n67555184)
print v(xbgr.mr_n67555504)
print v(xbgr.mr_n67555616)
print v(xbgr.mr_n67555936)
print v(xbgr.mr_n67556048)
print v(xbgr.mr_n67556368)
print v(xbgr.mr_n67556480)
print v(xbgr.mr_n67556800)
print v(xbgr.mr_n67556912)
print v(xbgr.mr_n67557232)
print v(xbgr.mr_n67557344)
print v(xbgr.mr_n67557664)
print v(xbgr.mr_n67557776)
print v(xbgr.mr_n67558096)
print v(xbgr.mr_n67558208)
print v(xbgr.mr_n67558528)
print v(xbgr.mr_n67558640)
print v(xbgr.mr_n67558960)
print v(xbgr.mr_n67559072)
print v(xbgr.mr_n67559392)
print v(xbgr.mr_n67559504)
print v(xbgr.mr_n67559824)
print v(xbgr.mr_n67559936)
print v(xbgr.mr_n67560256)
print v(xbgr.mr_n67560368)
print v(xbgr.mr_n67560688)
print v(xbgr.mr_n67560800)
print v(xbgr.mr_n67561120)
print v(xbgr.mr_n67561232)
print v(xbgr.mr_n67561552)
print v(xbgr.mr_n67561664)
print v(xbgr.mr_n67561984)
print v(xbgr.mr_n67562096)
print v(xbgr.mr_n67562416)
print v(xbgr.mr_n67562528)
print v(xbgr.mr_n67562848)
print v(xbgr.mr_n67562960)
print v(xbgr.mr_n67563280)
print v(xbgr.mr_n67563392)
print v(xbgr.mr_n67563712)
print v(xbgr.mr_n67563824)
print v(xbgr.mr_n67564144)
print v(xbgr.mr_n67564256)
print v(xbgr.mr_n67564576)
print v(xbgr.mr_n67564688)
print v(xbgr.mr_n67565008)
print v(xbgr.mr_n67565120)
print v(xbgr.mr_n67565440)
print v(xbgr.mr_n67565552)
print v(xbgr.mr_n67565872)
print v(xbgr.mr_n67565984)
print v(xbgr.mr_n67566304)
print v(xbgr.mr_n67566416)
print v(xbgr.mr_n67566736)
print v(xbgr.mr_n67566848)
print v(xbgr.mr_n67567168)
print v(xbgr.mr_n67567280)
print v(xbgr.mr_n67567600)
print v(xbgr.mr_n67567712)
print v(xbgr.mr_n67568032)
print v(xbgr.mr_n67568144)
print v(xbgr.mr_n67568464)
print v(xbgr.mr_n67568576)
print v(xbgr.mr_n67568896)
print v(xbgr.mr_n67569008)
print v(xbgr.mr_n67569328)
print v(xbgr.mr_n67569440)
print v(xbgr.mr_n67569760)
print v(xbgr.mr_n67569872)
print v(xbgr.mr_n67570192)
print v(xbgr.mr_n67570304)
print v(xbgr.mr_n67570624)
print v(xbgr.mr_n67570736)
print v(xbgr.mr_n67571056)
print v(xbgr.mr_n67571168)
print v(xbgr.mr_n67571488)
print v(xbgr.mr_n67571600)
print v(xbgr.mr_n67571920)
print v(xbgr.mr_n67572032)
print v(xbgr.mr_n67572352)
print v(xbgr.mr_n67572464)
print v(xbgr.mr_n67572784)
print v(xbgr.mr_n67572896)
print v(xbgr.mr_n67573216)
print v(xbgr.mr_n67573328)
print v(xbgr.mr_n67573648)
print v(xbgr.mr_n67573760)
print v(xbgr.mr_n67574080)
print v(xbgr.mr_n67574192)
print v(xbgr.mr_n67574512)
print v(xbgr.mr_n67574624)
print v(xbgr.mr_n67574944)
print v(xbgr.mr_n67575056)
print v(xbgr.mr_n67575376)
print v(xbgr.mr_n67575488)
print v(xbgr.mr_n67575808)
print v(xbgr.mr_n67575920)
print v(xbgr.mr_n67576240)
print v(xbgr.mr_n67576352)
print v(xbgr.mr_n67576672)
print v(xbgr.mr_n67576784)
print v(xbgr.mr_n67577104)
print v(xbgr.mr_n67577216)
print v(xbgr.mr_n67577536)
print v(xbgr.mr_n67577648)
print v(xbgr.mr_n67577968)
print v(xbgr.mr_n67578080)
print v(xbgr.mr_n67578400)
print v(xbgr.mr_n67578512)
print v(xbgr.mr_n67578832)
print v(xbgr.mr_n67578944)
print v(xbgr.mr_n67579264)
print v(xbgr.mr_n67579376)
print v(xbgr.mr_n67579696)
print v(xbgr.mr_n67579808)
print v(xbgr.mr_n67580128)
print v(xbgr.mr_n67580240)
print v(xbgr.mr_n67580560)
print v(xbgr.mr_n67580672)
print v(xbgr.mr_n67580992)
print v(xbgr.mr_n67581104)
print v(xbgr.mr_n67581424)
print v(xbgr.mr_n67581536)
print v(xbgr.mr_n67581856)
print v(xbgr.mr_n67581968)
print v(xbgr.mr_n67582288)
print v(xbgr.mr_n67582400)
print v(xbgr.mr_n67582720)
print v(xbgr.mr_n67582832)
print v(xbgr.mr_n67583152)
print v(xbgr.mr_n67583264)
print v(xbgr.mr_n67583584)
print v(xbgr.mr_n67583696)
print v(xbgr.mr_n67584016)
print v(xbgr.mr_n67584128)
print v(xbgr.mr_n67584448)
print v(xbgr.mr_n67584560)
print v(xbgr.mr_n67584880)
print v(xbgr.mr_n67584992)
print v(xbgr.mr_n67585312)
print v(xbgr.mr_n67585424)
print v(xbgr.mr_n67585744)
print v(xbgr.mr_n67585856)
print v(xbgr.mr_n67586176)
print v(xbgr.mr_n67586288)
print v(xbgr.mr_n67586608)
print v(xbgr.mr_n67586720)
print v(xbgr.mr_n67587040)
print v(xbgr.mr_n67587152)
print v(xbgr.mr_n67587472)
print v(xbgr.mr_n67587584)
print v(xbgr.mr_n67587904)
print v(xbgr.mr_n67588016)
print v(xbgr.mr_n67588336)
print v(xbgr.mr_n67588448)
print v(xbgr.mr_n67588768)
print v(xbgr.mr_n67588880)
print v(xbgr.mr_n67589200)
print v(xbgr.mr_n67589312)
print v(xbgr.mr_n67589632)
print v(xbgr.mr_n67589744)
print v(xbgr.mr_n67590064)
print v(xbgr.mr_n67590176)
print v(xbgr.mr_n67590496)
print v(xbgr.mr_n67590608)
print v(xbgr.mr_n67590928)
print v(xbgr.mr_n67591040)
print v(xbgr.mr_n67591360)
print v(xbgr.mr_n67591472)
print v(xbgr.mr_n67591792)
print v(xbgr.mr_n67591904)
print v(xbgr.mr_n67592224)
print v(xbgr.mr_n67592336)
print v(xbgr.mr_n67592656)
print v(xbgr.mr_n67592768)
print v(xbgr.mr_n67593088)
print v(xbgr.mr_n67593200)
print v(xbgr.mr_n67593520)
print v(xbgr.mr_n67593632)
print v(xbgr.mr_n67593952)
print v(xbgr.mr_n67594064)
print v(xbgr.mr_n67594384)
print v(xbgr.mr_n67594496)
print v(xbgr.mr_n67594816)
print v(xbgr.mr_n67594928)
print v(xbgr.mr_n67595248)
print v(xbgr.mr_n67595360)
print v(xbgr.mr_n67595680)
print v(xbgr.mr_n67595792)
print v(xbgr.mr_n67596112)
print v(xbgr.mr_n67596224)
print v(xbgr.mr_n67596544)
print v(xbgr.mr_n67596656)
print v(xbgr.mr_n67596976)
print v(xbgr.mr_n67597088)
print v(xbgr.mr_n67597408)
print v(xbgr.mr_n67597520)
print v(xbgr.mr_n67597840)
print v(xbgr.mr_n67597952)
print v(xbgr.mr_n67598272)
print v(xbgr.mr_n67598384)
print v(xbgr.mr_n67598704)
print v(xbgr.mr_n67598816)
print v(xbgr.mr_n67599136)
print v(xbgr.mr_n67599248)
print v(xbgr.mr_n67599568)
print v(xbgr.mr_n67599680)
print v(xbgr.mr_n67600000)
print v(xbgr.mr_n67600112)
print v(xbgr.mr_n67600432)
print v(xbgr.mr_n67600544)
print v(xbgr.mr_n67600864)
print v(xbgr.mr_n67600976)
print v(xbgr.mr_n67601296)
print v(xbgr.mr_n67601408)
print v(xbgr.mr_n67601728)
print v(xbgr.mr_n67601840)
print v(xbgr.mr_n67602160)
print v(xbgr.mr_n67602272)
print v(xbgr.mr_n67602592)
print v(xbgr.mr_n67602704)
print v(xbgr.mr_n67603024)
print v(xbgr.mr_n67603136)
print v(xbgr.mr_n67603456)
print v(xbgr.mr_n67603568)
print v(xbgr.mr_n67603888)
print v(xbgr.mr_n67604000)
print v(xbgr.mr_n67604320)
print v(xbgr.mr_n67604432)
print v(xbgr.mr_n67604752)
print v(xbgr.mr_n67604864)
print v(xbgr.mr_n67605184)
print v(xbgr.mr_n67605296)
print v(xbgr.mr_n67605616)
print v(xbgr.mr_n67605728)
print v(xbgr.mr_n67606048)
print v(xbgr.mr_n67606160)
print v(xbgr.mr_n67606480)
print v(xbgr.mr_n67606592)
print v(xbgr.mr_n67606912)
print v(xbgr.mr_n67607024)
print v(xbgr.mr_n67607344)
print v(xbgr.mr_n67607456)
print v(xbgr.mr_n67607776)
print v(xbgr.mr_n67607888)
print v(xbgr.mr_n67608208)
print v(xbgr.mr_n67608320)
print v(xbgr.mr_n67608640)
print v(xbgr.mr_n67608752)
print v(xbgr.mr_n67609072)
print v(xbgr.mr_n67609184)
print v(xbgr.mr_n67609504)
print v(xbgr.mr_n67609616)
print v(xbgr.mr_n67609936)
print v(xbgr.mr_n67610048)
print v(xbgr.mr_n67610368)
print v(xbgr.mr_n67610480)
print v(xbgr.mr_n67610800)
print v(xbgr.mr_n67610912)
print v(xbgr.mr_n67611232)
print v(xbgr.mr_n67611344)
print v(xbgr.mr_n67611664)
print v(xbgr.mr_n67611776)
print v(xbgr.mr_n67612096)
print v(xbgr.mr_n67612208)
print v(xbgr.mr_n67612528)
print v(xbgr.mr_n67612640)
print v(xbgr.mr_n67612960)
print v(xbgr.mr_n67613072)
print v(xbgr.mr_n67613392)
print v(xbgr.mr_n67613504)
print v(xbgr.mr_n67613824)
print v(xbgr.mr_n67613936)
print v(xbgr.mr_n67614256)
print v(xbgr.mr_n67614368)
print v(xbgr.mr_n67614688)
print v(xbgr.mr_n67614800)
print v(xbgr.mr_n67615120)
print v(xbgr.mr_n67615232)
print v(xbgr.mr_n67615552)
print v(xbgr.mr_n67615664)
print v(xbgr.mr_n67615984)
print v(xbgr.mr_n67616096)
print v(xbgr.mr_n67616416)
print v(xbgr.mr_n67616528)
print v(xbgr.mr_n67616848)
print v(xbgr.mr_n67616960)
print v(xbgr.mr_n67617280)
print v(xbgr.mr_n67617392)
print v(xbgr.mr_n67617712)
print v(xbgr.mr_n67617824)
print v(xbgr.mr_n67618144)
print v(xbgr.mr_n67618256)
print v(xbgr.mr_n67618576)
print v(xbgr.mr_n67618688)
print v(xbgr.mr_n67619008)
print v(xbgr.mr_n67619120)
print v(xbgr.mr_n67619440)
print v(xbgr.mr_n67619552)
print v(xbgr.mr_n67619872)
print v(xbgr.mr_n67619984)
print v(xbgr.mr_n67620304)
print v(xbgr.mr_n67620416)
print v(xbgr.mr_n67620736)
print v(xbgr.mr_n67620848)
print v(xbgr.mr_n67621168)
print v(xbgr.mr_n67621280)
print v(xbgr.mr_n67621600)
print v(xbgr.mr_n67621712)
print v(xbgr.mr_n67622032)
print v(xbgr.mr_n67622144)
print v(xbgr.mr_n67622464)
print v(xbgr.mr_n67622576)
print v(xbgr.mr_n67622896)
print v(xbgr.mr_n67623008)
print v(xbgr.mr_n67623328)
print v(xbgr.mr_n67623440)
print v(xbgr.mr_n67623760)
print v(xbgr.mr_n67623872)
print v(xbgr.mr_n67624192)
print v(xbgr.mr_n67624304)
print v(xbgr.mr_n67624624)
print v(xbgr.mr_n67624736)
print v(xbgr.mr_n67625056)
print v(xbgr.mr_n67625168)
print v(xbgr.mr_n67625488)
print v(xbgr.mr_n67625600)
print v(xbgr.mr_n67625920)
print v(xbgr.mr_n67626032)
print v(xbgr.mr_n67626352)
print v(xbgr.mr_n67626464)
print v(xbgr.mr_n67626784)
print v(xbgr.mr_n67626896)
print v(xbgr.mr_n67627216)
print v(xbgr.mr_n67627328)
print v(xbgr.mr_n67627648)
print v(xbgr.mr_n67627760)
print v(xbgr.mr_n67628080)
print v(xbgr.mr_n67628192)
print v(xbgr.mr_n67628512)
print v(xbgr.mr_n67628624)
print v(xbgr.mr_n67628944)
print v(xbgr.mr_n67629056)
print v(xbgr.mr_n67629376)
print v(xbgr.mr_n67629488)
print v(xbgr.mr_n67629808)
print v(xbgr.mr_n67629920)
print v(xbgr.mr_n67630240)
print v(xbgr.mr_n67630352)
print v(xbgr.mr_n67630672)
print v(xbgr.mr_n67630784)
print v(xbgr.mr_n67631104)
print v(xbgr.mr_n67631216)
print v(xbgr.mr_n67631536)
print v(xbgr.mr_n67631648)
print v(xbgr.mr_n67631968)
print v(xbgr.mr_n67632080)
print v(xbgr.mr_n67632400)
print v(xbgr.mr_n67632512)
print v(xbgr.mr_n67632832)
print v(xbgr.mr_n67632944)
print v(xbgr.mr_n67633264)
print v(xbgr.mr_n67633376)
print v(xbgr.mr_n67633696)
print v(xbgr.mr_n67633808)
print v(xbgr.mr_n67634128)
print v(xbgr.mr_n67634240)
print v(xbgr.mr_n67634560)
print v(xbgr.mr_n67634672)
print v(xbgr.mr_n67635104)
print v(xbgr.mr_n67635424)
print v(xbgr.mr_n67635536)
print v(xbgr.mr_n67635968)
print v(xbgr.mr_n67636288)
print v(xbgr.mr_n67636400)
print v(xbgr.mr_n67636832)
print v(xbgr.mr_n67637152)
print v(xbgr.mr_n67638016)
print v(xbgr.mr_n67638880)
print v(xbgr.mr_n67638992)
print v(xbgr.mr_n67639312)
print v(xbgr.mr_n67639424)
print v(xbgr.mr_n67639744)
print v(xbgr.mr_n67639856)
print v(xbgr.mr_n67640176)
print v(xbgr.mr_n67640288)
print v(xbgr.mr_n67640608)
print v(xbgr.mr_n67640720)
print v(xbgr.mr_n67641040)
print v(xbgr.mr_n67641152)
print v(xbgr.mr_n67641472)
print v(xbgr.mr_n67642336)
print v(xbgr.mr_n67643200)
print v(xbgr.mr_n67644064)
print v(xbgr.mr_n67644176)
print v(xbgr.mr_n67644496)
print v(xbgr.mr_n67644608)
print v(xbgr.mr_n67644928)
print v(xbgr.mr_n67645040)
print v(xbgr.mr_n67645360)
print v(xbgr.mr_n67645472)
print v(xbgr.mr_n67645792)
print v(xbgr.mr_n67646656)
print v(xbgr.mr_n67647520)
print v(xbgr.mr_n67647632)
print v(xbgr.mr_n67647952)
print v(xbgr.mr_n67648064)
print v(xbgr.mr_n67648384)
print v(xbgr.mr_n67648496)
print v(xbgr.mr_n67648816)
print v(xbgr.mr_n67648928)
print v(xbgr.mr_n67649248)
print v(xbgr.mr_n67649360)
print v(xbgr.mr_n67649680)
print v(xbgr.mr_n67649792)
print v(xbgr.mr_n67650112)
print v(xbgr.mr_n67650976)
print v(xbgr.mr_n67651088)
print v(xbgr.mr_n67651520)
print v(xbgr.mr_n67651840)
print v(xbgr.mr_n67651952)
print v(xbgr.mr_n67652384)
print v(xbgr.mr_n67652704)
print v(xbgr.mr_n67652816)
print v(xbgr.mr_n67653248)
print v(xbgr.mr_n67653568)
print v(xbgr.mr_n67654432)
print v(xbgr.mr_n67655296)
print v(xbgr.mr_n67656160)
print v(xbgr.mr_n67657024)
print v(xbgr.mr_n67657888)
print v(xbgr.mr_n67658752)
print v(xbgr.mr_n67658864)
print v(xbgr.mr_n67659184)
print v(xbgr.mr_n67659296)
print v(xbgr.mr_n67659616)
print v(xbgr.mr_n67659728)
print v(xbgr.mr_n67660048)
print v(xbgr.mr_n67660160)
print v(xbgr.mr_n67660480)
print v(xbgr.mr_n67661344)
print v(xbgr.mr_n67662208)
print v(xbgr.mr_n67663072)
print v(xbgr.mr_n67663936)
print v(xbgr.mr_n67664048)
print v(xbgr.mr_n67664480)
print v(xbgr.mr_n67664800)
print v(xbgr.mr_n67664912)
print v(xbgr.mr_n67665344)
print v(xbgr.mr_n67665664)
print v(xbgr.mr_n67665776)
print v(xbgr.mr_n67666208)
print v(xbgr.mr_n67666528)
print v(xbgr.mr_n67667392)
print v(xbgr.mr_n67668256)
print v(xbgr.mr_n67669120)
print v(xbgr.mr_n67669984)
print v(xbgr.mr_n67670848)
print v(xbgr.mr_n67671712)
print v(xbgr.mr_n67671824)
print v(xbgr.mr_n67672144)
print v(xbgr.mr_n67672256)
print v(xbgr.mr_n67672576)
print v(xbgr.mr_n67672688)
print v(xbgr.mr_n67673008)
print v(xbgr.mr_n67673120)
print v(xbgr.mr_n67673440)
print v(xbgr.mr_n67674304)
print v(xbgr.mr_n67675168)
print v(xbgr.mr_n67676032)
print v(xbgr.mr_n67676144)
print v(xbgr.mr_n67676464)
print v(xbgr.mr_n67676576)
print v(xbgr.mr_n67676896)
print v(xbgr.mr_n67677008)
print v(xbgr.mr_n67677440)
print v(xbgr.mr_n67677872)
print v(xbgr.mr_n67678304)
print v(xbgr.mr_n67678624)
print v(xbgr.mr_n67678736)
print v(xbgr.mr_n67679056)
print v(xbgr.mr_n67679168)
print v(xbgr.mr_n67679488)
print v(xbgr.mr_n67679600)
print v(xbgr.mr_n67679920)
print v(xbgr.mr_n67680032)
print v(xbgr.mr_n67680352)
print v(xbgr.mr_n67680464)
print v(xbgr.mr_n67680784)
print v(xbgr.mr_n67680896)
print v(xbgr.mr_n67681216)
print v(xbgr.mr_n67681328)
print v(xbgr.mr_n67681760)
print v(xbgr.mr_n67682080)
print v(xbgr.mr_n67682512)
print v(xbgr.mr_n67682624)
print v(xbgr.mr_n67682944)
print v(xbgr.mr_n67683056)
print v(xbgr.mr_n67683376)
print v(xbgr.mr_n67683488)
print v(xbgr.mr_n67683808)
print v(xbgr.mr_n67683920)
print v(xbgr.mr_n67684240)
print v(xbgr.mr_n67684352)
print v(xbgr.mr_n67684672)
print v(xbgr.mr_n67684784)
print v(xbgr.mr_n67685104)
print v(xbgr.mr_n67685216)
print v(xbgr.mr_n67685648)
print v(xbgr.mr_n67685968)
print v(xbgr.mr_n67686080)
print v(xbgr.mr_n67686512)
print v(xbgr.mr_n67686832)
print v(xbgr.mr_n67686944)
print v(xbgr.mr_n67687264)
print v(xbgr.mr_n67687376)
print v(xbgr.mr_n67687696)
print v(xbgr.mr_n67687808)
print v(xbgr.mr_n67688240)
print v(xbgr.mr_n67688672)
print v(xbgr.mr_n67688992)
print v(xbgr.mr_n67689104)
print v(xbgr.mr_n67689424)
print v(xbgr.mr_n67689536)
print v(xbgr.mr_n67689856)
print v(xbgr.mr_n67689968)
print v(xbgr.mr_n67690288)
print v(xbgr.mr_n67690400)
print v(xbgr.mr_n67690720)
print v(xbgr.mr_n67690832)
print v(xbgr.mr_n67691152)
print v(xbgr.mr_n67691264)
print v(xbgr.mr_n67691584)
print v(xbgr.mr_n67691696)
print v(xbgr.mr_n67692016)
print v(xbgr.mr_n67692128)
print v(xbgr.mr_n67692448)
print v(xbgr.mr_n67692560)
print v(xbgr.mr_n67692880)
print v(xbgr.mr_n67692992)
print v(xbgr.mr_n67693312)
print v(xbgr.mr_n67693424)
print v(xbgr.mr_n67693744)
print v(xbgr.mr_n67694608)
print v(xbgr.mr_n67695472)
print v(xbgr.mr_n67695584)
print v(xbgr.mr_n67696016)
print v(xbgr.mr_n67696336)
print v(xbgr.mr_n67696448)
print v(xbgr.mr_n67697200)
print v(xbgr.mr_n67697632)
print v(xbgr.mr_n67697744)
print v(xbgr.mr_n67698064)
print v(xbgr.mr_n67698176)
print v(xbgr.mr_n67698496)
print v(xbgr.mr_n67698608)
print v(xbgr.mr_n67698928)
print v(xbgr.mr_n67699040)
print v(xbgr.mr_n67699360)
print v(xbgr.mr_n67700224)
print v(xbgr.mr_n67700656)
print v(xbgr.mr_n67700768)
print v(xbgr.mr_n67701088)
print v(xbgr.mr_n67701200)
print v(xbgr.mr_n67701520)
print v(xbgr.mr_n67702384)
print v(xbgr.mr_n67703680)
print v(xbgr.mr_n67704544)
print v(xbgr.mr_n67705408)
print v(xbgr.mr_n67705520)
print v(xbgr.mr_n67706272)
print v(xbgr.mr_n67706384)
print v(xbgr.mr_n67706816)
print v(xbgr.mr_n67707248)
print v(xbgr.mr_n67708000)
print v(xbgr.mr_n67708864)
print v(xbgr.mr_n67709728)
print v(xbgr.mr_n67709840)
print v(xbgr.mr_n67710160)
print v(xbgr.mr_n67710272)
print v(xbgr.mr_n67710704)
print v(xbgr.mr_n67711024)
print v(xbgr.mr_n67711136)
print v(xbgr.mr_n67711568)
print v(xbgr.mr_n67711888)
print v(xbgr.mr_n67712000)
print v(xbgr.mr_n67712320)
print v(xbgr.mr_n67712432)
print v(xbgr.mr_n67712752)
print v(xbgr.mr_n67713616)
print v(xbgr.mr_n67713728)
print v(xbgr.mr_n67714160)
print v(xbgr.mr_n67714480)
print v(xbgr.mr_n67715456)
print v(xbgr.mr_n67715776)
print v(xbgr.mr_n67715888)
print v(xbgr.mr_n67716320)
print v(xbgr.mr_n67716640)
print v(xbgr.mr_n67717072)
print v(xbgr.mr_n67717184)
print v(xbgr.mr_n67717504)
print v(xbgr.mr_n67717616)
print v(xbgr.mr_n67717936)
print v(xbgr.mr_n67718368)
print v(xbgr.mr_n67718480)
print v(xbgr.mr_n67718800)
print v(xbgr.mr_n67718912)
print v(xbgr.mr_n67719232)
print v(xbgr.mr_n67719344)
print v(xbgr.mr_n67719664)
print v(xbgr.mr_n67719776)
print v(xbgr.mr_n67720096)
print v(xbgr.mr_n67720208)
print v(xbgr.mr_n67720640)
print v(xbgr.mr_n67720960)
print v(xbgr.mr_n67721072)
print v(xbgr.mr_n67721392)
print v(xbgr.mr_n67721504)
print v(xbgr.mr_n67721824)
print v(xbgr.mr_n67722368)
print v(xbgr.mr_n67723120)
print v(xbgr.mr_n67724416)
print v(xbgr.mr_n67724528)
print v(xbgr.mr_n67724848)
print v(xbgr.mr_n67724960)
print v(xbgr.mr_n67725280)
print v(xbgr.mr_n67726144)
print v(xbgr.mr_n67727008)
print v(xbgr.mr_n67727872)
print v(xbgr.mr_n67727984)
print v(xbgr.mr_n67728304)
print v(xbgr.mr_n67728416)
print v(xbgr.mr_n67728736)
print v(xbgr.mr_n67728848)
print v(xbgr.mr_n67729168)
print v(xbgr.mr_n67729280)
print v(xbgr.mr_n67729600)
print v(xbgr.mr_n67729712)
print v(xbgr.mr_n67730032)
print v(xbgr.mr_n67730896)
print v(xbgr.mr_n67731760)
print v(xbgr.mr_n67732624)
print v(xbgr.mr_n67732736)
print v(xbgr.mr_n67733056)
print v(xbgr.mr_n67733168)
print v(xbgr.mr_n67733488)
print v(xbgr.mr_n67733600)
print v(xbgr.mr_n67733920)
print v(xbgr.mr_n67734032)
print v(xbgr.mr_n67734464)
print v(xbgr.mr_n67734784)
print v(xbgr.mr_n67734896)
print v(xbgr.mr_n67735216)
print v(xbgr.mr_n67735328)
print v(xbgr.mr_n67735648)
print v(xbgr.mr_n67735760)
print v(xbgr.mr_n67736080)
print v(xbgr.mr_n67736192)
print v(xbgr.mr_n67736944)
print v(xbgr.mr_n67737488)
print v(xbgr.mr_n67737920)
print v(xbgr.mr_n67738352)
print v(xbgr.mr_n67738784)
print v(xbgr.mr_n67739104)
print v(xbgr.mr_n67739216)
print v(xbgr.mr_n67739968)
print v(xbgr.mr_n67740832)
print v(xbgr.mr_n67741696)
print v(xbgr.mr_n67742560)
print v(xbgr.mr_n67743424)
print v(xbgr.mr_n67744288)
print v(xbgr.mr_n67745152)
print v(xbgr.mr_n67745264)
print v(xbgr.mr_n67745584)
print v(xbgr.mr_n67745696)
print v(xbgr.mr_n67746128)
print v(xbgr.mr_n67746448)
print v(xbgr.mr_n67746560)
print v(xbgr.mr_n67746992)
print v(xbgr.mr_n67747312)
print v(xbgr.mr_n67747424)
print v(xbgr.mr_n67747744)
print v(xbgr.mr_n67747856)
print v(xbgr.mr_n67748176)
print v(xbgr.mr_n67748288)
print v(xbgr.mr_n67748608)
print v(xbgr.mr_n67748720)
print v(xbgr.mr_n67749040)
print v(xbgr.mr_n67749152)
print v(xbgr.mr_n67749472)
print v(xbgr.mr_n67749584)
print v(xbgr.mr_n67749904)
print v(xbgr.mr_n67750768)
print v(xbgr.mr_n67751200)
print v(xbgr.mr_n67752176)
print v(xbgr.mr_n67752608)
print v(xbgr.mr_n67753040)
print v(xbgr.mr_n67753472)
print v(xbgr.mr_n67753792)
print v(xbgr.mr_n67754656)
print v(xbgr.mr_n67755520)
print v(xbgr.mr_n67756384)
print v(xbgr.mr_n67757248)
print v(xbgr.mr_n67758112)
print v(xbgr.mr_n67758976)
print v(xbgr.mr_n67760272)
print v(xbgr.mr_n67760704)
print v(xbgr.mr_n67762000)
print v(xbgr.mr_n67762112)
print v(xbgr.mr_n67762432)
print v(xbgr.mr_n67762544)
print v(xbgr.mr_n67762864)
print v(xbgr.mr_n67762976)
print v(xbgr.mr_n67763408)
print v(xbgr.mr_n67763840)
print v(xbgr.mr_n67764160)
print v(xbgr.mr_n67764272)
print v(xbgr.mr_n67764592)
print v(xbgr.mr_n67764704)
print v(xbgr.mr_n67765024)
print v(xbgr.mr_n67765136)
print v(xbgr.mr_n67765456)
print v(xbgr.mr_n67765568)
print v(xbgr.mr_n67766000)
print v(xbgr.mr_n67766320)
print v(xbgr.mr_n67767184)
print v(xbgr.mr_n67767296)
print v(xbgr.mr_n67767616)
print v(xbgr.mr_n67767728)
print v(xbgr.mr_n67768048)
print v(xbgr.mr_n67768160)
print v(xbgr.mr_n67768480)
print v(xbgr.mr_n67768592)
print v(xbgr.mr_n67768912)
print v(xbgr.mr_n67769776)
print v(xbgr.mr_n67770208)
print v(xbgr.mr_n67771504)
print v(xbgr.mr_n67771616)
print v(xbgr.mr_n67771936)
print v(xbgr.mr_n67772048)
print v(xbgr.mr_n67772368)
print v(xbgr.mr_n67772480)
print v(xbgr.mr_n67772800)
print v(xbgr.mr_n67773664)
print v(xbgr.mr_n67773776)
print v(xbgr.mr_n67774208)
print v(xbgr.mr_n67774528)
print v(xbgr.mr_n67774640)
print v(xbgr.mr_n67774960)
print v(xbgr.mr_n67775072)
print v(xbgr.mr_n67775392)
print v(xbgr.mr_n67775504)
print v(xbgr.mr_n67775824)
print v(xbgr.mr_n67775936)
print v(xbgr.mr_n67776368)
print v(xbgr.mr_n67776688)
print v(xbgr.mr_n67777552)
print v(xbgr.mr_n67777664)
print v(xbgr.mr_n67777984)
print v(xbgr.mr_n67778848)
print v(xbgr.mr_n67778960)
print v(xbgr.mr_n67779280)
print v(xbgr.mr_n67779392)
print v(xbgr.mr_n67779712)
print v(xbgr.mr_n67780256)
print v(xbgr.mr_n67780688)
print v(xbgr.mr_n67781008)
print v(xbgr.mr_n67781440)
print v(xbgr.mr_n67781552)
print v(xbgr.mr_n67781872)
print v(xbgr.mr_n67781984)
print v(xbgr.mr_n67782304)
print v(xbgr.mr_n67782416)
print v(xbgr.mr_n67782736)
print v(xbgr.mr_n67782848)
print v(xbgr.mr_n67783168)
print v(xbgr.mr_n67783280)
print v(xbgr.mr_n67784032)
print v(xbgr.mr_n67784144)
print v(xbgr.mr_n67784464)
print v(xbgr.mr_n67784576)
print v(xbgr.mr_n67784896)
print v(xbgr.mr_n67786192)
print v(xbgr.mr_n67786304)
print v(xbgr.mr_n67786624)
print v(xbgr.mr_n67786736)
print v(xbgr.mr_n67787056)
print v(xbgr.mr_n67788032)
print v(xbgr.mr_n67788352)
print v(xbgr.mr_n67789216)
print v(xbgr.mr_n67789648)
print v(xbgr.mr_n67789760)
print v(xbgr.mr_n67790080)
print v(xbgr.mr_n67790192)
print v(xbgr.mr_n67790512)
print v(xbgr.mr_n67790624)
print v(xbgr.mr_n67790944)
print v(xbgr.mr_n67791808)
print v(xbgr.mr_n67793104)
print v(xbgr.mr_n67793968)
print v(xbgr.mr_n67794944)
print v(xbgr.mr_n67795264)
print v(xbgr.mr_n67795376)
print v(xbgr.mr_n67795808)
print v(xbgr.mr_n67796128)
print v(xbgr.mr_n67796240)
print v(xbgr.mr_n67796560)
print v(xbgr.mr_n67796672)
print v(xbgr.mr_n67796992)
print v(xbgr.mr_n67797104)
print v(xbgr.mr_n67797424)
print v(xbgr.mr_n67797536)
print v(xbgr.mr_n67797856)
print v(xbgr.mr_n67797968)
print v(xbgr.mr_n67798288)
print v(xbgr.mr_n67798400)
print v(xbgr.mr_n67798720)
print v(xbgr.mr_n67798832)
print v(xbgr.mr_n67799152)
print v(xbgr.mr_n67799264)
print v(xbgr.mr_n67799696)
print v(xbgr.mr_n67800016)
print v(xbgr.mr_n67800128)
print v(xbgr.mr_n67800560)
print v(xbgr.mr_n67800880)
print v(xbgr.mr_n67801744)
print v(xbgr.mr_n67802608)
print v(xbgr.mr_n67803472)
print v(xbgr.mr_n67803584)
print v(xbgr.mr_n67803904)
print v(xbgr.mr_n67804016)
print v(xbgr.mr_n67804336)
print v(xbgr.mr_n67804448)
print v(xbgr.mr_n67804768)
print v(xbgr.mr_n67804880)
print v(xbgr.mr_n67805312)
print v(xbgr.mr_n67805744)
print v(xbgr.mr_n67806176)
print v(xbgr.mr_n67806608)
print v(xbgr.mr_n67806928)
print v(xbgr.mr_n67807040)
print v(xbgr.mr_n67807360)
print v(xbgr.mr_n67807472)
print v(xbgr.mr_n67807792)
print v(xbgr.mr_n67807904)
print v(xbgr.mr_n67808224)
print v(xbgr.mr_n67808336)
print v(xbgr.mr_n67808656)
print v(xbgr.mr_n67808768)
print v(xbgr.mr_n67809088)
print v(xbgr.mr_n67809200)
print v(xbgr.mr_n67809520)
print v(xbgr.mr_n67809632)
print v(xbgr.mr_n67810064)
print v(xbgr.mr_n67810384)
print v(xbgr.mr_n67810496)
print v(xbgr.mr_n67810816)
print v(xbgr.mr_n67811680)
print v(xbgr.mr_n67812416)
print v(xbgr.mr_n67813280)
print v(xbgr.mr_n67814144)
print v(xbgr.mr_n67815008)
print v(xbgr.mr_n67815872)
print v(xbgr.mr_n67815984)
print v(xbgr.mr_n67816416)
print v(xbgr.mr_n67816736)
print v(xbgr.mr_n67816848)
print v(xbgr.mr_n67817280)
print v(xbgr.mr_n67817600)
print v(xbgr.mr_n67817712)
print v(xbgr.mr_n67818032)
print v(xbgr.mr_n67818144)
print v(xbgr.mr_n67818464)
print v(xbgr.mr_n67818576)
print v(xbgr.mr_n67819008)
print v(xbgr.mr_n67819328)
print v(xbgr.mr_n67820192)
print v(xbgr.mr_n67820304)
print v(xbgr.mr_n67820624)
print v(xbgr.mr_n67820736)
print v(xbgr.mr_n67821056)
print v(xbgr.mr_n67821168)
print v(xbgr.mr_n67821488)
print v(xbgr.mr_n67821600)
print v(xbgr.mr_n67821920)
print v(xbgr.mr_n67822032)
print v(xbgr.mr_n67822352)
print v(xbgr.mr_n67822464)
print v(xbgr.mr_n67822784)
print v(xbgr.mr_n67822896)
print v(xbgr.mr_n67823216)
print v(xbgr.mr_n67823648)
print v(xbgr.mr_n67823760)
print v(xbgr.mr_n67824080)
print v(xbgr.mr_n67824192)
print v(xbgr.mr_n67824512)
print v(xbgr.mr_n67824624)
print v(xbgr.mr_n67824944)
print v(xbgr.mr_n67825056)
print v(xbgr.mr_n67825376)
print v(xbgr.mr_n67826672)
print v(xbgr.mr_n67827536)
print v(xbgr.mr_n67828080)
print v(xbgr.mr_n67828512)
print v(xbgr.mr_n67828832)
print v(xbgr.mr_n67828944)
print v(xbgr.mr_n67829264)
print v(xbgr.mr_n67829376)
print v(xbgr.mr_n67829696)
print v(xbgr.mr_n67829808)
print v(xbgr.mr_n67830128)
print v(xbgr.mr_n67830240)
print v(xbgr.mr_n67830560)
print v(xbgr.mr_n67830672)
print v(xbgr.mr_n67830992)
print v(xbgr.mr_n67831104)
print v(xbgr.mr_n67831424)
print v(xbgr.mr_n67831536)
print v(xbgr.mr_n67831856)
print v(xbgr.mr_n67831968)
print v(xbgr.mr_n67832288)
print v(xbgr.mr_n67832400)
print v(xbgr.mr_n67832720)
print v(xbgr.mr_n67833584)
print v(xbgr.mr_n67834448)
print v(xbgr.mr_n67834560)
print v(xbgr.mr_n67834992)
print v(xbgr.mr_n67835744)
print v(xbgr.mr_n67836608)
print v(xbgr.mr_n67837472)
print v(xbgr.mr_n67838448)
print v(xbgr.mr_n67838880)
print v(xbgr.mr_n67839200)
print v(xbgr.mr_n67839312)
print v(xbgr.mr_n67839632)
print v(xbgr.mr_n67839744)
print v(xbgr.mr_n67840064)
print v(xbgr.mr_n67840928)
print v(xbgr.mr_n67841792)
print v(xbgr.mr_n67841904)
print v(xbgr.mr_n67842224)
print v(xbgr.mr_n67842336)
print v(xbgr.mr_n67842656)
print v(xbgr.mr_n67842768)
print v(xbgr.mr_n67843088)
print v(xbgr.mr_n67843200)
print v(xbgr.mr_n67843520)
print v(xbgr.mr_n67843632)
print v(xbgr.mr_n67843952)
print v(xbgr.mr_n67844064)
print v(xbgr.mr_n67844384)
print v(xbgr.mr_n67844496)
print v(xbgr.mr_n67844816)
print v(xbgr.mr_n67844928)
print v(xbgr.mr_n67845248)
print v(xbgr.mr_n67845360)
print v(xbgr.mr_n67845792)
print v(xbgr.mr_n67846112)
print v(xbgr.mr_n67846544)
print v(xbgr.mr_n67846656)
print v(xbgr.mr_n67847408)
print v(xbgr.mr_n67847520)
print v(xbgr.mr_n67847952)
print v(xbgr.mr_n67848704)
print v(xbgr.mr_n67848816)
print v(xbgr.mr_n67849136)
print v(xbgr.mr_n67849248)
print v(xbgr.mr_n67849680)
print v(xbgr.mr_n67850112)
print v(xbgr.mr_n67850544)
print v(xbgr.mr_n67850864)
print v(xbgr.mr_n67850976)
print v(xbgr.mr_n67851296)
print v(xbgr.mr_n67851408)
print v(xbgr.mr_n67851840)
print v(xbgr.mr_n67852160)
print v(xbgr.mr_n67853024)
print v(xbgr.mr_n67853136)
print v(xbgr.mr_n67853456)
print v(xbgr.mr_n67853568)
print v(xbgr.mr_n67853888)
print v(xbgr.mr_n67854000)
print v(xbgr.mr_n67854320)
print v(xbgr.mr_n67854432)
print v(xbgr.mr_n67854752)
print v(xbgr.mr_n67854864)
print v(xbgr.mr_n67855184)
print v(xbgr.mr_n67855296)
print v(xbgr.mr_n67855616)
print v(xbgr.mr_n67856480)
print v(xbgr.mr_n67857344)
print v(xbgr.mr_n67857456)
print v(xbgr.mr_n67857776)
print v(xbgr.mr_n67857888)
print v(xbgr.mr_n67858208)
print v(xbgr.mr_n67858320)
print v(xbgr.mr_n67858640)
print v(xbgr.mr_n67858752)
print v(xbgr.mr_n67859072)
print v(xbgr.mr_n67859936)
print v(xbgr.mr_n67860800)
print v(xbgr.mr_n67861664)
print v(xbgr.mr_n67862528)
print v(xbgr.mr_n67863936)
print v(xbgr.mr_n67864256)
print v(xbgr.mr_n67865120)
print v(xbgr.mr_n67865984)
print v(xbgr.mr_n67866096)
print v(xbgr.mr_n67866528)
print v(xbgr.mr_n67866848)
print v(xbgr.mr_n67866960)
print v(xbgr.mr_n67867392)
print v(xbgr.mr_n67867712)
print v(xbgr.mr_n67868576)
print v(xbgr.mr_n67869440)
print v(xbgr.mr_n67870304)
print v(xbgr.mr_n67871168)
print v(xbgr.mr_n67871280)
print v(xbgr.mr_n67871600)
print v(xbgr.mr_n67871712)
print v(xbgr.mr_n67872032)
print v(xbgr.mr_n67872144)
print v(xbgr.mr_n67872464)
print v(xbgr.mr_n67872576)
print v(xbgr.mr_n67872896)
print v(xbgr.mr_n67873760)
print v(xbgr.mr_n67874624)
print v(xbgr.mr_n67874736)
print v(xbgr.mr_n67875056)
print v(xbgr.mr_n67875168)
print v(xbgr.mr_n67875600)
print v(xbgr.mr_n67876032)
print v(xbgr.mr_n67876352)
print v(xbgr.mr_n67876464)
print v(xbgr.mr_n67876784)
print v(xbgr.mr_n67876896)
print v(xbgr.mr_n67877216)
print v(xbgr.mr_n67877328)
print v(xbgr.mr_n67877648)
print v(xbgr.mr_n67877760)
print v(xbgr.mr_n67878080)
print v(xbgr.mr_n67878192)
print v(xbgr.mr_n67878624)
print v(xbgr.mr_n67878944)
print v(xbgr.mr_n67879056)
print v(xbgr.mr_n67879488)
print v(xbgr.mr_n67879808)
print v(xbgr.mr_n67880672)
print v(xbgr.mr_n67881536)
print v(xbgr.mr_n67882400)
print v(xbgr.mr_n67883264)
print v(xbgr.mr_n67883376)
print v(xbgr.mr_n67883696)
print v(xbgr.mr_n67883808)
print v(xbgr.mr_n67884128)
print v(xbgr.mr_n67884240)
print v(xbgr.mr_n67884560)
print v(xbgr.mr_n67884672)
print v(xbgr.mr_n67884992)
print v(xbgr.mr_n67885856)
print v(xbgr.mr_n67886720)
print v(xbgr.mr_n67886832)
print v(xbgr.mr_n67887152)
print v(xbgr.mr_n67887264)
print v(xbgr.mr_n67887696)
print v(xbgr.mr_n67888128)
print v(xbgr.mr_n67888448)
print v(xbgr.mr_n67888560)
print v(xbgr.mr_n67888880)
print v(xbgr.mr_n67888992)
print v(xbgr.mr_n67889312)
print v(xbgr.mr_n67889424)
print v(xbgr.mr_n67889744)
print v(xbgr.mr_n67889856)
print v(xbgr.mr_n67890176)
print v(xbgr.mr_n67890288)
print v(xbgr.mr_n67890720)
print v(xbgr.mr_n67891040)
print v(xbgr.mr_n67891152)
print v(xbgr.mr_n67891584)
print v(xbgr.mr_n67891904)
print v(xbgr.mr_n67892016)
print v(xbgr.mr_n67892448)
print v(xbgr.mr_n67892768)
print v(xbgr.mr_n67892880)
print v(xbgr.mr_n67893312)
print v(xbgr.mr_n67893632)
print v(xbgr.mr_n67894496)
print v(xbgr.mr_n67895360)
print v(xbgr.mr_n67896224)
print v(xbgr.mr_n67897088)
print v(xbgr.mr_n67897952)
print v(xbgr.mr_n67898816)
print v(xbgr.mr_n67898928)
print v(xbgr.mr_n67899248)
print v(xbgr.mr_n67899360)
print v(xbgr.mr_n67899680)
print v(xbgr.mr_n67899792)
print v(xbgr.mr_n67900112)
print v(xbgr.mr_n67900224)
print v(xbgr.mr_n67900544)
print v(xbgr.mr_n67900656)
print v(xbgr.mr_n67900976)
print v(xbgr.mr_n67901088)
print v(xbgr.mr_n67901408)
print v(xbgr.mr_n67901520)
print v(xbgr.mr_n67901840)
print v(xbgr.mr_n67901952)
print v(xbgr.mr_n67902272)
print v(xbgr.mr_n67902384)
print v(xbgr.mr_n67902704)
print v(xbgr.mr_n67902816)
print v(xbgr.mr_n67903248)
print v(xbgr.mr_n67903680)
print v(xbgr.mr_n67904000)
print v(xbgr.mr_n67904864)
print v(xbgr.mr_n67905728)
print v(xbgr.mr_n67905840)
print v(xbgr.mr_n67906160)
print v(xbgr.mr_n67906272)
print v(xbgr.mr_n67906592)
print v(xbgr.mr_n67906704)
print v(xbgr.mr_n67907024)
print v(xbgr.mr_n67907136)
print v(xbgr.mr_n67907456)
print v(xbgr.mr_n67907568)
print v(xbgr.mr_n67907888)
print v(xbgr.mr_n67908000)
print v(xbgr.mr_n67908320)
print v(xbgr.mr_n67908432)
print v(xbgr.mr_n67908752)
print v(xbgr.mr_n67908864)
print v(xbgr.mr_n67909296)
print v(xbgr.mr_n67909728)
print v(xbgr.mr_n67910048)
print v(xbgr.mr_n67910160)
print v(xbgr.mr_n67910480)
print v(xbgr.mr_n67910592)
print v(xbgr.mr_n67910912)
print v(xbgr.mr_n67911024)
print v(xbgr.mr_n67911344)
print v(xbgr.mr_n67911456)
print v(xbgr.mr_n67911776)
print v(xbgr.mr_n67911888)
print v(xbgr.mr_n67912208)
print v(xbgr.mr_n67912320)
print v(xbgr.mr_n67912640)
print v(xbgr.mr_n67913504)
print v(xbgr.mr_n67914368)
print v(xbgr.mr_n67915232)
print v(xbgr.mr_n67916096)
print v(xbgr.mr_n67916208)
print v(xbgr.mr_n67916640)
print v(xbgr.mr_n67916960)
print v(xbgr.mr_n67917072)
print v(xbgr.mr_n67917392)
print v(xbgr.mr_n67917504)
print v(xbgr.mr_n67917824)
print v(xbgr.mr_n67917936)
print v(xbgr.mr_n67918256)
print v(xbgr.mr_n67918368)
print v(xbgr.mr_n67918688)
print v(xbgr.mr_n67918800)
print v(xbgr.mr_n67919120)
print v(xbgr.mr_n67919232)
print v(xbgr.mr_n67919552)
print v(xbgr.mr_n67919664)
print v(xbgr.mr_n67920096)
print v(xbgr.mr_n67920416)
print v(xbgr.mr_n67921280)
print v(xbgr.mr_n67921392)
print v(xbgr.mr_n67921712)
print v(xbgr.mr_n67921824)
print v(xbgr.mr_n67922144)
print v(xbgr.mr_n67922256)
print v(xbgr.mr_n67922576)
print v(xbgr.mr_n67922688)
print v(xbgr.mr_n67923008)
print v(xbgr.mr_n67923120)
print v(xbgr.mr_n67923552)
print v(xbgr.mr_n67923872)
print v(xbgr.mr_n67923984)
print v(xbgr.mr_n67924416)
print v(xbgr.mr_n67924736)
print v(xbgr.mr_n67925600)
print v(xbgr.mr_n67926464)
print v(xbgr.mr_n67927328)
print v(xbgr.mr_n67928192)
print v(xbgr.mr_n67928304)
print v(xbgr.mr_n67928624)
print v(xbgr.mr_n67928736)
print v(xbgr.mr_n67929056)
print v(xbgr.mr_n67929168)
print v(xbgr.mr_n67929488)
print v(xbgr.mr_n67929600)
print v(xbgr.mr_n67929920)
print v(xbgr.mr_n67930032)
print v(xbgr.mr_n67930352)
print v(xbgr.mr_n67930464)
print v(xbgr.mr_n67930784)
print v(xbgr.mr_n67931648)
print v(xbgr.mr_n67932512)
print v(xbgr.mr_n67932624)
print v(xbgr.mr_n67932944)
print v(xbgr.mr_n67933056)
print v(xbgr.mr_n67933488)
print v(xbgr.mr_n67933920)
print v(xbgr.mr_n67934240)
print v(xbgr.mr_n67934352)
print v(xbgr.mr_n67934672)
print v(xbgr.mr_n67934784)
print v(xbgr.mr_n67935104)
print v(xbgr.mr_n67935216)
print v(xbgr.mr_n67935536)
print v(xbgr.mr_n67935648)
print v(xbgr.mr_n67935968)
print v(xbgr.mr_n67936832)
print v(xbgr.mr_n67937696)
print v(xbgr.mr_n67938560)
print v(xbgr.mr_n67939424)
print v(xbgr.mr_n67940288)
print v(xbgr.mr_n67940400)
print v(xbgr.mr_n67940720)
print v(xbgr.mr_n67940832)
print v(xbgr.mr_n67941152)
print v(xbgr.mr_n67941264)
print v(xbgr.mr_n67941584)
print v(xbgr.mr_n67941696)
print v(xbgr.mr_n67942016)
print v(xbgr.mr_n67942128)
print v(xbgr.mr_n67942560)
print v(xbgr.mr_n67942880)
print v(xbgr.mr_n67942992)
print v(xbgr.mr_n67943424)
print v(xbgr.mr_n67943744)
print v(xbgr.mr_n67943856)
print v(xbgr.mr_n67944288)
print v(xbgr.mr_n67944608)
print v(xbgr.mr_n67944720)
print v(xbgr.mr_n67945152)
print v(xbgr.mr_n67945472)
print v(xbgr.mr_n67946336)
print v(xbgr.mr_n67946448)
print v(xbgr.mr_n67946768)
print v(xbgr.mr_n67946880)
print v(xbgr.mr_n67947200)
print v(xbgr.mr_n67947312)
print v(xbgr.mr_n67947632)
print v(xbgr.mr_n67947744)
print v(xbgr.mr_n67948064)
print v(xbgr.mr_n67948928)
print v(xbgr.mr_n67949792)
print v(xbgr.mr_n67950656)
print v(xbgr.mr_n67951520)
print v(xbgr.mr_n67952384)
print v(xbgr.mr_n67952496)
print v(xbgr.mr_n67952816)
print v(xbgr.mr_n67952928)
print v(xbgr.mr_n67953248)
print v(xbgr.mr_n67953360)
print v(xbgr.mr_n67953680)
print v(xbgr.mr_n67953792)
print v(xbgr.mr_n67954224)
print v(xbgr.mr_n67954656)
print v(xbgr.mr_n67954976)
print v(xbgr.mr_n67955088)
print v(xbgr.mr_n67955408)
print v(xbgr.mr_n67955520)
print v(xbgr.mr_n67955840)
print v(xbgr.mr_n67956704)
print v(xbgr.mr_n67956816)
print v(xbgr.mr_n67957136)
print v(xbgr.mr_n67957248)
print v(xbgr.mr_n67957568)
print v(xbgr.mr_n67958432)
print v(xbgr.mr_n67959296)
print v(xbgr.mr_n67959408)
print v(xbgr.mr_n67959728)
print v(xbgr.mr_n67959840)
print v(xbgr.mr_n67960160)
print v(xbgr.mr_n67961024)
print v(xbgr.mr_n67961888)
print v(xbgr.mr_n67962752)
print v(xbgr.mr_n67962864)
print v(xbgr.mr_n67963184)
print v(xbgr.mr_n67963296)
print v(xbgr.mr_n67963616)
print v(xbgr.mr_n67963728)
print v(xbgr.mr_n67964048)
print v(xbgr.mr_n67964160)
print v(xbgr.mr_n67964480)
print v(xbgr.mr_n67964592)
print v(xbgr.mr_n67964912)
print v(xbgr.mr_n67965024)
print v(xbgr.mr_n67965344)
print v(xbgr.mr_n67965456)
print v(xbgr.mr_n67965776)
print v(xbgr.mr_n67965888)
print v(xbgr.mr_n67966208)
print v(xbgr.mr_n67966320)
print v(xbgr.mr_n67966640)
print v(xbgr.mr_n67966752)
print v(xbgr.mr_n67967072)
print v(xbgr.mr_n67967184)
print v(xbgr.mr_n67967504)
print v(xbgr.mr_n67967616)
print v(xbgr.mr_n67968048)
print v(xbgr.mr_n67968368)
print v(xbgr.mr_n67968480)
print v(xbgr.mr_n67968912)
print v(xbgr.mr_n67969232)
print v(xbgr.mr_n67969344)
print v(xbgr.mr_n67969776)
print v(xbgr.mr_n67970096)
print v(xbgr.mr_n67970960)
print v(xbgr.mr_n67971824)
print v(xbgr.mr_n67972688)
print v(xbgr.mr_n67972800)
print v(xbgr.mr_n67973120)
print v(xbgr.mr_n67973232)
print v(xbgr.mr_n67973552)
print v(xbgr.mr_n67974416)
print v(xbgr.mr_n67975280)
print v(xbgr.mr_n67976144)
print v(xbgr.mr_n67976256)
print v(xbgr.mr_n67976576)
print v(xbgr.mr_n67976688)
print v(xbgr.mr_n67977008)
print v(xbgr.mr_n67977120)
print v(xbgr.mr_n67977440)
print v(xbgr.mr_n67977552)
print v(xbgr.mr_n67977872)
print v(xbgr.mr_n67977984)
print v(xbgr.mr_n67978304)
print v(xbgr.mr_n67978416)
print v(xbgr.mr_n67978736)
print v(xbgr.mr_n67978848)
print v(xbgr.mr_n67979168)
print v(xbgr.mr_n67979280)
print v(xbgr.mr_n67979600)
print v(xbgr.mr_n67979712)
print v(xbgr.mr_n67980032)
print v(xbgr.mr_n67980144)
print v(xbgr.mr_n67980464)
print v(xbgr.mr_n67980576)
print v(xbgr.mr_n67980896)
print v(xbgr.mr_n67981008)
print v(xbgr.mr_n67981328)
print v(xbgr.mr_n67981440)
print v(xbgr.mr_n67981872)
print v(xbgr.mr_n67982192)
print v(xbgr.mr_n67983056)
print v(xbgr.mr_n67983920)
print v(xbgr.mr_n67984784)
print v(xbgr.mr_n67984896)
print v(xbgr.mr_n67985328)
print v(xbgr.mr_n67985648)
print v(xbgr.mr_n67985760)
print v(xbgr.mr_n67986192)
print v(xbgr.mr_n67986512)
print v(xbgr.mr_n67986624)
print v(xbgr.mr_n67986944)
print v(xbgr.mr_n67987056)
print v(xbgr.mr_n67987376)
print v(xbgr.mr_n67987488)
print v(xbgr.mr_n67987920)
print v(xbgr.mr_n67988352)
print v(xbgr.mr_n67988784)
print v(xbgr.mr_n67989104)
print v(xbgr.mr_n67989968)
print v(xbgr.mr_n67990832)
print v(xbgr.mr_n67991696)
print v(xbgr.mr_n67992560)
print v(xbgr.mr_n67993424)
print v(xbgr.mr_n67994288)
print v(xbgr.mr_n67994400)
print v(xbgr.mr_n67994720)
print v(xbgr.mr_n67994832)
print v(xbgr.mr_n67995152)
print v(xbgr.mr_n67995264)
print v(xbgr.mr_n67995584)
print v(xbgr.mr_n67995696)
print v(xbgr.mr_n67996016)
print v(xbgr.mr_n67996128)
print v(xbgr.mr_n67996448)
print v(xbgr.mr_n67996560)
print v(xbgr.mr_n67996880)
print v(xbgr.mr_n67997744)
print v(xbgr.mr_n67998608)
print v(xbgr.mr_n67999584)
print v(xbgr.mr_n68000016)
print v(xbgr.mr_n68000448)
print v(xbgr.mr_n68000768)
print v(xbgr.mr_n68000880)
print v(xbgr.mr_n68001200)
print v(xbgr.mr_n68001312)
print v(xbgr.mr_n68001632)
print v(xbgr.mr_n68001744)
print v(xbgr.mr_n68002176)
print v(xbgr.mr_n68002496)
print v(xbgr.mr_n68002608)
print v(xbgr.mr_n68002928)
print v(xbgr.mr_n68003040)
print v(xbgr.mr_n68003472)
print v(xbgr.mr_n68003792)
print v(xbgr.mr_n68003904)
print v(xbgr.mr_n68004336)
print v(xbgr.mr_n68004656)
print v(xbgr.mr_n68004768)
print v(xbgr.mr_n68005200)
print v(xbgr.mr_n68005520)
print v(xbgr.mr_n68006384)
print v(xbgr.mr_n68007248)
print v(xbgr.mr_n68007360)
print v(xbgr.mr_n68007680)
print v(xbgr.mr_n68007792)
print v(xbgr.mr_n68008112)
print v(xbgr.mr_n68008224)
print v(xbgr.mr_n68008544)
print v(xbgr.mr_n68008656)
print v(xbgr.mr_n68009088)
print v(xbgr.mr_n68009408)
print v(xbgr.mr_n68010272)
print v(xbgr.mr_n68010384)
print v(xbgr.mr_n68010704)
print v(xbgr.mr_n68010816)
print v(xbgr.mr_n68011136)
print v(xbgr.mr_n68011248)
print v(xbgr.mr_n68011568)
print v(xbgr.mr_n68012432)
print v(xbgr.mr_n68012864)
print v(xbgr.mr_n68013728)
print v(xbgr.mr_n68013840)
print v(xbgr.mr_n68014160)
print v(xbgr.mr_n68014272)
print v(xbgr.mr_n68014592)
print v(xbgr.mr_n68014704)
print v(xbgr.mr_n68015024)
print v(xbgr.mr_n68015136)
print v(xbgr.mr_n68015456)
print v(xbgr.mr_n68015568)
print v(xbgr.mr_n68016000)
print v(xbgr.mr_n68016752)
print v(xbgr.mr_n68017616)
print v(xbgr.mr_n68018048)
print v(xbgr.mr_n68018160)
print v(xbgr.mr_n68018480)
print v(xbgr.mr_n68018912)
print v(xbgr.mr_n68019776)
print v(xbgr.mr_n68020640)
print v(xbgr.mr_n68021504)
print v(xbgr.mr_n68022368)
print v(xbgr.mr_n68023664)
print v(xbgr.mr_n68024528)
print v(xbgr.mr_n68025504)
print v(xbgr.mr_n68025824)
print v(xbgr.mr_n68025936)
print v(xbgr.mr_n68026368)
print v(xbgr.mr_n68026688)
print v(xbgr.mr_n68027552)
print v(xbgr.mr_n68027664)
print v(xbgr.mr_n68027984)
print v(xbgr.mr_n68028096)
print v(xbgr.mr_n68028528)
print v(xbgr.mr_n68028848)
print v(xbgr.mr_n68028960)
print v(xbgr.mr_n68029280)
print v(xbgr.mr_n68029392)
print v(xbgr.mr_n68029712)
print v(xbgr.mr_n68029824)
print v(xbgr.mr_n68030144)
print v(xbgr.mr_n68030256)
print v(xbgr.mr_n68030688)
print v(xbgr.mr_n68031008)
print v(xbgr.mr_n68031120)
print v(xbgr.mr_n68031440)
print v(xbgr.mr_n68031552)
print v(xbgr.mr_n68031872)
print v(xbgr.mr_n68032736)
print v(xbgr.mr_n68032848)
print v(xbgr.mr_n68033600)
print v(xbgr.mr_n68033712)
print v(xbgr.mr_n68034032)
print v(xbgr.mr_n68034144)
print v(xbgr.mr_n68034464)
print v(xbgr.mr_n68034576)
print v(xbgr.mr_n68034896)
print v(xbgr.mr_n68035008)
print v(xbgr.mr_n68035328)
print v(xbgr.mr_n68035440)
print v(xbgr.mr_n68035760)
print v(xbgr.mr_n68035872)
print v(xbgr.mr_n68036192)
print v(xbgr.mr_n68036304)
print v(xbgr.mr_n68036624)
print v(xbgr.mr_n68036736)
print v(xbgr.mr_n68037056)
print v(xbgr.mr_n68037168)
print v(xbgr.mr_n68037488)
print v(xbgr.mr_n68037600)
print v(xbgr.mr_n68037920)
print v(xbgr.mr_n68038032)
print v(xbgr.mr_n68038352)
print v(xbgr.mr_n68038464)
print v(xbgr.mr_n68038784)
print v(xbgr.mr_n68038896)
print v(xbgr.mr_n68039328)
print v(xbgr.mr_n68039648)
print v(xbgr.mr_n68039760)
print v(xbgr.mr_n68040192)
print v(xbgr.mr_n68040512)
print v(xbgr.mr_n68040624)
print v(xbgr.mr_n68041056)
print v(xbgr.mr_n68041376)
print v(xbgr.mr_n68042240)
print v(xbgr.mr_n68043104)
print v(xbgr.mr_n68043968)
print v(xbgr.mr_n68044832)
print v(xbgr.mr_n68045696)
print v(xbgr.mr_n68046560)
print v(xbgr.mr_n68046672)
print v(xbgr.mr_n68046992)
print v(xbgr.mr_n68047104)
print v(xbgr.mr_n68047424)
print v(xbgr.mr_n68047536)
print v(xbgr.mr_n68047856)
print v(xbgr.mr_n68047968)
print v(xbgr.mr_n68048288)
print v(xbgr.mr_n68049152)
print v(xbgr.mr_n68050016)
print v(xbgr.mr_n68050880)
print v(xbgr.mr_n68050992)
print v(xbgr.mr_n68051312)
print v(xbgr.mr_n68051424)
print v(xbgr.mr_n68051744)
print v(xbgr.mr_n68051856)
print v(xbgr.mr_n68052288)
print v(xbgr.mr_n68052720)
print v(xbgr.mr_n68053152)
print v(xbgr.mr_n68053472)
print v(xbgr.mr_n68053584)
print v(xbgr.mr_n68053904)
print v(xbgr.mr_n68054016)
print v(xbgr.mr_n68054336)
print v(xbgr.mr_n68054448)
print v(xbgr.mr_n68054768)
print v(xbgr.mr_n68054880)
print v(xbgr.mr_n68055200)
print v(xbgr.mr_n68055312)
print v(xbgr.mr_n68055632)
print v(xbgr.mr_n68055744)
print v(xbgr.mr_n68056064)
print v(xbgr.mr_n68056176)
print v(xbgr.mr_n68056608)
print v(xbgr.mr_n68056928)
print v(xbgr.mr_n68057040)
print v(xbgr.mr_n68057472)
print v(xbgr.mr_n68057792)
print v(xbgr.mr_n68057904)
print v(xbgr.mr_n68058336)
print v(xbgr.mr_n68058656)
print v(xbgr.mr_n68059520)
print v(xbgr.mr_n68060384)
print v(xbgr.mr_n68061248)
print v(xbgr.mr_n68062112)
print v(xbgr.mr_n68062976)
print v(xbgr.mr_n68063840)
print v(xbgr.mr_n68063952)
print v(xbgr.mr_n68064272)
print v(xbgr.mr_n68064384)
print v(xbgr.mr_n68064704)
print v(xbgr.mr_n68064816)
print v(xbgr.mr_n68065136)
print v(xbgr.mr_n68065248)
print v(xbgr.mr_n68065568)
print v(xbgr.mr_n68066432)
print v(xbgr.mr_n68067296)
print v(xbgr.mr_n68068160)
print v(xbgr.mr_n68068272)
print v(xbgr.mr_n68068592)
print v(xbgr.mr_n68068704)
print v(xbgr.mr_n68069024)
print v(xbgr.mr_n68069136)
print v(xbgr.mr_n68069568)
print v(xbgr.mr_n68069888)
print v(xbgr.mr_n68070000)
print v(xbgr.mr_n68070432)
print v(xbgr.mr_n68070752)
print v(xbgr.mr_n68070864)
print v(xbgr.mr_n68071296)
print v(xbgr.mr_n68071616)
print v(xbgr.mr_n68071728)
print v(xbgr.mr_n68072048)
print v(xbgr.mr_n68072160)
print v(xbgr.mr_n68072480)
print v(xbgr.mr_n68072592)
print v(xbgr.mr_n68073024)
print v(xbgr.mr_n68073344)
print v(xbgr.mr_n68074208)
print v(xbgr.mr_n68075072)
print v(xbgr.mr_n68075936)
print v(xbgr.mr_n68076048)
print v(xbgr.mr_n68076368)
print v(xbgr.mr_n68076480)
print v(xbgr.mr_n68076800)
print v(xbgr.mr_n68077664)
print v(xbgr.mr_n68078528)
print v(xbgr.mr_n68079392)
print v(xbgr.mr_n68080256)
print v(xbgr.mr_n68080368)
print v(xbgr.mr_n68080688)
print v(xbgr.mr_n68080800)
print v(xbgr.mr_n68081120)
print v(xbgr.mr_n68081984)
print v(xbgr.mr_n68082528)
print v(xbgr.mr_n68082848)
print v(xbgr.mr_n68082960)
print v(xbgr.mr_n68083280)
print v(xbgr.mr_n68083392)
print v(xbgr.mr_n68083712)
print v(xbgr.mr_n68083824)
print v(xbgr.mr_n68084144)
print v(xbgr.mr_n68084256)
print v(xbgr.mr_n68084688)
print v(xbgr.mr_n68085440)
print v(xbgr.mr_n68086304)
print v(xbgr.mr_n68087168)
print v(xbgr.mr_n68088032)
print v(xbgr.mr_n68088144)
print v(xbgr.mr_n68088464)
print v(xbgr.mr_n68088576)
print v(xbgr.mr_n68088896)
print v(xbgr.mr_n68089008)
print v(xbgr.mr_n68089328)
print v(xbgr.mr_n68089440)
print v(xbgr.mr_n68089760)
print v(xbgr.mr_n68089872)
print v(xbgr.mr_n68090192)
print v(xbgr.mr_n68090304)
print v(xbgr.mr_n68090624)
print v(xbgr.mr_n68090736)
print v(xbgr.mr_n68091168)
print v(xbgr.mr_n68091488)
print v(xbgr.mr_n68091600)
print v(xbgr.mr_n68091920)
print v(xbgr.mr_n68092032)
print v(xbgr.mr_n68092352)
print v(xbgr.mr_n68092464)
print v(xbgr.mr_n68092784)
print v(xbgr.mr_n68092896)
print v(xbgr.mr_n68093216)
print v(xbgr.mr_n68093328)
print v(xbgr.mr_n68093760)
print v(xbgr.mr_n68094080)
print v(xbgr.mr_n68094944)
print v(xbgr.mr_n68095056)
print v(xbgr.mr_n68095376)
print v(xbgr.mr_n68095488)
print v(xbgr.mr_n68095920)
print v(xbgr.mr_n68096352)
print v(xbgr.mr_n68096672)
print v(xbgr.mr_n68096784)
print v(xbgr.mr_n68097104)
print v(xbgr.mr_n68097216)
print v(xbgr.mr_n68097536)
print v(xbgr.mr_n68097648)
print v(xbgr.mr_n68097968)
print v(xbgr.mr_n68098080)
print v(xbgr.mr_n68098400)
print v(xbgr.mr_n68098512)
print v(xbgr.mr_n68098944)
print v(xbgr.mr_n68099264)
print v(xbgr.mr_n68099376)
print v(xbgr.mr_n68099808)
print v(xbgr.mr_n68100128)
print v(xbgr.mr_n68100992)
print v(xbgr.mr_n68101856)
print v(xbgr.mr_n68102720)
print v(xbgr.mr_n68103584)
print v(xbgr.mr_n68103696)
print v(xbgr.mr_n68104016)
print v(xbgr.mr_n68104128)
print v(xbgr.mr_n68104448)
print v(xbgr.mr_n68104560)
print v(xbgr.mr_n68104880)
print v(xbgr.mr_n68104992)
print v(xbgr.mr_n68105312)
print v(xbgr.mr_n68106176)
print v(xbgr.mr_n68107040)
print v(xbgr.mr_n68107152)
print v(xbgr.mr_n68107472)
print v(xbgr.mr_n68107584)
print v(xbgr.mr_n68108016)
print v(xbgr.mr_n68108448)
print v(xbgr.mr_n68108768)
print v(xbgr.mr_n68108880)
print v(xbgr.mr_n68109200)
print v(xbgr.mr_n68109312)
print v(xbgr.mr_n68109632)
print v(xbgr.mr_n68109744)
print v(xbgr.mr_n68110064)
print v(xbgr.mr_n68110176)
print v(xbgr.mr_n68110496)
print v(xbgr.mr_n68111360)
print v(xbgr.mr_n68112224)
print v(xbgr.mr_n68113088)
print v(xbgr.mr_n68113952)
print v(xbgr.mr_n68114816)
print v(xbgr.mr_n68114928)
print v(xbgr.mr_n68115360)
print v(xbgr.mr_n68115680)
print v(xbgr.mr_n68115792)
print v(xbgr.mr_n68116224)
print v(xbgr.mr_n68116544)
print v(xbgr.mr_n68116656)
print v(xbgr.mr_n68117088)
print v(xbgr.mr_n68117408)
print v(xbgr.mr_n68117520)
print v(xbgr.mr_n68117840)
print v(xbgr.mr_n68117952)
print v(xbgr.mr_n68118272)
print v(xbgr.mr_n68118384)
print v(xbgr.mr_n68118704)
print v(xbgr.mr_n68118816)
print v(xbgr.mr_n68119136)
print v(xbgr.mr_n68119248)
print v(xbgr.mr_n68119568)
print v(xbgr.mr_n68119680)
print v(xbgr.mr_n68120000)
print v(xbgr.mr_n68120112)
print v(xbgr.mr_n68120432)
print v(xbgr.mr_n68120544)
print v(xbgr.mr_n68120864)
print v(xbgr.mr_n68120976)
print v(xbgr.mr_n68121296)
print v(xbgr.mr_n68121408)
print v(xbgr.mr_n68121728)
print v(xbgr.mr_n68121840)
print v(xbgr.mr_n68122160)
print v(xbgr.mr_n68122272)
print v(xbgr.mr_n68122592)
print v(xbgr.mr_n68123456)
print v(xbgr.mr_n68124320)
print v(xbgr.mr_n68125184)
print v(xbgr.mr_n68125296)
print v(xbgr.mr_n68125728)
print v(xbgr.mr_n68126048)
print v(xbgr.mr_n68126160)
print v(xbgr.mr_n68126480)
print v(xbgr.mr_n68126592)
print v(xbgr.mr_n68126912)
print v(xbgr.mr_n68127024)
print v(xbgr.mr_n68127344)
print v(xbgr.mr_n68127456)
print v(xbgr.mr_n68127888)
print v(xbgr.mr_n68128320)
print v(xbgr.mr_n68128752)
print v(xbgr.mr_n68129184)
print v(xbgr.mr_n68129504)
print v(xbgr.mr_n68129616)
print v(xbgr.mr_n68130048)
print v(xbgr.mr_n68130368)
print v(xbgr.mr_n68131232)
print v(xbgr.mr_n68131344)
print v(xbgr.mr_n68131664)
print v(xbgr.mr_n68131776)
print v(xbgr.mr_n68132096)
print v(xbgr.mr_n68132208)
print v(xbgr.mr_n68132528)
print v(xbgr.mr_n68133504)
print v(xbgr.mr_n68133936)
print v(xbgr.mr_n68134368)
print v(xbgr.mr_n68134688)
print v(xbgr.mr_n68135552)
print v(xbgr.mr_n68135664)
print v(xbgr.mr_n68135984)
print v(xbgr.mr_n68136096)
print v(xbgr.mr_n68136416)
print v(xbgr.mr_n68136528)
print v(xbgr.mr_n68136848)
print v(xbgr.mr_n68136960)
print v(xbgr.mr_n68137280)
print v(xbgr.mr_n68137392)
print v(xbgr.mr_n68137712)
print v(xbgr.mr_n68137824)
print v(xbgr.mr_n68138144)
print v(xbgr.mr_n68138256)
print v(xbgr.mr_n68138576)
print v(xbgr.mr_n68138688)
print v(xbgr.mr_n68139008)
print v(xbgr.mr_n68139872)
print v(xbgr.mr_n68140736)
print v(xbgr.mr_n68141600)
print v(xbgr.mr_n68142464)
print v(xbgr.mr_n68143328)
print v(xbgr.mr_n68144192)
print v(xbgr.mr_n68145056)
print v(xbgr.mr_n68145920)
print v(xbgr.mr_n68146784)
print v(xbgr.mr_n68147648)
print v(xbgr.mr_n68148512)
print v(xbgr.mr_n68149376)
print v(xbgr.mr_n68149488)
print v(xbgr.mr_n68149808)
print v(xbgr.mr_n68149920)
print v(xbgr.mr_n68150240)
print v(xbgr.mr_n68150352)
print v(xbgr.mr_n68150672)
print v(xbgr.mr_n68150784)
print v(xbgr.mr_n68151104)
print v(xbgr.mr_n68151216)
print v(xbgr.mr_n68151648)
print v(xbgr.mr_n68151968)
print v(xbgr.mr_n68152080)
print v(xbgr.mr_n68152512)
print v(xbgr.mr_n68152832)
print v(xbgr.mr_n68153696)
print v(xbgr.mr_n68154560)
print v(xbgr.mr_n68155424)
print v(xbgr.mr_n68156288)
print v(xbgr.mr_n68156400)
print v(xbgr.mr_n68156720)
print v(xbgr.mr_n68156832)
print v(xbgr.mr_n68157152)
print v(xbgr.mr_n68157264)
print v(xbgr.mr_n68157584)
print v(xbgr.mr_n68157696)
print v(xbgr.mr_n68158016)
print v(xbgr.mr_n68158128)
print v(xbgr.mr_n68158448)
print v(xbgr.mr_n68158560)
print v(xbgr.mr_n68158880)
print v(xbgr.mr_n68158992)
print v(xbgr.mr_n68159312)
print v(xbgr.mr_n68160176)
print v(xbgr.mr_n68161040)
print v(xbgr.mr_n68161152)
print v(xbgr.mr_n68161472)
print v(xbgr.mr_n68161584)
print v(xbgr.mr_n68162016)
print v(xbgr.mr_n68162448)
print v(xbgr.mr_n68162768)
print v(xbgr.mr_n68162880)
print v(xbgr.mr_n68163200)
print v(xbgr.mr_n68163312)
print v(xbgr.mr_n68163632)
print v(xbgr.mr_n68163744)
print v(xbgr.mr_n68164064)
print v(xbgr.mr_n68164176)
print v(xbgr.mr_n68164496)
print v(xbgr.mr_n68164608)
print v(xbgr.mr_n68165040)
print v(xbgr.mr_n68165360)
print v(xbgr.mr_n68165472)
print v(xbgr.mr_n68165904)
print v(xbgr.mr_n68166224)
print v(xbgr.mr_n68166336)
print v(xbgr.mr_n68166656)
print v(xbgr.mr_n68167520)
print v(xbgr.mr_n68168384)
print v(xbgr.mr_n68169248)
print v(xbgr.mr_n68170112)
print v(xbgr.mr_n68170224)
print v(xbgr.mr_n68170544)
print v(xbgr.mr_n68170656)
print v(xbgr.mr_n68170976)
print v(xbgr.mr_n68171088)
print v(xbgr.mr_n68171408)
print v(xbgr.mr_n68171520)
print v(xbgr.mr_n68171840)
print v(xbgr.mr_n68171952)
print v(xbgr.mr_n68172272)
print v(xbgr.mr_n68172384)
print v(xbgr.mr_n68172704)
print v(xbgr.mr_n68173568)
print v(xbgr.mr_n68174432)
print v(xbgr.mr_n68174544)
print v(xbgr.mr_n68174976)
print v(xbgr.mr_n68175296)
print v(xbgr.mr_n68175408)
print v(xbgr.mr_n68175728)
print v(xbgr.mr_n68175840)
print v(xbgr.mr_n68176160)
print v(xbgr.mr_n68176272)
print v(xbgr.mr_n68176592)
print v(xbgr.mr_n68176704)
print v(xbgr.mr_n68177024)
print v(xbgr.mr_n68177136)
print v(xbgr.mr_n68177456)
print v(xbgr.mr_n68177568)
print v(xbgr.mr_n68178000)
print v(xbgr.mr_n68178432)
print v(xbgr.mr_n68178864)
print v(xbgr.mr_n68179296)
print v(xbgr.mr_n68179616)
print v(xbgr.mr_n68180048)
print v(xbgr.mr_n68180160)
print v(xbgr.mr_n68180480)
print v(xbgr.mr_n68180592)
print v(xbgr.mr_n68180912)
print v(xbgr.mr_n68181024)
print v(xbgr.mr_n68181344)
print v(xbgr.mr_n68181456)
print v(xbgr.mr_n68181776)
print v(xbgr.mr_n68181888)
print v(xbgr.mr_n68182208)
print v(xbgr.mr_n68182320)
print v(xbgr.mr_n68183072)
print v(xbgr.mr_n68183184)
print v(xbgr.mr_n68183616)
print v(xbgr.mr_n68183936)
print v(xbgr.mr_n68184368)
print v(xbgr.mr_n68184480)
print v(xbgr.mr_n68184912)
print v(xbgr.mr_n68185232)
print v(xbgr.mr_n68185344)
print v(xbgr.mr_n68185776)
print v(xbgr.mr_n68186096)
print v(xbgr.mr_n68186208)
print v(xbgr.mr_n68186640)
print v(xbgr.mr_n68187392)
print v(xbgr.mr_n68188256)
print v(xbgr.mr_n68189120)
print v(xbgr.mr_n68189984)
print v(xbgr.mr_n68190848)
print v(xbgr.mr_n68191712)
print v(xbgr.mr_n68191824)
print v(xbgr.mr_n68192144)
print v(xbgr.mr_n68192256)
print v(xbgr.mr_n68192576)
print v(xbgr.mr_n68192688)
print v(xbgr.mr_n68193008)
print v(xbgr.mr_n68193120)
print v(xbgr.mr_n68193440)
print v(xbgr.mr_n68194304)
print v(xbgr.mr_n68195168)
print v(xbgr.mr_n68196032)
print v(xbgr.mr_n68196144)
print v(xbgr.mr_n68196464)
print v(xbgr.mr_n68196576)
print v(xbgr.mr_n68196896)
print v(xbgr.mr_n68197008)
print v(xbgr.mr_n68197328)
print v(xbgr.mr_n68197440)
print v(xbgr.mr_n68197760)
print v(xbgr.mr_n68197872)
print v(xbgr.mr_n68198192)
print v(xbgr.mr_n68198304)
print v(xbgr.mr_n68198624)
print v(xbgr.mr_n68198736)
print v(xbgr.mr_n68199056)
print v(xbgr.mr_n68199168)
print v(xbgr.mr_n68199488)
print v(xbgr.mr_n68200352)
print v(xbgr.mr_n68200784)
print v(xbgr.mr_n68201648)
print v(xbgr.mr_n68202080)
print v(xbgr.mr_n68202944)
print v(xbgr.mr_n68203808)
print v(xbgr.mr_n68205104)
print v(xbgr.mr_n68206400)
print v(xbgr.mr_n68206512)
print v(xbgr.mr_n68206832)
print v(xbgr.mr_n68206944)
print v(xbgr.mr_n68207376)
print v(xbgr.mr_n68207696)
print v(xbgr.mr_n68207808)
print v(xbgr.mr_n68208240)
print v(xbgr.mr_n68208560)
print v(xbgr.mr_n68208672)
print v(xbgr.mr_n68208992)
print v(xbgr.mr_n68209104)
print v(xbgr.mr_n68209424)
print v(xbgr.mr_n68209536)
print v(xbgr.mr_n68209968)
print v(xbgr.mr_n68210288)
print v(xbgr.mr_n68210400)
print v(xbgr.mr_n68210832)
print v(xbgr.mr_n68211152)
print v(xbgr.mr_n68211264)
print v(xbgr.mr_n68211696)
print v(xbgr.mr_n68212016)
print v(xbgr.mr_n68212128)
print v(xbgr.mr_n68212448)
print v(xbgr.mr_n68212880)
print v(xbgr.mr_n68212992)
print v(xbgr.mr_n68213312)
print v(xbgr.mr_n68213424)
print v(xbgr.mr_n68213744)
print v(xbgr.mr_n68213856)
print v(xbgr.mr_n68214176)
print v(xbgr.mr_n68214288)
print v(xbgr.mr_n68215040)
print v(xbgr.mr_n68215904)
print v(xbgr.mr_n68216768)
print v(xbgr.mr_n68216880)
print v(xbgr.mr_n68217200)
print v(xbgr.mr_n68217312)
print v(xbgr.mr_n68217632)
print v(xbgr.mr_n68217744)
print v(xbgr.mr_n68218064)
print v(xbgr.mr_n68218176)
print v(xbgr.mr_n68218928)
print v(xbgr.mr_n68219360)
print v(xbgr.mr_n68220224)
print v(xbgr.mr_n68221520)
print v(xbgr.mr_n68221952)
print v(xbgr.mr_n68222816)
print v(xbgr.mr_n68222928)
print v(xbgr.mr_n68223248)
print v(xbgr.mr_n68223360)
print v(xbgr.mr_n68223680)
print v(xbgr.mr_n68224544)
print v(xbgr.mr_n68224976)
print v(xbgr.mr_n68225088)
print v(xbgr.mr_n68225408)
print v(xbgr.mr_n68226272)
print v(xbgr.mr_n68227136)
print v(xbgr.mr_n68228000)
print v(xbgr.mr_n68228864)
print v(xbgr.mr_n68228976)
print v(xbgr.mr_n68229296)
print v(xbgr.mr_n68229408)
print v(xbgr.mr_n68229728)
print v(xbgr.mr_n68229840)
print v(xbgr.mr_n68230160)
print v(xbgr.mr_n68230272)
print v(xbgr.mr_n68231024)
print v(xbgr.mr_n68231888)
print v(xbgr.mr_n68232752)
print v(xbgr.mr_n68232864)
print v(xbgr.mr_n68233296)
print v(xbgr.mr_n68233728)
print v(xbgr.mr_n68234160)
print v(xbgr.mr_n68234480)
print v(xbgr.mr_n68234592)
print v(xbgr.mr_n68234912)
print v(xbgr.mr_n68235024)
print v(xbgr.mr_n68235344)
print v(xbgr.mr_n68235456)
print v(xbgr.mr_n68235776)
print v(xbgr.mr_n68235888)
print v(xbgr.mr_n68236208)
print v(xbgr.mr_n68236320)
print v(xbgr.mr_n68236640)
print v(xbgr.mr_n68236752)
print v(xbgr.mr_n68237072)
print v(xbgr.mr_n68237184)
print v(xbgr.mr_n68237504)
print v(xbgr.mr_n68237616)
print v(xbgr.mr_n68238800)
print v(xbgr.mr_n68239344)
print v(xbgr.mr_n68239776)
print v(xbgr.mr_n68240208)
print v(xbgr.mr_n68240960)
print v(xbgr.mr_n68241072)
print v(xbgr.mr_n68241392)
print v(xbgr.mr_n68241504)
print v(xbgr.mr_n68241824)
print v(xbgr.mr_n68241936)
print v(xbgr.mr_n68242256)
print v(xbgr.mr_n68242368)
print v(xbgr.mr_n68242688)
print v(xbgr.mr_n68242800)
print v(xbgr.mr_n68243120)
print v(xbgr.mr_n68243232)
print v(xbgr.mr_n68243664)
print v(xbgr.mr_n68243984)
print v(xbgr.mr_n68244096)
print v(xbgr.mr_n68244416)
print v(xbgr.mr_n68244528)
print v(xbgr.mr_n68244960)
print v(xbgr.mr_n68245280)
print v(xbgr.mr_n68245392)
print v(xbgr.mr_n68245712)
print v(xbgr.mr_n68245824)
print v(xbgr.mr_n68246144)
print v(xbgr.mr_n68246256)
print v(xbgr.mr_n68246576)
print v(xbgr.mr_n68246688)
print v(xbgr.mr_n68247008)
print v(xbgr.mr_n68247120)
print v(xbgr.mr_n68247440)
print v(xbgr.mr_n68247552)
print v(xbgr.mr_n68247872)
print v(xbgr.mr_n68248736)
print v(xbgr.mr_n68249280)
print v(xbgr.mr_n68249600)
print v(xbgr.mr_n68249712)
print v(xbgr.mr_n68250144)
print v(xbgr.mr_n68250464)
print v(xbgr.mr_n68250576)
print v(xbgr.mr_n68251328)
print v(xbgr.mr_n68252192)
print v(xbgr.mr_n68252304)
print v(xbgr.mr_n68252624)
print v(xbgr.mr_n68252736)
print v(xbgr.mr_n68253056)
print v(xbgr.mr_n68253168)
print v(xbgr.mr_n68253488)
print v(xbgr.mr_n68253920)
print v(xbgr.mr_n68254784)
print v(xbgr.mr_n68256080)
print v(xbgr.mr_n68257056)
print v(xbgr.mr_n68257376)
print v(xbgr.mr_n68257488)
print v(xbgr.mr_n68257808)
print v(xbgr.mr_n68257920)
print v(xbgr.mr_n68258240)
print v(xbgr.mr_n68259104)
print v(xbgr.mr_n68259216)
print v(xbgr.mr_n68259536)
print v(xbgr.mr_n68259648)
print v(xbgr.mr_n68259968)
print v(xbgr.mr_n68260080)
print v(xbgr.mr_n68260400)
print v(xbgr.mr_n68260512)
print v(xbgr.mr_n68260832)
print v(xbgr.mr_n68260944)
print v(xbgr.mr_n68261264)
print v(xbgr.mr_n68261808)
print v(xbgr.mr_n68262128)
print v(xbgr.mr_n68263424)
print v(xbgr.mr_n68264288)
print v(xbgr.mr_n68264832)
print v(xbgr.mr_n68265264)
print v(xbgr.mr_n68266016)
print v(xbgr.mr_n68266128)
print v(xbgr.mr_n68266448)
print v(xbgr.mr_n68266560)
print v(xbgr.mr_n68266880)
print v(xbgr.mr_n68266992)
print v(xbgr.mr_n68267312)
print v(xbgr.mr_n68267424)
print v(xbgr.mr_n68267744)
print v(xbgr.mr_n68267856)
print v(xbgr.mr_n68268176)
print v(xbgr.mr_n68268288)
print v(xbgr.mr_n68268720)
print v(xbgr.mr_n68269040)
print v(xbgr.mr_n68269152)
print v(xbgr.mr_n68269472)
print v(xbgr.mr_n68269584)
print v(xbgr.mr_n68269904)
print v(xbgr.mr_n68270016)
print v(xbgr.mr_n68270336)
print v(xbgr.mr_n68270448)
print v(xbgr.mr_n68270768)
print v(xbgr.mr_n68270880)
print v(xbgr.mr_n68271200)
print v(xbgr.mr_n68271312)
print v(xbgr.mr_n68271632)
print v(xbgr.mr_n68271744)
print v(xbgr.mr_n68272064)
print v(xbgr.mr_n68272176)
print v(xbgr.mr_n68272608)
print v(xbgr.mr_n68273040)
print v(xbgr.mr_n68273472)
print v(xbgr.mr_n68273792)
print v(xbgr.mr_n68273904)
print v(xbgr.mr_n68274224)
print v(xbgr.mr_n68274336)
print v(xbgr.mr_n68274656)
print v(xbgr.mr_n68274768)
print v(xbgr.mr_n68275088)
print v(xbgr.mr_n68275200)
print v(xbgr.mr_n68275520)
print v(xbgr.mr_n68275632)
print v(xbgr.mr_n68276064)
print v(xbgr.mr_n68276384)
print v(xbgr.mr_n68277248)
print v(xbgr.mr_n68278112)
print v(xbgr.mr_n68278224)
print v(xbgr.mr_n68278544)
print v(xbgr.mr_n68278656)
print v(xbgr.mr_n68278976)
print v(xbgr.mr_n68279088)
print v(xbgr.mr_n68279408)
print v(xbgr.mr_n68279520)
print v(xbgr.mr_n68279840)
print v(xbgr.mr_n68280816)
print v(xbgr.mr_n68281136)
print v(xbgr.mr_n68281248)
print v(xbgr.mr_n68281568)
print v(xbgr.mr_n68281680)
print v(xbgr.mr_n68282000)
print v(xbgr.mr_n68282112)
print v(xbgr.mr_n68282432)
print v(xbgr.mr_n68282544)
print v(xbgr.mr_n68282864)
print v(xbgr.mr_n68282976)
print v(xbgr.mr_n68283296)
print v(xbgr.mr_n68284160)
print v(xbgr.mr_n68285024)
print v(xbgr.mr_n68285888)
print v(xbgr.mr_n68286752)
print v(xbgr.mr_n68286864)
print v(xbgr.mr_n68287184)
print v(xbgr.mr_n68287296)
print v(xbgr.mr_n68287616)
print v(xbgr.mr_n68288592)
print v(xbgr.mr_n68289024)
print v(xbgr.mr_n68289344)
print v(xbgr.mr_n68290208)
print v(xbgr.mr_n68291072)
print v(xbgr.mr_n68291936)
print v(xbgr.mr_n68292800)
print v(xbgr.mr_n68292912)
print v(xbgr.mr_n68293344)
print v(xbgr.mr_n68293664)
print v(xbgr.mr_n68293776)
print v(xbgr.mr_n68294096)
print v(xbgr.mr_n68294208)
print v(xbgr.mr_n68294528)
print v(xbgr.mr_n68294640)
print v(xbgr.mr_n68295072)
print v(xbgr.mr_n68295392)
print v(xbgr.mr_n68295504)
print v(xbgr.mr_n68295936)
print v(xbgr.mr_n68296256)
print v(xbgr.mr_n68296368)
print v(xbgr.mr_n68296688)
print v(xbgr.mr_n68296800)
print v(xbgr.mr_n68297120)
print v(xbgr.mr_n68297232)
print v(xbgr.mr_n68297552)
print v(xbgr.mr_n68297664)
print v(xbgr.mr_n68297984)
print v(xbgr.mr_n68298096)
print v(xbgr.mr_n68298416)
print v(xbgr.mr_n68298528)
print v(xbgr.mr_n68298960)
print v(xbgr.mr_n68299280)
print v(xbgr.mr_n68300144)
print v(xbgr.mr_n68300688)
print v(xbgr.mr_n68301008)
print v(xbgr.mr_n68301120)
print v(xbgr.mr_n68301440)
print v(xbgr.mr_n68301552)
print v(xbgr.mr_n68301872)
print v(xbgr.mr_n68301984)
print v(xbgr.mr_n68302304)
print v(xbgr.mr_n68302416)
print v(xbgr.mr_n68302736)
print v(xbgr.mr_n68302848)
print v(xbgr.mr_n68303168)
print v(xbgr.mr_n68303280)
print v(xbgr.mr_n68303712)
print v(xbgr.mr_n68304032)
print v(xbgr.mr_n68304896)
print v(xbgr.mr_n68305328)
print v(xbgr.mr_n68306192)
print v(xbgr.mr_n68307056)
print v(xbgr.mr_n68308464)
print v(xbgr.mr_n68309328)
print v(xbgr.mr_n68309760)
print v(xbgr.mr_n68310080)
print v(xbgr.mr_n68310944)
print v(xbgr.mr_n68311056)
print v(xbgr.mr_n68311376)
print v(xbgr.mr_n68311488)
print v(xbgr.mr_n68311808)
print v(xbgr.mr_n68311920)
print v(xbgr.mr_n68312240)
print v(xbgr.mr_n68312352)
print v(xbgr.mr_n68312672)
print v(xbgr.mr_n68312784)
print v(xbgr.mr_n68313104)
print v(xbgr.mr_n68313216)
print v(xbgr.mr_n68313536)
print v(xbgr.mr_n68313648)
print v(xbgr.mr_n68313968)
print v(xbgr.mr_n68314832)
print v(xbgr.mr_n68315808)
print v(xbgr.mr_n68316240)
print v(xbgr.mr_n68316672)
print v(xbgr.mr_n68316992)
print v(xbgr.mr_n68317104)
print v(xbgr.mr_n68317424)
print v(xbgr.mr_n68317536)
print v(xbgr.mr_n68317856)
print v(xbgr.mr_n68318720)
print v(xbgr.mr_n68319584)
print v(xbgr.mr_n68320448)
print v(xbgr.mr_n68320560)
print v(xbgr.mr_n68320880)
print v(xbgr.mr_n68320992)
print v(xbgr.mr_n68321312)
print v(xbgr.mr_n68322176)
print v(xbgr.mr_n68323040)
print v(xbgr.mr_n68323904)
print v(xbgr.mr_n68324016)
print v(xbgr.mr_n68324336)
print v(xbgr.mr_n68324448)
print v(xbgr.mr_n68324768)
print v(xbgr.mr_n68324880)
print v(xbgr.mr_n68325200)
print v(xbgr.mr_n68325312)
print v(xbgr.mr_n68325632)
print v(xbgr.mr_n68326496)
print v(xbgr.mr_n68327360)
print v(xbgr.mr_n68327472)
print v(xbgr.mr_n68327792)
print v(xbgr.mr_n68327904)
print v(xbgr.mr_n68328224)
print v(xbgr.mr_n68328336)
print v(xbgr.mr_n68328656)
print v(xbgr.mr_n68328768)
print v(xbgr.mr_n68329088)
print v(xbgr.mr_n68329200)
print v(xbgr.mr_n68329632)
print v(xbgr.mr_n68329952)
print v(xbgr.mr_n68330064)
print v(xbgr.mr_n68330384)
print v(xbgr.mr_n68330496)
print v(xbgr.mr_n68330816)
print v(xbgr.mr_n68330928)
print v(xbgr.mr_n68331248)
print v(xbgr.mr_n68331360)
print v(xbgr.mr_n68331680)
print v(xbgr.mr_n68332544)
print v(xbgr.mr_n68332656)
print v(xbgr.mr_n68333088)
print v(xbgr.mr_n68333408)
print v(xbgr.mr_n68333520)
print v(xbgr.mr_n68333840)
print v(xbgr.mr_n68333952)
print v(xbgr.mr_n68334272)
print v(xbgr.mr_n68334384)
print v(xbgr.mr_n68334704)
print v(xbgr.mr_n68334816)
print v(xbgr.mr_n68335136)
print v(xbgr.mr_n68335248)
print v(xbgr.mr_n68335568)
print v(xbgr.mr_n68335680)
print v(xbgr.mr_n68336000)
print v(xbgr.mr_n68336432)
print v(xbgr.mr_n68336544)
print v(xbgr.mr_n68336864)
print v(xbgr.mr_n68337408)
print v(xbgr.mr_n68337728)
print v(xbgr.mr_n68337840)
print v(xbgr.mr_n68338272)
print v(xbgr.mr_n68338704)
print v(xbgr.mr_n68339136)
print v(xbgr.mr_n68339568)
print v(xbgr.mr_n68340000)
print v(xbgr.mr_n68340320)
print v(xbgr.mr_n68340432)
print v(xbgr.mr_n68340864)
print v(xbgr.mr_n68341184)
print v(xbgr.mr_n68341296)
print v(xbgr.mr_n68341728)
print v(xbgr.mr_n68342048)
print v(xbgr.mr_n68342912)
print v(xbgr.mr_n68344208)
print v(xbgr.mr_n68344752)
print v(xbgr.mr_n68345072)
print v(xbgr.mr_n68345616)
print v(xbgr.mr_n68345936)
print v(xbgr.mr_n68346048)
print v(xbgr.mr_n68346800)
print v(xbgr.mr_n68347232)
print v(xbgr.mr_n68348096)
print v(xbgr.mr_n68348960)
print v(xbgr.mr_n68350256)
print v(xbgr.mr_n68351120)
print v(xbgr.mr_n68351552)
print v(xbgr.mr_n68351664)
print v(xbgr.mr_n68352416)
print v(xbgr.mr_n68352528)
print v(xbgr.mr_n68352848)
print v(xbgr.mr_n68352960)
print v(xbgr.mr_n68353280)
print v(xbgr.mr_n68353392)
print v(xbgr.mr_n68354144)
print v(xbgr.mr_n68355440)
print v(xbgr.mr_n68356304)
print v(xbgr.mr_n68357168)
print v(xbgr.mr_n68357600)
print v(xbgr.mr_n68357712)
print v(xbgr.mr_n68358032)
print v(xbgr.mr_n68358144)
print v(xbgr.mr_n68358464)
print v(xbgr.mr_n68358576)
print v(xbgr.mr_n68358896)
print v(xbgr.mr_n68359008)
print v(xbgr.mr_n68359760)
print v(xbgr.mr_n68359872)
print v(xbgr.mr_n68360192)
print v(xbgr.mr_n68360304)
print v(xbgr.mr_n68360624)
print v(xbgr.mr_n68360736)
print v(xbgr.mr_n68361056)
print v(xbgr.mr_n68361920)
print v(xbgr.mr_n68362032)
print v(xbgr.mr_n68362352)
print v(xbgr.mr_n68362464)
print v(xbgr.mr_n68362896)
print v(xbgr.mr_n68363216)
print v(xbgr.mr_n68363328)
print v(xbgr.mr_n68363648)
print v(xbgr.mr_n68363760)
print v(xbgr.mr_n68364080)
print v(xbgr.mr_n68364192)
print v(xbgr.mr_n68364624)
print v(xbgr.mr_n68365056)
print v(xbgr.mr_n68365376)
print v(xbgr.mr_n68365488)
print v(xbgr.mr_n68365808)
print v(xbgr.mr_n68365920)
print v(xbgr.mr_n68366240)
print v(xbgr.mr_n68366352)
print v(xbgr.mr_n68366784)
print v(xbgr.mr_n68367104)
print v(xbgr.mr_n68367216)
print v(xbgr.mr_n68367648)
print v(xbgr.mr_n68367968)
print v(xbgr.mr_n68368080)
print v(xbgr.mr_n68368400)
print v(xbgr.mr_n68368512)
print v(xbgr.mr_n68368832)
print v(xbgr.mr_n68368944)
print v(xbgr.mr_n68369264)
print v(xbgr.mr_n68369376)
print v(xbgr.mr_n68369696)
print v(xbgr.mr_n68370560)
print v(xbgr.mr_n68371424)
print v(xbgr.mr_n68371536)
print v(xbgr.mr_n68371856)
print v(xbgr.mr_n68372400)
print v(xbgr.mr_n68372720)
print v(xbgr.mr_n68373152)
print v(xbgr.mr_n68374448)
print v(xbgr.mr_n68375744)
print v(xbgr.mr_n68375856)
print v(xbgr.mr_n68376176)
print v(xbgr.mr_n68376288)
print v(xbgr.mr_n68376608)
print v(xbgr.mr_n68376720)
print v(xbgr.mr_n68377040)
print v(xbgr.mr_n68377152)
print v(xbgr.mr_n68377472)
print v(xbgr.mr_n68377584)
print v(xbgr.mr_n68377904)
print v(xbgr.mr_n68378016)
print v(xbgr.mr_n68378336)
print v(xbgr.mr_n68378448)
print v(xbgr.mr_n68378880)
print v(xbgr.mr_n68379200)
print v(xbgr.mr_n68380064)
print v(xbgr.mr_n68380176)
print v(xbgr.mr_n68380496)
print v(xbgr.mr_n68380608)
print v(xbgr.mr_n68380928)
print v(xbgr.mr_n68381040)
print v(xbgr.mr_n68381360)
print v(xbgr.mr_n68381472)
print v(xbgr.mr_n68381792)
print v(xbgr.mr_n68382656)
print v(xbgr.mr_n68383520)
print v(xbgr.mr_n68384384)
print v(xbgr.mr_n68385248)
print v(xbgr.mr_n68386112)
print v(xbgr.mr_n68386224)
print v(xbgr.mr_n68386544)
print v(xbgr.mr_n68386656)
print v(xbgr.mr_n68386976)
print v(xbgr.mr_n68387088)
print v(xbgr.mr_n68387408)
print v(xbgr.mr_n68387520)
print v(xbgr.mr_n68387840)
print v(xbgr.mr_n68387952)
print v(xbgr.mr_n68388272)
print v(xbgr.mr_n68388384)
print v(xbgr.mr_n68388704)
print v(xbgr.mr_n68388816)
print v(xbgr.mr_n68389136)
print v(xbgr.mr_n68389248)
print v(xbgr.mr_n68389568)
print v(xbgr.mr_n68389680)
print v(xbgr.mr_n68390000)
print v(xbgr.mr_n68390112)
print v(xbgr.mr_n68390544)
print v(xbgr.mr_n68390864)
print v(xbgr.mr_n68390976)
print v(xbgr.mr_n68391296)
print v(xbgr.mr_n68391408)
print v(xbgr.mr_n68391840)
print v(xbgr.mr_n68392160)
print v(xbgr.mr_n68392272)
print v(xbgr.mr_n68392704)
print v(xbgr.mr_n68393024)
print v(xbgr.mr_n68393136)
print v(xbgr.mr_n68393568)
print v(xbgr.mr_n68394000)
print v(xbgr.mr_n68394320)
print v(xbgr.mr_n68394432)
print v(xbgr.mr_n68394864)
print v(xbgr.mr_n68395184)
print v(xbgr.mr_n68395296)
print v(xbgr.mr_n68395616)
print v(xbgr.mr_n68395728)
print v(xbgr.mr_n68396048)
print v(xbgr.mr_n68396160)
print v(xbgr.mr_n68396480)
print v(xbgr.mr_n68396592)
print v(xbgr.mr_n68396912)
print v(xbgr.mr_n68397024)
print v(xbgr.mr_n68397344)
print v(xbgr.mr_n68397456)
print v(xbgr.mr_n68397776)
print v(xbgr.mr_n68397888)
print v(xbgr.mr_n68398208)
print v(xbgr.mr_n68398320)
print v(xbgr.mr_n68398640)
print v(xbgr.mr_n68399504)
print v(xbgr.mr_n68399616)
print v(xbgr.mr_n68399936)
print v(xbgr.mr_n68400048)
print v(xbgr.mr_n68400368)
print v(xbgr.mr_n68401232)
print v(xbgr.mr_n68402096)
print v(xbgr.mr_n68402960)
print v(xbgr.mr_n68403824)
print v(xbgr.mr_n68404688)
print v(xbgr.mr_n68404800)
print v(xbgr.mr_n68405120)
print v(xbgr.mr_n68405232)
print v(xbgr.mr_n68405552)
print v(xbgr.mr_n68405664)
print v(xbgr.mr_n68405984)
print v(xbgr.mr_n68406848)
print v(xbgr.mr_n68407712)
print v(xbgr.mr_n68408576)
print v(xbgr.mr_n68409440)
print v(xbgr.mr_n68410304)
print v(xbgr.mr_n68411168)
print v(xbgr.mr_n68412032)
print v(xbgr.mr_n68412144)
print v(xbgr.mr_n68412464)
print v(xbgr.mr_n68412576)
print v(xbgr.mr_n68413008)
print v(xbgr.mr_n68413328)
print v(xbgr.mr_n68414192)
print v(xbgr.mr_n68414736)
print v(xbgr.mr_n68415168)
print v(xbgr.mr_n68415600)
print v(xbgr.mr_n68416352)
print v(xbgr.mr_n68417216)
print v(xbgr.mr_n68418080)
print v(xbgr.mr_n68418192)
print v(xbgr.mr_n68418512)
print v(xbgr.mr_n68418624)
print v(xbgr.mr_n68419056)
print v(xbgr.mr_n68419488)
print v(xbgr.mr_n68419808)
print v(xbgr.mr_n68420672)
print v(xbgr.mr_n68420784)
print v(xbgr.mr_n68421216)
print v(xbgr.mr_n68421536)
print v(xbgr.mr_n68421648)
print v(xbgr.mr_n68422080)
print v(xbgr.mr_n68422400)
print v(xbgr.mr_n68423264)
print v(xbgr.mr_n68423376)
print v(xbgr.mr_n68423696)
print v(xbgr.mr_n68424560)
print v(xbgr.mr_n68425424)
print v(xbgr.mr_n68425536)
print v(xbgr.mr_n68425856)
print v(xbgr.mr_n68425968)
print v(xbgr.mr_n68426288)
print v(xbgr.mr_n68427152)
print v(xbgr.mr_n68427584)
print v(xbgr.mr_n68427696)
print v(xbgr.mr_n68428128)
print v(xbgr.mr_n68428448)
print v(xbgr.mr_n68428560)
print v(xbgr.mr_n68428992)
print v(xbgr.mr_n68429744)
print v(xbgr.mr_n68429856)
print v(xbgr.mr_n68430176)
print v(xbgr.mr_n68430288)
print v(xbgr.mr_n68430608)
print v(xbgr.mr_n68430720)
print v(xbgr.mr_n68431040)
print v(xbgr.mr_n68431472)
print v(xbgr.mr_n68431584)
print v(xbgr.mr_n68432336)
print v(xbgr.mr_n68432768)
print v(xbgr.mr_n68432880)
print v(xbgr.mr_n68433744)
print v(xbgr.mr_n68434064)
print v(xbgr.mr_n68434176)
print v(xbgr.mr_n68434496)
print v(xbgr.mr_n68435360)
print v(xbgr.mr_n68436224)
print v(xbgr.mr_n68437088)
print v(xbgr.mr_n68437952)
print v(xbgr.mr_n68438064)
print v(xbgr.mr_n68438384)
print v(xbgr.mr_n68438496)
print v(xbgr.mr_n68438816)
print v(xbgr.mr_n68438928)
print v(xbgr.mr_n68439248)
print v(xbgr.mr_n68439360)
print v(xbgr.mr_n68439680)
print v(xbgr.mr_n68439792)
print v(xbgr.mr_n68440112)
print v(xbgr.mr_n68440224)
print v(xbgr.mr_n68440544)
print v(xbgr.mr_n68440656)
print v(xbgr.mr_n68440976)
print v(xbgr.mr_n68441088)
print v(xbgr.mr_n68441408)
print v(xbgr.mr_n68441520)
print v(xbgr.mr_n68441840)
print v(xbgr.mr_n68441952)
print v(xbgr.mr_n68442384)
print v(xbgr.mr_n68442816)
print v(xbgr.mr_n68443248)
print v(xbgr.mr_n68443568)
print v(xbgr.mr_n68443680)
print v(xbgr.mr_n68444000)
print v(xbgr.mr_n68444864)
print v(xbgr.mr_n68444976)
print v(xbgr.mr_n68445296)
print v(xbgr.mr_n68445408)
print v(xbgr.mr_n68445728)
print v(xbgr.mr_n68445840)
print v(xbgr.mr_n68446272)
print v(xbgr.mr_n68446592)
print v(xbgr.mr_n68446704)
print v(xbgr.mr_n68447024)
print v(xbgr.mr_n68447136)
print v(xbgr.mr_n68447568)
print v(xbgr.mr_n68447888)
print v(xbgr.mr_n68448320)
print v(xbgr.mr_n68448432)
print v(xbgr.mr_n68448752)
print v(xbgr.mr_n68448864)
print v(xbgr.mr_n68449184)
print v(xbgr.mr_n68449296)
print v(xbgr.mr_n68449616)
print v(xbgr.mr_n68449728)
print v(xbgr.mr_n68450160)
print v(xbgr.mr_n68450480)
print v(xbgr.mr_n68450592)
print v(xbgr.mr_n68450912)
print v(xbgr.mr_n68451024)
print v(xbgr.mr_n68451344)
print v(xbgr.mr_n68451456)
print v(xbgr.mr_n68451776)
print v(xbgr.mr_n68451888)
print v(xbgr.mr_n68452208)
print v(xbgr.mr_n68452320)
print v(xbgr.mr_n68452640)
print v(xbgr.mr_n68452752)
print v(xbgr.mr_n68453072)
print v(xbgr.mr_n68453184)
print v(xbgr.mr_n68453936)
print v(xbgr.mr_n68454368)
print v(xbgr.mr_n68455232)
print v(xbgr.mr_n68455344)
print v(xbgr.mr_n68455664)
print v(xbgr.mr_n68456208)
print v(xbgr.mr_n68456640)
print v(xbgr.mr_n68457072)
print v(xbgr.mr_n68457392)
print v(xbgr.mr_n68457824)
print v(xbgr.mr_n68458688)
print v(xbgr.mr_n68460848)
print v(xbgr.mr_n68461712)
print v(xbgr.mr_n68461824)
print v(xbgr.mr_n68462144)
print v(xbgr.mr_n68463008)
print v(xbgr.mr_n68463872)
print v(xbgr.mr_n68463984)
print v(xbgr.mr_n68464304)
print v(xbgr.mr_n68464416)
print v(xbgr.mr_n68464736)
print v(xbgr.mr_n68464848)
print v(xbgr.mr_n68465168)
print v(xbgr.mr_n68465280)
print v(xbgr.mr_n68465600)
print v(xbgr.mr_n68466464)
print v(xbgr.mr_n68467328)
print v(xbgr.mr_n68467440)
print v(xbgr.mr_n68467760)
print v(xbgr.mr_n68467872)
print v(xbgr.mr_n68468192)
print v(xbgr.mr_n68468304)
print v(xbgr.mr_n68468624)
print v(xbgr.mr_n68468736)
print v(xbgr.mr_n68469056)
print v(xbgr.mr_n68469168)
print v(xbgr.mr_n68469488)
print v(xbgr.mr_n68469600)
print v(xbgr.mr_n68469920)
print v(xbgr.mr_n68470032)
print v(xbgr.mr_n68470464)
print v(xbgr.mr_n68470784)
print v(xbgr.mr_n68470896)
print v(xbgr.mr_n68471328)
print v(xbgr.mr_n68471648)
print v(xbgr.mr_n68472192)
print v(xbgr.mr_n68473056)
print v(xbgr.mr_n68473376)
print v(xbgr.mr_n68473488)
print v(xbgr.mr_n68474672)
print v(xbgr.mr_n68474784)
print v(xbgr.mr_n68475104)
print v(xbgr.mr_n68475216)
print v(xbgr.mr_n68475536)
print v(xbgr.mr_n68475648)
print v(xbgr.mr_n68475968)
print v(xbgr.mr_n68476080)
print v(xbgr.mr_n68476400)
print v(xbgr.mr_n68477264)
print v(xbgr.mr_n68478128)
print v(xbgr.mr_n68478240)
print v(xbgr.mr_n68478672)
print v(xbgr.mr_n68479104)
print v(xbgr.mr_n68479536)
print v(xbgr.mr_n68479856)
print v(xbgr.mr_n68479968)
print v(xbgr.mr_n68480288)
print v(xbgr.mr_n68480400)
print v(xbgr.mr_n68480720)
print v(xbgr.mr_n68480832)
print v(xbgr.mr_n68481152)
print v(xbgr.mr_n68481264)
print v(xbgr.mr_n68481584)
print v(xbgr.mr_n68481696)
print v(xbgr.mr_n68482016)
print v(xbgr.mr_n68482128)
print v(xbgr.mr_n68482448)
print v(xbgr.mr_n68483312)
print v(xbgr.mr_n68483424)
print v(xbgr.mr_n68483744)
print v(xbgr.mr_n68483856)
print v(xbgr.mr_n68484176)
print v(xbgr.mr_n68484288)
print v(xbgr.mr_n68484608)
print v(xbgr.mr_n68484720)
print v(xbgr.mr_n68485040)
print v(xbgr.mr_n68485584)
print v(xbgr.mr_n68486336)
print v(xbgr.mr_n68487200)
print v(xbgr.mr_n68488064)
print v(xbgr.mr_n68488928)
print v(xbgr.mr_n68489792)
print v(xbgr.mr_n68490656)
print v(xbgr.mr_n68490768)
print v(xbgr.mr_n68491088)
print v(xbgr.mr_n68491200)
print v(xbgr.mr_n68491520)
print v(xbgr.mr_n68491632)
print v(xbgr.mr_n68491952)
print v(xbgr.mr_n68492064)
print v(xbgr.mr_n68492384)
print v(xbgr.mr_n68492496)
print v(xbgr.mr_n68492816)
print v(xbgr.mr_n68492928)
print v(xbgr.mr_n68493248)
print v(xbgr.mr_n68494112)
print v(xbgr.mr_n68494976)
print v(xbgr.mr_n68495840)
print v(xbgr.mr_n68496704)
print v(xbgr.mr_n68497568)
print v(xbgr.mr_n68498432)
print v(xbgr.mr_n68499296)
print v(xbgr.mr_n68499408)
print v(xbgr.mr_n68499728)
print v(xbgr.mr_n68499840)
print v(xbgr.mr_n68500160)
print v(xbgr.mr_n68500272)
print v(xbgr.mr_n68500592)
print v(xbgr.mr_n68500704)
print v(xbgr.mr_n68501024)
print v(xbgr.mr_n68501136)
print v(xbgr.mr_n68501456)
print v(xbgr.mr_n68501568)
print v(xbgr.mr_n68501888)
print v(xbgr.mr_n68502000)
print v(xbgr.mr_n68502432)
print v(xbgr.mr_n68502752)
print v(xbgr.mr_n68502864)
print v(xbgr.mr_n68503296)
print v(xbgr.mr_n68503616)
print v(xbgr.mr_n68503728)
print v(xbgr.mr_n68504160)
print v(xbgr.mr_n68504480)
print v(xbgr.mr_n68505344)
print v(xbgr.mr_n68506208)
print v(xbgr.mr_n68507072)
print v(xbgr.mr_n68507936)
print v(xbgr.mr_n68508800)
print v(xbgr.mr_n68509664)
print v(xbgr.mr_n68509776)
print v(xbgr.mr_n68510096)
print v(xbgr.mr_n68510208)
print v(xbgr.mr_n68510528)
print v(xbgr.mr_n68510640)
print v(xbgr.mr_n68510960)
print v(xbgr.mr_n68511072)
print v(xbgr.mr_n68511392)
print v(xbgr.mr_n68512256)
print v(xbgr.mr_n68513120)
print v(xbgr.mr_n68513984)
print v(xbgr.mr_n68514096)
print v(xbgr.mr_n68514528)
print v(xbgr.mr_n68514848)
print v(xbgr.mr_n68514960)
print v(xbgr.mr_n68515280)
print v(xbgr.mr_n68515392)
print v(xbgr.mr_n68515712)
print v(xbgr.mr_n68515824)
print v(xbgr.mr_n68516144)
print v(xbgr.mr_n68516256)
print v(xbgr.mr_n68516576)
print v(xbgr.mr_n68516688)
print v(xbgr.mr_n68517120)
print v(xbgr.mr_n68517440)
print v(xbgr.mr_n68517552)
print v(xbgr.mr_n68517984)
print v(xbgr.mr_n68518304)
print v(xbgr.mr_n68518416)
print v(xbgr.mr_n68518736)
print v(xbgr.mr_n68518848)
print v(xbgr.mr_n68519280)
print v(xbgr.mr_n68519712)
print v(xbgr.mr_n68520032)
print v(xbgr.mr_n68520144)
print v(xbgr.mr_n68520576)
print v(xbgr.mr_n68520896)
print v(xbgr.mr_n68521008)
print v(xbgr.mr_n68521440)
print v(xbgr.mr_n68521760)
print v(xbgr.mr_n68522624)
print v(xbgr.mr_n68523488)
print v(xbgr.mr_n68524352)
print v(xbgr.mr_n68525216)
print v(xbgr.mr_n68525328)
print v(xbgr.mr_n68525648)
print v(xbgr.mr_n68525760)
print v(xbgr.mr_n68526080)
print v(xbgr.mr_n68526192)
print v(xbgr.mr_n68526512)
print v(xbgr.mr_n68526624)
print v(xbgr.mr_n68526944)
print v(xbgr.mr_n68527808)
print v(xbgr.mr_n68528672)
print v(xbgr.mr_n68529536)
print v(xbgr.mr_n68530400)
print v(xbgr.mr_n68531264)
print v(xbgr.mr_n68532128)
print v(xbgr.mr_n68532992)
print v(xbgr.mr_n68533856)
print v(xbgr.mr_n68533968)
print v(xbgr.mr_n68534288)
print v(xbgr.mr_n68534400)
print v(xbgr.mr_n68534720)
print v(xbgr.mr_n68534832)
print v(xbgr.mr_n68535152)
print v(xbgr.mr_n68535264)
print v(xbgr.mr_n68535584)
print v(xbgr.mr_n68535696)
print v(xbgr.mr_n68536016)
print v(xbgr.mr_n68536128)
print v(xbgr.mr_n68536448)
print v(xbgr.mr_n68536560)
print v(xbgr.mr_n68536880)
print v(xbgr.mr_n68536992)
print v(xbgr.mr_n68537312)
print v(xbgr.mr_n68537424)
print v(xbgr.mr_n68537744)
print v(xbgr.mr_n68537856)
print v(xbgr.mr_n68538288)
print v(xbgr.mr_n68538608)
print v(xbgr.mr_n68538720)
print v(xbgr.mr_n68539040)
print v(xbgr.mr_n68539152)
print v(xbgr.mr_n68539472)
print v(xbgr.mr_n68539584)
print v(xbgr.mr_n68539904)
print v(xbgr.mr_n68540016)
print v(xbgr.mr_n68540336)
print v(xbgr.mr_n68540448)
print v(xbgr.mr_n68540880)
print v(xbgr.mr_n68541200)
print v(xbgr.mr_n68541312)
print v(xbgr.mr_n68541744)
print v(xbgr.mr_n68542064)
print v(xbgr.mr_n68542176)
print v(xbgr.mr_n68542496)
print v(xbgr.mr_n68543360)
print v(xbgr.mr_n68544224)
print v(xbgr.mr_n68544768)
print v(xbgr.mr_n68545520)
print v(xbgr.mr_n68545952)
print v(xbgr.mr_n68546064)
print v(xbgr.mr_n68546816)
print v(xbgr.mr_n68546928)
print v(xbgr.mr_n68547360)
print v(xbgr.mr_n68547792)
print v(xbgr.mr_n68548112)
print v(xbgr.mr_n68548976)
print v(xbgr.mr_n68549408)
print v(xbgr.mr_n68550272)
print v(xbgr.mr_n68550384)
print v(xbgr.mr_n68551136)
print v(xbgr.mr_n68552432)
print v(xbgr.mr_n68553296)
print v(xbgr.mr_n68553408)
print v(xbgr.mr_n68553728)
print v(xbgr.mr_n68553840)
print v(xbgr.mr_n68554160)
print v(xbgr.mr_n68554272)
print v(xbgr.mr_n68554592)
print v(xbgr.mr_n68554704)
print v(xbgr.mr_n68555024)
print v(xbgr.mr_n68555888)
print v(xbgr.mr_n68556752)
print v(xbgr.mr_n68557616)
print v(xbgr.mr_n68557728)
print v(xbgr.mr_n68558048)
print v(xbgr.mr_n68558160)
print v(xbgr.mr_n68558480)
print v(xbgr.mr_n68559344)
print v(xbgr.mr_n68559456)
print v(xbgr.mr_n68559776)
print v(xbgr.mr_n68559888)
print v(xbgr.mr_n68560208)
print v(xbgr.mr_n68560320)
print v(xbgr.mr_n68560640)
print v(xbgr.mr_n68560752)
print v(xbgr.mr_n68561072)
print v(xbgr.mr_n68561936)
print v(xbgr.mr_n68562800)
print v(xbgr.mr_n68562912)
print v(xbgr.mr_n68563232)
print v(xbgr.mr_n68563344)
print v(xbgr.mr_n68563664)
print v(xbgr.mr_n68563776)
print v(xbgr.mr_n68564096)
print v(xbgr.mr_n68564208)
print v(xbgr.mr_n68564528)
print v(xbgr.mr_n68564640)
print v(xbgr.mr_n68564960)
print v(xbgr.mr_n68565072)
print v(xbgr.mr_n68565824)
print v(xbgr.mr_n68566688)
print v(xbgr.mr_n68567552)
print v(xbgr.mr_n68567664)
print v(xbgr.mr_n68567984)
print v(xbgr.mr_n68568096)
print v(xbgr.mr_n68568416)
print v(xbgr.mr_n68568528)
print v(xbgr.mr_n68568848)
print v(xbgr.mr_n68568960)
print v(xbgr.mr_n68569392)
print v(xbgr.mr_n68569712)
print v(xbgr.mr_n68569824)
print v(xbgr.mr_n68570576)
print v(xbgr.mr_n68571440)
print v(xbgr.mr_n68572304)
print v(xbgr.mr_n68573168)
print v(xbgr.mr_n68573280)
print v(xbgr.mr_n68573600)
print v(xbgr.mr_n68573712)
print v(xbgr.mr_n68574032)
print v(xbgr.mr_n68574144)
print v(xbgr.mr_n68574464)
print v(xbgr.mr_n68574576)
print v(xbgr.mr_n68574896)
print v(xbgr.mr_n68575760)
print v(xbgr.mr_n68577056)
print v(xbgr.mr_n68577168)
print v(xbgr.mr_n68577488)
print v(xbgr.mr_n68577600)
print v(xbgr.mr_n68578032)
print v(xbgr.mr_n68578352)
print v(xbgr.mr_n68578464)
print v(xbgr.mr_n68578896)
print v(xbgr.mr_n68579216)
print v(xbgr.mr_n68579648)
print v(xbgr.mr_n68580512)
print v(xbgr.mr_n68581376)
print v(xbgr.mr_n68581488)
print v(xbgr.mr_n68581808)
print v(xbgr.mr_n68581920)
print v(xbgr.mr_n68582352)
print v(xbgr.mr_n68582672)
print v(xbgr.mr_n68582784)
print v(xbgr.mr_n68583104)
print v(xbgr.mr_n68583216)
print v(xbgr.mr_n68583536)
print v(xbgr.mr_n68583648)
print v(xbgr.mr_n68583968)
print v(xbgr.mr_n68584080)
print v(xbgr.mr_n68584512)
print v(xbgr.mr_n68584944)
print v(xbgr.mr_n68585376)
print v(xbgr.mr_n68585808)
print v(xbgr.mr_n68586128)
print v(xbgr.mr_n68586240)
print v(xbgr.mr_n68586672)
print v(xbgr.mr_n68586992)
print v(xbgr.mr_n68587856)
print v(xbgr.mr_n68588720)
print v(xbgr.mr_n68589152)
print v(xbgr.mr_n68590016)
print v(xbgr.mr_n68590448)
print v(xbgr.mr_n68590560)
print v(xbgr.mr_n68591312)
print v(xbgr.mr_n68592176)
print v(xbgr.mr_n68593040)
print v(xbgr.mr_n68593152)
print v(xbgr.mr_n68593584)
print v(xbgr.mr_n68593904)
print v(xbgr.mr_n68594768)
print v(xbgr.mr_n68594880)
print v(xbgr.mr_n68595200)
print v(xbgr.mr_n68595312)
print v(xbgr.mr_n68595632)
print v(xbgr.mr_n68595744)
print v(xbgr.mr_n68596064)
print v(xbgr.mr_n68596176)
print v(xbgr.mr_n68596496)
print v(xbgr.mr_n68596608)
print v(xbgr.mr_n68596928)
print v(xbgr.mr_n68597040)
print v(xbgr.mr_n68597360)
print v(xbgr.mr_n68597472)
print v(xbgr.mr_n68597792)
print v(xbgr.mr_n68597904)
print v(xbgr.mr_n68598224)
print v(xbgr.mr_n68598336)
print v(xbgr.mr_n68598656)
print v(xbgr.mr_n68598768)
print v(xbgr.mr_n68599520)
print v(xbgr.mr_n68600816)
print v(xbgr.mr_n68601680)
print v(xbgr.mr_n68602976)
print v(xbgr.mr_n68603088)
print v(xbgr.mr_n68603408)
print v(xbgr.mr_n68603520)
print v(xbgr.mr_n68603840)
print v(xbgr.mr_n68603952)
print v(xbgr.mr_n68604272)
print v(xbgr.mr_n68604384)
print v(xbgr.mr_n68605136)
print v(xbgr.mr_n68606000)
print v(xbgr.mr_n68606864)
print v(xbgr.mr_n68607728)
print v(xbgr.mr_n68607840)
print v(xbgr.mr_n68608160)
print v(xbgr.mr_n68608272)
print v(xbgr.mr_n68608592)
print v(xbgr.mr_n68608704)
print v(xbgr.mr_n68609024)
print v(xbgr.mr_n68609136)
print v(xbgr.mr_n68609456)
print v(xbgr.mr_n68609568)
print v(xbgr.mr_n68609888)
print v(xbgr.mr_n68610432)
print v(xbgr.mr_n68611184)
print v(xbgr.mr_n68612048)
print v(xbgr.mr_n68612160)
print v(xbgr.mr_n68612480)
print v(xbgr.mr_n68612592)
print v(xbgr.mr_n68613024)
print v(xbgr.mr_n68613344)
print v(xbgr.mr_n68613456)
print v(xbgr.mr_n68613776)
print v(xbgr.mr_n68613888)
print v(xbgr.mr_n68614208)
print v(xbgr.mr_n68614320)
print v(xbgr.mr_n68614640)
print v(xbgr.mr_n68614752)
print v(xbgr.mr_n68615072)
print v(xbgr.mr_n68615504)
print v(xbgr.mr_n68615616)
print v(xbgr.mr_n68615936)
print v(xbgr.mr_n68616048)
print v(xbgr.mr_n68616800)
print v(xbgr.mr_n68616912)
print v(xbgr.mr_n68617232)
print v(xbgr.mr_n68617344)
print v(xbgr.mr_n68618096)
print v(xbgr.mr_n68618960)
print v(xbgr.mr_n68619072)
print v(xbgr.mr_n68619392)
print v(xbgr.mr_n68620256)
print v(xbgr.mr_n68620800)
print v(xbgr.mr_n68621120)
print v(xbgr.mr_n68621664)
print v(xbgr.mr_n68622096)
print v(xbgr.mr_n68622416)
print v(xbgr.mr_n68622528)
print v(xbgr.mr_n68623280)
print v(xbgr.mr_n68623392)
print v(xbgr.mr_n68623712)
print v(xbgr.mr_n68623824)
print v(xbgr.mr_n68624144)
print v(xbgr.mr_n68625008)
print v(xbgr.mr_n68625440)
print v(xbgr.mr_n68625552)
print v(xbgr.mr_n68625872)
print v(xbgr.mr_n68625984)
print v(xbgr.mr_n68626304)
print v(xbgr.mr_n68626416)
print v(xbgr.mr_n68626736)
print v(xbgr.mr_n68626848)
print v(xbgr.mr_n68627168)
print v(xbgr.mr_n68627280)
print v(xbgr.mr_n68628464)
print v(xbgr.mr_n68628576)
print v(xbgr.mr_n68628896)
print v(xbgr.mr_n68629008)
print v(xbgr.mr_n68629328)
print v(xbgr.mr_n68629440)
print v(xbgr.mr_n68629760)
print v(xbgr.mr_n68630192)
print v(xbgr.mr_n68762576)
print v(xbgr.mr_n68762688)
print v(xbgr.mr_n68763008)
print v(xbgr.mr_n68763120)
print v(xbgr.mr_n68763440)
print v(xbgr.mr_n68763552)
print v(xbgr.mr_n68763872)
print v(xbgr.mr_n68763984)
print v(xbgr.mr_n68764304)
print v(xbgr.mr_n68764416)
print v(xbgr.mr_n68764736)
print v(xbgr.mr_n68764848)
print v(xbgr.mr_n68765168)
print v(xbgr.mr_n68765280)
print v(xbgr.mr_n68765600)
print v(xbgr.mr_n68765712)
print v(xbgr.mr_n68766032)
print v(xbgr.mr_n68766144)
print v(xbgr.mr_n68766464)
print v(xbgr.mr_n68766576)
print v(xbgr.mr_n68766896)
print v(xbgr.mr_n68767008)
print v(xbgr.mr_n68767328)
print v(xbgr.mr_n68767440)
print v(xbgr.mr_n68767760)
print v(xbgr.mr_n68767872)
print v(xbgr.mr_n68768192)
print v(xbgr.mr_n68768304)
print v(xbgr.mr_n68768624)
print v(xbgr.mr_n68768736)
print v(xbgr.mr_n68769056)
print v(xbgr.mr_n68769168)
print v(xbgr.mr_n68769488)
print v(xbgr.mr_n68769600)
print v(xbgr.mr_n68769920)
print v(xbgr.mr_n68770032)
print v(xbgr.mr_n68770352)
print v(xbgr.mr_n68770464)
print v(xbgr.mr_n68770784)
print v(xbgr.mr_n68770896)
print v(xbgr.mr_n68771216)
print v(xbgr.mr_n68771328)
print v(xbgr.mr_n68771648)
print v(xbgr.mr_n68771760)
print v(xbgr.mr_n68772080)
print v(xbgr.mr_n68772192)
print v(xbgr.mr_n68772512)
print v(xbgr.mr_n68772624)
print v(xbgr.mr_n68772944)
print v(xbgr.mr_n68773056)
print v(xbgr.mr_n68773376)
print v(xbgr.mr_n68773488)
print v(xbgr.mr_n68773808)
print v(xbgr.mr_n68773920)
print v(xbgr.mr_n68774240)
print v(xbgr.mr_n68774352)
print v(xbgr.mr_n68774672)
print v(xbgr.mr_n68774784)
print v(xbgr.mr_n68775104)
print v(xbgr.mr_n68775216)
print v(xbgr.mr_n68775536)
print v(xbgr.mr_n68775648)
print v(xbgr.mr_n68775968)
print v(xbgr.mr_n68776080)
print v(xbgr.mr_n68776400)
print v(xbgr.mr_n68776512)
print v(xbgr.mr_n68776832)
print v(xbgr.mr_n68776944)
print v(xbgr.mr_n68777264)
print v(xbgr.mr_n68777376)
print v(xbgr.mr_n68777696)
print v(xbgr.mr_n68777808)
print v(xbgr.mr_n68778128)
print v(xbgr.mr_n68778240)
print v(xbgr.mr_n68778560)
print v(xbgr.mr_n68778672)
print v(xbgr.mr_n68778992)
print v(xbgr.mr_n68779104)
print v(xbgr.mr_n68779424)
print v(xbgr.mr_n68779536)
print v(xbgr.mr_n68779856)
print v(xbgr.mr_n68779968)
print v(xbgr.mr_n68780288)
print v(xbgr.mr_n68780400)
print v(xbgr.mr_n68780720)
print v(xbgr.mr_n68780832)
print v(xbgr.mr_n68781152)
print v(xbgr.mr_n68781264)
print v(xbgr.mr_n68781584)
print v(xbgr.mr_n68781696)
print v(xbgr.mr_n68782016)
print v(xbgr.mr_n68782128)
print v(xbgr.mr_n68782448)
print v(xbgr.mr_n68782560)
print v(xbgr.mr_n68782880)
print v(xbgr.mr_n68782992)
print v(xbgr.mr_n68783312)
print v(xbgr.mr_n68783424)
print v(xbgr.mr_n68783744)
print v(xbgr.mr_n68783856)
print v(xbgr.mr_n68784176)
print v(xbgr.mr_n68784288)
print v(xbgr.mr_n68784608)
print v(xbgr.mr_n68784720)
print v(xbgr.mr_n68785040)
print v(xbgr.mr_n68785152)
print v(xbgr.mr_n68785472)
print v(xbgr.mr_n68785584)
print v(xbgr.mr_n68785904)
print v(xbgr.mr_n68786016)
print v(xbgr.mr_n68786336)
print v(xbgr.mr_n68786448)
print v(xbgr.mr_n68786768)
print v(xbgr.mr_n68786880)
print v(xbgr.mr_n68787200)
print v(xbgr.mr_n68787312)
print v(xbgr.mr_n68787632)
print v(xbgr.mr_n68787744)
print v(xbgr.mr_n68788064)
print v(xbgr.mr_n68788176)
print v(xbgr.mr_n68788496)
print v(xbgr.mr_n68788608)
print v(xbgr.mr_n68788928)
print v(xbgr.mr_n68789040)
print v(xbgr.mr_n68789360)
print v(xbgr.mr_n68789472)
print v(xbgr.mr_n68789792)
print v(xbgr.mr_n68789904)
print v(xbgr.mr_n68790224)
print v(xbgr.mr_n68790336)
print v(xbgr.mr_n68790656)
print v(xbgr.mr_n68790768)
print v(xbgr.mr_n68791088)
print v(xbgr.mr_n68791200)
print v(xbgr.mr_n68791520)
print v(xbgr.mr_n68791632)
print v(xbgr.mr_n68791952)
print v(xbgr.mr_n68792064)
print v(xbgr.mr_n68792384)
print v(xbgr.mr_n68792496)
print v(xbgr.mr_n68792816)
print v(xbgr.mr_n68792928)
print v(xbgr.mr_n68793248)
print v(xbgr.mr_n68793360)
print v(xbgr.mr_n68793680)
print v(xbgr.mr_n68793792)
print v(xbgr.mr_n68794112)
print v(xbgr.mr_n68794224)
print v(xbgr.mr_n68794544)
print v(xbgr.mr_n68794656)
print v(xbgr.mr_n68794976)
print v(xbgr.mr_n68795088)
print v(xbgr.mr_n68795408)
print v(xbgr.mr_n68795520)
print v(xbgr.mr_n68795840)
print v(xbgr.mr_n68795952)
print v(xbgr.mr_n68796272)
print v(xbgr.mr_n68796384)
print v(xbgr.mr_n68796704)
print v(xbgr.mr_n68796816)
print v(xbgr.mr_n68797136)
print v(xbgr.mr_n68797248)
print v(xbgr.mr_n68797568)
print v(xbgr.mr_n68797680)
print v(xbgr.mr_n68798000)
print v(xbgr.mr_n68798112)
print v(xbgr.mr_n68798432)
print v(xbgr.mr_n68798544)
print v(xbgr.mr_n68798864)
print v(xbgr.mr_n68798976)
print v(xbgr.mr_n68799296)
print v(xbgr.mr_n68799408)
print v(xbgr.mr_n68799728)
print v(xbgr.mr_n68799840)
print v(xbgr.mr_n68800160)
print v(xbgr.mr_n68800272)
print v(xbgr.mr_n68800592)
print v(xbgr.mr_n68800704)
print v(xbgr.mr_n68801024)
print v(xbgr.mr_n68801136)
print v(xbgr.mr_n68801456)
print v(xbgr.mr_n68801568)
print v(xbgr.mr_n68801888)
print v(xbgr.mr_n68802000)
print v(xbgr.mr_n68802320)
print v(xbgr.mr_n68802432)
print v(xbgr.mr_n68802752)
print v(xbgr.mr_n68802864)
print v(xbgr.mr_n68803184)
print v(xbgr.mr_n68803296)
print v(xbgr.mr_n68803616)
print v(xbgr.mr_n68803728)
print v(xbgr.mr_n68804048)
print v(xbgr.mr_n68804160)
print v(xbgr.mr_n68804480)
print v(xbgr.mr_n68804592)
print v(xbgr.mr_n68804912)
print v(xbgr.mr_n68805024)
print v(xbgr.mr_n68805344)
print v(xbgr.mr_n68805456)
print v(xbgr.mr_n68805776)
print v(xbgr.mr_n68805888)
print v(xbgr.mr_n68806208)
print v(xbgr.mr_n68806320)
print v(xbgr.mr_n68806640)
print v(xbgr.mr_n68806752)
print v(xbgr.mr_n68807072)
print v(xbgr.mr_n68807184)
print v(xbgr.mr_n68807504)
print v(xbgr.mr_n68807616)
print v(xbgr.mr_n68807936)
print v(xbgr.mr_n68808048)
print v(xbgr.mr_n68808368)
print v(xbgr.mr_n68808480)
print v(xbgr.mr_n68808800)
print v(xbgr.mr_n68808912)
print v(xbgr.mr_n68809232)
print v(xbgr.mr_n68809344)
print v(xbgr.mr_n68809664)
print v(xbgr.mr_n68809776)
print v(xbgr.mr_n68810096)
print v(xbgr.mr_n68810208)
print v(xbgr.mr_n68810528)
print v(xbgr.mr_n68810640)
print v(xbgr.mr_n68810960)
print v(xbgr.mr_n68811072)
print v(xbgr.mr_n68811392)
print v(xbgr.mr_n68811504)
print v(xbgr.mr_n68811824)
print v(xbgr.mr_n68811936)
print v(xbgr.mr_n68812256)
print v(xbgr.mr_n68812368)
print v(xbgr.mr_n68812688)
print v(xbgr.mr_n68812800)
print v(xbgr.mr_n68813120)
print v(xbgr.mr_n68813232)
print v(xbgr.mr_n68813552)
print v(xbgr.mr_n68813664)
print v(xbgr.mr_n68813984)
print v(xbgr.mr_n68814096)
print v(xbgr.mr_n68814416)
print v(xbgr.mr_n68814528)
print v(xbgr.mr_n68814848)
print v(xbgr.mr_n68814960)
print v(xbgr.mr_n68815280)
print v(xbgr.mr_n68815392)
print v(xbgr.mr_n68815712)
print v(xbgr.mr_n68815824)
print v(xbgr.mr_n68816144)
print v(xbgr.mr_n68816256)
print v(xbgr.mr_n68816576)
print v(xbgr.mr_n68816688)
print v(xbgr.mr_n68817008)
print v(xbgr.mr_n68817120)
print v(xbgr.mr_n68817440)
print v(xbgr.mr_n68817552)
print v(xbgr.mr_n68817872)
print v(xbgr.mr_n68817984)
print v(xbgr.mr_n68818304)
print v(xbgr.mr_n68818416)
print v(xbgr.mr_n68818736)
print v(xbgr.mr_n68818848)
print v(xbgr.mr_n68819168)
print v(xbgr.mr_n68819280)
print v(xbgr.mr_n68819600)
print v(xbgr.mr_n68819712)
print v(xbgr.mr_n68820032)
print v(xbgr.mr_n68820144)
print v(xbgr.mr_n68820464)
print v(xbgr.mr_n68820576)
print v(xbgr.mr_n68820896)
print v(xbgr.mr_n68821008)
print v(xbgr.mr_n68821328)
print v(xbgr.mr_n68821440)
print v(xbgr.mr_n68821760)
print v(xbgr.mr_n68821872)
print v(xbgr.mr_n68822192)
print v(xbgr.mr_n68822304)
print v(xbgr.mr_n68822624)
print v(xbgr.mr_n68822736)
print v(xbgr.mr_n68823056)
print v(xbgr.mr_n68823168)
print v(xbgr.mr_n68823488)
print v(xbgr.mr_n68823600)
print v(xbgr.mr_n68823920)
print v(xbgr.mr_n68824032)
print v(xbgr.mr_n68824352)
print v(xbgr.mr_n68824464)
print v(xbgr.mr_n68824784)
print v(xbgr.mr_n68824896)
print v(xbgr.mr_n68825216)
print v(xbgr.mr_n68825328)
print v(xbgr.mr_n68825648)
print v(xbgr.mr_n68825760)
print v(xbgr.mr_n68826080)
print v(xbgr.mr_n68826192)
print v(xbgr.mr_n68826512)
print v(xbgr.mr_n68826624)
print v(xbgr.mr_n68826944)
print v(xbgr.mr_n68827056)
print v(xbgr.mr_n68827376)
print v(xbgr.mr_n68827488)
print v(xbgr.mr_n68827808)
print v(xbgr.mr_n68827920)
print v(xbgr.mr_n68828240)
print v(xbgr.mr_n68828352)
print v(xbgr.mr_n68828672)
print v(xbgr.mr_n68828784)
print v(xbgr.mr_n68829104)
print v(xbgr.mr_n68829216)
print v(xbgr.mr_n68829536)
print v(xbgr.mr_n68829648)
print v(xbgr.mr_n68829968)
print v(xbgr.mr_n68830080)
print v(xbgr.mr_n68830400)
print v(xbgr.mr_n68830512)
print v(xbgr.mr_n68830832)
print v(xbgr.mr_n68830944)
print v(xbgr.mr_n68831264)
print v(xbgr.mr_n68831376)
print v(xbgr.mr_n68831696)
print v(xbgr.mr_n68831808)
print v(xbgr.mr_n68832128)
print v(xbgr.mr_n68832240)
print v(xbgr.mr_n68832560)
print v(xbgr.mr_n68832672)
print v(xbgr.mr_n68832992)
print v(xbgr.mr_n68833104)
print v(xbgr.mr_n68833424)
print v(xbgr.mr_n68833536)
print v(xbgr.mr_n68833856)
print v(xbgr.mr_n68833968)
print v(xbgr.mr_n68834288)
print v(xbgr.mr_n68834400)
print v(xbgr.mr_n68834720)
print v(xbgr.mr_n68834832)
print v(xbgr.mr_n68835152)
print v(xbgr.mr_n68835264)
print v(xbgr.mr_n68835584)
print v(xbgr.mr_n68835696)
print v(xbgr.mr_n68836016)
print v(xbgr.mr_n68836128)
print v(xbgr.mr_n68836448)
print v(xbgr.mr_n68836560)
print v(xbgr.mr_n68836880)
print v(xbgr.mr_n68836992)
print v(xbgr.mr_n68837312)
print v(xbgr.mr_n68837424)
print v(xbgr.mr_n68837744)
print v(xbgr.mr_n68837856)
print v(xbgr.mr_n68838176)
print v(xbgr.mr_n68838288)
print v(xbgr.mr_n68838608)
print v(xbgr.mr_n68838720)
print v(xbgr.mr_n68839040)
print v(xbgr.mr_n68839152)
print v(xbgr.mr_n68839472)
print v(xbgr.mr_n68839584)
print v(xbgr.mr_n68839904)
print v(xbgr.mr_n68840016)
print v(xbgr.mr_n68840336)
print v(xbgr.mr_n68840448)
print v(xbgr.mr_n68840768)
print v(xbgr.mr_n68840880)
print v(xbgr.mr_n68841200)
print v(xbgr.mr_n68841312)
print v(xbgr.mr_n68841632)
print v(xbgr.mr_n68841744)
print v(xbgr.mr_n68842064)
print v(xbgr.mr_n68842176)
print v(xbgr.mr_n68842496)
print v(xbgr.mr_n68842608)
print v(xbgr.mr_n68842928)
print v(xbgr.mr_n68843040)
print v(xbgr.mr_n68843360)
print v(xbgr.mr_n68843472)
print v(xbgr.mr_n68843792)
print v(xbgr.mr_n68843904)
print v(xbgr.mr_n68844224)
print v(xbgr.mr_n68844336)
print v(xbgr.mr_n68844656)
print v(xbgr.mr_n68844768)
print v(xbgr.mr_n68845088)
print v(xbgr.mr_n68845200)
print v(xbgr.mr_n68845504)
print v(xbgr.mr_n68845616)
print v(xbgr.mr_n68845936)
print v(xbgr.mr_n68846048)
print v(xbgr.mr_n68846368)
print v(xbgr.mr_n68846480)
print v(xbgr.mr_n68846800)
print v(xbgr.mr_n68846912)
print v(xbgr.mr_n68847232)
print v(xbgr.mr_n68847344)
print v(xbgr.mr_n68847664)
print v(xbgr.mr_n68847776)
print v(xbgr.mr_n68848096)
print v(xbgr.mr_n68848208)
print v(xbgr.mr_n68848528)
print v(xbgr.mr_n68848640)
print v(xbgr.mr_n68848960)
print v(xbgr.mr_n68849072)
print v(xbgr.mr_n68849392)
print v(xbgr.mr_n68849504)
print v(xbgr.mr_n68849824)
print v(xbgr.mr_n68849936)
print v(xbgr.mr_n68850256)
print v(xbgr.mr_n68850368)
print v(xbgr.mr_n68850688)
print v(xbgr.mr_n68850800)
print v(xbgr.mr_n68851120)
print v(xbgr.mr_n68851232)
print v(xbgr.mr_n68851552)
print v(xbgr.mr_n68851664)
print v(xbgr.mr_n68851984)
print v(xbgr.mr_n68852096)
print v(xbgr.mr_n68852416)
print v(xbgr.mr_n68852528)
print v(xbgr.mr_n68852848)
print v(xbgr.mr_n68852960)
print v(xbgr.mr_n68853280)
print v(xbgr.mr_n68853392)
print v(xbgr.mr_n68853712)
print v(xbgr.mr_n68853824)
print v(xbgr.mr_n68854144)
print v(xbgr.mr_n68854256)
print v(xbgr.mr_n68854576)
print v(xbgr.mr_n68854688)
print v(xbgr.mr_n68855008)
print v(xbgr.mr_n68855120)
print v(xbgr.mr_n68855440)
print v(xbgr.mr_n68855552)
print v(xbgr.mr_n68855872)
print v(xbgr.mr_n68855984)
print v(xbgr.mr_n68856304)
print v(xbgr.mr_n68856416)
print v(xbgr.mr_n68856736)
print v(xbgr.mr_n68856848)
print v(xbgr.mr_n68857168)
print v(xbgr.mr_n68857280)
print v(xbgr.mr_n68857600)
print v(xbgr.mr_n68857712)
print v(xbgr.mr_n68858032)
print v(xbgr.mr_n68858144)
print v(xbgr.mr_n68858464)
print v(xbgr.mr_n68858576)
print v(xbgr.mr_n68858896)
print v(xbgr.mr_n68859008)
print v(xbgr.mr_n68859328)
print v(xbgr.mr_n68859440)
print v(xbgr.mr_n68859760)
print v(xbgr.mr_n68859872)
print v(xbgr.mr_n68860192)
print v(xbgr.mr_n68860304)
print v(xbgr.mr_n68860624)
print v(xbgr.mr_n68860736)
print v(xbgr.mr_n68861056)
print v(xbgr.mr_n68861168)
print v(xbgr.mr_n68861488)
print v(xbgr.mr_n68861600)
print v(xbgr.mr_n68861920)
print v(xbgr.mr_n68862032)
print v(xbgr.mr_n68862352)
print v(xbgr.mr_n68862464)
print v(xbgr.mr_n68862784)
print v(xbgr.mr_n68862896)
print v(xbgr.mr_n68863216)
print v(xbgr.mr_n68863328)
print v(xbgr.mr_n68863648)
print v(xbgr.mr_n68863760)
print v(xbgr.mr_n68864080)
print v(xbgr.mr_n68864192)
print v(xbgr.mr_n68864512)
print v(xbgr.mr_n68864624)
print v(xbgr.mr_n68864944)
print v(xbgr.mr_n68865056)
print v(xbgr.mr_n68865376)
print v(xbgr.mr_n68865488)
print v(xbgr.mr_n68865808)
print v(xbgr.mr_n68865920)
print v(xbgr.mr_n68866240)
print v(xbgr.mr_n68866352)
print v(xbgr.mr_n68866672)
print v(xbgr.mr_n68866784)
print v(xbgr.mr_n68867104)
print v(xbgr.mr_n68867216)
print v(xbgr.mr_n68867536)
print v(xbgr.mr_n68867648)
print v(xbgr.mr_n68867968)
print v(xbgr.mr_n68868080)
print v(xbgr.mr_n68868400)
print v(xbgr.mr_n68868512)
print v(xbgr.mr_n68868832)
print v(xbgr.mr_n68868944)
print v(xbgr.mr_n68869264)
print v(xbgr.mr_n68869376)
print v(xbgr.mr_n68869696)
print v(xbgr.mr_n68869808)
print v(xbgr.mr_n68870128)
print v(xbgr.mr_n68870240)
print v(xbgr.mr_n68870560)
print v(xbgr.mr_n68870672)
print v(xbgr.mr_n68870992)
print v(xbgr.mr_n68871104)
print v(xbgr.mr_n68871424)
print v(xbgr.mr_n68871536)
print v(xbgr.mr_n68871856)
print v(xbgr.mr_n68871968)
print v(xbgr.mr_n68872288)
print v(xbgr.mr_n68872400)
print v(xbgr.mr_n68872720)
print v(xbgr.mr_n68872832)
print v(xbgr.mr_n68873152)
print v(xbgr.mr_n68873264)
print v(xbgr.mr_n68873584)
print v(xbgr.mr_n68873696)
print v(xbgr.mr_n68874016)
print v(xbgr.mr_n68874128)
print v(xbgr.mr_n68874448)
print v(xbgr.mr_n68874560)
print v(xbgr.mr_n68874880)
print v(xbgr.mr_n68874992)
print v(xbgr.mr_n68875312)
print v(xbgr.mr_n68875424)
print v(xbgr.mr_n68875744)
print v(xbgr.mr_n68875856)
print v(xbgr.mr_n68876176)
print v(xbgr.mr_n68876288)
print v(xbgr.mr_n68876608)
print v(xbgr.mr_n68876720)
print v(xbgr.mr_n68877040)
print v(xbgr.mr_n68877152)
print v(xbgr.mr_n68877472)
print v(xbgr.mr_n68877584)
print v(xbgr.mr_n68877904)
print v(xbgr.mr_n68878016)
print v(xbgr.mr_n68878336)
print v(xbgr.mr_n68878448)
print v(xbgr.mr_n68878768)
print v(xbgr.mr_n68878880)
print v(xbgr.mr_n68879200)
print v(xbgr.mr_n68879312)
print v(xbgr.mr_n68879632)
print v(xbgr.mr_n68879744)
print v(xbgr.mr_n68880064)
print v(xbgr.mr_n68880176)
print v(xbgr.mr_n68880496)
print v(xbgr.mr_n68880608)
print v(xbgr.mr_n68880928)
print v(xbgr.mr_n68881040)
print v(xbgr.mr_n68881360)
print v(xbgr.mr_n68881472)
print v(xbgr.mr_n68881792)
print v(xbgr.mr_n68881904)
print v(xbgr.mr_n68882224)
print v(xbgr.mr_n68882336)
print v(xbgr.mr_n68882656)
print v(xbgr.mr_n68882768)
print v(xbgr.mr_n68883088)
print v(xbgr.mr_n68883200)
print v(xbgr.mr_n68883520)
print v(xbgr.mr_n68883632)
print v(xbgr.mr_n68883952)
print v(xbgr.mr_n68884064)
print v(xbgr.mr_n68884384)
print v(xbgr.mr_n68884496)
print v(xbgr.mr_n68884816)
print v(xbgr.mr_n68884928)
print v(xbgr.mr_n68885248)
print v(xbgr.mr_n68885360)
print v(xbgr.mr_n68885680)
print v(xbgr.mr_n68885792)
print v(xbgr.mr_n68886112)
print v(xbgr.mr_n68886224)
print v(xbgr.mr_n68886544)
print v(xbgr.mr_n68886656)
print v(xbgr.mr_n68886976)
print v(xbgr.mr_n68887088)
print v(xbgr.mr_n68887408)
print v(xbgr.mr_n68887520)
print v(xbgr.mr_n68887840)
print v(xbgr.mr_n68887952)
print v(xbgr.mr_n68888272)
print v(xbgr.mr_n68888384)
print v(xbgr.mr_n68888704)
print v(xbgr.mr_n68888816)
print v(xbgr.mr_n68889136)
print v(xbgr.mr_n68889248)
print v(xbgr.mr_n68889568)
print v(xbgr.mr_n68889680)
print v(xbgr.mr_n68890000)
print v(xbgr.mr_n68890112)
print v(xbgr.mr_n68890432)
print v(xbgr.mr_n68890544)
print v(xbgr.mr_n68890864)
print v(xbgr.mr_n68890976)
print v(xbgr.mr_n68891296)
print v(xbgr.mr_n68891408)
print v(xbgr.mr_n68891728)
print v(xbgr.mr_n68891840)
print v(xbgr.mr_n68892160)
print v(xbgr.mr_n68892272)
print v(xbgr.mr_n68892592)
print v(xbgr.mr_n68892704)
print v(xbgr.mr_n68893024)
print v(xbgr.mr_n68893136)
print v(xbgr.mr_n68893456)
print v(xbgr.mr_n68893664)
print v(xbgr.mr_n68893904)
print v(xbgr.mr_n68894768)
print v(xbgr.mr_n68894880)
print v(xbgr.mr_n68895200)
print v(xbgr.mr_n68895312)
print v(xbgr.mr_n68895632)
print v(xbgr.mr_n68895744)
print v(xbgr.mr_n68896064)
print v(xbgr.mr_n68896176)
print v(xbgr.mr_n68896496)
print v(xbgr.mr_n68896608)
print v(xbgr.mr_n68896928)
print v(xbgr.mr_n68897040)
print v(xbgr.mr_n68897360)
print v(xbgr.mr_n68898224)
print v(xbgr.mr_n68899088)
print v(xbgr.mr_n68899952)
print v(xbgr.mr_n68900064)
print v(xbgr.mr_n68900816)
print v(xbgr.mr_n68900928)
print v(xbgr.mr_n68901248)
print v(xbgr.mr_n68902112)
print v(xbgr.mr_n68902976)
print v(xbgr.mr_n68903840)
print v(xbgr.mr_n68904704)
print v(xbgr.mr_n68905248)
print v(xbgr.mr_n68906000)
print v(xbgr.mr_n68906544)
print v(xbgr.mr_n68906976)
print v(xbgr.mr_n68907728)
print v(xbgr.mr_n68907840)
print v(xbgr.mr_n68908160)
print v(xbgr.mr_n68908272)
print v(xbgr.mr_n68908592)
print v(xbgr.mr_n68909456)
print v(xbgr.mr_n68910320)
print v(xbgr.mr_n68911184)
print v(xbgr.mr_n68911296)
print v(xbgr.mr_n68911616)
print v(xbgr.mr_n68911728)
print v(xbgr.mr_n68912160)
print v(xbgr.mr_n68912480)
print v(xbgr.mr_n68912592)
print v(xbgr.mr_n68912912)
print v(xbgr.mr_n68913776)
print v(xbgr.mr_n68913888)
print v(xbgr.mr_n68914320)
print v(xbgr.mr_n68914640)
print v(xbgr.mr_n68914752)
print v(xbgr.mr_n68915072)
print v(xbgr.mr_n68915184)
print v(xbgr.mr_n68915504)
print v(xbgr.mr_n68915616)
print v(xbgr.mr_n68915936)
print v(xbgr.mr_n68916048)
print v(xbgr.mr_n68916368)
print v(xbgr.mr_n68917344)
print v(xbgr.mr_n68917664)
print v(xbgr.mr_n68917776)
print v(xbgr.mr_n68918096)
print v(xbgr.mr_n68918208)
print v(xbgr.mr_n68918528)
print v(xbgr.mr_n68918640)
print v(xbgr.mr_n68918960)
print v(xbgr.mr_n68919072)
print v(xbgr.mr_n68919392)
print v(xbgr.mr_n68919824)
print v(xbgr.mr_n68920800)
print v(xbgr.mr_n68921120)
print v(xbgr.mr_n68921984)
print v(xbgr.mr_n68922848)
print v(xbgr.mr_n68922960)
print v(xbgr.mr_n68923712)
print v(xbgr.mr_n68924576)
print v(xbgr.mr_n68924688)
print v(xbgr.mr_n68925008)
print v(xbgr.mr_n68925872)
print v(xbgr.mr_n68925984)
print v(xbgr.mr_n68926304)
print v(xbgr.mr_n68926416)
print v(xbgr.mr_n68926736)
print v(xbgr.mr_n68927600)
print v(xbgr.mr_n68927712)
print v(xbgr.mr_n68928032)
print v(xbgr.mr_n68928144)
print v(xbgr.mr_n68928464)
print v(xbgr.mr_n68928576)
print v(xbgr.mr_n68928896)
print v(xbgr.mr_n68929008)
print v(xbgr.mr_n68929328)
print v(xbgr.mr_n68930304)
print v(xbgr.mr_n68930736)
print v(xbgr.mr_n68931056)
print v(xbgr.mr_n68931920)
print v(xbgr.mr_n68932784)
print v(xbgr.mr_n68932896)
print v(xbgr.mr_n68933216)
print v(xbgr.mr_n68933328)
print v(xbgr.mr_n68933648)
print v(xbgr.mr_n68933760)
print v(xbgr.mr_n68934080)
print v(xbgr.mr_n68934192)
print v(xbgr.mr_n68934624)
print v(xbgr.mr_n68935056)
print v(xbgr.mr_n68935376)
print v(xbgr.mr_n68935488)
print v(xbgr.mr_n68935808)
print v(xbgr.mr_n68935920)
print v(xbgr.mr_n68936240)
print v(xbgr.mr_n68936352)
print v(xbgr.mr_n68936672)
print v(xbgr.mr_n68936784)
print v(xbgr.mr_n68937104)
print v(xbgr.mr_n68937968)
print v(xbgr.mr_n68938832)
print v(xbgr.mr_n68938944)
print v(xbgr.mr_n68939264)
print v(xbgr.mr_n68940128)
print v(xbgr.mr_n68940992)
print v(xbgr.mr_n68941104)
print v(xbgr.mr_n68941424)
print v(xbgr.mr_n68941536)
print v(xbgr.mr_n68941968)
print v(xbgr.mr_n68942288)
print v(xbgr.mr_n68942400)
print v(xbgr.mr_n68942832)
print v(xbgr.mr_n68943152)
print v(xbgr.mr_n68943584)
print v(xbgr.mr_n68943696)
print v(xbgr.mr_n68944016)
print v(xbgr.mr_n68944128)
print v(xbgr.mr_n68944448)
print v(xbgr.mr_n68944880)
print v(xbgr.mr_n68944992)
print v(xbgr.mr_n68945744)
print v(xbgr.mr_n68945856)
print v(xbgr.mr_n68946176)
print v(xbgr.mr_n68946288)
print v(xbgr.mr_n68946608)
print v(xbgr.mr_n68947040)
print v(xbgr.mr_n68947152)
print v(xbgr.mr_n68947472)
print v(xbgr.mr_n68947904)
print v(xbgr.mr_n68948768)
print v(xbgr.mr_n68950496)
print v(xbgr.mr_n68950608)
print v(xbgr.mr_n68950928)
print v(xbgr.mr_n68951040)
print v(xbgr.mr_n68951360)
print v(xbgr.mr_n68951472)
print v(xbgr.mr_n68951904)
print v(xbgr.mr_n68952336)
print v(xbgr.mr_n68952656)
print v(xbgr.mr_n68952768)
print v(xbgr.mr_n68953088)
print v(xbgr.mr_n68954496)
print v(xbgr.mr_n68954816)
print v(xbgr.mr_n68955792)
print v(xbgr.mr_n68956112)
print v(xbgr.mr_n68956224)
print v(xbgr.mr_n68956544)
print v(xbgr.mr_n68956656)
print v(xbgr.mr_n68957088)
print v(xbgr.mr_n68957408)
print v(xbgr.mr_n68957520)
print v(xbgr.mr_n68957952)
print v(xbgr.mr_n68958272)
print v(xbgr.mr_n68958384)
print v(xbgr.mr_n68958704)
print v(xbgr.mr_n68958816)
print v(xbgr.mr_n68959136)
print v(xbgr.mr_n68960000)
print v(xbgr.mr_n68960432)
print v(xbgr.mr_n68961296)
print v(xbgr.mr_n68961408)
print v(xbgr.mr_n68961728)
print v(xbgr.mr_n68961840)
print v(xbgr.mr_n68962160)
print v(xbgr.mr_n68962272)
print v(xbgr.mr_n68963024)
print v(xbgr.mr_n68963456)
print v(xbgr.mr_n68963568)
print v(xbgr.mr_n68963888)
print v(xbgr.mr_n68964320)
print v(xbgr.mr_n68964432)
print v(xbgr.mr_n68964752)
print v(xbgr.mr_n68964864)
print v(xbgr.mr_n68965184)
print v(xbgr.mr_n68965296)
print v(xbgr.mr_n68965616)
print v(xbgr.mr_n68965728)
print v(xbgr.mr_n68966048)
print v(xbgr.mr_n68966160)
print v(xbgr.mr_n68966480)
print v(xbgr.mr_n68967888)
print v(xbgr.mr_n68968208)
print v(xbgr.mr_n68968320)
print v(xbgr.mr_n68968752)
print v(xbgr.mr_n68969072)
print v(xbgr.mr_n68969184)
print v(xbgr.mr_n68969504)
print v(xbgr.mr_n68969936)
print v(xbgr.mr_n68970800)
print v(xbgr.mr_n68971664)
print v(xbgr.mr_n68972528)
print v(xbgr.mr_n68973392)
print v(xbgr.mr_n68974256)
print v(xbgr.mr_n68975552)
print v(xbgr.mr_n68975984)
print v(xbgr.mr_n68976096)
print v(xbgr.mr_n68976416)
print v(xbgr.mr_n68976848)
print v(xbgr.mr_n68976960)
print v(xbgr.mr_n68977280)
print v(xbgr.mr_n68978144)
print v(xbgr.mr_n68978256)
print v(xbgr.mr_n68978576)
print v(xbgr.mr_n68978688)
print v(xbgr.mr_n68979008)
print v(xbgr.mr_n68979872)
print v(xbgr.mr_n68979984)
print v(xbgr.mr_n68980848)
print v(xbgr.mr_n68981280)
print v(xbgr.mr_n68981712)
print v(xbgr.mr_n68982464)
print v(xbgr.mr_n68982576)
print v(xbgr.mr_n68983008)
print v(xbgr.mr_n68983760)
print v(xbgr.mr_n68984192)
print v(xbgr.mr_n68984304)
print v(xbgr.mr_n68984736)
print v(xbgr.mr_n68985488)
print v(xbgr.mr_n68985600)
print v(xbgr.mr_n68985920)
print v(xbgr.mr_n68986032)
print v(xbgr.mr_n68986352)
print v(xbgr.mr_n68986464)
print v(xbgr.mr_n68986784)
print v(xbgr.mr_n68986896)
print v(xbgr.mr_n68987216)
print v(xbgr.mr_n68987328)
print v(xbgr.mr_n68987648)
print v(xbgr.mr_n68987760)
print v(xbgr.mr_n68988080)
print v(xbgr.mr_n68988192)
print v(xbgr.mr_n68988512)
print v(xbgr.mr_n68988624)
print v(xbgr.mr_n68988944)
print v(xbgr.mr_n68989056)
print v(xbgr.mr_n68989376)
print v(xbgr.mr_n68989488)
print v(xbgr.mr_n68989808)
print v(xbgr.mr_n68989920)
print v(xbgr.mr_n68990240)
print v(xbgr.mr_n68990352)
print v(xbgr.mr_n68990672)
print v(xbgr.mr_n68990784)
print v(xbgr.mr_n68991104)
print v(xbgr.mr_n68991216)
print v(xbgr.mr_n68991648)
print v(xbgr.mr_n68991968)
print v(xbgr.mr_n68992080)
print v(xbgr.mr_n68992512)
print v(xbgr.mr_n68992832)
print v(xbgr.mr_n68992944)
print v(xbgr.mr_n68993696)
print v(xbgr.mr_n68994128)
print v(xbgr.mr_n68994992)
print v(xbgr.mr_n68995856)
print v(xbgr.mr_n68996720)
print v(xbgr.mr_n68996832)
print v(xbgr.mr_n68997152)
print v(xbgr.mr_n68997264)
print v(xbgr.mr_n68997584)
print v(xbgr.mr_n68997696)
print v(xbgr.mr_n68998016)
print v(xbgr.mr_n68998128)
print v(xbgr.mr_n68998880)
print v(xbgr.mr_n68999744)
print v(xbgr.mr_n69000608)
print v(xbgr.mr_n69001472)
print v(xbgr.mr_n69002768)
print v(xbgr.mr_n69002880)
print v(xbgr.mr_n69003200)
print v(xbgr.mr_n69003312)
print v(xbgr.mr_n69003632)
print v(xbgr.mr_n69003744)
print v(xbgr.mr_n69004176)
print v(xbgr.mr_n69004608)
print v(xbgr.mr_n69005040)
print v(xbgr.mr_n69005360)
print v(xbgr.mr_n69005472)
print v(xbgr.mr_n69005904)
print v(xbgr.mr_n69006224)
print v(xbgr.mr_n69006336)
print v(xbgr.mr_n69006656)
print v(xbgr.mr_n69006768)
print v(xbgr.mr_n69007088)
print v(xbgr.mr_n69007200)
print v(xbgr.mr_n69007520)
print v(xbgr.mr_n69007632)
print v(xbgr.mr_n69007952)
print v(xbgr.mr_n69008064)
print v(xbgr.mr_n69008496)
print v(xbgr.mr_n69008816)
print v(xbgr.mr_n69008928)
print v(xbgr.mr_n69009360)
print v(xbgr.mr_n69009680)
print v(xbgr.mr_n69010112)
print v(xbgr.mr_n69010224)
print v(xbgr.mr_n69010656)
print v(xbgr.mr_n69010976)
print v(xbgr.mr_n69011088)
print v(xbgr.mr_n69011520)
print v(xbgr.mr_n69011840)
print v(xbgr.mr_n69011952)
print v(xbgr.mr_n69012384)
print v(xbgr.mr_n69012704)
print v(xbgr.mr_n69012816)
print v(xbgr.mr_n69013136)
print v(xbgr.mr_n69013248)
print v(xbgr.mr_n69013568)
print v(xbgr.mr_n69014432)
print v(xbgr.mr_n69015296)
print v(xbgr.mr_n69016160)
print v(xbgr.mr_n69017024)
print v(xbgr.mr_n69017888)
print v(xbgr.mr_n69018752)
print v(xbgr.mr_n69018864)
print v(xbgr.mr_n69019616)
print v(xbgr.mr_n69020480)
print v(xbgr.mr_n69021344)
print v(xbgr.mr_n69022208)
print v(xbgr.mr_n69023072)
print v(xbgr.mr_n69023936)
print v(xbgr.mr_n69024048)
print v(xbgr.mr_n69024368)
print v(xbgr.mr_n69024480)
print v(xbgr.mr_n69024800)
print v(xbgr.mr_n69024912)
print v(xbgr.mr_n69025232)
print v(xbgr.mr_n69025344)
print v(xbgr.mr_n69025664)
print v(xbgr.mr_n69026528)
print v(xbgr.mr_n69027392)
print v(xbgr.mr_n69028256)
print v(xbgr.mr_n69028368)
print v(xbgr.mr_n69028688)
print v(xbgr.mr_n69028800)
print v(xbgr.mr_n69029120)
print v(xbgr.mr_n69029232)
print v(xbgr.mr_n69029552)
print v(xbgr.mr_n69030416)
print v(xbgr.mr_n69031280)
print v(xbgr.mr_n69032144)
print v(xbgr.mr_n69032256)
print v(xbgr.mr_n69032576)
print v(xbgr.mr_n69032688)
print v(xbgr.mr_n69033008)
print v(xbgr.mr_n69033120)
print v(xbgr.mr_n69033552)
print v(xbgr.mr_n69033984)
print v(xbgr.mr_n69034416)
print v(xbgr.mr_n69034736)
print v(xbgr.mr_n69034848)
print v(xbgr.mr_n69035168)
print v(xbgr.mr_n69035280)
print v(xbgr.mr_n69035600)
print v(xbgr.mr_n69035712)
print v(xbgr.mr_n69036032)
print v(xbgr.mr_n69036144)
print v(xbgr.mr_n69036464)
print v(xbgr.mr_n69036576)
print v(xbgr.mr_n69036896)
print v(xbgr.mr_n69037008)
print v(xbgr.mr_n69037328)
print v(xbgr.mr_n69037440)
print v(xbgr.mr_n69037760)
print v(xbgr.mr_n69037872)
print v(xbgr.mr_n69038192)
print v(xbgr.mr_n69038304)
print v(xbgr.mr_n69038736)
print v(xbgr.mr_n69039056)
print v(xbgr.mr_n69039168)
print v(xbgr.mr_n69039488)
print v(xbgr.mr_n69039920)
print v(xbgr.mr_n69040032)
print v(xbgr.mr_n69040352)
print v(xbgr.mr_n69040464)
print v(xbgr.mr_n69040784)
print v(xbgr.mr_n69040896)
print v(xbgr.mr_n69041216)
print v(xbgr.mr_n69041328)
print v(xbgr.mr_n69042080)
print v(xbgr.mr_n69042192)
print v(xbgr.mr_n69042944)
print v(xbgr.mr_n69043808)
print v(xbgr.mr_n69043920)
print v(xbgr.mr_n69044240)
print v(xbgr.mr_n69044352)
print v(xbgr.mr_n69044672)
print v(xbgr.mr_n69044784)
print v(xbgr.mr_n69045104)
print v(xbgr.mr_n69045216)
print v(xbgr.mr_n69045648)
print v(xbgr.mr_n69046080)
print v(xbgr.mr_n69046400)
print v(xbgr.mr_n69046512)
print v(xbgr.mr_n69046832)
print v(xbgr.mr_n69046944)
print v(xbgr.mr_n69047264)
print v(xbgr.mr_n69048128)
print v(xbgr.mr_n69049424)
print v(xbgr.mr_n69050288)
print v(xbgr.mr_n69050400)
print v(xbgr.mr_n69050720)
print v(xbgr.mr_n69050832)
print v(xbgr.mr_n69051152)
print v(xbgr.mr_n69051264)
print v(xbgr.mr_n69051584)
print v(xbgr.mr_n69051696)
print v(xbgr.mr_n69052128)
print v(xbgr.mr_n69052448)
print v(xbgr.mr_n69052560)
print v(xbgr.mr_n69052880)
print v(xbgr.mr_n69052992)
print v(xbgr.mr_n69053312)
print v(xbgr.mr_n69053424)
print v(xbgr.mr_n69053856)
print v(xbgr.mr_n69054176)
print v(xbgr.mr_n69054288)
print v(xbgr.mr_n69054608)
print v(xbgr.mr_n69054720)
print v(xbgr.mr_n69055040)
print v(xbgr.mr_n69055904)
print v(xbgr.mr_n69056768)
print v(xbgr.mr_n69057632)
print v(xbgr.mr_n69058496)
print v(xbgr.mr_n69058608)
print v(xbgr.mr_n69058928)
print v(xbgr.mr_n69059040)
print v(xbgr.mr_n69059472)
print v(xbgr.mr_n69059904)
print v(xbgr.mr_n69060224)
print v(xbgr.mr_n69060336)
print v(xbgr.mr_n69060656)
print v(xbgr.mr_n69061520)
print v(xbgr.mr_n69062384)
print v(xbgr.mr_n69062496)
print v(xbgr.mr_n69062816)
print v(xbgr.mr_n69062928)
print v(xbgr.mr_n69063248)
print v(xbgr.mr_n69063360)
print v(xbgr.mr_n69063680)
print v(xbgr.mr_n69063792)
print v(xbgr.mr_n69064112)
print v(xbgr.mr_n69064224)
print v(xbgr.mr_n69064656)
print v(xbgr.mr_n69064976)
print v(xbgr.mr_n69065088)
print v(xbgr.mr_n69065840)
print v(xbgr.mr_n69066704)
print v(xbgr.mr_n69066816)
print v(xbgr.mr_n69067136)
print v(xbgr.mr_n69067248)
print v(xbgr.mr_n69067680)
print v(xbgr.mr_n69068000)
print v(xbgr.mr_n69068112)
print v(xbgr.mr_n69068432)
print v(xbgr.mr_n69068544)
print v(xbgr.mr_n69068864)
print v(xbgr.mr_n69068976)
print v(xbgr.mr_n69069296)
print v(xbgr.mr_n69069408)
print v(xbgr.mr_n69069728)
print v(xbgr.mr_n69069840)
print v(xbgr.mr_n69070160)
print v(xbgr.mr_n69071024)
print v(xbgr.mr_n69072000)
print v(xbgr.mr_n69072320)
print v(xbgr.mr_n69073184)
print v(xbgr.mr_n69074048)
print v(xbgr.mr_n69074912)
print v(xbgr.mr_n69075344)
print v(xbgr.mr_n69075776)
print v(xbgr.mr_n69075888)
print v(xbgr.mr_n69076208)
print v(xbgr.mr_n69076320)
print v(xbgr.mr_n69076640)
print v(xbgr.mr_n69076752)
print v(xbgr.mr_n69077072)
print v(xbgr.mr_n69077184)
print v(xbgr.mr_n69077504)
print v(xbgr.mr_n69077616)
print v(xbgr.mr_n69077936)
print v(xbgr.mr_n69078048)
print v(xbgr.mr_n69078368)
print v(xbgr.mr_n69079232)
print v(xbgr.mr_n69080096)
print v(xbgr.mr_n69080208)
print v(xbgr.mr_n69080528)
print v(xbgr.mr_n69080640)
print v(xbgr.mr_n69080960)
print v(xbgr.mr_n69081072)
print v(xbgr.mr_n69081392)
print v(xbgr.mr_n69081504)
print v(xbgr.mr_n69083120)
print v(xbgr.mr_n69083984)
print v(xbgr.mr_n69084096)
print v(xbgr.mr_n69084416)
print v(xbgr.mr_n69084528)
print v(xbgr.mr_n69084848)
print v(xbgr.mr_n69085280)
print v(xbgr.mr_n69085392)
print v(xbgr.mr_n69085712)
print v(xbgr.mr_n69085824)
print v(xbgr.mr_n69086144)
print v(xbgr.mr_n69086256)
print v(xbgr.mr_n69086688)
print v(xbgr.mr_n69087008)
print v(xbgr.mr_n69087120)
print v(xbgr.mr_n69087552)
print v(xbgr.mr_n69088304)
print v(xbgr.mr_n69089168)
print v(xbgr.mr_n69090464)
print v(xbgr.mr_n69090576)
print v(xbgr.mr_n69091008)
print v(xbgr.mr_n69091328)
print v(xbgr.mr_n69092192)
print v(xbgr.mr_n69093056)
print v(xbgr.mr_n69093488)
print v(xbgr.mr_n69094784)
print v(xbgr.mr_n69095648)
print v(xbgr.mr_n69096080)
print v(xbgr.mr_n69096944)
print v(xbgr.mr_n69098240)
print v(xbgr.mr_n69098352)
print v(xbgr.mr_n69098672)
print v(xbgr.mr_n69098784)
print v(xbgr.mr_n69099104)
print v(xbgr.mr_n69099216)
print v(xbgr.mr_n69099536)
print v(xbgr.mr_n69099648)
print v(xbgr.mr_n69099968)
print v(xbgr.mr_n69100080)
print v(xbgr.mr_n69100400)
print v(xbgr.mr_n69100512)
print v(xbgr.mr_n69100832)
print v(xbgr.mr_n69100944)
print v(xbgr.mr_n69101696)
print v(xbgr.mr_n69101808)
print v(xbgr.mr_n69102240)
print v(xbgr.mr_n69102560)
print v(xbgr.mr_n69102672)
print v(xbgr.mr_n69102992)
print v(xbgr.mr_n69103104)
print v(xbgr.mr_n69103424)
print v(xbgr.mr_n69103536)
print v(xbgr.mr_n69103856)
print v(xbgr.mr_n69103968)
print v(xbgr.mr_n69104288)
print v(xbgr.mr_n69104400)
print v(xbgr.mr_n69104832)
print v(xbgr.mr_n69105152)
print v(xbgr.mr_n69105696)
print v(xbgr.mr_n69106016)
print v(xbgr.mr_n69106128)
print v(xbgr.mr_n69106560)
print v(xbgr.mr_n69106880)
print v(xbgr.mr_n69106992)
print v(xbgr.mr_n69107424)
print v(xbgr.mr_n69107744)
print v(xbgr.mr_n69107856)
print v(xbgr.mr_n69108176)
print v(xbgr.mr_n69108288)
print v(xbgr.mr_n69108608)
print v(xbgr.mr_n69108720)
print v(xbgr.mr_n69109040)
print v(xbgr.mr_n69109152)
print v(xbgr.mr_n69109472)
print v(xbgr.mr_n69109584)
print v(xbgr.mr_n69109904)
print v(xbgr.mr_n69110016)
print v(xbgr.mr_n69110336)
print v(xbgr.mr_n69110448)
print v(xbgr.mr_n69110768)
print v(xbgr.mr_n69110880)
print v(xbgr.mr_n69111200)
print v(xbgr.mr_n69112064)
print v(xbgr.mr_n69112176)
print v(xbgr.mr_n69112496)
print v(xbgr.mr_n69112608)
print v(xbgr.mr_n69112928)
print v(xbgr.mr_n69113040)
print v(xbgr.mr_n69113360)
print v(xbgr.mr_n69113472)
print v(xbgr.mr_n69113792)
print v(xbgr.mr_n69114656)
print v(xbgr.mr_n69115520)
print v(xbgr.mr_n69116384)
print v(xbgr.mr_n69116928)
print v(xbgr.mr_n69117360)
print v(xbgr.mr_n69117680)
print v(xbgr.mr_n69117792)
print v(xbgr.mr_n69118112)
print v(xbgr.mr_n69118224)
print v(xbgr.mr_n69118544)
print v(xbgr.mr_n69118656)
print v(xbgr.mr_n69118976)
print v(xbgr.mr_n69119088)
print v(xbgr.mr_n69119408)
print v(xbgr.mr_n69120704)
print v(xbgr.mr_n69121568)
print v(xbgr.mr_n69122544)
print v(xbgr.mr_n69122976)
print v(xbgr.mr_n69123296)
print v(xbgr.mr_n69123728)
print v(xbgr.mr_n69124592)
print v(xbgr.mr_n69125456)
print v(xbgr.mr_n69125568)
print v(xbgr.mr_n69125888)
print v(xbgr.mr_n69126000)
print v(xbgr.mr_n69126320)
print v(xbgr.mr_n69126432)
print v(xbgr.mr_n69126752)
print v(xbgr.mr_n69126864)
print v(xbgr.mr_n69128048)
print v(xbgr.mr_n69128160)
print v(xbgr.mr_n69128480)
print v(xbgr.mr_n69128592)
print v(xbgr.mr_n69128912)
print v(xbgr.mr_n69129024)
print v(xbgr.mr_n69129456)
print v(xbgr.mr_n69129776)
print v(xbgr.mr_n69130208)
print v(xbgr.mr_n69130320)
print v(xbgr.mr_n69130752)
print v(xbgr.mr_n69131072)
print v(xbgr.mr_n69131936)
print v(xbgr.mr_n69132048)
print v(xbgr.mr_n69132480)
print v(xbgr.mr_n69132800)
print v(xbgr.mr_n69132912)
print v(xbgr.mr_n69133664)
print v(xbgr.mr_n69134208)
print v(xbgr.mr_n69134528)
print v(xbgr.mr_n69134640)
print v(xbgr.mr_n69134960)
print v(xbgr.mr_n69135072)
print v(xbgr.mr_n69135392)
print v(xbgr.mr_n69135504)
print v(xbgr.mr_n69135824)
print v(xbgr.mr_n69136256)
print v(xbgr.mr_n69136368)
print v(xbgr.mr_n69136688)
print v(xbgr.mr_n69136800)
print v(xbgr.mr_n69137120)
print v(xbgr.mr_n69137232)
print v(xbgr.mr_n69137984)
print v(xbgr.mr_n69138096)
print v(xbgr.mr_n69138528)
print v(xbgr.mr_n69138848)
print v(xbgr.mr_n69138960)
print v(xbgr.mr_n69139280)
print v(xbgr.mr_n69139392)
print v(xbgr.mr_n69139712)
print v(xbgr.mr_n69139824)
print v(xbgr.mr_n69140144)
print v(xbgr.mr_n69141008)
print v(xbgr.mr_n69141440)
print v(xbgr.mr_n69141872)
print v(xbgr.mr_n69141984)
print v(xbgr.mr_n69142304)
print v(xbgr.mr_n69142416)
print v(xbgr.mr_n69143168)
print v(xbgr.mr_n69143280)
print v(xbgr.mr_n69143600)
print v(xbgr.mr_n69143712)
print v(xbgr.mr_n69144464)
print v(xbgr.mr_n69145328)
print v(xbgr.mr_n69145440)
print v(xbgr.mr_n69145760)
print v(xbgr.mr_n69146624)
print v(xbgr.mr_n69146736)
print v(xbgr.mr_n69147056)
print v(xbgr.mr_n69147168)
print v(xbgr.mr_n69147488)
print v(xbgr.mr_n69147600)
print v(xbgr.mr_n69147920)
print v(xbgr.mr_n69148032)
print v(xbgr.mr_n69148352)
print v(xbgr.mr_n69148464)
print v(xbgr.mr_n69148784)
print v(xbgr.mr_n69148896)
print v(xbgr.mr_n69149216)
print v(xbgr.mr_n69149328)
print v(xbgr.mr_n69149760)
print v(xbgr.mr_n69150192)
print v(xbgr.mr_n69150512)
print v(xbgr.mr_n69150944)
print v(xbgr.mr_n69151056)
print v(xbgr.mr_n69152240)
print v(xbgr.mr_n69153968)
print v(xbgr.mr_n69154080)
print v(xbgr.mr_n69154512)
print v(xbgr.mr_n69154832)
print v(xbgr.mr_n69154944)
print v(xbgr.mr_n69155264)
print v(xbgr.mr_n69155376)
print v(xbgr.mr_n69155808)
print v(xbgr.mr_n69156128)
print v(xbgr.mr_n69156240)
print v(xbgr.mr_n69156560)
print v(xbgr.mr_n69156992)
print v(xbgr.mr_n69157104)
print v(xbgr.mr_n69157856)
print v(xbgr.mr_n69157968)
print v(xbgr.mr_n69158288)
print v(xbgr.mr_n69158400)
print v(xbgr.mr_n69158720)
print v(xbgr.mr_n69158832)
print v(xbgr.mr_n69159152)
print v(xbgr.mr_n69159264)
print v(xbgr.mr_n69159584)
print v(xbgr.mr_n69159696)
print v(xbgr.mr_n69160016)
print v(xbgr.mr_n69160880)
print v(xbgr.mr_n69161744)
print v(xbgr.mr_n69162608)
print v(xbgr.mr_n69162720)
print v(xbgr.mr_n69163040)
print v(xbgr.mr_n69163472)
print v(xbgr.mr_n69163584)
print v(xbgr.mr_n69163904)
print v(xbgr.mr_n69164016)
print v(xbgr.mr_n69164336)
print v(xbgr.mr_n69164448)
print v(xbgr.mr_n69164768)
print v(xbgr.mr_n69165632)
print v(xbgr.mr_n69166608)
print v(xbgr.mr_n69166928)
print v(xbgr.mr_n69167040)
print v(xbgr.mr_n69167360)
print v(xbgr.mr_n69167472)
print v(xbgr.mr_n69167792)
print v(xbgr.mr_n69167904)
print v(xbgr.mr_n69168224)
print v(xbgr.mr_n69168336)
print v(xbgr.mr_n69168656)
print v(xbgr.mr_n69169200)
print v(xbgr.mr_n69169632)
print v(xbgr.mr_n69170064)
print v(xbgr.mr_n69171248)
print v(xbgr.mr_n69171360)
print v(xbgr.mr_n69171680)
print v(xbgr.mr_n69171792)
print v(xbgr.mr_n69172112)
print v(xbgr.mr_n69172976)
print v(xbgr.mr_n69173088)
print v(xbgr.mr_n69173408)
print v(xbgr.mr_n69173520)
print v(xbgr.mr_n69173840)
print v(xbgr.mr_n69174272)
print v(xbgr.mr_n69175136)
print v(xbgr.mr_n69176432)
print v(xbgr.mr_n69176544)
print v(xbgr.mr_n69176864)
print v(xbgr.mr_n69176976)
print v(xbgr.mr_n69177296)
print v(xbgr.mr_n69177728)
print v(xbgr.mr_n69178592)
print v(xbgr.mr_n69179024)
print v(xbgr.mr_n69179136)
print v(xbgr.mr_n69179456)
print v(xbgr.mr_n69179568)
print v(xbgr.mr_n69179888)
print v(xbgr.mr_n69180000)
print v(xbgr.mr_n69180320)
print v(xbgr.mr_n69180432)
print v(xbgr.mr_n69181184)
print v(xbgr.mr_n69181296)
print v(xbgr.mr_n69182048)
print v(xbgr.mr_n69183024)
print v(xbgr.mr_n69183344)
print v(xbgr.mr_n69183456)
print v(xbgr.mr_n69183776)
print v(xbgr.mr_n69183888)
print v(xbgr.mr_n69184208)
print v(xbgr.mr_n69184640)
print v(xbgr.mr_n69185504)
print v(xbgr.mr_n69185616)
print v(xbgr.mr_n69185936)
print v(xbgr.mr_n69186048)
print v(xbgr.mr_n69186368)
print v(xbgr.mr_n69186480)
print v(xbgr.mr_n69186800)
print v(xbgr.mr_n69186912)
print v(xbgr.mr_n69187232)
print v(xbgr.mr_n69187344)
print v(xbgr.mr_n69187776)
print v(xbgr.mr_n69188528)
print v(xbgr.mr_n69189504)
print v(xbgr.mr_n69189936)
print v(xbgr.mr_n69190256)
print v(xbgr.mr_n69190688)
print v(xbgr.mr_n69191664)
print v(xbgr.mr_n69192096)
print v(xbgr.mr_n69192416)
print v(xbgr.mr_n69192848)
print v(xbgr.mr_n69192960)
print v(xbgr.mr_n69193280)
print v(xbgr.mr_n69193392)
print v(xbgr.mr_n69193712)
print v(xbgr.mr_n69193824)
print v(xbgr.mr_n69194144)
print v(xbgr.mr_n69194256)
print v(xbgr.mr_n69195008)
print v(xbgr.mr_n69195872)
print v(xbgr.mr_n69197168)
print v(xbgr.mr_n69197280)
print v(xbgr.mr_n69197600)
print v(xbgr.mr_n69197712)
print v(xbgr.mr_n69198032)
print v(xbgr.mr_n69198144)
print v(xbgr.mr_n69198464)
print v(xbgr.mr_n69198576)
print v(xbgr.mr_n69198896)
print v(xbgr.mr_n69199008)
print v(xbgr.mr_n69199328)
print v(xbgr.mr_n69199760)
print v(xbgr.mr_n69199872)
print v(xbgr.mr_n69200192)
print v(xbgr.mr_n69200304)
print v(xbgr.mr_n69200624)
print v(xbgr.mr_n69200736)
print v(xbgr.mr_n69201056)
print v(xbgr.mr_n69201168)
print v(xbgr.mr_n69201488)
print v(xbgr.mr_n69201600)
print v(xbgr.mr_n69201920)
print v(xbgr.mr_n69202032)
print v(xbgr.mr_n69202352)
print v(xbgr.mr_n69202464)
print v(xbgr.mr_n69202784)
print v(xbgr.mr_n69202896)
print v(xbgr.mr_n69203216)
print v(xbgr.mr_n69203328)
print v(xbgr.mr_n69203760)
print v(xbgr.mr_n69204080)
print v(xbgr.mr_n69204192)
print v(xbgr.mr_n69204624)
print v(xbgr.mr_n69205056)
print v(xbgr.mr_n69205376)
print v(xbgr.mr_n69205488)
print v(xbgr.mr_n69205808)
print v(xbgr.mr_n69205920)
print v(xbgr.mr_n69206240)
print v(xbgr.mr_n69206352)
print v(xbgr.mr_n69206672)
print v(xbgr.mr_n69206784)
print v(xbgr.mr_n69207536)
print v(xbgr.mr_n69207648)
print v(xbgr.mr_n69208080)
print v(xbgr.mr_n69208400)
print v(xbgr.mr_n69208944)
print v(xbgr.mr_n69209264)
print v(xbgr.mr_n69210128)
print v(xbgr.mr_n69210240)
print v(xbgr.mr_n69210560)
print v(xbgr.mr_n69210992)
print v(xbgr.mr_n69211424)
print v(xbgr.mr_n69211856)
print v(xbgr.mr_n69211968)
print v(xbgr.mr_n69212720)
print v(xbgr.mr_n69212832)
print v(xbgr.mr_n69213152)
print v(xbgr.mr_n69213264)
print v(xbgr.mr_n69213584)
print v(xbgr.mr_n69214016)
print v(xbgr.mr_n69214128)
print v(xbgr.mr_n69214448)
print v(xbgr.mr_n69214560)
print v(xbgr.mr_n69214880)
print v(xbgr.mr_n69214992)
print v(xbgr.mr_n69215312)
print v(xbgr.mr_n69215744)
print v(xbgr.mr_n69216608)
print v(xbgr.mr_n69217472)
print v(xbgr.mr_n69218768)
print v(xbgr.mr_n69219632)
print v(xbgr.mr_n69220496)
print v(xbgr.mr_n69221360)
print v(xbgr.mr_n69221472)
print v(xbgr.mr_n69221792)
print v(xbgr.mr_n69222656)
print v(xbgr.mr_n69223520)
print v(xbgr.mr_n69224384)
print v(xbgr.mr_n69224496)
print v(xbgr.mr_n69224816)
print v(xbgr.mr_n69224928)
print v(xbgr.mr_n69225248)
print v(xbgr.mr_n69225360)
print v(xbgr.mr_n69225680)
print v(xbgr.mr_n69225792)
print v(xbgr.mr_n69226112)
print v(xbgr.mr_n69226224)
print v(xbgr.mr_n69226544)
print v(xbgr.mr_n69226656)
print v(xbgr.mr_n69228272)
print v(xbgr.mr_n69229248)
print v(xbgr.mr_n69229680)
print v(xbgr.mr_n69230112)
print v(xbgr.mr_n69230432)
print v(xbgr.mr_n69230544)
print v(xbgr.mr_n69230864)
print v(xbgr.mr_n69230976)
print v(xbgr.mr_n69231296)
print v(xbgr.mr_n69231408)
print v(xbgr.mr_n69231728)
print v(xbgr.mr_n69231840)
print v(xbgr.mr_n69232160)
print v(xbgr.mr_n69232272)
print v(xbgr.mr_n69232592)
print v(xbgr.mr_n69232704)
print v(xbgr.mr_n69233024)
print v(xbgr.mr_n69233136)
print v(xbgr.mr_n69233568)
print v(xbgr.mr_n69233888)
print v(xbgr.mr_n69234000)
print v(xbgr.mr_n69234432)
print v(xbgr.mr_n69234864)
print v(xbgr.mr_n69236048)
print v(xbgr.mr_n69236160)
print v(xbgr.mr_n69236480)
print v(xbgr.mr_n69236592)
print v(xbgr.mr_n69236912)
print v(xbgr.mr_n69237024)
print v(xbgr.mr_n69237344)
print v(xbgr.mr_n69237456)
print v(xbgr.mr_n69237776)
print v(xbgr.mr_n69237888)
print v(xbgr.mr_n69238208)
print v(xbgr.mr_n69238640)
print v(xbgr.mr_n69238752)
print v(xbgr.mr_n69239072)
print v(xbgr.mr_n69239184)
print v(xbgr.mr_n69239504)
print v(xbgr.mr_n69239616)
print v(xbgr.mr_n69239936)
print v(xbgr.mr_n69240048)
print v(xbgr.mr_n69240480)
print v(xbgr.mr_n69240800)
print v(xbgr.mr_n69241232)
print v(xbgr.mr_n69242096)
print v(xbgr.mr_n69242208)
print v(xbgr.mr_n69242528)
print v(xbgr.mr_n69242960)
print v(xbgr.mr_n69243392)
print v(xbgr.mr_n69243936)
print v(xbgr.mr_n69244256)
print v(xbgr.mr_n69245120)
print v(xbgr.mr_n69245232)
print v(xbgr.mr_n69245552)
print v(xbgr.mr_n69245664)
print v(xbgr.mr_n69246096)
print v(xbgr.mr_n69246848)
print v(xbgr.mr_n69247280)
print v(xbgr.mr_n69247712)
print v(xbgr.mr_n69248144)
print v(xbgr.mr_n69248256)
print v(xbgr.mr_n69249440)
print v(xbgr.mr_n69250304)
print v(xbgr.mr_n69251280)
print v(xbgr.mr_n69251600)
print v(xbgr.mr_n69251712)
print v(xbgr.mr_n69252144)
print v(xbgr.mr_n69252464)
print v(xbgr.mr_n69252576)
print v(xbgr.mr_n69252896)
print v(xbgr.mr_n69253008)
print v(xbgr.mr_n69253328)
print v(xbgr.mr_n69253440)
print v(xbgr.mr_n69253760)
print v(xbgr.mr_n69253872)
print v(xbgr.mr_n69254192)
print v(xbgr.mr_n69254304)
print v(xbgr.mr_n69254624)
print v(xbgr.mr_n69254736)
print v(xbgr.mr_n69255168)
print v(xbgr.mr_n69255600)
print v(xbgr.mr_n69256032)
print v(xbgr.mr_n69256784)
print v(xbgr.mr_n69257216)
print v(xbgr.mr_n69258080)
print v(xbgr.mr_n69258944)
print v(xbgr.mr_n69260672)
print v(xbgr.mr_n69261536)
print v(xbgr.mr_n69261648)
print v(xbgr.mr_n69262400)
print v(xbgr.mr_n69262512)
print v(xbgr.mr_n69262832)
print v(xbgr.mr_n69262944)
print v(xbgr.mr_n69263264)
print v(xbgr.mr_n69263376)
print v(xbgr.mr_n69265424)
print v(xbgr.mr_n69265536)
print v(xbgr.mr_n69265856)
print v(xbgr.mr_n69265968)
print v(xbgr.mr_n69266288)
print v(xbgr.mr_n69266400)
print v(xbgr.mr_n69266720)
print v(xbgr.mr_n69266832)
print v(xbgr.mr_n69267152)
print v(xbgr.mr_n69267264)
print v(xbgr.mr_n69267584)
print v(xbgr.mr_n69267696)
print v(xbgr.mr_n69268016)
print v(xbgr.mr_n69268128)
print v(xbgr.mr_n69268560)
print v(xbgr.mr_n69268880)
print v(xbgr.mr_n69268992)
print v(xbgr.mr_n69269424)
print v(xbgr.mr_n69269744)
print v(xbgr.mr_n69269856)
print v(xbgr.mr_n69270288)
print v(xbgr.mr_n69270608)
print v(xbgr.mr_n69270720)
print v(xbgr.mr_n69271040)
print v(xbgr.mr_n69271152)
print v(xbgr.mr_n69271472)
print v(xbgr.mr_n69271584)
print v(xbgr.mr_n69271904)
print v(xbgr.mr_n69272016)
print v(xbgr.mr_n69272336)
print v(xbgr.mr_n69272448)
print v(xbgr.mr_n69272768)
print v(xbgr.mr_n69272880)
print v(xbgr.mr_n69273200)
print v(xbgr.mr_n69273312)
print v(xbgr.mr_n69273632)
print v(xbgr.mr_n69273744)
print v(xbgr.mr_n69274064)
print v(xbgr.mr_n69274176)
print v(xbgr.mr_n69274496)
print v(xbgr.mr_n69274608)
print v(xbgr.mr_n69274928)
print v(xbgr.mr_n69275040)
print v(xbgr.mr_n69275360)
print v(xbgr.mr_n69275472)
print v(xbgr.mr_n69275792)
print v(xbgr.mr_n69275904)
print v(xbgr.mr_n69276224)
print v(xbgr.mr_n69276336)
print v(xbgr.mr_n69276656)
print v(xbgr.mr_n69276768)
print v(xbgr.mr_n69277088)
print v(xbgr.mr_n69277200)
print v(xbgr.mr_n69277520)
print v(xbgr.mr_n69277632)
print v(xbgr.mr_n69277952)
print v(xbgr.mr_n69278064)
print v(xbgr.mr_n69278496)
print v(xbgr.mr_n69278816)
print v(xbgr.mr_n69278928)
print v(xbgr.mr_n69279360)
print v(xbgr.mr_n69279680)
print v(xbgr.mr_n69279792)
print v(xbgr.mr_n69280224)
print v(xbgr.mr_n69280544)
print v(xbgr.mr_n69281408)
print v(xbgr.mr_n69282272)
print v(xbgr.mr_n69283136)
print v(xbgr.mr_n69284000)
print v(xbgr.mr_n69284864)
print v(xbgr.mr_n69285728)
print v(xbgr.mr_n69285840)
print v(xbgr.mr_n69286160)
print v(xbgr.mr_n69286272)
print v(xbgr.mr_n69286592)
print v(xbgr.mr_n69286704)
print v(xbgr.mr_n69287024)
print v(xbgr.mr_n69287136)
print v(xbgr.mr_n69287456)
print v(xbgr.mr_n69287568)
print v(xbgr.mr_n69287888)
print v(xbgr.mr_n69288000)
print v(xbgr.mr_n69288320)
print v(xbgr.mr_n69289184)
print v(xbgr.mr_n69290048)
print v(xbgr.mr_n69290912)
print v(xbgr.mr_n69291024)
print v(xbgr.mr_n69291344)
print v(xbgr.mr_n69291456)
print v(xbgr.mr_n69291776)
print v(xbgr.mr_n69291888)
print v(xbgr.mr_n69292320)
print v(xbgr.mr_n69292752)
print v(xbgr.mr_n69293184)
print v(xbgr.mr_n69293504)
print v(xbgr.mr_n69293616)
print v(xbgr.mr_n69294048)
print v(xbgr.mr_n69294368)
print v(xbgr.mr_n69294480)
print v(xbgr.mr_n69294800)
print v(xbgr.mr_n69294912)
print v(xbgr.mr_n69295232)
print v(xbgr.mr_n69295344)
print v(xbgr.mr_n69295664)
print v(xbgr.mr_n69295776)
print v(xbgr.mr_n69296096)
print v(xbgr.mr_n69296208)
print v(xbgr.mr_n69296528)
print v(xbgr.mr_n69296640)
print v(xbgr.mr_n69297072)
print v(xbgr.mr_n69297504)
print v(xbgr.mr_n69297824)
print v(xbgr.mr_n69297936)
print v(xbgr.mr_n69298368)
print v(xbgr.mr_n69298688)
print v(xbgr.mr_n69298800)
print v(xbgr.mr_n69299232)
print v(xbgr.mr_n69299552)
print v(xbgr.mr_n69299664)
print v(xbgr.mr_n69300096)
print v(xbgr.mr_n69300416)
print v(xbgr.mr_n69301280)
print v(xbgr.mr_n69302144)
print v(xbgr.mr_n69303008)
print v(xbgr.mr_n69303872)
print v(xbgr.mr_n69304736)
print v(xbgr.mr_n69304848)
print v(xbgr.mr_n69305168)
print v(xbgr.mr_n69305280)
print v(xbgr.mr_n69305600)
print v(xbgr.mr_n69305712)
print v(xbgr.mr_n69306032)
print v(xbgr.mr_n69306144)
print v(xbgr.mr_n69306464)
print v(xbgr.mr_n69307328)
print v(xbgr.mr_n69308192)
print v(xbgr.mr_n69309056)
print v(xbgr.mr_n69309168)
print v(xbgr.mr_n69309488)
print v(xbgr.mr_n69309600)
print v(xbgr.mr_n69309920)
print v(xbgr.mr_n69310032)
print v(xbgr.mr_n69310352)
print v(xbgr.mr_n69310464)
print v(xbgr.mr_n69310784)
print v(xbgr.mr_n69310896)
print v(xbgr.mr_n69311216)
print v(xbgr.mr_n69311328)
print v(xbgr.mr_n69311648)
print v(xbgr.mr_n69312512)
print v(xbgr.mr_n69313376)
print v(xbgr.mr_n69314240)
print v(xbgr.mr_n69315104)
print v(xbgr.mr_n69315968)
print v(xbgr.mr_n69316832)
print v(xbgr.mr_n69317696)
print v(xbgr.mr_n69318560)
print v(xbgr.mr_n69319424)
print v(xbgr.mr_n69319536)
print v(xbgr.mr_n69319856)
print v(xbgr.mr_n69319968)
print v(xbgr.mr_n69320288)
print v(xbgr.mr_n69320400)
print v(xbgr.mr_n69320720)
print v(xbgr.mr_n69320832)
print v(xbgr.mr_n69321152)
print v(xbgr.mr_n69321264)
print v(xbgr.mr_n69321584)
print v(xbgr.mr_n69321696)
print v(xbgr.mr_n69322016)
print v(xbgr.mr_n69322128)
print v(xbgr.mr_n69322448)
print v(xbgr.mr_n69322560)
print v(xbgr.mr_n69322880)
print v(xbgr.mr_n69322992)
print v(xbgr.mr_n69323312)
print v(xbgr.mr_n69323424)
print v(xbgr.mr_n69323744)
print v(xbgr.mr_n69324608)
print v(xbgr.mr_n69324720)
print v(xbgr.mr_n69325040)
print v(xbgr.mr_n69325152)
print v(xbgr.mr_n69325472)
print v(xbgr.mr_n69325584)
print v(xbgr.mr_n69325904)
print v(xbgr.mr_n69326016)
print v(xbgr.mr_n69326336)
print v(xbgr.mr_n69326448)
print v(xbgr.mr_n69326768)
print v(xbgr.mr_n69326880)
print v(xbgr.mr_n69327200)
print v(xbgr.mr_n69327312)
print v(xbgr.mr_n69327632)
print v(xbgr.mr_n69327744)
print v(xbgr.mr_n69328064)
print v(xbgr.mr_n69328176)
print v(xbgr.mr_n69328496)
print v(xbgr.mr_n69328608)
print v(xbgr.mr_n69328928)
print v(xbgr.mr_n69329040)
print v(xbgr.mr_n69329472)
print v(xbgr.mr_n69329792)
print v(xbgr.mr_n69329904)
print v(xbgr.mr_n69330336)
print v(xbgr.mr_n69330656)
print v(xbgr.mr_n69330768)
print v(xbgr.mr_n69331200)
print v(xbgr.mr_n69331520)
print v(xbgr.mr_n69331632)
print v(xbgr.mr_n69332064)
print v(xbgr.mr_n69332384)
print v(xbgr.mr_n69332496)
print v(xbgr.mr_n69332816)
print v(xbgr.mr_n69332928)
print v(xbgr.mr_n69333360)
print v(xbgr.mr_n69333792)
print v(xbgr.mr_n69334112)
print v(xbgr.mr_n69334224)
print v(xbgr.mr_n69334544)
print v(xbgr.mr_n69334656)
print v(xbgr.mr_n69334976)
print v(xbgr.mr_n69335088)
print v(xbgr.mr_n69335408)
print v(xbgr.mr_n69335520)
print v(xbgr.mr_n69335840)
print v(xbgr.mr_n69335952)
print v(xbgr.mr_n69336384)
print v(xbgr.mr_n69336704)
print v(xbgr.mr_n69336816)
print v(xbgr.mr_n69337248)
print v(xbgr.mr_n69337568)
print v(xbgr.mr_n69338432)
print v(xbgr.mr_n69339296)
print v(xbgr.mr_n69340160)
print v(xbgr.mr_n69341024)
print v(xbgr.mr_n69341136)
print v(xbgr.mr_n69341456)
print v(xbgr.mr_n69341568)
print v(xbgr.mr_n69341888)
print v(xbgr.mr_n69342000)
print v(xbgr.mr_n69342320)
print v(xbgr.mr_n69342432)
print v(xbgr.mr_n69342752)
print v(xbgr.mr_n69343616)
print v(xbgr.mr_n69344480)
print v(xbgr.mr_n69344592)
print v(xbgr.mr_n69344912)
print v(xbgr.mr_n69345024)
print v(xbgr.mr_n69345456)
print v(xbgr.mr_n69345888)
print v(xbgr.mr_n69346208)
print v(xbgr.mr_n69346320)
print v(xbgr.mr_n69346640)
print v(xbgr.mr_n69346752)
print v(xbgr.mr_n69347072)
print v(xbgr.mr_n69347184)
print v(xbgr.mr_n69347504)
print v(xbgr.mr_n69347616)
print v(xbgr.mr_n69347936)
print v(xbgr.mr_n69348048)
print v(xbgr.mr_n69348480)
print v(xbgr.mr_n69348800)
print v(xbgr.mr_n69348912)
print v(xbgr.mr_n69349344)
print v(xbgr.mr_n69349664)
print v(xbgr.mr_n69349776)
print v(xbgr.mr_n69350096)
print v(xbgr.mr_n69350208)
print v(xbgr.mr_n69350528)
print v(xbgr.mr_n69350640)
print v(xbgr.mr_n69350960)
print v(xbgr.mr_n69351072)
print v(xbgr.mr_n69351392)
print v(xbgr.mr_n69351504)
print v(xbgr.mr_n69351824)
print v(xbgr.mr_n69351936)
print v(xbgr.mr_n69352256)
print v(xbgr.mr_n69352368)
print v(xbgr.mr_n69352688)
print v(xbgr.mr_n69352800)
print v(xbgr.mr_n69353120)
print v(xbgr.mr_n69353232)
print v(xbgr.mr_n69353552)
print v(xbgr.mr_n69353664)
print v(xbgr.mr_n69353984)
print v(xbgr.mr_n69354848)
print v(xbgr.mr_n69355712)
print v(xbgr.mr_n69356576)
print v(xbgr.mr_n69357440)
print v(xbgr.mr_n69357552)
print v(xbgr.mr_n69357872)
print v(xbgr.mr_n69357984)
print v(xbgr.mr_n69358304)
print v(xbgr.mr_n69358416)
print v(xbgr.mr_n69358736)
print v(xbgr.mr_n69358848)
print v(xbgr.mr_n69359280)
print v(xbgr.mr_n69359712)
print v(xbgr.mr_n69360144)
print v(xbgr.mr_n69360576)
print v(xbgr.mr_n69360896)
print v(xbgr.mr_n69361008)
print v(xbgr.mr_n69361328)
print v(xbgr.mr_n69361440)
print v(xbgr.mr_n69361760)
print v(xbgr.mr_n69361872)
print v(xbgr.mr_n69362192)
print v(xbgr.mr_n69362304)
print v(xbgr.mr_n69362624)
print v(xbgr.mr_n69363488)
print v(xbgr.mr_n69364352)
print v(xbgr.mr_n69364464)
print v(xbgr.mr_n69364896)
print v(xbgr.mr_n69365216)
print v(xbgr.mr_n69366080)
print v(xbgr.mr_n69366192)
print v(xbgr.mr_n69366512)
print v(xbgr.mr_n69366624)
print v(xbgr.mr_n69366944)
print v(xbgr.mr_n69367056)
print v(xbgr.mr_n69367376)
print v(xbgr.mr_n69367488)
print v(xbgr.mr_n69367808)
print v(xbgr.mr_n69368672)
print v(xbgr.mr_n69368784)
print v(xbgr.mr_n69369216)
print v(xbgr.mr_n69369536)
print v(xbgr.mr_n69369648)
print v(xbgr.mr_n69369968)
print v(xbgr.mr_n69370080)
print v(xbgr.mr_n69370400)
print v(xbgr.mr_n69370512)
print v(xbgr.mr_n69370832)
print v(xbgr.mr_n69370944)
print v(xbgr.mr_n69371264)
print v(xbgr.mr_n69372128)
print v(xbgr.mr_n69372560)
print v(xbgr.mr_n69372672)
print v(xbgr.mr_n69372992)
print v(xbgr.mr_n69373104)
print v(xbgr.mr_n69373424)
print v(xbgr.mr_n69373856)
print v(xbgr.mr_n69374720)
print v(xbgr.mr_n69375584)
print v(xbgr.mr_n69375696)
print v(xbgr.mr_n69376448)
print v(xbgr.mr_n69376560)
print v(xbgr.mr_n69376880)
print v(xbgr.mr_n69376992)
print v(xbgr.mr_n69377312)
print v(xbgr.mr_n69378176)
print v(xbgr.mr_n69379040)
print v(xbgr.mr_n69379152)
print v(xbgr.mr_n69379472)
print v(xbgr.mr_n69379584)
print v(xbgr.mr_n69379904)
print v(xbgr.mr_n69380768)
print v(xbgr.mr_n69380880)
print v(xbgr.mr_n69381200)
print v(xbgr.mr_n69381312)
print v(xbgr.mr_n69381632)
print v(xbgr.mr_n69381744)
print v(xbgr.mr_n69382064)
print v(xbgr.mr_n69382176)
print v(xbgr.mr_n69382496)
print v(xbgr.mr_n69382608)
print v(xbgr.mr_n69383360)
print v(xbgr.mr_n69384224)
print v(xbgr.mr_n69385088)
print v(xbgr.mr_n69385200)
print v(xbgr.mr_n69385520)
print v(xbgr.mr_n69385632)
print v(xbgr.mr_n69385952)
print v(xbgr.mr_n69386064)
print v(xbgr.mr_n69386384)
print v(xbgr.mr_n69386496)
print v(xbgr.mr_n69386816)
print v(xbgr.mr_n69386928)
print v(xbgr.mr_n69387248)
print v(xbgr.mr_n69387360)
print v(xbgr.mr_n69387680)
print v(xbgr.mr_n69387792)
print v(xbgr.mr_n69388224)
print v(xbgr.mr_n69388544)
print v(xbgr.mr_n69388656)
print v(xbgr.mr_n69388976)
print v(xbgr.mr_n69389088)
print v(xbgr.mr_n69389408)
print v(xbgr.mr_n69390272)
print v(xbgr.mr_n69391136)
print v(xbgr.mr_n69392000)
print v(xbgr.mr_n69392864)
print v(xbgr.mr_n69393296)
print v(xbgr.mr_n69393408)
print v(xbgr.mr_n69393728)
print v(xbgr.mr_n69393840)
print v(xbgr.mr_n69394160)
print v(xbgr.mr_n69394272)
print v(xbgr.mr_n69394704)
print v(xbgr.mr_n69395456)
print v(xbgr.mr_n69395568)
print v(xbgr.mr_n69395888)
print v(xbgr.mr_n69396000)
print v(xbgr.mr_n69396320)
print v(xbgr.mr_n69397184)
print v(xbgr.mr_n69398048)
print v(xbgr.mr_n69398160)
print v(xbgr.mr_n69398480)
print v(xbgr.mr_n69398592)
print v(xbgr.mr_n69398912)
print v(xbgr.mr_n69399776)
print v(xbgr.mr_n69400640)
print v(xbgr.mr_n69401504)
print v(xbgr.mr_n69401616)
print v(xbgr.mr_n69401936)
print v(xbgr.mr_n69402048)
print v(xbgr.mr_n69402368)
print v(xbgr.mr_n69403232)
print v(xbgr.mr_n69404096)
print v(xbgr.mr_n69404208)
print v(xbgr.mr_n69404528)
print v(xbgr.mr_n69404640)
print v(xbgr.mr_n69404960)
print v(xbgr.mr_n69405072)
print v(xbgr.mr_n69405392)
print v(xbgr.mr_n69405504)
print v(xbgr.mr_n69405824)
print v(xbgr.mr_n69405936)
print v(xbgr.mr_n69406256)
print v(xbgr.mr_n69406368)
print v(xbgr.mr_n69406688)
print v(xbgr.mr_n69406800)
print v(xbgr.mr_n69407120)
print v(xbgr.mr_n69407232)
print v(xbgr.mr_n69407552)
print v(xbgr.mr_n69407664)
print v(xbgr.mr_n69407984)
print v(xbgr.mr_n69408096)
print v(xbgr.mr_n69408416)
print v(xbgr.mr_n69408528)
print v(xbgr.mr_n69408848)
print v(xbgr.mr_n69408960)
print v(xbgr.mr_n69409280)
print v(xbgr.mr_n69409392)
print v(xbgr.mr_n69409712)
print v(xbgr.mr_n69409824)
print v(xbgr.mr_n69410144)
print v(xbgr.mr_n69410256)
print v(xbgr.mr_n69410576)
print v(xbgr.mr_n69410688)
print v(xbgr.mr_n69411008)
print v(xbgr.mr_n69411120)
print v(xbgr.mr_n69411440)
print v(xbgr.mr_n69411552)
print v(xbgr.mr_n69411872)
print v(xbgr.mr_n69411984)
print v(xbgr.mr_n69412304)
print v(xbgr.mr_n69412416)
print v(xbgr.mr_n69412736)
print v(xbgr.mr_n69412848)
print v(xbgr.mr_n69413168)
print v(xbgr.mr_n69413280)
print v(xbgr.mr_n69413600)
print v(xbgr.mr_n69413712)
print v(xbgr.mr_n69414032)
print v(xbgr.mr_n69414144)
print v(xbgr.mr_n69414464)
print v(xbgr.mr_n69414576)
print v(xbgr.mr_n69414896)
print v(xbgr.mr_n69415008)
print v(xbgr.mr_n69415440)
print v(xbgr.mr_n69415872)
print v(xbgr.mr_n69416304)
print v(xbgr.mr_n69416736)
print v(xbgr.mr_n69417168)
print v(xbgr.mr_n69417600)
print v(xbgr.mr_n69418032)
print v(xbgr.mr_n69418464)
print v(xbgr.mr_n69418896)
print v(xbgr.mr_n69419328)
print v(xbgr.mr_n69419760)
print v(xbgr.mr_n69420192)
print v(xbgr.mr_n69420624)
print v(xbgr.mr_n69421056)
print v(xbgr.mr_n69421488)
print v(xbgr.mr_n69421920)
print v(xbgr.mr_n69422352)
print v(xbgr.mr_n69422784)
print v(xbgr.mr_n69423216)
print v(xbgr.mr_n69423648)
print v(xbgr.mr_n69424080)
print v(xbgr.mr_n69424512)
print v(xbgr.mr_n69424944)
print v(xbgr.mr_n69425376)
print v(xbgr.mr_n69425808)
print v(xbgr.mr_n69426240)
print v(xbgr.mr_n69426560)
print v(xbgr.mr_n69426672)
print v(xbgr.mr_n69426992)
print v(xbgr.mr_n69427104)
print v(xbgr.mr_n69427424)
print v(xbgr.mr_n69427536)
print v(xbgr.mr_n69427856)
print v(xbgr.mr_n69427968)
print v(xbgr.mr_n69428288)
print v(xbgr.mr_n69428400)
print v(xbgr.mr_n69428720)
print v(xbgr.mr_n69428832)
print v(xbgr.mr_n69429152)
print v(xbgr.mr_n69429264)
print v(xbgr.mr_n69429584)
print v(xbgr.mr_n69429696)
print v(xbgr.mr_n69430016)
print v(xbgr.mr_n69430128)
print v(xbgr.mr_n69430448)
print v(xbgr.mr_n69430560)
print v(xbgr.mr_n69430880)
print v(xbgr.mr_n69430992)
print v(xbgr.mr_n69431312)
print v(xbgr.mr_n69431424)
print v(xbgr.mr_n69431744)
print v(xbgr.mr_n69431856)
print v(xbgr.mr_n69432176)
print v(xbgr.mr_n69432288)
print v(xbgr.mr_n69432608)
print v(xbgr.mr_n69432720)
print v(xbgr.mr_n69433040)
print v(xbgr.mr_n69433152)
print v(xbgr.mr_n69433472)
print v(xbgr.mr_n69433584)
print v(xbgr.mr_n69433904)
print v(xbgr.mr_n69434016)
print v(xbgr.mr_n69434336)
print v(xbgr.mr_n69434448)
print v(xbgr.mr_n69434768)
print v(xbgr.mr_n69434880)
print v(xbgr.mr_n69435200)
print v(xbgr.mr_n69435312)
print v(xbgr.mr_n69435632)
print v(xbgr.mr_n69435744)
print v(xbgr.mr_n69436064)
print v(xbgr.mr_n69436176)
print v(xbgr.mr_n69436496)
print v(xbgr.mr_n69436608)
print v(xbgr.mr_n69437040)
print v(xbgr.mr_n69437472)
print v(xbgr.mr_n69437904)
print v(xbgr.mr_n69438336)
print v(xbgr.mr_n69438656)
print v(xbgr.mr_n69438768)
print v(xbgr.mr_n69439088)
print v(xbgr.mr_n69439200)
print v(xbgr.mr_n69439632)
print v(xbgr.mr_n69440064)
print v(xbgr.mr_n69440496)
print v(xbgr.mr_n69440928)
print v(xbgr.mr_n69441360)
print v(xbgr.mr_n69441792)
print v(xbgr.mr_n69442224)
print v(xbgr.mr_n69442656)
print v(xbgr.mr_n69443088)
print v(xbgr.mr_n69443520)
print v(xbgr.mr_n69443952)
print v(xbgr.mr_n69444384)
print v(xbgr.mr_n69444816)
print v(xbgr.mr_n69445248)
print v(xbgr.mr_n69445680)
print v(xbgr.mr_n69446112)
print v(xbgr.mr_n69446544)
print v(xbgr.mr_n69446976)
print v(xbgr.mr_n69447408)
print v(xbgr.mr_n69447840)
print v(xbgr.mr_n69448272)
print v(xbgr.mr_n69448704)
print v(xbgr.mr_n69449024)
print v(xbgr.mr_n69449136)
print v(xbgr.mr_n69449568)
print v(xbgr.mr_n69449888)
print v(xbgr.mr_n69450000)
print v(xbgr.mr_n69450432)
print v(xbgr.mr_n69450752)
print v(xbgr.mr_n69450864)
print v(xbgr.mr_n69451296)
print v(xbgr.mr_n69451616)
print v(xbgr.mr_n69451728)
print v(xbgr.mr_n69452160)
print v(xbgr.mr_n69452480)
print v(xbgr.mr_n69452592)
print v(xbgr.mr_n69453024)
print v(xbgr.mr_n69453344)
print v(xbgr.mr_n69453456)
print v(xbgr.mr_n69453776)
print v(xbgr.mr_n69453888)
print v(xbgr.mr_n69454208)
print v(xbgr.mr_n69454320)
print v(xbgr.mr_n69454752)
print v(xbgr.mr_n69455184)
print v(xbgr.mr_n69455616)
print v(xbgr.mr_n69455936)
print v(xbgr.mr_n69456048)
print v(xbgr.mr_n69456368)
print v(xbgr.mr_n69456480)
print v(xbgr.mr_n69456800)
print v(xbgr.mr_n69456912)
print v(xbgr.mr_n69457232)
print v(xbgr.mr_n69457344)
print v(xbgr.mr_n69457664)
print v(xbgr.mr_n69457776)
print v(xbgr.mr_n69458096)
print v(xbgr.mr_n69458208)
print v(xbgr.mr_n69458528)
print v(xbgr.mr_n69458640)
print v(xbgr.mr_n69459072)
print v(xbgr.mr_n69459392)
print v(xbgr.mr_n69459504)
print v(xbgr.mr_n69459936)
print v(xbgr.mr_n69460256)
print v(xbgr.mr_n69460368)
print v(xbgr.mr_n69460800)
print v(xbgr.mr_n69461120)
print v(xbgr.mr_n69461984)
print v(xbgr.mr_n69462848)
print v(xbgr.mr_n69463712)
print v(xbgr.mr_n69464576)
print v(xbgr.mr_n69465440)
print v(xbgr.mr_n69466304)
print v(xbgr.mr_n69466416)
print v(xbgr.mr_n69466736)
print v(xbgr.mr_n69466848)
print v(xbgr.mr_n69467168)
print v(xbgr.mr_n69467280)
print v(xbgr.mr_n69467600)
print v(xbgr.mr_n69467712)
print v(xbgr.mr_n69468032)
print v(xbgr.mr_n69468896)
print v(xbgr.mr_n69469760)
print v(xbgr.mr_n69470624)
print v(xbgr.mr_n69470736)
print v(xbgr.mr_n69471056)
print v(xbgr.mr_n69471168)
print v(xbgr.mr_n69471488)
print v(xbgr.mr_n69471600)
print v(xbgr.mr_n69472032)
print v(xbgr.mr_n69472464)
print v(xbgr.mr_n69472896)
print v(xbgr.mr_n69473216)
print v(xbgr.mr_n69473328)
print v(xbgr.mr_n69473648)
print v(xbgr.mr_n69473760)
print v(xbgr.mr_n69474080)
print v(xbgr.mr_n69474192)
print v(xbgr.mr_n69474512)
print v(xbgr.mr_n69474624)
print v(xbgr.mr_n69474944)
print v(xbgr.mr_n69475056)
print v(xbgr.mr_n69475376)
print v(xbgr.mr_n69475488)
print v(xbgr.mr_n69475808)
print v(xbgr.mr_n69475920)
print v(xbgr.mr_n69476240)
print v(xbgr.mr_n69476352)
print v(xbgr.mr_n69476672)
print v(xbgr.mr_n69476784)
print v(xbgr.mr_n69477216)
print v(xbgr.mr_n69477536)
print v(xbgr.mr_n69477648)
print v(xbgr.mr_n69478080)
print v(xbgr.mr_n69478400)
print v(xbgr.mr_n69478512)
print v(xbgr.mr_n69478832)
print v(xbgr.mr_n69478944)
print v(xbgr.mr_n69479264)
print v(xbgr.mr_n69480128)
print v(xbgr.mr_n69480992)
print v(xbgr.mr_n69481104)
print v(xbgr.mr_n69481424)
print v(xbgr.mr_n69481536)
print v(xbgr.mr_n69481856)
print v(xbgr.mr_n69482720)
print v(xbgr.mr_n69483264)
print v(xbgr.mr_n69483696)
print v(xbgr.mr_n69484448)
print v(xbgr.mr_n69485312)
print v(xbgr.mr_n69485424)
print v(xbgr.mr_n69485744)
print v(xbgr.mr_n69485856)
print v(xbgr.mr_n69486176)
print v(xbgr.mr_n69486288)
print v(xbgr.mr_n69486608)
print v(xbgr.mr_n69486720)
print v(xbgr.mr_n69487040)
print v(xbgr.mr_n69487152)
print v(xbgr.mr_n69487472)
print v(xbgr.mr_n69487584)
print v(xbgr.mr_n69487904)
print v(xbgr.mr_n69488016)
print v(xbgr.mr_n69488336)
print v(xbgr.mr_n69488448)
print v(xbgr.mr_n69488768)
print v(xbgr.mr_n69489632)
print v(xbgr.mr_n69489744)
print v(xbgr.mr_n69490064)
print v(xbgr.mr_n69490176)
print v(xbgr.mr_n69490496)
print v(xbgr.mr_n69491360)
print v(xbgr.mr_n69492224)
print v(xbgr.mr_n69492336)
print v(xbgr.mr_n69492656)
print v(xbgr.mr_n69492768)
print v(xbgr.mr_n69493088)
print v(xbgr.mr_n69493200)
print v(xbgr.mr_n69493632)
print v(xbgr.mr_n69493952)
print v(xbgr.mr_n69494384)
print v(xbgr.mr_n69495680)
print v(xbgr.mr_n69495792)
print v(xbgr.mr_n69496112)
print v(xbgr.mr_n69496224)
print v(xbgr.mr_n69496544)
print v(xbgr.mr_n69496656)
print v(xbgr.mr_n69496976)
print v(xbgr.mr_n69497088)
print v(xbgr.mr_n69497408)
print v(xbgr.mr_n69497520)
print v(xbgr.mr_n69497952)
print v(xbgr.mr_n69498272)
print v(xbgr.mr_n69498384)
print v(xbgr.mr_n69498704)
print v(xbgr.mr_n69498816)
print v(xbgr.mr_n69499136)
print v(xbgr.mr_n69499248)
print v(xbgr.mr_n69499568)
print v(xbgr.mr_n69499680)
print v(xbgr.mr_n69500000)
print v(xbgr.mr_n69500864)
print v(xbgr.mr_n69501728)
print v(xbgr.mr_n69502592)
print v(xbgr.mr_n69503456)
print v(xbgr.mr_n69503568)
print v(xbgr.mr_n69503888)
print v(xbgr.mr_n69504000)
print v(xbgr.mr_n69504320)
print v(xbgr.mr_n69504432)
print v(xbgr.mr_n69504752)
print v(xbgr.mr_n69504864)
print v(xbgr.mr_n69505184)
print v(xbgr.mr_n69506048)
print v(xbgr.mr_n69506912)
print v(xbgr.mr_n69507776)
print v(xbgr.mr_n69508640)
print v(xbgr.mr_n69509072)
print v(xbgr.mr_n69509184)
print v(xbgr.mr_n69509504)
print v(xbgr.mr_n69509616)
print v(xbgr.mr_n69509936)
print v(xbgr.mr_n69510048)
print v(xbgr.mr_n69510368)
print v(xbgr.mr_n69510480)
print v(xbgr.mr_n69510800)
print v(xbgr.mr_n69510912)
print v(xbgr.mr_n69511232)
print v(xbgr.mr_n69511344)
print v(xbgr.mr_n69511664)
print v(xbgr.mr_n69511776)
print v(xbgr.mr_n69512096)
print v(xbgr.mr_n69512208)
print v(xbgr.mr_n69512640)
print v(xbgr.mr_n69512960)
print v(xbgr.mr_n69513072)
print v(xbgr.mr_n69513504)
print v(xbgr.mr_n69513824)
print v(xbgr.mr_n69513936)
print v(xbgr.mr_n69514368)
print v(xbgr.mr_n69514688)
print v(xbgr.mr_n69514800)
print v(xbgr.mr_n69515120)
print v(xbgr.mr_n69515232)
print v(xbgr.mr_n69515552)
print v(xbgr.mr_n69516416)
print v(xbgr.mr_n69517280)
print v(xbgr.mr_n69518144)
print v(xbgr.mr_n69519008)
print v(xbgr.mr_n69519872)
print v(xbgr.mr_n69520736)
print v(xbgr.mr_n69521600)
print v(xbgr.mr_n69522464)
print v(xbgr.mr_n69523328)
print v(xbgr.mr_n69523440)
print v(xbgr.mr_n69523760)
print v(xbgr.mr_n69523872)
print v(xbgr.mr_n69524192)
print v(xbgr.mr_n69525056)
print v(xbgr.mr_n69525168)
print v(xbgr.mr_n69525488)
print v(xbgr.mr_n69525600)
print v(xbgr.mr_n69525920)
print v(xbgr.mr_n69526032)
print v(xbgr.mr_n69526352)
print v(xbgr.mr_n69526464)
print v(xbgr.mr_n69526784)
print v(xbgr.mr_n69526896)
print v(xbgr.mr_n69527216)
print v(xbgr.mr_n69527328)
print v(xbgr.mr_n69527648)
print v(xbgr.mr_n69527760)
print v(xbgr.mr_n69528080)
print v(xbgr.mr_n69528192)
print v(xbgr.mr_n69528512)
print v(xbgr.mr_n69529376)
print v(xbgr.mr_n69530240)
print v(xbgr.mr_n69531104)
print v(xbgr.mr_n69531216)
print v(xbgr.mr_n69531536)
print v(xbgr.mr_n69532832)
print v(xbgr.mr_n69533696)
print v(xbgr.mr_n69534560)
print v(xbgr.mr_n69535424)
print v(xbgr.mr_n69535536)
print v(xbgr.mr_n69535856)
print v(xbgr.mr_n69535968)
print v(xbgr.mr_n69536400)
print v(xbgr.mr_n69536720)
print v(xbgr.mr_n69536832)
print v(xbgr.mr_n69537264)
print v(xbgr.mr_n69537584)
print v(xbgr.mr_n69537696)
print v(xbgr.mr_n69538128)
print v(xbgr.mr_n69538448)
print v(xbgr.mr_n69538560)
print v(xbgr.mr_n69538992)
print v(xbgr.mr_n69539312)
print v(xbgr.mr_n69539424)
print v(xbgr.mr_n69539856)
print v(xbgr.mr_n69540176)
print v(xbgr.mr_n69540288)
print v(xbgr.mr_n69540608)
print v(xbgr.mr_n69540720)
print v(xbgr.mr_n69541040)
print v(xbgr.mr_n69541152)
print v(xbgr.mr_n69541584)
print v(xbgr.mr_n69541904)
print v(xbgr.mr_n69542016)
print v(xbgr.mr_n69542336)
print v(xbgr.mr_n69542448)
print v(xbgr.mr_n69542768)
print v(xbgr.mr_n69542880)
print v(xbgr.mr_n69543200)
print v(xbgr.mr_n69543312)
print v(xbgr.mr_n69543632)
print v(xbgr.mr_n69543744)
print v(xbgr.mr_n69544064)
print v(xbgr.mr_n69544176)
print v(xbgr.mr_n69544496)
print v(xbgr.mr_n69544608)
print v(xbgr.mr_n69544928)
print v(xbgr.mr_n69545040)
print v(xbgr.mr_n69545472)
print v(xbgr.mr_n69545792)
print v(xbgr.mr_n69546768)
print v(xbgr.mr_n69547200)
print v(xbgr.mr_n69547520)
print v(xbgr.mr_n69548384)
print v(xbgr.mr_n69548496)
print v(xbgr.mr_n69548816)
print v(xbgr.mr_n69548928)
print v(xbgr.mr_n69549248)
print v(xbgr.mr_n69549360)
print v(xbgr.mr_n69549680)
print v(xbgr.mr_n69549792)
print v(xbgr.mr_n69550112)
print v(xbgr.mr_n69550976)
print v(xbgr.mr_n69551408)
print v(xbgr.mr_n69552272)
print v(xbgr.mr_n69553136)
print v(xbgr.mr_n69553248)
print v(xbgr.mr_n69553568)
print v(xbgr.mr_n69553680)
print v(xbgr.mr_n69554000)
print v(xbgr.mr_n69554112)
print v(xbgr.mr_n69554432)
print v(xbgr.mr_n69554544)
print v(xbgr.mr_n69555296)
print v(xbgr.mr_n69555408)
print v(xbgr.mr_n69555728)
print v(xbgr.mr_n69555840)
print v(xbgr.mr_n69556160)
print v(xbgr.mr_n69556272)
print v(xbgr.mr_n69556592)
print v(xbgr.mr_n69556704)
print v(xbgr.mr_n69557024)
print v(xbgr.mr_n69557568)
print v(xbgr.mr_n69557888)
print v(xbgr.mr_n69558000)
print v(xbgr.mr_n69558432)
print v(xbgr.mr_n69558752)
print v(xbgr.mr_n69558864)
print v(xbgr.mr_n69560048)
print v(xbgr.mr_n69560480)
print v(xbgr.mr_n69560592)
print v(xbgr.mr_n69560912)
print v(xbgr.mr_n69561024)
print v(xbgr.mr_n69561344)
print v(xbgr.mr_n69561456)
print v(xbgr.mr_n69561776)
print v(xbgr.mr_n69561888)
print v(xbgr.mr_n69562208)
print v(xbgr.mr_n69562320)
print v(xbgr.mr_n69562640)
print v(xbgr.mr_n69562752)
print v(xbgr.mr_n69563504)
print v(xbgr.mr_n69564368)
print v(xbgr.mr_n69564480)
print v(xbgr.mr_n69564800)
print v(xbgr.mr_n69564912)
print v(xbgr.mr_n69565232)
print v(xbgr.mr_n69565344)
print v(xbgr.mr_n69565664)
print v(xbgr.mr_n69565776)
print v(xbgr.mr_n69566096)
print v(xbgr.mr_n69566208)
print v(xbgr.mr_n69566528)
print v(xbgr.mr_n69566640)
print v(xbgr.mr_n69566960)
print v(xbgr.mr_n69567072)
print v(xbgr.mr_n69567392)
print v(xbgr.mr_n69567504)
print v(xbgr.mr_n69567824)
print v(xbgr.mr_n69568688)
print v(xbgr.mr_n69569552)
print v(xbgr.mr_n69570416)
print v(xbgr.mr_n69570528)
print v(xbgr.mr_n69570960)
print v(xbgr.mr_n69571392)
print v(xbgr.mr_n69571712)
print v(xbgr.mr_n69572144)
print v(xbgr.mr_n69572256)
print v(xbgr.mr_n69572576)
print v(xbgr.mr_n69572688)
print v(xbgr.mr_n69573440)
print v(xbgr.mr_n69574848)
print v(xbgr.mr_n69575168)
print v(xbgr.mr_n69575280)
print v(xbgr.mr_n69575600)
print v(xbgr.mr_n69575712)
print v(xbgr.mr_n69576032)
print v(xbgr.mr_n69576144)
print v(xbgr.mr_n69576576)
print v(xbgr.mr_n69576896)
print v(xbgr.mr_n69577008)
print v(xbgr.mr_n69577440)
print v(xbgr.mr_n69577760)
print v(xbgr.mr_n69578192)
print v(xbgr.mr_n69578624)
print v(xbgr.mr_n69578736)
print v(xbgr.mr_n69579056)
print v(xbgr.mr_n69579168)
print v(xbgr.mr_n69579488)
print v(xbgr.mr_n69579600)
print v(xbgr.mr_n69580352)
print v(xbgr.mr_n69581216)
print v(xbgr.mr_n69581328)
print v(xbgr.mr_n69581760)
print v(xbgr.mr_n69582080)
print v(xbgr.mr_n69582944)
print v(xbgr.mr_n69583808)
print v(xbgr.mr_n69585104)
print v(xbgr.mr_n69585536)
print v(xbgr.mr_n69585648)
print v(xbgr.mr_n69585968)
print v(xbgr.mr_n69586080)
print v(xbgr.mr_n69586400)
print v(xbgr.mr_n69586512)
print v(xbgr.mr_n69586832)
print v(xbgr.mr_n69586944)
print v(xbgr.mr_n69587264)
print v(xbgr.mr_n69587376)
print v(xbgr.mr_n69587696)
print v(xbgr.mr_n69587808)
print v(xbgr.mr_n69588128)
print v(xbgr.mr_n69588240)
print v(xbgr.mr_n69588560)
print v(xbgr.mr_n69588672)
print v(xbgr.mr_n69589424)
print v(xbgr.mr_n69590288)
print v(xbgr.mr_n69591152)
print v(xbgr.mr_n69591264)
print v(xbgr.mr_n69591584)
print v(xbgr.mr_n69591696)
print v(xbgr.mr_n69592016)
print v(xbgr.mr_n69592128)
print v(xbgr.mr_n69592448)
print v(xbgr.mr_n69593312)
print v(xbgr.mr_n69594176)
print v(xbgr.mr_n69595040)
print v(xbgr.mr_n69595904)
print v(xbgr.mr_n69596768)
print v(xbgr.mr_n69597632)
print v(xbgr.mr_n69597744)
print v(xbgr.mr_n69598064)
print v(xbgr.mr_n69598928)
print v(xbgr.mr_n69599040)
print v(xbgr.mr_n69599360)
print v(xbgr.mr_n69599472)
print v(xbgr.mr_n69599792)
print v(xbgr.mr_n69600656)
print v(xbgr.mr_n69601088)
print v(xbgr.mr_n69601200)
print v(xbgr.mr_n69601952)
print v(xbgr.mr_n69602064)
print v(xbgr.mr_n69602384)
print v(xbgr.mr_n69602496)
print v(xbgr.mr_n69602816)
print v(xbgr.mr_n69602928)
print v(xbgr.mr_n69603248)
print v(xbgr.mr_n69603360)
print v(xbgr.mr_n69603680)
print v(xbgr.mr_n69603792)
print v(xbgr.mr_n69604112)
print v(xbgr.mr_n69604224)
print v(xbgr.mr_n69604544)
print v(xbgr.mr_n69604656)
print v(xbgr.mr_n69604976)
print v(xbgr.mr_n69605088)
print v(xbgr.mr_n69605408)
print v(xbgr.mr_n69605520)
print v(xbgr.mr_n69605840)
print v(xbgr.mr_n69606384)
print v(xbgr.mr_n69607136)
print v(xbgr.mr_n69608000)
print v(xbgr.mr_n69608864)
print v(xbgr.mr_n69608976)
print v(xbgr.mr_n69609408)
print v(xbgr.mr_n69609728)
print v(xbgr.mr_n69610592)
print v(xbgr.mr_n69611456)
print v(xbgr.mr_n69612320)
print v(xbgr.mr_n69613184)
print v(xbgr.mr_n69614048)
print v(xbgr.mr_n69614912)
print v(xbgr.mr_n69615024)
print v(xbgr.mr_n69615344)
print v(xbgr.mr_n69615456)
print v(xbgr.mr_n69615776)
print v(xbgr.mr_n69616640)
print v(xbgr.mr_n69617504)
print v(xbgr.mr_n69617616)
print v(xbgr.mr_n69617936)
print v(xbgr.mr_n69618048)
print v(xbgr.mr_n69618368)
print v(xbgr.mr_n69618480)
print v(xbgr.mr_n69618800)
print v(xbgr.mr_n69618912)
print v(xbgr.mr_n69619232)
print v(xbgr.mr_n69619344)
print v(xbgr.mr_n69619664)
print v(xbgr.mr_n69619776)
print v(xbgr.mr_n69620096)
print v(xbgr.mr_n69620208)
print v(xbgr.mr_n69620528)
print v(xbgr.mr_n69621392)
print v(xbgr.mr_n69621504)
print v(xbgr.mr_n69621824)
print v(xbgr.mr_n69621936)
print v(xbgr.mr_n69622256)
print v(xbgr.mr_n69622368)
print v(xbgr.mr_n69622688)
print v(xbgr.mr_n69622800)
print v(xbgr.mr_n69623120)
print v(xbgr.mr_n69623232)
print v(xbgr.mr_n69623552)
print v(xbgr.mr_n69623664)
print v(xbgr.mr_n69623984)
print v(xbgr.mr_n69624096)
print v(xbgr.mr_n69624416)
print v(xbgr.mr_n69624528)
print v(xbgr.mr_n69624960)
print v(xbgr.mr_n69625392)
print v(xbgr.mr_n69625824)
print v(xbgr.mr_n69626144)
print v(xbgr.mr_n69626256)
print v(xbgr.mr_n69626576)
print v(xbgr.mr_n69626688)
print v(xbgr.mr_n69627008)
print v(xbgr.mr_n69627120)
print v(xbgr.mr_n69627440)
print v(xbgr.mr_n69627552)
print v(xbgr.mr_n69627872)
print v(xbgr.mr_n69627984)
print v(xbgr.mr_n69628304)
print v(xbgr.mr_n69628416)
print v(xbgr.mr_n69628736)
print v(xbgr.mr_n69628848)
print v(xbgr.mr_n69629168)
print v(xbgr.mr_n69629280)
print v(xbgr.mr_n69629600)
print v(xbgr.mr_n69629712)
print v(xbgr.mr_n69630032)
print v(xbgr.mr_n69630144)
print v(xbgr.mr_n69630464)
print v(xbgr.mr_n69630576)
print v(xbgr.mr_n69630896)
print v(xbgr.mr_n69631008)
print v(xbgr.mr_n69631328)
print v(xbgr.mr_n69631440)
print v(xbgr.mr_n69631760)
print v(xbgr.mr_n69631872)
print v(xbgr.mr_n69632192)
print v(xbgr.mr_n69632304)
print v(xbgr.mr_n69632624)
print v(xbgr.mr_n69632736)
print v(xbgr.mr_n69633168)
print v(xbgr.mr_n69633488)
print v(xbgr.mr_n69633600)
print v(xbgr.mr_n69634032)
print v(xbgr.mr_n69634464)
print v(xbgr.mr_n69634784)
print v(xbgr.mr_n69634896)
print v(xbgr.mr_n69635216)
print v(xbgr.mr_n69635328)
print v(xbgr.mr_n69635648)
print v(xbgr.mr_n69635760)
print v(xbgr.mr_n69636080)
print v(xbgr.mr_n69636192)
print v(xbgr.mr_n69636624)
print v(xbgr.mr_n69637056)
print v(xbgr.mr_n69637488)
print v(xbgr.mr_n69637920)
print v(xbgr.mr_n69638352)
print v(xbgr.mr_n69638784)
print v(xbgr.mr_n69639216)
print v(xbgr.mr_n69639648)
print v(xbgr.mr_n69639968)
print v(xbgr.mr_n69640080)
print v(xbgr.mr_n69640400)
print v(xbgr.mr_n69640512)
print v(xbgr.mr_n69640832)
print v(xbgr.mr_n69640944)
print v(xbgr.mr_n69641264)
print v(xbgr.mr_n69641376)
print v(xbgr.mr_n69641696)
print v(xbgr.mr_n69641808)
print v(xbgr.mr_n69642128)
print v(xbgr.mr_n69642240)
print v(xbgr.mr_n69642560)
print v(xbgr.mr_n69642672)
print v(xbgr.mr_n69642992)
print v(xbgr.mr_n69643104)
print v(xbgr.mr_n69643424)
print v(xbgr.mr_n69643536)
print v(xbgr.mr_n69643856)
print v(xbgr.mr_n69643968)
print v(xbgr.mr_n69644288)
print v(xbgr.mr_n69644400)
print v(xbgr.mr_n69644720)
print v(xbgr.mr_n69644832)
print v(xbgr.mr_n69645152)
print v(xbgr.mr_n69645264)
print v(xbgr.mr_n69645584)
print v(xbgr.mr_n69645696)
print v(xbgr.mr_n69646016)
print v(xbgr.mr_n69646128)
print v(xbgr.mr_n69646448)
print v(xbgr.mr_n69646560)
print v(xbgr.mr_n69646880)
print v(xbgr.mr_n69646992)
print v(xbgr.mr_n69647312)
print v(xbgr.mr_n69647424)
print v(xbgr.mr_n69647744)
print v(xbgr.mr_n69647856)
print v(xbgr.mr_n69648176)
print v(xbgr.mr_n69648288)
print v(xbgr.mr_n69648608)
print v(xbgr.mr_n69648720)
print v(xbgr.mr_n69649040)
print v(xbgr.mr_n69649152)
print v(xbgr.mr_n69649472)
print v(xbgr.mr_n69649584)
print v(xbgr.mr_n69649904)
print v(xbgr.mr_n69650016)
print v(xbgr.mr_n69650448)
print v(xbgr.mr_n69650880)
print v(xbgr.mr_n69651200)
print v(xbgr.mr_n69651312)
print v(xbgr.mr_n69651632)
print v(xbgr.mr_n69651744)
print v(xbgr.mr_n69652176)
print v(xbgr.mr_n69652608)
print v(xbgr.mr_n69653040)
print v(xbgr.mr_n69653472)
print v(xbgr.mr_n69653904)
print v(xbgr.mr_n69654336)
print v(xbgr.mr_n69654768)
print v(xbgr.mr_n69655200)
print v(xbgr.mr_n69655632)
print v(xbgr.mr_n69656064)
print v(xbgr.mr_n69656496)
print v(xbgr.mr_n69656928)
print v(xbgr.mr_n69657360)
print v(xbgr.mr_n69657792)
print v(xbgr.mr_n69658224)
print v(xbgr.mr_n69658656)
print v(xbgr.mr_n69659088)
print v(xbgr.mr_n69659520)
print v(xbgr.mr_n69659952)
print v(xbgr.mr_n69660384)
print v(xbgr.mr_n69660816)
print v(xbgr.mr_n69661248)
print v(xbgr.mr_n69661680)
print v(xbgr.mr_n69662112)
print v(xbgr.mr_n69662432)
print v(xbgr.mr_n69662544)
print v(xbgr.mr_n69662864)
print v(xbgr.mr_n69662976)
print v(xbgr.mr_n69663296)
print v(xbgr.mr_n69663408)
print v(xbgr.mr_n69663728)
print v(xbgr.mr_n69663840)
print v(xbgr.mr_n69664160)
print v(xbgr.mr_n69664272)
print v(xbgr.mr_n69664592)
print v(xbgr.mr_n69664704)
print v(xbgr.mr_n69665024)
print v(xbgr.mr_n69665136)
print v(xbgr.mr_n69665456)
print v(xbgr.mr_n69665568)
print v(xbgr.mr_n69665888)
print v(xbgr.mr_n69666000)
print v(xbgr.mr_n69666320)
print v(xbgr.mr_n69666432)
print v(xbgr.mr_n69666752)
print v(xbgr.mr_n69666864)
print v(xbgr.mr_n69667184)
print v(xbgr.mr_n69667296)
print v(xbgr.mr_n69667616)
print v(xbgr.mr_n69667728)
print v(xbgr.mr_n69668160)
print v(xbgr.mr_n69668592)
print v(xbgr.mr_n69669024)
print v(xbgr.mr_n69669456)
print v(xbgr.mr_n69669888)
print v(xbgr.mr_n69670320)
print v(xbgr.mr_n69670752)
print v(xbgr.mr_n69671184)
print v(xbgr.mr_n69671616)
print v(xbgr.mr_n69672048)
print v(xbgr.mr_n69672480)
print v(xbgr.mr_n69672912)
print v(xbgr.mr_n69673344)
print v(xbgr.mr_n69673664)
print v(xbgr.mr_n69673776)
print v(xbgr.mr_n69674096)
print v(xbgr.mr_n69674208)
print v(xbgr.mr_n69674528)
print v(xbgr.mr_n69674640)
print v(xbgr.mr_n69674960)
print v(xbgr.mr_n69675072)
print v(xbgr.mr_n69675392)
print v(xbgr.mr_n69675504)
print v(xbgr.mr_n69675824)
print v(xbgr.mr_n69675936)
print v(xbgr.mr_n69676256)
print v(xbgr.mr_n69676368)
print v(xbgr.mr_n69676688)
print v(xbgr.mr_n69676800)
print v(xbgr.mr_n69677120)
print v(xbgr.mr_n69677232)
print v(xbgr.mr_n69677552)
print v(xbgr.mr_n69677664)
print v(xbgr.mr_n69677984)
print v(xbgr.mr_n69678096)
print v(xbgr.mr_n69678416)
print v(xbgr.mr_n69678528)
print v(xbgr.mr_n69678848)
print v(xbgr.mr_n69678960)
print v(xbgr.mr_n69679392)
print v(xbgr.mr_n69679824)
print v(xbgr.mr_n69680256)
print v(xbgr.mr_n69680688)
print v(xbgr.mr_n69681120)
print v(xbgr.mr_n69681552)
print v(xbgr.mr_n69681984)
print v(xbgr.mr_n69682416)
print v(xbgr.mr_n69682848)
print v(xbgr.mr_n69683280)
print v(xbgr.mr_n69683712)
print v(xbgr.mr_n69684144)
print v(xbgr.mr_n69684576)
print v(xbgr.mr_n69684896)
print v(xbgr.mr_n69685008)
print v(xbgr.mr_n69685328)
print v(xbgr.mr_n69685440)
print v(xbgr.mr_n69685760)
print v(xbgr.mr_n69685872)
print v(xbgr.mr_n69686192)
print v(xbgr.mr_n69686304)
print v(xbgr.mr_n69686624)
print v(xbgr.mr_n69686736)
print v(xbgr.mr_n69687056)
print v(xbgr.mr_n69687168)
print v(xbgr.mr_n69687488)
print v(xbgr.mr_n69687600)
print v(xbgr.mr_n69687920)
print v(xbgr.mr_n69688032)
print v(xbgr.mr_n69688352)
print v(xbgr.mr_n69688464)
print v(xbgr.mr_n69688784)
print v(xbgr.mr_n69688896)
print v(xbgr.mr_n69689216)
print v(xbgr.mr_n69689328)
print v(xbgr.mr_n69689648)
print v(xbgr.mr_n69689760)
print v(xbgr.mr_n69690080)
print v(xbgr.mr_n69690192)
print v(xbgr.mr_n69690624)
print v(xbgr.mr_n69691056)
print v(xbgr.mr_n69691488)
print v(xbgr.mr_n69691920)
print v(xbgr.mr_n69692352)
print v(xbgr.mr_n69692784)
print v(xbgr.mr_n69693216)
print v(xbgr.mr_n69693648)
print v(xbgr.mr_n69694080)
print v(xbgr.mr_n69694512)
print v(xbgr.mr_n69694944)
print v(xbgr.mr_n69695376)
print v(xbgr.mr_n69695808)
print v(xbgr.mr_n69696128)
print v(xbgr.mr_n69696240)
print v(xbgr.mr_n69696560)
print v(xbgr.mr_n69696672)
print v(xbgr.mr_n69696992)
print v(xbgr.mr_n69697104)
print v(xbgr.mr_n69697424)
print v(xbgr.mr_n69697536)
print v(xbgr.mr_n69697856)
print v(xbgr.mr_n69697968)
print v(xbgr.mr_n69698288)
print v(xbgr.mr_n69698400)
print v(xbgr.mr_n69698720)
print v(xbgr.mr_n69698832)
print v(xbgr.mr_n69699264)
print v(xbgr.mr_n69699696)
print v(xbgr.mr_n69700128)
print v(xbgr.mr_n69700560)
print v(xbgr.mr_n69700880)
print v(xbgr.mr_n69700992)
print v(xbgr.mr_n69701312)
print v(xbgr.mr_n69701424)
print v(xbgr.mr_n69701744)
print v(xbgr.mr_n69701856)
print v(xbgr.mr_n69702176)
print v(xbgr.mr_n69702288)
print v(xbgr.mr_n69702608)
print v(xbgr.mr_n69702720)
print v(xbgr.mr_n69703040)
print v(xbgr.mr_n69703152)
print v(xbgr.mr_n69703584)
print v(xbgr.mr_n69704016)
print v(xbgr.mr_n69704448)
print v(xbgr.mr_n69704880)
print v(xbgr.mr_n69705312)
print v(xbgr.mr_n69705744)
print v(xbgr.mr_n69706176)
print v(xbgr.mr_n69706608)
print v(xbgr.mr_n69707040)
print v(xbgr.mr_n69707360)
print v(xbgr.mr_n69707472)
print v(xbgr.mr_n69707792)
print v(xbgr.mr_n69707904)
print v(xbgr.mr_n69708224)
print v(xbgr.mr_n69708336)
print v(xbgr.mr_n69708656)
print v(xbgr.mr_n69708768)
print v(xbgr.mr_n69709088)
print v(xbgr.mr_n69709200)
print v(xbgr.mr_n69709520)
print v(xbgr.mr_n69709632)
print v(xbgr.mr_n69709952)
print v(xbgr.mr_n69710064)
print v(xbgr.mr_n69710384)
print v(xbgr.mr_n69710496)
print v(xbgr.mr_n69710816)
print v(xbgr.mr_n69710928)
print v(xbgr.mr_n69711248)
print v(xbgr.mr_n69711360)
print v(xbgr.mr_n69711680)
print v(xbgr.mr_n69711792)
print v(xbgr.mr_n69712112)
print v(xbgr.mr_n69712224)
print v(xbgr.mr_n69712544)
print v(xbgr.mr_n69712656)
print v(xbgr.mr_n69712976)
print v(xbgr.mr_n69713088)
print v(xbgr.mr_n69713520)
print v(xbgr.mr_n69713952)
print v(xbgr.mr_n69714384)
print v(xbgr.mr_n69714816)
print v(xbgr.mr_n69715136)
print v(xbgr.mr_n69715248)
print v(xbgr.mr_n69715568)
print v(xbgr.mr_n69715680)
print v(xbgr.mr_n69716112)
print v(xbgr.mr_n69716544)
print v(xbgr.mr_n69716976)
print v(xbgr.mr_n69717408)
print v(xbgr.mr_n69717840)
print v(xbgr.mr_n69718272)
print v(xbgr.mr_n69718704)
print v(xbgr.mr_n69719136)
print v(xbgr.mr_n69719456)
print v(xbgr.mr_n69719568)
print v(xbgr.mr_n69719888)
print v(xbgr.mr_n69720000)
print v(xbgr.mr_n69720320)
print v(xbgr.mr_n69720432)
print v(xbgr.mr_n69720752)
print v(xbgr.mr_n69720864)
print v(xbgr.mr_n69721184)
print v(xbgr.mr_n69721296)
print v(xbgr.mr_n69721616)
print v(xbgr.mr_n69721728)
print v(xbgr.mr_n69722048)
print v(xbgr.mr_n69722160)
print v(xbgr.mr_n69722480)
print v(xbgr.mr_n69722592)
print v(xbgr.mr_n69722912)
print v(xbgr.mr_n69723024)
print v(xbgr.mr_n69723344)
print v(xbgr.mr_n69723456)
print v(xbgr.mr_n69723776)
print v(xbgr.mr_n69723888)
print v(xbgr.mr_n69724208)
print v(xbgr.mr_n69724320)
print v(xbgr.mr_n69724752)
print v(xbgr.mr_n69725184)
print v(xbgr.mr_n69725616)
print v(xbgr.mr_n69726048)
print v(xbgr.mr_n69726480)
print v(xbgr.mr_n69726912)
print v(xbgr.mr_n69727232)
print v(xbgr.mr_n69727344)
print v(xbgr.mr_n69727664)
print v(xbgr.mr_n69727776)
print v(xbgr.mr_n69728096)
print v(xbgr.mr_n69728208)
print v(xbgr.mr_n69728528)
print v(xbgr.mr_n69728640)
print v(xbgr.mr_n69728960)
print v(xbgr.mr_n69729072)
print v(xbgr.mr_n69729392)
print v(xbgr.mr_n69729504)
print v(xbgr.mr_n69729824)
print v(xbgr.mr_n69729936)
print v(xbgr.mr_n69730256)
print v(xbgr.mr_n69730368)
print v(xbgr.mr_n69730688)
print v(xbgr.mr_n69730800)
print v(xbgr.mr_n69731120)
print v(xbgr.mr_n69731232)
print v(xbgr.mr_n69731552)
print v(xbgr.mr_n69731664)
print v(xbgr.mr_n69731984)
print v(xbgr.mr_n69732096)
print v(xbgr.mr_n69732416)
print v(xbgr.mr_n69732528)
print v(xbgr.mr_n69732848)
print v(xbgr.mr_n69732960)
print v(xbgr.mr_n69733280)
print v(xbgr.mr_n69733392)
print v(xbgr.mr_n69733712)
print v(xbgr.mr_n69733824)
print v(xbgr.mr_n69734144)
print v(xbgr.mr_n69734256)
print v(xbgr.mr_n69734576)
print v(xbgr.mr_n69734688)
print v(xbgr.mr_n69735120)
print v(xbgr.mr_n69735552)
print v(xbgr.mr_n69735872)
print v(xbgr.mr_n69735984)
print v(xbgr.mr_n69736304)
print v(xbgr.mr_n69736416)
print v(xbgr.mr_n69736736)
print v(xbgr.mr_n69736848)
print v(xbgr.mr_n69737168)
print v(xbgr.mr_n69737280)
print v(xbgr.mr_n69737712)
print v(xbgr.mr_n69738144)
print v(xbgr.mr_n69738576)
print v(xbgr.mr_n69739008)
print v(xbgr.mr_n69739440)
print v(xbgr.mr_n69739872)
print v(xbgr.mr_n69740304)
print v(xbgr.mr_n69740736)
print v(xbgr.mr_n69741168)
print v(xbgr.mr_n69741600)
print v(xbgr.mr_n69742032)
print v(xbgr.mr_n69742464)
print v(xbgr.mr_n69742896)
print v(xbgr.mr_n69743328)
print v(xbgr.mr_n69743760)
print v(xbgr.mr_n69744192)
print v(xbgr.mr_n69744512)
print v(xbgr.mr_n69744624)
print v(xbgr.mr_n69744944)
print v(xbgr.mr_n69745056)
print v(xbgr.mr_n69745376)
print v(xbgr.mr_n69745488)
print v(xbgr.mr_n69745808)
print v(xbgr.mr_n69745920)
print v(xbgr.mr_n69746240)
print v(xbgr.mr_n69746352)
print v(xbgr.mr_n69746672)
print v(xbgr.mr_n69746784)
print v(xbgr.mr_n69747104)
print v(xbgr.mr_n69747216)
print v(xbgr.mr_n69747536)
print v(xbgr.mr_n69747648)
print v(xbgr.mr_n69747968)
print v(xbgr.mr_n69748080)
print v(xbgr.mr_n69748400)
print v(xbgr.mr_n69748512)
print v(xbgr.mr_n69748944)
print v(xbgr.mr_n69749376)
print v(xbgr.mr_n69749808)
print v(xbgr.mr_n69750240)
print v(xbgr.mr_n69750672)
print v(xbgr.mr_n69751104)
print v(xbgr.mr_n69751536)
print v(xbgr.mr_n69751968)
print v(xbgr.mr_n69752288)
print v(xbgr.mr_n69752400)
print v(xbgr.mr_n69752720)
print v(xbgr.mr_n69752832)
print v(xbgr.mr_n69753152)
print v(xbgr.mr_n69753264)
print v(xbgr.mr_n69753584)
print v(xbgr.mr_n69753696)
print v(xbgr.mr_n69754016)
print v(xbgr.mr_n69754128)
print v(xbgr.mr_n69754448)
print v(xbgr.mr_n69754560)
print v(xbgr.mr_n69754880)
print v(xbgr.mr_n69754992)
print v(xbgr.mr_n69755312)
print v(xbgr.mr_n69755424)
print v(xbgr.mr_n69755744)
print v(xbgr.mr_n69755856)
print v(xbgr.mr_n69756176)
print v(xbgr.mr_n69756288)
print v(xbgr.mr_n69756608)
print v(xbgr.mr_n69756720)
print v(xbgr.mr_n69757040)
print v(xbgr.mr_n69757152)
print v(xbgr.mr_n69757472)
print v(xbgr.mr_n69757584)
print v(xbgr.mr_n69757904)
print v(xbgr.mr_n69758016)
print v(xbgr.mr_n69758448)
print v(xbgr.mr_n69758880)
print v(xbgr.mr_n69759312)
print v(xbgr.mr_n69759744)
print v(xbgr.mr_n69760176)
print v(xbgr.mr_n69760608)
print v(xbgr.mr_n69761040)
print v(xbgr.mr_n69761472)
print v(xbgr.mr_n69761904)
print v(xbgr.mr_n69762336)
print v(xbgr.mr_n69762768)
print v(xbgr.mr_n69763200)
print v(xbgr.mr_n69763632)
print v(xbgr.mr_n69764064)
print v(xbgr.mr_n69764384)
print v(xbgr.mr_n69764496)
print v(xbgr.mr_n69764816)
print v(xbgr.mr_n69764928)
print v(xbgr.mr_n69765248)
print v(xbgr.mr_n69765360)
print v(xbgr.mr_n69765680)
print v(xbgr.mr_n69765792)
print v(xbgr.mr_n69766112)
print v(xbgr.mr_n69766224)
print v(xbgr.mr_n69766544)
print v(xbgr.mr_n69766656)
print v(xbgr.mr_n69766976)
print v(xbgr.mr_n69767088)
print v(xbgr.mr_n69767408)
print v(xbgr.mr_n69767520)
print v(xbgr.mr_n69767840)
print v(xbgr.mr_n69767952)
print v(xbgr.mr_n69768272)
print v(xbgr.mr_n69768384)
print v(xbgr.mr_n69768704)
print v(xbgr.mr_n69768816)
print v(xbgr.mr_n69769136)
print v(xbgr.mr_n69769248)
print v(xbgr.mr_n69769568)
print v(xbgr.mr_n69769680)
print v(xbgr.mr_n69770000)
print v(xbgr.mr_n69770112)
print v(xbgr.mr_n69770432)
print v(xbgr.mr_n69770544)
print v(xbgr.mr_n69770864)
print v(xbgr.mr_n69770976)
print v(xbgr.mr_n69771296)
print v(xbgr.mr_n69771408)
print v(xbgr.mr_n69771728)
print v(xbgr.mr_n69771840)
print v(xbgr.mr_n69772160)
print v(xbgr.mr_n69772272)
print v(xbgr.mr_n69772592)
print v(xbgr.mr_n69772704)
print v(xbgr.mr_n69773024)
print v(xbgr.mr_n69773136)
print v(xbgr.mr_n69773456)
print v(xbgr.mr_n69773568)
print v(xbgr.mr_n69773888)
print v(xbgr.mr_n69774000)
print v(xbgr.mr_n69774320)
print v(xbgr.mr_n69774432)
print v(xbgr.mr_n69774864)
print v(xbgr.mr_n69775296)
print v(xbgr.mr_n69775728)
print v(xbgr.mr_n69776160)
print v(xbgr.mr_n69776592)
print v(xbgr.mr_n69777024)
print v(xbgr.mr_n69777456)
print v(xbgr.mr_n69777888)
print v(xbgr.mr_n69778320)
print v(xbgr.mr_n69778752)
print v(xbgr.mr_n69779184)
print v(xbgr.mr_n69779616)
print v(xbgr.mr_n69780048)
print v(xbgr.mr_n69780480)
print v(xbgr.mr_n69780912)
print v(xbgr.mr_n69781344)
print v(xbgr.mr_n69781664)
print v(xbgr.mr_n69781776)
print v(xbgr.mr_n69782096)
print v(xbgr.mr_n69782208)
print v(xbgr.mr_n69782640)
print v(xbgr.mr_n69783072)
print v(xbgr.mr_n69783504)
print v(xbgr.mr_n69783936)
print v(xbgr.mr_n69784368)
print v(xbgr.mr_n69784800)
print v(xbgr.mr_n69785232)
print v(xbgr.mr_n69785664)
print v(xbgr.mr_n69786096)
print v(xbgr.mr_n69786528)
print v(xbgr.mr_n69786848)
print v(xbgr.mr_n69786960)
print v(xbgr.mr_n69787280)
print v(xbgr.mr_n69787392)
print v(xbgr.mr_n69787712)
print v(xbgr.mr_n69787824)
print v(xbgr.mr_n69788144)
print v(xbgr.mr_n69788256)
print v(xbgr.mr_n69788576)
print v(xbgr.mr_n69788688)
print v(xbgr.mr_n69789008)
print v(xbgr.mr_n69789120)
print v(xbgr.mr_n69789440)
print v(xbgr.mr_n69789552)
print v(xbgr.mr_n69789872)
print v(xbgr.mr_n69789984)
print v(xbgr.mr_n69790304)
print v(xbgr.mr_n69790416)
print v(xbgr.mr_n69790736)
print v(xbgr.mr_n69790848)
print v(xbgr.mr_n69791168)
print v(xbgr.mr_n69791280)
print v(xbgr.mr_n69791600)
print v(xbgr.mr_n69791712)
print v(xbgr.mr_n69792032)
print v(xbgr.mr_n69792144)
print v(xbgr.mr_n69792576)
print v(xbgr.mr_n69793008)
print v(xbgr.mr_n69793440)
print v(xbgr.mr_n69793872)
print v(xbgr.mr_n69794304)
print v(xbgr.mr_n69794736)
print v(xbgr.mr_n69795168)
print v(xbgr.mr_n69795600)
print v(xbgr.mr_n69796032)
print v(xbgr.mr_n69796464)
print v(xbgr.mr_n69796896)
print v(xbgr.mr_n69797328)
print v(xbgr.mr_n69797760)
print v(xbgr.mr_n69798080)
print v(xbgr.mr_n69798192)
print v(xbgr.mr_n69798512)
print v(xbgr.mr_n69798624)
print v(xbgr.mr_n69798944)
print v(xbgr.mr_n69799056)
print v(xbgr.mr_n69799376)
print v(xbgr.mr_n69799488)
print v(xbgr.mr_n69799808)
print v(xbgr.mr_n69799920)
print v(xbgr.mr_n69800240)
print v(xbgr.mr_n69800352)
print v(xbgr.mr_n69800672)
print v(xbgr.mr_n69800784)
print v(xbgr.mr_n69801104)
print v(xbgr.mr_n69801216)
print v(xbgr.mr_n69801536)
print v(xbgr.mr_n69801648)
print v(xbgr.mr_n69801968)
print v(xbgr.mr_n69802080)
print v(xbgr.mr_n69802400)
print v(xbgr.mr_n69802512)
print v(xbgr.mr_n69802832)
print v(xbgr.mr_n69802944)
print v(xbgr.mr_n69803264)
print v(xbgr.mr_n69803376)
print v(xbgr.mr_n69803808)
print v(xbgr.mr_n69804240)
print v(xbgr.mr_n69804672)
print v(xbgr.mr_n69805104)
print v(xbgr.mr_n69805536)
print v(xbgr.mr_n69805968)
print v(xbgr.mr_n69806400)
print v(xbgr.mr_n69806832)
print v(xbgr.mr_n69807264)
print v(xbgr.mr_n69807696)
print v(xbgr.mr_n69808128)
print v(xbgr.mr_n69808560)
print v(xbgr.mr_n69808992)
print v(xbgr.mr_n69809312)
print v(xbgr.mr_n69809424)
print v(xbgr.mr_n69809744)
print v(xbgr.mr_n69809856)
print v(xbgr.mr_n69810176)
print v(xbgr.mr_n69810288)
print v(xbgr.mr_n69810608)
print v(xbgr.mr_n69810720)
print v(xbgr.mr_n69811040)
print v(xbgr.mr_n69811152)
print v(xbgr.mr_n69811472)
print v(xbgr.mr_n69811584)
print v(xbgr.mr_n69811904)
print v(xbgr.mr_n69812016)
print v(xbgr.mr_n69812336)
print v(xbgr.mr_n69812448)
print v(xbgr.mr_n69812768)
print v(xbgr.mr_n69812880)
print v(xbgr.mr_n69813200)
print v(xbgr.mr_n69813312)
print v(xbgr.mr_n69813632)
print v(xbgr.mr_n69813744)
print v(xbgr.mr_n69814064)
print v(xbgr.mr_n69814176)
print v(xbgr.mr_n69814496)
print v(xbgr.mr_n69814608)
print v(xbgr.mr_n69815040)
print v(xbgr.mr_n69815472)
print v(xbgr.mr_n69815904)
print v(xbgr.mr_n69816336)
print v(xbgr.mr_n69816768)
print v(xbgr.mr_n69817200)
print v(xbgr.mr_n69817632)
print v(xbgr.mr_n69818064)
print v(xbgr.mr_n69818496)
print v(xbgr.mr_n69818928)
print v(xbgr.mr_n69819360)
print v(xbgr.mr_n69819792)
print v(xbgr.mr_n69820224)
print v(xbgr.mr_n69820544)
print v(xbgr.mr_n69820656)
print v(xbgr.mr_n69820976)
print v(xbgr.mr_n69821088)
print v(xbgr.mr_n69821408)
print v(xbgr.mr_n69821520)
print v(xbgr.mr_n69821840)
print v(xbgr.mr_n69821952)
print v(xbgr.mr_n69822272)
print v(xbgr.mr_n69822384)
print v(xbgr.mr_n69822704)
print v(xbgr.mr_n69822816)
print v(xbgr.mr_n69823136)
print v(xbgr.mr_n69823248)
print v(xbgr.mr_n69823568)
print v(xbgr.mr_n69823680)
print v(xbgr.mr_n69824000)
print v(xbgr.mr_n69824112)
print v(xbgr.mr_n69824432)
print v(xbgr.mr_n69824544)
print v(xbgr.mr_n69824864)
print v(xbgr.mr_n69824976)
print v(xbgr.mr_n69825296)
print v(xbgr.mr_n69825408)
print v(xbgr.mr_n69825728)
print v(xbgr.mr_n69825840)
print v(xbgr.mr_n69826272)
print v(xbgr.mr_n69826704)
print v(xbgr.mr_n69827136)
print v(xbgr.mr_n69827568)
print v(xbgr.mr_n69828000)
print v(xbgr.mr_n69828432)
print v(xbgr.mr_n69828864)
print v(xbgr.mr_n69829296)
print v(xbgr.mr_n69829728)
print v(xbgr.mr_n69830160)
print v(xbgr.mr_n69830592)
print v(xbgr.mr_n69831024)
print v(xbgr.mr_n69831456)
print v(xbgr.mr_n69831776)
print v(xbgr.mr_n69831888)
print v(xbgr.mr_n69832208)
print v(xbgr.mr_n69832320)
print v(xbgr.mr_n69832640)
print v(xbgr.mr_n69832752)
print v(xbgr.mr_n69833072)
print v(xbgr.mr_n69833184)
print v(xbgr.mr_n69833504)
print v(xbgr.mr_n69833616)
print v(xbgr.mr_n69834048)
print v(xbgr.mr_n69834480)
print v(xbgr.mr_n69834912)
print v(xbgr.mr_n69835344)
print v(xbgr.mr_n69835776)
print v(xbgr.mr_n69836096)
print v(xbgr.mr_n69836208)
print v(xbgr.mr_n69836528)
print v(xbgr.mr_n69836640)
print v(xbgr.mr_n69836960)
print v(xbgr.mr_n69837072)
print v(xbgr.mr_n69837392)
print v(xbgr.mr_n69837504)
print v(xbgr.mr_n69837824)
print v(xbgr.mr_n69837936)
print v(xbgr.mr_n69838256)
print v(xbgr.mr_n69838368)
print v(xbgr.mr_n69838688)
print v(xbgr.mr_n69838800)
print v(xbgr.mr_n69839120)
print v(xbgr.mr_n69839232)
print v(xbgr.mr_n69839664)
print v(xbgr.mr_n69840096)
print v(xbgr.mr_n69840528)
print v(xbgr.mr_n69840960)
print v(xbgr.mr_n69841392)
print v(xbgr.mr_n69841824)
print v(xbgr.mr_n69842256)
print v(xbgr.mr_n69842688)
print v(xbgr.mr_n69843008)
print v(xbgr.mr_n69843120)
print v(xbgr.mr_n69843440)
print v(xbgr.mr_n69843552)
print v(xbgr.mr_n69843872)
print v(xbgr.mr_n69843984)
print v(xbgr.mr_n69844304)
print v(xbgr.mr_n69844416)
print v(xbgr.mr_n69844736)
print v(xbgr.mr_n69844848)
print v(xbgr.mr_n69845168)
print v(xbgr.mr_n69845280)
print v(xbgr.mr_n69845600)
print v(xbgr.mr_n69845712)
print v(xbgr.mr_n69846032)
print v(xbgr.mr_n69846144)
print v(xbgr.mr_n69846576)
print v(xbgr.mr_n69847008)
print v(xbgr.mr_n69847440)
print v(xbgr.mr_n69847872)
print v(xbgr.mr_n69848304)
print v(xbgr.mr_n69848624)
print v(xbgr.mr_n69848736)
print v(xbgr.mr_n69849056)
print v(xbgr.mr_n69849168)
print v(xbgr.mr_n69849488)
print v(xbgr.mr_n69849600)
print v(xbgr.mr_n69849920)
print v(xbgr.mr_n69850032)
print v(xbgr.mr_n69850352)
print v(xbgr.mr_n69850464)
print v(xbgr.mr_n69850896)
print v(xbgr.mr_n69851328)
print v(xbgr.mr_n69851760)
print v(xbgr.mr_n69852192)
print v(xbgr.mr_n69852624)
print v(xbgr.mr_n69853056)
print v(xbgr.mr_n69853488)
print v(xbgr.mr_n69853920)
print v(xbgr.mr_n69854240)
print v(xbgr.mr_n69854352)
print v(xbgr.mr_n69854672)
print v(xbgr.mr_n69854784)
print v(xbgr.mr_n69855104)
print v(xbgr.mr_n69855216)
print v(xbgr.mr_n69855536)
print v(xbgr.mr_n69855648)
print v(xbgr.mr_n69855968)
print v(xbgr.mr_n69856080)
print v(xbgr.mr_n69856400)
print v(xbgr.mr_n69856512)
print v(xbgr.mr_n69856832)
print v(xbgr.mr_n69856944)
print v(xbgr.mr_n69857376)
print v(xbgr.mr_n69857808)
print v(xbgr.mr_n69858240)
print v(xbgr.mr_n69858672)
print v(xbgr.mr_n69858992)
print v(xbgr.mr_n69859104)
print v(xbgr.mr_n69859536)
print v(xbgr.mr_n69859968)
print v(xbgr.mr_n69860288)
print v(xbgr.mr_n69860400)
print v(xbgr.mr_n69860720)
print v(xbgr.mr_n69860832)
print v(xbgr.mr_n69861152)
print v(xbgr.mr_n69861264)
print v(xbgr.mr_n69861584)
print v(xbgr.mr_n69861696)
print v(xbgr.mr_n69862016)
print v(xbgr.mr_n69862128)
print v(xbgr.mr_n69862560)
print v(xbgr.mr_n69862992)
print v(xbgr.mr_n69863424)
print v(xbgr.mr_n69863856)
print v(xbgr.mr_n69864288)
print v(xbgr.mr_n69864720)
print v(xbgr.mr_n69865152)
print v(xbgr.mr_n69865472)
print v(xbgr.mr_n69865584)
print v(xbgr.mr_n69865904)
print v(xbgr.mr_n69866016)
print v(xbgr.mr_n69866336)
print v(xbgr.mr_n69866448)
print v(xbgr.mr_n69866768)
print v(xbgr.mr_n69866880)
print v(xbgr.mr_n69867200)
print v(xbgr.mr_n69867312)
print v(xbgr.mr_n69867632)
print v(xbgr.mr_n69867744)
print v(xbgr.mr_n69868064)
print v(xbgr.mr_n69868176)
print v(xbgr.mr_n69868496)
print v(xbgr.mr_n69868608)
print v(xbgr.mr_n69868928)
print v(xbgr.mr_n69869040)
print v(xbgr.mr_n69869360)
print v(xbgr.mr_n69869472)
print v(xbgr.mr_n69869792)
print v(xbgr.mr_n69869904)
print v(xbgr.mr_n69870224)
print v(xbgr.mr_n69870336)
print v(xbgr.mr_n69870656)
print v(xbgr.mr_n69870768)
print v(xbgr.mr_n69871200)
print v(xbgr.mr_n69871632)
print v(xbgr.mr_n69872064)
print v(xbgr.mr_n69872496)
print v(xbgr.mr_n69872928)
print v(xbgr.mr_n69873360)
print v(xbgr.mr_n69873792)
print v(xbgr.mr_n69874224)
print v(xbgr.mr_n69874656)
print v(xbgr.mr_n69875088)
print v(xbgr.mr_n69875520)
print v(xbgr.mr_n69875952)
print v(xbgr.mr_n69876384)
print v(xbgr.mr_n69876704)
print v(xbgr.mr_n69876816)
print v(xbgr.mr_n69877136)
print v(xbgr.mr_n69877248)
print v(xbgr.mr_n69877568)
print v(xbgr.mr_n69877680)
print v(xbgr.mr_n69878000)
print v(xbgr.mr_n69878112)
print v(xbgr.mr_n69878432)
print v(xbgr.mr_n69878544)
print v(xbgr.mr_n69878864)
print v(xbgr.mr_n69878976)
print v(xbgr.mr_n69879296)
print v(xbgr.mr_n69879408)
print v(xbgr.mr_n69879728)
print v(xbgr.mr_n69879840)
print v(xbgr.mr_n69880160)
print v(xbgr.mr_n69880272)
print v(xbgr.mr_n69880592)
print v(xbgr.mr_n69880704)
print v(xbgr.mr_n69881024)
print v(xbgr.mr_n69881136)
print v(xbgr.mr_n69881456)
print v(xbgr.mr_n69881568)
print v(xbgr.mr_n69881888)
print v(xbgr.mr_n69882000)
print v(xbgr.mr_n69882320)
print v(xbgr.mr_n69882432)
print v(xbgr.mr_n69882752)
print v(xbgr.mr_n69882864)
print v(xbgr.mr_n69883184)
print v(xbgr.mr_n69883296)
print v(xbgr.mr_n69883728)
print v(xbgr.mr_n69884160)
print v(xbgr.mr_n69884592)
print v(xbgr.mr_n69885024)
print v(xbgr.mr_n69885456)
print v(xbgr.mr_n69885888)
print v(xbgr.mr_n69886208)
print v(xbgr.mr_n69886320)
print v(xbgr.mr_n69886640)
print v(xbgr.mr_n69886752)
print v(xbgr.mr_n69887072)
print v(xbgr.mr_n69887184)
print v(xbgr.mr_n69887504)
print v(xbgr.mr_n69887616)
print v(xbgr.mr_n69887936)
print v(xbgr.mr_n69888048)
print v(xbgr.mr_n69888368)
print v(xbgr.mr_n69888480)
print v(xbgr.mr_n69888800)
print v(xbgr.mr_n69888912)
print v(xbgr.mr_n69889232)
print v(xbgr.mr_n69889344)
print v(xbgr.mr_n69889664)
print v(xbgr.mr_n69889776)
print v(xbgr.mr_n69890096)
print v(xbgr.mr_n69890208)
print v(xbgr.mr_n69890640)
print v(xbgr.mr_n69891072)
print v(xbgr.mr_n69891504)
print v(xbgr.mr_n69891936)
print v(xbgr.mr_n69892368)
print v(xbgr.mr_n69892800)
print v(xbgr.mr_n69893232)
print v(xbgr.mr_n69893664)
print v(xbgr.mr_n69894096)
print v(xbgr.mr_n69894528)
print v(xbgr.mr_n69894960)
print v(xbgr.mr_n69895392)
print v(xbgr.mr_n69895824)
print v(xbgr.mr_n69896256)
print v(xbgr.mr_n69896688)
print v(xbgr.mr_n69897120)
print v(xbgr.mr_n69897552)
print v(xbgr.mr_n69897984)
print v(xbgr.mr_n69898416)
print v(xbgr.mr_n69898848)
print v(xbgr.mr_n69899168)
print v(xbgr.mr_n69899280)
print v(xbgr.mr_n69899600)
print v(xbgr.mr_n69899712)
print v(xbgr.mr_n69900032)
print v(xbgr.mr_n69900144)
print v(xbgr.mr_n69900464)
print v(xbgr.mr_n69900576)
print v(xbgr.mr_n69900896)
print v(xbgr.mr_n69901008)
print v(xbgr.mr_n69901328)
print v(xbgr.mr_n69901440)
print v(xbgr.mr_n69901760)
print v(xbgr.mr_n69901872)
print v(xbgr.mr_n69902192)
print v(xbgr.mr_n69902304)
print v(xbgr.mr_n69902624)
print v(xbgr.mr_n69902736)
print v(xbgr.mr_n69903056)
print v(xbgr.mr_n69903168)
print v(xbgr.mr_n69903488)
print v(xbgr.mr_n69903600)
print v(xbgr.mr_n69903920)
print v(xbgr.mr_n69904032)
print v(xbgr.mr_n69904352)
print v(xbgr.mr_n69904464)
print v(xbgr.mr_n69904784)
print v(xbgr.mr_n69904896)
print v(xbgr.mr_n69905328)
print v(xbgr.mr_n69905760)
print v(xbgr.mr_n69906192)
print v(xbgr.mr_n69906624)
print v(xbgr.mr_n69906944)
print v(xbgr.mr_n69907056)
print v(xbgr.mr_n69907376)
print v(xbgr.mr_n69907488)
print v(xbgr.mr_n69907808)
print v(xbgr.mr_n69907920)
print v(xbgr.mr_n69908240)
print v(xbgr.mr_n69908352)
print v(xbgr.mr_n69908672)
print v(xbgr.mr_n69908784)
print v(xbgr.mr_n69909104)
print v(xbgr.mr_n69909216)
print v(xbgr.mr_n69909648)
print v(xbgr.mr_n69910080)
print v(xbgr.mr_n69910512)
print v(xbgr.mr_n69910944)
print v(xbgr.mr_n69911376)
print v(xbgr.mr_n69911808)
print v(xbgr.mr_n69912240)
print v(xbgr.mr_n69912672)
print v(xbgr.mr_n69913104)
print v(xbgr.mr_n69913536)
print v(xbgr.mr_n69913856)
print v(xbgr.mr_n69913968)
print v(xbgr.mr_n69914288)
print v(xbgr.mr_n69914400)
print v(xbgr.mr_n69914832)
print v(xbgr.mr_n69915264)
print v(xbgr.mr_n69915584)
print v(xbgr.mr_n69915696)
print v(xbgr.mr_n69916016)
print v(xbgr.mr_n69916128)
print v(xbgr.mr_n69916448)
print v(xbgr.mr_n69916560)
print v(xbgr.mr_n69916880)
print v(xbgr.mr_n69916992)
print v(xbgr.mr_n69917424)
print v(xbgr.mr_n69917856)
print v(xbgr.mr_n69918288)
print v(xbgr.mr_n69918720)
print v(xbgr.mr_n69919152)
print v(xbgr.mr_n69919584)
print v(xbgr.mr_n69920016)
print v(xbgr.mr_n69920448)
print v(xbgr.mr_n69920880)
print v(xbgr.mr_n69921312)
print v(xbgr.mr_n69921632)
print v(xbgr.mr_n69921744)
print v(xbgr.mr_n69922064)
print v(xbgr.mr_n69922176)
print v(xbgr.mr_n69922496)
print v(xbgr.mr_n69922608)
print v(xbgr.mr_n69922928)
print v(xbgr.mr_n69923040)
print v(xbgr.mr_n69923360)
print v(xbgr.mr_n69923472)
print v(xbgr.mr_n69923792)
print v(xbgr.mr_n69923904)
print v(xbgr.mr_n69924224)
print v(xbgr.mr_n69924336)
print v(xbgr.mr_n69924656)
print v(xbgr.mr_n69924768)
print v(xbgr.mr_n69925088)
print v(xbgr.mr_n69925200)
print v(xbgr.mr_n69925520)
print v(xbgr.mr_n69925632)
print v(xbgr.mr_n69925952)
print v(xbgr.mr_n69926064)
print v(xbgr.mr_n69926384)
print v(xbgr.mr_n69926496)
print v(xbgr.mr_n69926816)
print v(xbgr.mr_n69926928)
print v(xbgr.mr_n69927248)
print v(xbgr.mr_n69927360)
print v(xbgr.mr_n69927680)
print v(xbgr.mr_n69927792)
print v(xbgr.mr_n69928112)
print v(xbgr.mr_n69928224)
print v(xbgr.mr_n69928544)
print v(xbgr.mr_n69928656)
print v(xbgr.mr_n69928976)
print v(xbgr.mr_n69929088)
print v(xbgr.mr_n69929408)
print v(xbgr.mr_n69929520)
print v(xbgr.mr_n69929840)
print v(xbgr.mr_n69929952)
print v(xbgr.mr_n69930272)
print v(xbgr.mr_n69930384)
print v(xbgr.mr_n69930704)
print v(xbgr.mr_n69931136)
print v(xbgr.mr_n69931248)
print v(xbgr.mr_n69931568)
print v(xbgr.mr_n69932000)
print v(xbgr.mr_n69932112)
print v(xbgr.mr_n69932432)
print v(xbgr.mr_n69932864)
print v(xbgr.mr_n69932976)
print v(xbgr.mr_n69933296)
print v(xbgr.mr_n69933728)
print v(xbgr.mr_n69933840)
print v(xbgr.mr_n69934160)
print v(xbgr.mr_n69934592)
print v(xbgr.mr_n69934704)
print v(xbgr.mr_n69935024)
print v(xbgr.mr_n69935136)
print v(xbgr.mr_n69935456)
print v(xbgr.mr_n69935568)
print v(xbgr.mr_n69935888)
print v(xbgr.mr_n69936000)
print v(xbgr.mr_n69936320)
print v(xbgr.mr_n69936432)
print v(xbgr.mr_n69936752)
print v(xbgr.mr_n69936864)
print v(xbgr.mr_n69937184)
print v(xbgr.mr_n69937296)
print v(xbgr.mr_n69937616)
print v(xbgr.mr_n69937728)
print v(xbgr.mr_n69938048)
print v(xbgr.mr_n69938160)
print v(xbgr.mr_n69938480)
print v(xbgr.mr_n69938592)
print v(xbgr.mr_n69938912)
print v(xbgr.mr_n69939024)
print v(xbgr.mr_n69939344)
print v(xbgr.mr_n69939456)
print v(xbgr.mr_n69939776)
print v(xbgr.mr_n69939888)
print v(xbgr.mr_n69940208)
print v(xbgr.mr_n69940320)
print v(xbgr.mr_n69940640)
print v(xbgr.mr_n69940752)
print v(xbgr.mr_n69941072)
print v(xbgr.mr_n69941184)
print v(xbgr.mr_n69941504)
print v(xbgr.mr_n69941616)
print v(xbgr.mr_n69941936)
print v(xbgr.mr_n69942048)
print v(xbgr.mr_n69942368)
print v(xbgr.mr_n69942480)
print v(xbgr.mr_n69942800)
print v(xbgr.mr_n69942912)
print v(xbgr.mr_n69943232)
print v(xbgr.mr_n69943344)
print v(xbgr.mr_n69943664)
print v(xbgr.mr_n69943776)
print v(xbgr.mr_n69944096)
print v(xbgr.mr_n69944208)
print v(xbgr.mr_n69944528)
print v(xbgr.mr_n69944640)
print v(xbgr.mr_n69944960)
print v(xbgr.mr_n69945072)
print v(xbgr.mr_n69945392)
print v(xbgr.mr_n69945504)
print v(xbgr.mr_n69945824)
print v(xbgr.mr_n69945936)
print v(xbgr.mr_n69946256)
print v(xbgr.mr_n69946368)
print v(xbgr.mr_n69946688)
print v(xbgr.mr_n69946800)
print v(xbgr.mr_n69947120)
print v(xbgr.mr_n69947232)
print v(xbgr.mr_n69947552)
print v(xbgr.mr_n69947664)
print v(xbgr.mr_n69947984)
print v(xbgr.mr_n69948096)
print v(xbgr.mr_n69948416)
print v(xbgr.mr_n69948528)
print v(xbgr.mr_n69948848)
print v(xbgr.mr_n69948960)
print v(xbgr.mr_n69949280)
print v(xbgr.mr_n69949392)
print v(xbgr.mr_n69949712)
print v(xbgr.mr_n69949824)
print v(xbgr.mr_n69950144)
print v(xbgr.mr_n69950256)
print v(xbgr.mr_n69950576)
print v(xbgr.mr_n69950688)
print v(xbgr.mr_n69951008)
print v(xbgr.mr_n69951120)
print v(xbgr.mr_n69951440)
print v(xbgr.mr_n69951552)
print v(xbgr.mr_n69951872)
print v(xbgr.mr_n69951984)
print v(xbgr.mr_n69952304)
print v(xbgr.mr_n69952416)
print v(xbgr.mr_n69952736)
print v(xbgr.mr_n69952848)
print v(xbgr.mr_n69953168)
print v(xbgr.mr_n69953280)
print v(xbgr.mr_n69953600)
print v(xbgr.mr_n69953712)
print v(xbgr.mr_n69954032)
print v(xbgr.mr_n69954144)
print v(xbgr.mr_n69954464)
print v(xbgr.mr_n69954576)
print v(xbgr.mr_n69954896)
print v(xbgr.mr_n69955008)
print v(xbgr.mr_n69955328)
print v(xbgr.mr_n69955440)
print v(xbgr.mr_n69955760)
print v(xbgr.mr_n69955872)
print v(xbgr.mr_n69956192)
print v(xbgr.mr_n69956304)
print v(xbgr.mr_n69956624)
print v(xbgr.mr_n69956736)
print v(xbgr.mr_n69957056)
print v(xbgr.mr_n69957168)
print v(xbgr.mr_n69957488)
print v(xbgr.mr_n69957600)
print v(xbgr.mr_n69957920)
print v(xbgr.mr_n69958032)
print v(xbgr.mr_n69958352)
print v(xbgr.mr_n69958464)
print v(xbgr.mr_n69958784)
print v(xbgr.mr_n69958896)
print v(xbgr.mr_n69959216)
print v(xbgr.mr_n69959328)
print v(xbgr.mr_n69959648)
print v(xbgr.mr_n69959760)
print v(xbgr.mr_n69960080)
print v(xbgr.mr_n69960192)
print v(xbgr.mr_n69960512)
print v(xbgr.mr_n69960624)
print v(xbgr.mr_n69960944)
print v(xbgr.mr_n69961056)
print v(xbgr.mr_n69961376)
print v(xbgr.mr_n69961488)
print v(xbgr.mr_n69961808)
print v(xbgr.mr_n69961920)
print v(xbgr.mr_n69962240)
print v(xbgr.mr_n69962352)
print v(xbgr.mr_n69962672)
print v(xbgr.mr_n69962784)
print v(xbgr.mr_n69963104)
print v(xbgr.mr_n69963216)
print v(xbgr.mr_n69963536)
print v(xbgr.mr_n69963648)
print v(xbgr.mr_n69963968)
print v(xbgr.mr_n69964080)
print v(xbgr.mr_n69964400)
print v(xbgr.mr_n69964512)
print v(xbgr.mr_n69964832)
print v(xbgr.mr_n69964944)
print v(xbgr.mr_n69965264)
print v(xbgr.mr_n69965376)
print v(xbgr.mr_n69965696)
print v(xbgr.mr_n69966128)
print v(xbgr.mr_n69966240)
print v(xbgr.mr_n69966560)
print v(xbgr.mr_n69966992)
print v(xbgr.mr_n69967104)
print v(xbgr.mr_n69967424)
print v(xbgr.mr_n69967856)
print v(xbgr.mr_n69967968)
print v(xbgr.mr_n69968288)
print v(xbgr.mr_n69968720)
print v(xbgr.mr_n69968832)
print v(xbgr.mr_n69969152)
print v(xbgr.mr_n69969264)
print v(xbgr.mr_n69969584)
print v(xbgr.mr_n69969696)
print v(xbgr.mr_n69970016)
print v(xbgr.mr_n69970128)
print v(xbgr.mr_n69970448)
print v(xbgr.mr_n69970880)
print v(xbgr.mr_n69970992)
print v(xbgr.mr_n69971312)
print v(xbgr.mr_n69971744)
print v(xbgr.mr_n69971856)
print v(xbgr.mr_n69972176)
print v(xbgr.mr_n69972608)
print v(xbgr.mr_n69972720)
print v(xbgr.mr_n69973040)
print v(xbgr.mr_n69973472)
print v(xbgr.mr_n69973584)
print v(xbgr.mr_n69973904)
print v(xbgr.mr_n69974016)
print v(xbgr.mr_n69974336)
print v(xbgr.mr_n69974448)
print v(xbgr.mr_n69974768)
print v(xbgr.mr_n69974880)
print v(xbgr.mr_n69975200)
print v(xbgr.mr_n69975312)
print v(xbgr.mr_n69975632)
print v(xbgr.mr_n69975744)
print v(xbgr.mr_n69976064)
print v(xbgr.mr_n69976176)
print v(xbgr.mr_n69976496)
print v(xbgr.mr_n69976608)
print v(xbgr.mr_n69976928)
print v(xbgr.mr_n69977040)
print v(xbgr.mr_n69977360)
print v(xbgr.mr_n69977472)
print v(xbgr.mr_n69977792)
print v(xbgr.mr_n69977904)
print v(xbgr.mr_n69978224)
print v(xbgr.mr_n69978336)
print v(xbgr.mr_n69978656)
print v(xbgr.mr_n69978768)
print v(xbgr.mr_n69979088)
print v(xbgr.mr_n69979200)
print v(xbgr.mr_n69979520)
print v(xbgr.mr_n69979632)
print v(xbgr.mr_n69979952)
print v(xbgr.mr_n69980064)
print v(xbgr.mr_n69980384)
print v(xbgr.mr_n69980496)
print v(xbgr.mr_n69980816)
print v(xbgr.mr_n69980928)
print v(xbgr.mr_n69981248)
print v(xbgr.mr_n69981360)
print v(xbgr.mr_n69981680)
print v(xbgr.mr_n69981792)
print v(xbgr.mr_n69982112)
print v(xbgr.mr_n69982224)
print v(xbgr.mr_n69982544)
print v(xbgr.mr_n69982656)
print v(xbgr.mr_n69982976)
print v(xbgr.mr_n69983088)
print v(xbgr.mr_n69983408)
print v(xbgr.mr_n69983520)
print v(xbgr.mr_n69983840)
print v(xbgr.mr_n69983952)
print v(xbgr.mr_n69984272)
print v(xbgr.mr_n69984384)
print v(xbgr.mr_n69984704)
print v(xbgr.mr_n69984816)
print v(xbgr.mr_n69985136)
print v(xbgr.mr_n69985248)
print v(xbgr.mr_n69985680)
print v(xbgr.mr_n69986112)
print v(xbgr.mr_n69986544)
print v(xbgr.mr_n69986976)
print v(xbgr.mr_n69987408)
print v(xbgr.mr_n69987840)
print v(xbgr.mr_n69988272)
print v(xbgr.mr_n69988704)
print v(xbgr.mr_n69989136)
print v(xbgr.mr_n69989568)
print v(xbgr.mr_n69990000)
print v(xbgr.mr_n69990432)
print v(xbgr.mr_n69990864)
print v(xbgr.mr_n69991296)
print v(xbgr.mr_n69991728)
print v(xbgr.mr_n69992160)
print v(xbgr.mr_n69992592)
print v(xbgr.mr_n69993024)
print v(xbgr.mr_n69993456)
print v(xbgr.mr_n69993888)
print v(xbgr.mr_n69994320)
print v(xbgr.mr_n69994752)
print v(xbgr.mr_n69995184)
print v(xbgr.mr_n69995616)
print v(xbgr.mr_n69996048)
print v(xbgr.mr_n69996480)
print v(xbgr.mr_n69996800)
print v(xbgr.mr_n69996912)
print v(xbgr.mr_n69997232)
print v(xbgr.mr_n69997344)
print v(xbgr.mr_n69997664)
print v(xbgr.mr_n69997776)
print v(xbgr.mr_n69998096)
print v(xbgr.mr_n69998208)
print v(xbgr.mr_n69998528)
print v(xbgr.mr_n69998640)
print v(xbgr.mr_n69998960)
print v(xbgr.mr_n69999072)
print v(xbgr.mr_n69999392)
print v(xbgr.mr_n69999504)
print v(xbgr.mr_n69999824)
print v(xbgr.mr_n69999936)
print v(xbgr.mr_n70000256)
print v(xbgr.mr_n70000368)
print v(xbgr.mr_n70000688)
print v(xbgr.mr_n70000800)
print v(xbgr.mr_n70001120)
print v(xbgr.mr_n70001232)
print v(xbgr.mr_n70001552)
print v(xbgr.mr_n70001664)
print v(xbgr.mr_n70001984)
print v(xbgr.mr_n70002096)
print v(xbgr.mr_n70002416)
print v(xbgr.mr_n70002528)
print v(xbgr.mr_n70002848)
print v(xbgr.mr_n70002960)
print v(xbgr.mr_n70003280)
print v(xbgr.mr_n70003392)
print v(xbgr.mr_n70003712)
print v(xbgr.mr_n70003824)
print v(xbgr.mr_n70004144)
print v(xbgr.mr_n70004256)
print v(xbgr.mr_n70004576)
print v(xbgr.mr_n70004688)
print v(xbgr.mr_n70005008)
print v(xbgr.mr_n70005120)
print v(xbgr.mr_n70005552)
print v(xbgr.mr_n70005984)
print v(xbgr.mr_n70006416)
print v(xbgr.mr_n70006848)
print v(xbgr.mr_n70007280)
print v(xbgr.mr_n70007712)
print v(xbgr.mr_n70008144)
print v(xbgr.mr_n70008576)
print v(xbgr.mr_n70009008)
print v(xbgr.mr_n70009440)
print v(xbgr.mr_n70009872)
print v(xbgr.mr_n70010304)
print v(xbgr.mr_n70010624)
print v(xbgr.mr_n70010736)
print v(xbgr.mr_n70011056)
print v(xbgr.mr_n70011168)
print v(xbgr.mr_n70011600)
print v(xbgr.mr_n70012032)
print v(xbgr.mr_n70012464)
print v(xbgr.mr_n70012896)
print v(xbgr.mr_n70013328)
print v(xbgr.mr_n70013760)
print v(xbgr.mr_n70014192)
print v(xbgr.mr_n70014624)
print v(xbgr.mr_n70015056)
print v(xbgr.mr_n70015488)
print v(xbgr.mr_n70015808)
print v(xbgr.mr_n70015920)
print v(xbgr.mr_n70016240)
print v(xbgr.mr_n70016352)
print v(xbgr.mr_n70016672)
print v(xbgr.mr_n70016784)
print v(xbgr.mr_n70017104)
print v(xbgr.mr_n70017216)
print v(xbgr.mr_n70017536)
print v(xbgr.mr_n70017648)
print v(xbgr.mr_n70017968)
print v(xbgr.mr_n70018080)
print v(xbgr.mr_n70018400)
print v(xbgr.mr_n70018512)
print v(xbgr.mr_n70018832)
print v(xbgr.mr_n70018944)
print v(xbgr.mr_n70019264)
print v(xbgr.mr_n70019376)
print v(xbgr.mr_n70019696)
print v(xbgr.mr_n70019808)
print v(xbgr.mr_n70020128)
print v(xbgr.mr_n70020240)
print v(xbgr.mr_n70020560)
print v(xbgr.mr_n70020672)
print v(xbgr.mr_n70020992)
print v(xbgr.mr_n70021104)
print v(xbgr.mr_n70021424)
print v(xbgr.mr_n70021536)
print v(xbgr.mr_n70021856)
print v(xbgr.mr_n70021968)
print v(xbgr.mr_n70022288)
print v(xbgr.mr_n70022400)
print v(xbgr.mr_n70022720)
print v(xbgr.mr_n70022832)
print v(xbgr.mr_n70023152)
print v(xbgr.mr_n70023264)
print v(xbgr.mr_n70023584)
print v(xbgr.mr_n70023696)
print v(xbgr.mr_n70024016)
print v(xbgr.mr_n70024128)
print v(xbgr.mr_n70024448)
print v(xbgr.mr_n70024560)
print v(xbgr.mr_n70024880)
print v(xbgr.mr_n70024992)
print v(xbgr.mr_n70025312)
print v(xbgr.mr_n70025424)
print v(xbgr.mr_n70025744)
print v(xbgr.mr_n70025856)
print v(xbgr.mr_n70026176)
print v(xbgr.mr_n70026288)
print v(xbgr.mr_n70026608)
print v(xbgr.mr_n70026720)
print v(xbgr.mr_n70027040)
print v(xbgr.mr_n70027472)
print v(xbgr.mr_n70027584)
print v(xbgr.mr_n70027904)
print v(xbgr.mr_n70028336)
print v(xbgr.mr_n70028448)
print v(xbgr.mr_n70028768)
print v(xbgr.mr_n70029200)
print v(xbgr.mr_n70029312)
print v(xbgr.mr_n70029632)
print v(xbgr.mr_n70030064)
print v(xbgr.mr_n70030176)
print v(xbgr.mr_n70030496)
print v(xbgr.mr_n70030928)
print v(xbgr.mr_n70031040)
print v(xbgr.mr_n70031360)
print v(xbgr.mr_n70031472)
print v(xbgr.mr_n70031792)
print v(xbgr.mr_n70031904)
print v(xbgr.mr_n70032224)
print v(xbgr.mr_n70032336)
print v(xbgr.mr_n70032656)
print v(xbgr.mr_n70032768)
print v(xbgr.mr_n70033088)
print v(xbgr.mr_n70033200)
print v(xbgr.mr_n70033520)
print v(xbgr.mr_n70033632)
print v(xbgr.mr_n70033952)
print v(xbgr.mr_n70034064)
print v(xbgr.mr_n70034384)
print v(xbgr.mr_n70034496)
print v(xbgr.mr_n70034816)
print v(xbgr.mr_n70034928)
print v(xbgr.mr_n70035248)
print v(xbgr.mr_n70035360)
print v(xbgr.mr_n70035680)
print v(xbgr.mr_n70035792)
print v(xbgr.mr_n70036112)
print v(xbgr.mr_n70036224)
print v(xbgr.mr_n70036544)
print v(xbgr.mr_n70036656)
print v(xbgr.mr_n70036976)
print v(xbgr.mr_n70037088)
print v(xbgr.mr_n70037408)
print v(xbgr.mr_n70037520)
print v(xbgr.mr_n70037840)
print v(xbgr.mr_n70037952)
print v(xbgr.mr_n70038272)
print v(xbgr.mr_n70038384)
print v(xbgr.mr_n70038704)
print v(xbgr.mr_n70038816)
print v(xbgr.mr_n70039136)
print v(xbgr.mr_n70039248)
print v(xbgr.mr_n70039568)
print v(xbgr.mr_n70039680)
print v(xbgr.mr_n70040000)
print v(xbgr.mr_n70040112)
print v(xbgr.mr_n70040432)
print v(xbgr.mr_n70040544)
print v(xbgr.mr_n70040864)
print v(xbgr.mr_n70040976)
print v(xbgr.mr_n70041296)
print v(xbgr.mr_n70041408)
print v(xbgr.mr_n70041728)
print v(xbgr.mr_n70041840)
print v(xbgr.mr_n70042160)
print v(xbgr.mr_n70042272)
print v(xbgr.mr_n70042592)
print v(xbgr.mr_n70042704)
print v(xbgr.mr_n70043024)
print v(xbgr.mr_n70043136)
print v(xbgr.mr_n70043456)
print v(xbgr.mr_n70043568)
print v(xbgr.mr_n70043888)
print v(xbgr.mr_n70044000)
print v(xbgr.mr_n70044320)
print v(xbgr.mr_n70044432)
print v(xbgr.mr_n70044752)
print v(xbgr.mr_n70044864)
print v(xbgr.mr_n70045184)
print v(xbgr.mr_n70045296)
print v(xbgr.mr_n70045616)
print v(xbgr.mr_n70045728)
print v(xbgr.mr_n70046048)
print v(xbgr.mr_n70046160)
print v(xbgr.mr_n70046480)
print v(xbgr.mr_n70046592)
print v(xbgr.mr_n70046912)
print v(xbgr.mr_n70047024)
print v(xbgr.mr_n70047344)
print v(xbgr.mr_n70047456)
print v(xbgr.mr_n70047776)
print v(xbgr.mr_n70047888)
print v(xbgr.mr_n70048208)
print v(xbgr.mr_n70048320)
print v(xbgr.mr_n70048640)
print v(xbgr.mr_n70048752)
print v(xbgr.mr_n70049072)
print v(xbgr.mr_n70049184)
print v(xbgr.mr_n70049504)
print v(xbgr.mr_n70049936)
print v(xbgr.mr_n70050048)
print v(xbgr.mr_n70050368)
print v(xbgr.mr_n70050480)
print v(xbgr.mr_n70050800)
print v(xbgr.mr_n70050912)
print v(xbgr.mr_n70051232)
print v(xbgr.mr_n70051664)
print v(xbgr.mr_n70051776)
print v(xbgr.mr_n70052096)
print v(xbgr.mr_n70052528)
print v(xbgr.mr_n70052640)
print v(xbgr.mr_n70052960)
print v(xbgr.mr_n70053072)
print v(xbgr.mr_n70053392)
print v(xbgr.mr_n70053504)
print v(xbgr.mr_n70053824)
print v(xbgr.mr_n70053936)
print v(xbgr.mr_n70054256)
print v(xbgr.mr_n70054368)
print v(xbgr.mr_n70054688)
print v(xbgr.mr_n70054800)
print v(xbgr.mr_n70055120)
print v(xbgr.mr_n70055232)
print v(xbgr.mr_n70055552)
print v(xbgr.mr_n70055664)
print v(xbgr.mr_n70055984)
print v(xbgr.mr_n70056096)
print v(xbgr.mr_n70056416)
print v(xbgr.mr_n70056528)
print v(xbgr.mr_n70056848)
print v(xbgr.mr_n70056960)
print v(xbgr.mr_n70057280)
print v(xbgr.mr_n70057392)
print v(xbgr.mr_n70057712)
print v(xbgr.mr_n70057824)
print v(xbgr.mr_n70058144)
print v(xbgr.mr_n70058576)
print v(xbgr.mr_n70058688)
print v(xbgr.mr_n70059008)
print v(xbgr.mr_n70059120)
print v(xbgr.mr_n70059440)
print v(xbgr.mr_n70059552)
print v(xbgr.mr_n70059872)
print v(xbgr.mr_n70059984)
print v(xbgr.mr_n70060304)
print v(xbgr.mr_n70060416)
print v(xbgr.mr_n70060736)
print v(xbgr.mr_n70060848)
print v(xbgr.mr_n70061168)
print v(xbgr.mr_n70061280)
print v(xbgr.mr_n70061600)
print v(xbgr.mr_n70061712)
print v(xbgr.mr_n70062032)
print v(xbgr.mr_n70062144)
print v(xbgr.mr_n70062464)
print v(xbgr.mr_n70062576)
print v(xbgr.mr_n70062896)
print v(xbgr.mr_n70063008)
print v(xbgr.mr_n70063328)
print v(xbgr.mr_n70063440)
print v(xbgr.mr_n70063760)
print v(xbgr.mr_n70063872)
print v(xbgr.mr_n70064192)
print v(xbgr.mr_n70064304)
print v(xbgr.mr_n70064624)
print v(xbgr.mr_n70064736)
print v(xbgr.mr_n70065056)
print v(xbgr.mr_n70065168)
print v(xbgr.mr_n70065488)
print v(xbgr.mr_n70065600)
print v(xbgr.mr_n70065920)
print v(xbgr.mr_n70066032)
print v(xbgr.mr_n70066352)
print v(xbgr.mr_n70066464)
print v(xbgr.mr_n70066784)
print v(xbgr.mr_n70066896)
print v(xbgr.mr_n70067216)
print v(xbgr.mr_n70067328)
print v(xbgr.mr_n70067648)
print v(xbgr.mr_n70067760)
print v(xbgr.mr_n70068080)
print v(xbgr.mr_n70068192)
print v(xbgr.mr_n70068512)
print v(xbgr.mr_n70068624)
print v(xbgr.mr_n70068944)
print v(xbgr.mr_n70069056)
print v(xbgr.mr_n70069376)
print v(xbgr.mr_n70069488)
print v(xbgr.mr_n70069808)
print v(xbgr.mr_n70069920)
print v(xbgr.mr_n70070240)
print v(xbgr.mr_n70070352)
print v(xbgr.mr_n70070672)
print v(xbgr.mr_n70070784)
print v(xbgr.mr_n70071104)
print v(xbgr.mr_n70071216)
print v(xbgr.mr_n70071536)
print v(xbgr.mr_n70071648)
print v(xbgr.mr_n70071968)
print v(xbgr.mr_n70072080)
print v(xbgr.mr_n70072400)
print v(xbgr.mr_n70072512)
print v(xbgr.mr_n70072832)
print v(xbgr.mr_n70072944)
print v(xbgr.mr_n70073264)
print v(xbgr.mr_n70073376)
print v(xbgr.mr_n70073696)
print v(xbgr.mr_n70073808)
print v(xbgr.mr_n70074128)
print v(xbgr.mr_n70074240)
print v(xbgr.mr_n70074560)
print v(xbgr.mr_n70074672)
print v(xbgr.mr_n70074992)
print v(xbgr.mr_n70075104)
print v(xbgr.mr_n70075424)
print v(xbgr.mr_n70075536)
print v(xbgr.mr_n70075856)
print v(xbgr.mr_n70075968)
print v(xbgr.mr_n70076288)
print v(xbgr.mr_n70076400)
print v(xbgr.mr_n70076720)
print v(xbgr.mr_n70076832)
print v(xbgr.mr_n70077152)
print v(xbgr.mr_n70077264)
print v(xbgr.mr_n70077584)
print v(xbgr.mr_n70077696)
print v(xbgr.mr_n70078016)
print v(xbgr.mr_n70078128)
print v(xbgr.mr_n70078448)
print v(xbgr.mr_n70078560)
print v(xbgr.mr_n70078880)
print v(xbgr.mr_n70078992)
print v(xbgr.mr_n70079312)
print v(xbgr.mr_n70079424)
print v(xbgr.mr_n70079744)
print v(xbgr.mr_n70079856)
print v(xbgr.mr_n70080288)
print v(xbgr.mr_n70080720)
print v(xbgr.mr_n70081152)
print v(xbgr.mr_n70081584)
print v(xbgr.mr_n70082016)
print v(xbgr.mr_n70082448)
print v(xbgr.mr_n70082880)
print v(xbgr.mr_n70083312)
print v(xbgr.mr_n70083632)
print v(xbgr.mr_n70083744)
print v(xbgr.mr_n70084064)
print v(xbgr.mr_n70084176)
print v(xbgr.mr_n70084496)
print v(xbgr.mr_n70084608)
print v(xbgr.mr_n70084928)
print v(xbgr.mr_n70085040)
print v(xbgr.mr_n70085360)
print v(xbgr.mr_n70085472)
print v(xbgr.mr_n70085792)
print v(xbgr.mr_n70085904)
print v(xbgr.mr_n70086224)
print v(xbgr.mr_n70086336)
print v(xbgr.mr_n70086656)
print v(xbgr.mr_n70086768)
print v(xbgr.mr_n70087200)
print v(xbgr.mr_n70087632)
print v(xbgr.mr_n70088064)
print v(xbgr.mr_n70088496)
print v(xbgr.mr_n70088928)
print v(xbgr.mr_n70089360)
print v(xbgr.mr_n70089680)
print v(xbgr.mr_n70089792)
print v(xbgr.mr_n70090224)
print v(xbgr.mr_n70090656)
print v(xbgr.mr_n70091088)
print v(xbgr.mr_n70091520)
print v(xbgr.mr_n70091952)
print v(xbgr.mr_n70092384)
print v(xbgr.mr_n70092816)
print v(xbgr.mr_n70093248)
print v(xbgr.mr_n70093680)
print v(xbgr.mr_n70094112)
print v(xbgr.mr_n70094544)
print v(xbgr.mr_n70094976)
print v(xbgr.mr_n70095296)
print v(xbgr.mr_n70095408)
print v(xbgr.mr_n70095728)
print v(xbgr.mr_n70095840)
print v(xbgr.mr_n70096160)
print v(xbgr.mr_n70096272)
print v(xbgr.mr_n70096592)
print v(xbgr.mr_n70096704)
print v(xbgr.mr_n70097024)
print v(xbgr.mr_n70097136)
print v(xbgr.mr_n70097456)
print v(xbgr.mr_n70097568)
print v(xbgr.mr_n70097888)
print v(xbgr.mr_n70098000)
print v(xbgr.mr_n70098320)
print v(xbgr.mr_n70098432)
print v(xbgr.mr_n70098752)
print v(xbgr.mr_n70098864)
print v(xbgr.mr_n70099184)
print v(xbgr.mr_n70099296)
print v(xbgr.mr_n70099616)
print v(xbgr.mr_n70099728)
print v(xbgr.mr_n70100048)
print v(xbgr.mr_n70100160)
print v(xbgr.mr_n70100480)
print v(xbgr.mr_n70100592)
print v(xbgr.mr_n70100912)
print v(xbgr.mr_n70101024)
print v(xbgr.mr_n70101344)
print v(xbgr.mr_n70101456)
print v(xbgr.mr_n70101776)
print v(xbgr.mr_n70101888)
print v(xbgr.mr_n70102208)
print v(xbgr.mr_n70102320)
print v(xbgr.mr_n70102640)
print v(xbgr.mr_n70102752)
print v(xbgr.mr_n70103072)
print v(xbgr.mr_n70103184)
print v(xbgr.mr_n70103504)
print v(xbgr.mr_n70103616)
print v(xbgr.mr_n70103936)
print v(xbgr.mr_n70104048)
print v(xbgr.mr_n70104480)
print v(xbgr.mr_n70104912)
print v(xbgr.mr_n70105344)
print v(xbgr.mr_n70105776)
print v(xbgr.mr_n70106208)
print v(xbgr.mr_n70106640)
print v(xbgr.mr_n70107072)
print v(xbgr.mr_n70107504)
print v(xbgr.mr_n70107936)
print v(xbgr.mr_n70108368)
print v(xbgr.mr_n70108800)
print v(xbgr.mr_n70109232)
print v(xbgr.mr_n70109664)
print v(xbgr.mr_n70110096)
print v(xbgr.mr_n70110528)
print v(xbgr.mr_n70110960)
print v(xbgr.mr_n70111392)
print v(xbgr.mr_n70111824)
print v(xbgr.mr_n70112256)
print v(xbgr.mr_n70112576)
print v(xbgr.mr_n70112688)
print v(xbgr.mr_n70113008)
print v(xbgr.mr_n70113120)
print v(xbgr.mr_n70113440)
print v(xbgr.mr_n70113552)
print v(xbgr.mr_n70113872)
print v(xbgr.mr_n70113984)
print v(xbgr.mr_n70114304)
print v(xbgr.mr_n70114416)
print v(xbgr.mr_n70114848)
print v(xbgr.mr_n70115280)
print v(xbgr.mr_n70115712)
print v(xbgr.mr_n70116144)
print v(xbgr.mr_n70116576)
print v(xbgr.mr_n70117008)
print v(xbgr.mr_n70117440)
print v(xbgr.mr_n70117760)
print v(xbgr.mr_n70117872)
print v(xbgr.mr_n70118192)
print v(xbgr.mr_n70118304)
print v(xbgr.mr_n70118624)
print v(xbgr.mr_n70118736)
print v(xbgr.mr_n70119056)
print v(xbgr.mr_n70119168)
print v(xbgr.mr_n70119488)
print v(xbgr.mr_n70119600)
print v(xbgr.mr_n70119920)
print v(xbgr.mr_n70120032)
print v(xbgr.mr_n70120352)
print v(xbgr.mr_n70120464)
print v(xbgr.mr_n70120784)
print v(xbgr.mr_n70120896)
print v(xbgr.mr_n70121216)
print v(xbgr.mr_n70121328)
print v(xbgr.mr_n70121648)
print v(xbgr.mr_n70121760)
print v(xbgr.mr_n70122080)
print v(xbgr.mr_n70122192)
print v(xbgr.mr_n70122512)
print v(xbgr.mr_n70122624)
print v(xbgr.mr_n70122944)
print v(xbgr.mr_n70123056)
print v(xbgr.mr_n70123488)
print v(xbgr.mr_n70123920)
print v(xbgr.mr_n70124352)
print v(xbgr.mr_n70124784)
print v(xbgr.mr_n70125216)
print v(xbgr.mr_n70125648)
print v(xbgr.mr_n70126080)
print v(xbgr.mr_n70126512)
print v(xbgr.mr_n70126944)
print v(xbgr.mr_n70127376)
print v(xbgr.mr_n70127808)
print v(xbgr.mr_n70128240)
print v(xbgr.mr_n70128672)
print v(xbgr.mr_n70128992)
print v(xbgr.mr_n70129104)
print v(xbgr.mr_n70129424)
print v(xbgr.mr_n70129536)
print v(xbgr.mr_n70129856)
print v(xbgr.mr_n70129968)
print v(xbgr.mr_n70130288)
print v(xbgr.mr_n70130400)
print v(xbgr.mr_n70130720)
print v(xbgr.mr_n70130832)
print v(xbgr.mr_n70131152)
print v(xbgr.mr_n70131264)
print v(xbgr.mr_n70131584)
print v(xbgr.mr_n70131696)
print v(xbgr.mr_n70132016)
print v(xbgr.mr_n70132128)
print v(xbgr.mr_n70132448)
print v(xbgr.mr_n70132560)
print v(xbgr.mr_n70132880)
print v(xbgr.mr_n70132992)
print v(xbgr.mr_n70133312)
print v(xbgr.mr_n70133424)
print v(xbgr.mr_n70133744)
print v(xbgr.mr_n70133856)
print v(xbgr.mr_n70134288)
print v(xbgr.mr_n70134720)
print v(xbgr.mr_n70135152)
print v(xbgr.mr_n70135584)
print v(xbgr.mr_n70136016)
print v(xbgr.mr_n70136448)
print v(xbgr.mr_n70136880)
print v(xbgr.mr_n70137312)
print v(xbgr.mr_n70137744)
print v(xbgr.mr_n70138176)
print v(xbgr.mr_n70138608)
print v(xbgr.mr_n70139040)
print v(xbgr.mr_n70139360)
print v(xbgr.mr_n70139472)
print v(xbgr.mr_n70139904)
print v(xbgr.mr_n70140224)
print v(xbgr.mr_n70140336)
print v(xbgr.mr_n70140656)
print v(xbgr.mr_n70140768)
print v(xbgr.mr_n70141088)
print v(xbgr.mr_n70141200)
print v(xbgr.mr_n70141520)
print v(xbgr.mr_n70141632)
print v(xbgr.mr_n70141952)
print v(xbgr.mr_n70142064)
print v(xbgr.mr_n70142496)
print v(xbgr.mr_n70142928)
print v(xbgr.mr_n70143248)
print v(xbgr.mr_n70143360)
print v(xbgr.mr_n70143680)
print v(xbgr.mr_n70143792)
print v(xbgr.mr_n70144112)
print v(xbgr.mr_n70144224)
print v(xbgr.mr_n70144544)
print v(xbgr.mr_n70144656)
print v(xbgr.mr_n70144976)
print v(xbgr.mr_n70145088)
print v(xbgr.mr_n70145408)
print v(xbgr.mr_n70145520)
print v(xbgr.mr_n70145840)
print v(xbgr.mr_n70145952)
print v(xbgr.mr_n70146272)
print v(xbgr.mr_n70146384)
print v(xbgr.mr_n70146816)
print v(xbgr.mr_n70147248)
print v(xbgr.mr_n70147680)
print v(xbgr.mr_n70148112)
print v(xbgr.mr_n70148544)
print v(xbgr.mr_n70148976)
print v(xbgr.mr_n70149408)
print v(xbgr.mr_n70149840)
print v(xbgr.mr_n70150272)
print v(xbgr.mr_n70150704)
print v(xbgr.mr_n70151136)
print v(xbgr.mr_n70151456)
print v(xbgr.mr_n70151568)
print v(xbgr.mr_n70151888)
print v(xbgr.mr_n70152000)
print v(xbgr.mr_n70152320)
print v(xbgr.mr_n70152432)
print v(xbgr.mr_n70152864)
print v(xbgr.mr_n70153296)
print v(xbgr.mr_n70153616)
print v(xbgr.mr_n70153728)
print v(xbgr.mr_n70154048)
print v(xbgr.mr_n70154160)
print v(xbgr.mr_n70154480)
print v(xbgr.mr_n70154592)
print v(xbgr.mr_n70154912)
print v(xbgr.mr_n70155024)
print v(xbgr.mr_n70155456)
print v(xbgr.mr_n70155776)
print v(xbgr.mr_n70155888)
print v(xbgr.mr_n70156208)
print v(xbgr.mr_n70156320)
print v(xbgr.mr_n70156640)
print v(xbgr.mr_n70156752)
print v(xbgr.mr_n70157072)
print v(xbgr.mr_n70157184)
print v(xbgr.mr_n70157504)
print v(xbgr.mr_n70157616)
print v(xbgr.mr_n70157936)
print v(xbgr.mr_n70158048)
print v(xbgr.mr_n70158480)
print v(xbgr.mr_n70158912)
print v(xbgr.mr_n70159344)
print v(xbgr.mr_n70159776)
print v(xbgr.mr_n70160208)
print v(xbgr.mr_n70160640)
print v(xbgr.mr_n70161072)
print v(xbgr.mr_n70161504)
print v(xbgr.mr_n70161936)
print v(xbgr.mr_n70162368)
print v(xbgr.mr_n70162688)
print v(xbgr.mr_n70162800)
print v(xbgr.mr_n70163120)
print v(xbgr.mr_n70163232)
print v(xbgr.mr_n70163552)
print v(xbgr.mr_n70163664)
print v(xbgr.mr_n70163984)
print v(xbgr.mr_n70164096)
print v(xbgr.mr_n70164416)
print v(xbgr.mr_n70164528)
print v(xbgr.mr_n70164848)
print v(xbgr.mr_n70164960)
print v(xbgr.mr_n70165280)
print v(xbgr.mr_n70165392)
print v(xbgr.mr_n70165712)
print v(xbgr.mr_n70165824)
print v(xbgr.mr_n70166144)
print v(xbgr.mr_n70166256)
print v(xbgr.mr_n70166576)
print v(xbgr.mr_n70166688)
print v(xbgr.mr_n70167008)
print v(xbgr.mr_n70167120)
print v(xbgr.mr_n70167440)
print v(xbgr.mr_n70167552)
print v(xbgr.mr_n70167872)
print v(xbgr.mr_n70167984)
print v(xbgr.mr_n70168416)
print v(xbgr.mr_n70168848)
print v(xbgr.mr_n70169280)
print v(xbgr.mr_n70169712)
print v(xbgr.mr_n70170144)
print v(xbgr.mr_n70170576)
print v(xbgr.mr_n70171008)
print v(xbgr.mr_n70171440)
print v(xbgr.mr_n70171872)
print v(xbgr.mr_n70172304)
print v(xbgr.mr_n70172736)
print v(xbgr.mr_n70173168)
print v(xbgr.mr_n70173600)
print v(xbgr.mr_n70173920)
print v(xbgr.mr_n70174032)
print v(xbgr.mr_n70174352)
print v(xbgr.mr_n70174464)
print v(xbgr.mr_n70174784)
print v(xbgr.mr_n70174896)
print v(xbgr.mr_n70175216)
print v(xbgr.mr_n70175328)
print v(xbgr.mr_n70175648)
print v(xbgr.mr_n70175760)
print v(xbgr.mr_n70176080)
print v(xbgr.mr_n70176192)
print v(xbgr.mr_n70176512)
print v(xbgr.mr_n70176624)
print v(xbgr.mr_n70176944)
print v(xbgr.mr_n70177056)
print v(xbgr.mr_n70177376)
print v(xbgr.mr_n70177488)
print v(xbgr.mr_n70177808)
print v(xbgr.mr_n70177920)
print v(xbgr.mr_n70178240)
print v(xbgr.mr_n70178352)
print v(xbgr.mr_n70178672)
print v(xbgr.mr_n70178784)
print v(xbgr.mr_n70179104)
print v(xbgr.mr_n70179216)
print v(xbgr.mr_n70179648)
print v(xbgr.mr_n70180080)
print v(xbgr.mr_n70180512)
print v(xbgr.mr_n70180944)
print v(xbgr.mr_n70181376)
print v(xbgr.mr_n70181808)
print v(xbgr.mr_n70182240)
print v(xbgr.mr_n70182672)
print v(xbgr.mr_n70183104)
print v(xbgr.mr_n70183536)
print v(xbgr.mr_n70183968)
print v(xbgr.mr_n70184400)
print v(xbgr.mr_n70184832)
print v(xbgr.mr_n70185152)
print v(xbgr.mr_n70185264)
print v(xbgr.mr_n70185584)
print v(xbgr.mr_n70185696)
print v(xbgr.mr_n70186016)
print v(xbgr.mr_n70186128)
print v(xbgr.mr_n70186448)
print v(xbgr.mr_n70186560)
print v(xbgr.mr_n70186880)
print v(xbgr.mr_n70186992)
print v(xbgr.mr_n70187312)
print v(xbgr.mr_n70187424)
print v(xbgr.mr_n70187744)
print v(xbgr.mr_n70187856)
print v(xbgr.mr_n70188176)
print v(xbgr.mr_n70188288)
print v(xbgr.mr_n70188608)
print v(xbgr.mr_n70188720)
print v(xbgr.mr_n70189040)
print v(xbgr.mr_n70189152)
print v(xbgr.mr_n70189472)
print v(xbgr.mr_n70189584)
print v(xbgr.mr_n70189904)
print v(xbgr.mr_n70190016)
print v(xbgr.mr_n70190336)
print v(xbgr.mr_n70190448)
print v(xbgr.mr_n70190880)
print v(xbgr.mr_n70191312)
print v(xbgr.mr_n70191744)
print v(xbgr.mr_n70192176)
print v(xbgr.mr_n70192608)
print v(xbgr.mr_n70193040)
print v(xbgr.mr_n70193472)
print v(xbgr.mr_n70193904)
print v(xbgr.mr_n70194336)
print v(xbgr.mr_n70194768)
print v(xbgr.mr_n70195200)
print v(xbgr.mr_n70195632)
print v(xbgr.mr_n70196064)
print v(xbgr.mr_n70196384)
print v(xbgr.mr_n70196496)
print v(xbgr.mr_n70196816)
print v(xbgr.mr_n70196928)
print v(xbgr.mr_n70197360)
print v(xbgr.mr_n70197680)
print v(xbgr.mr_n70197792)
print v(xbgr.mr_n70198112)
print v(xbgr.mr_n70198224)
print v(xbgr.mr_n70198544)
print v(xbgr.mr_n70198656)
print v(xbgr.mr_n70198976)
print v(xbgr.mr_n70199088)
print v(xbgr.mr_n70199520)
print v(xbgr.mr_n70199952)
print v(xbgr.mr_n70200384)
print v(xbgr.mr_n70200816)
print v(xbgr.mr_n70201136)
print v(xbgr.mr_n70201248)
print v(xbgr.mr_n70201568)
print v(xbgr.mr_n70201680)
print v(xbgr.mr_n70202112)
print v(xbgr.mr_n70202544)
print v(xbgr.mr_n70202864)
print v(xbgr.mr_n70202976)
print v(xbgr.mr_n70203296)
print v(xbgr.mr_n70203408)
print v(xbgr.mr_n70203728)
print v(xbgr.mr_n70203840)
print v(xbgr.mr_n70204160)
print v(xbgr.mr_n70204272)
print v(xbgr.mr_n70204592)
print v(xbgr.mr_n70204704)
print v(xbgr.mr_n70205136)
print v(xbgr.mr_n70205568)
print v(xbgr.mr_n70206000)
print v(xbgr.mr_n70206432)
print v(xbgr.mr_n70206864)
print v(xbgr.mr_n70207296)
print v(xbgr.mr_n70207616)
print v(xbgr.mr_n70207728)
print v(xbgr.mr_n70208048)
print v(xbgr.mr_n70208160)
print v(xbgr.mr_n70208480)
print v(xbgr.mr_n70208592)
print v(xbgr.mr_n70208912)
print v(xbgr.mr_n70209024)
print v(xbgr.mr_n70209344)
print v(xbgr.mr_n70209456)
print v(xbgr.mr_n70209776)
print v(xbgr.mr_n70209888)
print v(xbgr.mr_n70210208)
print v(xbgr.mr_n70210320)
print v(xbgr.mr_n70210640)
print v(xbgr.mr_n70210752)
print v(xbgr.mr_n70211072)
print v(xbgr.mr_n70211184)
print v(xbgr.mr_n70211504)
print v(xbgr.mr_n70211616)
print v(xbgr.mr_n70211936)
print v(xbgr.mr_n70212048)
print v(xbgr.mr_n70212368)
print v(xbgr.mr_n70212480)
print v(xbgr.mr_n70212912)
print v(xbgr.mr_n70213344)
print v(xbgr.mr_n70213776)
print v(xbgr.mr_n70214208)
print v(xbgr.mr_n70214640)
print v(xbgr.mr_n70215072)
print v(xbgr.mr_n70215504)
print v(xbgr.mr_n70215936)
print v(xbgr.mr_n70216256)
print v(xbgr.mr_n70216368)
print v(xbgr.mr_n70216688)
print v(xbgr.mr_n70216800)
print v(xbgr.mr_n70217120)
print v(xbgr.mr_n70217232)
print v(xbgr.mr_n70217552)
print v(xbgr.mr_n70217664)
print v(xbgr.mr_n70217984)
print v(xbgr.mr_n70218096)
print v(xbgr.mr_n70218416)
print v(xbgr.mr_n70218528)
print v(xbgr.mr_n70218848)
print v(xbgr.mr_n70218960)
print v(xbgr.mr_n70219280)
print v(xbgr.mr_n70219392)
print v(xbgr.mr_n70219824)
print v(xbgr.mr_n70220256)
print v(xbgr.mr_n70220576)
print v(xbgr.mr_n70220688)
print v(xbgr.mr_n70221008)
print v(xbgr.mr_n70221120)
print v(xbgr.mr_n70221440)
print v(xbgr.mr_n70221552)
print v(xbgr.mr_n70221872)
print v(xbgr.mr_n70221984)
print v(xbgr.mr_n70222304)
print v(xbgr.mr_n70222416)
print v(xbgr.mr_n70222736)
print v(xbgr.mr_n70222848)
print v(xbgr.mr_n70223280)
print v(xbgr.mr_n70223712)
print v(xbgr.mr_n70224144)
print v(xbgr.mr_n70224576)
print v(xbgr.mr_n70225008)
print v(xbgr.mr_n70225440)
print v(xbgr.mr_n70225872)
print v(xbgr.mr_n70226304)
print v(xbgr.mr_n70226736)
print v(xbgr.mr_n70227168)
print v(xbgr.mr_n70227600)
print v(xbgr.mr_n70228032)
print v(xbgr.mr_n70228464)
print v(xbgr.mr_n70228896)
print v(xbgr.mr_n70229328)
print v(xbgr.mr_n70229760)
print v(xbgr.mr_n70230080)
print v(xbgr.mr_n70230192)
print v(xbgr.mr_n70230512)
print v(xbgr.mr_n70230624)
print v(xbgr.mr_n70230944)
print v(xbgr.mr_n70231056)
print v(xbgr.mr_n70231376)
print v(xbgr.mr_n70231488)
print v(xbgr.mr_n70231808)
print v(xbgr.mr_n70231920)
print v(xbgr.mr_n70232240)
print v(xbgr.mr_n70232352)
print v(xbgr.mr_n70232672)
print v(xbgr.mr_n70232784)
print v(xbgr.mr_n70233104)
print v(xbgr.mr_n70233216)
print v(xbgr.mr_n70233536)
print v(xbgr.mr_n70233648)
print v(xbgr.mr_n70233968)
print v(xbgr.mr_n70234080)
print v(xbgr.mr_n70234400)
print v(xbgr.mr_n70234512)
print v(xbgr.mr_n70234832)
print v(xbgr.mr_n70234944)
print v(xbgr.mr_n70235264)
print v(xbgr.mr_n70235376)
print v(xbgr.mr_n70235696)
print v(xbgr.mr_n70235808)
print v(xbgr.mr_n70236128)
print v(xbgr.mr_n70236240)
print v(xbgr.mr_n70236560)
print v(xbgr.mr_n70236672)
print v(xbgr.mr_n70236992)
print v(xbgr.mr_n70237104)
print v(xbgr.mr_n70237424)
print v(xbgr.mr_n70237536)
print v(xbgr.mr_n70237856)
print v(xbgr.mr_n70237968)
print v(xbgr.mr_n70238288)
print v(xbgr.mr_n70238400)
print v(xbgr.mr_n70238832)
print v(xbgr.mr_n70239264)
print v(xbgr.mr_n70239696)
print v(xbgr.mr_n70240128)
print v(xbgr.mr_n70240560)
print v(xbgr.mr_n70240992)
print v(xbgr.mr_n70241312)
print v(xbgr.mr_n70241424)
print v(xbgr.mr_n70241744)
print v(xbgr.mr_n70241856)
print v(xbgr.mr_n70242176)
print v(xbgr.mr_n70242288)
print v(xbgr.mr_n70242608)
print v(xbgr.mr_n70242720)
print v(xbgr.mr_n70243040)
print v(xbgr.mr_n70243152)
print v(xbgr.mr_n70243472)
print v(xbgr.mr_n70243584)
print v(xbgr.mr_n70244016)
print v(xbgr.mr_n70244448)
print v(xbgr.mr_n70244880)
print v(xbgr.mr_n70245312)
print v(xbgr.mr_n70245744)
print v(xbgr.mr_n70246176)
print v(xbgr.mr_n70246608)
print v(xbgr.mr_n70247040)
print v(xbgr.mr_n70247472)
print v(xbgr.mr_n70247904)
print v(xbgr.mr_n70248336)
print v(xbgr.mr_n70248768)
print v(xbgr.mr_n70249200)
print v(xbgr.mr_n70249632)
print v(xbgr.mr_n70250064)
print v(xbgr.mr_n70250496)
print v(xbgr.mr_n70250928)
print v(xbgr.mr_n70251360)
print v(xbgr.mr_n70251792)
print v(xbgr.mr_n70252224)
print v(xbgr.mr_n70252544)
print v(xbgr.mr_n70252656)
print v(xbgr.mr_n70252976)
print v(xbgr.mr_n70253088)
print v(xbgr.mr_n70253408)
print v(xbgr.mr_n70253520)
print v(xbgr.mr_n70253840)
print v(xbgr.mr_n70253952)
print v(xbgr.mr_n70254272)
print v(xbgr.mr_n70254384)
print v(xbgr.mr_n70254704)
print v(xbgr.mr_n70254816)
print v(xbgr.mr_n70255136)
print v(xbgr.mr_n70255248)
print v(xbgr.mr_n70255568)
print v(xbgr.mr_n70255680)
print v(xbgr.mr_n70256000)
print v(xbgr.mr_n70256112)
print v(xbgr.mr_n70256432)
print v(xbgr.mr_n70256544)
print v(xbgr.mr_n70256864)
print v(xbgr.mr_n70256976)
print v(xbgr.mr_n70257296)
print v(xbgr.mr_n70257408)
print v(xbgr.mr_n70257728)
print v(xbgr.mr_n70257840)
print v(xbgr.mr_n70258160)
print v(xbgr.mr_n70258272)
print v(xbgr.mr_n70258592)
print v(xbgr.mr_n70258704)
print v(xbgr.mr_n70259024)
print v(xbgr.mr_n70259136)
print v(xbgr.mr_n70259456)
print v(xbgr.mr_n70259568)
print v(xbgr.mr_n70259888)
print v(xbgr.mr_n70260000)
print v(xbgr.mr_n70260320)
print v(xbgr.mr_n70260432)
print v(xbgr.mr_n70260752)
print v(xbgr.mr_n70260864)
print v(xbgr.mr_n70261184)
print v(xbgr.mr_n70261296)
print v(xbgr.mr_n70261616)
print v(xbgr.mr_n70261728)
print v(xbgr.mr_n70262048)
print v(xbgr.mr_n70262160)
print v(xbgr.mr_n70262480)
print v(xbgr.mr_n70262592)
print v(xbgr.mr_n70262912)
print v(xbgr.mr_n70263024)
print v(xbgr.mr_n70263344)
print v(xbgr.mr_n70263456)
print v(xbgr.mr_n70263776)
print v(xbgr.mr_n70263888)
print v(xbgr.mr_n70264208)
print v(xbgr.mr_n70264320)
print v(xbgr.mr_n70264640)
print v(xbgr.mr_n70264752)
print v(xbgr.mr_n70265072)
print v(xbgr.mr_n70265184)
print v(xbgr.mr_n70265504)
print v(xbgr.mr_n70265616)
print v(xbgr.mr_n70265936)
print v(xbgr.mr_n70266048)
print v(xbgr.mr_n70266480)
print v(xbgr.mr_n70266912)
print v(xbgr.mr_n70267232)
print v(xbgr.mr_n70267344)
print v(xbgr.mr_n70267664)
print v(xbgr.mr_n70267776)
print v(xbgr.mr_n70268096)
print v(xbgr.mr_n70268208)
print v(xbgr.mr_n70268528)
print v(xbgr.mr_n70268640)
print v(xbgr.mr_n70268960)
print v(xbgr.mr_n70269072)
print v(xbgr.mr_n70269392)
print v(xbgr.mr_n70269504)
print v(xbgr.mr_n70269824)
print v(xbgr.mr_n70269936)
print v(xbgr.mr_n70270256)
print v(xbgr.mr_n70270368)
print v(xbgr.mr_n70270688)
print v(xbgr.mr_n70270800)
print v(xbgr.mr_n70271120)
print v(xbgr.mr_n70271232)
print v(xbgr.mr_n70271664)
print v(xbgr.mr_n70272096)
print v(xbgr.mr_n70272528)
print v(xbgr.mr_n70272848)
print v(xbgr.mr_n70272960)
print v(xbgr.mr_n70273280)
print v(xbgr.mr_n70273392)
print v(xbgr.mr_n70273824)
print v(xbgr.mr_n70274256)
print v(xbgr.mr_n70274688)
print v(xbgr.mr_n70275120)
print v(xbgr.mr_n70275552)
print v(xbgr.mr_n70275984)
print v(xbgr.mr_n70276416)
print v(xbgr.mr_n70276848)
print v(xbgr.mr_n70277280)
print v(xbgr.mr_n70277712)
print v(xbgr.mr_n70278144)
print v(xbgr.mr_n70278464)
print v(xbgr.mr_n70278576)
print v(xbgr.mr_n70278896)
print v(xbgr.mr_n70279008)
print v(xbgr.mr_n70279328)
print v(xbgr.mr_n70279440)
print v(xbgr.mr_n70279760)
print v(xbgr.mr_n70279872)
print v(xbgr.mr_n70280192)
print v(xbgr.mr_n70280304)
print v(xbgr.mr_n70280624)
print v(xbgr.mr_n70280736)
print v(xbgr.mr_n70281056)
print v(xbgr.mr_n70281168)
print v(xbgr.mr_n70281488)
print v(xbgr.mr_n70281600)
print v(xbgr.mr_n70282032)
print v(xbgr.mr_n70282464)
print v(xbgr.mr_n70282896)
print v(xbgr.mr_n70283328)
print v(xbgr.mr_n70283760)
print v(xbgr.mr_n70284192)
print v(xbgr.mr_n70284624)
print v(xbgr.mr_n70285056)
print v(xbgr.mr_n70285488)
print v(xbgr.mr_n70285920)
print v(xbgr.mr_n70286352)
print v(xbgr.mr_n70286784)
print v(xbgr.mr_n70287216)
print v(xbgr.mr_n70287648)
print v(xbgr.mr_n70288080)
print v(xbgr.mr_n70288512)
print v(xbgr.mr_n70288944)
print v(xbgr.mr_n70289376)
print v(xbgr.mr_n70289808)
print v(xbgr.mr_n70290240)
print v(xbgr.mr_n70290560)
print v(xbgr.mr_n70290672)
print v(xbgr.mr_n70290992)
print v(xbgr.mr_n70291104)
print v(xbgr.mr_n70291424)
print v(xbgr.mr_n70291536)
print v(xbgr.mr_n70291856)
print v(xbgr.mr_n70291968)
print v(xbgr.mr_n70292288)
print v(xbgr.mr_n70292400)
print v(xbgr.mr_n70292720)
print v(xbgr.mr_n70292832)
print v(xbgr.mr_n70293152)
print v(xbgr.mr_n70293264)
print v(xbgr.mr_n70293584)
print v(xbgr.mr_n70293696)
print v(xbgr.mr_n70294016)
print v(xbgr.mr_n70294128)
print v(xbgr.mr_n70294448)
print v(xbgr.mr_n70294560)
print v(xbgr.mr_n70294880)
print v(xbgr.mr_n70294992)
print v(xbgr.mr_n70295312)
print v(xbgr.mr_n70295424)
print v(xbgr.mr_n70295744)
print v(xbgr.mr_n70295856)
print v(xbgr.mr_n70296288)
print v(xbgr.mr_n70296720)
print v(xbgr.mr_n70297152)
print v(xbgr.mr_n70297584)
print v(xbgr.mr_n70298016)
print v(xbgr.mr_n70298448)
print v(xbgr.mr_n70298880)
print v(xbgr.mr_n70299312)
print v(xbgr.mr_n70299744)
print v(xbgr.mr_n70300176)
print v(xbgr.mr_n70300608)
print v(xbgr.mr_n70301040)
print v(xbgr.mr_n70301472)
print v(xbgr.mr_n70301792)
print v(xbgr.mr_n70301904)
print v(xbgr.mr_n70302224)
print v(xbgr.mr_n70302336)
print v(xbgr.mr_n70302656)
print v(xbgr.mr_n70302768)
print v(xbgr.mr_n70303088)
print v(xbgr.mr_n70303200)
print v(xbgr.mr_n70303520)
print v(xbgr.mr_n70303632)
print v(xbgr.mr_n70303952)
print v(xbgr.mr_n70304064)
print v(xbgr.mr_n70304384)
print v(xbgr.mr_n70304496)
print v(xbgr.mr_n70304816)
print v(xbgr.mr_n70304928)
print v(xbgr.mr_n70305248)
print v(xbgr.mr_n70305360)
print v(xbgr.mr_n70305680)
print v(xbgr.mr_n70305792)
print v(xbgr.mr_n70306112)
print v(xbgr.mr_n70306224)
print v(xbgr.mr_n70306544)
print v(xbgr.mr_n70306656)
print v(xbgr.mr_n70307088)
print v(xbgr.mr_n70307408)
print v(xbgr.mr_n70307520)
print v(xbgr.mr_n70307952)
print v(xbgr.mr_n70308384)
print v(xbgr.mr_n70308816)
print v(xbgr.mr_n70309248)
print v(xbgr.mr_n70309680)
print v(xbgr.mr_n70310112)
print v(xbgr.mr_n70310544)
print v(xbgr.mr_n70310976)
print v(xbgr.mr_n70311408)
print v(xbgr.mr_n70311840)
print v(xbgr.mr_n70312272)
print v(xbgr.mr_n70312704)
print v(xbgr.mr_n70313024)
print v(xbgr.mr_n70313136)
print v(xbgr.mr_n70313456)
print v(xbgr.mr_n70313568)
print v(xbgr.mr_n70313888)
print v(xbgr.mr_n70314000)
print v(xbgr.mr_n70314320)
print v(xbgr.mr_n70314432)
print v(xbgr.mr_n70314752)
print v(xbgr.mr_n70314864)
print v(xbgr.mr_n70315184)
print v(xbgr.mr_n70315296)
print v(xbgr.mr_n70315616)
print v(xbgr.mr_n70315728)
print v(xbgr.mr_n70316048)
print v(xbgr.mr_n70316160)
print v(xbgr.mr_n70316480)
print v(xbgr.mr_n70316592)
print v(xbgr.mr_n70316912)
print v(xbgr.mr_n70317024)
print v(xbgr.mr_n70317344)
print v(xbgr.mr_n70317456)
print v(xbgr.mr_n70317888)
print v(xbgr.mr_n70318320)
print v(xbgr.mr_n70318752)
print v(xbgr.mr_n70319072)
print v(xbgr.mr_n70319184)
print v(xbgr.mr_n70319504)
print v(xbgr.mr_n70319616)
print v(xbgr.mr_n70320048)
print v(xbgr.mr_n70320480)
print v(xbgr.mr_n70320912)
print v(xbgr.mr_n70321344)
print v(xbgr.mr_n70321776)
print v(xbgr.mr_n70322208)
print v(xbgr.mr_n70322640)
print v(xbgr.mr_n70323072)
print v(xbgr.mr_n70323504)
print v(xbgr.mr_n70323936)
print v(xbgr.mr_n70324256)
print v(xbgr.mr_n70324368)
print v(xbgr.mr_n70324688)
print v(xbgr.mr_n70324800)
print v(xbgr.mr_n70325120)
print v(xbgr.mr_n70325232)
print v(xbgr.mr_n70325552)
print v(xbgr.mr_n70325664)
print v(xbgr.mr_n70325984)
print v(xbgr.mr_n70326096)
print v(xbgr.mr_n70326416)
print v(xbgr.mr_n70326528)
print v(xbgr.mr_n70326848)
print v(xbgr.mr_n70326960)
print v(xbgr.mr_n70327280)
print v(xbgr.mr_n70327392)
print v(xbgr.mr_n70327712)
print v(xbgr.mr_n70327824)
print v(xbgr.mr_n70328144)
print v(xbgr.mr_n70328256)
print v(xbgr.mr_n70328576)
print v(xbgr.mr_n70328688)
print v(xbgr.mr_n70329008)
print v(xbgr.mr_n70329120)
print v(xbgr.mr_n70329552)
print v(xbgr.mr_n70329984)
print v(xbgr.mr_n70330416)
print v(xbgr.mr_n70330848)
print v(xbgr.mr_n70331280)
print v(xbgr.mr_n70331712)
print v(xbgr.mr_n70332144)
print v(xbgr.mr_n70332464)
print v(xbgr.mr_n70332576)
print v(xbgr.mr_n70333008)
print v(xbgr.mr_n70333440)
print v(xbgr.mr_n70333872)
print v(xbgr.mr_n70334304)
print v(xbgr.mr_n70334736)
print v(xbgr.mr_n70335168)
print v(xbgr.mr_n70335488)
print v(xbgr.mr_n70335600)
print v(xbgr.mr_n70335920)
print v(xbgr.mr_n70336032)
print v(xbgr.mr_n70336352)
print v(xbgr.mr_n70336464)
print v(xbgr.mr_n70336784)
print v(xbgr.mr_n70336896)
print v(xbgr.mr_n70337216)
print v(xbgr.mr_n70337328)
print v(xbgr.mr_n70337648)
print v(xbgr.mr_n70337760)
print v(xbgr.mr_n70338080)
print v(xbgr.mr_n70338192)
print v(xbgr.mr_n70338512)
print v(xbgr.mr_n70338624)
print v(xbgr.mr_n70338944)
print v(xbgr.mr_n70339056)
print v(xbgr.mr_n70339376)
print v(xbgr.mr_n70339488)
print v(xbgr.mr_n70339808)
print v(xbgr.mr_n70339920)
print v(xbgr.mr_n70340240)
print v(xbgr.mr_n70340352)
print v(xbgr.mr_n70340672)
print v(xbgr.mr_n70340784)
print v(xbgr.mr_n70341104)
print v(xbgr.mr_n70341216)
print v(xbgr.mr_n70341536)
print v(xbgr.mr_n70341648)
print v(xbgr.mr_n70341968)
print v(xbgr.mr_n70342080)
print v(xbgr.mr_n70342400)
print v(xbgr.mr_n70342512)
print v(xbgr.mr_n70342832)
print v(xbgr.mr_n70342944)
print v(xbgr.mr_n70343264)
print v(xbgr.mr_n70343376)
print v(xbgr.mr_n70343696)
print v(xbgr.mr_n70343808)
print v(xbgr.mr_n70344128)
print v(xbgr.mr_n70344240)
print v(xbgr.mr_n70344560)
print v(xbgr.mr_n70344672)
print v(xbgr.mr_n70344992)
print v(xbgr.mr_n70345104)
print v(xbgr.mr_n70345424)
print v(xbgr.mr_n70345536)
print v(xbgr.mr_n70345968)
print v(xbgr.mr_n70346400)
print v(xbgr.mr_n70346832)
print v(xbgr.mr_n70347152)
print v(xbgr.mr_n70347264)
print v(xbgr.mr_n70347584)
print v(xbgr.mr_n70347696)
print v(xbgr.mr_n70348128)
print v(xbgr.mr_n70348560)
print v(xbgr.mr_n70348992)
print v(xbgr.mr_n70349424)
print v(xbgr.mr_n70349856)
print v(xbgr.mr_n70350288)
print v(xbgr.mr_n70350720)
print v(xbgr.mr_n70351152)
print v(xbgr.mr_n70351584)
print v(xbgr.mr_n70352016)
print v(xbgr.mr_n70352448)
print v(xbgr.mr_n70352880)
print v(xbgr.mr_n70353312)
print v(xbgr.mr_n70353744)
print v(xbgr.mr_n70354176)
print v(xbgr.mr_n70354608)
print v(xbgr.mr_n70355040)
print v(xbgr.mr_n70355472)
print v(xbgr.mr_n70355904)
print v(xbgr.mr_n70356336)
print v(xbgr.mr_n70356768)
print v(xbgr.mr_n70357200)
print v(xbgr.mr_n70357632)
print v(xbgr.mr_n70357952)
print v(xbgr.mr_n70358064)
print v(xbgr.mr_n70358384)
print v(xbgr.mr_n70358496)
print v(xbgr.mr_n70358816)
print v(xbgr.mr_n70358928)
print v(xbgr.mr_n70359248)
print v(xbgr.mr_n70359360)
print v(xbgr.mr_n70359680)
print v(xbgr.mr_n70359792)
print v(xbgr.mr_n70360112)
print v(xbgr.mr_n70360224)
print v(xbgr.mr_n70360544)
print v(xbgr.mr_n70360656)
print v(xbgr.mr_n70360976)
print v(xbgr.mr_n70361088)
print v(xbgr.mr_n70361408)
print v(xbgr.mr_n70361520)
print v(xbgr.mr_n70361840)
print v(xbgr.mr_n70361952)
print v(xbgr.mr_n70362272)
print v(xbgr.mr_n70362384)
print v(xbgr.mr_n70362704)
print v(xbgr.mr_n70362816)
print v(xbgr.mr_n70363136)
print v(xbgr.mr_n70363248)
print v(xbgr.mr_n70363568)
print v(xbgr.mr_n70363680)
print v(xbgr.mr_n70364112)
print v(xbgr.mr_n70364544)
print v(xbgr.mr_n70364864)
print v(xbgr.mr_n70364976)
print v(xbgr.mr_n70365296)
print v(xbgr.mr_n70365408)
print v(xbgr.mr_n70365728)
print v(xbgr.mr_n70365840)
print v(xbgr.mr_n70366160)
print v(xbgr.mr_n70366272)
print v(xbgr.mr_n70366704)
print v(xbgr.mr_n70367136)
print v(xbgr.mr_n70367456)
print v(xbgr.mr_n70367568)
print v(xbgr.mr_n70367888)
print v(xbgr.mr_n70368000)
print v(xbgr.mr_n70368320)
print v(xbgr.mr_n70368432)
print v(xbgr.mr_n70368752)
print v(xbgr.mr_n70368864)
print v(xbgr.mr_n70369184)
print v(xbgr.mr_n70369296)
print v(xbgr.mr_n70369616)
print v(xbgr.mr_n70369728)
print v(xbgr.mr_n70370048)
print v(xbgr.mr_n70370160)
print v(xbgr.mr_n70370480)
print v(xbgr.mr_n70370592)
print v(xbgr.mr_n70371024)
print v(xbgr.mr_n70371456)
print v(xbgr.mr_n70371888)
print v(xbgr.mr_n70372320)
print v(xbgr.mr_n70372752)
print v(xbgr.mr_n70373184)
print v(xbgr.mr_n70373616)
print v(xbgr.mr_n70374048)
print v(xbgr.mr_n70374480)
print v(xbgr.mr_n70374912)
print v(xbgr.mr_n70375232)
print v(xbgr.mr_n70375344)
print v(xbgr.mr_n70375664)
print v(xbgr.mr_n70375776)
print v(xbgr.mr_n70376096)
print v(xbgr.mr_n70376208)
print v(xbgr.mr_n70376528)
print v(xbgr.mr_n70376640)
print v(xbgr.mr_n70381664)
print v(xbgr.mr_n70381776)
print v(xbgr.mr_n70382112)
print v(xbgr.mr_n70382224)
print v(xbgr.mr_n70382544)
print v(xbgr.mr_n70382656)
print v(xbgr.mr_n70383024)
print v(xbgr.mr_n70383136)
print v(xbgr.mr_n70383456)
print v(xbgr.mr_n70383568)
print v(xbgr.mr_n70383888)
print v(xbgr.mr_n70384000)
print v(xbgr.mr_n70384240)
print v(xbgr.mr_n70384352)
print v(xbgr.mr_n70384672)
print v(xbgr.mr_n70384784)
print v(xbgr.mr_n70385104)
print v(xbgr.mr_n70385216)
print v(xbgr.mr_n70385536)
print v(xbgr.mr_n70385648)
print v(xbgr.mr_n70385968)
print v(xbgr.mr_n70386080)
print v(xbgr.mr_n70386400)
print v(xbgr.mr_n70386512)
print v(xbgr.mr_n70386832)
print v(xbgr.mr_n70386944)
print v(xbgr.mr_n70387264)
print v(xbgr.mr_n70387376)
print v(xbgr.mr_n70387696)
print v(xbgr.mr_n70387808)
print v(xbgr.mr_n70388128)
print v(xbgr.mr_n70388240)
print v(xbgr.mr_n70388560)
print v(xbgr.mr_n70388672)
print v(xbgr.mr_n70388992)
print v(xbgr.mr_n70389104)
print v(xbgr.mr_n70389424)
print v(xbgr.mr_n70389536)
print v(xbgr.mr_n70389856)
print v(xbgr.mr_n70389968)
print v(xbgr.mr_n70390288)
print v(xbgr.mr_n70390400)
print v(xbgr.mr_n70390720)
print v(xbgr.mr_n70390832)
print v(xbgr.mr_n70391152)
print v(xbgr.mr_n70391264)
print v(xbgr.mr_n70391584)
print v(xbgr.mr_n70391696)
print v(xbgr.mr_n70392016)
print v(xbgr.mr_n70392128)
print v(xbgr.mr_n70392448)
print v(xbgr.mr_n70392560)
print v(xbgr.mr_n70392880)
print v(xbgr.mr_n70392992)
print v(xbgr.mr_n70393312)
print v(xbgr.mr_n70393424)
print v(xbgr.mr_n70393744)
print v(xbgr.mr_n70393856)
print v(xbgr.mr_n70394176)
print v(xbgr.mr_n70394288)
print v(xbgr.mr_n70394608)
print v(xbgr.mr_n70394720)
print v(xbgr.mr_n70395040)
print v(xbgr.mr_n70395152)
print v(xbgr.mr_n70395472)
print v(xbgr.mr_n70395584)
print v(xbgr.mr_n70395904)
print v(xbgr.mr_n70396016)
print v(xbgr.mr_n70396336)
print v(xbgr.mr_n70396448)
print v(xbgr.mr_n70396768)
print v(xbgr.mr_n70396880)
print v(xbgr.mr_n70397200)
print v(xbgr.mr_n70397312)
print v(xbgr.mr_n70397632)
print v(xbgr.mr_n70397744)
print v(xbgr.mr_n70398064)
print v(xbgr.mr_n70398176)
print v(xbgr.mr_n70398496)
print v(xbgr.mr_n70398608)
print v(xbgr.mr_n70398928)
print v(xbgr.mr_n70399040)
print v(xbgr.mr_n70399360)
print v(xbgr.mr_n70399472)
print v(xbgr.mr_n70399792)
print v(xbgr.mr_n70399904)
print v(xbgr.mr_n70400224)
print v(xbgr.mr_n70400336)
print v(xbgr.mr_n70400656)
print v(xbgr.mr_n70400768)
print v(xbgr.mr_n70401088)
print v(xbgr.mr_n70401200)
print v(xbgr.mr_n70401520)
print v(xbgr.mr_n70401632)
print v(xbgr.mr_n70401952)
print v(xbgr.mr_n70402064)
print v(xbgr.mr_n70402384)
print v(xbgr.mr_n70402496)
print v(xbgr.mr_n70402816)
print v(xbgr.mr_n70402928)
print v(xbgr.mr_n70403248)
print v(xbgr.mr_n70403360)
print v(xbgr.mr_n70403680)
print v(xbgr.mr_n70403792)
print v(xbgr.mr_n70404112)
print v(xbgr.mr_n70404224)
print v(xbgr.mr_n70404544)
print v(xbgr.mr_n70404656)
print v(xbgr.mr_n70404976)
print v(xbgr.mr_n70405088)
print v(xbgr.mr_n70405408)
print v(xbgr.mr_n70405520)
print v(xbgr.mr_n70405840)
print v(xbgr.mr_n70405952)
print v(xbgr.mr_n70406272)
print v(xbgr.mr_n70406384)
print v(xbgr.mr_n70406704)
print v(xbgr.mr_n70406816)
print v(xbgr.mr_n70407136)
print v(xbgr.mr_n70407248)
print v(xbgr.mr_n70407568)
print v(xbgr.mr_n70407680)
print v(xbgr.mr_n70408000)
print v(xbgr.mr_n70408112)
print v(xbgr.mr_n70408432)
print v(xbgr.mr_n70408544)
print v(xbgr.mr_n70408864)
print v(xbgr.mr_n70408976)
print v(xbgr.mr_n70409296)
print v(xbgr.mr_n70409408)
print v(xbgr.mr_n70409728)
print v(xbgr.mr_n70409840)
print v(xbgr.mr_n70410160)
print v(xbgr.mr_n70410272)
print v(xbgr.mr_n70410592)
print v(xbgr.mr_n70410704)
print v(xbgr.mr_n70411024)
print v(xbgr.mr_n70411136)
print v(xbgr.mr_n70411456)
print v(xbgr.mr_n70411568)
print v(xbgr.mr_n70411792)
print v(xbgr.mr_n70411904)
print v(xbgr.mr_n70412160)
print v(xbgr.mr_n70412272)
print v(xbgr.mr_n70412528)
print v(xbgr.mr_n70412640)
print v(xbgr.mr_n70412896)
print v(xbgr.mr_n70413008)
print v(xbgr.mr_n70413264)
print v(xbgr.mr_n70413376)
print v(xbgr.mr_n70413632)
print v(xbgr.mr_n70413744)
print v(xbgr.mr_n70414000)
print v(xbgr.mr_n70414112)
print v(xbgr.mr_n70414368)
print v(xbgr.mr_n70414480)
print v(xbgr.mr_n70414736)
print v(xbgr.mr_n70414848)
print v(xbgr.mr_n70415136)
print v(xbgr.mr_n70415248)
print v(xbgr.mr_n70415568)
print v(xbgr.mr_n70415680)
print v(xbgr.mr_n70416000)
print v(xbgr.mr_n70416112)
print v(xbgr.mr_n70416432)
print v(xbgr.mr_n70416544)
print v(xbgr.mr_n70416864)
print v(xbgr.mr_n70416976)
print v(xbgr.mr_n70417296)
print v(xbgr.mr_n70417408)
print v(xbgr.mr_n70417728)
print v(xbgr.mr_n70417840)
print v(xbgr.mr_n70418160)
print v(xbgr.mr_n70418272)
print v(xbgr.mr_n70418592)
print v(xbgr.mr_n70418704)
print v(xbgr.mr_n70419024)
print v(xbgr.mr_n70419136)
print v(xbgr.mr_n70419456)
print v(xbgr.mr_n70419568)
print v(xbgr.mr_n70419888)
print v(xbgr.mr_n70420000)
print v(xbgr.mr_n70420320)
print v(xbgr.mr_n70420432)
print v(xbgr.mr_n70420752)
print v(xbgr.mr_n70420864)
print v(xbgr.mr_n70421184)
print v(xbgr.mr_n70421296)
print v(xbgr.mr_n70421616)
print v(xbgr.mr_n70421728)
print v(xbgr.mr_n70422048)
print v(xbgr.mr_n70422160)
print v(xbgr.mr_n70422480)
print v(xbgr.mr_n70422592)
print v(xbgr.mr_n70422912)
print v(xbgr.mr_n70423024)
print v(xbgr.mr_n70423344)
print v(xbgr.mr_n70423456)
print v(xbgr.mr_n70423776)
print v(xbgr.mr_n70423888)
print v(xbgr.mr_n70424208)
print v(xbgr.mr_n70424320)
print v(xbgr.mr_n70424640)
print v(xbgr.mr_n70424752)
print v(xbgr.mr_n70425072)
print v(xbgr.mr_n70425184)
print v(xbgr.mr_n70425504)
print v(xbgr.mr_n70425616)
print v(xbgr.mr_n70425936)
print v(xbgr.mr_n70426048)
print v(xbgr.mr_n70426368)
print v(xbgr.mr_n70426480)
print v(xbgr.mr_n70426800)
print v(xbgr.mr_n70426912)
print v(xbgr.mr_n70427232)
print v(xbgr.mr_n70427344)
print v(xbgr.mr_n70427664)
print v(xbgr.mr_n70427776)
print v(xbgr.mr_n70428096)
print v(xbgr.mr_n70428208)
print v(xbgr.mr_n70428528)
print v(xbgr.mr_n70428640)
print v(xbgr.mr_n70428960)
print v(xbgr.mr_n70429072)
print v(xbgr.mr_n70429392)
print v(xbgr.mr_n70429504)
print v(xbgr.mr_n70429824)
print v(xbgr.mr_n70429936)
print v(xbgr.mr_n70430256)
print v(xbgr.mr_n70430368)
print v(xbgr.mr_n70430688)
print v(xbgr.mr_n70430800)
print v(xbgr.mr_n70431120)
print v(xbgr.mr_n70431232)
print v(xbgr.mr_n70431552)
print v(xbgr.mr_n70431664)
print v(xbgr.mr_n70431984)
print v(xbgr.mr_n70432096)
print v(xbgr.mr_n70432416)
print v(xbgr.mr_n70432528)
print v(xbgr.mr_n70432848)
print v(xbgr.mr_n70432960)
print v(xbgr.mr_n70433280)
print v(xbgr.mr_n70433392)
print v(xbgr.mr_n70433712)
print v(xbgr.mr_n70433824)
print v(xbgr.mr_n70434144)
print v(xbgr.mr_n70434256)
print v(xbgr.mr_n70434576)
print v(xbgr.mr_n70434688)
print v(xbgr.mr_n70435008)
print v(xbgr.mr_n70435120)
print v(xbgr.mr_n70435440)
print v(xbgr.mr_n70435552)
print v(xbgr.mr_n70435872)
print v(xbgr.mr_n70435984)
print v(xbgr.mr_n70436304)
print v(xbgr.mr_n70436416)
print v(xbgr.mr_n70436736)
print v(xbgr.mr_n70436848)
print v(xbgr.mr_n70437168)
print v(xbgr.mr_n70437280)
print v(xbgr.mr_n70437600)
print v(xbgr.mr_n70437712)
print v(xbgr.mr_n70438032)
print v(xbgr.mr_n70438144)
print v(xbgr.mr_n70438464)
print v(xbgr.mr_n70438576)
print v(xbgr.mr_n70438896)
print v(xbgr.mr_n70439008)
print v(xbgr.mr_n70439328)
print v(xbgr.mr_n70439440)
print v(xbgr.mr_n70439760)
print v(xbgr.mr_n70439872)
print v(xbgr.mr_n70440192)
print v(xbgr.mr_n70440304)
print v(xbgr.mr_n70440624)
print v(xbgr.mr_n70440736)
print v(xbgr.mr_n70441056)
print v(xbgr.mr_n70441168)
print v(xbgr.mr_n70441488)
print v(xbgr.mr_n70441600)
print v(xbgr.mr_n70441920)
print v(xbgr.mr_n70442032)
print v(xbgr.mr_n70442352)
print v(xbgr.mr_n70442464)
print v(xbgr.mr_n70442784)
print v(xbgr.mr_n70442896)
print v(xbgr.mr_n70443104)
print v(xbgr.mr_n70443216)
print v(xbgr.mr_n70443536)
print v(xbgr.mr_n70443648)
print v(xbgr.mr_n70443968)
print v(xbgr.mr_n70444080)
print v(xbgr.mr_n70444400)
print v(xbgr.mr_n70444512)
print v(xbgr.mr_n70444832)
print v(xbgr.mr_n70444944)
print v(xbgr.mr_n70445264)
print v(xbgr.mr_n70445376)
print v(xbgr.mr_n70445696)
print v(xbgr.mr_n70445808)
print v(xbgr.mr_n70446128)
print v(xbgr.mr_n70446240)
print v(xbgr.mr_n70446560)
print v(xbgr.mr_n70446672)
print v(xbgr.mr_n70446992)
print v(xbgr.mr_n70447104)
print v(xbgr.mr_n70447424)
print v(xbgr.mr_n70447536)
print v(xbgr.mr_n70447856)
print v(xbgr.mr_n70447968)
print v(xbgr.mr_n70448288)
print v(xbgr.mr_n70448400)
print v(xbgr.mr_n70448720)
print v(xbgr.mr_n70448832)
print v(xbgr.mr_n70449152)
print v(xbgr.mr_n70449264)
print v(xbgr.mr_n70449584)
print v(xbgr.mr_n70449696)
print v(xbgr.mr_n70450016)
print v(xbgr.mr_n70450128)
print v(xbgr.mr_n70450448)
print v(xbgr.mr_n70450560)
print v(xbgr.mr_n70450880)
print v(xbgr.mr_n70450992)
print v(xbgr.mr_n70451312)
print v(xbgr.mr_n70451424)
print v(xbgr.mr_n70451744)
print v(xbgr.mr_n70451856)
print v(xbgr.mr_n70452176)
print v(xbgr.mr_n70452288)
print v(xbgr.mr_n70452608)
print v(xbgr.mr_n70452720)
print v(xbgr.mr_n70453040)
print v(xbgr.mr_n70453152)
print v(xbgr.mr_n70453472)
print v(xbgr.mr_n70453584)
print v(xbgr.mr_n70453904)
print v(xbgr.mr_n70454016)
print v(xbgr.mr_n70454336)
print v(xbgr.mr_n70454448)
print v(xbgr.mr_n70454768)
print v(xbgr.mr_n70454880)
print v(xbgr.mr_n70455200)
print v(xbgr.mr_n70455312)
print v(xbgr.mr_n70455632)
print v(xbgr.mr_n70455744)
print v(xbgr.mr_n70456064)
print v(xbgr.mr_n70456176)
print v(xbgr.mr_n70456496)
print v(xbgr.mr_n70456608)
print v(xbgr.mr_n70456928)
print v(xbgr.mr_n70457040)
print v(xbgr.mr_n70457360)
print v(xbgr.mr_n70457472)
print v(xbgr.mr_n70457792)
print v(xbgr.mr_n70457904)
print v(xbgr.mr_n70458224)
print v(xbgr.mr_n70458336)
print v(xbgr.mr_n70458656)
print v(xbgr.mr_n70458768)
print v(xbgr.mr_n70459088)
print v(xbgr.mr_n70459200)
print v(xbgr.mr_n70459520)
print v(xbgr.mr_n70459632)
print v(xbgr.mr_n70459952)
print v(xbgr.mr_n70460064)
print v(xbgr.mr_n70460384)
print v(xbgr.mr_n70460496)
print v(xbgr.mr_n70460816)
print v(xbgr.mr_n70460928)
print v(xbgr.mr_n70461248)
print v(xbgr.mr_n70461360)
print v(xbgr.mr_n70461680)
print v(xbgr.mr_n70461792)
print v(xbgr.mr_n70462112)
print v(xbgr.mr_n70462224)
print v(xbgr.mr_n70462544)
print v(xbgr.mr_n70462656)
print v(xbgr.mr_n70462976)
print v(xbgr.mr_n70463088)
print v(xbgr.mr_n70463408)
print v(xbgr.mr_n70463520)
print v(xbgr.mr_n70463840)
print v(xbgr.mr_n70463952)
print v(xbgr.mr_n70464272)
print v(xbgr.mr_n70464384)
print v(xbgr.mr_n70464704)
print v(xbgr.mr_n70464816)
print v(xbgr.mr_n70465136)
print v(xbgr.mr_n70465248)
print v(xbgr.mr_n70465568)
print v(xbgr.mr_n70465680)
print v(xbgr.mr_n70466000)
print v(xbgr.mr_n70466112)
print v(xbgr.mr_n70466432)
print v(xbgr.mr_n70466544)
print v(xbgr.mr_n70466864)
print v(xbgr.mr_n70466976)
print v(xbgr.mr_n70467296)
print v(xbgr.mr_n70467408)
print v(xbgr.mr_n70467728)
print v(xbgr.mr_n70467840)
print v(xbgr.mr_n70468160)
print v(xbgr.mr_n70468272)
print v(xbgr.mr_n70468592)
print v(xbgr.mr_n70468704)
print v(xbgr.mr_n70469024)
print v(xbgr.mr_n70469136)
print v(xbgr.mr_n70469456)
print v(xbgr.mr_n70469568)
print v(xbgr.mr_n70469888)
print v(xbgr.mr_n70470000)
print v(xbgr.mr_n70470320)
print v(xbgr.mr_n70470432)
print v(xbgr.mr_n70470752)
print v(xbgr.mr_n70470864)
print v(xbgr.mr_n70471184)
print v(xbgr.mr_n70471296)
print v(xbgr.mr_n70471616)
print v(xbgr.mr_n70471728)
print v(xbgr.mr_n70472048)
print v(xbgr.mr_n70472160)
print v(xbgr.mr_n70472480)
print v(xbgr.mr_n70472592)
print v(xbgr.mr_n70472912)
print v(xbgr.mr_n70473024)
print v(xbgr.mr_n70473344)
print v(xbgr.mr_n70473456)
print v(xbgr.mr_n70473776)
print v(xbgr.mr_n70473888)
print v(xbgr.mr_n70474208)
print v(xbgr.mr_n70474320)
print v(xbgr.mr_n70474640)
print v(xbgr.mr_n70474752)
print v(xbgr.mr_n70475072)
print v(xbgr.mr_n70475184)
print v(xbgr.mr_n70475504)
print v(xbgr.mr_n70475616)
print v(xbgr.mr_n70475936)
print v(xbgr.mr_n70476048)
print v(xbgr.mr_n70476368)
print v(xbgr.mr_n70476480)
print v(xbgr.mr_n70476800)
print v(xbgr.mr_n70476912)
print v(xbgr.mr_n70477232)
print v(xbgr.mr_n70477344)
print v(xbgr.mr_n70477664)
print v(xbgr.mr_n70477776)
print v(xbgr.mr_n70478096)
print v(xbgr.mr_n70478208)
print v(xbgr.mr_n70478528)
print v(xbgr.mr_n70478640)
print v(xbgr.mr_n70478960)
print v(xbgr.mr_n70479072)
print v(xbgr.mr_n70479392)
print v(xbgr.mr_n70479504)
print v(xbgr.mr_n70479824)
print v(xbgr.mr_n70479936)
print v(xbgr.mr_n70480256)
print v(xbgr.mr_n70480368)
print v(xbgr.mr_n70480688)
print v(xbgr.mr_n70480800)
print v(xbgr.mr_n70481120)
print v(xbgr.mr_n70481232)
print v(xbgr.mr_n70481552)
print v(xbgr.mr_n70481664)
print v(xbgr.mr_n70481984)
print v(xbgr.mr_n70482096)
print v(xbgr.mr_n70482416)
print v(xbgr.mr_n70482528)
print v(xbgr.mr_n70482848)
print v(xbgr.mr_n70482960)
print v(xbgr.mr_n70483280)
print v(xbgr.mr_n70483392)
print v(xbgr.mr_n70483712)
print v(xbgr.mr_n70483824)
print v(xbgr.mr_n70484144)
print v(xbgr.mr_n70484256)
print v(xbgr.mr_n70484576)
print v(xbgr.mr_n70484688)
print v(xbgr.mr_n70485008)
print v(xbgr.mr_n70485120)
print v(xbgr.mr_n70485440)
print v(xbgr.mr_n70485552)
print v(xbgr.mr_n70485872)
print v(xbgr.mr_n70485984)
print v(xbgr.mr_n70486304)
print v(xbgr.mr_n70486416)
print v(xbgr.mr_n70486736)
print v(xbgr.mr_n70486848)
print v(xbgr.mr_n70487168)
print v(xbgr.mr_n70487280)
print v(xbgr.mr_n70487600)
print v(xbgr.mr_n70487712)
print v(xbgr.mr_n70488032)
print v(xbgr.mr_n70488144)
print v(xbgr.mr_n70488464)
print v(xbgr.mr_n70488576)
print v(xbgr.mr_n70488896)
print v(xbgr.mr_n70489008)
print v(xbgr.mr_n70489328)
print v(xbgr.mr_n70489440)
print v(xbgr.mr_n70489760)
print v(xbgr.mr_n70489872)
print v(xbgr.mr_n70490192)
print v(xbgr.mr_n70490304)
print v(xbgr.mr_n70490624)
print v(xbgr.mr_n70490736)
print v(xbgr.mr_n70491056)
print v(xbgr.mr_n70491168)
print v(xbgr.mr_n70491488)
print v(xbgr.mr_n70491600)
print v(xbgr.mr_n70491920)
print v(xbgr.mr_n70492032)
print v(xbgr.mr_n70492352)
print v(xbgr.mr_n70492464)
print v(xbgr.mr_n70492784)
print v(xbgr.mr_n70492896)
print v(xbgr.mr_n70493216)
print v(xbgr.mr_n70493328)
print v(xbgr.mr_n70493648)
print v(xbgr.mr_n70493760)
print v(xbgr.mr_n70494080)
print v(xbgr.mr_n70494192)
print v(xbgr.mr_n70494512)
print v(xbgr.mr_n70494624)
print v(xbgr.mr_n70494944)
print v(xbgr.mr_n70495056)
print v(xbgr.mr_n70495376)
print v(xbgr.mr_n70495488)
print v(xbgr.mr_n70495808)
print v(xbgr.mr_n70495920)
print v(xbgr.mr_n70496240)
print v(xbgr.mr_n70496352)
print v(xbgr.mr_n70496672)
print v(xbgr.mr_n70496784)
print v(xbgr.mr_n70497104)
print v(xbgr.mr_n70497216)
print v(xbgr.mr_n70497536)
print v(xbgr.mr_n70497648)
print v(xbgr.mr_n70497968)
print v(xbgr.mr_n70498080)
print v(xbgr.mr_n70498400)
print v(xbgr.mr_n70498512)
print v(xbgr.mr_n70498832)
print v(xbgr.mr_n70498944)
print v(xbgr.mr_n70499264)
print v(xbgr.mr_n70499376)
print v(xbgr.mr_n70499696)
print v(xbgr.mr_n70499808)
print v(xbgr.mr_n70500128)
print v(xbgr.mr_n70500240)
print v(xbgr.mr_n70500560)
print v(xbgr.mr_n70500672)
print v(xbgr.mr_n70500992)
print v(xbgr.mr_n70501104)
print v(xbgr.mr_n70501424)
print v(xbgr.mr_n70501536)
print v(xbgr.mr_n70501856)
print v(xbgr.mr_n70501968)
print v(xbgr.mr_n70502288)
print v(xbgr.mr_n70502400)
print v(xbgr.mr_n70502720)
print v(xbgr.mr_n70502832)
print v(xbgr.mr_n70503152)
print v(xbgr.mr_n70503264)
print v(xbgr.mr_n70503584)
print v(xbgr.mr_n70503696)
print v(xbgr.mr_n70504016)
print v(xbgr.mr_n70504128)
print v(xbgr.mr_n70504656)
print v(xbgr.mr_n70504768)
print v(xbgr.mr_n70505088)
print v(xbgr.mr_n70505200)
print v(xbgr.mr_n70505520)
print v(xbgr.mr_n70505632)
print v(xbgr.mr_n70505952)
print v(xbgr.mr_n70506064)
print v(xbgr.mr_n70506384)
print v(xbgr.mr_n70506496)
print v(xbgr.mr_n70506816)
print v(xbgr.mr_n70506928)
print v(xbgr.mr_n70507248)
print v(xbgr.mr_n70507360)
print v(xbgr.mr_n70507680)
print v(xbgr.mr_n70507792)
print v(xbgr.mr_n70508112)
print v(xbgr.mr_n70508224)
print v(xbgr.mr_n70508544)
print v(xbgr.mr_n70508656)
print v(xbgr.mr_n70508976)
print v(xbgr.mr_n70509088)
print v(xbgr.mr_n70509408)
print v(xbgr.mr_n70509520)
print v(xbgr.mr_n70509840)
print v(xbgr.mr_n70509952)
print v(xbgr.mr_n70510272)
print v(xbgr.mr_n70510384)
print v(xbgr.mr_n70510704)
print v(xbgr.mr_n70510816)
print v(xbgr.mr_n70511136)
print v(xbgr.mr_n70511248)
print v(xbgr.mr_n70511568)
print v(xbgr.mr_n70511680)
print v(xbgr.mr_n70512000)
print v(xbgr.mr_n70512112)
print v(xbgr.mr_n70512432)
print v(xbgr.mr_n70512544)
print v(xbgr.mr_n70512864)
print v(xbgr.mr_n70512976)
print v(xbgr.mr_n70513296)
print v(xbgr.mr_n70513408)
print v(xbgr.mr_n70513728)
print v(xbgr.mr_n70513840)
print v(xbgr.mr_n70514160)
print v(xbgr.mr_n70514272)
print v(xbgr.mr_n70514592)
print v(xbgr.mr_n70514704)
print v(xbgr.mr_n70515024)
print v(xbgr.mr_n70515136)
print v(xbgr.mr_n70515456)
print v(xbgr.mr_n70515568)
print v(xbgr.mr_n70515888)
print v(xbgr.mr_n70516000)
print v(xbgr.mr_n70516320)
print v(xbgr.mr_n70516432)
print v(xbgr.mr_n70516752)
print v(xbgr.mr_n70516864)
print v(xbgr.mr_n70517184)
print v(xbgr.mr_n70517296)
print v(xbgr.mr_n70517616)
print v(xbgr.mr_n70517728)
print v(xbgr.mr_n70518048)
print v(xbgr.mr_n70518160)
print v(xbgr.mr_n70518480)
print v(xbgr.mr_n70518592)
print v(xbgr.mr_n70518912)
print v(xbgr.mr_n70519024)
print v(xbgr.mr_n70519344)
print v(xbgr.mr_n70519456)
print v(xbgr.mr_n70519776)
print v(xbgr.mr_n70519888)
print v(xbgr.mr_n70520208)
print v(xbgr.mr_n70520320)
print v(xbgr.mr_n70520640)
print v(xbgr.mr_n70520752)
print v(xbgr.mr_n70521072)
print v(xbgr.mr_n70521184)
print v(xbgr.mr_n70521504)
print v(xbgr.mr_n70521616)
print v(xbgr.mr_n70521936)
print v(xbgr.mr_n70522048)
print v(xbgr.mr_n70522368)
print v(xbgr.mr_n70522480)
print v(xbgr.mr_n70522800)
print v(xbgr.mr_n70522912)
print v(xbgr.mr_n70523232)
print v(xbgr.mr_n70523344)
print v(xbgr.mr_n70523664)
print v(xbgr.mr_n70523776)
print v(xbgr.mr_n70524096)
print v(xbgr.mr_n70524208)
print v(xbgr.mr_n70524528)
print v(xbgr.mr_n70524640)
print v(xbgr.mr_n70524960)
print v(xbgr.mr_n70525072)
print v(xbgr.mr_n70525392)
print v(xbgr.mr_n70525504)
print v(xbgr.mr_n70525824)
print v(xbgr.mr_n70525936)
print v(xbgr.mr_n70526256)
print v(xbgr.mr_n70526368)
print v(xbgr.mr_n70526688)
print v(xbgr.mr_n70526800)
print v(xbgr.mr_n70527120)
print v(xbgr.mr_n70527232)
print v(xbgr.mr_n70527552)
print v(xbgr.mr_n70527664)
print v(xbgr.mr_n70527984)
print v(xbgr.mr_n70528096)
print v(xbgr.mr_n70528416)
print v(xbgr.mr_n70528528)
print v(xbgr.mr_n70528848)
print v(xbgr.mr_n70528960)
print v(xbgr.mr_n70529280)
print v(xbgr.mr_n70529392)
print v(xbgr.mr_n70529712)
print v(xbgr.mr_n70529824)
print v(xbgr.mr_n70530144)
print v(xbgr.mr_n70530256)
print v(xbgr.mr_n70530576)
print v(xbgr.mr_n70530688)
print v(xbgr.mr_n70531008)
print v(xbgr.mr_n70531120)
print v(xbgr.mr_n70531440)
print v(xbgr.mr_n70531552)
print v(xbgr.mr_n70531872)
print v(xbgr.mr_n70531984)
print v(xbgr.mr_n70532304)
print v(xbgr.mr_n70532416)
print v(xbgr.mr_n70532736)
print v(xbgr.mr_n70532848)
print v(xbgr.mr_n70533168)
print v(xbgr.mr_n70533280)
print v(xbgr.mr_n70533600)
print v(xbgr.mr_n70533712)
print v(xbgr.mr_n70534032)
print v(xbgr.mr_n70534144)
print v(xbgr.mr_n70534464)
print v(xbgr.mr_n70534576)
print v(xbgr.mr_n70534896)
print v(xbgr.mr_n70535008)
print v(xbgr.mr_n70535328)
print v(xbgr.mr_n70535440)
print v(xbgr.mr_n70535760)
print v(xbgr.mr_n70535872)
print v(xbgr.mr_n70536192)
print v(xbgr.mr_n70536304)
print v(xbgr.mr_n70536624)
print v(xbgr.mr_n70536736)
print v(xbgr.mr_n70537056)
print v(xbgr.mr_n70537168)
print v(xbgr.mr_n70537488)
print v(xbgr.mr_n70537600)
print v(xbgr.mr_n70537920)
print v(xbgr.mr_n70538032)
print v(xbgr.mr_n70538352)
print v(xbgr.mr_n70538464)
print v(xbgr.mr_n70538784)
print v(xbgr.mr_n70538896)
print v(xbgr.mr_n70539216)
print v(xbgr.mr_n70539328)
print v(xbgr.mr_n70539648)
print v(xbgr.mr_n70539760)
print v(xbgr.mr_n70540080)
print v(xbgr.mr_n70540192)
print v(xbgr.mr_n70540512)
print v(xbgr.mr_n70540624)
print v(xbgr.mr_n70540944)
print v(xbgr.mr_n70541056)
print v(xbgr.mr_n70541376)
print v(xbgr.mr_n70541488)
print v(xbgr.mr_n70541808)
print v(xbgr.mr_n70541920)
print v(xbgr.mr_n70542240)
print v(xbgr.mr_n70542352)
print v(xbgr.mr_n70542672)
print v(xbgr.mr_n70542784)
print v(xbgr.mr_n70543104)
print v(xbgr.mr_n70543216)
print v(xbgr.mr_n70543536)
print v(xbgr.mr_n70543648)
print v(xbgr.mr_n70543968)
print v(xbgr.mr_n70544080)
print v(xbgr.mr_n70806560)
print v(xbgr.mr_n70806800)
print v(xbgr.mr_n70806912)
print v(xbgr.mr_n70807232)
print v(xbgr.mr_n70807344)
print v(xbgr.mr_n70807664)
print v(xbgr.mr_n70807776)
print v(xbgr.mr_n70808096)
print v(xbgr.mr_n70808208)
print v(xbgr.mr_n70808528)
print v(xbgr.mr_n70808640)
print v(xbgr.mr_n70808960)
print v(xbgr.mr_n70809072)
print v(xbgr.mr_n70809392)
print v(xbgr.mr_n70809504)
print v(xbgr.mr_n70809824)
print v(xbgr.mr_n70809936)
print v(xbgr.mr_n70810256)
print v(xbgr.mr_n70810368)
print v(xbgr.mr_n70810688)
print v(xbgr.mr_n70810800)
print v(xbgr.mr_n70811120)
print v(xbgr.mr_n70811232)
print v(xbgr.mr_n70811552)
print v(xbgr.mr_n70811664)
print v(xbgr.mr_n70811984)
print v(xbgr.mr_n70812096)
print v(xbgr.mr_n70812416)
print v(xbgr.mr_n70812528)
print v(xbgr.mr_n70812848)
print v(xbgr.mr_n70812960)
print v(xbgr.mr_n70813280)
print v(xbgr.mr_n70813392)
print v(xbgr.mr_n70813712)
print v(xbgr.mr_n70813824)
print v(xbgr.mr_n70814144)
print v(xbgr.mr_n70814256)
print v(xbgr.mr_n70814576)
print v(xbgr.mr_n70814688)
print v(xbgr.mr_n70815008)
print v(xbgr.mr_n70815120)
print v(xbgr.mr_n70815440)
print v(xbgr.mr_n70815552)
print v(xbgr.mr_n70815872)
print v(xbgr.mr_n70815984)
print v(xbgr.mr_n70816304)
print v(xbgr.mr_n70816416)
print v(xbgr.mr_n70816736)
print v(xbgr.mr_n70816848)
print v(xbgr.mr_n70817168)
print v(xbgr.mr_n70817280)
print v(xbgr.mr_n70817600)
print v(xbgr.mr_n70817712)
print v(xbgr.mr_n70818032)
print v(xbgr.mr_n70818144)
print v(xbgr.mr_n70818464)
print v(xbgr.mr_n70818576)
print v(xbgr.mr_n70818896)
print v(xbgr.mr_n70819008)
print v(xbgr.mr_n70819328)
print v(xbgr.mr_n70819440)
print v(xbgr.mr_n70819760)
print v(xbgr.mr_n70819872)
print v(xbgr.mr_n70820192)
print v(xbgr.mr_n70820304)
print v(xbgr.mr_n70820624)
print v(xbgr.mr_n70820736)
print v(xbgr.mr_n70821056)
print v(xbgr.mr_n70821168)
print v(xbgr.mr_n70821488)
print v(xbgr.mr_n70821600)
print v(xbgr.mr_n70821920)
print v(xbgr.mr_n70822032)
print v(xbgr.mr_n70822352)
print v(xbgr.mr_n70822464)
print v(xbgr.mr_n70822784)
print v(xbgr.mr_n70822896)
print v(xbgr.mr_n70823216)
print v(xbgr.mr_n70823328)
print v(xbgr.mr_n70823648)
print v(xbgr.mr_n70823760)
print v(xbgr.mr_n70824080)
print v(xbgr.mr_n70824192)
print v(xbgr.mr_n70824512)
print v(xbgr.mr_n70824624)
print v(xbgr.mr_n70824944)
print v(xbgr.mr_n70825056)
print v(xbgr.mr_n70825376)
print v(xbgr.mr_n70825488)
print v(xbgr.mr_n70825808)
print v(xbgr.mr_n70825920)
print v(xbgr.mr_n70826240)
print v(xbgr.mr_n70826352)
print v(xbgr.mr_n70826672)
print v(xbgr.mr_n70826784)
print v(xbgr.mr_n70827104)
print v(xbgr.mr_n70827216)
print v(xbgr.mr_n70827536)
print v(xbgr.mr_n70827648)
print v(xbgr.mr_n70827968)
print v(xbgr.mr_n70828080)
print v(xbgr.mr_n70828400)
print v(xbgr.mr_n70828512)
print v(xbgr.mr_n70828832)
print v(xbgr.mr_n70828944)
print v(xbgr.mr_n70829264)
print v(xbgr.mr_n70829376)
print v(xbgr.mr_n70829696)
print v(xbgr.mr_n70829808)
print v(xbgr.mr_n70830128)
print v(xbgr.mr_n70830240)
print v(xbgr.mr_n70830560)
print v(xbgr.mr_n70830672)
print v(xbgr.mr_n70830992)
print v(xbgr.mr_n70831104)
print v(xbgr.mr_n70831424)
print v(xbgr.mr_n70831536)
print v(xbgr.mr_n70831856)
print v(xbgr.mr_n70831968)
print v(xbgr.mr_n70832288)
print v(xbgr.mr_n70832400)
print v(xbgr.mr_n70832720)
print v(xbgr.mr_n70832832)
print v(xbgr.mr_n70833152)
print v(xbgr.mr_n70833264)
print v(xbgr.mr_n70833584)
print v(xbgr.mr_n70833696)
print v(xbgr.mr_n70834016)
print v(xbgr.mr_n70834128)
print v(xbgr.mr_n70834448)
print v(xbgr.mr_n70834560)
print v(xbgr.mr_n70834880)
print v(xbgr.mr_n70834992)
print v(xbgr.mr_n70835312)
print v(xbgr.mr_n70835424)
print v(xbgr.mr_n70835744)
print v(xbgr.mr_n70835856)
print v(xbgr.mr_n70836176)
print v(xbgr.mr_n70836288)
print v(xbgr.mr_n70836608)
print v(xbgr.mr_n70836720)
print v(xbgr.mr_n70837040)
print v(xbgr.mr_n70837152)
print v(xbgr.mr_n70837472)
print v(xbgr.mr_n70837584)
print v(xbgr.mr_n70837904)
print v(xbgr.mr_n70838016)
print v(xbgr.mr_n70838336)
print v(xbgr.mr_n70838448)
print v(xbgr.mr_n70838768)
print v(xbgr.mr_n70838880)
print v(xbgr.mr_n70839200)
print v(xbgr.mr_n70839312)
print v(xbgr.mr_n70839632)
print v(xbgr.mr_n70839744)
print v(xbgr.mr_n70840064)
print v(xbgr.mr_n70840176)
print v(xbgr.mr_n70840496)
print v(xbgr.mr_n70840608)
print v(xbgr.mr_n70840928)
print v(xbgr.mr_n70841040)
print v(xbgr.mr_n70841360)
print v(xbgr.mr_n70841472)
print v(xbgr.mr_n70841792)
print v(xbgr.mr_n70841904)
print v(xbgr.mr_n70842224)
print v(xbgr.mr_n70842336)
print v(xbgr.mr_n70842656)
print v(xbgr.mr_n70842768)
print v(xbgr.mr_n70843088)
print v(xbgr.mr_n70843200)
print v(xbgr.mr_n70843520)
print v(xbgr.mr_n70843632)
print v(xbgr.mr_n70843952)
print v(xbgr.mr_n70844064)
print v(xbgr.mr_n70844384)
print v(xbgr.mr_n70844496)
print v(xbgr.mr_n70844816)
print v(xbgr.mr_n70844928)
print v(xbgr.mr_n70845248)
print v(xbgr.mr_n70845360)
print v(xbgr.mr_n70845680)
print v(xbgr.mr_n70845792)
print v(xbgr.mr_n70846112)
print v(xbgr.mr_n70846224)
print v(xbgr.mr_n70846544)
print v(xbgr.mr_n70846656)
print v(xbgr.mr_n70846976)
print v(xbgr.mr_n70847088)
print v(xbgr.mr_n70847408)
print v(xbgr.mr_n70847520)
print v(xbgr.mr_n70847840)
print v(xbgr.mr_n70847952)
print v(xbgr.mr_n70848272)
print v(xbgr.mr_n70848384)
print v(xbgr.mr_n70848704)
print v(xbgr.mr_n70848816)
print v(xbgr.mr_n70849136)
print v(xbgr.mr_n70849248)
print v(xbgr.mr_n70849568)
print v(xbgr.mr_n70849680)
print v(xbgr.mr_n70850000)
print v(xbgr.mr_n70850112)
print v(xbgr.mr_n70850432)
print v(xbgr.mr_n70850544)
print v(xbgr.mr_n70850864)
print v(xbgr.mr_n70850976)
print v(xbgr.mr_n70851296)
print v(xbgr.mr_n70851408)
print v(xbgr.mr_n70851728)
print v(xbgr.mr_n70851840)
print v(xbgr.mr_n70852160)
print v(xbgr.mr_n70852272)
print v(xbgr.mr_n70852592)
print v(xbgr.mr_n70852704)
print v(xbgr.mr_n70853024)
print v(xbgr.mr_n70853136)
print v(xbgr.mr_n70853456)
print v(xbgr.mr_n70853568)
print v(xbgr.mr_n70853888)
print v(xbgr.mr_n70854000)
print v(xbgr.mr_n70854320)
print v(xbgr.mr_n70854432)
print v(xbgr.mr_n70854752)
print v(xbgr.mr_n70854864)
print v(xbgr.mr_n70855184)
print v(xbgr.mr_n70855296)
print v(xbgr.mr_n70855616)
print v(xbgr.mr_n70855728)
print v(xbgr.mr_n70856048)
print v(xbgr.mr_n70856160)
print v(xbgr.mr_n70856480)
print v(xbgr.mr_n70856592)
print v(xbgr.mr_n70856912)
print v(xbgr.mr_n70857024)
print v(xbgr.mr_n70857344)
print v(xbgr.mr_n70857456)
print v(xbgr.mr_n70857776)
print v(xbgr.mr_n70857888)
print v(xbgr.mr_n70858208)
print v(xbgr.mr_n70858320)
print v(xbgr.mr_n70858640)
print v(xbgr.mr_n70858752)
print v(xbgr.mr_n70859072)
print v(xbgr.mr_n70859184)
print v(xbgr.mr_n70859504)
print v(xbgr.mr_n70859616)
print v(xbgr.mr_n70859936)
print v(xbgr.mr_n70860048)
print v(xbgr.mr_n70860368)
print v(xbgr.mr_n70860480)
print v(xbgr.mr_n70860800)
print v(xbgr.mr_n70860912)
print v(xbgr.mr_n70861232)
print v(xbgr.mr_n70861344)
print v(xbgr.mr_n70861664)
print v(xbgr.mr_n70861776)
print v(xbgr.mr_n70862096)
print v(xbgr.mr_n70862208)
print v(xbgr.mr_n70862528)
print v(xbgr.mr_n70862640)
print v(xbgr.mr_n70862960)
print v(xbgr.mr_n70863072)
print v(xbgr.mr_n70863392)
print v(xbgr.mr_n70863504)
print v(xbgr.mr_n70863824)
print v(xbgr.mr_n70863936)
print v(xbgr.mr_n70864256)
print v(xbgr.mr_n70864368)
print v(xbgr.mr_n70864688)
print v(xbgr.mr_n70864800)
print v(xbgr.mr_n70865120)
print v(xbgr.mr_n70865232)
print v(xbgr.mr_n70865552)
print v(xbgr.mr_n70865664)
print v(xbgr.mr_n70865984)
print v(xbgr.mr_n70866096)
print v(xbgr.mr_n70866416)
print v(xbgr.mr_n70866528)
print v(xbgr.mr_n70866848)
print v(xbgr.mr_n70866960)
print v(xbgr.mr_n70867280)
print v(xbgr.mr_n70867392)
print v(xbgr.mr_n70867712)
print v(xbgr.mr_n70867824)
print v(xbgr.mr_n70868144)
print v(xbgr.mr_n70868256)
print v(xbgr.mr_n70868576)
print v(xbgr.mr_n70868688)
print v(xbgr.mr_n70869008)
print v(xbgr.mr_n70869120)
print v(xbgr.mr_n70869440)
print v(xbgr.mr_n70869552)
print v(xbgr.mr_n70869872)
print v(xbgr.mr_n70869984)
print v(xbgr.mr_n70870304)
print v(xbgr.mr_n70870416)
print v(xbgr.mr_n70870736)
print v(xbgr.mr_n70870848)
print v(xbgr.mr_n70871168)
print v(xbgr.mr_n70871280)
print v(xbgr.mr_n70871600)
print v(xbgr.mr_n70871712)
print v(xbgr.mr_n70872032)
print v(xbgr.mr_n70872144)
print v(xbgr.mr_n70872464)
print v(xbgr.mr_n70872576)
print v(xbgr.mr_n70872896)
print v(xbgr.mr_n70873008)
print v(xbgr.mr_n70873328)
print v(xbgr.mr_n70873440)
print v(xbgr.mr_n70873760)
print v(xbgr.mr_n70873872)
print v(xbgr.mr_n70874192)
print v(xbgr.mr_n70874304)
print v(xbgr.mr_n70874624)
print v(xbgr.mr_n70874736)
print v(xbgr.mr_n70875056)
print v(xbgr.mr_n70875168)
print v(xbgr.mr_n70875488)
print v(xbgr.mr_n70875600)
print v(xbgr.mr_n70875920)
print v(xbgr.mr_n70876032)
print v(xbgr.mr_n70876352)
print v(xbgr.mr_n70876464)
print v(xbgr.mr_n70876784)
print v(xbgr.mr_n70876896)
print v(xbgr.mr_n70877216)
print v(xbgr.mr_n70877328)
print v(xbgr.mr_n70877648)
print v(xbgr.mr_n70877760)
print v(xbgr.mr_n70878080)
print v(xbgr.mr_n70878192)
print v(xbgr.mr_n70878512)
print v(xbgr.mr_n70878624)
print v(xbgr.mr_n70878944)
print v(xbgr.mr_n70879056)
print v(xbgr.mr_n70879376)
print v(xbgr.mr_n70879488)
print v(xbgr.mr_n70879808)
print v(xbgr.mr_n70879920)
print v(xbgr.mr_n70880240)
print v(xbgr.mr_n70880352)
print v(xbgr.mr_n70880672)
print v(xbgr.mr_n70880784)
print v(xbgr.mr_n70881104)
print v(xbgr.mr_n70881216)
print v(xbgr.mr_n70881536)
print v(xbgr.mr_n70881648)
print v(xbgr.mr_n70881968)
print v(xbgr.mr_n70882080)
print v(xbgr.mr_n70882400)
print v(xbgr.mr_n70882512)
print v(xbgr.mr_n70882832)
print v(xbgr.mr_n70882944)
print v(xbgr.mr_n70883264)
print v(xbgr.mr_n70883376)
print v(xbgr.mr_n70883696)
print v(xbgr.mr_n70883808)
print v(xbgr.mr_n70884128)
print v(xbgr.mr_n70884240)
print v(xbgr.mr_n70884560)
print v(xbgr.mr_n70884672)
print v(xbgr.mr_n70884992)
print v(xbgr.mr_n70885104)
print v(xbgr.mr_n70885424)
print v(xbgr.mr_n70885536)
print v(xbgr.mr_n70885856)
print v(xbgr.mr_n70885968)
print v(xbgr.mr_n70886288)
print v(xbgr.mr_n70886400)
print v(xbgr.mr_n70886720)
print v(xbgr.mr_n70886832)
print v(xbgr.mr_n70887152)
print v(xbgr.mr_n70887264)
print v(xbgr.mr_n70887584)
print v(xbgr.mr_n70887696)
print v(xbgr.mr_n70888016)
print v(xbgr.mr_n70888128)
print v(xbgr.mr_n70888448)
print v(xbgr.mr_n70888560)
print v(xbgr.mr_n70888880)
print v(xbgr.mr_n70888992)
print v(xbgr.mr_n70889312)
print v(xbgr.mr_n70889424)
print v(xbgr.mr_n70889744)
print v(xbgr.mr_n70889856)
print v(xbgr.mr_n70890176)
print v(xbgr.mr_n70890288)
print v(xbgr.mr_n70890608)
print v(xbgr.mr_n70890720)
print v(xbgr.mr_n70891040)
print v(xbgr.mr_n70891152)
print v(xbgr.mr_n70891472)
print v(xbgr.mr_n70891584)
print v(xbgr.mr_n70891904)
print v(xbgr.mr_n70892016)
print v(xbgr.mr_n70892336)
print v(xbgr.mr_n70892448)
print v(xbgr.mr_n70892768)
print v(xbgr.mr_n70892880)
print v(xbgr.mr_n70893200)
print v(xbgr.mr_n70893312)
print v(xbgr.mr_n70893632)
print v(xbgr.mr_n70893744)
print v(xbgr.mr_n70894064)
print v(xbgr.mr_n70894176)
print v(xbgr.mr_n70894496)
print v(xbgr.mr_n70894608)
print v(xbgr.mr_n70894928)
print v(xbgr.mr_n70895040)
print v(xbgr.mr_n70895360)
print v(xbgr.mr_n70895472)
print v(xbgr.mr_n70895792)
print v(xbgr.mr_n70895904)
print v(xbgr.mr_n70896224)
print v(xbgr.mr_n70896336)
print v(xbgr.mr_n70896656)
print v(xbgr.mr_n70896768)
print v(xbgr.mr_n70897088)
print v(xbgr.mr_n70897200)
print v(xbgr.mr_n70897520)
print v(xbgr.mr_n70897632)
print v(xbgr.mr_n70897952)
print v(xbgr.mr_n70898064)
print v(xbgr.mr_n70898384)
print v(xbgr.mr_n70898496)
print v(xbgr.mr_n70898816)
print v(xbgr.mr_n70898928)
print v(xbgr.mr_n70899248)
print v(xbgr.mr_n70899360)
print v(xbgr.mr_n70899680)
print v(xbgr.mr_n70899792)
print v(xbgr.mr_n70900112)
print v(xbgr.mr_n70900224)
print v(xbgr.mr_n70900544)
print v(xbgr.mr_n70900656)
print v(xbgr.mr_n70900976)
print v(xbgr.mr_n70901088)
print v(xbgr.mr_n70901408)
print v(xbgr.mr_n70901520)
print v(xbgr.mr_n70901840)
print v(xbgr.mr_n70901952)
print v(xbgr.mr_n70902272)
print v(xbgr.mr_n70902384)
print v(xbgr.mr_n70902704)
print v(xbgr.mr_n70902816)
print v(xbgr.mr_n70903136)
print v(xbgr.mr_n70903248)
print v(xbgr.mr_n70903568)
print v(xbgr.mr_n70903680)
print v(xbgr.mr_n70904000)
print v(xbgr.mr_n70904112)
print v(xbgr.mr_n70904432)
print v(xbgr.mr_n70904544)
print v(xbgr.mr_n70904864)
print v(xbgr.mr_n70904976)
print v(xbgr.mr_n70905296)
print v(xbgr.mr_n70905408)
print v(xbgr.mr_n70905728)
print v(xbgr.mr_n70905840)
print v(xbgr.mr_n70906160)
print v(xbgr.mr_n70906272)
print v(xbgr.mr_n70906592)
print v(xbgr.mr_n70906704)
print v(xbgr.mr_n70907024)
print v(xbgr.mr_n70907136)
print v(xbgr.mr_n70907456)
print v(xbgr.mr_n70907568)
print v(xbgr.mr_n70907888)
print v(xbgr.mr_n70908000)
print v(xbgr.mr_n70908320)
print v(xbgr.mr_n70908432)
print v(xbgr.mr_n70908752)
print v(xbgr.mr_n70908864)
print v(xbgr.mr_n70909184)
print v(xbgr.mr_n70909296)
print v(xbgr.mr_n70909616)
print v(xbgr.mr_n70909728)
print v(xbgr.mr_n70910048)
print v(xbgr.mr_n70910160)
print v(xbgr.mr_n70910480)
print v(xbgr.mr_n70910592)
print v(xbgr.mr_n70910912)
print v(xbgr.mr_n70911024)
print v(xbgr.mr_n70911344)
print v(xbgr.mr_n70911456)
print v(xbgr.mr_n70911776)
print v(xbgr.mr_n70911888)
print v(xbgr.mr_n70912208)
print v(xbgr.mr_n70912320)
print v(xbgr.mr_n70912640)
print v(xbgr.mr_n70912752)
print v(xbgr.mr_n70913072)
print v(xbgr.mr_n70913184)
print v(xbgr.mr_n70913504)
print v(xbgr.mr_n70913616)
print v(xbgr.mr_n70913936)
print v(xbgr.mr_n70914048)
print v(xbgr.mr_n70914368)
print v(xbgr.mr_n70914480)
print v(xbgr.mr_n70914800)
print v(xbgr.mr_n70914912)
print v(xbgr.mr_n70915232)
print v(xbgr.mr_n70915344)
print v(xbgr.mr_n70915664)
print v(xbgr.mr_n70915776)
print v(xbgr.mr_n70916096)
print v(xbgr.mr_n70916208)
print v(xbgr.mr_n70916528)
print v(xbgr.mr_n70916640)
print v(xbgr.mr_n70916960)
print v(xbgr.mr_n70917072)
print v(xbgr.mr_n70917392)
print v(xbgr.mr_n70917504)
print v(xbgr.mr_n70917824)
print v(xbgr.mr_n70917936)
print v(xbgr.mr_n70918256)
print v(xbgr.mr_n70918368)
print v(xbgr.mr_n70918688)
print v(xbgr.mr_n70918800)
print v(xbgr.mr_n70919120)
print v(xbgr.mr_n70919232)
print v(xbgr.mr_n70919552)
print v(xbgr.mr_n70919664)
print v(xbgr.mr_n70919984)
print v(xbgr.mr_n70920096)
print v(xbgr.mr_n70920416)
print v(xbgr.mr_n70920528)
print v(xbgr.mr_n70920848)
print v(xbgr.mr_n70920960)
print v(xbgr.mr_n70921280)
print v(xbgr.mr_n70921392)
print v(xbgr.mr_n70921712)
print v(xbgr.mr_n70921824)
print v(xbgr.mr_n70922144)
print v(xbgr.mr_n70922256)
print v(xbgr.mr_n70922576)
print v(xbgr.mr_n70922688)
print v(xbgr.mr_n70923008)
print v(xbgr.mr_n70923120)
print v(xbgr.mr_n70923440)
print v(xbgr.mr_n70923552)
print v(xbgr.mr_n70923872)
print v(xbgr.mr_n70923984)
print v(xbgr.mr_n70924304)
print v(xbgr.mr_n70924416)
print v(xbgr.mr_n70924736)
print v(xbgr.mr_n70924848)
print v(xbgr.mr_n70925168)
print v(xbgr.mr_n70925280)
print v(xbgr.mr_n70925600)
print v(xbgr.mr_n70925712)
print v(xbgr.mr_n70926032)
print v(xbgr.mr_n70926144)
print v(xbgr.mr_n70926464)
print v(xbgr.mr_n70926576)
print v(xbgr.mr_n70926896)
print v(xbgr.mr_n70927008)
print v(xbgr.mr_n70927328)
print v(xbgr.mr_n70927440)
print v(xbgr.mr_n70927760)
print v(xbgr.mr_n70927872)
print v(xbgr.mr_n70928192)
print v(xbgr.mr_n70928304)
print v(xbgr.mr_n70928624)
print v(xbgr.mr_n70928736)
print v(xbgr.mr_n70929056)
print v(xbgr.mr_n70929168)
print v(xbgr.mr_n70929488)
print v(xbgr.mr_n70929600)
print v(xbgr.mr_n70929920)
print v(xbgr.mr_n70930032)
print v(xbgr.mr_n70930352)
print v(xbgr.mr_n70930464)
print v(xbgr.mr_n70930784)
print v(xbgr.mr_n70930896)
print v(xbgr.mr_n70931216)
print v(xbgr.mr_n70931328)
print v(xbgr.mr_n70931648)
print v(xbgr.mr_n70931760)
print v(xbgr.mr_n70932080)
print v(xbgr.mr_n70932192)
print v(xbgr.mr_n70932512)
print v(xbgr.mr_n70932624)
print v(xbgr.mr_n70932944)
print v(xbgr.mr_n70933056)
print v(xbgr.mr_n70933376)
print v(xbgr.mr_n70933488)
print v(xbgr.mr_n70933808)
print v(xbgr.mr_n70933920)
print v(xbgr.mr_n70934240)
print v(xbgr.mr_n70934352)
print v(xbgr.mr_n70934672)
print v(xbgr.mr_n70934784)
print v(xbgr.mr_n70935104)
print v(xbgr.mr_n70935216)
print v(xbgr.mr_n70935536)
print v(xbgr.mr_n70935648)
print v(xbgr.mr_n70935968)
print v(xbgr.mr_n70936080)
print v(xbgr.mr_n70936400)
print v(xbgr.mr_n70936512)
print v(xbgr.mr_n70936832)
print v(xbgr.mr_n70936944)
print v(xbgr.mr_n70937264)
print v(xbgr.mr_n70937376)
print v(xbgr.mr_n70937696)
print v(xbgr.mr_n70937808)
print v(xbgr.mr_n70938128)
print v(xbgr.mr_n70938240)
print v(xbgr.mr_n70938560)
print v(xbgr.mr_n70938672)
print v(xbgr.mr_n70938992)
print v(xbgr.mr_n70939104)
print v(xbgr.mr_n70939424)
print v(xbgr.mr_n70939536)
print v(xbgr.mr_n70939856)
print v(xbgr.mr_n70939968)
print v(xbgr.mr_n70940288)
print v(xbgr.mr_n70940400)
print v(xbgr.mr_n70940720)
print v(xbgr.mr_n70940832)
print v(xbgr.mr_n70941152)
print v(xbgr.mr_n70941264)
print v(xbgr.mr_n70941584)
print v(xbgr.mr_n70941696)
print v(xbgr.mr_n70942016)
print v(xbgr.mr_n70942128)
print v(xbgr.mr_n70942448)
print v(xbgr.mr_n70942560)
print v(xbgr.mr_n70942880)
print v(xbgr.mr_n70942992)
print v(xbgr.mr_n70943312)
print v(xbgr.mr_n70943424)
print v(xbgr.mr_n70943744)
print v(xbgr.mr_n70943856)
print v(xbgr.mr_n70944176)
print v(xbgr.mr_n70944288)
print v(xbgr.mr_n70944608)
print v(xbgr.mr_n70944720)
print v(xbgr.mr_n70945040)
print v(xbgr.mr_n70945152)
print v(xbgr.mr_n70945472)
print v(xbgr.mr_n70945584)
print v(xbgr.mr_n70945904)
print v(xbgr.mr_n70946016)
print v(xbgr.mr_n70946336)
print v(xbgr.mr_n70946448)
print v(xbgr.mr_n70946768)
print v(xbgr.mr_n70946880)
print v(xbgr.mr_n70947200)
print v(xbgr.mr_n70947312)
print v(xbgr.mr_n70947632)
print v(xbgr.mr_n70947744)
print v(xbgr.mr_n70948064)
print v(xbgr.mr_n70948176)
print v(xbgr.mr_n70948496)
print v(xbgr.mr_n70948608)
print v(xbgr.mr_n70948928)
print v(xbgr.mr_n70949040)
print v(xbgr.mr_n70949360)
print v(xbgr.mr_n70949472)
print v(xbgr.mr_n70949792)
print v(xbgr.mr_n70949904)
print v(xbgr.mr_n70950224)
print v(xbgr.mr_n70950336)
print v(xbgr.mr_n70950656)
print v(xbgr.mr_n70950768)
print v(xbgr.mr_n70951088)
print v(xbgr.mr_n70951200)
print v(xbgr.mr_n70951520)
print v(xbgr.mr_n70951632)
print v(xbgr.mr_n70951952)
print v(xbgr.mr_n70952064)
print v(xbgr.mr_n70952384)
print v(xbgr.mr_n70952496)
print v(xbgr.mr_n70952816)
print v(xbgr.mr_n70952928)
print v(xbgr.mr_n70953248)
print v(xbgr.mr_n70953360)
print v(xbgr.mr_n70953680)
print v(xbgr.mr_n70953792)
print v(xbgr.mr_n70954112)
print v(xbgr.mr_n70954224)
print v(xbgr.mr_n70954544)
print v(xbgr.mr_n70954656)
print v(xbgr.mr_n70954976)
print v(xbgr.mr_n70955088)
print v(xbgr.mr_n70955408)
print v(xbgr.mr_n70955520)
print v(xbgr.mr_n70955840)
print v(xbgr.mr_n70955952)
print v(xbgr.mr_n70956272)
print v(xbgr.mr_n70956384)
print v(xbgr.mr_n70956704)
print v(xbgr.mr_n70956816)
print v(xbgr.mr_n70957136)
print v(xbgr.mr_n70957248)
print v(xbgr.mr_n70957568)
print v(xbgr.mr_n70957680)
print v(xbgr.mr_n70958000)
print v(xbgr.mr_n70958112)
print v(xbgr.mr_n70958432)
print v(xbgr.mr_n70958544)
print v(xbgr.mr_n70958864)
print v(xbgr.mr_n70958976)
print v(xbgr.mr_n70959296)
print v(xbgr.mr_n70959408)
print v(xbgr.mr_n70959728)
print v(xbgr.mr_n70959840)
print v(xbgr.mr_n70960160)
print v(xbgr.mr_n70960272)
print v(xbgr.mr_n70960592)
print v(xbgr.mr_n70960704)
print v(xbgr.mr_n70961024)
print v(xbgr.mr_n70961136)
print v(xbgr.mr_n70961456)
print v(xbgr.mr_n70961568)
print v(xbgr.mr_n70961888)
print v(xbgr.mr_n70962000)
print v(xbgr.mr_n70962320)
print v(xbgr.mr_n70962432)
print v(xbgr.mr_n70962752)
print v(xbgr.mr_n70962864)
print v(xbgr.mr_n70963184)
print v(xbgr.mr_n70963296)
print v(xbgr.mr_n70963616)
print v(xbgr.mr_n70963728)
print v(xbgr.mr_n70964048)
print v(xbgr.mr_n70964160)
print v(xbgr.mr_n70964480)
print v(xbgr.mr_n70964592)
print v(xbgr.mr_n70964912)
print v(xbgr.mr_n70965024)
print v(xbgr.mr_n70965344)
print v(xbgr.mr_n70965456)
print v(xbgr.mr_n70965776)
print v(xbgr.mr_n70965888)
print v(xbgr.mr_n70966208)
print v(xbgr.mr_n70966320)
print v(xbgr.mr_n70966640)
print v(xbgr.mr_n70966752)
print v(xbgr.mr_n70967072)
print v(xbgr.mr_n70967184)
print v(xbgr.mr_n70967504)
print v(xbgr.mr_n70967616)
print v(xbgr.mr_n70967936)
print v(xbgr.mr_n70968048)
print v(xbgr.mr_n70968368)
print v(xbgr.mr_n70968480)
print v(xbgr.mr_n70968800)
print v(xbgr.mr_n70968912)
print v(xbgr.mr_n70969232)
print v(xbgr.mr_n70969344)
print v(xbgr.mr_n70969664)
print v(xbgr.mr_n70969776)
print v(xbgr.mr_n70970096)
print v(xbgr.mr_n70970208)
print v(xbgr.mr_n70970528)
print v(xbgr.mr_n70970640)
print v(xbgr.mr_n70970960)
print v(xbgr.mr_n70971072)
print v(xbgr.mr_n70971392)
print v(xbgr.mr_n70971504)
print v(xbgr.mr_n70971824)
print v(xbgr.mr_n70971936)
print v(xbgr.mr_n70972256)
print v(xbgr.mr_n70972368)
print v(xbgr.mr_n70972688)
print v(xbgr.mr_n70972800)
print v(xbgr.mr_n70973120)
print v(xbgr.mr_n70973232)
print v(xbgr.mr_n70973552)
print v(xbgr.mr_n70973664)
print v(xbgr.mr_n70973984)
print v(xbgr.mr_n70974096)
print v(xbgr.mr_n70974416)
print v(xbgr.mr_n70974528)
print v(xbgr.mr_n70974848)
print v(xbgr.mr_n70974960)
print v(xbgr.mr_n70975280)
print v(xbgr.mr_n70975392)
print v(xbgr.mr_n70975712)
print v(xbgr.mr_n70975824)
print v(xbgr.mr_n70976144)
print v(xbgr.mr_n70976256)
print v(xbgr.mr_n70976576)
print v(xbgr.mr_n70976688)
print v(xbgr.mr_n70977008)
print v(xbgr.mr_n70977120)
print v(xbgr.mr_n70977440)
print v(xbgr.mr_n70977552)
print v(xbgr.mr_n70977872)
print v(xbgr.mr_n70977984)
print v(xbgr.mr_n70978304)
print v(xbgr.mr_n70978416)
print v(xbgr.mr_n70978736)
print v(xbgr.mr_n70978848)
print v(xbgr.mr_n70979168)
print v(xbgr.mr_n70979280)
print v(xbgr.mr_n70979600)
print v(xbgr.mr_n70979712)
print v(xbgr.mr_n70980032)
print v(xbgr.mr_n70980144)
print v(xbgr.mr_n70980464)
print v(xbgr.mr_n70980576)
print v(xbgr.mr_n70980896)
print v(xbgr.mr_n70981008)
print v(xbgr.mr_n70981328)
print v(xbgr.mr_n70981440)
print v(xbgr.mr_n70981760)
print v(xbgr.mr_n70981872)
print v(xbgr.mr_n70982192)
print v(xbgr.mr_n70982304)
print v(xbgr.mr_n70982624)
print v(xbgr.mr_n70982736)
print v(xbgr.mr_n70983056)
print v(xbgr.mr_n70983168)
print v(xbgr.mr_n70983488)
print v(xbgr.mr_n70983600)
print v(xbgr.mr_n70983920)
print v(xbgr.mr_n70984032)
print v(xbgr.mr_n70984352)
print v(xbgr.mr_n70984464)
print v(xbgr.mr_n70984784)
print v(xbgr.mr_n70984896)
print v(xbgr.mr_n70985216)
print v(xbgr.mr_n70985328)
print v(xbgr.mr_n70985648)
print v(xbgr.mr_n70985760)
print v(xbgr.mr_n70986080)
print v(xbgr.mr_n70986192)
print v(xbgr.mr_n70986512)
print v(xbgr.mr_n70986624)
print v(xbgr.mr_n70986944)
print v(xbgr.mr_n70987056)
print v(xbgr.mr_n70987376)
print v(xbgr.mr_n70987488)
print v(xbgr.mr_n70987808)
print v(xbgr.mr_n70987920)
print v(xbgr.mr_n70988240)
print v(xbgr.mr_n70988352)
print v(xbgr.mr_n70988672)
print v(xbgr.mr_n70988784)
print v(xbgr.mr_n70989104)
print v(xbgr.mr_n70989216)
print v(xbgr.mr_n70989536)
print v(xbgr.mr_n70989648)
print v(xbgr.mr_n70989968)
print v(xbgr.mr_n70990080)
print v(xbgr.mr_n70990400)
print v(xbgr.mr_n70990512)
print v(xbgr.mr_n70990832)
print v(xbgr.mr_n70990944)
print v(xbgr.mr_n70991264)
print v(xbgr.mr_n70991376)
print v(xbgr.mr_n70991696)
print v(xbgr.mr_n70991808)
print v(xbgr.mr_n70992128)
print v(xbgr.mr_n70992240)
print v(xbgr.mr_n70992560)
print v(xbgr.mr_n70992672)
print v(xbgr.mr_n70992992)
print v(xbgr.mr_n70993104)
print v(xbgr.mr_n70993424)
print v(xbgr.mr_n70993536)
print v(xbgr.mr_n70993856)
print v(xbgr.mr_n70993968)
print v(xbgr.mr_n70994288)
print v(xbgr.mr_n70994400)
print v(xbgr.mr_n70994720)
print v(xbgr.mr_n70994832)
print v(xbgr.mr_n70995152)
print v(xbgr.mr_n70995264)
print v(xbgr.mr_n70995584)
print v(xbgr.mr_n70995696)
print v(xbgr.mr_n70996016)
print v(xbgr.mr_n70996128)
print v(xbgr.mr_n70996448)
print v(xbgr.mr_n70996560)
print v(xbgr.mr_n70996880)
print v(xbgr.mr_n70996992)
print v(xbgr.mr_n70997312)
print v(xbgr.mr_n70997424)
print v(xbgr.mr_n70997744)
print v(xbgr.mr_n70997856)
print v(xbgr.mr_n70998176)
print v(xbgr.mr_n70998288)
print v(xbgr.mr_n70998608)
print v(xbgr.mr_n70998720)
print v(xbgr.mr_n70999040)
print v(xbgr.mr_n70999152)
print v(xbgr.mr_n70999472)
print v(xbgr.mr_n70999584)
print v(xbgr.mr_n70999904)
print v(xbgr.mr_n71000016)
print v(xbgr.mr_n71000336)
print v(xbgr.mr_n71000448)
print v(xbgr.mr_n71000768)
print v(xbgr.mr_n71000880)
print v(xbgr.mr_n71001200)
print v(xbgr.mr_n71001312)
print v(xbgr.mr_n71001632)
print v(xbgr.mr_n71001744)
print v(xbgr.mr_n71002064)
print v(xbgr.mr_n71002176)
print v(xbgr.mr_n71002496)
print v(xbgr.mr_n71002608)
print v(xbgr.mr_n71002928)
print v(xbgr.mr_n71003040)
print v(xbgr.mr_n71003360)
print v(xbgr.mr_n71003472)
print v(xbgr.mr_n71003792)
print v(xbgr.mr_n71003904)
print v(xbgr.mr_n71004208)
print v(xbgr.mr_n71004320)
print v(xbgr.mr_n71004640)
print v(xbgr.mr_n71004752)
print v(xbgr.mr_n71005072)
print v(xbgr.mr_n71005184)
print v(xbgr.mr_n71005504)
print v(xbgr.mr_n71005616)
print v(xbgr.mr_n71005936)
print v(xbgr.mr_n71006048)
print v(xbgr.mr_n71006368)
print v(xbgr.mr_n71006480)
print v(xbgr.mr_n71006800)
print v(xbgr.mr_n71006912)
print v(xbgr.mr_n71007232)
print v(xbgr.mr_n71007344)
print v(xbgr.mr_n71007664)
print v(xbgr.mr_n71007776)
print v(xbgr.mr_n71008096)
print v(xbgr.mr_n71008208)
print v(xbgr.mr_n71008528)
print v(xbgr.mr_n71008640)
print v(xbgr.mr_n71008960)
print v(xbgr.mr_n71009072)
print v(xbgr.mr_n71009392)
print v(xbgr.mr_n71009504)
print v(xbgr.mr_n71009824)
print v(xbgr.mr_n71009936)
print v(xbgr.mr_n71010256)
print v(xbgr.mr_n71010368)
print v(xbgr.mr_n71010688)
print v(xbgr.mr_n71010800)
print v(xbgr.mr_n71011120)
print v(xbgr.mr_n71011232)
print v(xbgr.mr_n71011552)
print v(xbgr.mr_n71011664)
print v(xbgr.mr_n71011984)
print v(xbgr.mr_n71012096)
print v(xbgr.mr_n71012416)
print v(xbgr.mr_n71012528)
print v(xbgr.mr_n71012848)
print v(xbgr.mr_n71012960)
print v(xbgr.mr_n71013280)
print v(xbgr.mr_n71013392)
print v(xbgr.mr_n71013712)
print v(xbgr.mr_n71013824)
print v(xbgr.mr_n71014144)
print v(xbgr.mr_n71014256)
print v(xbgr.mr_n71014576)
print v(xbgr.mr_n71014688)
print v(xbgr.mr_n71015008)
print v(xbgr.mr_n71015120)
print v(xbgr.mr_n71015440)
print v(xbgr.mr_n71015552)
print v(xbgr.mr_n71015872)
print v(xbgr.mr_n71015984)
print v(xbgr.mr_n71016304)
print v(xbgr.mr_n71016416)
print v(xbgr.mr_n71016736)
print v(xbgr.mr_n71016848)
print v(xbgr.mr_n71017168)
print v(xbgr.mr_n71017280)
print v(xbgr.mr_n71017600)
print v(xbgr.mr_n71017712)
print v(xbgr.mr_n71018032)
print v(xbgr.mr_n71018144)
print v(xbgr.mr_n71018464)
print v(xbgr.mr_n71018576)
print v(xbgr.mr_n71018896)
print v(xbgr.mr_n71019008)
print v(xbgr.mr_n71019328)
print v(xbgr.mr_n71019440)
print v(xbgr.mr_n71019760)
print v(xbgr.mr_n71019872)
print v(xbgr.mr_n71020192)
print v(xbgr.mr_n71020304)
print v(xbgr.mr_n71020624)
print v(xbgr.mr_n71020736)
print v(xbgr.mr_n71021056)
print v(xbgr.mr_n71021168)
print v(xbgr.mr_n71021488)
print v(xbgr.mr_n71021600)
print v(xbgr.mr_n71021920)
print v(xbgr.mr_n71022032)
print v(xbgr.mr_n71022352)
print v(xbgr.mr_n71022464)
print v(xbgr.mr_n71022784)
print v(xbgr.mr_n71022896)
print v(xbgr.mr_n71023216)
print v(xbgr.mr_n71023328)
print v(xbgr.mr_n71023648)
print v(xbgr.mr_n71023760)
print v(xbgr.mr_n71024080)
print v(xbgr.mr_n71024192)
print v(xbgr.mr_n71024512)
print v(xbgr.mr_n71024624)
print v(xbgr.mr_n71024944)
print v(xbgr.mr_n71025056)
print v(xbgr.mr_n71025376)
print v(xbgr.mr_n71025488)
print v(xbgr.mr_n71025808)
print v(xbgr.mr_n71025920)
print v(xbgr.mr_n71026240)
print v(xbgr.mr_n71026352)
print v(xbgr.mr_n71026672)
print v(xbgr.mr_n71026784)
print v(xbgr.mr_n71027104)
print v(xbgr.mr_n71027216)
print v(xbgr.mr_n71027536)
print v(xbgr.mr_n71027648)
print v(xbgr.mr_n71027968)
print v(xbgr.mr_n71028080)
print v(xbgr.mr_n71028400)
print v(xbgr.mr_n71028512)
print v(xbgr.mr_n71028832)
print v(xbgr.mr_n71028944)
print v(xbgr.mr_n71029264)
print v(xbgr.mr_n71029376)
print v(xbgr.mr_n71029696)
print v(xbgr.mr_n71029808)
print v(xbgr.mr_n71030128)
print v(xbgr.mr_n71030240)
print v(xbgr.mr_n71030560)
print v(xbgr.mr_n71030672)
print v(xbgr.mr_n71030992)
print v(xbgr.mr_n71031104)
print v(xbgr.mr_n71031424)
print v(xbgr.mr_n71031536)
print v(xbgr.mr_n71031856)
print v(xbgr.mr_n71031968)
print v(xbgr.mr_n71032288)
print v(xbgr.mr_n71032400)
print v(xbgr.mr_n71032720)
print v(xbgr.mr_n71032832)
print v(xbgr.mr_n71033152)
print v(xbgr.mr_n71033264)
print v(xbgr.mr_n71033584)
print v(xbgr.mr_n71033696)
print v(xbgr.mr_n71034016)
print v(xbgr.mr_n71034128)
print v(xbgr.mr_n71034448)
print v(xbgr.mr_n71034560)
print v(xbgr.mr_n71034880)
print v(xbgr.mr_n71034992)
print v(xbgr.mr_n71035312)
print v(xbgr.mr_n71035424)
print v(xbgr.mr_n71035744)
print v(xbgr.mr_n71035856)
print v(xbgr.mr_n71036176)
print v(xbgr.mr_n71036288)
print v(xbgr.mr_n71036608)
print v(xbgr.mr_n71036720)
print v(xbgr.mr_n71037040)
print v(xbgr.mr_n71037152)
print v(xbgr.mr_n71037472)
print v(xbgr.mr_n71037584)
print v(xbgr.mr_n71037904)
print v(xbgr.mr_n71038016)
print v(xbgr.mr_n71038336)
print v(xbgr.mr_n71038448)
print v(xbgr.mr_n71038768)
print v(xbgr.mr_n71038880)
print v(xbgr.mr_n71039200)
print v(xbgr.mr_n71039312)
print v(xbgr.mr_n71039632)
print v(xbgr.mr_n71039744)
print v(xbgr.mr_n71040064)
print v(xbgr.mr_n71040176)
print v(xbgr.mr_n71040496)
print v(xbgr.mr_n71040608)
print v(xbgr.mr_n71040928)
print v(xbgr.mr_n71041040)
print v(xbgr.mr_n71041360)
print v(xbgr.mr_n71041472)
print v(xbgr.mr_n71041792)
print v(xbgr.mr_n71041904)
print v(xbgr.mr_n71042224)
print v(xbgr.mr_n71042336)
print v(xbgr.mr_n71042656)
print v(xbgr.mr_n71042768)
print v(xbgr.mr_n71043088)
print v(xbgr.mr_n71043200)
print v(xbgr.mr_n71043520)
print v(xbgr.mr_n71043632)
print v(xbgr.mr_n71043952)
print v(xbgr.mr_n71044064)
print v(xbgr.mr_n71044384)
print v(xbgr.mr_n71044496)
print v(xbgr.mr_n71044816)
print v(xbgr.mr_n71044928)
print v(xbgr.mr_n71045248)
print v(xbgr.mr_n71045360)
print v(xbgr.mr_n71045680)
print v(xbgr.mr_n71045792)
print v(xbgr.mr_n71046112)
print v(xbgr.mr_n71046224)
print v(xbgr.mr_n71046544)
print v(xbgr.mr_n71046656)
print v(xbgr.mr_n71046976)
print v(xbgr.mr_n71047088)
print v(xbgr.mr_n71047408)
print v(xbgr.mr_n71047520)
print v(xbgr.mr_n71047840)
print v(xbgr.mr_n71047952)
print v(xbgr.mr_n71048272)
print v(xbgr.mr_n71048384)
print v(xbgr.mr_n71048704)
print v(xbgr.mr_n71048816)
print v(xbgr.mr_n71049136)
print v(xbgr.mr_n71049248)
print v(xbgr.mr_n71049568)
print v(xbgr.mr_n71049680)
print v(xbgr.mr_n71050000)
print v(xbgr.mr_n71050112)
print v(xbgr.mr_n71050432)
print v(xbgr.mr_n71050544)
print v(xbgr.mr_n71050864)
print v(xbgr.mr_n71050976)
print v(xbgr.mr_n71051296)
print v(xbgr.mr_n71051408)
print v(xbgr.mr_n71051728)
print v(xbgr.mr_n71051840)
print v(xbgr.mr_n71052160)
print v(xbgr.mr_n71052272)
print v(xbgr.mr_n71052592)
print v(xbgr.mr_n71052704)
print v(xbgr.mr_n71053024)
print v(xbgr.mr_n71053136)
print v(xbgr.mr_n71053456)
print v(xbgr.mr_n71053568)
print v(xbgr.mr_n71053888)
print v(xbgr.mr_n71054000)
print v(xbgr.mr_n71054320)
print v(xbgr.mr_n71054432)
print v(xbgr.mr_n71054752)
print v(xbgr.mr_n71054864)
print v(xbgr.mr_n71055184)
print v(xbgr.mr_n71055296)
print v(xbgr.mr_n71055616)
print v(xbgr.mr_n71055728)
print v(xbgr.mr_n71056048)
print v(xbgr.mr_n71056160)
print v(xbgr.mr_n71056480)
print v(xbgr.mr_n71056592)
print v(xbgr.mr_n71056912)
print v(xbgr.mr_n71057024)
print v(xbgr.mr_n71057344)
print v(xbgr.mr_n71057456)
print v(xbgr.mr_n71057776)
print v(xbgr.mr_n71057888)
print v(xbgr.mr_n71058208)
print v(xbgr.mr_n71058320)
print v(xbgr.mr_n71058640)
print v(xbgr.mr_n71058752)
print v(xbgr.mr_n71059072)
print v(xbgr.mr_n71059184)
print v(xbgr.mr_n71059504)
print v(xbgr.mr_n71059616)
print v(xbgr.mr_n71059936)
print v(xbgr.mr_n71060048)
print v(xbgr.mr_n71060368)
print v(xbgr.mr_n71060480)
print v(xbgr.mr_n71060800)
print v(xbgr.mr_n71060912)
print v(xbgr.mr_n71061232)
print v(xbgr.mr_n71061344)
print v(xbgr.mr_n71061664)
print v(xbgr.mr_n71061776)
print v(xbgr.mr_n71062096)
print v(xbgr.mr_n71062208)
print v(xbgr.mr_n71062528)
print v(xbgr.mr_n71062640)
print v(xbgr.mr_n71062960)
print v(xbgr.mr_n71063072)
print v(xbgr.mr_n71063392)
print v(xbgr.mr_n71063504)
print v(xbgr.mr_n71063824)
print v(xbgr.mr_n71063936)
print v(xbgr.mr_n71064256)
print v(xbgr.mr_n71064368)
print v(xbgr.mr_n71064688)
print v(xbgr.mr_n71064800)
print v(xbgr.mr_n71065120)
print v(xbgr.mr_n71065232)
print v(xbgr.mr_n71065552)
print v(xbgr.mr_n71065664)
print v(xbgr.mr_n71065984)
print v(xbgr.mr_n71066096)
print v(xbgr.mr_n71066416)
print v(xbgr.mr_n71066528)
print v(xbgr.mr_n71066848)
print v(xbgr.mr_n71066960)
print v(xbgr.mr_n71067280)
print v(xbgr.mr_n71067392)
print v(xbgr.mr_n71067712)
print v(xbgr.mr_n71067824)
print v(xbgr.mr_n71068144)
print v(xbgr.mr_n71068256)
print v(xbgr.mr_n71068576)
print v(xbgr.mr_n71068688)
print v(xbgr.mr_n71069008)
print v(xbgr.mr_n71069120)
print v(xbgr.mr_n71069440)
print v(xbgr.mr_n71069552)
print v(xbgr.mr_n71069872)
print v(xbgr.mr_n71069984)
print v(xbgr.mr_n71070304)
print v(xbgr.mr_n71070416)
print v(xbgr.mr_n71070736)
print v(xbgr.mr_n71070848)
print v(xbgr.mr_n71071168)
print v(xbgr.mr_n71071280)
print v(xbgr.mr_n71071600)
print v(xbgr.mr_n71071712)
print v(xbgr.mr_n71072032)
print v(xbgr.mr_n71072144)
print v(xbgr.mr_n71072464)
print v(xbgr.mr_n71072576)
print v(xbgr.mr_n71072896)
print v(xbgr.mr_n71073008)
print v(xbgr.mr_n71073328)
print v(xbgr.mr_n71073440)
print v(xbgr.mr_n71073760)
print v(xbgr.mr_n71073872)
print v(xbgr.mr_n71074192)
print v(xbgr.mr_n71074304)
print v(xbgr.mr_n71074624)
print v(xbgr.mr_n71074736)
print v(xbgr.mr_n71075056)
print v(xbgr.mr_n71075168)
print v(xbgr.mr_n71075488)
print v(xbgr.mr_n71075600)
print v(xbgr.mr_n71075920)
print v(xbgr.mr_n71076032)
print v(xbgr.mr_n71076352)
print v(xbgr.mr_n71076464)
print v(xbgr.mr_n71076784)
print v(xbgr.mr_n71076896)
print v(xbgr.mr_n71077216)
print v(xbgr.mr_n71077328)
print v(xbgr.mr_n71077648)
print v(xbgr.mr_n71077760)
print v(xbgr.mr_n71078080)
print v(xbgr.mr_n71078192)
print v(xbgr.mr_n71078512)
print v(xbgr.mr_n71078624)
print v(xbgr.mr_n71078944)
print v(xbgr.mr_n71079056)
print v(xbgr.mr_n71079376)
print v(xbgr.mr_n71079488)
print v(xbgr.mr_n71079808)
print v(xbgr.mr_n71079920)
print v(xbgr.mr_n71080240)
print v(xbgr.mr_n71080352)
print v(xbgr.mr_n71080672)
print v(xbgr.mr_n71080784)
print v(xbgr.mr_n71081104)
print v(xbgr.mr_n71081216)
print v(xbgr.mr_n71081536)
print v(xbgr.mr_n71081648)
print v(xbgr.mr_n71081968)
print v(xbgr.mr_n71082080)
print v(xbgr.mr_n71082400)
print v(xbgr.mr_n71082512)
print v(xbgr.mr_n71082832)
print v(xbgr.mr_n71082944)
print v(xbgr.mr_n71083264)
print v(xbgr.mr_n71083376)
print v(xbgr.mr_n71083696)
print v(xbgr.mr_n71083808)
print v(xbgr.mr_n71084128)
print v(xbgr.mr_n71084240)
print v(xbgr.mr_n71084560)
print v(xbgr.mr_n71084672)
print v(xbgr.mr_n71084992)
print v(xbgr.mr_n71085104)
print v(xbgr.mr_n71085424)
print v(xbgr.mr_n71085536)
print v(xbgr.mr_n71085856)
print v(xbgr.mr_n71085968)
print v(xbgr.mr_n71086288)
print v(xbgr.mr_n71086400)
print v(xbgr.mr_n71086720)
print v(xbgr.mr_n71086832)
print v(xbgr.mr_n71087152)
print v(xbgr.mr_n71087264)
print v(xbgr.mr_n71087584)
print v(xbgr.mr_n71087696)
print v(xbgr.mr_n71088016)
print v(xbgr.mr_n71088128)
print v(xbgr.mr_n71088448)
print v(xbgr.mr_n71088560)
print v(xbgr.mr_n71088880)
print v(xbgr.mr_n71088992)
print v(xbgr.mr_n71089312)
print v(xbgr.mr_n71089424)
print v(xbgr.mr_n71089744)
print v(xbgr.mr_n71089856)
print v(xbgr.mr_n71090176)
print v(xbgr.mr_n71090288)
print v(xbgr.mr_n71090608)
print v(xbgr.mr_n71090720)
print v(xbgr.mr_n71091040)
print v(xbgr.mr_n71091152)
print v(xbgr.mr_n71091472)
print v(xbgr.mr_n71091584)
print v(xbgr.mr_n71091904)
print v(xbgr.mr_n71092016)
print v(xbgr.mr_n71092336)
print v(xbgr.mr_n71092448)
print v(xbgr.mr_n71092768)
print v(xbgr.mr_n71092880)
print v(xbgr.mr_n71093200)
print v(xbgr.mr_n71093312)
print v(xbgr.mr_n71093632)
print v(xbgr.mr_n71093744)
print v(xbgr.mr_n71094064)
print v(xbgr.mr_n71094176)
print v(xbgr.mr_n71094496)
print v(xbgr.mr_n71094608)
print v(xbgr.mr_n71094928)
print v(xbgr.mr_n71095040)
print v(xbgr.mr_n71095360)
print v(xbgr.mr_n71095472)
print v(xbgr.mr_n71095792)
print v(xbgr.mr_n71095904)
print v(xbgr.mr_n71096224)
print v(xbgr.mr_n71096336)
print v(xbgr.mr_n71096656)
print v(xbgr.mr_n71096768)
print v(xbgr.mr_n71097088)
print v(xbgr.mr_n71097200)
print v(xbgr.mr_n71097520)
print v(xbgr.mr_n71097632)
print v(xbgr.mr_n71097952)
print v(xbgr.mr_n71098064)
print v(xbgr.mr_n71098384)
print v(xbgr.mr_n71098496)
print v(xbgr.mr_n71098816)
print v(xbgr.mr_n71098928)
print v(xbgr.mr_n71099248)
print v(xbgr.mr_n71099360)
print v(xbgr.mr_n71099680)
print v(xbgr.mr_n71099792)
print v(xbgr.mr_n71100112)
print v(xbgr.mr_n71100224)
print v(xbgr.mr_n71100544)
print v(xbgr.mr_n71100656)
print v(xbgr.mr_n71100976)
print v(xbgr.mr_n71101088)
print v(xbgr.mr_n71101408)
print v(xbgr.mr_n71101520)
print v(xbgr.mr_n71101840)
print v(xbgr.mr_n71101952)
print v(xbgr.mr_n71102272)
print v(xbgr.mr_n71102384)
print v(xbgr.mr_n71102704)
print v(xbgr.mr_n71102816)
print v(xbgr.mr_n71103136)
print v(xbgr.mr_n71103248)
print v(xbgr.mr_n71103568)
print v(xbgr.mr_n71103680)
print v(xbgr.mr_n71104000)
print v(xbgr.mr_n71104112)
print v(xbgr.mr_n71104432)
print v(xbgr.mr_n71104544)
print v(xbgr.mr_n71104864)
print v(xbgr.mr_n71104976)
print v(xbgr.mr_n71105296)
print v(xbgr.mr_n71105408)
print v(xbgr.mr_n71105728)
print v(xbgr.mr_n71105840)
print v(xbgr.mr_n71106160)
print v(xbgr.mr_n71106272)
print v(xbgr.mr_n71106592)
print v(xbgr.mr_n71106704)
print v(xbgr.mr_n71107024)
print v(xbgr.mr_n71107136)
print v(xbgr.mr_n71107456)
print v(xbgr.mr_n71107568)
print v(xbgr.mr_n71107888)
print v(xbgr.mr_n71108000)
print v(xbgr.mr_n71108320)
print v(xbgr.mr_n71108432)
print v(xbgr.mr_n71108752)
print v(xbgr.mr_n71108864)
print v(xbgr.mr_n71109184)
print v(xbgr.mr_n71109296)
print v(xbgr.mr_n71109616)
print v(xbgr.mr_n71109728)
print v(xbgr.mr_n71110048)
print v(xbgr.mr_n71110160)
print v(xbgr.mr_n71110480)
print v(xbgr.mr_n71110592)
print v(xbgr.mr_n71110912)
print v(xbgr.mr_n71111024)
print v(xbgr.mr_n71111344)
print v(xbgr.mr_n71111456)
print v(xbgr.mr_n71111776)
print v(xbgr.mr_n71111888)
print v(xbgr.mr_n71112208)
print v(xbgr.mr_n71112320)
print v(xbgr.mr_n71112640)
print v(xbgr.mr_n71112752)
print v(xbgr.mr_n71113072)
print v(xbgr.mr_n71113184)
print v(xbgr.mr_n71113504)
print v(xbgr.mr_n71113616)
print v(xbgr.mr_n71113936)
print v(xbgr.mr_n71114048)
print v(xbgr.mr_n71114368)
print v(xbgr.mr_n71114480)
print v(xbgr.mr_n71114800)
print v(xbgr.mr_n71114912)
print v(xbgr.mr_n71115232)
print v(xbgr.mr_n71115344)
print v(xbgr.mr_n71115664)
print v(xbgr.mr_n71115776)
print v(xbgr.mr_n71116096)
print v(xbgr.mr_n71116208)
print v(xbgr.mr_n71116528)
print v(xbgr.mr_n71116640)
print v(xbgr.mr_n71116960)
print v(xbgr.mr_n71117072)
print v(xbgr.mr_n71117392)
print v(xbgr.mr_n71117504)
print v(xbgr.mr_n71117824)
print v(xbgr.mr_n71117936)
print v(xbgr.mr_n71118256)
print v(xbgr.mr_n71118368)
print v(xbgr.mr_n71118688)
print v(xbgr.mr_n71118800)
print v(xbgr.mr_n71119120)
print v(xbgr.mr_n71119232)
print v(xbgr.mr_n71119552)
print v(xbgr.mr_n71119664)
print v(xbgr.mr_n71119984)
print v(xbgr.mr_n71120096)
print v(xbgr.mr_n71120416)
print v(xbgr.mr_n71120528)
print v(xbgr.mr_n71120848)
print v(xbgr.mr_n71120960)
print v(xbgr.mr_n71121280)
print v(xbgr.mr_n71121392)
print v(xbgr.mr_n71121712)
print v(xbgr.mr_n71121824)
print v(xbgr.mr_n71122144)
print v(xbgr.mr_n71122256)
print v(xbgr.mr_n71122576)
print v(xbgr.mr_n71122688)
print v(xbgr.mr_n71123008)
print v(xbgr.mr_n71123120)
print v(xbgr.mr_n71123440)
print v(xbgr.mr_n71123552)
print v(xbgr.mr_n71123872)
print v(xbgr.mr_n71123984)
print v(xbgr.mr_n71124304)
print v(xbgr.mr_n71124416)
print v(xbgr.mr_n71124736)
print v(xbgr.mr_n71124848)
print v(xbgr.mr_n71125168)
print v(xbgr.mr_n71125280)
print v(xbgr.mr_n71125600)
print v(xbgr.mr_n71125712)
print v(xbgr.mr_n71126032)
print v(xbgr.mr_n71126144)
print v(xbgr.mr_n71126464)
print v(xbgr.mr_n71126576)
print v(xbgr.mr_n71126896)
print v(xbgr.mr_n71127008)
print v(xbgr.mr_n71127328)
print v(xbgr.mr_n71127440)
print v(xbgr.mr_n71127760)
print v(xbgr.mr_n71127872)
print v(xbgr.mr_n71128192)
print v(xbgr.mr_n71128304)
print v(xbgr.mr_n71128624)
print v(xbgr.mr_n71128736)
print v(xbgr.mr_n71129056)
print v(xbgr.mr_n71129168)
print v(xbgr.mr_n71129488)
print v(xbgr.mr_n71129600)
print v(xbgr.mr_n71129920)
print v(xbgr.mr_n71130032)
print v(xbgr.mr_n71130352)
print v(xbgr.mr_n71130464)
print v(xbgr.mr_n71130784)
print v(xbgr.mr_n71130896)
print v(xbgr.mr_n71131216)
print v(xbgr.mr_n71131328)
print v(xbgr.mr_n71131648)
print v(xbgr.mr_n71131760)
print v(xbgr.mr_n71132080)
print v(xbgr.mr_n71132192)
print v(xbgr.mr_n71132512)
print v(xbgr.mr_n71132624)
print v(xbgr.mr_n71132944)
print v(xbgr.mr_n71133056)
print v(xbgr.mr_n71133376)
print v(xbgr.mr_n71133488)
print v(xbgr.mr_n71133808)
print v(xbgr.mr_n71133920)
print v(xbgr.mr_n71134240)
print v(xbgr.mr_n71134352)
print v(xbgr.mr_n71134672)
print v(xbgr.mr_n71134784)
print v(xbgr.mr_n71135104)
print v(xbgr.mr_n71135216)
print v(xbgr.mr_n71135536)
print v(xbgr.mr_n71135648)
print v(xbgr.mr_n71135968)
print v(xbgr.mr_n71136080)
print v(xbgr.mr_n71136400)
print v(xbgr.mr_n71136512)
print v(xbgr.mr_n71136832)
print v(xbgr.mr_n71136944)
print v(xbgr.mr_n71137264)
print v(xbgr.mr_n71137376)
print v(xbgr.mr_n71137696)
print v(xbgr.mr_n71137808)
print v(xbgr.mr_n71138128)
print v(xbgr.mr_n71138240)
print v(xbgr.mr_n71138560)
print v(xbgr.mr_n71138672)
print v(xbgr.mr_n71138992)
print v(xbgr.mr_n71139104)
print v(xbgr.mr_n71139424)
print v(xbgr.mr_n71139536)
print v(xbgr.mr_n71139856)
print v(xbgr.mr_n71139968)
print v(xbgr.mr_n71140288)
print v(xbgr.mr_n71140400)
print v(xbgr.mr_n71140720)
print v(xbgr.mr_n71140832)
print v(xbgr.mr_n71141152)
print v(xbgr.mr_n71141264)
print v(xbgr.mr_n71141584)
print v(xbgr.mr_n71141696)
print v(xbgr.mr_n71142016)
print v(xbgr.mr_n71142128)
print v(xbgr.mr_n71142448)
print v(xbgr.mr_n71142560)
print v(xbgr.mr_n71142880)
print v(xbgr.mr_n71142992)
print v(xbgr.mr_n71143312)
print v(xbgr.mr_n71143424)
print v(xbgr.mr_n71143744)
print v(xbgr.mr_n71143856)
print v(xbgr.mr_n71144176)
print v(xbgr.mr_n71144288)
print v(xbgr.mr_n71144608)
print v(xbgr.mr_n71144720)
print v(xbgr.mr_n71145040)
print v(xbgr.mr_n71145152)
print v(xbgr.mr_n71145472)
print v(xbgr.mr_n71145584)
print v(xbgr.mr_n71145904)
print v(xbgr.mr_n71146016)
print v(xbgr.mr_n71146336)
print v(xbgr.mr_n71146448)
print v(xbgr.mr_n71146768)
print v(xbgr.mr_n71146880)
print v(xbgr.mr_n71147200)
print v(xbgr.mr_n71147312)
print v(xbgr.mr_n71147632)
print v(xbgr.mr_n71147744)
print v(xbgr.mr_n71148064)
print v(xbgr.mr_n71148176)
print v(xbgr.mr_n71148496)
print v(xbgr.mr_n71148608)
print v(xbgr.mr_n71148928)
print v(xbgr.mr_n71149040)
print v(xbgr.mr_n71149360)
print v(xbgr.mr_n71149472)
print v(xbgr.mr_n71149792)
print v(xbgr.mr_n71149904)
print v(xbgr.mr_n71150224)
print v(xbgr.mr_n71150336)
print v(xbgr.mr_n71150656)
print v(xbgr.mr_n71150768)
print v(xbgr.mr_n71151088)
print v(xbgr.mr_n71151200)
print v(xbgr.mr_n71151520)
print v(xbgr.mr_n71151632)
print v(xbgr.mr_n71151952)
print v(xbgr.mr_n71152064)
print v(xbgr.mr_n71152384)
print v(xbgr.mr_n71152496)
print v(xbgr.mr_n71152816)
print v(xbgr.mr_n71152928)
print v(xbgr.mr_n71153248)
print v(xbgr.mr_n71153360)
print v(xbgr.mr_n71153680)
print v(xbgr.mr_n71153792)
print v(xbgr.mr_n71154112)
print v(xbgr.mr_n71154224)
print v(xbgr.mr_n71154544)
print v(xbgr.mr_n71154656)
print v(xbgr.mr_n71154976)
print v(xbgr.mr_n71155088)
print v(xbgr.mr_n71155408)
print v(xbgr.mr_n71155520)
print v(xbgr.mr_n71155840)
print v(xbgr.mr_n71155952)
print v(xbgr.mr_n71156272)
print v(xbgr.mr_n71156384)
print v(xbgr.mr_n71156704)
print v(xbgr.mr_n71156816)
print v(xbgr.mr_n71157136)
print v(xbgr.mr_n71157248)
print v(xbgr.mr_n71157568)
print v(xbgr.mr_n71157680)
print v(xbgr.mr_n71158000)
print v(xbgr.mr_n71158112)
print v(xbgr.mr_n71158432)
print v(xbgr.mr_n71158544)
print v(xbgr.mr_n71158864)
print v(xbgr.mr_n71158976)
print v(xbgr.mr_n71159296)
print v(xbgr.mr_n71159408)
print v(xbgr.mr_n71159728)
print v(xbgr.mr_n71159840)
print v(xbgr.mr_n71160160)
print v(xbgr.mr_n71160272)
print v(xbgr.mr_n71160592)
print v(xbgr.mr_n71160704)
print v(xbgr.mr_n71161024)
print v(xbgr.mr_n71161136)
print v(xbgr.mr_n71161456)
print v(xbgr.mr_n71161568)
print v(xbgr.mr_n71161888)
print v(xbgr.mr_n71162000)
print v(xbgr.mr_n71162320)
print v(xbgr.mr_n71162432)
print v(xbgr.mr_n71162752)
print v(xbgr.mr_n71162864)
print v(xbgr.mr_n71163184)
print v(xbgr.mr_n71163296)
print v(xbgr.mr_n71163616)
print v(xbgr.mr_n71163728)
print v(xbgr.mr_n71164048)
print v(xbgr.mr_n71164160)
print v(xbgr.mr_n71164480)
print v(xbgr.mr_n71164592)
print v(xbgr.mr_n71164912)
print v(xbgr.mr_n71165024)
print v(xbgr.mr_n71165344)
print v(xbgr.mr_n71165456)
print v(xbgr.mr_n71165776)
print v(xbgr.mr_n71165888)
print v(xbgr.mr_n71166208)
print v(xbgr.mr_n71166320)
print v(xbgr.mr_n71166640)
print v(xbgr.mr_n71166752)
print v(xbgr.mr_n71167072)
print v(xbgr.mr_n71167184)
print v(xbgr.mr_n71167504)
print v(xbgr.mr_n71167616)
print v(xbgr.mr_n71167936)
print v(xbgr.mr_n71168048)
print v(xbgr.mr_n71168368)
print v(xbgr.mr_n71168480)
print v(xbgr.mr_n71168800)
print v(xbgr.mr_n71168912)
print v(xbgr.mr_n71169232)
print v(xbgr.mr_n71169344)
print v(xbgr.mr_n71169664)
print v(xbgr.mr_n71169776)
print v(xbgr.mr_n71170096)
print v(xbgr.mr_n71170208)
print v(xbgr.mr_n71170528)
print v(xbgr.mr_n71170640)
print v(xbgr.mr_n71170960)
print v(xbgr.mr_n71171072)
print v(xbgr.mr_n71171392)
print v(xbgr.mr_n71171504)
print v(xbgr.mr_n71171824)
print v(xbgr.mr_n71171936)
print v(xbgr.mr_n71172256)
print v(xbgr.mr_n71172368)
print v(xbgr.mr_n71172688)
print v(xbgr.mr_n71172800)
print v(xbgr.mr_n71173120)
print v(xbgr.mr_n71173232)
print v(xbgr.mr_n71173552)
print v(xbgr.mr_n71173664)
print v(xbgr.mr_n71173984)
print v(xbgr.mr_n71174096)
print v(xbgr.mr_n71174416)
print v(xbgr.mr_n71174528)
print v(xbgr.mr_n71174848)
print v(xbgr.mr_n71174960)
print v(xbgr.mr_n71175280)
print v(xbgr.mr_n71175392)
print v(xbgr.mr_n71175712)
print v(xbgr.mr_n71175824)
print v(xbgr.mr_n71176144)
print v(xbgr.mr_n71176256)
print v(xbgr.mr_n71176576)
print v(xbgr.mr_n71176688)
print v(xbgr.mr_n71177008)
print v(xbgr.mr_n71177120)
print v(xbgr.mr_n71177440)
print v(xbgr.mr_n71177552)
print v(xbgr.mr_n71177872)
print v(xbgr.mr_n71177984)
print v(xbgr.mr_n71178304)
print v(xbgr.mr_n71178416)
print v(xbgr.mr_n71178736)
print v(xbgr.mr_n71178848)
print v(xbgr.mr_n71179168)
print v(xbgr.mr_n71179280)
print v(xbgr.mr_n71179600)
print v(xbgr.mr_n71179712)
print v(xbgr.mr_n71180032)
print v(xbgr.mr_n71180144)
print v(xbgr.mr_n71180464)
print v(xbgr.mr_n71180576)
print v(xbgr.mr_n71180896)
print v(xbgr.mr_n71181008)
print v(xbgr.mr_n71181328)
print v(xbgr.mr_n71181440)
print v(xbgr.mr_n71181760)
print v(xbgr.mr_n71181872)
print v(xbgr.mr_n71182192)
print v(xbgr.mr_n71182304)
print v(xbgr.mr_n71182624)
print v(xbgr.mr_n71182736)
print v(xbgr.mr_n71183056)
print v(xbgr.mr_n71183168)
print v(xbgr.mr_n71183488)
print v(xbgr.mr_n71183600)
print v(xbgr.mr_n71183920)
print v(xbgr.mr_n71184032)
print v(xbgr.mr_n71184352)
print v(xbgr.mr_n71184464)
print v(xbgr.mr_n71184784)
print v(xbgr.mr_n71184896)
print v(xbgr.mr_n71185216)
print v(xbgr.mr_n71185328)
print v(xbgr.mr_n71185648)
print v(xbgr.mr_n71185760)
print v(xbgr.mr_n71186080)
print v(xbgr.mr_n71186192)
print v(xbgr.mr_n71186512)
print v(xbgr.mr_n71186624)
print v(xbgr.mr_n71186944)
print v(xbgr.mr_n71187056)
print v(xbgr.mr_n71187376)
print v(xbgr.mr_n71187488)
print v(xbgr.mr_n71187808)
print v(xbgr.mr_n71187920)
print v(xbgr.mr_n71188240)
print v(xbgr.mr_n71188352)
print v(xbgr.mr_n71188672)
print v(xbgr.mr_n71188784)
print v(xbgr.mr_n71189104)
print v(xbgr.mr_n71189216)
print v(xbgr.mr_n71189536)
print v(xbgr.mr_n71189648)
print v(xbgr.mr_n71189968)
print v(xbgr.mr_n71190080)
print v(xbgr.mr_n71190400)
print v(xbgr.mr_n71190512)
print v(xbgr.mr_n71190832)
print v(xbgr.mr_n71190944)
print v(xbgr.mr_n71191264)
print v(xbgr.mr_n71191376)
print v(xbgr.mr_n71191696)
print v(xbgr.mr_n71191808)
print v(xbgr.mr_n71192128)
print v(xbgr.mr_n71192240)
print v(xbgr.mr_n71192560)
print v(xbgr.mr_n71192672)
print v(xbgr.mr_n71192992)
print v(xbgr.mr_n71193104)
print v(xbgr.mr_n71193424)
print v(xbgr.mr_n71193536)
print v(xbgr.mr_n71193856)
print v(xbgr.mr_n71193968)
print v(xbgr.mr_n71194288)
print v(xbgr.mr_n71194400)
print v(xbgr.mr_n71194720)
print v(xbgr.mr_n71194832)
print v(xbgr.mr_n71195152)
print v(xbgr.mr_n71195264)
print v(xbgr.mr_n71195584)
print v(xbgr.mr_n71195696)
print v(xbgr.mr_n71196016)
print v(xbgr.mr_n71196128)
print v(xbgr.mr_n71196448)
print v(xbgr.mr_n71196560)
print v(xbgr.mr_n71196880)
print v(xbgr.mr_n71196992)
print v(xbgr.mr_n71197312)
print v(xbgr.mr_n71197424)
print v(xbgr.mr_n71197744)
print v(xbgr.mr_n71197856)
print v(xbgr.mr_n71198176)
print v(xbgr.mr_n71198288)
print v(xbgr.mr_n71198608)
print v(xbgr.mr_n71198720)
print v(xbgr.mr_n71199040)
print v(xbgr.mr_n71199152)
print v(xbgr.mr_n71199472)
print v(xbgr.mr_n71199584)
print v(xbgr.mr_n71199904)
print v(xbgr.mr_n71200016)
print v(xbgr.mr_n71200336)
print v(xbgr.mr_n71200448)
print v(xbgr.mr_n71200768)
print v(xbgr.mr_n71200880)
print v(xbgr.mr_n71201200)
print v(xbgr.mr_n71201312)
print v(xbgr.mr_n71201632)
print v(xbgr.mr_n71201744)
print v(xbgr.mr_n71202064)
print v(xbgr.mr_n71202176)
print v(xbgr.mr_n71202496)
print v(xbgr.mr_n71202608)
print v(xbgr.mr_n71202928)
print v(xbgr.mr_n71203040)
print v(xbgr.mr_n71203360)
print v(xbgr.mr_n71203472)
print v(xbgr.mr_n71203792)
print v(xbgr.mr_n71203904)
print v(xbgr.mr_n71204224)
print v(xbgr.mr_n71204336)
print v(xbgr.mr_n71204656)
print v(xbgr.mr_n71204768)
print v(xbgr.mr_n71205088)
print v(xbgr.mr_n71205200)
print v(xbgr.mr_n71205520)
print v(xbgr.mr_n71205632)
print v(xbgr.mr_n71205952)
print v(xbgr.mr_n71206064)
print v(xbgr.mr_n71206384)
print v(xbgr.mr_n71206496)
print v(xbgr.mr_n71206816)
print v(xbgr.mr_n71206928)
print v(xbgr.mr_n71207248)
print v(xbgr.mr_n71207360)
print v(xbgr.mr_n71207680)
print v(xbgr.mr_n71207792)
print v(xbgr.mr_n71208112)
print v(xbgr.mr_n71208224)
print v(xbgr.mr_n71208544)
print v(xbgr.mr_n71208656)
print v(xbgr.mr_n71208976)
print v(xbgr.mr_n71209088)
print v(xbgr.mr_n71209408)
print v(xbgr.mr_n71209520)
print v(xbgr.mr_n71209840)
print v(xbgr.mr_n71209952)
print v(xbgr.mr_n71210272)
print v(xbgr.mr_n71210384)
print v(xbgr.mr_n71210704)
print v(xbgr.mr_n71210816)
print v(xbgr.mr_n71211136)
print v(xbgr.mr_n71211248)
print v(xbgr.mr_n71211568)
print v(xbgr.mr_n71211680)
print v(xbgr.mr_n71212000)
print v(xbgr.mr_n71212112)
print v(xbgr.mr_n71212432)
print v(xbgr.mr_n71212544)
print v(xbgr.mr_n71212864)
print v(xbgr.mr_n71212976)
print v(xbgr.mr_n71213296)
print v(xbgr.mr_n71213408)
print v(xbgr.mr_n71213728)
print v(xbgr.mr_n71213840)
print v(xbgr.mr_n71214160)
print v(xbgr.mr_n71214272)
print v(xbgr.mr_n71214592)
print v(xbgr.mr_n71214704)
print v(xbgr.mr_n71215024)
print v(xbgr.mr_n71215136)
print v(xbgr.mr_n71215456)
print v(xbgr.mr_n71215568)
print v(xbgr.mr_n71215888)
print v(xbgr.mr_n71216000)
print v(xbgr.mr_n71216320)
print v(xbgr.mr_n71216432)
print v(xbgr.mr_n71216752)
print v(xbgr.mr_n71216864)
print v(xbgr.mr_n71217184)
print v(xbgr.mr_n71217296)
print v(xbgr.mr_n71217616)
print v(xbgr.mr_n71217728)
print v(xbgr.mr_n71218048)
print v(xbgr.mr_n71218160)
print v(xbgr.mr_n71218480)
print v(xbgr.mr_n71218592)
print v(xbgr.mr_n71218912)
print v(xbgr.mr_n71219024)
print v(xbgr.mr_n71219344)
print v(xbgr.mr_n71219456)
print v(xbgr.mr_n71219776)
print v(xbgr.mr_n71219888)
print v(xbgr.mr_n71220208)
print v(xbgr.mr_n71220320)
print v(xbgr.mr_n71220640)
print v(xbgr.mr_n71220752)
print v(xbgr.mr_n71221072)
print v(xbgr.mr_n71221184)
print v(xbgr.mr_n71221504)
print v(xbgr.mr_n71221616)
print v(xbgr.mr_n71221936)
print v(xbgr.mr_n71222048)
print v(xbgr.mr_n71222368)
print v(xbgr.mr_n71222480)
print v(xbgr.mr_n71222800)
print v(xbgr.mr_n71222912)
print v(xbgr.mr_n71223232)
print v(xbgr.mr_n71223344)
print v(xbgr.mr_n71223664)
print v(xbgr.mr_n71223776)
print v(xbgr.mr_n71224096)
print v(xbgr.mr_n71224208)
print v(xbgr.mr_n71224528)
print v(xbgr.mr_n71224640)
print v(xbgr.mr_n71224960)
print v(xbgr.mr_n71225072)
print v(xbgr.mr_n71225392)
print v(xbgr.mr_n71225504)
print v(xbgr.mr_n71225824)
print v(xbgr.mr_n71225936)
print v(xbgr.mr_n71226256)
print v(xbgr.mr_n71226368)
print v(xbgr.mr_n71226688)
print v(xbgr.mr_n71226800)
print v(xbgr.mr_n71227120)
print v(xbgr.mr_n71227232)
print v(xbgr.mr_n71227552)
print v(xbgr.mr_n71227664)
print v(xbgr.mr_n71227984)
print v(xbgr.mr_n71228096)
print v(xbgr.mr_n71228416)
print v(xbgr.mr_n71228528)
print v(xbgr.mr_n71228848)
print v(xbgr.mr_n71228960)
print v(xbgr.mr_n71229280)
print v(xbgr.mr_n71229392)
print v(xbgr.mr_n71229712)
print v(xbgr.mr_n71229824)
print v(xbgr.mr_n71230144)
print v(xbgr.mr_n71230256)
print v(xbgr.mr_n71230576)
print v(xbgr.mr_n71230688)
print v(xbgr.mr_n71231008)
print v(xbgr.mr_n71231120)
print v(xbgr.mr_n71231440)
print v(xbgr.mr_n71231552)
print v(xbgr.mr_n71231872)
print v(xbgr.mr_n71231984)
print v(xbgr.mr_n71232304)
print v(xbgr.mr_n71232416)
print v(xbgr.mr_n71232736)
print v(xbgr.mr_n71232848)
print v(xbgr.mr_n71233168)
print v(xbgr.mr_n71233280)
print v(xbgr.mr_n71233600)
print v(xbgr.mr_n71233712)
print v(xbgr.mr_n71234032)
print v(xbgr.mr_n71234144)
print v(xbgr.mr_n71234464)
print v(xbgr.mr_n71234576)
print v(xbgr.mr_n71234896)
print v(xbgr.mr_n71235008)
print v(xbgr.mr_n71235328)
print v(xbgr.mr_n71235440)
print v(xbgr.mr_n71235760)
print v(xbgr.mr_n71235872)
print v(xbgr.mr_n71236192)
print v(xbgr.mr_n71236304)
print v(xbgr.mr_n71236624)
print v(xbgr.mr_n71236736)
print v(xbgr.mr_n71237056)
print v(xbgr.mr_n71237168)
print v(xbgr.mr_n71237488)
print v(xbgr.mr_n71237600)
print v(xbgr.mr_n71237920)
print v(xbgr.mr_n71238032)
print v(xbgr.mr_n71238352)
print v(xbgr.mr_n71238464)
print v(xbgr.mr_n71238784)
print v(xbgr.mr_n71238896)
print v(xbgr.mr_n71239216)
print v(xbgr.mr_n71239328)
print v(xbgr.mr_n71239648)
print v(xbgr.mr_n71239760)
print v(xbgr.mr_n71240080)
print v(xbgr.mr_n71240192)
print v(xbgr.mr_n71240512)
print v(xbgr.mr_n71240624)
print v(xbgr.mr_n71240944)
print v(xbgr.mr_n71241056)
print v(xbgr.mr_n71241376)
print v(xbgr.mr_n71241488)
print v(xbgr.mr_n71241808)
print v(xbgr.mr_n71241920)
print v(xbgr.mr_n71242240)
print v(xbgr.mr_n71242352)
print v(xbgr.mr_n71242672)
print v(xbgr.mr_n71242784)
print v(xbgr.mr_n71243104)
print v(xbgr.mr_n71243216)
print v(xbgr.mr_n71243536)
print v(xbgr.mr_n71243648)
print v(xbgr.mr_n71243968)
print v(xbgr.mr_n71244080)
print v(xbgr.mr_n71244400)
print v(xbgr.mr_n71244512)
print v(xbgr.mr_n71244832)
print v(xbgr.mr_n71244944)
print v(xbgr.mr_n71245264)
print v(xbgr.mr_n71245376)
print v(xbgr.mr_n71245696)
print v(xbgr.mr_n71245808)
print v(xbgr.mr_n71246128)
print v(xbgr.mr_n71246240)
print v(xbgr.mr_n71246560)
print v(xbgr.mr_n71246672)
print v(xbgr.mr_n71246992)
print v(xbgr.mr_n71247104)
print v(xbgr.mr_n71247424)
print v(xbgr.mr_n71247536)
print v(xbgr.mr_n71247856)
print v(xbgr.mr_n71247968)
print v(xbgr.mr_n71248288)
print v(xbgr.mr_n71248400)
print v(xbgr.mr_n71248720)
print v(xbgr.mr_n71248832)
print v(xbgr.mr_n71249152)
print v(xbgr.mr_n71249264)
print v(xbgr.mr_n71249584)
print v(xbgr.mr_n71249696)
print v(xbgr.mr_n71250016)
print v(xbgr.mr_n71250128)
print v(xbgr.mr_n71250448)
print v(xbgr.mr_n71250560)
print v(xbgr.mr_n71250880)
print v(xbgr.mr_n71250992)
print v(xbgr.mr_n71251312)
print v(xbgr.mr_n71251424)
print v(xbgr.mr_n71251744)
print v(xbgr.mr_n71251856)
print v(xbgr.mr_n71252176)
print v(xbgr.mr_n71252288)
print v(xbgr.mr_n71252608)
print v(xbgr.mr_n71252720)
print v(xbgr.mr_n71253040)
print v(xbgr.mr_n71253152)
print v(xbgr.mr_n71253472)
print v(xbgr.mr_n71253584)
print v(xbgr.mr_n71253904)
print v(xbgr.mr_n71254016)
print v(xbgr.mr_n71254336)
print v(xbgr.mr_n71254448)
print v(xbgr.mr_n71254768)
print v(xbgr.mr_n71254880)
print v(xbgr.mr_n71255200)
print v(xbgr.mr_n71255312)
print v(xbgr.mr_n71255632)
print v(xbgr.mr_n71255744)
print v(xbgr.mr_n71256064)
print v(xbgr.mr_n71256176)
print v(xbgr.mr_n71256496)
print v(xbgr.mr_n71256608)
print v(xbgr.mr_n71256928)
print v(xbgr.mr_n71257040)
print v(xbgr.mr_n71257360)
print v(xbgr.mr_n71257472)
print v(xbgr.mr_n71257792)
print v(xbgr.mr_n71257904)
print v(xbgr.mr_n71258224)
print v(xbgr.mr_n71258336)
print v(xbgr.mr_n71258656)
print v(xbgr.mr_n71258768)
print v(xbgr.mr_n71259088)
print v(xbgr.mr_n71259200)
print v(xbgr.mr_n71259520)
print v(xbgr.mr_n71259632)
print v(xbgr.mr_n71259952)
print v(xbgr.mr_n71260064)
print v(xbgr.mr_n71260384)
print v(xbgr.mr_n71260496)
print v(xbgr.mr_n71260816)
print v(xbgr.mr_n71260928)
print v(xbgr.mr_n71261248)
print v(xbgr.mr_n71261360)
print v(xbgr.mr_n71261680)
print v(xbgr.mr_n71261792)
print v(xbgr.mr_n71262112)
print v(xbgr.mr_n71262224)
print v(xbgr.mr_n71262544)
print v(xbgr.mr_n71262656)
print v(xbgr.mr_n71262976)
print v(xbgr.mr_n71263088)
print v(xbgr.mr_n71263408)
print v(xbgr.mr_n71263520)
print v(xbgr.mr_n71263840)
print v(xbgr.mr_n71263952)
print v(xbgr.mr_n71264272)
print v(xbgr.mr_n71264384)
print v(xbgr.mr_n71264704)
print v(xbgr.mr_n71264816)
print v(xbgr.mr_n71265136)
print v(xbgr.mr_n71265248)
print v(xbgr.mr_n71265568)
print v(xbgr.mr_n71265680)
print v(xbgr.mr_n71266000)
print v(xbgr.mr_n71266112)
print v(xbgr.mr_n71266432)
print v(xbgr.mr_n71266544)
print v(xbgr.mr_n71266864)
print v(xbgr.mr_n71266976)
print v(xbgr.mr_n71267296)
print v(xbgr.mr_n71267408)
print v(xbgr.mr_n71267728)
print v(xbgr.mr_n71267840)
print v(xbgr.mr_n71268160)
print v(xbgr.mr_n71268272)
print v(xbgr.mr_n71268592)
print v(xbgr.mr_n71268704)
print v(xbgr.mr_n71269024)
print v(xbgr.mr_n71269136)
print v(xbgr.mr_n71269456)
print v(xbgr.mr_n71269568)
print v(xbgr.mr_n71269888)
print v(xbgr.mr_n71270000)
print v(xbgr.mr_n71270320)
print v(xbgr.mr_n71270432)
print v(xbgr.mr_n71270752)
print v(xbgr.mr_n71270864)
print v(xbgr.mr_n71271184)
print v(xbgr.mr_n71271296)
print v(xbgr.mr_n71271616)
print v(xbgr.mr_n71271728)
print v(xbgr.mr_n71272048)
print v(xbgr.mr_n71272160)
print v(xbgr.mr_n71272480)
print v(xbgr.mr_n71272592)
print v(xbgr.mr_n71272912)
print v(xbgr.mr_n71273024)
print v(xbgr.mr_n71273344)
print v(xbgr.mr_n71273456)
print v(xbgr.mr_n71273776)
print v(xbgr.mr_n71273888)
print v(xbgr.mr_n71274208)
print v(xbgr.mr_n71274320)
print v(xbgr.mr_n71274640)
print v(xbgr.mr_n71274752)
print v(xbgr.mr_n71275072)
print v(xbgr.mr_n71275184)
print v(xbgr.mr_n71275504)
print v(xbgr.mr_n71275616)
print v(xbgr.mr_n71275936)
print v(xbgr.mr_n71276048)
print v(xbgr.mr_n71276368)
print v(xbgr.mr_n71276480)
print v(xbgr.mr_n71276800)
print v(xbgr.mr_n71276912)
print v(xbgr.mr_n71277232)
print v(xbgr.mr_n71277344)
print v(xbgr.mr_n71277664)
print v(xbgr.mr_n71277776)
print v(xbgr.mr_n71278096)
print v(xbgr.mr_n71278208)
print v(xbgr.mr_n71278528)
print v(xbgr.mr_n71278640)
print v(xbgr.mr_n71278960)
print v(xbgr.mr_n71279072)
print v(xbgr.mr_n71279392)
print v(xbgr.mr_n71279504)
print v(xbgr.mr_n71279824)
print v(xbgr.mr_n71279936)
print v(xbgr.mr_n71280256)
print v(xbgr.mr_n71280368)
print v(xbgr.mr_n71280688)
print v(xbgr.mr_n71280800)
print v(xbgr.mr_n71281120)
print v(xbgr.mr_n71281232)
print v(xbgr.mr_n71281552)
print v(xbgr.mr_n71281664)
print v(xbgr.mr_n71281984)
print v(xbgr.mr_n71282096)
print v(xbgr.mr_n71282416)
print v(xbgr.mr_n71282528)
print v(xbgr.mr_n71282848)
print v(xbgr.mr_n71282960)
print v(xbgr.mr_n71283280)
print v(xbgr.mr_n71283392)
print v(xbgr.mr_n71283712)
print v(xbgr.mr_n71283824)
print v(xbgr.mr_n71284144)
print v(xbgr.mr_n71284256)
print v(xbgr.mr_n71284576)
print v(xbgr.mr_n71284688)
print v(xbgr.mr_n71285008)
print v(xbgr.mr_n71285120)
print v(xbgr.mr_n71285440)
print v(xbgr.mr_n71285552)
print v(xbgr.mr_n71285872)
print v(xbgr.mr_n71285984)
print v(xbgr.mr_n71286304)
print v(xbgr.mr_n71286416)
print v(xbgr.mr_n71286736)
print v(xbgr.mr_n71286848)
print v(xbgr.mr_n71287168)
print v(xbgr.mr_n71287280)
print v(xbgr.mr_n71287600)
print v(xbgr.mr_n71287712)
print v(xbgr.mr_n71288032)
print v(xbgr.mr_n71288144)
print v(xbgr.mr_n71288464)
print v(xbgr.mr_n71288576)
print v(xbgr.mr_n71288896)
print v(xbgr.mr_n71289008)
print v(xbgr.mr_n71289328)
print v(xbgr.mr_n71289440)
print v(xbgr.mr_n71289760)
print v(xbgr.mr_n71289872)
print v(xbgr.mr_n71290192)
print v(xbgr.mr_n71290304)
print v(xbgr.mr_n71290624)
print v(xbgr.mr_n71290736)
print v(xbgr.mr_n71291056)
print v(xbgr.mr_n71291168)
print v(xbgr.mr_n71291488)
print v(xbgr.mr_n71291600)
print v(xbgr.mr_n71291920)
print v(xbgr.mr_n71292032)
print v(xbgr.mr_n71292352)
print v(xbgr.mr_n71292464)
print v(xbgr.mr_n71292784)
print v(xbgr.mr_n71292896)
print v(xbgr.mr_n71293216)
print v(xbgr.mr_n71293328)
print v(xbgr.mr_n71293648)
print v(xbgr.mr_n71293760)
print v(xbgr.mr_n71294080)
print v(xbgr.mr_n71294192)
print v(xbgr.mr_n71294512)
print v(xbgr.mr_n71294624)
print v(xbgr.mr_n71294944)
print v(xbgr.mr_n71295056)
print v(xbgr.mr_n71295376)
print v(xbgr.mr_n71295488)
print v(xbgr.mr_n71295808)
print v(xbgr.mr_n71295920)
print v(xbgr.mr_n71296240)
print v(xbgr.mr_n71296352)
print v(xbgr.mr_n71296672)
print v(xbgr.mr_n71296784)
print v(xbgr.mr_n71297104)
print v(xbgr.mr_n71297216)
print v(xbgr.mr_n71297536)
print v(xbgr.mr_n71297648)
print v(xbgr.mr_n71297968)
print v(xbgr.mr_n71298080)
print v(xbgr.mr_n71298400)
print v(xbgr.mr_n71298512)
print v(xbgr.mr_n71298832)
print v(xbgr.mr_n71298944)
print v(xbgr.mr_n71299264)
print v(xbgr.mr_n71299376)
print v(xbgr.mr_n71299696)
print v(xbgr.mr_n71299808)
print v(xbgr.mr_n71300128)
print v(xbgr.mr_n71300240)
print v(xbgr.mr_n71300560)
print v(xbgr.mr_n71300672)
print v(xbgr.mr_n71300992)
print v(xbgr.mr_n71301104)
print v(xbgr.mr_n71301424)
print v(xbgr.mr_n71301536)
print v(xbgr.mr_n71301856)
print v(xbgr.mr_n71301968)
print v(xbgr.mr_n71302288)
print v(xbgr.mr_n71302400)
print v(xbgr.mr_n71302720)
print v(xbgr.mr_n71302832)
print v(xbgr.mr_n71303152)
print v(xbgr.mr_n71303264)
print v(xbgr.mr_n71303584)
print v(xbgr.mr_n71303696)
print v(xbgr.mr_n71304016)
print v(xbgr.mr_n71304128)
print v(xbgr.mr_n71304448)
print v(xbgr.mr_n71304560)
print v(xbgr.mr_n71304880)
print v(xbgr.mr_n71304992)
print v(xbgr.mr_n71305312)
print v(xbgr.mr_n71305424)
print v(xbgr.mr_n71305744)
print v(xbgr.mr_n71305856)
print v(xbgr.mr_n71306176)
print v(xbgr.mr_n71306288)
print v(xbgr.mr_n71306608)
print v(xbgr.mr_n71306720)
print v(xbgr.mr_n71307040)
print v(xbgr.mr_n71307152)
print v(xbgr.mr_n71307472)
print v(xbgr.mr_n71307584)
print v(xbgr.mr_n71307904)
print v(xbgr.mr_n71308016)
print v(xbgr.mr_n71308336)
print v(xbgr.mr_n71308448)
print v(xbgr.mr_n71308768)
print v(xbgr.mr_n71308880)
print v(xbgr.mr_n71309200)
print v(xbgr.mr_n71309312)
print v(xbgr.mr_n71309632)
print v(xbgr.mr_n71309744)
print v(xbgr.mr_n71310064)
print v(xbgr.mr_n71310176)
print v(xbgr.mr_n71310496)
print v(xbgr.mr_n71310608)
print v(xbgr.mr_n71310928)
print v(xbgr.mr_n71311040)
print v(xbgr.mr_n71311360)
print v(xbgr.mr_n71311472)
print v(xbgr.mr_n71311792)
print v(xbgr.mr_n71311904)
print v(xbgr.mr_n71312224)
print v(xbgr.mr_n71312336)
print v(xbgr.mr_n71312656)
print v(xbgr.mr_n71312768)
print v(xbgr.mr_n71313088)
print v(xbgr.mr_n71313200)
print v(xbgr.mr_n71313520)
print v(xbgr.mr_n71313632)
print v(xbgr.mr_n71313952)
print v(xbgr.mr_n71314064)
print v(xbgr.mr_n71314384)
print v(xbgr.mr_n71314496)
print v(xbgr.mr_n71314816)
print v(xbgr.mr_n71314928)
print v(xbgr.mr_n71315248)
print v(xbgr.mr_n71315360)
print v(xbgr.mr_n71315680)
print v(xbgr.mr_n71315792)
print v(xbgr.mr_n71316112)
print v(xbgr.mr_n71316224)
print v(xbgr.mr_n71316544)
print v(xbgr.mr_n71316656)
print v(xbgr.mr_n71316976)
print v(xbgr.mr_n71317088)
print v(xbgr.mr_n71317408)
print v(xbgr.mr_n71317520)
print v(xbgr.mr_n71317840)
print v(xbgr.mr_n71317952)
print v(xbgr.mr_n71318272)
print v(xbgr.mr_n71318384)
print v(xbgr.mr_n71318704)
print v(xbgr.mr_n71318816)
print v(xbgr.mr_n71319136)
print v(xbgr.mr_n71319248)
print v(xbgr.mr_n71319568)
print v(xbgr.mr_n71319680)
print v(xbgr.mr_n71320000)
print v(xbgr.mr_n71320112)
print v(xbgr.mr_n71320432)
print v(xbgr.mr_n71320544)
print v(xbgr.mr_n71320864)
print v(xbgr.mr_n71320976)
print v(xbgr.mr_n71321296)
print v(xbgr.mr_n71321408)
print v(xbgr.mr_n71321728)
print v(xbgr.mr_n71321840)
print v(xbgr.mr_n71322160)
print v(xbgr.mr_n71322272)
print v(xbgr.mr_n71322592)
print v(xbgr.mr_n71322704)
print v(xbgr.mr_n71323024)
print v(xbgr.mr_n71323136)
print v(xbgr.mr_n71323456)
print v(xbgr.mr_n71323568)
print v(xbgr.mr_n71323888)
print v(xbgr.mr_n71324000)
print v(xbgr.mr_n71324320)
print v(xbgr.mr_n71324432)
print v(xbgr.mr_n71324752)
print v(xbgr.mr_n71324864)
print v(xbgr.mr_n71325184)
print v(xbgr.mr_n71325296)
print v(xbgr.mr_n71325616)
print v(xbgr.mr_n71325728)
print v(xbgr.mr_n71326048)
print v(xbgr.mr_n71326160)
print v(xbgr.mr_n71326480)
print v(xbgr.mr_n71326592)
print v(xbgr.mr_n71326912)
print v(xbgr.mr_n71327024)
print v(xbgr.mr_n71327344)
print v(xbgr.mr_n71327456)
print v(xbgr.mr_n71327776)
print v(xbgr.mr_n71327888)
print v(xbgr.mr_n71328208)
print v(xbgr.mr_n71328320)
print v(xbgr.mr_n71328640)
print v(xbgr.mr_n71328752)
print v(xbgr.mr_n71329072)
print v(xbgr.mr_n71329184)
print v(xbgr.mr_n71329504)
print v(xbgr.mr_n71329616)
print v(xbgr.mr_n71329936)
print v(xbgr.mr_n71330048)
print v(xbgr.mr_n71330368)
print v(xbgr.mr_n71330480)
print v(xbgr.mr_n71330800)
print v(xbgr.mr_n71330912)
print v(xbgr.mr_n71331232)
print v(xbgr.mr_n71331344)
print v(xbgr.mr_n71331664)
print v(xbgr.mr_n71331776)
print v(xbgr.mr_n71332096)
print v(xbgr.mr_n71332208)
print v(xbgr.mr_n71332528)
print v(xbgr.mr_n71332640)
print v(xbgr.mr_n71332960)
print v(xbgr.mr_n71333072)
print v(xbgr.mr_n71333392)
print v(xbgr.mr_n71333504)
print v(xbgr.mr_n71333824)
print v(xbgr.mr_n71333936)
print v(xbgr.mr_n71334256)
print v(xbgr.mr_n71334368)
print v(xbgr.mr_n71334688)
print v(xbgr.mr_n71334800)
print v(xbgr.mr_n71335120)
print v(xbgr.mr_n71335232)
print v(xbgr.mr_n71335552)
print v(xbgr.mr_n71335664)
print v(xbgr.mr_n71335984)
print v(xbgr.mr_n71336096)
print v(xbgr.mr_n71336416)
print v(xbgr.mr_n71336528)
print v(xbgr.mr_n71336848)
print v(xbgr.mr_n71336960)
print v(xbgr.mr_n71337280)
print v(xbgr.mr_n71337392)
print v(xbgr.mr_n71337712)
print v(xbgr.mr_n71337824)
print v(xbgr.mr_n71338144)
print v(xbgr.mr_n71338256)
print v(xbgr.mr_n71338576)
print v(xbgr.mr_n71338688)
print v(xbgr.mr_n71339008)
print v(xbgr.mr_n71339120)
print v(xbgr.mr_n71339440)
print v(xbgr.mr_n71339552)
print v(xbgr.mr_n71339872)
print v(xbgr.mr_n71339984)
print v(xbgr.mr_n71340304)
print v(xbgr.mr_n71340416)
print v(xbgr.mr_n71340736)
print v(xbgr.mr_n71340848)
print v(xbgr.mr_n71341168)
print v(xbgr.mr_n71341280)
print v(xbgr.mr_n71341600)
print v(xbgr.mr_n71341712)
print v(xbgr.mr_n71342032)
print v(xbgr.mr_n71342144)
print v(xbgr.mr_n71342464)
print v(xbgr.mr_n71342576)
print v(xbgr.mr_n71342896)
print v(xbgr.mr_n71343008)
print v(xbgr.mr_n71343328)
print v(xbgr.mr_n71343440)
print v(xbgr.mr_n71343760)
print v(xbgr.mr_n71343872)
print v(xbgr.mr_n71344192)
print v(xbgr.mr_n71344304)
print v(xbgr.mr_n71344624)
print v(xbgr.mr_n71344736)
print v(xbgr.mr_n71345056)
print v(xbgr.mr_n71345168)
print v(xbgr.mr_n71345488)
print v(xbgr.mr_n71345600)
print v(xbgr.mr_n71345920)
print v(xbgr.mr_n71346032)
print v(xbgr.mr_n71346352)
print v(xbgr.mr_n71346464)
print v(xbgr.mr_n71346784)
print v(xbgr.mr_n71346896)
print v(xbgr.mr_n71347216)
print v(xbgr.mr_n71347328)
print v(xbgr.mr_n71347648)
print v(xbgr.mr_n71347760)
print v(xbgr.mr_n71348080)
print v(xbgr.mr_n71348192)
print v(xbgr.mr_n71348512)
print v(xbgr.mr_n71348624)
print v(xbgr.mr_n71348944)
print v(xbgr.mr_n71349056)
print v(xbgr.mr_n71349376)
print v(xbgr.mr_n71349488)
print v(xbgr.mr_n71349808)
print v(xbgr.mr_n71349920)
print v(xbgr.mr_n71350240)
print v(xbgr.mr_n71350352)
print v(xbgr.mr_n71350672)
print v(xbgr.mr_n71350784)
print v(xbgr.mr_n71351104)
print v(xbgr.mr_n71351216)
print v(xbgr.mr_n71351536)
print v(xbgr.mr_n71351648)
print v(xbgr.mr_n71351968)
print v(xbgr.mr_n71352080)
print v(xbgr.mr_n71352400)
print v(xbgr.mr_n71352512)
print v(xbgr.mr_n71352832)
print v(xbgr.mr_n71352944)
print v(xbgr.mr_n71353264)
print v(xbgr.mr_n71353376)
print v(xbgr.mr_n71353696)
print v(xbgr.mr_n71353808)
print v(xbgr.mr_n71354128)
print v(xbgr.mr_n71354240)
print v(xbgr.mr_n71354560)
print v(xbgr.mr_n71354672)
print v(xbgr.mr_n71354992)
print v(xbgr.mr_n71355104)
print v(xbgr.mr_n71355424)
print v(xbgr.mr_n71355536)
print v(xbgr.mr_n71355856)
print v(xbgr.mr_n71355968)
print v(xbgr.mr_n71356288)
print v(xbgr.mr_n71356400)
print v(xbgr.mr_n71356720)
print v(xbgr.mr_n71356832)
print v(xbgr.mr_n71357152)
print v(xbgr.mr_n71357264)
print v(xbgr.mr_n71357584)
print v(xbgr.mr_n71357696)
print v(xbgr.mr_n71358016)
print v(xbgr.mr_n71358128)
print v(xbgr.mr_n71358448)
print v(xbgr.mr_n71358560)
print v(xbgr.mr_n71358880)
print v(xbgr.mr_n71358992)
print v(xbgr.mr_n71359312)
print v(xbgr.mr_n71359424)
print v(xbgr.mr_n71359744)
print v(xbgr.mr_n71359856)
print v(xbgr.mr_n71360176)
print v(xbgr.mr_n71360288)
print v(xbgr.mr_n71360608)
print v(xbgr.mr_n71360720)
print v(xbgr.mr_n71361040)
print v(xbgr.mr_n71361152)
print v(xbgr.mr_n71361472)
print v(xbgr.mr_n71361584)
print v(xbgr.mr_n71361904)
print v(xbgr.mr_n71362016)
print v(xbgr.mr_n71362336)
print v(xbgr.mr_n71362448)
print v(xbgr.mr_n71362768)
print v(xbgr.mr_n71362880)
print v(xbgr.mr_n71363200)
print v(xbgr.mr_n71363312)
print v(xbgr.mr_n71363632)
print v(xbgr.mr_n71363744)
print v(xbgr.mr_n71364064)
print v(xbgr.mr_n71364176)
print v(xbgr.mr_n71364496)
print v(xbgr.mr_n71364608)
print v(xbgr.mr_n71364928)
print v(xbgr.mr_n71365040)
print v(xbgr.mr_n71365360)
print v(xbgr.mr_n71365472)
print v(xbgr.mr_n71365792)
print v(xbgr.mr_n71365904)
print v(xbgr.mr_n71366224)
print v(xbgr.mr_n71366336)
print v(xbgr.mr_n71366656)
print v(xbgr.mr_n71366768)
print v(xbgr.mr_n71367088)
print v(xbgr.mr_n71367200)
print v(xbgr.mr_n71367520)
print v(xbgr.mr_n71367632)
print v(xbgr.mr_n71367952)
print v(xbgr.mr_n71368064)
print v(xbgr.mr_n71368384)
print v(xbgr.mr_n71368496)
print v(xbgr.mr_n71368816)
print v(xbgr.mr_n71368928)
print v(xbgr.mr_n71369248)
print v(xbgr.mr_n71369360)
print v(xbgr.mr_n71369680)
print v(xbgr.mr_n71369792)
print v(xbgr.mr_n71370112)
print v(xbgr.mr_n71370224)
print v(xbgr.mr_n71370544)
print v(xbgr.mr_n71370656)
print v(xbgr.mr_n71370976)
print v(xbgr.mr_n71371088)
print v(xbgr.mr_n71371408)
print v(xbgr.mr_n71371520)
print v(xbgr.mr_n71371840)
print v(xbgr.mr_n71371952)
print v(xbgr.mr_n71372272)
print v(xbgr.mr_n71372384)
print v(xbgr.mr_n71372704)
print v(xbgr.mr_n71372816)
print v(xbgr.mr_n71373136)
print v(xbgr.mr_n71373248)
print v(xbgr.mr_n71373568)
print v(xbgr.mr_n71373680)
print v(xbgr.mr_n71374000)
print v(xbgr.mr_n71374112)
print v(xbgr.mr_n71374432)
print v(xbgr.mr_n71374544)
print v(xbgr.mr_n71374864)
print v(xbgr.mr_n71374976)
print v(xbgr.mr_n71375296)
print v(xbgr.mr_n71375408)
print v(xbgr.mr_n71375728)
print v(xbgr.mr_n71375840)
print v(xbgr.mr_n71376160)
print v(xbgr.mr_n71376272)
print v(xbgr.mr_n71376592)
print v(xbgr.mr_n71376704)
print v(xbgr.mr_n71377024)
print v(xbgr.mr_n71377136)
print v(xbgr.mr_n71377456)
print v(xbgr.mr_n71377568)
print v(xbgr.mr_n71377888)
print v(xbgr.mr_n71378000)
print v(xbgr.mr_n71378320)
print v(xbgr.mr_n71378432)
print v(xbgr.mr_n71378752)
print v(xbgr.mr_n71378864)
print v(xbgr.mr_n71379184)
print v(xbgr.mr_n71379296)
print v(xbgr.mr_n71379616)
print v(xbgr.mr_n71379728)
print v(xbgr.mr_n71380048)
print v(xbgr.mr_n71380160)
print v(xbgr.mr_n71380480)
print v(xbgr.mr_n71380592)
print v(xbgr.mr_n71380912)
print v(xbgr.mr_n71381024)
print v(xbgr.mr_n71381344)
print v(xbgr.mr_n71381456)
print v(xbgr.mr_n71381888)
print v(xbgr.mr_n71382208)
print v(xbgr.mr_n71382320)
print v(xbgr.mr_n71382640)
print v(xbgr.mr_n71382752)
print v(xbgr.mr_n71383072)
print v(xbgr.mr_n71383184)
print v(xbgr.mr_n71383504)
print v(xbgr.mr_n71383616)
print v(xbgr.mr_n71383936)
print v(xbgr.mr_n71384048)
print v(xbgr.mr_n71384368)
print v(xbgr.mr_n71384480)
print v(xbgr.mr_n71384800)
print v(xbgr.mr_n71384912)
print v(xbgr.mr_n71385232)
print v(xbgr.mr_n71385344)
print v(xbgr.mr_n71385664)
print v(xbgr.mr_n71385776)
print v(xbgr.mr_n71386096)
print v(xbgr.mr_n71386208)
print v(xbgr.mr_n71386528)
print v(xbgr.mr_n71386640)
print v(xbgr.mr_n71386960)
print v(xbgr.mr_n71387072)
print v(xbgr.mr_n71387392)
print v(xbgr.mr_n71387504)
print v(xbgr.mr_n71387936)
print v(xbgr.mr_n71388256)
print v(xbgr.mr_n71388368)
print v(xbgr.mr_n71388688)
print v(xbgr.mr_n71388800)
print v(xbgr.mr_n71389120)
print v(xbgr.mr_n71389232)
print v(xbgr.mr_n71389552)
print v(xbgr.mr_n71389664)
print v(xbgr.mr_n71389984)
print v(xbgr.mr_n71390096)
print v(xbgr.mr_n71390416)
print v(xbgr.mr_n71390528)
print v(xbgr.mr_n71390848)
print v(xbgr.mr_n71390960)
print v(xbgr.mr_n71391280)
print v(xbgr.mr_n71391392)
print v(xbgr.mr_n71391712)
print v(xbgr.mr_n71391824)
print v(xbgr.mr_n71392144)
print v(xbgr.mr_n71392256)
print v(xbgr.mr_n71392576)
print v(xbgr.mr_n71392688)
print v(xbgr.mr_n71393008)
print v(xbgr.mr_n71393120)
print v(xbgr.mr_n71393440)
print v(xbgr.mr_n71393552)
print v(xbgr.mr_n71393872)
print v(xbgr.mr_n71393984)
print v(xbgr.mr_n71394304)
print v(xbgr.mr_n71394416)
print v(xbgr.mr_n71394736)
print v(xbgr.mr_n71394848)
print v(xbgr.mr_n71395168)
print v(xbgr.mr_n71395280)
print v(xbgr.mr_n71395600)
print v(xbgr.mr_n71395712)
print v(xbgr.mr_n71396032)
print v(xbgr.mr_n71396144)
print v(xbgr.mr_n71396464)
print v(xbgr.mr_n71396576)
print v(xbgr.mr_n71396896)
print v(xbgr.mr_n71397008)
print v(xbgr.mr_n71397328)
print v(xbgr.mr_n71397440)
print v(xbgr.mr_n71397760)
print v(xbgr.mr_n71397872)
print v(xbgr.mr_n71398192)
print v(xbgr.mr_n71398304)
print v(xbgr.mr_n71398624)
print v(xbgr.mr_n71398736)
print v(xbgr.mr_n71399056)
print v(xbgr.mr_n71399168)
print v(xbgr.mr_n71399488)
print v(xbgr.mr_n71399600)
print v(xbgr.mr_n71399920)
print v(xbgr.mr_n71400032)
print v(xbgr.mr_n71400352)
print v(xbgr.mr_n71400464)
print v(xbgr.mr_n71400784)
print v(xbgr.mr_n71400896)
print v(xbgr.mr_n71401216)
print v(xbgr.mr_n71401328)
print v(xbgr.mr_n71401648)
print v(xbgr.mr_n71401760)
print v(xbgr.mr_n71402080)
print v(xbgr.mr_n71402192)
print v(xbgr.mr_n71402512)
print v(xbgr.mr_n71402624)
print v(xbgr.mr_n71402944)
print v(xbgr.mr_n71403056)
print v(xbgr.mr_n71403376)
print v(xbgr.mr_n71403488)
print v(xbgr.mr_n71403808)
print v(xbgr.mr_n71403920)
print v(xbgr.mr_n71404240)
print v(xbgr.mr_n71404352)
print v(xbgr.mr_n71404672)
print v(xbgr.mr_n71404784)
print v(xbgr.mr_n71405104)
print v(xbgr.mr_n71405216)
print v(xbgr.mr_n71405536)
print v(xbgr.mr_n71405648)
print v(xbgr.mr_n71405968)
print v(xbgr.mr_n71406080)
print v(xbgr.mr_n71406400)
print v(xbgr.mr_n71406512)
print v(xbgr.mr_n71406832)
print v(xbgr.mr_n71406944)
print v(xbgr.mr_n71407264)
print v(xbgr.mr_n71407376)
print v(xbgr.mr_n71407696)
print v(xbgr.mr_n71407808)
print v(xbgr.mr_n71408128)
print v(xbgr.mr_n71408240)
print v(xbgr.mr_n71408560)
print v(xbgr.mr_n71408672)
print v(xbgr.mr_n71408992)
print v(xbgr.mr_n71409104)
print v(xbgr.mr_n71409424)
print v(xbgr.mr_n71409536)
print v(xbgr.mr_n71409856)
print v(xbgr.mr_n71409968)
print v(xbgr.mr_n71410288)
print v(xbgr.mr_n71410400)
print v(xbgr.mr_n71410720)
print v(xbgr.mr_n71410832)
print v(xbgr.mr_n71411152)
print v(xbgr.mr_n71411264)
print v(xbgr.mr_n71411584)
print v(xbgr.mr_n71411696)
print v(xbgr.mr_n71412016)
print v(xbgr.mr_n71412128)
print v(xbgr.mr_n71412448)
print v(xbgr.mr_n71412560)
print v(xbgr.mr_n71412880)
print v(xbgr.mr_n71412992)
print v(xbgr.mr_n71413312)
print v(xbgr.mr_n71413424)
print v(xbgr.mr_n71413744)
print v(xbgr.mr_n71413856)
print v(xbgr.mr_n71414176)
print v(xbgr.mr_n71414288)
print v(xbgr.mr_n71414608)
print v(xbgr.mr_n71414720)
print v(xbgr.mr_n71415040)
print v(xbgr.mr_n71415152)
print v(xbgr.mr_n71415472)
print v(xbgr.mr_n71415584)
print v(xbgr.mr_n71415904)
print v(xbgr.mr_n71416016)
print v(xbgr.mr_n71416336)
print v(xbgr.mr_n71416448)
print v(xbgr.mr_n71416768)
print v(xbgr.mr_n71416880)
print v(xbgr.mr_n71417200)
print v(xbgr.mr_n71417312)
print v(xbgr.mr_n71417632)
print v(xbgr.mr_n71417744)
print v(xbgr.mr_n71418064)
print v(xbgr.mr_n71418176)
print v(xbgr.mr_n71418496)
print v(xbgr.mr_n71418608)
print v(xbgr.mr_n71418928)
print v(xbgr.mr_n71419040)
print v(xbgr.mr_n71419360)
print v(xbgr.mr_n71419472)
print v(xbgr.mr_n71419792)
print v(xbgr.mr_n71419904)
print v(xbgr.mr_n71420224)
print v(xbgr.mr_n71420336)
print v(xbgr.mr_n71420768)
print v(xbgr.mr_n71421088)
print v(xbgr.mr_n71421200)
print v(xbgr.mr_n71421520)
print v(xbgr.mr_n71421632)
print v(xbgr.mr_n71421952)
print v(xbgr.mr_n71422064)
print v(xbgr.mr_n71422496)
print v(xbgr.mr_n71422816)
print v(xbgr.mr_n71422928)
print v(xbgr.mr_n71423248)
print v(xbgr.mr_n71423360)
print v(xbgr.mr_n71423680)
print v(xbgr.mr_n71423792)
print v(xbgr.mr_n71424224)
print v(xbgr.mr_n71424544)
print v(xbgr.mr_n71424656)
print v(xbgr.mr_n71424976)
print v(xbgr.mr_n71425088)
print v(xbgr.mr_n71425408)
print v(xbgr.mr_n71425520)
print v(xbgr.mr_n71425840)
print v(xbgr.mr_n71425952)
print v(xbgr.mr_n71426272)
print v(xbgr.mr_n71426384)
print v(xbgr.mr_n71426704)
print v(xbgr.mr_n71426816)
print v(xbgr.mr_n71427136)
print v(xbgr.mr_n71427248)
print v(xbgr.mr_n71427568)
print v(xbgr.mr_n71427680)
print v(xbgr.mr_n71428000)
print v(xbgr.mr_n71428112)
print v(xbgr.mr_n71428432)
print v(xbgr.mr_n71428544)
print v(xbgr.mr_n71428864)
print v(xbgr.mr_n71428976)
print v(xbgr.mr_n71429296)
print v(xbgr.mr_n71429408)
print v(xbgr.mr_n71429728)
print v(xbgr.mr_n71429840)
print v(xbgr.mr_n71430160)
print v(xbgr.mr_n71430272)
print v(xbgr.mr_n71430592)
print v(xbgr.mr_n71430704)
print v(xbgr.mr_n71431024)
print v(xbgr.mr_n71431136)
print v(xbgr.mr_n71431456)
print v(xbgr.mr_n71431568)
print v(xbgr.mr_n71431888)
print v(xbgr.mr_n71432000)
print v(xbgr.mr_n71432320)
print v(xbgr.mr_n71432432)
print v(xbgr.mr_n71432752)
print v(xbgr.mr_n71432864)
print v(xbgr.mr_n71433184)
print v(xbgr.mr_n71433296)
print v(xbgr.mr_n71433616)
print v(xbgr.mr_n71433728)
print v(xbgr.mr_n71434048)
print v(xbgr.mr_n71434160)
print v(xbgr.mr_n71434480)
print v(xbgr.mr_n71434592)
print v(xbgr.mr_n71434912)
print v(xbgr.mr_n71435024)
print v(xbgr.mr_n71435344)
print v(xbgr.mr_n71435456)
print v(xbgr.mr_n71435776)
print v(xbgr.mr_n71435888)
print v(xbgr.mr_n71436208)
print v(xbgr.mr_n71436320)
print v(xbgr.mr_n71436640)
print v(xbgr.mr_n71436752)
print v(xbgr.mr_n71437072)
print v(xbgr.mr_n71437184)
print v(xbgr.mr_n71437504)
print v(xbgr.mr_n71437616)
print v(xbgr.mr_n71437936)
print v(xbgr.mr_n71438048)
print v(xbgr.mr_n71438368)
print v(xbgr.mr_n71438480)
print v(xbgr.mr_n71438800)
print v(xbgr.mr_n71438912)
print v(xbgr.mr_n71439232)
print v(xbgr.mr_n71439344)
print v(xbgr.mr_n71439664)
print v(xbgr.mr_n71439776)
print v(xbgr.mr_n71440096)
print v(xbgr.mr_n71440208)
print v(xbgr.mr_n71440528)
print v(xbgr.mr_n71440640)
print v(xbgr.mr_n71440960)
print v(xbgr.mr_n71441072)
print v(xbgr.mr_n71441392)
print v(xbgr.mr_n71441504)
print v(xbgr.mr_n71441824)
print v(xbgr.mr_n71441936)
print v(xbgr.mr_n71442256)
print v(xbgr.mr_n71442368)
print v(xbgr.mr_n71442688)
print v(xbgr.mr_n71442800)
print v(xbgr.mr_n71443120)
print v(xbgr.mr_n71443232)
print v(xbgr.mr_n71443552)
print v(xbgr.mr_n71443664)
print v(xbgr.mr_n71443984)
print v(xbgr.mr_n71444096)
print v(xbgr.mr_n71444528)
print v(xbgr.mr_n71444960)
print v(xbgr.mr_n71445392)
print v(xbgr.mr_n71445824)
print v(xbgr.mr_n71446256)
print v(xbgr.mr_n71446688)
print v(xbgr.mr_n71447120)
print v(xbgr.mr_n71447552)
print v(xbgr.mr_n71447984)
print v(xbgr.mr_n71448416)
print v(xbgr.mr_n71448848)
print v(xbgr.mr_n71449280)
print v(xbgr.mr_n71449712)
print v(xbgr.mr_n71450144)
print v(xbgr.mr_n71450576)
print v(xbgr.mr_n71451008)
print v(xbgr.mr_n71451440)
print v(xbgr.mr_n71451872)
print v(xbgr.mr_n71452304)
print v(xbgr.mr_n71452736)
print v(xbgr.mr_n71453168)
print v(xbgr.mr_n71453600)
print v(xbgr.mr_n71454032)
print v(xbgr.mr_n71454464)
print v(xbgr.mr_n71454896)
print v(xbgr.mr_n71455328)
print v(xbgr.mr_n71455760)
print v(xbgr.mr_n71456192)
print v(xbgr.mr_n71456624)
print v(xbgr.mr_n71457056)
print v(xbgr.mr_n71457488)
print v(xbgr.mr_n71457920)
print v(xbgr.mr_n71458352)
print v(xbgr.mr_n71458784)
print v(xbgr.mr_n71459216)
print v(xbgr.mr_n71459648)
print v(xbgr.mr_n71460080)
print v(xbgr.mr_n71460512)
print v(xbgr.mr_n71460944)
print v(xbgr.mr_n71461376)
print v(xbgr.mr_n71461808)
print v(xbgr.mr_n71462240)
print v(xbgr.mr_n71462672)
print v(xbgr.mr_n71463104)
print v(xbgr.mr_n71463536)
print v(xbgr.mr_n71463968)
print v(xbgr.mr_n71464400)
print v(xbgr.mr_n71464832)
print v(xbgr.mr_n71465264)
print v(xbgr.mr_n71465696)
print v(xbgr.mr_n71466128)
print v(xbgr.mr_n71466560)
print v(xbgr.mr_n71466992)
print v(xbgr.mr_n71467424)
print v(xbgr.mr_n71467856)
print v(xbgr.mr_n71468288)
print v(xbgr.mr_n71468720)
print v(xbgr.mr_n71469152)
print v(xbgr.mr_n71469584)
print v(xbgr.mr_n71470016)
print v(xbgr.mr_n71470448)
print v(xbgr.mr_n71470880)
print v(xbgr.mr_n71471312)
print v(xbgr.mr_n71471744)
print v(xbgr.mr_n71472176)
print v(xbgr.mr_n71472608)
print v(xbgr.mr_n71473040)
print v(xbgr.mr_n71473472)
print v(xbgr.mr_n71473904)
print v(xbgr.mr_n71474336)
print v(xbgr.mr_n71474768)
print v(xbgr.mr_n71475200)
print v(xbgr.mr_n71475632)
print v(xbgr.mr_n71476064)
print v(xbgr.mr_n71476496)
print v(xbgr.mr_n71476928)
print v(xbgr.mr_n71477360)
print v(xbgr.mr_n71477792)
print v(xbgr.mr_n71478224)
print v(xbgr.mr_n71478656)
print v(xbgr.mr_n71478976)
print v(xbgr.mr_n71479088)
print v(xbgr.mr_n71479520)
print v(xbgr.mr_n71479840)
print v(xbgr.mr_n71479952)
print v(xbgr.mr_n71480272)
print v(xbgr.mr_n71480384)
print v(xbgr.mr_n71480704)
print v(xbgr.mr_n71480816)
print v(xbgr.mr_n71481136)
print v(xbgr.mr_n71481248)
print v(xbgr.mr_n71481568)
print v(xbgr.mr_n71481680)
print v(xbgr.mr_n71482000)
print v(xbgr.mr_n71482112)
print v(xbgr.mr_n71482432)
print v(xbgr.mr_n71482544)
print v(xbgr.mr_n71482864)
print v(xbgr.mr_n71482976)
print v(xbgr.mr_n71483296)
print v(xbgr.mr_n71483408)
print v(xbgr.mr_n71483728)
print v(xbgr.mr_n71483840)
print v(xbgr.mr_n71484272)
print v(xbgr.mr_n71484704)
print v(xbgr.mr_n71485136)
print v(xbgr.mr_n71485568)
print v(xbgr.mr_n71486000)
print v(xbgr.mr_n71486432)
print v(xbgr.mr_n71486864)
print v(xbgr.mr_n71487296)
print v(xbgr.mr_n71487728)
print v(xbgr.mr_n71488160)
print v(xbgr.mr_n71488592)
print v(xbgr.mr_n71489024)
print v(xbgr.mr_n71489456)
print v(xbgr.mr_n71489888)
print v(xbgr.mr_n71490320)
print v(xbgr.mr_n71490752)
print v(xbgr.mr_n71491184)
print v(xbgr.mr_n71491616)
print v(xbgr.mr_n71492048)
print v(xbgr.mr_n71492480)
print v(xbgr.mr_n71492912)
print v(xbgr.mr_n71493344)
print v(xbgr.mr_n71493776)
print v(xbgr.mr_n71494208)
print v(xbgr.mr_n71494640)
print v(xbgr.mr_n71495072)
print v(xbgr.mr_n71495504)
print v(xbgr.mr_n71495776)
print v(xbgr.mr_n71495888)
print v(xbgr.mr_n71496208)
print v(xbgr.mr_n71496320)
print v(xbgr.mr_n71496640)
print v(xbgr.mr_n71496752)
print v(xbgr.mr_n71497072)
print v(xbgr.mr_n71497184)
print v(xbgr.mr_n71497504)
print v(xbgr.mr_n71497616)
print v(xbgr.mr_n71497936)
print v(xbgr.mr_n71498048)
print v(xbgr.mr_n71498368)
print v(xbgr.mr_n71498480)
print v(xbgr.mr_n71498800)
print v(xbgr.mr_n71498912)
print v(xbgr.mr_n71499232)
print v(xbgr.mr_n71499344)
print v(xbgr.mr_n71499664)
print v(xbgr.mr_n71499776)
print v(xbgr.mr_n71500096)
print v(xbgr.mr_n71500208)
print v(xbgr.mr_n71500528)
print v(xbgr.mr_n71500640)
print v(xbgr.mr_n71500960)
print v(xbgr.mr_n71501072)
print v(xbgr.mr_n71501392)
print v(xbgr.mr_n71501504)
print v(xbgr.mr_n71501824)
print v(xbgr.mr_n71501936)
print v(xbgr.mr_n71502256)
print v(xbgr.mr_n71502368)
print v(xbgr.mr_n71502688)
print v(xbgr.mr_n71502800)
print v(xbgr.mr_n71503120)
print v(xbgr.mr_n71503232)
print v(xbgr.mr_n71503552)
print v(xbgr.mr_n71503664)
print v(xbgr.mr_n71503984)
print v(xbgr.mr_n71504096)
print v(xbgr.mr_n71504416)
print v(xbgr.mr_n71504528)
print v(xbgr.mr_n71504848)
print v(xbgr.mr_n71504960)
print v(xbgr.mr_n71505280)
print v(xbgr.mr_n71505392)
print v(xbgr.mr_n71505712)
print v(xbgr.mr_n71505824)
print v(xbgr.mr_n71506144)
print v(xbgr.mr_n71506256)
print v(xbgr.mr_n71506576)
print v(xbgr.mr_n71506688)
print v(xbgr.mr_n71507008)
print v(xbgr.mr_n71507120)
print v(xbgr.mr_n71507440)
print v(xbgr.mr_n71507552)
print v(xbgr.mr_n71507872)
print v(xbgr.mr_n71507984)
print v(xbgr.mr_n71508304)
print v(xbgr.mr_n71508416)
print v(xbgr.mr_n71508736)
print v(xbgr.mr_n71508848)
print v(xbgr.mr_n71509168)
print v(xbgr.mr_n71509280)
print v(xbgr.mr_n71509600)
print v(xbgr.mr_n71509712)
print v(xbgr.mr_n71510032)
print v(xbgr.mr_n71510144)
print v(xbgr.mr_n71510464)
print v(xbgr.mr_n71510576)
print v(xbgr.mr_n71510896)
print v(xbgr.mr_n71511008)
print v(xbgr.mr_n71511328)
print v(xbgr.mr_n71511440)
print v(xbgr.mr_n71511760)
print v(xbgr.mr_n71511872)
print v(xbgr.mr_n71512192)
print v(xbgr.mr_n71512304)
print v(xbgr.mr_n71512624)
print v(xbgr.mr_n71512736)
print v(xbgr.mr_n71513056)
print v(xbgr.mr_n71513168)
print v(xbgr.mr_n71513488)
print v(xbgr.mr_n71513600)
print v(xbgr.mr_n71513920)
print v(xbgr.mr_n71514032)
print v(xbgr.mr_n71514352)
print v(xbgr.mr_n71514464)
print v(xbgr.mr_n71514784)
print v(xbgr.mr_n71514896)
print v(xbgr.mr_n71515216)
print v(xbgr.mr_n71515328)
print v(xbgr.mr_n71515648)
print v(xbgr.mr_n71515760)
print v(xbgr.mr_n71516080)
print v(xbgr.mr_n71516192)
print v(xbgr.mr_n71516512)
print v(xbgr.mr_n71516624)
print v(xbgr.mr_n71516944)
print v(xbgr.mr_n71517056)
print v(xbgr.mr_n71517376)
print v(xbgr.mr_n71517488)
print v(xbgr.mr_n71517808)
print v(xbgr.mr_n71517920)
print v(xbgr.mr_n71518240)
print v(xbgr.mr_n71518352)
print v(xbgr.mr_n71518672)
print v(xbgr.mr_n71518784)
print v(xbgr.mr_n71519104)
print v(xbgr.mr_n71519216)
print v(xbgr.mr_n71519536)
print v(xbgr.mr_n71519648)
print v(xbgr.mr_n71519968)
print v(xbgr.mr_n71520080)
print v(xbgr.mr_n71520400)
print v(xbgr.mr_n71520512)
print v(xbgr.mr_n71520832)
print v(xbgr.mr_n71520944)
print v(xbgr.mr_n71521264)
print v(xbgr.mr_n71521376)
print v(xbgr.mr_n71521696)
print v(xbgr.mr_n71521808)
print v(xbgr.mr_n71522128)
print v(xbgr.mr_n71522240)
print v(xbgr.mr_n71522560)
print v(xbgr.mr_n71522672)
print v(xbgr.mr_n71522992)
print v(xbgr.mr_n71523104)
print v(xbgr.mr_n71523424)
print v(xbgr.mr_n71523536)
print v(xbgr.mr_n71523856)
print v(xbgr.mr_n71523968)
print v(xbgr.mr_n71524288)
print v(xbgr.mr_n71524400)
print v(xbgr.mr_n71524720)
print v(xbgr.mr_n71524832)
print v(xbgr.mr_n71525152)
print v(xbgr.mr_n71525264)
print v(xbgr.mr_n71525584)
print v(xbgr.mr_n71525696)
print v(xbgr.mr_n71526016)
print v(xbgr.mr_n71526128)
print v(xbgr.mr_n71526448)
print v(xbgr.mr_n71526560)
print v(xbgr.mr_n71526880)
print v(xbgr.mr_n71526992)
print v(xbgr.mr_n71527312)
print v(xbgr.mr_n71527424)
print v(xbgr.mr_n71527744)
print v(xbgr.mr_n71527856)
print v(xbgr.mr_n71528176)
print v(xbgr.mr_n71528288)
print v(xbgr.mr_n71528608)
print v(xbgr.mr_n71528720)
print v(xbgr.mr_n71529040)
print v(xbgr.mr_n71529152)
print v(xbgr.mr_n71529472)
print v(xbgr.mr_n71529584)
print v(xbgr.mr_n71529904)
print v(xbgr.mr_n71530016)
print v(xbgr.mr_n71530336)
print v(xbgr.mr_n71530448)
print v(xbgr.mr_n71530768)
print v(xbgr.mr_n71530880)
print v(xbgr.mr_n71531200)
print v(xbgr.mr_n71531312)
print v(xbgr.mr_n71531632)
print v(xbgr.mr_n71531744)
print v(xbgr.mr_n71532064)
print v(xbgr.mr_n71532176)
print v(xbgr.mr_n71532496)
print v(xbgr.mr_n71532608)
print v(xbgr.mr_n71532928)
print v(xbgr.mr_n71533040)
print v(xbgr.mr_n71533360)
print v(xbgr.mr_n71533472)
print v(xbgr.mr_n71533792)
print v(xbgr.mr_n71533904)
print v(xbgr.mr_n71534224)
print v(xbgr.mr_n71534336)
print v(xbgr.mr_n71534656)
print v(xbgr.mr_n71534768)
print v(xbgr.mr_n71535088)
print v(xbgr.mr_n71535200)
print v(xbgr.mr_n71535520)
print v(xbgr.mr_n71535632)
print v(xbgr.mr_n71535952)
print v(xbgr.mr_n71536064)
print v(xbgr.mr_n71536384)
print v(xbgr.mr_n71536496)
print v(xbgr.mr_n71536816)
print v(xbgr.mr_n71536928)
print v(xbgr.mr_n71537248)
print v(xbgr.mr_n71537360)
print v(xbgr.mr_n71537680)
print v(xbgr.mr_n71537792)
print v(xbgr.mr_n71538112)
print v(xbgr.mr_n71538224)
print v(xbgr.mr_n71538544)
print v(xbgr.mr_n71538656)
print v(xbgr.mr_n71538976)
print v(xbgr.mr_n71539088)
print v(xbgr.mr_n71539408)
print v(xbgr.mr_n71539520)
print v(xbgr.mr_n71539840)
print v(xbgr.mr_n71539952)
print v(xbgr.mr_n71540272)
print v(xbgr.mr_n71540384)
print v(xbgr.mr_n71540704)
print v(xbgr.mr_n71540816)
print v(xbgr.mr_n71541136)
print v(xbgr.mr_n71541248)
print v(xbgr.mr_n71541568)
print v(xbgr.mr_n71541680)
print v(xbgr.mr_n71542000)
print v(xbgr.mr_n71542112)
print v(xbgr.mr_n71542432)
print v(xbgr.mr_n71542544)
print v(xbgr.mr_n71542864)
print v(xbgr.mr_n71542976)
print v(xbgr.mr_n71543296)
print v(xbgr.mr_n71543408)
print v(xbgr.mr_n71543728)
print v(xbgr.mr_n71543840)
print v(xbgr.mr_n71544160)
print v(xbgr.mr_n71544272)
print v(xbgr.mr_n71544592)
print v(xbgr.mr_n71544704)
print v(xbgr.mr_n71545024)
print v(xbgr.mr_n71545136)
print v(xbgr.mr_n71545456)
print v(xbgr.mr_n71545568)
print v(xbgr.mr_n71545888)
print v(xbgr.mr_n71546000)
print v(xbgr.mr_n71546320)
print v(xbgr.mr_n71546432)
print v(xbgr.mr_n71546752)
print v(xbgr.mr_n71546864)
print v(xbgr.mr_n71547184)
print v(xbgr.mr_n71547296)
print v(xbgr.mr_n71547616)
print v(xbgr.mr_n71547728)
print v(xbgr.mr_n71548048)
print v(xbgr.mr_n71548160)
print v(xbgr.mr_n71548480)
print v(xbgr.mr_n71548592)
print v(xbgr.mr_n71548912)
print v(xbgr.mr_n71549024)
print v(xbgr.mr_n71549344)
print v(xbgr.mr_n71549456)
print v(xbgr.mr_n71549776)
print v(xbgr.mr_n71549888)
print v(xbgr.mr_n71550208)
print v(xbgr.mr_n71550320)
print v(xbgr.mr_n71550640)
print v(xbgr.mr_n71550752)
print v(xbgr.mr_n71551072)
print v(xbgr.mr_n71551184)
print v(xbgr.mr_n71551504)
print v(xbgr.mr_n71551616)
print v(xbgr.mr_n71551936)
print v(xbgr.mr_n71552048)
print v(xbgr.mr_n71552368)
print v(xbgr.mr_n71552480)
print v(xbgr.mr_n71552800)
print v(xbgr.mr_n71552912)
print v(xbgr.mr_n71553232)
print v(xbgr.mr_n71553344)
print v(xbgr.mr_n71553664)
print v(xbgr.mr_n71553776)
print v(xbgr.mr_n71554096)
print v(xbgr.mr_n71554208)
print v(xbgr.mr_n71554528)
print v(xbgr.mr_n71554640)
print v(xbgr.mr_n71554960)
print v(xbgr.mr_n71555072)
print v(xbgr.mr_n71555392)
print v(xbgr.mr_n71555504)
print v(xbgr.mr_n71555824)
print v(xbgr.mr_n71555936)
print v(xbgr.mr_n71556256)
print v(xbgr.mr_n71556368)
print v(xbgr.mr_n71556688)
print v(xbgr.mr_n71556800)
print v(xbgr.mr_n71557120)
print v(xbgr.mr_n71557232)
print v(xbgr.mr_n71557552)
print v(xbgr.mr_n71557664)
print v(xbgr.mr_n71557984)
print v(xbgr.mr_n71558096)
print v(xbgr.mr_n71558416)
print v(xbgr.mr_n71558528)
print v(xbgr.mr_n71558848)
print v(xbgr.mr_n71558960)
print v(xbgr.mr_n71559280)
print v(xbgr.mr_n71559392)
print v(xbgr.mr_n71559712)
print v(xbgr.mr_n71559824)
print v(xbgr.mr_n71560144)
print v(xbgr.mr_n71560256)
print v(xbgr.mr_n71560576)
print v(xbgr.mr_n71560688)
print v(xbgr.mr_n71561008)
print v(xbgr.mr_n71561120)
print v(xbgr.mr_n71561440)
print v(xbgr.mr_n71561552)
print v(xbgr.mr_n71561872)
print v(xbgr.mr_n71561984)
print v(xbgr.mr_n71562304)
print v(xbgr.mr_n71562416)
print v(xbgr.mr_n71562736)
print v(xbgr.mr_n71562848)
print v(xbgr.mr_n71563168)
print v(xbgr.mr_n71563280)
print v(xbgr.mr_n71563600)
print v(xbgr.mr_n71563712)
print v(xbgr.mr_n71564032)
print v(xbgr.mr_n71564144)
print v(xbgr.mr_n71564464)
print v(xbgr.mr_n71564576)
print v(xbgr.mr_n71564896)
print v(xbgr.mr_n71565008)
print v(xbgr.mr_n71565328)
print v(xbgr.mr_n71565440)
print v(xbgr.mr_n71565760)
print v(xbgr.mr_n71565872)
print v(xbgr.mr_n71566192)
print v(xbgr.mr_n71566304)
print v(xbgr.mr_n71566624)
print v(xbgr.mr_n71566736)
print v(xbgr.mr_n71567056)
print v(xbgr.mr_n71567168)
print v(xbgr.mr_n71567488)
print v(xbgr.mr_n71567600)
print v(xbgr.mr_n71567920)
print v(xbgr.mr_n71568032)
print v(xbgr.mr_n71568352)
print v(xbgr.mr_n71568464)
print v(xbgr.mr_n71568784)
print v(xbgr.mr_n71568896)
print v(xbgr.mr_n71569216)
print v(xbgr.mr_n71569328)
print v(xbgr.mr_n71569648)
print v(xbgr.mr_n71569760)
print v(xbgr.mr_n71570080)
print v(xbgr.mr_n71570192)
print v(xbgr.mr_n71570512)
print v(xbgr.mr_n71570624)
print v(xbgr.mr_n71570944)
print v(xbgr.mr_n71571056)
print v(xbgr.mr_n71571376)
print v(xbgr.mr_n71571488)
print v(xbgr.mr_n71571808)
print v(xbgr.mr_n71571920)
print v(xbgr.mr_n71572240)
print v(xbgr.mr_n71572352)
print v(xbgr.mr_n71572672)
print v(xbgr.mr_n71572784)
print v(xbgr.mr_n71573104)
print v(xbgr.mr_n71573216)
print v(xbgr.mr_n71573536)
print v(xbgr.mr_n71573648)
print v(xbgr.mr_n71573968)
print v(xbgr.mr_n71574080)
print v(xbgr.mr_n71574400)
print v(xbgr.mr_n71574512)
print v(xbgr.mr_n71574832)
print v(xbgr.mr_n71574944)
print v(xbgr.mr_n71575264)
print v(xbgr.mr_n71575376)
print v(xbgr.mr_n71575696)
print v(xbgr.mr_n71575808)
print v(xbgr.mr_n71576128)
print v(xbgr.mr_n71576240)
print v(xbgr.mr_n71576560)
print v(xbgr.mr_n71576672)
print v(xbgr.mr_n71576992)
print v(xbgr.mr_n71577104)
print v(xbgr.mr_n71577424)
print v(xbgr.mr_n71577536)
print v(xbgr.mr_n71577856)
print v(xbgr.mr_n71577968)
print v(xbgr.mr_n71578288)
print v(xbgr.mr_n71578400)
print v(xbgr.mr_n71578720)
print v(xbgr.mr_n71578832)
print v(xbgr.mr_n71579152)
print v(xbgr.mr_n71579264)
print v(xbgr.mr_n71579584)
print v(xbgr.mr_n71579696)
print v(xbgr.mr_n71580016)
print v(xbgr.mr_n71580128)
print v(xbgr.mr_n71580560)
print v(xbgr.mr_n71580880)
print v(xbgr.mr_n71580992)
print v(xbgr.mr_n71581312)
print v(xbgr.mr_n71581424)
print v(xbgr.mr_n71581744)
print v(xbgr.mr_n71581856)
print v(xbgr.mr_n71582288)
print v(xbgr.mr_n71582608)
print v(xbgr.mr_n71582720)
print v(xbgr.mr_n71583040)
print v(xbgr.mr_n71583152)
print v(xbgr.mr_n71583472)
print v(xbgr.mr_n71583584)
print v(xbgr.mr_n71584016)
print v(xbgr.mr_n71584336)
print v(xbgr.mr_n71584448)
print v(xbgr.mr_n71584768)
print v(xbgr.mr_n71584880)
print v(xbgr.mr_n71585200)
print v(xbgr.mr_n71585312)
print v(xbgr.mr_n71585744)
print v(xbgr.mr_n71586064)
print v(xbgr.mr_n71586176)
print v(xbgr.mr_n71586496)
print v(xbgr.mr_n71586608)
print v(xbgr.mr_n71586928)
print v(xbgr.mr_n71587040)
print v(xbgr.mr_n71587472)
print v(xbgr.mr_n71587792)
print v(xbgr.mr_n71587904)
print v(xbgr.mr_n71588224)
print v(xbgr.mr_n71588336)
print v(xbgr.mr_n71588656)
print v(xbgr.mr_n71588768)
print v(xbgr.mr_n71589200)
print v(xbgr.mr_n71589520)
print v(xbgr.mr_n71589632)
print v(xbgr.mr_n71589952)
print v(xbgr.mr_n71590064)
print v(xbgr.mr_n71590384)
print v(xbgr.mr_n71590496)
print v(xbgr.mr_n71590928)
print v(xbgr.mr_n71591248)
print v(xbgr.mr_n71591360)
print v(xbgr.mr_n71591680)
print v(xbgr.mr_n71591792)
print v(xbgr.mr_n71592112)
print v(xbgr.mr_n71592224)
print v(xbgr.mr_n71592656)
print v(xbgr.mr_n71592976)
print v(xbgr.mr_n71593088)
print v(xbgr.mr_n71593408)
print v(xbgr.mr_n71593520)
print v(xbgr.mr_n71593840)
print v(xbgr.mr_n71593952)
print v(xbgr.mr_n71594272)
print v(xbgr.mr_n71594384)
print v(xbgr.mr_n71594704)
print v(xbgr.mr_n71594816)
print v(xbgr.mr_n71595136)
print v(xbgr.mr_n71595248)
print v(xbgr.mr_n71595568)
print v(xbgr.mr_n71595680)
print v(xbgr.mr_n71596000)
print v(xbgr.mr_n71596112)
print v(xbgr.mr_n71596432)
print v(xbgr.mr_n71596544)
print v(xbgr.mr_n71596864)
print v(xbgr.mr_n71596976)
print v(xbgr.mr_n71597296)
print v(xbgr.mr_n71597408)
print v(xbgr.mr_n71597728)
print v(xbgr.mr_n71597840)
print v(xbgr.mr_n71598160)
print v(xbgr.mr_n71598272)
print v(xbgr.mr_n71598592)
print v(xbgr.mr_n71598704)
print v(xbgr.mr_n71599024)
print v(xbgr.mr_n71599136)
print v(xbgr.mr_n71599456)
print v(xbgr.mr_n71599568)
print v(xbgr.mr_n71599888)
print v(xbgr.mr_n71600000)
print v(xbgr.mr_n71600320)
print v(xbgr.mr_n71600432)
print v(xbgr.mr_n71600752)
print v(xbgr.mr_n71600864)
print v(xbgr.mr_n71601184)
print v(xbgr.mr_n71601296)
print v(xbgr.mr_n71601616)
print v(xbgr.mr_n71601728)
print v(xbgr.mr_n71602048)
print v(xbgr.mr_n71602160)
print v(xbgr.mr_n71602480)
print v(xbgr.mr_n71602592)
print v(xbgr.mr_n71602912)
print v(xbgr.mr_n71603024)
print v(xbgr.mr_n71603344)
print v(xbgr.mr_n71603456)
print v(xbgr.mr_n71603776)
print v(xbgr.mr_n71603888)
print v(xbgr.mr_n71604208)
print v(xbgr.mr_n71604320)
print v(xbgr.mr_n71604640)
print v(xbgr.mr_n71604752)
print v(xbgr.mr_n71605072)
print v(xbgr.mr_n71605184)
print v(xbgr.mr_n71605504)
print v(xbgr.mr_n71605616)
print v(xbgr.mr_n71605936)
print v(xbgr.mr_n71606048)
print v(xbgr.mr_n71606368)
print v(xbgr.mr_n71606480)
print v(xbgr.mr_n71606800)
print v(xbgr.mr_n71606912)
print v(xbgr.mr_n71607232)
print v(xbgr.mr_n71607344)
print v(xbgr.mr_n71607664)
print v(xbgr.mr_n71607776)
print v(xbgr.mr_n71608096)
print v(xbgr.mr_n71608208)
print v(xbgr.mr_n71608528)
print v(xbgr.mr_n71608640)
print v(xbgr.mr_n71608960)
print v(xbgr.mr_n71609072)
print v(xbgr.mr_n71609392)
print v(xbgr.mr_n71609504)
print v(xbgr.mr_n71609824)
print v(xbgr.mr_n71609936)
print v(xbgr.mr_n71610256)
print v(xbgr.mr_n71610368)
print v(xbgr.mr_n71610688)
print v(xbgr.mr_n71610800)
print v(xbgr.mr_n71611120)
print v(xbgr.mr_n71611232)
print v(xbgr.mr_n71611552)
print v(xbgr.mr_n71611664)
print v(xbgr.mr_n71611984)
print v(xbgr.mr_n71612096)
print v(xbgr.mr_n71612416)
print v(xbgr.mr_n71612528)
print v(xbgr.mr_n71612848)
print v(xbgr.mr_n71612960)
print v(xbgr.mr_n71613280)
print v(xbgr.mr_n71613392)
print v(xbgr.mr_n71613712)
print v(xbgr.mr_n71613824)
print v(xbgr.mr_n71614144)
print v(xbgr.mr_n71614256)
print v(xbgr.mr_n71614576)
print v(xbgr.mr_n71614688)
print v(xbgr.mr_n71615008)
print v(xbgr.mr_n71615120)
print v(xbgr.mr_n71615440)
print v(xbgr.mr_n71615552)
print v(xbgr.mr_n71615872)
print v(xbgr.mr_n71615984)
print v(xbgr.mr_n71616304)
print v(xbgr.mr_n71616416)
print v(xbgr.mr_n71616736)
print v(xbgr.mr_n71616848)
print v(xbgr.mr_n71617168)
print v(xbgr.mr_n71617280)
print v(xbgr.mr_n71617600)
print v(xbgr.mr_n71617712)
print v(xbgr.mr_n71618032)
print v(xbgr.mr_n71618144)
print v(xbgr.mr_n71618464)
print v(xbgr.mr_n71618576)
print v(xbgr.mr_n71618896)
print v(xbgr.mr_n71619008)
print v(xbgr.mr_n71619328)
print v(xbgr.mr_n71619440)
print v(xbgr.mr_n71619760)
print v(xbgr.mr_n71619872)
print v(xbgr.mr_n71620192)
print v(xbgr.mr_n71620304)
print v(xbgr.mr_n71620624)
print v(xbgr.mr_n71620736)
print v(xbgr.mr_n71621056)
print v(xbgr.mr_n71621168)
print v(xbgr.mr_n71621488)
print v(xbgr.mr_n71621600)
print v(xbgr.mr_n71621920)
print v(xbgr.mr_n71622032)
print v(xbgr.mr_n71622352)
print v(xbgr.mr_n71622464)
print v(xbgr.mr_n71622896)
print v(xbgr.mr_n71623216)
print v(xbgr.mr_n71623328)
print v(xbgr.mr_n71623648)
print v(xbgr.mr_n71623760)
print v(xbgr.mr_n71624080)
print v(xbgr.mr_n71624192)
print v(xbgr.mr_n71624624)
print v(xbgr.mr_n71624944)
print v(xbgr.mr_n71625056)
print v(xbgr.mr_n71625376)
print v(xbgr.mr_n71625488)
print v(xbgr.mr_n71625808)
print v(xbgr.mr_n71625920)
print v(xbgr.mr_n71626352)
print v(xbgr.mr_n71626672)
print v(xbgr.mr_n71626784)
print v(xbgr.mr_n71627104)
print v(xbgr.mr_n71627216)
print v(xbgr.mr_n71627536)
print v(xbgr.mr_n71627648)
print v(xbgr.mr_n71627968)
print v(xbgr.mr_n71628080)
print v(xbgr.mr_n71628400)
print v(xbgr.mr_n71628512)
print v(xbgr.mr_n71628832)
print v(xbgr.mr_n71628944)
print v(xbgr.mr_n71629264)
print v(xbgr.mr_n71629376)
print v(xbgr.mr_n71629696)
print v(xbgr.mr_n71629808)
print v(xbgr.mr_n71630128)
print v(xbgr.mr_n71630240)
print v(xbgr.mr_n71630672)
print v(xbgr.mr_n71630992)
print v(xbgr.mr_n71631104)
print v(xbgr.mr_n71631536)
print v(xbgr.mr_n71631856)
print v(xbgr.mr_n71631968)
print v(xbgr.mr_n71632400)
print v(xbgr.mr_n71632720)
print v(xbgr.mr_n71632832)
print v(xbgr.mr_n71633152)
print v(xbgr.mr_n71633264)
print v(xbgr.mr_n71633584)
print v(xbgr.mr_n71633696)
print v(xbgr.mr_n71634128)
print v(xbgr.mr_n71634448)
print v(xbgr.mr_n71634560)
print v(xbgr.mr_n71634880)
print v(xbgr.mr_n71634992)
print v(xbgr.mr_n71635312)
print v(xbgr.mr_n71635424)
print v(xbgr.mr_n71635744)
print v(xbgr.mr_n71635856)
print v(xbgr.mr_n71636176)
print v(xbgr.mr_n71636288)
print v(xbgr.mr_n71636720)
print v(xbgr.mr_n71637040)
print v(xbgr.mr_n71637152)
print v(xbgr.mr_n71637472)
print v(xbgr.mr_n71637584)
print v(xbgr.mr_n71637904)
print v(xbgr.mr_n71638016)
print v(xbgr.mr_n71638336)
print v(xbgr.mr_n71638448)
print v(xbgr.mr_n71638768)
print v(xbgr.mr_n71638880)
print v(xbgr.mr_n71639200)
print v(xbgr.mr_n71639312)
print v(xbgr.mr_n71639632)
print v(xbgr.mr_n71639744)
print v(xbgr.mr_n71640064)
print v(xbgr.mr_n71640176)
print v(xbgr.mr_n71640496)
print v(xbgr.mr_n71640608)
print v(xbgr.mr_n71640928)
print v(xbgr.mr_n71641040)
print v(xbgr.mr_n71641360)
print v(xbgr.mr_n71641472)
print v(xbgr.mr_n71641792)
print v(xbgr.mr_n71641904)
print v(xbgr.mr_n71642224)
print v(xbgr.mr_n71642336)
print v(xbgr.mr_n71642656)
print v(xbgr.mr_n71642768)
print v(xbgr.mr_n71643088)
print v(xbgr.mr_n71643200)
print v(xbgr.mr_n71643520)
print v(xbgr.mr_n71643632)
print v(xbgr.mr_n71643952)
print v(xbgr.mr_n71644064)
print v(xbgr.mr_n71644384)
print v(xbgr.mr_n71644496)
print v(xbgr.mr_n71644816)
print v(xbgr.mr_n71644928)
print v(xbgr.mr_n71645248)
print v(xbgr.mr_n71645360)
print v(xbgr.mr_n71645680)
print v(xbgr.mr_n71645792)
print v(xbgr.mr_n71646112)
print v(xbgr.mr_n71646224)
print v(xbgr.mr_n71646544)
print v(xbgr.mr_n71646656)
print v(xbgr.mr_n71646976)
print v(xbgr.mr_n71647088)
print v(xbgr.mr_n71647408)
print v(xbgr.mr_n71647520)
print v(xbgr.mr_n71647840)
print v(xbgr.mr_n71647952)
print v(xbgr.mr_n71648272)
print v(xbgr.mr_n71648384)
print v(xbgr.mr_n71648704)
print v(xbgr.mr_n71648816)
print v(xbgr.mr_n71649136)
print v(xbgr.mr_n71649248)
print v(xbgr.mr_n71649568)
print v(xbgr.mr_n71649680)
print v(xbgr.mr_n71650000)
print v(xbgr.mr_n71650112)
print v(xbgr.mr_n71650432)
print v(xbgr.mr_n71650544)
print v(xbgr.mr_n71650864)
print v(xbgr.mr_n71650976)
print v(xbgr.mr_n71651296)
print v(xbgr.mr_n71651408)
print v(xbgr.mr_n71651728)
print v(xbgr.mr_n71651840)
print v(xbgr.mr_n71652160)
print v(xbgr.mr_n71652272)
print v(xbgr.mr_n71652592)
print v(xbgr.mr_n71652704)
print v(xbgr.mr_n71653024)
print v(xbgr.mr_n71653136)
print v(xbgr.mr_n71653456)
print v(xbgr.mr_n71653568)
print v(xbgr.mr_n71653888)
print v(xbgr.mr_n71654000)
print v(xbgr.mr_n71654320)
print v(xbgr.mr_n71654432)
print v(xbgr.mr_n71654752)
print v(xbgr.mr_n71654864)
print v(xbgr.mr_n71655184)
print v(xbgr.mr_n71655296)
print v(xbgr.mr_n71655616)
print v(xbgr.mr_n71655728)
print v(xbgr.mr_n71656048)
print v(xbgr.mr_n71656160)
print v(xbgr.mr_n71656480)
print v(xbgr.mr_n71656592)
print v(xbgr.mr_n71656912)
print v(xbgr.mr_n71657024)
print v(xbgr.mr_n71657344)
print v(xbgr.mr_n71657456)
print v(xbgr.mr_n71657776)
print v(xbgr.mr_n71657888)
print v(xbgr.mr_n71658208)
print v(xbgr.mr_n71658320)
print v(xbgr.mr_n71658640)
print v(xbgr.mr_n71658752)
print v(xbgr.mr_n71659072)
print v(xbgr.mr_n71659184)
print v(xbgr.mr_n71659504)
print v(xbgr.mr_n71659616)
print v(xbgr.mr_n71659936)
print v(xbgr.mr_n71660048)
print v(xbgr.mr_n71660368)
print v(xbgr.mr_n71660480)
print v(xbgr.mr_n71660800)
print v(xbgr.mr_n71660912)
print v(xbgr.mr_n71661232)
print v(xbgr.mr_n71661344)
print v(xbgr.mr_n71661664)
print v(xbgr.mr_n71661776)
print v(xbgr.mr_n71662096)
print v(xbgr.mr_n71662208)
print v(xbgr.mr_n71662528)
print v(xbgr.mr_n71662640)
print v(xbgr.mr_n71662960)
print v(xbgr.mr_n71663072)
print v(xbgr.mr_n71663392)
print v(xbgr.mr_n71663504)
print v(xbgr.mr_n71663824)
print v(xbgr.mr_n71663936)
print v(xbgr.mr_n71664256)
print v(xbgr.mr_n71664368)
print v(xbgr.mr_n71664688)
print v(xbgr.mr_n71664800)
print v(xbgr.mr_n71665120)
print v(xbgr.mr_n71665232)
print v(xbgr.mr_n71665552)
print v(xbgr.mr_n71665664)
print v(xbgr.mr_n71665984)
print v(xbgr.mr_n71666096)
print v(xbgr.mr_n71666416)
print v(xbgr.mr_n71666528)
print v(xbgr.mr_n71666848)
print v(xbgr.mr_n71666960)
print v(xbgr.mr_n71667280)
print v(xbgr.mr_n71667392)
print v(xbgr.mr_n71667712)
print v(xbgr.mr_n71667824)
print v(xbgr.mr_n71668144)
print v(xbgr.mr_n71668256)
print v(xbgr.mr_n71668576)
print v(xbgr.mr_n71668688)
print v(xbgr.mr_n71669008)
print v(xbgr.mr_n71669120)
print v(xbgr.mr_n71669440)
print v(xbgr.mr_n71669552)
print v(xbgr.mr_n71669872)
print v(xbgr.mr_n71669984)
print v(xbgr.mr_n71670304)
print v(xbgr.mr_n71670416)
print v(xbgr.mr_n71670736)
print v(xbgr.mr_n71670848)
print v(xbgr.mr_n71671168)
print v(xbgr.mr_n71671280)
print v(xbgr.mr_n71671600)
print v(xbgr.mr_n71671712)
print v(xbgr.mr_n71672032)
print v(xbgr.mr_n71672144)
print v(xbgr.mr_n71672464)
print v(xbgr.mr_n71672576)
print v(xbgr.mr_n71672896)
print v(xbgr.mr_n71673008)
print v(xbgr.mr_n71673328)
print v(xbgr.mr_n71673440)
print v(xbgr.mr_n71673760)
print v(xbgr.mr_n71673872)
print v(xbgr.mr_n71674192)
print v(xbgr.mr_n71674304)
print v(xbgr.mr_n71674624)
print v(xbgr.mr_n71674736)
print v(xbgr.mr_n71675056)
print v(xbgr.mr_n71675168)
print v(xbgr.mr_n71675488)
print v(xbgr.mr_n71675600)
print v(xbgr.mr_n71675920)
print v(xbgr.mr_n71676032)
print v(xbgr.mr_n71676352)
print v(xbgr.mr_n71676464)
print v(xbgr.mr_n71676784)
print v(xbgr.mr_n71676896)
print v(xbgr.mr_n71677216)
print v(xbgr.mr_n71677328)
print v(xbgr.mr_n71677648)
print v(xbgr.mr_n71677760)
print v(xbgr.mr_n71678080)
print v(xbgr.mr_n71678192)
print v(xbgr.mr_n71678512)
print v(xbgr.mr_n71678624)
print v(xbgr.mr_n71678944)
print v(xbgr.mr_n71679056)
print v(xbgr.mr_n71679376)
print v(xbgr.mr_n71679488)
print v(xbgr.mr_n71679808)
print v(xbgr.mr_n71679920)
print v(xbgr.mr_n71680240)
print v(xbgr.mr_n71680352)
print v(xbgr.mr_n71680672)
print v(xbgr.mr_n71680784)
print v(xbgr.mr_n71681104)
print v(xbgr.mr_n71681216)
print v(xbgr.mr_n71681536)
print v(xbgr.mr_n71681648)
print v(xbgr.mr_n71681968)
print v(xbgr.mr_n71682080)
print v(xbgr.mr_n71682400)
print v(xbgr.mr_n71682512)
print v(xbgr.mr_n71682832)
print v(xbgr.mr_n71682944)
print v(xbgr.mr_n71683264)
print v(xbgr.mr_n71683376)
print v(xbgr.mr_n71683696)
print v(xbgr.mr_n71683808)
print v(xbgr.mr_n71684128)
print v(xbgr.mr_n71684240)
print v(xbgr.mr_n71684560)
print v(xbgr.mr_n71684672)
print v(xbgr.mr_n71684992)
print v(xbgr.mr_n71685104)
print v(xbgr.mr_n71685424)
print v(xbgr.mr_n71685536)
print v(xbgr.mr_n71685856)
print v(xbgr.mr_n71685968)
print v(xbgr.mr_n71686288)
print v(xbgr.mr_n71686400)
print v(xbgr.mr_n71686720)
print v(xbgr.mr_n71686832)
print v(xbgr.mr_n71687152)
print v(xbgr.mr_n71687264)
print v(xbgr.mr_n71687584)
print v(xbgr.mr_n71687696)
print v(xbgr.mr_n71688016)
print v(xbgr.mr_n71688128)
print v(xbgr.mr_n71688448)
print v(xbgr.mr_n71688560)
print v(xbgr.mr_n71688880)
print v(xbgr.mr_n71688992)
print v(xbgr.mr_n71689312)
print v(xbgr.mr_n71689424)
print v(xbgr.mr_n71689744)
print v(xbgr.mr_n71689856)
print v(xbgr.mr_n71690176)
print v(xbgr.mr_n71690288)
print v(xbgr.mr_n71690608)
print v(xbgr.mr_n71690720)
print v(xbgr.mr_n71691040)
print v(xbgr.mr_n71691152)
print v(xbgr.mr_n71691472)
print v(xbgr.mr_n71691584)
print v(xbgr.mr_n71691904)
print v(xbgr.mr_n71692016)
print v(xbgr.mr_n71692336)
print v(xbgr.mr_n71692448)
print v(xbgr.mr_n71692768)
print v(xbgr.mr_n71692880)
print v(xbgr.mr_n71693200)
print v(xbgr.mr_n71693312)
print v(xbgr.mr_n71693632)
print v(xbgr.mr_n71693744)
print v(xbgr.mr_n71694064)
print v(xbgr.mr_n71694176)
print v(xbgr.mr_n71694496)
print v(xbgr.mr_n71694608)
print v(xbgr.mr_n71694928)
print v(xbgr.mr_n71695040)
print v(xbgr.mr_n71695360)
print v(xbgr.mr_n71695472)
print v(xbgr.mr_n71695792)
print v(xbgr.mr_n71695904)
print v(xbgr.mr_n71696224)
print v(xbgr.mr_n71696336)
print v(xbgr.mr_n71696656)
print v(xbgr.mr_n71696768)
print v(xbgr.mr_n71697088)
print v(xbgr.mr_n71697200)
print v(xbgr.mr_n71697520)
print v(xbgr.mr_n71697632)
print v(xbgr.mr_n71697952)
print v(xbgr.mr_n71698064)
print v(xbgr.mr_n71698384)
print v(xbgr.mr_n71698496)
print v(xbgr.mr_n71698816)
print v(xbgr.mr_n71698928)
print v(xbgr.mr_n71699248)
print v(xbgr.mr_n71699360)
print v(xbgr.mr_n71699680)
print v(xbgr.mr_n71699792)
print v(xbgr.mr_n71700112)
print v(xbgr.mr_n71700224)
print v(xbgr.mr_n71700544)
print v(xbgr.mr_n71700656)
print v(xbgr.mr_n71700976)
print v(xbgr.mr_n71701088)
print v(xbgr.mr_n71701408)
print v(xbgr.mr_n71701520)
print v(xbgr.mr_n71701840)
print v(xbgr.mr_n71701952)
print v(xbgr.mr_n71702272)
print v(xbgr.mr_n71702384)
print v(xbgr.mr_n71702704)
print v(xbgr.mr_n71702816)
print v(xbgr.mr_n71703136)
print v(xbgr.mr_n71703248)
print v(xbgr.mr_n71703568)
print v(xbgr.mr_n71703680)
print v(xbgr.mr_n71704000)
print v(xbgr.mr_n71704112)
print v(xbgr.mr_n71704432)
print v(xbgr.mr_n71704544)
print v(xbgr.mr_n71704864)
print v(xbgr.mr_n71704976)
print v(xbgr.mr_n71705296)
print v(xbgr.mr_n71705408)
print v(xbgr.mr_n71705728)
print v(xbgr.mr_n71705840)
print v(xbgr.mr_n71706160)
print v(xbgr.mr_n71706272)
print v(xbgr.mr_n71706592)
print v(xbgr.mr_n71706704)
print v(xbgr.mr_n71707024)
print v(xbgr.mr_n71707136)
print v(xbgr.mr_n71707456)
print v(xbgr.mr_n71707568)
print v(xbgr.mr_n71707888)
print v(xbgr.mr_n71708000)
print v(xbgr.mr_n71708320)
print v(xbgr.mr_n71708432)
print v(xbgr.mr_n71708752)
print v(xbgr.mr_n71708864)
print v(xbgr.mr_n71709184)
print v(xbgr.mr_n71709296)
print v(xbgr.mr_n71709616)
print v(xbgr.mr_n71709728)
print v(xbgr.mr_n71710048)
print v(xbgr.mr_n71710160)
print v(xbgr.mr_n71710480)
print v(xbgr.mr_n71710592)
print v(xbgr.mr_n71710912)
print v(xbgr.mr_n71711024)
print v(xbgr.mr_n71711344)
print v(xbgr.mr_n71711456)
print v(xbgr.mr_n71711888)
print v(xbgr.mr_n71712208)
print v(xbgr.mr_n71712320)
print v(xbgr.mr_n71712752)
print v(xbgr.mr_n71713072)
print v(xbgr.mr_n71713184)
print v(xbgr.mr_n71713616)
print v(xbgr.mr_n71713936)
print v(xbgr.mr_n71714800)
print v(xbgr.mr_n71714912)
print v(xbgr.mr_n71715344)
print v(xbgr.mr_n71715664)
print v(xbgr.mr_n71715776)
print v(xbgr.mr_n71716096)
print v(xbgr.mr_n71716208)
print v(xbgr.mr_n71716528)
print v(xbgr.mr_n71716640)
print v(xbgr.mr_n71716960)
print v(xbgr.mr_n71717072)
print v(xbgr.mr_n71717392)
print v(xbgr.mr_n71717504)
print v(xbgr.mr_n71717824)
print v(xbgr.mr_n71717936)
print v(xbgr.mr_n71718256)
print v(xbgr.mr_n71718368)
print v(xbgr.mr_n71718688)
print v(xbgr.mr_n71718800)
print v(xbgr.mr_n71719120)
print v(xbgr.mr_n71719984)
print v(xbgr.mr_n71720848)
print v(xbgr.mr_n71720960)
print v(xbgr.mr_n71721280)
print v(xbgr.mr_n71721392)
print v(xbgr.mr_n71721712)
print v(xbgr.mr_n71722576)
print v(xbgr.mr_n71722688)
print v(xbgr.mr_n71723008)
print v(xbgr.mr_n71723120)
print v(xbgr.mr_n71723440)
print v(xbgr.mr_n71723552)
print v(xbgr.mr_n71723872)
print v(xbgr.mr_n71723984)
print v(xbgr.mr_n71724304)
print v(xbgr.mr_n71724416)
print v(xbgr.mr_n71724736)
print v(xbgr.mr_n71724848)
print v(xbgr.mr_n71725168)
print v(xbgr.mr_n71725280)
print v(xbgr.mr_n71725600)
print v(xbgr.mr_n71725712)
print v(xbgr.mr_n71726032)
print v(xbgr.mr_n71726144)
print v(xbgr.mr_n71726464)
print v(xbgr.mr_n71726576)
print v(xbgr.mr_n71726896)
print v(xbgr.mr_n71727008)
print v(xbgr.mr_n71727328)
print v(xbgr.mr_n71727440)
print v(xbgr.mr_n71727760)
print v(xbgr.mr_n71727872)
print v(xbgr.mr_n71728192)
print v(xbgr.mr_n71728304)
print v(xbgr.mr_n71728624)
print v(xbgr.mr_n71728736)
print v(xbgr.mr_n71729056)
print v(xbgr.mr_n71729168)
print v(xbgr.mr_n71729488)
print v(xbgr.mr_n71729600)
print v(xbgr.mr_n71729920)
print v(xbgr.mr_n71730032)
print v(xbgr.mr_n71730352)
print v(xbgr.mr_n71730464)
print v(xbgr.mr_n71730784)
print v(xbgr.mr_n71730896)
print v(xbgr.mr_n71731216)
print v(xbgr.mr_n71731328)
print v(xbgr.mr_n71731648)
print v(xbgr.mr_n71731760)
print v(xbgr.mr_n71732080)
print v(xbgr.mr_n71732192)
print v(xbgr.mr_n71732512)
print v(xbgr.mr_n71732624)
print v(xbgr.mr_n71732944)
print v(xbgr.mr_n71733056)
print v(xbgr.mr_n71733488)
print v(xbgr.mr_n71733808)
print v(xbgr.mr_n71733920)
print v(xbgr.mr_n71734240)
print v(xbgr.mr_n71734352)
print v(xbgr.mr_n71734672)
print v(xbgr.mr_n71734784)
print v(xbgr.mr_n71735104)
print v(xbgr.mr_n71735216)
print v(xbgr.mr_n71735536)
print v(xbgr.mr_n71735648)
print v(xbgr.mr_n71735968)
print v(xbgr.mr_n71736080)
print v(xbgr.mr_n71736400)
print v(xbgr.mr_n71736512)
print v(xbgr.mr_n71736832)
print v(xbgr.mr_n71736944)
print v(xbgr.mr_n71737264)
print v(xbgr.mr_n71737376)
print v(xbgr.mr_n71737696)
print v(xbgr.mr_n71737808)
print v(xbgr.mr_n71738128)
print v(xbgr.mr_n71738240)
print v(xbgr.mr_n71738560)
print v(xbgr.mr_n71738672)
print v(xbgr.mr_n71738992)
print v(xbgr.mr_n71739104)
print v(xbgr.mr_n71739424)
print v(xbgr.mr_n71739536)
print v(xbgr.mr_n71739856)
print v(xbgr.mr_n71740720)
print v(xbgr.mr_n71740832)
print v(xbgr.mr_n71741152)
print v(xbgr.mr_n71741264)
print v(xbgr.mr_n71741584)
print v(xbgr.mr_n71741696)
print v(xbgr.mr_n71742016)
print v(xbgr.mr_n71742128)
print v(xbgr.mr_n71742448)
print v(xbgr.mr_n71742560)
print v(xbgr.mr_n71742880)
print v(xbgr.mr_n71742992)
print v(xbgr.mr_n71743312)
print v(xbgr.mr_n71743424)
print v(xbgr.mr_n71743744)
print v(xbgr.mr_n71743856)
print v(xbgr.mr_n71744176)
print v(xbgr.mr_n71744288)
print v(xbgr.mr_n71744608)
print v(xbgr.mr_n71744720)
print v(xbgr.mr_n71745040)
print v(xbgr.mr_n71745152)
print v(xbgr.mr_n71745472)
print v(xbgr.mr_n71745584)
print v(xbgr.mr_n71745904)
print v(xbgr.mr_n71746016)
print v(xbgr.mr_n71746336)
print v(xbgr.mr_n71746448)
print v(xbgr.mr_n71746768)
print v(xbgr.mr_n71746880)
print v(xbgr.mr_n71747200)
print v(xbgr.mr_n71747312)
print v(xbgr.mr_n71747632)
print v(xbgr.mr_n71747744)
print v(xbgr.mr_n71748064)
print v(xbgr.mr_n71748176)
print v(xbgr.mr_n71748496)
print v(xbgr.mr_n71748608)
print v(xbgr.mr_n71748928)
print v(xbgr.mr_n71749040)
print v(xbgr.mr_n71749360)
print v(xbgr.mr_n71749472)
print v(xbgr.mr_n71749792)
print v(xbgr.mr_n71749904)
print v(xbgr.mr_n71750224)
print v(xbgr.mr_n71750336)
print v(xbgr.mr_n71750656)
print v(xbgr.mr_n71750768)
print v(xbgr.mr_n71751088)
print v(xbgr.mr_n71751200)
print v(xbgr.mr_n71751520)
print v(xbgr.mr_n71751632)
print v(xbgr.mr_n71751952)
print v(xbgr.mr_n71752064)
print v(xbgr.mr_n71752384)
print v(xbgr.mr_n71752496)
print v(xbgr.mr_n71752816)
print v(xbgr.mr_n71752928)
print v(xbgr.mr_n71753248)
print v(xbgr.mr_n71753360)
print v(xbgr.mr_n71753680)
print v(xbgr.mr_n71753792)
print v(xbgr.mr_n71754112)
print v(xbgr.mr_n71754224)
print v(xbgr.mr_n71754544)
print v(xbgr.mr_n71754656)
print v(xbgr.mr_n71754976)
print v(xbgr.mr_n71755088)
print v(xbgr.mr_n71755408)
print v(xbgr.mr_n71755520)
print v(xbgr.mr_n71755840)
print v(xbgr.mr_n71755952)
print v(xbgr.mr_n71756272)
print v(xbgr.mr_n71756384)
print v(xbgr.mr_n71756704)
print v(xbgr.mr_n71756816)
print v(xbgr.mr_n71757136)
print v(xbgr.mr_n71757248)
print v(xbgr.mr_n71757568)
print v(xbgr.mr_n71757680)
print v(xbgr.mr_n71758000)
print v(xbgr.mr_n71758112)
print v(xbgr.mr_n71758432)
print v(xbgr.mr_n71758544)
print v(xbgr.mr_n71758864)
print v(xbgr.mr_n71758976)
print v(xbgr.mr_n71759296)
print v(xbgr.mr_n71759408)
print v(xbgr.mr_n71759728)
print v(xbgr.mr_n71759840)
print v(xbgr.mr_n71760160)
print v(xbgr.mr_n71760272)
print v(xbgr.mr_n71760592)
print v(xbgr.mr_n71760704)
print v(xbgr.mr_n71761024)
print v(xbgr.mr_n71761136)
print v(xbgr.mr_n71761456)
print v(xbgr.mr_n71761568)
print v(xbgr.mr_n71761888)
print v(xbgr.mr_n71762000)
print v(xbgr.mr_n71762320)
print v(xbgr.mr_n71762432)
print v(xbgr.mr_n71762752)
print v(xbgr.mr_n71762864)
print v(xbgr.mr_n71763184)
print v(xbgr.mr_n71763296)
print v(xbgr.mr_n71763616)
print v(xbgr.mr_n71763728)
print v(xbgr.mr_n71764048)
print v(xbgr.mr_n71764160)
print v(xbgr.mr_n71764480)
print v(xbgr.mr_n71764592)
print v(xbgr.mr_n71764912)
print v(xbgr.mr_n71765024)
print v(xbgr.mr_n71765344)
print v(xbgr.mr_n71765456)
print v(xbgr.mr_n71765776)
print v(xbgr.mr_n71765888)
print v(xbgr.mr_n71766208)
print v(xbgr.mr_n71766320)
print v(xbgr.mr_n71766640)
print v(xbgr.mr_n71766752)
print v(xbgr.mr_n71767072)
print v(xbgr.mr_n71767184)
print v(xbgr.mr_n71767504)
print v(xbgr.mr_n71767616)
print v(xbgr.mr_n71767936)
print v(xbgr.mr_n71768048)
print v(xbgr.mr_n71768368)
print v(xbgr.mr_n71768480)
print v(xbgr.mr_n71768800)
print v(xbgr.mr_n71768912)
print v(xbgr.mr_n71769232)
print v(xbgr.mr_n71769344)
print v(xbgr.mr_n71769664)
print v(xbgr.mr_n71769776)
print v(xbgr.mr_n71770096)
print v(xbgr.mr_n71770208)
print v(xbgr.mr_n71770528)
print v(xbgr.mr_n71770640)
print v(xbgr.mr_n71770960)
print v(xbgr.mr_n71771072)
print v(xbgr.mr_n71771392)
print v(xbgr.mr_n71771504)
print v(xbgr.mr_n71771824)
print v(xbgr.mr_n71771936)
print v(xbgr.mr_n71772256)
print v(xbgr.mr_n71772368)
print v(xbgr.mr_n71772688)
print v(xbgr.mr_n71772800)
print v(xbgr.mr_n71773120)
print v(xbgr.mr_n71773232)
print v(xbgr.mr_n71773552)
print v(xbgr.mr_n71773664)
print v(xbgr.mr_n71773984)
print v(xbgr.mr_n71774096)
print v(xbgr.mr_n71774416)
print v(xbgr.mr_n71774528)
print v(xbgr.mr_n71774848)
print v(xbgr.mr_n71774960)
print v(xbgr.mr_n71775280)
print v(xbgr.mr_n71775392)
print v(xbgr.mr_n71775712)
print v(xbgr.mr_n71775824)
print v(xbgr.mr_n71776144)
print v(xbgr.mr_n71776256)
print v(xbgr.mr_n71776576)
print v(xbgr.mr_n71776688)
print v(xbgr.mr_n71777008)
print v(xbgr.mr_n71777120)
print v(xbgr.mr_n71777440)
print v(xbgr.mr_n71777552)
print v(xbgr.mr_n71777872)
print v(xbgr.mr_n71777984)
print v(xbgr.mr_n71778304)
print v(xbgr.mr_n71778416)
print v(xbgr.mr_n71778736)
print v(xbgr.mr_n71778848)
print v(xbgr.mr_n71779168)
print v(xbgr.mr_n71779280)
print v(xbgr.mr_n71779600)
print v(xbgr.mr_n71779712)
print v(xbgr.mr_n71780032)
print v(xbgr.mr_n71780144)
print v(xbgr.mr_n71780464)
print v(xbgr.mr_n71780576)
print v(xbgr.mr_n71780896)
print v(xbgr.mr_n71781008)
print v(xbgr.mr_n71781328)
print v(xbgr.mr_n71781440)
print v(xbgr.mr_n71781760)
print v(xbgr.mr_n71781872)
print v(xbgr.mr_n71782192)
print v(xbgr.mr_n71782304)
print v(xbgr.mr_n71782624)
print v(xbgr.mr_n71782736)
print v(xbgr.mr_n71783056)
print v(xbgr.mr_n71783168)
print v(xbgr.mr_n71783488)
print v(xbgr.mr_n71783600)
print v(xbgr.mr_n71783920)
print v(xbgr.mr_n71784032)
print v(xbgr.mr_n71784352)
print v(xbgr.mr_n71784464)
print v(xbgr.mr_n71784784)
print v(xbgr.mr_n71784896)
print v(xbgr.mr_n71785216)
print v(xbgr.mr_n71785328)
print v(xbgr.mr_n71785648)
print v(xbgr.mr_n71785760)
print v(xbgr.mr_n71786080)
print v(xbgr.mr_n71786192)
print v(xbgr.mr_n71786512)
print v(xbgr.mr_n71786624)
print v(xbgr.mr_n71786944)
print v(xbgr.mr_n71787056)
print v(xbgr.mr_n71787376)
print v(xbgr.mr_n71787488)
print v(xbgr.mr_n71787808)
print v(xbgr.mr_n71787920)
print v(xbgr.mr_n71788240)
print v(xbgr.mr_n71788352)
print v(xbgr.mr_n71788672)
print v(xbgr.mr_n71788784)
print v(xbgr.mr_n71789104)
print v(xbgr.mr_n71789216)
print v(xbgr.mr_n71789536)
print v(xbgr.mr_n71789648)
print v(xbgr.mr_n71789968)
print v(xbgr.mr_n71790080)
print v(xbgr.mr_n71790400)
print v(xbgr.mr_n71790512)
print v(xbgr.mr_n71790832)
print v(xbgr.mr_n71790944)
print v(xbgr.mr_n71791264)
print v(xbgr.mr_n71791376)
print v(xbgr.mr_n71791696)
print v(xbgr.mr_n71791808)
print v(xbgr.mr_n71792128)
print v(xbgr.mr_n71792240)
print v(xbgr.mr_n71792560)
print v(xbgr.mr_n71792672)
print v(xbgr.mr_n71792992)
print v(xbgr.mr_n71793104)
print v(xbgr.mr_n71793424)
print v(xbgr.mr_n71793536)
print v(xbgr.mr_n71793856)
print v(xbgr.mr_n71793968)
print v(xbgr.mr_n71794288)
print v(xbgr.mr_n71794400)
print v(xbgr.mr_n71794720)
print v(xbgr.mr_n71794832)
print v(xbgr.mr_n71795152)
print v(xbgr.mr_n71795264)
print v(xbgr.mr_n71795584)
print v(xbgr.mr_n71795696)
print v(xbgr.mr_n71796016)
print v(xbgr.mr_n71796128)
print v(xbgr.mr_n71796448)
print v(xbgr.mr_n71796560)
print v(xbgr.mr_n71796880)
print v(xbgr.mr_n71796992)
print v(xbgr.mr_n71797312)
print v(xbgr.mr_n71797424)
print v(xbgr.mr_n71797744)
print v(xbgr.mr_n71797856)
print v(xbgr.mr_n71798176)
print v(xbgr.mr_n71798288)
print v(xbgr.mr_n71798608)
print v(xbgr.mr_n71798720)
print v(xbgr.mr_n71799040)
print v(xbgr.mr_n71799152)
print v(xbgr.mr_n71799472)
print v(xbgr.mr_n71799584)
print v(xbgr.mr_n71799904)
print v(xbgr.mr_n71800016)
print v(xbgr.mr_n71800336)
print v(xbgr.mr_n71800448)
print v(xbgr.mr_n71800768)
print v(xbgr.mr_n71800880)
print v(xbgr.mr_n71801200)
print v(xbgr.mr_n71801312)
print v(xbgr.mr_n71801632)
print v(xbgr.mr_n71801744)
print v(xbgr.mr_n71802064)
print v(xbgr.mr_n71802176)
print v(xbgr.mr_n71802496)
print v(xbgr.mr_n71802608)
print v(xbgr.mr_n71802928)
print v(xbgr.mr_n71803040)
print v(xbgr.mr_n71803360)
print v(xbgr.mr_n71803472)
print v(xbgr.mr_n71803792)
print v(xbgr.mr_n71803904)
print v(xbgr.mr_n71804224)
print v(xbgr.mr_n71804336)
print v(xbgr.mr_n71804656)
print v(xbgr.mr_n71804768)
print v(xbgr.mr_n71805088)
print v(xbgr.mr_n71805200)
print v(xbgr.mr_n71805520)
print v(xbgr.mr_n71805632)
print v(xbgr.mr_n71805952)
print v(xbgr.mr_n71806064)
print v(xbgr.mr_n71806384)
print v(xbgr.mr_n71806496)
print v(xbgr.mr_n71806816)
print v(xbgr.mr_n71806928)
print v(xbgr.mr_n71807248)
print v(xbgr.mr_n71807360)
print v(xbgr.mr_n71807680)
print v(xbgr.mr_n71807792)
print v(xbgr.mr_n71808112)
print v(xbgr.mr_n71808224)
print v(xbgr.mr_n71808544)
print v(xbgr.mr_n71808656)
print v(xbgr.mr_n71808976)
print v(xbgr.mr_n71809088)
print v(xbgr.mr_n71809408)
print v(xbgr.mr_n71809520)
print v(xbgr.mr_n71809840)
print v(xbgr.mr_n71809952)
print v(xbgr.mr_n71810272)
print v(xbgr.mr_n71810384)
print v(xbgr.mr_n71810704)
print v(xbgr.mr_n71810816)
print v(xbgr.mr_n71811136)
print v(xbgr.mr_n71811248)
print v(xbgr.mr_n71811568)
print v(xbgr.mr_n71811680)
print v(xbgr.mr_n71812000)
print v(xbgr.mr_n71812112)
print v(xbgr.mr_n71812432)
print v(xbgr.mr_n71812544)
print v(xbgr.mr_n71812864)
print v(xbgr.mr_n71812976)
print v(xbgr.mr_n71813296)
print v(xbgr.mr_n71813408)
print v(xbgr.mr_n71813728)
print v(xbgr.mr_n71813840)
print v(xbgr.mr_n71814160)
print v(xbgr.mr_n71814272)
print v(xbgr.mr_n71814592)
print v(xbgr.mr_n71814704)
print v(xbgr.mr_n71815024)
print v(xbgr.mr_n71815136)
print v(xbgr.mr_n71815456)
print v(xbgr.mr_n71815568)
print v(xbgr.mr_n71815888)
print v(xbgr.mr_n71816000)
print v(xbgr.mr_n71816320)
print v(xbgr.mr_n71816432)
print v(xbgr.mr_n71816752)
print v(xbgr.mr_n71816864)
print v(xbgr.mr_n71817184)
print v(xbgr.mr_n71817296)
print v(xbgr.mr_n71817616)
print v(xbgr.mr_n71817728)
print v(xbgr.mr_n71818048)
print v(xbgr.mr_n71818160)
print v(xbgr.mr_n71818480)
print v(xbgr.mr_n71818592)
print v(xbgr.mr_n71818912)
print v(xbgr.mr_n71819024)
print v(xbgr.mr_n71819344)
print v(xbgr.mr_n71819456)
print v(xbgr.mr_n71819776)
print v(xbgr.mr_n71819888)
print v(xbgr.mr_n71820208)
print v(xbgr.mr_n71820320)
print v(xbgr.mr_n71820640)
print v(xbgr.mr_n71820752)
print v(xbgr.mr_n71821072)
print v(xbgr.mr_n71821184)
print v(xbgr.mr_n71821504)
print v(xbgr.mr_n71821616)
print v(xbgr.mr_n71821936)
print v(xbgr.mr_n71822048)
print v(xbgr.mr_n71822368)
print v(xbgr.mr_n71822480)
print v(xbgr.mr_n71822800)
print v(xbgr.mr_n71822912)
print v(xbgr.mr_n71823232)
print v(xbgr.mr_n71823344)
print v(xbgr.mr_n71823664)
print v(xbgr.mr_n71823776)
print v(xbgr.mr_n71824096)
print v(xbgr.mr_n71824208)
print v(xbgr.mr_n71824528)
print v(xbgr.mr_n71824640)
print v(xbgr.mr_n71824960)
print v(xbgr.mr_n71825072)
print v(xbgr.mr_n71825392)
print v(xbgr.mr_n71825504)
print v(xbgr.mr_n71825824)
print v(xbgr.mr_n71825936)
print v(xbgr.mr_n71826256)
print v(xbgr.mr_n71826368)
print v(xbgr.mr_n71826688)
print v(xbgr.mr_n71826800)
print v(xbgr.mr_n71827120)
print v(xbgr.mr_n71827232)
print v(xbgr.mr_n71827552)
print v(xbgr.mr_n71827664)
print v(xbgr.mr_n71827984)
print v(xbgr.mr_n71828096)
print v(xbgr.mr_n71828416)
print v(xbgr.mr_n71828528)
print v(xbgr.mr_n71828848)
print v(xbgr.mr_n71828960)
print v(xbgr.mr_n71829280)
print v(xbgr.mr_n71829392)
print v(xbgr.mr_n71829712)
print v(xbgr.mr_n71829824)
print v(xbgr.mr_n71830144)
print v(xbgr.mr_n71830256)
print v(xbgr.mr_n71830576)
print v(xbgr.mr_n71830688)
print v(xbgr.mr_n71831008)
print v(xbgr.mr_n71831120)
print v(xbgr.mr_n71831440)
print v(xbgr.mr_n71831552)
print v(xbgr.mr_n71831872)
print v(xbgr.mr_n71831984)
print v(xbgr.mr_n71832304)
print v(xbgr.mr_n71832416)
print v(xbgr.mr_n71832736)
print v(xbgr.mr_n71832848)
print v(xbgr.mr_n71833168)
print v(xbgr.mr_n71833280)
print v(xbgr.mr_n71833600)
print v(xbgr.mr_n71833712)
print v(xbgr.mr_n71834032)
print v(xbgr.mr_n71834144)
print v(xbgr.mr_n71834464)
print v(xbgr.mr_n71834576)
print v(xbgr.mr_n71834896)
print v(xbgr.mr_n71835008)
print v(xbgr.mr_n71835328)
print v(xbgr.mr_n71835440)
print v(xbgr.mr_n71835760)
print v(xbgr.mr_n71835872)
print v(xbgr.mr_n71836192)
print v(xbgr.mr_n71836304)
print v(xbgr.mr_n71836624)
print v(xbgr.mr_n71836736)
print v(xbgr.mr_n71837056)
print v(xbgr.mr_n71837168)
print v(xbgr.mr_n71837488)
print v(xbgr.mr_n71837600)
print v(xbgr.mr_n71837920)
print v(xbgr.mr_n71838032)
print v(xbgr.mr_n71838352)
print v(xbgr.mr_n71838464)
print v(xbgr.mr_n71838784)
print v(xbgr.mr_n71838896)
print v(xbgr.mr_n71839216)
print v(xbgr.mr_n71839328)
print v(xbgr.mr_n71839648)
print v(xbgr.mr_n71839760)
print v(xbgr.mr_n71840080)
print v(xbgr.mr_n71840192)
print v(xbgr.mr_n71840512)
print v(xbgr.mr_n71840624)
print v(xbgr.mr_n71840944)
print v(xbgr.mr_n71841056)
print v(xbgr.mr_n71841376)
print v(xbgr.mr_n71841488)
print v(xbgr.mr_n71841808)
print v(xbgr.mr_n71841920)
print v(xbgr.mr_n71842240)
print v(xbgr.mr_n71842352)
print v(xbgr.mr_n71842672)
print v(xbgr.mr_n71842784)
print v(xbgr.mr_n71843104)
print v(xbgr.mr_n71843216)
print v(xbgr.mr_n71843536)
print v(xbgr.mr_n71843648)
print v(xbgr.mr_n71843968)
print v(xbgr.mr_n71844080)
print v(xbgr.mr_n71844400)
print v(xbgr.mr_n71844512)
print v(xbgr.mr_n71844832)
print v(xbgr.mr_n71844944)
print v(xbgr.mr_n71845264)
print v(xbgr.mr_n71845376)
print v(xbgr.mr_n71845696)
print v(xbgr.mr_n71845808)
print v(xbgr.mr_n71846128)
print v(xbgr.mr_n71846240)
print v(xbgr.mr_n71846560)
print v(xbgr.mr_n71846672)
print v(xbgr.mr_n71846992)
print v(xbgr.mr_n71847104)
print v(xbgr.mr_n71847424)
print v(xbgr.mr_n71847536)
print v(xbgr.mr_n71847856)
print v(xbgr.mr_n71847968)
print v(xbgr.mr_n71848288)
print v(xbgr.mr_n71848400)
print v(xbgr.mr_n71848720)
print v(xbgr.mr_n71848832)
print v(xbgr.mr_n71849152)
print v(xbgr.mr_n71849264)
print v(xbgr.mr_n71849584)
print v(xbgr.mr_n71849696)
print v(xbgr.mr_n71850016)
print v(xbgr.mr_n71850128)
print v(xbgr.mr_n71850448)
print v(xbgr.mr_n71850560)
print v(xbgr.mr_n71850880)
print v(xbgr.mr_n71850992)
print v(xbgr.mr_n71851312)
print v(xbgr.mr_n71851424)
print v(xbgr.mr_n71851744)
print v(xbgr.mr_n71851856)
print v(xbgr.mr_n71852176)
print v(xbgr.mr_n71852288)
print v(xbgr.mr_n71852608)
print v(xbgr.mr_n71852720)
print v(xbgr.mr_n71853040)
print v(xbgr.mr_n71853152)
print v(xbgr.mr_n71853472)
print v(xbgr.mr_n71853584)
print v(xbgr.mr_n71853904)
print v(xbgr.mr_n71854016)
print v(xbgr.mr_n71854336)
print v(xbgr.mr_n71854448)
print v(xbgr.mr_n71854768)
print v(xbgr.mr_n71854880)
print v(xbgr.mr_n71855200)
print v(xbgr.mr_n71855312)
print v(xbgr.mr_n71855632)
print v(xbgr.mr_n71855744)
print v(xbgr.mr_n71856064)
print v(xbgr.mr_n71856176)
print v(xbgr.mr_n71856496)
print v(xbgr.mr_n71856608)
print v(xbgr.mr_n71856928)
print v(xbgr.mr_n71857040)
print v(xbgr.mr_n71857360)
print v(xbgr.mr_n71857472)
print v(xbgr.mr_n71857792)
print v(xbgr.mr_n71857904)
print v(xbgr.mr_n71858224)
print v(xbgr.mr_n71858336)
print v(xbgr.mr_n71858656)
print v(xbgr.mr_n71858768)
print v(xbgr.mr_n71859088)
print v(xbgr.mr_n71859200)
print v(xbgr.mr_n71859520)
print v(xbgr.mr_n71859632)
print v(xbgr.mr_n71859952)
print v(xbgr.mr_n71860064)
print v(xbgr.mr_n71860384)
print v(xbgr.mr_n71860496)
print v(xbgr.mr_n71860816)
print v(xbgr.mr_n71860928)
print v(xbgr.mr_n71861248)
print v(xbgr.mr_n71861360)
print v(xbgr.mr_n71861680)
print v(xbgr.mr_n71861792)
print v(xbgr.mr_n71862112)
print v(xbgr.mr_n71862224)
print v(xbgr.mr_n71862544)
print v(xbgr.mr_n71862656)
print v(xbgr.mr_n71862976)
print v(xbgr.mr_n71863088)
print v(xbgr.mr_n71863408)
print v(xbgr.mr_n71863520)
print v(xbgr.mr_n71863840)
print v(xbgr.mr_n71863952)
print v(xbgr.mr_n71864272)
print v(xbgr.mr_n71864384)
print v(xbgr.mr_n71864704)
print v(xbgr.mr_n71864816)
print v(xbgr.mr_n71865136)
print v(xbgr.mr_n71865248)
print v(xbgr.mr_n71865568)
print v(xbgr.mr_n71865680)
print v(xbgr.mr_n71866000)
print v(xbgr.mr_n71866112)
print v(xbgr.mr_n71866432)
print v(xbgr.mr_n71866544)
print v(xbgr.mr_n71866864)
print v(xbgr.mr_n71866976)
print v(xbgr.mr_n71867296)
print v(xbgr.mr_n71867408)
print v(xbgr.mr_n71867728)
print v(xbgr.mr_n71867840)
print v(xbgr.mr_n71868160)
print v(xbgr.mr_n71868272)
print v(xbgr.mr_n71868592)
print v(xbgr.mr_n71868704)
print v(xbgr.mr_n71869024)
print v(xbgr.mr_n71869136)
print v(xbgr.mr_n71869456)
print v(xbgr.mr_n71869568)
print v(xbgr.mr_n71869888)
print v(xbgr.mr_n71870000)
print v(xbgr.mr_n71870320)
print v(xbgr.mr_n71870432)
print v(xbgr.mr_n71870752)
print v(xbgr.mr_n71870864)
print v(xbgr.mr_n71871184)
print v(xbgr.mr_n71871296)
print v(xbgr.mr_n71871616)
print v(xbgr.mr_n71871728)
print v(xbgr.mr_n71872048)
print v(xbgr.mr_n71872160)
print v(xbgr.mr_n71872480)
print v(xbgr.mr_n71872592)
print v(xbgr.mr_n71872912)
print v(xbgr.mr_n71873024)
print v(xbgr.mr_n71873344)
print v(xbgr.mr_n71873456)
print v(xbgr.mr_n71873776)
print v(xbgr.mr_n71873888)
print v(xbgr.mr_n71874208)
print v(xbgr.mr_n71874320)
print v(xbgr.mr_n71874640)
print v(xbgr.mr_n71874752)
print v(xbgr.mr_n71875072)
print v(xbgr.mr_n71875184)
print v(xbgr.mr_n71875504)
print v(xbgr.mr_n71875616)
print v(xbgr.mr_n71875936)
print v(xbgr.mr_n71876048)
print v(xbgr.mr_n71876368)
print v(xbgr.mr_n71876480)
print v(xbgr.mr_n71876800)
print v(xbgr.mr_n71876912)
print v(xbgr.mr_n71877232)
print v(xbgr.mr_n71877344)
print v(xbgr.mr_n71877664)
print v(xbgr.mr_n71877776)
print v(xbgr.mr_n71878096)
print v(xbgr.mr_n71878208)
print v(xbgr.mr_n71878528)
print v(xbgr.mr_n71878640)
print v(xbgr.mr_n71878960)
print v(xbgr.mr_n71879072)
print v(xbgr.mr_n71879392)
print v(xbgr.mr_n71879504)
print v(xbgr.mr_n71879824)
print v(xbgr.mr_n71879936)
print v(xbgr.mr_n71880256)
print v(xbgr.mr_n71880368)
print v(xbgr.mr_n71880688)
print v(xbgr.mr_n71880800)
print v(xbgr.mr_n71881120)
print v(xbgr.mr_n71881232)
print v(xbgr.mr_n71881552)
print v(xbgr.mr_n71881664)
print v(xbgr.mr_n71881984)
print v(xbgr.mr_n71882096)
print v(xbgr.mr_n71882416)
print v(xbgr.mr_n71882528)
print v(xbgr.mr_n71882848)
print v(xbgr.mr_n71882960)
print v(xbgr.mr_n71883280)
print v(xbgr.mr_n71883392)
print v(xbgr.mr_n71883712)
print v(xbgr.mr_n71883824)
print v(xbgr.mr_n71884144)
print v(xbgr.mr_n71884256)
print v(xbgr.mr_n71884576)
print v(xbgr.mr_n71884688)
print v(xbgr.mr_n71885008)
print v(xbgr.mr_n71885120)
print v(xbgr.mr_n71885440)
print v(xbgr.mr_n71885552)
print v(xbgr.mr_n71885872)
print v(xbgr.mr_n71885984)
print v(xbgr.mr_n71886304)
print v(xbgr.mr_n71886416)
print v(xbgr.mr_n71886736)
print v(xbgr.mr_n71886848)
print v(xbgr.mr_n71887168)
print v(xbgr.mr_n71887280)
print v(xbgr.mr_n71887600)
print v(xbgr.mr_n71887712)
print v(xbgr.mr_n71888032)
print v(xbgr.mr_n71888144)
print v(xbgr.mr_n71888464)
print v(xbgr.mr_n71888576)
print v(xbgr.mr_n71888896)
print v(xbgr.mr_n71889008)
print v(xbgr.mr_n71889328)
print v(xbgr.mr_n71889440)
print v(xbgr.mr_n71889760)
print v(xbgr.mr_n71889872)
print v(xbgr.mr_n71890192)
print v(xbgr.mr_n71890304)
print v(xbgr.mr_n71890624)
print v(xbgr.mr_n71890736)
print v(xbgr.mr_n71891056)
print v(xbgr.mr_n71891168)
print v(xbgr.mr_n71891488)
print v(xbgr.mr_n71891600)
print v(xbgr.mr_n71891920)
print v(xbgr.mr_n71892032)
print v(xbgr.mr_n71892352)
print v(xbgr.mr_n71892464)
print v(xbgr.mr_n71892784)
print v(xbgr.mr_n71892896)
print v(xbgr.mr_n71893216)
print v(xbgr.mr_n71893328)
print v(xbgr.mr_n71893648)
print v(xbgr.mr_n71893760)
print v(xbgr.mr_n71894080)
print v(xbgr.mr_n71894192)
print v(xbgr.mr_n71894512)
print v(xbgr.mr_n71894624)
print v(xbgr.mr_n71894944)
print v(xbgr.mr_n71895056)
print v(xbgr.mr_n71895376)
print v(xbgr.mr_n71895488)
print v(xbgr.mr_n71895808)
print v(xbgr.mr_n71895920)
print v(xbgr.mr_n71896240)
print v(xbgr.mr_n71896352)
print v(xbgr.mr_n71896672)
print v(xbgr.mr_n71896784)
print v(xbgr.mr_n71897104)
print v(xbgr.mr_n71897216)
print v(xbgr.mr_n71897536)
print v(xbgr.mr_n71897648)
print v(xbgr.mr_n71897968)
print v(xbgr.mr_n71898080)
print v(xbgr.mr_n71898400)
print v(xbgr.mr_n71898512)
print v(xbgr.mr_n71898832)
print v(xbgr.mr_n71898944)
print v(xbgr.mr_n71899264)
print v(xbgr.mr_n71899376)
print v(xbgr.mr_n71899696)
print v(xbgr.mr_n71899808)
print v(xbgr.mr_n71900128)
print v(xbgr.mr_n71900240)
print v(xbgr.mr_n71900560)
print v(xbgr.mr_n71900672)
print v(xbgr.mr_n71900992)
print v(xbgr.mr_n71901104)
print v(xbgr.mr_n71901424)
print v(xbgr.mr_n71901536)
print v(xbgr.mr_n71901856)
print v(xbgr.mr_n71901968)
print v(xbgr.mr_n71902288)
print v(xbgr.mr_n71902400)
print v(xbgr.mr_n71902720)
print v(xbgr.mr_n71902832)
print v(xbgr.mr_n71903152)
print v(xbgr.mr_n71903264)
print v(xbgr.mr_n71903584)
print v(xbgr.mr_n71903696)
print v(xbgr.mr_n71904016)
print v(xbgr.mr_n71904128)
print v(xbgr.mr_n71904448)
print v(xbgr.mr_n71904560)
print v(xbgr.mr_n71904880)
print v(xbgr.mr_n71904992)
print v(xbgr.mr_n71905312)
print v(xbgr.mr_n71905424)
print v(xbgr.mr_n71905744)
print v(xbgr.mr_n71905856)
print v(xbgr.mr_n71906176)
print v(xbgr.mr_n71906288)
print v(xbgr.mr_n71906608)
print v(xbgr.mr_n71906720)
print v(xbgr.mr_n71907040)
print v(xbgr.mr_n71907152)
print v(xbgr.mr_n71907472)
print v(xbgr.mr_n71907584)
print v(xbgr.mr_n71907904)
print v(xbgr.mr_n71908016)
print v(xbgr.mr_n71908336)
print v(xbgr.mr_n71908448)
print v(xbgr.mr_n71908768)
print v(xbgr.mr_n71908880)
print v(xbgr.mr_n71909200)
print v(xbgr.mr_n71909312)
print v(xbgr.mr_n71909632)
print v(xbgr.mr_n71909744)
print v(xbgr.mr_n71910064)
print v(xbgr.mr_n71910176)
print v(xbgr.mr_n71910496)
print v(xbgr.mr_n71910608)
print v(xbgr.mr_n71910928)
print v(xbgr.mr_n71911040)
print v(xbgr.mr_n71911360)
print v(xbgr.mr_n71911472)
print v(xbgr.mr_n71911792)
print v(xbgr.mr_n71911904)
print v(xbgr.mr_n71912336)
print v(xbgr.mr_n71912656)
print v(xbgr.mr_n71912768)
print v(xbgr.mr_n71913088)
print v(xbgr.mr_n71913200)
print v(xbgr.mr_n71913520)
print v(xbgr.mr_n71913632)
print v(xbgr.mr_n71913952)
print v(xbgr.mr_n71914064)
print v(xbgr.mr_n71914384)
print v(xbgr.mr_n71915248)
print v(xbgr.mr_n71915360)
print v(xbgr.mr_n71915680)
print v(xbgr.mr_n71915792)
print v(xbgr.mr_n71916112)
print v(xbgr.mr_n71916224)
print v(xbgr.mr_n71916544)
print v(xbgr.mr_n71916656)
print v(xbgr.mr_n71916976)
print v(xbgr.mr_n71917088)
print v(xbgr.mr_n71917408)
print v(xbgr.mr_n71917520)
print v(xbgr.mr_n71917840)
print v(xbgr.mr_n71917952)
print v(xbgr.mr_n71918272)
print v(xbgr.mr_n71918384)
print v(xbgr.mr_n71918704)
print v(xbgr.mr_n71918816)
print v(xbgr.mr_n71919136)
print v(xbgr.mr_n71919248)
print v(xbgr.mr_n71919568)
print v(xbgr.mr_n71919680)
print v(xbgr.mr_n71920112)
print v(xbgr.mr_n71920432)
print v(xbgr.mr_n71920544)
print v(xbgr.mr_n71920864)
print v(xbgr.mr_n71920976)
print v(xbgr.mr_n71921296)
print v(xbgr.mr_n71921408)
print v(xbgr.mr_n71921728)
print v(xbgr.mr_n71921840)
print v(xbgr.mr_n71922160)
print v(xbgr.mr_n71922272)
print v(xbgr.mr_n71922592)
print v(xbgr.mr_n71922704)
print v(xbgr.mr_n71923024)
print v(xbgr.mr_n71923136)
print v(xbgr.mr_n71923456)
print v(xbgr.mr_n71923568)
print v(xbgr.mr_n71923888)
print v(xbgr.mr_n71924000)
print v(xbgr.mr_n71924320)
print v(xbgr.mr_n71924432)
print v(xbgr.mr_n71924752)
print v(xbgr.mr_n71924864)
print v(xbgr.mr_n71925184)
print v(xbgr.mr_n71925296)
print v(xbgr.mr_n71925616)
print v(xbgr.mr_n71925728)
print v(xbgr.mr_n71926048)
print v(xbgr.mr_n71926160)
print v(xbgr.mr_n71926480)
print v(xbgr.mr_n71926592)
print v(xbgr.mr_n71926912)
print v(xbgr.mr_n71927024)
print v(xbgr.mr_n71927344)
print v(xbgr.mr_n71927456)
print v(xbgr.mr_n71927776)
print v(xbgr.mr_n71927888)
print v(xbgr.mr_n71928208)
print v(xbgr.mr_n71928320)
print v(xbgr.mr_n71928640)
print v(xbgr.mr_n71928752)
print v(xbgr.mr_n71929072)
print v(xbgr.mr_n71929184)
print v(xbgr.mr_n71929504)
print v(xbgr.mr_n71929616)
print v(xbgr.mr_n71929936)
print v(xbgr.mr_n71930048)
print v(xbgr.mr_n71930368)
print v(xbgr.mr_n71930480)
print v(xbgr.mr_n71930800)
print v(xbgr.mr_n71930912)
print v(xbgr.mr_n71931232)
print v(xbgr.mr_n71931344)
print v(xbgr.mr_n71931664)
print v(xbgr.mr_n71931776)
print v(xbgr.mr_n71932096)
print v(xbgr.mr_n71932208)
print v(xbgr.mr_n71932528)
print v(xbgr.mr_n71932640)
print v(xbgr.mr_n71932960)
print v(xbgr.mr_n71933072)
print v(xbgr.mr_n71933392)
print v(xbgr.mr_n71933504)
print v(xbgr.mr_n71933824)
print v(xbgr.mr_n71933936)
print v(xbgr.mr_n71934256)
print v(xbgr.mr_n71934368)
print v(xbgr.mr_n71934688)
print v(xbgr.mr_n71934800)
print v(xbgr.mr_n71935120)
print v(xbgr.mr_n71935232)
print v(xbgr.mr_n71935552)
print v(xbgr.mr_n71935664)
print v(xbgr.mr_n71935984)
print v(xbgr.mr_n71936096)
print v(xbgr.mr_n71936416)
print v(xbgr.mr_n71936528)
print v(xbgr.mr_n71936848)
print v(xbgr.mr_n71937712)
print v(xbgr.mr_n71937824)
print v(xbgr.mr_n71938144)
print v(xbgr.mr_n71938256)
print v(xbgr.mr_n71938576)
print v(xbgr.mr_n71938688)
print v(xbgr.mr_n71939008)
print v(xbgr.mr_n71939120)
print v(xbgr.mr_n71939440)
print v(xbgr.mr_n71939552)
print v(xbgr.mr_n71939872)
print v(xbgr.mr_n71939984)
print v(xbgr.mr_n71940304)
print v(xbgr.mr_n71940416)
print v(xbgr.mr_n71940736)
print v(xbgr.mr_n71940848)
print v(xbgr.mr_n71941168)
print v(xbgr.mr_n71941280)
print v(xbgr.mr_n71941600)
print v(xbgr.mr_n71941712)
print v(xbgr.mr_n71942032)
print v(xbgr.mr_n71942144)
print v(xbgr.mr_n71942464)
print v(xbgr.mr_n71942576)
print v(xbgr.mr_n71942896)
print v(xbgr.mr_n71943008)
print v(xbgr.mr_n71943328)
print v(xbgr.mr_n71943440)
print v(xbgr.mr_n71943760)
print v(xbgr.mr_n71943872)
print v(xbgr.mr_n71944192)
print v(xbgr.mr_n71944304)
print v(xbgr.mr_n71944624)
print v(xbgr.mr_n71944736)
print v(xbgr.mr_n71945056)
print v(xbgr.mr_n71945168)
print v(xbgr.mr_n71945488)
print v(xbgr.mr_n71945600)
print v(xbgr.mr_n71945920)
print v(xbgr.mr_n71946032)
print v(xbgr.mr_n71946352)
print v(xbgr.mr_n71946464)
print v(xbgr.mr_n71946784)
print v(xbgr.mr_n71946896)
print v(xbgr.mr_n71947216)
print v(xbgr.mr_n71947328)
print v(xbgr.mr_n71947648)
print v(xbgr.mr_n71947760)
print v(xbgr.mr_n71948080)
print v(xbgr.mr_n71948192)
print v(xbgr.mr_n71948512)
print v(xbgr.mr_n71948624)
print v(xbgr.mr_n71948944)
print v(xbgr.mr_n71949056)
print v(xbgr.mr_n71949376)
print v(xbgr.mr_n71949488)
print v(xbgr.mr_n71949808)
print v(xbgr.mr_n71949920)
print v(xbgr.mr_n71950240)
print v(xbgr.mr_n71950352)
print v(xbgr.mr_n71950672)
print v(xbgr.mr_n71950784)
print v(xbgr.mr_n71951104)
print v(xbgr.mr_n71951216)
print v(xbgr.mr_n71951536)
print v(xbgr.mr_n71951648)
print v(xbgr.mr_n71951968)
print v(xbgr.mr_n71952080)
print v(xbgr.mr_n71952400)
print v(xbgr.mr_n71952512)
print v(xbgr.mr_n71952832)
print v(xbgr.mr_n71952944)
print v(xbgr.mr_n71953264)
print v(xbgr.mr_n71953376)
print v(xbgr.mr_n71953696)
print v(xbgr.mr_n71953808)
print v(xbgr.mr_n71954128)
print v(xbgr.mr_n71954240)
print v(xbgr.mr_n71954560)
print v(xbgr.mr_n71954672)
print v(xbgr.mr_n71954992)
print v(xbgr.mr_n71955104)
print v(xbgr.mr_n71955424)
print v(xbgr.mr_n71955536)
print v(xbgr.mr_n71955856)
print v(xbgr.mr_n71955968)
print v(xbgr.mr_n71956288)
print v(xbgr.mr_n71956400)
print v(xbgr.mr_n71956720)
print v(xbgr.mr_n71956832)
print v(xbgr.mr_n71957152)
print v(xbgr.mr_n71957264)
print v(xbgr.mr_n71957584)
print v(xbgr.mr_n71957696)
print v(xbgr.mr_n71958016)
print v(xbgr.mr_n71958128)
print v(xbgr.mr_n71958448)
print v(xbgr.mr_n71958560)
print v(xbgr.mr_n71958880)
print v(xbgr.mr_n71958992)
print v(xbgr.mr_n71959312)
print v(xbgr.mr_n71959424)
print v(xbgr.mr_n71959744)
print v(xbgr.mr_n71959856)
print v(xbgr.mr_n71960176)
print v(xbgr.mr_n71960288)
print v(xbgr.mr_n71960608)
print v(xbgr.mr_n71960720)
print v(xbgr.mr_n71961040)
print v(xbgr.mr_n71961152)
print v(xbgr.mr_n71961472)
print v(xbgr.mr_n71961584)
print v(xbgr.mr_n71961904)
print v(xbgr.mr_n71962016)
print v(xbgr.mr_n71962336)
print v(xbgr.mr_n71962448)
print v(xbgr.mr_n71962768)
print v(xbgr.mr_n71962880)
print v(xbgr.mr_n71963200)
print v(xbgr.mr_n71963312)
print v(xbgr.mr_n71963632)
print v(xbgr.mr_n71963744)
print v(xbgr.mr_n71964064)
print v(xbgr.mr_n71964176)
print v(xbgr.mr_n71964496)
print v(xbgr.mr_n71964608)
print v(xbgr.mr_n71964928)
print v(xbgr.mr_n71965040)
print v(xbgr.mr_n71965360)
print v(xbgr.mr_n71965472)
print v(xbgr.mr_n71965792)
print v(xbgr.mr_n71965904)
print v(xbgr.mr_n71966224)
print v(xbgr.mr_n71966336)
print v(xbgr.mr_n71966656)
print v(xbgr.mr_n71966768)
print v(xbgr.mr_n71967088)
print v(xbgr.mr_n71967200)
print v(xbgr.mr_n71967520)
print v(xbgr.mr_n71967632)
print v(xbgr.mr_n71967952)
print v(xbgr.mr_n71968064)
print v(xbgr.mr_n71968384)
print v(xbgr.mr_n71968496)
print v(xbgr.mr_n71968816)
print v(xbgr.mr_n71968928)
print v(xbgr.mr_n71969248)
print v(xbgr.mr_n71969360)
print v(xbgr.mr_n71969680)
print v(xbgr.mr_n71969792)
print v(xbgr.mr_n71970112)
print v(xbgr.mr_n71970224)
print v(xbgr.mr_n71970544)
print v(xbgr.mr_n71970656)
print v(xbgr.mr_n71970976)
print v(xbgr.mr_n71971088)
print v(xbgr.mr_n71971408)
print v(xbgr.mr_n71971520)
print v(xbgr.mr_n71971840)
print v(xbgr.mr_n71971952)
print v(xbgr.mr_n71972272)
print v(xbgr.mr_n71972384)
print v(xbgr.mr_n71972704)
print v(xbgr.mr_n71972816)
print v(xbgr.mr_n71973136)
print v(xbgr.mr_n71973248)
print v(xbgr.mr_n71973568)
print v(xbgr.mr_n71973680)
print v(xbgr.mr_n71974000)
print v(xbgr.mr_n71974112)
print v(xbgr.mr_n71974432)
print v(xbgr.mr_n71974544)
print v(xbgr.mr_n71974864)
print v(xbgr.mr_n71974976)
print v(xbgr.mr_n71975296)
print v(xbgr.mr_n71975408)
print v(xbgr.mr_n71975728)
print v(xbgr.mr_n71975840)
print v(xbgr.mr_n71976160)
print v(xbgr.mr_n71976272)
print v(xbgr.mr_n71976592)
print v(xbgr.mr_n71976704)
print v(xbgr.mr_n71977024)
print v(xbgr.mr_n71977136)
print v(xbgr.mr_n71977456)
print v(xbgr.mr_n71977568)
print v(xbgr.mr_n71977888)
print v(xbgr.mr_n71978000)
print v(xbgr.mr_n71978320)
print v(xbgr.mr_n71978432)
print v(xbgr.mr_n71978752)
print v(xbgr.mr_n71978864)
print v(xbgr.mr_n71979184)
print v(xbgr.mr_n71979296)
print v(xbgr.mr_n71979616)
print v(xbgr.mr_n71979728)
print v(xbgr.mr_n71980048)
print v(xbgr.mr_n71980160)
print v(xbgr.mr_n71980480)
print v(xbgr.mr_n71980592)
print v(xbgr.mr_n71980912)
print v(xbgr.mr_n71981024)
print v(xbgr.mr_n71981344)
print v(xbgr.mr_n71981456)
print v(xbgr.mr_n71981776)
print v(xbgr.mr_n71981888)
print v(xbgr.mr_n71982208)
print v(xbgr.mr_n71982320)
print v(xbgr.mr_n71982640)
print v(xbgr.mr_n71982752)
print v(xbgr.mr_n71983072)
print v(xbgr.mr_n71983184)
print v(xbgr.mr_n71983504)
print v(xbgr.mr_n71983616)
print v(xbgr.mr_n71983936)
print v(xbgr.mr_n71984048)
print v(xbgr.mr_n71984368)
print v(xbgr.mr_n71984480)
print v(xbgr.mr_n71984800)
print v(xbgr.mr_n71984912)
print v(xbgr.mr_n71985232)
print v(xbgr.mr_n71985344)
print v(xbgr.mr_n71985664)
print v(xbgr.mr_n71985776)
print v(xbgr.mr_n71986096)
print v(xbgr.mr_n71986208)
print v(xbgr.mr_n71986528)
print v(xbgr.mr_n71986640)
print v(xbgr.mr_n71986960)
print v(xbgr.mr_n71987072)
print v(xbgr.mr_n71987392)
print v(xbgr.mr_n71987504)
print v(xbgr.mr_n71987824)
print v(xbgr.mr_n71987936)
print v(xbgr.mr_n71988256)
print v(xbgr.mr_n71988368)
print v(xbgr.mr_n71988688)
print v(xbgr.mr_n71988800)
print v(xbgr.mr_n71989120)
print v(xbgr.mr_n71989232)
print v(xbgr.mr_n71989552)
print v(xbgr.mr_n71989664)
print v(xbgr.mr_n71989984)
print v(xbgr.mr_n71990096)
print v(xbgr.mr_n71990416)
print v(xbgr.mr_n71990528)
print v(xbgr.mr_n71990848)
print v(xbgr.mr_n71990960)
print v(xbgr.mr_n71991280)
print v(xbgr.mr_n71991392)
print v(xbgr.mr_n71991712)
print v(xbgr.mr_n71991824)
print v(xbgr.mr_n71992144)
print v(xbgr.mr_n71992256)
print v(xbgr.mr_n71992576)
print v(xbgr.mr_n71992688)
print v(xbgr.mr_n71993008)
print v(xbgr.mr_n71993120)
print v(xbgr.mr_n71993440)
print v(xbgr.mr_n71993552)
print v(xbgr.mr_n71993872)
print v(xbgr.mr_n71993984)
print v(xbgr.mr_n71994304)
print v(xbgr.mr_n71994416)
print v(xbgr.mr_n71994736)
print v(xbgr.mr_n71994848)
print v(xbgr.mr_n71995168)
print v(xbgr.mr_n71995280)
print v(xbgr.mr_n71995600)
print v(xbgr.mr_n71995712)
print v(xbgr.mr_n71996032)
print v(xbgr.mr_n71996144)
print v(xbgr.mr_n71996464)
print v(xbgr.mr_n71996576)
print v(xbgr.mr_n71996896)
print v(xbgr.mr_n71997008)
print v(xbgr.mr_n71997328)
print v(xbgr.mr_n71997440)
print v(xbgr.mr_n71997760)
print v(xbgr.mr_n71997872)
print v(xbgr.mr_n71998192)
print v(xbgr.mr_n71998304)
print v(xbgr.mr_n71998624)
print v(xbgr.mr_n71998736)
print v(xbgr.mr_n71999056)
print v(xbgr.mr_n71999168)
print v(xbgr.mr_n71999488)
print v(xbgr.mr_n71999600)
print v(xbgr.mr_n71999920)
print v(xbgr.mr_n72000032)
print v(xbgr.mr_n72000352)
print v(xbgr.mr_n72000464)
print v(xbgr.mr_n72000784)
print v(xbgr.mr_n72000896)
print v(xbgr.mr_n72001216)
print v(xbgr.mr_n72001328)
print v(xbgr.mr_n72001648)
print v(xbgr.mr_n72001760)
print v(xbgr.mr_n72002080)
print v(xbgr.mr_n72002192)
print v(xbgr.mr_n72002512)
print v(xbgr.mr_n72002624)
print v(xbgr.mr_n72002944)
print v(xbgr.mr_n72003056)
print v(xbgr.mr_n72003376)
print v(xbgr.mr_n72003488)
print v(xbgr.mr_n72003808)
print v(xbgr.mr_n72003920)
print v(xbgr.mr_n72004240)
print v(xbgr.mr_n72004352)
print v(xbgr.mr_n72004672)
print v(xbgr.mr_n72004784)
print v(xbgr.mr_n72005104)
print v(xbgr.mr_n72005216)
print v(xbgr.mr_n72005536)
print v(xbgr.mr_n72005648)
print v(xbgr.mr_n72005968)
print v(xbgr.mr_n72006080)
print v(xbgr.mr_n72006400)
print v(xbgr.mr_n72006512)
print v(xbgr.mr_n72006832)
print v(xbgr.mr_n72006944)
print v(xbgr.mr_n72007264)
print v(xbgr.mr_n72007376)
print v(xbgr.mr_n72007696)
print v(xbgr.mr_n72007808)
print v(xbgr.mr_n72008128)
print v(xbgr.mr_n72008240)
print v(xbgr.mr_n72008560)
print v(xbgr.mr_n72008672)
print v(xbgr.mr_n72008992)
print v(xbgr.mr_n72009104)
print v(xbgr.mr_n72009424)
print v(xbgr.mr_n72009536)
print v(xbgr.mr_n72009856)
print v(xbgr.mr_n72009968)
print v(xbgr.mr_n72010288)
print v(xbgr.mr_n72010400)
print v(xbgr.mr_n72010720)
print v(xbgr.mr_n72010832)
print v(xbgr.mr_n72011152)
print v(xbgr.mr_n72011264)
print v(xbgr.mr_n72011584)
print v(xbgr.mr_n72011696)
print v(xbgr.mr_n72012016)
print v(xbgr.mr_n72012128)
print v(xbgr.mr_n72012448)
print v(xbgr.mr_n72012560)
print v(xbgr.mr_n72012880)
print v(xbgr.mr_n72012992)
print v(xbgr.mr_n72013312)
print v(xbgr.mr_n72013424)
print v(xbgr.mr_n72013744)
print v(xbgr.mr_n72013856)
print v(xbgr.mr_n72014176)
print v(xbgr.mr_n72014288)
print v(xbgr.mr_n72014608)
print v(xbgr.mr_n72014720)
print v(xbgr.mr_n72015040)
print v(xbgr.mr_n72015152)
print v(xbgr.mr_n72015472)
print v(xbgr.mr_n72015584)
print v(xbgr.mr_n72015904)
print v(xbgr.mr_n72016016)
print v(xbgr.mr_n72016336)
print v(xbgr.mr_n72016448)
print v(xbgr.mr_n72016768)
print v(xbgr.mr_n72016880)
print v(xbgr.mr_n72017200)
print v(xbgr.mr_n72017312)
print v(xbgr.mr_n72017632)
print v(xbgr.mr_n72017744)
print v(xbgr.mr_n72018064)
print v(xbgr.mr_n72018176)
print v(xbgr.mr_n72018496)
print v(xbgr.mr_n72018608)
print v(xbgr.mr_n72018928)
print v(xbgr.mr_n72019040)
print v(xbgr.mr_n72019360)
print v(xbgr.mr_n72019472)
print v(xbgr.mr_n72019792)
print v(xbgr.mr_n72019904)
print v(xbgr.mr_n72020224)
print v(xbgr.mr_n72020336)
print v(xbgr.mr_n72020656)
print v(xbgr.mr_n72020768)
print v(xbgr.mr_n72021088)
print v(xbgr.mr_n72021200)
print v(xbgr.mr_n72021520)
print v(xbgr.mr_n72021632)
print v(xbgr.mr_n72021952)
print v(xbgr.mr_n72022064)
print v(xbgr.mr_n72022384)
print v(xbgr.mr_n72022496)
print v(xbgr.mr_n72022816)
print v(xbgr.mr_n72022928)
print v(xbgr.mr_n72023248)
print v(xbgr.mr_n72023360)
print v(xbgr.mr_n72023680)
print v(xbgr.mr_n72023792)
print v(xbgr.mr_n72024112)
print v(xbgr.mr_n72024224)
print v(xbgr.mr_n72024544)
print v(xbgr.mr_n72024656)
print v(xbgr.mr_n72024976)
print v(xbgr.mr_n72025088)
print v(xbgr.mr_n72025408)
print v(xbgr.mr_n72025520)
print v(xbgr.mr_n72025840)
print v(xbgr.mr_n72025952)
print v(xbgr.mr_n72026272)
print v(xbgr.mr_n72026384)
print v(xbgr.mr_n72026704)
print v(xbgr.mr_n72026816)
print v(xbgr.mr_n72027136)
print v(xbgr.mr_n72027248)
print v(xbgr.mr_n72027568)
print v(xbgr.mr_n72027680)
print v(xbgr.mr_n72028000)
print v(xbgr.mr_n72028112)
print v(xbgr.mr_n72028432)
print v(xbgr.mr_n72028544)
print v(xbgr.mr_n72028864)
print v(xbgr.mr_n72028976)
print v(xbgr.mr_n72029296)
print v(xbgr.mr_n72029408)
print v(xbgr.mr_n72029728)
print v(xbgr.mr_n72029840)
print v(xbgr.mr_n72030160)
print v(xbgr.mr_n72030272)
print v(xbgr.mr_n72030592)
print v(xbgr.mr_n72030704)
print v(xbgr.mr_n72031024)
print v(xbgr.mr_n72031136)
print v(xbgr.mr_n72031456)
print v(xbgr.mr_n72031568)
print v(xbgr.mr_n72031888)
print v(xbgr.mr_n72032000)
print v(xbgr.mr_n72032320)
print v(xbgr.mr_n72032432)
print v(xbgr.mr_n72032752)
print v(xbgr.mr_n72032864)
print v(xbgr.mr_n72033184)
print v(xbgr.mr_n72033296)
print v(xbgr.mr_n72033616)
print v(xbgr.mr_n72033728)
print v(xbgr.mr_n72034048)
print v(xbgr.mr_n72034160)
print v(xbgr.mr_n72034480)
print v(xbgr.mr_n72034592)
print v(xbgr.mr_n72034912)
print v(xbgr.mr_n72035024)
print v(xbgr.mr_n72035344)
print v(xbgr.mr_n72035456)
print v(xbgr.mr_n72035776)
print v(xbgr.mr_n72035888)
print v(xbgr.mr_n72036208)
print v(xbgr.mr_n72036320)
print v(xbgr.mr_n72036640)
print v(xbgr.mr_n72036752)
print v(xbgr.mr_n72037072)
print v(xbgr.mr_n72037184)
print v(xbgr.mr_n72037504)
print v(xbgr.mr_n72037616)
print v(xbgr.mr_n72037936)
print v(xbgr.mr_n72038048)
print v(xbgr.mr_n72038368)
print v(xbgr.mr_n72038480)
print v(xbgr.mr_n72038800)
print v(xbgr.mr_n72038912)
print v(xbgr.mr_n72039232)
print v(xbgr.mr_n72039344)
print v(xbgr.mr_n72039664)
print v(xbgr.mr_n72039776)
print v(xbgr.mr_n72040096)
print v(xbgr.mr_n72040208)
print v(xbgr.mr_n72040528)
print v(xbgr.mr_n72040640)
print v(xbgr.mr_n72040960)
print v(xbgr.mr_n72041072)
print v(xbgr.mr_n72041392)
print v(xbgr.mr_n72041504)
print v(xbgr.mr_n72041824)
print v(xbgr.mr_n72041936)
print v(xbgr.mr_n72042256)
print v(xbgr.mr_n72042368)
print v(xbgr.mr_n72042688)
print v(xbgr.mr_n72042800)
print v(xbgr.mr_n72043120)
print v(xbgr.mr_n72043232)
print v(xbgr.mr_n72043552)
print v(xbgr.mr_n72043664)
print v(xbgr.mr_n72043984)
print v(xbgr.mr_n72044096)
print v(xbgr.mr_n72044416)
print v(xbgr.mr_n72044528)
print v(xbgr.mr_n72044848)
print v(xbgr.mr_n72044960)
print v(xbgr.mr_n72045280)
print v(xbgr.mr_n72045392)
print v(xbgr.mr_n72045712)
print v(xbgr.mr_n72045824)
print v(xbgr.mr_n72046144)
print v(xbgr.mr_n72046256)
print v(xbgr.mr_n72046576)
print v(xbgr.mr_n72046688)
print v(xbgr.mr_n72047008)
print v(xbgr.mr_n72047120)
print v(xbgr.mr_n72047440)
print v(xbgr.mr_n72047552)
print v(xbgr.mr_n72047872)
print v(xbgr.mr_n72047984)
print v(xbgr.mr_n72048304)
print v(xbgr.mr_n72048416)
print v(xbgr.mr_n72048736)
print v(xbgr.mr_n72048848)
print v(xbgr.mr_n72049168)
print v(xbgr.mr_n72049280)
print v(xbgr.mr_n72049600)
print v(xbgr.mr_n72049712)
print v(xbgr.mr_n72050032)
print v(xbgr.mr_n72050144)
print v(xbgr.mr_n72050464)
print v(xbgr.mr_n72050576)
print v(xbgr.mr_n72050896)
print v(xbgr.mr_n72051008)
print v(xbgr.mr_n72051328)
print v(xbgr.mr_n72051440)
print v(xbgr.mr_n72051760)
print v(xbgr.mr_n72051872)
print v(xbgr.mr_n72052192)
print v(xbgr.mr_n72052304)
print v(xbgr.mr_n72052624)
print v(xbgr.mr_n72052736)
print v(xbgr.mr_n72053056)
print v(xbgr.mr_n72053168)
print v(xbgr.mr_n72053488)
print v(xbgr.mr_n72053600)
print v(xbgr.mr_n72053920)
print v(xbgr.mr_n72054032)
print v(xbgr.mr_n72054352)
print v(xbgr.mr_n72054464)
print v(xbgr.mr_n72054784)
print v(xbgr.mr_n72054896)
print v(xbgr.mr_n72055216)
print v(xbgr.mr_n72055328)
print v(xbgr.mr_n72055648)
print v(xbgr.mr_n72055760)
print v(xbgr.mr_n72056080)
print v(xbgr.mr_n72056192)
print v(xbgr.mr_n72056512)
print v(xbgr.mr_n72056624)
print v(xbgr.mr_n72056944)
print v(xbgr.mr_n72057056)
print v(xbgr.mr_n72057376)
print v(xbgr.mr_n72057488)
print v(xbgr.mr_n72057808)
print v(xbgr.mr_n72057920)
print v(xbgr.mr_n72058240)
print v(xbgr.mr_n72058352)
print v(xbgr.mr_n72058672)
print v(xbgr.mr_n72058784)
print v(xbgr.mr_n72059104)
print v(xbgr.mr_n72059216)
print v(xbgr.mr_n72059536)
print v(xbgr.mr_n72059648)
print v(xbgr.mr_n72059968)
print v(xbgr.mr_n72060080)
print v(xbgr.mr_n72060400)
print v(xbgr.mr_n72060512)
print v(xbgr.mr_n72060832)
print v(xbgr.mr_n72060944)
print v(xbgr.mr_n72061264)
print v(xbgr.mr_n72061376)
print v(xbgr.mr_n72061696)
print v(xbgr.mr_n72061808)
print v(xbgr.mr_n72062128)
print v(xbgr.mr_n72062240)
print v(xbgr.mr_n72062560)
print v(xbgr.mr_n72062672)
print v(xbgr.mr_n72062992)
print v(xbgr.mr_n72063104)
print v(xbgr.mr_n72063424)
print v(xbgr.mr_n72063536)
print v(xbgr.mr_n72063856)
print v(xbgr.mr_n72063968)
print v(xbgr.mr_n72064400)
print v(xbgr.mr_n72064720)
print v(xbgr.mr_n72064832)
print v(xbgr.mr_n72065152)
print v(xbgr.mr_n72065264)
print v(xbgr.mr_n72065584)
print v(xbgr.mr_n72065696)
print v(xbgr.mr_n72066128)
print v(xbgr.mr_n72066448)
print v(xbgr.mr_n72066560)
print v(xbgr.mr_n72066880)
print v(xbgr.mr_n72066992)
print v(xbgr.mr_n72067312)
print v(xbgr.mr_n72067424)
print v(xbgr.mr_n72067744)
print v(xbgr.mr_n72067856)
print v(xbgr.mr_n72068176)
print v(xbgr.mr_n72068288)
print v(xbgr.mr_n72068608)
print v(xbgr.mr_n72068720)
print v(xbgr.mr_n72069040)
print v(xbgr.mr_n72069152)
print v(xbgr.mr_n72069472)
print v(xbgr.mr_n72069584)
print v(xbgr.mr_n72069904)
print v(xbgr.mr_n72070016)
print v(xbgr.mr_n72070336)
print v(xbgr.mr_n72070448)
print v(xbgr.mr_n72070768)
print v(xbgr.mr_n72070880)
print v(xbgr.mr_n72071200)
print v(xbgr.mr_n72071312)
print v(xbgr.mr_n72071632)
print v(xbgr.mr_n72071744)
print v(xbgr.mr_n72072064)
print v(xbgr.mr_n72072176)
print v(xbgr.mr_n72072496)
print v(xbgr.mr_n72072608)
print v(xbgr.mr_n72073040)
print v(xbgr.mr_n72073360)
print v(xbgr.mr_n72073472)
print v(xbgr.mr_n72073792)
print v(xbgr.mr_n72073904)
print v(xbgr.mr_n72074224)
print v(xbgr.mr_n72074336)
print v(xbgr.mr_n72074656)
print v(xbgr.mr_n72074768)
print v(xbgr.mr_n72075088)
print v(xbgr.mr_n72075200)
print v(xbgr.mr_n72075520)
print v(xbgr.mr_n72075632)
print v(xbgr.mr_n72075952)
print v(xbgr.mr_n72076064)
print v(xbgr.mr_n72076496)
print v(xbgr.mr_n72076816)
print v(xbgr.mr_n72076928)
print v(xbgr.mr_n72077248)
print v(xbgr.mr_n72077360)
print v(xbgr.mr_n72077680)
print v(xbgr.mr_n72077792)
print v(xbgr.mr_n72078112)
print v(xbgr.mr_n72078224)
print v(xbgr.mr_n72078544)
print v(xbgr.mr_n72078656)
print v(xbgr.mr_n72078976)
print v(xbgr.mr_n72079088)
print v(xbgr.mr_n72079408)
print v(xbgr.mr_n72079520)
print v(xbgr.mr_n72079840)
print v(xbgr.mr_n72079952)
print v(xbgr.mr_n72080272)
print v(xbgr.mr_n72080384)
print v(xbgr.mr_n72080704)
print v(xbgr.mr_n72080816)
print v(xbgr.mr_n72081136)
print v(xbgr.mr_n72081248)
print v(xbgr.mr_n72081568)
print v(xbgr.mr_n72081680)
print v(xbgr.mr_n72082000)
print v(xbgr.mr_n72082112)
print v(xbgr.mr_n72082544)
print v(xbgr.mr_n72082864)
print v(xbgr.mr_n72082976)
print v(xbgr.mr_n72083296)
print v(xbgr.mr_n72083408)
print v(xbgr.mr_n72083728)
print v(xbgr.mr_n72083840)
print v(xbgr.mr_n72084272)
print v(xbgr.mr_n72084592)
print v(xbgr.mr_n72084704)
print v(xbgr.mr_n72085024)
print v(xbgr.mr_n72085136)
print v(xbgr.mr_n72085456)
print v(xbgr.mr_n72085568)
print v(xbgr.mr_n72085888)
print v(xbgr.mr_n72086000)
print v(xbgr.mr_n72086320)
print v(xbgr.mr_n72086432)
print v(xbgr.mr_n72086864)
print v(xbgr.mr_n72087184)
print v(xbgr.mr_n72087296)
print v(xbgr.mr_n72087616)
print v(xbgr.mr_n72087728)
print v(xbgr.mr_n72088048)
print v(xbgr.mr_n72088160)
print v(xbgr.mr_n72088480)
print v(xbgr.mr_n72088592)
print v(xbgr.mr_n72088912)
print v(xbgr.mr_n72089024)
print v(xbgr.mr_n72089344)
print v(xbgr.mr_n72089456)
print v(xbgr.mr_n72089776)
print v(xbgr.mr_n72089888)
print v(xbgr.mr_n72090208)
print v(xbgr.mr_n72090320)
print v(xbgr.mr_n72090640)
print v(xbgr.mr_n72090752)
print v(xbgr.mr_n72091072)
print v(xbgr.mr_n72091184)
print v(xbgr.mr_n72091504)
print v(xbgr.mr_n72091616)
print v(xbgr.mr_n72091936)
print v(xbgr.mr_n72092048)
print v(xbgr.mr_n72092368)
print v(xbgr.mr_n72092480)
print v(xbgr.mr_n72092912)
print v(xbgr.mr_n72093232)
print v(xbgr.mr_n72093344)
print v(xbgr.mr_n72093664)
print v(xbgr.mr_n72093776)
print v(xbgr.mr_n72094096)
print v(xbgr.mr_n72094208)
print v(xbgr.mr_n72094640)
print v(xbgr.mr_n72094960)
print v(xbgr.mr_n72095072)
print v(xbgr.mr_n72095504)
print v(xbgr.mr_n72095824)
print v(xbgr.mr_n72095936)
print v(xbgr.mr_n72096256)
print v(xbgr.mr_n72096368)
print v(xbgr.mr_n72096688)
print v(xbgr.mr_n72096800)
print v(xbgr.mr_n72097232)
print v(xbgr.mr_n72097552)
print v(xbgr.mr_n72097664)
print v(xbgr.mr_n72097984)
print v(xbgr.mr_n72098096)
print v(xbgr.mr_n72098416)
print v(xbgr.mr_n72098528)
print v(xbgr.mr_n72098848)
print v(xbgr.mr_n72098960)
print v(xbgr.mr_n72099280)
print v(xbgr.mr_n72099392)
print v(xbgr.mr_n72099712)
print v(xbgr.mr_n72099824)
print v(xbgr.mr_n72100144)
print v(xbgr.mr_n72100256)
print v(xbgr.mr_n72100576)
print v(xbgr.mr_n72100688)
print v(xbgr.mr_n72101008)
print v(xbgr.mr_n72101120)
print v(xbgr.mr_n72101552)
print v(xbgr.mr_n72101872)
print v(xbgr.mr_n72101984)
print v(xbgr.mr_n72102304)
print v(xbgr.mr_n72102416)
print v(xbgr.mr_n72102736)
print v(xbgr.mr_n72102848)
print v(xbgr.mr_n72103168)
print v(xbgr.mr_n72103280)
print v(xbgr.mr_n72103600)
print v(xbgr.mr_n72103712)
print v(xbgr.mr_n72104032)
print v(xbgr.mr_n72104144)
print v(xbgr.mr_n72104464)
print v(xbgr.mr_n72104576)
print v(xbgr.mr_n72104896)
print v(xbgr.mr_n72105008)
print v(xbgr.mr_n72105328)
print v(xbgr.mr_n72105440)
print v(xbgr.mr_n72105760)
print v(xbgr.mr_n72105872)
print v(xbgr.mr_n72106192)
print v(xbgr.mr_n72106304)
print v(xbgr.mr_n72106624)
print v(xbgr.mr_n72106736)
print v(xbgr.mr_n72107056)
print v(xbgr.mr_n72107168)
print v(xbgr.mr_n72107488)
print v(xbgr.mr_n72107600)
print v(xbgr.mr_n72107920)
print v(xbgr.mr_n72108032)
print v(xbgr.mr_n72108352)
print v(xbgr.mr_n72108464)
print v(xbgr.mr_n72108784)
print v(xbgr.mr_n72108896)
print v(xbgr.mr_n72109216)
print v(xbgr.mr_n72109328)
print v(xbgr.mr_n72109648)
print v(xbgr.mr_n72109760)
print v(xbgr.mr_n72110080)
print v(xbgr.mr_n72110192)
print v(xbgr.mr_n72110512)
print v(xbgr.mr_n72110624)
print v(xbgr.mr_n72110944)
print v(xbgr.mr_n72111056)
print v(xbgr.mr_n72111376)
print v(xbgr.mr_n72111488)
print v(xbgr.mr_n72111808)
print v(xbgr.mr_n72111920)
print v(xbgr.mr_n72112240)
print v(xbgr.mr_n72112352)
print v(xbgr.mr_n72112672)
print v(xbgr.mr_n72112784)
print v(xbgr.mr_n72113104)
print v(xbgr.mr_n72113216)
print v(xbgr.mr_n72113536)
print v(xbgr.mr_n72113648)
print v(xbgr.mr_n72113968)
print v(xbgr.mr_n72114080)
print v(xbgr.mr_n72114400)
print v(xbgr.mr_n72114512)
print v(xbgr.mr_n72114832)
print v(xbgr.mr_n72114944)
print v(xbgr.mr_n72115264)
print v(xbgr.mr_n72115376)
print v(xbgr.mr_n72115696)
print v(xbgr.mr_n72115808)
print v(xbgr.mr_n72116128)
print v(xbgr.mr_n72116240)
print v(xbgr.mr_n72116560)
print v(xbgr.mr_n72116672)
print v(xbgr.mr_n72116992)
print v(xbgr.mr_n72117104)
print v(xbgr.mr_n72117424)
print v(xbgr.mr_n72117536)
print v(xbgr.mr_n72117856)
print v(xbgr.mr_n72117968)
print v(xbgr.mr_n72118288)
print v(xbgr.mr_n72118400)
print v(xbgr.mr_n72118720)
print v(xbgr.mr_n72118832)
print v(xbgr.mr_n72119152)
print v(xbgr.mr_n72119264)
print v(xbgr.mr_n72119584)
print v(xbgr.mr_n72119696)
print v(xbgr.mr_n72120016)
print v(xbgr.mr_n72120128)
print v(xbgr.mr_n72120448)
print v(xbgr.mr_n72120560)
print v(xbgr.mr_n72120880)
print v(xbgr.mr_n72120992)
print v(xbgr.mr_n72121312)
print v(xbgr.mr_n72121424)
print v(xbgr.mr_n72121744)
print v(xbgr.mr_n72121856)
print v(xbgr.mr_n72122176)
print v(xbgr.mr_n72122288)
print v(xbgr.mr_n72122608)
print v(xbgr.mr_n72122720)
print v(xbgr.mr_n72123040)
print v(xbgr.mr_n72123152)
print v(xbgr.mr_n72123472)
print v(xbgr.mr_n72123584)
print v(xbgr.mr_n72123904)
print v(xbgr.mr_n72124016)
print v(xbgr.mr_n72124336)
print v(xbgr.mr_n72124448)
print v(xbgr.mr_n72124768)
print v(xbgr.mr_n72124880)
print v(xbgr.mr_n72125200)
print v(xbgr.mr_n72125312)
print v(xbgr.mr_n72125632)
print v(xbgr.mr_n72125744)
print v(xbgr.mr_n72126064)
print v(xbgr.mr_n72126176)
print v(xbgr.mr_n72126496)
print v(xbgr.mr_n72126608)
print v(xbgr.mr_n72126928)
print v(xbgr.mr_n72127040)
print v(xbgr.mr_n72127360)
print v(xbgr.mr_n72127472)
print v(xbgr.mr_n72127792)
print v(xbgr.mr_n72127904)
print v(xbgr.mr_n72128224)
print v(xbgr.mr_n72128336)
print v(xbgr.mr_n72128656)
print v(xbgr.mr_n72128768)
print v(xbgr.mr_n72129088)
print v(xbgr.mr_n72129200)
print v(xbgr.mr_n72129520)
print v(xbgr.mr_n72129632)
print v(xbgr.mr_n72129952)
print v(xbgr.mr_n72130064)
print v(xbgr.mr_n72130384)
print v(xbgr.mr_n72130496)
print v(xbgr.mr_n72130816)
print v(xbgr.mr_n72130928)
print v(xbgr.mr_n72131248)
print v(xbgr.mr_n72131360)
print v(xbgr.mr_n72131680)
print v(xbgr.mr_n72131792)
print v(xbgr.mr_n72132112)
print v(xbgr.mr_n72132224)
print v(xbgr.mr_n72132544)
print v(xbgr.mr_n72132656)
print v(xbgr.mr_n72132976)
print v(xbgr.mr_n72133088)
print v(xbgr.mr_n72133408)
print v(xbgr.mr_n72133520)
print v(xbgr.mr_n72133840)
print v(xbgr.mr_n72133952)
print v(xbgr.mr_n72134272)
print v(xbgr.mr_n72134384)
print v(xbgr.mr_n72134704)
print v(xbgr.mr_n72134816)
print v(xbgr.mr_n72135136)
print v(xbgr.mr_n72135248)
print v(xbgr.mr_n72135568)
print v(xbgr.mr_n72135680)
print v(xbgr.mr_n72136000)
print v(xbgr.mr_n72136112)
print v(xbgr.mr_n72136432)
print v(xbgr.mr_n72136544)
print v(xbgr.mr_n72136864)
print v(xbgr.mr_n72136976)
print v(xbgr.mr_n72137296)
print v(xbgr.mr_n72137408)
print v(xbgr.mr_n72137728)
print v(xbgr.mr_n72137840)
print v(xbgr.mr_n72138160)
print v(xbgr.mr_n72138272)
print v(xbgr.mr_n72138592)
print v(xbgr.mr_n72138704)
print v(xbgr.mr_n72139024)
print v(xbgr.mr_n72139136)
print v(xbgr.mr_n72139456)
print v(xbgr.mr_n72139568)
print v(xbgr.mr_n72139888)
print v(xbgr.mr_n72140000)
print v(xbgr.mr_n72140320)
print v(xbgr.mr_n72140432)
print v(xbgr.mr_n72140752)
print v(xbgr.mr_n72140864)
print v(xbgr.mr_n72141184)
print v(xbgr.mr_n72141296)
print v(xbgr.mr_n72141616)
print v(xbgr.mr_n72141728)
print v(xbgr.mr_n72142048)
print v(xbgr.mr_n72142160)
print v(xbgr.mr_n72142480)
print v(xbgr.mr_n72142592)
print v(xbgr.mr_n72142912)
print v(xbgr.mr_n72143024)
print v(xbgr.mr_n72143344)
print v(xbgr.mr_n72143456)
print v(xbgr.mr_n72143776)
print v(xbgr.mr_n72143888)
print v(xbgr.mr_n72144208)
print v(xbgr.mr_n72144320)
print v(xbgr.mr_n72144640)
print v(xbgr.mr_n72144752)
print v(xbgr.mr_n72145072)
print v(xbgr.mr_n72145184)
print v(xbgr.mr_n72145504)
print v(xbgr.mr_n72145616)
print v(xbgr.mr_n72145936)
print v(xbgr.mr_n72146048)
print v(xbgr.mr_n72146368)
print v(xbgr.mr_n72146480)
print v(xbgr.mr_n72146800)
print v(xbgr.mr_n72146912)
print v(xbgr.mr_n72147232)
print v(xbgr.mr_n72147344)
print v(xbgr.mr_n72147664)
print v(xbgr.mr_n72147776)
print v(xbgr.mr_n72148096)
print v(xbgr.mr_n72148208)
print v(xbgr.mr_n72148528)
print v(xbgr.mr_n72148640)
print v(xbgr.mr_n72148960)
print v(xbgr.mr_n72149072)
print v(xbgr.mr_n72149392)
print v(xbgr.mr_n72149504)
print v(xbgr.mr_n72149824)
print v(xbgr.mr_n72149936)
print v(xbgr.mr_n72150256)
print v(xbgr.mr_n72150368)
print v(xbgr.mr_n72150688)
print v(xbgr.mr_n72150800)
print v(xbgr.mr_n72151120)
print v(xbgr.mr_n72151232)
print v(xbgr.mr_n72151552)
print v(xbgr.mr_n72151664)
print v(xbgr.mr_n72151984)
print v(xbgr.mr_n72152096)
print v(xbgr.mr_n72152416)
print v(xbgr.mr_n72152528)
print v(xbgr.mr_n72152848)
print v(xbgr.mr_n72152960)
print v(xbgr.mr_n72153280)
print v(xbgr.mr_n72153392)
print v(xbgr.mr_n72153712)
print v(xbgr.mr_n72153824)
print v(xbgr.mr_n72154144)
print v(xbgr.mr_n72154256)
print v(xbgr.mr_n72154576)
print v(xbgr.mr_n72154688)
print v(xbgr.mr_n72155008)
print v(xbgr.mr_n72155120)
print v(xbgr.mr_n72155440)
print v(xbgr.mr_n72155552)
print v(xbgr.mr_n72155872)
print v(xbgr.mr_n72155984)
print v(xbgr.mr_n72156304)
print v(xbgr.mr_n72156416)
print v(xbgr.mr_n72156736)
print v(xbgr.mr_n72156848)
print v(xbgr.mr_n72157168)
print v(xbgr.mr_n72157280)
print v(xbgr.mr_n72157600)
print v(xbgr.mr_n72157712)
print v(xbgr.mr_n72158032)
print v(xbgr.mr_n72158144)
print v(xbgr.mr_n72158464)
print v(xbgr.mr_n72158576)
print v(xbgr.mr_n72158896)
print v(xbgr.mr_n72159008)
print v(xbgr.mr_n72159328)
print v(xbgr.mr_n72159440)
print v(xbgr.mr_n72159760)
print v(xbgr.mr_n72159872)
print v(xbgr.mr_n72160192)
print v(xbgr.mr_n72160304)
print v(xbgr.mr_n72160624)
print v(xbgr.mr_n72160736)
print v(xbgr.mr_n72161056)
print v(xbgr.mr_n72161168)
print v(xbgr.mr_n72161488)
print v(xbgr.mr_n72161600)
print v(xbgr.mr_n72161920)
print v(xbgr.mr_n72162032)
print v(xbgr.mr_n72162352)
print v(xbgr.mr_n72162464)
print v(xbgr.mr_n72162784)
print v(xbgr.mr_n72162896)
print v(xbgr.mr_n72163216)
print v(xbgr.mr_n72163328)
print v(xbgr.mr_n72163648)
print v(xbgr.mr_n72163760)
print v(xbgr.mr_n72164080)
print v(xbgr.mr_n72164192)
print v(xbgr.mr_n72164512)
print v(xbgr.mr_n72164624)
print v(xbgr.mr_n72164944)
print v(xbgr.mr_n72165056)
print v(xbgr.mr_n72165376)
print v(xbgr.mr_n72165488)
print v(xbgr.mr_n72165808)
print v(xbgr.mr_n72165920)
print v(xbgr.mr_n72166240)
print v(xbgr.mr_n72166352)
print v(xbgr.mr_n72166672)
print v(xbgr.mr_n72166784)
print v(xbgr.mr_n72167104)
print v(xbgr.mr_n72167216)
print v(xbgr.mr_n72167536)
print v(xbgr.mr_n72167648)
print v(xbgr.mr_n72167968)
print v(xbgr.mr_n72168080)
print v(xbgr.mr_n72168400)
print v(xbgr.mr_n72168512)
print v(xbgr.mr_n72168832)
print v(xbgr.mr_n72168944)
print v(xbgr.mr_n72169264)
print v(xbgr.mr_n72169376)
print v(xbgr.mr_n72169696)
print v(xbgr.mr_n72169808)
print v(xbgr.mr_n72170128)
print v(xbgr.mr_n72170240)
print v(xbgr.mr_n72170560)
print v(xbgr.mr_n72170672)
print v(xbgr.mr_n72170992)
print v(xbgr.mr_n72171104)
print v(xbgr.mr_n72171424)
print v(xbgr.mr_n72171536)
print v(xbgr.mr_n72171856)
print v(xbgr.mr_n72171968)
print v(xbgr.mr_n72172288)
print v(xbgr.mr_n72172400)
print v(xbgr.mr_n72172720)
print v(xbgr.mr_n72172832)
print v(xbgr.mr_n72173152)
print v(xbgr.mr_n72173264)
print v(xbgr.mr_n72173584)
print v(xbgr.mr_n72173696)
print v(xbgr.mr_n72174016)
print v(xbgr.mr_n72174128)
print v(xbgr.mr_n72174448)
print v(xbgr.mr_n72174560)
print v(xbgr.mr_n72174880)
print v(xbgr.mr_n72174992)
print v(xbgr.mr_n72175312)
print v(xbgr.mr_n72175424)
print v(xbgr.mr_n72175744)
print v(xbgr.mr_n72175856)
print v(xbgr.mr_n72176176)
print v(xbgr.mr_n72176288)
print v(xbgr.mr_n72176608)
print v(xbgr.mr_n72176720)
print v(xbgr.mr_n72177040)
print v(xbgr.mr_n72177152)
print v(xbgr.mr_n72177472)
print v(xbgr.mr_n72177584)
print v(xbgr.mr_n72177904)
print v(xbgr.mr_n72178016)
print v(xbgr.mr_n72178336)
print v(xbgr.mr_n72178448)
print v(xbgr.mr_n72178768)
print v(xbgr.mr_n72178880)
print v(xbgr.mr_n72179200)
print v(xbgr.mr_n72179312)
print v(xbgr.mr_n72179632)
print v(xbgr.mr_n72179744)
print v(xbgr.mr_n72180064)
print v(xbgr.mr_n72180176)
print v(xbgr.mr_n72180496)
print v(xbgr.mr_n72180608)
print v(xbgr.mr_n72180928)
print v(xbgr.mr_n72181040)
print v(xbgr.mr_n72181360)
print v(xbgr.mr_n72181472)
print v(xbgr.mr_n72181792)
print v(xbgr.mr_n72181904)
print v(xbgr.mr_n72182224)
print v(xbgr.mr_n72182336)
print v(xbgr.mr_n72182656)
print v(xbgr.mr_n72182768)
print v(xbgr.mr_n72183088)
print v(xbgr.mr_n72183200)
print v(xbgr.mr_n72183520)
print v(xbgr.mr_n72183632)
print v(xbgr.mr_n72183952)
print v(xbgr.mr_n72184064)
print v(xbgr.mr_n72184384)
print v(xbgr.mr_n72184496)
print v(xbgr.mr_n72184816)
print v(xbgr.mr_n72184928)
print v(xbgr.mr_n72185248)
print v(xbgr.mr_n72185360)
print v(xbgr.mr_n72185680)
print v(xbgr.mr_n72185792)
print v(xbgr.mr_n72186112)
print v(xbgr.mr_n72186224)
print v(xbgr.mr_n72186544)
print v(xbgr.mr_n72186656)
print v(xbgr.mr_n72186976)
print v(xbgr.mr_n72187088)
print v(xbgr.mr_n72187408)
print v(xbgr.mr_n72187520)
print v(xbgr.mr_n72187840)
print v(xbgr.mr_n72187952)
print v(xbgr.mr_n72188272)
print v(xbgr.mr_n72188384)
print v(xbgr.mr_n72188704)
print v(xbgr.mr_n72188816)
print v(xbgr.mr_n72189136)
print v(xbgr.mr_n72189248)
print v(xbgr.mr_n72189568)
print v(xbgr.mr_n72189680)
print v(xbgr.mr_n72190000)
print v(xbgr.mr_n72190112)
print v(xbgr.mr_n72190432)
print v(xbgr.mr_n72190544)
print v(xbgr.mr_n72190864)
print v(xbgr.mr_n72190976)
print v(xbgr.mr_n72191296)
print v(xbgr.mr_n72191408)
print v(xbgr.mr_n72191728)
print v(xbgr.mr_n72191840)
print v(xbgr.mr_n72192160)
print v(xbgr.mr_n72192272)
print v(xbgr.mr_n72192592)
print v(xbgr.mr_n72192704)
print v(xbgr.mr_n72193024)
print v(xbgr.mr_n72193136)
print v(xbgr.mr_n72193456)
print v(xbgr.mr_n72193568)
print v(xbgr.mr_n72193888)
print v(xbgr.mr_n72194000)
print v(xbgr.mr_n72194320)
print v(xbgr.mr_n72194432)
print v(xbgr.mr_n72194752)
print v(xbgr.mr_n72194864)
print v(xbgr.mr_n72195184)
print v(xbgr.mr_n72195296)
print v(xbgr.mr_n72195616)
print v(xbgr.mr_n72195728)
print v(xbgr.mr_n72196048)
print v(xbgr.mr_n72196160)
print v(xbgr.mr_n72196480)
print v(xbgr.mr_n72196592)
print v(xbgr.mr_n72196912)
print v(xbgr.mr_n72197024)
print v(xbgr.mr_n72197344)
print v(xbgr.mr_n72197456)
print v(xbgr.mr_n72197776)
print v(xbgr.mr_n72197888)
print v(xbgr.mr_n72198208)
print v(xbgr.mr_n72198320)
print v(xbgr.mr_n72198640)
print v(xbgr.mr_n72198752)
print v(xbgr.mr_n72199072)
print v(xbgr.mr_n72199184)
print v(xbgr.mr_n72199504)
print v(xbgr.mr_n72199616)
print v(xbgr.mr_n72199936)
print v(xbgr.mr_n72200048)
print v(xbgr.mr_n72200368)
print v(xbgr.mr_n72200480)
print v(xbgr.mr_n72200800)
print v(xbgr.mr_n72200912)
print v(xbgr.mr_n72201232)
print v(xbgr.mr_n72201344)
print v(xbgr.mr_n72201664)
print v(xbgr.mr_n72201776)
print v(xbgr.mr_n72202096)
print v(xbgr.mr_n72202208)
print v(xbgr.mr_n72202528)
print v(xbgr.mr_n72202640)
print v(xbgr.mr_n72202960)
print v(xbgr.mr_n72203072)
print v(xbgr.mr_n72203392)
print v(xbgr.mr_n72203504)
print v(xbgr.mr_n72203824)
print v(xbgr.mr_n72203936)
print v(xbgr.mr_n72204256)
print v(xbgr.mr_n72204368)
print v(xbgr.mr_n72204688)
print v(xbgr.mr_n72204800)
print v(xbgr.mr_n72205120)
print v(xbgr.mr_n72205232)
print v(xbgr.mr_n72205552)
print v(xbgr.mr_n72205664)
print v(xbgr.mr_n72206096)
print v(xbgr.mr_n72206416)
print v(xbgr.mr_n72206528)
print v(xbgr.mr_n72206848)
print v(xbgr.mr_n72206960)
print v(xbgr.mr_n72207280)
print v(xbgr.mr_n72207392)
print v(xbgr.mr_n72207712)
print v(xbgr.mr_n72207824)
print v(xbgr.mr_n72208144)
print v(xbgr.mr_n72208256)
print v(xbgr.mr_n72208688)
print v(xbgr.mr_n72209008)
print v(xbgr.mr_n72209120)
print v(xbgr.mr_n72209440)
print v(xbgr.mr_n72209552)
print v(xbgr.mr_n72209872)
print v(xbgr.mr_n72209984)
print v(xbgr.mr_n72210304)
print v(xbgr.mr_n72210416)
print v(xbgr.mr_n72210736)
print v(xbgr.mr_n72210848)
print v(xbgr.mr_n72211280)
print v(xbgr.mr_n72211600)
print v(xbgr.mr_n72211712)
print v(xbgr.mr_n72212032)
print v(xbgr.mr_n72212144)
print v(xbgr.mr_n72212464)
print v(xbgr.mr_n72212576)
print v(xbgr.mr_n72212896)
print v(xbgr.mr_n72213008)
print v(xbgr.mr_n72213328)
print v(xbgr.mr_n72213440)
print v(xbgr.mr_n72213760)
print v(xbgr.mr_n72213872)
print v(xbgr.mr_n72214192)
print v(xbgr.mr_n72214304)
print v(xbgr.mr_n72214736)
print v(xbgr.mr_n72215056)
print v(xbgr.mr_n72215168)
print v(xbgr.mr_n72215600)
print v(xbgr.mr_n72215920)
print v(xbgr.mr_n72216032)
print v(xbgr.mr_n72216352)
print v(xbgr.mr_n72216464)
print v(xbgr.mr_n72216784)
print v(xbgr.mr_n72216896)
print v(xbgr.mr_n72217216)
print v(xbgr.mr_n72217328)
print v(xbgr.mr_n72217648)
print v(xbgr.mr_n72217760)
print v(xbgr.mr_n72218192)
print v(xbgr.mr_n72218512)
print v(xbgr.mr_n72218624)
print v(xbgr.mr_n72219056)
print v(xbgr.mr_n72219376)
print v(xbgr.mr_n72219488)
print v(xbgr.mr_n72219808)
print v(xbgr.mr_n72219920)
print v(xbgr.mr_n72220240)
print v(xbgr.mr_n72220352)
print v(xbgr.mr_n72220672)
print v(xbgr.mr_n72220784)
print v(xbgr.mr_n72221104)
print v(xbgr.mr_n72221216)
print v(xbgr.mr_n72221536)
print v(xbgr.mr_n72221648)
print v(xbgr.mr_n72221968)
print v(xbgr.mr_n72222080)
print v(xbgr.mr_n72222400)
print v(xbgr.mr_n72222512)
print v(xbgr.mr_n72222832)
print v(xbgr.mr_n72222944)
print v(xbgr.mr_n72223264)
print v(xbgr.mr_n72223376)
print v(xbgr.mr_n72223696)
print v(xbgr.mr_n72223808)
print v(xbgr.mr_n72224128)
print v(xbgr.mr_n72224240)
print v(xbgr.mr_n72224560)
print v(xbgr.mr_n72224672)
print v(xbgr.mr_n72224992)
print v(xbgr.mr_n72225104)
print v(xbgr.mr_n72225424)
print v(xbgr.mr_n72225536)
print v(xbgr.mr_n72225856)
print v(xbgr.mr_n72225968)
print v(xbgr.mr_n72226288)
print v(xbgr.mr_n72226400)
print v(xbgr.mr_n72226720)
print v(xbgr.mr_n72226832)
print v(xbgr.mr_n72227152)
print v(xbgr.mr_n72227264)
print v(xbgr.mr_n72227584)
print v(xbgr.mr_n72227696)
print v(xbgr.mr_n72228016)
print v(xbgr.mr_n72228128)
print v(xbgr.mr_n72228448)
print v(xbgr.mr_n72228560)
print v(xbgr.mr_n72228880)
print v(xbgr.mr_n72228992)
print v(xbgr.mr_n72229312)
print v(xbgr.mr_n72229424)
print v(xbgr.mr_n72229744)
print v(xbgr.mr_n72229856)
print v(xbgr.mr_n72230176)
print v(xbgr.mr_n72230288)
print v(xbgr.mr_n72230608)
print v(xbgr.mr_n72230720)
print v(xbgr.mr_n72231040)
print v(xbgr.mr_n72231152)
print v(xbgr.mr_n72231472)
print v(xbgr.mr_n72231584)
print v(xbgr.mr_n72231904)
print v(xbgr.mr_n72232016)
print v(xbgr.mr_n72232336)
print v(xbgr.mr_n72232448)
print v(xbgr.mr_n72232768)
print v(xbgr.mr_n72232880)
print v(xbgr.mr_n72233200)
print v(xbgr.mr_n72233312)
print v(xbgr.mr_n72233632)
print v(xbgr.mr_n72233744)
print v(xbgr.mr_n72234064)
print v(xbgr.mr_n72234176)
print v(xbgr.mr_n72234496)
print v(xbgr.mr_n72234608)
print v(xbgr.mr_n72234928)
print v(xbgr.mr_n72235040)
print v(xbgr.mr_n72235360)
print v(xbgr.mr_n72235472)
print v(xbgr.mr_n72235792)
print v(xbgr.mr_n72235904)
print v(xbgr.mr_n72236224)
print v(xbgr.mr_n72236336)
print v(xbgr.mr_n72236656)
print v(xbgr.mr_n72236768)
print v(xbgr.mr_n72237088)
print v(xbgr.mr_n72237200)
print v(xbgr.mr_n72237520)
print v(xbgr.mr_n72237632)
print v(xbgr.mr_n72237952)
print v(xbgr.mr_n72238064)
print v(xbgr.mr_n72238384)
print v(xbgr.mr_n72238496)
print v(xbgr.mr_n72238816)
print v(xbgr.mr_n72238928)
print v(xbgr.mr_n72239248)
print v(xbgr.mr_n72239360)
print v(xbgr.mr_n72239680)
print v(xbgr.mr_n72239792)
print v(xbgr.mr_n72240112)
print v(xbgr.mr_n72240224)
print v(xbgr.mr_n72240544)
print v(xbgr.mr_n72240656)
print v(xbgr.mr_n72240976)
print v(xbgr.mr_n72241088)
print v(xbgr.mr_n72241408)
print v(xbgr.mr_n72241520)
print v(xbgr.mr_n72241840)
print v(xbgr.mr_n72241952)
print v(xbgr.mr_n72242272)
print v(xbgr.mr_n72242384)
print v(xbgr.mr_n72242704)
print v(xbgr.mr_n72242816)
print v(xbgr.mr_n72243136)
print v(xbgr.mr_n72243248)
print v(xbgr.mr_n72243568)
print v(xbgr.mr_n72243680)
print v(xbgr.mr_n72244000)
print v(xbgr.mr_n72244112)
print v(xbgr.mr_n72244432)
print v(xbgr.mr_n72244544)
print v(xbgr.mr_n72244864)
print v(xbgr.mr_n72244976)
print v(xbgr.mr_n72245296)
print v(xbgr.mr_n72245408)
print v(xbgr.mr_n72245728)
print v(xbgr.mr_n72245840)
print v(xbgr.mr_n72246160)
print v(xbgr.mr_n72246272)
print v(xbgr.mr_n72246592)
print v(xbgr.mr_n72246704)
print v(xbgr.mr_n72247024)
print v(xbgr.mr_n72247136)
print v(xbgr.mr_n72247456)
print v(xbgr.mr_n72247568)
print v(xbgr.mr_n72247888)
print v(xbgr.mr_n72248000)
print v(xbgr.mr_n72248320)
print v(xbgr.mr_n72248432)
print v(xbgr.mr_n72248752)
print v(xbgr.mr_n72248864)
print v(xbgr.mr_n72249184)
print v(xbgr.mr_n72249296)
print v(xbgr.mr_n72249616)
print v(xbgr.mr_n72249728)
print v(xbgr.mr_n72250048)
print v(xbgr.mr_n72250160)
print v(xbgr.mr_n72250480)
print v(xbgr.mr_n72250592)
print v(xbgr.mr_n72250912)
print v(xbgr.mr_n72251024)
print v(xbgr.mr_n72251344)
print v(xbgr.mr_n72251456)
print v(xbgr.mr_n72251776)
print v(xbgr.mr_n72251888)
print v(xbgr.mr_n72252208)
print v(xbgr.mr_n72252320)
print v(xbgr.mr_n72252752)
print v(xbgr.mr_n72253072)
print v(xbgr.mr_n72253184)
print v(xbgr.mr_n72253504)
print v(xbgr.mr_n72253616)
print v(xbgr.mr_n72253936)
print v(xbgr.mr_n72254048)
print v(xbgr.mr_n72254480)
print v(xbgr.mr_n72254800)
print v(xbgr.mr_n72254912)
print v(xbgr.mr_n72255344)
print v(xbgr.mr_n72255664)
print v(xbgr.mr_n72255776)
print v(xbgr.mr_n72256096)
print v(xbgr.mr_n72256208)
print v(xbgr.mr_n72256528)
print v(xbgr.mr_n72256640)
print v(xbgr.mr_n72256960)
print v(xbgr.mr_n72257072)
print v(xbgr.mr_n72257392)
print v(xbgr.mr_n72257504)
print v(xbgr.mr_n72257824)
print v(xbgr.mr_n72257936)
print v(xbgr.mr_n72258256)
print v(xbgr.mr_n72258368)
print v(xbgr.mr_n72258688)
print v(xbgr.mr_n72258800)
print v(xbgr.mr_n72259120)
print v(xbgr.mr_n72259232)
print v(xbgr.mr_n72259552)
print v(xbgr.mr_n72259664)
print v(xbgr.mr_n72259984)
print v(xbgr.mr_n72260096)
print v(xbgr.mr_n72260416)
print v(xbgr.mr_n72260528)
print v(xbgr.mr_n72260848)
print v(xbgr.mr_n72260960)
print v(xbgr.mr_n72261280)
print v(xbgr.mr_n72261392)
print v(xbgr.mr_n72261712)
print v(xbgr.mr_n72261824)
print v(xbgr.mr_n72262144)
print v(xbgr.mr_n72262256)
print v(xbgr.mr_n72262576)
print v(xbgr.mr_n72262688)
print v(xbgr.mr_n72263008)
print v(xbgr.mr_n72263120)
print v(xbgr.mr_n72263440)
print v(xbgr.mr_n72263552)
print v(xbgr.mr_n72263872)
print v(xbgr.mr_n72263984)
print v(xbgr.mr_n72264304)
print v(xbgr.mr_n72264416)
print v(xbgr.mr_n72264736)
print v(xbgr.mr_n72264848)
print v(xbgr.mr_n72265168)
print v(xbgr.mr_n72265280)
print v(xbgr.mr_n72265600)
print v(xbgr.mr_n72265712)
print v(xbgr.mr_n72266032)
print v(xbgr.mr_n72266144)
print v(xbgr.mr_n72266464)
print v(xbgr.mr_n72266576)
print v(xbgr.mr_n72266896)
print v(xbgr.mr_n72267008)
print v(xbgr.mr_n72267440)
print v(xbgr.mr_n72267760)
print v(xbgr.mr_n72267872)
print v(xbgr.mr_n72268192)
print v(xbgr.mr_n72268304)
print v(xbgr.mr_n72268624)
print v(xbgr.mr_n72268736)
print v(xbgr.mr_n72269056)
print v(xbgr.mr_n72269168)
print v(xbgr.mr_n72269488)
print v(xbgr.mr_n72269600)
print v(xbgr.mr_n72269920)
print v(xbgr.mr_n72270032)
print v(xbgr.mr_n72270352)
print v(xbgr.mr_n72270464)
print v(xbgr.mr_n72270784)
print v(xbgr.mr_n72270896)
print v(xbgr.mr_n72271216)
print v(xbgr.mr_n72271328)
print v(xbgr.mr_n72271760)
print v(xbgr.mr_n72272080)
print v(xbgr.mr_n72272192)
print v(xbgr.mr_n72272512)
print v(xbgr.mr_n72272624)
print v(xbgr.mr_n72272944)
print v(xbgr.mr_n72273056)
print v(xbgr.mr_n72273488)
print v(xbgr.mr_n72273808)
print v(xbgr.mr_n72273920)
print v(xbgr.mr_n72274240)
print v(xbgr.mr_n72274352)
print v(xbgr.mr_n72274672)
print v(xbgr.mr_n72274784)
print v(xbgr.mr_n72275104)
print v(xbgr.mr_n72275216)
print v(xbgr.mr_n72275536)
print v(xbgr.mr_n72275648)
print v(xbgr.mr_n72276080)
print v(xbgr.mr_n72276400)
print v(xbgr.mr_n72276512)
print v(xbgr.mr_n72276832)
print v(xbgr.mr_n72276944)
print v(xbgr.mr_n72277264)
print v(xbgr.mr_n72277376)
print v(xbgr.mr_n72277696)
print v(xbgr.mr_n72277808)
print v(xbgr.mr_n72278128)
print v(xbgr.mr_n72278240)
print v(xbgr.mr_n72278560)
print v(xbgr.mr_n72278672)
print v(xbgr.mr_n72278992)
print v(xbgr.mr_n72279104)
print v(xbgr.mr_n72279424)
print v(xbgr.mr_n72279536)
print v(xbgr.mr_n72279856)
print v(xbgr.mr_n72279968)
print v(xbgr.mr_n72280288)
print v(xbgr.mr_n72280400)
print v(xbgr.mr_n72280720)
print v(xbgr.mr_n72280832)
print v(xbgr.mr_n72281152)
print v(xbgr.mr_n72281264)
print v(xbgr.mr_n72281584)
print v(xbgr.mr_n72281696)
print v(xbgr.mr_n72282016)
print v(xbgr.mr_n72282128)
print v(xbgr.mr_n72282448)
print v(xbgr.mr_n72282560)
print v(xbgr.mr_n72282880)
print v(xbgr.mr_n72282992)
print v(xbgr.mr_n72283312)
print v(xbgr.mr_n72283424)
print v(xbgr.mr_n72283744)
print v(xbgr.mr_n72283856)
print v(xbgr.mr_n72284176)
print v(xbgr.mr_n72284288)
print v(xbgr.mr_n72284608)
print v(xbgr.mr_n72284720)
print v(xbgr.mr_n72285040)
print v(xbgr.mr_n72285152)
print v(xbgr.mr_n72285472)
print v(xbgr.mr_n72285584)
print v(xbgr.mr_n72285904)
print v(xbgr.mr_n72286016)
print v(xbgr.mr_n72286336)
print v(xbgr.mr_n72286448)
print v(xbgr.mr_n72286768)
print v(xbgr.mr_n72286880)
print v(xbgr.mr_n72287200)
print v(xbgr.mr_n72287312)
print v(xbgr.mr_n72287632)
print v(xbgr.mr_n72287744)
print v(xbgr.mr_n72288064)
print v(xbgr.mr_n72288176)
print v(xbgr.mr_n72288496)
print v(xbgr.mr_n72288608)
print v(xbgr.mr_n72288928)
print v(xbgr.mr_n72289040)
print v(xbgr.mr_n72289360)
print v(xbgr.mr_n72289472)
print v(xbgr.mr_n72289792)
print v(xbgr.mr_n72289904)
print v(xbgr.mr_n72290224)
print v(xbgr.mr_n72290336)
print v(xbgr.mr_n72290656)
print v(xbgr.mr_n72290768)
print v(xbgr.mr_n72291088)
print v(xbgr.mr_n72291200)
print v(xbgr.mr_n72291520)
print v(xbgr.mr_n72291632)
print v(xbgr.mr_n72291952)
print v(xbgr.mr_n72292064)
print v(xbgr.mr_n72292384)
print v(xbgr.mr_n72292496)
print v(xbgr.mr_n72292816)
print v(xbgr.mr_n72292928)
print v(xbgr.mr_n72293248)
print v(xbgr.mr_n72293360)
print v(xbgr.mr_n72293680)
print v(xbgr.mr_n72293792)
print v(xbgr.mr_n72294112)
print v(xbgr.mr_n72294224)
print v(xbgr.mr_n72294544)
print v(xbgr.mr_n72294656)
print v(xbgr.mr_n72294976)
print v(xbgr.mr_n72295088)
print v(xbgr.mr_n72295408)
print v(xbgr.mr_n72295520)
print v(xbgr.mr_n72295840)
print v(xbgr.mr_n72295952)
print v(xbgr.mr_n72296272)
print v(xbgr.mr_n72296384)
print v(xbgr.mr_n72296704)
print v(xbgr.mr_n72296816)
print v(xbgr.mr_n72297136)
print v(xbgr.mr_n72297248)
print v(xbgr.mr_n72297568)
print v(xbgr.mr_n72297680)
print v(xbgr.mr_n72298000)
print v(xbgr.mr_n72298112)
print v(xbgr.mr_n72298432)
print v(xbgr.mr_n72298544)
print v(xbgr.mr_n72298864)
print v(xbgr.mr_n72298976)
print v(xbgr.mr_n72299296)
print v(xbgr.mr_n72299408)
print v(xbgr.mr_n72299728)
print v(xbgr.mr_n72299840)
print v(xbgr.mr_n72300160)
print v(xbgr.mr_n72300272)
print v(xbgr.mr_n72300592)
print v(xbgr.mr_n72300704)
print v(xbgr.mr_n72301024)
print v(xbgr.mr_n72301136)
print v(xbgr.mr_n72301456)
print v(xbgr.mr_n72301568)
print v(xbgr.mr_n72301888)
print v(xbgr.mr_n72302000)
print v(xbgr.mr_n72302320)
print v(xbgr.mr_n72302432)
print v(xbgr.mr_n72302752)
print v(xbgr.mr_n72302864)
print v(xbgr.mr_n72303184)
print v(xbgr.mr_n72303296)
print v(xbgr.mr_n72303616)
print v(xbgr.mr_n72303728)
print v(xbgr.mr_n72304048)
print v(xbgr.mr_n72304160)
print v(xbgr.mr_n72304480)
print v(xbgr.mr_n72304592)
print v(xbgr.mr_n72304912)
print v(xbgr.mr_n72305024)
print v(xbgr.mr_n72305344)
print v(xbgr.mr_n72305456)
print v(xbgr.mr_n72305776)
print v(xbgr.mr_n72305888)
print v(xbgr.mr_n72306320)
print v(xbgr.mr_n72306640)
print v(xbgr.mr_n72306752)
print v(xbgr.mr_n72307072)
print v(xbgr.mr_n72307184)
print v(xbgr.mr_n72307504)
print v(xbgr.mr_n72307616)
print v(xbgr.mr_n72308048)
print v(xbgr.mr_n72308368)
print v(xbgr.mr_n72308480)
print v(xbgr.mr_n72308912)
print v(xbgr.mr_n72309232)
print v(xbgr.mr_n72309344)
print v(xbgr.mr_n72309664)
print v(xbgr.mr_n72309776)
print v(xbgr.mr_n72310096)
print v(xbgr.mr_n72310208)
print v(xbgr.mr_n72310528)
print v(xbgr.mr_n72310640)
print v(xbgr.mr_n72310960)
print v(xbgr.mr_n72311072)
print v(xbgr.mr_n72311392)
print v(xbgr.mr_n72311504)
print v(xbgr.mr_n72311824)
print v(xbgr.mr_n72311936)
print v(xbgr.mr_n72312256)
print v(xbgr.mr_n72312368)
print v(xbgr.mr_n72312688)
print v(xbgr.mr_n72312800)
print v(xbgr.mr_n72313120)
print v(xbgr.mr_n72313232)
print v(xbgr.mr_n72313552)
print v(xbgr.mr_n72313664)
print v(xbgr.mr_n72313984)
print v(xbgr.mr_n72314096)
print v(xbgr.mr_n72314416)
print v(xbgr.mr_n72314528)
print v(xbgr.mr_n72314848)
print v(xbgr.mr_n72314960)
print v(xbgr.mr_n72315280)
print v(xbgr.mr_n72315392)
print v(xbgr.mr_n72315712)
print v(xbgr.mr_n72315824)
print v(xbgr.mr_n72316144)
print v(xbgr.mr_n72316256)
print v(xbgr.mr_n72316576)
print v(xbgr.mr_n72316688)
print v(xbgr.mr_n72317008)
print v(xbgr.mr_n72317120)
print v(xbgr.mr_n72317440)
print v(xbgr.mr_n72317552)
print v(xbgr.mr_n72317872)
print v(xbgr.mr_n72317984)
print v(xbgr.mr_n72318304)
print v(xbgr.mr_n72318416)
print v(xbgr.mr_n72318736)
print v(xbgr.mr_n72318848)
print v(xbgr.mr_n72319168)
print v(xbgr.mr_n72319280)
print v(xbgr.mr_n72319600)
print v(xbgr.mr_n72319712)
print v(xbgr.mr_n72320032)
print v(xbgr.mr_n72320144)
print v(xbgr.mr_n72320464)
print v(xbgr.mr_n72320576)
print v(xbgr.mr_n72320896)
print v(xbgr.mr_n72321008)
print v(xbgr.mr_n72321328)
print v(xbgr.mr_n72321440)
print v(xbgr.mr_n72321760)
print v(xbgr.mr_n72321872)
print v(xbgr.mr_n72322192)
print v(xbgr.mr_n72322304)
print v(xbgr.mr_n72322624)
print v(xbgr.mr_n72322736)
print v(xbgr.mr_n72323056)
print v(xbgr.mr_n72323168)
print v(xbgr.mr_n72323488)
print v(xbgr.mr_n72323600)
print v(xbgr.mr_n72323920)
print v(xbgr.mr_n72324032)
print v(xbgr.mr_n72324352)
print v(xbgr.mr_n72324464)
print v(xbgr.mr_n72324784)
print v(xbgr.mr_n72324896)
print v(xbgr.mr_n72325216)
print v(xbgr.mr_n72325328)
print v(xbgr.mr_n72325648)
print v(xbgr.mr_n72325760)
print v(xbgr.mr_n72326080)
print v(xbgr.mr_n72326192)
print v(xbgr.mr_n72326512)
print v(xbgr.mr_n72326624)
print v(xbgr.mr_n72326944)
print v(xbgr.mr_n72327056)
print v(xbgr.mr_n72327376)
print v(xbgr.mr_n72327488)
print v(xbgr.mr_n72327808)
print v(xbgr.mr_n72327920)
print v(xbgr.mr_n72328240)
print v(xbgr.mr_n72328352)
print v(xbgr.mr_n72328672)
print v(xbgr.mr_n72328784)
print v(xbgr.mr_n72329104)
print v(xbgr.mr_n72329216)
print v(xbgr.mr_n72329536)
print v(xbgr.mr_n72329648)
print v(xbgr.mr_n72329968)
print v(xbgr.mr_n72330080)
print v(xbgr.mr_n72330400)
print v(xbgr.mr_n72330512)
print v(xbgr.mr_n72330832)
print v(xbgr.mr_n72330944)
print v(xbgr.mr_n72331264)
print v(xbgr.mr_n72331376)
print v(xbgr.mr_n72331696)
print v(xbgr.mr_n72331808)
print v(xbgr.mr_n72332128)
print v(xbgr.mr_n72332240)
print v(xbgr.mr_n72332560)
print v(xbgr.mr_n72332672)
print v(xbgr.mr_n72332992)
print v(xbgr.mr_n72333104)
print v(xbgr.mr_n72333424)
print v(xbgr.mr_n72333536)
print v(xbgr.mr_n72333856)
print v(xbgr.mr_n72333968)
print v(xbgr.mr_n72334288)
print v(xbgr.mr_n72334400)
print v(xbgr.mr_n72334720)
print v(xbgr.mr_n72334832)
print v(xbgr.mr_n72335152)
print v(xbgr.mr_n72335264)
print v(xbgr.mr_n72335584)
print v(xbgr.mr_n72335696)
print v(xbgr.mr_n72336016)
print v(xbgr.mr_n72336128)
print v(xbgr.mr_n72336448)
print v(xbgr.mr_n72336560)
print v(xbgr.mr_n72336880)
print v(xbgr.mr_n72336992)
print v(xbgr.mr_n72337312)
print v(xbgr.mr_n72337424)
print v(xbgr.mr_n72337744)
print v(xbgr.mr_n72337856)
print v(xbgr.mr_n72338176)
print v(xbgr.mr_n72338288)
print v(xbgr.mr_n72338608)
print v(xbgr.mr_n72338720)
print v(xbgr.mr_n72339040)
print v(xbgr.mr_n72339152)
print v(xbgr.mr_n72339472)
print v(xbgr.mr_n72339584)
print v(xbgr.mr_n72339904)
print v(xbgr.mr_n72340016)
print v(xbgr.mr_n72340336)
print v(xbgr.mr_n72340448)
print v(xbgr.mr_n72340768)
print v(xbgr.mr_n72340880)
print v(xbgr.mr_n72341200)
print v(xbgr.mr_n72341312)
print v(xbgr.mr_n72341632)
print v(xbgr.mr_n72341744)
print v(xbgr.mr_n72342064)
print v(xbgr.mr_n72342176)
print v(xbgr.mr_n72342496)
print v(xbgr.mr_n72342608)
print v(xbgr.mr_n72342928)
print v(xbgr.mr_n72343040)
print v(xbgr.mr_n72343360)
print v(xbgr.mr_n72343472)
print v(xbgr.mr_n72343792)
print v(xbgr.mr_n72343904)
print v(xbgr.mr_n72344224)
print v(xbgr.mr_n72344336)
print v(xbgr.mr_n72344656)
print v(xbgr.mr_n72344768)
print v(xbgr.mr_n72345088)
print v(xbgr.mr_n72345200)
print v(xbgr.mr_n72345520)
print v(xbgr.mr_n72345632)
print v(xbgr.mr_n72345952)
print v(xbgr.mr_n72346064)
print v(xbgr.mr_n72346384)
print v(xbgr.mr_n72346496)
print v(xbgr.mr_n72346816)
print v(xbgr.mr_n72346928)
print v(xbgr.mr_n72347248)
print v(xbgr.mr_n72347360)
print v(xbgr.mr_n72347680)
print v(xbgr.mr_n72347792)
print v(xbgr.mr_n72348112)
print v(xbgr.mr_n72348224)
print v(xbgr.mr_n72348544)
print v(xbgr.mr_n72348656)
print v(xbgr.mr_n72348976)
print v(xbgr.mr_n72349088)
print v(xbgr.mr_n72349408)
print v(xbgr.mr_n72349520)
print v(xbgr.mr_n72349840)
print v(xbgr.mr_n72349952)
print v(xbgr.mr_n72350272)
print v(xbgr.mr_n72350384)
print v(xbgr.mr_n72350704)
print v(xbgr.mr_n72350816)
print v(xbgr.mr_n72351136)
print v(xbgr.mr_n72351248)
print v(xbgr.mr_n72351568)
print v(xbgr.mr_n72351680)
print v(xbgr.mr_n72352000)
print v(xbgr.mr_n72352112)
print v(xbgr.mr_n72352432)
print v(xbgr.mr_n72352544)
print v(xbgr.mr_n72352864)
print v(xbgr.mr_n72352976)
print v(xbgr.mr_n72353296)
print v(xbgr.mr_n72353408)
print v(xbgr.mr_n72353728)
print v(xbgr.mr_n72353840)
print v(xbgr.mr_n72354160)
print v(xbgr.mr_n72354272)
print v(xbgr.mr_n72354592)
print v(xbgr.mr_n72354704)
print v(xbgr.mr_n72355024)
print v(xbgr.mr_n72355136)
print v(xbgr.mr_n72355456)
print v(xbgr.mr_n72355568)
print v(xbgr.mr_n72355888)
print v(xbgr.mr_n72356000)
print v(xbgr.mr_n72356320)
print v(xbgr.mr_n72356432)
print v(xbgr.mr_n72356752)
print v(xbgr.mr_n72356864)
print v(xbgr.mr_n72357184)
print v(xbgr.mr_n72357296)
print v(xbgr.mr_n72357616)
print v(xbgr.mr_n72357728)
print v(xbgr.mr_n72358048)
print v(xbgr.mr_n72358160)
print v(xbgr.mr_n72358480)
print v(xbgr.mr_n72358592)
print v(xbgr.mr_n72358912)
print v(xbgr.mr_n72359024)
print v(xbgr.mr_n72359344)
print v(xbgr.mr_n72359456)
print v(xbgr.mr_n72359776)
print v(xbgr.mr_n72359888)
print v(xbgr.mr_n72360208)
print v(xbgr.mr_n72360320)
print v(xbgr.mr_n72360640)
print v(xbgr.mr_n72360752)
print v(xbgr.mr_n72361072)
print v(xbgr.mr_n72361184)
print v(xbgr.mr_n72361504)
print v(xbgr.mr_n72361616)
print v(xbgr.mr_n72361936)
print v(xbgr.mr_n72362048)
print v(xbgr.mr_n72362368)
print v(xbgr.mr_n72362480)
print v(xbgr.mr_n72362800)
print v(xbgr.mr_n72362912)
print v(xbgr.mr_n72363232)
print v(xbgr.mr_n72363344)
print v(xbgr.mr_n72363664)
print v(xbgr.mr_n72363776)
print v(xbgr.mr_n72364096)
print v(xbgr.mr_n72364208)
print v(xbgr.mr_n72364528)
print v(xbgr.mr_n72364640)
print v(xbgr.mr_n72364960)
print v(xbgr.mr_n72365072)
print v(xbgr.mr_n72365392)
print v(xbgr.mr_n72365504)
print v(xbgr.mr_n72365824)
print v(xbgr.mr_n72365936)
print v(xbgr.mr_n72366256)
print v(xbgr.mr_n72366368)
print v(xbgr.mr_n72366688)
print v(xbgr.mr_n72366800)
print v(xbgr.mr_n72367120)
print v(xbgr.mr_n72367232)
print v(xbgr.mr_n72367552)
print v(xbgr.mr_n72367664)
print v(xbgr.mr_n72367984)
print v(xbgr.mr_n72368096)
print v(xbgr.mr_n72368416)
print v(xbgr.mr_n72368528)
print v(xbgr.mr_n72368848)
print v(xbgr.mr_n72368960)
print v(xbgr.mr_n72369280)
print v(xbgr.mr_n72369392)
print v(xbgr.mr_n72369712)
print v(xbgr.mr_n72369824)
print v(xbgr.mr_n72370144)
print v(xbgr.mr_n72370256)
print v(xbgr.mr_n72370576)
print v(xbgr.mr_n72370688)
print v(xbgr.mr_n72371008)
print v(xbgr.mr_n72371120)
print v(xbgr.mr_n72371440)
print v(xbgr.mr_n72371552)
print v(xbgr.mr_n72371872)
print v(xbgr.mr_n72371984)
print v(xbgr.mr_n72372304)
print v(xbgr.mr_n72372416)
print v(xbgr.mr_n72372736)
print v(xbgr.mr_n72372848)
print v(xbgr.mr_n72373168)
print v(xbgr.mr_n72373280)
print v(xbgr.mr_n72373600)
print v(xbgr.mr_n72373712)
print v(xbgr.mr_n72374032)
print v(xbgr.mr_n72374144)
print v(xbgr.mr_n72374464)
print v(xbgr.mr_n72374576)
print v(xbgr.mr_n72374896)
print v(xbgr.mr_n72375008)
print v(xbgr.mr_n72375328)
print v(xbgr.mr_n72375440)
print v(xbgr.mr_n72375760)
print v(xbgr.mr_n72375872)
print v(xbgr.mr_n72376192)
print v(xbgr.mr_n72376304)
print v(xbgr.mr_n72376624)
print v(xbgr.mr_n72376736)
print v(xbgr.mr_n72377056)
print v(xbgr.mr_n72377168)
print v(xbgr.mr_n72377488)
print v(xbgr.mr_n72377600)
print v(xbgr.mr_n72377920)
print v(xbgr.mr_n72378032)
print v(xbgr.mr_n72378352)
print v(xbgr.mr_n72378464)
print v(xbgr.mr_n72378784)
print v(xbgr.mr_n72378896)
print v(xbgr.mr_n72379216)
print v(xbgr.mr_n72379328)
print v(xbgr.mr_n72379648)
print v(xbgr.mr_n72379760)
print v(xbgr.mr_n72380080)
print v(xbgr.mr_n72380192)
print v(xbgr.mr_n72380512)
print v(xbgr.mr_n72380624)
print v(xbgr.mr_n72380944)
print v(xbgr.mr_n72381056)
print v(xbgr.mr_n72381376)
print v(xbgr.mr_n72381488)
print v(xbgr.mr_n72381808)
print v(xbgr.mr_n72381920)
print v(xbgr.mr_n72382240)
print v(xbgr.mr_n72382352)
print v(xbgr.mr_n72382672)
print v(xbgr.mr_n72382784)
print v(xbgr.mr_n72383104)
print v(xbgr.mr_n72383216)
print v(xbgr.mr_n72383536)
print v(xbgr.mr_n72383648)
print v(xbgr.mr_n72383968)
print v(xbgr.mr_n72384080)
print v(xbgr.mr_n72384400)
print v(xbgr.mr_n72384512)
print v(xbgr.mr_n72384832)
print v(xbgr.mr_n72384944)
print v(xbgr.mr_n72385264)
print v(xbgr.mr_n72385376)
print v(xbgr.mr_n72385696)
print v(xbgr.mr_n72385808)
print v(xbgr.mr_n72386128)
print v(xbgr.mr_n72386240)
print v(xbgr.mr_n72386560)
print v(xbgr.mr_n72386672)
print v(xbgr.mr_n72386992)
print v(xbgr.mr_n72387104)
print v(xbgr.mr_n72387424)
print v(xbgr.mr_n72387536)
print v(xbgr.mr_n72387856)
print v(xbgr.mr_n72387968)
print v(xbgr.mr_n72388288)
print v(xbgr.mr_n72388400)
print v(xbgr.mr_n72388720)
print v(xbgr.mr_n72388832)
print v(xbgr.mr_n72389152)
print v(xbgr.mr_n72389264)
print v(xbgr.mr_n72389584)
print v(xbgr.mr_n72389696)
print v(xbgr.mr_n72390016)
print v(xbgr.mr_n72390128)
print v(xbgr.mr_n72390448)
print v(xbgr.mr_n72390560)
print v(xbgr.mr_n72390880)
print v(xbgr.mr_n72390992)
print v(xbgr.mr_n72391312)
print v(xbgr.mr_n72391424)
print v(xbgr.mr_n72391744)
print v(xbgr.mr_n72391856)
print v(xbgr.mr_n72392176)
print v(xbgr.mr_n72392288)
print v(xbgr.mr_n72392608)
print v(xbgr.mr_n72392720)
print v(xbgr.mr_n72393040)
print v(xbgr.mr_n72393152)
print v(xbgr.mr_n72393472)
print v(xbgr.mr_n72393584)
print v(xbgr.mr_n72393904)
print v(xbgr.mr_n72394016)
print v(xbgr.mr_n72394336)
print v(xbgr.mr_n72394448)
print v(xbgr.mr_n72394768)
print v(xbgr.mr_n72394880)
print v(xbgr.mr_n72395200)
print v(xbgr.mr_n72395312)
print v(xbgr.mr_n72395632)
print v(xbgr.mr_n72395744)
print v(xbgr.mr_n72396064)
print v(xbgr.mr_n72396176)
print v(xbgr.mr_n72396496)
print v(xbgr.mr_n72396608)
print v(xbgr.mr_n72396928)
print v(xbgr.mr_n72397040)
print v(xbgr.mr_n72397360)
print v(xbgr.mr_n72397472)
print v(xbgr.mr_n72397792)
print v(xbgr.mr_n72397904)
print v(xbgr.mr_n72398224)
print v(xbgr.mr_n72398336)
print v(xbgr.mr_n72398656)
print v(xbgr.mr_n72398768)
print v(xbgr.mr_n72399088)
print v(xbgr.mr_n72399200)
print v(xbgr.mr_n72465072)
print v(xbgr.mr_n72465184)
print v(xbgr.mr_n72465504)
print v(xbgr.mr_n72465616)
print v(xbgr.mr_n72465936)
print v(xbgr.mr_n72466048)
print v(xbgr.mr_n72466480)
print v(xbgr.mr_n72466800)
print v(xbgr.mr_n72466912)
print v(xbgr.mr_n72467232)
print v(xbgr.mr_n72467344)
print v(xbgr.mr_n72467776)
print v(xbgr.mr_n72468208)
print v(xbgr.mr_n72468528)
print v(xbgr.mr_n72468640)
print v(xbgr.mr_n72468960)
print v(xbgr.mr_n72469072)
print v(xbgr.mr_n72469392)
print v(xbgr.mr_n72469504)
print v(xbgr.mr_n72469824)
print v(xbgr.mr_n72469936)
print v(xbgr.mr_n72470256)
print v(xbgr.mr_n72470368)
print v(xbgr.mr_n72470688)
print v(xbgr.mr_n72470800)
print v(xbgr.mr_n72471120)
print v(xbgr.mr_n72471232)
print v(xbgr.mr_n72471552)
print v(xbgr.mr_n72471664)
print v(xbgr.mr_n72471984)
print v(xbgr.mr_n72472096)
print v(xbgr.mr_n72472416)
print v(xbgr.mr_n72472528)
print v(xbgr.mr_n72472848)
print v(xbgr.mr_n72472960)
print v(xbgr.mr_n72473280)
print v(xbgr.mr_n72473392)
print v(xbgr.mr_n72473824)
print v(xbgr.mr_n72474144)
print v(xbgr.mr_n72474256)
print v(xbgr.mr_n72474576)
print v(xbgr.mr_n72474688)
print v(xbgr.mr_n72475008)
print v(xbgr.mr_n72475120)
print v(xbgr.mr_n72475440)
print v(xbgr.mr_n72475552)
print v(xbgr.mr_n72475872)
print v(xbgr.mr_n72475984)
print v(xbgr.mr_n72476304)
print v(xbgr.mr_n72476416)
print v(xbgr.mr_n72476736)
print v(xbgr.mr_n72476848)
print v(xbgr.mr_n72477168)
print v(xbgr.mr_n72477280)
print v(xbgr.mr_n72477600)
print v(xbgr.mr_n72477712)
print v(xbgr.mr_n72478032)
print v(xbgr.mr_n72478144)
print v(xbgr.mr_n72478576)
print v(xbgr.mr_n72479008)
print v(xbgr.mr_n72479328)
print v(xbgr.mr_n72479440)
print v(xbgr.mr_n72479760)
print v(xbgr.mr_n72479872)
print v(xbgr.mr_n72480192)
print v(xbgr.mr_n72480304)
print v(xbgr.mr_n72480624)
print v(xbgr.mr_n72480736)
print v(xbgr.mr_n72481056)
print v(xbgr.mr_n72481168)
print v(xbgr.mr_n72481488)
print v(xbgr.mr_n72481600)
print v(xbgr.mr_n72481920)
print v(xbgr.mr_n72482032)
print v(xbgr.mr_n72482352)
print v(xbgr.mr_n72482464)
print v(xbgr.mr_n72482784)
print v(xbgr.mr_n72482896)
print v(xbgr.mr_n72483216)
print v(xbgr.mr_n72483328)
print v(xbgr.mr_n72483648)
print v(xbgr.mr_n72483760)
print v(xbgr.mr_n72484080)
print v(xbgr.mr_n72484192)
print v(xbgr.mr_n72484512)
print v(xbgr.mr_n72484624)
print v(xbgr.mr_n72484944)
print v(xbgr.mr_n72485056)
print v(xbgr.mr_n72485376)
print v(xbgr.mr_n72485488)
print v(xbgr.mr_n72485808)
print v(xbgr.mr_n72485920)
print v(xbgr.mr_n72486240)
print v(xbgr.mr_n72486352)
print v(xbgr.mr_n72486672)
print v(xbgr.mr_n72486784)
print v(xbgr.mr_n72487104)
print v(xbgr.mr_n72487216)
print v(xbgr.mr_n72487536)
print v(xbgr.mr_n72487648)
print v(xbgr.mr_n72487968)
print v(xbgr.mr_n72488080)
print v(xbgr.mr_n72488400)
print v(xbgr.mr_n72488512)
print v(xbgr.mr_n72488832)
print v(xbgr.mr_n72488944)
print v(xbgr.mr_n72489264)
print v(xbgr.mr_n72489376)
print v(xbgr.mr_n72489696)
print v(xbgr.mr_n72489808)
print v(xbgr.mr_n72490128)
print v(xbgr.mr_n72490240)
print v(xbgr.mr_n72490560)
print v(xbgr.mr_n72490672)
print v(xbgr.mr_n72490992)
print v(xbgr.mr_n72491104)
print v(xbgr.mr_n72491424)
print v(xbgr.mr_n72491536)
print v(xbgr.mr_n72491856)
print v(xbgr.mr_n72491968)
print v(xbgr.mr_n72492288)
print v(xbgr.mr_n72492400)
print v(xbgr.mr_n72492720)
print v(xbgr.mr_n72492832)
print v(xbgr.mr_n72493152)
print v(xbgr.mr_n72493264)
print v(xbgr.mr_n72493584)
print v(xbgr.mr_n72493696)
print v(xbgr.mr_n72494016)
print v(xbgr.mr_n72494128)
print v(xbgr.mr_n72494448)
print v(xbgr.mr_n72494560)
print v(xbgr.mr_n72494880)
print v(xbgr.mr_n72494992)
print v(xbgr.mr_n72495312)
print v(xbgr.mr_n72495424)
print v(xbgr.mr_n72495744)
print v(xbgr.mr_n72495856)
print v(xbgr.mr_n72496176)
print v(xbgr.mr_n72496288)
print v(xbgr.mr_n72496608)
print v(xbgr.mr_n72496720)
print v(xbgr.mr_n72497040)
print v(xbgr.mr_n72497152)
print v(xbgr.mr_n72497472)
print v(xbgr.mr_n72497584)
print v(xbgr.mr_n72497904)
print v(xbgr.mr_n72498016)
print v(xbgr.mr_n72498336)
print v(xbgr.mr_n72498448)
print v(xbgr.mr_n72498768)
print v(xbgr.mr_n72498880)
print v(xbgr.mr_n72499200)
print v(xbgr.mr_n72499312)
print v(xbgr.mr_n72499632)
print v(xbgr.mr_n72499744)
print v(xbgr.mr_n72500064)
print v(xbgr.mr_n72500176)
print v(xbgr.mr_n72500496)
print v(xbgr.mr_n72500608)
print v(xbgr.mr_n72500928)
print v(xbgr.mr_n72501040)
print v(xbgr.mr_n72501360)
print v(xbgr.mr_n72501472)
print v(xbgr.mr_n72501792)
print v(xbgr.mr_n72501904)
print v(xbgr.mr_n72502224)
print v(xbgr.mr_n72502336)
print v(xbgr.mr_n72502656)
print v(xbgr.mr_n72502768)
print v(xbgr.mr_n72503088)
print v(xbgr.mr_n72503200)
print v(xbgr.mr_n72503520)
print v(xbgr.mr_n72503632)
print v(xbgr.mr_n72503952)
print v(xbgr.mr_n72504064)
print v(xbgr.mr_n72504384)
print v(xbgr.mr_n72504496)
print v(xbgr.mr_n72504816)
print v(xbgr.mr_n72504928)
print v(xbgr.mr_n72505248)
print v(xbgr.mr_n72505360)
print v(xbgr.mr_n72505680)
print v(xbgr.mr_n72505792)
print v(xbgr.mr_n72506112)
print v(xbgr.mr_n72506224)
print v(xbgr.mr_n72506544)
print v(xbgr.mr_n72506656)
print v(xbgr.mr_n72506976)
print v(xbgr.mr_n72507088)
print v(xbgr.mr_n72507408)
print v(xbgr.mr_n72507520)
print v(xbgr.mr_n72507840)
print v(xbgr.mr_n72507952)
print v(xbgr.mr_n72508272)
print v(xbgr.mr_n72508384)
print v(xbgr.mr_n72508704)
print v(xbgr.mr_n72508816)
print v(xbgr.mr_n72509136)
print v(xbgr.mr_n72509248)
print v(xbgr.mr_n72509568)
print v(xbgr.mr_n72509680)
print v(xbgr.mr_n72510000)
print v(xbgr.mr_n72510112)
print v(xbgr.mr_n72510432)
print v(xbgr.mr_n72510544)
print v(xbgr.mr_n72510864)
print v(xbgr.mr_n72510976)
print v(xbgr.mr_n72511296)
print v(xbgr.mr_n72511408)
print v(xbgr.mr_n72511728)
print v(xbgr.mr_n72511840)
print v(xbgr.mr_n72512160)
print v(xbgr.mr_n72512272)
print v(xbgr.mr_n72512592)
print v(xbgr.mr_n72512704)
print v(xbgr.mr_n72513024)
print v(xbgr.mr_n72513136)
print v(xbgr.mr_n72513456)
print v(xbgr.mr_n72513568)
print v(xbgr.mr_n72513888)
print v(xbgr.mr_n72514000)
print v(xbgr.mr_n72514320)
print v(xbgr.mr_n72514432)
print v(xbgr.mr_n72514752)
print v(xbgr.mr_n72514864)
print v(xbgr.mr_n72515184)
print v(xbgr.mr_n72515296)
print v(xbgr.mr_n72515616)
print v(xbgr.mr_n72515728)
print v(xbgr.mr_n72516048)
print v(xbgr.mr_n72516160)
print v(xbgr.mr_n72516480)
print v(xbgr.mr_n72516592)
print v(xbgr.mr_n72516912)
print v(xbgr.mr_n72517024)
print v(xbgr.mr_n72517344)
print v(xbgr.mr_n72517456)
print v(xbgr.mr_n72517776)
print v(xbgr.mr_n72517888)
print v(xbgr.mr_n72518208)
print v(xbgr.mr_n72518320)
print v(xbgr.mr_n72518640)
print v(xbgr.mr_n72518752)
print v(xbgr.mr_n72519072)
print v(xbgr.mr_n72519184)
print v(xbgr.mr_n72519504)
print v(xbgr.mr_n72519616)
print v(xbgr.mr_n72519936)
print v(xbgr.mr_n72520048)
print v(xbgr.mr_n72520368)
print v(xbgr.mr_n72520480)
print v(xbgr.mr_n72520800)
print v(xbgr.mr_n72520912)
print v(xbgr.mr_n72521232)
print v(xbgr.mr_n72521344)
print v(xbgr.mr_n72521664)
print v(xbgr.mr_n72521776)
print v(xbgr.mr_n72522096)
print v(xbgr.mr_n72522208)
print v(xbgr.mr_n72522528)
print v(xbgr.mr_n72522640)
print v(xbgr.mr_n72522960)
print v(xbgr.mr_n72523072)
print v(xbgr.mr_n72523392)
print v(xbgr.mr_n72523504)
print v(xbgr.mr_n72523824)
print v(xbgr.mr_n72523936)
print v(xbgr.mr_n72524256)
print v(xbgr.mr_n72524368)
print v(xbgr.mr_n72524688)
print v(xbgr.mr_n72524800)
print v(xbgr.mr_n72525120)
print v(xbgr.mr_n72525232)
print v(xbgr.mr_n72525552)
print v(xbgr.mr_n72525664)
print v(xbgr.mr_n72525984)
print v(xbgr.mr_n72526096)
print v(xbgr.mr_n72526416)
print v(xbgr.mr_n72526528)
print v(xbgr.mr_n72526848)
print v(xbgr.mr_n72526960)
print v(xbgr.mr_n72527280)
print v(xbgr.mr_n72527392)
print v(xbgr.mr_n72527712)
print v(xbgr.mr_n72527824)
print v(xbgr.mr_n72528144)
print v(xbgr.mr_n72528256)
print v(xbgr.mr_n72528576)
print v(xbgr.mr_n72528688)
print v(xbgr.mr_n72529008)
print v(xbgr.mr_n72529120)
print v(xbgr.mr_n72529440)
print v(xbgr.mr_n72529552)
print v(xbgr.mr_n72529872)
print v(xbgr.mr_n72529984)
print v(xbgr.mr_n72530304)
print v(xbgr.mr_n72530416)
print v(xbgr.mr_n72530736)
print v(xbgr.mr_n72530848)
print v(xbgr.mr_n72531168)
print v(xbgr.mr_n72531280)
print v(xbgr.mr_n72531600)
print v(xbgr.mr_n72531712)
print v(xbgr.mr_n72532032)
print v(xbgr.mr_n72532144)
print v(xbgr.mr_n72532464)
print v(xbgr.mr_n72532576)
print v(xbgr.mr_n72532896)
print v(xbgr.mr_n72533008)
print v(xbgr.mr_n72533328)
print v(xbgr.mr_n72533440)
print v(xbgr.mr_n72533760)
print v(xbgr.mr_n72533872)
print v(xbgr.mr_n72534192)
print v(xbgr.mr_n72534304)
print v(xbgr.mr_n72534624)
print v(xbgr.mr_n72534736)
print v(xbgr.mr_n72535056)
print v(xbgr.mr_n72535168)
print v(xbgr.mr_n72535488)
print v(xbgr.mr_n72535600)
print v(xbgr.mr_n72535920)
print v(xbgr.mr_n72536032)
print v(xbgr.mr_n72536352)
print v(xbgr.mr_n72536464)
print v(xbgr.mr_n72536784)
print v(xbgr.mr_n72536896)
print v(xbgr.mr_n72537216)
print v(xbgr.mr_n72537328)
print v(xbgr.mr_n72537648)
print v(xbgr.mr_n72537760)
print v(xbgr.mr_n72538080)
print v(xbgr.mr_n72538192)
print v(xbgr.mr_n72538512)
print v(xbgr.mr_n72538624)
print v(xbgr.mr_n72538944)
print v(xbgr.mr_n72539056)
print v(xbgr.mr_n72539376)
print v(xbgr.mr_n72539488)
print v(xbgr.mr_n72539808)
print v(xbgr.mr_n72539920)
print v(xbgr.mr_n72540240)
print v(xbgr.mr_n72540352)
print v(xbgr.mr_n72540672)
print v(xbgr.mr_n72540784)
print v(xbgr.mr_n72541104)
print v(xbgr.mr_n72541216)
print v(xbgr.mr_n72541536)
print v(xbgr.mr_n72541648)
print v(xbgr.mr_n72541968)
print v(xbgr.mr_n72542080)
print v(xbgr.mr_n72542400)
print v(xbgr.mr_n72542512)
print v(xbgr.mr_n72542832)
print v(xbgr.mr_n72542944)
print v(xbgr.mr_n72543264)
print v(xbgr.mr_n72543376)
print v(xbgr.mr_n72543696)
print v(xbgr.mr_n72543808)
print v(xbgr.mr_n72544128)
print v(xbgr.mr_n72544240)
print v(xbgr.mr_n72544560)
print v(xbgr.mr_n72544672)
print v(xbgr.mr_n72544992)
print v(xbgr.mr_n72545104)
print v(xbgr.mr_n72545424)
print v(xbgr.mr_n72545536)
print v(xbgr.mr_n72545856)
print v(xbgr.mr_n72545968)
print v(xbgr.mr_n72546288)
print v(xbgr.mr_n72546400)
print v(xbgr.mr_n72546720)
print v(xbgr.mr_n72546832)
print v(xbgr.mr_n72547264)
print v(xbgr.mr_n72547584)
print v(xbgr.mr_n72547696)
print v(xbgr.mr_n72548016)
print v(xbgr.mr_n72548128)
print v(xbgr.mr_n72548448)
print v(xbgr.mr_n72548560)
print v(xbgr.mr_n72548880)
print v(xbgr.mr_n72548992)
print v(xbgr.mr_n72549312)
print v(xbgr.mr_n72550176)
print v(xbgr.mr_n72550288)
print v(xbgr.mr_n72550608)
print v(xbgr.mr_n72550720)
print v(xbgr.mr_n72551040)
print v(xbgr.mr_n72551152)
print v(xbgr.mr_n72551472)
print v(xbgr.mr_n72551584)
print v(xbgr.mr_n72551904)
print v(xbgr.mr_n72552016)
print v(xbgr.mr_n72552448)
print v(xbgr.mr_n72552768)
print v(xbgr.mr_n72552880)
print v(xbgr.mr_n72553200)
print v(xbgr.mr_n72553312)
print v(xbgr.mr_n72553632)
print v(xbgr.mr_n72553744)
print v(xbgr.mr_n72554064)
print v(xbgr.mr_n72554176)
print v(xbgr.mr_n72554496)
print v(xbgr.mr_n72554608)
print v(xbgr.mr_n72555040)
print v(xbgr.mr_n72555360)
print v(xbgr.mr_n72556224)
print v(xbgr.mr_n72556336)
print v(xbgr.mr_n72556768)
print v(xbgr.mr_n72557088)
print v(xbgr.mr_n72557952)
print v(xbgr.mr_n72558064)
print v(xbgr.mr_n72558496)
print v(xbgr.mr_n72558816)
print v(xbgr.mr_n72558928)
print v(xbgr.mr_n72559248)
print v(xbgr.mr_n72559360)
print v(xbgr.mr_n72559680)
print v(xbgr.mr_n72559792)
print v(xbgr.mr_n72560112)
print v(xbgr.mr_n72560224)
print v(xbgr.mr_n72560544)
print v(xbgr.mr_n72560656)
print v(xbgr.mr_n72560976)
print v(xbgr.mr_n72561088)
print v(xbgr.mr_n72561408)
print v(xbgr.mr_n72562272)
print v(xbgr.mr_n72562384)
print v(xbgr.mr_n72562704)
print v(xbgr.mr_n72562816)
print v(xbgr.mr_n72563136)
print v(xbgr.mr_n72564000)
print v(xbgr.mr_n72564112)
print v(xbgr.mr_n72564432)
print v(xbgr.mr_n72564544)
print v(xbgr.mr_n72564864)
print v(xbgr.mr_n72564976)
print v(xbgr.mr_n72565296)
print v(xbgr.mr_n72565408)
print v(xbgr.mr_n72565728)
print v(xbgr.mr_n72565840)
print v(xbgr.mr_n72566160)
print v(xbgr.mr_n72566272)
print v(xbgr.mr_n72566592)
print v(xbgr.mr_n72566704)
print v(xbgr.mr_n72567024)
print v(xbgr.mr_n72567136)
print v(xbgr.mr_n72567456)
print v(xbgr.mr_n72567568)
print v(xbgr.mr_n72567888)
print v(xbgr.mr_n72568000)
print v(xbgr.mr_n72568320)
print v(xbgr.mr_n72568432)
print v(xbgr.mr_n72568752)
print v(xbgr.mr_n72568864)
print v(xbgr.mr_n72569184)
print v(xbgr.mr_n72569296)
print v(xbgr.mr_n72569616)
print v(xbgr.mr_n72569728)
print v(xbgr.mr_n72570048)
print v(xbgr.mr_n72570160)
print v(xbgr.mr_n72570480)
print v(xbgr.mr_n72570592)
print v(xbgr.mr_n72570912)
print v(xbgr.mr_n72571024)
print v(xbgr.mr_n72571344)
print v(xbgr.mr_n72571456)
print v(xbgr.mr_n72571776)
print v(xbgr.mr_n72571888)
print v(xbgr.mr_n72572208)
print v(xbgr.mr_n72572320)
print v(xbgr.mr_n72572640)
print v(xbgr.mr_n72572752)
print v(xbgr.mr_n72573072)
print v(xbgr.mr_n72573184)
print v(xbgr.mr_n72573504)
print v(xbgr.mr_n72573616)
print v(xbgr.mr_n72573936)
print v(xbgr.mr_n72574048)
print v(xbgr.mr_n72574368)
print v(xbgr.mr_n72574480)
print v(xbgr.mr_n72574800)
print v(xbgr.mr_n72574912)
print v(xbgr.mr_n72575344)
print v(xbgr.mr_n72575776)
print v(xbgr.mr_n72576208)
print v(xbgr.mr_n72576640)
print v(xbgr.mr_n72577072)
print v(xbgr.mr_n72577504)
print v(xbgr.mr_n72577936)
print v(xbgr.mr_n72578368)
print v(xbgr.mr_n72578800)
print v(xbgr.mr_n72579232)
print v(xbgr.mr_n72579664)
print v(xbgr.mr_n72580096)
print v(xbgr.mr_n72580528)
print v(xbgr.mr_n72580960)
print v(xbgr.mr_n72581392)
print v(xbgr.mr_n72581824)
print v(xbgr.mr_n72582256)
print v(xbgr.mr_n72582688)
print v(xbgr.mr_n72583120)
print v(xbgr.mr_n72583552)
print v(xbgr.mr_n72583984)
print v(xbgr.mr_n72584416)
print v(xbgr.mr_n72584736)
print v(xbgr.mr_n72584848)
print v(xbgr.mr_n72585280)
print v(xbgr.mr_n72585712)
print v(xbgr.mr_n72586144)
print v(xbgr.mr_n72586576)
print v(xbgr.mr_n72587008)
print v(xbgr.mr_n72587440)
print v(xbgr.mr_n72587872)
print v(xbgr.mr_n72588304)
print v(xbgr.mr_n72588736)
print v(xbgr.mr_n72589168)
print v(xbgr.mr_n72589600)
print v(xbgr.mr_n72590032)
print v(xbgr.mr_n72590464)
print v(xbgr.mr_n72590896)
print v(xbgr.mr_n72591328)
print v(xbgr.mr_n72591760)
print v(xbgr.mr_n72592192)
print v(xbgr.mr_n72592624)
print v(xbgr.mr_n72593056)
print v(xbgr.mr_n72593488)
print v(xbgr.mr_n72593920)
print v(xbgr.mr_n72594352)
print v(xbgr.mr_n72594784)
print v(xbgr.mr_n72595216)
print v(xbgr.mr_n72595648)
print v(xbgr.mr_n72596080)
print v(xbgr.mr_n72596512)
print v(xbgr.mr_n72596944)
print v(xbgr.mr_n72597376)
print v(xbgr.mr_n72597808)
print v(xbgr.mr_n72598240)
print v(xbgr.mr_n72598672)
print v(xbgr.mr_n72599104)
print v(xbgr.mr_n72599536)
print v(xbgr.mr_n72599968)
print v(xbgr.mr_n72600400)
print v(xbgr.mr_n72600832)
print v(xbgr.mr_n72601264)
print v(xbgr.mr_n72601696)
print v(xbgr.mr_n72602128)
print v(xbgr.mr_n72602560)
print v(xbgr.mr_n72602992)
print v(xbgr.mr_n72603424)
print v(xbgr.mr_n72603856)
print v(xbgr.mr_n72604288)
print v(xbgr.mr_n72604720)
print v(xbgr.mr_n72605152)
print v(xbgr.mr_n72605584)
print v(xbgr.mr_n72606016)
print v(xbgr.mr_n72606448)
print v(xbgr.mr_n72606880)
print v(xbgr.mr_n72607312)
print v(xbgr.mr_n72607744)
print v(xbgr.mr_n72608176)
print v(xbgr.mr_n72608608)
print v(xbgr.mr_n72609040)
print v(xbgr.mr_n72609472)
print v(xbgr.mr_n72609904)
print v(xbgr.mr_n72610336)
print v(xbgr.mr_n72610768)
print v(xbgr.mr_n72611200)
print v(xbgr.mr_n72611632)
print v(xbgr.mr_n72612064)
print v(xbgr.mr_n72612384)
print v(xbgr.mr_n72612496)
print v(xbgr.mr_n72612816)
print v(xbgr.mr_n72612928)
print v(xbgr.mr_n72613248)
print v(xbgr.mr_n72613360)
print v(xbgr.mr_n72613680)
print v(xbgr.mr_n72613792)
print v(xbgr.mr_n72614112)
print v(xbgr.mr_n72614224)
print v(xbgr.mr_n72614544)
print v(xbgr.mr_n72614656)
print v(xbgr.mr_n72614976)
print v(xbgr.mr_n72615088)
print v(xbgr.mr_n72615408)
print v(xbgr.mr_n72615520)
print v(xbgr.mr_n72615840)
print v(xbgr.mr_n72615952)
print v(xbgr.mr_n72616272)
print v(xbgr.mr_n72616384)
print v(xbgr.mr_n72616704)
print v(xbgr.mr_n72616816)
print v(xbgr.mr_n72617136)
print v(xbgr.mr_n72617248)
print v(xbgr.mr_n72617568)
print v(xbgr.mr_n72618000)
print v(xbgr.mr_n72618112)
print v(xbgr.mr_n72618432)
print v(xbgr.mr_n72618544)
print v(xbgr.mr_n72618864)
print v(xbgr.mr_n72618976)
print v(xbgr.mr_n72619296)
print v(xbgr.mr_n72619408)
print v(xbgr.mr_n72619728)
print v(xbgr.mr_n72619840)
print v(xbgr.mr_n72620160)
print v(xbgr.mr_n72620272)
print v(xbgr.mr_n72620592)
print v(xbgr.mr_n72620704)
print v(xbgr.mr_n72621024)
print v(xbgr.mr_n72621136)
print v(xbgr.mr_n72621456)
print v(xbgr.mr_n72621568)
print v(xbgr.mr_n72621888)
print v(xbgr.mr_n72622000)
print v(xbgr.mr_n72622320)
print v(xbgr.mr_n72622432)
print v(xbgr.mr_n72622864)
print v(xbgr.mr_n72623296)
print v(xbgr.mr_n72623728)
print v(xbgr.mr_n72624160)
print v(xbgr.mr_n72624592)
print v(xbgr.mr_n72625024)
print v(xbgr.mr_n72625456)
print v(xbgr.mr_n72625888)
print v(xbgr.mr_n72626320)
print v(xbgr.mr_n72626752)
print v(xbgr.mr_n72627184)
print v(xbgr.mr_n72627616)
print v(xbgr.mr_n72628048)
print v(xbgr.mr_n72628480)
print v(xbgr.mr_n72628912)
print v(xbgr.mr_n72629344)
print v(xbgr.mr_n72629776)
print v(xbgr.mr_n72630208)
print v(xbgr.mr_n72630640)
print v(xbgr.mr_n72631072)
print v(xbgr.mr_n72631504)
print v(xbgr.mr_n72631936)
print v(xbgr.mr_n72632368)
print v(xbgr.mr_n72632800)
print v(xbgr.mr_n72633232)
print v(xbgr.mr_n72633664)
print v(xbgr.mr_n72634096)
print v(xbgr.mr_n72634528)
print v(xbgr.mr_n72634960)
print v(xbgr.mr_n72635392)
print v(xbgr.mr_n72635824)
print v(xbgr.mr_n72636256)
print v(xbgr.mr_n72636688)
print v(xbgr.mr_n72637120)
print v(xbgr.mr_n72637552)
print v(xbgr.mr_n72637984)
print v(xbgr.mr_n72638416)
print v(xbgr.mr_n72638848)
print v(xbgr.mr_n72639280)
print v(xbgr.mr_n72639712)
print v(xbgr.mr_n72640144)
print v(xbgr.mr_n72640576)
print v(xbgr.mr_n72641008)
print v(xbgr.mr_n72641440)
print v(xbgr.mr_n72641872)
print v(xbgr.mr_n72642304)
print v(xbgr.mr_n72642736)
print v(xbgr.mr_n72643168)
print v(xbgr.mr_n72643600)
print v(xbgr.mr_n72644032)
print v(xbgr.mr_n72644464)
print v(xbgr.mr_n72644896)
print v(xbgr.mr_n72645328)
print v(xbgr.mr_n72645760)
print v(xbgr.mr_n72646192)
print v(xbgr.mr_n72646624)
print v(xbgr.mr_n72647056)
print v(xbgr.mr_n72647488)
print v(xbgr.mr_n72647920)
print v(xbgr.mr_n72648352)
print v(xbgr.mr_n72648784)
print v(xbgr.mr_n72649216)
print v(xbgr.mr_n72649648)
print v(xbgr.mr_n72650080)
print v(xbgr.mr_n72650512)
print v(xbgr.mr_n72650944)
print v(xbgr.mr_n72651376)
print v(xbgr.mr_n72651808)
print v(xbgr.mr_n72652240)
print v(xbgr.mr_n72652672)
print v(xbgr.mr_n72653104)
print v(xbgr.mr_n72653536)
print v(xbgr.mr_n72653968)
print v(xbgr.mr_n72654400)
print v(xbgr.mr_n72654832)
print v(xbgr.mr_n72655264)
print v(xbgr.mr_n72655696)
print v(xbgr.mr_n72656128)
print v(xbgr.mr_n72656560)
print v(xbgr.mr_n72656992)
print v(xbgr.mr_n72657424)
print v(xbgr.mr_n72657856)
print v(xbgr.mr_n72658288)
print v(xbgr.mr_n72658720)
print v(xbgr.mr_n72659152)
print v(xbgr.mr_n72659584)
print v(xbgr.mr_n72659904)
print v(xbgr.mr_n72660016)
print v(xbgr.mr_n72660336)
print v(xbgr.mr_n72660448)
print v(xbgr.mr_n72660768)
print v(xbgr.mr_n72660880)
print v(xbgr.mr_n72661200)
print v(xbgr.mr_n72661312)
print v(xbgr.mr_n72661632)
print v(xbgr.mr_n72661744)
print v(xbgr.mr_n72662064)
print v(xbgr.mr_n72662176)
print v(xbgr.mr_n72662496)
print v(xbgr.mr_n72662608)
print v(xbgr.mr_n72662928)
print v(xbgr.mr_n72663040)
print v(xbgr.mr_n72663360)
print v(xbgr.mr_n72663472)
print v(xbgr.mr_n72663792)
print v(xbgr.mr_n72663904)
print v(xbgr.mr_n72664224)
print v(xbgr.mr_n72664336)
print v(xbgr.mr_n72664656)
print v(xbgr.mr_n72664768)
print v(xbgr.mr_n72665088)
print v(xbgr.mr_n72665200)
print v(xbgr.mr_n72665520)
print v(xbgr.mr_n72665632)
print v(xbgr.mr_n72665952)
print v(xbgr.mr_n72666064)
print v(xbgr.mr_n72666384)
print v(xbgr.mr_n72666496)
print v(xbgr.mr_n72666816)
print v(xbgr.mr_n72666928)
print v(xbgr.mr_n72667248)
print v(xbgr.mr_n72667360)
print v(xbgr.mr_n72667680)
print v(xbgr.mr_n72668224)
print v(xbgr.mr_n72668544)
print v(xbgr.mr_n72668976)
print v(xbgr.mr_n72669088)
print v(xbgr.mr_n72669408)
print v(xbgr.mr_n72669520)
print v(xbgr.mr_n72669952)
print v(xbgr.mr_n72670272)
print v(xbgr.mr_n72671136)
print v(xbgr.mr_n72671248)
print v(xbgr.mr_n72671680)
print v(xbgr.mr_n72672000)
print v(xbgr.mr_n72672864)
print v(xbgr.mr_n72672976)
print v(xbgr.mr_n72673408)
print v(xbgr.mr_n72673728)
print v(xbgr.mr_n72673840)
print v(xbgr.mr_n72674272)
print v(xbgr.mr_n72674704)
print v(xbgr.mr_n72675024)
print v(xbgr.mr_n72675888)
print v(xbgr.mr_n72676864)
print v(xbgr.mr_n72677184)
print v(xbgr.mr_n72677296)
print v(xbgr.mr_n72677728)
print v(xbgr.mr_n72678048)
print v(xbgr.mr_n72678160)
print v(xbgr.mr_n72678592)
print v(xbgr.mr_n72678912)
print v(xbgr.mr_n72679024)
print v(xbgr.mr_n72679344)
print v(xbgr.mr_n72679456)
print v(xbgr.mr_n72679776)
print v(xbgr.mr_n72679888)
print v(xbgr.mr_n72680208)
print v(xbgr.mr_n72680320)
print v(xbgr.mr_n72680640)
print v(xbgr.mr_n72680752)
print v(xbgr.mr_n72681072)
print v(xbgr.mr_n72681184)
print v(xbgr.mr_n72681504)
print v(xbgr.mr_n72681616)
print v(xbgr.mr_n72681936)
print v(xbgr.mr_n72682048)
print v(xbgr.mr_n72682368)
print v(xbgr.mr_n72682480)
print v(xbgr.mr_n72682800)
print v(xbgr.mr_n72682912)
print v(xbgr.mr_n72683232)
print v(xbgr.mr_n72683344)
print v(xbgr.mr_n72683664)
print v(xbgr.mr_n72683776)
print v(xbgr.mr_n72684096)
print v(xbgr.mr_n72684960)
print v(xbgr.mr_n72685824)
print v(xbgr.mr_n72686256)
print v(xbgr.mr_n72686688)
print v(xbgr.mr_n72687120)
print v(xbgr.mr_n72687552)
print v(xbgr.mr_n72687984)
print v(xbgr.mr_n72688416)
print v(xbgr.mr_n72688848)
print v(xbgr.mr_n72689280)
print v(xbgr.mr_n72689712)
print v(xbgr.mr_n72690144)
print v(xbgr.mr_n72690576)
print v(xbgr.mr_n72691008)
print v(xbgr.mr_n72691120)
print v(xbgr.mr_n72691440)
print v(xbgr.mr_n72691552)
print v(xbgr.mr_n72691872)
print v(xbgr.mr_n72691984)
print v(xbgr.mr_n72692304)
print v(xbgr.mr_n72692416)
print v(xbgr.mr_n72692736)
print v(xbgr.mr_n72692848)
print v(xbgr.mr_n72693168)
print v(xbgr.mr_n72693280)
print v(xbgr.mr_n72693600)
print v(xbgr.mr_n72693712)
print v(xbgr.mr_n72694032)
print v(xbgr.mr_n72694144)
print v(xbgr.mr_n72694464)
print v(xbgr.mr_n72694576)
print v(xbgr.mr_n72694896)
print v(xbgr.mr_n72695008)
print v(xbgr.mr_n72695328)
print v(xbgr.mr_n72695440)
print v(xbgr.mr_n72695760)
print v(xbgr.mr_n72695872)
print v(xbgr.mr_n72696192)
print v(xbgr.mr_n72696624)
print v(xbgr.mr_n72696736)
print v(xbgr.mr_n72697056)
print v(xbgr.mr_n72697168)
print v(xbgr.mr_n72697488)
print v(xbgr.mr_n72697600)
print v(xbgr.mr_n72697920)
print v(xbgr.mr_n72698032)
print v(xbgr.mr_n72698352)
print v(xbgr.mr_n72698464)
print v(xbgr.mr_n72698784)
print v(xbgr.mr_n72698896)
print v(xbgr.mr_n72699216)
print v(xbgr.mr_n72699328)
print v(xbgr.mr_n72699648)
print v(xbgr.mr_n72699760)
print v(xbgr.mr_n72700080)
print v(xbgr.mr_n72700192)
print v(xbgr.mr_n72700512)
print v(xbgr.mr_n72700624)
print v(xbgr.mr_n72700944)
print v(xbgr.mr_n72701056)
print v(xbgr.mr_n72701376)
print v(xbgr.mr_n72701488)
print v(xbgr.mr_n72701808)
print v(xbgr.mr_n72701920)
print v(xbgr.mr_n72702240)
print v(xbgr.mr_n72702352)
print v(xbgr.mr_n72702672)
print v(xbgr.mr_n72702784)
print v(xbgr.mr_n72703104)
print v(xbgr.mr_n72703216)
print v(xbgr.mr_n72703536)
print v(xbgr.mr_n72703648)
print v(xbgr.mr_n72703968)
print v(xbgr.mr_n72704080)
print v(xbgr.mr_n72704400)
print v(xbgr.mr_n72704512)
print v(xbgr.mr_n72704832)
print v(xbgr.mr_n72704944)
print v(xbgr.mr_n72705264)
print v(xbgr.mr_n72705376)
print v(xbgr.mr_n72705696)
print v(xbgr.mr_n72705808)
print v(xbgr.mr_n72706128)
print v(xbgr.mr_n72706240)
print v(xbgr.mr_n72706560)
print v(xbgr.mr_n72706672)
print v(xbgr.mr_n72706992)
print v(xbgr.mr_n72707104)
print v(xbgr.mr_n72707424)
print v(xbgr.mr_n72707536)
print v(xbgr.mr_n72707856)
print v(xbgr.mr_n72707968)
print v(xbgr.mr_n72708288)
print v(xbgr.mr_n72708400)
print v(xbgr.mr_n72708720)
print v(xbgr.mr_n72708832)
print v(xbgr.mr_n72709152)
print v(xbgr.mr_n72709264)
print v(xbgr.mr_n72709584)
print v(xbgr.mr_n72709696)
print v(xbgr.mr_n72710016)
print v(xbgr.mr_n72710128)
print v(xbgr.mr_n72710448)
print v(xbgr.mr_n72710560)
print v(xbgr.mr_n72710880)
print v(xbgr.mr_n72710992)
print v(xbgr.mr_n72711312)
print v(xbgr.mr_n72711424)
print v(xbgr.mr_n72711744)
print v(xbgr.mr_n72711856)
print v(xbgr.mr_n72712176)
print v(xbgr.mr_n72712288)
print v(xbgr.mr_n72712608)
print v(xbgr.mr_n72712720)
print v(xbgr.mr_n72713040)
print v(xbgr.mr_n72713152)
print v(xbgr.mr_n72713472)
print v(xbgr.mr_n72713584)
print v(xbgr.mr_n72713904)
print v(xbgr.mr_n72714016)
print v(xbgr.mr_n72714336)
print v(xbgr.mr_n72714448)
print v(xbgr.mr_n72714768)
print v(xbgr.mr_n72714880)
print v(xbgr.mr_n72715200)
print v(xbgr.mr_n72715312)
print v(xbgr.mr_n72715632)
print v(xbgr.mr_n72715744)
print v(xbgr.mr_n72716064)
print v(xbgr.mr_n72716176)
print v(xbgr.mr_n72716496)
print v(xbgr.mr_n72716608)
print v(xbgr.mr_n72716928)
print v(xbgr.mr_n72717040)
print v(xbgr.mr_n72717360)
print v(xbgr.mr_n72717472)
print v(xbgr.mr_n72717792)
print v(xbgr.mr_n72717904)
print v(xbgr.mr_n72718224)
print v(xbgr.mr_n72718336)
print v(xbgr.mr_n72718656)
print v(xbgr.mr_n72718768)
print v(xbgr.mr_n72719088)
print v(xbgr.mr_n72719200)
print v(xbgr.mr_n72719520)
print v(xbgr.mr_n72719632)
print v(xbgr.mr_n72719952)
print v(xbgr.mr_n72720064)
print v(xbgr.mr_n72720384)
print v(xbgr.mr_n72720496)
print v(xbgr.mr_n72720816)
print v(xbgr.mr_n72720928)
print v(xbgr.mr_n72721248)
print v(xbgr.mr_n72721360)
print v(xbgr.mr_n72721680)
print v(xbgr.mr_n72721792)
print v(xbgr.mr_n72722112)
print v(xbgr.mr_n72722224)
print v(xbgr.mr_n72722544)
print v(xbgr.mr_n72722656)
print v(xbgr.mr_n72722976)
print v(xbgr.mr_n72723088)
print v(xbgr.mr_n72723408)
print v(xbgr.mr_n72723520)
print v(xbgr.mr_n72723840)
print v(xbgr.mr_n72723952)
print v(xbgr.mr_n72724272)
print v(xbgr.mr_n72724384)
print v(xbgr.mr_n72724704)
print v(xbgr.mr_n72724816)
print v(xbgr.mr_n72725136)
print v(xbgr.mr_n72725248)
print v(xbgr.mr_n72725568)
print v(xbgr.mr_n72725680)
print v(xbgr.mr_n72726000)
print v(xbgr.mr_n72726112)
print v(xbgr.mr_n72726432)
print v(xbgr.mr_n72726544)
print v(xbgr.mr_n72726864)
print v(xbgr.mr_n72726976)
print v(xbgr.mr_n72727296)
print v(xbgr.mr_n72727408)
print v(xbgr.mr_n72727728)
print v(xbgr.mr_n72727840)
print v(xbgr.mr_n72728160)
print v(xbgr.mr_n72728592)
print v(xbgr.mr_n72728704)
print v(xbgr.mr_n72729024)
print v(xbgr.mr_n72729136)
print v(xbgr.mr_n72729456)
print v(xbgr.mr_n72729568)
print v(xbgr.mr_n72729888)
print v(xbgr.mr_n72730000)
print v(xbgr.mr_n72730320)
print v(xbgr.mr_n72730432)
print v(xbgr.mr_n72730752)
print v(xbgr.mr_n72730864)
print v(xbgr.mr_n72731184)
print v(xbgr.mr_n72731296)
print v(xbgr.mr_n72731616)
print v(xbgr.mr_n72731728)
print v(xbgr.mr_n72732048)
print v(xbgr.mr_n72732160)
print v(xbgr.mr_n72732480)
print v(xbgr.mr_n72732592)
print v(xbgr.mr_n72732912)
print v(xbgr.mr_n72733024)
print v(xbgr.mr_n72733344)
print v(xbgr.mr_n72733456)
print v(xbgr.mr_n72733776)
print v(xbgr.mr_n72733888)
print v(xbgr.mr_n72734208)
print v(xbgr.mr_n72734320)
print v(xbgr.mr_n72734640)
print v(xbgr.mr_n72734752)
print v(xbgr.mr_n72735072)
print v(xbgr.mr_n72735184)
print v(xbgr.mr_n72735504)
print v(xbgr.mr_n72735616)
print v(xbgr.mr_n72735936)
print v(xbgr.mr_n72736048)
print v(xbgr.mr_n72736368)
print v(xbgr.mr_n72736912)
print v(xbgr.mr_n72737232)
print v(xbgr.mr_n72737344)
print v(xbgr.mr_n72737664)
print v(xbgr.mr_n72737776)
print v(xbgr.mr_n72738208)
print v(xbgr.mr_n72738640)
print v(xbgr.mr_n72739072)
print v(xbgr.mr_n72739504)
print v(xbgr.mr_n72739936)
print v(xbgr.mr_n72740368)
print v(xbgr.mr_n72740800)
print v(xbgr.mr_n72741232)
print v(xbgr.mr_n72741664)
print v(xbgr.mr_n72742096)
print v(xbgr.mr_n72742528)
print v(xbgr.mr_n72742960)
print v(xbgr.mr_n72743392)
print v(xbgr.mr_n72743824)
print v(xbgr.mr_n72744256)
print v(xbgr.mr_n72744688)
print v(xbgr.mr_n72745120)
print v(xbgr.mr_n72745552)
print v(xbgr.mr_n72745984)
print v(xbgr.mr_n72746416)
print v(xbgr.mr_n72746848)
print v(xbgr.mr_n72747280)
print v(xbgr.mr_n72747712)
print v(xbgr.mr_n72748144)
print v(xbgr.mr_n72748576)
print v(xbgr.mr_n72749008)
print v(xbgr.mr_n72749440)
print v(xbgr.mr_n72749872)
print v(xbgr.mr_n72750304)
print v(xbgr.mr_n72750736)
print v(xbgr.mr_n72751168)
print v(xbgr.mr_n72751600)
print v(xbgr.mr_n72752032)
print v(xbgr.mr_n72752464)
print v(xbgr.mr_n72752896)
print v(xbgr.mr_n72753328)
print v(xbgr.mr_n72753760)
print v(xbgr.mr_n72754192)
print v(xbgr.mr_n72754624)
print v(xbgr.mr_n72755056)
print v(xbgr.mr_n72755488)
print v(xbgr.mr_n72755920)
print v(xbgr.mr_n72756352)
print v(xbgr.mr_n72756784)
print v(xbgr.mr_n72757216)
print v(xbgr.mr_n72757648)
print v(xbgr.mr_n72758080)
print v(xbgr.mr_n72758512)
print v(xbgr.mr_n72758944)
print v(xbgr.mr_n72759376)
print v(xbgr.mr_n72759808)
print v(xbgr.mr_n72760240)
print v(xbgr.mr_n72760672)
print v(xbgr.mr_n72761104)
print v(xbgr.mr_n72761536)
print v(xbgr.mr_n72761968)
print v(xbgr.mr_n72762400)
print v(xbgr.mr_n72762832)
print v(xbgr.mr_n72763264)
print v(xbgr.mr_n72763696)
print v(xbgr.mr_n72764128)
print v(xbgr.mr_n72764560)
print v(xbgr.mr_n72764992)
print v(xbgr.mr_n72765424)
print v(xbgr.mr_n72765856)
print v(xbgr.mr_n72766288)
print v(xbgr.mr_n72766720)
print v(xbgr.mr_n72767152)
print v(xbgr.mr_n72767584)
print v(xbgr.mr_n72768016)
print v(xbgr.mr_n72768448)
print v(xbgr.mr_n72768880)
print v(xbgr.mr_n72769312)
print v(xbgr.mr_n72769744)
print v(xbgr.mr_n72770176)
print v(xbgr.mr_n72770608)
print v(xbgr.mr_n72771040)
print v(xbgr.mr_n72771472)
print v(xbgr.mr_n72771904)
print v(xbgr.mr_n72772336)
print v(xbgr.mr_n72772768)
print v(xbgr.mr_n72773200)
print v(xbgr.mr_n72773632)
print v(xbgr.mr_n72774064)
print v(xbgr.mr_n72774496)
print v(xbgr.mr_n72774928)
print v(xbgr.mr_n72775360)
print v(xbgr.mr_n72775792)
print v(xbgr.mr_n72776224)
print v(xbgr.mr_n72776656)
print v(xbgr.mr_n72777088)
print v(xbgr.mr_n72777520)
print v(xbgr.mr_n72777952)
print v(xbgr.mr_n72778384)
print v(xbgr.mr_n72778816)
print v(xbgr.mr_n72779248)
print v(xbgr.mr_n72779680)
print v(xbgr.mr_n72780112)
print v(xbgr.mr_n72780544)
print v(xbgr.mr_n72780976)
print v(xbgr.mr_n72781408)
print v(xbgr.mr_n72781840)
print v(xbgr.mr_n72782272)
print v(xbgr.mr_n72782704)
print v(xbgr.mr_n72783136)
print v(xbgr.mr_n72783456)
print v(xbgr.mr_n72783568)
print v(xbgr.mr_n72783888)
print v(xbgr.mr_n72784000)
print v(xbgr.mr_n72784320)
print v(xbgr.mr_n72784432)
print v(xbgr.mr_n72784752)
print v(xbgr.mr_n72784864)
print v(xbgr.mr_n72785184)
print v(xbgr.mr_n72785296)
print v(xbgr.mr_n72785616)
print v(xbgr.mr_n72785728)
print v(xbgr.mr_n72786048)
print v(xbgr.mr_n72786160)
print v(xbgr.mr_n72786480)
print v(xbgr.mr_n72786592)
print v(xbgr.mr_n72786912)
print v(xbgr.mr_n72787024)
print v(xbgr.mr_n72787344)
print v(xbgr.mr_n72787456)
print v(xbgr.mr_n72787776)
print v(xbgr.mr_n72787888)
print v(xbgr.mr_n72788208)
print v(xbgr.mr_n72788320)
print v(xbgr.mr_n72788640)
print v(xbgr.mr_n72788752)
print v(xbgr.mr_n72789072)
print v(xbgr.mr_n72789184)
print v(xbgr.mr_n72789504)
print v(xbgr.mr_n72789616)
print v(xbgr.mr_n72789936)
print v(xbgr.mr_n72790048)
print v(xbgr.mr_n72790368)
print v(xbgr.mr_n72790480)
print v(xbgr.mr_n72790800)
print v(xbgr.mr_n72790912)
print v(xbgr.mr_n72791232)
print v(xbgr.mr_n72791344)
print v(xbgr.mr_n72791664)
print v(xbgr.mr_n72791776)
print v(xbgr.mr_n72792096)
print v(xbgr.mr_n72792208)
print v(xbgr.mr_n72792528)
print v(xbgr.mr_n72792640)
print v(xbgr.mr_n72792960)
print v(xbgr.mr_n72793072)
print v(xbgr.mr_n72793392)
print v(xbgr.mr_n72793504)
print v(xbgr.mr_n72793824)
print v(xbgr.mr_n72793936)
print v(xbgr.mr_n72794256)
print v(xbgr.mr_n72794368)
print v(xbgr.mr_n72794688)
print v(xbgr.mr_n72794800)
print v(xbgr.mr_n72795120)
print v(xbgr.mr_n72795232)
print v(xbgr.mr_n72795552)
print v(xbgr.mr_n72795664)
print v(xbgr.mr_n72795984)
print v(xbgr.mr_n72796096)
print v(xbgr.mr_n72796416)
print v(xbgr.mr_n72796528)
print v(xbgr.mr_n72796848)
print v(xbgr.mr_n72796960)
print v(xbgr.mr_n72797280)
print v(xbgr.mr_n72797392)
print v(xbgr.mr_n72797712)
print v(xbgr.mr_n72797824)
print v(xbgr.mr_n72798144)
print v(xbgr.mr_n72798256)
print v(xbgr.mr_n72798576)
print v(xbgr.mr_n72798688)
print v(xbgr.mr_n72799008)
print v(xbgr.mr_n72799120)
print v(xbgr.mr_n72799440)
print v(xbgr.mr_n72799552)
print v(xbgr.mr_n72799872)
print v(xbgr.mr_n72799984)
print v(xbgr.mr_n72800304)
print v(xbgr.mr_n72800416)
print v(xbgr.mr_n72800736)
print v(xbgr.mr_n72800848)
print v(xbgr.mr_n72801168)
print v(xbgr.mr_n72801280)
print v(xbgr.mr_n72801600)
print v(xbgr.mr_n72802032)
print v(xbgr.mr_n72802144)
print v(xbgr.mr_n72802464)
print v(xbgr.mr_n72802576)
print v(xbgr.mr_n72802896)
print v(xbgr.mr_n72803008)
print v(xbgr.mr_n72803328)
print v(xbgr.mr_n72803440)
print v(xbgr.mr_n72803760)
print v(xbgr.mr_n72803872)
print v(xbgr.mr_n72804192)
print v(xbgr.mr_n72804304)
print v(xbgr.mr_n72804624)
print v(xbgr.mr_n72804736)
print v(xbgr.mr_n72805056)
print v(xbgr.mr_n72805168)
print v(xbgr.mr_n72805488)
print v(xbgr.mr_n72805600)
print v(xbgr.mr_n72805920)
print v(xbgr.mr_n72806032)
print v(xbgr.mr_n72806352)
print v(xbgr.mr_n72806464)
print v(xbgr.mr_n72806784)
print v(xbgr.mr_n72806896)
print v(xbgr.mr_n72807216)
print v(xbgr.mr_n72807328)
print v(xbgr.mr_n72807648)
print v(xbgr.mr_n72807760)
print v(xbgr.mr_n72808080)
print v(xbgr.mr_n72808192)
print v(xbgr.mr_n72808512)
print v(xbgr.mr_n72808624)
print v(xbgr.mr_n72808944)
print v(xbgr.mr_n72809056)
print v(xbgr.mr_n72809376)
print v(xbgr.mr_n72809488)
print v(xbgr.mr_n72809808)
print v(xbgr.mr_n72809920)
print v(xbgr.mr_n72810240)
print v(xbgr.mr_n72810352)
print v(xbgr.mr_n72810672)
print v(xbgr.mr_n72810784)
print v(xbgr.mr_n72811104)
print v(xbgr.mr_n72811216)
print v(xbgr.mr_n72811536)
print v(xbgr.mr_n72811648)
print v(xbgr.mr_n72811968)
print v(xbgr.mr_n72812080)
print v(xbgr.mr_n72812400)
print v(xbgr.mr_n72812512)
print v(xbgr.mr_n72812832)
print v(xbgr.mr_n72812944)
print v(xbgr.mr_n72813264)
print v(xbgr.mr_n72813376)
print v(xbgr.mr_n72813696)
print v(xbgr.mr_n72813808)
print v(xbgr.mr_n72814128)
print v(xbgr.mr_n72814240)
print v(xbgr.mr_n72814560)
print v(xbgr.mr_n72814672)
print v(xbgr.mr_n72814992)
print v(xbgr.mr_n72815104)
print v(xbgr.mr_n72815424)
print v(xbgr.mr_n72815536)
print v(xbgr.mr_n72815856)
print v(xbgr.mr_n72815968)
print v(xbgr.mr_n72816288)
print v(xbgr.mr_n72816400)
print v(xbgr.mr_n72816720)
print v(xbgr.mr_n72816832)
print v(xbgr.mr_n72817152)
print v(xbgr.mr_n72817264)
print v(xbgr.mr_n72817584)
print v(xbgr.mr_n72817696)
print v(xbgr.mr_n72818016)
print v(xbgr.mr_n72818128)
print v(xbgr.mr_n72818448)
print v(xbgr.mr_n72818560)
print v(xbgr.mr_n72818880)
print v(xbgr.mr_n72818992)
print v(xbgr.mr_n72819312)
print v(xbgr.mr_n72819424)
print v(xbgr.mr_n72819744)
print v(xbgr.mr_n72819856)
print v(xbgr.mr_n72820176)
print v(xbgr.mr_n72820288)
print v(xbgr.mr_n72820608)
print v(xbgr.mr_n72820720)
print v(xbgr.mr_n72821040)
print v(xbgr.mr_n72821152)
print v(xbgr.mr_n72821472)
print v(xbgr.mr_n72821584)
print v(xbgr.mr_n72821904)
print v(xbgr.mr_n72822016)
print v(xbgr.mr_n72822336)
print v(xbgr.mr_n72822448)
print v(xbgr.mr_n72822768)
print v(xbgr.mr_n72822880)
print v(xbgr.mr_n72823200)
print v(xbgr.mr_n72823312)
print v(xbgr.mr_n72823632)
print v(xbgr.mr_n72823744)
print v(xbgr.mr_n72824064)
print v(xbgr.mr_n72824176)
print v(xbgr.mr_n72824496)
print v(xbgr.mr_n72824608)
print v(xbgr.mr_n72824928)
print v(xbgr.mr_n72825040)
print v(xbgr.mr_n72825360)
print v(xbgr.mr_n72825472)
print v(xbgr.mr_n72825792)
print v(xbgr.mr_n72825904)
print v(xbgr.mr_n72826224)
print v(xbgr.mr_n72826336)
print v(xbgr.mr_n72826656)
print v(xbgr.mr_n72826768)
print v(xbgr.mr_n72827088)
print v(xbgr.mr_n72827200)
print v(xbgr.mr_n72827520)
print v(xbgr.mr_n72827632)
print v(xbgr.mr_n72827952)
print v(xbgr.mr_n72828064)
print v(xbgr.mr_n72828384)
print v(xbgr.mr_n72828496)
print v(xbgr.mr_n72828816)
print v(xbgr.mr_n72828928)
print v(xbgr.mr_n72829248)
print v(xbgr.mr_n72829360)
print v(xbgr.mr_n72829680)
print v(xbgr.mr_n72829792)
print v(xbgr.mr_n72830112)
print v(xbgr.mr_n72830224)
print v(xbgr.mr_n72830544)
print v(xbgr.mr_n72830656)
print v(xbgr.mr_n72830976)
print v(xbgr.mr_n72831088)
print v(xbgr.mr_n72831408)
print v(xbgr.mr_n72831520)
print v(xbgr.mr_n72831840)
print v(xbgr.mr_n72831952)
print v(xbgr.mr_n72832272)
print v(xbgr.mr_n72832384)
print v(xbgr.mr_n72832704)
print v(xbgr.mr_n72832816)
print v(xbgr.mr_n72833136)
print v(xbgr.mr_n72833248)
print v(xbgr.mr_n72833568)
print v(xbgr.mr_n72833680)
print v(xbgr.mr_n72834000)
print v(xbgr.mr_n72834112)
print v(xbgr.mr_n72834432)
print v(xbgr.mr_n72834544)
print v(xbgr.mr_n72834864)
print v(xbgr.mr_n72834976)
print v(xbgr.mr_n72835296)
print v(xbgr.mr_n72835408)
print v(xbgr.mr_n72835728)
print v(xbgr.mr_n72835840)
print v(xbgr.mr_n72836160)
print v(xbgr.mr_n72836272)
print v(xbgr.mr_n72836592)
print v(xbgr.mr_n72836704)
print v(xbgr.mr_n72837024)
print v(xbgr.mr_n72837136)
print v(xbgr.mr_n72837456)
print v(xbgr.mr_n72837568)
print v(xbgr.mr_n72837888)
print v(xbgr.mr_n72838000)
print v(xbgr.mr_n72838320)
print v(xbgr.mr_n72838432)
print v(xbgr.mr_n72838752)
print v(xbgr.mr_n72838864)
print v(xbgr.mr_n72839184)
print v(xbgr.mr_n72839296)
print v(xbgr.mr_n72839616)
print v(xbgr.mr_n72839728)
print v(xbgr.mr_n72840048)
print v(xbgr.mr_n72840160)
print v(xbgr.mr_n72840480)
print v(xbgr.mr_n72840592)
print v(xbgr.mr_n72840912)
print v(xbgr.mr_n72841024)
print v(xbgr.mr_n72841344)
print v(xbgr.mr_n72841456)
print v(xbgr.mr_n72841776)
print v(xbgr.mr_n72841888)
print v(xbgr.mr_n72842208)
print v(xbgr.mr_n72842320)
print v(xbgr.mr_n72842640)
print v(xbgr.mr_n72842752)
print v(xbgr.mr_n72843072)
print v(xbgr.mr_n72843184)
print v(xbgr.mr_n72843504)
print v(xbgr.mr_n72843616)
print v(xbgr.mr_n72843936)
print v(xbgr.mr_n72844048)
print v(xbgr.mr_n72844368)
print v(xbgr.mr_n72844480)
print v(xbgr.mr_n72844800)
print v(xbgr.mr_n72844912)
print v(xbgr.mr_n72845232)
print v(xbgr.mr_n72845344)
print v(xbgr.mr_n72845664)
print v(xbgr.mr_n72845776)
print v(xbgr.mr_n72846096)
print v(xbgr.mr_n72846208)
print v(xbgr.mr_n72846528)
print v(xbgr.mr_n72846640)
print v(xbgr.mr_n72846960)
print v(xbgr.mr_n72847072)
print v(xbgr.mr_n72847392)
print v(xbgr.mr_n72847504)
print v(xbgr.mr_n72847824)
print v(xbgr.mr_n72847936)
print v(xbgr.mr_n72848256)
print v(xbgr.mr_n72848368)
print v(xbgr.mr_n72848688)
print v(xbgr.mr_n72848800)
print v(xbgr.mr_n72849120)
print v(xbgr.mr_n72849232)
print v(xbgr.mr_n72849552)
print v(xbgr.mr_n72849664)
print v(xbgr.mr_n72849984)
print v(xbgr.mr_n72850096)
print v(xbgr.mr_n72850416)
print v(xbgr.mr_n72850528)
print v(xbgr.mr_n72850848)
print v(xbgr.mr_n72850960)
print v(xbgr.mr_n72851280)
print v(xbgr.mr_n72851392)
print v(xbgr.mr_n72851712)
print v(xbgr.mr_n72852144)
print v(xbgr.mr_n72852256)
print v(xbgr.mr_n72852576)
print v(xbgr.mr_n72852688)
print v(xbgr.mr_n72853008)
print v(xbgr.mr_n72853120)
print v(xbgr.mr_n72853440)
print v(xbgr.mr_n72853552)
print v(xbgr.mr_n72853872)
print v(xbgr.mr_n72853984)
print v(xbgr.mr_n72854304)
print v(xbgr.mr_n72854416)
print v(xbgr.mr_n72854736)
print v(xbgr.mr_n72854848)
print v(xbgr.mr_n72855168)
print v(xbgr.mr_n72855280)
print v(xbgr.mr_n72855600)
print v(xbgr.mr_n72855712)
print v(xbgr.mr_n72856032)
print v(xbgr.mr_n72856144)
print v(xbgr.mr_n72856464)
print v(xbgr.mr_n72856576)
print v(xbgr.mr_n72856896)
print v(xbgr.mr_n72857008)
print v(xbgr.mr_n72857328)
print v(xbgr.mr_n72857440)
print v(xbgr.mr_n72857760)
print v(xbgr.mr_n72857872)
print v(xbgr.mr_n72858192)
print v(xbgr.mr_n72858304)
print v(xbgr.mr_n72858624)
print v(xbgr.mr_n72858736)
print v(xbgr.mr_n72859056)
print v(xbgr.mr_n72859168)
print v(xbgr.mr_n72859488)
print v(xbgr.mr_n72859600)
print v(xbgr.mr_n72859920)
print v(xbgr.mr_n72860032)
print v(xbgr.mr_n72860352)
print v(xbgr.mr_n72860464)
print v(xbgr.mr_n72860784)
print v(xbgr.mr_n72860896)
print v(xbgr.mr_n72861216)
print v(xbgr.mr_n72861328)
print v(xbgr.mr_n72861648)
print v(xbgr.mr_n72861760)
print v(xbgr.mr_n72862080)
print v(xbgr.mr_n72862192)
print v(xbgr.mr_n72862512)
print v(xbgr.mr_n72862624)
print v(xbgr.mr_n72862944)
print v(xbgr.mr_n72863056)
print v(xbgr.mr_n72863376)
print v(xbgr.mr_n72863488)
print v(xbgr.mr_n72863808)
print v(xbgr.mr_n72863920)
print v(xbgr.mr_n72864240)
print v(xbgr.mr_n72864352)
print v(xbgr.mr_n72864672)
print v(xbgr.mr_n72864784)
print v(xbgr.mr_n72865104)
print v(xbgr.mr_n72865216)
print v(xbgr.mr_n72865536)
print v(xbgr.mr_n72865648)
print v(xbgr.mr_n72865968)
print v(xbgr.mr_n72866080)
print v(xbgr.mr_n72866400)
print v(xbgr.mr_n72866512)
print v(xbgr.mr_n72866832)
print v(xbgr.mr_n72866944)
print v(xbgr.mr_n72867264)
print v(xbgr.mr_n72867376)
print v(xbgr.mr_n72867696)
print v(xbgr.mr_n72867808)
print v(xbgr.mr_n72868128)
print v(xbgr.mr_n72868240)
print v(xbgr.mr_n72868560)
print v(xbgr.mr_n72868672)
print v(xbgr.mr_n72868992)
print v(xbgr.mr_n72869104)
print v(xbgr.mr_n72869424)
print v(xbgr.mr_n72869536)
print v(xbgr.mr_n72869856)
print v(xbgr.mr_n72869968)
print v(xbgr.mr_n72870288)
print v(xbgr.mr_n72870400)
print v(xbgr.mr_n72870720)
print v(xbgr.mr_n72870832)
print v(xbgr.mr_n72871152)
print v(xbgr.mr_n72871264)
print v(xbgr.mr_n72871584)
print v(xbgr.mr_n72871696)
print v(xbgr.mr_n72872016)
print v(xbgr.mr_n72872128)
print v(xbgr.mr_n72872448)
print v(xbgr.mr_n72872880)
print v(xbgr.mr_n72872992)
print v(xbgr.mr_n72873312)
print v(xbgr.mr_n72873424)
print v(xbgr.mr_n72873744)
print v(xbgr.mr_n72873856)
print v(xbgr.mr_n72874176)
print v(xbgr.mr_n72874288)
print v(xbgr.mr_n72874608)
print v(xbgr.mr_n72874720)
print v(xbgr.mr_n72875040)
print v(xbgr.mr_n72875152)
print v(xbgr.mr_n72875584)
print v(xbgr.mr_n72876016)
print v(xbgr.mr_n72876336)
print v(xbgr.mr_n72876448)
print v(xbgr.mr_n72876768)
print v(xbgr.mr_n72876880)
print v(xbgr.mr_n72877200)
print v(xbgr.mr_n72877312)
print v(xbgr.mr_n72877632)
print v(xbgr.mr_n72877744)
print v(xbgr.mr_n72878064)
print v(xbgr.mr_n72878176)
print v(xbgr.mr_n72878496)
print v(xbgr.mr_n72878608)
print v(xbgr.mr_n72878928)
print v(xbgr.mr_n72879040)
print v(xbgr.mr_n72879360)
print v(xbgr.mr_n72879472)
print v(xbgr.mr_n72879792)
print v(xbgr.mr_n72879904)
print v(xbgr.mr_n72880224)
print v(xbgr.mr_n72880336)
print v(xbgr.mr_n72880656)
print v(xbgr.mr_n72880768)
print v(xbgr.mr_n72881088)
print v(xbgr.mr_n72881200)
print v(xbgr.mr_n72881520)
print v(xbgr.mr_n72881632)
print v(xbgr.mr_n72881952)
print v(xbgr.mr_n72882064)
print v(xbgr.mr_n72882384)
print v(xbgr.mr_n72882496)
print v(xbgr.mr_n72882816)
print v(xbgr.mr_n72882928)
print v(xbgr.mr_n72883248)
print v(xbgr.mr_n72883360)
print v(xbgr.mr_n72883680)
print v(xbgr.mr_n72883792)
print v(xbgr.mr_n72884112)
print v(xbgr.mr_n72884224)
print v(xbgr.mr_n72884544)
print v(xbgr.mr_n72884656)
print v(xbgr.mr_n72884976)
print v(xbgr.mr_n72885088)
print v(xbgr.mr_n72885408)
print v(xbgr.mr_n72885520)
print v(xbgr.mr_n72885840)
print v(xbgr.mr_n72885952)
print v(xbgr.mr_n72886272)
print v(xbgr.mr_n72886384)
print v(xbgr.mr_n72886704)
print v(xbgr.mr_n72886816)
print v(xbgr.mr_n72887136)
print v(xbgr.mr_n72887248)
print v(xbgr.mr_n72887568)
print v(xbgr.mr_n72887680)
print v(xbgr.mr_n72888000)
print v(xbgr.mr_n72888112)
print v(xbgr.mr_n72888432)
print v(xbgr.mr_n72888544)
print v(xbgr.mr_n72888864)
print v(xbgr.mr_n72888976)
print v(xbgr.mr_n72889296)
print v(xbgr.mr_n72889408)
print v(xbgr.mr_n72889728)
print v(xbgr.mr_n72889840)
print v(xbgr.mr_n72890160)
print v(xbgr.mr_n72890272)
print v(xbgr.mr_n72890592)
print v(xbgr.mr_n72890704)
print v(xbgr.mr_n72891024)
print v(xbgr.mr_n72891136)
print v(xbgr.mr_n72891456)
print v(xbgr.mr_n72891568)
print v(xbgr.mr_n72891888)
print v(xbgr.mr_n72892000)
print v(xbgr.mr_n72892320)
print v(xbgr.mr_n72892432)
print v(xbgr.mr_n72892752)
print v(xbgr.mr_n72892864)
print v(xbgr.mr_n72893184)
print v(xbgr.mr_n72893296)
print v(xbgr.mr_n72893616)
print v(xbgr.mr_n72893728)
print v(xbgr.mr_n72894048)
print v(xbgr.mr_n72894160)
print v(xbgr.mr_n72894480)
print v(xbgr.mr_n72894592)
print v(xbgr.mr_n72894912)
print v(xbgr.mr_n72895024)
print v(xbgr.mr_n72895344)
print v(xbgr.mr_n72895456)
print v(xbgr.mr_n72895776)
print v(xbgr.mr_n72895888)
print v(xbgr.mr_n72896208)
print v(xbgr.mr_n72896320)
print v(xbgr.mr_n72896640)
print v(xbgr.mr_n72896752)
print v(xbgr.mr_n72897072)
print v(xbgr.mr_n72897184)
print v(xbgr.mr_n72897504)
print v(xbgr.mr_n72897616)
print v(xbgr.mr_n72897936)
print v(xbgr.mr_n72898048)
print v(xbgr.mr_n72898368)
print v(xbgr.mr_n72898480)
print v(xbgr.mr_n72898800)
print v(xbgr.mr_n72898912)
print v(xbgr.mr_n72899232)
print v(xbgr.mr_n72899344)
print v(xbgr.mr_n72899664)
print v(xbgr.mr_n72899776)
print v(xbgr.mr_n72900096)
print v(xbgr.mr_n72900208)
print v(xbgr.mr_n72900528)
print v(xbgr.mr_n72900640)
print v(xbgr.mr_n72900960)
print v(xbgr.mr_n72901072)
print v(xbgr.mr_n72901392)
print v(xbgr.mr_n72901504)
print v(xbgr.mr_n72901824)
print v(xbgr.mr_n72901936)
print v(xbgr.mr_n72902256)
print v(xbgr.mr_n72902368)
print v(xbgr.mr_n72902688)
print v(xbgr.mr_n72902800)
print v(xbgr.mr_n72903120)
print v(xbgr.mr_n72903232)
print v(xbgr.mr_n72903552)
print v(xbgr.mr_n72903664)
print v(xbgr.mr_n72903984)
print v(xbgr.mr_n72904096)
print v(xbgr.mr_n72904416)
print v(xbgr.mr_n72904528)
print v(xbgr.mr_n72904848)
print v(xbgr.mr_n72904960)
print v(xbgr.mr_n72905280)
print v(xbgr.mr_n72905392)
print v(xbgr.mr_n72905712)
print v(xbgr.mr_n72905824)
print v(xbgr.mr_n72906144)
print v(xbgr.mr_n72906256)
print v(xbgr.mr_n72906576)
print v(xbgr.mr_n72906688)
print v(xbgr.mr_n72907008)
print v(xbgr.mr_n72907120)
print v(xbgr.mr_n72907440)
print v(xbgr.mr_n72907552)
print v(xbgr.mr_n72907872)
print v(xbgr.mr_n72907984)
print v(xbgr.mr_n72908304)
print v(xbgr.mr_n72908416)
print v(xbgr.mr_n72908736)
print v(xbgr.mr_n72908848)
print v(xbgr.mr_n72909168)
print v(xbgr.mr_n72909280)
print v(xbgr.mr_n72909600)
print v(xbgr.mr_n72909712)
print v(xbgr.mr_n72910032)
print v(xbgr.mr_n72910144)
print v(xbgr.mr_n72910464)
print v(xbgr.mr_n72910576)
print v(xbgr.mr_n72910896)
print v(xbgr.mr_n72911008)
print v(xbgr.mr_n72911328)
print v(xbgr.mr_n72911440)
print v(xbgr.mr_n72911760)
print v(xbgr.mr_n72911872)
print v(xbgr.mr_n72912192)
print v(xbgr.mr_n72912304)
print v(xbgr.mr_n72912624)
print v(xbgr.mr_n72912736)
print v(xbgr.mr_n72913056)
print v(xbgr.mr_n72913168)
print v(xbgr.mr_n72913488)
print v(xbgr.mr_n72913600)
print v(xbgr.mr_n72913920)
print v(xbgr.mr_n72914032)
print v(xbgr.mr_n72914352)
print v(xbgr.mr_n72914464)
print v(xbgr.mr_n72914784)
print v(xbgr.mr_n72914896)
print v(xbgr.mr_n72915216)
print v(xbgr.mr_n72915328)
print v(xbgr.mr_n72915648)
print v(xbgr.mr_n72915760)
print v(xbgr.mr_n72916080)
print v(xbgr.mr_n72916192)
print v(xbgr.mr_n72916512)
print v(xbgr.mr_n72916624)
print v(xbgr.mr_n72916944)
print v(xbgr.mr_n72917056)
print v(xbgr.mr_n72917376)
print v(xbgr.mr_n72917488)
print v(xbgr.mr_n72917808)
print v(xbgr.mr_n72917920)
print v(xbgr.mr_n72918240)
print v(xbgr.mr_n72918352)
print v(xbgr.mr_n72918672)
print v(xbgr.mr_n72918784)
print v(xbgr.mr_n72919104)
print v(xbgr.mr_n72919216)
print v(xbgr.mr_n72919536)
print v(xbgr.mr_n72919648)
print v(xbgr.mr_n72919968)
print v(xbgr.mr_n72920080)
print v(xbgr.mr_n72920400)
print v(xbgr.mr_n72920512)
print v(xbgr.mr_n72920832)
print v(xbgr.mr_n72920944)
print v(xbgr.mr_n72921264)
print v(xbgr.mr_n72921376)
print v(xbgr.mr_n72921696)
print v(xbgr.mr_n72921808)
print v(xbgr.mr_n72922128)
print v(xbgr.mr_n72922240)
print v(xbgr.mr_n72922560)
print v(xbgr.mr_n72922672)
print v(xbgr.mr_n72922992)
print v(xbgr.mr_n72923104)
print v(xbgr.mr_n72923424)
print v(xbgr.mr_n72923536)
print v(xbgr.mr_n72923856)
print v(xbgr.mr_n72923968)
print v(xbgr.mr_n72924288)
print v(xbgr.mr_n72924400)
print v(xbgr.mr_n72924720)
print v(xbgr.mr_n72924832)
print v(xbgr.mr_n72925152)
print v(xbgr.mr_n72925264)
print v(xbgr.mr_n72925584)
print v(xbgr.mr_n72925696)
print v(xbgr.mr_n72926016)
print v(xbgr.mr_n72926128)
print v(xbgr.mr_n72926448)
print v(xbgr.mr_n72926560)
print v(xbgr.mr_n72926880)
print v(xbgr.mr_n72926992)
print v(xbgr.mr_n72927312)
print v(xbgr.mr_n72927424)
print v(xbgr.mr_n72927744)
print v(xbgr.mr_n72927856)
print v(xbgr.mr_n72928176)
print v(xbgr.mr_n72928288)
print v(xbgr.mr_n72928608)
print v(xbgr.mr_n72928720)
print v(xbgr.mr_n72929040)
print v(xbgr.mr_n72929152)
print v(xbgr.mr_n72929472)
print v(xbgr.mr_n72929584)
print v(xbgr.mr_n72929904)
print v(xbgr.mr_n72930016)
print v(xbgr.mr_n72930336)
print v(xbgr.mr_n72930448)
print v(xbgr.mr_n72930768)
print v(xbgr.mr_n72930880)
print v(xbgr.mr_n72931200)
print v(xbgr.mr_n72931312)
print v(xbgr.mr_n72931632)
print v(xbgr.mr_n72931744)
print v(xbgr.mr_n72932176)
print v(xbgr.mr_n72932608)
print v(xbgr.mr_n72933040)
print v(xbgr.mr_n72933472)
print v(xbgr.mr_n72933904)
print v(xbgr.mr_n72934336)
print v(xbgr.mr_n72934768)
print v(xbgr.mr_n72935200)
print v(xbgr.mr_n72935632)
print v(xbgr.mr_n72936064)
print v(xbgr.mr_n72936496)
print v(xbgr.mr_n72936928)
print v(xbgr.mr_n72937360)
print v(xbgr.mr_n72937792)
print v(xbgr.mr_n72938224)
print v(xbgr.mr_n72938656)
print v(xbgr.mr_n72939088)
print v(xbgr.mr_n72939520)
print v(xbgr.mr_n72939952)
print v(xbgr.mr_n72940384)
print v(xbgr.mr_n72940816)
print v(xbgr.mr_n72941248)
print v(xbgr.mr_n72941680)
print v(xbgr.mr_n72942112)
print v(xbgr.mr_n72942544)
print v(xbgr.mr_n72942976)
print v(xbgr.mr_n72943408)
print v(xbgr.mr_n72943840)
print v(xbgr.mr_n72944272)
print v(xbgr.mr_n72944704)
print v(xbgr.mr_n72945136)
print v(xbgr.mr_n72945568)
print v(xbgr.mr_n72946000)
print v(xbgr.mr_n72946432)
print v(xbgr.mr_n72946864)
print v(xbgr.mr_n72947296)
print v(xbgr.mr_n72947728)
print v(xbgr.mr_n72948160)
print v(xbgr.mr_n72948592)
print v(xbgr.mr_n72949024)
print v(xbgr.mr_n72949456)
print v(xbgr.mr_n72949888)
print v(xbgr.mr_n72950320)
print v(xbgr.mr_n72950752)
print v(xbgr.mr_n72951184)
print v(xbgr.mr_n72951616)
print v(xbgr.mr_n72952048)
print v(xbgr.mr_n72952480)
print v(xbgr.mr_n72952912)
print v(xbgr.mr_n72953344)
print v(xbgr.mr_n72953776)
print v(xbgr.mr_n72954208)
print v(xbgr.mr_n72954640)
print v(xbgr.mr_n72955072)
print v(xbgr.mr_n72955504)
print v(xbgr.mr_n72955936)
print v(xbgr.mr_n72956368)
print v(xbgr.mr_n72956800)
print v(xbgr.mr_n72957232)
print v(xbgr.mr_n72957664)
print v(xbgr.mr_n72958096)
print v(xbgr.mr_n72958528)
print v(xbgr.mr_n72958960)
print v(xbgr.mr_n72959392)
print v(xbgr.mr_n72959824)
print v(xbgr.mr_n72960256)
print v(xbgr.mr_n72960688)
print v(xbgr.mr_n72961120)
print v(xbgr.mr_n72961552)
print v(xbgr.mr_n72961984)
print v(xbgr.mr_n72962416)
print v(xbgr.mr_n72962848)
print v(xbgr.mr_n72963280)
print v(xbgr.mr_n72963712)
print v(xbgr.mr_n72964144)
print v(xbgr.mr_n72964576)
print v(xbgr.mr_n72965008)
print v(xbgr.mr_n72965440)
print v(xbgr.mr_n72965872)
print v(xbgr.mr_n72966304)
print v(xbgr.mr_n72966736)
print v(xbgr.mr_n72967168)
print v(xbgr.mr_n72967600)
print v(xbgr.mr_n72968032)
print v(xbgr.mr_n72968464)
print v(xbgr.mr_n72968896)
print v(xbgr.mr_n72969328)
print v(xbgr.mr_n72969760)
print v(xbgr.mr_n72970192)
print v(xbgr.mr_n72970624)
print v(xbgr.mr_n72971056)
print v(xbgr.mr_n72971488)
print v(xbgr.mr_n72971920)
print v(xbgr.mr_n72972352)
print v(xbgr.mr_n72972784)
print v(xbgr.mr_n72973216)
print v(xbgr.mr_n72973648)
print v(xbgr.mr_n72974080)
print v(xbgr.mr_n72974400)
print v(xbgr.mr_n72974512)
print v(xbgr.mr_n72974832)
print v(xbgr.mr_n72974944)
print v(xbgr.mr_n72975264)
print v(xbgr.mr_n72975376)
print v(xbgr.mr_n72975696)
print v(xbgr.mr_n72975808)
print v(xbgr.mr_n72976128)
print v(xbgr.mr_n72976240)
print v(xbgr.mr_n72976560)
print v(xbgr.mr_n72976672)
print v(xbgr.mr_n72976992)
print v(xbgr.mr_n72977104)
print v(xbgr.mr_n72977424)
print v(xbgr.mr_n72977536)
print v(xbgr.mr_n72977856)
print v(xbgr.mr_n72977968)
print v(xbgr.mr_n72978288)
print v(xbgr.mr_n72978400)
print v(xbgr.mr_n72978720)
print v(xbgr.mr_n72978832)
print v(xbgr.mr_n72979152)
print v(xbgr.mr_n72979264)
print v(xbgr.mr_n72979584)
print v(xbgr.mr_n72979696)
print v(xbgr.mr_n72980016)
print v(xbgr.mr_n72980128)
print v(xbgr.mr_n72980448)
print v(xbgr.mr_n72980560)
print v(xbgr.mr_n72980880)
print v(xbgr.mr_n72980992)
print v(xbgr.mr_n72981312)
print v(xbgr.mr_n72981424)
print v(xbgr.mr_n72981744)
print v(xbgr.mr_n72981856)
print v(xbgr.mr_n72982176)
print v(xbgr.mr_n72982288)
print v(xbgr.mr_n72982608)
print v(xbgr.mr_n72982720)
print v(xbgr.mr_n72983040)
print v(xbgr.mr_n72983152)
print v(xbgr.mr_n72983472)
print v(xbgr.mr_n72983584)
print v(xbgr.mr_n72983904)
print v(xbgr.mr_n72984016)
print v(xbgr.mr_n72984336)
print v(xbgr.mr_n72984448)
print v(xbgr.mr_n72984768)
print v(xbgr.mr_n72984880)
print v(xbgr.mr_n72985200)
print v(xbgr.mr_n72985312)
print v(xbgr.mr_n72985632)
print v(xbgr.mr_n72985744)
print v(xbgr.mr_n72986064)
print v(xbgr.mr_n72986176)
print v(xbgr.mr_n72986496)
print v(xbgr.mr_n72986608)
print v(xbgr.mr_n72986928)
print v(xbgr.mr_n72987040)
print v(xbgr.mr_n72987360)
print v(xbgr.mr_n72987472)
print v(xbgr.mr_n72987792)
print v(xbgr.mr_n72987904)
print v(xbgr.mr_n72988224)
print v(xbgr.mr_n72988336)
print v(xbgr.mr_n72988656)
print v(xbgr.mr_n72988768)
print v(xbgr.mr_n72989088)
print v(xbgr.mr_n72989200)
print v(xbgr.mr_n72989520)
print v(xbgr.mr_n72989632)
print v(xbgr.mr_n72989952)
print v(xbgr.mr_n72990064)
print v(xbgr.mr_n72990384)
print v(xbgr.mr_n72990496)
print v(xbgr.mr_n72990816)
print v(xbgr.mr_n72990928)
print v(xbgr.mr_n72991248)
print v(xbgr.mr_n72991360)
print v(xbgr.mr_n72991680)
print v(xbgr.mr_n72991792)
print v(xbgr.mr_n72992112)
print v(xbgr.mr_n72992224)
print v(xbgr.mr_n72992544)
print v(xbgr.mr_n72992656)
print v(xbgr.mr_n72992976)
print v(xbgr.mr_n72993088)
print v(xbgr.mr_n72993408)
print v(xbgr.mr_n72993520)
print v(xbgr.mr_n72993840)
print v(xbgr.mr_n72993952)
print v(xbgr.mr_n72994272)
print v(xbgr.mr_n72994384)
print v(xbgr.mr_n72994704)
print v(xbgr.mr_n72994816)
print v(xbgr.mr_n72995136)
print v(xbgr.mr_n72995248)
print v(xbgr.mr_n72995568)
print v(xbgr.mr_n72995680)
print v(xbgr.mr_n72996000)
print v(xbgr.mr_n72996112)
print v(xbgr.mr_n72996432)
print v(xbgr.mr_n72996544)
print v(xbgr.mr_n72996864)
print v(xbgr.mr_n72996976)
print v(xbgr.mr_n72997296)
print v(xbgr.mr_n72997408)
print v(xbgr.mr_n72997728)
print v(xbgr.mr_n72997840)
print v(xbgr.mr_n72998160)
print v(xbgr.mr_n72998272)
print v(xbgr.mr_n72998592)
print v(xbgr.mr_n72998704)
print v(xbgr.mr_n72999024)
print v(xbgr.mr_n72999136)
print v(xbgr.mr_n72999456)
print v(xbgr.mr_n72999568)
print v(xbgr.mr_n72999888)
print v(xbgr.mr_n73000000)
print v(xbgr.mr_n73000320)
print v(xbgr.mr_n73000432)
print v(xbgr.mr_n73000752)
print v(xbgr.mr_n73000864)
print v(xbgr.mr_n73001184)
print v(xbgr.mr_n73001296)
print v(xbgr.mr_n73001616)
print v(xbgr.mr_n73001728)
print v(xbgr.mr_n73002048)
print v(xbgr.mr_n73002160)
print v(xbgr.mr_n73002480)
print v(xbgr.mr_n73002592)
print v(xbgr.mr_n73002912)
print v(xbgr.mr_n73003024)
print v(xbgr.mr_n73003344)
print v(xbgr.mr_n73003456)
print v(xbgr.mr_n73003776)
print v(xbgr.mr_n73003888)
print v(xbgr.mr_n73004208)
print v(xbgr.mr_n73004320)
print v(xbgr.mr_n73004640)
print v(xbgr.mr_n73004752)
print v(xbgr.mr_n73005072)
print v(xbgr.mr_n73005184)
print v(xbgr.mr_n73005504)
print v(xbgr.mr_n73005616)
print v(xbgr.mr_n73005936)
print v(xbgr.mr_n73006048)
print v(xbgr.mr_n73006368)
print v(xbgr.mr_n73006480)
print v(xbgr.mr_n73006800)
print v(xbgr.mr_n73006912)
print v(xbgr.mr_n73007232)
print v(xbgr.mr_n73007344)
print v(xbgr.mr_n73007664)
print v(xbgr.mr_n73007776)
print v(xbgr.mr_n73008096)
print v(xbgr.mr_n73008208)
print v(xbgr.mr_n73008528)
print v(xbgr.mr_n73008640)
print v(xbgr.mr_n73008960)
print v(xbgr.mr_n73009072)
print v(xbgr.mr_n73009392)
print v(xbgr.mr_n73009504)
print v(xbgr.mr_n73009824)
print v(xbgr.mr_n73009936)
print v(xbgr.mr_n73010256)
print v(xbgr.mr_n73010368)
print v(xbgr.mr_n73010688)
print v(xbgr.mr_n73010800)
print v(xbgr.mr_n73011120)
print v(xbgr.mr_n73011232)
print v(xbgr.mr_n73011552)
print v(xbgr.mr_n73011664)
print v(xbgr.mr_n73011984)
print v(xbgr.mr_n73012096)
print v(xbgr.mr_n73012416)
print v(xbgr.mr_n73012528)
print v(xbgr.mr_n73012848)
print v(xbgr.mr_n73012960)
print v(xbgr.mr_n73013280)
print v(xbgr.mr_n73013392)
print v(xbgr.mr_n73013712)
print v(xbgr.mr_n73013824)
print v(xbgr.mr_n73014144)
print v(xbgr.mr_n73014256)
print v(xbgr.mr_n73014576)
print v(xbgr.mr_n73014688)
print v(xbgr.mr_n73015008)
print v(xbgr.mr_n73015120)
print v(xbgr.mr_n73015440)
print v(xbgr.mr_n73015552)
print v(xbgr.mr_n73015872)
print v(xbgr.mr_n73015984)
print v(xbgr.mr_n73016304)
print v(xbgr.mr_n73016416)
print v(xbgr.mr_n73016736)
print v(xbgr.mr_n73016848)
print v(xbgr.mr_n73017168)
print v(xbgr.mr_n73017280)
print v(xbgr.mr_n73017600)
print v(xbgr.mr_n73017712)
print v(xbgr.mr_n73018032)
print v(xbgr.mr_n73018144)
print v(xbgr.mr_n73018464)
print v(xbgr.mr_n73018576)
print v(xbgr.mr_n73018896)
print v(xbgr.mr_n73019008)
print v(xbgr.mr_n73019328)
print v(xbgr.mr_n73019440)
print v(xbgr.mr_n73019760)
print v(xbgr.mr_n73019872)
print v(xbgr.mr_n73020192)
print v(xbgr.mr_n73020304)
print v(xbgr.mr_n73020624)
print v(xbgr.mr_n73020736)
print v(xbgr.mr_n73021056)
print v(xbgr.mr_n73021168)
print v(xbgr.mr_n73021488)
print v(xbgr.mr_n73021600)
print v(xbgr.mr_n73021920)
print v(xbgr.mr_n73022032)
print v(xbgr.mr_n73022352)
print v(xbgr.mr_n73022464)
print v(xbgr.mr_n73022784)
print v(xbgr.mr_n73022896)
print v(xbgr.mr_n73023216)
print v(xbgr.mr_n73023328)
print v(xbgr.mr_n73023648)
print v(xbgr.mr_n73023760)
print v(xbgr.mr_n73024080)
print v(xbgr.mr_n73024192)
print v(xbgr.mr_n73024512)
print v(xbgr.mr_n73024624)
print v(xbgr.mr_n73024944)
print v(xbgr.mr_n73025056)
print v(xbgr.mr_n73025376)
print v(xbgr.mr_n73025488)
print v(xbgr.mr_n73025808)
print v(xbgr.mr_n73025920)
print v(xbgr.mr_n73026240)
print v(xbgr.mr_n73026352)
print v(xbgr.mr_n73026672)
print v(xbgr.mr_n73026784)
print v(xbgr.mr_n73027104)
print v(xbgr.mr_n73027216)
print v(xbgr.mr_n73027536)
print v(xbgr.mr_n73027648)
print v(xbgr.mr_n73027968)
print v(xbgr.mr_n73028080)
print v(xbgr.mr_n73028400)
print v(xbgr.mr_n73028512)
print v(xbgr.mr_n73028832)
print v(xbgr.mr_n73028944)
print v(xbgr.mr_n73029264)
print v(xbgr.mr_n73029376)
print v(xbgr.mr_n73029696)
print v(xbgr.mr_n73029808)
print v(xbgr.mr_n73030128)
print v(xbgr.mr_n73030240)
print v(xbgr.mr_n73030560)
print v(xbgr.mr_n73030672)
print v(xbgr.mr_n73030992)
print v(xbgr.mr_n73031104)
print v(xbgr.mr_n73031424)
print v(xbgr.mr_n73031536)
print v(xbgr.mr_n73031856)
print v(xbgr.mr_n73031968)
print v(xbgr.mr_n73032288)
print v(xbgr.mr_n73032400)
print v(xbgr.mr_n73032720)
print v(xbgr.mr_n73032832)
print v(xbgr.mr_n73033152)
print v(xbgr.mr_n73033264)
print v(xbgr.mr_n73033584)
print v(xbgr.mr_n73033696)
print v(xbgr.mr_n73034016)
print v(xbgr.mr_n73034128)
print v(xbgr.mr_n73034448)
print v(xbgr.mr_n73034560)
print v(xbgr.mr_n73034880)
print v(xbgr.mr_n73034992)
print v(xbgr.mr_n73035312)
print v(xbgr.mr_n73035424)
print v(xbgr.mr_n73035744)
print v(xbgr.mr_n73035856)
print v(xbgr.mr_n73036176)
print v(xbgr.mr_n73036288)
print v(xbgr.mr_n73036608)
print v(xbgr.mr_n73036720)
print v(xbgr.mr_n73037040)
print v(xbgr.mr_n73037152)
print v(xbgr.mr_n73037584)
print v(xbgr.mr_n73038016)
print v(xbgr.mr_n73038448)
print v(xbgr.mr_n73038880)
print v(xbgr.mr_n73039312)
print v(xbgr.mr_n73039744)
print v(xbgr.mr_n73040176)
print v(xbgr.mr_n73040608)
print v(xbgr.mr_n73041040)
print v(xbgr.mr_n73041472)
print v(xbgr.mr_n73041904)
print v(xbgr.mr_n73042336)
print v(xbgr.mr_n73042768)
print v(xbgr.mr_n73043200)
print v(xbgr.mr_n73043632)
print v(xbgr.mr_n73044064)
print v(xbgr.mr_n73044496)
print v(xbgr.mr_n73044928)
print v(xbgr.mr_n73045360)
print v(xbgr.mr_n73045792)
print v(xbgr.mr_n73046224)
print v(xbgr.mr_n73046656)
print v(xbgr.mr_n73047088)
print v(xbgr.mr_n73047520)
print v(xbgr.mr_n73047952)
print v(xbgr.mr_n73048384)
print v(xbgr.mr_n73048816)
print v(xbgr.mr_n73049248)
print v(xbgr.mr_n73049680)
print v(xbgr.mr_n73050112)
print v(xbgr.mr_n73050544)
print v(xbgr.mr_n73050976)
print v(xbgr.mr_n73051408)
print v(xbgr.mr_n73051840)
print v(xbgr.mr_n73052272)
print v(xbgr.mr_n73052704)
print v(xbgr.mr_n73053136)
print v(xbgr.mr_n73053568)
print v(xbgr.mr_n73054000)
print v(xbgr.mr_n73054432)
print v(xbgr.mr_n73054864)
print v(xbgr.mr_n73055296)
print v(xbgr.mr_n73055728)
print v(xbgr.mr_n73056160)
print v(xbgr.mr_n73056592)
print v(xbgr.mr_n73057024)
print v(xbgr.mr_n73057456)
print v(xbgr.mr_n73057888)
print v(xbgr.mr_n73058320)
print v(xbgr.mr_n73058752)
print v(xbgr.mr_n73059184)
print v(xbgr.mr_n73059616)
print v(xbgr.mr_n73060048)
print v(xbgr.mr_n73060480)
print v(xbgr.mr_n73060912)
print v(xbgr.mr_n73061344)
print v(xbgr.mr_n73061776)
print v(xbgr.mr_n73062208)
print v(xbgr.mr_n73062640)
print v(xbgr.mr_n73063072)
print v(xbgr.mr_n73063504)
print v(xbgr.mr_n73063936)
print v(xbgr.mr_n73064368)
print v(xbgr.mr_n73064800)
print v(xbgr.mr_n73065232)
print v(xbgr.mr_n73065664)
print v(xbgr.mr_n73066096)
print v(xbgr.mr_n73066528)
print v(xbgr.mr_n73066960)
print v(xbgr.mr_n73067392)
print v(xbgr.mr_n73067824)
print v(xbgr.mr_n73068256)
print v(xbgr.mr_n73068688)
print v(xbgr.mr_n73069120)
print v(xbgr.mr_n73069552)
print v(xbgr.mr_n73069984)
print v(xbgr.mr_n73070416)
print v(xbgr.mr_n73070848)
print v(xbgr.mr_n73071280)
print v(xbgr.mr_n73071712)
print v(xbgr.mr_n73072144)
print v(xbgr.mr_n73072576)
print v(xbgr.mr_n73073008)
print v(xbgr.mr_n73073440)
print v(xbgr.mr_n73073872)
print v(xbgr.mr_n73074304)
print v(xbgr.mr_n73074736)
print v(xbgr.mr_n73075168)
print v(xbgr.mr_n73075600)
print v(xbgr.mr_n73076032)
print v(xbgr.mr_n73076464)
print v(xbgr.mr_n73076896)
print v(xbgr.mr_n73077328)
print v(xbgr.mr_n73077760)
print v(xbgr.mr_n73078192)
print v(xbgr.mr_n73078624)
print v(xbgr.mr_n73079056)
print v(xbgr.mr_n73079488)
print v(xbgr.mr_n73079920)
print v(xbgr.mr_n73080352)
print v(xbgr.mr_n73080784)
print v(xbgr.mr_n73081216)
print v(xbgr.mr_n73081648)
print v(xbgr.mr_n73082080)
print v(xbgr.mr_n73082512)
print v(xbgr.mr_n73082944)
print v(xbgr.mr_n73083376)
print v(xbgr.mr_n73083808)
print v(xbgr.mr_n73084240)
print v(xbgr.mr_n73084672)
print v(xbgr.mr_n73085104)
print v(xbgr.mr_n73085536)
print v(xbgr.mr_n73085968)
print v(xbgr.mr_n73086400)
print v(xbgr.mr_n73086832)
print v(xbgr.mr_n73087264)
print v(xbgr.mr_n73087696)
print v(xbgr.mr_n73088128)
print v(xbgr.mr_n73088560)
print v(xbgr.mr_n73088992)
print v(xbgr.mr_n73089424)
print v(xbgr.mr_n73089856)
print v(xbgr.mr_n73090288)
print v(xbgr.mr_n73090720)
print v(xbgr.mr_n73091152)
print v(xbgr.mr_n73091584)
print v(xbgr.mr_n73092016)
print v(xbgr.mr_n73092448)
print v(xbgr.mr_n73092880)
print v(xbgr.mr_n73093312)
print v(xbgr.mr_n73093744)
print v(xbgr.mr_n73094176)
print v(xbgr.mr_n73094608)
print v(xbgr.mr_n73095040)
print v(xbgr.mr_n73095472)
print v(xbgr.mr_n73095904)
print v(xbgr.mr_n73096336)
print v(xbgr.mr_n73096768)
print v(xbgr.mr_n73097200)
print v(xbgr.mr_n73097632)
print v(xbgr.mr_n73098064)
print v(xbgr.mr_n73098496)
print v(xbgr.mr_n73098928)
print v(xbgr.mr_n73099360)
print v(xbgr.mr_n73099792)
print v(xbgr.mr_n73100224)
print v(xbgr.mr_n73100656)
print v(xbgr.mr_n73101088)
print v(xbgr.mr_n73101520)
print v(xbgr.mr_n73101952)
print v(xbgr.mr_n73102384)
print v(xbgr.mr_n73102816)
print v(xbgr.mr_n73103248)
print v(xbgr.mr_n73103680)
print v(xbgr.mr_n73104112)
print v(xbgr.mr_n73104544)
print v(xbgr.mr_n73104976)
print v(xbgr.mr_n73105408)
print v(xbgr.mr_n73105840)
print v(xbgr.mr_n73106272)
print v(xbgr.mr_n73106704)
print v(xbgr.mr_n73107136)
print v(xbgr.mr_n73107568)
print v(xbgr.mr_n73108000)
print v(xbgr.mr_n73108432)
print v(xbgr.mr_n73108864)
print v(xbgr.mr_n73109296)
print v(xbgr.mr_n73109728)
print v(xbgr.mr_n73110160)
print v(xbgr.mr_n73110592)
print v(xbgr.mr_n73111024)
print v(xbgr.mr_n73111456)
print v(xbgr.mr_n73111888)
print v(xbgr.mr_n73112320)
print v(xbgr.mr_n73112752)
print v(xbgr.mr_n73113184)
print v(xbgr.mr_n73113616)
print v(xbgr.mr_n73114048)
print v(xbgr.mr_n73114480)
print v(xbgr.mr_n73114912)
print v(xbgr.mr_n73115344)
print v(xbgr.mr_n73115776)
print v(xbgr.mr_n73116208)
print v(xbgr.mr_n73116640)
print v(xbgr.mr_n73117072)
print v(xbgr.mr_n73117504)
print v(xbgr.mr_n73117936)
print v(xbgr.mr_n73118368)
print v(xbgr.mr_n73118800)
print v(xbgr.mr_n73119232)
print v(xbgr.mr_n73119664)
print v(xbgr.mr_n73120096)
print v(xbgr.mr_n73120528)
print v(xbgr.mr_n73120960)
print v(xbgr.mr_n73121392)
print v(xbgr.mr_n73121824)
print v(xbgr.mr_n73122256)
print v(xbgr.mr_n73122688)
print v(xbgr.mr_n73123120)
print v(xbgr.mr_n73123552)
print v(xbgr.mr_n73123984)
print v(xbgr.mr_n73124416)
print v(xbgr.mr_n73124848)
print v(xbgr.mr_n73125280)
print v(xbgr.mr_n73125712)
print v(xbgr.mr_n73126144)
print v(xbgr.mr_n73126576)
print v(xbgr.mr_n73127008)
print v(xbgr.mr_n73127440)
print v(xbgr.mr_n73127872)
print v(xbgr.mr_n73128304)
print v(xbgr.mr_n73128736)
print v(xbgr.mr_n73129168)
print v(xbgr.mr_n73129600)
print v(xbgr.mr_n73129920)
print v(xbgr.mr_n73130032)
print v(xbgr.mr_n73130352)
print v(xbgr.mr_n73130464)
print v(xbgr.mr_n73130784)
print v(xbgr.mr_n73130896)
print v(xbgr.mr_n73131216)
print v(xbgr.mr_n73131328)
print v(xbgr.mr_n73131648)
print v(xbgr.mr_n73131760)
print v(xbgr.mr_n73132080)
print v(xbgr.mr_n73132192)
print v(xbgr.mr_n73132512)
print v(xbgr.mr_n73132624)
print v(xbgr.mr_n73132944)
print v(xbgr.mr_n73133056)
print v(xbgr.mr_n73133376)
print v(xbgr.mr_n73133488)
print v(xbgr.mr_n73133808)
print v(xbgr.mr_n73133920)
print v(xbgr.mr_n73134240)
print v(xbgr.mr_n73134352)
print v(xbgr.mr_n73134672)
print v(xbgr.mr_n73134784)
print v(xbgr.mr_n73135104)
print v(xbgr.mr_n73135216)
print v(xbgr.mr_n73135536)
print v(xbgr.mr_n73135648)
print v(xbgr.mr_n73135968)
print v(xbgr.mr_n73136080)
print v(xbgr.mr_n73136400)
print v(xbgr.mr_n73136512)
print v(xbgr.mr_n73136832)
print v(xbgr.mr_n73136944)
print v(xbgr.mr_n73137264)
print v(xbgr.mr_n73137376)
print v(xbgr.mr_n73137696)
print v(xbgr.mr_n73137808)
print v(xbgr.mr_n73138128)
print v(xbgr.mr_n73138240)
print v(xbgr.mr_n73138560)
print v(xbgr.mr_n73138672)
print v(xbgr.mr_n73138992)
print v(xbgr.mr_n73139104)
print v(xbgr.mr_n73139424)
print v(xbgr.mr_n73139536)
print v(xbgr.mr_n73139856)
print v(xbgr.mr_n73139968)
print v(xbgr.mr_n73140288)
print v(xbgr.mr_n73140400)
print v(xbgr.mr_n73140720)
print v(xbgr.mr_n73140832)
print v(xbgr.mr_n73141152)
print v(xbgr.mr_n73141264)
print v(xbgr.mr_n73141584)
print v(xbgr.mr_n73141696)
print v(xbgr.mr_n73142016)
print v(xbgr.mr_n73142128)
print v(xbgr.mr_n73142448)
print v(xbgr.mr_n73142560)
print v(xbgr.mr_n73142880)
print v(xbgr.mr_n73142992)
print v(xbgr.mr_n73143312)
print v(xbgr.mr_n73143424)
print v(xbgr.mr_n73143744)
print v(xbgr.mr_n73143856)
print v(xbgr.mr_n73144176)
print v(xbgr.mr_n73144288)
print v(xbgr.mr_n73144608)
print v(xbgr.mr_n73144720)
print v(xbgr.mr_n73145040)
print v(xbgr.mr_n73145152)
print v(xbgr.mr_n73145472)
print v(xbgr.mr_n73145584)
print v(xbgr.mr_n73145904)
print v(xbgr.mr_n73146016)
print v(xbgr.mr_n73146336)
print v(xbgr.mr_n73146448)
print v(xbgr.mr_n73146768)
print v(xbgr.mr_n73146880)
print v(xbgr.mr_n73147200)
print v(xbgr.mr_n73147312)
print v(xbgr.mr_n73147632)
print v(xbgr.mr_n73147744)
print v(xbgr.mr_n73148064)
print v(xbgr.mr_n73148176)
print v(xbgr.mr_n73148496)
print v(xbgr.mr_n73148608)
print v(xbgr.mr_n73148928)
print v(xbgr.mr_n73149040)
print v(xbgr.mr_n73149360)
print v(xbgr.mr_n73149472)
print v(xbgr.mr_n73149792)
print v(xbgr.mr_n73149904)
print v(xbgr.mr_n73150224)
print v(xbgr.mr_n73150336)
print v(xbgr.mr_n73150656)
print v(xbgr.mr_n73150768)
print v(xbgr.mr_n73151088)
print v(xbgr.mr_n73151200)
print v(xbgr.mr_n73151520)
print v(xbgr.mr_n73151632)
print v(xbgr.mr_n73151952)
print v(xbgr.mr_n73152064)
print v(xbgr.mr_n73152384)
print v(xbgr.mr_n73152496)
print v(xbgr.mr_n73152816)
print v(xbgr.mr_n73152928)
print v(xbgr.mr_n73153248)
print v(xbgr.mr_n73153360)
print v(xbgr.mr_n73153680)
print v(xbgr.mr_n73153792)
print v(xbgr.mr_n73154112)
print v(xbgr.mr_n73154224)
print v(xbgr.mr_n73154544)
print v(xbgr.mr_n73154656)
print v(xbgr.mr_n73154976)
print v(xbgr.mr_n73155088)
print v(xbgr.mr_n73155408)
print v(xbgr.mr_n73155520)
print v(xbgr.mr_n73155840)
print v(xbgr.mr_n73155952)
print v(xbgr.mr_n73156272)
print v(xbgr.mr_n73156384)
print v(xbgr.mr_n73156704)
print v(xbgr.mr_n73156816)
print v(xbgr.mr_n73157136)
print v(xbgr.mr_n73157248)
print v(xbgr.mr_n73157568)
print v(xbgr.mr_n73157680)
print v(xbgr.mr_n73158000)
print v(xbgr.mr_n73158112)
print v(xbgr.mr_n73158432)
print v(xbgr.mr_n73158544)
print v(xbgr.mr_n73158864)
print v(xbgr.mr_n73158976)
print v(xbgr.mr_n73159296)
print v(xbgr.mr_n73159408)
print v(xbgr.mr_n73159728)
print v(xbgr.mr_n73159840)
print v(xbgr.mr_n73160160)
print v(xbgr.mr_n73160272)
print v(xbgr.mr_n73160592)
print v(xbgr.mr_n73160704)
print v(xbgr.mr_n73161024)
print v(xbgr.mr_n73161136)
print v(xbgr.mr_n73161456)
print v(xbgr.mr_n73161568)
print v(xbgr.mr_n73161888)
print v(xbgr.mr_n73162000)
print v(xbgr.mr_n73162320)
print v(xbgr.mr_n73162432)
print v(xbgr.mr_n73162752)
print v(xbgr.mr_n73162864)
print v(xbgr.mr_n73163184)
print v(xbgr.mr_n73163296)
print v(xbgr.mr_n73163616)
print v(xbgr.mr_n73163728)
print v(xbgr.mr_n73164048)
print v(xbgr.mr_n73164160)
print v(xbgr.mr_n73164480)
print v(xbgr.mr_n73164592)
print v(xbgr.mr_n73164912)
print v(xbgr.mr_n73165024)
print v(xbgr.mr_n73165344)
print v(xbgr.mr_n73165456)
print v(xbgr.mr_n73165776)
print v(xbgr.mr_n73165888)
print v(xbgr.mr_n73166208)
print v(xbgr.mr_n73166320)
print v(xbgr.mr_n73166640)
print v(xbgr.mr_n73166752)
print v(xbgr.mr_n73167072)
print v(xbgr.mr_n73167184)
print v(xbgr.mr_n73167504)
print v(xbgr.mr_n73167616)
print v(xbgr.mr_n73167936)
print v(xbgr.mr_n73168048)
print v(xbgr.mr_n73168368)
print v(xbgr.mr_n73168480)
print v(xbgr.mr_n73168800)
print v(xbgr.mr_n73168912)
print v(xbgr.mr_n73169232)
print v(xbgr.mr_n73169344)
print v(xbgr.mr_n73169664)
print v(xbgr.mr_n73169776)
print v(xbgr.mr_n73170096)
print v(xbgr.mr_n73170208)
print v(xbgr.mr_n73170528)
print v(xbgr.mr_n73170640)
print v(xbgr.mr_n73170960)
print v(xbgr.mr_n73171072)
print v(xbgr.mr_n73171392)
print v(xbgr.mr_n73171504)
print v(xbgr.mr_n73171824)
print v(xbgr.mr_n73171936)
print v(xbgr.mr_n73172256)
print v(xbgr.mr_n73172368)
print v(xbgr.mr_n73172688)
print v(xbgr.mr_n73172800)
print v(xbgr.mr_n73173120)
print v(xbgr.mr_n73173232)
print v(xbgr.mr_n73173552)
print v(xbgr.mr_n73173664)
print v(xbgr.mr_n73173984)
print v(xbgr.mr_n73174096)
print v(xbgr.mr_n73174416)
print v(xbgr.mr_n73174528)
print v(xbgr.mr_n73174848)
print v(xbgr.mr_n73174960)
print v(xbgr.mr_n73175280)
print v(xbgr.mr_n73175392)
print v(xbgr.mr_n73175712)
print v(xbgr.mr_n73175824)
print v(xbgr.mr_n73176144)
print v(xbgr.mr_n73176256)
print v(xbgr.mr_n73176576)
print v(xbgr.mr_n73176688)
print v(xbgr.mr_n73177008)
print v(xbgr.mr_n73177120)
print v(xbgr.mr_n73177440)
print v(xbgr.mr_n73177552)
print v(xbgr.mr_n73177872)
print v(xbgr.mr_n73177984)
print v(xbgr.mr_n73178304)
print v(xbgr.mr_n73178416)
print v(xbgr.mr_n73178736)
print v(xbgr.mr_n73178848)
print v(xbgr.mr_n73179168)
print v(xbgr.mr_n73179280)
print v(xbgr.mr_n73179600)
print v(xbgr.mr_n73179712)
print v(xbgr.mr_n73180032)
print v(xbgr.mr_n73180144)
print v(xbgr.mr_n73180464)
print v(xbgr.mr_n73180576)
print v(xbgr.mr_n73180896)
print v(xbgr.mr_n73181008)
print v(xbgr.mr_n73181328)
print v(xbgr.mr_n73181440)
print v(xbgr.mr_n73181760)
print v(xbgr.mr_n73181872)
print v(xbgr.mr_n73182192)
print v(xbgr.mr_n73182304)
print v(xbgr.mr_n73182624)
print v(xbgr.mr_n73182736)
print v(xbgr.mr_n73183056)
print v(xbgr.mr_n73183168)
print v(xbgr.mr_n73183488)
print v(xbgr.mr_n73183600)
print v(xbgr.mr_n73183920)
print v(xbgr.mr_n73184032)
print v(xbgr.mr_n73184352)
print v(xbgr.mr_n73184464)
print v(xbgr.mr_n73184784)
print v(xbgr.mr_n73184896)
print v(xbgr.mr_n73185216)
print v(xbgr.mr_n73185328)
print v(xbgr.mr_n73185648)
print v(xbgr.mr_n73185760)
print v(xbgr.mr_n73186080)
print v(xbgr.mr_n73186192)
print v(xbgr.mr_n73186512)
print v(xbgr.mr_n73186624)
print v(xbgr.mr_n73186944)
print v(xbgr.mr_n73187056)
print v(xbgr.mr_n73187376)
print v(xbgr.mr_n73187488)
print v(xbgr.mr_n73187808)
print v(xbgr.mr_n73187920)
print v(xbgr.mr_n73188240)
print v(xbgr.mr_n73188352)
print v(xbgr.mr_n73188672)
print v(xbgr.mr_n73188784)
print v(xbgr.mr_n73189104)
print v(xbgr.mr_n73189216)
print v(xbgr.mr_n73189536)
print v(xbgr.mr_n73189648)
print v(xbgr.mr_n73189968)
print v(xbgr.mr_n73190080)
print v(xbgr.mr_n73190400)
print v(xbgr.mr_n73190512)
print v(xbgr.mr_n73190832)
print v(xbgr.mr_n73190944)
print v(xbgr.mr_n73191264)
print v(xbgr.mr_n73191376)
print v(xbgr.mr_n73191696)
print v(xbgr.mr_n73191808)
print v(xbgr.mr_n73192128)
print v(xbgr.mr_n73192240)
print v(xbgr.mr_n73192560)
print v(xbgr.mr_n73192672)
print v(xbgr.mr_n73192992)
print v(xbgr.mr_n73193104)
print v(xbgr.mr_n73193424)
print v(xbgr.mr_n73193536)
print v(xbgr.mr_n73193856)
print v(xbgr.mr_n73193968)
print v(xbgr.mr_n73194288)
print v(xbgr.mr_n73194400)
print v(xbgr.mr_n73194720)
print v(xbgr.mr_n73194832)
print v(xbgr.mr_n73195152)
print v(xbgr.mr_n73195264)
print v(xbgr.mr_n73195584)
print v(xbgr.mr_n73195696)
print v(xbgr.mr_n73196016)
print v(xbgr.mr_n73196128)
print v(xbgr.mr_n73196448)
print v(xbgr.mr_n73196560)
print v(xbgr.mr_n73196880)
print v(xbgr.mr_n73196992)
print v(xbgr.mr_n73197312)
print v(xbgr.mr_n73197424)
print v(xbgr.mr_n73197744)
print v(xbgr.mr_n73197856)
print v(xbgr.mr_n73198176)
print v(xbgr.mr_n73198288)
print v(xbgr.mr_n73198608)
print v(xbgr.mr_n73198720)
print v(xbgr.mr_n73199040)
print v(xbgr.mr_n73199152)
print v(xbgr.mr_n73199472)
print v(xbgr.mr_n73199584)
print v(xbgr.mr_n73199904)
print v(xbgr.mr_n73200016)
print v(xbgr.mr_n73200336)
print v(xbgr.mr_n73200448)
print v(xbgr.mr_n73200768)
print v(xbgr.mr_n73200880)
print v(xbgr.mr_n73201200)
print v(xbgr.mr_n73201312)
print v(xbgr.mr_n73201632)
print v(xbgr.mr_n73201744)
print v(xbgr.mr_n73202064)
print v(xbgr.mr_n73202176)
print v(xbgr.mr_n73202496)
print v(xbgr.mr_n73202608)
print v(xbgr.mr_n73202928)
print v(xbgr.mr_n73203040)
print v(xbgr.mr_n73203360)
print v(xbgr.mr_n73203472)
print v(xbgr.mr_n73203792)
print v(xbgr.mr_n73203904)
print v(xbgr.mr_n73204224)
print v(xbgr.mr_n73204336)
print v(xbgr.mr_n73204656)
print v(xbgr.mr_n73204768)
print v(xbgr.mr_n73205088)
print v(xbgr.mr_n73205200)
print v(xbgr.mr_n73205520)
print v(xbgr.mr_n73205632)
print v(xbgr.mr_n73205952)
print v(xbgr.mr_n73206064)
print v(xbgr.mr_n73206384)
print v(xbgr.mr_n73206496)
print v(xbgr.mr_n73206816)
print v(xbgr.mr_n73206928)
print v(xbgr.mr_n73207248)
print v(xbgr.mr_n73207360)
print v(xbgr.mr_n73207680)
print v(xbgr.mr_n73207792)
print v(xbgr.mr_n73208112)
print v(xbgr.mr_n73208224)
print v(xbgr.mr_n73208544)
print v(xbgr.mr_n73208656)
print v(xbgr.mr_n73208976)
print v(xbgr.mr_n73209088)
print v(xbgr.mr_n73209408)
print v(xbgr.mr_n73209520)
print v(xbgr.mr_n73209840)
print v(xbgr.mr_n73209952)
print v(xbgr.mr_n73210272)
print v(xbgr.mr_n73210384)
print v(xbgr.mr_n73210704)
print v(xbgr.mr_n73210816)
print v(xbgr.mr_n73211136)
print v(xbgr.mr_n73211248)
print v(xbgr.mr_n73211568)
print v(xbgr.mr_n73211680)
print v(xbgr.mr_n73212000)
print v(xbgr.mr_n73212112)
print v(xbgr.mr_n73212432)
print v(xbgr.mr_n73212544)
print v(xbgr.mr_n73212864)
print v(xbgr.mr_n73212976)
print v(xbgr.mr_n73213296)
print v(xbgr.mr_n73213408)
print v(xbgr.mr_n73213728)
print v(xbgr.mr_n73213840)
print v(xbgr.mr_n73214160)
print v(xbgr.mr_n73214272)
print v(xbgr.mr_n73214592)
print v(xbgr.mr_n73214704)
print v(xbgr.mr_n73215024)
print v(xbgr.mr_n73215136)
print v(xbgr.mr_n73215456)
print v(xbgr.mr_n73215568)
print v(xbgr.mr_n73215888)
print v(xbgr.mr_n73216000)
print v(xbgr.mr_n73216320)
print v(xbgr.mr_n73216432)
print v(xbgr.mr_n73216752)
print v(xbgr.mr_n73216864)
print v(xbgr.mr_n73217184)
print v(xbgr.mr_n73217296)
print v(xbgr.mr_n73217616)
print v(xbgr.mr_n73217728)
print v(xbgr.mr_n73218048)
print v(xbgr.mr_n73218160)
print v(xbgr.mr_n73218480)
print v(xbgr.mr_n73218592)
print v(xbgr.mr_n73218912)
print v(xbgr.mr_n73219024)
print v(xbgr.mr_n73219344)
print v(xbgr.mr_n73219456)
print v(xbgr.mr_n73219776)
print v(xbgr.mr_n73219888)
print v(xbgr.mr_n73220208)
print v(xbgr.mr_n73220320)
print v(xbgr.mr_n73220640)
print v(xbgr.mr_n73220752)
print v(xbgr.mr_n73221072)
print v(xbgr.mr_n73221184)
print v(xbgr.mr_n73221504)
print v(xbgr.mr_n73221616)
print v(xbgr.mr_n73221936)
print v(xbgr.mr_n73222048)
print v(xbgr.mr_n73222368)
print v(xbgr.mr_n73222480)
print v(xbgr.mr_n73222800)
print v(xbgr.mr_n73222912)
print v(xbgr.mr_n73223232)
print v(xbgr.mr_n73223344)
print v(xbgr.mr_n73223664)
print v(xbgr.mr_n73223776)
print v(xbgr.mr_n73224640)
print v(xbgr.mr_n73225072)
print v(xbgr.mr_n73225504)
print v(xbgr.mr_n73225936)
print v(xbgr.mr_n73226368)
print v(xbgr.mr_n73226800)
print v(xbgr.mr_n73227232)
print v(xbgr.mr_n73227664)
print v(xbgr.mr_n73228096)
print v(xbgr.mr_n73228528)
print v(xbgr.mr_n73228960)
print v(xbgr.mr_n73229392)
print v(xbgr.mr_n73229824)
print v(xbgr.mr_n73230256)
print v(xbgr.mr_n73230688)
print v(xbgr.mr_n73231120)
print v(xbgr.mr_n73231552)
print v(xbgr.mr_n73231984)
print v(xbgr.mr_n73232416)
print v(xbgr.mr_n73232848)
print v(xbgr.mr_n73233280)
print v(xbgr.mr_n73233712)
print v(xbgr.mr_n73234144)
print v(xbgr.mr_n73234576)
print v(xbgr.mr_n73236736)
print v(xbgr.mr_n73237168)
print v(xbgr.mr_n73237600)
print v(xbgr.mr_n73238032)
print v(xbgr.mr_n73238464)
print v(xbgr.mr_n73238896)
print v(xbgr.mr_n73239328)
print v(xbgr.mr_n73239760)
print v(xbgr.mr_n73240192)
print v(xbgr.mr_n73240624)
print v(xbgr.mr_n73241056)
print v(xbgr.mr_n73241488)
print v(xbgr.mr_n73241920)
print v(xbgr.mr_n73242352)
print v(xbgr.mr_n73242784)
print v(xbgr.mr_n73243216)
print v(xbgr.mr_n73243648)
print v(xbgr.mr_n73244080)
print v(xbgr.mr_n73244512)
print v(xbgr.mr_n73244944)
print v(xbgr.mr_n73245376)
print v(xbgr.mr_n73245808)
print v(xbgr.mr_n73246240)
print v(xbgr.mr_n73246672)
print v(xbgr.mr_n73250560)
print v(xbgr.mr_n73250992)
print v(xbgr.mr_n73251424)
print v(xbgr.mr_n73251856)
print v(xbgr.mr_n73252288)
print v(xbgr.mr_n73252720)
print v(xbgr.mr_n73253152)
print v(xbgr.mr_n73253584)
print v(xbgr.mr_n73254016)
print v(xbgr.mr_n73254448)
print v(xbgr.mr_n73254880)
print v(xbgr.mr_n73255312)
print v(xbgr.mr_n73255744)
print v(xbgr.mr_n73256176)
print v(xbgr.mr_n73256608)
print v(xbgr.mr_n73257904)
print v(xbgr.mr_n73258336)
print v(xbgr.mr_n73258768)
print v(xbgr.mr_n73259200)
print v(xbgr.mr_n73259632)
print v(xbgr.mr_n73260064)
print v(xbgr.mr_n73260496)
print v(xbgr.mr_n73260928)
print v(xbgr.mr_n73261360)
print v(xbgr.mr_n73261792)
print v(xbgr.mr_n73263088)
print v(xbgr.mr_n73263520)
print v(xbgr.mr_n73263952)
print v(xbgr.mr_n73264384)
print v(xbgr.mr_n73264816)
print v(xbgr.mr_n73265248)
print v(xbgr.mr_n73265680)
print v(xbgr.mr_n73266112)
print v(xbgr.mr_n73266432)
print v(xbgr.mr_n73266544)
print v(xbgr.mr_n73266864)
print v(xbgr.mr_n73266976)
print v(xbgr.mr_n73267296)
print v(xbgr.mr_n73267408)
print v(xbgr.mr_n73267728)
print v(xbgr.mr_n73267840)
print v(xbgr.mr_n73268160)
print v(xbgr.mr_n73268272)
print v(xbgr.mr_n73268592)
print v(xbgr.mr_n73268704)
print v(xbgr.mr_n73269024)
print v(xbgr.mr_n73269136)
print v(xbgr.mr_n73269456)
print v(xbgr.mr_n73269568)
print v(xbgr.mr_n73269888)
print v(xbgr.mr_n73270000)
print v(xbgr.mr_n73270320)
print v(xbgr.mr_n73270432)
print v(xbgr.mr_n73270752)
print v(xbgr.mr_n73270864)
print v(xbgr.mr_n73271184)
print v(xbgr.mr_n73271296)
print v(xbgr.mr_n73271616)
print v(xbgr.mr_n73271728)
print v(xbgr.mr_n73272048)
print v(xbgr.mr_n73272160)
print v(xbgr.mr_n73272480)
print v(xbgr.mr_n73272592)
print v(xbgr.mr_n73272912)
print v(xbgr.mr_n73273024)
print v(xbgr.mr_n73273344)
print v(xbgr.mr_n73273456)
print v(xbgr.mr_n73273776)
print v(xbgr.mr_n73273888)
print v(xbgr.mr_n73274208)
print v(xbgr.mr_n73274320)
print v(xbgr.mr_n73274640)
print v(xbgr.mr_n73274752)
print v(xbgr.mr_n73275072)
print v(xbgr.mr_n73275184)
print v(xbgr.mr_n73275504)
print v(xbgr.mr_n73275616)
print v(xbgr.mr_n73275936)
print v(xbgr.mr_n73276048)
print v(xbgr.mr_n73276368)
print v(xbgr.mr_n73276480)
print v(xbgr.mr_n73276800)
print v(xbgr.mr_n73276912)
print v(xbgr.mr_n73277232)
print v(xbgr.mr_n73277344)
print v(xbgr.mr_n73277664)
print v(xbgr.mr_n73277776)
print v(xbgr.mr_n73278096)
print v(xbgr.mr_n73278208)
print v(xbgr.mr_n73278528)
print v(xbgr.mr_n73278640)
print v(xbgr.mr_n73278960)
print v(xbgr.mr_n73279072)
print v(xbgr.mr_n73279392)
print v(xbgr.mr_n73279504)
print v(xbgr.mr_n73279824)
print v(xbgr.mr_n73279936)
print v(xbgr.mr_n73280256)
print v(xbgr.mr_n73280368)
print v(xbgr.mr_n73280688)
print v(xbgr.mr_n73280800)
print v(xbgr.mr_n73281120)
print v(xbgr.mr_n73281232)
print v(xbgr.mr_n73281552)
print v(xbgr.mr_n73281664)
print v(xbgr.mr_n73281984)
print v(xbgr.mr_n73282096)
print v(xbgr.mr_n73282416)
print v(xbgr.mr_n73282528)
print v(xbgr.mr_n73282848)
print v(xbgr.mr_n73282960)
print v(xbgr.mr_n73283280)
print v(xbgr.mr_n73283392)
print v(xbgr.mr_n73283712)
print v(xbgr.mr_n73283824)
print v(xbgr.mr_n73284144)
print v(xbgr.mr_n73284256)
print v(xbgr.mr_n73284576)
print v(xbgr.mr_n73284688)
print v(xbgr.mr_n73285008)
print v(xbgr.mr_n73285120)
print v(xbgr.mr_n73285440)
print v(xbgr.mr_n73285552)
print v(xbgr.mr_n73285872)
print v(xbgr.mr_n73285984)
print v(xbgr.mr_n73286304)
print v(xbgr.mr_n73286416)
print v(xbgr.mr_n73286736)
print v(xbgr.mr_n73286848)
print v(xbgr.mr_n73287168)
print v(xbgr.mr_n73287280)
print v(xbgr.mr_n73287600)
print v(xbgr.mr_n73287712)
print v(xbgr.mr_n73288032)
print v(xbgr.mr_n73288144)
print v(xbgr.mr_n73288464)
print v(xbgr.mr_n73288576)
print v(xbgr.mr_n73288896)
print v(xbgr.mr_n73289008)
print v(xbgr.mr_n73289328)
print v(xbgr.mr_n73289440)
print v(xbgr.mr_n73289760)
print v(xbgr.mr_n73289872)
print v(xbgr.mr_n73290192)
print v(xbgr.mr_n73290304)
print v(xbgr.mr_n73290624)
print v(xbgr.mr_n73290736)
print v(xbgr.mr_n73291056)
print v(xbgr.mr_n73291168)
print v(xbgr.mr_n73291488)
print v(xbgr.mr_n73291600)
print v(xbgr.mr_n73291920)
print v(xbgr.mr_n73292032)
print v(xbgr.mr_n73292352)
print v(xbgr.mr_n73292464)
print v(xbgr.mr_n73292784)
print v(xbgr.mr_n73292896)
print v(xbgr.mr_n73293216)
print v(xbgr.mr_n73293328)
print v(xbgr.mr_n73293648)
print v(xbgr.mr_n73293760)
print v(xbgr.mr_n73294080)
print v(xbgr.mr_n73294192)
print v(xbgr.mr_n73294512)
print v(xbgr.mr_n73294624)
print v(xbgr.mr_n73294944)
print v(xbgr.mr_n73295056)
print v(xbgr.mr_n73295376)
print v(xbgr.mr_n73295488)
print v(xbgr.mr_n73295808)
print v(xbgr.mr_n73295920)
print v(xbgr.mr_n73296240)
print v(xbgr.mr_n73296352)
print v(xbgr.mr_n73296672)
print v(xbgr.mr_n73296784)
print v(xbgr.mr_n73297104)
print v(xbgr.mr_n73297216)
print v(xbgr.mr_n73297536)
print v(xbgr.mr_n73297648)
print v(xbgr.mr_n73297968)
print v(xbgr.mr_n73298080)
print v(xbgr.mr_n73298400)
print v(xbgr.mr_n73298512)
print v(xbgr.mr_n73298832)
print v(xbgr.mr_n73298944)
print v(xbgr.mr_n73299264)
print v(xbgr.mr_n73299376)
print v(xbgr.mr_n73299696)
print v(xbgr.mr_n73299808)
print v(xbgr.mr_n73300128)
print v(xbgr.mr_n73300240)
print v(xbgr.mr_n73300560)
print v(xbgr.mr_n73300672)
print v(xbgr.mr_n73300992)
print v(xbgr.mr_n73301104)
print v(xbgr.mr_n73301424)
print v(xbgr.mr_n73301536)
print v(xbgr.mr_n73301856)
print v(xbgr.mr_n73301968)
print v(xbgr.mr_n73302288)
print v(xbgr.mr_n73302400)
print v(xbgr.mr_n73302720)
print v(xbgr.mr_n73302832)
print v(xbgr.mr_n73303152)
print v(xbgr.mr_n73303264)
print v(xbgr.mr_n73303584)
print v(xbgr.mr_n73303696)
print v(xbgr.mr_n73304016)
print v(xbgr.mr_n73304128)
print v(xbgr.mr_n73304448)
print v(xbgr.mr_n73304560)
print v(xbgr.mr_n73304880)
print v(xbgr.mr_n73304992)
print v(xbgr.mr_n73305312)
print v(xbgr.mr_n73305424)
print v(xbgr.mr_n73305744)
print v(xbgr.mr_n73305856)
print v(xbgr.mr_n73306176)
print v(xbgr.mr_n73306288)
print v(xbgr.mr_n73306608)
print v(xbgr.mr_n73306720)
print v(xbgr.mr_n73307040)
print v(xbgr.mr_n73307152)
print v(xbgr.mr_n73307472)
print v(xbgr.mr_n73307584)
print v(xbgr.mr_n73307904)
print v(xbgr.mr_n73308016)
print v(xbgr.mr_n73308336)
print v(xbgr.mr_n73308448)
print v(xbgr.mr_n73308768)
print v(xbgr.mr_n73308880)
print v(xbgr.mr_n73309200)
print v(xbgr.mr_n73309312)
print v(xbgr.mr_n73309632)
print v(xbgr.mr_n73309744)
print v(xbgr.mr_n73310064)
print v(xbgr.mr_n73310176)
print v(xbgr.mr_n73310496)
print v(xbgr.mr_n73310608)
print v(xbgr.mr_n73310928)
print v(xbgr.mr_n73311040)
print v(xbgr.mr_n73311360)
print v(xbgr.mr_n73311472)
print v(xbgr.mr_n73311792)
print v(xbgr.mr_n73311904)
print v(xbgr.mr_n73312224)
print v(xbgr.mr_n73312336)
print v(xbgr.mr_n73312656)
print v(xbgr.mr_n73312768)
print v(xbgr.mr_n73313088)
print v(xbgr.mr_n73313520)
print v(xbgr.mr_n73313632)
print v(xbgr.mr_n73313952)
print v(xbgr.mr_n73314064)
print v(xbgr.mr_n73314384)
print v(xbgr.mr_n73314496)
print v(xbgr.mr_n73314816)
print v(xbgr.mr_n73314928)
print v(xbgr.mr_n73315248)
print v(xbgr.mr_n73315360)
print v(xbgr.mr_n73315680)
print v(xbgr.mr_n73315792)
print v(xbgr.mr_n73316112)
print v(xbgr.mr_n73316224)
print v(xbgr.mr_n73316544)
print v(xbgr.mr_n73316656)
print v(xbgr.mr_n73316976)
print v(xbgr.mr_n73317088)
print v(xbgr.mr_n73317408)
print v(xbgr.mr_n73317520)
print v(xbgr.mr_n73317840)
print v(xbgr.mr_n73317952)
print v(xbgr.mr_n73318272)
print v(xbgr.mr_n73318384)
print v(xbgr.mr_n73318704)
print v(xbgr.mr_n73318816)
print v(xbgr.mr_n73319136)
print v(xbgr.mr_n73319248)
print v(xbgr.mr_n73319568)
print v(xbgr.mr_n73319680)
print v(xbgr.mr_n73320000)
print v(xbgr.mr_n73320112)
print v(xbgr.mr_n73320432)
print v(xbgr.mr_n73320544)
print v(xbgr.mr_n73320864)
print v(xbgr.mr_n73320976)
print v(xbgr.mr_n73321296)
print v(xbgr.mr_n73321408)
print v(xbgr.mr_n73321728)
print v(xbgr.mr_n73321840)
print v(xbgr.mr_n73322160)
print v(xbgr.mr_n73322272)
print v(xbgr.mr_n73322592)
print v(xbgr.mr_n73322704)
print v(xbgr.mr_n73323024)
print v(xbgr.mr_n73323136)
print v(xbgr.mr_n73323456)
print v(xbgr.mr_n73323568)
print v(xbgr.mr_n73323888)
print v(xbgr.mr_n73324000)
print v(xbgr.mr_n73324320)
print v(xbgr.mr_n73324432)
print v(xbgr.mr_n73324752)
print v(xbgr.mr_n73324864)
print v(xbgr.mr_n73325184)
print v(xbgr.mr_n73325296)
print v(xbgr.mr_n73325616)
print v(xbgr.mr_n73325728)
print v(xbgr.mr_n73326048)
print v(xbgr.mr_n73326160)
print v(xbgr.mr_n73326480)
print v(xbgr.mr_n73326592)
print v(xbgr.mr_n73326912)
print v(xbgr.mr_n73327024)
print v(xbgr.mr_n73327344)
print v(xbgr.mr_n73327456)
print v(xbgr.mr_n73327776)
print v(xbgr.mr_n73327888)
print v(xbgr.mr_n73328208)
print v(xbgr.mr_n73328320)
print v(xbgr.mr_n73328640)
print v(xbgr.mr_n73329072)
print v(xbgr.mr_n73329184)
print v(xbgr.mr_n73329504)
print v(xbgr.mr_n73329616)
print v(xbgr.mr_n73329936)
print v(xbgr.mr_n73330048)
print v(xbgr.mr_n73330368)
print v(xbgr.mr_n73330800)
print v(xbgr.mr_n73330912)
print v(xbgr.mr_n73331232)
print v(xbgr.mr_n73331344)
print v(xbgr.mr_n73331664)
print v(xbgr.mr_n73331776)
print v(xbgr.mr_n73332096)
print v(xbgr.mr_n73332528)
print v(xbgr.mr_n73332640)
print v(xbgr.mr_n73332960)
print v(xbgr.mr_n73333072)
print v(xbgr.mr_n73333392)
print v(xbgr.mr_n73333504)
print v(xbgr.mr_n73333824)
print v(xbgr.mr_n73333936)
print v(xbgr.mr_n73334256)
print v(xbgr.mr_n73334368)
print v(xbgr.mr_n73334688)
print v(xbgr.mr_n73334800)
print v(xbgr.mr_n73335120)
print v(xbgr.mr_n73335232)
print v(xbgr.mr_n73335552)
print v(xbgr.mr_n73335664)
print v(xbgr.mr_n73335984)
print v(xbgr.mr_n73336096)
print v(xbgr.mr_n73336416)
print v(xbgr.mr_n73336528)
print v(xbgr.mr_n73336848)
print v(xbgr.mr_n73336960)
print v(xbgr.mr_n73337280)
print v(xbgr.mr_n73337392)
print v(xbgr.mr_n73337712)
print v(xbgr.mr_n73337824)
print v(xbgr.mr_n73338144)
print v(xbgr.mr_n73338256)
print v(xbgr.mr_n73338576)
print v(xbgr.mr_n73338688)
print v(xbgr.mr_n73339008)
print v(xbgr.mr_n73339120)
print v(xbgr.mr_n73339440)
print v(xbgr.mr_n73339872)
print v(xbgr.mr_n73339984)
print v(xbgr.mr_n73340304)
print v(xbgr.mr_n73340416)
print v(xbgr.mr_n73340736)
print v(xbgr.mr_n73340848)
print v(xbgr.mr_n73341168)
print v(xbgr.mr_n73341280)
print v(xbgr.mr_n73341600)
print v(xbgr.mr_n73341712)
print v(xbgr.mr_n73342032)
print v(xbgr.mr_n73342144)
print v(xbgr.mr_n73342464)
print v(xbgr.mr_n73342576)
print v(xbgr.mr_n73342896)
print v(xbgr.mr_n73343008)
print v(xbgr.mr_n73343328)
print v(xbgr.mr_n73343440)
print v(xbgr.mr_n73343760)
print v(xbgr.mr_n73343872)
print v(xbgr.mr_n73344192)
print v(xbgr.mr_n73344624)
print v(xbgr.mr_n73344736)
print v(xbgr.mr_n73345056)
print v(xbgr.mr_n73345488)
print v(xbgr.mr_n73345600)
print v(xbgr.mr_n73345920)
print v(xbgr.mr_n73346032)
print v(xbgr.mr_n73346352)
print v(xbgr.mr_n73346464)
print v(xbgr.mr_n73346784)
print v(xbgr.mr_n73346896)
print v(xbgr.mr_n73347216)
print v(xbgr.mr_n73347328)
print v(xbgr.mr_n73347648)
print v(xbgr.mr_n73348080)
print v(xbgr.mr_n73348192)
print v(xbgr.mr_n73348512)
print v(xbgr.mr_n73348624)
print v(xbgr.mr_n73348944)
print v(xbgr.mr_n73349056)
print v(xbgr.mr_n73353824)
print v(xbgr.mr_n73353936)
print v(xbgr.mr_n73354272)
print v(xbgr.mr_n73354384)
print v(xbgr.mr_n73354704)
print v(xbgr.mr_n73354816)
print v(xbgr.mr_n73355184)
print v(xbgr.mr_n73355296)
print v(xbgr.mr_n73355616)
print v(xbgr.mr_n73355728)
print v(xbgr.mr_n73356048)
print v(xbgr.mr_n73356400)
print v(xbgr.mr_n73356512)
print v(xbgr.mr_n73356832)
print v(xbgr.mr_n73357264)
print v(xbgr.mr_n73357376)
print v(xbgr.mr_n73357696)
print v(xbgr.mr_n73357808)
print v(xbgr.mr_n73358128)
print v(xbgr.mr_n73358240)
print v(xbgr.mr_n73358560)
print v(xbgr.mr_n73358672)
print v(xbgr.mr_n73358992)
print v(xbgr.mr_n73359104)
print v(xbgr.mr_n73359424)
print v(xbgr.mr_n73359856)
print v(xbgr.mr_n73359968)
print v(xbgr.mr_n73360288)
print v(xbgr.mr_n73360720)
print v(xbgr.mr_n73360832)
print v(xbgr.mr_n73361152)
print v(xbgr.mr_n73361264)
print v(xbgr.mr_n73361584)
print v(xbgr.mr_n73361696)
print v(xbgr.mr_n73362016)
print v(xbgr.mr_n73362128)
print v(xbgr.mr_n73362448)
print v(xbgr.mr_n73362560)
print v(xbgr.mr_n73362880)
print v(xbgr.mr_n73362992)
print v(xbgr.mr_n73363312)
print v(xbgr.mr_n73363424)
print v(xbgr.mr_n73363744)
print v(xbgr.mr_n73364176)
print v(xbgr.mr_n73364288)
print v(xbgr.mr_n73364608)
print v(xbgr.mr_n73364720)
print v(xbgr.mr_n73365040)
print v(xbgr.mr_n73365152)
print v(xbgr.mr_n73365472)
print v(xbgr.mr_n73365584)
print v(xbgr.mr_n73365904)
print v(xbgr.mr_n73366016)
print v(xbgr.mr_n73366336)
print v(xbgr.mr_n73366448)
print v(xbgr.mr_n73366768)
print v(xbgr.mr_n73366880)
print v(xbgr.mr_n73367200)
print v(xbgr.mr_n73367632)
print v(xbgr.mr_n73367744)
print v(xbgr.mr_n73368064)
print v(xbgr.mr_n73368496)
print v(xbgr.mr_n73368608)
print v(xbgr.mr_n73368928)
print v(xbgr.mr_n73369040)
print v(xbgr.mr_n73369360)
print v(xbgr.mr_n73369472)
print v(xbgr.mr_n73369792)
print v(xbgr.mr_n73369904)
print v(xbgr.mr_n73370224)
print v(xbgr.mr_n73370336)
print v(xbgr.mr_n73370656)
print v(xbgr.mr_n73370768)
print v(xbgr.mr_n73371088)
print v(xbgr.mr_n73371200)
print v(xbgr.mr_n73371520)
print v(xbgr.mr_n73371952)
print v(xbgr.mr_n73372064)
print v(xbgr.mr_n73372384)
print v(xbgr.mr_n73372496)
print v(xbgr.mr_n73372816)
print v(xbgr.mr_n73372928)
print v(xbgr.mr_n73373248)
print v(xbgr.mr_n73373680)
print v(xbgr.mr_n73373792)
print v(xbgr.mr_n73374112)
print v(xbgr.mr_n73374224)
print v(xbgr.mr_n73374544)
print v(xbgr.mr_n73374656)
print v(xbgr.mr_n73374976)
print v(xbgr.mr_n73375088)
print v(xbgr.mr_n73375408)
print v(xbgr.mr_n73375520)
print v(xbgr.mr_n73375840)
print v(xbgr.mr_n73375952)
print v(xbgr.mr_n73376272)
print v(xbgr.mr_n73376384)
print v(xbgr.mr_n73376704)
print v(xbgr.mr_n73377136)
print v(xbgr.mr_n73377248)
print v(xbgr.mr_n73377568)
print v(xbgr.mr_n73377680)
print v(xbgr.mr_n73378000)
print v(xbgr.mr_n73378112)
print v(xbgr.mr_n73378432)
print v(xbgr.mr_n73378864)
print v(xbgr.mr_n73378976)
print v(xbgr.mr_n73379296)
print v(xbgr.mr_n73379408)
print v(xbgr.mr_n73379728)
print v(xbgr.mr_n73379840)
print v(xbgr.mr_n73380160)
print v(xbgr.mr_n73380272)
print v(xbgr.mr_n73380592)
print v(xbgr.mr_n73380704)
print v(xbgr.mr_n73381024)
print v(xbgr.mr_n73381136)
print v(xbgr.mr_n73381456)
print v(xbgr.mr_n73381568)
print v(xbgr.mr_n73381888)
print v(xbgr.mr_n73382000)
print v(xbgr.mr_n73382320)
print v(xbgr.mr_n73382432)
print v(xbgr.mr_n73382752)
print v(xbgr.mr_n73383184)
print v(xbgr.mr_n73383296)
print v(xbgr.mr_n73383616)
print v(xbgr.mr_n73383728)
print v(xbgr.mr_n73383952)
print v(xbgr.mr_n73384320)
print v(xbgr.mr_n73384432)
print v(xbgr.mr_n73384688)
print v(xbgr.mr_n73384800)
print v(xbgr.mr_n73385056)
print v(xbgr.mr_n73385168)
print v(xbgr.mr_n73385424)
print v(xbgr.mr_n73385536)
print v(xbgr.mr_n73385792)
print v(xbgr.mr_n73385904)
print v(xbgr.mr_n73386160)
print v(xbgr.mr_n73386528)
print v(xbgr.mr_n73386640)
print v(xbgr.mr_n73386896)
print v(xbgr.mr_n73387264)
print v(xbgr.mr_n73387376)
print v(xbgr.mr_n73387632)
print v(xbgr.mr_n73388000)
print v(xbgr.mr_n73388112)
print v(xbgr.mr_n73388368)
print v(xbgr.mr_n73388480)
print v(xbgr.mr_n73388736)
print v(xbgr.mr_n73388848)
print v(xbgr.mr_n73389104)
print v(xbgr.mr_n73389472)
print v(xbgr.mr_n73389584)
print v(xbgr.mr_n73389840)
print v(xbgr.mr_n73390208)
print v(xbgr.mr_n73390320)
print v(xbgr.mr_n73390576)
print v(xbgr.mr_n73390944)
print v(xbgr.mr_n73391056)
print v(xbgr.mr_n73391312)
print v(xbgr.mr_n73391424)
print v(xbgr.mr_n73391680)
print v(xbgr.mr_n73391792)
print v(xbgr.mr_n73392048)
print v(xbgr.mr_n73392160)
print v(xbgr.mr_n73392416)
print v(xbgr.mr_n73392528)
print v(xbgr.mr_n73392784)
print v(xbgr.mr_n73393152)
print v(xbgr.mr_n73393264)
print v(xbgr.mr_n73393520)
print v(xbgr.mr_n73393632)
print v(xbgr.mr_n73393888)
print v(xbgr.mr_n73394000)
print v(xbgr.mr_n73394256)
print v(xbgr.mr_n73394368)
print v(xbgr.mr_n73394624)
print v(xbgr.mr_n73394736)
print v(xbgr.mr_n73394992)
print v(xbgr.mr_n73395360)
print v(xbgr.mr_n73395472)
print v(xbgr.mr_n73395728)
print v(xbgr.mr_n73396096)
print v(xbgr.mr_n73396208)
print v(xbgr.mr_n73396464)
print v(xbgr.mr_n73396576)
print v(xbgr.mr_n73396832)
print v(xbgr.mr_n73396944)
print v(xbgr.mr_n73397200)
print v(xbgr.mr_n73397568)
print v(xbgr.mr_n73397680)
print v(xbgr.mr_n73397936)
print v(xbgr.mr_n73398304)
print v(xbgr.mr_n73398416)
print v(xbgr.mr_n73398672)
print v(xbgr.mr_n73398784)
print v(xbgr.mr_n73399040)
print v(xbgr.mr_n73399152)
print v(xbgr.mr_n73399408)
print v(xbgr.mr_n73399520)
print v(xbgr.mr_n73399776)
print v(xbgr.mr_n73399888)
print v(xbgr.mr_n73400144)
print v(xbgr.mr_n73400256)
print v(xbgr.mr_n73400512)
print v(xbgr.mr_n73400624)
print v(xbgr.mr_n73400912)
print v(xbgr.mr_n73401344)
print v(xbgr.mr_n73401456)
print v(xbgr.mr_n73401776)
print v(xbgr.mr_n73401888)
print v(xbgr.mr_n73402208)
print v(xbgr.mr_n73402320)
print v(xbgr.mr_n73402640)
print v(xbgr.mr_n73402752)
print v(xbgr.mr_n73403072)
print v(xbgr.mr_n73403184)
print v(xbgr.mr_n73403504)
print v(xbgr.mr_n73403936)
print v(xbgr.mr_n73404048)
print v(xbgr.mr_n73404368)
print v(xbgr.mr_n73404800)
print v(xbgr.mr_n73404912)
print v(xbgr.mr_n73405232)
print v(xbgr.mr_n73405344)
print v(xbgr.mr_n73405664)
print v(xbgr.mr_n73405776)
print v(xbgr.mr_n73406096)
print v(xbgr.mr_n73406208)
print v(xbgr.mr_n73406528)
print v(xbgr.mr_n73406640)
print v(xbgr.mr_n73406960)
print v(xbgr.mr_n73407072)
print v(xbgr.mr_n73407392)
print v(xbgr.mr_n73407504)
print v(xbgr.mr_n73407824)
print v(xbgr.mr_n73407936)
print v(xbgr.mr_n73408256)
print v(xbgr.mr_n73408800)
print v(xbgr.mr_n73409232)
print v(xbgr.mr_n73409664)
print v(xbgr.mr_n73410096)
print v(xbgr.mr_n73410528)
print v(xbgr.mr_n73410960)
print v(xbgr.mr_n73411392)
print v(xbgr.mr_n73411824)
print v(xbgr.mr_n73412256)
print v(xbgr.mr_n73412688)
print v(xbgr.mr_n73413008)
print v(xbgr.mr_n73413440)
print v(xbgr.mr_n73413872)
print v(xbgr.mr_n73414304)
print v(xbgr.mr_n73414736)
print v(xbgr.mr_n73415168)
print v(xbgr.mr_n73415600)
print v(xbgr.mr_n73416032)
print v(xbgr.mr_n73416464)
print v(xbgr.mr_n73416896)
print v(xbgr.mr_n73417328)
print v(xbgr.mr_n73417760)
print v(xbgr.mr_n73418192)
print v(xbgr.mr_n73418624)
print v(xbgr.mr_n73419056)
print v(xbgr.mr_n73419488)
print v(xbgr.mr_n73419920)
print v(xbgr.mr_n73420352)
print v(xbgr.mr_n73420784)
print v(xbgr.mr_n73421216)
print v(xbgr.mr_n73421648)
print v(xbgr.mr_n73422080)
print v(xbgr.mr_n73422512)
print v(xbgr.mr_n73422944)
print v(xbgr.mr_n73423376)
print v(xbgr.mr_n73423808)
print v(xbgr.mr_n73424240)
print v(xbgr.mr_n73424672)
print v(xbgr.mr_n73425104)
print v(xbgr.mr_n73425536)
print v(xbgr.mr_n73425968)
print v(xbgr.mr_n73426400)
print v(xbgr.mr_n73426832)
print v(xbgr.mr_n73427264)
print v(xbgr.mr_n73427696)
print v(xbgr.mr_n73428128)
print v(xbgr.mr_n73428560)
print v(xbgr.mr_n73428992)
print v(xbgr.mr_n73429424)
print v(xbgr.mr_n73429856)
print v(xbgr.mr_n73430288)
print v(xbgr.mr_n73430720)
print v(xbgr.mr_n73431152)
print v(xbgr.mr_n73431584)
print v(xbgr.mr_n73432016)
print v(xbgr.mr_n73432448)
print v(xbgr.mr_n73432880)
print v(xbgr.mr_n73433312)
print v(xbgr.mr_n73434608)
print v(xbgr.mr_n73435040)
print v(xbgr.mr_n73435472)
print v(xbgr.mr_n73435904)
print v(xbgr.mr_n73436336)
print v(xbgr.mr_n73436768)
print v(xbgr.mr_n73437200)
print v(xbgr.mr_n73437632)
print v(xbgr.mr_n73438064)
print v(xbgr.mr_n73438496)
print v(xbgr.mr_n73438928)
print v(xbgr.mr_n73439360)
print v(xbgr.mr_n73441520)
print v(xbgr.mr_n73441952)
print v(xbgr.mr_n73442384)
print v(xbgr.mr_n73442816)
print v(xbgr.mr_n73443248)
print v(xbgr.mr_n73443680)
print v(xbgr.mr_n73444112)
print v(xbgr.mr_n73444544)
print v(xbgr.mr_n73444976)
print v(xbgr.mr_n73445408)
print v(xbgr.mr_n73446704)
print v(xbgr.mr_n73447136)
print v(xbgr.mr_n73447568)
print v(xbgr.mr_n73448000)
print v(xbgr.mr_n73448432)
print v(xbgr.mr_n73448864)
print v(xbgr.mr_n73449296)
print v(xbgr.mr_n73449728)
print v(xbgr.mr_n73450160)
print v(xbgr.mr_n73450592)
print v(xbgr.mr_n73451024)
print v(xbgr.mr_n73451456)
print v(xbgr.mr_n73452752)
print v(xbgr.mr_n73453184)
print v(xbgr.mr_n73454480)
print v(xbgr.mr_n73454912)
print v(xbgr.mr_n73455344)
print v(xbgr.mr_n73455776)
print v(xbgr.mr_n73456208)
print v(xbgr.mr_n73456640)
print v(xbgr.mr_n73457072)
print v(xbgr.mr_n73457504)
print v(xbgr.mr_n73458800)
print v(xbgr.mr_n73459232)
print v(xbgr.mr_n73459552)
print v(xbgr.mr_n73459664)
print v(xbgr.mr_n73459984)
print v(xbgr.mr_n73460096)
print v(xbgr.mr_n73460416)
print v(xbgr.mr_n73460528)
print v(xbgr.mr_n73460848)
print v(xbgr.mr_n73460960)
print v(xbgr.mr_n73461280)
print v(xbgr.mr_n73461392)
print v(xbgr.mr_n73461712)
print v(xbgr.mr_n73461824)
print v(xbgr.mr_n73462144)
print v(xbgr.mr_n73462256)
print v(xbgr.mr_n73462576)
print v(xbgr.mr_n73462688)
print v(xbgr.mr_n73463120)
print v(xbgr.mr_n73463552)
print v(xbgr.mr_n73463984)
print v(xbgr.mr_n73464416)
print v(xbgr.mr_n73464848)
print v(xbgr.mr_n73465280)
print v(xbgr.mr_n73465712)
print v(xbgr.mr_n73466144)
print v(xbgr.mr_n73466576)
print v(xbgr.mr_n73467008)
print v(xbgr.mr_n73467440)
print v(xbgr.mr_n73467872)
print v(xbgr.mr_n73468304)
print v(xbgr.mr_n73468736)
print v(xbgr.mr_n73469168)
print v(xbgr.mr_n73469600)
print v(xbgr.mr_n73470032)
print v(xbgr.mr_n73470464)
print v(xbgr.mr_n73470896)
print v(xbgr.mr_n73471328)
print v(xbgr.mr_n73471760)
print v(xbgr.mr_n73472192)
print v(xbgr.mr_n73472624)
print v(xbgr.mr_n73473056)
print v(xbgr.mr_n73473488)
print v(xbgr.mr_n73473920)
print v(xbgr.mr_n73474560)
print v(xbgr.mr_n73474992)
print v(xbgr.mr_n73475424)
print v(xbgr.mr_n73475856)
print v(xbgr.mr_n73476288)
print v(xbgr.mr_n73476720)
print v(xbgr.mr_n73477152)
print v(xbgr.mr_n73477584)
print v(xbgr.mr_n73478016)
print v(xbgr.mr_n73478448)
print v(xbgr.mr_n73478880)
print v(xbgr.mr_n73479312)
print v(xbgr.mr_n73479744)
print v(xbgr.mr_n73480176)
print v(xbgr.mr_n73480608)
print v(xbgr.mr_n73481040)
print v(xbgr.mr_n73481472)
print v(xbgr.mr_n73481904)
print v(xbgr.mr_n73482336)
print v(xbgr.mr_n73482768)
print v(xbgr.mr_n73483200)
print v(xbgr.mr_n73483632)
print v(xbgr.mr_n73484064)
print v(xbgr.mr_n73484496)
print v(xbgr.mr_n73484928)
print v(xbgr.mr_n73485360)
print v(xbgr.mr_n73485792)
print v(xbgr.mr_n73486224)
print v(xbgr.mr_n73486656)
print v(xbgr.mr_n73487088)
print v(xbgr.mr_n73487520)
print v(xbgr.mr_n73487952)
print v(xbgr.mr_n73488384)
print v(xbgr.mr_n73488816)
print v(xbgr.mr_n73489248)
print v(xbgr.mr_n73489680)
print v(xbgr.mr_n73490112)
print v(xbgr.mr_n73490544)
print v(xbgr.mr_n73490976)
print v(xbgr.mr_n73491408)
print v(xbgr.mr_n73491840)
print v(xbgr.mr_n73492272)
print v(xbgr.mr_n73492704)
print v(xbgr.mr_n73493136)
print v(xbgr.mr_n73493568)
print v(xbgr.mr_n73494000)
print v(xbgr.mr_n73494432)
print v(xbgr.mr_n73494864)
print v(xbgr.mr_n73495296)
print v(xbgr.mr_n73495728)
print v(xbgr.mr_n73496160)
print v(xbgr.mr_n73496592)
print v(xbgr.mr_n73497024)
print v(xbgr.mr_n73497456)
print v(xbgr.mr_n73497888)
print v(xbgr.mr_n73498320)
print v(xbgr.mr_n73498752)
print v(xbgr.mr_n73499184)
print v(xbgr.mr_n73499616)
print v(xbgr.mr_n73500048)
print v(xbgr.mr_n73500480)
print v(xbgr.mr_n73500912)
print v(xbgr.mr_n73501344)
print v(xbgr.mr_n73501776)
print v(xbgr.mr_n73502208)
print v(xbgr.mr_n73502640)
print v(xbgr.mr_n73503072)
print v(xbgr.mr_n73503504)
print v(xbgr.mr_n73503936)
print v(xbgr.mr_n73504368)
print v(xbgr.mr_n73504800)
print v(xbgr.mr_n73505232)
print v(xbgr.mr_n73505664)
print v(xbgr.mr_n73506096)
print v(xbgr.mr_n73506528)
print v(xbgr.mr_n73506960)
print v(xbgr.mr_n73507392)
print v(xbgr.mr_n73507824)
print v(xbgr.mr_n73508256)
print v(xbgr.mr_n73508688)
print v(xbgr.mr_n73509120)
print v(xbgr.mr_n73509552)
print v(xbgr.mr_n73509984)
print v(xbgr.mr_n73510416)
print v(xbgr.mr_n73510848)
print v(xbgr.mr_n73511168)
print v(xbgr.mr_n73511280)
print v(xbgr.mr_n73511600)
print v(xbgr.mr_n73511712)
print v(xbgr.mr_n73512032)
print v(xbgr.mr_n73512144)
print v(xbgr.mr_n73512464)
print v(xbgr.mr_n73512576)
print v(xbgr.mr_n73513008)
print v(xbgr.mr_n73513440)
print v(xbgr.mr_n73513872)
print v(xbgr.mr_n73514304)
print v(xbgr.mr_n73514736)
print v(xbgr.mr_n73515168)
print v(xbgr.mr_n73515600)
print v(xbgr.mr_n73516032)
print v(xbgr.mr_n73516464)
print v(xbgr.mr_n73516896)
print v(xbgr.mr_n73517328)
print v(xbgr.mr_n73517760)
print v(xbgr.mr_n73518192)
print v(xbgr.mr_n73518624)
print v(xbgr.mr_n73519056)
print v(xbgr.mr_n73519488)
print v(xbgr.mr_n73519920)
print v(xbgr.mr_n73520352)
print v(xbgr.mr_n73520784)
print v(xbgr.mr_n73521216)
print v(xbgr.mr_n73521648)
print v(xbgr.mr_n73522080)
print v(xbgr.mr_n73522512)
print v(xbgr.mr_n73522944)
print v(xbgr.mr_n73523376)
print v(xbgr.mr_n73523808)
print v(xbgr.mr_n73524240)
print v(xbgr.mr_n73524672)
print v(xbgr.mr_n73525104)
print v(xbgr.mr_n73525536)
print v(xbgr.mr_n73525968)
print v(xbgr.mr_n73526400)
print v(xbgr.mr_n73526832)
print v(xbgr.mr_n73527264)
print v(xbgr.mr_n73527696)
print v(xbgr.mr_n73528128)
print v(xbgr.mr_n73528560)
print v(xbgr.mr_n73528992)
print v(xbgr.mr_n73529424)
print v(xbgr.mr_n73529856)
print v(xbgr.mr_n73530288)
print v(xbgr.mr_n73530720)
print v(xbgr.mr_n73531152)
print v(xbgr.mr_n73531584)
print v(xbgr.mr_n73532016)
print v(xbgr.mr_n73532448)
print v(xbgr.mr_n73532880)
print v(xbgr.mr_n73533312)
print v(xbgr.mr_n73533744)
print v(xbgr.mr_n73534176)
print v(xbgr.mr_n73534608)
print v(xbgr.mr_n73535040)
print v(xbgr.mr_n73535472)
print v(xbgr.mr_n73535904)
print v(xbgr.mr_n73536336)
print v(xbgr.mr_n73536768)
print v(xbgr.mr_n73537200)
print v(xbgr.mr_n73537632)
print v(xbgr.mr_n73538064)
print v(xbgr.mr_n73538496)
print v(xbgr.mr_n73538928)
print v(xbgr.mr_n73539360)
print v(xbgr.mr_n73539792)
print v(xbgr.mr_n73540224)
print v(xbgr.mr_n73541520)
print v(xbgr.mr_n73541952)
print v(xbgr.mr_n73543248)
print v(xbgr.mr_n73543680)
print v(xbgr.mr_n73544976)
print v(xbgr.mr_n73545408)
print v(xbgr.mr_n73545840)
print v(xbgr.mr_n73546272)
print v(xbgr.mr_n73546704)
print v(xbgr.mr_n73547136)
print v(xbgr.mr_n73547568)
print v(xbgr.mr_n73548000)
print v(xbgr.mr_n73548432)
print v(xbgr.mr_n73548864)
print v(xbgr.mr_n73549296)
print v(xbgr.mr_n73549728)
print v(xbgr.mr_n73550160)
print v(xbgr.mr_n73550592)
print v(xbgr.mr_n73551024)
print v(xbgr.mr_n73551456)
print v(xbgr.mr_n73552752)
print v(xbgr.mr_n73553184)
print v(xbgr.mr_n73553616)
print v(xbgr.mr_n73554048)
print v(xbgr.mr_n73554480)
print v(xbgr.mr_n73554912)
print v(xbgr.mr_n73556208)
print v(xbgr.mr_n73556640)
print v(xbgr.mr_n73557072)
print v(xbgr.mr_n73557504)
print v(xbgr.mr_n73557936)
print v(xbgr.mr_n73558368)
print v(xbgr.mr_n73558800)
print v(xbgr.mr_n73559232)
print v(xbgr.mr_n73559664)
print v(xbgr.mr_n73560096)
print v(xbgr.mr_n73560528)
print v(xbgr.mr_n73560960)
print v(xbgr.mr_n73561392)
print v(xbgr.mr_n73561824)
print v(xbgr.mr_n73562256)
print v(xbgr.mr_n73562688)
print v(xbgr.mr_n73563120)
print v(xbgr.mr_n73563552)
print v(xbgr.mr_n73563984)
print v(xbgr.mr_n73564416)
print v(xbgr.mr_n73564848)
print v(xbgr.mr_n73565280)
print v(xbgr.mr_n73565712)
print v(xbgr.mr_n73566144)
print v(xbgr.mr_n73566576)
print v(xbgr.mr_n73567008)
print v(xbgr.mr_n73567440)
print v(xbgr.mr_n73567872)
print v(xbgr.mr_n73568304)
print v(xbgr.mr_n73568736)
print v(xbgr.mr_n73569168)
print v(xbgr.mr_n73569600)
print v(xbgr.mr_n73570032)
print v(xbgr.mr_n73570464)
print v(xbgr.mr_n73570896)
print v(xbgr.mr_n73571328)
print v(xbgr.mr_n73571760)
print v(xbgr.mr_n73572192)
print v(xbgr.mr_n73572624)
print v(xbgr.mr_n73573056)
print v(xbgr.mr_n73573488)
print v(xbgr.mr_n73573920)
print v(xbgr.mr_n73574352)
print v(xbgr.mr_n73574784)
print v(xbgr.mr_n73575216)
print v(xbgr.mr_n73575648)
print v(xbgr.mr_n73576080)
print v(xbgr.mr_n73576512)
print v(xbgr.mr_n73576944)
print v(xbgr.mr_n73577376)
print v(xbgr.mr_n73577808)
print v(xbgr.mr_n73578240)
print v(xbgr.mr_n73578672)
print v(xbgr.mr_n73579104)
print v(xbgr.mr_n73579536)
print v(xbgr.mr_n73579968)
print v(xbgr.mr_n73580400)
print v(xbgr.mr_n73580720)
print v(xbgr.mr_n73580832)
print v(xbgr.mr_n73581152)
print v(xbgr.mr_n73581264)
print v(xbgr.mr_n73581584)
print v(xbgr.mr_n73581696)
print v(xbgr.mr_n73582016)
print v(xbgr.mr_n73582128)
print v(xbgr.mr_n73582448)
print v(xbgr.mr_n73582560)
print v(xbgr.mr_n73582880)
print v(xbgr.mr_n73582992)
print v(xbgr.mr_n73583312)
print v(xbgr.mr_n73583424)
print v(xbgr.mr_n73583744)
print v(xbgr.mr_n73583856)
print v(xbgr.mr_n73584176)
print v(xbgr.mr_n73584288)
print v(xbgr.mr_n73584608)
print v(xbgr.mr_n73584720)
print v(xbgr.mr_n73585040)
print v(xbgr.mr_n73585152)
print v(xbgr.mr_n73585472)
print v(xbgr.mr_n73585584)
print v(xbgr.mr_n73585904)
print v(xbgr.mr_n73586016)
print v(xbgr.mr_n73586336)
print v(xbgr.mr_n73586448)
print v(xbgr.mr_n73586768)
print v(xbgr.mr_n73586880)
print v(xbgr.mr_n73587200)
print v(xbgr.mr_n73587312)
print v(xbgr.mr_n73587632)
print v(xbgr.mr_n73587744)
print v(xbgr.mr_n73588064)
print v(xbgr.mr_n73588176)
print v(xbgr.mr_n73588496)
print v(xbgr.mr_n73588608)
print v(xbgr.mr_n73588928)
print v(xbgr.mr_n73589040)
print v(xbgr.mr_n73589360)
print v(xbgr.mr_n73589472)
print v(xbgr.mr_n73589792)
print v(xbgr.mr_n73589904)
print v(xbgr.mr_n73590224)
print v(xbgr.mr_n73590336)
print v(xbgr.mr_n73590656)
print v(xbgr.mr_n73590768)
print v(xbgr.mr_n73591088)
print v(xbgr.mr_n73591200)
print v(xbgr.mr_n73591520)
print v(xbgr.mr_n73591632)
print v(xbgr.mr_n73591952)
print v(xbgr.mr_n73592064)
print v(xbgr.mr_n73592384)
print v(xbgr.mr_n73592496)
print v(xbgr.mr_n73592816)
print v(xbgr.mr_n73592928)
print v(xbgr.mr_n73593248)
print v(xbgr.mr_n73593360)
print v(xbgr.mr_n73593680)
print v(xbgr.mr_n73593792)
print v(xbgr.mr_n73594112)
print v(xbgr.mr_n73594224)
print v(xbgr.mr_n73594544)
print v(xbgr.mr_n73594656)
print v(xbgr.mr_n73594976)
print v(xbgr.mr_n73595088)
print v(xbgr.mr_n73595408)
print v(xbgr.mr_n73595520)
print v(xbgr.mr_n73595840)
print v(xbgr.mr_n73595952)
print v(xbgr.mr_n73596272)
print v(xbgr.mr_n73596384)
print v(xbgr.mr_n73596704)
print v(xbgr.mr_n73596816)
print v(xbgr.mr_n73597232)
print v(xbgr.mr_n73597664)
print v(xbgr.mr_n73598096)
print v(xbgr.mr_n73598528)
print v(xbgr.mr_n73598960)
print v(xbgr.mr_n73599392)
print v(xbgr.mr_n73599824)
print v(xbgr.mr_n73600256)
print v(xbgr.mr_n73600688)
print v(xbgr.mr_n73601120)
print v(xbgr.mr_n73601552)
print v(xbgr.mr_n73601984)
print v(xbgr.mr_n73602304)
print v(xbgr.mr_n73602416)
print v(xbgr.mr_n73602736)
print v(xbgr.mr_n73602848)
print v(xbgr.mr_n73603280)
print v(xbgr.mr_n73603712)
print v(xbgr.mr_n73604144)
print v(xbgr.mr_n73604576)
print v(xbgr.mr_n73605008)
print v(xbgr.mr_n73605440)
print v(xbgr.mr_n73605872)
print v(xbgr.mr_n73606304)
print v(xbgr.mr_n73606736)
print v(xbgr.mr_n73607168)
print v(xbgr.mr_n73607600)
print v(xbgr.mr_n73608032)
print v(xbgr.mr_n73608464)
print v(xbgr.mr_n73608896)
print v(xbgr.mr_n73609328)
print v(xbgr.mr_n73609760)
print v(xbgr.mr_n73610192)
print v(xbgr.mr_n73610624)
print v(xbgr.mr_n73611056)
print v(xbgr.mr_n73611488)
print v(xbgr.mr_n73611920)
print v(xbgr.mr_n73612352)
print v(xbgr.mr_n73612784)
print v(xbgr.mr_n73613216)
print v(xbgr.mr_n73613648)
print v(xbgr.mr_n73614080)
print v(xbgr.mr_n73614512)
print v(xbgr.mr_n73614944)
print v(xbgr.mr_n73615376)
print v(xbgr.mr_n73615808)
print v(xbgr.mr_n73616240)
print v(xbgr.mr_n73616672)
print v(xbgr.mr_n73617104)
print v(xbgr.mr_n73617536)
print v(xbgr.mr_n73617968)
print v(xbgr.mr_n73618400)
print v(xbgr.mr_n73618832)
print v(xbgr.mr_n73619264)
print v(xbgr.mr_n73619696)
print v(xbgr.mr_n73620128)
print v(xbgr.mr_n73620448)
print v(xbgr.mr_n73620560)
print v(xbgr.mr_n73620880)
print v(xbgr.mr_n73620992)
print v(xbgr.mr_n73621424)
print v(xbgr.mr_n73621744)
print v(xbgr.mr_n73621856)
print v(xbgr.mr_n73622288)
print v(xbgr.mr_n73622720)
print v(xbgr.mr_n73623152)
print v(xbgr.mr_n73623584)
print v(xbgr.mr_n73624016)
print v(xbgr.mr_n73624448)
print v(xbgr.mr_n73624880)
print v(xbgr.mr_n73625312)
print v(xbgr.mr_n73625744)
print v(xbgr.mr_n73626176)
print v(xbgr.mr_n73626608)
print v(xbgr.mr_n73627040)
print v(xbgr.mr_n73627472)
print v(xbgr.mr_n73627904)
print v(xbgr.mr_n73628336)
print v(xbgr.mr_n73628768)
print v(xbgr.mr_n73629200)
print v(xbgr.mr_n73629632)
print v(xbgr.mr_n73630064)
print v(xbgr.mr_n73630496)
print v(xbgr.mr_n73630928)
print v(xbgr.mr_n73631360)
print v(xbgr.mr_n73631792)
print v(xbgr.mr_n73632224)
print v(xbgr.mr_n73632656)
print v(xbgr.mr_n73633088)
print v(xbgr.mr_n73633520)
print v(xbgr.mr_n73633952)
print v(xbgr.mr_n73634384)
print v(xbgr.mr_n73634816)
print v(xbgr.mr_n73635248)
print v(xbgr.mr_n73635680)
print v(xbgr.mr_n73636112)
print v(xbgr.mr_n73636544)
print v(xbgr.mr_n73636976)
print v(xbgr.mr_n73637408)
print v(xbgr.mr_n73637840)
print v(xbgr.mr_n73638272)
print v(xbgr.mr_n73638704)
print v(xbgr.mr_n73639136)
print v(xbgr.mr_n73639568)
print v(xbgr.mr_n73640000)
print v(xbgr.mr_n73640432)
print v(xbgr.mr_n73640864)
print v(xbgr.mr_n73641296)
print v(xbgr.mr_n73641728)
print v(xbgr.mr_n73642160)
print v(xbgr.mr_n73642480)
print v(xbgr.mr_n73642592)
print v(xbgr.mr_n73643024)
print v(xbgr.mr_n73643456)
print v(xbgr.mr_n73643776)
print v(xbgr.mr_n73643888)
print v(xbgr.mr_n73644208)
print v(xbgr.mr_n73644320)
print v(xbgr.mr_n73644640)
print v(xbgr.mr_n73644752)
print v(xbgr.mr_n73645072)
print v(xbgr.mr_n73645184)
print v(xbgr.mr_n73645504)
print v(xbgr.mr_n73645616)
print v(xbgr.mr_n73645936)
print v(xbgr.mr_n73646048)
print v(xbgr.mr_n73646480)
print v(xbgr.mr_n73646800)
print v(xbgr.mr_n73646912)
print v(xbgr.mr_n73647232)
print v(xbgr.mr_n73647344)
print v(xbgr.mr_n73647664)
print v(xbgr.mr_n73647776)
print v(xbgr.mr_n73648096)
print v(xbgr.mr_n73648208)
print v(xbgr.mr_n73648528)
print v(xbgr.mr_n73648640)
print v(xbgr.mr_n73648960)
print v(xbgr.mr_n73649072)
print v(xbgr.mr_n73649504)
print v(xbgr.mr_n73649824)
print v(xbgr.mr_n73649936)
print v(xbgr.mr_n73650256)
print v(xbgr.mr_n73650368)
print v(xbgr.mr_n73650688)
print v(xbgr.mr_n73650800)
print v(xbgr.mr_n73651120)
print v(xbgr.mr_n73651232)
print v(xbgr.mr_n73651552)
print v(xbgr.mr_n73651664)
print v(xbgr.mr_n73651984)
print v(xbgr.mr_n73652096)
print v(xbgr.mr_n73652528)
print v(xbgr.mr_n73652848)
print v(xbgr.mr_n73652960)
print v(xbgr.mr_n73653280)
print v(xbgr.mr_n73653392)
print v(xbgr.mr_n73653712)
print v(xbgr.mr_n73653824)
print v(xbgr.mr_n73654256)
print v(xbgr.mr_n73654576)
print v(xbgr.mr_n73654688)
print v(xbgr.mr_n73655120)
print v(xbgr.mr_n73655552)
print v(xbgr.mr_n73655984)
print v(xbgr.mr_n73656416)
print v(xbgr.mr_n73657712)
print v(xbgr.mr_n73658144)
print v(xbgr.mr_n73659440)
print v(xbgr.mr_n73659872)
print v(xbgr.mr_n73660192)
print v(xbgr.mr_n73660304)
print v(xbgr.mr_n73660624)
print v(xbgr.mr_n73660736)
print v(xbgr.mr_n73661056)
print v(xbgr.mr_n73661168)
print v(xbgr.mr_n73661488)
print v(xbgr.mr_n73662032)
print v(xbgr.mr_n73662784)
print v(xbgr.mr_n73662896)
print v(xbgr.mr_n73663216)
print v(xbgr.mr_n73665488)
print v(xbgr.mr_n73666352)
print v(xbgr.mr_n73667216)
print v(xbgr.mr_n73667648)
print v(xbgr.mr_n73668080)
print v(xbgr.mr_n73668512)
print v(xbgr.mr_n73670560)
print v(xbgr.mr_n73670672)
print v(xbgr.mr_n73671104)
print v(xbgr.mr_n73671424)
print v(xbgr.mr_n73671536)
print v(xbgr.mr_n73671856)
print v(xbgr.mr_n73671968)
print v(xbgr.mr_n73672400)
print v(xbgr.mr_n73672720)
print v(xbgr.mr_n73672832)
print v(xbgr.mr_n73673152)
print v(xbgr.mr_n73673264)
print v(xbgr.mr_n73673584)
print v(xbgr.mr_n73673696)
print v(xbgr.mr_n73674128)
print v(xbgr.mr_n73674448)
print v(xbgr.mr_n73674560)
print v(xbgr.mr_n73674880)
print v(xbgr.mr_n73674992)
print v(xbgr.mr_n73675312)
print v(xbgr.mr_n73675424)
print v(xbgr.mr_n73675856)
print v(xbgr.mr_n73676176)
print v(xbgr.mr_n73676288)
print v(xbgr.mr_n73676608)
print v(xbgr.mr_n73676720)
print v(xbgr.mr_n73677040)
print v(xbgr.mr_n73677152)
print v(xbgr.mr_n73677472)
print v(xbgr.mr_n73677584)
print v(xbgr.mr_n73677904)
print v(xbgr.mr_n73678016)
print v(xbgr.mr_n73678448)
print v(xbgr.mr_n73678768)
print v(xbgr.mr_n73678880)
print v(xbgr.mr_n73679200)
print v(xbgr.mr_n73679312)
print v(xbgr.mr_n73679632)
print v(xbgr.mr_n73679744)
print v(xbgr.mr_n73680064)
print v(xbgr.mr_n73680176)
print v(xbgr.mr_n73680608)
print v(xbgr.mr_n73680928)
print v(xbgr.mr_n73681040)
print v(xbgr.mr_n73681360)
print v(xbgr.mr_n73681472)
print v(xbgr.mr_n73681904)
print v(xbgr.mr_n73682224)
print v(xbgr.mr_n73682336)
print v(xbgr.mr_n73682656)
print v(xbgr.mr_n73682768)
print v(xbgr.mr_n73683088)
print v(xbgr.mr_n73683200)
print v(xbgr.mr_n73683632)
print v(xbgr.mr_n73683952)
print v(xbgr.mr_n73684064)
print v(xbgr.mr_n73684384)
print v(xbgr.mr_n73684496)
print v(xbgr.mr_n73684816)
print v(xbgr.mr_n73684928)
print v(xbgr.mr_n73685360)
print v(xbgr.mr_n73685680)
print v(xbgr.mr_n73685792)
print v(xbgr.mr_n73686112)
print v(xbgr.mr_n73686224)
print v(xbgr.mr_n73686544)
print v(xbgr.mr_n73686656)
print v(xbgr.mr_n73686976)
print v(xbgr.mr_n73687088)
print v(xbgr.mr_n73687408)
print v(xbgr.mr_n73687520)
print v(xbgr.mr_n73687840)
print v(xbgr.mr_n73687952)
print v(xbgr.mr_n73688272)
print v(xbgr.mr_n73688384)
print v(xbgr.mr_n73688704)
print v(xbgr.mr_n73688816)
print v(xbgr.mr_n73689136)
print v(xbgr.mr_n73689248)
print v(xbgr.mr_n73689568)
print v(xbgr.mr_n73689680)
print v(xbgr.mr_n73690000)
print v(xbgr.mr_n73690112)
print v(xbgr.mr_n73690432)
print v(xbgr.mr_n73690544)
print v(xbgr.mr_n73690864)
print v(xbgr.mr_n73690976)
print v(xbgr.mr_n73691408)
print v(xbgr.mr_n73691728)
print v(xbgr.mr_n73691840)
print v(xbgr.mr_n73692160)
print v(xbgr.mr_n73692272)
print v(xbgr.mr_n73692592)
print v(xbgr.mr_n73692704)
print v(xbgr.mr_n73693024)
print v(xbgr.mr_n73693136)
print v(xbgr.mr_n73693456)
print v(xbgr.mr_n73693568)
print v(xbgr.mr_n73693888)
print v(xbgr.mr_n73694000)
print v(xbgr.mr_n73694320)
print v(xbgr.mr_n73694432)
print v(xbgr.mr_n73694752)
print v(xbgr.mr_n73694864)
print v(xbgr.mr_n73695184)
print v(xbgr.mr_n73695296)
print v(xbgr.mr_n73695616)
print v(xbgr.mr_n73695728)
print v(xbgr.mr_n73696160)
print v(xbgr.mr_n73696480)
print v(xbgr.mr_n73696592)
print v(xbgr.mr_n73696912)
print v(xbgr.mr_n73697024)
print v(xbgr.mr_n73697344)
print v(xbgr.mr_n73697456)
print v(xbgr.mr_n73697776)
print v(xbgr.mr_n73697888)
print v(xbgr.mr_n73698208)
print v(xbgr.mr_n73698320)
print v(xbgr.mr_n73698640)
print v(xbgr.mr_n73698752)
print v(xbgr.mr_n73699072)
print v(xbgr.mr_n73699184)
print v(xbgr.mr_n73699504)
print v(xbgr.mr_n73699616)
print v(xbgr.mr_n73699936)
print v(xbgr.mr_n73700048)
print v(xbgr.mr_n73700368)
print v(xbgr.mr_n73700480)
print v(xbgr.mr_n73700800)
print v(xbgr.mr_n73700912)
print v(xbgr.mr_n73701232)
print v(xbgr.mr_n73701344)
print v(xbgr.mr_n73701664)
print v(xbgr.mr_n73701776)
print v(xbgr.mr_n73702096)
print v(xbgr.mr_n73702208)
print v(xbgr.mr_n73702528)
print v(xbgr.mr_n73702640)
print v(xbgr.mr_n73702960)
print v(xbgr.mr_n73703072)
print v(xbgr.mr_n73703504)
print v(xbgr.mr_n73703824)
print v(xbgr.mr_n73703936)
print v(xbgr.mr_n73704256)
print v(xbgr.mr_n73704368)
print v(xbgr.mr_n73704688)
print v(xbgr.mr_n73704800)
print v(xbgr.mr_n73705120)
print v(xbgr.mr_n73705232)
print v(xbgr.mr_n73705552)
print v(xbgr.mr_n73705664)
print v(xbgr.mr_n73705984)
print v(xbgr.mr_n73706096)
print v(xbgr.mr_n73706416)
print v(xbgr.mr_n73706528)
print v(xbgr.mr_n73706848)
print v(xbgr.mr_n73706960)
print v(xbgr.mr_n73707280)
print v(xbgr.mr_n73707392)
print v(xbgr.mr_n73707712)
print v(xbgr.mr_n73707824)
print v(xbgr.mr_n73708144)
print v(xbgr.mr_n73708256)
print v(xbgr.mr_n73708576)
print v(xbgr.mr_n73708688)
print v(xbgr.mr_n73709120)
print v(xbgr.mr_n73709440)
print v(xbgr.mr_n73709552)
print v(xbgr.mr_n73709872)
print v(xbgr.mr_n73709984)
print v(xbgr.mr_n73710304)
print v(xbgr.mr_n73710416)
print v(xbgr.mr_n73710736)
print v(xbgr.mr_n73710848)
print v(xbgr.mr_n73711168)
print v(xbgr.mr_n73711280)
print v(xbgr.mr_n73711600)
print v(xbgr.mr_n73711712)
print v(xbgr.mr_n73712032)
print v(xbgr.mr_n73712144)
print v(xbgr.mr_n73712464)
print v(xbgr.mr_n73712576)
print v(xbgr.mr_n73712896)
print v(xbgr.mr_n73713008)
print v(xbgr.mr_n73713328)
print v(xbgr.mr_n73713440)
print v(xbgr.mr_n73713760)
print v(xbgr.mr_n73713872)
print v(xbgr.mr_n73714192)
print v(xbgr.mr_n73714304)
print v(xbgr.mr_n73714624)
print v(xbgr.mr_n73714736)
print v(xbgr.mr_n73715056)
print v(xbgr.mr_n73715168)
print v(xbgr.mr_n73715488)
print v(xbgr.mr_n73715600)
print v(xbgr.mr_n73715920)
print v(xbgr.mr_n73716032)
print v(xbgr.mr_n73716352)
print v(xbgr.mr_n73716464)
print v(xbgr.mr_n73716784)
print v(xbgr.mr_n73716896)
print v(xbgr.mr_n73717216)
print v(xbgr.mr_n73717328)
print v(xbgr.mr_n73717648)
print v(xbgr.mr_n73717760)
print v(xbgr.mr_n73718192)
print v(xbgr.mr_n73718512)
print v(xbgr.mr_n73718624)
print v(xbgr.mr_n73718944)
print v(xbgr.mr_n73719056)
print v(xbgr.mr_n73719376)
print v(xbgr.mr_n73719488)
print v(xbgr.mr_n73719808)
print v(xbgr.mr_n73719920)
print v(xbgr.mr_n73720240)
print v(xbgr.mr_n73720352)
print v(xbgr.mr_n73720672)
print v(xbgr.mr_n73720784)
print v(xbgr.mr_n73721104)
print v(xbgr.mr_n73721216)
print v(xbgr.mr_n73721536)
print v(xbgr.mr_n73721648)
print v(xbgr.mr_n73721968)
print v(xbgr.mr_n73722080)
print v(xbgr.mr_n73722400)
print v(xbgr.mr_n73722512)
print v(xbgr.mr_n73722832)
print v(xbgr.mr_n73722944)
print v(xbgr.mr_n73723264)
print v(xbgr.mr_n73723376)
print v(xbgr.mr_n73723696)
print v(xbgr.mr_n73723808)
print v(xbgr.mr_n73724128)
print v(xbgr.mr_n73724240)
print v(xbgr.mr_n73724560)
print v(xbgr.mr_n73724672)
print v(xbgr.mr_n73724992)
print v(xbgr.mr_n73725104)
print v(xbgr.mr_n73725424)
print v(xbgr.mr_n73725536)
print v(xbgr.mr_n73725856)
print v(xbgr.mr_n73725968)
print v(xbgr.mr_n73726288)
print v(xbgr.mr_n73726400)
print v(xbgr.mr_n73726720)
print v(xbgr.mr_n73726832)
print v(xbgr.mr_n73727152)
print v(xbgr.mr_n73727264)
print v(xbgr.mr_n73727584)
print v(xbgr.mr_n73727696)
print v(xbgr.mr_n73728128)
print v(xbgr.mr_n73728448)
print v(xbgr.mr_n73728560)
print v(xbgr.mr_n73728880)
print v(xbgr.mr_n73728992)
print v(xbgr.mr_n73729312)
print v(xbgr.mr_n73729424)
print v(xbgr.mr_n73729744)
print v(xbgr.mr_n73729856)
print v(xbgr.mr_n73730176)
print v(xbgr.mr_n73730288)
print v(xbgr.mr_n73730608)
print v(xbgr.mr_n73730720)
print v(xbgr.mr_n73731040)
print v(xbgr.mr_n73731152)
print v(xbgr.mr_n73731472)
print v(xbgr.mr_n73731584)
print v(xbgr.mr_n73731904)
print v(xbgr.mr_n73732016)
print v(xbgr.mr_n73732336)
print v(xbgr.mr_n73732448)
print v(xbgr.mr_n73732768)
print v(xbgr.mr_n73732880)
print v(xbgr.mr_n73733200)
print v(xbgr.mr_n73733312)
print v(xbgr.mr_n73733744)
print v(xbgr.mr_n73734176)
print v(xbgr.mr_n73734608)
print v(xbgr.mr_n73735040)
print v(xbgr.mr_n73735472)
print v(xbgr.mr_n73735904)
print v(xbgr.mr_n73736336)
print v(xbgr.mr_n73736768)
print v(xbgr.mr_n73737200)
print v(xbgr.mr_n73737632)
print v(xbgr.mr_n73738064)
print v(xbgr.mr_n73738496)
print v(xbgr.mr_n73738928)
print v(xbgr.mr_n73739360)
print v(xbgr.mr_n73739792)
print v(xbgr.mr_n73740224)
print v(xbgr.mr_n73740656)
print v(xbgr.mr_n73741088)
print v(xbgr.mr_n73741520)
print v(xbgr.mr_n73741952)
print v(xbgr.mr_n73742384)
print v(xbgr.mr_n73742816)
print v(xbgr.mr_n73743248)
print v(xbgr.mr_n73743680)
print v(xbgr.mr_n73744112)
print v(xbgr.mr_n73744544)
print v(xbgr.mr_n73744976)
print v(xbgr.mr_n73745408)
print v(xbgr.mr_n73745840)
print v(xbgr.mr_n73746272)
print v(xbgr.mr_n73746704)
print v(xbgr.mr_n73747136)
print v(xbgr.mr_n73747568)
print v(xbgr.mr_n73748000)
print v(xbgr.mr_n73748432)
print v(xbgr.mr_n73748864)
print v(xbgr.mr_n73749296)
print v(xbgr.mr_n73749728)
print v(xbgr.mr_n73750160)
print v(xbgr.mr_n73750592)
print v(xbgr.mr_n73751024)
print v(xbgr.mr_n73751456)
print v(xbgr.mr_n73751888)
print v(xbgr.mr_n73752320)
print v(xbgr.mr_n73752752)
print v(xbgr.mr_n73753184)
print v(xbgr.mr_n73753616)
print v(xbgr.mr_n73754048)
print v(xbgr.mr_n73754480)
print v(xbgr.mr_n73754912)
print v(xbgr.mr_n73755344)
print v(xbgr.mr_n73755776)
print v(xbgr.mr_n73756208)
print v(xbgr.mr_n73756640)
print v(xbgr.mr_n73757072)
print v(xbgr.mr_n73757504)
print v(xbgr.mr_n73757936)
print v(xbgr.mr_n73758368)
print v(xbgr.mr_n73758800)
print v(xbgr.mr_n73759232)
print v(xbgr.mr_n73759664)
print v(xbgr.mr_n73760096)
print v(xbgr.mr_n73760528)
print v(xbgr.mr_n73760960)
print v(xbgr.mr_n73761392)
print v(xbgr.mr_n73761824)
print v(xbgr.mr_n73762256)
print v(xbgr.mr_n73762688)
print v(xbgr.mr_n73763120)
print v(xbgr.mr_n73763552)
print v(xbgr.mr_n73763984)
print v(xbgr.mr_n73764416)
print v(xbgr.mr_n73764848)
print v(xbgr.mr_n73765280)
print v(xbgr.mr_n73765712)
print v(xbgr.mr_n73766144)
print v(xbgr.mr_n73766576)
print v(xbgr.mr_n73767008)
print v(xbgr.mr_n73767440)
print v(xbgr.mr_n73767872)
print v(xbgr.mr_n73768304)
print v(xbgr.mr_n73768736)
print v(xbgr.mr_n73769168)
print v(xbgr.mr_n73769600)
print v(xbgr.mr_n73770032)
print v(xbgr.mr_n73770464)
print v(xbgr.mr_n73770896)
print v(xbgr.mr_n73771328)
print v(xbgr.mr_n73771760)
print v(xbgr.mr_n73772192)
print v(xbgr.mr_n73772624)
print v(xbgr.mr_n73773056)
print v(xbgr.mr_n73773488)
print v(xbgr.mr_n73773920)
print v(xbgr.mr_n73774352)
print v(xbgr.mr_n73774784)
print v(xbgr.mr_n73775216)
print v(xbgr.mr_n73775648)
print v(xbgr.mr_n73776080)
print v(xbgr.mr_n73776512)
print v(xbgr.mr_n73776944)
print v(xbgr.mr_n73777376)
print v(xbgr.mr_n73777808)
print v(xbgr.mr_n73778240)
print v(xbgr.mr_n73778672)
print v(xbgr.mr_n73779104)
print v(xbgr.mr_n73779536)
print v(xbgr.mr_n73779968)
print v(xbgr.mr_n73780400)
print v(xbgr.mr_n73780832)
print v(xbgr.mr_n73781152)
print v(xbgr.mr_n73781264)
print v(xbgr.mr_n73781584)
print v(xbgr.mr_n73781696)
print v(xbgr.mr_n73782016)
print v(xbgr.mr_n73782128)
print v(xbgr.mr_n73782448)
print v(xbgr.mr_n73782560)
print v(xbgr.mr_n73782880)
print v(xbgr.mr_n73782992)
print v(xbgr.mr_n73783312)
print v(xbgr.mr_n73783424)
print v(xbgr.mr_n73783744)
print v(xbgr.mr_n73783856)
print v(xbgr.mr_n73784176)
print v(xbgr.mr_n73784288)
print v(xbgr.mr_n73784608)
print v(xbgr.mr_n73784720)
print v(xbgr.mr_n73785040)
print v(xbgr.mr_n73785152)
print v(xbgr.mr_n73785472)
print v(xbgr.mr_n73785584)
print v(xbgr.mr_n73785904)
print v(xbgr.mr_n73786016)
print v(xbgr.mr_n73786336)
print v(xbgr.mr_n73786448)
print v(xbgr.mr_n73786768)
print v(xbgr.mr_n73786880)
print v(xbgr.mr_n73787200)
print v(xbgr.mr_n73787312)
print v(xbgr.mr_n73787632)
print v(xbgr.mr_n73787744)
print v(xbgr.mr_n73788064)
print v(xbgr.mr_n73788176)
print v(xbgr.mr_n73788496)
print v(xbgr.mr_n73788608)
print v(xbgr.mr_n73788928)
print v(xbgr.mr_n73789040)
print v(xbgr.mr_n73789360)
print v(xbgr.mr_n73789472)
print v(xbgr.mr_n73789792)
print v(xbgr.mr_n73789904)
print v(xbgr.mr_n73790224)
print v(xbgr.mr_n73790336)
print v(xbgr.mr_n73790656)
print v(xbgr.mr_n73790768)
print v(xbgr.mr_n73791088)
print v(xbgr.mr_n73791200)
print v(xbgr.mr_n73791520)
print v(xbgr.mr_n73791632)
print v(xbgr.mr_n73791952)
print v(xbgr.mr_n73792064)
print v(xbgr.mr_n73792384)
print v(xbgr.mr_n73792496)
print v(xbgr.mr_n73792816)
print v(xbgr.mr_n73792928)
print v(xbgr.mr_n73793248)
print v(xbgr.mr_n73793360)
print v(xbgr.mr_n73793680)
print v(xbgr.mr_n73793792)
print v(xbgr.mr_n73794112)
print v(xbgr.mr_n73794224)
print v(xbgr.mr_n73794544)
print v(xbgr.mr_n73794656)
print v(xbgr.mr_n73794976)
print v(xbgr.mr_n73795088)
print v(xbgr.mr_n73795408)
print v(xbgr.mr_n73795520)
print v(xbgr.mr_n73795840)
print v(xbgr.mr_n73795952)
print v(xbgr.mr_n73796272)
print v(xbgr.mr_n73796384)
print v(xbgr.mr_n73796704)
print v(xbgr.mr_n73796816)
print v(xbgr.mr_n73797136)
print v(xbgr.mr_n73797248)
print v(xbgr.mr_n73797568)
print v(xbgr.mr_n73797680)
print v(xbgr.mr_n73798000)
print v(xbgr.mr_n73798112)
print v(xbgr.mr_n73798432)
print v(xbgr.mr_n73798544)
print v(xbgr.mr_n73798864)
print v(xbgr.mr_n73798976)
print v(xbgr.mr_n73799296)
print v(xbgr.mr_n73799408)
print v(xbgr.mr_n73799728)
print v(xbgr.mr_n73799840)
print v(xbgr.mr_n73800160)
print v(xbgr.mr_n73800272)
print v(xbgr.mr_n73800592)
print v(xbgr.mr_n73800704)
print v(xbgr.mr_n73801024)
print v(xbgr.mr_n73801136)
print v(xbgr.mr_n73801456)
print v(xbgr.mr_n73801568)
print v(xbgr.mr_n73801888)
print v(xbgr.mr_n73802000)
print v(xbgr.mr_n73802320)
print v(xbgr.mr_n73802432)
print v(xbgr.mr_n73802864)
print v(xbgr.mr_n73803184)
print v(xbgr.mr_n73803296)
print v(xbgr.mr_n73803616)
print v(xbgr.mr_n73803728)
print v(xbgr.mr_n73804048)
print v(xbgr.mr_n73804160)
print v(xbgr.mr_n73804480)
print v(xbgr.mr_n73804592)
print v(xbgr.mr_n73804912)
print v(xbgr.mr_n73805024)
print v(xbgr.mr_n73805344)
print v(xbgr.mr_n73805456)
print v(xbgr.mr_n73805776)
print v(xbgr.mr_n73805888)
print v(xbgr.mr_n73806208)
print v(xbgr.mr_n73806320)
print v(xbgr.mr_n73806640)
print v(xbgr.mr_n73806752)
print v(xbgr.mr_n73807072)
print v(xbgr.mr_n73807184)
print v(xbgr.mr_n73807504)
print v(xbgr.mr_n73807616)
print v(xbgr.mr_n73807936)
print v(xbgr.mr_n73808048)
print v(xbgr.mr_n73808368)
print v(xbgr.mr_n73808480)
print v(xbgr.mr_n73808800)
print v(xbgr.mr_n73808912)
print v(xbgr.mr_n73809232)
print v(xbgr.mr_n73809344)
print v(xbgr.mr_n73809664)
print v(xbgr.mr_n73809776)
print v(xbgr.mr_n73810224)
print v(xbgr.mr_n73810336)
print v(xbgr.mr_n73810656)
print v(xbgr.mr_n73810768)
print v(xbgr.mr_n73811088)
print v(xbgr.mr_n73811200)
print v(xbgr.mr_n73811520)
print v(xbgr.mr_n73811632)
print v(xbgr.mr_n73811952)
print v(xbgr.mr_n73812064)
print v(xbgr.mr_n73812384)
print v(xbgr.mr_n73812496)
print v(xbgr.mr_n73812816)
print v(xbgr.mr_n73812928)
print v(xbgr.mr_n73813248)
print v(xbgr.mr_n73813360)
print v(xbgr.mr_n73813680)
print v(xbgr.mr_n73813792)
print v(xbgr.mr_n73814112)
print v(xbgr.mr_n73814224)
print v(xbgr.mr_n73814544)
print v(xbgr.mr_n73814656)
print v(xbgr.mr_n73814976)
print v(xbgr.mr_n73815088)
print v(xbgr.mr_n73815408)
print v(xbgr.mr_n73815520)
print v(xbgr.mr_n73815840)
print v(xbgr.mr_n73815952)
print v(xbgr.mr_n73816272)
print v(xbgr.mr_n73816384)
print v(xbgr.mr_n73816704)
print v(xbgr.mr_n73816816)
print v(xbgr.mr_n73817248)
print v(xbgr.mr_n73817680)
print v(xbgr.mr_n73818000)
print v(xbgr.mr_n73818112)
print v(xbgr.mr_n73818432)
print v(xbgr.mr_n73818544)
print v(xbgr.mr_n73818864)
print v(xbgr.mr_n73818976)
print v(xbgr.mr_n73819296)
print v(xbgr.mr_n73819408)
print v(xbgr.mr_n73819728)
print v(xbgr.mr_n73819840)
print v(xbgr.mr_n73820160)
print v(xbgr.mr_n73820272)
print v(xbgr.mr_n73820704)
print v(xbgr.mr_n73821024)
print v(xbgr.mr_n73821136)
print v(xbgr.mr_n73821456)
print v(xbgr.mr_n73821568)
print v(xbgr.mr_n73821888)
print v(xbgr.mr_n73822000)
print v(xbgr.mr_n73822320)
print v(xbgr.mr_n73822432)
print v(xbgr.mr_n73822752)
print v(xbgr.mr_n73822864)
print v(xbgr.mr_n73823184)
print v(xbgr.mr_n73823296)
print v(xbgr.mr_n73823616)
print v(xbgr.mr_n73823728)
print v(xbgr.mr_n73824048)
print v(xbgr.mr_n73824160)
print v(xbgr.mr_n73824480)
print v(xbgr.mr_n73824592)
print v(xbgr.mr_n73824912)
print v(xbgr.mr_n73825024)
print v(xbgr.mr_n73825344)
print v(xbgr.mr_n73825456)
print v(xbgr.mr_n73825776)
print v(xbgr.mr_n73825888)
print v(xbgr.mr_n73826320)
print v(xbgr.mr_n73826752)
print v(xbgr.mr_n73827184)
print v(xbgr.mr_n73827616)
print v(xbgr.mr_n73828112)
print v(xbgr.mr_n73828224)
print v(xbgr.mr_n73828560)
print v(xbgr.mr_n73828672)
print v(xbgr.mr_n73828992)
print v(xbgr.mr_n73829104)
print v(xbgr.mr_n73829472)
print v(xbgr.mr_n73829584)
print v(xbgr.mr_n73829904)
print v(xbgr.mr_n73830016)
print v(xbgr.mr_n73830336)
print v(xbgr.mr_n73830448)
print v(xbgr.mr_n73830688)
print v(xbgr.mr_n73830800)
print v(xbgr.mr_n73831120)
print v(xbgr.mr_n73831232)
print v(xbgr.mr_n73831552)
print v(xbgr.mr_n73831664)
print v(xbgr.mr_n73831984)
print v(xbgr.mr_n73832096)
print v(xbgr.mr_n73832416)
print v(xbgr.mr_n73832528)
print v(xbgr.mr_n73832848)
print v(xbgr.mr_n73832960)
print v(xbgr.mr_n73833280)
print v(xbgr.mr_n73833392)
print v(xbgr.mr_n73833712)
print v(xbgr.mr_n73833824)
print v(xbgr.mr_n73834144)
print v(xbgr.mr_n73834256)
print v(xbgr.mr_n73834576)
print v(xbgr.mr_n73834688)
print v(xbgr.mr_n73835008)
print v(xbgr.mr_n73835120)
print v(xbgr.mr_n73835440)
print v(xbgr.mr_n73835552)
print v(xbgr.mr_n73835872)
print v(xbgr.mr_n73835984)
print v(xbgr.mr_n73836304)
print v(xbgr.mr_n73836416)
print v(xbgr.mr_n73836736)
print v(xbgr.mr_n73836848)
print v(xbgr.mr_n73837168)
print v(xbgr.mr_n73837280)
print v(xbgr.mr_n73837600)
print v(xbgr.mr_n73837712)
print v(xbgr.mr_n73838032)
print v(xbgr.mr_n73838144)
print v(xbgr.mr_n73838464)
print v(xbgr.mr_n73838576)
print v(xbgr.mr_n73838896)
print v(xbgr.mr_n73839008)
print v(xbgr.mr_n73839328)
print v(xbgr.mr_n73839440)
print v(xbgr.mr_n73839760)
print v(xbgr.mr_n73839872)
print v(xbgr.mr_n73840192)
print v(xbgr.mr_n73840304)
print v(xbgr.mr_n73840624)
print v(xbgr.mr_n73840736)
print v(xbgr.mr_n73841056)
print v(xbgr.mr_n73841168)
print v(xbgr.mr_n73841600)
print v(xbgr.mr_n73841920)
print v(xbgr.mr_n73842912)
print v(xbgr.mr_n73843024)
print v(xbgr.mr_n73843344)
print v(xbgr.mr_n73843456)
print v(xbgr.mr_n73843776)
print v(xbgr.mr_n73843888)
print v(xbgr.mr_n73844320)
print v(xbgr.mr_n73844640)
print v(xbgr.mr_n73844752)
print v(xbgr.mr_n73845072)
print v(xbgr.mr_n73845184)
print v(xbgr.mr_n73845504)
print v(xbgr.mr_n73845616)
print v(xbgr.mr_n73845936)
print v(xbgr.mr_n73846048)
print v(xbgr.mr_n73846368)
print v(xbgr.mr_n73846480)
print v(xbgr.mr_n73846912)
print v(xbgr.mr_n73847344)
print v(xbgr.mr_n73847776)
print v(xbgr.mr_n73848208)
print v(xbgr.mr_n73848528)
print v(xbgr.mr_n73848640)
print v(xbgr.mr_n73848960)
print v(xbgr.mr_n73849072)
print v(xbgr.mr_n73849392)
print v(xbgr.mr_n73849504)
print v(xbgr.mr_n73849936)
print v(xbgr.mr_n73850368)
print v(xbgr.mr_n73850688)
print v(xbgr.mr_n73850800)
print v(xbgr.mr_n73851120)
print v(xbgr.mr_n73851232)
print v(xbgr.mr_n73851552)
print v(xbgr.mr_n73851664)
print v(xbgr.mr_n73851984)
print v(xbgr.mr_n73852096)
print v(xbgr.mr_n73852528)
print v(xbgr.mr_n73852960)
print v(xbgr.mr_n73853392)
print v(xbgr.mr_n73853824)
print v(xbgr.mr_n73854256)
print v(xbgr.mr_n73854576)
print v(xbgr.mr_n73854688)
print v(xbgr.mr_n73855008)
print v(xbgr.mr_n73855120)
print v(xbgr.mr_n73855440)
print v(xbgr.mr_n73855552)
print v(xbgr.mr_n73855872)
print v(xbgr.mr_n73855984)
print v(xbgr.mr_n73856304)
print v(xbgr.mr_n73856416)
print v(xbgr.mr_n73856736)
print v(xbgr.mr_n73856848)
print v(xbgr.mr_n73857168)
print v(xbgr.mr_n73857280)
print v(xbgr.mr_n73857600)
print v(xbgr.mr_n73857712)
print v(xbgr.mr_n73858032)
print v(xbgr.mr_n73858144)
print v(xbgr.mr_n73858464)
print v(xbgr.mr_n73858576)
print v(xbgr.mr_n73858896)
print v(xbgr.mr_n73859008)
print v(xbgr.mr_n73859328)
print v(xbgr.mr_n73859440)
print v(xbgr.mr_n73859872)
print v(xbgr.mr_n73860192)
print v(xbgr.mr_n73860304)
print v(xbgr.mr_n73860624)
print v(xbgr.mr_n73860736)
print v(xbgr.mr_n73861056)
print v(xbgr.mr_n73861168)
print v(xbgr.mr_n73861488)
print v(xbgr.mr_n73861600)
print v(xbgr.mr_n73861920)
print v(xbgr.mr_n73862032)
print v(xbgr.mr_n73862464)
print v(xbgr.mr_n73862896)
print v(xbgr.mr_n73863328)
print v(xbgr.mr_n73863760)
print v(xbgr.mr_n73864080)
print v(xbgr.mr_n73864192)
print v(xbgr.mr_n73864512)
print v(xbgr.mr_n73864624)
print v(xbgr.mr_n73864944)
print v(xbgr.mr_n73865056)
print v(xbgr.mr_n73865376)
print v(xbgr.mr_n73865488)
print v(xbgr.mr_n73865808)
print v(xbgr.mr_n73865920)
print v(xbgr.mr_n73866240)
print v(xbgr.mr_n73866352)
print v(xbgr.mr_n73866672)
print v(xbgr.mr_n73866784)
print v(xbgr.mr_n73867104)
print v(xbgr.mr_n73867216)
print v(xbgr.mr_n73867536)
print v(xbgr.mr_n73867648)
print v(xbgr.mr_n73867968)
print v(xbgr.mr_n73868080)
print v(xbgr.mr_n73868400)
print v(xbgr.mr_n73868512)
print v(xbgr.mr_n73868832)
print v(xbgr.mr_n73868944)
print v(xbgr.mr_n73869264)
print v(xbgr.mr_n73869376)
print v(xbgr.mr_n73869696)
print v(xbgr.mr_n73869808)
print v(xbgr.mr_n73870128)
print v(xbgr.mr_n73870240)
print v(xbgr.mr_n73870560)
print v(xbgr.mr_n73870672)
print v(xbgr.mr_n73870992)
print v(xbgr.mr_n73871104)
print v(xbgr.mr_n73871424)
print v(xbgr.mr_n73871536)
print v(xbgr.mr_n73871856)
print v(xbgr.mr_n73871968)
print v(xbgr.mr_n73872288)
print v(xbgr.mr_n73872400)
print v(xbgr.mr_n73872720)
print v(xbgr.mr_n73872832)
print v(xbgr.mr_n73873152)
print v(xbgr.mr_n73873264)
print v(xbgr.mr_n73873584)
print v(xbgr.mr_n73873696)
print v(xbgr.mr_n73874016)
print v(xbgr.mr_n73874128)
print v(xbgr.mr_n73874448)
print v(xbgr.mr_n73874560)
print v(xbgr.mr_n73874880)
print v(xbgr.mr_n73874992)
print v(xbgr.mr_n73875312)
print v(xbgr.mr_n73875424)
print v(xbgr.mr_n73875744)
print v(xbgr.mr_n73875856)
print v(xbgr.mr_n73876176)
print v(xbgr.mr_n73876288)
print v(xbgr.mr_n73876608)
print v(xbgr.mr_n73876720)
print v(xbgr.mr_n73877040)
print v(xbgr.mr_n73877152)
print v(xbgr.mr_n73877472)
print v(xbgr.mr_n73877584)
print v(xbgr.mr_n73877904)
print v(xbgr.mr_n73878016)
print v(xbgr.mr_n73878336)
print v(xbgr.mr_n73878448)
print v(xbgr.mr_n73878768)
print v(xbgr.mr_n73878880)
print v(xbgr.mr_n73879200)
print v(xbgr.mr_n73879312)
print v(xbgr.mr_n73879632)
print v(xbgr.mr_n73879744)
print v(xbgr.mr_n73880064)
print v(xbgr.mr_n73880176)
print v(xbgr.mr_n73880496)
print v(xbgr.mr_n73880608)
print v(xbgr.mr_n73880928)
print v(xbgr.mr_n73881040)
print v(xbgr.mr_n73881360)
print v(xbgr.mr_n73881472)
print v(xbgr.mr_n73881792)
print v(xbgr.mr_n73881904)
print v(xbgr.mr_n73882224)
print v(xbgr.mr_n73882336)
print v(xbgr.mr_n73882656)
print v(xbgr.mr_n73882768)
print v(xbgr.mr_n73883200)
print v(xbgr.mr_n73883632)
print v(xbgr.mr_n73883952)
print v(xbgr.mr_n73884064)
print v(xbgr.mr_n73884384)
print v(xbgr.mr_n73884496)
print v(xbgr.mr_n73884816)
print v(xbgr.mr_n73884928)
print v(xbgr.mr_n73885248)
print v(xbgr.mr_n73885360)
print v(xbgr.mr_n73885792)
print v(xbgr.mr_n73886224)
print v(xbgr.mr_n73886544)
print v(xbgr.mr_n73886656)
print v(xbgr.mr_n73886976)
print v(xbgr.mr_n73887088)
print v(xbgr.mr_n73887408)
print v(xbgr.mr_n73887520)
print v(xbgr.mr_n73887840)
print v(xbgr.mr_n73887952)
print v(xbgr.mr_n73888384)
print v(xbgr.mr_n73888816)
print v(xbgr.mr_n73889248)
print v(xbgr.mr_n73889680)
print v(xbgr.mr_n73890112)
print v(xbgr.mr_n73890544)
print v(xbgr.mr_n73890976)
print v(xbgr.mr_n73891408)
print v(xbgr.mr_n73891840)
print v(xbgr.mr_n73892272)
print v(xbgr.mr_n73892704)
print v(xbgr.mr_n73893136)
print v(xbgr.mr_n73893456)
print v(xbgr.mr_n73893888)
print v(xbgr.mr_n73894320)
print v(xbgr.mr_n73894752)
print v(xbgr.mr_n73895184)
print v(xbgr.mr_n73895616)
print v(xbgr.mr_n73896048)
print v(xbgr.mr_n73896480)
print v(xbgr.mr_n73896912)
print v(xbgr.mr_n73897024)
print v(xbgr.mr_n73897344)
print v(xbgr.mr_n73897456)
print v(xbgr.mr_n73897776)
print v(xbgr.mr_n73897888)
print v(xbgr.mr_n73898208)
print v(xbgr.mr_n73898320)
print v(xbgr.mr_n73898640)
print v(xbgr.mr_n73898752)
print v(xbgr.mr_n73899072)
print v(xbgr.mr_n73899184)
print v(xbgr.mr_n73899504)
print v(xbgr.mr_n73899616)
print v(xbgr.mr_n73899936)
print v(xbgr.mr_n73900048)
print v(xbgr.mr_n73900368)
print v(xbgr.mr_n73900800)
print v(xbgr.mr_n73901232)
print v(xbgr.mr_n73901664)
print v(xbgr.mr_n73902096)
print v(xbgr.mr_n73902528)
print v(xbgr.mr_n73902960)
print v(xbgr.mr_n73903392)
print v(xbgr.mr_n73903824)
print v(xbgr.mr_n73904256)
print v(xbgr.mr_n73904800)
print v(xbgr.mr_n73905232)
print v(xbgr.mr_n73905664)
print v(xbgr.mr_n73906096)
print v(xbgr.mr_n73906528)
print v(xbgr.mr_n73906960)
print v(xbgr.mr_n73907392)
print v(xbgr.mr_n73907824)
print v(xbgr.mr_n73908256)
print v(xbgr.mr_n73908688)
print v(xbgr.mr_n73909120)
print v(xbgr.mr_n73909552)
print v(xbgr.mr_n73909984)
print v(xbgr.mr_n73910416)
print v(xbgr.mr_n73910848)
print v(xbgr.mr_n73911280)
print v(xbgr.mr_n73911712)
print v(xbgr.mr_n73912144)
print v(xbgr.mr_n73912576)
print v(xbgr.mr_n73913008)
print v(xbgr.mr_n73913440)
print v(xbgr.mr_n73913872)
print v(xbgr.mr_n73914304)
print v(xbgr.mr_n73914736)
print v(xbgr.mr_n73915168)
print v(xbgr.mr_n73915600)
print v(xbgr.mr_n73916032)
print v(xbgr.mr_n73916464)
print v(xbgr.mr_n73916896)
print v(xbgr.mr_n73917328)
print v(xbgr.mr_n73917760)
print v(xbgr.mr_n73918192)
print v(xbgr.mr_n73918624)
print v(xbgr.mr_n73919056)
print v(xbgr.mr_n73919488)
print v(xbgr.mr_n73919920)
print v(xbgr.mr_n73920352)
print v(xbgr.mr_n73920784)
print v(xbgr.mr_n73921216)
print v(xbgr.mr_n73921648)
print v(xbgr.mr_n73922080)
print v(xbgr.mr_n73922512)
print v(xbgr.mr_n73922944)
print v(xbgr.mr_n73923376)
print v(xbgr.mr_n73923808)
print v(xbgr.mr_n73924240)
print v(xbgr.mr_n73924672)
print v(xbgr.mr_n73925104)
print v(xbgr.mr_n73925536)
print v(xbgr.mr_n73925968)
print v(xbgr.mr_n73926400)
print v(xbgr.mr_n73926832)
print v(xbgr.mr_n73927264)
print v(xbgr.mr_n73927696)
print v(xbgr.mr_n73928128)
print v(xbgr.mr_n73928560)
print v(xbgr.mr_n73928992)
print v(xbgr.mr_n73929424)
print v(xbgr.mr_n73929856)
print v(xbgr.mr_n73930288)
print v(xbgr.mr_n73930720)
print v(xbgr.mr_n73931152)
print v(xbgr.mr_n73931584)
print v(xbgr.mr_n73932016)
print v(xbgr.mr_n73932336)
print v(xbgr.mr_n73932768)
print v(xbgr.mr_n73933200)
print v(xbgr.mr_n73933632)
print v(xbgr.mr_n73934064)
print v(xbgr.mr_n73934496)
print v(xbgr.mr_n73935040)
print v(xbgr.mr_n73935472)
print v(xbgr.mr_n73935904)
print v(xbgr.mr_n73936336)
print v(xbgr.mr_n73936768)
print v(xbgr.mr_n73937200)
print v(xbgr.mr_n73937632)
print v(xbgr.mr_n73938064)
print v(xbgr.mr_n73938496)
print v(xbgr.mr_n73938928)
print v(xbgr.mr_n73939360)
print v(xbgr.mr_n73939792)
print v(xbgr.mr_n73940224)
print v(xbgr.mr_n73940656)
print v(xbgr.mr_n73941088)
print v(xbgr.mr_n73941520)
print v(xbgr.mr_n73941952)
print v(xbgr.mr_n73942384)
print v(xbgr.mr_n73942816)
print v(xbgr.mr_n73943248)
print v(xbgr.mr_n73943680)
print v(xbgr.mr_n73944112)
print v(xbgr.mr_n73944544)
print v(xbgr.mr_n73944976)
print v(xbgr.mr_n73945408)
print v(xbgr.mr_n73945840)
print v(xbgr.mr_n73946160)
print v(xbgr.mr_n73946272)
print v(xbgr.mr_n73946592)
print v(xbgr.mr_n73946704)
print v(xbgr.mr_n73947024)
print v(xbgr.mr_n73947136)
print v(xbgr.mr_n73947456)
print v(xbgr.mr_n73947568)
print v(xbgr.mr_n73947888)
print v(xbgr.mr_n73948000)
print v(xbgr.mr_n73948320)
print v(xbgr.mr_n73948432)
print v(xbgr.mr_n73948752)
print v(xbgr.mr_n73948864)
print v(xbgr.mr_n73949184)
print v(xbgr.mr_n73949296)
print v(xbgr.mr_n73949616)
print v(xbgr.mr_n73949728)
print v(xbgr.mr_n73950048)
print v(xbgr.mr_n73950160)
print v(xbgr.mr_n73950480)
print v(xbgr.mr_n73950592)
print v(xbgr.mr_n73950912)
print v(xbgr.mr_n73951024)
print v(xbgr.mr_n73951344)
print v(xbgr.mr_n73951456)
print v(xbgr.mr_n73951776)
print v(xbgr.mr_n73951888)
print v(xbgr.mr_n73952208)
print v(xbgr.mr_n73952320)
print v(xbgr.mr_n73952640)
print v(xbgr.mr_n73953072)
print v(xbgr.mr_n73953184)
print v(xbgr.mr_n73953504)
print v(xbgr.mr_n73953936)
print v(xbgr.mr_n73954048)
print v(xbgr.mr_n73954368)
print v(xbgr.mr_n73954480)
print v(xbgr.mr_n73954800)
print v(xbgr.mr_n73954912)
print v(xbgr.mr_n73955232)
print v(xbgr.mr_n73955344)
print v(xbgr.mr_n73955664)
print v(xbgr.mr_n73955776)
print v(xbgr.mr_n73956096)
print v(xbgr.mr_n73956208)
print v(xbgr.mr_n73956528)
print v(xbgr.mr_n73956640)
print v(xbgr.mr_n73956960)
print v(xbgr.mr_n73957392)
print v(xbgr.mr_n73957504)
print v(xbgr.mr_n73957824)
print v(xbgr.mr_n73957936)
print v(xbgr.mr_n73958256)
print v(xbgr.mr_n73958368)
print v(xbgr.mr_n73958688)
print v(xbgr.mr_n73958800)
print v(xbgr.mr_n73959120)
print v(xbgr.mr_n73959232)
print v(xbgr.mr_n73959552)
print v(xbgr.mr_n73959664)
print v(xbgr.mr_n73959984)
print v(xbgr.mr_n73960096)
print v(xbgr.mr_n73960416)
print v(xbgr.mr_n73960528)
print v(xbgr.mr_n73960848)
print v(xbgr.mr_n73960960)
print v(xbgr.mr_n73961280)
print v(xbgr.mr_n73961392)
print v(xbgr.mr_n73961712)
print v(xbgr.mr_n73961824)
print v(xbgr.mr_n73962144)
print v(xbgr.mr_n73962576)
print v(xbgr.mr_n73962688)
print v(xbgr.mr_n73963008)
print v(xbgr.mr_n73963120)
print v(xbgr.mr_n73963440)
print v(xbgr.mr_n73963552)
print v(xbgr.mr_n73963872)
print v(xbgr.mr_n73963984)
print v(xbgr.mr_n73964304)
print v(xbgr.mr_n73964416)
print v(xbgr.mr_n73964736)
print v(xbgr.mr_n73964848)
print v(xbgr.mr_n73965168)
print v(xbgr.mr_n73965280)
print v(xbgr.mr_n73965600)
print v(xbgr.mr_n73965712)
print v(xbgr.mr_n73966032)
print v(xbgr.mr_n73966144)
print v(xbgr.mr_n73966464)
print v(xbgr.mr_n73966576)
print v(xbgr.mr_n73966896)
print v(xbgr.mr_n73967008)
print v(xbgr.mr_n73967328)
print v(xbgr.mr_n73967440)
print v(xbgr.mr_n73967760)
print v(xbgr.mr_n73967872)
print v(xbgr.mr_n73968192)
print v(xbgr.mr_n73968624)
print v(xbgr.mr_n73968736)
print v(xbgr.mr_n73969056)
print v(xbgr.mr_n73969168)
print v(xbgr.mr_n73969488)
print v(xbgr.mr_n73969600)
print v(xbgr.mr_n73969920)
print v(xbgr.mr_n73970032)
print v(xbgr.mr_n73970352)
print v(xbgr.mr_n73970464)
print v(xbgr.mr_n73970784)
print v(xbgr.mr_n73970896)
print v(xbgr.mr_n73971216)
print v(xbgr.mr_n73971328)
print v(xbgr.mr_n73971648)
print v(xbgr.mr_n73972080)
print v(xbgr.mr_n73972192)
print v(xbgr.mr_n73972512)
print v(xbgr.mr_n73972944)
print v(xbgr.mr_n73973056)
print v(xbgr.mr_n73973376)
print v(xbgr.mr_n73973488)
print v(xbgr.mr_n73973808)
print v(xbgr.mr_n73973920)
print v(xbgr.mr_n73974240)
print v(xbgr.mr_n73974352)
print v(xbgr.mr_n73974672)
print v(xbgr.mr_n73974784)
print v(xbgr.mr_n73975104)
print v(xbgr.mr_n73975216)
print v(xbgr.mr_n73975536)
print v(xbgr.mr_n73975648)
print v(xbgr.mr_n73975968)
print v(xbgr.mr_n73976080)
print v(xbgr.mr_n73976400)
print v(xbgr.mr_n73976512)
print v(xbgr.mr_n73976832)
print v(xbgr.mr_n73976944)
print v(xbgr.mr_n73977264)
print v(xbgr.mr_n73977376)
print v(xbgr.mr_n73977696)
print v(xbgr.mr_n73977808)
print v(xbgr.mr_n73978240)
print v(xbgr.mr_n73978672)
print v(xbgr.mr_n73979104)
print v(xbgr.mr_n73979536)
print v(xbgr.mr_n73979968)
print v(xbgr.mr_n73980400)
print v(xbgr.mr_n73980832)
print v(xbgr.mr_n73981264)
print v(xbgr.mr_n73981696)
print v(xbgr.mr_n73982128)
print v(xbgr.mr_n73982560)
print v(xbgr.mr_n73982992)
print v(xbgr.mr_n73983424)
print v(xbgr.mr_n73983856)
print v(xbgr.mr_n73984288)
print v(xbgr.mr_n73984720)
print v(xbgr.mr_n73985152)
print v(xbgr.mr_n73985584)
print v(xbgr.mr_n73986016)
print v(xbgr.mr_n73986448)
print v(xbgr.mr_n73986880)
print v(xbgr.mr_n73987312)
print v(xbgr.mr_n73987744)
print v(xbgr.mr_n73988176)
print v(xbgr.mr_n73988608)
print v(xbgr.mr_n73989040)
print v(xbgr.mr_n73989472)
print v(xbgr.mr_n73989904)
print v(xbgr.mr_n73990336)
print v(xbgr.mr_n73990768)
print v(xbgr.mr_n73991200)
print v(xbgr.mr_n73991632)
print v(xbgr.mr_n73992064)
print v(xbgr.mr_n73992496)
print v(xbgr.mr_n73992928)
print v(xbgr.mr_n73993360)
print v(xbgr.mr_n73993792)
print v(xbgr.mr_n73994224)
print v(xbgr.mr_n73994656)
print v(xbgr.mr_n73995088)
print v(xbgr.mr_n73995520)
print v(xbgr.mr_n73995952)
print v(xbgr.mr_n73996384)
print v(xbgr.mr_n73996816)
print v(xbgr.mr_n73997248)
print v(xbgr.mr_n73997680)
print v(xbgr.mr_n73998112)
print v(xbgr.mr_n73998544)
print v(xbgr.mr_n73998976)
print v(xbgr.mr_n73999408)
print v(xbgr.mr_n73999840)
print v(xbgr.mr_n74000272)
print v(xbgr.mr_n74000704)
print v(xbgr.mr_n74001136)
print v(xbgr.mr_n74001568)
print v(xbgr.mr_n74002000)
print v(xbgr.mr_n74002432)
print v(xbgr.mr_n74002864)
print v(xbgr.mr_n74003296)
print v(xbgr.mr_n74003728)
print v(xbgr.mr_n74004160)
print v(xbgr.mr_n74004592)
print v(xbgr.mr_n74005024)
print v(xbgr.mr_n74005456)
print v(xbgr.mr_n74005888)
print v(xbgr.mr_n74006320)
print v(xbgr.mr_n74006752)
print v(xbgr.mr_n74007184)
print v(xbgr.mr_n74007616)
print v(xbgr.mr_n74008048)
print v(xbgr.mr_n74008480)
print v(xbgr.mr_n74008912)
print v(xbgr.mr_n74009344)
print v(xbgr.mr_n74009776)
print v(xbgr.mr_n74010208)
print v(xbgr.mr_n74010640)
print v(xbgr.mr_n74011072)
print v(xbgr.mr_n74011504)
print v(xbgr.mr_n74011824)
print v(xbgr.mr_n74011936)
print v(xbgr.mr_n74012256)
print v(xbgr.mr_n74012368)
print v(xbgr.mr_n74012800)
print v(xbgr.mr_n74013232)
print v(xbgr.mr_n74013552)
print v(xbgr.mr_n74013664)
print v(xbgr.mr_n74013984)
print v(xbgr.mr_n74014528)
print v(xbgr.mr_n74014960)
print v(xbgr.mr_n74015280)
print v(xbgr.mr_n74015392)
print v(xbgr.mr_n74015712)
print v(xbgr.mr_n74015824)
print v(xbgr.mr_n74016144)
print v(xbgr.mr_n74016256)
print v(xbgr.mr_n74016576)
print v(xbgr.mr_n74016688)
print v(xbgr.mr_n74017008)
print v(xbgr.mr_n74017120)
print v(xbgr.mr_n74017440)
print v(xbgr.mr_n74017552)
print v(xbgr.mr_n74017872)
print v(xbgr.mr_n74017984)
print v(xbgr.mr_n74018304)
print v(xbgr.mr_n74018416)
print v(xbgr.mr_n74018736)
print v(xbgr.mr_n74018848)
print v(xbgr.mr_n74019168)
print v(xbgr.mr_n74019280)
print v(xbgr.mr_n74019600)
print v(xbgr.mr_n74019712)
print v(xbgr.mr_n74020032)
print v(xbgr.mr_n74020144)
print v(xbgr.mr_n74020576)
print v(xbgr.mr_n74021008)
print v(xbgr.mr_n74021328)
print v(xbgr.mr_n74021440)
print v(xbgr.mr_n74021760)
print v(xbgr.mr_n74021872)
print v(xbgr.mr_n74022304)
print v(xbgr.mr_n74022736)
print v(xbgr.mr_n74023168)
print v(xbgr.mr_n74023600)
print v(xbgr.mr_n74024032)
print v(xbgr.mr_n74024464)
print v(xbgr.mr_n74024896)
print v(xbgr.mr_n74025328)
print v(xbgr.mr_n74025760)
print v(xbgr.mr_n74026192)
print v(xbgr.mr_n74026624)
print v(xbgr.mr_n74027056)
print v(xbgr.mr_n74027488)
print v(xbgr.mr_n74027920)
print v(xbgr.mr_n74028352)
print v(xbgr.mr_n74028784)
print v(xbgr.mr_n74029216)
print v(xbgr.mr_n74029648)
print v(xbgr.mr_n74030080)
print v(xbgr.mr_n74030512)
print v(xbgr.mr_n74030944)
print v(xbgr.mr_n74031376)
print v(xbgr.mr_n74031808)
print v(xbgr.mr_n74032240)
print v(xbgr.mr_n74032672)
print v(xbgr.mr_n74033104)
print v(xbgr.mr_n74033536)
print v(xbgr.mr_n74033968)
print v(xbgr.mr_n74034400)
print v(xbgr.mr_n74034832)
print v(xbgr.mr_n74035264)
print v(xbgr.mr_n74035696)
print v(xbgr.mr_n74036128)
print v(xbgr.mr_n74036560)
print v(xbgr.mr_n74036992)
print v(xbgr.mr_n74037424)
print v(xbgr.mr_n74037856)
print v(xbgr.mr_n74038288)
print v(xbgr.mr_n74038720)
print v(xbgr.mr_n74039152)
print v(xbgr.mr_n74039584)
print v(xbgr.mr_n74040016)
print v(xbgr.mr_n74040448)
print v(xbgr.mr_n74040880)
print v(xbgr.mr_n74041312)
print v(xbgr.mr_n74041744)
print v(xbgr.mr_n74042176)
print v(xbgr.mr_n74042608)
print v(xbgr.mr_n74043040)
print v(xbgr.mr_n74043472)
print v(xbgr.mr_n74043904)
print v(xbgr.mr_n74044336)
print v(xbgr.mr_n74044768)
print v(xbgr.mr_n74045200)
print v(xbgr.mr_n74045632)
print v(xbgr.mr_n74046064)
print v(xbgr.mr_n74046496)
print v(xbgr.mr_n74046928)
print v(xbgr.mr_n74047360)
print v(xbgr.mr_n74047792)
print v(xbgr.mr_n74048224)
print v(xbgr.mr_n74048656)
print v(xbgr.mr_n74049088)
print v(xbgr.mr_n74049520)
print v(xbgr.mr_n74049952)
print v(xbgr.mr_n74050384)
print v(xbgr.mr_n74050816)
print v(xbgr.mr_n74051248)
print v(xbgr.mr_n74051680)
print v(xbgr.mr_n74052112)
print v(xbgr.mr_n74052544)
print v(xbgr.mr_n74052976)
print v(xbgr.mr_n74053408)
print v(xbgr.mr_n74053840)
print v(xbgr.mr_n74054272)
print v(xbgr.mr_n74054704)
print v(xbgr.mr_n74055136)
print v(xbgr.mr_n74055568)
print v(xbgr.mr_n74056000)
print v(xbgr.mr_n74056432)
print v(xbgr.mr_n74056864)
print v(xbgr.mr_n74057296)
print v(xbgr.mr_n74057728)
print v(xbgr.mr_n74058160)
print v(xbgr.mr_n74058592)
print v(xbgr.mr_n74059024)
print v(xbgr.mr_n74059456)
print v(xbgr.mr_n74059888)
print v(xbgr.mr_n74060320)
print v(xbgr.mr_n74060752)
print v(xbgr.mr_n74061184)
print v(xbgr.mr_n74061616)
print v(xbgr.mr_n74062048)
print v(xbgr.mr_n74062480)
print v(xbgr.mr_n74062912)
print v(xbgr.mr_n74063344)
print v(xbgr.mr_n74063776)
print v(xbgr.mr_n74064208)
print v(xbgr.mr_n74064640)
print v(xbgr.mr_n74065072)
print v(xbgr.mr_n74065504)
print v(xbgr.mr_n74065936)
print v(xbgr.mr_n74066368)
print v(xbgr.mr_n74066800)
print v(xbgr.mr_n74067232)
print v(xbgr.mr_n74067664)
print v(xbgr.mr_n74068096)
print v(xbgr.mr_n74068528)
print v(xbgr.mr_n74068960)
print v(xbgr.mr_n74069392)
print v(xbgr.mr_n74069824)
print v(xbgr.mr_n74070256)
print v(xbgr.mr_n74070688)
print v(xbgr.mr_n74071120)
print v(xbgr.mr_n74071552)
print v(xbgr.mr_n74071984)
print v(xbgr.mr_n74072416)
print v(xbgr.mr_n74072848)
print v(xbgr.mr_n74073280)
print v(xbgr.mr_n74073712)
print v(xbgr.mr_n74074144)
print v(xbgr.mr_n74074576)
print v(xbgr.mr_n74075008)
print v(xbgr.mr_n74075440)
print v(xbgr.mr_n74075872)
print v(xbgr.mr_n74076304)
print v(xbgr.mr_n74076736)
print v(xbgr.mr_n74077168)
print v(xbgr.mr_n74077600)
print v(xbgr.mr_n74078032)
print v(xbgr.mr_n74078464)
print v(xbgr.mr_n74078896)
print v(xbgr.mr_n74079328)
print v(xbgr.mr_n74079760)
print v(xbgr.mr_n74080192)
print v(xbgr.mr_n74080624)
print v(xbgr.mr_n74080944)
print v(xbgr.mr_n74081056)
print v(xbgr.mr_n74081376)
print v(xbgr.mr_n74081488)
print v(xbgr.mr_n74081808)
print v(xbgr.mr_n74081920)
print v(xbgr.mr_n74082240)
print v(xbgr.mr_n74082352)
print v(xbgr.mr_n74082672)
print v(xbgr.mr_n74082784)
print v(xbgr.mr_n74083104)
print v(xbgr.mr_n74083216)
print v(xbgr.mr_n74083536)
print v(xbgr.mr_n74083648)
print v(xbgr.mr_n74083968)
print v(xbgr.mr_n74084080)
print v(xbgr.mr_n74084400)
print v(xbgr.mr_n74084512)
print v(xbgr.mr_n74084832)
print v(xbgr.mr_n74084944)
print v(xbgr.mr_n74085264)
print v(xbgr.mr_n74085376)
print v(xbgr.mr_n74085696)
print v(xbgr.mr_n74085808)
print v(xbgr.mr_n74086128)
print v(xbgr.mr_n74086240)
print v(xbgr.mr_n74086560)
print v(xbgr.mr_n74086672)
print v(xbgr.mr_n74086992)
print v(xbgr.mr_n74087104)
print v(xbgr.mr_n74087424)
print v(xbgr.mr_n74087536)
print v(xbgr.mr_n74087856)
print v(xbgr.mr_n74087968)
print v(xbgr.mr_n74088288)
print v(xbgr.mr_n74088400)
print v(xbgr.mr_n74088720)
print v(xbgr.mr_n74088832)
print v(xbgr.mr_n74089152)
print v(xbgr.mr_n74089264)
print v(xbgr.mr_n74089584)
print v(xbgr.mr_n74089696)
print v(xbgr.mr_n74090016)
print v(xbgr.mr_n74090128)
print v(xbgr.mr_n74090448)
print v(xbgr.mr_n74090560)
print v(xbgr.mr_n74090880)
print v(xbgr.mr_n74090992)
print v(xbgr.mr_n74091312)
print v(xbgr.mr_n74091424)
print v(xbgr.mr_n74091744)
print v(xbgr.mr_n74091856)
print v(xbgr.mr_n74092176)
print v(xbgr.mr_n74092288)
print v(xbgr.mr_n74092608)
print v(xbgr.mr_n74092720)
print v(xbgr.mr_n74093040)
print v(xbgr.mr_n74093152)
print v(xbgr.mr_n74093472)
print v(xbgr.mr_n74093584)
print v(xbgr.mr_n74094016)
print v(xbgr.mr_n74094448)
print v(xbgr.mr_n74094880)
print v(xbgr.mr_n74095312)
print v(xbgr.mr_n74095632)
print v(xbgr.mr_n74095744)
print v(xbgr.mr_n74096064)
print v(xbgr.mr_n74096176)
print v(xbgr.mr_n74096496)
print v(xbgr.mr_n74096608)
print v(xbgr.mr_n74096928)
print v(xbgr.mr_n74097040)
print v(xbgr.mr_n74097360)
print v(xbgr.mr_n74097472)
print v(xbgr.mr_n74097792)
print v(xbgr.mr_n74097904)
print v(xbgr.mr_n74098336)
print v(xbgr.mr_n74098768)
print v(xbgr.mr_n74099200)
print v(xbgr.mr_n74099520)
print v(xbgr.mr_n74099632)
print v(xbgr.mr_n74099952)
print v(xbgr.mr_n74100064)
print v(xbgr.mr_n74100384)
print v(xbgr.mr_n74100496)
print v(xbgr.mr_n74100816)
print v(xbgr.mr_n74100928)
print v(xbgr.mr_n74101248)
print v(xbgr.mr_n74101360)
print v(xbgr.mr_n74101680)
print v(xbgr.mr_n74101792)
print v(xbgr.mr_n74102112)
print v(xbgr.mr_n74102224)
print v(xbgr.mr_n74102544)
print v(xbgr.mr_n74102656)
print v(xbgr.mr_n74102976)
print v(xbgr.mr_n74103088)
print v(xbgr.mr_n74103408)
print v(xbgr.mr_n74103520)
print v(xbgr.mr_n74103952)
print v(xbgr.mr_n74104384)
print v(xbgr.mr_n74104816)
print v(xbgr.mr_n74105248)
print v(xbgr.mr_n74105680)
print v(xbgr.mr_n74106112)
print v(xbgr.mr_n74106544)
print v(xbgr.mr_n74106976)
print v(xbgr.mr_n74107408)
print v(xbgr.mr_n74107840)
print v(xbgr.mr_n74108272)
print v(xbgr.mr_n74108704)
print v(xbgr.mr_n74109136)
print v(xbgr.mr_n74109456)
print v(xbgr.mr_n74109568)
print v(xbgr.mr_n74109888)
print v(xbgr.mr_n74110000)
print v(xbgr.mr_n74110320)
print v(xbgr.mr_n74110432)
print v(xbgr.mr_n74110752)
print v(xbgr.mr_n74110864)
print v(xbgr.mr_n74111184)
print v(xbgr.mr_n74111296)
print v(xbgr.mr_n74111728)
print v(xbgr.mr_n74112160)
print v(xbgr.mr_n74112592)
print v(xbgr.mr_n74113024)
print v(xbgr.mr_n74113456)
print v(xbgr.mr_n74113888)
print v(xbgr.mr_n74114208)
print v(xbgr.mr_n74114320)
print v(xbgr.mr_n74114640)
print v(xbgr.mr_n74114752)
print v(xbgr.mr_n74115184)
print v(xbgr.mr_n74115616)
print v(xbgr.mr_n74115936)
print v(xbgr.mr_n74116048)
print v(xbgr.mr_n74116368)
print v(xbgr.mr_n74116480)
print v(xbgr.mr_n74116800)
print v(xbgr.mr_n74116912)
print v(xbgr.mr_n74117232)
print v(xbgr.mr_n74117344)
print v(xbgr.mr_n74117664)
print v(xbgr.mr_n74117776)
print v(xbgr.mr_n74118096)
print v(xbgr.mr_n74118208)
print v(xbgr.mr_n74118528)
print v(xbgr.mr_n74118640)
print v(xbgr.mr_n74118960)
print v(xbgr.mr_n74119072)
print v(xbgr.mr_n74119392)
print v(xbgr.mr_n74119504)
print v(xbgr.mr_n74119824)
print v(xbgr.mr_n74119936)
print v(xbgr.mr_n74120256)
print v(xbgr.mr_n74120368)
print v(xbgr.mr_n74120688)
print v(xbgr.mr_n74120800)
print v(xbgr.mr_n74121120)
print v(xbgr.mr_n74121232)
print v(xbgr.mr_n74121552)
print v(xbgr.mr_n74121664)
print v(xbgr.mr_n74122096)
print v(xbgr.mr_n74122528)
print v(xbgr.mr_n74122848)
print v(xbgr.mr_n74122960)
print v(xbgr.mr_n74123280)
print v(xbgr.mr_n74123392)
print v(xbgr.mr_n74123712)
print v(xbgr.mr_n74123824)
print v(xbgr.mr_n74124144)
print v(xbgr.mr_n74124256)
print v(xbgr.mr_n74124576)
print v(xbgr.mr_n74124688)
print v(xbgr.mr_n74125008)
print v(xbgr.mr_n74125120)
print v(xbgr.mr_n74125552)
print v(xbgr.mr_n74125984)
print v(xbgr.mr_n74126304)
print v(xbgr.mr_n74126416)
print v(xbgr.mr_n74126736)
print v(xbgr.mr_n74126848)
print v(xbgr.mr_n74127168)
print v(xbgr.mr_n74127280)
print v(xbgr.mr_n74127600)
print v(xbgr.mr_n74127712)
print v(xbgr.mr_n74128032)
print v(xbgr.mr_n74128144)
print v(xbgr.mr_n74128464)
print v(xbgr.mr_n74128576)
print v(xbgr.mr_n74128896)
print v(xbgr.mr_n74129008)
print v(xbgr.mr_n74129328)
print v(xbgr.mr_n74129440)
print v(xbgr.mr_n74129760)
print v(xbgr.mr_n74129872)
print v(xbgr.mr_n74130192)
print v(xbgr.mr_n74130304)
print v(xbgr.mr_n74130624)
print v(xbgr.mr_n74130736)
print v(xbgr.mr_n74131056)
print v(xbgr.mr_n74131168)
print v(xbgr.mr_n74131488)
print v(xbgr.mr_n74131600)
print v(xbgr.mr_n74131920)
print v(xbgr.mr_n74132032)
print v(xbgr.mr_n74132352)
print v(xbgr.mr_n74132464)
print v(xbgr.mr_n74132784)
print v(xbgr.mr_n74132896)
print v(xbgr.mr_n74133216)
print v(xbgr.mr_n74133328)
print v(xbgr.mr_n74133648)
print v(xbgr.mr_n74133760)
print v(xbgr.mr_n74134080)
print v(xbgr.mr_n74134192)
print v(xbgr.mr_n74134512)
print v(xbgr.mr_n74134624)
print v(xbgr.mr_n74134944)
print v(xbgr.mr_n74135056)
print v(xbgr.mr_n74135376)
print v(xbgr.mr_n74135488)
print v(xbgr.mr_n74135808)
print v(xbgr.mr_n74135920)
print v(xbgr.mr_n74136240)
print v(xbgr.mr_n74136352)
print v(xbgr.mr_n74136672)
print v(xbgr.mr_n74136784)
print v(xbgr.mr_n74137104)
print v(xbgr.mr_n74137216)
print v(xbgr.mr_n74137536)
print v(xbgr.mr_n74137648)
print v(xbgr.mr_n74137968)
print v(xbgr.mr_n74138080)
print v(xbgr.mr_n74138400)
print v(xbgr.mr_n74138512)
print v(xbgr.mr_n74138832)
print v(xbgr.mr_n74138944)
print v(xbgr.mr_n74139264)
print v(xbgr.mr_n74139376)
print v(xbgr.mr_n74139696)
print v(xbgr.mr_n74139808)
print v(xbgr.mr_n74140128)
print v(xbgr.mr_n74140240)
print v(xbgr.mr_n74140560)
print v(xbgr.mr_n74140672)
print v(xbgr.mr_n74140992)
print v(xbgr.mr_n74141104)
print v(xbgr.mr_n74141424)
print v(xbgr.mr_n74141536)
print v(xbgr.mr_n74141856)
print v(xbgr.mr_n74141968)
print v(xbgr.mr_n74142288)
print v(xbgr.mr_n74142400)
print v(xbgr.mr_n74142720)
print v(xbgr.mr_n74142832)
print v(xbgr.mr_n74143152)
print v(xbgr.mr_n74143264)
print v(xbgr.mr_n74143584)
print v(xbgr.mr_n74143696)
print v(xbgr.mr_n74144016)
print v(xbgr.mr_n74144128)
print v(xbgr.mr_n74144448)
print v(xbgr.mr_n74144560)
print v(xbgr.mr_n74144880)
print v(xbgr.mr_n74144992)
print v(xbgr.mr_n74145312)
print v(xbgr.mr_n74145424)
print v(xbgr.mr_n74145744)
print v(xbgr.mr_n74145856)
print v(xbgr.mr_n74146176)
print v(xbgr.mr_n74146288)
print v(xbgr.mr_n74146608)
print v(xbgr.mr_n74146720)
print v(xbgr.mr_n74147040)
print v(xbgr.mr_n74147152)
print v(xbgr.mr_n74147472)
print v(xbgr.mr_n74147584)
print v(xbgr.mr_n74147904)
print v(xbgr.mr_n74148016)
print v(xbgr.mr_n74148336)
print v(xbgr.mr_n74148448)
print v(xbgr.mr_n74148768)
print v(xbgr.mr_n74148880)
print v(xbgr.mr_n74149200)
print v(xbgr.mr_n74149312)
print v(xbgr.mr_n74149632)
print v(xbgr.mr_n74149744)
print v(xbgr.mr_n74150064)
print v(xbgr.mr_n74150176)
print v(xbgr.mr_n74150496)
print v(xbgr.mr_n74150608)
print v(xbgr.mr_n74150928)
print v(xbgr.mr_n74151040)
print v(xbgr.mr_n74151360)
print v(xbgr.mr_n74151472)
print v(xbgr.mr_n74151792)
print v(xbgr.mr_n74151904)
print v(xbgr.mr_n74152224)
print v(xbgr.mr_n74152336)
print v(xbgr.mr_n74152656)
print v(xbgr.mr_n74152768)
print v(xbgr.mr_n74153088)
print v(xbgr.mr_n74153200)
print v(xbgr.mr_n74153520)
print v(xbgr.mr_n74153632)
print v(xbgr.mr_n74153952)
print v(xbgr.mr_n74154064)
print v(xbgr.mr_n74154384)
print v(xbgr.mr_n74154496)
print v(xbgr.mr_n74154816)
print v(xbgr.mr_n74154928)
print v(xbgr.mr_n74155248)
print v(xbgr.mr_n74155360)
print v(xbgr.mr_n74155680)
print v(xbgr.mr_n74155792)
print v(xbgr.mr_n74156112)
print v(xbgr.mr_n74156224)
print v(xbgr.mr_n74156544)
print v(xbgr.mr_n74156656)
print v(xbgr.mr_n74156976)
print v(xbgr.mr_n74157088)
print v(xbgr.mr_n74157408)
print v(xbgr.mr_n74157520)
print v(xbgr.mr_n74157840)
print v(xbgr.mr_n74157952)
print v(xbgr.mr_n74158272)
print v(xbgr.mr_n74158384)
print v(xbgr.mr_n74158704)
print v(xbgr.mr_n74158816)
print v(xbgr.mr_n74159136)
print v(xbgr.mr_n74159248)
print v(xbgr.mr_n74159568)
print v(xbgr.mr_n74159680)
print v(xbgr.mr_n74160000)
print v(xbgr.mr_n74160112)
print v(xbgr.mr_n74160432)
print v(xbgr.mr_n74160544)
print v(xbgr.mr_n74160864)
print v(xbgr.mr_n74160976)
print v(xbgr.mr_n74161296)
print v(xbgr.mr_n74161408)
print v(xbgr.mr_n74161728)
print v(xbgr.mr_n74161840)
print v(xbgr.mr_n74162160)
print v(xbgr.mr_n74162272)
print v(xbgr.mr_n74162592)
print v(xbgr.mr_n74162704)
print v(xbgr.mr_n74163024)
print v(xbgr.mr_n74163136)
print v(xbgr.mr_n74163456)
print v(xbgr.mr_n74163568)
print v(xbgr.mr_n74163888)
print v(xbgr.mr_n74164000)
print v(xbgr.mr_n74164320)
print v(xbgr.mr_n74164432)
print v(xbgr.mr_n74164752)
print v(xbgr.mr_n74164864)
print v(xbgr.mr_n74165184)
print v(xbgr.mr_n74165296)
print v(xbgr.mr_n74165616)
print v(xbgr.mr_n74165728)
print v(xbgr.mr_n74166048)
print v(xbgr.mr_n74166160)
print v(xbgr.mr_n74166480)
print v(xbgr.mr_n74166592)
print v(xbgr.mr_n74166912)
print v(xbgr.mr_n74167024)
print v(xbgr.mr_n74167344)
print v(xbgr.mr_n74167456)
print v(xbgr.mr_n74167776)
print v(xbgr.mr_n74167888)
print v(xbgr.mr_n74168208)
print v(xbgr.mr_n74168320)
print v(xbgr.mr_n74168640)
print v(xbgr.mr_n74168752)
print v(xbgr.mr_n74169072)
print v(xbgr.mr_n74169184)
print v(xbgr.mr_n74169504)
print v(xbgr.mr_n74169616)
print v(xbgr.mr_n74169936)
print v(xbgr.mr_n74170048)
print v(xbgr.mr_n74170368)
print v(xbgr.mr_n74170480)
print v(xbgr.mr_n74170800)
print v(xbgr.mr_n74170912)
print v(xbgr.mr_n74171232)
print v(xbgr.mr_n74171344)
print v(xbgr.mr_n74171664)
print v(xbgr.mr_n74171776)
print v(xbgr.mr_n74172096)
print v(xbgr.mr_n74172208)
print v(xbgr.mr_n74172528)
print v(xbgr.mr_n74172640)
print v(xbgr.mr_n74172960)
print v(xbgr.mr_n74173072)
print v(xbgr.mr_n74173392)
print v(xbgr.mr_n74173504)
print v(xbgr.mr_n74173824)
print v(xbgr.mr_n74173936)
print v(xbgr.mr_n74174256)
print v(xbgr.mr_n74174368)
print v(xbgr.mr_n74174688)
print v(xbgr.mr_n74174800)
print v(xbgr.mr_n74175120)
print v(xbgr.mr_n74175232)
print v(xbgr.mr_n74175552)
print v(xbgr.mr_n74175664)
print v(xbgr.mr_n74175984)
print v(xbgr.mr_n74176096)
print v(xbgr.mr_n74176416)
print v(xbgr.mr_n74176528)
print v(xbgr.mr_n74176960)
print v(xbgr.mr_n74177392)
print v(xbgr.mr_n74177824)
print v(xbgr.mr_n74178256)
print v(xbgr.mr_n74178688)
print v(xbgr.mr_n74179120)
print v(xbgr.mr_n74179552)
print v(xbgr.mr_n74179984)
print v(xbgr.mr_n74180416)
print v(xbgr.mr_n74180848)
print v(xbgr.mr_n74181280)
print v(xbgr.mr_n74181712)
print v(xbgr.mr_n74182144)
print v(xbgr.mr_n74182576)
print v(xbgr.mr_n74183008)
print v(xbgr.mr_n74183440)
print v(xbgr.mr_n74183872)
print v(xbgr.mr_n74184304)
print v(xbgr.mr_n74184736)
print v(xbgr.mr_n74185168)
print v(xbgr.mr_n74185600)
print v(xbgr.mr_n74186032)
print v(xbgr.mr_n74186464)
print v(xbgr.mr_n74186896)
print v(xbgr.mr_n74187328)
print v(xbgr.mr_n74187760)
print v(xbgr.mr_n74188192)
print v(xbgr.mr_n74188624)
print v(xbgr.mr_n74189056)
print v(xbgr.mr_n74189488)
print v(xbgr.mr_n74189920)
print v(xbgr.mr_n74190352)
print v(xbgr.mr_n74190784)
print v(xbgr.mr_n74191216)
print v(xbgr.mr_n74191536)
print v(xbgr.mr_n74191648)
print v(xbgr.mr_n74191968)
print v(xbgr.mr_n74192080)
print v(xbgr.mr_n74192512)
print v(xbgr.mr_n74192832)
print v(xbgr.mr_n74192944)
print v(xbgr.mr_n74193264)
print v(xbgr.mr_n74193376)
print v(xbgr.mr_n74193696)
print v(xbgr.mr_n74193808)
print v(xbgr.mr_n74194128)
print v(xbgr.mr_n74194240)
print v(xbgr.mr_n74194560)
print v(xbgr.mr_n74194672)
print v(xbgr.mr_n74194992)
print v(xbgr.mr_n74195104)
print v(xbgr.mr_n74195424)
print v(xbgr.mr_n74195536)
print v(xbgr.mr_n74195856)
print v(xbgr.mr_n74195968)
print v(xbgr.mr_n74196400)
print v(xbgr.mr_n74196832)
print v(xbgr.mr_n74197264)
print v(xbgr.mr_n74197696)
print v(xbgr.mr_n74198128)
print v(xbgr.mr_n74198560)
print v(xbgr.mr_n74198992)
print v(xbgr.mr_n74199424)
print v(xbgr.mr_n74199856)
print v(xbgr.mr_n74200176)
print v(xbgr.mr_n74200288)
print v(xbgr.mr_n74200608)
print v(xbgr.mr_n74200720)
print v(xbgr.mr_n74201040)
print v(xbgr.mr_n74201152)
print v(xbgr.mr_n74201472)
print v(xbgr.mr_n74201584)
print v(xbgr.mr_n74202016)
print v(xbgr.mr_n74202448)
print v(xbgr.mr_n74202880)
print v(xbgr.mr_n74203312)
print v(xbgr.mr_n74203744)
print v(xbgr.mr_n74204176)
print v(xbgr.mr_n74204608)
print v(xbgr.mr_n74205040)
print v(xbgr.mr_n74205472)
print v(xbgr.mr_n74205904)
print v(xbgr.mr_n74206336)
print v(xbgr.mr_n74206768)
print v(xbgr.mr_n74207200)
print v(xbgr.mr_n74207632)
print v(xbgr.mr_n74208064)
print v(xbgr.mr_n74208496)
print v(xbgr.mr_n74208928)
print v(xbgr.mr_n74209360)
print v(xbgr.mr_n74209792)
print v(xbgr.mr_n74210224)
print v(xbgr.mr_n74210656)
print v(xbgr.mr_n74211088)
print v(xbgr.mr_n74211520)
print v(xbgr.mr_n74211952)
print v(xbgr.mr_n74212384)
print v(xbgr.mr_n74212816)
print v(xbgr.mr_n74213248)
print v(xbgr.mr_n74213680)
print v(xbgr.mr_n74214112)
print v(xbgr.mr_n74214432)
print v(xbgr.mr_n74214544)
print v(xbgr.mr_n74214864)
print v(xbgr.mr_n74214976)
print v(xbgr.mr_n74215296)
print v(xbgr.mr_n74215408)
print v(xbgr.mr_n74215728)
print v(xbgr.mr_n74215840)
print v(xbgr.mr_n74216160)
print v(xbgr.mr_n74216272)
print v(xbgr.mr_n74216592)
print v(xbgr.mr_n74216704)
print v(xbgr.mr_n74479184)
print v(xbgr.mr_n74479968)
print v(xbgr.mr_n74480832)
print v(xbgr.mr_n74480944)
print v(xbgr.mr_n74481264)
print v(xbgr.mr_n74481696)
print v(xbgr.mr_n74482128)
print v(xbgr.mr_n74482560)
print v(xbgr.mr_n74482672)
print v(xbgr.mr_n74482992)
print v(xbgr.mr_n74483424)
print v(xbgr.mr_n74483856)
print v(xbgr.mr_n74484288)
print v(xbgr.mr_n74484400)
print v(xbgr.mr_n74484720)
print v(xbgr.mr_n74484832)
print v(xbgr.mr_n74485152)
print v(xbgr.mr_n74485264)
print v(xbgr.mr_n74485696)
print v(xbgr.mr_n74486128)
print v(xbgr.mr_n74486560)
print v(xbgr.mr_n74486880)
print v(xbgr.mr_n74487744)
print v(xbgr.mr_n74487856)
print v(xbgr.mr_n74488176)
print v(xbgr.mr_n74488288)
print v(xbgr.mr_n74488608)
print v(xbgr.mr_n74489584)
print v(xbgr.mr_n74490016)
print v(xbgr.mr_n74490336)
print v(xbgr.mr_n74491200)
print v(xbgr.mr_n74491312)
print v(xbgr.mr_n74491632)
print v(xbgr.mr_n74491744)
print v(xbgr.mr_n74492064)
print v(xbgr.mr_n74492176)
print v(xbgr.mr_n74494672)
print v(xbgr.mr_n74495104)
print v(xbgr.mr_n74495424)
print v(xbgr.mr_n74496400)
print v(xbgr.mr_n74496720)
print v(xbgr.mr_n74497696)
print v(xbgr.mr_n74498016)
print v(xbgr.mr_n74498992)
print v(xbgr.mr_n74499312)
print v(xbgr.mr_n74499424)
print v(xbgr.mr_n74499856)
print v(xbgr.mr_n74500288)
print v(xbgr.mr_n74500608)
print v(xbgr.mr_n74501584)
print v(xbgr.mr_n74501904)
print v(xbgr.mr_n74502880)
print v(xbgr.mr_n74503200)
print v(xbgr.mr_n74504176)
print v(xbgr.mr_n74504608)
print v(xbgr.mr_n74505040)
print v(xbgr.mr_n74505472)
print v(xbgr.mr_n74505904)
print v(xbgr.mr_n74506336)
print v(xbgr.mr_n74506768)
print v(xbgr.mr_n74507200)
print v(xbgr.mr_n74507632)
print v(xbgr.mr_n74508064)
print v(xbgr.mr_n74508496)
print v(xbgr.mr_n74508928)
print v(xbgr.mr_n74509360)
print v(xbgr.mr_n74509792)
print v(xbgr.mr_n74510224)
print v(xbgr.mr_n74510656)
print v(xbgr.mr_n74511088)
print v(xbgr.mr_n74511520)
print v(xbgr.mr_n74511952)
print v(xbgr.mr_n74512384)
print v(xbgr.mr_n74512816)
print v(xbgr.mr_n74513248)
print v(xbgr.mr_n74513680)
print v(xbgr.mr_n74514112)
print v(xbgr.mr_n74514544)
print v(xbgr.mr_n74573984)
print v(xbgr.mr_n74576992)
print v(xbgr.mr_n74577680)
print v(xbgr.mr_n74577888)
print v(xbgr.mr_n74578576)
print v(xbgr.mr_n74579680)
print v(xbgr.mr_n74579856)
print v(xbgr.mr_n74583904)
print v(xbgr.mr_n74584720)
print v(xbgr.mr_n74585856)
print v(xbgr.mr_n74588432)
print v(xbgr.mr_n74590688)
print v(xbgr.mr_n74591696)
print v(xbgr.mr_n74592624)
print v(xbgr.mr_n74593360)
print v(xbgr.mr_n74596016)
print v(xbgr.mr_n74596960)
print v(xbgr.mr_n74597856)
print v(xbgr.mr_n74599824)
print v(xbgr.mr_n74600272)
print v(xbgr.mr_n74600656)
print v(xbgr.mr_n74601552)
print v(xbgr.mr_n74603344)
print v(xbgr.mr_n74603856)
print v(xbgr.mr_n74604320)
print v(xbgr.mr_n74605648)
print v(xbgr.mr_n74607376)
print v(xbgr.mr_n74607888)
print v(xbgr.mr_n74608784)
print v(xbgr.mr_n74610128)
print v(xbgr.mr_n74610752)
print v(xbgr.mr_n74612784)
print v(xbgr.mr_n74613264)
print v(xbgr.mr_n74614544)
print v(xbgr.mr_n74616016)
print v(xbgr.mr_n74616336)
print v(xbgr.mr_n74709632)
print v(xbgr.mr_n74722736)
print v(xbgr.mr_n74725504)
print v(xbgr.mr_n74729600)
print v(xbgr.mr_n74733888)
print v(xbgr.mr_n74739200)
print v(xbgr.mr_n74756096)
print v(xbgr.mr_n74756352)
print v(xbgr.mr_n74756608)
print v(xbgr.mr_n74760880)
print v(xbgr.mr_n74830432)
print v(xbgr.mr_n74833360)
print v(xbgr.mr_n74836704)
print v(xbgr.mr_n74839184)
print v(xbgr.mr_n74839840)
print v(xbgr.mr_n74841184)
print v(xbgr.mr_n74842528)
print v(xbgr.mr_n74842768)
print v(xbgr.mr_n74844112)
print v(xbgr.mr_n74844384)
print v(xbgr.mr_n74845456)
print v(xbgr.mr_n74845904)
print v(xbgr.mr_n74846800)
print v(xbgr.mr_n74847696)
print v(xbgr.mr_n74848144)
print v(xbgr.mr_n74848480)
print v(xbgr.mr_n74850384)
print v(xbgr.mr_n74851488)
print v(xbgr.mr_n74852800)
print v(xbgr.mr_n74854592)
print v(xbgr.mr_n74855936)
print v(xbgr.mr_n74857824)
print v(xbgr.mr_n74861232)
print v(xbgr.mr_n74861520)
print v(xbgr.mr_n74861792)
print v(xbgr.mr_n74874880)
print v(xbgr.mr_n74876672)
print v(xbgr.mr_n74876816)
print v(xbgr.mr_n74877168)
print v(xbgr.mr_n74877568)
print v(xbgr.mr_n74877760)
print v(xbgr.mr_n74882720)
print v(xbgr.mr_n74887552)
print v(xbgr.mr_n74887984)
print v(xbgr.mr_n74889936)
print v(xbgr.mr_n74929904)
print v(xbgr.mr_n74930800)
print v(xbgr.mr_n74931152)
print v(xbgr.mr_n74931504)
print v(xbgr.mr_n74931680)
print v(xbgr.mr_n74932032)
print v(xbgr.mr_n74932208)
print v(xbgr.mr_n74932384)
print v(xbgr.mr_n74934496)
print v(xbgr.mr_n74936064)
print v(xbgr.mr_n74936960)
print v(xbgr.mr_n74937408)
print v(xbgr.mr_n74937616)
print v(xbgr.mr_n74938752)
print v(xbgr.mr_n74939568)
print v(xbgr.mr_n74940448)
print v(xbgr.mr_n74940592)
print v(xbgr.mr_n74941376)
print v(xbgr.mr_n74946752)
print v(xbgr.mr_n74948144)
print v(xbgr.mr_n74953696)
print v(xbgr.mr_n74954464)
print v(xbgr.mr_n74956240)
print v(xbgr.mr_n75013056)
print v(xbgr.mr_n75017920)
print v(xbgr.mr_n75022752)
print v(xbgr.mr_n75024048)
print v(xbgr.mr_n75025632)
print v(xbgr.mr_n75152096)
print v(xbgr.mr_n75199088)
print v(xbgr.mr_n75288896)
print v(xbgr.mr_n75289184)
print v(xbgr.mr_n75290432)
print v(xbgr.mr_n75291072)
print v(xbgr.mr_n75344480)
print v(xbgr.mr_n75345648)
print v(xbgr.mr_n75348064)
print v(xbgr.mr_n75351584)
print v(xbgr.mr_n75358688)
print v(xbgr.mr_n75359728)
print v(xbgr.mr_n75361760)
print v(xbgr.mr_n75384928)
print v(xbgr.mr_n75393056)
print v(xbgr.mr_n75393712)
print v(xbgr.mr_n75395888)
print v(xbgr.mr_n75396384)
print v(xbgr.mr_n75396896)
print v(xbgr.mr_n75399984)
print v(xbgr.mr_n75401392)
print v(xbgr.mr_n75410016)
print v(xbgr.mr_n75419792)
print v(xbgr.mr_n75420944)
print v(xbgr.mr_n75421520)
print v(xbgr.mr_n75424720)
print v(xbgr.mr_n75425632)
print v(xbgr.mr_n75426064)
print v(xbgr.mr_n75426256)
print v(xbgr.mr_n75428752)
print v(xbgr.mr_n75433232)
print v(xbgr.mr_n75434080)
print v(xbgr.mr_n75434256)
print v(xbgr.mr_n75434976)
print v(xbgr.mr_n75437856)
print v(xbgr.mr_n75437968)
print v(xbgr.mr_n75438080)
print v(xbgr.mr_n75438192)
print v(xbgr.mr_n75438496)
print v(xbgr.mr_n75438768)
print v(xbgr.mr_n75439040)
print v(xbgr.mr_n75441152)
print v(xbgr.mr_n75441616)
print v(xbgr.mr_n75442080)
print v(xbgr.mr_n75442544)
print v(xbgr.mr_n75443008)
print v(xbgr.mr_n75443472)
print v(xbgr.mr_n75443936)
print v(xbgr.mr_n75444400)
print v(xbgr.mr_n75444864)
print v(xbgr.mr_n75445328)
print v(xbgr.mr_n75445792)
print v(xbgr.mr_n75451920)
print v(xbgr.mr_n75452992)
print v(xbgr.mr_n75454880)
print v(xbgr.mr_n75456032)
print v(xbgr.mr_n75457184)
print v(xbgr.mr_n75458464)
print v(xbgr.mr_n75459248)
print v(xbgr.mr_n75460288)
print v(xbgr.mr_n75460784)
print v(xbgr.mr_n75461568)
print v(xbgr.mr_n75462720)
print v(xbgr.mr_n75463760)
print v(xbgr.mr_n75464368)
print v(xbgr.mr_n75466368)
print v(xbgr.mr_n75467664)
print v(xbgr.mr_n75468080)
print v(xbgr.mr_n75469680)
print v(xbgr.mr_n75472000)
print v(xbgr.mr_n75472496)
print v(xbgr.mr_n75473648)
print v(xbgr.mr_n75474112)
print v(xbgr.mr_n75474608)
print v(xbgr.mr_n75476720)
print v(xbgr.mr_n75476928)
print v(xbgr.mr_n75479104)
print v(xbgr.mr_n75479632)
print v(xbgr.mr_n75479744)
print v(xbgr.mr_n75481216)
print v(xbgr.mr_n75483760)
print v(xbgr.mr_n75483968)
print v(xbgr.mr_n75484288)
print v(xbgr.mr_n75484672)
print v(xbgr.mr_n75490096)
print v(xbgr.mr_n75491504)
print v(xbgr.mr_n75491712)
print v(xbgr.mr_n75492096)
print v(xbgr.mr_n75492208)
print v(xbgr.mr_n75494592)
print v(xbgr.mr_n75495024)
print v(xbgr.mr_n75495232)
print v(xbgr.mr_n75495728)
print v(xbgr.mr_n75498752)
print v(xbgr.mr_n75499456)
print v(xbgr.mr_n75501360)
print v(xbgr.mr_n75502800)
print v(xbgr.mr_n75503680)
print v(xbgr.mr_n75504448)
print v(xbgr.mr_n75506320)
print v(xbgr.mr_n75507696)
print v(xbgr.mr_n75508400)
print v(xbgr.mr_n75510512)
print v(xbgr.mr_n75510784)
print v(xbgr.mr_n75512624)
print v(xbgr.mr_n75512896)
print v(xbgr.mr_n75518256)
print v(xbgr.mr_n75520368)
print v(xbgr.mr_n75520960)
print v(xbgr.mr_n75521152)
print v(xbgr.mr_n75522672)
print v(xbgr.mr_n75522880)
print v(xbgr.mr_n75523232)
print v(xbgr.mr_n75526064)
print v(xbgr.mr_n75526176)
print v(xbgr.mr_n75527936)
print v(xbgr.mr_n75528400)
print v(xbgr.mr_n75528864)
print v(xbgr.mr_n75529136)
print v(xbgr.mr_n75529328)
print v(xbgr.mr_n75529792)
print v(xbgr.mr_n75530256)
print v(xbgr.mr_n75530720)
print v(xbgr.mr_n75531184)
print v(xbgr.mr_n75531648)
print v(xbgr.mr_n75532112)
print v(xbgr.mr_n75532576)
print v(xbgr.mr_n75533136)
print v(xbgr.mr_n75534656)
print v(xbgr.mr_n75535808)
print v(xbgr.mr_n75536720)
print v(xbgr.mr_n75537824)
print v(xbgr.mr_n75537936)
print v(xbgr.mr_n75538912)
print v(xbgr.mr_n75540400)
print v(xbgr.mr_n75540864)
print v(xbgr.mr_n75541344)
print v(xbgr.mr_n75545536)
print v(xbgr.mr_n75547056)
print v(xbgr.mr_n75549184)
print v(xbgr.mr_n75549424)
print v(xbgr.mr_n75549856)
print v(xbgr.mr_n75550400)
print v(xbgr.mr_n75551792)
print v(xbgr.mr_n75553744)
print v(xbgr.mr_n75555984)
print v(xbgr.mr_n75557152)
print v(xbgr.mr_n75557392)
print v(xbgr.mr_n75558608)
print v(xbgr.mr_n75561712)
print v(xbgr.mr_n75562624)
print v(xbgr.mr_n75563472)
print v(xbgr.mr_n75566944)
print v(xbgr.mr_n75568768)
print v(xbgr.mr_n75569776)
print v(xbgr.mr_n75570016)
print v(xbgr.mr_n75571024)
print v(xbgr.mr_n75576768)
print v(xbgr.mr_n75576960)
print v(xbgr.mr_n75577536)
print v(xbgr.mr_n75579072)
print v(xbgr.mr_n75579536)
print v(xbgr.mr_n75580000)
print v(xbgr.mr_n75580464)
print v(xbgr.mr_n75580928)
print v(xbgr.mr_n75581392)
print v(xbgr.mr_n75581856)
print v(xbgr.mr_n75582320)
print v(xbgr.mr_n75582784)
print v(xbgr.mr_n75583248)
print v(xbgr.mr_n75583712)
print v(xbgr.mr_n75584176)
print v(xbgr.mr_n75584640)
print v(xbgr.mr_n75585104)
print v(xbgr.mr_n75585568)
print v(xbgr.mr_n75586032)
print v(xbgr.mr_n75586496)
print v(xbgr.mr_n75586960)
print v(xbgr.mr_n75587424)
print v(xbgr.mr_n75587888)
print v(xbgr.mr_n75588352)
print v(xbgr.mr_n75588816)
print v(xbgr.mr_n75589280)
print v(xbgr.mr_n75589744)
print v(xbgr.mr_n75590208)
print v(xbgr.mr_n75590672)
print v(xbgr.mr_n75591136)
print v(xbgr.mr_n75591600)
print v(xbgr.mr_n75592064)
print v(xbgr.mr_n75592528)
print v(xbgr.mr_n75592992)
print v(xbgr.mr_n75593456)
print v(xbgr.mr_n75593920)
print v(xbgr.mr_n75594384)
print v(xbgr.mr_n75594848)
print v(xbgr.mr_n75595312)
print v(xbgr.mr_n75595776)
print v(xbgr.mr_n75596240)
print v(xbgr.mr_n75596704)
print v(xbgr.mr_n75597168)
print v(xbgr.mr_n75597632)
print v(xbgr.mr_n75598096)
print v(xbgr.mr_n75598560)
print v(xbgr.mr_n75599008)
print v(xbgr.mr_n75599472)
print v(xbgr.mr_n75599872)
print v(xbgr.mr_n75600272)
print v(xbgr.mr_n75600736)
print v(xbgr.mr_n75601200)
print v(xbgr.mr_n75601664)
print v(xbgr.mr_n75602128)
print v(xbgr.mr_n75602592)
print v(xbgr.mr_n75603056)
print v(xbgr.mr_n75603520)
print v(xbgr.mr_n75603984)
print v(xbgr.mr_n75604448)
print v(xbgr.mr_n75604912)
print v(xbgr.mr_n75605376)
print v(xbgr.mr_n75605840)
print v(xbgr.mr_n75606304)
print v(xbgr.mr_n75606768)
print v(xbgr.mr_n75607232)
print v(xbgr.mr_n75607696)
print v(xbgr.mr_n75608160)
print v(xbgr.mr_n75608512)
print v(xbgr.mr_n75608624)
print v(xbgr.mr_n75609088)
print v(xbgr.mr_n75609552)
print v(xbgr.mr_n75610016)
print v(xbgr.mr_n75610480)
print v(xbgr.mr_n75610944)
print v(xbgr.mr_n75611408)
print v(xbgr.mr_n75611872)
print v(xbgr.mr_n75612336)
print v(xbgr.mr_n75612800)
print v(xbgr.mr_n75613264)
print v(xbgr.mr_n75613728)
print v(xbgr.mr_n75614192)
print v(xbgr.mr_n75614656)
print v(xbgr.mr_n75615120)
print v(xbgr.mr_n75615392)
print v(xbgr.mr_n75615584)
print v(xbgr.mr_n75616048)
print v(xbgr.mr_n75616512)
print v(xbgr.mr_n75616976)
print v(xbgr.mr_n75617440)
print v(xbgr.mr_n75617904)
print v(xbgr.mr_n75618368)
print v(xbgr.mr_n75618832)
print v(xbgr.mr_n75619296)
print v(xbgr.mr_n75619760)
print v(xbgr.mr_n75620224)
print v(xbgr.mr_n75620688)
print v(xbgr.mr_n75621152)
print v(xbgr.mr_n75621616)
print v(xbgr.mr_n75622080)
print v(xbgr.mr_n75622544)
print v(xbgr.mr_n75623008)
print v(xbgr.mr_n75623472)
print v(xbgr.mr_n75623936)
print v(xbgr.mr_n75624400)
print v(xbgr.mr_n75624864)
print v(xbgr.mr_n75625328)
print v(xbgr.mr_n75625792)
print v(xbgr.mr_n75626256)
print v(xbgr.mr_n75626720)
print v(xbgr.mr_n75626992)
print v(xbgr.mr_n75627184)
print v(xbgr.mr_n75627648)
print v(xbgr.mr_n75628112)
print v(xbgr.mr_n75628576)
print v(xbgr.mr_n75629040)
print v(xbgr.mr_n75629504)
print v(xbgr.mr_n75629968)
print v(xbgr.mr_n75630432)
print v(xbgr.mr_n75630896)
print v(xbgr.mr_n75631360)
print v(xbgr.mr_n75631824)
print v(xbgr.mr_n75632288)
print v(xbgr.mr_n75632752)
print v(xbgr.mr_n75633216)
print v(xbgr.mr_n75633680)
print v(xbgr.mr_n75634144)
print v(xbgr.mr_n75634256)
print v(xbgr.mr_n75634880)
print v(xbgr.mr_n75634992)
print v(xbgr.mr_n75635616)
print v(xbgr.mr_n75635840)
print v(xbgr.mr_n75636352)
print v(xbgr.mr_n75636576)
print v(xbgr.mr_n75637088)
print v(xbgr.mr_n75637200)
print v(xbgr.mr_n75637312)
print v(xbgr.mr_n75637824)
print v(xbgr.mr_n75637936)
print v(xbgr.mr_n75638048)
print v(xbgr.mr_n75638560)
print v(xbgr.mr_n75638672)
print v(xbgr.mr_n75638784)
print v(xbgr.mr_n75639296)
print v(xbgr.mr_n75639568)
print v(xbgr.mr_n75639840)
print v(xbgr.mr_n75640112)
print v(xbgr.mr_n75640224)
print v(xbgr.mr_n75640336)
print v(xbgr.mr_n75640848)
print v(xbgr.mr_n75641120)
print v(xbgr.mr_n75641392)
print v(xbgr.mr_n75641664)
print v(xbgr.mr_n75641936)
print v(xbgr.mr_n75642480)
print v(xbgr.mr_n75642752)
print v(xbgr.mr_n75643024)
print v(xbgr.mr_n75643296)
print v(xbgr.mr_n75643568)
print v(xbgr.mr_n75643840)
print v(xbgr.mr_n75644112)
print v(xbgr.mr_n75644384)
print v(xbgr.mr_n75644656)
print v(xbgr.mr_n75644928)
print v(xbgr.mr_n75645200)
print v(xbgr.mr_n75645472)
print v(xbgr.mr_n75645744)
print v(xbgr.mr_n75646016)
print v(xbgr.mr_n75646288)
print v(xbgr.mr_n75646560)
print v(xbgr.mr_n75646832)
print v(xbgr.mr_n75647104)
print v(xbgr.mr_n75647376)
print v(xbgr.mr_n75647648)
print v(xbgr.mr_n75648112)
print v(xbgr.mr_n75648576)
print v(xbgr.mr_n75649040)
print v(xbgr.mr_n75649440)
print v(xbgr.mr_n75649968)
print v(xbgr.mr_n75650368)
print v(xbgr.mr_n75650896)
print v(xbgr.mr_n75651360)
print v(xbgr.mr_n75651824)
print v(xbgr.mr_n75652160)
print v(xbgr.mr_n75652288)
print v(xbgr.mr_n75652752)
print v(xbgr.mr_n75655264)
print v(xbgr.mr_n75656416)
print v(xbgr.mr_n75657376)
print v(xbgr.mr_n75658096)
print v(xbgr.mr_n75658624)
print v(xbgr.mr_n75663648)
print v(xbgr.mr_n75665504)
print v(xbgr.mr_n75666608)
print v(xbgr.mr_n75669936)
print v(xbgr.mr_n75670336)
print v(xbgr.mr_n75670864)
print v(xbgr.mr_n75671360)
print v(xbgr.mr_n75671952)
print v(xbgr.mr_n75672544)
print v(xbgr.mr_n75673136)
print v(xbgr.mr_n75673472)
print v(xbgr.mr_n75673728)
print v(xbgr.mr_n75674320)
print v(xbgr.mr_n75674912)
print v(xbgr.mr_n75675504)
print v(xbgr.mr_n75676096)
print v(xbgr.mr_n75676688)
print v(xbgr.mr_n75677216)
print v(xbgr.mr_n75677872)
print v(xbgr.mr_n75678464)
print v(xbgr.mr_n75678800)
print v(xbgr.mr_n75679056)
print v(xbgr.mr_n75679648)
print v(xbgr.mr_n75680240)
print v(xbgr.mr_n75680832)
print v(xbgr.mr_n75681424)
print v(xbgr.mr_n75681952)
print v(xbgr.mr_n75682608)
print v(xbgr.mr_n75683792)
print v(xbgr.mr_n75684384)
print v(xbgr.mr_n75684976)
print v(xbgr.mr_n75685568)
print v(xbgr.mr_n75688208)
print v(xbgr.mr_n75689888)
print v(xbgr.mr_n75690496)
print v(xbgr.mr_n75696000)
print v(xbgr.mr_n75701520)
print v(xbgr.mr_n75703520)
print v(xbgr.mr_n75703872)
print v(xbgr.mr_n75705696)
print v(xbgr.mr_n75707520)
print v(xbgr.mr_n75710624)
print v(xbgr.mr_n75713120)
print v(xbgr.mr_n75713376)
print v(xbgr.mr_n75716848)
print v(xbgr.mr_n75719216)
print v(xbgr.mr_n75721696)
print v(xbgr.mr_n75722720)
print v(xbgr.mr_n75725232)
print v(xbgr.mr_n75726624)
print v(xbgr.mr_n75727728)
print v(xbgr.mr_n75729440)
print v(xbgr.mr_n75730272)
print v(xbgr.mr_n75731712)
print v(xbgr.mr_n75732864)
print v(xbgr.mr_n75734576)
print v(xbgr.mr_n75735184)
print v(xbgr.mr_n75735296)
print v(xbgr.mr_n75735904)
print v(xbgr.mr_n75736016)
print v(xbgr.mr_n75736624)
print v(xbgr.mr_n75736736)
print v(xbgr.mr_n75737344)
print v(xbgr.mr_n75738064)
print v(xbgr.mr_n75738176)
print v(xbgr.mr_n75738784)
print v(xbgr.mr_n75739504)
print v(xbgr.mr_n75740640)
print v(xbgr.mr_n75745088)
print v(xbgr.mr_n75747520)
print v(xbgr.mr_n75748128)
print v(xbgr.mr_n75750928)
print v(xbgr.mr_n75751536)
print v(xbgr.mr_n75752496)
print v(xbgr.mr_n75753296)
print v(xbgr.mr_n75755792)
print v(xbgr.mr_n75757616)
print v(xbgr.mr_n75759440)
print v(xbgr.mr_n75760048)
print v(xbgr.mr_n75761264)
print v(xbgr.mr_n75761872)
print v(xbgr.mr_n75763392)
print v(xbgr.mr_n75765520)
print v(xbgr.mr_n75765760)
print v(xbgr.mr_n75768592)
print v(xbgr.mr_n75770928)
print v(xbgr.mr_n75774464)
print v(xbgr.mr_n75774640)
print v(xbgr.mr_n75775376)
print v(xbgr.mr_n75775648)
print v(xbgr.mr_n75777968)
print v(xbgr.mr_n75778432)
print v(xbgr.mr_n75780448)
print v(xbgr.mr_n75780624)
print v(xbgr.mr_n75781248)
print v(xbgr.mr_n75783648)
print v(xbgr.mr_n75784272)
print v(xbgr.mr_n75784720)
print v(xbgr.mr_n75785248)
print v(xbgr.mr_n75786608)
print v(xbgr.mr_n75786800)
print v(xbgr.mr_n75788928)
print v(xbgr.mr_n75791104)
print v(xbgr.mr_n75791280)
print v(xbgr.mr_n75791456)
print v(xbgr.mr_n75793760)
print v(xbgr.mr_n75794352)
print v(xbgr.mr_n75794880)
print v(xbgr.mr_n75795456)
print v(xbgr.mr_n75796128)
print v(xbgr.mr_n75796720)
print v(xbgr.mr_n75797312)
print v(xbgr.mr_n75797904)
print v(xbgr.mr_n75798432)
print v(xbgr.mr_n75799008)
print v(xbgr.mr_n75799680)
print v(xbgr.mr_n75800272)
print v(xbgr.mr_n75800864)
print v(xbgr.mr_n75801456)
print v(xbgr.mr_n75802048)
print v(xbgr.mr_n75802640)
print v(xbgr.mr_n75803232)
print v(xbgr.mr_n75803744)
print v(xbgr.mr_n75804416)
print v(xbgr.mr_n75805008)
print v(xbgr.mr_n75805344)
print v(xbgr.mr_n75805600)
print v(xbgr.mr_n75806192)
print v(xbgr.mr_n75806720)
print v(xbgr.mr_n75807296)
print v(xbgr.mr_n75807888)
print v(xbgr.mr_n75808560)
print v(xbgr.mr_n75809152)
print v(xbgr.mr_n75809744)
print v(xbgr.mr_n75810336)
print v(xbgr.mr_n75810928)
print v(xbgr.mr_n75811456)
print v(xbgr.mr_n75812112)
print v(xbgr.mr_n75812704)
print v(xbgr.mr_n75813296)
print v(xbgr.mr_n75813888)
print v(xbgr.mr_n75815072)
print v(xbgr.mr_n75815584)
print v(xbgr.mr_n75816176)
print v(xbgr.mr_n75816848)
print v(xbgr.mr_n75817440)
print v(xbgr.mr_n75818032)
print v(xbgr.mr_n75818624)
print v(xbgr.mr_n75819216)
print v(xbgr.mr_n75819808)
print v(xbgr.mr_n75820400)
print v(xbgr.mr_n75821120)
print v(xbgr.mr_n75821472)
print v(xbgr.mr_n75822112)
print v(xbgr.mr_n75823088)
print v(xbgr.mr_n75823872)
print v(xbgr.mr_n75824464)
print v(xbgr.mr_n75824992)
print v(xbgr.mr_n75825648)
print v(xbgr.mr_n75826176)
print v(xbgr.mr_n75826832)
print v(xbgr.mr_n75827344)
print v(xbgr.mr_n75828000)
print v(xbgr.mr_n75828592)
print v(xbgr.mr_n75829184)
print v(xbgr.mr_n75829776)
print v(xbgr.mr_n75830336)
print v(xbgr.mr_n75830928)
print v(xbgr.mr_n75831520)
print v(xbgr.mr_n75832032)
print v(xbgr.mr_n75832704)
print v(xbgr.mr_n75833296)
print v(xbgr.mr_n75833888)
print v(xbgr.mr_n75834480)
print v(xbgr.mr_n75835072)
print v(xbgr.mr_n75835664)
print v(xbgr.mr_n75836256)
print v(xbgr.mr_n75836784)
print v(xbgr.mr_n75837440)
print v(xbgr.mr_n75837952)
print v(xbgr.mr_n75838448)
print v(xbgr.mr_n75838624)
print v(xbgr.mr_n75839216)
print v(xbgr.mr_n75839808)
print v(xbgr.mr_n75840400)
print v(xbgr.mr_n75840992)
print v(xbgr.mr_n75841504)
print v(xbgr.mr_n75842176)
print v(xbgr.mr_n75842768)
print v(xbgr.mr_n75843360)
print v(xbgr.mr_n75843872)
print v(xbgr.mr_n75844544)
print v(xbgr.mr_n75845136)
print v(xbgr.mr_n75845552)
print v(xbgr.mr_n75845728)
print v(xbgr.mr_n75846320)
print v(xbgr.mr_n75846912)
print v(xbgr.mr_n75847328)
print v(xbgr.mr_n75847504)
print v(xbgr.mr_n75848096)
print v(xbgr.mr_n75848688)
print v(xbgr.mr_n75849280)
print v(xbgr.mr_n75849872)
print v(xbgr.mr_n75850464)
print v(xbgr.mr_n75851056)
print v(xbgr.mr_n75851472)
print v(xbgr.mr_n75851648)
print v(xbgr.mr_n75852176)
print v(xbgr.mr_n75852832)
print v(xbgr.mr_n75853424)
print v(xbgr.mr_n75854016)
print v(xbgr.mr_n75854608)
print v(xbgr.mr_n75855200)
print v(xbgr.mr_n75855712)
print v(xbgr.mr_n75856384)
print v(xbgr.mr_n75856976)
print v(xbgr.mr_n75857568)
print v(xbgr.mr_n75858096)
print v(xbgr.mr_n75858496)
print v(xbgr.mr_n75858752)
print v(xbgr.mr_n75859344)
print v(xbgr.mr_n75859936)
print v(xbgr.mr_n75860528)
print v(xbgr.mr_n75861120)
print v(xbgr.mr_n75861648)
print v(xbgr.mr_n75862304)
print v(xbgr.mr_n75862896)
print v(xbgr.mr_n75863488)
print v(xbgr.mr_n75864080)
print v(xbgr.mr_n75864672)
print v(xbgr.mr_n75865264)
print v(xbgr.mr_n75865856)
print v(xbgr.mr_n75866384)
print v(xbgr.mr_n75867040)
print v(xbgr.mr_n75867568)
print v(xbgr.mr_n75868224)
print v(xbgr.mr_n75868752)
print v(xbgr.mr_n75869408)
print v(xbgr.mr_n75870000)
print v(xbgr.mr_n75870592)
print v(xbgr.mr_n75871184)
print v(xbgr.mr_n75871776)
print v(xbgr.mr_n75872608)
print v(xbgr.mr_n75873008)
print v(xbgr.mr_n75873408)
print v(xbgr.mr_n75874208)
print v(xbgr.mr_n75875008)
print v(xbgr.mr_n75875408)
print v(xbgr.mr_n75875808)
print v(xbgr.mr_n75876208)
print v(xbgr.mr_n75876608)
print v(xbgr.mr_n75877664)
print v(xbgr.mr_n75881248)
print v(xbgr.mr_n75881488)
print v(xbgr.mr_n75885984)
print v(xbgr.mr_n75889520)
print v(xbgr.mr_n75890400)
print v(xbgr.mr_n75892496)
print v(xbgr.mr_n75892640)
print v(xbgr.mr_n75904912)
print v(xbgr.mr_n75905280)
print v(xbgr.mr_n75906816)
print v(xbgr.mr_n75907408)
print v(xbgr.mr_n75908000)
print v(xbgr.mr_n75908592)
print v(xbgr.mr_n75909184)
print v(xbgr.mr_n75909776)
print v(xbgr.mr_n75910112)
print v(xbgr.mr_n75910368)
print v(xbgr.mr_n75910960)
print v(xbgr.mr_n75911552)
print v(xbgr.mr_n75912144)
print v(xbgr.mr_n75912736)
print v(xbgr.mr_n75913536)
print v(xbgr.mr_n75916480)
print v(xbgr.mr_n75918848)
print v(xbgr.mr_n75922096)
print v(xbgr.mr_n75923904)
print v(xbgr.mr_n75927728)
print v(xbgr.mr_n75933376)
print v(xbgr.mr_n75947216)
print v(xbgr.mr_n75947360)
print v(xbgr.mr_n75948176)
print v(xbgr.mr_n75948288)
print v(xbgr.mr_n75949264)
print v(xbgr.mr_n75951264)
print v(xbgr.mr_n75952448)
print v(xbgr.mr_n75953040)
print v(xbgr.mr_n75953456)
print v(xbgr.mr_n75953632)
print v(xbgr.mr_n75954224)
print v(xbgr.mr_n75955408)
print v(xbgr.mr_n75955664)
print v(xbgr.mr_n75956000)
print v(xbgr.mr_n75956304)
print v(xbgr.mr_n75956416)
print v(xbgr.mr_n75958000)
print v(xbgr.mr_n75958528)
print v(xbgr.mr_n75959184)
print v(xbgr.mr_n75959776)
print v(xbgr.mr_n75960368)
print v(xbgr.mr_n75961552)
print v(xbgr.mr_n75962144)
print v(xbgr.mr_n75962736)
print v(xbgr.mr_n75963328)
print v(xbgr.mr_n75963920)
print v(xbgr.mr_n75964512)
print v(xbgr.mr_n75965104)
print v(xbgr.mr_n75965696)
print v(xbgr.mr_n75966288)
print v(xbgr.mr_n75966880)
print v(xbgr.mr_n75967472)
print v(xbgr.mr_n75968656)
print v(xbgr.mr_n75969248)
print v(xbgr.mr_n75969840)
print v(xbgr.mr_n75970432)
print v(xbgr.mr_n75971024)
print v(xbgr.mr_n75971616)
print v(xbgr.mr_n75972208)
print v(xbgr.mr_n75972800)
print v(xbgr.mr_n75973392)
print v(xbgr.mr_n75973984)
print v(xbgr.mr_n75974576)
print v(xbgr.mr_n75975760)
print v(xbgr.mr_n75976288)
print v(xbgr.mr_n75976944)
print v(xbgr.mr_n75977536)
print v(xbgr.mr_n75978128)
print v(xbgr.mr_n75978720)
print v(xbgr.mr_n75979312)
print v(xbgr.mr_n75979904)
print v(xbgr.mr_n75980496)
print v(xbgr.mr_n75981088)
print v(xbgr.mr_n75981680)
print v(xbgr.mr_n75982272)
print v(xbgr.mr_n75982864)
print v(xbgr.mr_n75983456)
print v(xbgr.mr_n75984048)
print v(xbgr.mr_n75984640)
print v(xbgr.mr_n75985232)
print v(xbgr.mr_n75985824)
print v(xbgr.mr_n75986416)
print v(xbgr.mr_n75987008)
print v(xbgr.mr_n75987600)
print v(xbgr.mr_n75988192)
print v(xbgr.mr_n75988784)
print v(xbgr.mr_n75989968)
print v(xbgr.mr_n75990560)
print v(xbgr.mr_n75991152)
print v(xbgr.mr_n75991744)
print v(xbgr.mr_n75992336)
print v(xbgr.mr_n75992928)
print v(xbgr.mr_n75993520)
print v(xbgr.mr_n75994112)
print v(xbgr.mr_n75994704)
print v(xbgr.mr_n75995120)
print v(xbgr.mr_n75995296)
print v(xbgr.mr_n75995888)
print v(xbgr.mr_n75996480)
print v(xbgr.mr_n75997072)
print v(xbgr.mr_n75997664)
print v(xbgr.mr_n75998256)
print v(xbgr.mr_n75998848)
print v(xbgr.mr_n75999440)
print v(xbgr.mr_n76000032)
print v(xbgr.mr_n76000624)
print v(xbgr.mr_n76001216)
print v(xbgr.mr_n76001808)
print v(xbgr.mr_n76002400)
print v(xbgr.mr_n76002992)
print v(xbgr.mr_n76003584)
print v(xbgr.mr_n76004176)
print v(xbgr.mr_n76004592)
print v(xbgr.mr_n76004768)
print v(xbgr.mr_n76005360)
print v(xbgr.mr_n76005952)
print v(xbgr.mr_n76006544)
print v(xbgr.mr_n76007136)
print v(xbgr.mr_n76007728)
print v(xbgr.mr_n76008320)
print v(xbgr.mr_n76008912)
print v(xbgr.mr_n76009504)
print v(xbgr.mr_n76010096)
print v(xbgr.mr_n76010688)
print v(xbgr.mr_n76011280)
print v(xbgr.mr_n76011808)
print v(xbgr.mr_n76012464)
print v(xbgr.mr_n76013056)
print v(xbgr.mr_n76013648)
print v(xbgr.mr_n76014240)
print v(xbgr.mr_n76015424)
print v(xbgr.mr_n76016016)
print v(xbgr.mr_n76016432)
print v(xbgr.mr_n76016608)
print v(xbgr.mr_n76017200)
print v(xbgr.mr_n76017792)
print v(xbgr.mr_n76018384)
print v(xbgr.mr_n76018976)
print v(xbgr.mr_n76019568)
print v(xbgr.mr_n76020160)
print v(xbgr.mr_n76020688)
print v(xbgr.mr_n76021152)
print v(xbgr.mr_n76021616)
print v(xbgr.mr_n76021728)
print v(xbgr.mr_n76022080)
print v(xbgr.mr_n76022544)
print v(xbgr.mr_n76022656)
print v(xbgr.mr_n76023008)
print v(xbgr.mr_n76023120)
print v(xbgr.mr_n76024512)
print v(xbgr.mr_n76024768)
print v(xbgr.mr_n76025104)
print v(xbgr.mr_n76025744)
print v(xbgr.mr_n76026144)
print v(xbgr.mr_n76026544)
print v(xbgr.mr_n76026944)
print v(xbgr.mr_n76027344)
print v(xbgr.mr_n76027744)
print v(xbgr.mr_n76028144)
print v(xbgr.mr_n76028544)
print v(xbgr.mr_n76028944)
print v(xbgr.mr_n76029344)
print v(xbgr.mr_n76029744)
print v(xbgr.mr_n76030144)
print v(xbgr.mr_n76030544)
print v(xbgr.mr_n76030944)
print v(xbgr.mr_n76031344)
print v(xbgr.mr_n76031744)
print v(xbgr.mr_n76032144)
print v(xbgr.mr_n76032544)
print v(xbgr.mr_n76032944)
print v(xbgr.mr_n76033344)
print v(xbgr.mr_n76033744)
print v(xbgr.mr_n76034144)
print v(xbgr.mr_n76034544)
print v(xbgr.mr_n76034944)
print v(xbgr.mr_n76035344)
print v(xbgr.mr_n76035744)
print v(xbgr.mr_n76036144)
print v(xbgr.mr_n76036544)
print v(xbgr.mr_n76036944)
print v(xbgr.mr_n76037344)
print v(xbgr.mr_n76037744)
print v(xbgr.mr_n76038144)
print v(xbgr.mr_n76038544)
print v(xbgr.mr_n76038944)
print v(xbgr.mr_n76039344)
print v(xbgr.mr_n76039744)
print v(xbgr.mr_n76040144)
print v(xbgr.mr_n76040800)
print v(xbgr.mr_n76041392)
print v(xbgr.mr_n76041984)
print v(xbgr.mr_n76042576)
print v(xbgr.mr_n76043168)
print v(xbgr.mr_n76043760)
print v(xbgr.mr_n76044352)
print v(xbgr.mr_n76044944)
print v(xbgr.mr_n76045536)
print v(xbgr.mr_n76046128)
print v(xbgr.mr_n76050064)
print v(xbgr.mr_n76061504)
print v(xbgr.mr_n76063184)
print v(xbgr.mr_n76063776)
print v(xbgr.mr_n76064368)
print v(xbgr.mr_n76064960)
print v(xbgr.mr_n76065472)
print v(xbgr.mr_n76066144)
print v(xbgr.mr_n76066736)
print v(xbgr.mr_n76067328)
print v(xbgr.mr_n76067856)
print v(xbgr.mr_n76068512)
print v(xbgr.mr_n76069104)
print v(xbgr.mr_n76069696)
print v(xbgr.mr_n76070288)
print v(xbgr.mr_n76070880)
print v(xbgr.mr_n76071472)
print v(xbgr.mr_n76072064)
print v(xbgr.mr_n76072576)
print v(xbgr.mr_n76073248)
print v(xbgr.mr_n76073840)
print v(xbgr.mr_n76074432)
print v(xbgr.mr_n76074848)
print v(xbgr.mr_n76075024)
print v(xbgr.mr_n76075616)
print v(xbgr.mr_n76076208)
print v(xbgr.mr_n76076720)
print v(xbgr.mr_n76077312)
print v(xbgr.mr_n76077984)
print v(xbgr.mr_n76078576)
print v(xbgr.mr_n76079168)
print v(xbgr.mr_n76079760)
print v(xbgr.mr_n76080272)
print v(xbgr.mr_n76080864)
print v(xbgr.mr_n76081536)
print v(xbgr.mr_n76082128)
print v(xbgr.mr_n76082720)
print v(xbgr.mr_n76083312)
print v(xbgr.mr_n76083904)
print v(xbgr.mr_n76084496)
print v(xbgr.mr_n76085152)
print v(xbgr.mr_n76085600)
print v(xbgr.mr_n76086272)
print v(xbgr.mr_n76086864)
print v(xbgr.mr_n76087456)
print v(xbgr.mr_n76088048)
print v(xbgr.mr_n76088640)
print v(xbgr.mr_n76089232)
print v(xbgr.mr_n76089824)
print v(xbgr.mr_n76090416)
print v(xbgr.mr_n76091296)
print v(xbgr.mr_n76091888)
print v(xbgr.mr_n76095216)
print v(xbgr.mr_n76095328)
print v(xbgr.mr_n76098176)
print v(xbgr.mr_n76099696)
print v(xbgr.mr_n76101408)
print v(xbgr.mr_n76102624)
print v(xbgr.mr_n76103312)
print v(xbgr.mr_n76103856)
print v(xbgr.mr_n76106352)
print v(xbgr.mr_n76106768)
print v(xbgr.mr_n76113376)
print v(xbgr.mr_n76120608)
print v(xbgr.mr_n76123712)
print v(xbgr.mr_n76132304)
print v(xbgr.mr_n76133088)
print v(xbgr.mr_n76133744)
print v(xbgr.mr_n76135616)
print v(xbgr.mr_n76136560)
print v(xbgr.mr_n76136672)
print v(xbgr.mr_n76137280)
print v(xbgr.mr_n76138000)
print v(xbgr.mr_n76138112)
print v(xbgr.mr_n76138720)
print v(xbgr.mr_n76139552)
print v(xbgr.mr_n76140160)
print v(xbgr.mr_n76140464)
print v(xbgr.mr_n76149792)
print v(xbgr.mr_n76151088)
print v(xbgr.mr_n76155200)
print v(xbgr.mr_n76157040)
print v(xbgr.mr_n76177104)
print v(xbgr.mr_n76178208)
print v(xbgr.mr_n76178544)
print v(xbgr.mr_n76179488)
print v(xbgr.mr_n76179632)
print v(xbgr.mr_n76180896)
print v(xbgr.mr_n76181104)
print v(xbgr.mr_n76181648)
print v(xbgr.mr_n76182272)
print v(xbgr.mr_n76182384)
print v(xbgr.mr_n76183376)
print v(xbgr.mr_n76184592)
print v(xbgr.mr_n76185520)
print v(xbgr.mr_n76185984)
print v(xbgr.mr_n76186336)
print v(xbgr.mr_n76186448)
print v(xbgr.mr_n76187504)
print v(xbgr.mr_n76188096)
print v(xbgr.mr_n76188688)
print v(xbgr.mr_n76189280)
print v(xbgr.mr_n76189872)
print v(xbgr.mr_n76190464)
print v(xbgr.mr_n76191056)
print v(xbgr.mr_n76191424)
print v(xbgr.mr_n76191648)
print v(xbgr.mr_n76192240)
print v(xbgr.mr_n76192832)
print v(xbgr.mr_n76193360)
print v(xbgr.mr_n76194016)
print v(xbgr.mr_n76194608)
print v(xbgr.mr_n76195200)
print v(xbgr.mr_n76195792)
print v(xbgr.mr_n76196304)
print v(xbgr.mr_n76196976)
print v(xbgr.mr_n76197568)
print v(xbgr.mr_n76198096)
print v(xbgr.mr_n76198752)
print v(xbgr.mr_n76199344)
print v(xbgr.mr_n76199936)
print v(xbgr.mr_n76200448)
print v(xbgr.mr_n76201120)
print v(xbgr.mr_n76201712)
print v(xbgr.mr_n76202304)
print v(xbgr.mr_n76202896)
print v(xbgr.mr_n76203488)
print v(xbgr.mr_n76204080)
print v(xbgr.mr_n76205264)
print v(xbgr.mr_n76205856)
print v(xbgr.mr_n76206448)
print v(xbgr.mr_n76207040)
print v(xbgr.mr_n76207632)
print v(xbgr.mr_n76208224)
print v(xbgr.mr_n76208816)
print v(xbgr.mr_n76209312)
print v(xbgr.mr_n76209920)
print v(xbgr.mr_n76210576)
print v(xbgr.mr_n76210992)
print v(xbgr.mr_n76211168)
print v(xbgr.mr_n76211760)
print v(xbgr.mr_n76212352)
print v(xbgr.mr_n76212944)
print v(xbgr.mr_n76213536)
print v(xbgr.mr_n76214128)
print v(xbgr.mr_n76214720)
print v(xbgr.mr_n76215312)
print v(xbgr.mr_n76215904)
print v(xbgr.mr_n76216496)
print v(xbgr.mr_n76217088)
print v(xbgr.mr_n76217680)
print v(xbgr.mr_n76218208)
print v(xbgr.mr_n76219456)
print v(xbgr.mr_n76220048)
print v(xbgr.mr_n76220640)
print v(xbgr.mr_n76221232)
print v(xbgr.mr_n76221824)
print v(xbgr.mr_n76222416)
print v(xbgr.mr_n76222944)
print v(xbgr.mr_n76223600)
print v(xbgr.mr_n76224128)
print v(xbgr.mr_n76224784)
print v(xbgr.mr_n76225376)
print v(xbgr.mr_n76225968)
print v(xbgr.mr_n76226496)
print v(xbgr.mr_n76226608)
print v(xbgr.mr_n76227552)
print v(xbgr.mr_n76228256)
print v(xbgr.mr_n76228720)
print v(xbgr.mr_n76229184)
print v(xbgr.mr_n76230224)
print v(xbgr.mr_n76231104)
print v(xbgr.mr_n76231760)
print v(xbgr.mr_n76232416)
print v(xbgr.mr_n76232944)
print v(xbgr.mr_n76233472)
print v(xbgr.mr_n76234128)
print v(xbgr.mr_n76234720)
print v(xbgr.mr_n76235344)
print v(xbgr.mr_n76238816)
print v(xbgr.mr_n76240368)
print v(xbgr.mr_n76240480)
print v(xbgr.mr_n76240592)
print v(xbgr.mr_n76240704)
print v(xbgr.mr_n76240816)
print v(xbgr.mr_n76240928)
print v(xbgr.mr_n76241040)
print v(xbgr.mr_n76241152)
print v(xbgr.mr_n76241344)
print v(xbgr.mr_n76241616)
print v(xbgr.mr_n76241888)
print v(xbgr.mr_n76242160)
print v(xbgr.mr_n76242432)
print v(xbgr.mr_n76242704)
print v(xbgr.mr_n76242976)
print v(xbgr.mr_n76243168)
print v(xbgr.mr_n76243552)
print v(xbgr.mr_n76243952)
print v(xbgr.mr_n76244352)
print v(xbgr.mr_n76244752)
print v(xbgr.mr_n76245152)
print v(xbgr.mr_n76245552)
print v(xbgr.mr_n76245952)
print v(xbgr.mr_n76246352)
print v(xbgr.mr_n76246752)
print v(xbgr.mr_n76247152)
print v(xbgr.mr_n76247472)
print v(xbgr.mr_n76247952)
print v(xbgr.mr_n76248352)
print v(xbgr.mr_n76248752)
print v(xbgr.mr_n76249152)
print v(xbgr.mr_n76249552)
print v(xbgr.mr_n76249952)
print v(xbgr.mr_n76250352)
print v(xbgr.mr_n76250752)
print v(xbgr.mr_n76251072)
print v(xbgr.mr_n76251552)
print v(xbgr.mr_n76251952)
print v(xbgr.mr_n76252352)
print v(xbgr.mr_n76252672)
print v(xbgr.mr_n76253072)
print v(xbgr.mr_n76253552)
print v(xbgr.mr_n76253872)
print v(xbgr.mr_n76254352)
print v(xbgr.mr_n76254752)
print v(xbgr.mr_n76255088)
print v(xbgr.mr_n76255200)
print v(xbgr.mr_n76255472)
print v(xbgr.mr_n76255744)
print v(xbgr.mr_n76256016)
print v(xbgr.mr_n76256288)
print v(xbgr.mr_n76256560)
print v(xbgr.mr_n76256832)
print v(xbgr.mr_n76257104)
print v(xbgr.mr_n76257376)
print v(xbgr.mr_n76257648)
print v(xbgr.mr_n76257920)
print v(xbgr.mr_n76258192)
print v(xbgr.mr_n76258464)
print v(xbgr.mr_n76258736)
print v(xbgr.mr_n76259008)
print v(xbgr.mr_n76259280)
print v(xbgr.mr_n76259552)
print v(xbgr.mr_n76260000)
print v(xbgr.mr_n76260192)
print v(xbgr.mr_n76260384)
print v(xbgr.mr_n76260576)
print v(xbgr.mr_n76261520)
print v(xbgr.mr_n76265280)
print v(xbgr.mr_n76265392)
print v(xbgr.mr_n76265584)
print v(xbgr.mr_n76266336)
print v(xbgr.mr_n76267248)
print v(xbgr.mr_n76268000)
print v(xbgr.mr_n76270272)
print v(xbgr.mr_n76270384)
print v(xbgr.mr_n76270576)
print v(xbgr.mr_n76271328)
print v(xbgr.mr_n76272240)
print v(xbgr.mr_n76272992)
print v(xbgr.mr_n76275264)
print v(xbgr.mr_n76275376)
print v(xbgr.mr_n76275568)
print v(xbgr.mr_n76276320)
print v(xbgr.mr_n76277232)
print v(xbgr.mr_n76277984)
print v(xbgr.mr_n76280256)
print v(xbgr.mr_n76280368)
print v(xbgr.mr_n76280560)
print v(xbgr.mr_n76281312)
print v(xbgr.mr_n76282224)
print v(xbgr.mr_n76282976)
print v(xbgr.mr_n76285248)
print v(xbgr.mr_n76285360)
print v(xbgr.mr_n76285552)
print v(xbgr.mr_n76286304)
print v(xbgr.mr_n76287216)
print v(xbgr.mr_n76287968)
print v(xbgr.mr_n76290240)
print v(xbgr.mr_n76290352)
print v(xbgr.mr_n76290544)
print v(xbgr.mr_n76291296)
print v(xbgr.mr_n76294816)
print v(xbgr.mr_n76295328)
print v(xbgr.mr_n76295760)
print v(xbgr.mr_n76295936)
print v(xbgr.mr_n76296272)
print v(xbgr.mr_n76296784)
print v(xbgr.mr_n76297216)
print v(xbgr.mr_n76297392)
print v(xbgr.mr_n76297648)
print v(xbgr.mr_n76298432)
print v(xbgr.mr_n76298608)
print v(xbgr.mr_n76298784)
print v(xbgr.mr_n76299296)
print v(xbgr.mr_n76299408)
print v(xbgr.mr_n76299968)
print v(xbgr.mr_n76300144)
print v(xbgr.mr_n76300400)
print v(xbgr.mr_n76301344)
print v(xbgr.mr_n76301520)
print v(xbgr.mr_n76301696)
print v(xbgr.mr_n76302208)
print v(xbgr.mr_n76302320)
print v(xbgr.mr_n76302880)
print v(xbgr.mr_n76303056)
print v(xbgr.mr_n76303552)
print v(xbgr.mr_n76304064)
print v(xbgr.mr_n76304496)
print v(xbgr.mr_n76304672)
print v(xbgr.mr_n76305008)
print v(xbgr.mr_n76305712)
print v(xbgr.mr_n76305888)
print v(xbgr.mr_n76306064)
print v(xbgr.mr_n76306576)
print v(xbgr.mr_n76306688)
print v(xbgr.mr_n76307248)
print v(xbgr.mr_n76307424)
print v(xbgr.mr_n76307840)
print v(xbgr.mr_n76308432)
print v(xbgr.mr_n76308864)
print v(xbgr.mr_n76309040)
print v(xbgr.mr_n76309296)
print v(xbgr.mr_n76309888)
print v(xbgr.mr_n76310320)
print v(xbgr.mr_n76310496)
print v(xbgr.mr_n76310832)
print v(xbgr.mr_n76311536)
print v(xbgr.mr_n76311712)
print v(xbgr.mr_n76311888)
print v(xbgr.mr_n76312400)
print v(xbgr.mr_n76312832)
print v(xbgr.mr_n76313008)
print v(xbgr.mr_n76313344)
print v(xbgr.mr_n76313856)
print v(xbgr.mr_n76314288)
print v(xbgr.mr_n76314464)
print v(xbgr.mr_n76314800)
print v(xbgr.mr_n76315312)
print v(xbgr.mr_n76315424)
print v(xbgr.mr_n76316160)
print v(xbgr.mr_n76316576)
print v(xbgr.mr_n76317360)
print v(xbgr.mr_n76317536)
print v(xbgr.mr_n76317712)
print v(xbgr.mr_n76318224)
print v(xbgr.mr_n76318336)
print v(xbgr.mr_n76318448)
print v(xbgr.mr_n76318560)
print v(xbgr.mr_n76318672)
print v(xbgr.mr_n76318944)
print v(xbgr.mr_n76319296)
print v(xbgr.mr_n76319408)
print v(xbgr.mr_n76319680)
print v(xbgr.mr_n76320032)
print v(xbgr.mr_n76320272)
print v(xbgr.mr_n76320608)
print v(xbgr.mr_n76320960)
print v(xbgr.mr_n76321072)
print v(xbgr.mr_n76321264)
print v(xbgr.mr_n76321536)
print v(xbgr.mr_n76321808)
print v(xbgr.mr_n76322080)
print v(xbgr.mr_n76322352)
print v(xbgr.mr_n76322624)
print v(xbgr.mr_n76323248)
print v(xbgr.mr_n76323440)
print v(xbgr.mr_n76323632)
print v(xbgr.mr_n76323824)
print v(xbgr.mr_n76324576)
print v(xbgr.mr_n76342720)
print v(xbgr.mr_n76342896)
print v(xbgr.mr_n76343600)
print v(xbgr.mr_n76343776)
print v(xbgr.mr_n76343952)
print v(xbgr.mr_n76344656)
print v(xbgr.mr_n76344832)
print v(xbgr.mr_n76345008)
print v(xbgr.mr_n76345712)
print v(xbgr.mr_n76345888)
print v(xbgr.mr_n76346064)
print v(xbgr.mr_n76346768)
print v(xbgr.mr_n76346944)
print v(xbgr.mr_n76347120)
print v(xbgr.mr_n76347824)
print v(xbgr.mr_n76348000)
print v(xbgr.mr_n76348176)
print v(xbgr.mr_n76348752)
print v(xbgr.mr_n76348944)
print v(xbgr.mr_n76349216)
print v(xbgr.mr_n76349488)
print v(xbgr.mr_n76349760)
print v(xbgr.mr_n76350032)
print v(xbgr.mr_n76350304)
print v(xbgr.mr_n76350576)
print v(xbgr.mr_n76350848)
print v(xbgr.mr_n76351120)
print v(xbgr.mr_n76354656)
print v(xbgr.mr_n76354992)
print v(xbgr.mr_n76355328)
print v(xbgr.mr_n76355664)
print v(xbgr.mr_n76356320)
print v(xbgr.mr_n76356960)
print v(xbgr.mr_n76357360)
print v(xbgr.mr_n76357760)
print v(xbgr.mr_n76358160)
print v(xbgr.mr_n76358560)
print v(xbgr.mr_n76358960)
print v(xbgr.mr_n76359360)
print v(xbgr.mr_n76359824)
print v(xbgr.mr_n76360000)
print v(xbgr.mr_n76360624)
print v(xbgr.mr_n76360800)
print v(xbgr.mr_n76361424)
print v(xbgr.mr_n76361600)
print v(xbgr.mr_n76361712)
print v(xbgr.mr_n76362048)
print v(xbgr.mr_n76362352)
print v(xbgr.mr_n76362464)
print v(xbgr.mr_n76362576)
print v(xbgr.mr_n76364208)
print v(xbgr.mr_n76364848)
print v(xbgr.mr_n76367584)
print v(xbgr.mr_n76368096)
print v(xbgr.mr_n76369312)
print v(xbgr.mr_n76369904)
print v(xbgr.mr_n76371120)
print v(xbgr.mr_n76371712)
print v(xbgr.mr_n76372928)
print v(xbgr.mr_n76373520)
print v(xbgr.mr_n76374736)
print v(xbgr.mr_n76375328)
print v(xbgr.mr_n76376544)
print v(xbgr.mr_n76377136)
print v(xbgr.mr_n76378432)
print v(xbgr.mr_n76378944)
print v(xbgr.mr_n76380160)
print v(xbgr.mr_n76380752)
print v(xbgr.mr_n76382048)
print v(xbgr.mr_n76382560)
print v(xbgr.mr_n76383776)
print v(xbgr.mr_n76384368)
print v(xbgr.mr_n76385584)
print v(xbgr.mr_n76387472)
print v(xbgr.mr_n76387984)
print v(xbgr.mr_n76389280)
print v(xbgr.mr_n76389792)
print v(xbgr.mr_n76389904)
print v(xbgr.mr_n76390016)
print v(xbgr.mr_n76390128)
print v(xbgr.mr_n76390400)
print v(xbgr.mr_n76390512)
print v(xbgr.mr_n76390864)
print v(xbgr.mr_n76390976)
print v(xbgr.mr_n76391248)
print v(xbgr.mr_n76391600)
print v(xbgr.mr_n76391712)
print v(xbgr.mr_n76392080)
print v(xbgr.mr_n76392704)
print v(xbgr.mr_n76393184)
print v(xbgr.mr_n76393616)
print v(xbgr.mr_n76394032)
print v(xbgr.mr_n76394720)
print v(xbgr.mr_n76395184)
print v(xbgr.mr_n76395600)
print v(xbgr.mr_n76396288)
print v(xbgr.mr_n76396816)
print v(xbgr.mr_n76397168)
print v(xbgr.mr_n76397856)
print v(xbgr.mr_n76398320)
print v(xbgr.mr_n76398736)
print v(xbgr.mr_n76399424)
print v(xbgr.mr_n76399952)
print v(xbgr.mr_n76400304)
print v(xbgr.mr_n76400992)
print v(xbgr.mr_n76401456)
print v(xbgr.mr_n76401872)
print v(xbgr.mr_n76402560)
print v(xbgr.mr_n76403024)
print v(xbgr.mr_n76403440)
print v(xbgr.mr_n76404128)
print v(xbgr.mr_n76404592)
print v(xbgr.mr_n76405008)
print v(xbgr.mr_n76405696)
print v(xbgr.mr_n76406224)
print v(xbgr.mr_n76406576)
print v(xbgr.mr_n76407264)
print v(xbgr.mr_n76407792)
print v(xbgr.mr_n76408144)
print v(xbgr.mr_n76408832)
print v(xbgr.mr_n76409296)
print v(xbgr.mr_n76409712)
print v(xbgr.mr_n76410400)
print v(xbgr.mr_n76410928)
print v(xbgr.mr_n76411280)
print v(xbgr.mr_n76411968)
print v(xbgr.mr_n76412432)
print v(xbgr.mr_n76412848)
print v(xbgr.mr_n76415328)
print v(xbgr.mr_n76415776)
print v(xbgr.mr_n76417056)
print v(xbgr.mr_n76417824)
print v(xbgr.mr_n76418352)
print v(xbgr.mr_n76418736)
print v(xbgr.mr_n76419504)
print v(xbgr.mr_n76422944)
print v(xbgr.mr_n76424112)
print v(xbgr.mr_n76424880)
print v(xbgr.mr_n76425056)
print v(xbgr.mr_n76425520)
print v(xbgr.mr_n76427040)
print v(xbgr.mr_n76427552)
print v(xbgr.mr_n76428896)
print v(xbgr.mr_n76431664)
print v(xbgr.mr_n76431776)
print v(xbgr.mr_n76432352)
print v(xbgr.mr_n76434976)
print v(xbgr.mr_n76435904)
print v(xbgr.mr_n76436368)
print v(xbgr.mr_n76436832)
print v(xbgr.mr_n76437296)
print v(xbgr.mr_n76437760)
print v(xbgr.mr_n76438224)
print v(xbgr.mr_n76438688)
print v(xbgr.mr_n76439152)
print v(xbgr.mr_n76439616)
print v(xbgr.mr_n76440080)
print v(xbgr.mr_n76440544)
print v(xbgr.mr_n76441008)
print v(xbgr.mr_n76441472)
print v(xbgr.mr_n76441936)
print v(xbgr.mr_n76442400)
print v(xbgr.mr_n76442864)
print v(xbgr.mr_n76442976)
print v(xbgr.mr_n76443232)
print v(xbgr.mr_n76444080)
print v(xbgr.mr_n76446752)
print v(xbgr.mr_n76446928)
print v(xbgr.mr_n76447264)
print v(xbgr.mr_n76447440)
print v(xbgr.mr_n76447936)
print v(xbgr.mr_n76448080)
print v(xbgr.mr_n76448992)
print v(xbgr.mr_n76450256)
print v(xbgr.mr_n76450848)
print v(xbgr.mr_n76450992)
print v(xbgr.mr_n76452112)
print v(xbgr.mr_n76456016)
print v(xbgr.mr_n76457952)
print v(xbgr.mr_n76460880)
print v(xbgr.mr_n76464368)
print v(xbgr.mr_n76464992)
print v(xbgr.mr_n76467536)
print v(xbgr.mr_n76470160)
print v(xbgr.mr_n76470288)
print v(xbgr.mr_n76471200)
print v(xbgr.mr_n76472096)
print v(xbgr.mr_n76472288)
print v(xbgr.mr_n76473072)
print v(xbgr.mr_n76473568)
print v(xbgr.mr_n76473920)
print v(xbgr.mr_n76474192)
print v(xbgr.mr_n76474768)
print v(xbgr.mr_n76492624)
print v(xbgr.mr_n76495056)
print v(xbgr.mr_n76495408)
print v(xbgr.mr_n76495840)
print v(xbgr.mr_n76496016)
print v(xbgr.mr_n76496208)
print v(xbgr.mr_n76496576)
print v(xbgr.mr_n76500240)
print v(xbgr.mr_n76506688)
print v(xbgr.mr_n76507152)
print v(xbgr.mr_n76507616)
print v(xbgr.mr_n76508080)
print v(xbgr.mr_n76508544)
print v(xbgr.mr_n76509008)
print v(xbgr.mr_n76509472)
print v(xbgr.mr_n76509936)
print v(xbgr.mr_n76510400)
print v(xbgr.mr_n76510864)
print v(xbgr.mr_n76511328)
print v(xbgr.mr_n76511792)
print v(xbgr.mr_n76512256)
print v(xbgr.mr_n76512720)
print v(xbgr.mr_n76513184)
print v(xbgr.mr_n76513648)
print v(xbgr.mr_n76514112)
print v(xbgr.mr_n76525392)
print v(xbgr.mr_n76528496)
print v(xbgr.mr_n76530896)
print v(xbgr.mr_n76537552)
print v(xbgr.mr_n76543760)
print v(xbgr.mr_n76546000)
print v(xbgr.mr_n76548016)
print v(xbgr.mr_n76548528)
print v(xbgr.mr_n76548784)
print v(xbgr.mr_n76549616)
print v(xbgr.mr_n76549808)
print v(xbgr.mr_n76550064)
print v(xbgr.mr_n76550320)
print v(xbgr.mr_n76550960)
print v(xbgr.mr_n76552288)
print v(xbgr.mr_n76556032)
print v(xbgr.mr_n76557360)
print v(xbgr.mr_n76559408)
print v(xbgr.mr_n76562176)
print v(xbgr.mr_n76563504)
print v(xbgr.mr_n76565552)
print v(xbgr.mr_n76568320)
print v(xbgr.mr_n76569648)
print v(xbgr.mr_n76571696)
print v(xbgr.mr_n76574464)
print v(xbgr.mr_n76575792)
print v(xbgr.mr_n76577840)
print v(xbgr.mr_n76580608)
print v(xbgr.mr_n76581936)
print v(xbgr.mr_n76583984)
print v(xbgr.mr_n76586752)
print v(xbgr.mr_n76588080)
print v(xbgr.mr_n76590432)
print v(xbgr.mr_n76591200)
print v(xbgr.mr_n76595392)
print v(xbgr.mr_n76595792)
print v(xbgr.mr_n76596192)
print v(xbgr.mr_n76596592)
print v(xbgr.mr_n76596992)
print v(xbgr.mr_n76597392)
print v(xbgr.mr_n76597792)
print v(xbgr.mr_n76598192)
print v(xbgr.mr_n76598592)
print v(xbgr.mr_n76598992)
print v(xbgr.mr_n76599392)
print v(xbgr.mr_n76599792)
print v(xbgr.mr_n76600192)
print v(xbgr.mr_n76600592)
print v(xbgr.mr_n76600992)
print v(xbgr.mr_n76601392)
print v(xbgr.mr_n76601664)
print v(xbgr.mr_n76601776)
print v(xbgr.mr_n76601888)
print v(xbgr.mr_n76602000)
print v(xbgr.mr_n76602112)
print v(xbgr.mr_n76602304)
print v(xbgr.mr_n76602576)
print v(xbgr.mr_n76602848)
print v(xbgr.mr_n76603120)
print v(xbgr.mr_n76603392)
print v(xbgr.mr_n76603664)
print v(xbgr.mr_n76603936)
print v(xbgr.mr_n76604208)
print v(xbgr.mr_n76604544)
print v(xbgr.mr_n76604944)
print v(xbgr.mr_n76606576)
print v(xbgr.mr_n76617440)
print v(xbgr.mr_n76619168)
print v(xbgr.mr_n76619712)
print v(xbgr.mr_n76619888)
print v(xbgr.mr_n76620736)
print v(xbgr.mr_n76621216)
print v(xbgr.mr_n76621552)
print v(xbgr.mr_n76621712)
print v(xbgr.mr_n76622256)
print v(xbgr.mr_n76622432)
print v(xbgr.mr_n76623216)
print v(xbgr.mr_n76623760)
print v(xbgr.mr_n76624192)
print v(xbgr.mr_n76624800)
print v(xbgr.mr_n76624976)
print v(xbgr.mr_n76625824)
print v(xbgr.mr_n76626304)
print v(xbgr.mr_n76626800)
print v(xbgr.mr_n76627344)
print v(xbgr.mr_n76627520)
print v(xbgr.mr_n76628304)
print v(xbgr.mr_n76628848)
print v(xbgr.mr_n76629344)
print v(xbgr.mr_n76629888)
print v(xbgr.mr_n76630064)
print v(xbgr.mr_n76630912)
print v(xbgr.mr_n76631392)
print v(xbgr.mr_n76631888)
print v(xbgr.mr_n76632000)
print v(xbgr.mr_n76633184)
print v(xbgr.mr_n76633952)
print v(xbgr.mr_n76634368)
print v(xbgr.mr_n76634480)
print v(xbgr.mr_n76635264)
print v(xbgr.mr_n76636224)
print v(xbgr.mr_n76636720)
print v(xbgr.mr_n76637072)
print v(xbgr.mr_n76637184)
print v(xbgr.mr_n76637376)
print v(xbgr.mr_n76637840)
print v(xbgr.mr_n76638304)
print v(xbgr.mr_n76638768)
print v(xbgr.mr_n76639232)
print v(xbgr.mr_n76641520)
print v(xbgr.mr_n76651360)
print v(xbgr.mr_n76651552)
print v(xbgr.mr_n76651808)
print v(xbgr.mr_n76652064)
print v(xbgr.mr_n76654032)
print v(xbgr.mr_n76678688)
print v(xbgr.mr_n76679184)
print v(xbgr.mr_n76679488)
print v(xbgr.mr_n76679984)
print v(xbgr.mr_n76680288)
print v(xbgr.mr_n76680848)
print v(xbgr.mr_n76681152)
print v(xbgr.mr_n76682032)
print v(xbgr.mr_n76682336)
print v(xbgr.mr_n76683216)
print v(xbgr.mr_n76683520)
print v(xbgr.mr_n76684400)
print v(xbgr.mr_n76684704)
print v(xbgr.mr_n76685584)
print v(xbgr.mr_n76685888)
print v(xbgr.mr_n76686768)
print v(xbgr.mr_n76687072)
print v(xbgr.mr_n76687952)
print v(xbgr.mr_n76688256)
print v(xbgr.mr_n76689136)
print v(xbgr.mr_n76689440)
print v(xbgr.mr_n76690320)
print v(xbgr.mr_n76690624)
print v(xbgr.mr_n76691504)
print v(xbgr.mr_n76691808)
print v(xbgr.mr_n76692688)
print v(xbgr.mr_n76692992)
print v(xbgr.mr_n76693872)
print v(xbgr.mr_n76694176)
print v(xbgr.mr_n76695056)
print v(xbgr.mr_n76695248)
print v(xbgr.mr_n76695520)
print v(xbgr.mr_n76695984)
print v(xbgr.mr_n76707360)
print v(xbgr.mr_n76709312)
print v(xbgr.mr_n76709648)
print v(xbgr.mr_n76709984)
print v(xbgr.mr_n76710320)
print v(xbgr.mr_n76712352)
print v(xbgr.mr_n76713120)
print v(xbgr.mr_n76713520)
print v(xbgr.mr_n76713920)
print v(xbgr.mr_n76714320)
print v(xbgr.mr_n76714720)
print v(xbgr.mr_n76715120)
print v(xbgr.mr_n76715520)
print v(xbgr.mr_n76715920)
print v(xbgr.mr_n76716320)
print v(xbgr.mr_n76716720)
print v(xbgr.mr_n76717120)
print v(xbgr.mr_n76717520)
print v(xbgr.mr_n76717920)
print v(xbgr.mr_n76718320)
print v(xbgr.mr_n76718720)
print v(xbgr.mr_n76719120)
print v(xbgr.mr_n76722048)
print v(xbgr.mr_n76724912)
print v(xbgr.mr_n76725536)
print v(xbgr.mr_n76742256)
print v(xbgr.mr_n76743344)
print v(xbgr.mr_n76746608)
print v(xbgr.mr_n76749536)
print v(xbgr.mr_n76749840)
print v(xbgr.mr_n76750144)
print v(xbgr.mr_n76750448)
print v(xbgr.mr_n76750832)
print v(xbgr.mr_n76751296)
print v(xbgr.mr_n76751760)
print v(xbgr.mr_n76752224)
print v(xbgr.mr_n76752688)
print v(xbgr.mr_n76753152)
print v(xbgr.mr_n76753616)
print v(xbgr.mr_n76754080)
print v(xbgr.mr_n76754544)
print v(xbgr.mr_n76755616)
print v(xbgr.mr_n76756784)
print v(xbgr.mr_n76758832)
print v(xbgr.mr_n76765344)
print v(xbgr.mr_n76765488)
print v(xbgr.mr_n76765680)
print v(xbgr.mr_n76766016)
print v(xbgr.mr_n76766352)
print v(xbgr.mr_n76766496)
print v(xbgr.mr_n76768512)
print v(xbgr.mr_n76770256)
print v(xbgr.mr_n76770896)
print v(xbgr.mr_n76771168)
print v(xbgr.mr_n76773920)
print v(xbgr.mr_n76774560)
print v(xbgr.mr_n76774672)
print v(xbgr.mr_n76776368)
print v(xbgr.mr_n76776480)
print v(xbgr.mr_n76776592)
print v(xbgr.mr_n76776864)
print v(xbgr.mr_n76778832)
print v(xbgr.mr_n76779616)
print v(xbgr.mr_n76779728)
print v(xbgr.mr_n76781424)
print v(xbgr.mr_n76781536)
print v(xbgr.mr_n76781648)
print v(xbgr.mr_n76781920)
print v(xbgr.mr_n76783888)
print v(xbgr.mr_n76784672)
print v(xbgr.mr_n76784784)
print v(xbgr.mr_n76786048)
print v(xbgr.mr_n76786752)
print v(xbgr.mr_n76787392)
print v(xbgr.mr_n76787504)
print v(xbgr.mr_n76789008)
print v(xbgr.mr_n76789728)
print v(xbgr.mr_n76789840)
print v(xbgr.mr_n76791536)
print v(xbgr.mr_n76791648)
print v(xbgr.mr_n76791760)
print v(xbgr.mr_n76792032)
print v(xbgr.mr_n76794192)
print v(xbgr.mr_n76794304)
print v(xbgr.mr_n76794496)
print v(xbgr.mr_n76795968)
print v(xbgr.mr_n76796304)
print v(xbgr.mr_n76797504)
print v(xbgr.mr_n76797616)
print v(xbgr.mr_n76799120)
print v(xbgr.mr_n76799840)
print v(xbgr.mr_n76799952)
print v(xbgr.mr_n76801648)
print v(xbgr.mr_n76801760)
print v(xbgr.mr_n76801872)
print v(xbgr.mr_n76802144)
print v(xbgr.mr_n76804304)
print v(xbgr.mr_n76804416)
print v(xbgr.mr_n76804608)
print v(xbgr.mr_n76806640)
print v(xbgr.mr_n76806752)
print v(xbgr.mr_n76806864)
print v(xbgr.mr_n76807136)
print v(xbgr.mr_n76809360)
print v(xbgr.mr_n76809472)
print v(xbgr.mr_n76809664)
print v(xbgr.mr_n76810176)
print v(xbgr.mr_n76810512)
print v(xbgr.mr_n76810864)
print v(xbgr.mr_n76811488)
print v(xbgr.mr_n76812016)
print v(xbgr.mr_n76812368)
print v(xbgr.mr_n76812688)
print v(xbgr.mr_n76813056)
print v(xbgr.mr_n76813584)
print v(xbgr.mr_n76813936)
print v(xbgr.mr_n76814624)
print v(xbgr.mr_n76815088)
print v(xbgr.mr_n76815504)
print v(xbgr.mr_n76816192)
print v(xbgr.mr_n76816720)
print v(xbgr.mr_n76817072)
print v(xbgr.mr_n76817760)
print v(xbgr.mr_n76818288)
print v(xbgr.mr_n76818640)
print v(xbgr.mr_n76819328)
print v(xbgr.mr_n76819856)
print v(xbgr.mr_n76820208)
print v(xbgr.mr_n76820896)
print v(xbgr.mr_n76821360)
print v(xbgr.mr_n76821776)
print v(xbgr.mr_n76822464)
print v(xbgr.mr_n76822848)
print v(xbgr.mr_n76823344)
print v(xbgr.mr_n76824032)
print v(xbgr.mr_n76824496)
print v(xbgr.mr_n76824912)
print v(xbgr.mr_n76825600)
print v(xbgr.mr_n76826128)
print v(xbgr.mr_n76826480)
print v(xbgr.mr_n76827168)
print v(xbgr.mr_n76827696)
print v(xbgr.mr_n76832912)
print v(xbgr.mr_n76833216)
print v(xbgr.mr_n76833600)
print v(xbgr.mr_n76848528)
print v(xbgr.mr_n76848992)
print v(xbgr.mr_n76849456)
print v(xbgr.mr_n76849920)
print v(xbgr.mr_n76850384)
print v(xbgr.mr_n76850848)
print v(xbgr.mr_n76851312)
print v(xbgr.mr_n76851776)
print v(xbgr.mr_n76852240)
print v(xbgr.mr_n76852704)
print v(xbgr.mr_n76853168)
print v(xbgr.mr_n76853632)
print v(xbgr.mr_n76854096)
print v(xbgr.mr_n76854560)
print v(xbgr.mr_n76855024)
print v(xbgr.mr_n76855488)
print v(xbgr.mr_n76855952)
print v(xbgr.mr_n76856416)
print v(xbgr.mr_n76856880)
print v(xbgr.mr_n76858368)
print v(xbgr.mr_n76861632)
print v(xbgr.mr_n76868656)
print v(xbgr.mr_n76880416)
print v(xbgr.mr_n76880608)
print v(xbgr.mr_n76883088)
print v(xbgr.mr_n76902576)
print v(xbgr.mr_n76902864)
print v(xbgr.mr_n76904304)
print v(xbgr.mr_n76904416)
print v(xbgr.mr_n76904528)
print v(xbgr.mr_n76905232)
print v(xbgr.mr_n76905344)
print v(xbgr.mr_n76905456)
print v(xbgr.mr_n76905968)
print v(xbgr.mr_n76906144)
print v(xbgr.mr_n76906320)
print v(xbgr.mr_n76906960)
print v(xbgr.mr_n76907136)
print v(xbgr.mr_n76907616)
print v(xbgr.mr_n76907792)
print v(xbgr.mr_n76908272)
print v(xbgr.mr_n76908448)
print v(xbgr.mr_n76908928)
print v(xbgr.mr_n76909104)
print v(xbgr.mr_n76909584)
print v(xbgr.mr_n76909760)
print v(xbgr.mr_n76910240)
print v(xbgr.mr_n76910416)
print v(xbgr.mr_n76910896)
print v(xbgr.mr_n76911072)
print v(xbgr.mr_n76911552)
print v(xbgr.mr_n76911728)
print v(xbgr.mr_n76912208)
print v(xbgr.mr_n76912384)
print v(xbgr.mr_n76912864)
print v(xbgr.mr_n76913040)
print v(xbgr.mr_n76916400)
print v(xbgr.mr_n76916736)
print v(xbgr.mr_n76917312)
print v(xbgr.mr_n76918224)
print v(xbgr.mr_n76918400)
print v(xbgr.mr_n76918576)
print v(xbgr.mr_n76919280)
print v(xbgr.mr_n76919456)
print v(xbgr.mr_n76920016)
print v(xbgr.mr_n76920480)
print v(xbgr.mr_n76920656)
print v(xbgr.mr_n76920832)
print v(xbgr.mr_n76921536)
print v(xbgr.mr_n76921712)
print v(xbgr.mr_n76922336)
print v(xbgr.mr_n76922512)
print v(xbgr.mr_n76922688)
print v(xbgr.mr_n76923200)
print v(xbgr.mr_n76923632)
print v(xbgr.mr_n76923808)
print v(xbgr.mr_n76924144)
print v(xbgr.mr_n76924848)
print v(xbgr.mr_n76925024)
print v(xbgr.mr_n76925648)
print v(xbgr.mr_n76925824)
print v(xbgr.mr_n76926000)
print v(xbgr.mr_n76926704)
print v(xbgr.mr_n76926880)
print v(xbgr.mr_n76927504)
print v(xbgr.mr_n76927680)
print v(xbgr.mr_n76927856)
print v(xbgr.mr_n76928496)
print v(xbgr.mr_n76928768)
print v(xbgr.mr_n76929200)
print v(xbgr.mr_n76929376)
print v(xbgr.mr_n76929712)
print v(xbgr.mr_n76930416)
print v(xbgr.mr_n76930592)
print v(xbgr.mr_n76931216)
print v(xbgr.mr_n76931392)
print v(xbgr.mr_n76931568)
print v(xbgr.mr_n76932208)
print v(xbgr.mr_n76932480)
print v(xbgr.mr_n76932592)
print v(xbgr.mr_n76932704)
print v(xbgr.mr_n76932816)
print v(xbgr.mr_n76932928)
print v(xbgr.mr_n76933200)
print v(xbgr.mr_n76933552)
print v(xbgr.mr_n76933664)
print v(xbgr.mr_n76933776)
print v(xbgr.mr_n76934208)
print v(xbgr.mr_n76934688)
print v(xbgr.mr_n76934864)
print v(xbgr.mr_n76935216)
print v(xbgr.mr_n76935584)
print v(xbgr.mr_n76935920)
print v(xbgr.mr_n76936272)
print v(xbgr.mr_n76936384)
print v(xbgr.mr_n76936880)
print v(xbgr.mr_n76937376)
print v(xbgr.mr_n76937856)
print v(xbgr.mr_n76938032)
print v(xbgr.mr_n76938384)
print v(xbgr.mr_n76938752)
print v(xbgr.mr_n76939088)
print v(xbgr.mr_n76939440)
print v(xbgr.mr_n76939552)
print v(xbgr.mr_n76940048)
print v(xbgr.mr_n76940544)
print v(xbgr.mr_n76941024)
print v(xbgr.mr_n76941200)
print v(xbgr.mr_n76941552)
print v(xbgr.mr_n76941920)
print v(xbgr.mr_n76942256)
print v(xbgr.mr_n76942608)
print v(xbgr.mr_n76951808)
print v(xbgr.mr_n76954496)
print v(xbgr.mr_n76954880)
print v(xbgr.mr_n76955344)
print v(xbgr.mr_n76955808)
print v(xbgr.mr_n76956272)
print v(xbgr.mr_n76956736)
print v(xbgr.mr_n76957200)
print v(xbgr.mr_n76957664)
print v(xbgr.mr_n76958128)
print v(xbgr.mr_n76958592)
print v(xbgr.mr_n76959056)
print v(xbgr.mr_n76959520)
print v(xbgr.mr_n76959984)
print v(xbgr.mr_n76960448)
print v(xbgr.mr_n76960912)
print v(xbgr.mr_n76961376)
print v(xbgr.mr_n76961840)
print v(xbgr.mr_n76962304)
print v(xbgr.mr_n76962768)
print v(xbgr.mr_n76963232)
print v(xbgr.mr_n76963696)
print v(xbgr.mr_n76964160)
print v(xbgr.mr_n76964624)
print v(xbgr.mr_n76965088)
print v(xbgr.mr_n76965616)
print v(xbgr.mr_n76966208)
print v(xbgr.mr_n76967040)
print v(xbgr.mr_n76972736)
print v(xbgr.mr_n76991744)
print v(xbgr.mr_n76992000)
print v(xbgr.mr_n76998640)
print v(xbgr.mr_n76998816)
print v(xbgr.mr_n76999152)
print v(xbgr.mr_n77001216)
print v(xbgr.mr_n77001328)
print v(xbgr.mr_n77001520)
print v(xbgr.mr_n77002272)
print v(xbgr.mr_n77004896)
print v(xbgr.mr_n77005648)
print v(xbgr.mr_n77012752)
print v(xbgr.mr_n77015792)
print v(xbgr.mr_n77016112)
print v(xbgr.mr_n77021904)
print v(xbgr.mr_n77022688)
print v(xbgr.mr_n77023120)
print v(xbgr.mr_n77023296)
print v(xbgr.mr_n77023472)
print v(xbgr.mr_n77024336)
print v(xbgr.mr_n77024512)
print v(xbgr.mr_n77024704)
print v(xbgr.mr_n77025136)
print v(xbgr.mr_n77025312)
print v(xbgr.mr_n77025936)
print v(xbgr.mr_n77026112)
print v(xbgr.mr_n77026608)
print v(xbgr.mr_n77026736)
print v(xbgr.mr_n77026912)
print v(xbgr.mr_n77027536)
print v(xbgr.mr_n77027712)
print v(xbgr.mr_n77028336)
print v(xbgr.mr_n77028512)
print v(xbgr.mr_n77029136)
print v(xbgr.mr_n77029312)
print v(xbgr.mr_n77029872)
print v(xbgr.mr_n77030144)
print v(xbgr.mr_n77031152)
print v(xbgr.mr_n77031408)
print v(xbgr.mr_n77032832)
print v(xbgr.mr_n77033056)
print v(xbgr.mr_n77033600)
print v(xbgr.mr_n77035872)
print v(xbgr.mr_n77036544)
print v(xbgr.mr_n77037456)
print v(xbgr.mr_n77037728)
print v(xbgr.mr_n77037984)
print v(xbgr.mr_n77039616)
print v(xbgr.mr_n77040304)
print v(xbgr.mr_n77040608)
print v(xbgr.mr_n77040752)
print v(xbgr.mr_n77041056)
print v(xbgr.mr_n77041440)
print v(xbgr.mr_n77041776)
print v(xbgr.mr_n77043248)
print v(xbgr.mr_n77043728)
print v(xbgr.mr_n77044320)
print v(xbgr.mr_n77044432)
print v(xbgr.mr_n77045056)
print v(xbgr.mr_n77045632)
print v(xbgr.mr_n77046224)
print v(xbgr.mr_n77046912)
print v(xbgr.mr_n77048192)
print v(xbgr.mr_n77048368)
print v(xbgr.mr_n77048720)
print v(xbgr.mr_n77048912)
print v(xbgr.mr_n77049536)
print v(xbgr.mr_n77049648)
print v(xbgr.mr_n77049920)
print v(xbgr.mr_n77050256)
print v(xbgr.mr_n77050368)
print v(xbgr.mr_n77050592)
print v(xbgr.mr_n77050928)
print v(xbgr.mr_n77051104)
print v(xbgr.mr_n77051568)
print v(xbgr.mr_n77051920)
print v(xbgr.mr_n77052384)
print v(xbgr.mr_n77052576)
print v(xbgr.mr_n77053072)
print v(xbgr.mr_n77053712)
print v(xbgr.mr_n77053824)
print v(xbgr.mr_n77055072)
print v(xbgr.mr_n77057520)
print v(xbgr.mr_n77057664)
print v(xbgr.mr_n77057840)
print v(xbgr.mr_n77058096)
print v(xbgr.mr_n77058528)
print v(xbgr.mr_n77058720)
print v(xbgr.mr_n77058912)
print v(xbgr.mr_n77059808)
print v(xbgr.mr_n77060640)
print v(xbgr.mr_n77060928)
print v(xbgr.mr_n77062656)
print v(xbgr.mr_n77063056)
print v(xbgr.mr_n77063792)
print v(xbgr.mr_n77064224)
print v(xbgr.mr_n77064448)
print v(xbgr.mr_n77065744)
print v(xbgr.mr_n77065936)
print v(xbgr.mr_n77066384)
print v(xbgr.mr_n77067024)
print v(xbgr.mr_n77068096)
print v(xbgr.mr_n77068464)
print v(xbgr.mr_n77068992)
print v(xbgr.mr_n77069632)
print v(xbgr.mr_n77070336)
print v(xbgr.mr_n77070592)
print v(xbgr.mr_n77071360)
print v(xbgr.mr_n77071552)
print v(xbgr.mr_n77072432)
print v(xbgr.mr_n77072544)
print v(xbgr.mr_n77072768)
print v(xbgr.mr_n77072960)
print v(xbgr.mr_n77073360)
print v(xbgr.mr_n77074096)
print v(xbgr.mr_n77074848)
print v(xbgr.mr_n77075440)
print v(xbgr.mr_n77075984)
print v(xbgr.mr_n77076256)
print v(xbgr.mr_n77077024)
print v(xbgr.mr_n77077248)
print v(xbgr.mr_n77077568)
print v(xbgr.mr_n77078800)
print v(xbgr.mr_n77079568)
print v(xbgr.mr_n77079760)
print v(xbgr.mr_n77080496)
print v(xbgr.mr_n77080928)
print v(xbgr.mr_n77081584)
print v(xbgr.mr_n77081696)
print v(xbgr.mr_n77081968)
print v(xbgr.mr_n77082288)
print v(xbgr.mr_n77082480)
print v(xbgr.mr_n77082672)
print v(xbgr.mr_n77082864)
print v(xbgr.mr_n77083056)
print v(xbgr.mr_n77083248)
print v(xbgr.mr_n77083440)
print v(xbgr.mr_n77083632)
print v(xbgr.mr_n77086112)
print v(xbgr.mr_n77086896)
print v(xbgr.mr_n77087168)
print v(xbgr.mr_n77087440)
print v(xbgr.mr_n77087712)
print v(xbgr.mr_n77087984)
print v(xbgr.mr_n77088256)
print v(xbgr.mr_n77088528)
print v(xbgr.mr_n77088800)
print v(xbgr.mr_n77089200)
print v(xbgr.mr_n77089664)
print v(xbgr.mr_n77103936)
print v(xbgr.mr_n77107376)
print v(xbgr.mr_n77118864)
print v(xbgr.mr_n77120368)
print v(xbgr.mr_n77120560)
print v(xbgr.mr_n77129520)
print v(xbgr.mr_n77129808)
print v(xbgr.mr_n77131344)
print v(xbgr.mr_n77136880)
print v(xbgr.mr_n77137216)
print v(xbgr.mr_n77137552)
print v(xbgr.mr_n77137888)
print v(xbgr.mr_n77138224)
print v(xbgr.mr_n77138480)
print v(xbgr.mr_n77138592)
print v(xbgr.mr_n77138704)
print v(xbgr.mr_n77138816)
print v(xbgr.mr_n77138928)
print v(xbgr.mr_n77139040)
print v(xbgr.mr_n77139152)
print v(xbgr.mr_n77139264)
print v(xbgr.mr_n77139616)
print v(xbgr.mr_n77139968)
print v(xbgr.mr_n77140080)
print v(xbgr.mr_n77140432)
print v(xbgr.mr_n77140672)
print v(xbgr.mr_n77140944)
print v(xbgr.mr_n77141408)
print v(xbgr.mr_n77142128)
print v(xbgr.mr_n77142240)
print v(xbgr.mr_n77142352)
print v(xbgr.mr_n77146672)
print v(xbgr.mr_n77147056)
print v(xbgr.mr_n77147168)
print v(xbgr.mr_n77147520)
print v(xbgr.mr_n77148656)
print v(xbgr.mr_n77148912)
print v(xbgr.mr_n77149056)
print v(xbgr.mr_n77149168)
print v(xbgr.mr_n77149360)
print v(xbgr.mr_n77149552)
print v(xbgr.mr_n77150160)
print v(xbgr.mr_n77150272)
print v(xbgr.mr_n77150384)
print v(xbgr.mr_n77152128)
print v(xbgr.mr_n77152544)
print v(xbgr.mr_n77152736)
print v(xbgr.mr_n77152928)
print v(xbgr.mr_n77153200)
print v(xbgr.mr_n77154368)
print v(xbgr.mr_n77155200)
print v(xbgr.mr_n77155472)
print v(xbgr.mr_n77155888)
print v(xbgr.mr_n77156320)
print v(xbgr.mr_n77156624)
print v(xbgr.mr_n77157248)
print v(xbgr.mr_n77157600)
print v(xbgr.mr_n77158032)
print v(xbgr.mr_n77158384)
print v(xbgr.mr_n77158816)
print v(xbgr.mr_n77159280)
print v(xbgr.mr_n77159632)
print v(xbgr.mr_n77160064)
print v(xbgr.mr_n77160368)
print v(xbgr.mr_n77160992)
print v(xbgr.mr_n77161344)
print v(xbgr.mr_n77161776)
print v(xbgr.mr_n77162128)
print v(xbgr.mr_n77162560)
print v(xbgr.mr_n77162960)
print v(xbgr.mr_n77163376)
print v(xbgr.mr_n77163808)
print v(xbgr.mr_n77164000)
print v(xbgr.mr_n77164112)
print v(xbgr.mr_n77164736)
print v(xbgr.mr_n77165088)
print v(xbgr.mr_n77165520)
print v(xbgr.mr_n77165872)
print v(xbgr.mr_n77166304)
print v(xbgr.mr_n77166704)
print v(xbgr.mr_n77167120)
print v(xbgr.mr_n77167552)
print v(xbgr.mr_n77167856)
print v(xbgr.mr_n77168480)
print v(xbgr.mr_n77168832)
print v(xbgr.mr_n77168944)
print v(xbgr.mr_n77169136)
print v(xbgr.mr_n77169408)
print v(xbgr.mr_n77169680)
print v(xbgr.mr_n77169952)
print v(xbgr.mr_n77170224)
print v(xbgr.mr_n77170496)
print v(xbgr.mr_n77170768)
print v(xbgr.mr_n77171040)
print v(xbgr.mr_n77171312)
print v(xbgr.mr_n77171584)
print v(xbgr.mr_n77171856)
print v(xbgr.mr_n77172128)
print v(xbgr.mr_n77172400)
print v(xbgr.mr_n77180144)
print v(xbgr.mr_n77184416)
print v(xbgr.mr_n77185376)
print v(xbgr.mr_n77192256)
print v(xbgr.mr_n77195392)
print v(xbgr.mr_n77195584)
print v(xbgr.mr_n77195776)
print v(xbgr.mr_n77196032)
print v(xbgr.mr_n77196288)
print v(xbgr.mr_n77198256)
print v(xbgr.mr_n77199504)
print v(xbgr.mr_n77201456)
print v(xbgr.mr_n77202128)
print v(xbgr.mr_n77203648)
print v(xbgr.mr_n77204704)
print v(xbgr.mr_n77205568)
print v(xbgr.mr_n77206352)
print v(xbgr.mr_n77209072)
print v(xbgr.mr_n77209728)
print v(xbgr.mr_n77210240)
print v(xbgr.mr_n77211536)
print v(xbgr.mr_n77212048)
print v(xbgr.mr_n77213344)
print v(xbgr.mr_n77213856)
print v(xbgr.mr_n77215152)
print v(xbgr.mr_n77215664)
print v(xbgr.mr_n77216720)
print v(xbgr.mr_n77217472)
print v(xbgr.mr_n77218768)
print v(xbgr.mr_n77219280)
print v(xbgr.mr_n77220576)
print v(xbgr.mr_n77221088)
print v(xbgr.mr_n77222304)
print v(xbgr.mr_n77222896)
print v(xbgr.mr_n77224112)
print v(xbgr.mr_n77224704)
print v(xbgr.mr_n77224816)
print v(xbgr.mr_n77224928)
print v(xbgr.mr_n77225040)
print v(xbgr.mr_n77225152)
print v(xbgr.mr_n77225344)
print v(xbgr.mr_n77225776)
print v(xbgr.mr_n77225888)
print v(xbgr.mr_n77226160)
print v(xbgr.mr_n77226512)
print v(xbgr.mr_n77226752)
print v(xbgr.mr_n77227152)
print v(xbgr.mr_n77227504)
print v(xbgr.mr_n77227936)
print v(xbgr.mr_n77228624)
print v(xbgr.mr_n77229248)
print v(xbgr.mr_n77229792)
print v(xbgr.mr_n77230224)
print v(xbgr.mr_n77230640)
print v(xbgr.mr_n77231328)
print v(xbgr.mr_n77231792)
print v(xbgr.mr_n77232208)
print v(xbgr.mr_n77232640)
print v(xbgr.mr_n77233328)
print v(xbgr.mr_n77233952)
print v(xbgr.mr_n77234496)
print v(xbgr.mr_n77234992)
print v(xbgr.mr_n77235344)
print v(xbgr.mr_n77236032)
print v(xbgr.mr_n77236560)
print v(xbgr.mr_n77236912)
print v(xbgr.mr_n77237344)
print v(xbgr.mr_n77238032)
print v(xbgr.mr_n77238720)
print v(xbgr.mr_n77239200)
print v(xbgr.mr_n77239696)
print v(xbgr.mr_n77240048)
print v(xbgr.mr_n77240736)
print v(xbgr.mr_n77241616)
print v(xbgr.mr_n77241872)
print v(xbgr.mr_n77242048)
print v(xbgr.mr_n77242736)
print v(xbgr.mr_n77243360)
print v(xbgr.mr_n77243904)
print v(xbgr.mr_n77244336)
print v(xbgr.mr_n77244752)
print v(xbgr.mr_n77245440)
print v(xbgr.mr_n77245968)
print v(xbgr.mr_n77246320)
print v(xbgr.mr_n77246752)
print v(xbgr.mr_n77246944)
print v(xbgr.mr_n77247440)
print v(xbgr.mr_n77248064)
print v(xbgr.mr_n77248608)
print v(xbgr.mr_n77249040)
print v(xbgr.mr_n77249456)
print v(xbgr.mr_n77250144)
print v(xbgr.mr_n77250608)
print v(xbgr.mr_n77251024)
print v(xbgr.mr_n77251456)
print v(xbgr.mr_n77251648)
print v(xbgr.mr_n77251920)
print v(xbgr.mr_n77252192)
print v(xbgr.mr_n77252464)
print v(xbgr.mr_n77252736)
print v(xbgr.mr_n77253008)
print v(xbgr.mr_n77253280)
print v(xbgr.mr_n77253552)
print v(xbgr.mr_n77253824)
print v(xbgr.mr_n77254096)
print v(xbgr.mr_n77254368)
print v(xbgr.mr_n77254640)
print v(xbgr.mr_n77254912)
print v(xbgr.mr_n77263024)
print v(xbgr.mr_n77270896)
print v(xbgr.mr_n77272896)
print v(xbgr.mr_n77274608)
print v(xbgr.mr_n77277184)
print v(xbgr.mr_n77279632)
print v(xbgr.mr_n77280096)
print v(xbgr.mr_n77280560)
print v(xbgr.mr_n77281024)
print v(xbgr.mr_n77281488)
print v(xbgr.mr_n77282304)
print v(xbgr.mr_n77303056)
print v(xbgr.mr_n77310128)
print v(xbgr.mr_n77310320)
print v(xbgr.mr_n77310576)
print v(xbgr.mr_n77310832)
print v(xbgr.mr_n77312800)
print v(xbgr.mr_n77313104)
print v(xbgr.mr_n77313216)
print v(xbgr.mr_n77313584)
print v(xbgr.mr_n77315792)
print v(xbgr.mr_n77317632)
print v(xbgr.mr_n77324784)
print v(xbgr.mr_n77325568)
print v(xbgr.mr_n77326864)
print v(xbgr.mr_n77327376)
print v(xbgr.mr_n77328672)
print v(xbgr.mr_n77329184)
print v(xbgr.mr_n77330480)
print v(xbgr.mr_n77330992)
print v(xbgr.mr_n77331888)
print v(xbgr.mr_n77332544)
print v(xbgr.mr_n77333056)
print v(xbgr.mr_n77333952)
print v(xbgr.mr_n77334528)
print v(xbgr.mr_n77335120)
print v(xbgr.mr_n77336016)
print v(xbgr.mr_n77336672)
print v(xbgr.mr_n77337184)
print v(xbgr.mr_n77338080)
print v(xbgr.mr_n77338736)
print v(xbgr.mr_n77339248)
print v(xbgr.mr_n77340144)
print v(xbgr.mr_n77340720)
print v(xbgr.mr_n77341312)
print v(xbgr.mr_n77342208)
print v(xbgr.mr_n77342864)
print v(xbgr.mr_n77343376)
print v(xbgr.mr_n77344272)
print v(xbgr.mr_n77344848)
print v(xbgr.mr_n77345440)
print v(xbgr.mr_n77346336)
print v(xbgr.mr_n77346992)
print v(xbgr.mr_n77347504)
print v(xbgr.mr_n77348400)
print v(xbgr.mr_n77349056)
print v(xbgr.mr_n77349568)
print v(xbgr.mr_n77350464)
print v(xbgr.mr_n77351120)
print v(xbgr.mr_n77351632)
print v(xbgr.mr_n77352528)
print v(xbgr.mr_n77353184)
print v(xbgr.mr_n77353696)
print v(xbgr.mr_n77354592)
print v(xbgr.mr_n77355248)
print v(xbgr.mr_n77355760)
print v(xbgr.mr_n77357056)
print v(xbgr.mr_n77357568)
print v(xbgr.mr_n77357680)
print v(xbgr.mr_n77357792)
print v(xbgr.mr_n77357904)
print v(xbgr.mr_n77358176)
print v(xbgr.mr_n77358288)
print v(xbgr.mr_n77358640)
print v(xbgr.mr_n77358752)
print v(xbgr.mr_n77358864)
print v(xbgr.mr_n77359296)
print v(xbgr.mr_n77359776)
print v(xbgr.mr_n77359952)
print v(xbgr.mr_n77360304)
print v(xbgr.mr_n77360672)
print v(xbgr.mr_n77361008)
print v(xbgr.mr_n77361360)
print v(xbgr.mr_n77361472)
print v(xbgr.mr_n77361968)
print v(xbgr.mr_n77362464)
print v(xbgr.mr_n77362944)
print v(xbgr.mr_n77363120)
print v(xbgr.mr_n77363472)
print v(xbgr.mr_n77363840)
print v(xbgr.mr_n77364176)
print v(xbgr.mr_n77364528)
print v(xbgr.mr_n77364640)
print v(xbgr.mr_n77365136)
print v(xbgr.mr_n77365632)
print v(xbgr.mr_n77366112)
print v(xbgr.mr_n77366288)
print v(xbgr.mr_n77366640)
print v(xbgr.mr_n77367072)
print v(xbgr.mr_n77367600)
print v(xbgr.mr_n77367952)
print v(xbgr.mr_n77368384)
print v(xbgr.mr_n77369072)
print v(xbgr.mr_n77369696)
print v(xbgr.mr_n77370240)
print v(xbgr.mr_n77370736)
print v(xbgr.mr_n77371088)
print v(xbgr.mr_n77371776)
print v(xbgr.mr_n77372240)
print v(xbgr.mr_n77372656)
print v(xbgr.mr_n77373088)
print v(xbgr.mr_n77373776)
print v(xbgr.mr_n77374464)
print v(xbgr.mr_n77374816)
print v(xbgr.mr_n77374928)
print v(xbgr.mr_n77375120)
print v(xbgr.mr_n77375392)
print v(xbgr.mr_n77375664)
print v(xbgr.mr_n77375936)
print v(xbgr.mr_n77376208)
print v(xbgr.mr_n77376480)
print v(xbgr.mr_n77376752)
print v(xbgr.mr_n77377024)
print v(xbgr.mr_n77377296)
print v(xbgr.mr_n77377568)
print v(xbgr.mr_n77377840)
print v(xbgr.mr_n77378112)
print v(xbgr.mr_n77378384)
print v(xbgr.mr_n77378656)
print v(xbgr.mr_n77378928)
print v(xbgr.mr_n77379200)
print v(xbgr.mr_n77387440)
print v(xbgr.mr_n77392000)
print v(xbgr.mr_n77396544)
print v(xbgr.mr_n77397072)
print v(xbgr.mr_n77397536)
print v(xbgr.mr_n77398000)
print v(xbgr.mr_n77398464)
print v(xbgr.mr_n77398928)
print v(xbgr.mr_n77399392)
print v(xbgr.mr_n77399856)
print v(xbgr.mr_n77400384)
print v(xbgr.mr_n77400976)
print v(xbgr.mr_n77401568)
print v(xbgr.mr_n77402160)
print v(xbgr.mr_n77402752)
print v(xbgr.mr_n77403344)
print v(xbgr.mr_n77403936)
print v(xbgr.mr_n77404528)
print v(xbgr.mr_n77405120)
print v(xbgr.mr_n77405712)
print v(xbgr.mr_n77425152)
print v(xbgr.mr_n77434672)
print v(xbgr.mr_n77434864)
print v(xbgr.mr_n77435120)
print v(xbgr.mr_n77435376)
print v(xbgr.mr_n77437536)
print v(xbgr.mr_n77443696)
print v(xbgr.mr_n77443808)
print v(xbgr.mr_n77445488)
print v(xbgr.mr_n77446192)
print v(xbgr.mr_n77448544)
print v(xbgr.mr_n77449056)
print v(xbgr.mr_n77450352)
print v(xbgr.mr_n77450864)
print v(xbgr.mr_n77452160)
print v(xbgr.mr_n77452672)
print v(xbgr.mr_n77453888)
print v(xbgr.mr_n77454480)
print v(xbgr.mr_n77455536)
print v(xbgr.mr_n77456288)
print v(xbgr.mr_n77457584)
print v(xbgr.mr_n77458096)
print v(xbgr.mr_n77459312)
print v(xbgr.mr_n77459904)
print v(xbgr.mr_n77461120)
print v(xbgr.mr_n77461712)
print v(xbgr.mr_n77463008)
print v(xbgr.mr_n77463520)
print v(xbgr.mr_n77464816)
print v(xbgr.mr_n77465328)
print v(xbgr.mr_n77466624)
print v(xbgr.mr_n77467136)
print v(xbgr.mr_n77468352)
print v(xbgr.mr_n77468944)
print v(xbgr.mr_n77470240)
print v(xbgr.mr_n77470752)
print v(xbgr.mr_n77472048)
print v(xbgr.mr_n77472560)
print v(xbgr.mr_n77473856)
print v(xbgr.mr_n77474368)
print v(xbgr.mr_n77474480)
print v(xbgr.mr_n77474592)
print v(xbgr.mr_n77474704)
print v(xbgr.mr_n77474976)
print v(xbgr.mr_n77475088)
print v(xbgr.mr_n77475440)
print v(xbgr.mr_n77475552)
print v(xbgr.mr_n77475824)
print v(xbgr.mr_n77476176)
print v(xbgr.mr_n77476288)
print v(xbgr.mr_n77476656)
print v(xbgr.mr_n77477152)
print v(xbgr.mr_n77477632)
print v(xbgr.mr_n77478064)
print v(xbgr.mr_n77478480)
print v(xbgr.mr_n77479168)
print v(xbgr.mr_n77479696)
print v(xbgr.mr_n77480048)
print v(xbgr.mr_n77480368)
print v(xbgr.mr_n77480480)
print v(xbgr.mr_n77481168)
print v(xbgr.mr_n77481792)
print v(xbgr.mr_n77482336)
print v(xbgr.mr_n77482832)
print v(xbgr.mr_n77483184)
print v(xbgr.mr_n77483872)
print v(xbgr.mr_n77484336)
print v(xbgr.mr_n77484752)
print v(xbgr.mr_n77485184)
print v(xbgr.mr_n77485872)
print v(xbgr.mr_n77486560)
print v(xbgr.mr_n77487040)
print v(xbgr.mr_n77487472)
print v(xbgr.mr_n77487888)
print v(xbgr.mr_n77488576)
print v(xbgr.mr_n77489104)
print v(xbgr.mr_n77489456)
print v(xbgr.mr_n77489888)
print v(xbgr.mr_n77490576)
print v(xbgr.mr_n77491200)
print v(xbgr.mr_n77491744)
print v(xbgr.mr_n77492240)
print v(xbgr.mr_n77492592)
print v(xbgr.mr_n77493280)
print v(xbgr.mr_n77493744)
print v(xbgr.mr_n77494160)
print v(xbgr.mr_n77494592)
print v(xbgr.mr_n77495280)
print v(xbgr.mr_n77495968)
print v(xbgr.mr_n77496448)
print v(xbgr.mr_n77496880)
print v(xbgr.mr_n77497296)
print v(xbgr.mr_n77497984)
print v(xbgr.mr_n77498448)
print v(xbgr.mr_n77498864)
print v(xbgr.mr_n77499296)
print v(xbgr.mr_n77499984)
print v(xbgr.mr_n77500672)
print v(xbgr.mr_n77501024)
print v(xbgr.mr_n77501136)
print v(xbgr.mr_n77501328)
print v(xbgr.mr_n77501600)
print v(xbgr.mr_n77501872)
print v(xbgr.mr_n77502144)
print v(xbgr.mr_n77502416)
print v(xbgr.mr_n77502688)
print v(xbgr.mr_n77502960)
print v(xbgr.mr_n77503232)
print v(xbgr.mr_n77503504)
print v(xbgr.mr_n77503776)
print v(xbgr.mr_n77504048)
print v(xbgr.mr_n77504320)
print v(xbgr.mr_n77504592)
print v(xbgr.mr_n77504864)
print v(xbgr.mr_n77505136)
print v(xbgr.mr_n77505408)
print v(xbgr.mr_n77512960)
print v(xbgr.mr_n77522800)
print v(xbgr.mr_n77525744)
print v(xbgr.mr_n77529168)
print v(xbgr.mr_n77529632)
print v(xbgr.mr_n77530096)
print v(xbgr.mr_n77530560)
print v(xbgr.mr_n77531024)
print v(xbgr.mr_n77531488)
print v(xbgr.mr_n77531952)
print v(xbgr.mr_n77532480)
print v(xbgr.mr_n77533072)
print v(xbgr.mr_n77533664)
print v(xbgr.mr_n77534256)
print v(xbgr.mr_n77534848)
print v(xbgr.mr_n77535440)
print v(xbgr.mr_n77536032)
print v(xbgr.mr_n77536624)
print v(xbgr.mr_n77537216)
print v(xbgr.mr_n77537808)
print v(xbgr.mr_n77545152)
print v(xbgr.mr_n77546752)
print v(xbgr.mr_n77553856)
print v(xbgr.mr_n77555648)
print v(xbgr.mr_n77555824)
print v(xbgr.mr_n77556160)
print v(xbgr.mr_n77557936)
print v(xbgr.mr_n77558528)
print v(xbgr.mr_n77559120)
print v(xbgr.mr_n77559712)
print v(xbgr.mr_n77560304)
print v(xbgr.mr_n77560896)
print v(xbgr.mr_n77561488)
print v(xbgr.mr_n77561680)
print v(xbgr.mr_n77562080)
print v(xbgr.mr_n77562672)
print v(xbgr.mr_n77563264)
print v(xbgr.mr_n77563856)
print v(xbgr.mr_n77564448)
print v(xbgr.mr_n77565040)
print v(xbgr.mr_n77565632)
print v(xbgr.mr_n77566224)
print v(xbgr.mr_n77566816)
print v(xbgr.mr_n77567408)
print v(xbgr.mr_n77567856)
print v(xbgr.mr_n77568000)
print v(xbgr.mr_n77568592)
print v(xbgr.mr_n77575840)
print v(xbgr.mr_n77577504)
print v(xbgr.mr_n77578048)
print v(xbgr.mr_n77578224)
print v(xbgr.mr_n77578336)
print v(xbgr.mr_n77578448)
print v(xbgr.mr_n77579040)
print v(xbgr.mr_n77579232)
print v(xbgr.mr_n77580176)
print v(xbgr.mr_n77583424)
print v(xbgr.mr_n77583776)
print v(xbgr.mr_n77583888)
print v(xbgr.mr_n77584592)
print v(xbgr.mr_n77586768)
print v(xbgr.mr_n77587184)
print v(xbgr.mr_n77587296)
print v(xbgr.mr_n77588000)
print v(xbgr.mr_n77590064)
print v(xbgr.mr_n77590176)
print v(xbgr.mr_n77590592)
print v(xbgr.mr_n77590704)
print v(xbgr.mr_n77591408)
print v(xbgr.mr_n77593584)
print v(xbgr.mr_n77594000)
print v(xbgr.mr_n77594112)
print v(xbgr.mr_n77594816)
print v(xbgr.mr_n77596992)
print v(xbgr.mr_n77597408)
print v(xbgr.mr_n77597520)
print v(xbgr.mr_n77598224)
print v(xbgr.mr_n77600400)
print v(xbgr.mr_n77600816)
print v(xbgr.mr_n77600928)
print v(xbgr.mr_n77601632)
print v(xbgr.mr_n77603872)
print v(xbgr.mr_n77604224)
print v(xbgr.mr_n77604336)
print v(xbgr.mr_n77605040)
print v(xbgr.mr_n77607216)
print v(xbgr.mr_n77607632)
print v(xbgr.mr_n77607744)
print v(xbgr.mr_n77608448)
print v(xbgr.mr_n77622400)
print v(xbgr.mr_n77622576)
print v(xbgr.mr_n77623200)
print v(xbgr.mr_n77623376)
print v(xbgr.mr_n77624000)
print v(xbgr.mr_n77624176)
print v(xbgr.mr_n77624800)
print v(xbgr.mr_n77624976)
print v(xbgr.mr_n77625600)
print v(xbgr.mr_n77625776)
print v(xbgr.mr_n77626400)
print v(xbgr.mr_n77626576)
print v(xbgr.mr_n77627200)
print v(xbgr.mr_n77627376)
print v(xbgr.mr_n77628000)
print v(xbgr.mr_n77628176)
print v(xbgr.mr_n77628800)
print v(xbgr.mr_n77628976)
print v(xbgr.mr_n77629600)
print v(xbgr.mr_n77629776)
print v(xbgr.mr_n77630400)
print v(xbgr.mr_n77630576)
print v(xbgr.mr_n77631200)
print v(xbgr.mr_n77631376)
print v(xbgr.mr_n77632000)
print v(xbgr.mr_n77632176)
print v(xbgr.mr_n77632800)
print v(xbgr.mr_n77632976)
print v(xbgr.mr_n77633600)
print v(xbgr.mr_n77633776)
print v(xbgr.mr_n77634400)
print v(xbgr.mr_n77634576)
print v(xbgr.mr_n77635008)
print v(xbgr.mr_n77635120)
print v(xbgr.mr_n77635232)
print v(xbgr.mr_n77635344)
print v(xbgr.mr_n77635536)
print v(xbgr.mr_n77635808)
print v(xbgr.mr_n77636080)
print v(xbgr.mr_n77636352)
print v(xbgr.mr_n77636624)
print v(xbgr.mr_n77636896)
print v(xbgr.mr_n77637168)
print v(xbgr.mr_n77637440)
print v(xbgr.mr_n77637712)
print v(xbgr.mr_n77637984)
print v(xbgr.mr_n77638256)
print v(xbgr.mr_n77638528)
print v(xbgr.mr_n77638800)
print v(xbgr.mr_n77642576)
print v(xbgr.mr_n77644096)
print v(xbgr.mr_n77649936)
print v(xbgr.mr_n77655744)
print v(xbgr.mr_n77661696)
print v(xbgr.mr_n77673344)
print v(xbgr.mr_n77676288)
print v(xbgr.mr_n77676464)
print v(xbgr.mr_n77676800)
print v(xbgr.mr_n77678640)
print v(xbgr.mr_n77678816)
print v(xbgr.mr_n77679760)
print v(xbgr.mr_n77680416)
print v(xbgr.mr_n77680592)
print v(xbgr.mr_n77681536)
print v(xbgr.mr_n77682192)
print v(xbgr.mr_n77682368)
print v(xbgr.mr_n77683312)
print v(xbgr.mr_n77683968)
print v(xbgr.mr_n77684144)
print v(xbgr.mr_n77685088)
print v(xbgr.mr_n77685744)
print v(xbgr.mr_n77685920)
print v(xbgr.mr_n77686864)
print v(xbgr.mr_n77687520)
print v(xbgr.mr_n77687696)
print v(xbgr.mr_n77688640)
print v(xbgr.mr_n77689296)
print v(xbgr.mr_n77689472)
print v(xbgr.mr_n77690416)
print v(xbgr.mr_n77691072)
print v(xbgr.mr_n77691248)
print v(xbgr.mr_n77692192)
print v(xbgr.mr_n77692848)
print v(xbgr.mr_n77693024)
print v(xbgr.mr_n77693968)
print v(xbgr.mr_n77694624)
print v(xbgr.mr_n77694800)
print v(xbgr.mr_n77695840)
print v(xbgr.mr_n77696112)
print v(xbgr.mr_n77696384)
print v(xbgr.mr_n77696720)
print v(xbgr.mr_n77697184)
print v(xbgr.mr_n77697536)
print v(xbgr.mr_n77697728)
print v(xbgr.mr_n77697920)
print v(xbgr.mr_n77698112)
print v(xbgr.mr_n77698864)
print v(xbgr.mr_n77702512)
print v(xbgr.mr_n77702864)
print v(xbgr.mr_n77702976)
print v(xbgr.mr_n77703680)
print v(xbgr.mr_n77705856)
print v(xbgr.mr_n77706272)
print v(xbgr.mr_n77706384)
print v(xbgr.mr_n77707088)
print v(xbgr.mr_n77709264)
print v(xbgr.mr_n77709680)
print v(xbgr.mr_n77709792)
print v(xbgr.mr_n77710496)
print v(xbgr.mr_n77712736)
print v(xbgr.mr_n77713088)
print v(xbgr.mr_n77713200)
print v(xbgr.mr_n77713904)
print v(xbgr.mr_n77714016)
print v(xbgr.mr_n77714128)
print v(xbgr.mr_n77714688)
print v(xbgr.mr_n77717280)
print v(xbgr.mr_n77718176)
print v(xbgr.mr_n77718528)
print v(xbgr.mr_n77718640)
print v(xbgr.mr_n77719344)
print v(xbgr.mr_n77722160)
print v(xbgr.mr_n77722576)
print v(xbgr.mr_n77722688)
print v(xbgr.mr_n77723392)
print v(xbgr.mr_n77725568)
print v(xbgr.mr_n77725984)
print v(xbgr.mr_n77726096)
print v(xbgr.mr_n77726800)
print v(xbgr.mr_n77728720)
print v(xbgr.mr_n77728976)
print v(xbgr.mr_n77729392)
print v(xbgr.mr_n77729504)
print v(xbgr.mr_n77730208)
print v(xbgr.mr_n77742768)
print v(xbgr.mr_n77742944)
print v(xbgr.mr_n77743568)
print v(xbgr.mr_n77743744)
print v(xbgr.mr_n77744368)
print v(xbgr.mr_n77744544)
print v(xbgr.mr_n77745168)
print v(xbgr.mr_n77745344)
print v(xbgr.mr_n77745968)
print v(xbgr.mr_n77746144)
print v(xbgr.mr_n77746768)
print v(xbgr.mr_n77746944)
print v(xbgr.mr_n77747568)
print v(xbgr.mr_n77747744)
print v(xbgr.mr_n77748368)
print v(xbgr.mr_n77748544)
print v(xbgr.mr_n77749168)
print v(xbgr.mr_n77749344)
print v(xbgr.mr_n77749968)
print v(xbgr.mr_n77750144)
print v(xbgr.mr_n77750768)
print v(xbgr.mr_n77750944)
print v(xbgr.mr_n77751568)
print v(xbgr.mr_n77751744)
print v(xbgr.mr_n77752368)
print v(xbgr.mr_n77752544)
print v(xbgr.mr_n77753168)
print v(xbgr.mr_n77753344)
print v(xbgr.mr_n77753968)
print v(xbgr.mr_n77754144)
print v(xbgr.mr_n77754768)
print v(xbgr.mr_n77754944)
print v(xbgr.mr_n77757888)
print v(xbgr.mr_n77761392)
print v(xbgr.mr_n77766576)
print v(xbgr.mr_n77766880)
print v(xbgr.mr_n77767184)
print v(xbgr.mr_n77767488)
print v(xbgr.mr_n77767872)
print v(xbgr.mr_n77768336)
print v(xbgr.mr_n77768800)
print v(xbgr.mr_n77769264)
print v(xbgr.mr_n77769728)
print v(xbgr.mr_n77770192)
print v(xbgr.mr_n77770656)
print v(xbgr.mr_n77771120)
print v(xbgr.mr_n77771584)
print v(xbgr.mr_n77772048)
print v(xbgr.mr_n77772512)
print v(xbgr.mr_n77772976)
print v(xbgr.mr_n77773440)
print v(xbgr.mr_n77773904)
print v(xbgr.mr_n77774368)
print v(xbgr.mr_n77774832)
print v(xbgr.mr_n77775296)
print v(xbgr.mr_n77775760)
print v(xbgr.mr_n77776224)
print v(xbgr.mr_n77776688)
print v(xbgr.mr_n77777152)
print v(xbgr.mr_n77777616)
print v(xbgr.mr_n77778080)
print v(xbgr.mr_n77778544)
print v(xbgr.mr_n77779008)
print v(xbgr.mr_n77779472)
print v(xbgr.mr_n77793280)
print v(xbgr.mr_n77795008)
print v(xbgr.mr_n77796544)
print v(xbgr.mr_n77797072)
print v(xbgr.mr_n77803536)
print v(xbgr.mr_n77804064)
print v(xbgr.mr_n77804528)
print v(xbgr.mr_n77804992)
print v(xbgr.mr_n77805520)
print v(xbgr.mr_n77806112)
print v(xbgr.mr_n77806704)
print v(xbgr.mr_n77807296)
print v(xbgr.mr_n77807888)
print v(xbgr.mr_n77808480)
print v(xbgr.mr_n77809072)
print v(xbgr.mr_n77809664)
print v(xbgr.mr_n77810256)
print v(xbgr.mr_n77810848)
print v(xbgr.mr_n77811440)
print v(xbgr.mr_n77812032)
print v(xbgr.mr_n77812624)
print v(xbgr.mr_n77813216)
print v(xbgr.mr_n77816336)
print v(xbgr.mr_n77818000)
print v(xbgr.mr_n77820960)
print v(xbgr.mr_n77835936)
print v(xbgr.mr_n77836128)
print v(xbgr.mr_n77836384)
print v(xbgr.mr_n77836640)
print v(xbgr.mr_n77838800)
print v(xbgr.mr_n77857984)
print v(xbgr.mr_n77859584)
print v(xbgr.mr_n77869392)
print v(xbgr.mr_n77885808)
print v(xbgr.mr_n77898880)
print v(xbgr.mr_n77901296)
print v(xbgr.mr_n77904240)
print v(xbgr.mr_n77904832)
print v(xbgr.mr_n77905424)
print v(xbgr.mr_n77906016)
print v(xbgr.mr_n77906608)
print v(xbgr.mr_n77907200)
print v(xbgr.mr_n77907792)
print v(xbgr.mr_n77908384)
print v(xbgr.mr_n77908976)
print v(xbgr.mr_n77909568)
print v(xbgr.mr_n77910160)
print v(xbgr.mr_n77910752)
print v(xbgr.mr_n77912432)
print v(xbgr.mr_n77916304)
print v(xbgr.mr_n77917072)
print v(xbgr.mr_n77917248)
print v(xbgr.mr_n77917424)
print v(xbgr.mr_n77919216)
print v(xbgr.mr_n77919744)
print v(xbgr.mr_n77923680)
print v(xbgr.mr_n77924016)
print v(xbgr.mr_n77924352)
print v(xbgr.mr_n77925936)
print v(xbgr.mr_n77926832)
print v(xbgr.mr_n77927008)
print v(xbgr.mr_n77927520)
print v(xbgr.mr_n77928016)
print v(xbgr.mr_n77928192)
print v(xbgr.mr_n77928528)
print v(xbgr.mr_n77929120)
print v(xbgr.mr_n77929616)
print v(xbgr.mr_n77929952)
print v(xbgr.mr_n77930464)
print v(xbgr.mr_n77930576)
print v(xbgr.mr_n77930688)
print v(xbgr.mr_n77931680)
print v(xbgr.mr_n77932016)
print v(xbgr.mr_n77932608)
print v(xbgr.mr_n77933104)
print v(xbgr.mr_n77933280)
print v(xbgr.mr_n77933616)
print v(xbgr.mr_n77934208)
print v(xbgr.mr_n77934768)
print v(xbgr.mr_n77934944)
print v(xbgr.mr_n77935200)
print v(xbgr.mr_n77936208)
print v(xbgr.mr_n77936384)
print v(xbgr.mr_n77936640)
print v(xbgr.mr_n77937152)
print v(xbgr.mr_n77937264)
print v(xbgr.mr_n77937376)
print v(xbgr.mr_n77937488)
print v(xbgr.mr_n77938976)
print v(xbgr.mr_n77939152)
print v(xbgr.mr_n77939728)
print v(xbgr.mr_n77940432)
print v(xbgr.mr_n77940608)
print v(xbgr.mr_n77941040)
print v(xbgr.mr_n77941152)
print v(xbgr.mr_n77941984)
print v(xbgr.mr_n77942160)
print v(xbgr.mr_n77942416)
print v(xbgr.mr_n77942992)
print v(xbgr.mr_n77943776)
print v(xbgr.mr_n77943952)
print v(xbgr.mr_n77944384)
print v(xbgr.mr_n77944944)
print v(xbgr.mr_n77945120)
print v(xbgr.mr_n77945456)
print v(xbgr.mr_n77946128)
print v(xbgr.mr_n77946240)
print v(xbgr.mr_n77946944)
print v(xbgr.mr_n77947280)
print v(xbgr.mr_n77947872)
print v(xbgr.mr_n77948368)
print v(xbgr.mr_n77948544)
print v(xbgr.mr_n77948880)
print v(xbgr.mr_n77949472)
print v(xbgr.mr_n77949968)
print v(xbgr.mr_n77950304)
print v(xbgr.mr_n77950816)
print v(xbgr.mr_n77950928)
print v(xbgr.mr_n77951040)
print v(xbgr.mr_n77952160)
print v(xbgr.mr_n77952336)
print v(xbgr.mr_n77952592)
print v(xbgr.mr_n77953248)
print v(xbgr.mr_n77953760)
print v(xbgr.mr_n77953872)
print v(xbgr.mr_n77954064)
print v(xbgr.mr_n77954416)
print v(xbgr.mr_n77954528)
print v(xbgr.mr_n77955040)
print v(xbgr.mr_n77955152)
print v(xbgr.mr_n77955264)
print v(xbgr.mr_n77955616)
print v(xbgr.mr_n77955952)
print v(xbgr.mr_n77956896)
print v(xbgr.mr_n77957312)
print v(xbgr.mr_n77957424)
print v(xbgr.mr_n77957984)
print v(xbgr.mr_n77958240)
print v(xbgr.mr_n77959056)
print v(xbgr.mr_n77959488)
print v(xbgr.mr_n77959664)
print v(xbgr.mr_n77960592)
print v(xbgr.mr_n77960768)
print v(xbgr.mr_n77961344)
print v(xbgr.mr_n77961456)
print v(xbgr.mr_n77961568)
print v(xbgr.mr_n77962336)
print v(xbgr.mr_n77962672)
print v(xbgr.mr_n77963616)
print v(xbgr.mr_n77964032)
print v(xbgr.mr_n77964144)
print v(xbgr.mr_n77964704)
print v(xbgr.mr_n77964960)
print v(xbgr.mr_n77965904)
print v(xbgr.mr_n77966320)
print v(xbgr.mr_n77966432)
print v(xbgr.mr_n77966544)
print v(xbgr.mr_n77967312)
print v(xbgr.mr_n77967648)
print v(xbgr.mr_n77968656)
print v(xbgr.mr_n77968832)
print v(xbgr.mr_n77969408)
print v(xbgr.mr_n77969840)
print v(xbgr.mr_n77970016)
print v(xbgr.mr_n77970752)
print v(xbgr.mr_n77970864)
print v(xbgr.mr_n77971424)
print v(xbgr.mr_n77971680)
print v(xbgr.mr_n77972624)
print v(xbgr.mr_n77973040)
print v(xbgr.mr_n77973152)
print v(xbgr.mr_n77973264)
print v(xbgr.mr_n77974032)
print v(xbgr.mr_n77974368)
print v(xbgr.mr_n77975184)
print v(xbgr.mr_n77975296)
print v(xbgr.mr_n77975856)
print v(xbgr.mr_n77975968)
print v(xbgr.mr_n77976112)
print v(xbgr.mr_n77977056)
print v(xbgr.mr_n77977472)
print v(xbgr.mr_n77977584)
print v(xbgr.mr_n77978144)
print v(xbgr.mr_n77978400)
print v(xbgr.mr_n77979216)
print v(xbgr.mr_n77979648)
print v(xbgr.mr_n77979824)
print v(xbgr.mr_n77982304)
print v(xbgr.mr_n77984192)
print v(xbgr.mr_n77984656)
print v(xbgr.mr_n77985120)
print v(xbgr.mr_n77985584)
print v(xbgr.mr_n77986048)
print v(xbgr.mr_n77986512)
print v(xbgr.mr_n77986976)
print v(xbgr.mr_n77987440)
print v(xbgr.mr_n77987904)
print v(xbgr.mr_n77988368)
print v(xbgr.mr_n77988832)
print v(xbgr.mr_n77989296)
print v(xbgr.mr_n77989760)
print v(xbgr.mr_n77990224)
print v(xbgr.mr_n77990688)
print v(xbgr.mr_n77991152)
print v(xbgr.mr_n77991616)
print v(xbgr.mr_n77992080)
print v(xbgr.mr_n77992544)
print v(xbgr.mr_n77993008)
print v(xbgr.mr_n77993472)
print v(xbgr.mr_n77993936)
print v(xbgr.mr_n77994384)
print v(xbgr.mr_n77994848)
print v(xbgr.mr_n77995312)
print v(xbgr.mr_n77995776)
print v(xbgr.mr_n77996240)
print v(xbgr.mr_n77996704)
print v(xbgr.mr_n78003152)
print v(xbgr.mr_n78004880)
print v(xbgr.mr_n78009680)
print v(xbgr.mr_n78010352)
print v(xbgr.mr_n78014464)
print v(xbgr.mr_n78014896)
print v(xbgr.mr_n78015968)
print v(xbgr.mr_n78019312)
print v(xbgr.mr_n78021712)
print v(xbgr.mr_n78028176)
print v(xbgr.mr_n78028320)
print v(xbgr.mr_n78030128)
print v(xbgr.mr_n78030640)
print v(xbgr.mr_n78032272)
print v(xbgr.mr_n78035184)
print v(xbgr.mr_n78039856)
print v(xbgr.mr_n78040192)
print v(xbgr.mr_n78040528)
print v(xbgr.mr_n78040864)
print v(xbgr.mr_n78042752)
print v(xbgr.mr_n78043536)
print v(xbgr.mr_n78043648)
print v(xbgr.mr_n78045536)
print v(xbgr.mr_n78045648)
print v(xbgr.mr_n78047344)
print v(xbgr.mr_n78047456)
print v(xbgr.mr_n78049152)
print v(xbgr.mr_n78049264)
print v(xbgr.mr_n78050960)
print v(xbgr.mr_n78051072)
print v(xbgr.mr_n78052768)
print v(xbgr.mr_n78052880)
print v(xbgr.mr_n78054576)
print v(xbgr.mr_n78054688)
print v(xbgr.mr_n78056384)
print v(xbgr.mr_n78056496)
print v(xbgr.mr_n78058192)
print v(xbgr.mr_n78058304)
print v(xbgr.mr_n78060000)
print v(xbgr.mr_n78060112)
print v(xbgr.mr_n78061808)
print v(xbgr.mr_n78061920)
print v(xbgr.mr_n78063616)
print v(xbgr.mr_n78063728)
print v(xbgr.mr_n78065424)
print v(xbgr.mr_n78065536)
print v(xbgr.mr_n78067232)
print v(xbgr.mr_n78067344)
print v(xbgr.mr_n78069040)
print v(xbgr.mr_n78069152)
print v(xbgr.mr_n78070848)
print v(xbgr.mr_n78070960)
print v(xbgr.mr_n78072656)
print v(xbgr.mr_n78072768)
print v(xbgr.mr_n78080000)
print v(xbgr.mr_n78089648)
print v(xbgr.mr_n78098768)
print v(xbgr.mr_n78099232)
print v(xbgr.mr_n78099344)
print v(xbgr.mr_n78100160)
print v(xbgr.mr_n78100624)
print v(xbgr.mr_n78100736)
print v(xbgr.mr_n78101552)
print v(xbgr.mr_n78102080)
print v(xbgr.mr_n78102256)
print v(xbgr.mr_n78103200)
print v(xbgr.mr_n78103856)
print v(xbgr.mr_n78104032)
print v(xbgr.mr_n78104976)
print v(xbgr.mr_n78105632)
print v(xbgr.mr_n78105808)
print v(xbgr.mr_n78106752)
print v(xbgr.mr_n78107408)
print v(xbgr.mr_n78107584)
print v(xbgr.mr_n78108528)
print v(xbgr.mr_n78109184)
print v(xbgr.mr_n78109360)
print v(xbgr.mr_n78110304)
print v(xbgr.mr_n78110960)
print v(xbgr.mr_n78111136)
print v(xbgr.mr_n78112080)
print v(xbgr.mr_n78112736)
print v(xbgr.mr_n78112912)
print v(xbgr.mr_n78113856)
print v(xbgr.mr_n78114448)
print v(xbgr.mr_n78115040)
print v(xbgr.mr_n78115632)
print v(xbgr.mr_n78116224)
print v(xbgr.mr_n78116816)
print v(xbgr.mr_n78117408)
print v(xbgr.mr_n78118000)
print v(xbgr.mr_n78118592)
print v(xbgr.mr_n78118896)
print v(xbgr.mr_n78119008)
print v(xbgr.mr_n78119120)
print v(xbgr.mr_n78119232)
print v(xbgr.mr_n78119344)
print v(xbgr.mr_n78122224)
print v(xbgr.mr_n78122816)
print v(xbgr.mr_n78123408)
print v(xbgr.mr_n78124000)
print v(xbgr.mr_n78124592)
print v(xbgr.mr_n78125184)
print v(xbgr.mr_n78125776)
print v(xbgr.mr_n78126368)
print v(xbgr.mr_n78126960)
print v(xbgr.mr_n78127552)
print v(xbgr.mr_n78128144)
print v(xbgr.mr_n78128736)
print v(xbgr.mr_n78129328)
print v(xbgr.mr_n78129920)
print v(xbgr.mr_n78130512)
print v(xbgr.mr_n78131104)
print v(xbgr.mr_n78131696)
print v(xbgr.mr_n78132288)
print v(xbgr.mr_n78132880)
print v(xbgr.mr_n78134304)
print v(xbgr.mr_n78136800)
print v(xbgr.mr_n78138416)
print v(xbgr.mr_n78141792)
print v(xbgr.mr_n78142048)
print v(xbgr.mr_n78149696)
print v(xbgr.mr_n78150032)
print v(xbgr.mr_n78150688)
print v(xbgr.mr_n78151200)
print v(xbgr.mr_n78151312)
print v(xbgr.mr_n78153008)
print v(xbgr.mr_n78153120)
print v(xbgr.mr_n78154816)
print v(xbgr.mr_n78154928)
print v(xbgr.mr_n78156624)
print v(xbgr.mr_n78156736)
print v(xbgr.mr_n78158432)
print v(xbgr.mr_n78158544)
print v(xbgr.mr_n78160240)
print v(xbgr.mr_n78160352)
print v(xbgr.mr_n78162048)
print v(xbgr.mr_n78162160)
print v(xbgr.mr_n78163856)
print v(xbgr.mr_n78163968)
print v(xbgr.mr_n78165664)
print v(xbgr.mr_n78165776)
print v(xbgr.mr_n78167472)
print v(xbgr.mr_n78167584)
print v(xbgr.mr_n78169280)
print v(xbgr.mr_n78169392)
print v(xbgr.mr_n78169504)
print v(xbgr.mr_n78171344)
print v(xbgr.mr_n78171456)
print v(xbgr.mr_n78171568)
print v(xbgr.mr_n78173408)
print v(xbgr.mr_n78173520)
print v(xbgr.mr_n78173632)
print v(xbgr.mr_n78175472)
print v(xbgr.mr_n78175584)
print v(xbgr.mr_n78175696)
print v(xbgr.mr_n78177536)
print v(xbgr.mr_n78177648)
print v(xbgr.mr_n78177760)
print v(xbgr.mr_n78179600)
print v(xbgr.mr_n78179712)
print v(xbgr.mr_n78179824)
print v(xbgr.mr_n78181664)
print v(xbgr.mr_n78181776)
print v(xbgr.mr_n78181888)
print v(xbgr.mr_n78182800)
print v(xbgr.mr_n78183152)
print v(xbgr.mr_n78183664)
print v(xbgr.mr_n78184208)
print v(xbgr.mr_n78184752)
print v(xbgr.mr_n78185296)
print v(xbgr.mr_n78185840)
print v(xbgr.mr_n78186384)
print v(xbgr.mr_n78186848)
print v(xbgr.mr_n78187392)
print v(xbgr.mr_n78187936)
print v(xbgr.mr_n78188480)
print v(xbgr.mr_n78189024)
print v(xbgr.mr_n78189568)
print v(xbgr.mr_n78190112)
print v(xbgr.mr_n78190656)
print v(xbgr.mr_n78191200)
print v(xbgr.mr_n78191744)
print v(xbgr.mr_n78192288)
print v(xbgr.mr_n78192832)
print v(xbgr.mr_n78193376)
print v(xbgr.mr_n78193920)
print v(xbgr.mr_n78194384)
print v(xbgr.mr_n78194928)
print v(xbgr.mr_n78195472)
print v(xbgr.mr_n78196016)
print v(xbgr.mr_n78196560)
print v(xbgr.mr_n78197104)
print v(xbgr.mr_n78197840)
print v(xbgr.mr_n78198144)
print v(xbgr.mr_n78198528)
print v(xbgr.mr_n78198992)
print v(xbgr.mr_n78199456)
print v(xbgr.mr_n78199920)
print v(xbgr.mr_n78200384)
print v(xbgr.mr_n78200848)
print v(xbgr.mr_n78201312)
print v(xbgr.mr_n78201776)
print v(xbgr.mr_n78202240)
print v(xbgr.mr_n78202704)
print v(xbgr.mr_n78203168)
print v(xbgr.mr_n78203632)
print v(xbgr.mr_n78204096)
print v(xbgr.mr_n78204560)
print v(xbgr.mr_n78205024)
print v(xbgr.mr_n78205488)
print v(xbgr.mr_n78205952)
print v(xbgr.mr_n78206416)
print v(xbgr.mr_n78206880)
print v(xbgr.mr_n78207344)
print v(xbgr.mr_n78207808)
print v(xbgr.mr_n78208304)
print v(xbgr.mr_n78208896)
print v(xbgr.mr_n78209488)
print v(xbgr.mr_n78210080)
print v(xbgr.mr_n78210672)
print v(xbgr.mr_n78211264)
print v(xbgr.mr_n78211856)
print v(xbgr.mr_n78215920)
print v(xbgr.mr_n78216352)
print v(xbgr.mr_n78216928)
print v(xbgr.mr_n78220928)
print v(xbgr.mr_n78222544)
print v(xbgr.mr_n78222800)
print v(xbgr.mr_n78225536)
print v(xbgr.mr_n78231840)
print v(xbgr.mr_n78232048)
print v(xbgr.mr_n78239584)
print v(xbgr.mr_n78239824)
print v(xbgr.mr_n78245472)
print v(xbgr.mr_n78246176)
print v(xbgr.mr_n78246352)
print v(xbgr.mr_n78246528)
print v(xbgr.mr_n78250208)
print v(xbgr.mr_n78255296)
print v(xbgr.mr_n78257040)
print v(xbgr.mr_n78258832)
print v(xbgr.mr_n78259984)
print v(xbgr.mr_n78265216)
print v(xbgr.mr_n78265392)
print v(xbgr.mr_n78267264)
print v(xbgr.mr_n78267872)
print v(xbgr.mr_n78271264)
print v(xbgr.mr_n78275200)
print v(xbgr.mr_n78275824)
print v(xbgr.mr_n78277648)
print v(xbgr.mr_n78280688)
print v(xbgr.mr_n78284864)
print v(xbgr.mr_n78291904)
print v(xbgr.mr_n78297968)
print v(xbgr.mr_n78300528)
print v(xbgr.mr_n78300704)
print v(xbgr.mr_n78300880)
print v(xbgr.mr_n78304432)
print v(xbgr.mr_n78304880)
print v(xbgr.mr_n78305744)
print v(xbgr.mr_n78308624)
print v(xbgr.mr_n78309216)
print v(xbgr.mr_n78309440)
print v(xbgr.mr_n78309616)
print v(xbgr.mr_n78315024)
print v(xbgr.mr_n78319552)
print v(xbgr.mr_n78319888)
print v(xbgr.mr_n78320224)
print v(xbgr.mr_n78320560)
print v(xbgr.mr_n78320976)
print v(xbgr.mr_n78321216)
print v(xbgr.mr_n78321520)
print v(xbgr.mr_n78322112)
print v(xbgr.mr_n78322224)
print v(xbgr.mr_n78322336)
print v(xbgr.mr_n78324176)
print v(xbgr.mr_n78324288)
print v(xbgr.mr_n78324400)
print v(xbgr.mr_n78326240)
print v(xbgr.mr_n78326352)
print v(xbgr.mr_n78326464)
print v(xbgr.mr_n78328304)
print v(xbgr.mr_n78328416)
print v(xbgr.mr_n78328528)
print v(xbgr.mr_n78330368)
print v(xbgr.mr_n78330480)
print v(xbgr.mr_n78330592)
print v(xbgr.mr_n78332432)
print v(xbgr.mr_n78332544)
print v(xbgr.mr_n78332656)
print v(xbgr.mr_n78334496)
print v(xbgr.mr_n78334608)
print v(xbgr.mr_n78334720)
print v(xbgr.mr_n78336560)
print v(xbgr.mr_n78336672)
print v(xbgr.mr_n78336784)
print v(xbgr.mr_n78338624)
print v(xbgr.mr_n78338736)
print v(xbgr.mr_n78338848)
print v(xbgr.mr_n78340688)
print v(xbgr.mr_n78340800)
print v(xbgr.mr_n78340912)
print v(xbgr.mr_n78342752)
print v(xbgr.mr_n78342864)
print v(xbgr.mr_n78342976)
print v(xbgr.mr_n78344816)
print v(xbgr.mr_n78344928)
print v(xbgr.mr_n78345040)
print v(xbgr.mr_n78346880)
print v(xbgr.mr_n78346992)
print v(xbgr.mr_n78347104)
print v(xbgr.mr_n78349648)
print v(xbgr.mr_n78349760)
print v(xbgr.mr_n78350128)
print v(xbgr.mr_n78353632)
print v(xbgr.mr_n78353744)
print v(xbgr.mr_n78354112)
print v(xbgr.mr_n78355872)
print v(xbgr.mr_n78357616)
print v(xbgr.mr_n78357728)
print v(xbgr.mr_n78358096)
print v(xbgr.mr_n78359824)
print v(xbgr.mr_n78361600)
print v(xbgr.mr_n78361712)
print v(xbgr.mr_n78362080)
print v(xbgr.mr_n78363408)
print v(xbgr.mr_n78364672)
print v(xbgr.mr_n78364784)
print v(xbgr.mr_n78366288)
print v(xbgr.mr_n78367008)
print v(xbgr.mr_n78367184)
print v(xbgr.mr_n78367952)
print v(xbgr.mr_n78368752)
print v(xbgr.mr_n78369568)
print v(xbgr.mr_n78369744)
print v(xbgr.mr_n78371312)
print v(xbgr.mr_n78372128)
print v(xbgr.mr_n78372304)
print v(xbgr.mr_n78373872)
print v(xbgr.mr_n78374688)
print v(xbgr.mr_n78374864)
print v(xbgr.mr_n78376432)
print v(xbgr.mr_n78377248)
print v(xbgr.mr_n78377424)
print v(xbgr.mr_n78378992)
print v(xbgr.mr_n78379808)
print v(xbgr.mr_n78379984)
print v(xbgr.mr_n78380608)
print v(xbgr.mr_n78381552)
print v(xbgr.mr_n78382368)
print v(xbgr.mr_n78382544)
print v(xbgr.mr_n78384112)
print v(xbgr.mr_n78384928)
print v(xbgr.mr_n78385104)
print v(xbgr.mr_n78386672)
print v(xbgr.mr_n78387488)
print v(xbgr.mr_n78387664)
print v(xbgr.mr_n78389232)
print v(xbgr.mr_n78389904)
print v(xbgr.mr_n78390688)
print v(xbgr.mr_n78390864)
print v(xbgr.mr_n78391616)
print v(xbgr.mr_n78391728)
print v(xbgr.mr_n78393312)
print v(xbgr.mr_n78393808)
print v(xbgr.mr_n78393920)
print v(xbgr.mr_n78396640)
print v(xbgr.mr_n78397808)
print v(xbgr.mr_n78397984)
print v(xbgr.mr_n78399552)
print v(xbgr.mr_n78400368)
print v(xbgr.mr_n78400544)
print v(xbgr.mr_n78402112)
print v(xbgr.mr_n78402928)
print v(xbgr.mr_n78403104)
print v(xbgr.mr_n78404672)
print v(xbgr.mr_n78405488)
print v(xbgr.mr_n78405664)
print v(xbgr.mr_n78406368)
print v(xbgr.mr_n78407232)
print v(xbgr.mr_n78408048)
print v(xbgr.mr_n78408224)
print v(xbgr.mr_n78409792)
print v(xbgr.mr_n78410608)
print v(xbgr.mr_n78410784)
print v(xbgr.mr_n78411168)
print v(xbgr.mr_n78412352)
print v(xbgr.mr_n78413168)
print v(xbgr.mr_n78413344)
print v(xbgr.mr_n78414912)
print v(xbgr.mr_n78415728)
print v(xbgr.mr_n78415904)
print v(xbgr.mr_n78417472)
print v(xbgr.mr_n78418288)
print v(xbgr.mr_n78418464)
print v(xbgr.mr_n78420032)
print v(xbgr.mr_n78420848)
print v(xbgr.mr_n78421024)
print v(xbgr.mr_n78422592)
print v(xbgr.mr_n78423408)
print v(xbgr.mr_n78423584)
print v(xbgr.mr_n78424016)
print v(xbgr.mr_n78425152)
print v(xbgr.mr_n78425968)
print v(xbgr.mr_n78426144)
print v(xbgr.mr_n78427712)
print v(xbgr.mr_n78428528)
print v(xbgr.mr_n78428704)
print v(xbgr.mr_n78430272)
print v(xbgr.mr_n78431088)
print v(xbgr.mr_n78431264)
print v(xbgr.mr_n78432832)
print v(xbgr.mr_n78474624)
print v(xbgr.mr_n78516816)
print v(xbgr.mr_n78531920)
print v(xbgr.mr_n78538768)
print v(xbgr.mr_n78542784)
print v(xbgr.mr_n78543584)
print v(xbgr.mr_n78543760)
print v(xbgr.mr_n78544112)
print v(xbgr.mr_n78545984)
print v(xbgr.mr_n78546336)
print v(xbgr.mr_n78547376)
print v(xbgr.mr_n78549360)
print v(xbgr.mr_n78550160)
print v(xbgr.mr_n78550336)
print v(xbgr.mr_n78551760)
print v(xbgr.mr_n78552800)
print v(xbgr.mr_n78553392)
print v(xbgr.mr_n78553840)
print v(xbgr.mr_n78651296)
print v(xbgr.mr_n78651408)
print v(xbgr.mr_n78652240)
print v(xbgr.mr_n78652352)
print v(xbgr.mr_n78653184)
print v(xbgr.mr_n78653296)
print v(xbgr.mr_n78654128)
print v(xbgr.mr_n78654240)
print v(xbgr.mr_n78655072)
print v(xbgr.mr_n78655184)
print v(xbgr.mr_n78656016)
print v(xbgr.mr_n78656128)
print v(xbgr.mr_n78656960)
print v(xbgr.mr_n78657072)
print v(xbgr.mr_n78657904)
print v(xbgr.mr_n78658016)
print v(xbgr.mr_n78658848)
print v(xbgr.mr_n78658960)
print v(xbgr.mr_n78661040)
print v(xbgr.mr_n78661312)
print v(xbgr.mr_n78661504)
print v(xbgr.mr_n78662272)
print v(xbgr.mr_n78662640)
print v(xbgr.mr_n78662912)
print v(xbgr.mr_n78663024)
print v(xbgr.mr_n78663136)
print v(xbgr.mr_n78664000)
print v(xbgr.mr_n78664272)
print v(xbgr.mr_n78664464)
print v(xbgr.mr_n78666720)
print v(xbgr.mr_n78669840)
print v(xbgr.mr_n78672816)
print v(xbgr.mr_n78674160)
print v(xbgr.mr_n78674352)
print v(xbgr.mr_n78676896)
print v(xbgr.mr_n78678512)
print v(xbgr.mr_n78680192)
print v(xbgr.mr_n78682448)
print v(xbgr.mr_n78684704)
print v(xbgr.mr_n78686960)
print v(xbgr.mr_n78689216)
print v(xbgr.mr_n78691472)
print v(xbgr.mr_n78693728)
print v(xbgr.mr_n78695984)
print v(xbgr.mr_n78705280)
print v(xbgr.mr_n78706352)
print v(xbgr.mr_n78716384)
print v(xbgr.mr_n78720880)
print v(xbgr.mr_n78722032)
print v(xbgr.mr_n78722144)
print v(xbgr.mr_n78722768)
print v(xbgr.mr_n78724304)
print v(xbgr.mr_n78725168)
print v(xbgr.mr_n78726128)
print v(xbgr.mr_n78726240)
print v(xbgr.mr_n78727184)
print v(xbgr.mr_n78728336)
print v(xbgr.mr_n78728448)
print v(xbgr.mr_n78729072)
print v(xbgr.mr_n78730608)
print v(xbgr.mr_n78731472)
print v(xbgr.mr_n78732432)
print v(xbgr.mr_n78732544)
print v(xbgr.mr_n78733488)
print v(xbgr.mr_n78734640)
print v(xbgr.mr_n78734752)
print v(xbgr.mr_n78735376)
print v(xbgr.mr_n78736912)
print v(xbgr.mr_n78737776)
print v(xbgr.mr_n78738736)
print v(xbgr.mr_n78738848)
print v(xbgr.mr_n78739792)
print v(xbgr.mr_n78740944)
print v(xbgr.mr_n78741056)
print v(xbgr.mr_n78741680)
print v(xbgr.mr_n78743216)
print v(xbgr.mr_n78744080)
print v(xbgr.mr_n78745040)
print v(xbgr.mr_n78745152)
print v(xbgr.mr_n78746096)
print v(xbgr.mr_n78747248)
print v(xbgr.mr_n78747360)
print v(xbgr.mr_n78747984)
print v(xbgr.mr_n78749520)
print v(xbgr.mr_n78750384)
print v(xbgr.mr_n78751344)
print v(xbgr.mr_n78751456)
print v(xbgr.mr_n78752400)
print v(xbgr.mr_n78753552)
print v(xbgr.mr_n78753664)
print v(xbgr.mr_n78754288)
print v(xbgr.mr_n78756464)
print v(xbgr.mr_n78756800)
print v(xbgr.mr_n78757984)
print v(xbgr.mr_n78758128)
print v(xbgr.mr_n78758720)
print v(xbgr.mr_n78759280)
print v(xbgr.mr_n78759968)
print v(xbgr.mr_n78760720)
print v(xbgr.mr_n78761664)
print v(xbgr.mr_n78762608)
print v(xbgr.mr_n78763552)
print v(xbgr.mr_n78764496)
print v(xbgr.mr_n78765440)
print v(xbgr.mr_n78766384)
print v(xbgr.mr_n78767328)
print v(xbgr.mr_n78768272)
print v(xbgr.mr_n78769216)
print v(xbgr.mr_n78770160)
print v(xbgr.mr_n78771104)
print v(xbgr.mr_n78772048)
print v(xbgr.mr_n78772992)
print v(xbgr.mr_n78773936)
print v(xbgr.mr_n78774880)
print v(xbgr.mr_n78775824)
print v(xbgr.mr_n78776768)
print v(xbgr.mr_n78777712)
print v(xbgr.mr_n78778656)
print v(xbgr.mr_n78779600)
print v(xbgr.mr_n78780544)
print v(xbgr.mr_n78781488)
print v(xbgr.mr_n78782432)
print v(xbgr.mr_n78783376)
print v(xbgr.mr_n78784320)
print v(xbgr.mr_n78785264)
print v(xbgr.mr_n78786208)
print v(xbgr.mr_n78787152)
print v(xbgr.mr_n78788096)
print v(xbgr.mr_n78789040)
print v(xbgr.mr_n78789984)
print v(xbgr.mr_n78790928)
print v(xbgr.mr_n78794848)
print v(xbgr.mr_n78795632)
print v(xbgr.mr_n78796720)
print v(xbgr.mr_n78796832)
print v(xbgr.mr_n78798368)
print v(xbgr.mr_n78798480)
print v(xbgr.mr_n78800464)
print v(xbgr.mr_n78800576)
print v(xbgr.mr_n78801728)
print v(xbgr.mr_n78801840)
print v(xbgr.mr_n78802992)
print v(xbgr.mr_n78803104)
print v(xbgr.mr_n78804192)
print v(xbgr.mr_n78804304)
print v(xbgr.mr_n78805520)
print v(xbgr.mr_n78805632)
print v(xbgr.mr_n78806784)
print v(xbgr.mr_n78806896)
print v(xbgr.mr_n78808048)
print v(xbgr.mr_n78808160)
print v(xbgr.mr_n78809312)
print v(xbgr.mr_n78809424)
print v(xbgr.mr_n78810576)
print v(xbgr.mr_n78810688)
print v(xbgr.mr_n78811776)
print v(xbgr.mr_n78811888)
print v(xbgr.mr_n78812000)
print v(xbgr.mr_n78817888)
print v(xbgr.mr_n78823456)
print v(xbgr.mr_n78824352)
print v(xbgr.mr_n78828256)
print v(xbgr.mr_n78829024)
print v(xbgr.mr_n78829280)
print v(xbgr.mr_n78829536)
print v(xbgr.mr_n78829792)
print v(xbgr.mr_n78832384)
print v(xbgr.mr_n78832496)
print v(xbgr.mr_n78833968)
print v(xbgr.mr_n78834752)
print v(xbgr.mr_n78838048)
print v(xbgr.mr_n78840736)
print v(xbgr.mr_n78841984)
print v(xbgr.mr_n78842096)
print v(xbgr.mr_n78844096)
print v(xbgr.mr_n78845840)
print v(xbgr.mr_n78846112)
print v(xbgr.mr_n78846304)
print v(xbgr.mr_n78849536)
print v(xbgr.mr_n78849728)
print v(xbgr.mr_n78853872)
print v(xbgr.mr_n78854144)
print v(xbgr.mr_n78854336)
print v(xbgr.mr_n78857568)
print v(xbgr.mr_n78857760)
print v(xbgr.mr_n78860576)
print v(xbgr.mr_n78861904)
print v(xbgr.mr_n78862176)
print v(xbgr.mr_n78862368)
print v(xbgr.mr_n78865600)
print v(xbgr.mr_n78865792)
print v(xbgr.mr_n78869936)
print v(xbgr.mr_n78870208)
print v(xbgr.mr_n78870400)
print v(xbgr.mr_n78874128)
print v(xbgr.mr_n78875376)
print v(xbgr.mr_n78875488)
print v(xbgr.mr_n78878528)
print v(xbgr.mr_n78878720)
print v(xbgr.mr_n78878912)
print v(xbgr.mr_n78880160)
print v(xbgr.mr_n78880272)
print v(xbgr.mr_n78881888)
print v(xbgr.mr_n78884688)
print v(xbgr.mr_n78885936)
print v(xbgr.mr_n78886048)
print v(xbgr.mr_n78897984)
print v(xbgr.mr_n78898816)
print v(xbgr.mr_n78898928)
print v(xbgr.mr_n78899760)
print v(xbgr.mr_n78899872)
print v(xbgr.mr_n78900704)
print v(xbgr.mr_n78900816)
print v(xbgr.mr_n78901904)
print v(xbgr.mr_n78902016)
print v(xbgr.mr_n78903168)
print v(xbgr.mr_n78903280)
print v(xbgr.mr_n78904432)
print v(xbgr.mr_n78904544)
print v(xbgr.mr_n78905696)
print v(xbgr.mr_n78905808)
print v(xbgr.mr_n78906960)
print v(xbgr.mr_n78907072)
print v(xbgr.mr_n78908224)
print v(xbgr.mr_n78908336)
print v(xbgr.mr_n78909488)
print v(xbgr.mr_n78909600)
print v(xbgr.mr_n78910752)
print v(xbgr.mr_n78910864)
print v(xbgr.mr_n78912016)
print v(xbgr.mr_n78912128)
print v(xbgr.mr_n78913280)
print v(xbgr.mr_n78913392)
print v(xbgr.mr_n78914544)
print v(xbgr.mr_n78914656)
print v(xbgr.mr_n78915808)
print v(xbgr.mr_n78915920)
print v(xbgr.mr_n78920896)
print v(xbgr.mr_n78923328)
print v(xbgr.mr_n78924016)
print v(xbgr.mr_n78924704)
print v(xbgr.mr_n78925424)
print v(xbgr.mr_n78927040)
print v(xbgr.mr_n78928432)
print v(xbgr.mr_n78929376)
print v(xbgr.mr_n78930016)
print v(xbgr.mr_n78930736)
print v(xbgr.mr_n78932816)
print v(xbgr.mr_n78934000)
print v(xbgr.mr_n78935344)
print v(xbgr.mr_n78935888)
print v(xbgr.mr_n78937232)
print v(xbgr.mr_n78937776)
print v(xbgr.mr_n78939120)
print v(xbgr.mr_n78939664)
print v(xbgr.mr_n78940240)
print v(xbgr.mr_n78941008)
print v(xbgr.mr_n78941552)
print v(xbgr.mr_n78942896)
print v(xbgr.mr_n78943440)
print v(xbgr.mr_n78944720)
print v(xbgr.mr_n78945264)
print v(xbgr.mr_n78946672)
print v(xbgr.mr_n78947216)
print v(xbgr.mr_n78948560)
print v(xbgr.mr_n78949104)
print v(xbgr.mr_n78950384)
print v(xbgr.mr_n78950928)
print v(xbgr.mr_n78952336)
print v(xbgr.mr_n78953200)
print v(xbgr.mr_n78954160)
print v(xbgr.mr_n78954272)
print v(xbgr.mr_n78955216)
print v(xbgr.mr_n78956368)
print v(xbgr.mr_n78956480)
print v(xbgr.mr_n78957424)
print v(xbgr.mr_n78958576)
print v(xbgr.mr_n78958688)
print v(xbgr.mr_n78963600)
print v(xbgr.mr_n78968352)
print v(xbgr.mr_n78973040)
print v(xbgr.mr_n78974224)
print v(xbgr.mr_n78974912)
print v(xbgr.mr_n78975600)
print v(xbgr.mr_n78976320)
print v(xbgr.mr_n78977264)
print v(xbgr.mr_n78977456)
print v(xbgr.mr_n78977648)
print v(xbgr.mr_n78977840)
print v(xbgr.mr_n78978032)
print v(xbgr.mr_n78978224)
print v(xbgr.mr_n78980368)
print v(xbgr.mr_n78980480)
print v(xbgr.mr_n78982496)
print v(xbgr.mr_n78984512)
print v(xbgr.mr_n78984624)
print v(xbgr.mr_n78990272)
print v(xbgr.mr_n78991216)
print v(xbgr.mr_n78996256)
print v(xbgr.mr_n79006240)
print v(xbgr.mr_n79007184)
print v(xbgr.mr_n79008128)
print v(xbgr.mr_n79009072)
print v(xbgr.mr_n79010016)
print v(xbgr.mr_n79010960)
print v(xbgr.mr_n79011904)
print v(xbgr.mr_n79012848)
print v(xbgr.mr_n79018400)
print v(xbgr.mr_n79018592)
print v(xbgr.mr_n79019424)
print v(xbgr.mr_n79019936)
print v(xbgr.mr_n79021696)
print v(xbgr.mr_n79021888)
print v(xbgr.mr_n79022576)
print v(xbgr.mr_n79023088)
print v(xbgr.mr_n79024640)
print v(xbgr.mr_n79025168)
print v(xbgr.mr_n79025728)
print v(xbgr.mr_n79026240)
print v(xbgr.mr_n79028000)
print v(xbgr.mr_n79028192)
print v(xbgr.mr_n79028880)
print v(xbgr.mr_n79029392)
print v(xbgr.mr_n79030944)
print v(xbgr.mr_n79031472)
print v(xbgr.mr_n79032032)
print v(xbgr.mr_n79032544)
print v(xbgr.mr_n79034160)
print v(xbgr.mr_n79034352)
print v(xbgr.mr_n79035184)
print v(xbgr.mr_n79035696)
print v(xbgr.mr_n79037456)
print v(xbgr.mr_n79037648)
print v(xbgr.mr_n79038336)
print v(xbgr.mr_n79038848)
print v(xbgr.mr_n79040608)
print v(xbgr.mr_n79040800)
print v(xbgr.mr_n79041488)
print v(xbgr.mr_n79042192)
print v(xbgr.mr_n79042752)
print v(xbgr.mr_n79043456)
print v(xbgr.mr_n79044016)
print v(xbgr.mr_n79044720)
print v(xbgr.mr_n79045280)
print v(xbgr.mr_n79045712)
print v(xbgr.mr_n79046544)
print v(xbgr.mr_n79047120)
print v(xbgr.mr_n79047808)
print v(xbgr.mr_n79048512)
print v(xbgr.mr_n79049072)
print v(xbgr.mr_n79049648)
print v(xbgr.mr_n79050336)
print v(xbgr.mr_n79052768)
print v(xbgr.mr_n79053456)
print v(xbgr.mr_n79054144)
print v(xbgr.mr_n79056656)
print v(xbgr.mr_n79056848)
print v(xbgr.mr_n79057680)
print v(xbgr.mr_n79057872)
print v(xbgr.mr_n79058448)
print v(xbgr.mr_n79058560)
print v(xbgr.mr_n79060320)
print v(xbgr.mr_n79061152)
print v(xbgr.mr_n79061424)
print v(xbgr.mr_n79061536)
print v(xbgr.mr_n79062176)
print v(xbgr.mr_n79062288)
print v(xbgr.mr_n79062400)
print v(xbgr.mr_n79062592)
print v(xbgr.mr_n79062784)
print v(xbgr.mr_n79062976)
print v(xbgr.mr_n79065184)
print v(xbgr.mr_n79065376)
print v(xbgr.mr_n79065888)
print v(xbgr.mr_n79068448)
print v(xbgr.mr_n79068560)
print v(xbgr.mr_n79069984)
print v(xbgr.mr_n79070176)
print v(xbgr.mr_n79070368)
print v(xbgr.mr_n79070560)
print v(xbgr.mr_n79071072)
print v(xbgr.mr_n79072752)
print v(xbgr.mr_n79073024)
print v(xbgr.mr_n79073216)
print v(xbgr.mr_n79073728)
print v(xbgr.mr_n79075664)
print v(xbgr.mr_n79076176)
print v(xbgr.mr_n79078912)
print v(xbgr.mr_n79079184)
print v(xbgr.mr_n79079376)
print v(xbgr.mr_n79079888)
print v(xbgr.mr_n79081504)
print v(xbgr.mr_n79081696)
print v(xbgr.mr_n79083888)
print v(xbgr.mr_n79084160)
print v(xbgr.mr_n79084352)
print v(xbgr.mr_n79084864)
print v(xbgr.mr_n79086864)
print v(xbgr.mr_n79087376)
print v(xbgr.mr_n79090048)
print v(xbgr.mr_n79090320)
print v(xbgr.mr_n79090512)
print v(xbgr.mr_n79091024)
print v(xbgr.mr_n79092640)
print v(xbgr.mr_n79092832)
print v(xbgr.mr_n79095024)
print v(xbgr.mr_n79095296)
print v(xbgr.mr_n79095488)
print v(xbgr.mr_n79096000)
print v(xbgr.mr_n79096816)
print v(xbgr.mr_n79097936)
print v(xbgr.mr_n79098448)
print v(xbgr.mr_n79099584)
print v(xbgr.mr_n79101520)
print v(xbgr.mr_n79101712)
print v(xbgr.mr_n79102224)
print v(xbgr.mr_n79103840)
print v(xbgr.mr_n79104032)
print v(xbgr.mr_n79106160)
print v(xbgr.mr_n79106432)
print v(xbgr.mr_n79106624)
print v(xbgr.mr_n79107136)
print v(xbgr.mr_n79107984)
print v(xbgr.mr_n79109072)
print v(xbgr.mr_n79109584)
print v(xbgr.mr_n79112320)
print v(xbgr.mr_n79112592)
print v(xbgr.mr_n79112784)
print v(xbgr.mr_n79113296)
print v(xbgr.mr_n79117008)
print v(xbgr.mr_n79118160)
print v(xbgr.mr_n79118272)
print v(xbgr.mr_n79119424)
print v(xbgr.mr_n79119536)
print v(xbgr.mr_n79120688)
print v(xbgr.mr_n79120800)
print v(xbgr.mr_n79121952)
print v(xbgr.mr_n79122064)
print v(xbgr.mr_n79123216)
print v(xbgr.mr_n79123328)
print v(xbgr.mr_n79124480)
print v(xbgr.mr_n79124592)
print v(xbgr.mr_n79125744)
print v(xbgr.mr_n79125856)
print v(xbgr.mr_n79127008)
print v(xbgr.mr_n79127120)
print v(xbgr.mr_n79128272)
print v(xbgr.mr_n79128384)
print v(xbgr.mr_n79129536)
print v(xbgr.mr_n79129648)
print v(xbgr.mr_n79130800)
print v(xbgr.mr_n79130912)
print v(xbgr.mr_n79132064)
print v(xbgr.mr_n79132176)
print v(xbgr.mr_n79133328)
print v(xbgr.mr_n79133440)
print v(xbgr.mr_n79134592)
print v(xbgr.mr_n79134704)
print v(xbgr.mr_n79135856)
print v(xbgr.mr_n79135968)
print v(xbgr.mr_n79143728)
print v(xbgr.mr_n79144064)
print v(xbgr.mr_n79154304)
print v(xbgr.mr_n79160384)
print v(xbgr.mr_n79164352)
print v(xbgr.mr_n79165296)
print v(xbgr.mr_n79169648)
print v(xbgr.mr_n79170336)
print v(xbgr.mr_n79171088)
print v(xbgr.mr_n79172032)
print v(xbgr.mr_n79174064)
print v(xbgr.mr_n79174384)
print v(xbgr.mr_n79178432)
print v(xbgr.mr_n79178624)
print v(xbgr.mr_n79179312)
print v(xbgr.mr_n79179424)
print v(xbgr.mr_n79179536)
print v(xbgr.mr_n79179648)
print v(xbgr.mr_n79179760)
print v(xbgr.mr_n79181504)
print v(xbgr.mr_n79181696)
print v(xbgr.mr_n79181888)
print v(xbgr.mr_n79182480)
print v(xbgr.mr_n79184416)
print v(xbgr.mr_n79184688)
print v(xbgr.mr_n79186160)
print v(xbgr.mr_n79186432)
print v(xbgr.mr_n79186624)
print v(xbgr.mr_n79187136)
print v(xbgr.mr_n79189152)
print v(xbgr.mr_n79189344)
print v(xbgr.mr_n79191152)
print v(xbgr.mr_n79191344)
print v(xbgr.mr_n79191856)
print v(xbgr.mr_n79193024)
print v(xbgr.mr_n79193536)
print v(xbgr.mr_n79195584)
print v(xbgr.mr_n79196976)
print v(xbgr.mr_n79197248)
print v(xbgr.mr_n79197440)
print v(xbgr.mr_n79197952)
print v(xbgr.mr_n79200096)
print v(xbgr.mr_n79200688)
print v(xbgr.mr_n79202144)
print v(xbgr.mr_n79203536)
print v(xbgr.mr_n79203648)
print v(xbgr.mr_n79203760)
print v(xbgr.mr_n79203872)
print v(xbgr.mr_n79205616)
print v(xbgr.mr_n79205888)
print v(xbgr.mr_n79206080)
print v(xbgr.mr_n79206592)
print v(xbgr.mr_n79210048)
print v(xbgr.mr_n79210160)
print v(xbgr.mr_n79211904)
print v(xbgr.mr_n79212176)
print v(xbgr.mr_n79212368)
print v(xbgr.mr_n79212880)
print v(xbgr.mr_n79214112)
print v(xbgr.mr_n79214624)
print v(xbgr.mr_n79216752)
print v(xbgr.mr_n79216944)
print v(xbgr.mr_n79217136)
print v(xbgr.mr_n79219360)
print v(xbgr.mr_n79221184)
print v(xbgr.mr_n79221296)
print v(xbgr.mr_n79223040)
print v(xbgr.mr_n79223312)
print v(xbgr.mr_n79223504)
print v(xbgr.mr_n79224016)
print v(xbgr.mr_n79225248)
print v(xbgr.mr_n79225760)
print v(xbgr.mr_n79229200)
print v(xbgr.mr_n79229472)
print v(xbgr.mr_n79229664)
print v(xbgr.mr_n79230176)
print v(xbgr.mr_n79232320)
print v(xbgr.mr_n79232432)
print v(xbgr.mr_n79234176)
print v(xbgr.mr_n79234448)
print v(xbgr.mr_n79234640)
print v(xbgr.mr_n79235152)
print v(xbgr.mr_n79236304)
print v(xbgr.mr_n79236896)
print v(xbgr.mr_n79240336)
print v(xbgr.mr_n79240608)
print v(xbgr.mr_n79240800)
print v(xbgr.mr_n79241312)
print v(xbgr.mr_n79243376)
print v(xbgr.mr_n79243488)
print v(xbgr.mr_n79244000)
print v(xbgr.mr_n79244112)
print v(xbgr.mr_n79244624)
print v(xbgr.mr_n79244736)
print v(xbgr.mr_n79245504)
print v(xbgr.mr_n79245616)
print v(xbgr.mr_n79246448)
print v(xbgr.mr_n79246560)
print v(xbgr.mr_n79247392)
print v(xbgr.mr_n79247504)
print v(xbgr.mr_n79248336)
print v(xbgr.mr_n79248448)
print v(xbgr.mr_n79249280)
print v(xbgr.mr_n79249392)
print v(xbgr.mr_n79250288)
print v(xbgr.mr_n79250400)
print v(xbgr.mr_n79251552)
print v(xbgr.mr_n79251664)
print v(xbgr.mr_n79252816)
print v(xbgr.mr_n79252928)
print v(xbgr.mr_n79254080)
print v(xbgr.mr_n79254192)
print v(xbgr.mr_n79255344)
print v(xbgr.mr_n79255456)
print v(xbgr.mr_n79256608)
print v(xbgr.mr_n79256720)
print v(xbgr.mr_n79257872)
print v(xbgr.mr_n79257984)
print v(xbgr.mr_n79259056)
print v(xbgr.mr_n79261136)
print v(xbgr.mr_n79269760)
print v(xbgr.mr_n79269872)
print v(xbgr.mr_n79271024)
print v(xbgr.mr_n79271136)
print v(xbgr.mr_n79272288)
print v(xbgr.mr_n79272400)
print v(xbgr.mr_n79273552)
print v(xbgr.mr_n79273664)
print v(xbgr.mr_n79274816)
print v(xbgr.mr_n79274928)
print v(xbgr.mr_n79276080)
print v(xbgr.mr_n79276192)
print v(xbgr.mr_n79277344)
print v(xbgr.mr_n79277456)
print v(xbgr.mr_n79278608)
print v(xbgr.mr_n79278720)
print v(xbgr.mr_n79279872)
print v(xbgr.mr_n79279984)
print v(xbgr.mr_n79281136)
print v(xbgr.mr_n79281248)
print v(xbgr.mr_n79282400)
print v(xbgr.mr_n79282512)
print v(xbgr.mr_n79283664)
print v(xbgr.mr_n79283776)
print v(xbgr.mr_n79284928)
print v(xbgr.mr_n79285040)
print v(xbgr.mr_n79286192)
print v(xbgr.mr_n79286304)
print v(xbgr.mr_n79287456)
print v(xbgr.mr_n79287568)
print v(xbgr.mr_n79288720)
print v(xbgr.mr_n79288832)
print v(xbgr.mr_n79289984)
print v(xbgr.mr_n79290096)
print v(xbgr.mr_n79297888)
print v(xbgr.mr_n79306944)
print v(xbgr.mr_n79308512)
print v(xbgr.mr_n79310112)
print v(xbgr.mr_n79310768)
print v(xbgr.mr_n79313408)
print v(xbgr.mr_n79313648)
print v(xbgr.mr_n79314288)
print v(xbgr.mr_n79314640)
print v(xbgr.mr_n79315232)
print v(xbgr.mr_n79315344)
print v(xbgr.mr_n79316288)
print v(xbgr.mr_n79316464)
print v(xbgr.mr_n79316752)
print v(xbgr.mr_n79317808)
print v(xbgr.mr_n79319104)
print v(xbgr.mr_n79319744)
print v(xbgr.mr_n79319920)
print v(xbgr.mr_n79320864)
print v(xbgr.mr_n79321152)
print v(xbgr.mr_n79321328)
print v(xbgr.mr_n79321744)
print v(xbgr.mr_n79322208)
print v(xbgr.mr_n79322384)
print v(xbgr.mr_n79322560)
print v(xbgr.mr_n79322736)
print v(xbgr.mr_n79323504)
print v(xbgr.mr_n79324384)
print v(xbgr.mr_n79324560)
print v(xbgr.mr_n79324912)
print v(xbgr.mr_n79325264)
print v(xbgr.mr_n79325968)
print v(xbgr.mr_n79326144)
print v(xbgr.mr_n79327552)
print v(xbgr.mr_n79327728)
print v(xbgr.mr_n79328256)
print v(xbgr.mr_n79328784)
print v(xbgr.mr_n79329072)
print v(xbgr.mr_n79329424)
print v(xbgr.mr_n79330016)
print v(xbgr.mr_n79330128)
print v(xbgr.mr_n79331776)
print v(xbgr.mr_n79332176)
print v(xbgr.mr_n79332288)
print v(xbgr.mr_n79333184)
print v(xbgr.mr_n79334432)
print v(xbgr.mr_n79335568)
print v(xbgr.mr_n79337440)
print v(xbgr.mr_n79337664)
print v(xbgr.mr_n79342784)
print v(xbgr.mr_n79344192)
print v(xbgr.mr_n79344384)
print v(xbgr.mr_n79345072)
print v(xbgr.mr_n79345184)
print v(xbgr.mr_n79345296)
print v(xbgr.mr_n79345408)
print v(xbgr.mr_n79345520)
print v(xbgr.mr_n79347264)
print v(xbgr.mr_n79347536)
print v(xbgr.mr_n79347728)
print v(xbgr.mr_n79348240)
print v(xbgr.mr_n79350240)
print v(xbgr.mr_n79351984)
print v(xbgr.mr_n79352256)
print v(xbgr.mr_n79352448)
print v(xbgr.mr_n79352960)
print v(xbgr.mr_n79354976)
print v(xbgr.mr_n79355168)
print v(xbgr.mr_n79356976)
print v(xbgr.mr_n79357168)
print v(xbgr.mr_n79357680)
print v(xbgr.mr_n79359792)
print v(xbgr.mr_n79359984)
print v(xbgr.mr_n79360176)
print v(xbgr.mr_n79360368)
print v(xbgr.mr_n79360640)
print v(xbgr.mr_n79362592)
print v(xbgr.mr_n79364208)
print v(xbgr.mr_n79365952)
print v(xbgr.mr_n79366224)
print v(xbgr.mr_n79366416)
print v(xbgr.mr_n79366928)
print v(xbgr.mr_n79368864)
print v(xbgr.mr_n79370608)
print v(xbgr.mr_n79370880)
print v(xbgr.mr_n79371072)
print v(xbgr.mr_n79371584)
print v(xbgr.mr_n79373520)
print v(xbgr.mr_n79375264)
print v(xbgr.mr_n79375456)
print v(xbgr.mr_n79375648)
print v(xbgr.mr_n79376240)
print v(xbgr.mr_n79378176)
print v(xbgr.mr_n79379920)
print v(xbgr.mr_n79380192)
print v(xbgr.mr_n79380384)
print v(xbgr.mr_n79380896)
print v(xbgr.mr_n79382832)
print v(xbgr.mr_n79384576)
print v(xbgr.mr_n79384848)
print v(xbgr.mr_n79385040)
print v(xbgr.mr_n79385552)
print v(xbgr.mr_n79387488)
print v(xbgr.mr_n79389232)
print v(xbgr.mr_n79389504)
print v(xbgr.mr_n79389696)
print v(xbgr.mr_n79390208)
print v(xbgr.mr_n79392144)
print v(xbgr.mr_n79393888)
print v(xbgr.mr_n79394160)
print v(xbgr.mr_n79394352)
print v(xbgr.mr_n79394864)
print v(xbgr.mr_n79396880)
print v(xbgr.mr_n79397072)
print v(xbgr.mr_n79398880)
print v(xbgr.mr_n79399072)
print v(xbgr.mr_n79399584)
print v(xbgr.mr_n79401536)
print v(xbgr.mr_n79401728)
print v(xbgr.mr_n79403536)
print v(xbgr.mr_n79403728)
print v(xbgr.mr_n79404240)
print v(xbgr.mr_n79406112)
print v(xbgr.mr_n79407856)
print v(xbgr.mr_n79408128)
print v(xbgr.mr_n79408320)
print v(xbgr.mr_n79408832)
print v(xbgr.mr_n79410768)
print v(xbgr.mr_n79412512)
print v(xbgr.mr_n79412784)
print v(xbgr.mr_n79412976)
print v(xbgr.mr_n79413488)
print v(xbgr.mr_n79415424)
print v(xbgr.mr_n79417168)
print v(xbgr.mr_n79417440)
print v(xbgr.mr_n79417632)
print v(xbgr.mr_n79418144)
print v(xbgr.mr_n79420080)
print v(xbgr.mr_n79421824)
print v(xbgr.mr_n79422016)
print v(xbgr.mr_n79422208)
print v(xbgr.mr_n79422800)
print v(xbgr.mr_n79425632)
print v(xbgr.mr_n79426416)
print v(xbgr.mr_n79428064)
print v(xbgr.mr_n79428400)
print v(xbgr.mr_n79430608)
print v(xbgr.mr_n79432704)
print v(xbgr.mr_n79433136)
print v(xbgr.mr_n79434560)
print v(xbgr.mr_n79435136)
print v(xbgr.mr_n79435248)
print v(xbgr.mr_n79436192)
print v(xbgr.mr_n79437024)
print v(xbgr.mr_n79437136)
print v(xbgr.mr_n79438080)
print v(xbgr.mr_n79439232)
print v(xbgr.mr_n79439344)
print v(xbgr.mr_n79440288)
print v(xbgr.mr_n79441440)
print v(xbgr.mr_n79441552)
print v(xbgr.mr_n79442496)
print v(xbgr.mr_n79443648)
print v(xbgr.mr_n79443760)
print v(xbgr.mr_n79444704)
print v(xbgr.mr_n79445856)
print v(xbgr.mr_n79445968)
print v(xbgr.mr_n79446912)
print v(xbgr.mr_n79448064)
print v(xbgr.mr_n79448176)
print v(xbgr.mr_n79449120)
print v(xbgr.mr_n79450272)
print v(xbgr.mr_n79450384)
print v(xbgr.mr_n79451328)
print v(xbgr.mr_n79452480)
print v(xbgr.mr_n79452592)
print v(xbgr.mr_n79453536)
print v(xbgr.mr_n79454688)
print v(xbgr.mr_n79454800)
print v(xbgr.mr_n79455744)
print v(xbgr.mr_n79456896)
print v(xbgr.mr_n79457008)
print v(xbgr.mr_n79457952)
print v(xbgr.mr_n79459040)
print v(xbgr.mr_n79459152)
print v(xbgr.mr_n79460096)
print v(xbgr.mr_n79461312)
print v(xbgr.mr_n79461424)
print v(xbgr.mr_n79462368)
print v(xbgr.mr_n79463520)
print v(xbgr.mr_n79463632)
print v(xbgr.mr_n79464576)
print v(xbgr.mr_n79465728)
print v(xbgr.mr_n79465840)
print v(xbgr.mr_n79466992)
print v(xbgr.mr_n79467104)
print v(xbgr.mr_n79468256)
print v(xbgr.mr_n79468368)
print v(xbgr.mr_n79470208)
print v(xbgr.mr_n79471200)
print v(xbgr.mr_n79471968)
print v(xbgr.mr_n79472080)
print v(xbgr.mr_n79473072)
print v(xbgr.mr_n79473184)
print v(xbgr.mr_n79474016)
print v(xbgr.mr_n79474128)
print v(xbgr.mr_n79476848)
print v(xbgr.mr_n79476960)
print v(xbgr.mr_n79478112)
print v(xbgr.mr_n79478224)
print v(xbgr.mr_n79479312)
print v(xbgr.mr_n79479424)
print v(xbgr.mr_n79480640)
print v(xbgr.mr_n79480752)
print v(xbgr.mr_n79481840)
print v(xbgr.mr_n79481952)
print v(xbgr.mr_n79483168)
print v(xbgr.mr_n79483280)
print v(xbgr.mr_n79484432)
print v(xbgr.mr_n79484544)
print v(xbgr.mr_n79484848)
print v(xbgr.mr_n79488688)
print v(xbgr.mr_n79491520)
print v(xbgr.mr_n79492080)
print v(xbgr.mr_n79492464)
print v(xbgr.mr_n79499152)
print v(xbgr.mr_n79503568)
print v(xbgr.mr_n79506896)
print v(xbgr.mr_n79508816)
print v(xbgr.mr_n79514000)
print v(xbgr.mr_n79514192)
print v(xbgr.mr_n79514384)
print v(xbgr.mr_n79514576)
print v(xbgr.mr_n79516896)
print v(xbgr.mr_n79517168)
print v(xbgr.mr_n79517360)
print v(xbgr.mr_n79517872)
print v(xbgr.mr_n79523552)
print v(xbgr.mr_n79523744)
print v(xbgr.mr_n79523936)
print v(xbgr.mr_n79524528)
print v(xbgr.mr_n79526672)
print v(xbgr.mr_n79526784)
print v(xbgr.mr_n79528528)
print v(xbgr.mr_n79528800)
print v(xbgr.mr_n79528992)
print v(xbgr.mr_n79529504)
print v(xbgr.mr_n79530736)
print v(xbgr.mr_n79531248)
print v(xbgr.mr_n79534688)
print v(xbgr.mr_n79534960)
print v(xbgr.mr_n79535152)
print v(xbgr.mr_n79535664)
print v(xbgr.mr_n79537808)
print v(xbgr.mr_n79537920)
print v(xbgr.mr_n79539664)
print v(xbgr.mr_n79539936)
print v(xbgr.mr_n79540128)
print v(xbgr.mr_n79540640)
print v(xbgr.mr_n79541872)
print v(xbgr.mr_n79542384)
print v(xbgr.mr_n79544352)
print v(xbgr.mr_n79546160)
print v(xbgr.mr_n79546352)
print v(xbgr.mr_n79546864)
print v(xbgr.mr_n79548944)
print v(xbgr.mr_n79549056)
print v(xbgr.mr_n79550800)
print v(xbgr.mr_n79551072)
print v(xbgr.mr_n79551264)
print v(xbgr.mr_n79551776)
print v(xbgr.mr_n79553072)
print v(xbgr.mr_n79553584)
print v(xbgr.mr_n79555488)
print v(xbgr.mr_n79557296)
print v(xbgr.mr_n79557488)
print v(xbgr.mr_n79558000)
print v(xbgr.mr_n79560080)
print v(xbgr.mr_n79560192)
print v(xbgr.mr_n79561936)
print v(xbgr.mr_n79562208)
print v(xbgr.mr_n79562400)
print v(xbgr.mr_n79562912)
print v(xbgr.mr_n79564144)
print v(xbgr.mr_n79564656)
print v(xbgr.mr_n79568096)
print v(xbgr.mr_n79568288)
print v(xbgr.mr_n79568480)
print v(xbgr.mr_n79569072)
print v(xbgr.mr_n79571216)
print v(xbgr.mr_n79571328)
print v(xbgr.mr_n79573072)
print v(xbgr.mr_n79573344)
print v(xbgr.mr_n79573536)
print v(xbgr.mr_n79574048)
print v(xbgr.mr_n79575280)
print v(xbgr.mr_n79575792)
print v(xbgr.mr_n79577760)
print v(xbgr.mr_n79579568)
print v(xbgr.mr_n79579760)
print v(xbgr.mr_n79580272)
print v(xbgr.mr_n79585408)
print v(xbgr.mr_n79585520)
print v(xbgr.mr_n79586352)
print v(xbgr.mr_n79586464)
print v(xbgr.mr_n79587296)
print v(xbgr.mr_n79587408)
print v(xbgr.mr_n79588496)
print v(xbgr.mr_n79588608)
print v(xbgr.mr_n79589696)
print v(xbgr.mr_n79589808)
print v(xbgr.mr_n79591024)
print v(xbgr.mr_n79591136)
print v(xbgr.mr_n79592288)
print v(xbgr.mr_n79592400)
print v(xbgr.mr_n79593552)
print v(xbgr.mr_n79593664)
print v(xbgr.mr_n79594816)
print v(xbgr.mr_n79594928)
print v(xbgr.mr_n79596080)
print v(xbgr.mr_n79596192)
print v(xbgr.mr_n79597344)
print v(xbgr.mr_n79597456)
print v(xbgr.mr_n79598608)
print v(xbgr.mr_n79598720)
print v(xbgr.mr_n79599872)
print v(xbgr.mr_n79599984)
print v(xbgr.mr_n79601136)
print v(xbgr.mr_n79601248)
print v(xbgr.mr_n79602400)
print v(xbgr.mr_n79602512)
print v(xbgr.mr_n79613184)
print v(xbgr.mr_n79613872)
print v(xbgr.mr_n79614560)
print v(xbgr.mr_n79615248)
print v(xbgr.mr_n79615936)
print v(xbgr.mr_n79616624)
print v(xbgr.mr_n79618016)
print v(xbgr.mr_n79619440)
print v(xbgr.mr_n79620384)
print v(xbgr.mr_n79621328)
print v(xbgr.mr_n79622272)
print v(xbgr.mr_n79622672)
print v(xbgr.mr_n79624688)
print v(xbgr.mr_n79625024)
print v(xbgr.mr_n79627168)
print v(xbgr.mr_n79628800)
print v(xbgr.mr_n79629728)
print v(xbgr.mr_n79630368)
print v(xbgr.mr_n79631936)
print v(xbgr.mr_n79633504)
print v(xbgr.mr_n79635072)
print v(xbgr.mr_n79636640)
print v(xbgr.mr_n79638208)
print v(xbgr.mr_n79642688)
print v(xbgr.mr_n79643376)
print v(xbgr.mr_n79644064)
print v(xbgr.mr_n79644816)
print v(xbgr.mr_n79646432)
print v(xbgr.mr_n79647712)
print v(xbgr.mr_n79647824)
print v(xbgr.mr_n79648768)
print v(xbgr.mr_n79648944)
print v(xbgr.mr_n79649920)
print v(xbgr.mr_n79650032)
print v(xbgr.mr_n79650976)
print v(xbgr.mr_n79652128)
print v(xbgr.mr_n79652240)
print v(xbgr.mr_n79653184)
print v(xbgr.mr_n79653424)
print v(xbgr.mr_n79654336)
print v(xbgr.mr_n79654448)
print v(xbgr.mr_n79655392)
print v(xbgr.mr_n79655712)
print v(xbgr.mr_n79656544)
print v(xbgr.mr_n79656656)
print v(xbgr.mr_n79657600)
print v(xbgr.mr_n79657776)
print v(xbgr.mr_n79658752)
print v(xbgr.mr_n79658864)
print v(xbgr.mr_n79659808)
print v(xbgr.mr_n79660896)
print v(xbgr.mr_n79661008)
print v(xbgr.mr_n79661952)
print v(xbgr.mr_n79663168)
print v(xbgr.mr_n79663280)
print v(xbgr.mr_n79664224)
print v(xbgr.mr_n79664480)
print v(xbgr.mr_n79665376)
print v(xbgr.mr_n79665488)
print v(xbgr.mr_n79666432)
print v(xbgr.mr_n79667584)
print v(xbgr.mr_n79667696)
print v(xbgr.mr_n79668640)
print v(xbgr.mr_n79669792)
print v(xbgr.mr_n79669904)
print v(xbgr.mr_n79670848)
print v(xbgr.mr_n79672000)
print v(xbgr.mr_n79672112)
print v(xbgr.mr_n79673056)
print v(xbgr.mr_n79674208)
print v(xbgr.mr_n79674320)
print v(xbgr.mr_n79675264)
print v(xbgr.mr_n79675440)
print v(xbgr.mr_n79676416)
print v(xbgr.mr_n79676528)
print v(xbgr.mr_n79677472)
print v(xbgr.mr_n79678624)
print v(xbgr.mr_n79678736)
print v(xbgr.mr_n79679680)
print v(xbgr.mr_n79680832)
print v(xbgr.mr_n79680944)
print v(xbgr.mr_n79681888)
print v(xbgr.mr_n79683040)
print v(xbgr.mr_n79683152)
print v(xbgr.mr_n79684032)
print v(xbgr.mr_n79684720)
print v(xbgr.mr_n79685408)
print v(xbgr.mr_n79686128)
print v(xbgr.mr_n79687072)
print v(xbgr.mr_n79688016)
print v(xbgr.mr_n79688960)
print v(xbgr.mr_n79689904)
print v(xbgr.mr_n79690848)
print v(xbgr.mr_n79691792)
print v(xbgr.mr_n79692736)
print v(xbgr.mr_n79693696)
print v(xbgr.mr_n79698256)
print v(xbgr.mr_n79701232)
print v(xbgr.mr_n79702912)
print v(xbgr.mr_n79708032)
print v(xbgr.mr_n79708608)
print v(xbgr.mr_n79712512)
print v(xbgr.mr_n79715856)
print v(xbgr.mr_n79716928)
print v(xbgr.mr_n79717120)
print v(xbgr.mr_n79717312)
print v(xbgr.mr_n79717504)
print v(xbgr.mr_n79719824)
print v(xbgr.mr_n79720096)
print v(xbgr.mr_n79720288)
print v(xbgr.mr_n79720800)
print v(xbgr.mr_n79725520)
print v(xbgr.mr_n79725792)
print v(xbgr.mr_n79725984)
print v(xbgr.mr_n79726496)
print v(xbgr.mr_n79728640)
print v(xbgr.mr_n79728752)
print v(xbgr.mr_n79730496)
print v(xbgr.mr_n79730768)
print v(xbgr.mr_n79730960)
print v(xbgr.mr_n79731472)
print v(xbgr.mr_n79732704)
print v(xbgr.mr_n79733216)
print v(xbgr.mr_n79736656)
print v(xbgr.mr_n79737040)
print v(xbgr.mr_n79737632)
print v(xbgr.mr_n79740160)
print v(xbgr.mr_n79741280)
print v(xbgr.mr_n79742112)
print v(xbgr.mr_n79742928)
print v(xbgr.mr_n79743040)
print v(xbgr.mr_n79743152)
print v(xbgr.mr_n79743264)
print v(xbgr.mr_n79745008)
print v(xbgr.mr_n79745280)
print v(xbgr.mr_n79745472)
print v(xbgr.mr_n79745984)
print v(xbgr.mr_n79749952)
print v(xbgr.mr_n79750064)
print v(xbgr.mr_n79751808)
print v(xbgr.mr_n79752080)
print v(xbgr.mr_n79752272)
print v(xbgr.mr_n79752784)
print v(xbgr.mr_n79754016)
print v(xbgr.mr_n79754528)
print v(xbgr.mr_n79757968)
print v(xbgr.mr_n79758240)
print v(xbgr.mr_n79758432)
print v(xbgr.mr_n79758944)
print v(xbgr.mr_n79761088)
print v(xbgr.mr_n79761200)
print v(xbgr.mr_n79762944)
print v(xbgr.mr_n79763136)
print v(xbgr.mr_n79763328)
print v(xbgr.mr_n79763920)
print v(xbgr.mr_n79765152)
print v(xbgr.mr_n79765664)
print v(xbgr.mr_n79769104)
print v(xbgr.mr_n79769376)
print v(xbgr.mr_n79769568)
print v(xbgr.mr_n79770080)
print v(xbgr.mr_n79772224)
print v(xbgr.mr_n79772416)
print v(xbgr.mr_n79772608)
print v(xbgr.mr_n79774416)
print v(xbgr.mr_n79774608)
print v(xbgr.mr_n79775120)
print v(xbgr.mr_n79776288)
print v(xbgr.mr_n79776800)
print v(xbgr.mr_n79780240)
print v(xbgr.mr_n79780512)
print v(xbgr.mr_n79780704)
print v(xbgr.mr_n79781216)
print v(xbgr.mr_n79782352)
print v(xbgr.mr_n79782672)
print v(xbgr.mr_n79786160)
print v(xbgr.mr_n79786272)
print v(xbgr.mr_n79787104)
print v(xbgr.mr_n79787216)
print v(xbgr.mr_n79788048)
print v(xbgr.mr_n79788160)
print v(xbgr.mr_n79789248)
print v(xbgr.mr_n79789360)
print v(xbgr.mr_n79790512)
print v(xbgr.mr_n79790624)
print v(xbgr.mr_n79791776)
print v(xbgr.mr_n79791888)
print v(xbgr.mr_n79793040)
print v(xbgr.mr_n79793152)
print v(xbgr.mr_n79794304)
print v(xbgr.mr_n79794416)
print v(xbgr.mr_n79795568)
print v(xbgr.mr_n79795680)
print v(xbgr.mr_n79796832)
print v(xbgr.mr_n79796944)
print v(xbgr.mr_n79798096)
print v(xbgr.mr_n79798208)
print v(xbgr.mr_n79799360)
print v(xbgr.mr_n79799472)
print v(xbgr.mr_n79800624)
print v(xbgr.mr_n79800736)
print v(xbgr.mr_n79801888)
print v(xbgr.mr_n79802000)
print v(xbgr.mr_n79803152)
print v(xbgr.mr_n79803264)
print v(xbgr.mr_n79804800)
print v(xbgr.mr_n79804912)
print v(xbgr.mr_n79806064)
print v(xbgr.mr_n79806176)
print v(xbgr.mr_n79807328)
print v(xbgr.mr_n79807440)
print v(xbgr.mr_n79808592)
print v(xbgr.mr_n79808704)
print v(xbgr.mr_n79809856)
print v(xbgr.mr_n79809968)
print v(xbgr.mr_n79811120)
print v(xbgr.mr_n79811232)
print v(xbgr.mr_n79812384)
print v(xbgr.mr_n79812496)
print v(xbgr.mr_n79813648)
print v(xbgr.mr_n79813760)
print v(xbgr.mr_n79814912)
print v(xbgr.mr_n79815024)
print v(xbgr.mr_n79816176)
print v(xbgr.mr_n79816288)
print v(xbgr.mr_n79817440)
print v(xbgr.mr_n79817552)
print v(xbgr.mr_n79818704)
print v(xbgr.mr_n79818816)
print v(xbgr.mr_n79819968)
print v(xbgr.mr_n79820080)
print v(xbgr.mr_n79821232)
print v(xbgr.mr_n79821344)
print v(xbgr.mr_n79822496)
print v(xbgr.mr_n79822608)
print v(xbgr.mr_n79823760)
print v(xbgr.mr_n79823872)
print v(xbgr.mr_n79825024)
print v(xbgr.mr_n79825136)
print v(xbgr.mr_n79829600)
print v(xbgr.mr_n79835296)
print v(xbgr.mr_n79837360)
print v(xbgr.mr_n79838432)
print v(xbgr.mr_n79840544)
print v(xbgr.mr_n79846384)
print v(xbgr.mr_n79847248)
print v(xbgr.mr_n79848336)
print v(xbgr.mr_n79852640)
print v(xbgr.mr_n79854896)
print v(xbgr.mr_n79855824)
print v(xbgr.mr_n79857968)
print v(xbgr.mr_n79858160)
print v(xbgr.mr_n79860176)
print v(xbgr.mr_n79860560)
print v(xbgr.mr_n79861824)
print v(xbgr.mr_n79862512)
print v(xbgr.mr_n79863200)
print v(xbgr.mr_n79863920)
print v(xbgr.mr_n79864864)
print v(xbgr.mr_n79865808)
print v(xbgr.mr_n79866752)
print v(xbgr.mr_n79867696)
print v(xbgr.mr_n79868640)
print v(xbgr.mr_n79869584)
print v(xbgr.mr_n79870528)
print v(xbgr.mr_n79871472)
print v(xbgr.mr_n79872416)
print v(xbgr.mr_n79873360)
print v(xbgr.mr_n79874304)
print v(xbgr.mr_n79875248)
print v(xbgr.mr_n79880752)
print v(xbgr.mr_n79882992)
print v(xbgr.mr_n79884992)
print v(xbgr.mr_n79886240)
print v(xbgr.mr_n79887008)
print v(xbgr.mr_n79891728)
print v(xbgr.mr_n79891904)
print v(xbgr.mr_n79892096)
print v(xbgr.mr_n79892784)
print v(xbgr.mr_n79892896)
print v(xbgr.mr_n79893008)
print v(xbgr.mr_n79893120)
print v(xbgr.mr_n79893232)
print v(xbgr.mr_n79893424)
print v(xbgr.mr_n79894976)
print v(xbgr.mr_n79895248)
print v(xbgr.mr_n79895440)
print v(xbgr.mr_n79895952)
print v(xbgr.mr_n79896416)
print v(xbgr.mr_n79898544)
print v(xbgr.mr_n79898816)
print v(xbgr.mr_n79899008)
print v(xbgr.mr_n79899520)
print v(xbgr.mr_n79903008)
print v(xbgr.mr_n79903280)
print v(xbgr.mr_n79903472)
print v(xbgr.mr_n79903984)
print v(xbgr.mr_n79905536)
print v(xbgr.mr_n79907792)
print v(xbgr.mr_n79908064)
print v(xbgr.mr_n79908256)
print v(xbgr.mr_n79908768)
print v(xbgr.mr_n79910336)
print v(xbgr.mr_n79912592)
print v(xbgr.mr_n79912784)
print v(xbgr.mr_n79913296)
print v(xbgr.mr_n79914848)
print v(xbgr.mr_n79917040)
print v(xbgr.mr_n79917312)
print v(xbgr.mr_n79917504)
print v(xbgr.mr_n79918016)
print v(xbgr.mr_n79919744)
print v(xbgr.mr_n79920000)
print v(xbgr.mr_n79920256)
print v(xbgr.mr_n79922800)
print v(xbgr.mr_n79924432)
print v(xbgr.mr_n79924624)
print v(xbgr.mr_n79926624)
print v(xbgr.mr_n79926816)
print v(xbgr.mr_n79927328)
print v(xbgr.mr_n79930752)
print v(xbgr.mr_n79931024)
print v(xbgr.mr_n79931216)
print v(xbgr.mr_n79931728)
print v(xbgr.mr_n79933280)
print v(xbgr.mr_n79935536)
print v(xbgr.mr_n79935808)
print v(xbgr.mr_n79936000)
print v(xbgr.mr_n79936512)
print v(xbgr.mr_n79938000)
print v(xbgr.mr_n79940000)
print v(xbgr.mr_n79940272)
print v(xbgr.mr_n79940464)
print v(xbgr.mr_n79940976)
print v(xbgr.mr_n79942112)
print v(xbgr.mr_n79944176)
print v(xbgr.mr_n79944368)
print v(xbgr.mr_n79944880)
print v(xbgr.mr_n79947680)
print v(xbgr.mr_n79947952)
print v(xbgr.mr_n79948144)
print v(xbgr.mr_n79948656)
print v(xbgr.mr_n79952016)
print v(xbgr.mr_n79952128)
print v(xbgr.mr_n79953872)
print v(xbgr.mr_n79954144)
print v(xbgr.mr_n79954336)
print v(xbgr.mr_n79954848)
print v(xbgr.mr_n79956992)
print v(xbgr.mr_n79957104)
print v(xbgr.mr_n79958848)
print v(xbgr.mr_n79959120)
print v(xbgr.mr_n79959312)
print v(xbgr.mr_n79959824)
print v(xbgr.mr_n79961968)
print v(xbgr.mr_n79962160)
print v(xbgr.mr_n79962352)
print v(xbgr.mr_n79964160)
print v(xbgr.mr_n79964352)
print v(xbgr.mr_n79964864)
print v(xbgr.mr_n79966944)
print v(xbgr.mr_n79967056)
print v(xbgr.mr_n79968800)
print v(xbgr.mr_n79969072)
print v(xbgr.mr_n79969264)
print v(xbgr.mr_n79969776)
print v(xbgr.mr_n79974944)
print v(xbgr.mr_n79977136)
print v(xbgr.mr_n79978704)
print v(xbgr.mr_n79979648)
print v(xbgr.mr_n79981840)
print v(xbgr.mr_n79983408)
print v(xbgr.mr_n79984352)
print v(xbgr.mr_n79986544)
print v(xbgr.mr_n79988160)
print v(xbgr.mr_n79988656)
print v(xbgr.mr_n79988768)
print v(xbgr.mr_n79989600)
print v(xbgr.mr_n79989712)
print v(xbgr.mr_n79990544)
print v(xbgr.mr_n79990656)
print v(xbgr.mr_n79991488)
print v(xbgr.mr_n79991600)
print v(xbgr.mr_n79992432)
print v(xbgr.mr_n79992544)
print v(xbgr.mr_n79993376)
print v(xbgr.mr_n79993488)
print v(xbgr.mr_n79994320)
print v(xbgr.mr_n79994432)
print v(xbgr.mr_n79995264)
print v(xbgr.mr_n79995376)
print v(xbgr.mr_n79996208)
print v(xbgr.mr_n79996320)
print v(xbgr.mr_n79997344)
print v(xbgr.mr_n79997456)
print v(xbgr.mr_n80000016)
print v(xbgr.mr_n80000256)
print v(xbgr.mr_n80006192)
print v(xbgr.mr_n80009936)
print v(xbgr.mr_n80011072)
print v(xbgr.mr_n80011952)
print v(xbgr.mr_n80013712)
print v(xbgr.mr_n80019520)
print v(xbgr.mr_n80022080)
print v(xbgr.mr_n80022768)
print v(xbgr.mr_n80023456)
print v(xbgr.mr_n80024144)
print v(xbgr.mr_n80024832)
print v(xbgr.mr_n80026512)
print v(xbgr.mr_n80027456)
print v(xbgr.mr_n80028400)
print v(xbgr.mr_n80029344)
print v(xbgr.mr_n80030288)
print v(xbgr.mr_n80031232)
print v(xbgr.mr_n80032176)
print v(xbgr.mr_n80033120)
print v(xbgr.mr_n80034064)
print v(xbgr.mr_n80035008)
print v(xbgr.mr_n80035952)
print v(xbgr.mr_n80036896)
print v(xbgr.mr_n80037840)
print v(xbgr.mr_n80038784)
print v(xbgr.mr_n80038976)
print v(xbgr.mr_n80039168)
print v(xbgr.mr_n80039360)
print v(xbgr.mr_n80039552)
print v(xbgr.mr_n80039744)
print v(xbgr.mr_n80041888)
print v(xbgr.mr_n80042000)
print v(xbgr.mr_n80045312)
print v(xbgr.mr_n80045424)
print v(xbgr.mr_n80050304)
print v(xbgr.mr_n80052144)
print v(xbgr.mr_n80053984)
print v(xbgr.mr_n80055824)
print v(xbgr.mr_n80062032)
print v(xbgr.mr_n80062800)
print v(xbgr.mr_n80072992)
print v(xbgr.mr_n80074560)
print v(xbgr.mr_n80076128)
print v(xbgr.mr_n80077696)
print v(xbgr.mr_n80079264)
print v(xbgr.mr_n80080832)
print v(xbgr.mr_n80082400)
print v(xbgr.mr_n80083968)
print v(xbgr.mr_n80085536)
print v(xbgr.mr_n80087104)
print v(xbgr.mr_n80088672)
print v(xbgr.mr_n80090240)
print v(xbgr.mr_n80091808)
print v(xbgr.mr_n80093376)
print v(xbgr.mr_n80094944)
print v(xbgr.mr_n80096512)
print v(xbgr.mr_n80099760)
print v(xbgr.mr_n80100096)
print v(xbgr.mr_n80100208)
print v(xbgr.mr_n80101040)
print v(xbgr.mr_n80101152)
print v(xbgr.mr_n80101984)
print v(xbgr.mr_n80102096)
print v(xbgr.mr_n80102928)
print v(xbgr.mr_n80103040)
print v(xbgr.mr_n80105520)
print v(xbgr.mr_n80105712)
print v(xbgr.mr_n80106528)
print v(xbgr.mr_n80107040)
print v(xbgr.mr_n80107152)
print v(xbgr.mr_n80107264)
print v(xbgr.mr_n80107376)
print v(xbgr.mr_n80107488)
print v(xbgr.mr_n80108912)
print v(xbgr.mr_n80109184)
print v(xbgr.mr_n80109376)
print v(xbgr.mr_n80109888)
print v(xbgr.mr_n80112032)
print v(xbgr.mr_n80112144)
print v(xbgr.mr_n80113888)
print v(xbgr.mr_n80114160)
print v(xbgr.mr_n80114352)
print v(xbgr.mr_n80114864)
print v(xbgr.mr_n80117008)
print v(xbgr.mr_n80117200)
print v(xbgr.mr_n80117392)
print v(xbgr.mr_n80119200)
print v(xbgr.mr_n80119392)
print v(xbgr.mr_n80119904)
print v(xbgr.mr_n80121984)
print v(xbgr.mr_n80122096)
print v(xbgr.mr_n80123840)
print v(xbgr.mr_n80124112)
print v(xbgr.mr_n80124304)
print v(xbgr.mr_n80124816)
print v(xbgr.mr_n80126960)
print v(xbgr.mr_n80127072)
print v(xbgr.mr_n80128816)
print v(xbgr.mr_n80129088)
print v(xbgr.mr_n80129280)
print v(xbgr.mr_n80129792)
print v(xbgr.mr_n80132096)
print v(xbgr.mr_n80132288)
print v(xbgr.mr_n80132480)
print v(xbgr.mr_n80132672)
print v(xbgr.mr_n80132864)
print v(xbgr.mr_n80135088)
print v(xbgr.mr_n80136912)
print v(xbgr.mr_n80137024)
print v(xbgr.mr_n80138768)
print v(xbgr.mr_n80139040)
print v(xbgr.mr_n80139232)
print v(xbgr.mr_n80139744)
print v(xbgr.mr_n80141888)
print v(xbgr.mr_n80142000)
print v(xbgr.mr_n80143744)
print v(xbgr.mr_n80144016)
print v(xbgr.mr_n80144208)
print v(xbgr.mr_n80144720)
print v(xbgr.mr_n80146912)
print v(xbgr.mr_n80149152)
print v(xbgr.mr_n80150000)
print v(xbgr.mr_n80150688)
print v(xbgr.mr_n80151376)
print v(xbgr.mr_n80152064)
print v(xbgr.mr_n80152752)
print v(xbgr.mr_n80153440)
print v(xbgr.mr_n80154128)
print v(xbgr.mr_n80155200)
print v(xbgr.mr_n80157072)
print v(xbgr.mr_n80158016)
print v(xbgr.mr_n80158960)
print v(xbgr.mr_n80159904)
print v(xbgr.mr_n80160848)
print v(xbgr.mr_n80161792)
print v(xbgr.mr_n80162736)
print v(xbgr.mr_n80163680)
print v(xbgr.mr_n80164624)
print v(xbgr.mr_n80165568)
print v(xbgr.mr_n80166512)
print v(xbgr.mr_n80167456)
print v(xbgr.mr_n80167952)
print v(xbgr.mr_n80179680)
print v(xbgr.mr_n80180704)
print v(xbgr.mr_n80181584)
print v(xbgr.mr_n80182016)
print v(xbgr.mr_n80184400)
print v(xbgr.mr_n80185968)
print v(xbgr.mr_n80187008)
print v(xbgr.mr_n80187120)
print v(xbgr.mr_n80187232)
print v(xbgr.mr_n80188832)
print v(xbgr.mr_n80188944)
print v(xbgr.mr_n80190768)
print v(xbgr.mr_n80191328)
print v(xbgr.mr_n80193152)
print v(xbgr.mr_n80194368)
print v(xbgr.mr_n80194480)
print v(xbgr.mr_n80195568)
print v(xbgr.mr_n80198224)
print v(xbgr.mr_n80199696)
print v(xbgr.mr_n80201264)
print v(xbgr.mr_n80202832)
print v(xbgr.mr_n80204400)
print v(xbgr.mr_n80210480)
print v(xbgr.mr_n80210752)
print v(xbgr.mr_n80211824)
print v(xbgr.mr_n80213056)
print v(xbgr.mr_n80213248)
print v(xbgr.mr_n80213792)
print v(xbgr.mr_n80214624)
print v(xbgr.mr_n80214736)
print v(xbgr.mr_n80216896)
print v(xbgr.mr_n80218448)
print v(xbgr.mr_n80219568)
print v(xbgr.mr_n80220256)
print v(xbgr.mr_n80221456)
print v(xbgr.mr_n80223152)
print v(xbgr.mr_n80224720)
print v(xbgr.mr_n80225664)
print v(xbgr.mr_n80227040)
print v(xbgr.mr_n80228192)
print v(xbgr.mr_n80229024)
print v(xbgr.mr_n80232816)
print v(xbgr.mr_n80234432)
print v(xbgr.mr_n80234544)
print v(xbgr.mr_n80235696)
print v(xbgr.mr_n80235808)
print v(xbgr.mr_n80236960)
print v(xbgr.mr_n80237072)
print v(xbgr.mr_n80238224)
print v(xbgr.mr_n80238336)
print v(xbgr.mr_n80239424)
print v(xbgr.mr_n80239536)
print v(xbgr.mr_n80240752)
print v(xbgr.mr_n80240864)
print v(xbgr.mr_n80242016)
print v(xbgr.mr_n80242128)
print v(xbgr.mr_n80243216)
print v(xbgr.mr_n80243328)
print v(xbgr.mr_n80244544)
print v(xbgr.mr_n80244656)
print v(xbgr.mr_n80245808)
print v(xbgr.mr_n80245920)
print v(xbgr.mr_n80248912)
print v(xbgr.mr_n80250464)
print v(xbgr.mr_n80251216)
print v(xbgr.mr_n80252768)
print v(xbgr.mr_n80260624)
print v(xbgr.mr_n80264640)
print v(xbgr.mr_n80265424)
print v(xbgr.mr_n80265536)
print v(xbgr.mr_n80265728)
print v(xbgr.mr_n80265920)
print v(xbgr.mr_n80266112)
print v(xbgr.mr_n80268528)
print v(xbgr.mr_n80274368)
print v(xbgr.mr_n80275312)
print v(xbgr.mr_n80276256)
print v(xbgr.mr_n80277200)
print v(xbgr.mr_n80278144)
print v(xbgr.mr_n80279088)
print v(xbgr.mr_n80280032)
print v(xbgr.mr_n80280976)
print v(xbgr.mr_n80281776)
print v(xbgr.mr_n80281952)
print v(xbgr.mr_n80283088)
print v(xbgr.mr_n80284192)
print v(xbgr.mr_n80286544)
print v(xbgr.mr_n80287488)
print v(xbgr.mr_n80288432)
print v(xbgr.mr_n80289376)
print v(xbgr.mr_n80290320)
print v(xbgr.mr_n80291264)
print v(xbgr.mr_n80292208)
print v(xbgr.mr_n80293152)
print v(xbgr.mr_n80294096)
print v(xbgr.mr_n80295040)
print v(xbgr.mr_n80295984)
print v(xbgr.mr_n80296928)
print v(xbgr.mr_n80297872)
print v(xbgr.mr_n80298816)
print v(xbgr.mr_n80299248)
print v(xbgr.mr_n80302576)
print v(xbgr.mr_n80303520)
print v(xbgr.mr_n80304464)
print v(xbgr.mr_n80304656)
print v(xbgr.mr_n80304848)
print v(xbgr.mr_n80305040)
print v(xbgr.mr_n80305232)
print v(xbgr.mr_n80305424)
print v(xbgr.mr_n80307568)
print v(xbgr.mr_n80307680)
print v(xbgr.mr_n80310768)
print v(xbgr.mr_n80310880)
print v(xbgr.mr_n80316528)
print v(xbgr.mr_n80317472)
print v(xbgr.mr_n80318416)
print v(xbgr.mr_n80319360)
print v(xbgr.mr_n80320304)
print v(xbgr.mr_n80321248)
print v(xbgr.mr_n80322192)
print v(xbgr.mr_n80323136)
print v(xbgr.mr_n80324080)
print v(xbgr.mr_n80325024)
print v(xbgr.mr_n80325712)
print v(xbgr.mr_n80327408)
print v(xbgr.mr_n80328096)
print v(xbgr.mr_n80329040)
print v(xbgr.mr_n80329232)
print v(xbgr.mr_n80329424)
print v(xbgr.mr_n80329616)
print v(xbgr.mr_n80331808)
print v(xbgr.mr_n80332080)
print v(xbgr.mr_n80332272)
print v(xbgr.mr_n80332784)
print v(xbgr.mr_n80333472)
print v(xbgr.mr_n80335328)
print v(xbgr.mr_n80338272)
print v(xbgr.mr_n80339104)
print v(xbgr.mr_n80339216)
print v(xbgr.mr_n80339328)
print v(xbgr.mr_n80339440)
print v(xbgr.mr_n80339552)
print v(xbgr.mr_n80341296)
print v(xbgr.mr_n80341568)
print v(xbgr.mr_n80341760)
print v(xbgr.mr_n80342272)
print v(xbgr.mr_n80344416)
print v(xbgr.mr_n80344608)
print v(xbgr.mr_n80344800)
print v(xbgr.mr_n80346608)
print v(xbgr.mr_n80346800)
print v(xbgr.mr_n80347312)
print v(xbgr.mr_n80349392)
print v(xbgr.mr_n80349504)
print v(xbgr.mr_n80351248)
print v(xbgr.mr_n80351520)
print v(xbgr.mr_n80351712)
print v(xbgr.mr_n80352224)
print v(xbgr.mr_n80354368)
print v(xbgr.mr_n80354480)
print v(xbgr.mr_n80356224)
print v(xbgr.mr_n80356496)
print v(xbgr.mr_n80356688)
print v(xbgr.mr_n80357200)
print v(xbgr.mr_n80359344)
print v(xbgr.mr_n80359536)
print v(xbgr.mr_n80359728)
print v(xbgr.mr_n80361536)
print v(xbgr.mr_n80362240)
print v(xbgr.mr_n80364432)
print v(xbgr.mr_n80366448)
print v(xbgr.mr_n80366640)
print v(xbgr.mr_n80367152)
print v(xbgr.mr_n80369296)
print v(xbgr.mr_n80369408)
print v(xbgr.mr_n80371152)
print v(xbgr.mr_n80371424)
print v(xbgr.mr_n80371616)
print v(xbgr.mr_n80372128)
print v(xbgr.mr_n80380016)
print v(xbgr.mr_n80380448)
print v(xbgr.mr_n80381920)
print v(xbgr.mr_n80382592)
print v(xbgr.mr_n80382784)
print v(xbgr.mr_n80383824)
print v(xbgr.mr_n80383936)
print v(xbgr.mr_n80384816)
print v(xbgr.mr_n80390336)
print v(xbgr.mr_n80391024)
print v(xbgr.mr_n80391712)
print v(xbgr.mr_n80392400)
print v(xbgr.mr_n80393088)
print v(xbgr.mr_n80393776)
print v(xbgr.mr_n80394464)
print v(xbgr.mr_n80395152)
print v(xbgr.mr_n80395840)
print v(xbgr.mr_n80396528)
print v(xbgr.mr_n80397216)
print v(xbgr.mr_n80397904)
print v(xbgr.mr_n80399360)
print v(xbgr.mr_n80408672)
print v(xbgr.mr_n80409504)
print v(xbgr.mr_n80410528)
print v(xbgr.mr_n80410640)
print v(xbgr.mr_n80413104)
print v(xbgr.mr_n80413216)
print v(xbgr.mr_n80414368)
print v(xbgr.mr_n80414480)
print v(xbgr.mr_n80415632)
print v(xbgr.mr_n80415744)
print v(xbgr.mr_n80415952)
print v(xbgr.mr_n80416752)
print v(xbgr.mr_n80416864)
print v(xbgr.mr_n80417696)
print v(xbgr.mr_n80417808)
print v(xbgr.mr_n80418880)
print v(xbgr.mr_n80418992)
print v(xbgr.mr_n80420400)
print v(xbgr.mr_n80420512)
print v(xbgr.mr_n80422912)
print v(xbgr.mr_n80423024)
print v(xbgr.mr_n80424176)
print v(xbgr.mr_n80424288)
print v(xbgr.mr_n80425440)
print v(xbgr.mr_n80425552)
print v(xbgr.mr_n80426704)
print v(xbgr.mr_n80426816)
print v(xbgr.mr_n80427968)
print v(xbgr.mr_n80428080)
print v(xbgr.mr_n80429232)
print v(xbgr.mr_n80429344)
print v(xbgr.mr_n80433088)
print v(xbgr.mr_n80434208)
print v(xbgr.mr_n80435680)
print v(xbgr.mr_n80437248)
print v(xbgr.mr_n80438816)
print v(xbgr.mr_n80440384)
print v(xbgr.mr_n80441952)
print v(xbgr.mr_n80443520)
print v(xbgr.mr_n80445088)
print v(xbgr.mr_n80446656)
print v(xbgr.mr_n80448224)
print v(xbgr.mr_n80449792)
print v(xbgr.mr_n80451984)
print v(xbgr.mr_n80453552)
print v(xbgr.mr_n80455120)
print v(xbgr.mr_n80457040)
print v(xbgr.mr_n80457600)
print v(xbgr.mr_n80466848)
print v(xbgr.mr_n80467920)
print v(xbgr.mr_n80468112)
print v(xbgr.mr_n80468304)
print v(xbgr.mr_n80468496)
print v(xbgr.mr_n80470816)
print v(xbgr.mr_n80471088)
print v(xbgr.mr_n80471280)
print v(xbgr.mr_n80471792)
print v(xbgr.mr_n80476608)
print v(xbgr.mr_n80476880)
print v(xbgr.mr_n80477072)
print v(xbgr.mr_n80477584)
print v(xbgr.mr_n80478848)
print v(xbgr.mr_n80480656)
print v(xbgr.mr_n80480848)
print v(xbgr.mr_n80481360)
print v(xbgr.mr_n80483440)
print v(xbgr.mr_n80483552)
print v(xbgr.mr_n80485296)
print v(xbgr.mr_n80485568)
print v(xbgr.mr_n80485760)
print v(xbgr.mr_n80486272)
print v(xbgr.mr_n80487568)
print v(xbgr.mr_n80488080)
print v(xbgr.mr_n80490064)
print v(xbgr.mr_n80492384)
print v(xbgr.mr_n80494448)
print v(xbgr.mr_n80495808)
print v(xbgr.mr_n80496000)
print v(xbgr.mr_n80496192)
print v(xbgr.mr_n80496784)
print v(xbgr.mr_n80498144)
print v(xbgr.mr_n80498656)
print v(xbgr.mr_n80500336)
print v(xbgr.mr_n80500848)
print v(xbgr.mr_n80502976)
print v(xbgr.mr_n80503488)
print v(xbgr.mr_n80505488)
print v(xbgr.mr_n80506000)
print v(xbgr.mr_n80506944)
print v(xbgr.mr_n80508064)
print v(xbgr.mr_n80508576)
print v(xbgr.mr_n80510640)
print v(xbgr.mr_n80511152)
print v(xbgr.mr_n80513216)
print v(xbgr.mr_n80513728)
print v(xbgr.mr_n80515792)
print v(xbgr.mr_n80516304)
print v(xbgr.mr_n80518368)
print v(xbgr.mr_n80518880)
print v(xbgr.mr_n80519696)
print v(xbgr.mr_n80520160)
print v(xbgr.mr_n80520944)
print v(xbgr.mr_n80521456)
print v(xbgr.mr_n80522272)
print v(xbgr.mr_n80523520)
print v(xbgr.mr_n80524032)
print v(xbgr.mr_n80525056)
print v(xbgr.mr_n80528816)
print v(xbgr.mr_n80529072)
print v(xbgr.mr_n80532304)
print v(xbgr.mr_n80532416)
print v(xbgr.mr_n80533632)
print v(xbgr.mr_n80533744)
print v(xbgr.mr_n80534896)
print v(xbgr.mr_n80535008)
print v(xbgr.mr_n80536160)
print v(xbgr.mr_n80536272)
print v(xbgr.mr_n80537360)
print v(xbgr.mr_n80537472)
print v(xbgr.mr_n80538688)
print v(xbgr.mr_n80538800)
print v(xbgr.mr_n80539952)
print v(xbgr.mr_n80540064)
print v(xbgr.mr_n80541216)
print v(xbgr.mr_n80541328)
print v(xbgr.mr_n80542480)
print v(xbgr.mr_n80542592)
print v(xbgr.mr_n80543744)
print v(xbgr.mr_n80543856)
print v(xbgr.mr_n80545008)
print v(xbgr.mr_n80545120)
print v(xbgr.mr_n80546272)
print v(xbgr.mr_n80546384)
print v(xbgr.mr_n80547472)
print v(xbgr.mr_n80547584)
print v(xbgr.mr_n80548800)
print v(xbgr.mr_n80548912)
print v(xbgr.mr_n80550304)
print v(xbgr.mr_n80559808)
print v(xbgr.mr_n80561632)
print v(xbgr.mr_n80564192)
print v(xbgr.mr_n80564880)
print v(xbgr.mr_n80565920)
print v(xbgr.mr_n80567536)
print v(xbgr.mr_n80568480)
print v(xbgr.mr_n80569424)
print v(xbgr.mr_n80570368)
print v(xbgr.mr_n80571312)
print v(xbgr.mr_n80572256)
print v(xbgr.mr_n80573200)
print v(xbgr.mr_n80574144)
print v(xbgr.mr_n80575088)
print v(xbgr.mr_n80576032)
print v(xbgr.mr_n80576976)
print v(xbgr.mr_n80577920)
print v(xbgr.mr_n80578864)
print v(xbgr.mr_n80579808)
print v(xbgr.mr_n80580752)
print v(xbgr.mr_n80581696)
print v(xbgr.mr_n80586112)
print v(xbgr.mr_n80586992)
print v(xbgr.mr_n80588016)
print v(xbgr.mr_n80589584)
print v(xbgr.mr_n80591136)
print v(xbgr.mr_n80592928)
print v(xbgr.mr_n80594160)
print v(xbgr.mr_n80594272)
print v(xbgr.mr_n80595216)
print v(xbgr.mr_n80596304)
print v(xbgr.mr_n80596416)
print v(xbgr.mr_n80598256)
print v(xbgr.mr_n80598368)
print v(xbgr.mr_n80599312)
print v(xbgr.mr_n80600464)
print v(xbgr.mr_n80600576)
print v(xbgr.mr_n80602352)
print v(xbgr.mr_n80602464)
print v(xbgr.mr_n80603408)
print v(xbgr.mr_n80604560)
print v(xbgr.mr_n80604672)
print v(xbgr.mr_n80606448)
print v(xbgr.mr_n80606560)
print v(xbgr.mr_n80607504)
print v(xbgr.mr_n80608656)
print v(xbgr.mr_n80608768)
print v(xbgr.mr_n80610480)
print v(xbgr.mr_n80610592)
print v(xbgr.mr_n80611536)
print v(xbgr.mr_n80612752)
print v(xbgr.mr_n80612864)
print v(xbgr.mr_n80614640)
print v(xbgr.mr_n80614752)
print v(xbgr.mr_n80615696)
print v(xbgr.mr_n80616848)
print v(xbgr.mr_n80616960)
print v(xbgr.mr_n80618736)
print v(xbgr.mr_n80618848)
print v(xbgr.mr_n80619792)
print v(xbgr.mr_n80620944)
print v(xbgr.mr_n80621056)
print v(xbgr.mr_n80622240)
print v(xbgr.mr_n80622768)
print v(xbgr.mr_n80622880)
print v(xbgr.mr_n80623824)
print v(xbgr.mr_n80625040)
print v(xbgr.mr_n80625152)
print v(xbgr.mr_n80626928)
print v(xbgr.mr_n80627040)
print v(xbgr.mr_n80628336)
print v(xbgr.mr_n80631552)
print v(xbgr.mr_n80633120)
print v(xbgr.mr_n80634688)
print v(xbgr.mr_n80636256)
print v(xbgr.mr_n80637824)
print v(xbgr.mr_n80639392)
print v(xbgr.mr_n80640960)
print v(xbgr.mr_n80647600)
print v(xbgr.mr_n80648112)
print v(xbgr.mr_n80649920)
print v(xbgr.mr_n80650800)
print v(xbgr.mr_n80658960)
print v(xbgr.mr_n80659824)
print v(xbgr.mr_n80660896)
print v(xbgr.mr_n80661088)
print v(xbgr.mr_n80661280)
print v(xbgr.mr_n80661664)
print v(xbgr.mr_n80663984)
print v(xbgr.mr_n80664176)
print v(xbgr.mr_n80664368)
print v(xbgr.mr_n80664960)
print v(xbgr.mr_n80665456)
print v(xbgr.mr_n80667024)
print v(xbgr.mr_n80670912)
print v(xbgr.mr_n80671104)
print v(xbgr.mr_n80671616)
print v(xbgr.mr_n80673712)
print v(xbgr.mr_n80674352)
print v(xbgr.mr_n80674624)
print v(xbgr.mr_n80674816)
print v(xbgr.mr_n80675328)
print v(xbgr.mr_n80677472)
print v(xbgr.mr_n80677584)
print v(xbgr.mr_n80677856)
print v(xbgr.mr_n80679328)
print v(xbgr.mr_n80679600)
print v(xbgr.mr_n80679792)
print v(xbgr.mr_n80680304)
print v(xbgr.mr_n80681536)
print v(xbgr.mr_n80682048)
print v(xbgr.mr_n80684224)
print v(xbgr.mr_n80685200)
print v(xbgr.mr_n80686288)
print v(xbgr.mr_n80686464)
print v(xbgr.mr_n80687344)
print v(xbgr.mr_n80687456)
print v(xbgr.mr_n80687568)
print v(xbgr.mr_n80687680)
print v(xbgr.mr_n80688864)
print v(xbgr.mr_n80689136)
print v(xbgr.mr_n80689328)
print v(xbgr.mr_n80689840)
print v(xbgr.mr_n80690032)
print v(xbgr.mr_n80690144)
print v(xbgr.mr_n80691920)
print v(xbgr.mr_n80693632)
print v(xbgr.mr_n80695040)
print v(xbgr.mr_n80695232)
print v(xbgr.mr_n80695424)
print v(xbgr.mr_n80696016)
print v(xbgr.mr_n80699248)
print v(xbgr.mr_n80699440)
print v(xbgr.mr_n80699632)
print v(xbgr.mr_n80701440)
print v(xbgr.mr_n80701632)
print v(xbgr.mr_n80702144)
print v(xbgr.mr_n80703312)
print v(xbgr.mr_n80703824)
print v(xbgr.mr_n80707264)
print v(xbgr.mr_n80707536)
print v(xbgr.mr_n80707728)
print v(xbgr.mr_n80708240)
print v(xbgr.mr_n80710384)
print v(xbgr.mr_n80710496)
print v(xbgr.mr_n80712240)
print v(xbgr.mr_n80712512)
print v(xbgr.mr_n80712704)
print v(xbgr.mr_n80713216)
print v(xbgr.mr_n80714448)
print v(xbgr.mr_n80714960)
print v(xbgr.mr_n80718400)
print v(xbgr.mr_n80718672)
print v(xbgr.mr_n80718864)
print v(xbgr.mr_n80719376)
print v(xbgr.mr_n80721520)
print v(xbgr.mr_n80721632)
print v(xbgr.mr_n80723376)
print v(xbgr.mr_n80723648)
print v(xbgr.mr_n80723840)
print v(xbgr.mr_n80724352)
print v(xbgr.mr_n80725584)
print v(xbgr.mr_n80726096)
print v(xbgr.mr_n80728896)
print v(xbgr.mr_n80730896)
print v(xbgr.mr_n80733152)
print v(xbgr.mr_n80733264)
print v(xbgr.mr_n80734096)
print v(xbgr.mr_n80734208)
print v(xbgr.mr_n80735040)
print v(xbgr.mr_n80735152)
print v(xbgr.mr_n80736240)
print v(xbgr.mr_n80736352)
print v(xbgr.mr_n80737504)
print v(xbgr.mr_n80737616)
print v(xbgr.mr_n80738768)
print v(xbgr.mr_n80738880)
print v(xbgr.mr_n80740032)
print v(xbgr.mr_n80740144)
print v(xbgr.mr_n80741296)
print v(xbgr.mr_n80741408)
print v(xbgr.mr_n80742496)
print v(xbgr.mr_n80742608)
print v(xbgr.mr_n80743824)
print v(xbgr.mr_n80743936)
print v(xbgr.mr_n80745088)
print v(xbgr.mr_n80745200)
print v(xbgr.mr_n80746352)
print v(xbgr.mr_n80746464)
print v(xbgr.mr_n80747616)
print v(xbgr.mr_n80747728)
print v(xbgr.mr_n80748880)
print v(xbgr.mr_n80748992)
print v(xbgr.mr_n80750144)
print v(xbgr.mr_n80750256)
print v(xbgr.mr_n80750704)
print v(xbgr.mr_n80751648)
print v(xbgr.mr_n80753520)
print v(xbgr.mr_n80753824)
print v(xbgr.mr_n80756768)
print v(xbgr.mr_n80757456)
print v(xbgr.mr_n80758144)
print v(xbgr.mr_n80758864)
print v(xbgr.mr_n80759808)
print v(xbgr.mr_n80760752)
print v(xbgr.mr_n80761696)
print v(xbgr.mr_n80762640)
print v(xbgr.mr_n80763584)
print v(xbgr.mr_n80764528)
print v(xbgr.mr_n80765472)
print v(xbgr.mr_n80766416)
print v(xbgr.mr_n80767360)
print v(xbgr.mr_n80768304)
print v(xbgr.mr_n80769248)
print v(xbgr.mr_n80770192)
print v(xbgr.mr_n80771136)
print v(xbgr.mr_n80772080)
print v(xbgr.mr_n80773024)
print v(xbgr.mr_n80775520)
print v(xbgr.mr_n80775984)
print v(xbgr.mr_n80787152)
print v(xbgr.mr_n80788560)
print v(xbgr.mr_n80790128)
print v(xbgr.mr_n80792608)
print v(xbgr.mr_n80793648)
print v(xbgr.mr_n80793760)
print v(xbgr.mr_n80794704)
print v(xbgr.mr_n80795856)
print v(xbgr.mr_n80795968)
print v(xbgr.mr_n80797744)
print v(xbgr.mr_n80797856)
print v(xbgr.mr_n80798800)
print v(xbgr.mr_n80799952)
print v(xbgr.mr_n80800064)
print v(xbgr.mr_n80801840)
print v(xbgr.mr_n80801952)
print v(xbgr.mr_n80802896)
print v(xbgr.mr_n80804048)
print v(xbgr.mr_n80804160)
print v(xbgr.mr_n80805936)
print v(xbgr.mr_n80806048)
print v(xbgr.mr_n80806992)
print v(xbgr.mr_n80808144)
print v(xbgr.mr_n80808256)
print v(xbgr.mr_n80810032)
print v(xbgr.mr_n80810144)
print v(xbgr.mr_n80811088)
print v(xbgr.mr_n80812240)
print v(xbgr.mr_n80812352)
print v(xbgr.mr_n80813520)
print v(xbgr.mr_n80814128)
print v(xbgr.mr_n80814240)
print v(xbgr.mr_n80815184)
print v(xbgr.mr_n80816336)
print v(xbgr.mr_n80816448)
print v(xbgr.mr_n80818224)
print v(xbgr.mr_n80818336)
print v(xbgr.mr_n80819280)
print v(xbgr.mr_n80820432)
print v(xbgr.mr_n80820544)
print v(xbgr.mr_n80822256)
print v(xbgr.mr_n80822576)
print v(xbgr.mr_n80823904)
print v(xbgr.mr_n80824768)
print v(xbgr.mr_n80825872)
print v(xbgr.mr_n80828464)
print v(xbgr.mr_n80830032)
print v(xbgr.mr_n80831600)
print v(xbgr.mr_n80833168)
print v(xbgr.mr_n80834736)
print v(xbgr.mr_n80836304)
print v(xbgr.mr_n80842368)
print v(xbgr.mr_n80845184)
print v(xbgr.mr_n80852768)
print v(xbgr.mr_n80853168)
print v(xbgr.mr_n80854352)
print v(xbgr.mr_n80855392)
print v(xbgr.mr_n80855904)
print v(xbgr.mr_n80862880)
print v(xbgr.mr_n80863408)
print v(xbgr.mr_n80863600)
print v(xbgr.mr_n80864288)
print v(xbgr.mr_n80864720)
print v(xbgr.mr_n80865552)
print v(xbgr.mr_n80866128)
print v(xbgr.mr_n80866816)
print v(xbgr.mr_n80867520)
print v(xbgr.mr_n80868080)
print v(xbgr.mr_n80868656)
print v(xbgr.mr_n80869344)
print v(xbgr.mr_n80869920)
print v(xbgr.mr_n80870608)
print v(xbgr.mr_n80871040)
print v(xbgr.mr_n80871872)
print v(xbgr.mr_n80872448)
print v(xbgr.mr_n80873136)
print v(xbgr.mr_n80873568)
print v(xbgr.mr_n80874400)
print v(xbgr.mr_n80874832)
print v(xbgr.mr_n80875664)
print v(xbgr.mr_n80876096)
print v(xbgr.mr_n80876928)
print v(xbgr.mr_n80877360)
print v(xbgr.mr_n80878192)
print v(xbgr.mr_n80878768)
print v(xbgr.mr_n80879456)
print v(xbgr.mr_n80880032)
print v(xbgr.mr_n80880720)
print v(xbgr.mr_n80881296)
print v(xbgr.mr_n80881984)
print v(xbgr.mr_n80882560)
print v(xbgr.mr_n80883248)
print v(xbgr.mr_n80883824)
print v(xbgr.mr_n80884512)
print v(xbgr.mr_n80884624)
print v(xbgr.mr_n80888016)
print v(xbgr.mr_n80888128)
print v(xbgr.mr_n80888240)
print v(xbgr.mr_n80888352)
print v(xbgr.mr_n80890672)
print v(xbgr.mr_n80890944)
print v(xbgr.mr_n80891136)
print v(xbgr.mr_n80891648)
print v(xbgr.mr_n80892880)
print v(xbgr.mr_n80893392)
print v(xbgr.mr_n80894944)
print v(xbgr.mr_n80895456)
print v(xbgr.mr_n80897392)
print v(xbgr.mr_n80897904)
print v(xbgr.mr_n80899840)
print v(xbgr.mr_n80900352)
print v(xbgr.mr_n80901424)
print v(xbgr.mr_n80902288)
print v(xbgr.mr_n80902800)
print v(xbgr.mr_n80904736)
print v(xbgr.mr_n80905248)
print v(xbgr.mr_n80907184)
print v(xbgr.mr_n80907696)
print v(xbgr.mr_n80909632)
print v(xbgr.mr_n80910144)
print v(xbgr.mr_n80912080)
print v(xbgr.mr_n80912592)
print v(xbgr.mr_n80914528)
print v(xbgr.mr_n80915040)
print v(xbgr.mr_n80916000)
print v(xbgr.mr_n80916976)
print v(xbgr.mr_n80917488)
print v(xbgr.mr_n80919424)
print v(xbgr.mr_n80919936)
print v(xbgr.mr_n80921872)
print v(xbgr.mr_n80922384)
print v(xbgr.mr_n80924320)
print v(xbgr.mr_n80924832)
print v(xbgr.mr_n80926768)
print v(xbgr.mr_n80927280)
print v(xbgr.mr_n80929216)
print v(xbgr.mr_n80929728)
print v(xbgr.mr_n80929904)
print v(xbgr.mr_n80937648)
print v(xbgr.mr_n80938800)
print v(xbgr.mr_n80938912)
print v(xbgr.mr_n80940000)
print v(xbgr.mr_n80940112)
print v(xbgr.mr_n80941328)
print v(xbgr.mr_n80941440)
print v(xbgr.mr_n80942592)
print v(xbgr.mr_n80942704)
print v(xbgr.mr_n80943856)
print v(xbgr.mr_n80943968)
print v(xbgr.mr_n80945120)
print v(xbgr.mr_n80945232)
print v(xbgr.mr_n80946384)
print v(xbgr.mr_n80946496)
print v(xbgr.mr_n80947648)
print v(xbgr.mr_n80947760)
print v(xbgr.mr_n80948912)
print v(xbgr.mr_n80949024)
print v(xbgr.mr_n80950176)
print v(xbgr.mr_n80950288)
print v(xbgr.mr_n80951440)
print v(xbgr.mr_n80951552)
print v(xbgr.mr_n80952704)
print v(xbgr.mr_n80952816)
print v(xbgr.mr_n80953968)
print v(xbgr.mr_n80954080)
print v(xbgr.mr_n80955168)
print v(xbgr.mr_n80955280)
print v(xbgr.mr_n80956496)
print v(xbgr.mr_n80956608)
print v(xbgr.mr_n80957424)
print v(xbgr.mr_n80957536)
print v(xbgr.mr_n80957648)
print v(xbgr.mr_n80957760)
print v(xbgr.mr_n80959088)
print v(xbgr.mr_n80959776)
print v(xbgr.mr_n80960848)
print v(xbgr.mr_n80963136)
print v(xbgr.mr_n80964080)
print v(xbgr.mr_n80965024)
print v(xbgr.mr_n80975632)
print v(xbgr.mr_n80981312)
print v(xbgr.mr_n80989040)
print v(xbgr.mr_n80990608)
print v(xbgr.mr_n80992416)
print v(xbgr.mr_n80993728)
print v(xbgr.mr_n80994960)
print v(xbgr.mr_n80995072)
print v(xbgr.mr_n80996016)
print v(xbgr.mr_n80997168)
print v(xbgr.mr_n80997280)
print v(xbgr.mr_n80999056)
print v(xbgr.mr_n80999168)
print v(xbgr.mr_n81000112)
print v(xbgr.mr_n81001264)
print v(xbgr.mr_n81001376)
print v(xbgr.mr_n81003152)
print v(xbgr.mr_n81003264)
print v(xbgr.mr_n81004208)
print v(xbgr.mr_n81005360)
print v(xbgr.mr_n81005472)
print v(xbgr.mr_n81007184)
print v(xbgr.mr_n81007296)
print v(xbgr.mr_n81008240)
print v(xbgr.mr_n81009456)
print v(xbgr.mr_n81009568)
print v(xbgr.mr_n81010816)
print v(xbgr.mr_n81011344)
print v(xbgr.mr_n81011456)
print v(xbgr.mr_n81012400)
print v(xbgr.mr_n81013552)
print v(xbgr.mr_n81013664)
print v(xbgr.mr_n81015440)
print v(xbgr.mr_n81015552)
print v(xbgr.mr_n81016496)
print v(xbgr.mr_n81017648)
print v(xbgr.mr_n81017760)
print v(xbgr.mr_n81019536)
print v(xbgr.mr_n81019648)
print v(xbgr.mr_n81020592)
print v(xbgr.mr_n81021744)
print v(xbgr.mr_n81021856)
print v(xbgr.mr_n81023632)
print v(xbgr.mr_n81023744)
print v(xbgr.mr_n81024688)
print v(xbgr.mr_n81025840)
print v(xbgr.mr_n81025952)
print v(xbgr.mr_n81027120)
print v(xbgr.mr_n81027728)
print v(xbgr.mr_n81027840)
print v(xbgr.mr_n81029152)
print v(xbgr.mr_n81030272)
print v(xbgr.mr_n81032368)
print v(xbgr.mr_n81033936)
print v(xbgr.mr_n81035504)
print v(xbgr.mr_n81037072)
print v(xbgr.mr_n81038640)
print v(xbgr.mr_n81040208)
print v(xbgr.mr_n81041776)
print v(xbgr.mr_n81052192)
print v(xbgr.mr_n81052912)
print v(xbgr.mr_n81059520)
print v(xbgr.mr_n81061376)
print v(xbgr.mr_n81061488)
print v(xbgr.mr_n81062432)
print v(xbgr.mr_n81062624)
print v(xbgr.mr_n81062816)
print v(xbgr.mr_n81063008)
print v(xbgr.mr_n81063584)
print v(xbgr.mr_n81065264)
print v(xbgr.mr_n81065536)
print v(xbgr.mr_n81065728)
print v(xbgr.mr_n81066240)
print v(xbgr.mr_n81066736)
print v(xbgr.mr_n81070368)
print v(xbgr.mr_n81070480)
print v(xbgr.mr_n81072224)
print v(xbgr.mr_n81072496)
print v(xbgr.mr_n81072688)
print v(xbgr.mr_n81073200)
print v(xbgr.mr_n81075344)
print v(xbgr.mr_n81075456)
print v(xbgr.mr_n81077200)
print v(xbgr.mr_n81077472)
print v(xbgr.mr_n81077664)
print v(xbgr.mr_n81078176)
print v(xbgr.mr_n81080320)
print v(xbgr.mr_n81080432)
print v(xbgr.mr_n81082176)
print v(xbgr.mr_n81082448)
print v(xbgr.mr_n81082640)
print v(xbgr.mr_n81083152)
print v(xbgr.mr_n81085296)
print v(xbgr.mr_n81085408)
print v(xbgr.mr_n81087152)
print v(xbgr.mr_n81087424)
print v(xbgr.mr_n81087616)
print v(xbgr.mr_n81088128)
print v(xbgr.mr_n81090272)
print v(xbgr.mr_n81090384)
print v(xbgr.mr_n81092400)
print v(xbgr.mr_n81092720)
print v(xbgr.mr_n81092832)
print v(xbgr.mr_n81093136)
print v(xbgr.mr_n81095440)
print v(xbgr.mr_n81096272)
print v(xbgr.mr_n81097248)
print v(xbgr.mr_n81097360)
print v(xbgr.mr_n81097472)
print v(xbgr.mr_n81097584)
print v(xbgr.mr_n81099328)
print v(xbgr.mr_n81099600)
print v(xbgr.mr_n81099792)
print v(xbgr.mr_n81100304)
print v(xbgr.mr_n81103536)
print v(xbgr.mr_n81103648)
print v(xbgr.mr_n81105392)
print v(xbgr.mr_n81105664)
print v(xbgr.mr_n81105856)
print v(xbgr.mr_n81106368)
print v(xbgr.mr_n81108512)
print v(xbgr.mr_n81108624)
print v(xbgr.mr_n81110368)
print v(xbgr.mr_n81110640)
print v(xbgr.mr_n81110832)
print v(xbgr.mr_n81111344)
print v(xbgr.mr_n81113488)
print v(xbgr.mr_n81113600)
print v(xbgr.mr_n81115344)
print v(xbgr.mr_n81115536)
print v(xbgr.mr_n81115728)
print v(xbgr.mr_n81116320)
print v(xbgr.mr_n81118464)
print v(xbgr.mr_n81118656)
print v(xbgr.mr_n81118848)
print v(xbgr.mr_n81120656)
print v(xbgr.mr_n81120848)
print v(xbgr.mr_n81121360)
print v(xbgr.mr_n81123440)
print v(xbgr.mr_n81123552)
print v(xbgr.mr_n81125296)
print v(xbgr.mr_n81125568)
print v(xbgr.mr_n81125760)
print v(xbgr.mr_n81126272)
print v(xbgr.mr_n81128416)
print v(xbgr.mr_n81128528)
print v(xbgr.mr_n81130272)
print v(xbgr.mr_n81130544)
print v(xbgr.mr_n81130736)
print v(xbgr.mr_n81131248)
print v(xbgr.mr_n81133392)
print v(xbgr.mr_n81133504)
print v(xbgr.mr_n81135248)
print v(xbgr.mr_n81135520)
print v(xbgr.mr_n81135712)
print v(xbgr.mr_n81136224)
print v(xbgr.mr_n81138368)
print v(xbgr.mr_n81138560)
print v(xbgr.mr_n81138752)
print v(xbgr.mr_n81140560)
print v(xbgr.mr_n81140752)
print v(xbgr.mr_n81141264)
print v(xbgr.mr_n81143344)
print v(xbgr.mr_n81143456)
print v(xbgr.mr_n81145200)
print v(xbgr.mr_n81145472)
print v(xbgr.mr_n81145664)
print v(xbgr.mr_n81146176)
print v(xbgr.mr_n81148592)
print v(xbgr.mr_n81149488)
print v(xbgr.mr_n81149952)
print v(xbgr.mr_n81151056)
print v(xbgr.mr_n81151648)
print v(xbgr.mr_n81155808)
print v(xbgr.mr_n81169936)
print v(xbgr.mr_n81177648)
print v(xbgr.mr_n81178768)
print v(xbgr.mr_n81179824)
print v(xbgr.mr_n81180256)
print v(xbgr.mr_n81183664)
print v(xbgr.mr_n81183776)
print v(xbgr.mr_n81184928)
print v(xbgr.mr_n81185040)
print v(xbgr.mr_n81186192)
print v(xbgr.mr_n81186304)
print v(xbgr.mr_n81187456)
print v(xbgr.mr_n81187568)
print v(xbgr.mr_n81188720)
print v(xbgr.mr_n81188832)
print v(xbgr.mr_n81189984)
print v(xbgr.mr_n81190096)
print v(xbgr.mr_n81191248)
print v(xbgr.mr_n81191360)
print v(xbgr.mr_n81192512)
print v(xbgr.mr_n81192624)
print v(xbgr.mr_n81193776)
print v(xbgr.mr_n81193888)
print v(xbgr.mr_n81195040)
print v(xbgr.mr_n81195152)
print v(xbgr.mr_n81196304)
print v(xbgr.mr_n81196416)
print v(xbgr.mr_n81197568)
print v(xbgr.mr_n81197680)
print v(xbgr.mr_n81198832)
print v(xbgr.mr_n81198944)
print v(xbgr.mr_n81200096)
print v(xbgr.mr_n81200208)
print v(xbgr.mr_n81201360)
print v(xbgr.mr_n81201472)
print v(xbgr.mr_n81206768)
print v(xbgr.mr_n81207488)
print v(xbgr.mr_n81209344)
print v(xbgr.mr_n81211632)
print v(xbgr.mr_n81212320)
print v(xbgr.mr_n81213008)
print v(xbgr.mr_n81213728)
print v(xbgr.mr_n81214672)
print v(xbgr.mr_n81215616)
print v(xbgr.mr_n81216560)
print v(xbgr.mr_n81217504)
print v(xbgr.mr_n81218448)
print v(xbgr.mr_n81219392)
print v(xbgr.mr_n81220336)
print v(xbgr.mr_n81221280)
print v(xbgr.mr_n81222224)
print v(xbgr.mr_n81223168)
print v(xbgr.mr_n81224112)
print v(xbgr.mr_n81225056)
print v(xbgr.mr_n81226000)
print v(xbgr.mr_n81226944)
print v(xbgr.mr_n81227744)
print v(xbgr.mr_n81227856)
print v(xbgr.mr_n81228032)
print v(xbgr.mr_n81229200)
print v(xbgr.mr_n81230624)
print v(xbgr.mr_n81232336)
print v(xbgr.mr_n81233280)
print v(xbgr.mr_n81234224)
print v(xbgr.mr_n81235168)
print v(xbgr.mr_n81237264)
print v(xbgr.mr_n81243536)
print v(xbgr.mr_n81247936)
print v(xbgr.mr_n81249600)
print v(xbgr.mr_n81250880)
print v(xbgr.mr_n81252176)
print v(xbgr.mr_n81253072)
print v(xbgr.mr_n81253600)
print v(xbgr.mr_n81254480)
print v(xbgr.mr_n81255360)
print v(xbgr.mr_n81255472)
print v(xbgr.mr_n81255824)
print v(xbgr.mr_n81256000)
print v(xbgr.mr_n81256768)
print v(xbgr.mr_n81257824)
print v(xbgr.mr_n81258528)
print v(xbgr.mr_n81259168)
print v(xbgr.mr_n81260288)
print v(xbgr.mr_n81260752)
print v(xbgr.mr_n81260992)
print v(xbgr.mr_n81261168)
print v(xbgr.mr_n81261696)
print v(xbgr.mr_n81262512)
print v(xbgr.mr_n81264624)
print v(xbgr.mr_n81265568)
print v(xbgr.mr_n81266560)
print v(xbgr.mr_n81266912)
print v(xbgr.mr_n81267088)
print v(xbgr.mr_n81267264)
print v(xbgr.mr_n81267856)
print v(xbgr.mr_n81268144)
print v(xbgr.mr_n81268384)
print v(xbgr.mr_n81268848)
print v(xbgr.mr_n81270736)
print v(xbgr.mr_n81271904)
print v(xbgr.mr_n81272896)
print v(xbgr.mr_n81273600)
print v(xbgr.mr_n81273776)
print v(xbgr.mr_n81274016)
print v(xbgr.mr_n81274128)
print v(xbgr.mr_n81274304)
print v(xbgr.mr_n81274656)
print v(xbgr.mr_n81274896)
print v(xbgr.mr_n81275008)
print v(xbgr.mr_n81275360)
print v(xbgr.mr_n81275600)
print v(xbgr.mr_n81276320)
print v(xbgr.mr_n81277136)
print v(xbgr.mr_n81277744)
print v(xbgr.mr_n81278096)
print v(xbgr.mr_n81280096)
print v(xbgr.mr_n81281040)
print v(xbgr.mr_n81281984)
print v(xbgr.mr_n81282928)
print v(xbgr.mr_n81283872)
print v(xbgr.mr_n81284816)
print v(xbgr.mr_n81285760)
print v(xbgr.mr_n81286704)
print v(xbgr.mr_n81287648)
print v(xbgr.mr_n81288592)
print v(xbgr.mr_n81289536)
print v(xbgr.mr_n81290480)
print v(xbgr.mr_n81291424)
print v(xbgr.mr_n81292368)
print v(xbgr.mr_n81293312)
print v(xbgr.mr_n81294256)
print v(xbgr.mr_n81295200)
print v(xbgr.mr_n81296144)
print v(xbgr.mr_n81297088)
print v(xbgr.mr_n81298032)
print v(xbgr.mr_n81298976)
print v(xbgr.mr_n81299920)
print v(xbgr.mr_n81300864)
print v(xbgr.mr_n81301808)
print v(xbgr.mr_n81302752)
print v(xbgr.mr_n81303696)
print v(xbgr.mr_n81304640)
print v(xbgr.mr_n81305584)
print v(xbgr.mr_n81306528)
print v(xbgr.mr_n81307472)
print v(xbgr.mr_n81308416)
print v(xbgr.mr_n81309360)
print v(xbgr.mr_n81310304)
print v(xbgr.mr_n81311248)
print v(xbgr.mr_n81312192)
print v(xbgr.mr_n81313136)
print v(xbgr.mr_n81314080)
print v(xbgr.mr_n81315024)
print v(xbgr.mr_n81315968)
print v(xbgr.mr_n81316912)
print v(xbgr.mr_n81317856)
print v(xbgr.mr_n81318800)
print v(xbgr.mr_n81319744)
print v(xbgr.mr_n81320688)
print v(xbgr.mr_n81321632)
print v(xbgr.mr_n81322576)
print v(xbgr.mr_n81323520)
print v(xbgr.mr_n81324464)
print v(xbgr.mr_n81325408)
print v(xbgr.mr_n81326352)
print v(xbgr.mr_n81327296)
print v(xbgr.mr_n81328240)
print v(xbgr.mr_n81329184)
print v(xbgr.mr_n81330128)
print v(xbgr.mr_n81331072)
print v(xbgr.mr_n81332016)
print v(xbgr.mr_n81332960)
print v(xbgr.mr_n81333904)
print v(xbgr.mr_n81334848)
print v(xbgr.mr_n81335792)
print v(xbgr.mr_n81336736)
print v(xbgr.mr_n81337680)
print v(xbgr.mr_n81338624)
print v(xbgr.mr_n81339568)
print v(xbgr.mr_n81340512)
print v(xbgr.mr_n81341456)
print v(xbgr.mr_n81342400)
print v(xbgr.mr_n81343344)
print v(xbgr.mr_n81344288)
print v(xbgr.mr_n81345232)
print v(xbgr.mr_n81346176)
print v(xbgr.mr_n81347120)
print v(xbgr.mr_n81348064)
print v(xbgr.mr_n81349008)
print v(xbgr.mr_n81349952)
print v(xbgr.mr_n81350896)
print v(xbgr.mr_n81351840)
print v(xbgr.mr_n81352784)
print v(xbgr.mr_n81353728)
print v(xbgr.mr_n81354672)
print v(xbgr.mr_n81355616)
print v(xbgr.mr_n81356560)
print v(xbgr.mr_n81357504)
print v(xbgr.mr_n81358448)
print v(xbgr.mr_n81359392)
print v(xbgr.mr_n81360336)
print v(xbgr.mr_n81361280)
print v(xbgr.mr_n81362224)
print v(xbgr.mr_n81363424)
print v(xbgr.mr_n81363696)
print v(xbgr.mr_n81367264)
print v(xbgr.mr_n81367456)
print v(xbgr.mr_n81368000)
print v(xbgr.mr_n81374624)
print v(xbgr.mr_n81374736)
print v(xbgr.mr_n81376480)
print v(xbgr.mr_n81376752)
print v(xbgr.mr_n81376944)
print v(xbgr.mr_n81377456)
print v(xbgr.mr_n81380640)
print v(xbgr.mr_n81380752)
print v(xbgr.mr_n81380864)
print v(xbgr.mr_n81380976)
print v(xbgr.mr_n81382720)
print v(xbgr.mr_n81382992)
print v(xbgr.mr_n81383184)
print v(xbgr.mr_n81383696)
print v(xbgr.mr_n81384064)
print v(xbgr.mr_n81384928)
print v(xbgr.mr_n81385440)
print v(xbgr.mr_n81388288)
print v(xbgr.mr_n81388400)
print v(xbgr.mr_n81390144)
print v(xbgr.mr_n81390416)
print v(xbgr.mr_n81390608)
print v(xbgr.mr_n81391120)
print v(xbgr.mr_n81394304)
print v(xbgr.mr_n81394416)
print v(xbgr.mr_n81394528)
print v(xbgr.mr_n81394640)
print v(xbgr.mr_n81396384)
print v(xbgr.mr_n81396656)
print v(xbgr.mr_n81396848)
print v(xbgr.mr_n81397360)
print v(xbgr.mr_n81400544)
print v(xbgr.mr_n81400656)
print v(xbgr.mr_n81400768)
print v(xbgr.mr_n81400880)
print v(xbgr.mr_n81402624)
print v(xbgr.mr_n81402896)
print v(xbgr.mr_n81403088)
print v(xbgr.mr_n81403600)
print v(xbgr.mr_n81404048)
print v(xbgr.mr_n81404832)
print v(xbgr.mr_n81405344)
print v(xbgr.mr_n81408192)
print v(xbgr.mr_n81408384)
print v(xbgr.mr_n81408576)
print v(xbgr.mr_n81410384)
print v(xbgr.mr_n81410576)
print v(xbgr.mr_n81411088)
print v(xbgr.mr_n81414208)
print v(xbgr.mr_n81414320)
print v(xbgr.mr_n81414432)
print v(xbgr.mr_n81414544)
print v(xbgr.mr_n81416288)
print v(xbgr.mr_n81416560)
print v(xbgr.mr_n81416752)
print v(xbgr.mr_n81417264)
print v(xbgr.mr_n81420448)
print v(xbgr.mr_n81420560)
print v(xbgr.mr_n81420672)
print v(xbgr.mr_n81420784)
print v(xbgr.mr_n81422528)
print v(xbgr.mr_n81422800)
print v(xbgr.mr_n81422992)
print v(xbgr.mr_n81423504)
print v(xbgr.mr_n81423616)
print v(xbgr.mr_n81424736)
print v(xbgr.mr_n81425248)
print v(xbgr.mr_n81428096)
print v(xbgr.mr_n81428208)
print v(xbgr.mr_n81429952)
print v(xbgr.mr_n81430224)
print v(xbgr.mr_n81430416)
print v(xbgr.mr_n81430928)
print v(xbgr.mr_n81434112)
print v(xbgr.mr_n81434224)
print v(xbgr.mr_n81434336)
print v(xbgr.mr_n81434448)
print v(xbgr.mr_n81436192)
print v(xbgr.mr_n81436464)
print v(xbgr.mr_n81436656)
print v(xbgr.mr_n81437168)
print v(xbgr.mr_n81440352)
print v(xbgr.mr_n81440464)
print v(xbgr.mr_n81440656)
print v(xbgr.mr_n81440848)
print v(xbgr.mr_n81441040)
print v(xbgr.mr_n81441232)
print v(xbgr.mr_n81441424)
print v(xbgr.mr_n81443664)
print v(xbgr.mr_n81444640)
print v(xbgr.mr_n81445152)
print v(xbgr.mr_n81448000)
print v(xbgr.mr_n81448112)
print v(xbgr.mr_n81449856)
print v(xbgr.mr_n81450128)
print v(xbgr.mr_n81450320)
print v(xbgr.mr_n81450832)
print v(xbgr.mr_n81452896)
print v(xbgr.mr_n81453008)
print v(xbgr.mr_n81453520)
print v(xbgr.mr_n81453632)
print v(xbgr.mr_n81454144)
print v(xbgr.mr_n81454256)
print v(xbgr.mr_n81455024)
print v(xbgr.mr_n81455136)
print v(xbgr.mr_n81455968)
print v(xbgr.mr_n81456080)
print v(xbgr.mr_n81457168)
print v(xbgr.mr_n81457280)
print v(xbgr.mr_n81458432)
print v(xbgr.mr_n81458544)
print v(xbgr.mr_n81459696)
print v(xbgr.mr_n81459808)
print v(xbgr.mr_n81460960)
print v(xbgr.mr_n81461072)
print v(xbgr.mr_n81462224)
print v(xbgr.mr_n81462336)
print v(xbgr.mr_n81463488)
print v(xbgr.mr_n81463600)
print v(xbgr.mr_n81464752)
print v(xbgr.mr_n81464864)
print v(xbgr.mr_n81466016)
print v(xbgr.mr_n81466128)
print v(xbgr.mr_n81467280)
print v(xbgr.mr_n81467392)
print v(xbgr.mr_n81468544)
print v(xbgr.mr_n81468656)
print v(xbgr.mr_n81469808)
print v(xbgr.mr_n81469920)
print v(xbgr.mr_n81480608)
print v(xbgr.mr_n81483792)
print v(xbgr.mr_n81487456)
print v(xbgr.mr_n81494608)
print v(xbgr.mr_n81494720)
print v(xbgr.mr_n81494976)
print v(xbgr.mr_n81495440)
print v(xbgr.mr_n81497632)
print v(xbgr.mr_n81498928)
print v(xbgr.mr_n81499040)
print v(xbgr.mr_n81499344)
print v(xbgr.mr_n81499456)
print v(xbgr.mr_n81499568)
print v(xbgr.mr_n81501056)
print v(xbgr.mr_n81501168)
print v(xbgr.mr_n81502960)
print v(xbgr.mr_n81505056)
print v(xbgr.mr_n81509040)
print v(xbgr.mr_n81511184)
print v(xbgr.mr_n81511840)
print v(xbgr.mr_n81514480)
print v(xbgr.mr_n81519456)
print v(xbgr.mr_n81520304)
print v(xbgr.mr_n81522864)
print v(xbgr.mr_n81524624)
print v(xbgr.mr_n81525888)
print v(xbgr.mr_n81527472)
print v(xbgr.mr_n81527936)
print v(xbgr.mr_n81528288)
print v(xbgr.mr_n81535712)
print v(xbgr.mr_n81536656)
print v(xbgr.mr_n81537600)
print v(xbgr.mr_n81538544)
print v(xbgr.mr_n81539488)
print v(xbgr.mr_n81540432)
print v(xbgr.mr_n81541376)
print v(xbgr.mr_n81542320)
print v(xbgr.mr_n81543264)
print v(xbgr.mr_n81544208)
print v(xbgr.mr_n81545152)
print v(xbgr.mr_n81546096)
print v(xbgr.mr_n81547040)
print v(xbgr.mr_n81547984)
print v(xbgr.mr_n81548928)
print v(xbgr.mr_n81549872)
print v(xbgr.mr_n81550816)
print v(xbgr.mr_n81551760)
print v(xbgr.mr_n81552704)
print v(xbgr.mr_n81553648)
print v(xbgr.mr_n81554592)
print v(xbgr.mr_n81555536)
print v(xbgr.mr_n81556480)
print v(xbgr.mr_n81557424)
print v(xbgr.mr_n81558112)
print v(xbgr.mr_n81560496)
print v(xbgr.mr_n81563360)
print v(xbgr.mr_n81564304)
print v(xbgr.mr_n81565248)
print v(xbgr.mr_n81571376)
print v(xbgr.mr_n81571904)
print v(xbgr.mr_n81572464)
print v(xbgr.mr_n81572576)
print v(xbgr.mr_n81572688)
print v(xbgr.mr_n81572800)
print v(xbgr.mr_n81572912)
print v(xbgr.mr_n81574656)
print v(xbgr.mr_n81574928)
print v(xbgr.mr_n81575120)
print v(xbgr.mr_n81575632)
print v(xbgr.mr_n81577568)
print v(xbgr.mr_n81579312)
print v(xbgr.mr_n81579584)
print v(xbgr.mr_n81579776)
print v(xbgr.mr_n81580288)
print v(xbgr.mr_n81582224)
print v(xbgr.mr_n81583968)
print v(xbgr.mr_n81584240)
print v(xbgr.mr_n81584432)
print v(xbgr.mr_n81584944)
print v(xbgr.mr_n81586880)
print v(xbgr.mr_n81588624)
print v(xbgr.mr_n81588896)
print v(xbgr.mr_n81589088)
print v(xbgr.mr_n81589600)
print v(xbgr.mr_n81591536)
print v(xbgr.mr_n81593280)
print v(xbgr.mr_n81593552)
print v(xbgr.mr_n81593744)
print v(xbgr.mr_n81594256)
print v(xbgr.mr_n81596192)
print v(xbgr.mr_n81597936)
print v(xbgr.mr_n81598208)
print v(xbgr.mr_n81598400)
print v(xbgr.mr_n81598912)
print v(xbgr.mr_n81600848)
print v(xbgr.mr_n81602592)
print v(xbgr.mr_n81602864)
print v(xbgr.mr_n81603056)
print v(xbgr.mr_n81603568)
print v(xbgr.mr_n81605504)
print v(xbgr.mr_n81607248)
print v(xbgr.mr_n81607520)
print v(xbgr.mr_n81607712)
print v(xbgr.mr_n81608224)
print v(xbgr.mr_n81610160)
print v(xbgr.mr_n81610448)
print v(xbgr.mr_n81611904)
print v(xbgr.mr_n81612176)
print v(xbgr.mr_n81612368)
print v(xbgr.mr_n81612880)
print v(xbgr.mr_n81614816)
print v(xbgr.mr_n81616560)
print v(xbgr.mr_n81616832)
print v(xbgr.mr_n81617024)
print v(xbgr.mr_n81617536)
print v(xbgr.mr_n81619472)
print v(xbgr.mr_n81619664)
print v(xbgr.mr_n81621216)
print v(xbgr.mr_n81621488)
print v(xbgr.mr_n81621680)
print v(xbgr.mr_n81622192)
print v(xbgr.mr_n81624128)
print v(xbgr.mr_n81625872)
print v(xbgr.mr_n81626144)
print v(xbgr.mr_n81626336)
print v(xbgr.mr_n81626848)
print v(xbgr.mr_n81628784)
print v(xbgr.mr_n81630528)
print v(xbgr.mr_n81630800)
print v(xbgr.mr_n81630992)
print v(xbgr.mr_n81631504)
print v(xbgr.mr_n81633696)
print v(xbgr.mr_n81634592)
print v(xbgr.mr_n81635072)
print v(xbgr.mr_n81635264)
print v(xbgr.mr_n81636096)
print v(xbgr.mr_n81638096)
print v(xbgr.mr_n81638432)
print v(xbgr.mr_n81638832)
print v(xbgr.mr_n81640192)
print v(xbgr.mr_n81640384)
print v(xbgr.mr_n81641216)
print v(xbgr.mr_n81642736)
print v(xbgr.mr_n81644384)
print v(xbgr.mr_n81647216)
print v(xbgr.mr_n81648656)
print v(xbgr.mr_n81650064)
print v(xbgr.mr_n81650672)
print v(xbgr.mr_n81651296)
print v(xbgr.mr_n81653328)
print v(xbgr.mr_n81654704)
print v(xbgr.mr_n81656000)
print v(xbgr.mr_n81657040)
print v(xbgr.mr_n81657440)
print v(xbgr.mr_n81658000)
print v(xbgr.mr_n81666096)
print v(xbgr.mr_n81667008)
print v(xbgr.mr_n81669008)
print v(xbgr.mr_n81669184)
print v(xbgr.mr_n81669872)
print v(xbgr.mr_n81671440)
print v(xbgr.mr_n81672960)
print v(xbgr.mr_n81673728)
print v(xbgr.mr_n81675152)
print v(xbgr.mr_n81675904)
print v(xbgr.mr_n81678944)
print v(xbgr.mr_n81679232)
print v(xbgr.mr_n81680624)
print v(xbgr.mr_n81683264)
print v(xbgr.mr_n81683888)
print v(xbgr.mr_n81685760)
print v(xbgr.mr_n81687232)
print v(xbgr.mr_n81688560)
print v(xbgr.mr_n81689280)
print v(xbgr.mr_n81689472)
print v(xbgr.mr_n81695072)
print v(xbgr.mr_n81695232)
print v(xbgr.mr_n81695600)
print v(xbgr.mr_n81697760)
print v(xbgr.mr_n81698160)
print v(xbgr.mr_n81700592)
print v(xbgr.mr_n81700800)
print v(xbgr.mr_n81702080)
print v(xbgr.mr_n81702272)
print v(xbgr.mr_n81702464)
print v(xbgr.mr_n81703344)
print v(xbgr.mr_n81704320)
print v(xbgr.mr_n81705328)
print v(xbgr.mr_n81706832)
print v(xbgr.mr_n81707120)
print v(xbgr.mr_n81707328)
print v(xbgr.mr_n81708544)
print v(xbgr.mr_n81708656)
print v(xbgr.mr_n81709088)
print v(xbgr.mr_n81709600)
print v(xbgr.mr_n81709712)
print v(xbgr.mr_n81710144)
print v(xbgr.mr_n81710656)
print v(xbgr.mr_n81710768)
print v(xbgr.mr_n81711200)
print v(xbgr.mr_n81711712)
print v(xbgr.mr_n81712096)
print v(xbgr.mr_n81712576)
print v(xbgr.mr_n81714544)
print v(xbgr.mr_n81715408)
print v(xbgr.mr_n81715616)
print v(xbgr.mr_n81715936)
print v(xbgr.mr_n81716224)
print v(xbgr.mr_n81716336)
print v(xbgr.mr_n81716560)
print v(xbgr.mr_n81716752)
print v(xbgr.mr_n81717152)
print v(xbgr.mr_n81721248)
print v(xbgr.mr_n81724864)
print v(xbgr.mr_n81725584)
print v(xbgr.mr_n81726992)
print v(xbgr.mr_n81727648)
print v(xbgr.mr_n81728048)
print v(xbgr.mr_n81731040)
print v(xbgr.mr_n81731296)
print v(xbgr.mr_n81731888)
print v(xbgr.mr_n81735920)
print v(xbgr.mr_n81736400)
print v(xbgr.mr_n81738208)
print v(xbgr.mr_n81738544)
print v(xbgr.mr_n81738736)
print v(xbgr.mr_n81739264)
print v(xbgr.mr_n81739664)
print v(xbgr.mr_n81740480)
print v(xbgr.mr_n81740816)
print v(xbgr.mr_n81741008)
print v(xbgr.mr_n81741472)
print v(xbgr.mr_n81741664)
print v(xbgr.mr_n81742608)
print v(xbgr.mr_n81742944)
print v(xbgr.mr_n81743408)
print v(xbgr.mr_n81743600)
print v(xbgr.mr_n81743792)
print v(xbgr.mr_n81744944)
print v(xbgr.mr_n81745344)
print v(xbgr.mr_n81745536)
print v(xbgr.mr_n81748384)
print v(xbgr.mr_n81748656)
print v(xbgr.mr_n81749760)
print v(xbgr.mr_n81756560)
print v(xbgr.mr_n81756992)
print v(xbgr.mr_n81757504)
print v(xbgr.mr_n81757616)
print v(xbgr.mr_n81758432)
print v(xbgr.mr_n81759120)
print v(xbgr.mr_n81759808)
print v(xbgr.mr_n81760496)
print v(xbgr.mr_n81761184)
print v(xbgr.mr_n81761872)
print v(xbgr.mr_n81762560)
print v(xbgr.mr_n81763248)
print v(xbgr.mr_n81763936)
print v(xbgr.mr_n81764624)
print v(xbgr.mr_n81765312)
print v(xbgr.mr_n81766000)
print v(xbgr.mr_n81766688)
print v(xbgr.mr_n81767376)
print v(xbgr.mr_n81768064)
print v(xbgr.mr_n81768400)
print v(xbgr.mr_n81768832)
print v(xbgr.mr_n81768944)
print v(xbgr.mr_n81769056)
print v(xbgr.mr_n81771920)
print v(xbgr.mr_n81772032)
print v(xbgr.mr_n81773344)
print v(xbgr.mr_n81773456)
print v(xbgr.mr_n81774288)
print v(xbgr.mr_n81774400)
print v(xbgr.mr_n81775232)
print v(xbgr.mr_n81775344)
print v(xbgr.mr_n81776176)
print v(xbgr.mr_n81776288)
print v(xbgr.mr_n81777120)
print v(xbgr.mr_n81777232)
print v(xbgr.mr_n81778064)
print v(xbgr.mr_n81778176)
print v(xbgr.mr_n81779008)
print v(xbgr.mr_n81779120)
print v(xbgr.mr_n81779952)
print v(xbgr.mr_n81780064)
print v(xbgr.mr_n81780896)
print v(xbgr.mr_n81781008)
print v(xbgr.mr_n81781840)
print v(xbgr.mr_n81781952)
print v(xbgr.mr_n81782784)
print v(xbgr.mr_n81782896)
print v(xbgr.mr_n81783728)
print v(xbgr.mr_n81783840)
print v(xbgr.mr_n81784864)
print v(xbgr.mr_n81784976)
print v(xbgr.mr_n81786128)
print v(xbgr.mr_n81786240)
print v(xbgr.mr_n81787392)
print v(xbgr.mr_n81787504)
print v(xbgr.mr_n81791584)
print v(xbgr.mr_n81794912)
print v(xbgr.mr_n81795936)
print v(xbgr.mr_n81798624)
print v(xbgr.mr_n81800368)
print v(xbgr.mr_n81806112)
print v(xbgr.mr_n81806304)
print v(xbgr.mr_n81806496)
print v(xbgr.mr_n81806688)
print v(xbgr.mr_n81809008)
print v(xbgr.mr_n81809280)
print v(xbgr.mr_n81809472)
print v(xbgr.mr_n81809984)
print v(xbgr.mr_n81810096)
print v(xbgr.mr_n81810208)
print v(xbgr.mr_n81810320)
print v(xbgr.mr_n81810512)
print v(xbgr.mr_n81810704)
print v(xbgr.mr_n81810896)
print v(xbgr.mr_n81814464)
print v(xbgr.mr_n81821200)
print v(xbgr.mr_n81830480)
print v(xbgr.mr_n81834016)
print v(xbgr.mr_n81835632)
print v(xbgr.mr_n81837312)
print v(xbgr.mr_n81839568)
print v(xbgr.mr_n81841824)
print v(xbgr.mr_n81844080)
print v(xbgr.mr_n81846336)
print v(xbgr.mr_n81848768)
print v(xbgr.mr_n81849776)
print v(xbgr.mr_n81852848)
print v(xbgr.mr_n81854016)
print v(xbgr.mr_n81857200)
print v(xbgr.mr_n81867632)
print v(xbgr.mr_n81868208)
print v(xbgr.mr_n81868896)
print v(xbgr.mr_n81869472)
print v(xbgr.mr_n81870160)
print v(xbgr.mr_n81870736)
print v(xbgr.mr_n81871424)
print v(xbgr.mr_n81871856)
print v(xbgr.mr_n81872688)
print v(xbgr.mr_n81873120)
print v(xbgr.mr_n81873952)
print v(xbgr.mr_n81874384)
print v(xbgr.mr_n81875216)
print v(xbgr.mr_n81875792)
print v(xbgr.mr_n81876480)
print v(xbgr.mr_n81877360)
print v(xbgr.mr_n81877744)
print v(xbgr.mr_n81879344)
print v(xbgr.mr_n81884544)
print v(xbgr.mr_n81888240)
print v(xbgr.mr_n81889920)
print v(xbgr.mr_n81891328)
print v(xbgr.mr_n81894336)
print v(xbgr.mr_n81901008)
print v(xbgr.mr_n81903248)
print v(xbgr.mr_n81904576)
print v(xbgr.mr_n81905568)
print v(xbgr.mr_n81906176)
print v(xbgr.mr_n81907712)
print v(xbgr.mr_n81908560)
print v(xbgr.mr_n81909440)
print v(xbgr.mr_n81909552)
print v(xbgr.mr_n81909664)
print v(xbgr.mr_n81909776)
print v(xbgr.mr_n81909888)
print v(xbgr.mr_n81910000)
print v(xbgr.mr_n81910112)
print v(xbgr.mr_n81910224)
print v(xbgr.mr_n81910416)
print v(xbgr.mr_n81910528)
print v(xbgr.mr_n81911552)
print v(xbgr.mr_n81911888)
print v(xbgr.mr_n81912080)
print v(xbgr.mr_n81913728)
print v(xbgr.mr_n81914112)
print v(xbgr.mr_n81914304)
print v(xbgr.mr_n81914704)
print v(xbgr.mr_n81914896)
print v(xbgr.mr_n81915712)
print v(xbgr.mr_n81915984)
print v(xbgr.mr_n81916320)
print v(xbgr.mr_n81916512)
print v(xbgr.mr_n81917328)
print v(xbgr.mr_n81917808)
print v(xbgr.mr_n81920272)
print v(xbgr.mr_n81920384)
print v(xbgr.mr_n81920896)
print v(xbgr.mr_n81921008)
print v(xbgr.mr_n81921520)
print v(xbgr.mr_n81921632)
print v(xbgr.mr_n81922144)
print v(xbgr.mr_n81922256)
print v(xbgr.mr_n81922768)
print v(xbgr.mr_n81922880)
print v(xbgr.mr_n81923392)
print v(xbgr.mr_n81923504)
print v(xbgr.mr_n81924016)
print v(xbgr.mr_n81924128)
print v(xbgr.mr_n81924640)
print v(xbgr.mr_n81924752)
print v(xbgr.mr_n81938368)
print v(xbgr.mr_n81939056)
print v(xbgr.mr_n81939744)
print v(xbgr.mr_n81940432)
print v(xbgr.mr_n81941120)
print v(xbgr.mr_n81942192)
print v(xbgr.mr_n81943872)
print v(xbgr.mr_n81944816)
print v(xbgr.mr_n81945760)
print v(xbgr.mr_n81946704)
print v(xbgr.mr_n81947648)
print v(xbgr.mr_n81948592)
print v(xbgr.mr_n81949536)
print v(xbgr.mr_n81950480)
print v(xbgr.mr_n81951424)
print v(xbgr.mr_n81952368)
print v(xbgr.mr_n81953312)
print v(xbgr.mr_n81954256)
print v(xbgr.mr_n81961696)
print v(xbgr.mr_n81962080)
print v(xbgr.mr_n81962464)
print v(xbgr.mr_n81963232)
print v(xbgr.mr_n81964464)
print v(xbgr.mr_n81964768)
print v(xbgr.mr_n81965152)
print v(xbgr.mr_n81965536)
print v(xbgr.mr_n81965920)
print v(xbgr.mr_n81966384)
print v(xbgr.mr_n81966768)
print v(xbgr.mr_n81967536)
print v(xbgr.mr_n81967840)
print v(xbgr.mr_n81968224)
print v(xbgr.mr_n81968608)
print v(xbgr.mr_n81968992)
print v(xbgr.mr_n81969456)
print v(xbgr.mr_n81969760)
print v(xbgr.mr_n81970992)
print v(xbgr.mr_n81971296)
print v(xbgr.mr_n81971680)
print v(xbgr.mr_n81974512)
print v(xbgr.mr_n81974704)
print v(xbgr.mr_n81975712)
print v(xbgr.mr_n81976096)
print v(xbgr.mr_n81979280)
print v(xbgr.mr_n81979552)
print v(xbgr.mr_n81980832)
print v(xbgr.mr_n81983968)
print v(xbgr.mr_n81984416)
print v(xbgr.mr_n81984832)
print v(xbgr.mr_n81984944)
print v(xbgr.mr_n81985504)
print v(xbgr.mr_n81987104)
print v(xbgr.mr_n81987328)
print v(xbgr.mr_n81989056)
print v(xbgr.mr_n81994640)
print v(xbgr.mr_n81996208)
print v(xbgr.mr_n82003408)
print v(xbgr.mr_n82003984)
print v(xbgr.mr_n82004656)
print v(xbgr.mr_n82006704)
print v(xbgr.mr_n82008400)
print v(xbgr.mr_n82008512)
print v(xbgr.mr_n82009216)
print v(xbgr.mr_n82010288)
print v(xbgr.mr_n82010800)
print v(xbgr.mr_n82010912)
print v(xbgr.mr_n82011344)
print v(xbgr.mr_n82011856)
print v(xbgr.mr_n82011968)
print v(xbgr.mr_n82012400)
print v(xbgr.mr_n82012912)
print v(xbgr.mr_n82013024)
print v(xbgr.mr_n82013456)
print v(xbgr.mr_n82013968)
print v(xbgr.mr_n82014080)
print v(xbgr.mr_n82016544)
print v(xbgr.mr_n82017040)
print v(xbgr.mr_n82021888)
print v(xbgr.mr_n82022400)
print v(xbgr.mr_n82023792)
print v(xbgr.mr_n82025200)
print v(xbgr.mr_n82025712)
print v(xbgr.mr_n82026816)
print v(xbgr.mr_n82027904)
print v(xbgr.mr_n82033184)
print v(xbgr.mr_n82033504)
print v(xbgr.mr_n82036992)
print v(xbgr.mr_n82040544)
print v(xbgr.mr_n82046160)
print v(xbgr.mr_n82046816)
print v(xbgr.mr_n82048288)
print v(xbgr.mr_n82048864)
print v(xbgr.mr_n82054048)
print v(xbgr.mr_n82054480)
print v(xbgr.mr_n82054784)
print v(xbgr.mr_n82057696)
print v(xbgr.mr_n82058720)
print v(xbgr.mr_n82061072)
print v(xbgr.mr_n82061424)
print v(xbgr.mr_n82061888)
print v(xbgr.mr_n82062080)
print v(xbgr.mr_n82062544)
print v(xbgr.mr_n82062736)
print v(xbgr.mr_n82063200)
print v(xbgr.mr_n82063664)
print v(xbgr.mr_n82063856)
print v(xbgr.mr_n82064320)
print v(xbgr.mr_n82064512)
print v(xbgr.mr_n82064976)
print v(xbgr.mr_n82065920)
print v(xbgr.mr_n82066240)
print v(xbgr.mr_n82066944)
print v(xbgr.mr_n82067056)
print v(xbgr.mr_n82067872)
print v(xbgr.mr_n82068064)
print v(xbgr.mr_n82069152)
print v(xbgr.mr_n82069488)
print v(xbgr.mr_n82069952)
print v(xbgr.mr_n82070416)
print v(xbgr.mr_n82070880)
print v(xbgr.mr_n82071344)
print v(xbgr.mr_n82071808)
print v(xbgr.mr_n82072272)
print v(xbgr.mr_n82072736)
print v(xbgr.mr_n82073680)
print v(xbgr.mr_n82074496)
print v(xbgr.mr_n82074832)
print v(xbgr.mr_n82075776)
print v(xbgr.mr_n82076272)
print v(xbgr.mr_n82076464)
print v(xbgr.mr_n82079472)
print v(xbgr.mr_n82080800)
print v(xbgr.mr_n82081760)
print v(xbgr.mr_n82084976)
print v(xbgr.mr_n82085152)
print v(xbgr.mr_n82085616)
print v(xbgr.mr_n82086080)
print v(xbgr.mr_n82086976)
print v(xbgr.mr_n82087088)
print v(xbgr.mr_n82087312)
print v(xbgr.mr_n82093984)
print v(xbgr.mr_n82095968)
print v(xbgr.mr_n82096480)
print v(xbgr.mr_n82096592)
print v(xbgr.mr_n82097024)
print v(xbgr.mr_n82097536)
print v(xbgr.mr_n82097648)
print v(xbgr.mr_n82098080)
print v(xbgr.mr_n82098592)
print v(xbgr.mr_n82098704)
print v(xbgr.mr_n82099136)
print v(xbgr.mr_n82099648)
print v(xbgr.mr_n82099760)
print v(xbgr.mr_n82100192)
print v(xbgr.mr_n82100704)
print v(xbgr.mr_n82100816)
print v(xbgr.mr_n82101248)
print v(xbgr.mr_n82101760)
print v(xbgr.mr_n82101872)
print v(xbgr.mr_n82102304)
print v(xbgr.mr_n82102816)
print v(xbgr.mr_n82102928)
print v(xbgr.mr_n82103360)
print v(xbgr.mr_n82103872)
print v(xbgr.mr_n82103984)
print v(xbgr.mr_n82104416)
print v(xbgr.mr_n82104928)
print v(xbgr.mr_n82105040)
print v(xbgr.mr_n82105472)
print v(xbgr.mr_n82106368)
print v(xbgr.mr_n82106480)
print v(xbgr.mr_n82107360)
print v(xbgr.mr_n82108048)
print v(xbgr.mr_n82108736)
print v(xbgr.mr_n82109424)
print v(xbgr.mr_n82110112)
print v(xbgr.mr_n82110800)
print v(xbgr.mr_n82111488)
print v(xbgr.mr_n82112176)
print v(xbgr.mr_n82112864)
print v(xbgr.mr_n82113552)
print v(xbgr.mr_n82114240)
print v(xbgr.mr_n82114928)
print v(xbgr.mr_n82115616)
print v(xbgr.mr_n82116304)
print v(xbgr.mr_n82116992)
print v(xbgr.mr_n82117680)
print v(xbgr.mr_n82118368)
print v(xbgr.mr_n82119056)
print v(xbgr.mr_n82119744)
print v(xbgr.mr_n82120432)
print v(xbgr.mr_n82121536)
print v(xbgr.mr_n82122768)
print v(xbgr.mr_n82123712)
print v(xbgr.mr_n82124656)
print v(xbgr.mr_n82125600)
print v(xbgr.mr_n82126544)
print v(xbgr.mr_n82127488)
print v(xbgr.mr_n82128432)
print v(xbgr.mr_n82129376)
print v(xbgr.mr_n82130320)
print v(xbgr.mr_n82131264)
print v(xbgr.mr_n82132208)
print v(xbgr.mr_n82133152)
print v(xbgr.mr_n82134096)
print v(xbgr.mr_n82135040)
print v(xbgr.mr_n82135984)
print v(xbgr.mr_n82136928)
print v(xbgr.mr_n82137872)
print v(xbgr.mr_n82138816)
print v(xbgr.mr_n82139760)
print v(xbgr.mr_n82140704)
print v(xbgr.mr_n82141648)
print v(xbgr.mr_n82142592)
print v(xbgr.mr_n82143536)
print v(xbgr.mr_n82144480)
print v(xbgr.mr_n82145424)
print v(xbgr.mr_n82150224)
print v(xbgr.mr_n82150480)
print v(xbgr.mr_n82150736)
print v(xbgr.mr_n82150992)
print v(xbgr.mr_n82151248)
print v(xbgr.mr_n82151504)
print v(xbgr.mr_n82154304)
print v(xbgr.mr_n82154752)
print v(xbgr.mr_n82154944)
print v(xbgr.mr_n82155136)
print v(xbgr.mr_n82155328)
print v(xbgr.mr_n82155520)
print v(xbgr.mr_n82155712)
print v(xbgr.mr_n82155968)
print v(xbgr.mr_n82160976)
print v(xbgr.mr_n82174128)
print v(xbgr.mr_n82178336)
print v(xbgr.mr_n82178848)
print v(xbgr.mr_n82179040)
print v(xbgr.mr_n82180832)
print v(xbgr.mr_n82181408)
print v(xbgr.mr_n82181600)
print v(xbgr.mr_n82193424)
print v(xbgr.mr_n82193856)
print v(xbgr.mr_n82194160)
print v(xbgr.mr_n82194352)
print v(xbgr.mr_n82194544)
print v(xbgr.mr_n82194736)
print v(xbgr.mr_n82194928)
print v(xbgr.mr_n82195776)
print v(xbgr.mr_n82196640)
print v(xbgr.mr_n82197744)
print v(xbgr.mr_n82200928)
print v(xbgr.mr_n82201392)
print v(xbgr.mr_n82467600)
print v(xbgr.mr_n82479744)
print v(xbgr.mr_n82482656)
print v(xbgr.mr_n82496272)
print v(xbgr.mr_n82496464)
print v(xbgr.mr_n82496656)
print v(xbgr.mr_n82497008)
print v(xbgr.mr_n82497360)
print v(xbgr.mr_n82497632)
print v(xbgr.mr_n82539376)
print v(xbgr.mr_n82602192)
print v(xbgr.mr_n82602384)
print v(xbgr.mr_n82602496)
print v(xbgr.mr_n82602816)
print v(xbgr.mr_n82602960)
print v(xbgr.mr_n82603280)
print v(xbgr.mr_n82630080)
print v(xbgr.mr_n82631056)
print v(xbgr.mr_n82631264)
print v(xbgr.mr_n82647152)
print v(xbgr.mr_n82647952)
print v(xbgr.mr_n82648112)
print v(xbgr.mr_n82648400)
print v(xbgr.mr_n82716672)
print v(xbgr.mr_n82748032)
print v(xbgr.mr_n82749888)
print v(xbgr.mr_n82750848)
print v(xbgr.mr_n82754688)
print v(xbgr.mr_n82764720)
print v(xbgr.mr_n82797280)
print v(xbgr.mr_n82797472)
print v(xbgr.mr_n82797664)
print v(xbgr.mr_n82797856)
print v(xbgr.mr_n82798048)
print v(xbgr.mr_n82818720)
print v(xbgr.mr_n82841152)
print v(xbgr.mr_n82841344)
print v(xbgr.mr_n82871280)
print v(xbgr.mr_n82880528)
print v(xbgr.mr_n82880640)
print v(xbgr.mr_n82880912)
print v(xbgr.mr_n82901520)
print v(xbgr.mr_n82962912)
print v(xbgr.mr_n82978304)
print v(xbgr.mr_n82978576)
print v(xbgr.mr_n82979136)
print v(xbgr.mr_n83006336)
print v(xbgr.mr_n83012160)
print v(xbgr.mr_n83013536)
print v(xbgr.mr_n83013936)
print v(xbgr.mr_n83021952)
print v(xbgr.mr_n83033968)
print v(xbgr.mr_n83040064)
print v(xbgr.mr_n83041072)
print v(xbgr.mr_n83070160)
print v(xbgr.mr_n83071200)
print v(xbgr.mr_n83076256)
print v(xbgr.mr_n83081600)
print v(xbgr.mr_n83084128)
print v(xbgr.mr_n83084768)
print v(xbgr.mr_n83090272)
print v(xbgr.mr_n83090464)
print v(xbgr.mr_n83091056)
print v(xbgr.mr_n83116496)
print v(xbgr.mr_n83119152)
print v(xbgr.mr_n83120080)
print v(xbgr.mr_n83130224)
print v(xbgr.mr_n83164608)
print v(xbgr.mr_n83194144)
print v(xbgr.mr_n83219616)
print v(xbgr.mr_n83219808)
print v(xbgr.mr_n83250096)
print v(xbgr.mr_n83269072)
print v(xbgr.mr_n83269472)
print v(xbgr.mr_n83273056)
print v(xbgr.mr_n83290400)
print v(xbgr.mr_n83300688)
print v(xbgr.n1)
print v(xbgr.n_10)
print v(xbgr.n_11)
print v(xbgr.n_12)
print v(xbgr.n_13)
print v(xbgr.n_14)
print v(xbgr.n_15)
print v(xbgr.n_16)
print v(xbgr.n_17)
print v(xbgr.n_18)
print v(xbgr.n_19)
print v(xbgr.n_2)
print v(xbgr.n_21)
print v(xbgr.n_22)
print v(xbgr.n_23)
print v(xbgr.n_24)
print v(xbgr.n_25)
print v(xbgr.n_26)
print v(xbgr.n_27)
print v(xbgr.n_3)
print v(xbgr.n_30)
print v(xbgr.n_31)
print v(xbgr.n_33)
print v(xbgr.n_34)
print v(xbgr.n_36)
print v(xbgr.n_37)
print v(xbgr.n_4)
print v(xbgr.n_5)
print v(xbgr.n_6)
print v(xbgr.n_7)
print v(xbgr.n_8)
print v(xbgr.n_9)
print v(pbias)
print v(pcasc)
print v(r4)
print v(xbgr.r4n)
print v(xbgr.vb2)
print v(vbe)
print v(xbgr.vbe3)
print v(xbgr.vd1)
print v(xbgr.vd2)
print v(vdd)
print v(vref)
print v(vdd)-v(vdd)
echo METALLIC_ALL_NODE_VOLTAGES_END
quit
.endc
.end
