.subckt bgr_mos_proto_01 vbe r4 b1b vss
MUNIT vbe r4 b1b vss sg13_hv_nmos l=0.5u w=2u as=0.68p ad=0.68p ps=4.68u pd=4.68u rfmode=0
.ends bgr_mos_proto_01
