.subckt bgr_mos_proto_05 n1 vb2 vbe vss
MUNIT n1 vb2 vbe vss sg13_hv_nmos l=1u w=10u as=3.4p ad=3.4p ps=20.68u pd=20.68u rfmode=0
.ends bgr_mos_proto_05
