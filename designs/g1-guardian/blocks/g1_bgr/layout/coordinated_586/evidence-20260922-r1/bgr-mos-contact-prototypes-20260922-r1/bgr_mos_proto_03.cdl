.subckt bgr_mos_proto_03 kick det vss
MUNIT kick det vss vss sg13_hv_nmos l=0.6u w=1u as=0.34p ad=0.34p ps=2.68u pd=2.68u rfmode=0
.ends bgr_mos_proto_03
