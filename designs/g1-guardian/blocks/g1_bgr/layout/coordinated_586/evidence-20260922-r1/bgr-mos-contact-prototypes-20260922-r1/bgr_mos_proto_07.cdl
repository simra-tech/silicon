.subckt bgr_mos_proto_07 vb2 pcasc d5
MUNIT vb2 pcasc d5 d5 sg13_hv_pmos l=4u w=10u as=3.4p ad=3.4p ps=20.68u pd=20.68u rfmode=0
.ends bgr_mos_proto_07
