.subckt bgr_hbt_proto_00 vss
QUNIT vss vss vss vss npn13G2 we=0.07u le=0.9u Nx=1 m=1
.ends bgr_hbt_proto_00
