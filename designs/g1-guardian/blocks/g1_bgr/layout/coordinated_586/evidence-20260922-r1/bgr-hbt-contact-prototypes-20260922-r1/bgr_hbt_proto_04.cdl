.subckt bgr_hbt_proto_04 vd1 vd2 vss
QUNIT vd1 vd1 vd2 vss npn13G2 we=0.07u le=0.9u Nx=1 m=1
.ends bgr_hbt_proto_04
