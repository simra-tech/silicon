.subckt bgr_hbt_proto_03 c2 vbe dvbe vss
QUNIT c2 vbe dvbe vss npn13G2 we=0.07u le=0.9u Nx=1 m=1
.ends bgr_hbt_proto_03
