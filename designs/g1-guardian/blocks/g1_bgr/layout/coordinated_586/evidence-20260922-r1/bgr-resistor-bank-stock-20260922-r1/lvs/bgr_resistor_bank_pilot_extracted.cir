* Extracted by KLayout with SG13G2 LVS runset on : 22/09/2026 19:33

.SUBCKT bgr_resistor_bank_pilot det dvbe n_10 n_11 n_12 n_13 n_14 n_15 n_16
+ n_17 n_18 n_19 n_2 n_21 n_22 n_23 n_24 n_25 n_26 n_27 n_3 n_30 n_31 n_33 n_34
+ n_36 n_37 n_4 n_5 n_6 n_7 n_8 n_9 pbias pcasc vb2 vbe3 vd1 vref vss
R$1 vss n_23 vss rhigh w=0.5u l=49u ps=0u b=0 m=1
R$2 n_12 det vss rhigh w=0.5u l=49u ps=0u b=0 m=1
R$3 n_17 n_21 vss rhigh w=0.5u l=49u ps=0u b=0 m=1
R$4 n_18 n_23 vss rhigh w=0.5u l=49u ps=0u b=0 m=1
R$5 n_18 n_22 vss rhigh w=0.5u l=49u ps=0u b=0 m=1
R$6 n_17 n_22 vss rhigh w=0.5u l=49u ps=0u b=0 m=1
R$7 n_13 n_25 vss rhigh w=0.5u l=49u ps=0u b=0 m=1
R$8 n_12 n_25 vss rhigh w=0.5u l=49u ps=0u b=0 m=1
R$9 n_14 n_24 vss rhigh w=0.5u l=49u ps=0u b=0 m=1
R$10 n_13 n_24 vss rhigh w=0.5u l=49u ps=0u b=0 m=1
R$11 n_16 n_21 vss rhigh w=0.5u l=49u ps=0u b=0 m=1
R$12 n_16 n_27 vss rhigh w=0.5u l=49u ps=0u b=0 m=1
R$13 n_15 n_27 vss rhigh w=0.5u l=49u ps=0u b=0 m=1
R$14 n_15 n_26 vss rhigh w=0.5u l=49u ps=0u b=0 m=1
R$15 n_14 n_26 vss rhigh w=0.5u l=49u ps=0u b=0 m=1
R$16 n_7 vref vss rppd w=1u l=53.465u ps=0u b=0 m=4
R$17 n_8 vbe3 vss rppd w=1u l=53.465u ps=0u b=0 m=4
R$19 n_8 n_37 vss rppd w=1u l=53.465u ps=0u b=0 m=4
R$21 n_2 n_37 vss rppd w=1u l=53.465u ps=0u b=0 m=4
R$24 n_2 n_36 vss rppd w=1u l=53.465u ps=0u b=0 m=4
R$26 n_7 n_36 vss rppd w=1u l=53.465u ps=0u b=0 m=4
R$40 n_4 pbias vss rppd w=1u l=50u ps=0u b=0 m=24
R$41 n_3 n_33 vss rppd w=1u l=50u ps=0u b=0 m=24
R$46 n_4 n_30 vss rppd w=1u l=50u ps=0u b=0 m=24
R$58 n_5 n_30 vss rppd w=1u l=50u ps=0u b=0 m=24
R$60 n_11 n_34 vss rppd w=1u l=50u ps=0u b=0 m=24
R$66 n_11 pcasc vss rppd w=1u l=50u ps=0u b=0 m=24
R$91 n_10 n_34 vss rppd w=1u l=50u ps=0u b=0 m=24
R$95 n_3 n_31 vss rppd w=1u l=50u ps=0u b=0 m=24
R$125 n_5 n_31 vss rppd w=1u l=50u ps=0u b=0 m=24
R$132 n_10 n_33 vss rppd w=1u l=50u ps=0u b=0 m=24
R$280 n_6 vb2 vss rppd w=1u l=48u ps=0u b=0 m=24
R$281 n_6 n_19 vss rppd w=1u l=48u ps=0u b=0 m=24
R$285 n_9 n_19 vss rppd w=1u l=48u ps=0u b=0 m=24
R$299 n_9 vd1 vss rppd w=1u l=48u ps=0u b=0 m=24
R$376 vss dvbe vss rppd w=1u l=51.5u ps=0u b=0 m=24
.ENDS bgr_resistor_bank_pilot
