* Extracted by KLayout with SG13G2 LVS runset on : 22/09/2026 19:16

.SUBCKT bgr_hbt_proto_04 vd1 vd2 vss
Q$1 vd1 vd1 vd2 vss npn13G2 we=70n le=900n Nx=1 m=1
.ENDS bgr_hbt_proto_04
