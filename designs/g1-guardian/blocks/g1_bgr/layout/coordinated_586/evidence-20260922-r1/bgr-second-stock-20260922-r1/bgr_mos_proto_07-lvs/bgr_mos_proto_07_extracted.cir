* Extracted by KLayout with SG13G2 LVS runset on : 22/09/2026 19:16

.SUBCKT bgr_mos_proto_07 d5 pcasc vb2
M$1 d5 pcasc vb2 d5 sg13_hv_pmos L=4u W=10u AS=3.4p AD=3.4p PS=20.68u PD=20.68u
+ rfmode=0
.ENDS bgr_mos_proto_07
