* Extracted by KLayout with SG13G2 LVS runset on : 22/09/2026 19:15

.SUBCKT bgr_hbt_proto_03 c2 dvbe vbe vss
Q$1 c2 vbe dvbe vss npn13G2 we=70n le=900n Nx=1 m=1
.ENDS bgr_hbt_proto_03
