* Extracted by KLayout with SG13G2 LVS runset on : 22/09/2026 19:16

.SUBCKT bgr_mos_proto_01 b1b r4 vbe vss
M$1 b1b r4 vbe vss sg13_hv_nmos L=0.5u W=2u AS=0.68p AD=0.68p PS=4.68u PD=4.68u
+ rfmode=0
.ENDS bgr_mos_proto_01
