* Extracted by KLayout with SG13G2 LVS runset on : 22/09/2026 19:16

.SUBCKT bgr_mos_proto_04 r4 r4n vss
M$1 vss r4 r4n vss sg13_hv_nmos L=0.5u W=1u AS=0.34p AD=0.34p PS=2.68u PD=2.68u
+ rfmode=0
.ENDS bgr_mos_proto_04
