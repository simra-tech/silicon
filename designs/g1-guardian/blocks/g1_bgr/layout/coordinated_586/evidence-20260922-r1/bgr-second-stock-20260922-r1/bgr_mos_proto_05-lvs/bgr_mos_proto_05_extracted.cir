* Extracted by KLayout with SG13G2 LVS runset on : 22/09/2026 19:16

.SUBCKT bgr_mos_proto_05 n1 vb2 vbe vss
M$1 vbe vb2 n1 vss sg13_hv_nmos L=1u W=10u AS=3.4p AD=3.4p PS=20.68u PD=20.68u
+ rfmode=0
.ENDS bgr_mos_proto_05
