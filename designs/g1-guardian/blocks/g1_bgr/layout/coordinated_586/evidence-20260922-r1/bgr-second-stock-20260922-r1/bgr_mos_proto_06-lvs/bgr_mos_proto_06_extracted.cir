* Extracted by KLayout with SG13G2 LVS runset on : 22/09/2026 19:16

.SUBCKT bgr_mos_proto_06 d1 pbias vdd
M$1 vdd pbias d1 vdd sg13_hv_pmos L=4u W=5u AS=1.7p AD=1.7p PS=10.68u PD=10.68u
+ rfmode=0
.ENDS bgr_mos_proto_06
