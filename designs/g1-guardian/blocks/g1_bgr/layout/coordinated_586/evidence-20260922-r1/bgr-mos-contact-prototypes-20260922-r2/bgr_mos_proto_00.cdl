.subckt bgr_mos_proto_00 kick det vdd
MUNIT kick det vdd vdd sg13_hv_pmos l=0.5u w=2u as=0.68p ad=0.68p ps=4.68u pd=4.68u rfmode=0
.ends bgr_mos_proto_00
