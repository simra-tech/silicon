.subckt bgr_mos_proto_04 r4n r4 vss
MUNIT r4n r4 vss vss sg13_hv_nmos l=0.5u w=1u as=0.34p ad=0.34p ps=2.68u pd=2.68u rfmode=0
.ends bgr_mos_proto_04
