.subckt bgr_mos_proto_06 d1 pbias vdd
MUNIT d1 pbias vdd vdd sg13_hv_pmos l=4u w=5u as=1.7p ad=1.7p ps=10.68u pd=10.68u rfmode=0
.ends bgr_mos_proto_06
