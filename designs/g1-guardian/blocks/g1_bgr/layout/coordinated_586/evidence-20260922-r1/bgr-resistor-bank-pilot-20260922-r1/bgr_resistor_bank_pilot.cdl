.subckt bgr_resistor_bank_pilot det dvbe n_10 n_11 n_12 n_13 n_14 n_15 n_16 n_17 n_18 n_19 n_2 n_21 n_22 n_23 n_24 n_25 n_26 n_27 n_3 n_30 n_31 n_33 n_34 n_36 n_37 n_4 n_5 n_6 n_7 n_8 n_9 pbias pcasc vb2 vbe3 vd1 vref vss
RR16 vss dvbe vss rppd w=1u l=51.5u b=0 m=1
RR16_u2 vss dvbe vss rppd w=1u l=51.5u b=0 m=1
RR16_u3 vss dvbe vss rppd w=1u l=51.5u b=0 m=1
RR16_u4 vss dvbe vss rppd w=1u l=51.5u b=0 m=1
RR16_u5 vss dvbe vss rppd w=1u l=51.5u b=0 m=1
RR16_u6 vss dvbe vss rppd w=1u l=51.5u b=0 m=1
RR16_u7 vss dvbe vss rppd w=1u l=51.5u b=0 m=1
RR16_u8 vss dvbe vss rppd w=1u l=51.5u b=0 m=1
RR16_u9 vss dvbe vss rppd w=1u l=51.5u b=0 m=1
RR16_u10 vss dvbe vss rppd w=1u l=51.5u b=0 m=1
RR16_u11 vss dvbe vss rppd w=1u l=51.5u b=0 m=1
RR16_u12 vss dvbe vss rppd w=1u l=51.5u b=0 m=1
RR16_u13 vss dvbe vss rppd w=1u l=51.5u b=0 m=1
RR16_u14 vss dvbe vss rppd w=1u l=51.5u b=0 m=1
RR16_u15 vss dvbe vss rppd w=1u l=51.5u b=0 m=1
RR16_u16 vss dvbe vss rppd w=1u l=51.5u b=0 m=1
RR16_u17 vss dvbe vss rppd w=1u l=51.5u b=0 m=1
RR16_u18 vss dvbe vss rppd w=1u l=51.5u b=0 m=1
RR16_u19 vss dvbe vss rppd w=1u l=51.5u b=0 m=1
RR16_u20 vss dvbe vss rppd w=1u l=51.5u b=0 m=1
RR16_u21 vss dvbe vss rppd w=1u l=51.5u b=0 m=1
RR16_u22 vss dvbe vss rppd w=1u l=51.5u b=0 m=1
RR16_u23 vss dvbe vss rppd w=1u l=51.5u b=0 m=1
RR16_u24 vss dvbe vss rppd w=1u l=51.5u b=0 m=1
RR23 n_6 vb2 vss rppd w=1u l=48u b=0 m=1
RR23_u2 n_6 vb2 vss rppd w=1u l=48u b=0 m=1
RR23_u3 n_6 vb2 vss rppd w=1u l=48u b=0 m=1
RR23_u4 n_6 vb2 vss rppd w=1u l=48u b=0 m=1
RR23_u5 n_6 vb2 vss rppd w=1u l=48u b=0 m=1
RR23_u6 n_6 vb2 vss rppd w=1u l=48u b=0 m=1
RR23_u7 n_6 vb2 vss rppd w=1u l=48u b=0 m=1
RR23_u8 n_6 vb2 vss rppd w=1u l=48u b=0 m=1
RR23_u9 n_6 vb2 vss rppd w=1u l=48u b=0 m=1
RR23_u10 n_6 vb2 vss rppd w=1u l=48u b=0 m=1
RR23_u11 n_6 vb2 vss rppd w=1u l=48u b=0 m=1
RR23_u12 n_6 vb2 vss rppd w=1u l=48u b=0 m=1
RR23_u13 n_6 vb2 vss rppd w=1u l=48u b=0 m=1
RR23_u14 n_6 vb2 vss rppd w=1u l=48u b=0 m=1
RR23_u15 n_6 vb2 vss rppd w=1u l=48u b=0 m=1
RR23_u16 n_6 vb2 vss rppd w=1u l=48u b=0 m=1
RR23_u17 n_6 vb2 vss rppd w=1u l=48u b=0 m=1
RR23_u18 n_6 vb2 vss rppd w=1u l=48u b=0 m=1
RR23_u19 n_6 vb2 vss rppd w=1u l=48u b=0 m=1
RR23_u20 n_6 vb2 vss rppd w=1u l=48u b=0 m=1
RR23_u21 n_6 vb2 vss rppd w=1u l=48u b=0 m=1
RR23_u22 n_6 vb2 vss rppd w=1u l=48u b=0 m=1
RR23_u23 n_6 vb2 vss rppd w=1u l=48u b=0 m=1
RR23_u24 n_6 vb2 vss rppd w=1u l=48u b=0 m=1
RR24 n_9 vd1 vss rppd w=1u l=48u b=0 m=1
RR24_u2 n_9 vd1 vss rppd w=1u l=48u b=0 m=1
RR24_u3 n_9 vd1 vss rppd w=1u l=48u b=0 m=1
RR24_u4 n_9 vd1 vss rppd w=1u l=48u b=0 m=1
RR24_u5 n_9 vd1 vss rppd w=1u l=48u b=0 m=1
RR24_u6 n_9 vd1 vss rppd w=1u l=48u b=0 m=1
RR24_u7 n_9 vd1 vss rppd w=1u l=48u b=0 m=1
RR24_u8 n_9 vd1 vss rppd w=1u l=48u b=0 m=1
RR24_u9 n_9 vd1 vss rppd w=1u l=48u b=0 m=1
RR24_u10 n_9 vd1 vss rppd w=1u l=48u b=0 m=1
RR24_u11 n_9 vd1 vss rppd w=1u l=48u b=0 m=1
RR24_u12 n_9 vd1 vss rppd w=1u l=48u b=0 m=1
RR24_u13 n_9 vd1 vss rppd w=1u l=48u b=0 m=1
RR24_u14 n_9 vd1 vss rppd w=1u l=48u b=0 m=1
RR24_u15 n_9 vd1 vss rppd w=1u l=48u b=0 m=1
RR24_u16 n_9 vd1 vss rppd w=1u l=48u b=0 m=1
RR24_u17 n_9 vd1 vss rppd w=1u l=48u b=0 m=1
RR24_u18 n_9 vd1 vss rppd w=1u l=48u b=0 m=1
RR24_u19 n_9 vd1 vss rppd w=1u l=48u b=0 m=1
RR24_u20 n_9 vd1 vss rppd w=1u l=48u b=0 m=1
RR24_u21 n_9 vd1 vss rppd w=1u l=48u b=0 m=1
RR24_u22 n_9 vd1 vss rppd w=1u l=48u b=0 m=1
RR24_u23 n_9 vd1 vss rppd w=1u l=48u b=0 m=1
RR24_u24 n_9 vd1 vss rppd w=1u l=48u b=0 m=1
RR25 n_6 n_19 vss rppd w=1u l=48u b=0 m=1
RR25_u2 n_6 n_19 vss rppd w=1u l=48u b=0 m=1
RR25_u3 n_6 n_19 vss rppd w=1u l=48u b=0 m=1
RR25_u4 n_6 n_19 vss rppd w=1u l=48u b=0 m=1
RR25_u5 n_6 n_19 vss rppd w=1u l=48u b=0 m=1
RR25_u6 n_6 n_19 vss rppd w=1u l=48u b=0 m=1
RR25_u7 n_6 n_19 vss rppd w=1u l=48u b=0 m=1
RR25_u8 n_6 n_19 vss rppd w=1u l=48u b=0 m=1
RR25_u9 n_6 n_19 vss rppd w=1u l=48u b=0 m=1
RR25_u10 n_6 n_19 vss rppd w=1u l=48u b=0 m=1
RR25_u11 n_6 n_19 vss rppd w=1u l=48u b=0 m=1
RR25_u12 n_6 n_19 vss rppd w=1u l=48u b=0 m=1
RR25_u13 n_6 n_19 vss rppd w=1u l=48u b=0 m=1
RR25_u14 n_6 n_19 vss rppd w=1u l=48u b=0 m=1
RR25_u15 n_6 n_19 vss rppd w=1u l=48u b=0 m=1
RR25_u16 n_6 n_19 vss rppd w=1u l=48u b=0 m=1
RR25_u17 n_6 n_19 vss rppd w=1u l=48u b=0 m=1
RR25_u18 n_6 n_19 vss rppd w=1u l=48u b=0 m=1
RR25_u19 n_6 n_19 vss rppd w=1u l=48u b=0 m=1
RR25_u20 n_6 n_19 vss rppd w=1u l=48u b=0 m=1
RR25_u21 n_6 n_19 vss rppd w=1u l=48u b=0 m=1
RR25_u22 n_6 n_19 vss rppd w=1u l=48u b=0 m=1
RR25_u23 n_6 n_19 vss rppd w=1u l=48u b=0 m=1
RR25_u24 n_6 n_19 vss rppd w=1u l=48u b=0 m=1
RR26 n_9 n_19 vss rppd w=1u l=48u b=0 m=1
RR26_u2 n_9 n_19 vss rppd w=1u l=48u b=0 m=1
RR26_u3 n_9 n_19 vss rppd w=1u l=48u b=0 m=1
RR26_u4 n_9 n_19 vss rppd w=1u l=48u b=0 m=1
RR26_u5 n_9 n_19 vss rppd w=1u l=48u b=0 m=1
RR26_u6 n_9 n_19 vss rppd w=1u l=48u b=0 m=1
RR26_u7 n_9 n_19 vss rppd w=1u l=48u b=0 m=1
RR26_u8 n_9 n_19 vss rppd w=1u l=48u b=0 m=1
RR26_u9 n_9 n_19 vss rppd w=1u l=48u b=0 m=1
RR26_u10 n_9 n_19 vss rppd w=1u l=48u b=0 m=1
RR26_u11 n_9 n_19 vss rppd w=1u l=48u b=0 m=1
RR26_u12 n_9 n_19 vss rppd w=1u l=48u b=0 m=1
RR26_u13 n_9 n_19 vss rppd w=1u l=48u b=0 m=1
RR26_u14 n_9 n_19 vss rppd w=1u l=48u b=0 m=1
RR26_u15 n_9 n_19 vss rppd w=1u l=48u b=0 m=1
RR26_u16 n_9 n_19 vss rppd w=1u l=48u b=0 m=1
RR26_u17 n_9 n_19 vss rppd w=1u l=48u b=0 m=1
RR26_u18 n_9 n_19 vss rppd w=1u l=48u b=0 m=1
RR26_u19 n_9 n_19 vss rppd w=1u l=48u b=0 m=1
RR26_u20 n_9 n_19 vss rppd w=1u l=48u b=0 m=1
RR26_u21 n_9 n_19 vss rppd w=1u l=48u b=0 m=1
RR26_u22 n_9 n_19 vss rppd w=1u l=48u b=0 m=1
RR26_u23 n_9 n_19 vss rppd w=1u l=48u b=0 m=1
RR26_u24 n_9 n_19 vss rppd w=1u l=48u b=0 m=1
RR77 n_4 pbias vss rppd w=1u l=50u b=0 m=1
RR77_u2 n_4 pbias vss rppd w=1u l=50u b=0 m=1
RR77_u3 n_4 pbias vss rppd w=1u l=50u b=0 m=1
RR77_u4 n_4 pbias vss rppd w=1u l=50u b=0 m=1
RR77_u5 n_4 pbias vss rppd w=1u l=50u b=0 m=1
RR77_u6 n_4 pbias vss rppd w=1u l=50u b=0 m=1
RR77_u7 n_4 pbias vss rppd w=1u l=50u b=0 m=1
RR77_u8 n_4 pbias vss rppd w=1u l=50u b=0 m=1
RR77_u9 n_4 pbias vss rppd w=1u l=50u b=0 m=1
RR77_u10 n_4 pbias vss rppd w=1u l=50u b=0 m=1
RR77_u11 n_4 pbias vss rppd w=1u l=50u b=0 m=1
RR77_u12 n_4 pbias vss rppd w=1u l=50u b=0 m=1
RR77_u13 n_4 pbias vss rppd w=1u l=50u b=0 m=1
RR77_u14 n_4 pbias vss rppd w=1u l=50u b=0 m=1
RR77_u15 n_4 pbias vss rppd w=1u l=50u b=0 m=1
RR77_u16 n_4 pbias vss rppd w=1u l=50u b=0 m=1
RR77_u17 n_4 pbias vss rppd w=1u l=50u b=0 m=1
RR77_u18 n_4 pbias vss rppd w=1u l=50u b=0 m=1
RR77_u19 n_4 pbias vss rppd w=1u l=50u b=0 m=1
RR77_u20 n_4 pbias vss rppd w=1u l=50u b=0 m=1
RR77_u21 n_4 pbias vss rppd w=1u l=50u b=0 m=1
RR77_u22 n_4 pbias vss rppd w=1u l=50u b=0 m=1
RR77_u23 n_4 pbias vss rppd w=1u l=50u b=0 m=1
RR77_u24 n_4 pbias vss rppd w=1u l=50u b=0 m=1
RR78 n_11 n_34 vss rppd w=1u l=50u b=0 m=1
RR78_u2 n_11 n_34 vss rppd w=1u l=50u b=0 m=1
RR78_u3 n_11 n_34 vss rppd w=1u l=50u b=0 m=1
RR78_u4 n_11 n_34 vss rppd w=1u l=50u b=0 m=1
RR78_u5 n_11 n_34 vss rppd w=1u l=50u b=0 m=1
RR78_u6 n_11 n_34 vss rppd w=1u l=50u b=0 m=1
RR78_u7 n_11 n_34 vss rppd w=1u l=50u b=0 m=1
RR78_u8 n_11 n_34 vss rppd w=1u l=50u b=0 m=1
RR78_u9 n_11 n_34 vss rppd w=1u l=50u b=0 m=1
RR78_u10 n_11 n_34 vss rppd w=1u l=50u b=0 m=1
RR78_u11 n_11 n_34 vss rppd w=1u l=50u b=0 m=1
RR78_u12 n_11 n_34 vss rppd w=1u l=50u b=0 m=1
RR78_u13 n_11 n_34 vss rppd w=1u l=50u b=0 m=1
RR78_u14 n_11 n_34 vss rppd w=1u l=50u b=0 m=1
RR78_u15 n_11 n_34 vss rppd w=1u l=50u b=0 m=1
RR78_u16 n_11 n_34 vss rppd w=1u l=50u b=0 m=1
RR78_u17 n_11 n_34 vss rppd w=1u l=50u b=0 m=1
RR78_u18 n_11 n_34 vss rppd w=1u l=50u b=0 m=1
RR78_u19 n_11 n_34 vss rppd w=1u l=50u b=0 m=1
RR78_u20 n_11 n_34 vss rppd w=1u l=50u b=0 m=1
RR78_u21 n_11 n_34 vss rppd w=1u l=50u b=0 m=1
RR78_u22 n_11 n_34 vss rppd w=1u l=50u b=0 m=1
RR78_u23 n_11 n_34 vss rppd w=1u l=50u b=0 m=1
RR78_u24 n_11 n_34 vss rppd w=1u l=50u b=0 m=1
RR79 n_10 n_34 vss rppd w=1u l=50u b=0 m=1
RR79_u2 n_10 n_34 vss rppd w=1u l=50u b=0 m=1
RR79_u3 n_10 n_34 vss rppd w=1u l=50u b=0 m=1
RR79_u4 n_10 n_34 vss rppd w=1u l=50u b=0 m=1
RR79_u5 n_10 n_34 vss rppd w=1u l=50u b=0 m=1
RR79_u6 n_10 n_34 vss rppd w=1u l=50u b=0 m=1
RR79_u7 n_10 n_34 vss rppd w=1u l=50u b=0 m=1
RR79_u8 n_10 n_34 vss rppd w=1u l=50u b=0 m=1
RR79_u9 n_10 n_34 vss rppd w=1u l=50u b=0 m=1
RR79_u10 n_10 n_34 vss rppd w=1u l=50u b=0 m=1
RR79_u11 n_10 n_34 vss rppd w=1u l=50u b=0 m=1
RR79_u12 n_10 n_34 vss rppd w=1u l=50u b=0 m=1
RR79_u13 n_10 n_34 vss rppd w=1u l=50u b=0 m=1
RR79_u14 n_10 n_34 vss rppd w=1u l=50u b=0 m=1
RR79_u15 n_10 n_34 vss rppd w=1u l=50u b=0 m=1
RR79_u16 n_10 n_34 vss rppd w=1u l=50u b=0 m=1
RR79_u17 n_10 n_34 vss rppd w=1u l=50u b=0 m=1
RR79_u18 n_10 n_34 vss rppd w=1u l=50u b=0 m=1
RR79_u19 n_10 n_34 vss rppd w=1u l=50u b=0 m=1
RR79_u20 n_10 n_34 vss rppd w=1u l=50u b=0 m=1
RR79_u21 n_10 n_34 vss rppd w=1u l=50u b=0 m=1
RR79_u22 n_10 n_34 vss rppd w=1u l=50u b=0 m=1
RR79_u23 n_10 n_34 vss rppd w=1u l=50u b=0 m=1
RR79_u24 n_10 n_34 vss rppd w=1u l=50u b=0 m=1
RR80 n_3 n_31 vss rppd w=1u l=50u b=0 m=1
RR80_u2 n_3 n_31 vss rppd w=1u l=50u b=0 m=1
RR80_u3 n_3 n_31 vss rppd w=1u l=50u b=0 m=1
RR80_u4 n_3 n_31 vss rppd w=1u l=50u b=0 m=1
RR80_u5 n_3 n_31 vss rppd w=1u l=50u b=0 m=1
RR80_u6 n_3 n_31 vss rppd w=1u l=50u b=0 m=1
RR80_u7 n_3 n_31 vss rppd w=1u l=50u b=0 m=1
RR80_u8 n_3 n_31 vss rppd w=1u l=50u b=0 m=1
RR80_u9 n_3 n_31 vss rppd w=1u l=50u b=0 m=1
RR80_u10 n_3 n_31 vss rppd w=1u l=50u b=0 m=1
RR80_u11 n_3 n_31 vss rppd w=1u l=50u b=0 m=1
RR80_u12 n_3 n_31 vss rppd w=1u l=50u b=0 m=1
RR80_u13 n_3 n_31 vss rppd w=1u l=50u b=0 m=1
RR80_u14 n_3 n_31 vss rppd w=1u l=50u b=0 m=1
RR80_u15 n_3 n_31 vss rppd w=1u l=50u b=0 m=1
RR80_u16 n_3 n_31 vss rppd w=1u l=50u b=0 m=1
RR80_u17 n_3 n_31 vss rppd w=1u l=50u b=0 m=1
RR80_u18 n_3 n_31 vss rppd w=1u l=50u b=0 m=1
RR80_u19 n_3 n_31 vss rppd w=1u l=50u b=0 m=1
RR80_u20 n_3 n_31 vss rppd w=1u l=50u b=0 m=1
RR80_u21 n_3 n_31 vss rppd w=1u l=50u b=0 m=1
RR80_u22 n_3 n_31 vss rppd w=1u l=50u b=0 m=1
RR80_u23 n_3 n_31 vss rppd w=1u l=50u b=0 m=1
RR80_u24 n_3 n_31 vss rppd w=1u l=50u b=0 m=1
RR81 n_10 n_33 vss rppd w=1u l=50u b=0 m=1
RR81_u2 n_10 n_33 vss rppd w=1u l=50u b=0 m=1
RR81_u3 n_10 n_33 vss rppd w=1u l=50u b=0 m=1
RR81_u4 n_10 n_33 vss rppd w=1u l=50u b=0 m=1
RR81_u5 n_10 n_33 vss rppd w=1u l=50u b=0 m=1
RR81_u6 n_10 n_33 vss rppd w=1u l=50u b=0 m=1
RR81_u7 n_10 n_33 vss rppd w=1u l=50u b=0 m=1
RR81_u8 n_10 n_33 vss rppd w=1u l=50u b=0 m=1
RR81_u9 n_10 n_33 vss rppd w=1u l=50u b=0 m=1
RR81_u10 n_10 n_33 vss rppd w=1u l=50u b=0 m=1
RR81_u11 n_10 n_33 vss rppd w=1u l=50u b=0 m=1
RR81_u12 n_10 n_33 vss rppd w=1u l=50u b=0 m=1
RR81_u13 n_10 n_33 vss rppd w=1u l=50u b=0 m=1
RR81_u14 n_10 n_33 vss rppd w=1u l=50u b=0 m=1
RR81_u15 n_10 n_33 vss rppd w=1u l=50u b=0 m=1
RR81_u16 n_10 n_33 vss rppd w=1u l=50u b=0 m=1
RR81_u17 n_10 n_33 vss rppd w=1u l=50u b=0 m=1
RR81_u18 n_10 n_33 vss rppd w=1u l=50u b=0 m=1
RR81_u19 n_10 n_33 vss rppd w=1u l=50u b=0 m=1
RR81_u20 n_10 n_33 vss rppd w=1u l=50u b=0 m=1
RR81_u21 n_10 n_33 vss rppd w=1u l=50u b=0 m=1
RR81_u22 n_10 n_33 vss rppd w=1u l=50u b=0 m=1
RR81_u23 n_10 n_33 vss rppd w=1u l=50u b=0 m=1
RR81_u24 n_10 n_33 vss rppd w=1u l=50u b=0 m=1
RR82 n_5 n_31 vss rppd w=1u l=50u b=0 m=1
RR82_u2 n_5 n_31 vss rppd w=1u l=50u b=0 m=1
RR82_u3 n_5 n_31 vss rppd w=1u l=50u b=0 m=1
RR82_u4 n_5 n_31 vss rppd w=1u l=50u b=0 m=1
RR82_u5 n_5 n_31 vss rppd w=1u l=50u b=0 m=1
RR82_u6 n_5 n_31 vss rppd w=1u l=50u b=0 m=1
RR82_u7 n_5 n_31 vss rppd w=1u l=50u b=0 m=1
RR82_u8 n_5 n_31 vss rppd w=1u l=50u b=0 m=1
RR82_u9 n_5 n_31 vss rppd w=1u l=50u b=0 m=1
RR82_u10 n_5 n_31 vss rppd w=1u l=50u b=0 m=1
RR82_u11 n_5 n_31 vss rppd w=1u l=50u b=0 m=1
RR82_u12 n_5 n_31 vss rppd w=1u l=50u b=0 m=1
RR82_u13 n_5 n_31 vss rppd w=1u l=50u b=0 m=1
RR82_u14 n_5 n_31 vss rppd w=1u l=50u b=0 m=1
RR82_u15 n_5 n_31 vss rppd w=1u l=50u b=0 m=1
RR82_u16 n_5 n_31 vss rppd w=1u l=50u b=0 m=1
RR82_u17 n_5 n_31 vss rppd w=1u l=50u b=0 m=1
RR82_u18 n_5 n_31 vss rppd w=1u l=50u b=0 m=1
RR82_u19 n_5 n_31 vss rppd w=1u l=50u b=0 m=1
RR82_u20 n_5 n_31 vss rppd w=1u l=50u b=0 m=1
RR82_u21 n_5 n_31 vss rppd w=1u l=50u b=0 m=1
RR82_u22 n_5 n_31 vss rppd w=1u l=50u b=0 m=1
RR82_u23 n_5 n_31 vss rppd w=1u l=50u b=0 m=1
RR82_u24 n_5 n_31 vss rppd w=1u l=50u b=0 m=1
RR83 n_5 n_30 vss rppd w=1u l=50u b=0 m=1
RR83_u2 n_5 n_30 vss rppd w=1u l=50u b=0 m=1
RR83_u3 n_5 n_30 vss rppd w=1u l=50u b=0 m=1
RR83_u4 n_5 n_30 vss rppd w=1u l=50u b=0 m=1
RR83_u5 n_5 n_30 vss rppd w=1u l=50u b=0 m=1
RR83_u6 n_5 n_30 vss rppd w=1u l=50u b=0 m=1
RR83_u7 n_5 n_30 vss rppd w=1u l=50u b=0 m=1
RR83_u8 n_5 n_30 vss rppd w=1u l=50u b=0 m=1
RR83_u9 n_5 n_30 vss rppd w=1u l=50u b=0 m=1
RR83_u10 n_5 n_30 vss rppd w=1u l=50u b=0 m=1
RR83_u11 n_5 n_30 vss rppd w=1u l=50u b=0 m=1
RR83_u12 n_5 n_30 vss rppd w=1u l=50u b=0 m=1
RR83_u13 n_5 n_30 vss rppd w=1u l=50u b=0 m=1
RR83_u14 n_5 n_30 vss rppd w=1u l=50u b=0 m=1
RR83_u15 n_5 n_30 vss rppd w=1u l=50u b=0 m=1
RR83_u16 n_5 n_30 vss rppd w=1u l=50u b=0 m=1
RR83_u17 n_5 n_30 vss rppd w=1u l=50u b=0 m=1
RR83_u18 n_5 n_30 vss rppd w=1u l=50u b=0 m=1
RR83_u19 n_5 n_30 vss rppd w=1u l=50u b=0 m=1
RR83_u20 n_5 n_30 vss rppd w=1u l=50u b=0 m=1
RR83_u21 n_5 n_30 vss rppd w=1u l=50u b=0 m=1
RR83_u22 n_5 n_30 vss rppd w=1u l=50u b=0 m=1
RR83_u23 n_5 n_30 vss rppd w=1u l=50u b=0 m=1
RR83_u24 n_5 n_30 vss rppd w=1u l=50u b=0 m=1
RR84 n_4 n_30 vss rppd w=1u l=50u b=0 m=1
RR84_u2 n_4 n_30 vss rppd w=1u l=50u b=0 m=1
RR84_u3 n_4 n_30 vss rppd w=1u l=50u b=0 m=1
RR84_u4 n_4 n_30 vss rppd w=1u l=50u b=0 m=1
RR84_u5 n_4 n_30 vss rppd w=1u l=50u b=0 m=1
RR84_u6 n_4 n_30 vss rppd w=1u l=50u b=0 m=1
RR84_u7 n_4 n_30 vss rppd w=1u l=50u b=0 m=1
RR84_u8 n_4 n_30 vss rppd w=1u l=50u b=0 m=1
RR84_u9 n_4 n_30 vss rppd w=1u l=50u b=0 m=1
RR84_u10 n_4 n_30 vss rppd w=1u l=50u b=0 m=1
RR84_u11 n_4 n_30 vss rppd w=1u l=50u b=0 m=1
RR84_u12 n_4 n_30 vss rppd w=1u l=50u b=0 m=1
RR84_u13 n_4 n_30 vss rppd w=1u l=50u b=0 m=1
RR84_u14 n_4 n_30 vss rppd w=1u l=50u b=0 m=1
RR84_u15 n_4 n_30 vss rppd w=1u l=50u b=0 m=1
RR84_u16 n_4 n_30 vss rppd w=1u l=50u b=0 m=1
RR84_u17 n_4 n_30 vss rppd w=1u l=50u b=0 m=1
RR84_u18 n_4 n_30 vss rppd w=1u l=50u b=0 m=1
RR84_u19 n_4 n_30 vss rppd w=1u l=50u b=0 m=1
RR84_u20 n_4 n_30 vss rppd w=1u l=50u b=0 m=1
RR84_u21 n_4 n_30 vss rppd w=1u l=50u b=0 m=1
RR84_u22 n_4 n_30 vss rppd w=1u l=50u b=0 m=1
RR84_u23 n_4 n_30 vss rppd w=1u l=50u b=0 m=1
RR84_u24 n_4 n_30 vss rppd w=1u l=50u b=0 m=1
RR85 n_3 n_33 vss rppd w=1u l=50u b=0 m=1
RR85_u2 n_3 n_33 vss rppd w=1u l=50u b=0 m=1
RR85_u3 n_3 n_33 vss rppd w=1u l=50u b=0 m=1
RR85_u4 n_3 n_33 vss rppd w=1u l=50u b=0 m=1
RR85_u5 n_3 n_33 vss rppd w=1u l=50u b=0 m=1
RR85_u6 n_3 n_33 vss rppd w=1u l=50u b=0 m=1
RR85_u7 n_3 n_33 vss rppd w=1u l=50u b=0 m=1
RR85_u8 n_3 n_33 vss rppd w=1u l=50u b=0 m=1
RR85_u9 n_3 n_33 vss rppd w=1u l=50u b=0 m=1
RR85_u10 n_3 n_33 vss rppd w=1u l=50u b=0 m=1
RR85_u11 n_3 n_33 vss rppd w=1u l=50u b=0 m=1
RR85_u12 n_3 n_33 vss rppd w=1u l=50u b=0 m=1
RR85_u13 n_3 n_33 vss rppd w=1u l=50u b=0 m=1
RR85_u14 n_3 n_33 vss rppd w=1u l=50u b=0 m=1
RR85_u15 n_3 n_33 vss rppd w=1u l=50u b=0 m=1
RR85_u16 n_3 n_33 vss rppd w=1u l=50u b=0 m=1
RR85_u17 n_3 n_33 vss rppd w=1u l=50u b=0 m=1
RR85_u18 n_3 n_33 vss rppd w=1u l=50u b=0 m=1
RR85_u19 n_3 n_33 vss rppd w=1u l=50u b=0 m=1
RR85_u20 n_3 n_33 vss rppd w=1u l=50u b=0 m=1
RR85_u21 n_3 n_33 vss rppd w=1u l=50u b=0 m=1
RR85_u22 n_3 n_33 vss rppd w=1u l=50u b=0 m=1
RR85_u23 n_3 n_33 vss rppd w=1u l=50u b=0 m=1
RR85_u24 n_3 n_33 vss rppd w=1u l=50u b=0 m=1
RR86 n_11 pcasc vss rppd w=1u l=50u b=0 m=1
RR86_u2 n_11 pcasc vss rppd w=1u l=50u b=0 m=1
RR86_u3 n_11 pcasc vss rppd w=1u l=50u b=0 m=1
RR86_u4 n_11 pcasc vss rppd w=1u l=50u b=0 m=1
RR86_u5 n_11 pcasc vss rppd w=1u l=50u b=0 m=1
RR86_u6 n_11 pcasc vss rppd w=1u l=50u b=0 m=1
RR86_u7 n_11 pcasc vss rppd w=1u l=50u b=0 m=1
RR86_u8 n_11 pcasc vss rppd w=1u l=50u b=0 m=1
RR86_u9 n_11 pcasc vss rppd w=1u l=50u b=0 m=1
RR86_u10 n_11 pcasc vss rppd w=1u l=50u b=0 m=1
RR86_u11 n_11 pcasc vss rppd w=1u l=50u b=0 m=1
RR86_u12 n_11 pcasc vss rppd w=1u l=50u b=0 m=1
RR86_u13 n_11 pcasc vss rppd w=1u l=50u b=0 m=1
RR86_u14 n_11 pcasc vss rppd w=1u l=50u b=0 m=1
RR86_u15 n_11 pcasc vss rppd w=1u l=50u b=0 m=1
RR86_u16 n_11 pcasc vss rppd w=1u l=50u b=0 m=1
RR86_u17 n_11 pcasc vss rppd w=1u l=50u b=0 m=1
RR86_u18 n_11 pcasc vss rppd w=1u l=50u b=0 m=1
RR86_u19 n_11 pcasc vss rppd w=1u l=50u b=0 m=1
RR86_u20 n_11 pcasc vss rppd w=1u l=50u b=0 m=1
RR86_u21 n_11 pcasc vss rppd w=1u l=50u b=0 m=1
RR86_u22 n_11 pcasc vss rppd w=1u l=50u b=0 m=1
RR86_u23 n_11 pcasc vss rppd w=1u l=50u b=0 m=1
RR86_u24 n_11 pcasc vss rppd w=1u l=50u b=0 m=1
RR17 n_7 vref vss rppd w=1u l=53.465u b=0 m=1
RR17_u2 n_7 vref vss rppd w=1u l=53.465u b=0 m=1
RR17_u3 n_7 vref vss rppd w=1u l=53.465u b=0 m=1
RR17_u4 n_7 vref vss rppd w=1u l=53.465u b=0 m=1
RR18 n_2 n_36 vss rppd w=1u l=53.465u b=0 m=1
RR18_u2 n_2 n_36 vss rppd w=1u l=53.465u b=0 m=1
RR18_u3 n_2 n_36 vss rppd w=1u l=53.465u b=0 m=1
RR18_u4 n_2 n_36 vss rppd w=1u l=53.465u b=0 m=1
RR19 n_7 n_36 vss rppd w=1u l=53.465u b=0 m=1
RR19_u2 n_7 n_36 vss rppd w=1u l=53.465u b=0 m=1
RR19_u3 n_7 n_36 vss rppd w=1u l=53.465u b=0 m=1
RR19_u4 n_7 n_36 vss rppd w=1u l=53.465u b=0 m=1
RR20 n_2 n_37 vss rppd w=1u l=53.465u b=0 m=1
RR20_u2 n_2 n_37 vss rppd w=1u l=53.465u b=0 m=1
RR20_u3 n_2 n_37 vss rppd w=1u l=53.465u b=0 m=1
RR20_u4 n_2 n_37 vss rppd w=1u l=53.465u b=0 m=1
RR21 n_8 n_37 vss rppd w=1u l=53.465u b=0 m=1
RR21_u2 n_8 n_37 vss rppd w=1u l=53.465u b=0 m=1
RR21_u3 n_8 n_37 vss rppd w=1u l=53.465u b=0 m=1
RR21_u4 n_8 n_37 vss rppd w=1u l=53.465u b=0 m=1
RR22 n_8 vbe3 vss rppd w=1u l=53.465u b=0 m=1
RR22_u2 n_8 vbe3 vss rppd w=1u l=53.465u b=0 m=1
RR22_u3 n_8 vbe3 vss rppd w=1u l=53.465u b=0 m=1
RR22_u4 n_8 vbe3 vss rppd w=1u l=53.465u b=0 m=1
RR1 vss n_23 vss rhigh w=0.5u l=49u b=0 m=1
RR10 n_12 n_25 vss rhigh w=0.5u l=49u b=0 m=1
RR11 n_13 n_25 vss rhigh w=0.5u l=49u b=0 m=1
RR12 n_17 n_22 vss rhigh w=0.5u l=49u b=0 m=1
RR13 n_18 n_22 vss rhigh w=0.5u l=49u b=0 m=1
RR14 n_18 n_23 vss rhigh w=0.5u l=49u b=0 m=1
RR15 n_17 n_21 vss rhigh w=0.5u l=49u b=0 m=1
RR2 n_12 det vss rhigh w=0.5u l=49u b=0 m=1
RR3 n_13 n_24 vss rhigh w=0.5u l=49u b=0 m=1
RR4 n_14 n_24 vss rhigh w=0.5u l=49u b=0 m=1
RR5 n_14 n_26 vss rhigh w=0.5u l=49u b=0 m=1
RR6 n_15 n_26 vss rhigh w=0.5u l=49u b=0 m=1
RR7 n_15 n_27 vss rhigh w=0.5u l=49u b=0 m=1
RR8 n_16 n_27 vss rhigh w=0.5u l=49u b=0 m=1
RR9 n_16 n_21 vss rhigh w=0.5u l=49u b=0 m=1
.ends bgr_resistor_bank_pilot
