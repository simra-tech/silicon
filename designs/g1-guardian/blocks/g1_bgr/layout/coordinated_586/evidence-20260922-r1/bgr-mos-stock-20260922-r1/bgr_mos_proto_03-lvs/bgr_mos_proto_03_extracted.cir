* Extracted by KLayout with SG13G2 LVS runset on : 22/09/2026 19:07

.SUBCKT bgr_mos_proto_03 det kick vss
M$1 vss det kick vss sg13_hv_nmos L=0.6u W=1u AS=0.34p AD=0.34p PS=2.68u
+ PD=2.68u rfmode=0
.ENDS bgr_mos_proto_03
