* G1_BGR standalone capacitance-PEX qualification
.lib /foss/pdks/ihp-sg13g2/libs.tech/ngspice/models/cornerHBT.lib hbt_typ
.lib /foss/pdks/ihp-sg13g2/libs.tech/ngspice/models/cornerMOShv.lib mos_tt
.lib /foss/pdks/ihp-sg13g2/libs.tech/ngspice/models/cornerRES.lib res_typ
.include conditional_metal.spice
.option seed=44001 gmin=1e-15 abstol=1e-14 reltol=1e-5 vntol=1e-7
.global sub!
Vsub sub! 0 0
Vdd vdd 0 3.3
Vr4 r4 0 0
Xbgr vdd 0 r4 vref iptat pbias pcasc vbe dvbe g1_bgr
Vload iptat 0 1
Cload vref 0 1e-12
.control
set num_threads=1
set numdgt=15
set wr_singlescale
set wr_vecnames
op
echo RAW_CURRENT_LEDGER_BEGIN
print @n.xbgr.xr1.nr1[ibody]
print @n.xbgr.xr2.nr1[ibody]
print @n.xbgr.xr3.nr1[ibody]
print @n.xbgr.xr4.nr1[ibody]
print @n.xbgr.xr5.nr1[ibody]
print @n.xbgr.xr6.nr1[ibody]
print @n.xbgr.xr7.nr1[ibody]
print @n.xbgr.xr8.nr1[ibody]
print @n.xbgr.xr9.nr1[ibody]
print @n.xbgr.xr10.nr1[ibody]
print @n.xbgr.xr11.nr1[ibody]
print @n.xbgr.xr12.nr1[ibody]
print @n.xbgr.xr13.nr1[ibody]
print @n.xbgr.xr14.nr1[ibody]
print @n.xbgr.xr15.nr1[ibody]
print @n.xbgr.xr16.nr1[ibody]
print @n.xbgr.xr17.nr1[ibody]
print @n.xbgr.xr18.nr1[ibody]
print @n.xbgr.xr19.nr1[ibody]
print @n.xbgr.xr20.nr1[ibody]
print @n.xbgr.xr21.nr1[ibody]
print @n.xbgr.xr22.nr1[ibody]
print @n.xbgr.xr23.nr1[ibody]
print @n.xbgr.xr24.nr1[ibody]
print @n.xbgr.xr25.nr1[ibody]
print @n.xbgr.xr26.nr1[ibody]
print @n.xbgr.xm27.nsg13_hv_pmos[ide]
print @n.xbgr.xm27.nsg13_hv_pmos[ige]
print @n.xbgr.xm27.nsg13_hv_pmos[ise]
print @n.xbgr.xm27.nsg13_hv_pmos[ibe]
print @n.xbgr.xm27.nsg13_hv_pmos[ctype]
print @n.xbgr.xm28.nsg13_hv_pmos[ide]
print @n.xbgr.xm28.nsg13_hv_pmos[ige]
print @n.xbgr.xm28.nsg13_hv_pmos[ise]
print @n.xbgr.xm28.nsg13_hv_pmos[ibe]
print @n.xbgr.xm28.nsg13_hv_pmos[ctype]
print @n.xbgr.xm29.nsg13_hv_nmos[ide]
print @n.xbgr.xm29.nsg13_hv_nmos[ige]
print @n.xbgr.xm29.nsg13_hv_nmos[ise]
print @n.xbgr.xm29.nsg13_hv_nmos[ibe]
print @n.xbgr.xm29.nsg13_hv_nmos[ctype]
print @n.xbgr.xm30.nsg13_hv_nmos[ide]
print @n.xbgr.xm30.nsg13_hv_nmos[ige]
print @n.xbgr.xm30.nsg13_hv_nmos[ise]
print @n.xbgr.xm30.nsg13_hv_nmos[ibe]
print @n.xbgr.xm30.nsg13_hv_nmos[ctype]
print @n.xbgr.xm31.nsg13_hv_nmos[ide]
print @n.xbgr.xm31.nsg13_hv_nmos[ige]
print @n.xbgr.xm31.nsg13_hv_nmos[ise]
print @n.xbgr.xm31.nsg13_hv_nmos[ibe]
print @n.xbgr.xm31.nsg13_hv_nmos[ctype]
print @n.xbgr.xm32.nsg13_hv_nmos[ide]
print @n.xbgr.xm32.nsg13_hv_nmos[ige]
print @n.xbgr.xm32.nsg13_hv_nmos[ise]
print @n.xbgr.xm32.nsg13_hv_nmos[ibe]
print @n.xbgr.xm32.nsg13_hv_nmos[ctype]
print @n.xbgr.xm33.nsg13_hv_nmos[ide]
print @n.xbgr.xm33.nsg13_hv_nmos[ige]
print @n.xbgr.xm33.nsg13_hv_nmos[ise]
print @n.xbgr.xm33.nsg13_hv_nmos[ibe]
print @n.xbgr.xm33.nsg13_hv_nmos[ctype]
print @n.xbgr.xm34.nsg13_hv_nmos[ide]
print @n.xbgr.xm34.nsg13_hv_nmos[ige]
print @n.xbgr.xm34.nsg13_hv_nmos[ise]
print @n.xbgr.xm34.nsg13_hv_nmos[ibe]
print @n.xbgr.xm34.nsg13_hv_nmos[ctype]
print @n.xbgr.xm35.nsg13_hv_nmos[ide]
print @n.xbgr.xm35.nsg13_hv_nmos[ige]
print @n.xbgr.xm35.nsg13_hv_nmos[ise]
print @n.xbgr.xm35.nsg13_hv_nmos[ibe]
print @n.xbgr.xm35.nsg13_hv_nmos[ctype]
print @n.xbgr.xm36.nsg13_hv_nmos[ide]
print @n.xbgr.xm36.nsg13_hv_nmos[ige]
print @n.xbgr.xm36.nsg13_hv_nmos[ise]
print @n.xbgr.xm36.nsg13_hv_nmos[ibe]
print @n.xbgr.xm36.nsg13_hv_nmos[ctype]
print @n.xbgr.xm37.nsg13_hv_nmos[ide]
print @n.xbgr.xm37.nsg13_hv_nmos[ige]
print @n.xbgr.xm37.nsg13_hv_nmos[ise]
print @n.xbgr.xm37.nsg13_hv_nmos[ibe]
print @n.xbgr.xm37.nsg13_hv_nmos[ctype]
print @n.xbgr.xm38.nsg13_hv_pmos[ide]
print @n.xbgr.xm38.nsg13_hv_pmos[ige]
print @n.xbgr.xm38.nsg13_hv_pmos[ise]
print @n.xbgr.xm38.nsg13_hv_pmos[ibe]
print @n.xbgr.xm38.nsg13_hv_pmos[ctype]
print @n.xbgr.xm39.nsg13_hv_pmos[ide]
print @n.xbgr.xm39.nsg13_hv_pmos[ige]
print @n.xbgr.xm39.nsg13_hv_pmos[ise]
print @n.xbgr.xm39.nsg13_hv_pmos[ibe]
print @n.xbgr.xm39.nsg13_hv_pmos[ctype]
print @n.xbgr.xm40.nsg13_hv_pmos[ide]
print @n.xbgr.xm40.nsg13_hv_pmos[ige]
print @n.xbgr.xm40.nsg13_hv_pmos[ise]
print @n.xbgr.xm40.nsg13_hv_pmos[ibe]
print @n.xbgr.xm40.nsg13_hv_pmos[ctype]
print @n.xbgr.xm41.nsg13_hv_pmos[ide]
print @n.xbgr.xm41.nsg13_hv_pmos[ige]
print @n.xbgr.xm41.nsg13_hv_pmos[ise]
print @n.xbgr.xm41.nsg13_hv_pmos[ibe]
print @n.xbgr.xm41.nsg13_hv_pmos[ctype]
print @n.xbgr.xm42.nsg13_hv_pmos[ide]
print @n.xbgr.xm42.nsg13_hv_pmos[ige]
print @n.xbgr.xm42.nsg13_hv_pmos[ise]
print @n.xbgr.xm42.nsg13_hv_pmos[ibe]
print @n.xbgr.xm42.nsg13_hv_pmos[ctype]
print @n.xbgr.xm43.nsg13_hv_pmos[ide]
print @n.xbgr.xm43.nsg13_hv_pmos[ige]
print @n.xbgr.xm43.nsg13_hv_pmos[ise]
print @n.xbgr.xm43.nsg13_hv_pmos[ibe]
print @n.xbgr.xm43.nsg13_hv_pmos[ctype]
print @n.xbgr.xm44.nsg13_hv_pmos[ide]
print @n.xbgr.xm44.nsg13_hv_pmos[ige]
print @n.xbgr.xm44.nsg13_hv_pmos[ise]
print @n.xbgr.xm44.nsg13_hv_pmos[ibe]
print @n.xbgr.xm44.nsg13_hv_pmos[ctype]
print @n.xbgr.xm45.nsg13_hv_pmos[ide]
print @n.xbgr.xm45.nsg13_hv_pmos[ige]
print @n.xbgr.xm45.nsg13_hv_pmos[ise]
print @n.xbgr.xm45.nsg13_hv_pmos[ibe]
print @n.xbgr.xm45.nsg13_hv_pmos[ctype]
print @n.xbgr.xm46.nsg13_hv_pmos[ide]
print @n.xbgr.xm46.nsg13_hv_pmos[ige]
print @n.xbgr.xm46.nsg13_hv_pmos[ise]
print @n.xbgr.xm46.nsg13_hv_pmos[ibe]
print @n.xbgr.xm46.nsg13_hv_pmos[ctype]
print @n.xbgr.xm47.nsg13_hv_pmos[ide]
print @n.xbgr.xm47.nsg13_hv_pmos[ige]
print @n.xbgr.xm47.nsg13_hv_pmos[ise]
print @n.xbgr.xm47.nsg13_hv_pmos[ibe]
print @n.xbgr.xm47.nsg13_hv_pmos[ctype]
print @n.xbgr.xm48.nsg13_hv_pmos[ide]
print @n.xbgr.xm48.nsg13_hv_pmos[ige]
print @n.xbgr.xm48.nsg13_hv_pmos[ise]
print @n.xbgr.xm48.nsg13_hv_pmos[ibe]
print @n.xbgr.xm48.nsg13_hv_pmos[ctype]
print @n.xbgr.xm49.nsg13_hv_pmos[ide]
print @n.xbgr.xm49.nsg13_hv_pmos[ige]
print @n.xbgr.xm49.nsg13_hv_pmos[ise]
print @n.xbgr.xm49.nsg13_hv_pmos[ibe]
print @n.xbgr.xm49.nsg13_hv_pmos[ctype]
print @n.xbgr.xm50.nsg13_hv_pmos[ide]
print @n.xbgr.xm50.nsg13_hv_pmos[ige]
print @n.xbgr.xm50.nsg13_hv_pmos[ise]
print @n.xbgr.xm50.nsg13_hv_pmos[ibe]
print @n.xbgr.xm50.nsg13_hv_pmos[ctype]
print @n.xbgr.xm51.nsg13_hv_pmos[ide]
print @n.xbgr.xm51.nsg13_hv_pmos[ige]
print @n.xbgr.xm51.nsg13_hv_pmos[ise]
print @n.xbgr.xm51.nsg13_hv_pmos[ibe]
print @n.xbgr.xm51.nsg13_hv_pmos[ctype]
print @n.xbgr.xm52.nsg13_hv_pmos[ide]
print @n.xbgr.xm52.nsg13_hv_pmos[ige]
print @n.xbgr.xm52.nsg13_hv_pmos[ise]
print @n.xbgr.xm52.nsg13_hv_pmos[ibe]
print @n.xbgr.xm52.nsg13_hv_pmos[ctype]
print @n.xbgr.xm53.nsg13_hv_pmos[ide]
print @n.xbgr.xm53.nsg13_hv_pmos[ige]
print @n.xbgr.xm53.nsg13_hv_pmos[ise]
print @n.xbgr.xm53.nsg13_hv_pmos[ibe]
print @n.xbgr.xm53.nsg13_hv_pmos[ctype]
print @n.xbgr.xm54.nsg13_hv_pmos[ide]
print @n.xbgr.xm54.nsg13_hv_pmos[ige]
print @n.xbgr.xm54.nsg13_hv_pmos[ise]
print @n.xbgr.xm54.nsg13_hv_pmos[ibe]
print @n.xbgr.xm54.nsg13_hv_pmos[ctype]
print @q.xbgr.xq55.qnpn13g2[ic]
print @q.xbgr.xq55.qnpn13g2[ib]
print @q.xbgr.xq55.qnpn13g2[ie]
print @q.xbgr.xq55.qnpn13g2[is]
print @r.xbgr.xq55.rsub[i]
print @c.xbgr.xq55.csub[i]
print @q.xbgr.xq56.qnpn13g2[ic]
print @q.xbgr.xq56.qnpn13g2[ib]
print @q.xbgr.xq56.qnpn13g2[ie]
print @q.xbgr.xq56.qnpn13g2[is]
print @r.xbgr.xq56.rsub[i]
print @c.xbgr.xq56.csub[i]
print @q.xbgr.xq57.qnpn13g2[ic]
print @q.xbgr.xq57.qnpn13g2[ib]
print @q.xbgr.xq57.qnpn13g2[ie]
print @q.xbgr.xq57.qnpn13g2[is]
print @r.xbgr.xq57.rsub[i]
print @c.xbgr.xq57.csub[i]
print @q.xbgr.xq58.qnpn13g2[ic]
print @q.xbgr.xq58.qnpn13g2[ib]
print @q.xbgr.xq58.qnpn13g2[ie]
print @q.xbgr.xq58.qnpn13g2[is]
print @r.xbgr.xq58.rsub[i]
print @c.xbgr.xq58.csub[i]
print @q.xbgr.xq59.qnpn13g2[ic]
print @q.xbgr.xq59.qnpn13g2[ib]
print @q.xbgr.xq59.qnpn13g2[ie]
print @q.xbgr.xq59.qnpn13g2[is]
print @r.xbgr.xq59.rsub[i]
print @c.xbgr.xq59.csub[i]
print @q.xbgr.xq60.qnpn13g2[ic]
print @q.xbgr.xq60.qnpn13g2[ib]
print @q.xbgr.xq60.qnpn13g2[ie]
print @q.xbgr.xq60.qnpn13g2[is]
print @r.xbgr.xq60.rsub[i]
print @c.xbgr.xq60.csub[i]
print @q.xbgr.xq61.qnpn13g2[ic]
print @q.xbgr.xq61.qnpn13g2[ib]
print @q.xbgr.xq61.qnpn13g2[ie]
print @q.xbgr.xq61.qnpn13g2[is]
print @r.xbgr.xq61.rsub[i]
print @c.xbgr.xq61.csub[i]
print @q.xbgr.xq62.qnpn13g2[ic]
print @q.xbgr.xq62.qnpn13g2[ib]
print @q.xbgr.xq62.qnpn13g2[ie]
print @q.xbgr.xq62.qnpn13g2[is]
print @r.xbgr.xq62.rsub[i]
print @c.xbgr.xq62.csub[i]
print @q.xbgr.xq63.qnpn13g2[ic]
print @q.xbgr.xq63.qnpn13g2[ib]
print @q.xbgr.xq63.qnpn13g2[ie]
print @q.xbgr.xq63.qnpn13g2[is]
print @r.xbgr.xq63.rsub[i]
print @c.xbgr.xq63.csub[i]
print @q.xbgr.xq64.qnpn13g2[ic]
print @q.xbgr.xq64.qnpn13g2[ib]
print @q.xbgr.xq64.qnpn13g2[ie]
print @q.xbgr.xq64.qnpn13g2[is]
print @r.xbgr.xq64.rsub[i]
print @c.xbgr.xq64.csub[i]
print @q.xbgr.xq65.qnpn13g2[ic]
print @q.xbgr.xq65.qnpn13g2[ib]
print @q.xbgr.xq65.qnpn13g2[ie]
print @q.xbgr.xq65.qnpn13g2[is]
print @r.xbgr.xq65.rsub[i]
print @c.xbgr.xq65.csub[i]
print @q.xbgr.xq66.qnpn13g2[ic]
print @q.xbgr.xq66.qnpn13g2[ib]
print @q.xbgr.xq66.qnpn13g2[ie]
print @q.xbgr.xq66.qnpn13g2[is]
print @r.xbgr.xq66.rsub[i]
print @c.xbgr.xq66.csub[i]
print @q.xbgr.xq67.qnpn13g2[ic]
print @q.xbgr.xq67.qnpn13g2[ib]
print @q.xbgr.xq67.qnpn13g2[ie]
print @q.xbgr.xq67.qnpn13g2[is]
print @r.xbgr.xq67.rsub[i]
print @c.xbgr.xq67.csub[i]
print @q.xbgr.xq68.qnpn13g2[ic]
print @q.xbgr.xq68.qnpn13g2[ib]
print @q.xbgr.xq68.qnpn13g2[ie]
print @q.xbgr.xq68.qnpn13g2[is]
print @r.xbgr.xq68.rsub[i]
print @c.xbgr.xq68.csub[i]
print @q.xbgr.xq69.qnpn13g2[ic]
print @q.xbgr.xq69.qnpn13g2[ib]
print @q.xbgr.xq69.qnpn13g2[ie]
print @q.xbgr.xq69.qnpn13g2[is]
print @r.xbgr.xq69.rsub[i]
print @c.xbgr.xq69.csub[i]
print @q.xbgr.xq70.qnpn13g2[ic]
print @q.xbgr.xq70.qnpn13g2[ib]
print @q.xbgr.xq70.qnpn13g2[ie]
print @q.xbgr.xq70.qnpn13g2[is]
print @r.xbgr.xq70.rsub[i]
print @c.xbgr.xq70.csub[i]
print @q.xbgr.xq71.qnpn13g2[ic]
print @q.xbgr.xq71.qnpn13g2[ib]
print @q.xbgr.xq71.qnpn13g2[ie]
print @q.xbgr.xq71.qnpn13g2[is]
print @r.xbgr.xq71.rsub[i]
print @c.xbgr.xq71.csub[i]
print @q.xbgr.xq72.qnpn13g2[ic]
print @q.xbgr.xq72.qnpn13g2[ib]
print @q.xbgr.xq72.qnpn13g2[ie]
print @q.xbgr.xq72.qnpn13g2[is]
print @r.xbgr.xq72.rsub[i]
print @c.xbgr.xq72.csub[i]
print @q.xbgr.xq73.qnpn13g2[ic]
print @q.xbgr.xq73.qnpn13g2[ib]
print @q.xbgr.xq73.qnpn13g2[ie]
print @q.xbgr.xq73.qnpn13g2[is]
print @r.xbgr.xq73.rsub[i]
print @c.xbgr.xq73.csub[i]
print @q.xbgr.xq74.qnpn13g2[ic]
print @q.xbgr.xq74.qnpn13g2[ib]
print @q.xbgr.xq74.qnpn13g2[ie]
print @q.xbgr.xq74.qnpn13g2[is]
print @r.xbgr.xq74.rsub[i]
print @c.xbgr.xq74.csub[i]
print @q.xbgr.xq75.qnpn13g2[ic]
print @q.xbgr.xq75.qnpn13g2[ib]
print @q.xbgr.xq75.qnpn13g2[ie]
print @q.xbgr.xq75.qnpn13g2[is]
print @r.xbgr.xq75.rsub[i]
print @c.xbgr.xq75.csub[i]
print @q.xbgr.xq76.qnpn13g2[ic]
print @q.xbgr.xq76.qnpn13g2[ib]
print @q.xbgr.xq76.qnpn13g2[ie]
print @q.xbgr.xq76.qnpn13g2[is]
print @r.xbgr.xq76.rsub[i]
print @c.xbgr.xq76.csub[i]
print @n.xbgr.xr77.nr1[ibody]
print @n.xbgr.xr78.nr1[ibody]
print @n.xbgr.xr79.nr1[ibody]
print @n.xbgr.xr80.nr1[ibody]
print @n.xbgr.xr81.nr1[ibody]
print @n.xbgr.xr82.nr1[ibody]
print @n.xbgr.xr83.nr1[ibody]
print @n.xbgr.xr84.nr1[ibody]
print @n.xbgr.xr85.nr1[ibody]
print @n.xbgr.xr86.nr1[ibody]
print @n.xbgr.xr16_u2.nr1[ibody]
print @n.xbgr.xr16_u3.nr1[ibody]
print @n.xbgr.xr16_u4.nr1[ibody]
print @n.xbgr.xr16_u5.nr1[ibody]
print @n.xbgr.xr16_u6.nr1[ibody]
print @n.xbgr.xr16_u7.nr1[ibody]
print @n.xbgr.xr16_u8.nr1[ibody]
print @n.xbgr.xr16_u9.nr1[ibody]
print @n.xbgr.xr16_u10.nr1[ibody]
print @n.xbgr.xr16_u11.nr1[ibody]
print @n.xbgr.xr16_u12.nr1[ibody]
print @n.xbgr.xr16_u13.nr1[ibody]
print @n.xbgr.xr16_u14.nr1[ibody]
print @n.xbgr.xr16_u15.nr1[ibody]
print @n.xbgr.xr16_u16.nr1[ibody]
print @n.xbgr.xr16_u17.nr1[ibody]
print @n.xbgr.xr16_u18.nr1[ibody]
print @n.xbgr.xr16_u19.nr1[ibody]
print @n.xbgr.xr16_u20.nr1[ibody]
print @n.xbgr.xr16_u21.nr1[ibody]
print @n.xbgr.xr16_u22.nr1[ibody]
print @n.xbgr.xr16_u23.nr1[ibody]
print @n.xbgr.xr16_u24.nr1[ibody]
print @n.xbgr.xr17_u2.nr1[ibody]
print @n.xbgr.xr17_u3.nr1[ibody]
print @n.xbgr.xr17_u4.nr1[ibody]
print @n.xbgr.xr18_u2.nr1[ibody]
print @n.xbgr.xr18_u3.nr1[ibody]
print @n.xbgr.xr18_u4.nr1[ibody]
print @n.xbgr.xr19_u2.nr1[ibody]
print @n.xbgr.xr19_u3.nr1[ibody]
print @n.xbgr.xr19_u4.nr1[ibody]
print @n.xbgr.xr20_u2.nr1[ibody]
print @n.xbgr.xr20_u3.nr1[ibody]
print @n.xbgr.xr20_u4.nr1[ibody]
print @n.xbgr.xr21_u2.nr1[ibody]
print @n.xbgr.xr21_u3.nr1[ibody]
print @n.xbgr.xr21_u4.nr1[ibody]
print @n.xbgr.xr22_u2.nr1[ibody]
print @n.xbgr.xr22_u3.nr1[ibody]
print @n.xbgr.xr22_u4.nr1[ibody]
print @n.xbgr.xr23_u2.nr1[ibody]
print @n.xbgr.xr23_u3.nr1[ibody]
print @n.xbgr.xr23_u4.nr1[ibody]
print @n.xbgr.xr23_u5.nr1[ibody]
print @n.xbgr.xr23_u6.nr1[ibody]
print @n.xbgr.xr23_u7.nr1[ibody]
print @n.xbgr.xr23_u8.nr1[ibody]
print @n.xbgr.xr23_u9.nr1[ibody]
print @n.xbgr.xr23_u10.nr1[ibody]
print @n.xbgr.xr23_u11.nr1[ibody]
print @n.xbgr.xr23_u12.nr1[ibody]
print @n.xbgr.xr23_u13.nr1[ibody]
print @n.xbgr.xr23_u14.nr1[ibody]
print @n.xbgr.xr23_u15.nr1[ibody]
print @n.xbgr.xr23_u16.nr1[ibody]
print @n.xbgr.xr23_u17.nr1[ibody]
print @n.xbgr.xr23_u18.nr1[ibody]
print @n.xbgr.xr23_u19.nr1[ibody]
print @n.xbgr.xr23_u20.nr1[ibody]
print @n.xbgr.xr23_u21.nr1[ibody]
print @n.xbgr.xr23_u22.nr1[ibody]
print @n.xbgr.xr23_u23.nr1[ibody]
print @n.xbgr.xr23_u24.nr1[ibody]
print @n.xbgr.xr24_u2.nr1[ibody]
print @n.xbgr.xr24_u3.nr1[ibody]
print @n.xbgr.xr24_u4.nr1[ibody]
print @n.xbgr.xr24_u5.nr1[ibody]
print @n.xbgr.xr24_u6.nr1[ibody]
print @n.xbgr.xr24_u7.nr1[ibody]
print @n.xbgr.xr24_u8.nr1[ibody]
print @n.xbgr.xr24_u9.nr1[ibody]
print @n.xbgr.xr24_u10.nr1[ibody]
print @n.xbgr.xr24_u11.nr1[ibody]
print @n.xbgr.xr24_u12.nr1[ibody]
print @n.xbgr.xr24_u13.nr1[ibody]
print @n.xbgr.xr24_u14.nr1[ibody]
print @n.xbgr.xr24_u15.nr1[ibody]
print @n.xbgr.xr24_u16.nr1[ibody]
print @n.xbgr.xr24_u17.nr1[ibody]
print @n.xbgr.xr24_u18.nr1[ibody]
print @n.xbgr.xr24_u19.nr1[ibody]
print @n.xbgr.xr24_u20.nr1[ibody]
print @n.xbgr.xr24_u21.nr1[ibody]
print @n.xbgr.xr24_u22.nr1[ibody]
print @n.xbgr.xr24_u23.nr1[ibody]
print @n.xbgr.xr24_u24.nr1[ibody]
print @n.xbgr.xr25_u2.nr1[ibody]
print @n.xbgr.xr25_u3.nr1[ibody]
print @n.xbgr.xr25_u4.nr1[ibody]
print @n.xbgr.xr25_u5.nr1[ibody]
print @n.xbgr.xr25_u6.nr1[ibody]
print @n.xbgr.xr25_u7.nr1[ibody]
print @n.xbgr.xr25_u8.nr1[ibody]
print @n.xbgr.xr25_u9.nr1[ibody]
print @n.xbgr.xr25_u10.nr1[ibody]
print @n.xbgr.xr25_u11.nr1[ibody]
print @n.xbgr.xr25_u12.nr1[ibody]
print @n.xbgr.xr25_u13.nr1[ibody]
print @n.xbgr.xr25_u14.nr1[ibody]
print @n.xbgr.xr25_u15.nr1[ibody]
print @n.xbgr.xr25_u16.nr1[ibody]
print @n.xbgr.xr25_u17.nr1[ibody]
print @n.xbgr.xr25_u18.nr1[ibody]
print @n.xbgr.xr25_u19.nr1[ibody]
print @n.xbgr.xr25_u20.nr1[ibody]
print @n.xbgr.xr25_u21.nr1[ibody]
print @n.xbgr.xr25_u22.nr1[ibody]
print @n.xbgr.xr25_u23.nr1[ibody]
print @n.xbgr.xr25_u24.nr1[ibody]
print @n.xbgr.xr26_u2.nr1[ibody]
print @n.xbgr.xr26_u3.nr1[ibody]
print @n.xbgr.xr26_u4.nr1[ibody]
print @n.xbgr.xr26_u5.nr1[ibody]
print @n.xbgr.xr26_u6.nr1[ibody]
print @n.xbgr.xr26_u7.nr1[ibody]
print @n.xbgr.xr26_u8.nr1[ibody]
print @n.xbgr.xr26_u9.nr1[ibody]
print @n.xbgr.xr26_u10.nr1[ibody]
print @n.xbgr.xr26_u11.nr1[ibody]
print @n.xbgr.xr26_u12.nr1[ibody]
print @n.xbgr.xr26_u13.nr1[ibody]
print @n.xbgr.xr26_u14.nr1[ibody]
print @n.xbgr.xr26_u15.nr1[ibody]
print @n.xbgr.xr26_u16.nr1[ibody]
print @n.xbgr.xr26_u17.nr1[ibody]
print @n.xbgr.xr26_u18.nr1[ibody]
print @n.xbgr.xr26_u19.nr1[ibody]
print @n.xbgr.xr26_u20.nr1[ibody]
print @n.xbgr.xr26_u21.nr1[ibody]
print @n.xbgr.xr26_u22.nr1[ibody]
print @n.xbgr.xr26_u23.nr1[ibody]
print @n.xbgr.xr26_u24.nr1[ibody]
print @n.xbgr.xm34_u2.nsg13_hv_nmos[ide]
print @n.xbgr.xm34_u2.nsg13_hv_nmos[ige]
print @n.xbgr.xm34_u2.nsg13_hv_nmos[ise]
print @n.xbgr.xm34_u2.nsg13_hv_nmos[ibe]
print @n.xbgr.xm34_u2.nsg13_hv_nmos[ctype]
print @n.xbgr.xm34_u3.nsg13_hv_nmos[ide]
print @n.xbgr.xm34_u3.nsg13_hv_nmos[ige]
print @n.xbgr.xm34_u3.nsg13_hv_nmos[ise]
print @n.xbgr.xm34_u3.nsg13_hv_nmos[ibe]
print @n.xbgr.xm34_u3.nsg13_hv_nmos[ctype]
print @n.xbgr.xm34_u4.nsg13_hv_nmos[ide]
print @n.xbgr.xm34_u4.nsg13_hv_nmos[ige]
print @n.xbgr.xm34_u4.nsg13_hv_nmos[ise]
print @n.xbgr.xm34_u4.nsg13_hv_nmos[ibe]
print @n.xbgr.xm34_u4.nsg13_hv_nmos[ctype]
print @n.xbgr.xm34_u5.nsg13_hv_nmos[ide]
print @n.xbgr.xm34_u5.nsg13_hv_nmos[ige]
print @n.xbgr.xm34_u5.nsg13_hv_nmos[ise]
print @n.xbgr.xm34_u5.nsg13_hv_nmos[ibe]
print @n.xbgr.xm34_u5.nsg13_hv_nmos[ctype]
print @n.xbgr.xm34_u6.nsg13_hv_nmos[ide]
print @n.xbgr.xm34_u6.nsg13_hv_nmos[ige]
print @n.xbgr.xm34_u6.nsg13_hv_nmos[ise]
print @n.xbgr.xm34_u6.nsg13_hv_nmos[ibe]
print @n.xbgr.xm34_u6.nsg13_hv_nmos[ctype]
print @n.xbgr.xm34_u7.nsg13_hv_nmos[ide]
print @n.xbgr.xm34_u7.nsg13_hv_nmos[ige]
print @n.xbgr.xm34_u7.nsg13_hv_nmos[ise]
print @n.xbgr.xm34_u7.nsg13_hv_nmos[ibe]
print @n.xbgr.xm34_u7.nsg13_hv_nmos[ctype]
print @n.xbgr.xm34_u8.nsg13_hv_nmos[ide]
print @n.xbgr.xm34_u8.nsg13_hv_nmos[ige]
print @n.xbgr.xm34_u8.nsg13_hv_nmos[ise]
print @n.xbgr.xm34_u8.nsg13_hv_nmos[ibe]
print @n.xbgr.xm34_u8.nsg13_hv_nmos[ctype]
print @n.xbgr.xm34_u9.nsg13_hv_nmos[ide]
print @n.xbgr.xm34_u9.nsg13_hv_nmos[ige]
print @n.xbgr.xm34_u9.nsg13_hv_nmos[ise]
print @n.xbgr.xm34_u9.nsg13_hv_nmos[ibe]
print @n.xbgr.xm34_u9.nsg13_hv_nmos[ctype]
print @n.xbgr.xm34_u10.nsg13_hv_nmos[ide]
print @n.xbgr.xm34_u10.nsg13_hv_nmos[ige]
print @n.xbgr.xm34_u10.nsg13_hv_nmos[ise]
print @n.xbgr.xm34_u10.nsg13_hv_nmos[ibe]
print @n.xbgr.xm34_u10.nsg13_hv_nmos[ctype]
print @n.xbgr.xm34_u11.nsg13_hv_nmos[ide]
print @n.xbgr.xm34_u11.nsg13_hv_nmos[ige]
print @n.xbgr.xm34_u11.nsg13_hv_nmos[ise]
print @n.xbgr.xm34_u11.nsg13_hv_nmos[ibe]
print @n.xbgr.xm34_u11.nsg13_hv_nmos[ctype]
print @n.xbgr.xm34_u12.nsg13_hv_nmos[ide]
print @n.xbgr.xm34_u12.nsg13_hv_nmos[ige]
print @n.xbgr.xm34_u12.nsg13_hv_nmos[ise]
print @n.xbgr.xm34_u12.nsg13_hv_nmos[ibe]
print @n.xbgr.xm34_u12.nsg13_hv_nmos[ctype]
print @n.xbgr.xm34_u13.nsg13_hv_nmos[ide]
print @n.xbgr.xm34_u13.nsg13_hv_nmos[ige]
print @n.xbgr.xm34_u13.nsg13_hv_nmos[ise]
print @n.xbgr.xm34_u13.nsg13_hv_nmos[ibe]
print @n.xbgr.xm34_u13.nsg13_hv_nmos[ctype]
print @n.xbgr.xm34_u14.nsg13_hv_nmos[ide]
print @n.xbgr.xm34_u14.nsg13_hv_nmos[ige]
print @n.xbgr.xm34_u14.nsg13_hv_nmos[ise]
print @n.xbgr.xm34_u14.nsg13_hv_nmos[ibe]
print @n.xbgr.xm34_u14.nsg13_hv_nmos[ctype]
print @n.xbgr.xm34_u15.nsg13_hv_nmos[ide]
print @n.xbgr.xm34_u15.nsg13_hv_nmos[ige]
print @n.xbgr.xm34_u15.nsg13_hv_nmos[ise]
print @n.xbgr.xm34_u15.nsg13_hv_nmos[ibe]
print @n.xbgr.xm34_u15.nsg13_hv_nmos[ctype]
print @n.xbgr.xm34_u16.nsg13_hv_nmos[ide]
print @n.xbgr.xm34_u16.nsg13_hv_nmos[ige]
print @n.xbgr.xm34_u16.nsg13_hv_nmos[ise]
print @n.xbgr.xm34_u16.nsg13_hv_nmos[ibe]
print @n.xbgr.xm34_u16.nsg13_hv_nmos[ctype]
print @n.xbgr.xm34_u17.nsg13_hv_nmos[ide]
print @n.xbgr.xm34_u17.nsg13_hv_nmos[ige]
print @n.xbgr.xm34_u17.nsg13_hv_nmos[ise]
print @n.xbgr.xm34_u17.nsg13_hv_nmos[ibe]
print @n.xbgr.xm34_u17.nsg13_hv_nmos[ctype]
print @n.xbgr.xm34_u18.nsg13_hv_nmos[ide]
print @n.xbgr.xm34_u18.nsg13_hv_nmos[ige]
print @n.xbgr.xm34_u18.nsg13_hv_nmos[ise]
print @n.xbgr.xm34_u18.nsg13_hv_nmos[ibe]
print @n.xbgr.xm34_u18.nsg13_hv_nmos[ctype]
print @n.xbgr.xm34_u19.nsg13_hv_nmos[ide]
print @n.xbgr.xm34_u19.nsg13_hv_nmos[ige]
print @n.xbgr.xm34_u19.nsg13_hv_nmos[ise]
print @n.xbgr.xm34_u19.nsg13_hv_nmos[ibe]
print @n.xbgr.xm34_u19.nsg13_hv_nmos[ctype]
print @n.xbgr.xm34_u20.nsg13_hv_nmos[ide]
print @n.xbgr.xm34_u20.nsg13_hv_nmos[ige]
print @n.xbgr.xm34_u20.nsg13_hv_nmos[ise]
print @n.xbgr.xm34_u20.nsg13_hv_nmos[ibe]
print @n.xbgr.xm34_u20.nsg13_hv_nmos[ctype]
print @n.xbgr.xm34_u21.nsg13_hv_nmos[ide]
print @n.xbgr.xm34_u21.nsg13_hv_nmos[ige]
print @n.xbgr.xm34_u21.nsg13_hv_nmos[ise]
print @n.xbgr.xm34_u21.nsg13_hv_nmos[ibe]
print @n.xbgr.xm34_u21.nsg13_hv_nmos[ctype]
print @n.xbgr.xm34_u22.nsg13_hv_nmos[ide]
print @n.xbgr.xm34_u22.nsg13_hv_nmos[ige]
print @n.xbgr.xm34_u22.nsg13_hv_nmos[ise]
print @n.xbgr.xm34_u22.nsg13_hv_nmos[ibe]
print @n.xbgr.xm34_u22.nsg13_hv_nmos[ctype]
print @n.xbgr.xm34_u23.nsg13_hv_nmos[ide]
print @n.xbgr.xm34_u23.nsg13_hv_nmos[ige]
print @n.xbgr.xm34_u23.nsg13_hv_nmos[ise]
print @n.xbgr.xm34_u23.nsg13_hv_nmos[ibe]
print @n.xbgr.xm34_u23.nsg13_hv_nmos[ctype]
print @n.xbgr.xm34_u24.nsg13_hv_nmos[ide]
print @n.xbgr.xm34_u24.nsg13_hv_nmos[ige]
print @n.xbgr.xm34_u24.nsg13_hv_nmos[ise]
print @n.xbgr.xm34_u24.nsg13_hv_nmos[ibe]
print @n.xbgr.xm34_u24.nsg13_hv_nmos[ctype]
print @n.xbgr.xm35_u2.nsg13_hv_nmos[ide]
print @n.xbgr.xm35_u2.nsg13_hv_nmos[ige]
print @n.xbgr.xm35_u2.nsg13_hv_nmos[ise]
print @n.xbgr.xm35_u2.nsg13_hv_nmos[ibe]
print @n.xbgr.xm35_u2.nsg13_hv_nmos[ctype]
print @n.xbgr.xm35_u3.nsg13_hv_nmos[ide]
print @n.xbgr.xm35_u3.nsg13_hv_nmos[ige]
print @n.xbgr.xm35_u3.nsg13_hv_nmos[ise]
print @n.xbgr.xm35_u3.nsg13_hv_nmos[ibe]
print @n.xbgr.xm35_u3.nsg13_hv_nmos[ctype]
print @n.xbgr.xm35_u4.nsg13_hv_nmos[ide]
print @n.xbgr.xm35_u4.nsg13_hv_nmos[ige]
print @n.xbgr.xm35_u4.nsg13_hv_nmos[ise]
print @n.xbgr.xm35_u4.nsg13_hv_nmos[ibe]
print @n.xbgr.xm35_u4.nsg13_hv_nmos[ctype]
print @n.xbgr.xm35_u5.nsg13_hv_nmos[ide]
print @n.xbgr.xm35_u5.nsg13_hv_nmos[ige]
print @n.xbgr.xm35_u5.nsg13_hv_nmos[ise]
print @n.xbgr.xm35_u5.nsg13_hv_nmos[ibe]
print @n.xbgr.xm35_u5.nsg13_hv_nmos[ctype]
print @n.xbgr.xm35_u6.nsg13_hv_nmos[ide]
print @n.xbgr.xm35_u6.nsg13_hv_nmos[ige]
print @n.xbgr.xm35_u6.nsg13_hv_nmos[ise]
print @n.xbgr.xm35_u6.nsg13_hv_nmos[ibe]
print @n.xbgr.xm35_u6.nsg13_hv_nmos[ctype]
print @n.xbgr.xm35_u7.nsg13_hv_nmos[ide]
print @n.xbgr.xm35_u7.nsg13_hv_nmos[ige]
print @n.xbgr.xm35_u7.nsg13_hv_nmos[ise]
print @n.xbgr.xm35_u7.nsg13_hv_nmos[ibe]
print @n.xbgr.xm35_u7.nsg13_hv_nmos[ctype]
print @n.xbgr.xm35_u8.nsg13_hv_nmos[ide]
print @n.xbgr.xm35_u8.nsg13_hv_nmos[ige]
print @n.xbgr.xm35_u8.nsg13_hv_nmos[ise]
print @n.xbgr.xm35_u8.nsg13_hv_nmos[ibe]
print @n.xbgr.xm35_u8.nsg13_hv_nmos[ctype]
print @n.xbgr.xm35_u9.nsg13_hv_nmos[ide]
print @n.xbgr.xm35_u9.nsg13_hv_nmos[ige]
print @n.xbgr.xm35_u9.nsg13_hv_nmos[ise]
print @n.xbgr.xm35_u9.nsg13_hv_nmos[ibe]
print @n.xbgr.xm35_u9.nsg13_hv_nmos[ctype]
print @n.xbgr.xm35_u10.nsg13_hv_nmos[ide]
print @n.xbgr.xm35_u10.nsg13_hv_nmos[ige]
print @n.xbgr.xm35_u10.nsg13_hv_nmos[ise]
print @n.xbgr.xm35_u10.nsg13_hv_nmos[ibe]
print @n.xbgr.xm35_u10.nsg13_hv_nmos[ctype]
print @n.xbgr.xm35_u11.nsg13_hv_nmos[ide]
print @n.xbgr.xm35_u11.nsg13_hv_nmos[ige]
print @n.xbgr.xm35_u11.nsg13_hv_nmos[ise]
print @n.xbgr.xm35_u11.nsg13_hv_nmos[ibe]
print @n.xbgr.xm35_u11.nsg13_hv_nmos[ctype]
print @n.xbgr.xm35_u12.nsg13_hv_nmos[ide]
print @n.xbgr.xm35_u12.nsg13_hv_nmos[ige]
print @n.xbgr.xm35_u12.nsg13_hv_nmos[ise]
print @n.xbgr.xm35_u12.nsg13_hv_nmos[ibe]
print @n.xbgr.xm35_u12.nsg13_hv_nmos[ctype]
print @n.xbgr.xm35_u13.nsg13_hv_nmos[ide]
print @n.xbgr.xm35_u13.nsg13_hv_nmos[ige]
print @n.xbgr.xm35_u13.nsg13_hv_nmos[ise]
print @n.xbgr.xm35_u13.nsg13_hv_nmos[ibe]
print @n.xbgr.xm35_u13.nsg13_hv_nmos[ctype]
print @n.xbgr.xm35_u14.nsg13_hv_nmos[ide]
print @n.xbgr.xm35_u14.nsg13_hv_nmos[ige]
print @n.xbgr.xm35_u14.nsg13_hv_nmos[ise]
print @n.xbgr.xm35_u14.nsg13_hv_nmos[ibe]
print @n.xbgr.xm35_u14.nsg13_hv_nmos[ctype]
print @n.xbgr.xm35_u15.nsg13_hv_nmos[ide]
print @n.xbgr.xm35_u15.nsg13_hv_nmos[ige]
print @n.xbgr.xm35_u15.nsg13_hv_nmos[ise]
print @n.xbgr.xm35_u15.nsg13_hv_nmos[ibe]
print @n.xbgr.xm35_u15.nsg13_hv_nmos[ctype]
print @n.xbgr.xm35_u16.nsg13_hv_nmos[ide]
print @n.xbgr.xm35_u16.nsg13_hv_nmos[ige]
print @n.xbgr.xm35_u16.nsg13_hv_nmos[ise]
print @n.xbgr.xm35_u16.nsg13_hv_nmos[ibe]
print @n.xbgr.xm35_u16.nsg13_hv_nmos[ctype]
print @n.xbgr.xm35_u17.nsg13_hv_nmos[ide]
print @n.xbgr.xm35_u17.nsg13_hv_nmos[ige]
print @n.xbgr.xm35_u17.nsg13_hv_nmos[ise]
print @n.xbgr.xm35_u17.nsg13_hv_nmos[ibe]
print @n.xbgr.xm35_u17.nsg13_hv_nmos[ctype]
print @n.xbgr.xm35_u18.nsg13_hv_nmos[ide]
print @n.xbgr.xm35_u18.nsg13_hv_nmos[ige]
print @n.xbgr.xm35_u18.nsg13_hv_nmos[ise]
print @n.xbgr.xm35_u18.nsg13_hv_nmos[ibe]
print @n.xbgr.xm35_u18.nsg13_hv_nmos[ctype]
print @n.xbgr.xm35_u19.nsg13_hv_nmos[ide]
print @n.xbgr.xm35_u19.nsg13_hv_nmos[ige]
print @n.xbgr.xm35_u19.nsg13_hv_nmos[ise]
print @n.xbgr.xm35_u19.nsg13_hv_nmos[ibe]
print @n.xbgr.xm35_u19.nsg13_hv_nmos[ctype]
print @n.xbgr.xm35_u20.nsg13_hv_nmos[ide]
print @n.xbgr.xm35_u20.nsg13_hv_nmos[ige]
print @n.xbgr.xm35_u20.nsg13_hv_nmos[ise]
print @n.xbgr.xm35_u20.nsg13_hv_nmos[ibe]
print @n.xbgr.xm35_u20.nsg13_hv_nmos[ctype]
print @n.xbgr.xm35_u21.nsg13_hv_nmos[ide]
print @n.xbgr.xm35_u21.nsg13_hv_nmos[ige]
print @n.xbgr.xm35_u21.nsg13_hv_nmos[ise]
print @n.xbgr.xm35_u21.nsg13_hv_nmos[ibe]
print @n.xbgr.xm35_u21.nsg13_hv_nmos[ctype]
print @n.xbgr.xm35_u22.nsg13_hv_nmos[ide]
print @n.xbgr.xm35_u22.nsg13_hv_nmos[ige]
print @n.xbgr.xm35_u22.nsg13_hv_nmos[ise]
print @n.xbgr.xm35_u22.nsg13_hv_nmos[ibe]
print @n.xbgr.xm35_u22.nsg13_hv_nmos[ctype]
print @n.xbgr.xm35_u23.nsg13_hv_nmos[ide]
print @n.xbgr.xm35_u23.nsg13_hv_nmos[ige]
print @n.xbgr.xm35_u23.nsg13_hv_nmos[ise]
print @n.xbgr.xm35_u23.nsg13_hv_nmos[ibe]
print @n.xbgr.xm35_u23.nsg13_hv_nmos[ctype]
print @n.xbgr.xm35_u24.nsg13_hv_nmos[ide]
print @n.xbgr.xm35_u24.nsg13_hv_nmos[ige]
print @n.xbgr.xm35_u24.nsg13_hv_nmos[ise]
print @n.xbgr.xm35_u24.nsg13_hv_nmos[ibe]
print @n.xbgr.xm35_u24.nsg13_hv_nmos[ctype]
print @n.xbgr.xm36_u2.nsg13_hv_nmos[ide]
print @n.xbgr.xm36_u2.nsg13_hv_nmos[ige]
print @n.xbgr.xm36_u2.nsg13_hv_nmos[ise]
print @n.xbgr.xm36_u2.nsg13_hv_nmos[ibe]
print @n.xbgr.xm36_u2.nsg13_hv_nmos[ctype]
print @n.xbgr.xm36_u3.nsg13_hv_nmos[ide]
print @n.xbgr.xm36_u3.nsg13_hv_nmos[ige]
print @n.xbgr.xm36_u3.nsg13_hv_nmos[ise]
print @n.xbgr.xm36_u3.nsg13_hv_nmos[ibe]
print @n.xbgr.xm36_u3.nsg13_hv_nmos[ctype]
print @n.xbgr.xm36_u4.nsg13_hv_nmos[ide]
print @n.xbgr.xm36_u4.nsg13_hv_nmos[ige]
print @n.xbgr.xm36_u4.nsg13_hv_nmos[ise]
print @n.xbgr.xm36_u4.nsg13_hv_nmos[ibe]
print @n.xbgr.xm36_u4.nsg13_hv_nmos[ctype]
print @n.xbgr.xm36_u5.nsg13_hv_nmos[ide]
print @n.xbgr.xm36_u5.nsg13_hv_nmos[ige]
print @n.xbgr.xm36_u5.nsg13_hv_nmos[ise]
print @n.xbgr.xm36_u5.nsg13_hv_nmos[ibe]
print @n.xbgr.xm36_u5.nsg13_hv_nmos[ctype]
print @n.xbgr.xm36_u6.nsg13_hv_nmos[ide]
print @n.xbgr.xm36_u6.nsg13_hv_nmos[ige]
print @n.xbgr.xm36_u6.nsg13_hv_nmos[ise]
print @n.xbgr.xm36_u6.nsg13_hv_nmos[ibe]
print @n.xbgr.xm36_u6.nsg13_hv_nmos[ctype]
print @n.xbgr.xm36_u7.nsg13_hv_nmos[ide]
print @n.xbgr.xm36_u7.nsg13_hv_nmos[ige]
print @n.xbgr.xm36_u7.nsg13_hv_nmos[ise]
print @n.xbgr.xm36_u7.nsg13_hv_nmos[ibe]
print @n.xbgr.xm36_u7.nsg13_hv_nmos[ctype]
print @n.xbgr.xm36_u8.nsg13_hv_nmos[ide]
print @n.xbgr.xm36_u8.nsg13_hv_nmos[ige]
print @n.xbgr.xm36_u8.nsg13_hv_nmos[ise]
print @n.xbgr.xm36_u8.nsg13_hv_nmos[ibe]
print @n.xbgr.xm36_u8.nsg13_hv_nmos[ctype]
print @n.xbgr.xm36_u9.nsg13_hv_nmos[ide]
print @n.xbgr.xm36_u9.nsg13_hv_nmos[ige]
print @n.xbgr.xm36_u9.nsg13_hv_nmos[ise]
print @n.xbgr.xm36_u9.nsg13_hv_nmos[ibe]
print @n.xbgr.xm36_u9.nsg13_hv_nmos[ctype]
print @n.xbgr.xm36_u10.nsg13_hv_nmos[ide]
print @n.xbgr.xm36_u10.nsg13_hv_nmos[ige]
print @n.xbgr.xm36_u10.nsg13_hv_nmos[ise]
print @n.xbgr.xm36_u10.nsg13_hv_nmos[ibe]
print @n.xbgr.xm36_u10.nsg13_hv_nmos[ctype]
print @n.xbgr.xm36_u11.nsg13_hv_nmos[ide]
print @n.xbgr.xm36_u11.nsg13_hv_nmos[ige]
print @n.xbgr.xm36_u11.nsg13_hv_nmos[ise]
print @n.xbgr.xm36_u11.nsg13_hv_nmos[ibe]
print @n.xbgr.xm36_u11.nsg13_hv_nmos[ctype]
print @n.xbgr.xm36_u12.nsg13_hv_nmos[ide]
print @n.xbgr.xm36_u12.nsg13_hv_nmos[ige]
print @n.xbgr.xm36_u12.nsg13_hv_nmos[ise]
print @n.xbgr.xm36_u12.nsg13_hv_nmos[ibe]
print @n.xbgr.xm36_u12.nsg13_hv_nmos[ctype]
print @n.xbgr.xm36_u13.nsg13_hv_nmos[ide]
print @n.xbgr.xm36_u13.nsg13_hv_nmos[ige]
print @n.xbgr.xm36_u13.nsg13_hv_nmos[ise]
print @n.xbgr.xm36_u13.nsg13_hv_nmos[ibe]
print @n.xbgr.xm36_u13.nsg13_hv_nmos[ctype]
print @n.xbgr.xm36_u14.nsg13_hv_nmos[ide]
print @n.xbgr.xm36_u14.nsg13_hv_nmos[ige]
print @n.xbgr.xm36_u14.nsg13_hv_nmos[ise]
print @n.xbgr.xm36_u14.nsg13_hv_nmos[ibe]
print @n.xbgr.xm36_u14.nsg13_hv_nmos[ctype]
print @n.xbgr.xm36_u15.nsg13_hv_nmos[ide]
print @n.xbgr.xm36_u15.nsg13_hv_nmos[ige]
print @n.xbgr.xm36_u15.nsg13_hv_nmos[ise]
print @n.xbgr.xm36_u15.nsg13_hv_nmos[ibe]
print @n.xbgr.xm36_u15.nsg13_hv_nmos[ctype]
print @n.xbgr.xm36_u16.nsg13_hv_nmos[ide]
print @n.xbgr.xm36_u16.nsg13_hv_nmos[ige]
print @n.xbgr.xm36_u16.nsg13_hv_nmos[ise]
print @n.xbgr.xm36_u16.nsg13_hv_nmos[ibe]
print @n.xbgr.xm36_u16.nsg13_hv_nmos[ctype]
print @n.xbgr.xm36_u17.nsg13_hv_nmos[ide]
print @n.xbgr.xm36_u17.nsg13_hv_nmos[ige]
print @n.xbgr.xm36_u17.nsg13_hv_nmos[ise]
print @n.xbgr.xm36_u17.nsg13_hv_nmos[ibe]
print @n.xbgr.xm36_u17.nsg13_hv_nmos[ctype]
print @n.xbgr.xm36_u18.nsg13_hv_nmos[ide]
print @n.xbgr.xm36_u18.nsg13_hv_nmos[ige]
print @n.xbgr.xm36_u18.nsg13_hv_nmos[ise]
print @n.xbgr.xm36_u18.nsg13_hv_nmos[ibe]
print @n.xbgr.xm36_u18.nsg13_hv_nmos[ctype]
print @n.xbgr.xm36_u19.nsg13_hv_nmos[ide]
print @n.xbgr.xm36_u19.nsg13_hv_nmos[ige]
print @n.xbgr.xm36_u19.nsg13_hv_nmos[ise]
print @n.xbgr.xm36_u19.nsg13_hv_nmos[ibe]
print @n.xbgr.xm36_u19.nsg13_hv_nmos[ctype]
print @n.xbgr.xm36_u20.nsg13_hv_nmos[ide]
print @n.xbgr.xm36_u20.nsg13_hv_nmos[ige]
print @n.xbgr.xm36_u20.nsg13_hv_nmos[ise]
print @n.xbgr.xm36_u20.nsg13_hv_nmos[ibe]
print @n.xbgr.xm36_u20.nsg13_hv_nmos[ctype]
print @n.xbgr.xm36_u21.nsg13_hv_nmos[ide]
print @n.xbgr.xm36_u21.nsg13_hv_nmos[ige]
print @n.xbgr.xm36_u21.nsg13_hv_nmos[ise]
print @n.xbgr.xm36_u21.nsg13_hv_nmos[ibe]
print @n.xbgr.xm36_u21.nsg13_hv_nmos[ctype]
print @n.xbgr.xm36_u22.nsg13_hv_nmos[ide]
print @n.xbgr.xm36_u22.nsg13_hv_nmos[ige]
print @n.xbgr.xm36_u22.nsg13_hv_nmos[ise]
print @n.xbgr.xm36_u22.nsg13_hv_nmos[ibe]
print @n.xbgr.xm36_u22.nsg13_hv_nmos[ctype]
print @n.xbgr.xm36_u23.nsg13_hv_nmos[ide]
print @n.xbgr.xm36_u23.nsg13_hv_nmos[ige]
print @n.xbgr.xm36_u23.nsg13_hv_nmos[ise]
print @n.xbgr.xm36_u23.nsg13_hv_nmos[ibe]
print @n.xbgr.xm36_u23.nsg13_hv_nmos[ctype]
print @n.xbgr.xm36_u24.nsg13_hv_nmos[ide]
print @n.xbgr.xm36_u24.nsg13_hv_nmos[ige]
print @n.xbgr.xm36_u24.nsg13_hv_nmos[ise]
print @n.xbgr.xm36_u24.nsg13_hv_nmos[ibe]
print @n.xbgr.xm36_u24.nsg13_hv_nmos[ctype]
print @n.xbgr.xm37_u2.nsg13_hv_nmos[ide]
print @n.xbgr.xm37_u2.nsg13_hv_nmos[ige]
print @n.xbgr.xm37_u2.nsg13_hv_nmos[ise]
print @n.xbgr.xm37_u2.nsg13_hv_nmos[ibe]
print @n.xbgr.xm37_u2.nsg13_hv_nmos[ctype]
print @n.xbgr.xm37_u3.nsg13_hv_nmos[ide]
print @n.xbgr.xm37_u3.nsg13_hv_nmos[ige]
print @n.xbgr.xm37_u3.nsg13_hv_nmos[ise]
print @n.xbgr.xm37_u3.nsg13_hv_nmos[ibe]
print @n.xbgr.xm37_u3.nsg13_hv_nmos[ctype]
print @n.xbgr.xm37_u4.nsg13_hv_nmos[ide]
print @n.xbgr.xm37_u4.nsg13_hv_nmos[ige]
print @n.xbgr.xm37_u4.nsg13_hv_nmos[ise]
print @n.xbgr.xm37_u4.nsg13_hv_nmos[ibe]
print @n.xbgr.xm37_u4.nsg13_hv_nmos[ctype]
print @n.xbgr.xm37_u5.nsg13_hv_nmos[ide]
print @n.xbgr.xm37_u5.nsg13_hv_nmos[ige]
print @n.xbgr.xm37_u5.nsg13_hv_nmos[ise]
print @n.xbgr.xm37_u5.nsg13_hv_nmos[ibe]
print @n.xbgr.xm37_u5.nsg13_hv_nmos[ctype]
print @n.xbgr.xm37_u6.nsg13_hv_nmos[ide]
print @n.xbgr.xm37_u6.nsg13_hv_nmos[ige]
print @n.xbgr.xm37_u6.nsg13_hv_nmos[ise]
print @n.xbgr.xm37_u6.nsg13_hv_nmos[ibe]
print @n.xbgr.xm37_u6.nsg13_hv_nmos[ctype]
print @n.xbgr.xm37_u7.nsg13_hv_nmos[ide]
print @n.xbgr.xm37_u7.nsg13_hv_nmos[ige]
print @n.xbgr.xm37_u7.nsg13_hv_nmos[ise]
print @n.xbgr.xm37_u7.nsg13_hv_nmos[ibe]
print @n.xbgr.xm37_u7.nsg13_hv_nmos[ctype]
print @n.xbgr.xm37_u8.nsg13_hv_nmos[ide]
print @n.xbgr.xm37_u8.nsg13_hv_nmos[ige]
print @n.xbgr.xm37_u8.nsg13_hv_nmos[ise]
print @n.xbgr.xm37_u8.nsg13_hv_nmos[ibe]
print @n.xbgr.xm37_u8.nsg13_hv_nmos[ctype]
print @n.xbgr.xm37_u9.nsg13_hv_nmos[ide]
print @n.xbgr.xm37_u9.nsg13_hv_nmos[ige]
print @n.xbgr.xm37_u9.nsg13_hv_nmos[ise]
print @n.xbgr.xm37_u9.nsg13_hv_nmos[ibe]
print @n.xbgr.xm37_u9.nsg13_hv_nmos[ctype]
print @n.xbgr.xm37_u10.nsg13_hv_nmos[ide]
print @n.xbgr.xm37_u10.nsg13_hv_nmos[ige]
print @n.xbgr.xm37_u10.nsg13_hv_nmos[ise]
print @n.xbgr.xm37_u10.nsg13_hv_nmos[ibe]
print @n.xbgr.xm37_u10.nsg13_hv_nmos[ctype]
print @n.xbgr.xm37_u11.nsg13_hv_nmos[ide]
print @n.xbgr.xm37_u11.nsg13_hv_nmos[ige]
print @n.xbgr.xm37_u11.nsg13_hv_nmos[ise]
print @n.xbgr.xm37_u11.nsg13_hv_nmos[ibe]
print @n.xbgr.xm37_u11.nsg13_hv_nmos[ctype]
print @n.xbgr.xm37_u12.nsg13_hv_nmos[ide]
print @n.xbgr.xm37_u12.nsg13_hv_nmos[ige]
print @n.xbgr.xm37_u12.nsg13_hv_nmos[ise]
print @n.xbgr.xm37_u12.nsg13_hv_nmos[ibe]
print @n.xbgr.xm37_u12.nsg13_hv_nmos[ctype]
print @n.xbgr.xm37_u13.nsg13_hv_nmos[ide]
print @n.xbgr.xm37_u13.nsg13_hv_nmos[ige]
print @n.xbgr.xm37_u13.nsg13_hv_nmos[ise]
print @n.xbgr.xm37_u13.nsg13_hv_nmos[ibe]
print @n.xbgr.xm37_u13.nsg13_hv_nmos[ctype]
print @n.xbgr.xm37_u14.nsg13_hv_nmos[ide]
print @n.xbgr.xm37_u14.nsg13_hv_nmos[ige]
print @n.xbgr.xm37_u14.nsg13_hv_nmos[ise]
print @n.xbgr.xm37_u14.nsg13_hv_nmos[ibe]
print @n.xbgr.xm37_u14.nsg13_hv_nmos[ctype]
print @n.xbgr.xm37_u15.nsg13_hv_nmos[ide]
print @n.xbgr.xm37_u15.nsg13_hv_nmos[ige]
print @n.xbgr.xm37_u15.nsg13_hv_nmos[ise]
print @n.xbgr.xm37_u15.nsg13_hv_nmos[ibe]
print @n.xbgr.xm37_u15.nsg13_hv_nmos[ctype]
print @n.xbgr.xm37_u16.nsg13_hv_nmos[ide]
print @n.xbgr.xm37_u16.nsg13_hv_nmos[ige]
print @n.xbgr.xm37_u16.nsg13_hv_nmos[ise]
print @n.xbgr.xm37_u16.nsg13_hv_nmos[ibe]
print @n.xbgr.xm37_u16.nsg13_hv_nmos[ctype]
print @n.xbgr.xm37_u17.nsg13_hv_nmos[ide]
print @n.xbgr.xm37_u17.nsg13_hv_nmos[ige]
print @n.xbgr.xm37_u17.nsg13_hv_nmos[ise]
print @n.xbgr.xm37_u17.nsg13_hv_nmos[ibe]
print @n.xbgr.xm37_u17.nsg13_hv_nmos[ctype]
print @n.xbgr.xm37_u18.nsg13_hv_nmos[ide]
print @n.xbgr.xm37_u18.nsg13_hv_nmos[ige]
print @n.xbgr.xm37_u18.nsg13_hv_nmos[ise]
print @n.xbgr.xm37_u18.nsg13_hv_nmos[ibe]
print @n.xbgr.xm37_u18.nsg13_hv_nmos[ctype]
print @n.xbgr.xm37_u19.nsg13_hv_nmos[ide]
print @n.xbgr.xm37_u19.nsg13_hv_nmos[ige]
print @n.xbgr.xm37_u19.nsg13_hv_nmos[ise]
print @n.xbgr.xm37_u19.nsg13_hv_nmos[ibe]
print @n.xbgr.xm37_u19.nsg13_hv_nmos[ctype]
print @n.xbgr.xm37_u20.nsg13_hv_nmos[ide]
print @n.xbgr.xm37_u20.nsg13_hv_nmos[ige]
print @n.xbgr.xm37_u20.nsg13_hv_nmos[ise]
print @n.xbgr.xm37_u20.nsg13_hv_nmos[ibe]
print @n.xbgr.xm37_u20.nsg13_hv_nmos[ctype]
print @n.xbgr.xm37_u21.nsg13_hv_nmos[ide]
print @n.xbgr.xm37_u21.nsg13_hv_nmos[ige]
print @n.xbgr.xm37_u21.nsg13_hv_nmos[ise]
print @n.xbgr.xm37_u21.nsg13_hv_nmos[ibe]
print @n.xbgr.xm37_u21.nsg13_hv_nmos[ctype]
print @n.xbgr.xm37_u22.nsg13_hv_nmos[ide]
print @n.xbgr.xm37_u22.nsg13_hv_nmos[ige]
print @n.xbgr.xm37_u22.nsg13_hv_nmos[ise]
print @n.xbgr.xm37_u22.nsg13_hv_nmos[ibe]
print @n.xbgr.xm37_u22.nsg13_hv_nmos[ctype]
print @n.xbgr.xm37_u23.nsg13_hv_nmos[ide]
print @n.xbgr.xm37_u23.nsg13_hv_nmos[ige]
print @n.xbgr.xm37_u23.nsg13_hv_nmos[ise]
print @n.xbgr.xm37_u23.nsg13_hv_nmos[ibe]
print @n.xbgr.xm37_u23.nsg13_hv_nmos[ctype]
print @n.xbgr.xm37_u24.nsg13_hv_nmos[ide]
print @n.xbgr.xm37_u24.nsg13_hv_nmos[ige]
print @n.xbgr.xm37_u24.nsg13_hv_nmos[ise]
print @n.xbgr.xm37_u24.nsg13_hv_nmos[ibe]
print @n.xbgr.xm37_u24.nsg13_hv_nmos[ctype]
print @n.xbgr.xm38_u2.nsg13_hv_pmos[ide]
print @n.xbgr.xm38_u2.nsg13_hv_pmos[ige]
print @n.xbgr.xm38_u2.nsg13_hv_pmos[ise]
print @n.xbgr.xm38_u2.nsg13_hv_pmos[ibe]
print @n.xbgr.xm38_u2.nsg13_hv_pmos[ctype]
print @n.xbgr.xm38_u3.nsg13_hv_pmos[ide]
print @n.xbgr.xm38_u3.nsg13_hv_pmos[ige]
print @n.xbgr.xm38_u3.nsg13_hv_pmos[ise]
print @n.xbgr.xm38_u3.nsg13_hv_pmos[ibe]
print @n.xbgr.xm38_u3.nsg13_hv_pmos[ctype]
print @n.xbgr.xm38_u4.nsg13_hv_pmos[ide]
print @n.xbgr.xm38_u4.nsg13_hv_pmos[ige]
print @n.xbgr.xm38_u4.nsg13_hv_pmos[ise]
print @n.xbgr.xm38_u4.nsg13_hv_pmos[ibe]
print @n.xbgr.xm38_u4.nsg13_hv_pmos[ctype]
print @n.xbgr.xm38_u5.nsg13_hv_pmos[ide]
print @n.xbgr.xm38_u5.nsg13_hv_pmos[ige]
print @n.xbgr.xm38_u5.nsg13_hv_pmos[ise]
print @n.xbgr.xm38_u5.nsg13_hv_pmos[ibe]
print @n.xbgr.xm38_u5.nsg13_hv_pmos[ctype]
print @n.xbgr.xm38_u6.nsg13_hv_pmos[ide]
print @n.xbgr.xm38_u6.nsg13_hv_pmos[ige]
print @n.xbgr.xm38_u6.nsg13_hv_pmos[ise]
print @n.xbgr.xm38_u6.nsg13_hv_pmos[ibe]
print @n.xbgr.xm38_u6.nsg13_hv_pmos[ctype]
print @n.xbgr.xm38_u7.nsg13_hv_pmos[ide]
print @n.xbgr.xm38_u7.nsg13_hv_pmos[ige]
print @n.xbgr.xm38_u7.nsg13_hv_pmos[ise]
print @n.xbgr.xm38_u7.nsg13_hv_pmos[ibe]
print @n.xbgr.xm38_u7.nsg13_hv_pmos[ctype]
print @n.xbgr.xm38_u8.nsg13_hv_pmos[ide]
print @n.xbgr.xm38_u8.nsg13_hv_pmos[ige]
print @n.xbgr.xm38_u8.nsg13_hv_pmos[ise]
print @n.xbgr.xm38_u8.nsg13_hv_pmos[ibe]
print @n.xbgr.xm38_u8.nsg13_hv_pmos[ctype]
print @n.xbgr.xm38_u9.nsg13_hv_pmos[ide]
print @n.xbgr.xm38_u9.nsg13_hv_pmos[ige]
print @n.xbgr.xm38_u9.nsg13_hv_pmos[ise]
print @n.xbgr.xm38_u9.nsg13_hv_pmos[ibe]
print @n.xbgr.xm38_u9.nsg13_hv_pmos[ctype]
print @n.xbgr.xm38_u10.nsg13_hv_pmos[ide]
print @n.xbgr.xm38_u10.nsg13_hv_pmos[ige]
print @n.xbgr.xm38_u10.nsg13_hv_pmos[ise]
print @n.xbgr.xm38_u10.nsg13_hv_pmos[ibe]
print @n.xbgr.xm38_u10.nsg13_hv_pmos[ctype]
print @n.xbgr.xm38_u11.nsg13_hv_pmos[ide]
print @n.xbgr.xm38_u11.nsg13_hv_pmos[ige]
print @n.xbgr.xm38_u11.nsg13_hv_pmos[ise]
print @n.xbgr.xm38_u11.nsg13_hv_pmos[ibe]
print @n.xbgr.xm38_u11.nsg13_hv_pmos[ctype]
print @n.xbgr.xm38_u12.nsg13_hv_pmos[ide]
print @n.xbgr.xm38_u12.nsg13_hv_pmos[ige]
print @n.xbgr.xm38_u12.nsg13_hv_pmos[ise]
print @n.xbgr.xm38_u12.nsg13_hv_pmos[ibe]
print @n.xbgr.xm38_u12.nsg13_hv_pmos[ctype]
print @n.xbgr.xm38_u13.nsg13_hv_pmos[ide]
print @n.xbgr.xm38_u13.nsg13_hv_pmos[ige]
print @n.xbgr.xm38_u13.nsg13_hv_pmos[ise]
print @n.xbgr.xm38_u13.nsg13_hv_pmos[ibe]
print @n.xbgr.xm38_u13.nsg13_hv_pmos[ctype]
print @n.xbgr.xm38_u14.nsg13_hv_pmos[ide]
print @n.xbgr.xm38_u14.nsg13_hv_pmos[ige]
print @n.xbgr.xm38_u14.nsg13_hv_pmos[ise]
print @n.xbgr.xm38_u14.nsg13_hv_pmos[ibe]
print @n.xbgr.xm38_u14.nsg13_hv_pmos[ctype]
print @n.xbgr.xm38_u15.nsg13_hv_pmos[ide]
print @n.xbgr.xm38_u15.nsg13_hv_pmos[ige]
print @n.xbgr.xm38_u15.nsg13_hv_pmos[ise]
print @n.xbgr.xm38_u15.nsg13_hv_pmos[ibe]
print @n.xbgr.xm38_u15.nsg13_hv_pmos[ctype]
print @n.xbgr.xm38_u16.nsg13_hv_pmos[ide]
print @n.xbgr.xm38_u16.nsg13_hv_pmos[ige]
print @n.xbgr.xm38_u16.nsg13_hv_pmos[ise]
print @n.xbgr.xm38_u16.nsg13_hv_pmos[ibe]
print @n.xbgr.xm38_u16.nsg13_hv_pmos[ctype]
print @n.xbgr.xm38_u17.nsg13_hv_pmos[ide]
print @n.xbgr.xm38_u17.nsg13_hv_pmos[ige]
print @n.xbgr.xm38_u17.nsg13_hv_pmos[ise]
print @n.xbgr.xm38_u17.nsg13_hv_pmos[ibe]
print @n.xbgr.xm38_u17.nsg13_hv_pmos[ctype]
print @n.xbgr.xm38_u18.nsg13_hv_pmos[ide]
print @n.xbgr.xm38_u18.nsg13_hv_pmos[ige]
print @n.xbgr.xm38_u18.nsg13_hv_pmos[ise]
print @n.xbgr.xm38_u18.nsg13_hv_pmos[ibe]
print @n.xbgr.xm38_u18.nsg13_hv_pmos[ctype]
print @n.xbgr.xm38_u19.nsg13_hv_pmos[ide]
print @n.xbgr.xm38_u19.nsg13_hv_pmos[ige]
print @n.xbgr.xm38_u19.nsg13_hv_pmos[ise]
print @n.xbgr.xm38_u19.nsg13_hv_pmos[ibe]
print @n.xbgr.xm38_u19.nsg13_hv_pmos[ctype]
print @n.xbgr.xm38_u20.nsg13_hv_pmos[ide]
print @n.xbgr.xm38_u20.nsg13_hv_pmos[ige]
print @n.xbgr.xm38_u20.nsg13_hv_pmos[ise]
print @n.xbgr.xm38_u20.nsg13_hv_pmos[ibe]
print @n.xbgr.xm38_u20.nsg13_hv_pmos[ctype]
print @n.xbgr.xm38_u21.nsg13_hv_pmos[ide]
print @n.xbgr.xm38_u21.nsg13_hv_pmos[ige]
print @n.xbgr.xm38_u21.nsg13_hv_pmos[ise]
print @n.xbgr.xm38_u21.nsg13_hv_pmos[ibe]
print @n.xbgr.xm38_u21.nsg13_hv_pmos[ctype]
print @n.xbgr.xm38_u22.nsg13_hv_pmos[ide]
print @n.xbgr.xm38_u22.nsg13_hv_pmos[ige]
print @n.xbgr.xm38_u22.nsg13_hv_pmos[ise]
print @n.xbgr.xm38_u22.nsg13_hv_pmos[ibe]
print @n.xbgr.xm38_u22.nsg13_hv_pmos[ctype]
print @n.xbgr.xm38_u23.nsg13_hv_pmos[ide]
print @n.xbgr.xm38_u23.nsg13_hv_pmos[ige]
print @n.xbgr.xm38_u23.nsg13_hv_pmos[ise]
print @n.xbgr.xm38_u23.nsg13_hv_pmos[ibe]
print @n.xbgr.xm38_u23.nsg13_hv_pmos[ctype]
print @n.xbgr.xm38_u24.nsg13_hv_pmos[ide]
print @n.xbgr.xm38_u24.nsg13_hv_pmos[ige]
print @n.xbgr.xm38_u24.nsg13_hv_pmos[ise]
print @n.xbgr.xm38_u24.nsg13_hv_pmos[ibe]
print @n.xbgr.xm38_u24.nsg13_hv_pmos[ctype]
print @n.xbgr.xm39_u2.nsg13_hv_pmos[ide]
print @n.xbgr.xm39_u2.nsg13_hv_pmos[ige]
print @n.xbgr.xm39_u2.nsg13_hv_pmos[ise]
print @n.xbgr.xm39_u2.nsg13_hv_pmos[ibe]
print @n.xbgr.xm39_u2.nsg13_hv_pmos[ctype]
print @n.xbgr.xm39_u3.nsg13_hv_pmos[ide]
print @n.xbgr.xm39_u3.nsg13_hv_pmos[ige]
print @n.xbgr.xm39_u3.nsg13_hv_pmos[ise]
print @n.xbgr.xm39_u3.nsg13_hv_pmos[ibe]
print @n.xbgr.xm39_u3.nsg13_hv_pmos[ctype]
print @n.xbgr.xm39_u4.nsg13_hv_pmos[ide]
print @n.xbgr.xm39_u4.nsg13_hv_pmos[ige]
print @n.xbgr.xm39_u4.nsg13_hv_pmos[ise]
print @n.xbgr.xm39_u4.nsg13_hv_pmos[ibe]
print @n.xbgr.xm39_u4.nsg13_hv_pmos[ctype]
print @n.xbgr.xm39_u5.nsg13_hv_pmos[ide]
print @n.xbgr.xm39_u5.nsg13_hv_pmos[ige]
print @n.xbgr.xm39_u5.nsg13_hv_pmos[ise]
print @n.xbgr.xm39_u5.nsg13_hv_pmos[ibe]
print @n.xbgr.xm39_u5.nsg13_hv_pmos[ctype]
print @n.xbgr.xm39_u6.nsg13_hv_pmos[ide]
print @n.xbgr.xm39_u6.nsg13_hv_pmos[ige]
print @n.xbgr.xm39_u6.nsg13_hv_pmos[ise]
print @n.xbgr.xm39_u6.nsg13_hv_pmos[ibe]
print @n.xbgr.xm39_u6.nsg13_hv_pmos[ctype]
print @n.xbgr.xm39_u7.nsg13_hv_pmos[ide]
print @n.xbgr.xm39_u7.nsg13_hv_pmos[ige]
print @n.xbgr.xm39_u7.nsg13_hv_pmos[ise]
print @n.xbgr.xm39_u7.nsg13_hv_pmos[ibe]
print @n.xbgr.xm39_u7.nsg13_hv_pmos[ctype]
print @n.xbgr.xm39_u8.nsg13_hv_pmos[ide]
print @n.xbgr.xm39_u8.nsg13_hv_pmos[ige]
print @n.xbgr.xm39_u8.nsg13_hv_pmos[ise]
print @n.xbgr.xm39_u8.nsg13_hv_pmos[ibe]
print @n.xbgr.xm39_u8.nsg13_hv_pmos[ctype]
print @n.xbgr.xm39_u9.nsg13_hv_pmos[ide]
print @n.xbgr.xm39_u9.nsg13_hv_pmos[ige]
print @n.xbgr.xm39_u9.nsg13_hv_pmos[ise]
print @n.xbgr.xm39_u9.nsg13_hv_pmos[ibe]
print @n.xbgr.xm39_u9.nsg13_hv_pmos[ctype]
print @n.xbgr.xm39_u10.nsg13_hv_pmos[ide]
print @n.xbgr.xm39_u10.nsg13_hv_pmos[ige]
print @n.xbgr.xm39_u10.nsg13_hv_pmos[ise]
print @n.xbgr.xm39_u10.nsg13_hv_pmos[ibe]
print @n.xbgr.xm39_u10.nsg13_hv_pmos[ctype]
print @n.xbgr.xm39_u11.nsg13_hv_pmos[ide]
print @n.xbgr.xm39_u11.nsg13_hv_pmos[ige]
print @n.xbgr.xm39_u11.nsg13_hv_pmos[ise]
print @n.xbgr.xm39_u11.nsg13_hv_pmos[ibe]
print @n.xbgr.xm39_u11.nsg13_hv_pmos[ctype]
print @n.xbgr.xm39_u12.nsg13_hv_pmos[ide]
print @n.xbgr.xm39_u12.nsg13_hv_pmos[ige]
print @n.xbgr.xm39_u12.nsg13_hv_pmos[ise]
print @n.xbgr.xm39_u12.nsg13_hv_pmos[ibe]
print @n.xbgr.xm39_u12.nsg13_hv_pmos[ctype]
print @n.xbgr.xm39_u13.nsg13_hv_pmos[ide]
print @n.xbgr.xm39_u13.nsg13_hv_pmos[ige]
print @n.xbgr.xm39_u13.nsg13_hv_pmos[ise]
print @n.xbgr.xm39_u13.nsg13_hv_pmos[ibe]
print @n.xbgr.xm39_u13.nsg13_hv_pmos[ctype]
print @n.xbgr.xm39_u14.nsg13_hv_pmos[ide]
print @n.xbgr.xm39_u14.nsg13_hv_pmos[ige]
print @n.xbgr.xm39_u14.nsg13_hv_pmos[ise]
print @n.xbgr.xm39_u14.nsg13_hv_pmos[ibe]
print @n.xbgr.xm39_u14.nsg13_hv_pmos[ctype]
print @n.xbgr.xm39_u15.nsg13_hv_pmos[ide]
print @n.xbgr.xm39_u15.nsg13_hv_pmos[ige]
print @n.xbgr.xm39_u15.nsg13_hv_pmos[ise]
print @n.xbgr.xm39_u15.nsg13_hv_pmos[ibe]
print @n.xbgr.xm39_u15.nsg13_hv_pmos[ctype]
print @n.xbgr.xm39_u16.nsg13_hv_pmos[ide]
print @n.xbgr.xm39_u16.nsg13_hv_pmos[ige]
print @n.xbgr.xm39_u16.nsg13_hv_pmos[ise]
print @n.xbgr.xm39_u16.nsg13_hv_pmos[ibe]
print @n.xbgr.xm39_u16.nsg13_hv_pmos[ctype]
print @n.xbgr.xm39_u17.nsg13_hv_pmos[ide]
print @n.xbgr.xm39_u17.nsg13_hv_pmos[ige]
print @n.xbgr.xm39_u17.nsg13_hv_pmos[ise]
print @n.xbgr.xm39_u17.nsg13_hv_pmos[ibe]
print @n.xbgr.xm39_u17.nsg13_hv_pmos[ctype]
print @n.xbgr.xm39_u18.nsg13_hv_pmos[ide]
print @n.xbgr.xm39_u18.nsg13_hv_pmos[ige]
print @n.xbgr.xm39_u18.nsg13_hv_pmos[ise]
print @n.xbgr.xm39_u18.nsg13_hv_pmos[ibe]
print @n.xbgr.xm39_u18.nsg13_hv_pmos[ctype]
print @n.xbgr.xm39_u19.nsg13_hv_pmos[ide]
print @n.xbgr.xm39_u19.nsg13_hv_pmos[ige]
print @n.xbgr.xm39_u19.nsg13_hv_pmos[ise]
print @n.xbgr.xm39_u19.nsg13_hv_pmos[ibe]
print @n.xbgr.xm39_u19.nsg13_hv_pmos[ctype]
print @n.xbgr.xm39_u20.nsg13_hv_pmos[ide]
print @n.xbgr.xm39_u20.nsg13_hv_pmos[ige]
print @n.xbgr.xm39_u20.nsg13_hv_pmos[ise]
print @n.xbgr.xm39_u20.nsg13_hv_pmos[ibe]
print @n.xbgr.xm39_u20.nsg13_hv_pmos[ctype]
print @n.xbgr.xm39_u21.nsg13_hv_pmos[ide]
print @n.xbgr.xm39_u21.nsg13_hv_pmos[ige]
print @n.xbgr.xm39_u21.nsg13_hv_pmos[ise]
print @n.xbgr.xm39_u21.nsg13_hv_pmos[ibe]
print @n.xbgr.xm39_u21.nsg13_hv_pmos[ctype]
print @n.xbgr.xm39_u22.nsg13_hv_pmos[ide]
print @n.xbgr.xm39_u22.nsg13_hv_pmos[ige]
print @n.xbgr.xm39_u22.nsg13_hv_pmos[ise]
print @n.xbgr.xm39_u22.nsg13_hv_pmos[ibe]
print @n.xbgr.xm39_u22.nsg13_hv_pmos[ctype]
print @n.xbgr.xm39_u23.nsg13_hv_pmos[ide]
print @n.xbgr.xm39_u23.nsg13_hv_pmos[ige]
print @n.xbgr.xm39_u23.nsg13_hv_pmos[ise]
print @n.xbgr.xm39_u23.nsg13_hv_pmos[ibe]
print @n.xbgr.xm39_u23.nsg13_hv_pmos[ctype]
print @n.xbgr.xm39_u24.nsg13_hv_pmos[ide]
print @n.xbgr.xm39_u24.nsg13_hv_pmos[ige]
print @n.xbgr.xm39_u24.nsg13_hv_pmos[ise]
print @n.xbgr.xm39_u24.nsg13_hv_pmos[ibe]
print @n.xbgr.xm39_u24.nsg13_hv_pmos[ctype]
print @n.xbgr.xm41_u2.nsg13_hv_pmos[ide]
print @n.xbgr.xm41_u2.nsg13_hv_pmos[ige]
print @n.xbgr.xm41_u2.nsg13_hv_pmos[ise]
print @n.xbgr.xm41_u2.nsg13_hv_pmos[ibe]
print @n.xbgr.xm41_u2.nsg13_hv_pmos[ctype]
print @n.xbgr.xm41_u3.nsg13_hv_pmos[ide]
print @n.xbgr.xm41_u3.nsg13_hv_pmos[ige]
print @n.xbgr.xm41_u3.nsg13_hv_pmos[ise]
print @n.xbgr.xm41_u3.nsg13_hv_pmos[ibe]
print @n.xbgr.xm41_u3.nsg13_hv_pmos[ctype]
print @n.xbgr.xm41_u4.nsg13_hv_pmos[ide]
print @n.xbgr.xm41_u4.nsg13_hv_pmos[ige]
print @n.xbgr.xm41_u4.nsg13_hv_pmos[ise]
print @n.xbgr.xm41_u4.nsg13_hv_pmos[ibe]
print @n.xbgr.xm41_u4.nsg13_hv_pmos[ctype]
print @n.xbgr.xm41_u5.nsg13_hv_pmos[ide]
print @n.xbgr.xm41_u5.nsg13_hv_pmos[ige]
print @n.xbgr.xm41_u5.nsg13_hv_pmos[ise]
print @n.xbgr.xm41_u5.nsg13_hv_pmos[ibe]
print @n.xbgr.xm41_u5.nsg13_hv_pmos[ctype]
print @n.xbgr.xm41_u6.nsg13_hv_pmos[ide]
print @n.xbgr.xm41_u6.nsg13_hv_pmos[ige]
print @n.xbgr.xm41_u6.nsg13_hv_pmos[ise]
print @n.xbgr.xm41_u6.nsg13_hv_pmos[ibe]
print @n.xbgr.xm41_u6.nsg13_hv_pmos[ctype]
print @n.xbgr.xm41_u7.nsg13_hv_pmos[ide]
print @n.xbgr.xm41_u7.nsg13_hv_pmos[ige]
print @n.xbgr.xm41_u7.nsg13_hv_pmos[ise]
print @n.xbgr.xm41_u7.nsg13_hv_pmos[ibe]
print @n.xbgr.xm41_u7.nsg13_hv_pmos[ctype]
print @n.xbgr.xm41_u8.nsg13_hv_pmos[ide]
print @n.xbgr.xm41_u8.nsg13_hv_pmos[ige]
print @n.xbgr.xm41_u8.nsg13_hv_pmos[ise]
print @n.xbgr.xm41_u8.nsg13_hv_pmos[ibe]
print @n.xbgr.xm41_u8.nsg13_hv_pmos[ctype]
print @n.xbgr.xm41_u9.nsg13_hv_pmos[ide]
print @n.xbgr.xm41_u9.nsg13_hv_pmos[ige]
print @n.xbgr.xm41_u9.nsg13_hv_pmos[ise]
print @n.xbgr.xm41_u9.nsg13_hv_pmos[ibe]
print @n.xbgr.xm41_u9.nsg13_hv_pmos[ctype]
print @n.xbgr.xm41_u10.nsg13_hv_pmos[ide]
print @n.xbgr.xm41_u10.nsg13_hv_pmos[ige]
print @n.xbgr.xm41_u10.nsg13_hv_pmos[ise]
print @n.xbgr.xm41_u10.nsg13_hv_pmos[ibe]
print @n.xbgr.xm41_u10.nsg13_hv_pmos[ctype]
print @n.xbgr.xm41_u11.nsg13_hv_pmos[ide]
print @n.xbgr.xm41_u11.nsg13_hv_pmos[ige]
print @n.xbgr.xm41_u11.nsg13_hv_pmos[ise]
print @n.xbgr.xm41_u11.nsg13_hv_pmos[ibe]
print @n.xbgr.xm41_u11.nsg13_hv_pmos[ctype]
print @n.xbgr.xm41_u12.nsg13_hv_pmos[ide]
print @n.xbgr.xm41_u12.nsg13_hv_pmos[ige]
print @n.xbgr.xm41_u12.nsg13_hv_pmos[ise]
print @n.xbgr.xm41_u12.nsg13_hv_pmos[ibe]
print @n.xbgr.xm41_u12.nsg13_hv_pmos[ctype]
print @n.xbgr.xm41_u13.nsg13_hv_pmos[ide]
print @n.xbgr.xm41_u13.nsg13_hv_pmos[ige]
print @n.xbgr.xm41_u13.nsg13_hv_pmos[ise]
print @n.xbgr.xm41_u13.nsg13_hv_pmos[ibe]
print @n.xbgr.xm41_u13.nsg13_hv_pmos[ctype]
print @n.xbgr.xm41_u14.nsg13_hv_pmos[ide]
print @n.xbgr.xm41_u14.nsg13_hv_pmos[ige]
print @n.xbgr.xm41_u14.nsg13_hv_pmos[ise]
print @n.xbgr.xm41_u14.nsg13_hv_pmos[ibe]
print @n.xbgr.xm41_u14.nsg13_hv_pmos[ctype]
print @n.xbgr.xm41_u15.nsg13_hv_pmos[ide]
print @n.xbgr.xm41_u15.nsg13_hv_pmos[ige]
print @n.xbgr.xm41_u15.nsg13_hv_pmos[ise]
print @n.xbgr.xm41_u15.nsg13_hv_pmos[ibe]
print @n.xbgr.xm41_u15.nsg13_hv_pmos[ctype]
print @n.xbgr.xm41_u16.nsg13_hv_pmos[ide]
print @n.xbgr.xm41_u16.nsg13_hv_pmos[ige]
print @n.xbgr.xm41_u16.nsg13_hv_pmos[ise]
print @n.xbgr.xm41_u16.nsg13_hv_pmos[ibe]
print @n.xbgr.xm41_u16.nsg13_hv_pmos[ctype]
print @n.xbgr.xm41_u17.nsg13_hv_pmos[ide]
print @n.xbgr.xm41_u17.nsg13_hv_pmos[ige]
print @n.xbgr.xm41_u17.nsg13_hv_pmos[ise]
print @n.xbgr.xm41_u17.nsg13_hv_pmos[ibe]
print @n.xbgr.xm41_u17.nsg13_hv_pmos[ctype]
print @n.xbgr.xm41_u18.nsg13_hv_pmos[ide]
print @n.xbgr.xm41_u18.nsg13_hv_pmos[ige]
print @n.xbgr.xm41_u18.nsg13_hv_pmos[ise]
print @n.xbgr.xm41_u18.nsg13_hv_pmos[ibe]
print @n.xbgr.xm41_u18.nsg13_hv_pmos[ctype]
print @n.xbgr.xm41_u19.nsg13_hv_pmos[ide]
print @n.xbgr.xm41_u19.nsg13_hv_pmos[ige]
print @n.xbgr.xm41_u19.nsg13_hv_pmos[ise]
print @n.xbgr.xm41_u19.nsg13_hv_pmos[ibe]
print @n.xbgr.xm41_u19.nsg13_hv_pmos[ctype]
print @n.xbgr.xm41_u20.nsg13_hv_pmos[ide]
print @n.xbgr.xm41_u20.nsg13_hv_pmos[ige]
print @n.xbgr.xm41_u20.nsg13_hv_pmos[ise]
print @n.xbgr.xm41_u20.nsg13_hv_pmos[ibe]
print @n.xbgr.xm41_u20.nsg13_hv_pmos[ctype]
print @n.xbgr.xm41_u21.nsg13_hv_pmos[ide]
print @n.xbgr.xm41_u21.nsg13_hv_pmos[ige]
print @n.xbgr.xm41_u21.nsg13_hv_pmos[ise]
print @n.xbgr.xm41_u21.nsg13_hv_pmos[ibe]
print @n.xbgr.xm41_u21.nsg13_hv_pmos[ctype]
print @n.xbgr.xm41_u22.nsg13_hv_pmos[ide]
print @n.xbgr.xm41_u22.nsg13_hv_pmos[ige]
print @n.xbgr.xm41_u22.nsg13_hv_pmos[ise]
print @n.xbgr.xm41_u22.nsg13_hv_pmos[ibe]
print @n.xbgr.xm41_u22.nsg13_hv_pmos[ctype]
print @n.xbgr.xm41_u23.nsg13_hv_pmos[ide]
print @n.xbgr.xm41_u23.nsg13_hv_pmos[ige]
print @n.xbgr.xm41_u23.nsg13_hv_pmos[ise]
print @n.xbgr.xm41_u23.nsg13_hv_pmos[ibe]
print @n.xbgr.xm41_u23.nsg13_hv_pmos[ctype]
print @n.xbgr.xm41_u24.nsg13_hv_pmos[ide]
print @n.xbgr.xm41_u24.nsg13_hv_pmos[ige]
print @n.xbgr.xm41_u24.nsg13_hv_pmos[ise]
print @n.xbgr.xm41_u24.nsg13_hv_pmos[ibe]
print @n.xbgr.xm41_u24.nsg13_hv_pmos[ctype]
print @n.xbgr.xm43_u2.nsg13_hv_pmos[ide]
print @n.xbgr.xm43_u2.nsg13_hv_pmos[ige]
print @n.xbgr.xm43_u2.nsg13_hv_pmos[ise]
print @n.xbgr.xm43_u2.nsg13_hv_pmos[ibe]
print @n.xbgr.xm43_u2.nsg13_hv_pmos[ctype]
print @n.xbgr.xm43_u3.nsg13_hv_pmos[ide]
print @n.xbgr.xm43_u3.nsg13_hv_pmos[ige]
print @n.xbgr.xm43_u3.nsg13_hv_pmos[ise]
print @n.xbgr.xm43_u3.nsg13_hv_pmos[ibe]
print @n.xbgr.xm43_u3.nsg13_hv_pmos[ctype]
print @n.xbgr.xm43_u4.nsg13_hv_pmos[ide]
print @n.xbgr.xm43_u4.nsg13_hv_pmos[ige]
print @n.xbgr.xm43_u4.nsg13_hv_pmos[ise]
print @n.xbgr.xm43_u4.nsg13_hv_pmos[ibe]
print @n.xbgr.xm43_u4.nsg13_hv_pmos[ctype]
print @n.xbgr.xm44_u2.nsg13_hv_pmos[ide]
print @n.xbgr.xm44_u2.nsg13_hv_pmos[ige]
print @n.xbgr.xm44_u2.nsg13_hv_pmos[ise]
print @n.xbgr.xm44_u2.nsg13_hv_pmos[ibe]
print @n.xbgr.xm44_u2.nsg13_hv_pmos[ctype]
print @n.xbgr.xm44_u3.nsg13_hv_pmos[ide]
print @n.xbgr.xm44_u3.nsg13_hv_pmos[ige]
print @n.xbgr.xm44_u3.nsg13_hv_pmos[ise]
print @n.xbgr.xm44_u3.nsg13_hv_pmos[ibe]
print @n.xbgr.xm44_u3.nsg13_hv_pmos[ctype]
print @n.xbgr.xm44_u4.nsg13_hv_pmos[ide]
print @n.xbgr.xm44_u4.nsg13_hv_pmos[ige]
print @n.xbgr.xm44_u4.nsg13_hv_pmos[ise]
print @n.xbgr.xm44_u4.nsg13_hv_pmos[ibe]
print @n.xbgr.xm44_u4.nsg13_hv_pmos[ctype]
print @n.xbgr.xm45_u2.nsg13_hv_pmos[ide]
print @n.xbgr.xm45_u2.nsg13_hv_pmos[ige]
print @n.xbgr.xm45_u2.nsg13_hv_pmos[ise]
print @n.xbgr.xm45_u2.nsg13_hv_pmos[ibe]
print @n.xbgr.xm45_u2.nsg13_hv_pmos[ctype]
print @n.xbgr.xm45_u3.nsg13_hv_pmos[ide]
print @n.xbgr.xm45_u3.nsg13_hv_pmos[ige]
print @n.xbgr.xm45_u3.nsg13_hv_pmos[ise]
print @n.xbgr.xm45_u3.nsg13_hv_pmos[ibe]
print @n.xbgr.xm45_u3.nsg13_hv_pmos[ctype]
print @n.xbgr.xm45_u4.nsg13_hv_pmos[ide]
print @n.xbgr.xm45_u4.nsg13_hv_pmos[ige]
print @n.xbgr.xm45_u4.nsg13_hv_pmos[ise]
print @n.xbgr.xm45_u4.nsg13_hv_pmos[ibe]
print @n.xbgr.xm45_u4.nsg13_hv_pmos[ctype]
print @n.xbgr.xm45_u5.nsg13_hv_pmos[ide]
print @n.xbgr.xm45_u5.nsg13_hv_pmos[ige]
print @n.xbgr.xm45_u5.nsg13_hv_pmos[ise]
print @n.xbgr.xm45_u5.nsg13_hv_pmos[ibe]
print @n.xbgr.xm45_u5.nsg13_hv_pmos[ctype]
print @n.xbgr.xm45_u6.nsg13_hv_pmos[ide]
print @n.xbgr.xm45_u6.nsg13_hv_pmos[ige]
print @n.xbgr.xm45_u6.nsg13_hv_pmos[ise]
print @n.xbgr.xm45_u6.nsg13_hv_pmos[ibe]
print @n.xbgr.xm45_u6.nsg13_hv_pmos[ctype]
print @n.xbgr.xm45_u7.nsg13_hv_pmos[ide]
print @n.xbgr.xm45_u7.nsg13_hv_pmos[ige]
print @n.xbgr.xm45_u7.nsg13_hv_pmos[ise]
print @n.xbgr.xm45_u7.nsg13_hv_pmos[ibe]
print @n.xbgr.xm45_u7.nsg13_hv_pmos[ctype]
print @n.xbgr.xm45_u8.nsg13_hv_pmos[ide]
print @n.xbgr.xm45_u8.nsg13_hv_pmos[ige]
print @n.xbgr.xm45_u8.nsg13_hv_pmos[ise]
print @n.xbgr.xm45_u8.nsg13_hv_pmos[ibe]
print @n.xbgr.xm45_u8.nsg13_hv_pmos[ctype]
print @n.xbgr.xm45_u9.nsg13_hv_pmos[ide]
print @n.xbgr.xm45_u9.nsg13_hv_pmos[ige]
print @n.xbgr.xm45_u9.nsg13_hv_pmos[ise]
print @n.xbgr.xm45_u9.nsg13_hv_pmos[ibe]
print @n.xbgr.xm45_u9.nsg13_hv_pmos[ctype]
print @n.xbgr.xm45_u10.nsg13_hv_pmos[ide]
print @n.xbgr.xm45_u10.nsg13_hv_pmos[ige]
print @n.xbgr.xm45_u10.nsg13_hv_pmos[ise]
print @n.xbgr.xm45_u10.nsg13_hv_pmos[ibe]
print @n.xbgr.xm45_u10.nsg13_hv_pmos[ctype]
print @n.xbgr.xm45_u11.nsg13_hv_pmos[ide]
print @n.xbgr.xm45_u11.nsg13_hv_pmos[ige]
print @n.xbgr.xm45_u11.nsg13_hv_pmos[ise]
print @n.xbgr.xm45_u11.nsg13_hv_pmos[ibe]
print @n.xbgr.xm45_u11.nsg13_hv_pmos[ctype]
print @n.xbgr.xm45_u12.nsg13_hv_pmos[ide]
print @n.xbgr.xm45_u12.nsg13_hv_pmos[ige]
print @n.xbgr.xm45_u12.nsg13_hv_pmos[ise]
print @n.xbgr.xm45_u12.nsg13_hv_pmos[ibe]
print @n.xbgr.xm45_u12.nsg13_hv_pmos[ctype]
print @n.xbgr.xm45_u13.nsg13_hv_pmos[ide]
print @n.xbgr.xm45_u13.nsg13_hv_pmos[ige]
print @n.xbgr.xm45_u13.nsg13_hv_pmos[ise]
print @n.xbgr.xm45_u13.nsg13_hv_pmos[ibe]
print @n.xbgr.xm45_u13.nsg13_hv_pmos[ctype]
print @n.xbgr.xm45_u14.nsg13_hv_pmos[ide]
print @n.xbgr.xm45_u14.nsg13_hv_pmos[ige]
print @n.xbgr.xm45_u14.nsg13_hv_pmos[ise]
print @n.xbgr.xm45_u14.nsg13_hv_pmos[ibe]
print @n.xbgr.xm45_u14.nsg13_hv_pmos[ctype]
print @n.xbgr.xm45_u15.nsg13_hv_pmos[ide]
print @n.xbgr.xm45_u15.nsg13_hv_pmos[ige]
print @n.xbgr.xm45_u15.nsg13_hv_pmos[ise]
print @n.xbgr.xm45_u15.nsg13_hv_pmos[ibe]
print @n.xbgr.xm45_u15.nsg13_hv_pmos[ctype]
print @n.xbgr.xm45_u16.nsg13_hv_pmos[ide]
print @n.xbgr.xm45_u16.nsg13_hv_pmos[ige]
print @n.xbgr.xm45_u16.nsg13_hv_pmos[ise]
print @n.xbgr.xm45_u16.nsg13_hv_pmos[ibe]
print @n.xbgr.xm45_u16.nsg13_hv_pmos[ctype]
print @n.xbgr.xm45_u17.nsg13_hv_pmos[ide]
print @n.xbgr.xm45_u17.nsg13_hv_pmos[ige]
print @n.xbgr.xm45_u17.nsg13_hv_pmos[ise]
print @n.xbgr.xm45_u17.nsg13_hv_pmos[ibe]
print @n.xbgr.xm45_u17.nsg13_hv_pmos[ctype]
print @n.xbgr.xm45_u18.nsg13_hv_pmos[ide]
print @n.xbgr.xm45_u18.nsg13_hv_pmos[ige]
print @n.xbgr.xm45_u18.nsg13_hv_pmos[ise]
print @n.xbgr.xm45_u18.nsg13_hv_pmos[ibe]
print @n.xbgr.xm45_u18.nsg13_hv_pmos[ctype]
print @n.xbgr.xm45_u19.nsg13_hv_pmos[ide]
print @n.xbgr.xm45_u19.nsg13_hv_pmos[ige]
print @n.xbgr.xm45_u19.nsg13_hv_pmos[ise]
print @n.xbgr.xm45_u19.nsg13_hv_pmos[ibe]
print @n.xbgr.xm45_u19.nsg13_hv_pmos[ctype]
print @n.xbgr.xm45_u20.nsg13_hv_pmos[ide]
print @n.xbgr.xm45_u20.nsg13_hv_pmos[ige]
print @n.xbgr.xm45_u20.nsg13_hv_pmos[ise]
print @n.xbgr.xm45_u20.nsg13_hv_pmos[ibe]
print @n.xbgr.xm45_u20.nsg13_hv_pmos[ctype]
print @n.xbgr.xm45_u21.nsg13_hv_pmos[ide]
print @n.xbgr.xm45_u21.nsg13_hv_pmos[ige]
print @n.xbgr.xm45_u21.nsg13_hv_pmos[ise]
print @n.xbgr.xm45_u21.nsg13_hv_pmos[ibe]
print @n.xbgr.xm45_u21.nsg13_hv_pmos[ctype]
print @n.xbgr.xm45_u22.nsg13_hv_pmos[ide]
print @n.xbgr.xm45_u22.nsg13_hv_pmos[ige]
print @n.xbgr.xm45_u22.nsg13_hv_pmos[ise]
print @n.xbgr.xm45_u22.nsg13_hv_pmos[ibe]
print @n.xbgr.xm45_u22.nsg13_hv_pmos[ctype]
print @n.xbgr.xm45_u23.nsg13_hv_pmos[ide]
print @n.xbgr.xm45_u23.nsg13_hv_pmos[ige]
print @n.xbgr.xm45_u23.nsg13_hv_pmos[ise]
print @n.xbgr.xm45_u23.nsg13_hv_pmos[ibe]
print @n.xbgr.xm45_u23.nsg13_hv_pmos[ctype]
print @n.xbgr.xm45_u24.nsg13_hv_pmos[ide]
print @n.xbgr.xm45_u24.nsg13_hv_pmos[ige]
print @n.xbgr.xm45_u24.nsg13_hv_pmos[ise]
print @n.xbgr.xm45_u24.nsg13_hv_pmos[ibe]
print @n.xbgr.xm45_u24.nsg13_hv_pmos[ctype]
print @n.xbgr.xm47_u2.nsg13_hv_pmos[ide]
print @n.xbgr.xm47_u2.nsg13_hv_pmos[ige]
print @n.xbgr.xm47_u2.nsg13_hv_pmos[ise]
print @n.xbgr.xm47_u2.nsg13_hv_pmos[ibe]
print @n.xbgr.xm47_u2.nsg13_hv_pmos[ctype]
print @n.xbgr.xm47_u3.nsg13_hv_pmos[ide]
print @n.xbgr.xm47_u3.nsg13_hv_pmos[ige]
print @n.xbgr.xm47_u3.nsg13_hv_pmos[ise]
print @n.xbgr.xm47_u3.nsg13_hv_pmos[ibe]
print @n.xbgr.xm47_u3.nsg13_hv_pmos[ctype]
print @n.xbgr.xm47_u4.nsg13_hv_pmos[ide]
print @n.xbgr.xm47_u4.nsg13_hv_pmos[ige]
print @n.xbgr.xm47_u4.nsg13_hv_pmos[ise]
print @n.xbgr.xm47_u4.nsg13_hv_pmos[ibe]
print @n.xbgr.xm47_u4.nsg13_hv_pmos[ctype]
print @n.xbgr.xm47_u5.nsg13_hv_pmos[ide]
print @n.xbgr.xm47_u5.nsg13_hv_pmos[ige]
print @n.xbgr.xm47_u5.nsg13_hv_pmos[ise]
print @n.xbgr.xm47_u5.nsg13_hv_pmos[ibe]
print @n.xbgr.xm47_u5.nsg13_hv_pmos[ctype]
print @n.xbgr.xm47_u6.nsg13_hv_pmos[ide]
print @n.xbgr.xm47_u6.nsg13_hv_pmos[ige]
print @n.xbgr.xm47_u6.nsg13_hv_pmos[ise]
print @n.xbgr.xm47_u6.nsg13_hv_pmos[ibe]
print @n.xbgr.xm47_u6.nsg13_hv_pmos[ctype]
print @n.xbgr.xm47_u7.nsg13_hv_pmos[ide]
print @n.xbgr.xm47_u7.nsg13_hv_pmos[ige]
print @n.xbgr.xm47_u7.nsg13_hv_pmos[ise]
print @n.xbgr.xm47_u7.nsg13_hv_pmos[ibe]
print @n.xbgr.xm47_u7.nsg13_hv_pmos[ctype]
print @n.xbgr.xm47_u8.nsg13_hv_pmos[ide]
print @n.xbgr.xm47_u8.nsg13_hv_pmos[ige]
print @n.xbgr.xm47_u8.nsg13_hv_pmos[ise]
print @n.xbgr.xm47_u8.nsg13_hv_pmos[ibe]
print @n.xbgr.xm47_u8.nsg13_hv_pmos[ctype]
print @n.xbgr.xm47_u9.nsg13_hv_pmos[ide]
print @n.xbgr.xm47_u9.nsg13_hv_pmos[ige]
print @n.xbgr.xm47_u9.nsg13_hv_pmos[ise]
print @n.xbgr.xm47_u9.nsg13_hv_pmos[ibe]
print @n.xbgr.xm47_u9.nsg13_hv_pmos[ctype]
print @n.xbgr.xm47_u10.nsg13_hv_pmos[ide]
print @n.xbgr.xm47_u10.nsg13_hv_pmos[ige]
print @n.xbgr.xm47_u10.nsg13_hv_pmos[ise]
print @n.xbgr.xm47_u10.nsg13_hv_pmos[ibe]
print @n.xbgr.xm47_u10.nsg13_hv_pmos[ctype]
print @n.xbgr.xm47_u11.nsg13_hv_pmos[ide]
print @n.xbgr.xm47_u11.nsg13_hv_pmos[ige]
print @n.xbgr.xm47_u11.nsg13_hv_pmos[ise]
print @n.xbgr.xm47_u11.nsg13_hv_pmos[ibe]
print @n.xbgr.xm47_u11.nsg13_hv_pmos[ctype]
print @n.xbgr.xm47_u12.nsg13_hv_pmos[ide]
print @n.xbgr.xm47_u12.nsg13_hv_pmos[ige]
print @n.xbgr.xm47_u12.nsg13_hv_pmos[ise]
print @n.xbgr.xm47_u12.nsg13_hv_pmos[ibe]
print @n.xbgr.xm47_u12.nsg13_hv_pmos[ctype]
print @n.xbgr.xm47_u13.nsg13_hv_pmos[ide]
print @n.xbgr.xm47_u13.nsg13_hv_pmos[ige]
print @n.xbgr.xm47_u13.nsg13_hv_pmos[ise]
print @n.xbgr.xm47_u13.nsg13_hv_pmos[ibe]
print @n.xbgr.xm47_u13.nsg13_hv_pmos[ctype]
print @n.xbgr.xm47_u14.nsg13_hv_pmos[ide]
print @n.xbgr.xm47_u14.nsg13_hv_pmos[ige]
print @n.xbgr.xm47_u14.nsg13_hv_pmos[ise]
print @n.xbgr.xm47_u14.nsg13_hv_pmos[ibe]
print @n.xbgr.xm47_u14.nsg13_hv_pmos[ctype]
print @n.xbgr.xm47_u15.nsg13_hv_pmos[ide]
print @n.xbgr.xm47_u15.nsg13_hv_pmos[ige]
print @n.xbgr.xm47_u15.nsg13_hv_pmos[ise]
print @n.xbgr.xm47_u15.nsg13_hv_pmos[ibe]
print @n.xbgr.xm47_u15.nsg13_hv_pmos[ctype]
print @n.xbgr.xm47_u16.nsg13_hv_pmos[ide]
print @n.xbgr.xm47_u16.nsg13_hv_pmos[ige]
print @n.xbgr.xm47_u16.nsg13_hv_pmos[ise]
print @n.xbgr.xm47_u16.nsg13_hv_pmos[ibe]
print @n.xbgr.xm47_u16.nsg13_hv_pmos[ctype]
print @n.xbgr.xm47_u17.nsg13_hv_pmos[ide]
print @n.xbgr.xm47_u17.nsg13_hv_pmos[ige]
print @n.xbgr.xm47_u17.nsg13_hv_pmos[ise]
print @n.xbgr.xm47_u17.nsg13_hv_pmos[ibe]
print @n.xbgr.xm47_u17.nsg13_hv_pmos[ctype]
print @n.xbgr.xm47_u18.nsg13_hv_pmos[ide]
print @n.xbgr.xm47_u18.nsg13_hv_pmos[ige]
print @n.xbgr.xm47_u18.nsg13_hv_pmos[ise]
print @n.xbgr.xm47_u18.nsg13_hv_pmos[ibe]
print @n.xbgr.xm47_u18.nsg13_hv_pmos[ctype]
print @n.xbgr.xm47_u19.nsg13_hv_pmos[ide]
print @n.xbgr.xm47_u19.nsg13_hv_pmos[ige]
print @n.xbgr.xm47_u19.nsg13_hv_pmos[ise]
print @n.xbgr.xm47_u19.nsg13_hv_pmos[ibe]
print @n.xbgr.xm47_u19.nsg13_hv_pmos[ctype]
print @n.xbgr.xm47_u20.nsg13_hv_pmos[ide]
print @n.xbgr.xm47_u20.nsg13_hv_pmos[ige]
print @n.xbgr.xm47_u20.nsg13_hv_pmos[ise]
print @n.xbgr.xm47_u20.nsg13_hv_pmos[ibe]
print @n.xbgr.xm47_u20.nsg13_hv_pmos[ctype]
print @n.xbgr.xm47_u21.nsg13_hv_pmos[ide]
print @n.xbgr.xm47_u21.nsg13_hv_pmos[ige]
print @n.xbgr.xm47_u21.nsg13_hv_pmos[ise]
print @n.xbgr.xm47_u21.nsg13_hv_pmos[ibe]
print @n.xbgr.xm47_u21.nsg13_hv_pmos[ctype]
print @n.xbgr.xm47_u22.nsg13_hv_pmos[ide]
print @n.xbgr.xm47_u22.nsg13_hv_pmos[ige]
print @n.xbgr.xm47_u22.nsg13_hv_pmos[ise]
print @n.xbgr.xm47_u22.nsg13_hv_pmos[ibe]
print @n.xbgr.xm47_u22.nsg13_hv_pmos[ctype]
print @n.xbgr.xm47_u23.nsg13_hv_pmos[ide]
print @n.xbgr.xm47_u23.nsg13_hv_pmos[ige]
print @n.xbgr.xm47_u23.nsg13_hv_pmos[ise]
print @n.xbgr.xm47_u23.nsg13_hv_pmos[ibe]
print @n.xbgr.xm47_u23.nsg13_hv_pmos[ctype]
print @n.xbgr.xm47_u24.nsg13_hv_pmos[ide]
print @n.xbgr.xm47_u24.nsg13_hv_pmos[ige]
print @n.xbgr.xm47_u24.nsg13_hv_pmos[ise]
print @n.xbgr.xm47_u24.nsg13_hv_pmos[ibe]
print @n.xbgr.xm47_u24.nsg13_hv_pmos[ctype]
print @n.xbgr.xm48_u2.nsg13_hv_pmos[ide]
print @n.xbgr.xm48_u2.nsg13_hv_pmos[ige]
print @n.xbgr.xm48_u2.nsg13_hv_pmos[ise]
print @n.xbgr.xm48_u2.nsg13_hv_pmos[ibe]
print @n.xbgr.xm48_u2.nsg13_hv_pmos[ctype]
print @n.xbgr.xm48_u3.nsg13_hv_pmos[ide]
print @n.xbgr.xm48_u3.nsg13_hv_pmos[ige]
print @n.xbgr.xm48_u3.nsg13_hv_pmos[ise]
print @n.xbgr.xm48_u3.nsg13_hv_pmos[ibe]
print @n.xbgr.xm48_u3.nsg13_hv_pmos[ctype]
print @n.xbgr.xm48_u4.nsg13_hv_pmos[ide]
print @n.xbgr.xm48_u4.nsg13_hv_pmos[ige]
print @n.xbgr.xm48_u4.nsg13_hv_pmos[ise]
print @n.xbgr.xm48_u4.nsg13_hv_pmos[ibe]
print @n.xbgr.xm48_u4.nsg13_hv_pmos[ctype]
print @n.xbgr.xm48_u5.nsg13_hv_pmos[ide]
print @n.xbgr.xm48_u5.nsg13_hv_pmos[ige]
print @n.xbgr.xm48_u5.nsg13_hv_pmos[ise]
print @n.xbgr.xm48_u5.nsg13_hv_pmos[ibe]
print @n.xbgr.xm48_u5.nsg13_hv_pmos[ctype]
print @n.xbgr.xm48_u6.nsg13_hv_pmos[ide]
print @n.xbgr.xm48_u6.nsg13_hv_pmos[ige]
print @n.xbgr.xm48_u6.nsg13_hv_pmos[ise]
print @n.xbgr.xm48_u6.nsg13_hv_pmos[ibe]
print @n.xbgr.xm48_u6.nsg13_hv_pmos[ctype]
print @n.xbgr.xm48_u7.nsg13_hv_pmos[ide]
print @n.xbgr.xm48_u7.nsg13_hv_pmos[ige]
print @n.xbgr.xm48_u7.nsg13_hv_pmos[ise]
print @n.xbgr.xm48_u7.nsg13_hv_pmos[ibe]
print @n.xbgr.xm48_u7.nsg13_hv_pmos[ctype]
print @n.xbgr.xm48_u8.nsg13_hv_pmos[ide]
print @n.xbgr.xm48_u8.nsg13_hv_pmos[ige]
print @n.xbgr.xm48_u8.nsg13_hv_pmos[ise]
print @n.xbgr.xm48_u8.nsg13_hv_pmos[ibe]
print @n.xbgr.xm48_u8.nsg13_hv_pmos[ctype]
print @n.xbgr.xm48_u9.nsg13_hv_pmos[ide]
print @n.xbgr.xm48_u9.nsg13_hv_pmos[ige]
print @n.xbgr.xm48_u9.nsg13_hv_pmos[ise]
print @n.xbgr.xm48_u9.nsg13_hv_pmos[ibe]
print @n.xbgr.xm48_u9.nsg13_hv_pmos[ctype]
print @n.xbgr.xm48_u10.nsg13_hv_pmos[ide]
print @n.xbgr.xm48_u10.nsg13_hv_pmos[ige]
print @n.xbgr.xm48_u10.nsg13_hv_pmos[ise]
print @n.xbgr.xm48_u10.nsg13_hv_pmos[ibe]
print @n.xbgr.xm48_u10.nsg13_hv_pmos[ctype]
print @n.xbgr.xm48_u11.nsg13_hv_pmos[ide]
print @n.xbgr.xm48_u11.nsg13_hv_pmos[ige]
print @n.xbgr.xm48_u11.nsg13_hv_pmos[ise]
print @n.xbgr.xm48_u11.nsg13_hv_pmos[ibe]
print @n.xbgr.xm48_u11.nsg13_hv_pmos[ctype]
print @n.xbgr.xm48_u12.nsg13_hv_pmos[ide]
print @n.xbgr.xm48_u12.nsg13_hv_pmos[ige]
print @n.xbgr.xm48_u12.nsg13_hv_pmos[ise]
print @n.xbgr.xm48_u12.nsg13_hv_pmos[ibe]
print @n.xbgr.xm48_u12.nsg13_hv_pmos[ctype]
print @n.xbgr.xm48_u13.nsg13_hv_pmos[ide]
print @n.xbgr.xm48_u13.nsg13_hv_pmos[ige]
print @n.xbgr.xm48_u13.nsg13_hv_pmos[ise]
print @n.xbgr.xm48_u13.nsg13_hv_pmos[ibe]
print @n.xbgr.xm48_u13.nsg13_hv_pmos[ctype]
print @n.xbgr.xm48_u14.nsg13_hv_pmos[ide]
print @n.xbgr.xm48_u14.nsg13_hv_pmos[ige]
print @n.xbgr.xm48_u14.nsg13_hv_pmos[ise]
print @n.xbgr.xm48_u14.nsg13_hv_pmos[ibe]
print @n.xbgr.xm48_u14.nsg13_hv_pmos[ctype]
print @n.xbgr.xm48_u15.nsg13_hv_pmos[ide]
print @n.xbgr.xm48_u15.nsg13_hv_pmos[ige]
print @n.xbgr.xm48_u15.nsg13_hv_pmos[ise]
print @n.xbgr.xm48_u15.nsg13_hv_pmos[ibe]
print @n.xbgr.xm48_u15.nsg13_hv_pmos[ctype]
print @n.xbgr.xm48_u16.nsg13_hv_pmos[ide]
print @n.xbgr.xm48_u16.nsg13_hv_pmos[ige]
print @n.xbgr.xm48_u16.nsg13_hv_pmos[ise]
print @n.xbgr.xm48_u16.nsg13_hv_pmos[ibe]
print @n.xbgr.xm48_u16.nsg13_hv_pmos[ctype]
print @n.xbgr.xm48_u17.nsg13_hv_pmos[ide]
print @n.xbgr.xm48_u17.nsg13_hv_pmos[ige]
print @n.xbgr.xm48_u17.nsg13_hv_pmos[ise]
print @n.xbgr.xm48_u17.nsg13_hv_pmos[ibe]
print @n.xbgr.xm48_u17.nsg13_hv_pmos[ctype]
print @n.xbgr.xm48_u18.nsg13_hv_pmos[ide]
print @n.xbgr.xm48_u18.nsg13_hv_pmos[ige]
print @n.xbgr.xm48_u18.nsg13_hv_pmos[ise]
print @n.xbgr.xm48_u18.nsg13_hv_pmos[ibe]
print @n.xbgr.xm48_u18.nsg13_hv_pmos[ctype]
print @n.xbgr.xm48_u19.nsg13_hv_pmos[ide]
print @n.xbgr.xm48_u19.nsg13_hv_pmos[ige]
print @n.xbgr.xm48_u19.nsg13_hv_pmos[ise]
print @n.xbgr.xm48_u19.nsg13_hv_pmos[ibe]
print @n.xbgr.xm48_u19.nsg13_hv_pmos[ctype]
print @n.xbgr.xm48_u20.nsg13_hv_pmos[ide]
print @n.xbgr.xm48_u20.nsg13_hv_pmos[ige]
print @n.xbgr.xm48_u20.nsg13_hv_pmos[ise]
print @n.xbgr.xm48_u20.nsg13_hv_pmos[ibe]
print @n.xbgr.xm48_u20.nsg13_hv_pmos[ctype]
print @n.xbgr.xm48_u21.nsg13_hv_pmos[ide]
print @n.xbgr.xm48_u21.nsg13_hv_pmos[ige]
print @n.xbgr.xm48_u21.nsg13_hv_pmos[ise]
print @n.xbgr.xm48_u21.nsg13_hv_pmos[ibe]
print @n.xbgr.xm48_u21.nsg13_hv_pmos[ctype]
print @n.xbgr.xm48_u22.nsg13_hv_pmos[ide]
print @n.xbgr.xm48_u22.nsg13_hv_pmos[ige]
print @n.xbgr.xm48_u22.nsg13_hv_pmos[ise]
print @n.xbgr.xm48_u22.nsg13_hv_pmos[ibe]
print @n.xbgr.xm48_u22.nsg13_hv_pmos[ctype]
print @n.xbgr.xm48_u23.nsg13_hv_pmos[ide]
print @n.xbgr.xm48_u23.nsg13_hv_pmos[ige]
print @n.xbgr.xm48_u23.nsg13_hv_pmos[ise]
print @n.xbgr.xm48_u23.nsg13_hv_pmos[ibe]
print @n.xbgr.xm48_u23.nsg13_hv_pmos[ctype]
print @n.xbgr.xm48_u24.nsg13_hv_pmos[ide]
print @n.xbgr.xm48_u24.nsg13_hv_pmos[ige]
print @n.xbgr.xm48_u24.nsg13_hv_pmos[ise]
print @n.xbgr.xm48_u24.nsg13_hv_pmos[ibe]
print @n.xbgr.xm48_u24.nsg13_hv_pmos[ctype]
print @n.xbgr.xm50_u2.nsg13_hv_pmos[ide]
print @n.xbgr.xm50_u2.nsg13_hv_pmos[ige]
print @n.xbgr.xm50_u2.nsg13_hv_pmos[ise]
print @n.xbgr.xm50_u2.nsg13_hv_pmos[ibe]
print @n.xbgr.xm50_u2.nsg13_hv_pmos[ctype]
print @n.xbgr.xm50_u3.nsg13_hv_pmos[ide]
print @n.xbgr.xm50_u3.nsg13_hv_pmos[ige]
print @n.xbgr.xm50_u3.nsg13_hv_pmos[ise]
print @n.xbgr.xm50_u3.nsg13_hv_pmos[ibe]
print @n.xbgr.xm50_u3.nsg13_hv_pmos[ctype]
print @n.xbgr.xm50_u4.nsg13_hv_pmos[ide]
print @n.xbgr.xm50_u4.nsg13_hv_pmos[ige]
print @n.xbgr.xm50_u4.nsg13_hv_pmos[ise]
print @n.xbgr.xm50_u4.nsg13_hv_pmos[ibe]
print @n.xbgr.xm50_u4.nsg13_hv_pmos[ctype]
print @n.xbgr.xm50_u5.nsg13_hv_pmos[ide]
print @n.xbgr.xm50_u5.nsg13_hv_pmos[ige]
print @n.xbgr.xm50_u5.nsg13_hv_pmos[ise]
print @n.xbgr.xm50_u5.nsg13_hv_pmos[ibe]
print @n.xbgr.xm50_u5.nsg13_hv_pmos[ctype]
print @n.xbgr.xm50_u6.nsg13_hv_pmos[ide]
print @n.xbgr.xm50_u6.nsg13_hv_pmos[ige]
print @n.xbgr.xm50_u6.nsg13_hv_pmos[ise]
print @n.xbgr.xm50_u6.nsg13_hv_pmos[ibe]
print @n.xbgr.xm50_u6.nsg13_hv_pmos[ctype]
print @n.xbgr.xm50_u7.nsg13_hv_pmos[ide]
print @n.xbgr.xm50_u7.nsg13_hv_pmos[ige]
print @n.xbgr.xm50_u7.nsg13_hv_pmos[ise]
print @n.xbgr.xm50_u7.nsg13_hv_pmos[ibe]
print @n.xbgr.xm50_u7.nsg13_hv_pmos[ctype]
print @n.xbgr.xm50_u8.nsg13_hv_pmos[ide]
print @n.xbgr.xm50_u8.nsg13_hv_pmos[ige]
print @n.xbgr.xm50_u8.nsg13_hv_pmos[ise]
print @n.xbgr.xm50_u8.nsg13_hv_pmos[ibe]
print @n.xbgr.xm50_u8.nsg13_hv_pmos[ctype]
print @n.xbgr.xm50_u9.nsg13_hv_pmos[ide]
print @n.xbgr.xm50_u9.nsg13_hv_pmos[ige]
print @n.xbgr.xm50_u9.nsg13_hv_pmos[ise]
print @n.xbgr.xm50_u9.nsg13_hv_pmos[ibe]
print @n.xbgr.xm50_u9.nsg13_hv_pmos[ctype]
print @n.xbgr.xm50_u10.nsg13_hv_pmos[ide]
print @n.xbgr.xm50_u10.nsg13_hv_pmos[ige]
print @n.xbgr.xm50_u10.nsg13_hv_pmos[ise]
print @n.xbgr.xm50_u10.nsg13_hv_pmos[ibe]
print @n.xbgr.xm50_u10.nsg13_hv_pmos[ctype]
print @n.xbgr.xm50_u11.nsg13_hv_pmos[ide]
print @n.xbgr.xm50_u11.nsg13_hv_pmos[ige]
print @n.xbgr.xm50_u11.nsg13_hv_pmos[ise]
print @n.xbgr.xm50_u11.nsg13_hv_pmos[ibe]
print @n.xbgr.xm50_u11.nsg13_hv_pmos[ctype]
print @n.xbgr.xm50_u12.nsg13_hv_pmos[ide]
print @n.xbgr.xm50_u12.nsg13_hv_pmos[ige]
print @n.xbgr.xm50_u12.nsg13_hv_pmos[ise]
print @n.xbgr.xm50_u12.nsg13_hv_pmos[ibe]
print @n.xbgr.xm50_u12.nsg13_hv_pmos[ctype]
print @n.xbgr.xm50_u13.nsg13_hv_pmos[ide]
print @n.xbgr.xm50_u13.nsg13_hv_pmos[ige]
print @n.xbgr.xm50_u13.nsg13_hv_pmos[ise]
print @n.xbgr.xm50_u13.nsg13_hv_pmos[ibe]
print @n.xbgr.xm50_u13.nsg13_hv_pmos[ctype]
print @n.xbgr.xm50_u14.nsg13_hv_pmos[ide]
print @n.xbgr.xm50_u14.nsg13_hv_pmos[ige]
print @n.xbgr.xm50_u14.nsg13_hv_pmos[ise]
print @n.xbgr.xm50_u14.nsg13_hv_pmos[ibe]
print @n.xbgr.xm50_u14.nsg13_hv_pmos[ctype]
print @n.xbgr.xm50_u15.nsg13_hv_pmos[ide]
print @n.xbgr.xm50_u15.nsg13_hv_pmos[ige]
print @n.xbgr.xm50_u15.nsg13_hv_pmos[ise]
print @n.xbgr.xm50_u15.nsg13_hv_pmos[ibe]
print @n.xbgr.xm50_u15.nsg13_hv_pmos[ctype]
print @n.xbgr.xm50_u16.nsg13_hv_pmos[ide]
print @n.xbgr.xm50_u16.nsg13_hv_pmos[ige]
print @n.xbgr.xm50_u16.nsg13_hv_pmos[ise]
print @n.xbgr.xm50_u16.nsg13_hv_pmos[ibe]
print @n.xbgr.xm50_u16.nsg13_hv_pmos[ctype]
print @n.xbgr.xm50_u17.nsg13_hv_pmos[ide]
print @n.xbgr.xm50_u17.nsg13_hv_pmos[ige]
print @n.xbgr.xm50_u17.nsg13_hv_pmos[ise]
print @n.xbgr.xm50_u17.nsg13_hv_pmos[ibe]
print @n.xbgr.xm50_u17.nsg13_hv_pmos[ctype]
print @n.xbgr.xm50_u18.nsg13_hv_pmos[ide]
print @n.xbgr.xm50_u18.nsg13_hv_pmos[ige]
print @n.xbgr.xm50_u18.nsg13_hv_pmos[ise]
print @n.xbgr.xm50_u18.nsg13_hv_pmos[ibe]
print @n.xbgr.xm50_u18.nsg13_hv_pmos[ctype]
print @n.xbgr.xm50_u19.nsg13_hv_pmos[ide]
print @n.xbgr.xm50_u19.nsg13_hv_pmos[ige]
print @n.xbgr.xm50_u19.nsg13_hv_pmos[ise]
print @n.xbgr.xm50_u19.nsg13_hv_pmos[ibe]
print @n.xbgr.xm50_u19.nsg13_hv_pmos[ctype]
print @n.xbgr.xm50_u20.nsg13_hv_pmos[ide]
print @n.xbgr.xm50_u20.nsg13_hv_pmos[ige]
print @n.xbgr.xm50_u20.nsg13_hv_pmos[ise]
print @n.xbgr.xm50_u20.nsg13_hv_pmos[ibe]
print @n.xbgr.xm50_u20.nsg13_hv_pmos[ctype]
print @n.xbgr.xm50_u21.nsg13_hv_pmos[ide]
print @n.xbgr.xm50_u21.nsg13_hv_pmos[ige]
print @n.xbgr.xm50_u21.nsg13_hv_pmos[ise]
print @n.xbgr.xm50_u21.nsg13_hv_pmos[ibe]
print @n.xbgr.xm50_u21.nsg13_hv_pmos[ctype]
print @n.xbgr.xm50_u22.nsg13_hv_pmos[ide]
print @n.xbgr.xm50_u22.nsg13_hv_pmos[ige]
print @n.xbgr.xm50_u22.nsg13_hv_pmos[ise]
print @n.xbgr.xm50_u22.nsg13_hv_pmos[ibe]
print @n.xbgr.xm50_u22.nsg13_hv_pmos[ctype]
print @n.xbgr.xm50_u23.nsg13_hv_pmos[ide]
print @n.xbgr.xm50_u23.nsg13_hv_pmos[ige]
print @n.xbgr.xm50_u23.nsg13_hv_pmos[ise]
print @n.xbgr.xm50_u23.nsg13_hv_pmos[ibe]
print @n.xbgr.xm50_u23.nsg13_hv_pmos[ctype]
print @n.xbgr.xm50_u24.nsg13_hv_pmos[ide]
print @n.xbgr.xm50_u24.nsg13_hv_pmos[ige]
print @n.xbgr.xm50_u24.nsg13_hv_pmos[ise]
print @n.xbgr.xm50_u24.nsg13_hv_pmos[ibe]
print @n.xbgr.xm50_u24.nsg13_hv_pmos[ctype]
print @n.xbgr.xm51_u2.nsg13_hv_pmos[ide]
print @n.xbgr.xm51_u2.nsg13_hv_pmos[ige]
print @n.xbgr.xm51_u2.nsg13_hv_pmos[ise]
print @n.xbgr.xm51_u2.nsg13_hv_pmos[ibe]
print @n.xbgr.xm51_u2.nsg13_hv_pmos[ctype]
print @n.xbgr.xm51_u3.nsg13_hv_pmos[ide]
print @n.xbgr.xm51_u3.nsg13_hv_pmos[ige]
print @n.xbgr.xm51_u3.nsg13_hv_pmos[ise]
print @n.xbgr.xm51_u3.nsg13_hv_pmos[ibe]
print @n.xbgr.xm51_u3.nsg13_hv_pmos[ctype]
print @n.xbgr.xm51_u4.nsg13_hv_pmos[ide]
print @n.xbgr.xm51_u4.nsg13_hv_pmos[ige]
print @n.xbgr.xm51_u4.nsg13_hv_pmos[ise]
print @n.xbgr.xm51_u4.nsg13_hv_pmos[ibe]
print @n.xbgr.xm51_u4.nsg13_hv_pmos[ctype]
print @n.xbgr.xm52_u2.nsg13_hv_pmos[ide]
print @n.xbgr.xm52_u2.nsg13_hv_pmos[ige]
print @n.xbgr.xm52_u2.nsg13_hv_pmos[ise]
print @n.xbgr.xm52_u2.nsg13_hv_pmos[ibe]
print @n.xbgr.xm52_u2.nsg13_hv_pmos[ctype]
print @n.xbgr.xm52_u3.nsg13_hv_pmos[ide]
print @n.xbgr.xm52_u3.nsg13_hv_pmos[ige]
print @n.xbgr.xm52_u3.nsg13_hv_pmos[ise]
print @n.xbgr.xm52_u3.nsg13_hv_pmos[ibe]
print @n.xbgr.xm52_u3.nsg13_hv_pmos[ctype]
print @n.xbgr.xm52_u4.nsg13_hv_pmos[ide]
print @n.xbgr.xm52_u4.nsg13_hv_pmos[ige]
print @n.xbgr.xm52_u4.nsg13_hv_pmos[ise]
print @n.xbgr.xm52_u4.nsg13_hv_pmos[ibe]
print @n.xbgr.xm52_u4.nsg13_hv_pmos[ctype]
print @n.xbgr.xm52_u5.nsg13_hv_pmos[ide]
print @n.xbgr.xm52_u5.nsg13_hv_pmos[ige]
print @n.xbgr.xm52_u5.nsg13_hv_pmos[ise]
print @n.xbgr.xm52_u5.nsg13_hv_pmos[ibe]
print @n.xbgr.xm52_u5.nsg13_hv_pmos[ctype]
print @n.xbgr.xm52_u6.nsg13_hv_pmos[ide]
print @n.xbgr.xm52_u6.nsg13_hv_pmos[ige]
print @n.xbgr.xm52_u6.nsg13_hv_pmos[ise]
print @n.xbgr.xm52_u6.nsg13_hv_pmos[ibe]
print @n.xbgr.xm52_u6.nsg13_hv_pmos[ctype]
print @n.xbgr.xm52_u7.nsg13_hv_pmos[ide]
print @n.xbgr.xm52_u7.nsg13_hv_pmos[ige]
print @n.xbgr.xm52_u7.nsg13_hv_pmos[ise]
print @n.xbgr.xm52_u7.nsg13_hv_pmos[ibe]
print @n.xbgr.xm52_u7.nsg13_hv_pmos[ctype]
print @n.xbgr.xm52_u8.nsg13_hv_pmos[ide]
print @n.xbgr.xm52_u8.nsg13_hv_pmos[ige]
print @n.xbgr.xm52_u8.nsg13_hv_pmos[ise]
print @n.xbgr.xm52_u8.nsg13_hv_pmos[ibe]
print @n.xbgr.xm52_u8.nsg13_hv_pmos[ctype]
print @n.xbgr.xm52_u9.nsg13_hv_pmos[ide]
print @n.xbgr.xm52_u9.nsg13_hv_pmos[ige]
print @n.xbgr.xm52_u9.nsg13_hv_pmos[ise]
print @n.xbgr.xm52_u9.nsg13_hv_pmos[ibe]
print @n.xbgr.xm52_u9.nsg13_hv_pmos[ctype]
print @n.xbgr.xm52_u10.nsg13_hv_pmos[ide]
print @n.xbgr.xm52_u10.nsg13_hv_pmos[ige]
print @n.xbgr.xm52_u10.nsg13_hv_pmos[ise]
print @n.xbgr.xm52_u10.nsg13_hv_pmos[ibe]
print @n.xbgr.xm52_u10.nsg13_hv_pmos[ctype]
print @n.xbgr.xm52_u11.nsg13_hv_pmos[ide]
print @n.xbgr.xm52_u11.nsg13_hv_pmos[ige]
print @n.xbgr.xm52_u11.nsg13_hv_pmos[ise]
print @n.xbgr.xm52_u11.nsg13_hv_pmos[ibe]
print @n.xbgr.xm52_u11.nsg13_hv_pmos[ctype]
print @n.xbgr.xm52_u12.nsg13_hv_pmos[ide]
print @n.xbgr.xm52_u12.nsg13_hv_pmos[ige]
print @n.xbgr.xm52_u12.nsg13_hv_pmos[ise]
print @n.xbgr.xm52_u12.nsg13_hv_pmos[ibe]
print @n.xbgr.xm52_u12.nsg13_hv_pmos[ctype]
print @n.xbgr.xm52_u13.nsg13_hv_pmos[ide]
print @n.xbgr.xm52_u13.nsg13_hv_pmos[ige]
print @n.xbgr.xm52_u13.nsg13_hv_pmos[ise]
print @n.xbgr.xm52_u13.nsg13_hv_pmos[ibe]
print @n.xbgr.xm52_u13.nsg13_hv_pmos[ctype]
print @n.xbgr.xm52_u14.nsg13_hv_pmos[ide]
print @n.xbgr.xm52_u14.nsg13_hv_pmos[ige]
print @n.xbgr.xm52_u14.nsg13_hv_pmos[ise]
print @n.xbgr.xm52_u14.nsg13_hv_pmos[ibe]
print @n.xbgr.xm52_u14.nsg13_hv_pmos[ctype]
print @n.xbgr.xm52_u15.nsg13_hv_pmos[ide]
print @n.xbgr.xm52_u15.nsg13_hv_pmos[ige]
print @n.xbgr.xm52_u15.nsg13_hv_pmos[ise]
print @n.xbgr.xm52_u15.nsg13_hv_pmos[ibe]
print @n.xbgr.xm52_u15.nsg13_hv_pmos[ctype]
print @n.xbgr.xm52_u16.nsg13_hv_pmos[ide]
print @n.xbgr.xm52_u16.nsg13_hv_pmos[ige]
print @n.xbgr.xm52_u16.nsg13_hv_pmos[ise]
print @n.xbgr.xm52_u16.nsg13_hv_pmos[ibe]
print @n.xbgr.xm52_u16.nsg13_hv_pmos[ctype]
print @n.xbgr.xm52_u17.nsg13_hv_pmos[ide]
print @n.xbgr.xm52_u17.nsg13_hv_pmos[ige]
print @n.xbgr.xm52_u17.nsg13_hv_pmos[ise]
print @n.xbgr.xm52_u17.nsg13_hv_pmos[ibe]
print @n.xbgr.xm52_u17.nsg13_hv_pmos[ctype]
print @n.xbgr.xm52_u18.nsg13_hv_pmos[ide]
print @n.xbgr.xm52_u18.nsg13_hv_pmos[ige]
print @n.xbgr.xm52_u18.nsg13_hv_pmos[ise]
print @n.xbgr.xm52_u18.nsg13_hv_pmos[ibe]
print @n.xbgr.xm52_u18.nsg13_hv_pmos[ctype]
print @n.xbgr.xm52_u19.nsg13_hv_pmos[ide]
print @n.xbgr.xm52_u19.nsg13_hv_pmos[ige]
print @n.xbgr.xm52_u19.nsg13_hv_pmos[ise]
print @n.xbgr.xm52_u19.nsg13_hv_pmos[ibe]
print @n.xbgr.xm52_u19.nsg13_hv_pmos[ctype]
print @n.xbgr.xm52_u20.nsg13_hv_pmos[ide]
print @n.xbgr.xm52_u20.nsg13_hv_pmos[ige]
print @n.xbgr.xm52_u20.nsg13_hv_pmos[ise]
print @n.xbgr.xm52_u20.nsg13_hv_pmos[ibe]
print @n.xbgr.xm52_u20.nsg13_hv_pmos[ctype]
print @n.xbgr.xm52_u21.nsg13_hv_pmos[ide]
print @n.xbgr.xm52_u21.nsg13_hv_pmos[ige]
print @n.xbgr.xm52_u21.nsg13_hv_pmos[ise]
print @n.xbgr.xm52_u21.nsg13_hv_pmos[ibe]
print @n.xbgr.xm52_u21.nsg13_hv_pmos[ctype]
print @n.xbgr.xm52_u22.nsg13_hv_pmos[ide]
print @n.xbgr.xm52_u22.nsg13_hv_pmos[ige]
print @n.xbgr.xm52_u22.nsg13_hv_pmos[ise]
print @n.xbgr.xm52_u22.nsg13_hv_pmos[ibe]
print @n.xbgr.xm52_u22.nsg13_hv_pmos[ctype]
print @n.xbgr.xm52_u23.nsg13_hv_pmos[ide]
print @n.xbgr.xm52_u23.nsg13_hv_pmos[ige]
print @n.xbgr.xm52_u23.nsg13_hv_pmos[ise]
print @n.xbgr.xm52_u23.nsg13_hv_pmos[ibe]
print @n.xbgr.xm52_u23.nsg13_hv_pmos[ctype]
print @n.xbgr.xm52_u24.nsg13_hv_pmos[ide]
print @n.xbgr.xm52_u24.nsg13_hv_pmos[ige]
print @n.xbgr.xm52_u24.nsg13_hv_pmos[ise]
print @n.xbgr.xm52_u24.nsg13_hv_pmos[ibe]
print @n.xbgr.xm52_u24.nsg13_hv_pmos[ctype]
print @n.xbgr.xm54_u2.nsg13_hv_pmos[ide]
print @n.xbgr.xm54_u2.nsg13_hv_pmos[ige]
print @n.xbgr.xm54_u2.nsg13_hv_pmos[ise]
print @n.xbgr.xm54_u2.nsg13_hv_pmos[ibe]
print @n.xbgr.xm54_u2.nsg13_hv_pmos[ctype]
print @n.xbgr.xm54_u3.nsg13_hv_pmos[ide]
print @n.xbgr.xm54_u3.nsg13_hv_pmos[ige]
print @n.xbgr.xm54_u3.nsg13_hv_pmos[ise]
print @n.xbgr.xm54_u3.nsg13_hv_pmos[ibe]
print @n.xbgr.xm54_u3.nsg13_hv_pmos[ctype]
print @n.xbgr.xm54_u4.nsg13_hv_pmos[ide]
print @n.xbgr.xm54_u4.nsg13_hv_pmos[ige]
print @n.xbgr.xm54_u4.nsg13_hv_pmos[ise]
print @n.xbgr.xm54_u4.nsg13_hv_pmos[ibe]
print @n.xbgr.xm54_u4.nsg13_hv_pmos[ctype]
print @n.xbgr.xm54_u5.nsg13_hv_pmos[ide]
print @n.xbgr.xm54_u5.nsg13_hv_pmos[ige]
print @n.xbgr.xm54_u5.nsg13_hv_pmos[ise]
print @n.xbgr.xm54_u5.nsg13_hv_pmos[ibe]
print @n.xbgr.xm54_u5.nsg13_hv_pmos[ctype]
print @n.xbgr.xm54_u6.nsg13_hv_pmos[ide]
print @n.xbgr.xm54_u6.nsg13_hv_pmos[ige]
print @n.xbgr.xm54_u6.nsg13_hv_pmos[ise]
print @n.xbgr.xm54_u6.nsg13_hv_pmos[ibe]
print @n.xbgr.xm54_u6.nsg13_hv_pmos[ctype]
print @n.xbgr.xm54_u7.nsg13_hv_pmos[ide]
print @n.xbgr.xm54_u7.nsg13_hv_pmos[ige]
print @n.xbgr.xm54_u7.nsg13_hv_pmos[ise]
print @n.xbgr.xm54_u7.nsg13_hv_pmos[ibe]
print @n.xbgr.xm54_u7.nsg13_hv_pmos[ctype]
print @n.xbgr.xm54_u8.nsg13_hv_pmos[ide]
print @n.xbgr.xm54_u8.nsg13_hv_pmos[ige]
print @n.xbgr.xm54_u8.nsg13_hv_pmos[ise]
print @n.xbgr.xm54_u8.nsg13_hv_pmos[ibe]
print @n.xbgr.xm54_u8.nsg13_hv_pmos[ctype]
print @n.xbgr.xm54_u9.nsg13_hv_pmos[ide]
print @n.xbgr.xm54_u9.nsg13_hv_pmos[ige]
print @n.xbgr.xm54_u9.nsg13_hv_pmos[ise]
print @n.xbgr.xm54_u9.nsg13_hv_pmos[ibe]
print @n.xbgr.xm54_u9.nsg13_hv_pmos[ctype]
print @n.xbgr.xm54_u10.nsg13_hv_pmos[ide]
print @n.xbgr.xm54_u10.nsg13_hv_pmos[ige]
print @n.xbgr.xm54_u10.nsg13_hv_pmos[ise]
print @n.xbgr.xm54_u10.nsg13_hv_pmos[ibe]
print @n.xbgr.xm54_u10.nsg13_hv_pmos[ctype]
print @n.xbgr.xm54_u11.nsg13_hv_pmos[ide]
print @n.xbgr.xm54_u11.nsg13_hv_pmos[ige]
print @n.xbgr.xm54_u11.nsg13_hv_pmos[ise]
print @n.xbgr.xm54_u11.nsg13_hv_pmos[ibe]
print @n.xbgr.xm54_u11.nsg13_hv_pmos[ctype]
print @n.xbgr.xm54_u12.nsg13_hv_pmos[ide]
print @n.xbgr.xm54_u12.nsg13_hv_pmos[ige]
print @n.xbgr.xm54_u12.nsg13_hv_pmos[ise]
print @n.xbgr.xm54_u12.nsg13_hv_pmos[ibe]
print @n.xbgr.xm54_u12.nsg13_hv_pmos[ctype]
print @n.xbgr.xm54_u13.nsg13_hv_pmos[ide]
print @n.xbgr.xm54_u13.nsg13_hv_pmos[ige]
print @n.xbgr.xm54_u13.nsg13_hv_pmos[ise]
print @n.xbgr.xm54_u13.nsg13_hv_pmos[ibe]
print @n.xbgr.xm54_u13.nsg13_hv_pmos[ctype]
print @n.xbgr.xm54_u14.nsg13_hv_pmos[ide]
print @n.xbgr.xm54_u14.nsg13_hv_pmos[ige]
print @n.xbgr.xm54_u14.nsg13_hv_pmos[ise]
print @n.xbgr.xm54_u14.nsg13_hv_pmos[ibe]
print @n.xbgr.xm54_u14.nsg13_hv_pmos[ctype]
print @n.xbgr.xm54_u15.nsg13_hv_pmos[ide]
print @n.xbgr.xm54_u15.nsg13_hv_pmos[ige]
print @n.xbgr.xm54_u15.nsg13_hv_pmos[ise]
print @n.xbgr.xm54_u15.nsg13_hv_pmos[ibe]
print @n.xbgr.xm54_u15.nsg13_hv_pmos[ctype]
print @n.xbgr.xm54_u16.nsg13_hv_pmos[ide]
print @n.xbgr.xm54_u16.nsg13_hv_pmos[ige]
print @n.xbgr.xm54_u16.nsg13_hv_pmos[ise]
print @n.xbgr.xm54_u16.nsg13_hv_pmos[ibe]
print @n.xbgr.xm54_u16.nsg13_hv_pmos[ctype]
print @n.xbgr.xm54_u17.nsg13_hv_pmos[ide]
print @n.xbgr.xm54_u17.nsg13_hv_pmos[ige]
print @n.xbgr.xm54_u17.nsg13_hv_pmos[ise]
print @n.xbgr.xm54_u17.nsg13_hv_pmos[ibe]
print @n.xbgr.xm54_u17.nsg13_hv_pmos[ctype]
print @n.xbgr.xm54_u18.nsg13_hv_pmos[ide]
print @n.xbgr.xm54_u18.nsg13_hv_pmos[ige]
print @n.xbgr.xm54_u18.nsg13_hv_pmos[ise]
print @n.xbgr.xm54_u18.nsg13_hv_pmos[ibe]
print @n.xbgr.xm54_u18.nsg13_hv_pmos[ctype]
print @n.xbgr.xm54_u19.nsg13_hv_pmos[ide]
print @n.xbgr.xm54_u19.nsg13_hv_pmos[ige]
print @n.xbgr.xm54_u19.nsg13_hv_pmos[ise]
print @n.xbgr.xm54_u19.nsg13_hv_pmos[ibe]
print @n.xbgr.xm54_u19.nsg13_hv_pmos[ctype]
print @n.xbgr.xm54_u20.nsg13_hv_pmos[ide]
print @n.xbgr.xm54_u20.nsg13_hv_pmos[ige]
print @n.xbgr.xm54_u20.nsg13_hv_pmos[ise]
print @n.xbgr.xm54_u20.nsg13_hv_pmos[ibe]
print @n.xbgr.xm54_u20.nsg13_hv_pmos[ctype]
print @n.xbgr.xm54_u21.nsg13_hv_pmos[ide]
print @n.xbgr.xm54_u21.nsg13_hv_pmos[ige]
print @n.xbgr.xm54_u21.nsg13_hv_pmos[ise]
print @n.xbgr.xm54_u21.nsg13_hv_pmos[ibe]
print @n.xbgr.xm54_u21.nsg13_hv_pmos[ctype]
print @n.xbgr.xm54_u22.nsg13_hv_pmos[ide]
print @n.xbgr.xm54_u22.nsg13_hv_pmos[ige]
print @n.xbgr.xm54_u22.nsg13_hv_pmos[ise]
print @n.xbgr.xm54_u22.nsg13_hv_pmos[ibe]
print @n.xbgr.xm54_u22.nsg13_hv_pmos[ctype]
print @n.xbgr.xm54_u23.nsg13_hv_pmos[ide]
print @n.xbgr.xm54_u23.nsg13_hv_pmos[ige]
print @n.xbgr.xm54_u23.nsg13_hv_pmos[ise]
print @n.xbgr.xm54_u23.nsg13_hv_pmos[ibe]
print @n.xbgr.xm54_u23.nsg13_hv_pmos[ctype]
print @n.xbgr.xm54_u24.nsg13_hv_pmos[ide]
print @n.xbgr.xm54_u24.nsg13_hv_pmos[ige]
print @n.xbgr.xm54_u24.nsg13_hv_pmos[ise]
print @n.xbgr.xm54_u24.nsg13_hv_pmos[ibe]
print @n.xbgr.xm54_u24.nsg13_hv_pmos[ctype]
print @q.xbgr.xq56_u2.qnpn13g2[ic]
print @q.xbgr.xq56_u2.qnpn13g2[ib]
print @q.xbgr.xq56_u2.qnpn13g2[ie]
print @q.xbgr.xq56_u2.qnpn13g2[is]
print @r.xbgr.xq56_u2.rsub[i]
print @c.xbgr.xq56_u2.csub[i]
print @q.xbgr.xq56_u3.qnpn13g2[ic]
print @q.xbgr.xq56_u3.qnpn13g2[ib]
print @q.xbgr.xq56_u3.qnpn13g2[ie]
print @q.xbgr.xq56_u3.qnpn13g2[is]
print @r.xbgr.xq56_u3.rsub[i]
print @c.xbgr.xq56_u3.csub[i]
print @q.xbgr.xq56_u4.qnpn13g2[ic]
print @q.xbgr.xq56_u4.qnpn13g2[ib]
print @q.xbgr.xq56_u4.qnpn13g2[ie]
print @q.xbgr.xq56_u4.qnpn13g2[is]
print @r.xbgr.xq56_u4.rsub[i]
print @c.xbgr.xq56_u4.csub[i]
print @q.xbgr.xq56_u5.qnpn13g2[ic]
print @q.xbgr.xq56_u5.qnpn13g2[ib]
print @q.xbgr.xq56_u5.qnpn13g2[ie]
print @q.xbgr.xq56_u5.qnpn13g2[is]
print @r.xbgr.xq56_u5.rsub[i]
print @c.xbgr.xq56_u5.csub[i]
print @q.xbgr.xq56_u6.qnpn13g2[ic]
print @q.xbgr.xq56_u6.qnpn13g2[ib]
print @q.xbgr.xq56_u6.qnpn13g2[ie]
print @q.xbgr.xq56_u6.qnpn13g2[is]
print @r.xbgr.xq56_u6.rsub[i]
print @c.xbgr.xq56_u6.csub[i]
print @q.xbgr.xq56_u7.qnpn13g2[ic]
print @q.xbgr.xq56_u7.qnpn13g2[ib]
print @q.xbgr.xq56_u7.qnpn13g2[ie]
print @q.xbgr.xq56_u7.qnpn13g2[is]
print @r.xbgr.xq56_u7.rsub[i]
print @c.xbgr.xq56_u7.csub[i]
print @q.xbgr.xq56_u8.qnpn13g2[ic]
print @q.xbgr.xq56_u8.qnpn13g2[ib]
print @q.xbgr.xq56_u8.qnpn13g2[ie]
print @q.xbgr.xq56_u8.qnpn13g2[is]
print @r.xbgr.xq56_u8.rsub[i]
print @c.xbgr.xq56_u8.csub[i]
print @q.xbgr.xq56_u9.qnpn13g2[ic]
print @q.xbgr.xq56_u9.qnpn13g2[ib]
print @q.xbgr.xq56_u9.qnpn13g2[ie]
print @q.xbgr.xq56_u9.qnpn13g2[is]
print @r.xbgr.xq56_u9.rsub[i]
print @c.xbgr.xq56_u9.csub[i]
print @q.xbgr.xq56_u10.qnpn13g2[ic]
print @q.xbgr.xq56_u10.qnpn13g2[ib]
print @q.xbgr.xq56_u10.qnpn13g2[ie]
print @q.xbgr.xq56_u10.qnpn13g2[is]
print @r.xbgr.xq56_u10.rsub[i]
print @c.xbgr.xq56_u10.csub[i]
print @q.xbgr.xq56_u11.qnpn13g2[ic]
print @q.xbgr.xq56_u11.qnpn13g2[ib]
print @q.xbgr.xq56_u11.qnpn13g2[ie]
print @q.xbgr.xq56_u11.qnpn13g2[is]
print @r.xbgr.xq56_u11.rsub[i]
print @c.xbgr.xq56_u11.csub[i]
print @q.xbgr.xq56_u12.qnpn13g2[ic]
print @q.xbgr.xq56_u12.qnpn13g2[ib]
print @q.xbgr.xq56_u12.qnpn13g2[ie]
print @q.xbgr.xq56_u12.qnpn13g2[is]
print @r.xbgr.xq56_u12.rsub[i]
print @c.xbgr.xq56_u12.csub[i]
print @q.xbgr.xq56_u13.qnpn13g2[ic]
print @q.xbgr.xq56_u13.qnpn13g2[ib]
print @q.xbgr.xq56_u13.qnpn13g2[ie]
print @q.xbgr.xq56_u13.qnpn13g2[is]
print @r.xbgr.xq56_u13.rsub[i]
print @c.xbgr.xq56_u13.csub[i]
print @q.xbgr.xq56_u14.qnpn13g2[ic]
print @q.xbgr.xq56_u14.qnpn13g2[ib]
print @q.xbgr.xq56_u14.qnpn13g2[ie]
print @q.xbgr.xq56_u14.qnpn13g2[is]
print @r.xbgr.xq56_u14.rsub[i]
print @c.xbgr.xq56_u14.csub[i]
print @q.xbgr.xq56_u15.qnpn13g2[ic]
print @q.xbgr.xq56_u15.qnpn13g2[ib]
print @q.xbgr.xq56_u15.qnpn13g2[ie]
print @q.xbgr.xq56_u15.qnpn13g2[is]
print @r.xbgr.xq56_u15.rsub[i]
print @c.xbgr.xq56_u15.csub[i]
print @q.xbgr.xq56_u16.qnpn13g2[ic]
print @q.xbgr.xq56_u16.qnpn13g2[ib]
print @q.xbgr.xq56_u16.qnpn13g2[ie]
print @q.xbgr.xq56_u16.qnpn13g2[is]
print @r.xbgr.xq56_u16.rsub[i]
print @c.xbgr.xq56_u16.csub[i]
print @q.xbgr.xq56_u17.qnpn13g2[ic]
print @q.xbgr.xq56_u17.qnpn13g2[ib]
print @q.xbgr.xq56_u17.qnpn13g2[ie]
print @q.xbgr.xq56_u17.qnpn13g2[is]
print @r.xbgr.xq56_u17.rsub[i]
print @c.xbgr.xq56_u17.csub[i]
print @q.xbgr.xq56_u18.qnpn13g2[ic]
print @q.xbgr.xq56_u18.qnpn13g2[ib]
print @q.xbgr.xq56_u18.qnpn13g2[ie]
print @q.xbgr.xq56_u18.qnpn13g2[is]
print @r.xbgr.xq56_u18.rsub[i]
print @c.xbgr.xq56_u18.csub[i]
print @q.xbgr.xq56_u19.qnpn13g2[ic]
print @q.xbgr.xq56_u19.qnpn13g2[ib]
print @q.xbgr.xq56_u19.qnpn13g2[ie]
print @q.xbgr.xq56_u19.qnpn13g2[is]
print @r.xbgr.xq56_u19.rsub[i]
print @c.xbgr.xq56_u19.csub[i]
print @q.xbgr.xq56_u20.qnpn13g2[ic]
print @q.xbgr.xq56_u20.qnpn13g2[ib]
print @q.xbgr.xq56_u20.qnpn13g2[ie]
print @q.xbgr.xq56_u20.qnpn13g2[is]
print @r.xbgr.xq56_u20.rsub[i]
print @c.xbgr.xq56_u20.csub[i]
print @q.xbgr.xq56_u21.qnpn13g2[ic]
print @q.xbgr.xq56_u21.qnpn13g2[ib]
print @q.xbgr.xq56_u21.qnpn13g2[ie]
print @q.xbgr.xq56_u21.qnpn13g2[is]
print @r.xbgr.xq56_u21.rsub[i]
print @c.xbgr.xq56_u21.csub[i]
print @q.xbgr.xq56_u22.qnpn13g2[ic]
print @q.xbgr.xq56_u22.qnpn13g2[ib]
print @q.xbgr.xq56_u22.qnpn13g2[ie]
print @q.xbgr.xq56_u22.qnpn13g2[is]
print @r.xbgr.xq56_u22.rsub[i]
print @c.xbgr.xq56_u22.csub[i]
print @q.xbgr.xq56_u23.qnpn13g2[ic]
print @q.xbgr.xq56_u23.qnpn13g2[ib]
print @q.xbgr.xq56_u23.qnpn13g2[ie]
print @q.xbgr.xq56_u23.qnpn13g2[is]
print @r.xbgr.xq56_u23.rsub[i]
print @c.xbgr.xq56_u23.csub[i]
print @q.xbgr.xq56_u24.qnpn13g2[ic]
print @q.xbgr.xq56_u24.qnpn13g2[ib]
print @q.xbgr.xq56_u24.qnpn13g2[ie]
print @q.xbgr.xq56_u24.qnpn13g2[is]
print @r.xbgr.xq56_u24.rsub[i]
print @c.xbgr.xq56_u24.csub[i]
print @q.xbgr.xq60_u2.qnpn13g2[ic]
print @q.xbgr.xq60_u2.qnpn13g2[ib]
print @q.xbgr.xq60_u2.qnpn13g2[ie]
print @q.xbgr.xq60_u2.qnpn13g2[is]
print @r.xbgr.xq60_u2.rsub[i]
print @c.xbgr.xq60_u2.csub[i]
print @q.xbgr.xq60_u3.qnpn13g2[ic]
print @q.xbgr.xq60_u3.qnpn13g2[ib]
print @q.xbgr.xq60_u3.qnpn13g2[ie]
print @q.xbgr.xq60_u3.qnpn13g2[is]
print @r.xbgr.xq60_u3.rsub[i]
print @c.xbgr.xq60_u3.csub[i]
print @q.xbgr.xq60_u4.qnpn13g2[ic]
print @q.xbgr.xq60_u4.qnpn13g2[ib]
print @q.xbgr.xq60_u4.qnpn13g2[ie]
print @q.xbgr.xq60_u4.qnpn13g2[is]
print @r.xbgr.xq60_u4.rsub[i]
print @c.xbgr.xq60_u4.csub[i]
print @q.xbgr.xq62_u2.qnpn13g2[ic]
print @q.xbgr.xq62_u2.qnpn13g2[ib]
print @q.xbgr.xq62_u2.qnpn13g2[ie]
print @q.xbgr.xq62_u2.qnpn13g2[is]
print @r.xbgr.xq62_u2.rsub[i]
print @c.xbgr.xq62_u2.csub[i]
print @q.xbgr.xq62_u3.qnpn13g2[ic]
print @q.xbgr.xq62_u3.qnpn13g2[ib]
print @q.xbgr.xq62_u3.qnpn13g2[ie]
print @q.xbgr.xq62_u3.qnpn13g2[is]
print @r.xbgr.xq62_u3.rsub[i]
print @c.xbgr.xq62_u3.csub[i]
print @q.xbgr.xq62_u4.qnpn13g2[ic]
print @q.xbgr.xq62_u4.qnpn13g2[ib]
print @q.xbgr.xq62_u4.qnpn13g2[ie]
print @q.xbgr.xq62_u4.qnpn13g2[is]
print @r.xbgr.xq62_u4.rsub[i]
print @c.xbgr.xq62_u4.csub[i]
print @q.xbgr.xq62_u5.qnpn13g2[ic]
print @q.xbgr.xq62_u5.qnpn13g2[ib]
print @q.xbgr.xq62_u5.qnpn13g2[ie]
print @q.xbgr.xq62_u5.qnpn13g2[is]
print @r.xbgr.xq62_u5.rsub[i]
print @c.xbgr.xq62_u5.csub[i]
print @q.xbgr.xq62_u6.qnpn13g2[ic]
print @q.xbgr.xq62_u6.qnpn13g2[ib]
print @q.xbgr.xq62_u6.qnpn13g2[ie]
print @q.xbgr.xq62_u6.qnpn13g2[is]
print @r.xbgr.xq62_u6.rsub[i]
print @c.xbgr.xq62_u6.csub[i]
print @q.xbgr.xq62_u7.qnpn13g2[ic]
print @q.xbgr.xq62_u7.qnpn13g2[ib]
print @q.xbgr.xq62_u7.qnpn13g2[ie]
print @q.xbgr.xq62_u7.qnpn13g2[is]
print @r.xbgr.xq62_u7.rsub[i]
print @c.xbgr.xq62_u7.csub[i]
print @q.xbgr.xq62_u8.qnpn13g2[ic]
print @q.xbgr.xq62_u8.qnpn13g2[ib]
print @q.xbgr.xq62_u8.qnpn13g2[ie]
print @q.xbgr.xq62_u8.qnpn13g2[is]
print @r.xbgr.xq62_u8.rsub[i]
print @c.xbgr.xq62_u8.csub[i]
print @q.xbgr.xq62_u9.qnpn13g2[ic]
print @q.xbgr.xq62_u9.qnpn13g2[ib]
print @q.xbgr.xq62_u9.qnpn13g2[ie]
print @q.xbgr.xq62_u9.qnpn13g2[is]
print @r.xbgr.xq62_u9.rsub[i]
print @c.xbgr.xq62_u9.csub[i]
print @q.xbgr.xq62_u10.qnpn13g2[ic]
print @q.xbgr.xq62_u10.qnpn13g2[ib]
print @q.xbgr.xq62_u10.qnpn13g2[ie]
print @q.xbgr.xq62_u10.qnpn13g2[is]
print @r.xbgr.xq62_u10.rsub[i]
print @c.xbgr.xq62_u10.csub[i]
print @q.xbgr.xq62_u11.qnpn13g2[ic]
print @q.xbgr.xq62_u11.qnpn13g2[ib]
print @q.xbgr.xq62_u11.qnpn13g2[ie]
print @q.xbgr.xq62_u11.qnpn13g2[is]
print @r.xbgr.xq62_u11.rsub[i]
print @c.xbgr.xq62_u11.csub[i]
print @q.xbgr.xq62_u12.qnpn13g2[ic]
print @q.xbgr.xq62_u12.qnpn13g2[ib]
print @q.xbgr.xq62_u12.qnpn13g2[ie]
print @q.xbgr.xq62_u12.qnpn13g2[is]
print @r.xbgr.xq62_u12.rsub[i]
print @c.xbgr.xq62_u12.csub[i]
print @q.xbgr.xq62_u13.qnpn13g2[ic]
print @q.xbgr.xq62_u13.qnpn13g2[ib]
print @q.xbgr.xq62_u13.qnpn13g2[ie]
print @q.xbgr.xq62_u13.qnpn13g2[is]
print @r.xbgr.xq62_u13.rsub[i]
print @c.xbgr.xq62_u13.csub[i]
print @q.xbgr.xq62_u14.qnpn13g2[ic]
print @q.xbgr.xq62_u14.qnpn13g2[ib]
print @q.xbgr.xq62_u14.qnpn13g2[ie]
print @q.xbgr.xq62_u14.qnpn13g2[is]
print @r.xbgr.xq62_u14.rsub[i]
print @c.xbgr.xq62_u14.csub[i]
print @q.xbgr.xq62_u15.qnpn13g2[ic]
print @q.xbgr.xq62_u15.qnpn13g2[ib]
print @q.xbgr.xq62_u15.qnpn13g2[ie]
print @q.xbgr.xq62_u15.qnpn13g2[is]
print @r.xbgr.xq62_u15.rsub[i]
print @c.xbgr.xq62_u15.csub[i]
print @q.xbgr.xq62_u16.qnpn13g2[ic]
print @q.xbgr.xq62_u16.qnpn13g2[ib]
print @q.xbgr.xq62_u16.qnpn13g2[ie]
print @q.xbgr.xq62_u16.qnpn13g2[is]
print @r.xbgr.xq62_u16.rsub[i]
print @c.xbgr.xq62_u16.csub[i]
print @q.xbgr.xq62_u17.qnpn13g2[ic]
print @q.xbgr.xq62_u17.qnpn13g2[ib]
print @q.xbgr.xq62_u17.qnpn13g2[ie]
print @q.xbgr.xq62_u17.qnpn13g2[is]
print @r.xbgr.xq62_u17.rsub[i]
print @c.xbgr.xq62_u17.csub[i]
print @q.xbgr.xq62_u18.qnpn13g2[ic]
print @q.xbgr.xq62_u18.qnpn13g2[ib]
print @q.xbgr.xq62_u18.qnpn13g2[ie]
print @q.xbgr.xq62_u18.qnpn13g2[is]
print @r.xbgr.xq62_u18.rsub[i]
print @c.xbgr.xq62_u18.csub[i]
print @q.xbgr.xq62_u19.qnpn13g2[ic]
print @q.xbgr.xq62_u19.qnpn13g2[ib]
print @q.xbgr.xq62_u19.qnpn13g2[ie]
print @q.xbgr.xq62_u19.qnpn13g2[is]
print @r.xbgr.xq62_u19.rsub[i]
print @c.xbgr.xq62_u19.csub[i]
print @q.xbgr.xq62_u20.qnpn13g2[ic]
print @q.xbgr.xq62_u20.qnpn13g2[ib]
print @q.xbgr.xq62_u20.qnpn13g2[ie]
print @q.xbgr.xq62_u20.qnpn13g2[is]
print @r.xbgr.xq62_u20.rsub[i]
print @c.xbgr.xq62_u20.csub[i]
print @q.xbgr.xq62_u21.qnpn13g2[ic]
print @q.xbgr.xq62_u21.qnpn13g2[ib]
print @q.xbgr.xq62_u21.qnpn13g2[ie]
print @q.xbgr.xq62_u21.qnpn13g2[is]
print @r.xbgr.xq62_u21.rsub[i]
print @c.xbgr.xq62_u21.csub[i]
print @q.xbgr.xq62_u22.qnpn13g2[ic]
print @q.xbgr.xq62_u22.qnpn13g2[ib]
print @q.xbgr.xq62_u22.qnpn13g2[ie]
print @q.xbgr.xq62_u22.qnpn13g2[is]
print @r.xbgr.xq62_u22.rsub[i]
print @c.xbgr.xq62_u22.csub[i]
print @q.xbgr.xq62_u23.qnpn13g2[ic]
print @q.xbgr.xq62_u23.qnpn13g2[ib]
print @q.xbgr.xq62_u23.qnpn13g2[ie]
print @q.xbgr.xq62_u23.qnpn13g2[is]
print @r.xbgr.xq62_u23.rsub[i]
print @c.xbgr.xq62_u23.csub[i]
print @q.xbgr.xq62_u24.qnpn13g2[ic]
print @q.xbgr.xq62_u24.qnpn13g2[ib]
print @q.xbgr.xq62_u24.qnpn13g2[ie]
print @q.xbgr.xq62_u24.qnpn13g2[is]
print @r.xbgr.xq62_u24.rsub[i]
print @c.xbgr.xq62_u24.csub[i]
print @q.xbgr.xq67_u2.qnpn13g2[ic]
print @q.xbgr.xq67_u2.qnpn13g2[ib]
print @q.xbgr.xq67_u2.qnpn13g2[ie]
print @q.xbgr.xq67_u2.qnpn13g2[is]
print @r.xbgr.xq67_u2.rsub[i]
print @c.xbgr.xq67_u2.csub[i]
print @q.xbgr.xq67_u3.qnpn13g2[ic]
print @q.xbgr.xq67_u3.qnpn13g2[ib]
print @q.xbgr.xq67_u3.qnpn13g2[ie]
print @q.xbgr.xq67_u3.qnpn13g2[is]
print @r.xbgr.xq67_u3.rsub[i]
print @c.xbgr.xq67_u3.csub[i]
print @q.xbgr.xq67_u4.qnpn13g2[ic]
print @q.xbgr.xq67_u4.qnpn13g2[ib]
print @q.xbgr.xq67_u4.qnpn13g2[ie]
print @q.xbgr.xq67_u4.qnpn13g2[is]
print @r.xbgr.xq67_u4.rsub[i]
print @c.xbgr.xq67_u4.csub[i]
print @q.xbgr.xq67_u5.qnpn13g2[ic]
print @q.xbgr.xq67_u5.qnpn13g2[ib]
print @q.xbgr.xq67_u5.qnpn13g2[ie]
print @q.xbgr.xq67_u5.qnpn13g2[is]
print @r.xbgr.xq67_u5.rsub[i]
print @c.xbgr.xq67_u5.csub[i]
print @q.xbgr.xq67_u6.qnpn13g2[ic]
print @q.xbgr.xq67_u6.qnpn13g2[ib]
print @q.xbgr.xq67_u6.qnpn13g2[ie]
print @q.xbgr.xq67_u6.qnpn13g2[is]
print @r.xbgr.xq67_u6.rsub[i]
print @c.xbgr.xq67_u6.csub[i]
print @q.xbgr.xq67_u7.qnpn13g2[ic]
print @q.xbgr.xq67_u7.qnpn13g2[ib]
print @q.xbgr.xq67_u7.qnpn13g2[ie]
print @q.xbgr.xq67_u7.qnpn13g2[is]
print @r.xbgr.xq67_u7.rsub[i]
print @c.xbgr.xq67_u7.csub[i]
print @q.xbgr.xq67_u8.qnpn13g2[ic]
print @q.xbgr.xq67_u8.qnpn13g2[ib]
print @q.xbgr.xq67_u8.qnpn13g2[ie]
print @q.xbgr.xq67_u8.qnpn13g2[is]
print @r.xbgr.xq67_u8.rsub[i]
print @c.xbgr.xq67_u8.csub[i]
print @q.xbgr.xq67_u9.qnpn13g2[ic]
print @q.xbgr.xq67_u9.qnpn13g2[ib]
print @q.xbgr.xq67_u9.qnpn13g2[ie]
print @q.xbgr.xq67_u9.qnpn13g2[is]
print @r.xbgr.xq67_u9.rsub[i]
print @c.xbgr.xq67_u9.csub[i]
print @q.xbgr.xq67_u10.qnpn13g2[ic]
print @q.xbgr.xq67_u10.qnpn13g2[ib]
print @q.xbgr.xq67_u10.qnpn13g2[ie]
print @q.xbgr.xq67_u10.qnpn13g2[is]
print @r.xbgr.xq67_u10.rsub[i]
print @c.xbgr.xq67_u10.csub[i]
print @q.xbgr.xq67_u11.qnpn13g2[ic]
print @q.xbgr.xq67_u11.qnpn13g2[ib]
print @q.xbgr.xq67_u11.qnpn13g2[ie]
print @q.xbgr.xq67_u11.qnpn13g2[is]
print @r.xbgr.xq67_u11.rsub[i]
print @c.xbgr.xq67_u11.csub[i]
print @q.xbgr.xq67_u12.qnpn13g2[ic]
print @q.xbgr.xq67_u12.qnpn13g2[ib]
print @q.xbgr.xq67_u12.qnpn13g2[ie]
print @q.xbgr.xq67_u12.qnpn13g2[is]
print @r.xbgr.xq67_u12.rsub[i]
print @c.xbgr.xq67_u12.csub[i]
print @q.xbgr.xq67_u13.qnpn13g2[ic]
print @q.xbgr.xq67_u13.qnpn13g2[ib]
print @q.xbgr.xq67_u13.qnpn13g2[ie]
print @q.xbgr.xq67_u13.qnpn13g2[is]
print @r.xbgr.xq67_u13.rsub[i]
print @c.xbgr.xq67_u13.csub[i]
print @q.xbgr.xq67_u14.qnpn13g2[ic]
print @q.xbgr.xq67_u14.qnpn13g2[ib]
print @q.xbgr.xq67_u14.qnpn13g2[ie]
print @q.xbgr.xq67_u14.qnpn13g2[is]
print @r.xbgr.xq67_u14.rsub[i]
print @c.xbgr.xq67_u14.csub[i]
print @q.xbgr.xq67_u15.qnpn13g2[ic]
print @q.xbgr.xq67_u15.qnpn13g2[ib]
print @q.xbgr.xq67_u15.qnpn13g2[ie]
print @q.xbgr.xq67_u15.qnpn13g2[is]
print @r.xbgr.xq67_u15.rsub[i]
print @c.xbgr.xq67_u15.csub[i]
print @q.xbgr.xq67_u16.qnpn13g2[ic]
print @q.xbgr.xq67_u16.qnpn13g2[ib]
print @q.xbgr.xq67_u16.qnpn13g2[ie]
print @q.xbgr.xq67_u16.qnpn13g2[is]
print @r.xbgr.xq67_u16.rsub[i]
print @c.xbgr.xq67_u16.csub[i]
print @q.xbgr.xq67_u17.qnpn13g2[ic]
print @q.xbgr.xq67_u17.qnpn13g2[ib]
print @q.xbgr.xq67_u17.qnpn13g2[ie]
print @q.xbgr.xq67_u17.qnpn13g2[is]
print @r.xbgr.xq67_u17.rsub[i]
print @c.xbgr.xq67_u17.csub[i]
print @q.xbgr.xq67_u18.qnpn13g2[ic]
print @q.xbgr.xq67_u18.qnpn13g2[ib]
print @q.xbgr.xq67_u18.qnpn13g2[ie]
print @q.xbgr.xq67_u18.qnpn13g2[is]
print @r.xbgr.xq67_u18.rsub[i]
print @c.xbgr.xq67_u18.csub[i]
print @q.xbgr.xq67_u19.qnpn13g2[ic]
print @q.xbgr.xq67_u19.qnpn13g2[ib]
print @q.xbgr.xq67_u19.qnpn13g2[ie]
print @q.xbgr.xq67_u19.qnpn13g2[is]
print @r.xbgr.xq67_u19.rsub[i]
print @c.xbgr.xq67_u19.csub[i]
print @q.xbgr.xq67_u20.qnpn13g2[ic]
print @q.xbgr.xq67_u20.qnpn13g2[ib]
print @q.xbgr.xq67_u20.qnpn13g2[ie]
print @q.xbgr.xq67_u20.qnpn13g2[is]
print @r.xbgr.xq67_u20.rsub[i]
print @c.xbgr.xq67_u20.csub[i]
print @q.xbgr.xq67_u21.qnpn13g2[ic]
print @q.xbgr.xq67_u21.qnpn13g2[ib]
print @q.xbgr.xq67_u21.qnpn13g2[ie]
print @q.xbgr.xq67_u21.qnpn13g2[is]
print @r.xbgr.xq67_u21.rsub[i]
print @c.xbgr.xq67_u21.csub[i]
print @q.xbgr.xq67_u22.qnpn13g2[ic]
print @q.xbgr.xq67_u22.qnpn13g2[ib]
print @q.xbgr.xq67_u22.qnpn13g2[ie]
print @q.xbgr.xq67_u22.qnpn13g2[is]
print @r.xbgr.xq67_u22.rsub[i]
print @c.xbgr.xq67_u22.csub[i]
print @q.xbgr.xq67_u23.qnpn13g2[ic]
print @q.xbgr.xq67_u23.qnpn13g2[ib]
print @q.xbgr.xq67_u23.qnpn13g2[ie]
print @q.xbgr.xq67_u23.qnpn13g2[is]
print @r.xbgr.xq67_u23.rsub[i]
print @c.xbgr.xq67_u23.csub[i]
print @q.xbgr.xq67_u24.qnpn13g2[ic]
print @q.xbgr.xq67_u24.qnpn13g2[ib]
print @q.xbgr.xq67_u24.qnpn13g2[ie]
print @q.xbgr.xq67_u24.qnpn13g2[is]
print @r.xbgr.xq67_u24.rsub[i]
print @c.xbgr.xq67_u24.csub[i]
print @q.xbgr.xq68_u2.qnpn13g2[ic]
print @q.xbgr.xq68_u2.qnpn13g2[ib]
print @q.xbgr.xq68_u2.qnpn13g2[ie]
print @q.xbgr.xq68_u2.qnpn13g2[is]
print @r.xbgr.xq68_u2.rsub[i]
print @c.xbgr.xq68_u2.csub[i]
print @q.xbgr.xq68_u3.qnpn13g2[ic]
print @q.xbgr.xq68_u3.qnpn13g2[ib]
print @q.xbgr.xq68_u3.qnpn13g2[ie]
print @q.xbgr.xq68_u3.qnpn13g2[is]
print @r.xbgr.xq68_u3.rsub[i]
print @c.xbgr.xq68_u3.csub[i]
print @q.xbgr.xq68_u4.qnpn13g2[ic]
print @q.xbgr.xq68_u4.qnpn13g2[ib]
print @q.xbgr.xq68_u4.qnpn13g2[ie]
print @q.xbgr.xq68_u4.qnpn13g2[is]
print @r.xbgr.xq68_u4.rsub[i]
print @c.xbgr.xq68_u4.csub[i]
print @q.xbgr.xq68_u5.qnpn13g2[ic]
print @q.xbgr.xq68_u5.qnpn13g2[ib]
print @q.xbgr.xq68_u5.qnpn13g2[ie]
print @q.xbgr.xq68_u5.qnpn13g2[is]
print @r.xbgr.xq68_u5.rsub[i]
print @c.xbgr.xq68_u5.csub[i]
print @q.xbgr.xq68_u6.qnpn13g2[ic]
print @q.xbgr.xq68_u6.qnpn13g2[ib]
print @q.xbgr.xq68_u6.qnpn13g2[ie]
print @q.xbgr.xq68_u6.qnpn13g2[is]
print @r.xbgr.xq68_u6.rsub[i]
print @c.xbgr.xq68_u6.csub[i]
print @q.xbgr.xq68_u7.qnpn13g2[ic]
print @q.xbgr.xq68_u7.qnpn13g2[ib]
print @q.xbgr.xq68_u7.qnpn13g2[ie]
print @q.xbgr.xq68_u7.qnpn13g2[is]
print @r.xbgr.xq68_u7.rsub[i]
print @c.xbgr.xq68_u7.csub[i]
print @q.xbgr.xq68_u8.qnpn13g2[ic]
print @q.xbgr.xq68_u8.qnpn13g2[ib]
print @q.xbgr.xq68_u8.qnpn13g2[ie]
print @q.xbgr.xq68_u8.qnpn13g2[is]
print @r.xbgr.xq68_u8.rsub[i]
print @c.xbgr.xq68_u8.csub[i]
print @q.xbgr.xq68_u9.qnpn13g2[ic]
print @q.xbgr.xq68_u9.qnpn13g2[ib]
print @q.xbgr.xq68_u9.qnpn13g2[ie]
print @q.xbgr.xq68_u9.qnpn13g2[is]
print @r.xbgr.xq68_u9.rsub[i]
print @c.xbgr.xq68_u9.csub[i]
print @q.xbgr.xq68_u10.qnpn13g2[ic]
print @q.xbgr.xq68_u10.qnpn13g2[ib]
print @q.xbgr.xq68_u10.qnpn13g2[ie]
print @q.xbgr.xq68_u10.qnpn13g2[is]
print @r.xbgr.xq68_u10.rsub[i]
print @c.xbgr.xq68_u10.csub[i]
print @q.xbgr.xq68_u11.qnpn13g2[ic]
print @q.xbgr.xq68_u11.qnpn13g2[ib]
print @q.xbgr.xq68_u11.qnpn13g2[ie]
print @q.xbgr.xq68_u11.qnpn13g2[is]
print @r.xbgr.xq68_u11.rsub[i]
print @c.xbgr.xq68_u11.csub[i]
print @q.xbgr.xq68_u12.qnpn13g2[ic]
print @q.xbgr.xq68_u12.qnpn13g2[ib]
print @q.xbgr.xq68_u12.qnpn13g2[ie]
print @q.xbgr.xq68_u12.qnpn13g2[is]
print @r.xbgr.xq68_u12.rsub[i]
print @c.xbgr.xq68_u12.csub[i]
print @q.xbgr.xq68_u13.qnpn13g2[ic]
print @q.xbgr.xq68_u13.qnpn13g2[ib]
print @q.xbgr.xq68_u13.qnpn13g2[ie]
print @q.xbgr.xq68_u13.qnpn13g2[is]
print @r.xbgr.xq68_u13.rsub[i]
print @c.xbgr.xq68_u13.csub[i]
print @q.xbgr.xq68_u14.qnpn13g2[ic]
print @q.xbgr.xq68_u14.qnpn13g2[ib]
print @q.xbgr.xq68_u14.qnpn13g2[ie]
print @q.xbgr.xq68_u14.qnpn13g2[is]
print @r.xbgr.xq68_u14.rsub[i]
print @c.xbgr.xq68_u14.csub[i]
print @q.xbgr.xq68_u15.qnpn13g2[ic]
print @q.xbgr.xq68_u15.qnpn13g2[ib]
print @q.xbgr.xq68_u15.qnpn13g2[ie]
print @q.xbgr.xq68_u15.qnpn13g2[is]
print @r.xbgr.xq68_u15.rsub[i]
print @c.xbgr.xq68_u15.csub[i]
print @q.xbgr.xq68_u16.qnpn13g2[ic]
print @q.xbgr.xq68_u16.qnpn13g2[ib]
print @q.xbgr.xq68_u16.qnpn13g2[ie]
print @q.xbgr.xq68_u16.qnpn13g2[is]
print @r.xbgr.xq68_u16.rsub[i]
print @c.xbgr.xq68_u16.csub[i]
print @q.xbgr.xq68_u17.qnpn13g2[ic]
print @q.xbgr.xq68_u17.qnpn13g2[ib]
print @q.xbgr.xq68_u17.qnpn13g2[ie]
print @q.xbgr.xq68_u17.qnpn13g2[is]
print @r.xbgr.xq68_u17.rsub[i]
print @c.xbgr.xq68_u17.csub[i]
print @q.xbgr.xq68_u18.qnpn13g2[ic]
print @q.xbgr.xq68_u18.qnpn13g2[ib]
print @q.xbgr.xq68_u18.qnpn13g2[ie]
print @q.xbgr.xq68_u18.qnpn13g2[is]
print @r.xbgr.xq68_u18.rsub[i]
print @c.xbgr.xq68_u18.csub[i]
print @q.xbgr.xq68_u19.qnpn13g2[ic]
print @q.xbgr.xq68_u19.qnpn13g2[ib]
print @q.xbgr.xq68_u19.qnpn13g2[ie]
print @q.xbgr.xq68_u19.qnpn13g2[is]
print @r.xbgr.xq68_u19.rsub[i]
print @c.xbgr.xq68_u19.csub[i]
print @q.xbgr.xq68_u20.qnpn13g2[ic]
print @q.xbgr.xq68_u20.qnpn13g2[ib]
print @q.xbgr.xq68_u20.qnpn13g2[ie]
print @q.xbgr.xq68_u20.qnpn13g2[is]
print @r.xbgr.xq68_u20.rsub[i]
print @c.xbgr.xq68_u20.csub[i]
print @q.xbgr.xq68_u21.qnpn13g2[ic]
print @q.xbgr.xq68_u21.qnpn13g2[ib]
print @q.xbgr.xq68_u21.qnpn13g2[ie]
print @q.xbgr.xq68_u21.qnpn13g2[is]
print @r.xbgr.xq68_u21.rsub[i]
print @c.xbgr.xq68_u21.csub[i]
print @q.xbgr.xq68_u22.qnpn13g2[ic]
print @q.xbgr.xq68_u22.qnpn13g2[ib]
print @q.xbgr.xq68_u22.qnpn13g2[ie]
print @q.xbgr.xq68_u22.qnpn13g2[is]
print @r.xbgr.xq68_u22.rsub[i]
print @c.xbgr.xq68_u22.csub[i]
print @q.xbgr.xq68_u23.qnpn13g2[ic]
print @q.xbgr.xq68_u23.qnpn13g2[ib]
print @q.xbgr.xq68_u23.qnpn13g2[ie]
print @q.xbgr.xq68_u23.qnpn13g2[is]
print @r.xbgr.xq68_u23.rsub[i]
print @c.xbgr.xq68_u23.csub[i]
print @q.xbgr.xq68_u24.qnpn13g2[ic]
print @q.xbgr.xq68_u24.qnpn13g2[ib]
print @q.xbgr.xq68_u24.qnpn13g2[ie]
print @q.xbgr.xq68_u24.qnpn13g2[is]
print @r.xbgr.xq68_u24.rsub[i]
print @c.xbgr.xq68_u24.csub[i]
print @q.xbgr.xq69_u2.qnpn13g2[ic]
print @q.xbgr.xq69_u2.qnpn13g2[ib]
print @q.xbgr.xq69_u2.qnpn13g2[ie]
print @q.xbgr.xq69_u2.qnpn13g2[is]
print @r.xbgr.xq69_u2.rsub[i]
print @c.xbgr.xq69_u2.csub[i]
print @q.xbgr.xq69_u3.qnpn13g2[ic]
print @q.xbgr.xq69_u3.qnpn13g2[ib]
print @q.xbgr.xq69_u3.qnpn13g2[ie]
print @q.xbgr.xq69_u3.qnpn13g2[is]
print @r.xbgr.xq69_u3.rsub[i]
print @c.xbgr.xq69_u3.csub[i]
print @q.xbgr.xq69_u4.qnpn13g2[ic]
print @q.xbgr.xq69_u4.qnpn13g2[ib]
print @q.xbgr.xq69_u4.qnpn13g2[ie]
print @q.xbgr.xq69_u4.qnpn13g2[is]
print @r.xbgr.xq69_u4.rsub[i]
print @c.xbgr.xq69_u4.csub[i]
print @q.xbgr.xq69_u5.qnpn13g2[ic]
print @q.xbgr.xq69_u5.qnpn13g2[ib]
print @q.xbgr.xq69_u5.qnpn13g2[ie]
print @q.xbgr.xq69_u5.qnpn13g2[is]
print @r.xbgr.xq69_u5.rsub[i]
print @c.xbgr.xq69_u5.csub[i]
print @q.xbgr.xq69_u6.qnpn13g2[ic]
print @q.xbgr.xq69_u6.qnpn13g2[ib]
print @q.xbgr.xq69_u6.qnpn13g2[ie]
print @q.xbgr.xq69_u6.qnpn13g2[is]
print @r.xbgr.xq69_u6.rsub[i]
print @c.xbgr.xq69_u6.csub[i]
print @q.xbgr.xq69_u7.qnpn13g2[ic]
print @q.xbgr.xq69_u7.qnpn13g2[ib]
print @q.xbgr.xq69_u7.qnpn13g2[ie]
print @q.xbgr.xq69_u7.qnpn13g2[is]
print @r.xbgr.xq69_u7.rsub[i]
print @c.xbgr.xq69_u7.csub[i]
print @q.xbgr.xq69_u8.qnpn13g2[ic]
print @q.xbgr.xq69_u8.qnpn13g2[ib]
print @q.xbgr.xq69_u8.qnpn13g2[ie]
print @q.xbgr.xq69_u8.qnpn13g2[is]
print @r.xbgr.xq69_u8.rsub[i]
print @c.xbgr.xq69_u8.csub[i]
print @q.xbgr.xq69_u9.qnpn13g2[ic]
print @q.xbgr.xq69_u9.qnpn13g2[ib]
print @q.xbgr.xq69_u9.qnpn13g2[ie]
print @q.xbgr.xq69_u9.qnpn13g2[is]
print @r.xbgr.xq69_u9.rsub[i]
print @c.xbgr.xq69_u9.csub[i]
print @q.xbgr.xq69_u10.qnpn13g2[ic]
print @q.xbgr.xq69_u10.qnpn13g2[ib]
print @q.xbgr.xq69_u10.qnpn13g2[ie]
print @q.xbgr.xq69_u10.qnpn13g2[is]
print @r.xbgr.xq69_u10.rsub[i]
print @c.xbgr.xq69_u10.csub[i]
print @q.xbgr.xq69_u11.qnpn13g2[ic]
print @q.xbgr.xq69_u11.qnpn13g2[ib]
print @q.xbgr.xq69_u11.qnpn13g2[ie]
print @q.xbgr.xq69_u11.qnpn13g2[is]
print @r.xbgr.xq69_u11.rsub[i]
print @c.xbgr.xq69_u11.csub[i]
print @q.xbgr.xq69_u12.qnpn13g2[ic]
print @q.xbgr.xq69_u12.qnpn13g2[ib]
print @q.xbgr.xq69_u12.qnpn13g2[ie]
print @q.xbgr.xq69_u12.qnpn13g2[is]
print @r.xbgr.xq69_u12.rsub[i]
print @c.xbgr.xq69_u12.csub[i]
print @q.xbgr.xq69_u13.qnpn13g2[ic]
print @q.xbgr.xq69_u13.qnpn13g2[ib]
print @q.xbgr.xq69_u13.qnpn13g2[ie]
print @q.xbgr.xq69_u13.qnpn13g2[is]
print @r.xbgr.xq69_u13.rsub[i]
print @c.xbgr.xq69_u13.csub[i]
print @q.xbgr.xq69_u14.qnpn13g2[ic]
print @q.xbgr.xq69_u14.qnpn13g2[ib]
print @q.xbgr.xq69_u14.qnpn13g2[ie]
print @q.xbgr.xq69_u14.qnpn13g2[is]
print @r.xbgr.xq69_u14.rsub[i]
print @c.xbgr.xq69_u14.csub[i]
print @q.xbgr.xq69_u15.qnpn13g2[ic]
print @q.xbgr.xq69_u15.qnpn13g2[ib]
print @q.xbgr.xq69_u15.qnpn13g2[ie]
print @q.xbgr.xq69_u15.qnpn13g2[is]
print @r.xbgr.xq69_u15.rsub[i]
print @c.xbgr.xq69_u15.csub[i]
print @q.xbgr.xq69_u16.qnpn13g2[ic]
print @q.xbgr.xq69_u16.qnpn13g2[ib]
print @q.xbgr.xq69_u16.qnpn13g2[ie]
print @q.xbgr.xq69_u16.qnpn13g2[is]
print @r.xbgr.xq69_u16.rsub[i]
print @c.xbgr.xq69_u16.csub[i]
print @q.xbgr.xq69_u17.qnpn13g2[ic]
print @q.xbgr.xq69_u17.qnpn13g2[ib]
print @q.xbgr.xq69_u17.qnpn13g2[ie]
print @q.xbgr.xq69_u17.qnpn13g2[is]
print @r.xbgr.xq69_u17.rsub[i]
print @c.xbgr.xq69_u17.csub[i]
print @q.xbgr.xq69_u18.qnpn13g2[ic]
print @q.xbgr.xq69_u18.qnpn13g2[ib]
print @q.xbgr.xq69_u18.qnpn13g2[ie]
print @q.xbgr.xq69_u18.qnpn13g2[is]
print @r.xbgr.xq69_u18.rsub[i]
print @c.xbgr.xq69_u18.csub[i]
print @q.xbgr.xq69_u19.qnpn13g2[ic]
print @q.xbgr.xq69_u19.qnpn13g2[ib]
print @q.xbgr.xq69_u19.qnpn13g2[ie]
print @q.xbgr.xq69_u19.qnpn13g2[is]
print @r.xbgr.xq69_u19.rsub[i]
print @c.xbgr.xq69_u19.csub[i]
print @q.xbgr.xq69_u20.qnpn13g2[ic]
print @q.xbgr.xq69_u20.qnpn13g2[ib]
print @q.xbgr.xq69_u20.qnpn13g2[ie]
print @q.xbgr.xq69_u20.qnpn13g2[is]
print @r.xbgr.xq69_u20.rsub[i]
print @c.xbgr.xq69_u20.csub[i]
print @q.xbgr.xq69_u21.qnpn13g2[ic]
print @q.xbgr.xq69_u21.qnpn13g2[ib]
print @q.xbgr.xq69_u21.qnpn13g2[ie]
print @q.xbgr.xq69_u21.qnpn13g2[is]
print @r.xbgr.xq69_u21.rsub[i]
print @c.xbgr.xq69_u21.csub[i]
print @q.xbgr.xq69_u22.qnpn13g2[ic]
print @q.xbgr.xq69_u22.qnpn13g2[ib]
print @q.xbgr.xq69_u22.qnpn13g2[ie]
print @q.xbgr.xq69_u22.qnpn13g2[is]
print @r.xbgr.xq69_u22.rsub[i]
print @c.xbgr.xq69_u22.csub[i]
print @q.xbgr.xq69_u23.qnpn13g2[ic]
print @q.xbgr.xq69_u23.qnpn13g2[ib]
print @q.xbgr.xq69_u23.qnpn13g2[ie]
print @q.xbgr.xq69_u23.qnpn13g2[is]
print @r.xbgr.xq69_u23.rsub[i]
print @c.xbgr.xq69_u23.csub[i]
print @q.xbgr.xq69_u24.qnpn13g2[ic]
print @q.xbgr.xq69_u24.qnpn13g2[ib]
print @q.xbgr.xq69_u24.qnpn13g2[ie]
print @q.xbgr.xq69_u24.qnpn13g2[is]
print @r.xbgr.xq69_u24.rsub[i]
print @c.xbgr.xq69_u24.csub[i]
print @q.xbgr.xq70_u2.qnpn13g2[ic]
print @q.xbgr.xq70_u2.qnpn13g2[ib]
print @q.xbgr.xq70_u2.qnpn13g2[ie]
print @q.xbgr.xq70_u2.qnpn13g2[is]
print @r.xbgr.xq70_u2.rsub[i]
print @c.xbgr.xq70_u2.csub[i]
print @q.xbgr.xq70_u3.qnpn13g2[ic]
print @q.xbgr.xq70_u3.qnpn13g2[ib]
print @q.xbgr.xq70_u3.qnpn13g2[ie]
print @q.xbgr.xq70_u3.qnpn13g2[is]
print @r.xbgr.xq70_u3.rsub[i]
print @c.xbgr.xq70_u3.csub[i]
print @q.xbgr.xq70_u4.qnpn13g2[ic]
print @q.xbgr.xq70_u4.qnpn13g2[ib]
print @q.xbgr.xq70_u4.qnpn13g2[ie]
print @q.xbgr.xq70_u4.qnpn13g2[is]
print @r.xbgr.xq70_u4.rsub[i]
print @c.xbgr.xq70_u4.csub[i]
print @q.xbgr.xq70_u5.qnpn13g2[ic]
print @q.xbgr.xq70_u5.qnpn13g2[ib]
print @q.xbgr.xq70_u5.qnpn13g2[ie]
print @q.xbgr.xq70_u5.qnpn13g2[is]
print @r.xbgr.xq70_u5.rsub[i]
print @c.xbgr.xq70_u5.csub[i]
print @q.xbgr.xq70_u6.qnpn13g2[ic]
print @q.xbgr.xq70_u6.qnpn13g2[ib]
print @q.xbgr.xq70_u6.qnpn13g2[ie]
print @q.xbgr.xq70_u6.qnpn13g2[is]
print @r.xbgr.xq70_u6.rsub[i]
print @c.xbgr.xq70_u6.csub[i]
print @q.xbgr.xq70_u7.qnpn13g2[ic]
print @q.xbgr.xq70_u7.qnpn13g2[ib]
print @q.xbgr.xq70_u7.qnpn13g2[ie]
print @q.xbgr.xq70_u7.qnpn13g2[is]
print @r.xbgr.xq70_u7.rsub[i]
print @c.xbgr.xq70_u7.csub[i]
print @q.xbgr.xq70_u8.qnpn13g2[ic]
print @q.xbgr.xq70_u8.qnpn13g2[ib]
print @q.xbgr.xq70_u8.qnpn13g2[ie]
print @q.xbgr.xq70_u8.qnpn13g2[is]
print @r.xbgr.xq70_u8.rsub[i]
print @c.xbgr.xq70_u8.csub[i]
print @q.xbgr.xq70_u9.qnpn13g2[ic]
print @q.xbgr.xq70_u9.qnpn13g2[ib]
print @q.xbgr.xq70_u9.qnpn13g2[ie]
print @q.xbgr.xq70_u9.qnpn13g2[is]
print @r.xbgr.xq70_u9.rsub[i]
print @c.xbgr.xq70_u9.csub[i]
print @q.xbgr.xq70_u10.qnpn13g2[ic]
print @q.xbgr.xq70_u10.qnpn13g2[ib]
print @q.xbgr.xq70_u10.qnpn13g2[ie]
print @q.xbgr.xq70_u10.qnpn13g2[is]
print @r.xbgr.xq70_u10.rsub[i]
print @c.xbgr.xq70_u10.csub[i]
print @q.xbgr.xq70_u11.qnpn13g2[ic]
print @q.xbgr.xq70_u11.qnpn13g2[ib]
print @q.xbgr.xq70_u11.qnpn13g2[ie]
print @q.xbgr.xq70_u11.qnpn13g2[is]
print @r.xbgr.xq70_u11.rsub[i]
print @c.xbgr.xq70_u11.csub[i]
print @q.xbgr.xq70_u12.qnpn13g2[ic]
print @q.xbgr.xq70_u12.qnpn13g2[ib]
print @q.xbgr.xq70_u12.qnpn13g2[ie]
print @q.xbgr.xq70_u12.qnpn13g2[is]
print @r.xbgr.xq70_u12.rsub[i]
print @c.xbgr.xq70_u12.csub[i]
print @q.xbgr.xq70_u13.qnpn13g2[ic]
print @q.xbgr.xq70_u13.qnpn13g2[ib]
print @q.xbgr.xq70_u13.qnpn13g2[ie]
print @q.xbgr.xq70_u13.qnpn13g2[is]
print @r.xbgr.xq70_u13.rsub[i]
print @c.xbgr.xq70_u13.csub[i]
print @q.xbgr.xq70_u14.qnpn13g2[ic]
print @q.xbgr.xq70_u14.qnpn13g2[ib]
print @q.xbgr.xq70_u14.qnpn13g2[ie]
print @q.xbgr.xq70_u14.qnpn13g2[is]
print @r.xbgr.xq70_u14.rsub[i]
print @c.xbgr.xq70_u14.csub[i]
print @q.xbgr.xq70_u15.qnpn13g2[ic]
print @q.xbgr.xq70_u15.qnpn13g2[ib]
print @q.xbgr.xq70_u15.qnpn13g2[ie]
print @q.xbgr.xq70_u15.qnpn13g2[is]
print @r.xbgr.xq70_u15.rsub[i]
print @c.xbgr.xq70_u15.csub[i]
print @q.xbgr.xq70_u16.qnpn13g2[ic]
print @q.xbgr.xq70_u16.qnpn13g2[ib]
print @q.xbgr.xq70_u16.qnpn13g2[ie]
print @q.xbgr.xq70_u16.qnpn13g2[is]
print @r.xbgr.xq70_u16.rsub[i]
print @c.xbgr.xq70_u16.csub[i]
print @q.xbgr.xq70_u17.qnpn13g2[ic]
print @q.xbgr.xq70_u17.qnpn13g2[ib]
print @q.xbgr.xq70_u17.qnpn13g2[ie]
print @q.xbgr.xq70_u17.qnpn13g2[is]
print @r.xbgr.xq70_u17.rsub[i]
print @c.xbgr.xq70_u17.csub[i]
print @q.xbgr.xq70_u18.qnpn13g2[ic]
print @q.xbgr.xq70_u18.qnpn13g2[ib]
print @q.xbgr.xq70_u18.qnpn13g2[ie]
print @q.xbgr.xq70_u18.qnpn13g2[is]
print @r.xbgr.xq70_u18.rsub[i]
print @c.xbgr.xq70_u18.csub[i]
print @q.xbgr.xq70_u19.qnpn13g2[ic]
print @q.xbgr.xq70_u19.qnpn13g2[ib]
print @q.xbgr.xq70_u19.qnpn13g2[ie]
print @q.xbgr.xq70_u19.qnpn13g2[is]
print @r.xbgr.xq70_u19.rsub[i]
print @c.xbgr.xq70_u19.csub[i]
print @q.xbgr.xq70_u20.qnpn13g2[ic]
print @q.xbgr.xq70_u20.qnpn13g2[ib]
print @q.xbgr.xq70_u20.qnpn13g2[ie]
print @q.xbgr.xq70_u20.qnpn13g2[is]
print @r.xbgr.xq70_u20.rsub[i]
print @c.xbgr.xq70_u20.csub[i]
print @q.xbgr.xq70_u21.qnpn13g2[ic]
print @q.xbgr.xq70_u21.qnpn13g2[ib]
print @q.xbgr.xq70_u21.qnpn13g2[ie]
print @q.xbgr.xq70_u21.qnpn13g2[is]
print @r.xbgr.xq70_u21.rsub[i]
print @c.xbgr.xq70_u21.csub[i]
print @q.xbgr.xq70_u22.qnpn13g2[ic]
print @q.xbgr.xq70_u22.qnpn13g2[ib]
print @q.xbgr.xq70_u22.qnpn13g2[ie]
print @q.xbgr.xq70_u22.qnpn13g2[is]
print @r.xbgr.xq70_u22.rsub[i]
print @c.xbgr.xq70_u22.csub[i]
print @q.xbgr.xq70_u23.qnpn13g2[ic]
print @q.xbgr.xq70_u23.qnpn13g2[ib]
print @q.xbgr.xq70_u23.qnpn13g2[ie]
print @q.xbgr.xq70_u23.qnpn13g2[is]
print @r.xbgr.xq70_u23.rsub[i]
print @c.xbgr.xq70_u23.csub[i]
print @q.xbgr.xq70_u24.qnpn13g2[ic]
print @q.xbgr.xq70_u24.qnpn13g2[ib]
print @q.xbgr.xq70_u24.qnpn13g2[ie]
print @q.xbgr.xq70_u24.qnpn13g2[is]
print @r.xbgr.xq70_u24.rsub[i]
print @c.xbgr.xq70_u24.csub[i]
print @q.xbgr.xq71_u2.qnpn13g2[ic]
print @q.xbgr.xq71_u2.qnpn13g2[ib]
print @q.xbgr.xq71_u2.qnpn13g2[ie]
print @q.xbgr.xq71_u2.qnpn13g2[is]
print @r.xbgr.xq71_u2.rsub[i]
print @c.xbgr.xq71_u2.csub[i]
print @q.xbgr.xq71_u3.qnpn13g2[ic]
print @q.xbgr.xq71_u3.qnpn13g2[ib]
print @q.xbgr.xq71_u3.qnpn13g2[ie]
print @q.xbgr.xq71_u3.qnpn13g2[is]
print @r.xbgr.xq71_u3.rsub[i]
print @c.xbgr.xq71_u3.csub[i]
print @q.xbgr.xq71_u4.qnpn13g2[ic]
print @q.xbgr.xq71_u4.qnpn13g2[ib]
print @q.xbgr.xq71_u4.qnpn13g2[ie]
print @q.xbgr.xq71_u4.qnpn13g2[is]
print @r.xbgr.xq71_u4.rsub[i]
print @c.xbgr.xq71_u4.csub[i]
print @q.xbgr.xq71_u5.qnpn13g2[ic]
print @q.xbgr.xq71_u5.qnpn13g2[ib]
print @q.xbgr.xq71_u5.qnpn13g2[ie]
print @q.xbgr.xq71_u5.qnpn13g2[is]
print @r.xbgr.xq71_u5.rsub[i]
print @c.xbgr.xq71_u5.csub[i]
print @q.xbgr.xq71_u6.qnpn13g2[ic]
print @q.xbgr.xq71_u6.qnpn13g2[ib]
print @q.xbgr.xq71_u6.qnpn13g2[ie]
print @q.xbgr.xq71_u6.qnpn13g2[is]
print @r.xbgr.xq71_u6.rsub[i]
print @c.xbgr.xq71_u6.csub[i]
print @q.xbgr.xq71_u7.qnpn13g2[ic]
print @q.xbgr.xq71_u7.qnpn13g2[ib]
print @q.xbgr.xq71_u7.qnpn13g2[ie]
print @q.xbgr.xq71_u7.qnpn13g2[is]
print @r.xbgr.xq71_u7.rsub[i]
print @c.xbgr.xq71_u7.csub[i]
print @q.xbgr.xq71_u8.qnpn13g2[ic]
print @q.xbgr.xq71_u8.qnpn13g2[ib]
print @q.xbgr.xq71_u8.qnpn13g2[ie]
print @q.xbgr.xq71_u8.qnpn13g2[is]
print @r.xbgr.xq71_u8.rsub[i]
print @c.xbgr.xq71_u8.csub[i]
print @q.xbgr.xq71_u9.qnpn13g2[ic]
print @q.xbgr.xq71_u9.qnpn13g2[ib]
print @q.xbgr.xq71_u9.qnpn13g2[ie]
print @q.xbgr.xq71_u9.qnpn13g2[is]
print @r.xbgr.xq71_u9.rsub[i]
print @c.xbgr.xq71_u9.csub[i]
print @q.xbgr.xq71_u10.qnpn13g2[ic]
print @q.xbgr.xq71_u10.qnpn13g2[ib]
print @q.xbgr.xq71_u10.qnpn13g2[ie]
print @q.xbgr.xq71_u10.qnpn13g2[is]
print @r.xbgr.xq71_u10.rsub[i]
print @c.xbgr.xq71_u10.csub[i]
print @q.xbgr.xq71_u11.qnpn13g2[ic]
print @q.xbgr.xq71_u11.qnpn13g2[ib]
print @q.xbgr.xq71_u11.qnpn13g2[ie]
print @q.xbgr.xq71_u11.qnpn13g2[is]
print @r.xbgr.xq71_u11.rsub[i]
print @c.xbgr.xq71_u11.csub[i]
print @q.xbgr.xq71_u12.qnpn13g2[ic]
print @q.xbgr.xq71_u12.qnpn13g2[ib]
print @q.xbgr.xq71_u12.qnpn13g2[ie]
print @q.xbgr.xq71_u12.qnpn13g2[is]
print @r.xbgr.xq71_u12.rsub[i]
print @c.xbgr.xq71_u12.csub[i]
print @q.xbgr.xq71_u13.qnpn13g2[ic]
print @q.xbgr.xq71_u13.qnpn13g2[ib]
print @q.xbgr.xq71_u13.qnpn13g2[ie]
print @q.xbgr.xq71_u13.qnpn13g2[is]
print @r.xbgr.xq71_u13.rsub[i]
print @c.xbgr.xq71_u13.csub[i]
print @q.xbgr.xq71_u14.qnpn13g2[ic]
print @q.xbgr.xq71_u14.qnpn13g2[ib]
print @q.xbgr.xq71_u14.qnpn13g2[ie]
print @q.xbgr.xq71_u14.qnpn13g2[is]
print @r.xbgr.xq71_u14.rsub[i]
print @c.xbgr.xq71_u14.csub[i]
print @q.xbgr.xq71_u15.qnpn13g2[ic]
print @q.xbgr.xq71_u15.qnpn13g2[ib]
print @q.xbgr.xq71_u15.qnpn13g2[ie]
print @q.xbgr.xq71_u15.qnpn13g2[is]
print @r.xbgr.xq71_u15.rsub[i]
print @c.xbgr.xq71_u15.csub[i]
print @q.xbgr.xq71_u16.qnpn13g2[ic]
print @q.xbgr.xq71_u16.qnpn13g2[ib]
print @q.xbgr.xq71_u16.qnpn13g2[ie]
print @q.xbgr.xq71_u16.qnpn13g2[is]
print @r.xbgr.xq71_u16.rsub[i]
print @c.xbgr.xq71_u16.csub[i]
print @q.xbgr.xq71_u17.qnpn13g2[ic]
print @q.xbgr.xq71_u17.qnpn13g2[ib]
print @q.xbgr.xq71_u17.qnpn13g2[ie]
print @q.xbgr.xq71_u17.qnpn13g2[is]
print @r.xbgr.xq71_u17.rsub[i]
print @c.xbgr.xq71_u17.csub[i]
print @q.xbgr.xq71_u18.qnpn13g2[ic]
print @q.xbgr.xq71_u18.qnpn13g2[ib]
print @q.xbgr.xq71_u18.qnpn13g2[ie]
print @q.xbgr.xq71_u18.qnpn13g2[is]
print @r.xbgr.xq71_u18.rsub[i]
print @c.xbgr.xq71_u18.csub[i]
print @q.xbgr.xq71_u19.qnpn13g2[ic]
print @q.xbgr.xq71_u19.qnpn13g2[ib]
print @q.xbgr.xq71_u19.qnpn13g2[ie]
print @q.xbgr.xq71_u19.qnpn13g2[is]
print @r.xbgr.xq71_u19.rsub[i]
print @c.xbgr.xq71_u19.csub[i]
print @q.xbgr.xq71_u20.qnpn13g2[ic]
print @q.xbgr.xq71_u20.qnpn13g2[ib]
print @q.xbgr.xq71_u20.qnpn13g2[ie]
print @q.xbgr.xq71_u20.qnpn13g2[is]
print @r.xbgr.xq71_u20.rsub[i]
print @c.xbgr.xq71_u20.csub[i]
print @q.xbgr.xq71_u21.qnpn13g2[ic]
print @q.xbgr.xq71_u21.qnpn13g2[ib]
print @q.xbgr.xq71_u21.qnpn13g2[ie]
print @q.xbgr.xq71_u21.qnpn13g2[is]
print @r.xbgr.xq71_u21.rsub[i]
print @c.xbgr.xq71_u21.csub[i]
print @q.xbgr.xq71_u22.qnpn13g2[ic]
print @q.xbgr.xq71_u22.qnpn13g2[ib]
print @q.xbgr.xq71_u22.qnpn13g2[ie]
print @q.xbgr.xq71_u22.qnpn13g2[is]
print @r.xbgr.xq71_u22.rsub[i]
print @c.xbgr.xq71_u22.csub[i]
print @q.xbgr.xq71_u23.qnpn13g2[ic]
print @q.xbgr.xq71_u23.qnpn13g2[ib]
print @q.xbgr.xq71_u23.qnpn13g2[ie]
print @q.xbgr.xq71_u23.qnpn13g2[is]
print @r.xbgr.xq71_u23.rsub[i]
print @c.xbgr.xq71_u23.csub[i]
print @q.xbgr.xq71_u24.qnpn13g2[ic]
print @q.xbgr.xq71_u24.qnpn13g2[ib]
print @q.xbgr.xq71_u24.qnpn13g2[ie]
print @q.xbgr.xq71_u24.qnpn13g2[is]
print @r.xbgr.xq71_u24.rsub[i]
print @c.xbgr.xq71_u24.csub[i]
print @q.xbgr.xq72_u2.qnpn13g2[ic]
print @q.xbgr.xq72_u2.qnpn13g2[ib]
print @q.xbgr.xq72_u2.qnpn13g2[ie]
print @q.xbgr.xq72_u2.qnpn13g2[is]
print @r.xbgr.xq72_u2.rsub[i]
print @c.xbgr.xq72_u2.csub[i]
print @q.xbgr.xq72_u3.qnpn13g2[ic]
print @q.xbgr.xq72_u3.qnpn13g2[ib]
print @q.xbgr.xq72_u3.qnpn13g2[ie]
print @q.xbgr.xq72_u3.qnpn13g2[is]
print @r.xbgr.xq72_u3.rsub[i]
print @c.xbgr.xq72_u3.csub[i]
print @q.xbgr.xq72_u4.qnpn13g2[ic]
print @q.xbgr.xq72_u4.qnpn13g2[ib]
print @q.xbgr.xq72_u4.qnpn13g2[ie]
print @q.xbgr.xq72_u4.qnpn13g2[is]
print @r.xbgr.xq72_u4.rsub[i]
print @c.xbgr.xq72_u4.csub[i]
print @q.xbgr.xq72_u5.qnpn13g2[ic]
print @q.xbgr.xq72_u5.qnpn13g2[ib]
print @q.xbgr.xq72_u5.qnpn13g2[ie]
print @q.xbgr.xq72_u5.qnpn13g2[is]
print @r.xbgr.xq72_u5.rsub[i]
print @c.xbgr.xq72_u5.csub[i]
print @q.xbgr.xq72_u6.qnpn13g2[ic]
print @q.xbgr.xq72_u6.qnpn13g2[ib]
print @q.xbgr.xq72_u6.qnpn13g2[ie]
print @q.xbgr.xq72_u6.qnpn13g2[is]
print @r.xbgr.xq72_u6.rsub[i]
print @c.xbgr.xq72_u6.csub[i]
print @q.xbgr.xq72_u7.qnpn13g2[ic]
print @q.xbgr.xq72_u7.qnpn13g2[ib]
print @q.xbgr.xq72_u7.qnpn13g2[ie]
print @q.xbgr.xq72_u7.qnpn13g2[is]
print @r.xbgr.xq72_u7.rsub[i]
print @c.xbgr.xq72_u7.csub[i]
print @q.xbgr.xq72_u8.qnpn13g2[ic]
print @q.xbgr.xq72_u8.qnpn13g2[ib]
print @q.xbgr.xq72_u8.qnpn13g2[ie]
print @q.xbgr.xq72_u8.qnpn13g2[is]
print @r.xbgr.xq72_u8.rsub[i]
print @c.xbgr.xq72_u8.csub[i]
print @q.xbgr.xq72_u9.qnpn13g2[ic]
print @q.xbgr.xq72_u9.qnpn13g2[ib]
print @q.xbgr.xq72_u9.qnpn13g2[ie]
print @q.xbgr.xq72_u9.qnpn13g2[is]
print @r.xbgr.xq72_u9.rsub[i]
print @c.xbgr.xq72_u9.csub[i]
print @q.xbgr.xq72_u10.qnpn13g2[ic]
print @q.xbgr.xq72_u10.qnpn13g2[ib]
print @q.xbgr.xq72_u10.qnpn13g2[ie]
print @q.xbgr.xq72_u10.qnpn13g2[is]
print @r.xbgr.xq72_u10.rsub[i]
print @c.xbgr.xq72_u10.csub[i]
print @q.xbgr.xq72_u11.qnpn13g2[ic]
print @q.xbgr.xq72_u11.qnpn13g2[ib]
print @q.xbgr.xq72_u11.qnpn13g2[ie]
print @q.xbgr.xq72_u11.qnpn13g2[is]
print @r.xbgr.xq72_u11.rsub[i]
print @c.xbgr.xq72_u11.csub[i]
print @q.xbgr.xq72_u12.qnpn13g2[ic]
print @q.xbgr.xq72_u12.qnpn13g2[ib]
print @q.xbgr.xq72_u12.qnpn13g2[ie]
print @q.xbgr.xq72_u12.qnpn13g2[is]
print @r.xbgr.xq72_u12.rsub[i]
print @c.xbgr.xq72_u12.csub[i]
print @q.xbgr.xq72_u13.qnpn13g2[ic]
print @q.xbgr.xq72_u13.qnpn13g2[ib]
print @q.xbgr.xq72_u13.qnpn13g2[ie]
print @q.xbgr.xq72_u13.qnpn13g2[is]
print @r.xbgr.xq72_u13.rsub[i]
print @c.xbgr.xq72_u13.csub[i]
print @q.xbgr.xq72_u14.qnpn13g2[ic]
print @q.xbgr.xq72_u14.qnpn13g2[ib]
print @q.xbgr.xq72_u14.qnpn13g2[ie]
print @q.xbgr.xq72_u14.qnpn13g2[is]
print @r.xbgr.xq72_u14.rsub[i]
print @c.xbgr.xq72_u14.csub[i]
print @q.xbgr.xq72_u15.qnpn13g2[ic]
print @q.xbgr.xq72_u15.qnpn13g2[ib]
print @q.xbgr.xq72_u15.qnpn13g2[ie]
print @q.xbgr.xq72_u15.qnpn13g2[is]
print @r.xbgr.xq72_u15.rsub[i]
print @c.xbgr.xq72_u15.csub[i]
print @q.xbgr.xq72_u16.qnpn13g2[ic]
print @q.xbgr.xq72_u16.qnpn13g2[ib]
print @q.xbgr.xq72_u16.qnpn13g2[ie]
print @q.xbgr.xq72_u16.qnpn13g2[is]
print @r.xbgr.xq72_u16.rsub[i]
print @c.xbgr.xq72_u16.csub[i]
print @q.xbgr.xq72_u17.qnpn13g2[ic]
print @q.xbgr.xq72_u17.qnpn13g2[ib]
print @q.xbgr.xq72_u17.qnpn13g2[ie]
print @q.xbgr.xq72_u17.qnpn13g2[is]
print @r.xbgr.xq72_u17.rsub[i]
print @c.xbgr.xq72_u17.csub[i]
print @q.xbgr.xq72_u18.qnpn13g2[ic]
print @q.xbgr.xq72_u18.qnpn13g2[ib]
print @q.xbgr.xq72_u18.qnpn13g2[ie]
print @q.xbgr.xq72_u18.qnpn13g2[is]
print @r.xbgr.xq72_u18.rsub[i]
print @c.xbgr.xq72_u18.csub[i]
print @q.xbgr.xq72_u19.qnpn13g2[ic]
print @q.xbgr.xq72_u19.qnpn13g2[ib]
print @q.xbgr.xq72_u19.qnpn13g2[ie]
print @q.xbgr.xq72_u19.qnpn13g2[is]
print @r.xbgr.xq72_u19.rsub[i]
print @c.xbgr.xq72_u19.csub[i]
print @q.xbgr.xq72_u20.qnpn13g2[ic]
print @q.xbgr.xq72_u20.qnpn13g2[ib]
print @q.xbgr.xq72_u20.qnpn13g2[ie]
print @q.xbgr.xq72_u20.qnpn13g2[is]
print @r.xbgr.xq72_u20.rsub[i]
print @c.xbgr.xq72_u20.csub[i]
print @q.xbgr.xq72_u21.qnpn13g2[ic]
print @q.xbgr.xq72_u21.qnpn13g2[ib]
print @q.xbgr.xq72_u21.qnpn13g2[ie]
print @q.xbgr.xq72_u21.qnpn13g2[is]
print @r.xbgr.xq72_u21.rsub[i]
print @c.xbgr.xq72_u21.csub[i]
print @q.xbgr.xq72_u22.qnpn13g2[ic]
print @q.xbgr.xq72_u22.qnpn13g2[ib]
print @q.xbgr.xq72_u22.qnpn13g2[ie]
print @q.xbgr.xq72_u22.qnpn13g2[is]
print @r.xbgr.xq72_u22.rsub[i]
print @c.xbgr.xq72_u22.csub[i]
print @q.xbgr.xq72_u23.qnpn13g2[ic]
print @q.xbgr.xq72_u23.qnpn13g2[ib]
print @q.xbgr.xq72_u23.qnpn13g2[ie]
print @q.xbgr.xq72_u23.qnpn13g2[is]
print @r.xbgr.xq72_u23.rsub[i]
print @c.xbgr.xq72_u23.csub[i]
print @q.xbgr.xq72_u24.qnpn13g2[ic]
print @q.xbgr.xq72_u24.qnpn13g2[ib]
print @q.xbgr.xq72_u24.qnpn13g2[ie]
print @q.xbgr.xq72_u24.qnpn13g2[is]
print @r.xbgr.xq72_u24.rsub[i]
print @c.xbgr.xq72_u24.csub[i]
print @q.xbgr.xq73_u2.qnpn13g2[ic]
print @q.xbgr.xq73_u2.qnpn13g2[ib]
print @q.xbgr.xq73_u2.qnpn13g2[ie]
print @q.xbgr.xq73_u2.qnpn13g2[is]
print @r.xbgr.xq73_u2.rsub[i]
print @c.xbgr.xq73_u2.csub[i]
print @q.xbgr.xq73_u3.qnpn13g2[ic]
print @q.xbgr.xq73_u3.qnpn13g2[ib]
print @q.xbgr.xq73_u3.qnpn13g2[ie]
print @q.xbgr.xq73_u3.qnpn13g2[is]
print @r.xbgr.xq73_u3.rsub[i]
print @c.xbgr.xq73_u3.csub[i]
print @q.xbgr.xq73_u4.qnpn13g2[ic]
print @q.xbgr.xq73_u4.qnpn13g2[ib]
print @q.xbgr.xq73_u4.qnpn13g2[ie]
print @q.xbgr.xq73_u4.qnpn13g2[is]
print @r.xbgr.xq73_u4.rsub[i]
print @c.xbgr.xq73_u4.csub[i]
print @q.xbgr.xq73_u5.qnpn13g2[ic]
print @q.xbgr.xq73_u5.qnpn13g2[ib]
print @q.xbgr.xq73_u5.qnpn13g2[ie]
print @q.xbgr.xq73_u5.qnpn13g2[is]
print @r.xbgr.xq73_u5.rsub[i]
print @c.xbgr.xq73_u5.csub[i]
print @q.xbgr.xq73_u6.qnpn13g2[ic]
print @q.xbgr.xq73_u6.qnpn13g2[ib]
print @q.xbgr.xq73_u6.qnpn13g2[ie]
print @q.xbgr.xq73_u6.qnpn13g2[is]
print @r.xbgr.xq73_u6.rsub[i]
print @c.xbgr.xq73_u6.csub[i]
print @q.xbgr.xq73_u7.qnpn13g2[ic]
print @q.xbgr.xq73_u7.qnpn13g2[ib]
print @q.xbgr.xq73_u7.qnpn13g2[ie]
print @q.xbgr.xq73_u7.qnpn13g2[is]
print @r.xbgr.xq73_u7.rsub[i]
print @c.xbgr.xq73_u7.csub[i]
print @q.xbgr.xq73_u8.qnpn13g2[ic]
print @q.xbgr.xq73_u8.qnpn13g2[ib]
print @q.xbgr.xq73_u8.qnpn13g2[ie]
print @q.xbgr.xq73_u8.qnpn13g2[is]
print @r.xbgr.xq73_u8.rsub[i]
print @c.xbgr.xq73_u8.csub[i]
print @q.xbgr.xq73_u9.qnpn13g2[ic]
print @q.xbgr.xq73_u9.qnpn13g2[ib]
print @q.xbgr.xq73_u9.qnpn13g2[ie]
print @q.xbgr.xq73_u9.qnpn13g2[is]
print @r.xbgr.xq73_u9.rsub[i]
print @c.xbgr.xq73_u9.csub[i]
print @q.xbgr.xq73_u10.qnpn13g2[ic]
print @q.xbgr.xq73_u10.qnpn13g2[ib]
print @q.xbgr.xq73_u10.qnpn13g2[ie]
print @q.xbgr.xq73_u10.qnpn13g2[is]
print @r.xbgr.xq73_u10.rsub[i]
print @c.xbgr.xq73_u10.csub[i]
print @q.xbgr.xq73_u11.qnpn13g2[ic]
print @q.xbgr.xq73_u11.qnpn13g2[ib]
print @q.xbgr.xq73_u11.qnpn13g2[ie]
print @q.xbgr.xq73_u11.qnpn13g2[is]
print @r.xbgr.xq73_u11.rsub[i]
print @c.xbgr.xq73_u11.csub[i]
print @q.xbgr.xq73_u12.qnpn13g2[ic]
print @q.xbgr.xq73_u12.qnpn13g2[ib]
print @q.xbgr.xq73_u12.qnpn13g2[ie]
print @q.xbgr.xq73_u12.qnpn13g2[is]
print @r.xbgr.xq73_u12.rsub[i]
print @c.xbgr.xq73_u12.csub[i]
print @q.xbgr.xq73_u13.qnpn13g2[ic]
print @q.xbgr.xq73_u13.qnpn13g2[ib]
print @q.xbgr.xq73_u13.qnpn13g2[ie]
print @q.xbgr.xq73_u13.qnpn13g2[is]
print @r.xbgr.xq73_u13.rsub[i]
print @c.xbgr.xq73_u13.csub[i]
print @q.xbgr.xq73_u14.qnpn13g2[ic]
print @q.xbgr.xq73_u14.qnpn13g2[ib]
print @q.xbgr.xq73_u14.qnpn13g2[ie]
print @q.xbgr.xq73_u14.qnpn13g2[is]
print @r.xbgr.xq73_u14.rsub[i]
print @c.xbgr.xq73_u14.csub[i]
print @q.xbgr.xq73_u15.qnpn13g2[ic]
print @q.xbgr.xq73_u15.qnpn13g2[ib]
print @q.xbgr.xq73_u15.qnpn13g2[ie]
print @q.xbgr.xq73_u15.qnpn13g2[is]
print @r.xbgr.xq73_u15.rsub[i]
print @c.xbgr.xq73_u15.csub[i]
print @q.xbgr.xq73_u16.qnpn13g2[ic]
print @q.xbgr.xq73_u16.qnpn13g2[ib]
print @q.xbgr.xq73_u16.qnpn13g2[ie]
print @q.xbgr.xq73_u16.qnpn13g2[is]
print @r.xbgr.xq73_u16.rsub[i]
print @c.xbgr.xq73_u16.csub[i]
print @q.xbgr.xq73_u17.qnpn13g2[ic]
print @q.xbgr.xq73_u17.qnpn13g2[ib]
print @q.xbgr.xq73_u17.qnpn13g2[ie]
print @q.xbgr.xq73_u17.qnpn13g2[is]
print @r.xbgr.xq73_u17.rsub[i]
print @c.xbgr.xq73_u17.csub[i]
print @q.xbgr.xq73_u18.qnpn13g2[ic]
print @q.xbgr.xq73_u18.qnpn13g2[ib]
print @q.xbgr.xq73_u18.qnpn13g2[ie]
print @q.xbgr.xq73_u18.qnpn13g2[is]
print @r.xbgr.xq73_u18.rsub[i]
print @c.xbgr.xq73_u18.csub[i]
print @q.xbgr.xq73_u19.qnpn13g2[ic]
print @q.xbgr.xq73_u19.qnpn13g2[ib]
print @q.xbgr.xq73_u19.qnpn13g2[ie]
print @q.xbgr.xq73_u19.qnpn13g2[is]
print @r.xbgr.xq73_u19.rsub[i]
print @c.xbgr.xq73_u19.csub[i]
print @q.xbgr.xq73_u20.qnpn13g2[ic]
print @q.xbgr.xq73_u20.qnpn13g2[ib]
print @q.xbgr.xq73_u20.qnpn13g2[ie]
print @q.xbgr.xq73_u20.qnpn13g2[is]
print @r.xbgr.xq73_u20.rsub[i]
print @c.xbgr.xq73_u20.csub[i]
print @q.xbgr.xq73_u21.qnpn13g2[ic]
print @q.xbgr.xq73_u21.qnpn13g2[ib]
print @q.xbgr.xq73_u21.qnpn13g2[ie]
print @q.xbgr.xq73_u21.qnpn13g2[is]
print @r.xbgr.xq73_u21.rsub[i]
print @c.xbgr.xq73_u21.csub[i]
print @q.xbgr.xq73_u22.qnpn13g2[ic]
print @q.xbgr.xq73_u22.qnpn13g2[ib]
print @q.xbgr.xq73_u22.qnpn13g2[ie]
print @q.xbgr.xq73_u22.qnpn13g2[is]
print @r.xbgr.xq73_u22.rsub[i]
print @c.xbgr.xq73_u22.csub[i]
print @q.xbgr.xq73_u23.qnpn13g2[ic]
print @q.xbgr.xq73_u23.qnpn13g2[ib]
print @q.xbgr.xq73_u23.qnpn13g2[ie]
print @q.xbgr.xq73_u23.qnpn13g2[is]
print @r.xbgr.xq73_u23.rsub[i]
print @c.xbgr.xq73_u23.csub[i]
print @q.xbgr.xq73_u24.qnpn13g2[ic]
print @q.xbgr.xq73_u24.qnpn13g2[ib]
print @q.xbgr.xq73_u24.qnpn13g2[ie]
print @q.xbgr.xq73_u24.qnpn13g2[is]
print @r.xbgr.xq73_u24.rsub[i]
print @c.xbgr.xq73_u24.csub[i]
print @q.xbgr.xq74_u2.qnpn13g2[ic]
print @q.xbgr.xq74_u2.qnpn13g2[ib]
print @q.xbgr.xq74_u2.qnpn13g2[ie]
print @q.xbgr.xq74_u2.qnpn13g2[is]
print @r.xbgr.xq74_u2.rsub[i]
print @c.xbgr.xq74_u2.csub[i]
print @q.xbgr.xq74_u3.qnpn13g2[ic]
print @q.xbgr.xq74_u3.qnpn13g2[ib]
print @q.xbgr.xq74_u3.qnpn13g2[ie]
print @q.xbgr.xq74_u3.qnpn13g2[is]
print @r.xbgr.xq74_u3.rsub[i]
print @c.xbgr.xq74_u3.csub[i]
print @q.xbgr.xq74_u4.qnpn13g2[ic]
print @q.xbgr.xq74_u4.qnpn13g2[ib]
print @q.xbgr.xq74_u4.qnpn13g2[ie]
print @q.xbgr.xq74_u4.qnpn13g2[is]
print @r.xbgr.xq74_u4.rsub[i]
print @c.xbgr.xq74_u4.csub[i]
print @q.xbgr.xq74_u5.qnpn13g2[ic]
print @q.xbgr.xq74_u5.qnpn13g2[ib]
print @q.xbgr.xq74_u5.qnpn13g2[ie]
print @q.xbgr.xq74_u5.qnpn13g2[is]
print @r.xbgr.xq74_u5.rsub[i]
print @c.xbgr.xq74_u5.csub[i]
print @q.xbgr.xq74_u6.qnpn13g2[ic]
print @q.xbgr.xq74_u6.qnpn13g2[ib]
print @q.xbgr.xq74_u6.qnpn13g2[ie]
print @q.xbgr.xq74_u6.qnpn13g2[is]
print @r.xbgr.xq74_u6.rsub[i]
print @c.xbgr.xq74_u6.csub[i]
print @q.xbgr.xq74_u7.qnpn13g2[ic]
print @q.xbgr.xq74_u7.qnpn13g2[ib]
print @q.xbgr.xq74_u7.qnpn13g2[ie]
print @q.xbgr.xq74_u7.qnpn13g2[is]
print @r.xbgr.xq74_u7.rsub[i]
print @c.xbgr.xq74_u7.csub[i]
print @q.xbgr.xq74_u8.qnpn13g2[ic]
print @q.xbgr.xq74_u8.qnpn13g2[ib]
print @q.xbgr.xq74_u8.qnpn13g2[ie]
print @q.xbgr.xq74_u8.qnpn13g2[is]
print @r.xbgr.xq74_u8.rsub[i]
print @c.xbgr.xq74_u8.csub[i]
print @q.xbgr.xq74_u9.qnpn13g2[ic]
print @q.xbgr.xq74_u9.qnpn13g2[ib]
print @q.xbgr.xq74_u9.qnpn13g2[ie]
print @q.xbgr.xq74_u9.qnpn13g2[is]
print @r.xbgr.xq74_u9.rsub[i]
print @c.xbgr.xq74_u9.csub[i]
print @q.xbgr.xq74_u10.qnpn13g2[ic]
print @q.xbgr.xq74_u10.qnpn13g2[ib]
print @q.xbgr.xq74_u10.qnpn13g2[ie]
print @q.xbgr.xq74_u10.qnpn13g2[is]
print @r.xbgr.xq74_u10.rsub[i]
print @c.xbgr.xq74_u10.csub[i]
print @q.xbgr.xq74_u11.qnpn13g2[ic]
print @q.xbgr.xq74_u11.qnpn13g2[ib]
print @q.xbgr.xq74_u11.qnpn13g2[ie]
print @q.xbgr.xq74_u11.qnpn13g2[is]
print @r.xbgr.xq74_u11.rsub[i]
print @c.xbgr.xq74_u11.csub[i]
print @q.xbgr.xq74_u12.qnpn13g2[ic]
print @q.xbgr.xq74_u12.qnpn13g2[ib]
print @q.xbgr.xq74_u12.qnpn13g2[ie]
print @q.xbgr.xq74_u12.qnpn13g2[is]
print @r.xbgr.xq74_u12.rsub[i]
print @c.xbgr.xq74_u12.csub[i]
print @q.xbgr.xq74_u13.qnpn13g2[ic]
print @q.xbgr.xq74_u13.qnpn13g2[ib]
print @q.xbgr.xq74_u13.qnpn13g2[ie]
print @q.xbgr.xq74_u13.qnpn13g2[is]
print @r.xbgr.xq74_u13.rsub[i]
print @c.xbgr.xq74_u13.csub[i]
print @q.xbgr.xq74_u14.qnpn13g2[ic]
print @q.xbgr.xq74_u14.qnpn13g2[ib]
print @q.xbgr.xq74_u14.qnpn13g2[ie]
print @q.xbgr.xq74_u14.qnpn13g2[is]
print @r.xbgr.xq74_u14.rsub[i]
print @c.xbgr.xq74_u14.csub[i]
print @q.xbgr.xq74_u15.qnpn13g2[ic]
print @q.xbgr.xq74_u15.qnpn13g2[ib]
print @q.xbgr.xq74_u15.qnpn13g2[ie]
print @q.xbgr.xq74_u15.qnpn13g2[is]
print @r.xbgr.xq74_u15.rsub[i]
print @c.xbgr.xq74_u15.csub[i]
print @q.xbgr.xq74_u16.qnpn13g2[ic]
print @q.xbgr.xq74_u16.qnpn13g2[ib]
print @q.xbgr.xq74_u16.qnpn13g2[ie]
print @q.xbgr.xq74_u16.qnpn13g2[is]
print @r.xbgr.xq74_u16.rsub[i]
print @c.xbgr.xq74_u16.csub[i]
print @q.xbgr.xq74_u17.qnpn13g2[ic]
print @q.xbgr.xq74_u17.qnpn13g2[ib]
print @q.xbgr.xq74_u17.qnpn13g2[ie]
print @q.xbgr.xq74_u17.qnpn13g2[is]
print @r.xbgr.xq74_u17.rsub[i]
print @c.xbgr.xq74_u17.csub[i]
print @q.xbgr.xq74_u18.qnpn13g2[ic]
print @q.xbgr.xq74_u18.qnpn13g2[ib]
print @q.xbgr.xq74_u18.qnpn13g2[ie]
print @q.xbgr.xq74_u18.qnpn13g2[is]
print @r.xbgr.xq74_u18.rsub[i]
print @c.xbgr.xq74_u18.csub[i]
print @q.xbgr.xq74_u19.qnpn13g2[ic]
print @q.xbgr.xq74_u19.qnpn13g2[ib]
print @q.xbgr.xq74_u19.qnpn13g2[ie]
print @q.xbgr.xq74_u19.qnpn13g2[is]
print @r.xbgr.xq74_u19.rsub[i]
print @c.xbgr.xq74_u19.csub[i]
print @q.xbgr.xq74_u20.qnpn13g2[ic]
print @q.xbgr.xq74_u20.qnpn13g2[ib]
print @q.xbgr.xq74_u20.qnpn13g2[ie]
print @q.xbgr.xq74_u20.qnpn13g2[is]
print @r.xbgr.xq74_u20.rsub[i]
print @c.xbgr.xq74_u20.csub[i]
print @q.xbgr.xq74_u21.qnpn13g2[ic]
print @q.xbgr.xq74_u21.qnpn13g2[ib]
print @q.xbgr.xq74_u21.qnpn13g2[ie]
print @q.xbgr.xq74_u21.qnpn13g2[is]
print @r.xbgr.xq74_u21.rsub[i]
print @c.xbgr.xq74_u21.csub[i]
print @q.xbgr.xq74_u22.qnpn13g2[ic]
print @q.xbgr.xq74_u22.qnpn13g2[ib]
print @q.xbgr.xq74_u22.qnpn13g2[ie]
print @q.xbgr.xq74_u22.qnpn13g2[is]
print @r.xbgr.xq74_u22.rsub[i]
print @c.xbgr.xq74_u22.csub[i]
print @q.xbgr.xq74_u23.qnpn13g2[ic]
print @q.xbgr.xq74_u23.qnpn13g2[ib]
print @q.xbgr.xq74_u23.qnpn13g2[ie]
print @q.xbgr.xq74_u23.qnpn13g2[is]
print @r.xbgr.xq74_u23.rsub[i]
print @c.xbgr.xq74_u23.csub[i]
print @q.xbgr.xq74_u24.qnpn13g2[ic]
print @q.xbgr.xq74_u24.qnpn13g2[ib]
print @q.xbgr.xq74_u24.qnpn13g2[ie]
print @q.xbgr.xq74_u24.qnpn13g2[is]
print @r.xbgr.xq74_u24.rsub[i]
print @c.xbgr.xq74_u24.csub[i]
print @q.xbgr.xq75_u2.qnpn13g2[ic]
print @q.xbgr.xq75_u2.qnpn13g2[ib]
print @q.xbgr.xq75_u2.qnpn13g2[ie]
print @q.xbgr.xq75_u2.qnpn13g2[is]
print @r.xbgr.xq75_u2.rsub[i]
print @c.xbgr.xq75_u2.csub[i]
print @q.xbgr.xq75_u3.qnpn13g2[ic]
print @q.xbgr.xq75_u3.qnpn13g2[ib]
print @q.xbgr.xq75_u3.qnpn13g2[ie]
print @q.xbgr.xq75_u3.qnpn13g2[is]
print @r.xbgr.xq75_u3.rsub[i]
print @c.xbgr.xq75_u3.csub[i]
print @q.xbgr.xq75_u4.qnpn13g2[ic]
print @q.xbgr.xq75_u4.qnpn13g2[ib]
print @q.xbgr.xq75_u4.qnpn13g2[ie]
print @q.xbgr.xq75_u4.qnpn13g2[is]
print @r.xbgr.xq75_u4.rsub[i]
print @c.xbgr.xq75_u4.csub[i]
print @q.xbgr.xq75_u5.qnpn13g2[ic]
print @q.xbgr.xq75_u5.qnpn13g2[ib]
print @q.xbgr.xq75_u5.qnpn13g2[ie]
print @q.xbgr.xq75_u5.qnpn13g2[is]
print @r.xbgr.xq75_u5.rsub[i]
print @c.xbgr.xq75_u5.csub[i]
print @q.xbgr.xq75_u6.qnpn13g2[ic]
print @q.xbgr.xq75_u6.qnpn13g2[ib]
print @q.xbgr.xq75_u6.qnpn13g2[ie]
print @q.xbgr.xq75_u6.qnpn13g2[is]
print @r.xbgr.xq75_u6.rsub[i]
print @c.xbgr.xq75_u6.csub[i]
print @q.xbgr.xq75_u7.qnpn13g2[ic]
print @q.xbgr.xq75_u7.qnpn13g2[ib]
print @q.xbgr.xq75_u7.qnpn13g2[ie]
print @q.xbgr.xq75_u7.qnpn13g2[is]
print @r.xbgr.xq75_u7.rsub[i]
print @c.xbgr.xq75_u7.csub[i]
print @q.xbgr.xq75_u8.qnpn13g2[ic]
print @q.xbgr.xq75_u8.qnpn13g2[ib]
print @q.xbgr.xq75_u8.qnpn13g2[ie]
print @q.xbgr.xq75_u8.qnpn13g2[is]
print @r.xbgr.xq75_u8.rsub[i]
print @c.xbgr.xq75_u8.csub[i]
print @q.xbgr.xq75_u9.qnpn13g2[ic]
print @q.xbgr.xq75_u9.qnpn13g2[ib]
print @q.xbgr.xq75_u9.qnpn13g2[ie]
print @q.xbgr.xq75_u9.qnpn13g2[is]
print @r.xbgr.xq75_u9.rsub[i]
print @c.xbgr.xq75_u9.csub[i]
print @q.xbgr.xq75_u10.qnpn13g2[ic]
print @q.xbgr.xq75_u10.qnpn13g2[ib]
print @q.xbgr.xq75_u10.qnpn13g2[ie]
print @q.xbgr.xq75_u10.qnpn13g2[is]
print @r.xbgr.xq75_u10.rsub[i]
print @c.xbgr.xq75_u10.csub[i]
print @q.xbgr.xq75_u11.qnpn13g2[ic]
print @q.xbgr.xq75_u11.qnpn13g2[ib]
print @q.xbgr.xq75_u11.qnpn13g2[ie]
print @q.xbgr.xq75_u11.qnpn13g2[is]
print @r.xbgr.xq75_u11.rsub[i]
print @c.xbgr.xq75_u11.csub[i]
print @q.xbgr.xq75_u12.qnpn13g2[ic]
print @q.xbgr.xq75_u12.qnpn13g2[ib]
print @q.xbgr.xq75_u12.qnpn13g2[ie]
print @q.xbgr.xq75_u12.qnpn13g2[is]
print @r.xbgr.xq75_u12.rsub[i]
print @c.xbgr.xq75_u12.csub[i]
print @q.xbgr.xq75_u13.qnpn13g2[ic]
print @q.xbgr.xq75_u13.qnpn13g2[ib]
print @q.xbgr.xq75_u13.qnpn13g2[ie]
print @q.xbgr.xq75_u13.qnpn13g2[is]
print @r.xbgr.xq75_u13.rsub[i]
print @c.xbgr.xq75_u13.csub[i]
print @q.xbgr.xq75_u14.qnpn13g2[ic]
print @q.xbgr.xq75_u14.qnpn13g2[ib]
print @q.xbgr.xq75_u14.qnpn13g2[ie]
print @q.xbgr.xq75_u14.qnpn13g2[is]
print @r.xbgr.xq75_u14.rsub[i]
print @c.xbgr.xq75_u14.csub[i]
print @q.xbgr.xq75_u15.qnpn13g2[ic]
print @q.xbgr.xq75_u15.qnpn13g2[ib]
print @q.xbgr.xq75_u15.qnpn13g2[ie]
print @q.xbgr.xq75_u15.qnpn13g2[is]
print @r.xbgr.xq75_u15.rsub[i]
print @c.xbgr.xq75_u15.csub[i]
print @q.xbgr.xq75_u16.qnpn13g2[ic]
print @q.xbgr.xq75_u16.qnpn13g2[ib]
print @q.xbgr.xq75_u16.qnpn13g2[ie]
print @q.xbgr.xq75_u16.qnpn13g2[is]
print @r.xbgr.xq75_u16.rsub[i]
print @c.xbgr.xq75_u16.csub[i]
print @q.xbgr.xq75_u17.qnpn13g2[ic]
print @q.xbgr.xq75_u17.qnpn13g2[ib]
print @q.xbgr.xq75_u17.qnpn13g2[ie]
print @q.xbgr.xq75_u17.qnpn13g2[is]
print @r.xbgr.xq75_u17.rsub[i]
print @c.xbgr.xq75_u17.csub[i]
print @q.xbgr.xq75_u18.qnpn13g2[ic]
print @q.xbgr.xq75_u18.qnpn13g2[ib]
print @q.xbgr.xq75_u18.qnpn13g2[ie]
print @q.xbgr.xq75_u18.qnpn13g2[is]
print @r.xbgr.xq75_u18.rsub[i]
print @c.xbgr.xq75_u18.csub[i]
print @q.xbgr.xq75_u19.qnpn13g2[ic]
print @q.xbgr.xq75_u19.qnpn13g2[ib]
print @q.xbgr.xq75_u19.qnpn13g2[ie]
print @q.xbgr.xq75_u19.qnpn13g2[is]
print @r.xbgr.xq75_u19.rsub[i]
print @c.xbgr.xq75_u19.csub[i]
print @q.xbgr.xq75_u20.qnpn13g2[ic]
print @q.xbgr.xq75_u20.qnpn13g2[ib]
print @q.xbgr.xq75_u20.qnpn13g2[ie]
print @q.xbgr.xq75_u20.qnpn13g2[is]
print @r.xbgr.xq75_u20.rsub[i]
print @c.xbgr.xq75_u20.csub[i]
print @q.xbgr.xq75_u21.qnpn13g2[ic]
print @q.xbgr.xq75_u21.qnpn13g2[ib]
print @q.xbgr.xq75_u21.qnpn13g2[ie]
print @q.xbgr.xq75_u21.qnpn13g2[is]
print @r.xbgr.xq75_u21.rsub[i]
print @c.xbgr.xq75_u21.csub[i]
print @q.xbgr.xq75_u22.qnpn13g2[ic]
print @q.xbgr.xq75_u22.qnpn13g2[ib]
print @q.xbgr.xq75_u22.qnpn13g2[ie]
print @q.xbgr.xq75_u22.qnpn13g2[is]
print @r.xbgr.xq75_u22.rsub[i]
print @c.xbgr.xq75_u22.csub[i]
print @q.xbgr.xq75_u23.qnpn13g2[ic]
print @q.xbgr.xq75_u23.qnpn13g2[ib]
print @q.xbgr.xq75_u23.qnpn13g2[ie]
print @q.xbgr.xq75_u23.qnpn13g2[is]
print @r.xbgr.xq75_u23.rsub[i]
print @c.xbgr.xq75_u23.csub[i]
print @q.xbgr.xq75_u24.qnpn13g2[ic]
print @q.xbgr.xq75_u24.qnpn13g2[ib]
print @q.xbgr.xq75_u24.qnpn13g2[ie]
print @q.xbgr.xq75_u24.qnpn13g2[is]
print @r.xbgr.xq75_u24.rsub[i]
print @c.xbgr.xq75_u24.csub[i]
print @q.xbgr.xq76_u2.qnpn13g2[ic]
print @q.xbgr.xq76_u2.qnpn13g2[ib]
print @q.xbgr.xq76_u2.qnpn13g2[ie]
print @q.xbgr.xq76_u2.qnpn13g2[is]
print @r.xbgr.xq76_u2.rsub[i]
print @c.xbgr.xq76_u2.csub[i]
print @q.xbgr.xq76_u3.qnpn13g2[ic]
print @q.xbgr.xq76_u3.qnpn13g2[ib]
print @q.xbgr.xq76_u3.qnpn13g2[ie]
print @q.xbgr.xq76_u3.qnpn13g2[is]
print @r.xbgr.xq76_u3.rsub[i]
print @c.xbgr.xq76_u3.csub[i]
print @q.xbgr.xq76_u4.qnpn13g2[ic]
print @q.xbgr.xq76_u4.qnpn13g2[ib]
print @q.xbgr.xq76_u4.qnpn13g2[ie]
print @q.xbgr.xq76_u4.qnpn13g2[is]
print @r.xbgr.xq76_u4.rsub[i]
print @c.xbgr.xq76_u4.csub[i]
print @q.xbgr.xq76_u5.qnpn13g2[ic]
print @q.xbgr.xq76_u5.qnpn13g2[ib]
print @q.xbgr.xq76_u5.qnpn13g2[ie]
print @q.xbgr.xq76_u5.qnpn13g2[is]
print @r.xbgr.xq76_u5.rsub[i]
print @c.xbgr.xq76_u5.csub[i]
print @q.xbgr.xq76_u6.qnpn13g2[ic]
print @q.xbgr.xq76_u6.qnpn13g2[ib]
print @q.xbgr.xq76_u6.qnpn13g2[ie]
print @q.xbgr.xq76_u6.qnpn13g2[is]
print @r.xbgr.xq76_u6.rsub[i]
print @c.xbgr.xq76_u6.csub[i]
print @q.xbgr.xq76_u7.qnpn13g2[ic]
print @q.xbgr.xq76_u7.qnpn13g2[ib]
print @q.xbgr.xq76_u7.qnpn13g2[ie]
print @q.xbgr.xq76_u7.qnpn13g2[is]
print @r.xbgr.xq76_u7.rsub[i]
print @c.xbgr.xq76_u7.csub[i]
print @q.xbgr.xq76_u8.qnpn13g2[ic]
print @q.xbgr.xq76_u8.qnpn13g2[ib]
print @q.xbgr.xq76_u8.qnpn13g2[ie]
print @q.xbgr.xq76_u8.qnpn13g2[is]
print @r.xbgr.xq76_u8.rsub[i]
print @c.xbgr.xq76_u8.csub[i]
print @q.xbgr.xq76_u9.qnpn13g2[ic]
print @q.xbgr.xq76_u9.qnpn13g2[ib]
print @q.xbgr.xq76_u9.qnpn13g2[ie]
print @q.xbgr.xq76_u9.qnpn13g2[is]
print @r.xbgr.xq76_u9.rsub[i]
print @c.xbgr.xq76_u9.csub[i]
print @q.xbgr.xq76_u10.qnpn13g2[ic]
print @q.xbgr.xq76_u10.qnpn13g2[ib]
print @q.xbgr.xq76_u10.qnpn13g2[ie]
print @q.xbgr.xq76_u10.qnpn13g2[is]
print @r.xbgr.xq76_u10.rsub[i]
print @c.xbgr.xq76_u10.csub[i]
print @q.xbgr.xq76_u11.qnpn13g2[ic]
print @q.xbgr.xq76_u11.qnpn13g2[ib]
print @q.xbgr.xq76_u11.qnpn13g2[ie]
print @q.xbgr.xq76_u11.qnpn13g2[is]
print @r.xbgr.xq76_u11.rsub[i]
print @c.xbgr.xq76_u11.csub[i]
print @q.xbgr.xq76_u12.qnpn13g2[ic]
print @q.xbgr.xq76_u12.qnpn13g2[ib]
print @q.xbgr.xq76_u12.qnpn13g2[ie]
print @q.xbgr.xq76_u12.qnpn13g2[is]
print @r.xbgr.xq76_u12.rsub[i]
print @c.xbgr.xq76_u12.csub[i]
print @q.xbgr.xq76_u13.qnpn13g2[ic]
print @q.xbgr.xq76_u13.qnpn13g2[ib]
print @q.xbgr.xq76_u13.qnpn13g2[ie]
print @q.xbgr.xq76_u13.qnpn13g2[is]
print @r.xbgr.xq76_u13.rsub[i]
print @c.xbgr.xq76_u13.csub[i]
print @q.xbgr.xq76_u14.qnpn13g2[ic]
print @q.xbgr.xq76_u14.qnpn13g2[ib]
print @q.xbgr.xq76_u14.qnpn13g2[ie]
print @q.xbgr.xq76_u14.qnpn13g2[is]
print @r.xbgr.xq76_u14.rsub[i]
print @c.xbgr.xq76_u14.csub[i]
print @q.xbgr.xq76_u15.qnpn13g2[ic]
print @q.xbgr.xq76_u15.qnpn13g2[ib]
print @q.xbgr.xq76_u15.qnpn13g2[ie]
print @q.xbgr.xq76_u15.qnpn13g2[is]
print @r.xbgr.xq76_u15.rsub[i]
print @c.xbgr.xq76_u15.csub[i]
print @q.xbgr.xq76_u16.qnpn13g2[ic]
print @q.xbgr.xq76_u16.qnpn13g2[ib]
print @q.xbgr.xq76_u16.qnpn13g2[ie]
print @q.xbgr.xq76_u16.qnpn13g2[is]
print @r.xbgr.xq76_u16.rsub[i]
print @c.xbgr.xq76_u16.csub[i]
print @q.xbgr.xq76_u17.qnpn13g2[ic]
print @q.xbgr.xq76_u17.qnpn13g2[ib]
print @q.xbgr.xq76_u17.qnpn13g2[ie]
print @q.xbgr.xq76_u17.qnpn13g2[is]
print @r.xbgr.xq76_u17.rsub[i]
print @c.xbgr.xq76_u17.csub[i]
print @q.xbgr.xq76_u18.qnpn13g2[ic]
print @q.xbgr.xq76_u18.qnpn13g2[ib]
print @q.xbgr.xq76_u18.qnpn13g2[ie]
print @q.xbgr.xq76_u18.qnpn13g2[is]
print @r.xbgr.xq76_u18.rsub[i]
print @c.xbgr.xq76_u18.csub[i]
print @q.xbgr.xq76_u19.qnpn13g2[ic]
print @q.xbgr.xq76_u19.qnpn13g2[ib]
print @q.xbgr.xq76_u19.qnpn13g2[ie]
print @q.xbgr.xq76_u19.qnpn13g2[is]
print @r.xbgr.xq76_u19.rsub[i]
print @c.xbgr.xq76_u19.csub[i]
print @q.xbgr.xq76_u20.qnpn13g2[ic]
print @q.xbgr.xq76_u20.qnpn13g2[ib]
print @q.xbgr.xq76_u20.qnpn13g2[ie]
print @q.xbgr.xq76_u20.qnpn13g2[is]
print @r.xbgr.xq76_u20.rsub[i]
print @c.xbgr.xq76_u20.csub[i]
print @q.xbgr.xq76_u21.qnpn13g2[ic]
print @q.xbgr.xq76_u21.qnpn13g2[ib]
print @q.xbgr.xq76_u21.qnpn13g2[ie]
print @q.xbgr.xq76_u21.qnpn13g2[is]
print @r.xbgr.xq76_u21.rsub[i]
print @c.xbgr.xq76_u21.csub[i]
print @q.xbgr.xq76_u22.qnpn13g2[ic]
print @q.xbgr.xq76_u22.qnpn13g2[ib]
print @q.xbgr.xq76_u22.qnpn13g2[ie]
print @q.xbgr.xq76_u22.qnpn13g2[is]
print @r.xbgr.xq76_u22.rsub[i]
print @c.xbgr.xq76_u22.csub[i]
print @q.xbgr.xq76_u23.qnpn13g2[ic]
print @q.xbgr.xq76_u23.qnpn13g2[ib]
print @q.xbgr.xq76_u23.qnpn13g2[ie]
print @q.xbgr.xq76_u23.qnpn13g2[is]
print @r.xbgr.xq76_u23.rsub[i]
print @c.xbgr.xq76_u23.csub[i]
print @q.xbgr.xq76_u24.qnpn13g2[ic]
print @q.xbgr.xq76_u24.qnpn13g2[ib]
print @q.xbgr.xq76_u24.qnpn13g2[ie]
print @q.xbgr.xq76_u24.qnpn13g2[is]
print @r.xbgr.xq76_u24.rsub[i]
print @c.xbgr.xq76_u24.csub[i]
print @n.xbgr.xr77_u2.nr1[ibody]
print @n.xbgr.xr77_u3.nr1[ibody]
print @n.xbgr.xr77_u4.nr1[ibody]
print @n.xbgr.xr77_u5.nr1[ibody]
print @n.xbgr.xr77_u6.nr1[ibody]
print @n.xbgr.xr77_u7.nr1[ibody]
print @n.xbgr.xr77_u8.nr1[ibody]
print @n.xbgr.xr77_u9.nr1[ibody]
print @n.xbgr.xr77_u10.nr1[ibody]
print @n.xbgr.xr77_u11.nr1[ibody]
print @n.xbgr.xr77_u12.nr1[ibody]
print @n.xbgr.xr77_u13.nr1[ibody]
print @n.xbgr.xr77_u14.nr1[ibody]
print @n.xbgr.xr77_u15.nr1[ibody]
print @n.xbgr.xr77_u16.nr1[ibody]
print @n.xbgr.xr77_u17.nr1[ibody]
print @n.xbgr.xr77_u18.nr1[ibody]
print @n.xbgr.xr77_u19.nr1[ibody]
print @n.xbgr.xr77_u20.nr1[ibody]
print @n.xbgr.xr77_u21.nr1[ibody]
print @n.xbgr.xr77_u22.nr1[ibody]
print @n.xbgr.xr77_u23.nr1[ibody]
print @n.xbgr.xr77_u24.nr1[ibody]
print @n.xbgr.xr78_u2.nr1[ibody]
print @n.xbgr.xr78_u3.nr1[ibody]
print @n.xbgr.xr78_u4.nr1[ibody]
print @n.xbgr.xr78_u5.nr1[ibody]
print @n.xbgr.xr78_u6.nr1[ibody]
print @n.xbgr.xr78_u7.nr1[ibody]
print @n.xbgr.xr78_u8.nr1[ibody]
print @n.xbgr.xr78_u9.nr1[ibody]
print @n.xbgr.xr78_u10.nr1[ibody]
print @n.xbgr.xr78_u11.nr1[ibody]
print @n.xbgr.xr78_u12.nr1[ibody]
print @n.xbgr.xr78_u13.nr1[ibody]
print @n.xbgr.xr78_u14.nr1[ibody]
print @n.xbgr.xr78_u15.nr1[ibody]
print @n.xbgr.xr78_u16.nr1[ibody]
print @n.xbgr.xr78_u17.nr1[ibody]
print @n.xbgr.xr78_u18.nr1[ibody]
print @n.xbgr.xr78_u19.nr1[ibody]
print @n.xbgr.xr78_u20.nr1[ibody]
print @n.xbgr.xr78_u21.nr1[ibody]
print @n.xbgr.xr78_u22.nr1[ibody]
print @n.xbgr.xr78_u23.nr1[ibody]
print @n.xbgr.xr78_u24.nr1[ibody]
print @n.xbgr.xr79_u2.nr1[ibody]
print @n.xbgr.xr79_u3.nr1[ibody]
print @n.xbgr.xr79_u4.nr1[ibody]
print @n.xbgr.xr79_u5.nr1[ibody]
print @n.xbgr.xr79_u6.nr1[ibody]
print @n.xbgr.xr79_u7.nr1[ibody]
print @n.xbgr.xr79_u8.nr1[ibody]
print @n.xbgr.xr79_u9.nr1[ibody]
print @n.xbgr.xr79_u10.nr1[ibody]
print @n.xbgr.xr79_u11.nr1[ibody]
print @n.xbgr.xr79_u12.nr1[ibody]
print @n.xbgr.xr79_u13.nr1[ibody]
print @n.xbgr.xr79_u14.nr1[ibody]
print @n.xbgr.xr79_u15.nr1[ibody]
print @n.xbgr.xr79_u16.nr1[ibody]
print @n.xbgr.xr79_u17.nr1[ibody]
print @n.xbgr.xr79_u18.nr1[ibody]
print @n.xbgr.xr79_u19.nr1[ibody]
print @n.xbgr.xr79_u20.nr1[ibody]
print @n.xbgr.xr79_u21.nr1[ibody]
print @n.xbgr.xr79_u22.nr1[ibody]
print @n.xbgr.xr79_u23.nr1[ibody]
print @n.xbgr.xr79_u24.nr1[ibody]
print @n.xbgr.xr80_u2.nr1[ibody]
print @n.xbgr.xr80_u3.nr1[ibody]
print @n.xbgr.xr80_u4.nr1[ibody]
print @n.xbgr.xr80_u5.nr1[ibody]
print @n.xbgr.xr80_u6.nr1[ibody]
print @n.xbgr.xr80_u7.nr1[ibody]
print @n.xbgr.xr80_u8.nr1[ibody]
print @n.xbgr.xr80_u9.nr1[ibody]
print @n.xbgr.xr80_u10.nr1[ibody]
print @n.xbgr.xr80_u11.nr1[ibody]
print @n.xbgr.xr80_u12.nr1[ibody]
print @n.xbgr.xr80_u13.nr1[ibody]
print @n.xbgr.xr80_u14.nr1[ibody]
print @n.xbgr.xr80_u15.nr1[ibody]
print @n.xbgr.xr80_u16.nr1[ibody]
print @n.xbgr.xr80_u17.nr1[ibody]
print @n.xbgr.xr80_u18.nr1[ibody]
print @n.xbgr.xr80_u19.nr1[ibody]
print @n.xbgr.xr80_u20.nr1[ibody]
print @n.xbgr.xr80_u21.nr1[ibody]
print @n.xbgr.xr80_u22.nr1[ibody]
print @n.xbgr.xr80_u23.nr1[ibody]
print @n.xbgr.xr80_u24.nr1[ibody]
print @n.xbgr.xr81_u2.nr1[ibody]
print @n.xbgr.xr81_u3.nr1[ibody]
print @n.xbgr.xr81_u4.nr1[ibody]
print @n.xbgr.xr81_u5.nr1[ibody]
print @n.xbgr.xr81_u6.nr1[ibody]
print @n.xbgr.xr81_u7.nr1[ibody]
print @n.xbgr.xr81_u8.nr1[ibody]
print @n.xbgr.xr81_u9.nr1[ibody]
print @n.xbgr.xr81_u10.nr1[ibody]
print @n.xbgr.xr81_u11.nr1[ibody]
print @n.xbgr.xr81_u12.nr1[ibody]
print @n.xbgr.xr81_u13.nr1[ibody]
print @n.xbgr.xr81_u14.nr1[ibody]
print @n.xbgr.xr81_u15.nr1[ibody]
print @n.xbgr.xr81_u16.nr1[ibody]
print @n.xbgr.xr81_u17.nr1[ibody]
print @n.xbgr.xr81_u18.nr1[ibody]
print @n.xbgr.xr81_u19.nr1[ibody]
print @n.xbgr.xr81_u20.nr1[ibody]
print @n.xbgr.xr81_u21.nr1[ibody]
print @n.xbgr.xr81_u22.nr1[ibody]
print @n.xbgr.xr81_u23.nr1[ibody]
print @n.xbgr.xr81_u24.nr1[ibody]
print @n.xbgr.xr82_u2.nr1[ibody]
print @n.xbgr.xr82_u3.nr1[ibody]
print @n.xbgr.xr82_u4.nr1[ibody]
print @n.xbgr.xr82_u5.nr1[ibody]
print @n.xbgr.xr82_u6.nr1[ibody]
print @n.xbgr.xr82_u7.nr1[ibody]
print @n.xbgr.xr82_u8.nr1[ibody]
print @n.xbgr.xr82_u9.nr1[ibody]
print @n.xbgr.xr82_u10.nr1[ibody]
print @n.xbgr.xr82_u11.nr1[ibody]
print @n.xbgr.xr82_u12.nr1[ibody]
print @n.xbgr.xr82_u13.nr1[ibody]
print @n.xbgr.xr82_u14.nr1[ibody]
print @n.xbgr.xr82_u15.nr1[ibody]
print @n.xbgr.xr82_u16.nr1[ibody]
print @n.xbgr.xr82_u17.nr1[ibody]
print @n.xbgr.xr82_u18.nr1[ibody]
print @n.xbgr.xr82_u19.nr1[ibody]
print @n.xbgr.xr82_u20.nr1[ibody]
print @n.xbgr.xr82_u21.nr1[ibody]
print @n.xbgr.xr82_u22.nr1[ibody]
print @n.xbgr.xr82_u23.nr1[ibody]
print @n.xbgr.xr82_u24.nr1[ibody]
print @n.xbgr.xr83_u2.nr1[ibody]
print @n.xbgr.xr83_u3.nr1[ibody]
print @n.xbgr.xr83_u4.nr1[ibody]
print @n.xbgr.xr83_u5.nr1[ibody]
print @n.xbgr.xr83_u6.nr1[ibody]
print @n.xbgr.xr83_u7.nr1[ibody]
print @n.xbgr.xr83_u8.nr1[ibody]
print @n.xbgr.xr83_u9.nr1[ibody]
print @n.xbgr.xr83_u10.nr1[ibody]
print @n.xbgr.xr83_u11.nr1[ibody]
print @n.xbgr.xr83_u12.nr1[ibody]
print @n.xbgr.xr83_u13.nr1[ibody]
print @n.xbgr.xr83_u14.nr1[ibody]
print @n.xbgr.xr83_u15.nr1[ibody]
print @n.xbgr.xr83_u16.nr1[ibody]
print @n.xbgr.xr83_u17.nr1[ibody]
print @n.xbgr.xr83_u18.nr1[ibody]
print @n.xbgr.xr83_u19.nr1[ibody]
print @n.xbgr.xr83_u20.nr1[ibody]
print @n.xbgr.xr83_u21.nr1[ibody]
print @n.xbgr.xr83_u22.nr1[ibody]
print @n.xbgr.xr83_u23.nr1[ibody]
print @n.xbgr.xr83_u24.nr1[ibody]
print @n.xbgr.xr84_u2.nr1[ibody]
print @n.xbgr.xr84_u3.nr1[ibody]
print @n.xbgr.xr84_u4.nr1[ibody]
print @n.xbgr.xr84_u5.nr1[ibody]
print @n.xbgr.xr84_u6.nr1[ibody]
print @n.xbgr.xr84_u7.nr1[ibody]
print @n.xbgr.xr84_u8.nr1[ibody]
print @n.xbgr.xr84_u9.nr1[ibody]
print @n.xbgr.xr84_u10.nr1[ibody]
print @n.xbgr.xr84_u11.nr1[ibody]
print @n.xbgr.xr84_u12.nr1[ibody]
print @n.xbgr.xr84_u13.nr1[ibody]
print @n.xbgr.xr84_u14.nr1[ibody]
print @n.xbgr.xr84_u15.nr1[ibody]
print @n.xbgr.xr84_u16.nr1[ibody]
print @n.xbgr.xr84_u17.nr1[ibody]
print @n.xbgr.xr84_u18.nr1[ibody]
print @n.xbgr.xr84_u19.nr1[ibody]
print @n.xbgr.xr84_u20.nr1[ibody]
print @n.xbgr.xr84_u21.nr1[ibody]
print @n.xbgr.xr84_u22.nr1[ibody]
print @n.xbgr.xr84_u23.nr1[ibody]
print @n.xbgr.xr84_u24.nr1[ibody]
print @n.xbgr.xr85_u2.nr1[ibody]
print @n.xbgr.xr85_u3.nr1[ibody]
print @n.xbgr.xr85_u4.nr1[ibody]
print @n.xbgr.xr85_u5.nr1[ibody]
print @n.xbgr.xr85_u6.nr1[ibody]
print @n.xbgr.xr85_u7.nr1[ibody]
print @n.xbgr.xr85_u8.nr1[ibody]
print @n.xbgr.xr85_u9.nr1[ibody]
print @n.xbgr.xr85_u10.nr1[ibody]
print @n.xbgr.xr85_u11.nr1[ibody]
print @n.xbgr.xr85_u12.nr1[ibody]
print @n.xbgr.xr85_u13.nr1[ibody]
print @n.xbgr.xr85_u14.nr1[ibody]
print @n.xbgr.xr85_u15.nr1[ibody]
print @n.xbgr.xr85_u16.nr1[ibody]
print @n.xbgr.xr85_u17.nr1[ibody]
print @n.xbgr.xr85_u18.nr1[ibody]
print @n.xbgr.xr85_u19.nr1[ibody]
print @n.xbgr.xr85_u20.nr1[ibody]
print @n.xbgr.xr85_u21.nr1[ibody]
print @n.xbgr.xr85_u22.nr1[ibody]
print @n.xbgr.xr85_u23.nr1[ibody]
print @n.xbgr.xr85_u24.nr1[ibody]
print @n.xbgr.xr86_u2.nr1[ibody]
print @n.xbgr.xr86_u3.nr1[ibody]
print @n.xbgr.xr86_u4.nr1[ibody]
print @n.xbgr.xr86_u5.nr1[ibody]
print @n.xbgr.xr86_u6.nr1[ibody]
print @n.xbgr.xr86_u7.nr1[ibody]
print @n.xbgr.xr86_u8.nr1[ibody]
print @n.xbgr.xr86_u9.nr1[ibody]
print @n.xbgr.xr86_u10.nr1[ibody]
print @n.xbgr.xr86_u11.nr1[ibody]
print @n.xbgr.xr86_u12.nr1[ibody]
print @n.xbgr.xr86_u13.nr1[ibody]
print @n.xbgr.xr86_u14.nr1[ibody]
print @n.xbgr.xr86_u15.nr1[ibody]
print @n.xbgr.xr86_u16.nr1[ibody]
print @n.xbgr.xr86_u17.nr1[ibody]
print @n.xbgr.xr86_u18.nr1[ibody]
print @n.xbgr.xr86_u19.nr1[ibody]
print @n.xbgr.xr86_u20.nr1[ibody]
print @n.xbgr.xr86_u21.nr1[ibody]
print @n.xbgr.xr86_u22.nr1[ibody]
print @n.xbgr.xr86_u23.nr1[ibody]
print @n.xbgr.xr86_u24.nr1[ibody]
echo RAW_CURRENT_LEDGER_END
wrdata op_nodes.dat v(xbgr.b1b) v(xbgr.c2) v(xbgr.d1) v(xbgr.d2) v(xbgr.d3) v(xbgr.d4) v(xbgr.d5) v(xbgr.det) v(dvbe) v(iptat) v(xbgr.kick) v(xbgr.n1) v(xbgr.n_10) v(xbgr.n_11) v(xbgr.n_12) v(xbgr.n_13) v(xbgr.n_14) v(xbgr.n_15) v(xbgr.n_16) v(xbgr.n_17) v(xbgr.n_18) v(xbgr.n_19) v(xbgr.n_2) v(xbgr.n_21) v(xbgr.n_22) v(xbgr.n_23) v(xbgr.n_24) v(xbgr.n_25) v(xbgr.n_26) v(xbgr.n_27) v(xbgr.n_3) v(xbgr.n_30) v(xbgr.n_31) v(xbgr.n_33) v(xbgr.n_34) v(xbgr.n_36) v(xbgr.n_37) v(xbgr.n_4) v(xbgr.n_5) v(xbgr.n_6) v(xbgr.n_7) v(xbgr.n_8) v(xbgr.n_9) v(pbias) v(pcasc) v(r4) v(xbgr.r4n) v(xbgr.vb2) v(vbe) v(xbgr.vbe3) v(xbgr.vd1) v(xbgr.vd2) v(vdd) v(vref) v(vdd)-v(vdd) i(vdd) i(vload) i(vr4) i(vsub)
print @n.xbgr.xr1.nr1[nsmm_rsh]
print @n.xbgr.xr1.nr1[nsmm_w]
print @n.xbgr.xr1.nr1[nsmm_l]
print @n.xbgr.xr2.nr1[nsmm_rsh]
print @n.xbgr.xr2.nr1[nsmm_w]
print @n.xbgr.xr2.nr1[nsmm_l]
print @n.xbgr.xr3.nr1[nsmm_rsh]
print @n.xbgr.xr3.nr1[nsmm_w]
print @n.xbgr.xr3.nr1[nsmm_l]
print @n.xbgr.xr4.nr1[nsmm_rsh]
print @n.xbgr.xr4.nr1[nsmm_w]
print @n.xbgr.xr4.nr1[nsmm_l]
print @n.xbgr.xr5.nr1[nsmm_rsh]
print @n.xbgr.xr5.nr1[nsmm_w]
print @n.xbgr.xr5.nr1[nsmm_l]
print @n.xbgr.xr6.nr1[nsmm_rsh]
print @n.xbgr.xr6.nr1[nsmm_w]
print @n.xbgr.xr6.nr1[nsmm_l]
print @n.xbgr.xr7.nr1[nsmm_rsh]
print @n.xbgr.xr7.nr1[nsmm_w]
print @n.xbgr.xr7.nr1[nsmm_l]
print @n.xbgr.xr8.nr1[nsmm_rsh]
print @n.xbgr.xr8.nr1[nsmm_w]
print @n.xbgr.xr8.nr1[nsmm_l]
print @n.xbgr.xr9.nr1[nsmm_rsh]
print @n.xbgr.xr9.nr1[nsmm_w]
print @n.xbgr.xr9.nr1[nsmm_l]
print @n.xbgr.xr10.nr1[nsmm_rsh]
print @n.xbgr.xr10.nr1[nsmm_w]
print @n.xbgr.xr10.nr1[nsmm_l]
print @n.xbgr.xr11.nr1[nsmm_rsh]
print @n.xbgr.xr11.nr1[nsmm_w]
print @n.xbgr.xr11.nr1[nsmm_l]
print @n.xbgr.xr12.nr1[nsmm_rsh]
print @n.xbgr.xr12.nr1[nsmm_w]
print @n.xbgr.xr12.nr1[nsmm_l]
print @n.xbgr.xr13.nr1[nsmm_rsh]
print @n.xbgr.xr13.nr1[nsmm_w]
print @n.xbgr.xr13.nr1[nsmm_l]
print @n.xbgr.xr14.nr1[nsmm_rsh]
print @n.xbgr.xr14.nr1[nsmm_w]
print @n.xbgr.xr14.nr1[nsmm_l]
print @n.xbgr.xr15.nr1[nsmm_rsh]
print @n.xbgr.xr15.nr1[nsmm_w]
print @n.xbgr.xr15.nr1[nsmm_l]
print @n.xbgr.xr16.nr1[nsmm_rsh]
print @n.xbgr.xr16.nr1[nsmm_w]
print @n.xbgr.xr16.nr1[nsmm_l]
print @n.xbgr.xr17.nr1[nsmm_rsh]
print @n.xbgr.xr17.nr1[nsmm_w]
print @n.xbgr.xr17.nr1[nsmm_l]
print @n.xbgr.xr18.nr1[nsmm_rsh]
print @n.xbgr.xr18.nr1[nsmm_w]
print @n.xbgr.xr18.nr1[nsmm_l]
print @n.xbgr.xr19.nr1[nsmm_rsh]
print @n.xbgr.xr19.nr1[nsmm_w]
print @n.xbgr.xr19.nr1[nsmm_l]
print @n.xbgr.xr20.nr1[nsmm_rsh]
print @n.xbgr.xr20.nr1[nsmm_w]
print @n.xbgr.xr20.nr1[nsmm_l]
print @n.xbgr.xr21.nr1[nsmm_rsh]
print @n.xbgr.xr21.nr1[nsmm_w]
print @n.xbgr.xr21.nr1[nsmm_l]
print @n.xbgr.xr22.nr1[nsmm_rsh]
print @n.xbgr.xr22.nr1[nsmm_w]
print @n.xbgr.xr22.nr1[nsmm_l]
print @n.xbgr.xr23.nr1[nsmm_rsh]
print @n.xbgr.xr23.nr1[nsmm_w]
print @n.xbgr.xr23.nr1[nsmm_l]
print @n.xbgr.xr24.nr1[nsmm_rsh]
print @n.xbgr.xr24.nr1[nsmm_w]
print @n.xbgr.xr24.nr1[nsmm_l]
print @n.xbgr.xr25.nr1[nsmm_rsh]
print @n.xbgr.xr25.nr1[nsmm_w]
print @n.xbgr.xr25.nr1[nsmm_l]
print @n.xbgr.xr26.nr1[nsmm_rsh]
print @n.xbgr.xr26.nr1[nsmm_w]
print @n.xbgr.xr26.nr1[nsmm_l]
print @n.xbgr.xm27.nsg13_hv_pmos[w]
print @n.xbgr.xm27.nsg13_hv_pmos[l]
print @n.xbgr.xm27.nsg13_hv_pmos[delvto]
print @n.xbgr.xm27.nsg13_hv_pmos[factuo]
print @n.xbgr.xm28.nsg13_hv_pmos[w]
print @n.xbgr.xm28.nsg13_hv_pmos[l]
print @n.xbgr.xm28.nsg13_hv_pmos[delvto]
print @n.xbgr.xm28.nsg13_hv_pmos[factuo]
print @n.xbgr.xm29.nsg13_hv_nmos[w]
print @n.xbgr.xm29.nsg13_hv_nmos[l]
print @n.xbgr.xm29.nsg13_hv_nmos[delvto]
print @n.xbgr.xm29.nsg13_hv_nmos[factuo]
print @n.xbgr.xm30.nsg13_hv_nmos[w]
print @n.xbgr.xm30.nsg13_hv_nmos[l]
print @n.xbgr.xm30.nsg13_hv_nmos[delvto]
print @n.xbgr.xm30.nsg13_hv_nmos[factuo]
print @n.xbgr.xm31.nsg13_hv_nmos[w]
print @n.xbgr.xm31.nsg13_hv_nmos[l]
print @n.xbgr.xm31.nsg13_hv_nmos[delvto]
print @n.xbgr.xm31.nsg13_hv_nmos[factuo]
print @n.xbgr.xm32.nsg13_hv_nmos[w]
print @n.xbgr.xm32.nsg13_hv_nmos[l]
print @n.xbgr.xm32.nsg13_hv_nmos[delvto]
print @n.xbgr.xm32.nsg13_hv_nmos[factuo]
print @n.xbgr.xm33.nsg13_hv_nmos[w]
print @n.xbgr.xm33.nsg13_hv_nmos[l]
print @n.xbgr.xm33.nsg13_hv_nmos[delvto]
print @n.xbgr.xm33.nsg13_hv_nmos[factuo]
print @n.xbgr.xm34.nsg13_hv_nmos[w]
print @n.xbgr.xm34.nsg13_hv_nmos[l]
print @n.xbgr.xm34.nsg13_hv_nmos[delvto]
print @n.xbgr.xm34.nsg13_hv_nmos[factuo]
print @n.xbgr.xm35.nsg13_hv_nmos[w]
print @n.xbgr.xm35.nsg13_hv_nmos[l]
print @n.xbgr.xm35.nsg13_hv_nmos[delvto]
print @n.xbgr.xm35.nsg13_hv_nmos[factuo]
print @n.xbgr.xm36.nsg13_hv_nmos[w]
print @n.xbgr.xm36.nsg13_hv_nmos[l]
print @n.xbgr.xm36.nsg13_hv_nmos[delvto]
print @n.xbgr.xm36.nsg13_hv_nmos[factuo]
print @n.xbgr.xm37.nsg13_hv_nmos[w]
print @n.xbgr.xm37.nsg13_hv_nmos[l]
print @n.xbgr.xm37.nsg13_hv_nmos[delvto]
print @n.xbgr.xm37.nsg13_hv_nmos[factuo]
print @n.xbgr.xm38.nsg13_hv_pmos[w]
print @n.xbgr.xm38.nsg13_hv_pmos[l]
print @n.xbgr.xm38.nsg13_hv_pmos[delvto]
print @n.xbgr.xm38.nsg13_hv_pmos[factuo]
print @n.xbgr.xm39.nsg13_hv_pmos[w]
print @n.xbgr.xm39.nsg13_hv_pmos[l]
print @n.xbgr.xm39.nsg13_hv_pmos[delvto]
print @n.xbgr.xm39.nsg13_hv_pmos[factuo]
print @n.xbgr.xm40.nsg13_hv_pmos[w]
print @n.xbgr.xm40.nsg13_hv_pmos[l]
print @n.xbgr.xm40.nsg13_hv_pmos[delvto]
print @n.xbgr.xm40.nsg13_hv_pmos[factuo]
print @n.xbgr.xm41.nsg13_hv_pmos[w]
print @n.xbgr.xm41.nsg13_hv_pmos[l]
print @n.xbgr.xm41.nsg13_hv_pmos[delvto]
print @n.xbgr.xm41.nsg13_hv_pmos[factuo]
print @n.xbgr.xm42.nsg13_hv_pmos[w]
print @n.xbgr.xm42.nsg13_hv_pmos[l]
print @n.xbgr.xm42.nsg13_hv_pmos[delvto]
print @n.xbgr.xm42.nsg13_hv_pmos[factuo]
print @n.xbgr.xm43.nsg13_hv_pmos[w]
print @n.xbgr.xm43.nsg13_hv_pmos[l]
print @n.xbgr.xm43.nsg13_hv_pmos[delvto]
print @n.xbgr.xm43.nsg13_hv_pmos[factuo]
print @n.xbgr.xm44.nsg13_hv_pmos[w]
print @n.xbgr.xm44.nsg13_hv_pmos[l]
print @n.xbgr.xm44.nsg13_hv_pmos[delvto]
print @n.xbgr.xm44.nsg13_hv_pmos[factuo]
print @n.xbgr.xm45.nsg13_hv_pmos[w]
print @n.xbgr.xm45.nsg13_hv_pmos[l]
print @n.xbgr.xm45.nsg13_hv_pmos[delvto]
print @n.xbgr.xm45.nsg13_hv_pmos[factuo]
print @n.xbgr.xm46.nsg13_hv_pmos[w]
print @n.xbgr.xm46.nsg13_hv_pmos[l]
print @n.xbgr.xm46.nsg13_hv_pmos[delvto]
print @n.xbgr.xm46.nsg13_hv_pmos[factuo]
print @n.xbgr.xm47.nsg13_hv_pmos[w]
print @n.xbgr.xm47.nsg13_hv_pmos[l]
print @n.xbgr.xm47.nsg13_hv_pmos[delvto]
print @n.xbgr.xm47.nsg13_hv_pmos[factuo]
print @n.xbgr.xm48.nsg13_hv_pmos[w]
print @n.xbgr.xm48.nsg13_hv_pmos[l]
print @n.xbgr.xm48.nsg13_hv_pmos[delvto]
print @n.xbgr.xm48.nsg13_hv_pmos[factuo]
print @n.xbgr.xm49.nsg13_hv_pmos[w]
print @n.xbgr.xm49.nsg13_hv_pmos[l]
print @n.xbgr.xm49.nsg13_hv_pmos[delvto]
print @n.xbgr.xm49.nsg13_hv_pmos[factuo]
print @n.xbgr.xm50.nsg13_hv_pmos[w]
print @n.xbgr.xm50.nsg13_hv_pmos[l]
print @n.xbgr.xm50.nsg13_hv_pmos[delvto]
print @n.xbgr.xm50.nsg13_hv_pmos[factuo]
print @n.xbgr.xm51.nsg13_hv_pmos[w]
print @n.xbgr.xm51.nsg13_hv_pmos[l]
print @n.xbgr.xm51.nsg13_hv_pmos[delvto]
print @n.xbgr.xm51.nsg13_hv_pmos[factuo]
print @n.xbgr.xm52.nsg13_hv_pmos[w]
print @n.xbgr.xm52.nsg13_hv_pmos[l]
print @n.xbgr.xm52.nsg13_hv_pmos[delvto]
print @n.xbgr.xm52.nsg13_hv_pmos[factuo]
print @n.xbgr.xm53.nsg13_hv_pmos[w]
print @n.xbgr.xm53.nsg13_hv_pmos[l]
print @n.xbgr.xm53.nsg13_hv_pmos[delvto]
print @n.xbgr.xm53.nsg13_hv_pmos[factuo]
print @n.xbgr.xm54.nsg13_hv_pmos[w]
print @n.xbgr.xm54.nsg13_hv_pmos[l]
print @n.xbgr.xm54.nsg13_hv_pmos[delvto]
print @n.xbgr.xm54.nsg13_hv_pmos[factuo]
print @q.xbgr.xq55.qnpn13g2[area]
print @q.xbgr.xq56.qnpn13g2[area]
print @q.xbgr.xq57.qnpn13g2[area]
print @q.xbgr.xq58.qnpn13g2[area]
print @q.xbgr.xq59.qnpn13g2[area]
print @q.xbgr.xq60.qnpn13g2[area]
print @q.xbgr.xq61.qnpn13g2[area]
print @q.xbgr.xq62.qnpn13g2[area]
print @q.xbgr.xq63.qnpn13g2[area]
print @q.xbgr.xq64.qnpn13g2[area]
print @q.xbgr.xq65.qnpn13g2[area]
print @q.xbgr.xq66.qnpn13g2[area]
print @q.xbgr.xq67.qnpn13g2[area]
print @q.xbgr.xq68.qnpn13g2[area]
print @q.xbgr.xq69.qnpn13g2[area]
print @q.xbgr.xq70.qnpn13g2[area]
print @q.xbgr.xq71.qnpn13g2[area]
print @q.xbgr.xq72.qnpn13g2[area]
print @q.xbgr.xq73.qnpn13g2[area]
print @q.xbgr.xq74.qnpn13g2[area]
print @q.xbgr.xq75.qnpn13g2[area]
print @q.xbgr.xq76.qnpn13g2[area]
print @n.xbgr.xr77.nr1[nsmm_rsh]
print @n.xbgr.xr77.nr1[nsmm_w]
print @n.xbgr.xr77.nr1[nsmm_l]
print @n.xbgr.xr78.nr1[nsmm_rsh]
print @n.xbgr.xr78.nr1[nsmm_w]
print @n.xbgr.xr78.nr1[nsmm_l]
print @n.xbgr.xr79.nr1[nsmm_rsh]
print @n.xbgr.xr79.nr1[nsmm_w]
print @n.xbgr.xr79.nr1[nsmm_l]
print @n.xbgr.xr80.nr1[nsmm_rsh]
print @n.xbgr.xr80.nr1[nsmm_w]
print @n.xbgr.xr80.nr1[nsmm_l]
print @n.xbgr.xr81.nr1[nsmm_rsh]
print @n.xbgr.xr81.nr1[nsmm_w]
print @n.xbgr.xr81.nr1[nsmm_l]
print @n.xbgr.xr82.nr1[nsmm_rsh]
print @n.xbgr.xr82.nr1[nsmm_w]
print @n.xbgr.xr82.nr1[nsmm_l]
print @n.xbgr.xr83.nr1[nsmm_rsh]
print @n.xbgr.xr83.nr1[nsmm_w]
print @n.xbgr.xr83.nr1[nsmm_l]
print @n.xbgr.xr84.nr1[nsmm_rsh]
print @n.xbgr.xr84.nr1[nsmm_w]
print @n.xbgr.xr84.nr1[nsmm_l]
print @n.xbgr.xr85.nr1[nsmm_rsh]
print @n.xbgr.xr85.nr1[nsmm_w]
print @n.xbgr.xr85.nr1[nsmm_l]
print @n.xbgr.xr86.nr1[nsmm_rsh]
print @n.xbgr.xr86.nr1[nsmm_w]
print @n.xbgr.xr86.nr1[nsmm_l]
print @n.xbgr.xr16_u2.nr1[nsmm_rsh]
print @n.xbgr.xr16_u2.nr1[nsmm_w]
print @n.xbgr.xr16_u2.nr1[nsmm_l]
print @n.xbgr.xr16_u3.nr1[nsmm_rsh]
print @n.xbgr.xr16_u3.nr1[nsmm_w]
print @n.xbgr.xr16_u3.nr1[nsmm_l]
print @n.xbgr.xr16_u4.nr1[nsmm_rsh]
print @n.xbgr.xr16_u4.nr1[nsmm_w]
print @n.xbgr.xr16_u4.nr1[nsmm_l]
print @n.xbgr.xr16_u5.nr1[nsmm_rsh]
print @n.xbgr.xr16_u5.nr1[nsmm_w]
print @n.xbgr.xr16_u5.nr1[nsmm_l]
print @n.xbgr.xr16_u6.nr1[nsmm_rsh]
print @n.xbgr.xr16_u6.nr1[nsmm_w]
print @n.xbgr.xr16_u6.nr1[nsmm_l]
print @n.xbgr.xr16_u7.nr1[nsmm_rsh]
print @n.xbgr.xr16_u7.nr1[nsmm_w]
print @n.xbgr.xr16_u7.nr1[nsmm_l]
print @n.xbgr.xr16_u8.nr1[nsmm_rsh]
print @n.xbgr.xr16_u8.nr1[nsmm_w]
print @n.xbgr.xr16_u8.nr1[nsmm_l]
print @n.xbgr.xr16_u9.nr1[nsmm_rsh]
print @n.xbgr.xr16_u9.nr1[nsmm_w]
print @n.xbgr.xr16_u9.nr1[nsmm_l]
print @n.xbgr.xr16_u10.nr1[nsmm_rsh]
print @n.xbgr.xr16_u10.nr1[nsmm_w]
print @n.xbgr.xr16_u10.nr1[nsmm_l]
print @n.xbgr.xr16_u11.nr1[nsmm_rsh]
print @n.xbgr.xr16_u11.nr1[nsmm_w]
print @n.xbgr.xr16_u11.nr1[nsmm_l]
print @n.xbgr.xr16_u12.nr1[nsmm_rsh]
print @n.xbgr.xr16_u12.nr1[nsmm_w]
print @n.xbgr.xr16_u12.nr1[nsmm_l]
print @n.xbgr.xr16_u13.nr1[nsmm_rsh]
print @n.xbgr.xr16_u13.nr1[nsmm_w]
print @n.xbgr.xr16_u13.nr1[nsmm_l]
print @n.xbgr.xr16_u14.nr1[nsmm_rsh]
print @n.xbgr.xr16_u14.nr1[nsmm_w]
print @n.xbgr.xr16_u14.nr1[nsmm_l]
print @n.xbgr.xr16_u15.nr1[nsmm_rsh]
print @n.xbgr.xr16_u15.nr1[nsmm_w]
print @n.xbgr.xr16_u15.nr1[nsmm_l]
print @n.xbgr.xr16_u16.nr1[nsmm_rsh]
print @n.xbgr.xr16_u16.nr1[nsmm_w]
print @n.xbgr.xr16_u16.nr1[nsmm_l]
print @n.xbgr.xr16_u17.nr1[nsmm_rsh]
print @n.xbgr.xr16_u17.nr1[nsmm_w]
print @n.xbgr.xr16_u17.nr1[nsmm_l]
print @n.xbgr.xr16_u18.nr1[nsmm_rsh]
print @n.xbgr.xr16_u18.nr1[nsmm_w]
print @n.xbgr.xr16_u18.nr1[nsmm_l]
print @n.xbgr.xr16_u19.nr1[nsmm_rsh]
print @n.xbgr.xr16_u19.nr1[nsmm_w]
print @n.xbgr.xr16_u19.nr1[nsmm_l]
print @n.xbgr.xr16_u20.nr1[nsmm_rsh]
print @n.xbgr.xr16_u20.nr1[nsmm_w]
print @n.xbgr.xr16_u20.nr1[nsmm_l]
print @n.xbgr.xr16_u21.nr1[nsmm_rsh]
print @n.xbgr.xr16_u21.nr1[nsmm_w]
print @n.xbgr.xr16_u21.nr1[nsmm_l]
print @n.xbgr.xr16_u22.nr1[nsmm_rsh]
print @n.xbgr.xr16_u22.nr1[nsmm_w]
print @n.xbgr.xr16_u22.nr1[nsmm_l]
print @n.xbgr.xr16_u23.nr1[nsmm_rsh]
print @n.xbgr.xr16_u23.nr1[nsmm_w]
print @n.xbgr.xr16_u23.nr1[nsmm_l]
print @n.xbgr.xr16_u24.nr1[nsmm_rsh]
print @n.xbgr.xr16_u24.nr1[nsmm_w]
print @n.xbgr.xr16_u24.nr1[nsmm_l]
print @n.xbgr.xr17_u2.nr1[nsmm_rsh]
print @n.xbgr.xr17_u2.nr1[nsmm_w]
print @n.xbgr.xr17_u2.nr1[nsmm_l]
print @n.xbgr.xr17_u3.nr1[nsmm_rsh]
print @n.xbgr.xr17_u3.nr1[nsmm_w]
print @n.xbgr.xr17_u3.nr1[nsmm_l]
print @n.xbgr.xr17_u4.nr1[nsmm_rsh]
print @n.xbgr.xr17_u4.nr1[nsmm_w]
print @n.xbgr.xr17_u4.nr1[nsmm_l]
print @n.xbgr.xr18_u2.nr1[nsmm_rsh]
print @n.xbgr.xr18_u2.nr1[nsmm_w]
print @n.xbgr.xr18_u2.nr1[nsmm_l]
print @n.xbgr.xr18_u3.nr1[nsmm_rsh]
print @n.xbgr.xr18_u3.nr1[nsmm_w]
print @n.xbgr.xr18_u3.nr1[nsmm_l]
print @n.xbgr.xr18_u4.nr1[nsmm_rsh]
print @n.xbgr.xr18_u4.nr1[nsmm_w]
print @n.xbgr.xr18_u4.nr1[nsmm_l]
print @n.xbgr.xr19_u2.nr1[nsmm_rsh]
print @n.xbgr.xr19_u2.nr1[nsmm_w]
print @n.xbgr.xr19_u2.nr1[nsmm_l]
print @n.xbgr.xr19_u3.nr1[nsmm_rsh]
print @n.xbgr.xr19_u3.nr1[nsmm_w]
print @n.xbgr.xr19_u3.nr1[nsmm_l]
print @n.xbgr.xr19_u4.nr1[nsmm_rsh]
print @n.xbgr.xr19_u4.nr1[nsmm_w]
print @n.xbgr.xr19_u4.nr1[nsmm_l]
print @n.xbgr.xr20_u2.nr1[nsmm_rsh]
print @n.xbgr.xr20_u2.nr1[nsmm_w]
print @n.xbgr.xr20_u2.nr1[nsmm_l]
print @n.xbgr.xr20_u3.nr1[nsmm_rsh]
print @n.xbgr.xr20_u3.nr1[nsmm_w]
print @n.xbgr.xr20_u3.nr1[nsmm_l]
print @n.xbgr.xr20_u4.nr1[nsmm_rsh]
print @n.xbgr.xr20_u4.nr1[nsmm_w]
print @n.xbgr.xr20_u4.nr1[nsmm_l]
print @n.xbgr.xr21_u2.nr1[nsmm_rsh]
print @n.xbgr.xr21_u2.nr1[nsmm_w]
print @n.xbgr.xr21_u2.nr1[nsmm_l]
print @n.xbgr.xr21_u3.nr1[nsmm_rsh]
print @n.xbgr.xr21_u3.nr1[nsmm_w]
print @n.xbgr.xr21_u3.nr1[nsmm_l]
print @n.xbgr.xr21_u4.nr1[nsmm_rsh]
print @n.xbgr.xr21_u4.nr1[nsmm_w]
print @n.xbgr.xr21_u4.nr1[nsmm_l]
print @n.xbgr.xr22_u2.nr1[nsmm_rsh]
print @n.xbgr.xr22_u2.nr1[nsmm_w]
print @n.xbgr.xr22_u2.nr1[nsmm_l]
print @n.xbgr.xr22_u3.nr1[nsmm_rsh]
print @n.xbgr.xr22_u3.nr1[nsmm_w]
print @n.xbgr.xr22_u3.nr1[nsmm_l]
print @n.xbgr.xr22_u4.nr1[nsmm_rsh]
print @n.xbgr.xr22_u4.nr1[nsmm_w]
print @n.xbgr.xr22_u4.nr1[nsmm_l]
print @n.xbgr.xr23_u2.nr1[nsmm_rsh]
print @n.xbgr.xr23_u2.nr1[nsmm_w]
print @n.xbgr.xr23_u2.nr1[nsmm_l]
print @n.xbgr.xr23_u3.nr1[nsmm_rsh]
print @n.xbgr.xr23_u3.nr1[nsmm_w]
print @n.xbgr.xr23_u3.nr1[nsmm_l]
print @n.xbgr.xr23_u4.nr1[nsmm_rsh]
print @n.xbgr.xr23_u4.nr1[nsmm_w]
print @n.xbgr.xr23_u4.nr1[nsmm_l]
print @n.xbgr.xr23_u5.nr1[nsmm_rsh]
print @n.xbgr.xr23_u5.nr1[nsmm_w]
print @n.xbgr.xr23_u5.nr1[nsmm_l]
print @n.xbgr.xr23_u6.nr1[nsmm_rsh]
print @n.xbgr.xr23_u6.nr1[nsmm_w]
print @n.xbgr.xr23_u6.nr1[nsmm_l]
print @n.xbgr.xr23_u7.nr1[nsmm_rsh]
print @n.xbgr.xr23_u7.nr1[nsmm_w]
print @n.xbgr.xr23_u7.nr1[nsmm_l]
print @n.xbgr.xr23_u8.nr1[nsmm_rsh]
print @n.xbgr.xr23_u8.nr1[nsmm_w]
print @n.xbgr.xr23_u8.nr1[nsmm_l]
print @n.xbgr.xr23_u9.nr1[nsmm_rsh]
print @n.xbgr.xr23_u9.nr1[nsmm_w]
print @n.xbgr.xr23_u9.nr1[nsmm_l]
print @n.xbgr.xr23_u10.nr1[nsmm_rsh]
print @n.xbgr.xr23_u10.nr1[nsmm_w]
print @n.xbgr.xr23_u10.nr1[nsmm_l]
print @n.xbgr.xr23_u11.nr1[nsmm_rsh]
print @n.xbgr.xr23_u11.nr1[nsmm_w]
print @n.xbgr.xr23_u11.nr1[nsmm_l]
print @n.xbgr.xr23_u12.nr1[nsmm_rsh]
print @n.xbgr.xr23_u12.nr1[nsmm_w]
print @n.xbgr.xr23_u12.nr1[nsmm_l]
print @n.xbgr.xr23_u13.nr1[nsmm_rsh]
print @n.xbgr.xr23_u13.nr1[nsmm_w]
print @n.xbgr.xr23_u13.nr1[nsmm_l]
print @n.xbgr.xr23_u14.nr1[nsmm_rsh]
print @n.xbgr.xr23_u14.nr1[nsmm_w]
print @n.xbgr.xr23_u14.nr1[nsmm_l]
print @n.xbgr.xr23_u15.nr1[nsmm_rsh]
print @n.xbgr.xr23_u15.nr1[nsmm_w]
print @n.xbgr.xr23_u15.nr1[nsmm_l]
print @n.xbgr.xr23_u16.nr1[nsmm_rsh]
print @n.xbgr.xr23_u16.nr1[nsmm_w]
print @n.xbgr.xr23_u16.nr1[nsmm_l]
print @n.xbgr.xr23_u17.nr1[nsmm_rsh]
print @n.xbgr.xr23_u17.nr1[nsmm_w]
print @n.xbgr.xr23_u17.nr1[nsmm_l]
print @n.xbgr.xr23_u18.nr1[nsmm_rsh]
print @n.xbgr.xr23_u18.nr1[nsmm_w]
print @n.xbgr.xr23_u18.nr1[nsmm_l]
print @n.xbgr.xr23_u19.nr1[nsmm_rsh]
print @n.xbgr.xr23_u19.nr1[nsmm_w]
print @n.xbgr.xr23_u19.nr1[nsmm_l]
print @n.xbgr.xr23_u20.nr1[nsmm_rsh]
print @n.xbgr.xr23_u20.nr1[nsmm_w]
print @n.xbgr.xr23_u20.nr1[nsmm_l]
print @n.xbgr.xr23_u21.nr1[nsmm_rsh]
print @n.xbgr.xr23_u21.nr1[nsmm_w]
print @n.xbgr.xr23_u21.nr1[nsmm_l]
print @n.xbgr.xr23_u22.nr1[nsmm_rsh]
print @n.xbgr.xr23_u22.nr1[nsmm_w]
print @n.xbgr.xr23_u22.nr1[nsmm_l]
print @n.xbgr.xr23_u23.nr1[nsmm_rsh]
print @n.xbgr.xr23_u23.nr1[nsmm_w]
print @n.xbgr.xr23_u23.nr1[nsmm_l]
print @n.xbgr.xr23_u24.nr1[nsmm_rsh]
print @n.xbgr.xr23_u24.nr1[nsmm_w]
print @n.xbgr.xr23_u24.nr1[nsmm_l]
print @n.xbgr.xr24_u2.nr1[nsmm_rsh]
print @n.xbgr.xr24_u2.nr1[nsmm_w]
print @n.xbgr.xr24_u2.nr1[nsmm_l]
print @n.xbgr.xr24_u3.nr1[nsmm_rsh]
print @n.xbgr.xr24_u3.nr1[nsmm_w]
print @n.xbgr.xr24_u3.nr1[nsmm_l]
print @n.xbgr.xr24_u4.nr1[nsmm_rsh]
print @n.xbgr.xr24_u4.nr1[nsmm_w]
print @n.xbgr.xr24_u4.nr1[nsmm_l]
print @n.xbgr.xr24_u5.nr1[nsmm_rsh]
print @n.xbgr.xr24_u5.nr1[nsmm_w]
print @n.xbgr.xr24_u5.nr1[nsmm_l]
print @n.xbgr.xr24_u6.nr1[nsmm_rsh]
print @n.xbgr.xr24_u6.nr1[nsmm_w]
print @n.xbgr.xr24_u6.nr1[nsmm_l]
print @n.xbgr.xr24_u7.nr1[nsmm_rsh]
print @n.xbgr.xr24_u7.nr1[nsmm_w]
print @n.xbgr.xr24_u7.nr1[nsmm_l]
print @n.xbgr.xr24_u8.nr1[nsmm_rsh]
print @n.xbgr.xr24_u8.nr1[nsmm_w]
print @n.xbgr.xr24_u8.nr1[nsmm_l]
print @n.xbgr.xr24_u9.nr1[nsmm_rsh]
print @n.xbgr.xr24_u9.nr1[nsmm_w]
print @n.xbgr.xr24_u9.nr1[nsmm_l]
print @n.xbgr.xr24_u10.nr1[nsmm_rsh]
print @n.xbgr.xr24_u10.nr1[nsmm_w]
print @n.xbgr.xr24_u10.nr1[nsmm_l]
print @n.xbgr.xr24_u11.nr1[nsmm_rsh]
print @n.xbgr.xr24_u11.nr1[nsmm_w]
print @n.xbgr.xr24_u11.nr1[nsmm_l]
print @n.xbgr.xr24_u12.nr1[nsmm_rsh]
print @n.xbgr.xr24_u12.nr1[nsmm_w]
print @n.xbgr.xr24_u12.nr1[nsmm_l]
print @n.xbgr.xr24_u13.nr1[nsmm_rsh]
print @n.xbgr.xr24_u13.nr1[nsmm_w]
print @n.xbgr.xr24_u13.nr1[nsmm_l]
print @n.xbgr.xr24_u14.nr1[nsmm_rsh]
print @n.xbgr.xr24_u14.nr1[nsmm_w]
print @n.xbgr.xr24_u14.nr1[nsmm_l]
print @n.xbgr.xr24_u15.nr1[nsmm_rsh]
print @n.xbgr.xr24_u15.nr1[nsmm_w]
print @n.xbgr.xr24_u15.nr1[nsmm_l]
print @n.xbgr.xr24_u16.nr1[nsmm_rsh]
print @n.xbgr.xr24_u16.nr1[nsmm_w]
print @n.xbgr.xr24_u16.nr1[nsmm_l]
print @n.xbgr.xr24_u17.nr1[nsmm_rsh]
print @n.xbgr.xr24_u17.nr1[nsmm_w]
print @n.xbgr.xr24_u17.nr1[nsmm_l]
print @n.xbgr.xr24_u18.nr1[nsmm_rsh]
print @n.xbgr.xr24_u18.nr1[nsmm_w]
print @n.xbgr.xr24_u18.nr1[nsmm_l]
print @n.xbgr.xr24_u19.nr1[nsmm_rsh]
print @n.xbgr.xr24_u19.nr1[nsmm_w]
print @n.xbgr.xr24_u19.nr1[nsmm_l]
print @n.xbgr.xr24_u20.nr1[nsmm_rsh]
print @n.xbgr.xr24_u20.nr1[nsmm_w]
print @n.xbgr.xr24_u20.nr1[nsmm_l]
print @n.xbgr.xr24_u21.nr1[nsmm_rsh]
print @n.xbgr.xr24_u21.nr1[nsmm_w]
print @n.xbgr.xr24_u21.nr1[nsmm_l]
print @n.xbgr.xr24_u22.nr1[nsmm_rsh]
print @n.xbgr.xr24_u22.nr1[nsmm_w]
print @n.xbgr.xr24_u22.nr1[nsmm_l]
print @n.xbgr.xr24_u23.nr1[nsmm_rsh]
print @n.xbgr.xr24_u23.nr1[nsmm_w]
print @n.xbgr.xr24_u23.nr1[nsmm_l]
print @n.xbgr.xr24_u24.nr1[nsmm_rsh]
print @n.xbgr.xr24_u24.nr1[nsmm_w]
print @n.xbgr.xr24_u24.nr1[nsmm_l]
print @n.xbgr.xr25_u2.nr1[nsmm_rsh]
print @n.xbgr.xr25_u2.nr1[nsmm_w]
print @n.xbgr.xr25_u2.nr1[nsmm_l]
print @n.xbgr.xr25_u3.nr1[nsmm_rsh]
print @n.xbgr.xr25_u3.nr1[nsmm_w]
print @n.xbgr.xr25_u3.nr1[nsmm_l]
print @n.xbgr.xr25_u4.nr1[nsmm_rsh]
print @n.xbgr.xr25_u4.nr1[nsmm_w]
print @n.xbgr.xr25_u4.nr1[nsmm_l]
print @n.xbgr.xr25_u5.nr1[nsmm_rsh]
print @n.xbgr.xr25_u5.nr1[nsmm_w]
print @n.xbgr.xr25_u5.nr1[nsmm_l]
print @n.xbgr.xr25_u6.nr1[nsmm_rsh]
print @n.xbgr.xr25_u6.nr1[nsmm_w]
print @n.xbgr.xr25_u6.nr1[nsmm_l]
print @n.xbgr.xr25_u7.nr1[nsmm_rsh]
print @n.xbgr.xr25_u7.nr1[nsmm_w]
print @n.xbgr.xr25_u7.nr1[nsmm_l]
print @n.xbgr.xr25_u8.nr1[nsmm_rsh]
print @n.xbgr.xr25_u8.nr1[nsmm_w]
print @n.xbgr.xr25_u8.nr1[nsmm_l]
print @n.xbgr.xr25_u9.nr1[nsmm_rsh]
print @n.xbgr.xr25_u9.nr1[nsmm_w]
print @n.xbgr.xr25_u9.nr1[nsmm_l]
print @n.xbgr.xr25_u10.nr1[nsmm_rsh]
print @n.xbgr.xr25_u10.nr1[nsmm_w]
print @n.xbgr.xr25_u10.nr1[nsmm_l]
print @n.xbgr.xr25_u11.nr1[nsmm_rsh]
print @n.xbgr.xr25_u11.nr1[nsmm_w]
print @n.xbgr.xr25_u11.nr1[nsmm_l]
print @n.xbgr.xr25_u12.nr1[nsmm_rsh]
print @n.xbgr.xr25_u12.nr1[nsmm_w]
print @n.xbgr.xr25_u12.nr1[nsmm_l]
print @n.xbgr.xr25_u13.nr1[nsmm_rsh]
print @n.xbgr.xr25_u13.nr1[nsmm_w]
print @n.xbgr.xr25_u13.nr1[nsmm_l]
print @n.xbgr.xr25_u14.nr1[nsmm_rsh]
print @n.xbgr.xr25_u14.nr1[nsmm_w]
print @n.xbgr.xr25_u14.nr1[nsmm_l]
print @n.xbgr.xr25_u15.nr1[nsmm_rsh]
print @n.xbgr.xr25_u15.nr1[nsmm_w]
print @n.xbgr.xr25_u15.nr1[nsmm_l]
print @n.xbgr.xr25_u16.nr1[nsmm_rsh]
print @n.xbgr.xr25_u16.nr1[nsmm_w]
print @n.xbgr.xr25_u16.nr1[nsmm_l]
print @n.xbgr.xr25_u17.nr1[nsmm_rsh]
print @n.xbgr.xr25_u17.nr1[nsmm_w]
print @n.xbgr.xr25_u17.nr1[nsmm_l]
print @n.xbgr.xr25_u18.nr1[nsmm_rsh]
print @n.xbgr.xr25_u18.nr1[nsmm_w]
print @n.xbgr.xr25_u18.nr1[nsmm_l]
print @n.xbgr.xr25_u19.nr1[nsmm_rsh]
print @n.xbgr.xr25_u19.nr1[nsmm_w]
print @n.xbgr.xr25_u19.nr1[nsmm_l]
print @n.xbgr.xr25_u20.nr1[nsmm_rsh]
print @n.xbgr.xr25_u20.nr1[nsmm_w]
print @n.xbgr.xr25_u20.nr1[nsmm_l]
print @n.xbgr.xr25_u21.nr1[nsmm_rsh]
print @n.xbgr.xr25_u21.nr1[nsmm_w]
print @n.xbgr.xr25_u21.nr1[nsmm_l]
print @n.xbgr.xr25_u22.nr1[nsmm_rsh]
print @n.xbgr.xr25_u22.nr1[nsmm_w]
print @n.xbgr.xr25_u22.nr1[nsmm_l]
print @n.xbgr.xr25_u23.nr1[nsmm_rsh]
print @n.xbgr.xr25_u23.nr1[nsmm_w]
print @n.xbgr.xr25_u23.nr1[nsmm_l]
print @n.xbgr.xr25_u24.nr1[nsmm_rsh]
print @n.xbgr.xr25_u24.nr1[nsmm_w]
print @n.xbgr.xr25_u24.nr1[nsmm_l]
print @n.xbgr.xr26_u2.nr1[nsmm_rsh]
print @n.xbgr.xr26_u2.nr1[nsmm_w]
print @n.xbgr.xr26_u2.nr1[nsmm_l]
print @n.xbgr.xr26_u3.nr1[nsmm_rsh]
print @n.xbgr.xr26_u3.nr1[nsmm_w]
print @n.xbgr.xr26_u3.nr1[nsmm_l]
print @n.xbgr.xr26_u4.nr1[nsmm_rsh]
print @n.xbgr.xr26_u4.nr1[nsmm_w]
print @n.xbgr.xr26_u4.nr1[nsmm_l]
print @n.xbgr.xr26_u5.nr1[nsmm_rsh]
print @n.xbgr.xr26_u5.nr1[nsmm_w]
print @n.xbgr.xr26_u5.nr1[nsmm_l]
print @n.xbgr.xr26_u6.nr1[nsmm_rsh]
print @n.xbgr.xr26_u6.nr1[nsmm_w]
print @n.xbgr.xr26_u6.nr1[nsmm_l]
print @n.xbgr.xr26_u7.nr1[nsmm_rsh]
print @n.xbgr.xr26_u7.nr1[nsmm_w]
print @n.xbgr.xr26_u7.nr1[nsmm_l]
print @n.xbgr.xr26_u8.nr1[nsmm_rsh]
print @n.xbgr.xr26_u8.nr1[nsmm_w]
print @n.xbgr.xr26_u8.nr1[nsmm_l]
print @n.xbgr.xr26_u9.nr1[nsmm_rsh]
print @n.xbgr.xr26_u9.nr1[nsmm_w]
print @n.xbgr.xr26_u9.nr1[nsmm_l]
print @n.xbgr.xr26_u10.nr1[nsmm_rsh]
print @n.xbgr.xr26_u10.nr1[nsmm_w]
print @n.xbgr.xr26_u10.nr1[nsmm_l]
print @n.xbgr.xr26_u11.nr1[nsmm_rsh]
print @n.xbgr.xr26_u11.nr1[nsmm_w]
print @n.xbgr.xr26_u11.nr1[nsmm_l]
print @n.xbgr.xr26_u12.nr1[nsmm_rsh]
print @n.xbgr.xr26_u12.nr1[nsmm_w]
print @n.xbgr.xr26_u12.nr1[nsmm_l]
print @n.xbgr.xr26_u13.nr1[nsmm_rsh]
print @n.xbgr.xr26_u13.nr1[nsmm_w]
print @n.xbgr.xr26_u13.nr1[nsmm_l]
print @n.xbgr.xr26_u14.nr1[nsmm_rsh]
print @n.xbgr.xr26_u14.nr1[nsmm_w]
print @n.xbgr.xr26_u14.nr1[nsmm_l]
print @n.xbgr.xr26_u15.nr1[nsmm_rsh]
print @n.xbgr.xr26_u15.nr1[nsmm_w]
print @n.xbgr.xr26_u15.nr1[nsmm_l]
print @n.xbgr.xr26_u16.nr1[nsmm_rsh]
print @n.xbgr.xr26_u16.nr1[nsmm_w]
print @n.xbgr.xr26_u16.nr1[nsmm_l]
print @n.xbgr.xr26_u17.nr1[nsmm_rsh]
print @n.xbgr.xr26_u17.nr1[nsmm_w]
print @n.xbgr.xr26_u17.nr1[nsmm_l]
print @n.xbgr.xr26_u18.nr1[nsmm_rsh]
print @n.xbgr.xr26_u18.nr1[nsmm_w]
print @n.xbgr.xr26_u18.nr1[nsmm_l]
print @n.xbgr.xr26_u19.nr1[nsmm_rsh]
print @n.xbgr.xr26_u19.nr1[nsmm_w]
print @n.xbgr.xr26_u19.nr1[nsmm_l]
print @n.xbgr.xr26_u20.nr1[nsmm_rsh]
print @n.xbgr.xr26_u20.nr1[nsmm_w]
print @n.xbgr.xr26_u20.nr1[nsmm_l]
print @n.xbgr.xr26_u21.nr1[nsmm_rsh]
print @n.xbgr.xr26_u21.nr1[nsmm_w]
print @n.xbgr.xr26_u21.nr1[nsmm_l]
print @n.xbgr.xr26_u22.nr1[nsmm_rsh]
print @n.xbgr.xr26_u22.nr1[nsmm_w]
print @n.xbgr.xr26_u22.nr1[nsmm_l]
print @n.xbgr.xr26_u23.nr1[nsmm_rsh]
print @n.xbgr.xr26_u23.nr1[nsmm_w]
print @n.xbgr.xr26_u23.nr1[nsmm_l]
print @n.xbgr.xr26_u24.nr1[nsmm_rsh]
print @n.xbgr.xr26_u24.nr1[nsmm_w]
print @n.xbgr.xr26_u24.nr1[nsmm_l]
print @n.xbgr.xm34_u2.nsg13_hv_nmos[w]
print @n.xbgr.xm34_u2.nsg13_hv_nmos[l]
print @n.xbgr.xm34_u2.nsg13_hv_nmos[delvto]
print @n.xbgr.xm34_u2.nsg13_hv_nmos[factuo]
print @n.xbgr.xm34_u3.nsg13_hv_nmos[w]
print @n.xbgr.xm34_u3.nsg13_hv_nmos[l]
print @n.xbgr.xm34_u3.nsg13_hv_nmos[delvto]
print @n.xbgr.xm34_u3.nsg13_hv_nmos[factuo]
print @n.xbgr.xm34_u4.nsg13_hv_nmos[w]
print @n.xbgr.xm34_u4.nsg13_hv_nmos[l]
print @n.xbgr.xm34_u4.nsg13_hv_nmos[delvto]
print @n.xbgr.xm34_u4.nsg13_hv_nmos[factuo]
print @n.xbgr.xm34_u5.nsg13_hv_nmos[w]
print @n.xbgr.xm34_u5.nsg13_hv_nmos[l]
print @n.xbgr.xm34_u5.nsg13_hv_nmos[delvto]
print @n.xbgr.xm34_u5.nsg13_hv_nmos[factuo]
print @n.xbgr.xm34_u6.nsg13_hv_nmos[w]
print @n.xbgr.xm34_u6.nsg13_hv_nmos[l]
print @n.xbgr.xm34_u6.nsg13_hv_nmos[delvto]
print @n.xbgr.xm34_u6.nsg13_hv_nmos[factuo]
print @n.xbgr.xm34_u7.nsg13_hv_nmos[w]
print @n.xbgr.xm34_u7.nsg13_hv_nmos[l]
print @n.xbgr.xm34_u7.nsg13_hv_nmos[delvto]
print @n.xbgr.xm34_u7.nsg13_hv_nmos[factuo]
print @n.xbgr.xm34_u8.nsg13_hv_nmos[w]
print @n.xbgr.xm34_u8.nsg13_hv_nmos[l]
print @n.xbgr.xm34_u8.nsg13_hv_nmos[delvto]
print @n.xbgr.xm34_u8.nsg13_hv_nmos[factuo]
print @n.xbgr.xm34_u9.nsg13_hv_nmos[w]
print @n.xbgr.xm34_u9.nsg13_hv_nmos[l]
print @n.xbgr.xm34_u9.nsg13_hv_nmos[delvto]
print @n.xbgr.xm34_u9.nsg13_hv_nmos[factuo]
print @n.xbgr.xm34_u10.nsg13_hv_nmos[w]
print @n.xbgr.xm34_u10.nsg13_hv_nmos[l]
print @n.xbgr.xm34_u10.nsg13_hv_nmos[delvto]
print @n.xbgr.xm34_u10.nsg13_hv_nmos[factuo]
print @n.xbgr.xm34_u11.nsg13_hv_nmos[w]
print @n.xbgr.xm34_u11.nsg13_hv_nmos[l]
print @n.xbgr.xm34_u11.nsg13_hv_nmos[delvto]
print @n.xbgr.xm34_u11.nsg13_hv_nmos[factuo]
print @n.xbgr.xm34_u12.nsg13_hv_nmos[w]
print @n.xbgr.xm34_u12.nsg13_hv_nmos[l]
print @n.xbgr.xm34_u12.nsg13_hv_nmos[delvto]
print @n.xbgr.xm34_u12.nsg13_hv_nmos[factuo]
print @n.xbgr.xm34_u13.nsg13_hv_nmos[w]
print @n.xbgr.xm34_u13.nsg13_hv_nmos[l]
print @n.xbgr.xm34_u13.nsg13_hv_nmos[delvto]
print @n.xbgr.xm34_u13.nsg13_hv_nmos[factuo]
print @n.xbgr.xm34_u14.nsg13_hv_nmos[w]
print @n.xbgr.xm34_u14.nsg13_hv_nmos[l]
print @n.xbgr.xm34_u14.nsg13_hv_nmos[delvto]
print @n.xbgr.xm34_u14.nsg13_hv_nmos[factuo]
print @n.xbgr.xm34_u15.nsg13_hv_nmos[w]
print @n.xbgr.xm34_u15.nsg13_hv_nmos[l]
print @n.xbgr.xm34_u15.nsg13_hv_nmos[delvto]
print @n.xbgr.xm34_u15.nsg13_hv_nmos[factuo]
print @n.xbgr.xm34_u16.nsg13_hv_nmos[w]
print @n.xbgr.xm34_u16.nsg13_hv_nmos[l]
print @n.xbgr.xm34_u16.nsg13_hv_nmos[delvto]
print @n.xbgr.xm34_u16.nsg13_hv_nmos[factuo]
print @n.xbgr.xm34_u17.nsg13_hv_nmos[w]
print @n.xbgr.xm34_u17.nsg13_hv_nmos[l]
print @n.xbgr.xm34_u17.nsg13_hv_nmos[delvto]
print @n.xbgr.xm34_u17.nsg13_hv_nmos[factuo]
print @n.xbgr.xm34_u18.nsg13_hv_nmos[w]
print @n.xbgr.xm34_u18.nsg13_hv_nmos[l]
print @n.xbgr.xm34_u18.nsg13_hv_nmos[delvto]
print @n.xbgr.xm34_u18.nsg13_hv_nmos[factuo]
print @n.xbgr.xm34_u19.nsg13_hv_nmos[w]
print @n.xbgr.xm34_u19.nsg13_hv_nmos[l]
print @n.xbgr.xm34_u19.nsg13_hv_nmos[delvto]
print @n.xbgr.xm34_u19.nsg13_hv_nmos[factuo]
print @n.xbgr.xm34_u20.nsg13_hv_nmos[w]
print @n.xbgr.xm34_u20.nsg13_hv_nmos[l]
print @n.xbgr.xm34_u20.nsg13_hv_nmos[delvto]
print @n.xbgr.xm34_u20.nsg13_hv_nmos[factuo]
print @n.xbgr.xm34_u21.nsg13_hv_nmos[w]
print @n.xbgr.xm34_u21.nsg13_hv_nmos[l]
print @n.xbgr.xm34_u21.nsg13_hv_nmos[delvto]
print @n.xbgr.xm34_u21.nsg13_hv_nmos[factuo]
print @n.xbgr.xm34_u22.nsg13_hv_nmos[w]
print @n.xbgr.xm34_u22.nsg13_hv_nmos[l]
print @n.xbgr.xm34_u22.nsg13_hv_nmos[delvto]
print @n.xbgr.xm34_u22.nsg13_hv_nmos[factuo]
print @n.xbgr.xm34_u23.nsg13_hv_nmos[w]
print @n.xbgr.xm34_u23.nsg13_hv_nmos[l]
print @n.xbgr.xm34_u23.nsg13_hv_nmos[delvto]
print @n.xbgr.xm34_u23.nsg13_hv_nmos[factuo]
print @n.xbgr.xm34_u24.nsg13_hv_nmos[w]
print @n.xbgr.xm34_u24.nsg13_hv_nmos[l]
print @n.xbgr.xm34_u24.nsg13_hv_nmos[delvto]
print @n.xbgr.xm34_u24.nsg13_hv_nmos[factuo]
print @n.xbgr.xm35_u2.nsg13_hv_nmos[w]
print @n.xbgr.xm35_u2.nsg13_hv_nmos[l]
print @n.xbgr.xm35_u2.nsg13_hv_nmos[delvto]
print @n.xbgr.xm35_u2.nsg13_hv_nmos[factuo]
print @n.xbgr.xm35_u3.nsg13_hv_nmos[w]
print @n.xbgr.xm35_u3.nsg13_hv_nmos[l]
print @n.xbgr.xm35_u3.nsg13_hv_nmos[delvto]
print @n.xbgr.xm35_u3.nsg13_hv_nmos[factuo]
print @n.xbgr.xm35_u4.nsg13_hv_nmos[w]
print @n.xbgr.xm35_u4.nsg13_hv_nmos[l]
print @n.xbgr.xm35_u4.nsg13_hv_nmos[delvto]
print @n.xbgr.xm35_u4.nsg13_hv_nmos[factuo]
print @n.xbgr.xm35_u5.nsg13_hv_nmos[w]
print @n.xbgr.xm35_u5.nsg13_hv_nmos[l]
print @n.xbgr.xm35_u5.nsg13_hv_nmos[delvto]
print @n.xbgr.xm35_u5.nsg13_hv_nmos[factuo]
print @n.xbgr.xm35_u6.nsg13_hv_nmos[w]
print @n.xbgr.xm35_u6.nsg13_hv_nmos[l]
print @n.xbgr.xm35_u6.nsg13_hv_nmos[delvto]
print @n.xbgr.xm35_u6.nsg13_hv_nmos[factuo]
print @n.xbgr.xm35_u7.nsg13_hv_nmos[w]
print @n.xbgr.xm35_u7.nsg13_hv_nmos[l]
print @n.xbgr.xm35_u7.nsg13_hv_nmos[delvto]
print @n.xbgr.xm35_u7.nsg13_hv_nmos[factuo]
print @n.xbgr.xm35_u8.nsg13_hv_nmos[w]
print @n.xbgr.xm35_u8.nsg13_hv_nmos[l]
print @n.xbgr.xm35_u8.nsg13_hv_nmos[delvto]
print @n.xbgr.xm35_u8.nsg13_hv_nmos[factuo]
print @n.xbgr.xm35_u9.nsg13_hv_nmos[w]
print @n.xbgr.xm35_u9.nsg13_hv_nmos[l]
print @n.xbgr.xm35_u9.nsg13_hv_nmos[delvto]
print @n.xbgr.xm35_u9.nsg13_hv_nmos[factuo]
print @n.xbgr.xm35_u10.nsg13_hv_nmos[w]
print @n.xbgr.xm35_u10.nsg13_hv_nmos[l]
print @n.xbgr.xm35_u10.nsg13_hv_nmos[delvto]
print @n.xbgr.xm35_u10.nsg13_hv_nmos[factuo]
print @n.xbgr.xm35_u11.nsg13_hv_nmos[w]
print @n.xbgr.xm35_u11.nsg13_hv_nmos[l]
print @n.xbgr.xm35_u11.nsg13_hv_nmos[delvto]
print @n.xbgr.xm35_u11.nsg13_hv_nmos[factuo]
print @n.xbgr.xm35_u12.nsg13_hv_nmos[w]
print @n.xbgr.xm35_u12.nsg13_hv_nmos[l]
print @n.xbgr.xm35_u12.nsg13_hv_nmos[delvto]
print @n.xbgr.xm35_u12.nsg13_hv_nmos[factuo]
print @n.xbgr.xm35_u13.nsg13_hv_nmos[w]
print @n.xbgr.xm35_u13.nsg13_hv_nmos[l]
print @n.xbgr.xm35_u13.nsg13_hv_nmos[delvto]
print @n.xbgr.xm35_u13.nsg13_hv_nmos[factuo]
print @n.xbgr.xm35_u14.nsg13_hv_nmos[w]
print @n.xbgr.xm35_u14.nsg13_hv_nmos[l]
print @n.xbgr.xm35_u14.nsg13_hv_nmos[delvto]
print @n.xbgr.xm35_u14.nsg13_hv_nmos[factuo]
print @n.xbgr.xm35_u15.nsg13_hv_nmos[w]
print @n.xbgr.xm35_u15.nsg13_hv_nmos[l]
print @n.xbgr.xm35_u15.nsg13_hv_nmos[delvto]
print @n.xbgr.xm35_u15.nsg13_hv_nmos[factuo]
print @n.xbgr.xm35_u16.nsg13_hv_nmos[w]
print @n.xbgr.xm35_u16.nsg13_hv_nmos[l]
print @n.xbgr.xm35_u16.nsg13_hv_nmos[delvto]
print @n.xbgr.xm35_u16.nsg13_hv_nmos[factuo]
print @n.xbgr.xm35_u17.nsg13_hv_nmos[w]
print @n.xbgr.xm35_u17.nsg13_hv_nmos[l]
print @n.xbgr.xm35_u17.nsg13_hv_nmos[delvto]
print @n.xbgr.xm35_u17.nsg13_hv_nmos[factuo]
print @n.xbgr.xm35_u18.nsg13_hv_nmos[w]
print @n.xbgr.xm35_u18.nsg13_hv_nmos[l]
print @n.xbgr.xm35_u18.nsg13_hv_nmos[delvto]
print @n.xbgr.xm35_u18.nsg13_hv_nmos[factuo]
print @n.xbgr.xm35_u19.nsg13_hv_nmos[w]
print @n.xbgr.xm35_u19.nsg13_hv_nmos[l]
print @n.xbgr.xm35_u19.nsg13_hv_nmos[delvto]
print @n.xbgr.xm35_u19.nsg13_hv_nmos[factuo]
print @n.xbgr.xm35_u20.nsg13_hv_nmos[w]
print @n.xbgr.xm35_u20.nsg13_hv_nmos[l]
print @n.xbgr.xm35_u20.nsg13_hv_nmos[delvto]
print @n.xbgr.xm35_u20.nsg13_hv_nmos[factuo]
print @n.xbgr.xm35_u21.nsg13_hv_nmos[w]
print @n.xbgr.xm35_u21.nsg13_hv_nmos[l]
print @n.xbgr.xm35_u21.nsg13_hv_nmos[delvto]
print @n.xbgr.xm35_u21.nsg13_hv_nmos[factuo]
print @n.xbgr.xm35_u22.nsg13_hv_nmos[w]
print @n.xbgr.xm35_u22.nsg13_hv_nmos[l]
print @n.xbgr.xm35_u22.nsg13_hv_nmos[delvto]
print @n.xbgr.xm35_u22.nsg13_hv_nmos[factuo]
print @n.xbgr.xm35_u23.nsg13_hv_nmos[w]
print @n.xbgr.xm35_u23.nsg13_hv_nmos[l]
print @n.xbgr.xm35_u23.nsg13_hv_nmos[delvto]
print @n.xbgr.xm35_u23.nsg13_hv_nmos[factuo]
print @n.xbgr.xm35_u24.nsg13_hv_nmos[w]
print @n.xbgr.xm35_u24.nsg13_hv_nmos[l]
print @n.xbgr.xm35_u24.nsg13_hv_nmos[delvto]
print @n.xbgr.xm35_u24.nsg13_hv_nmos[factuo]
print @n.xbgr.xm36_u2.nsg13_hv_nmos[w]
print @n.xbgr.xm36_u2.nsg13_hv_nmos[l]
print @n.xbgr.xm36_u2.nsg13_hv_nmos[delvto]
print @n.xbgr.xm36_u2.nsg13_hv_nmos[factuo]
print @n.xbgr.xm36_u3.nsg13_hv_nmos[w]
print @n.xbgr.xm36_u3.nsg13_hv_nmos[l]
print @n.xbgr.xm36_u3.nsg13_hv_nmos[delvto]
print @n.xbgr.xm36_u3.nsg13_hv_nmos[factuo]
print @n.xbgr.xm36_u4.nsg13_hv_nmos[w]
print @n.xbgr.xm36_u4.nsg13_hv_nmos[l]
print @n.xbgr.xm36_u4.nsg13_hv_nmos[delvto]
print @n.xbgr.xm36_u4.nsg13_hv_nmos[factuo]
print @n.xbgr.xm36_u5.nsg13_hv_nmos[w]
print @n.xbgr.xm36_u5.nsg13_hv_nmos[l]
print @n.xbgr.xm36_u5.nsg13_hv_nmos[delvto]
print @n.xbgr.xm36_u5.nsg13_hv_nmos[factuo]
print @n.xbgr.xm36_u6.nsg13_hv_nmos[w]
print @n.xbgr.xm36_u6.nsg13_hv_nmos[l]
print @n.xbgr.xm36_u6.nsg13_hv_nmos[delvto]
print @n.xbgr.xm36_u6.nsg13_hv_nmos[factuo]
print @n.xbgr.xm36_u7.nsg13_hv_nmos[w]
print @n.xbgr.xm36_u7.nsg13_hv_nmos[l]
print @n.xbgr.xm36_u7.nsg13_hv_nmos[delvto]
print @n.xbgr.xm36_u7.nsg13_hv_nmos[factuo]
print @n.xbgr.xm36_u8.nsg13_hv_nmos[w]
print @n.xbgr.xm36_u8.nsg13_hv_nmos[l]
print @n.xbgr.xm36_u8.nsg13_hv_nmos[delvto]
print @n.xbgr.xm36_u8.nsg13_hv_nmos[factuo]
print @n.xbgr.xm36_u9.nsg13_hv_nmos[w]
print @n.xbgr.xm36_u9.nsg13_hv_nmos[l]
print @n.xbgr.xm36_u9.nsg13_hv_nmos[delvto]
print @n.xbgr.xm36_u9.nsg13_hv_nmos[factuo]
print @n.xbgr.xm36_u10.nsg13_hv_nmos[w]
print @n.xbgr.xm36_u10.nsg13_hv_nmos[l]
print @n.xbgr.xm36_u10.nsg13_hv_nmos[delvto]
print @n.xbgr.xm36_u10.nsg13_hv_nmos[factuo]
print @n.xbgr.xm36_u11.nsg13_hv_nmos[w]
print @n.xbgr.xm36_u11.nsg13_hv_nmos[l]
print @n.xbgr.xm36_u11.nsg13_hv_nmos[delvto]
print @n.xbgr.xm36_u11.nsg13_hv_nmos[factuo]
print @n.xbgr.xm36_u12.nsg13_hv_nmos[w]
print @n.xbgr.xm36_u12.nsg13_hv_nmos[l]
print @n.xbgr.xm36_u12.nsg13_hv_nmos[delvto]
print @n.xbgr.xm36_u12.nsg13_hv_nmos[factuo]
print @n.xbgr.xm36_u13.nsg13_hv_nmos[w]
print @n.xbgr.xm36_u13.nsg13_hv_nmos[l]
print @n.xbgr.xm36_u13.nsg13_hv_nmos[delvto]
print @n.xbgr.xm36_u13.nsg13_hv_nmos[factuo]
print @n.xbgr.xm36_u14.nsg13_hv_nmos[w]
print @n.xbgr.xm36_u14.nsg13_hv_nmos[l]
print @n.xbgr.xm36_u14.nsg13_hv_nmos[delvto]
print @n.xbgr.xm36_u14.nsg13_hv_nmos[factuo]
print @n.xbgr.xm36_u15.nsg13_hv_nmos[w]
print @n.xbgr.xm36_u15.nsg13_hv_nmos[l]
print @n.xbgr.xm36_u15.nsg13_hv_nmos[delvto]
print @n.xbgr.xm36_u15.nsg13_hv_nmos[factuo]
print @n.xbgr.xm36_u16.nsg13_hv_nmos[w]
print @n.xbgr.xm36_u16.nsg13_hv_nmos[l]
print @n.xbgr.xm36_u16.nsg13_hv_nmos[delvto]
print @n.xbgr.xm36_u16.nsg13_hv_nmos[factuo]
print @n.xbgr.xm36_u17.nsg13_hv_nmos[w]
print @n.xbgr.xm36_u17.nsg13_hv_nmos[l]
print @n.xbgr.xm36_u17.nsg13_hv_nmos[delvto]
print @n.xbgr.xm36_u17.nsg13_hv_nmos[factuo]
print @n.xbgr.xm36_u18.nsg13_hv_nmos[w]
print @n.xbgr.xm36_u18.nsg13_hv_nmos[l]
print @n.xbgr.xm36_u18.nsg13_hv_nmos[delvto]
print @n.xbgr.xm36_u18.nsg13_hv_nmos[factuo]
print @n.xbgr.xm36_u19.nsg13_hv_nmos[w]
print @n.xbgr.xm36_u19.nsg13_hv_nmos[l]
print @n.xbgr.xm36_u19.nsg13_hv_nmos[delvto]
print @n.xbgr.xm36_u19.nsg13_hv_nmos[factuo]
print @n.xbgr.xm36_u20.nsg13_hv_nmos[w]
print @n.xbgr.xm36_u20.nsg13_hv_nmos[l]
print @n.xbgr.xm36_u20.nsg13_hv_nmos[delvto]
print @n.xbgr.xm36_u20.nsg13_hv_nmos[factuo]
print @n.xbgr.xm36_u21.nsg13_hv_nmos[w]
print @n.xbgr.xm36_u21.nsg13_hv_nmos[l]
print @n.xbgr.xm36_u21.nsg13_hv_nmos[delvto]
print @n.xbgr.xm36_u21.nsg13_hv_nmos[factuo]
print @n.xbgr.xm36_u22.nsg13_hv_nmos[w]
print @n.xbgr.xm36_u22.nsg13_hv_nmos[l]
print @n.xbgr.xm36_u22.nsg13_hv_nmos[delvto]
print @n.xbgr.xm36_u22.nsg13_hv_nmos[factuo]
print @n.xbgr.xm36_u23.nsg13_hv_nmos[w]
print @n.xbgr.xm36_u23.nsg13_hv_nmos[l]
print @n.xbgr.xm36_u23.nsg13_hv_nmos[delvto]
print @n.xbgr.xm36_u23.nsg13_hv_nmos[factuo]
print @n.xbgr.xm36_u24.nsg13_hv_nmos[w]
print @n.xbgr.xm36_u24.nsg13_hv_nmos[l]
print @n.xbgr.xm36_u24.nsg13_hv_nmos[delvto]
print @n.xbgr.xm36_u24.nsg13_hv_nmos[factuo]
print @n.xbgr.xm37_u2.nsg13_hv_nmos[w]
print @n.xbgr.xm37_u2.nsg13_hv_nmos[l]
print @n.xbgr.xm37_u2.nsg13_hv_nmos[delvto]
print @n.xbgr.xm37_u2.nsg13_hv_nmos[factuo]
print @n.xbgr.xm37_u3.nsg13_hv_nmos[w]
print @n.xbgr.xm37_u3.nsg13_hv_nmos[l]
print @n.xbgr.xm37_u3.nsg13_hv_nmos[delvto]
print @n.xbgr.xm37_u3.nsg13_hv_nmos[factuo]
print @n.xbgr.xm37_u4.nsg13_hv_nmos[w]
print @n.xbgr.xm37_u4.nsg13_hv_nmos[l]
print @n.xbgr.xm37_u4.nsg13_hv_nmos[delvto]
print @n.xbgr.xm37_u4.nsg13_hv_nmos[factuo]
print @n.xbgr.xm37_u5.nsg13_hv_nmos[w]
print @n.xbgr.xm37_u5.nsg13_hv_nmos[l]
print @n.xbgr.xm37_u5.nsg13_hv_nmos[delvto]
print @n.xbgr.xm37_u5.nsg13_hv_nmos[factuo]
print @n.xbgr.xm37_u6.nsg13_hv_nmos[w]
print @n.xbgr.xm37_u6.nsg13_hv_nmos[l]
print @n.xbgr.xm37_u6.nsg13_hv_nmos[delvto]
print @n.xbgr.xm37_u6.nsg13_hv_nmos[factuo]
print @n.xbgr.xm37_u7.nsg13_hv_nmos[w]
print @n.xbgr.xm37_u7.nsg13_hv_nmos[l]
print @n.xbgr.xm37_u7.nsg13_hv_nmos[delvto]
print @n.xbgr.xm37_u7.nsg13_hv_nmos[factuo]
print @n.xbgr.xm37_u8.nsg13_hv_nmos[w]
print @n.xbgr.xm37_u8.nsg13_hv_nmos[l]
print @n.xbgr.xm37_u8.nsg13_hv_nmos[delvto]
print @n.xbgr.xm37_u8.nsg13_hv_nmos[factuo]
print @n.xbgr.xm37_u9.nsg13_hv_nmos[w]
print @n.xbgr.xm37_u9.nsg13_hv_nmos[l]
print @n.xbgr.xm37_u9.nsg13_hv_nmos[delvto]
print @n.xbgr.xm37_u9.nsg13_hv_nmos[factuo]
print @n.xbgr.xm37_u10.nsg13_hv_nmos[w]
print @n.xbgr.xm37_u10.nsg13_hv_nmos[l]
print @n.xbgr.xm37_u10.nsg13_hv_nmos[delvto]
print @n.xbgr.xm37_u10.nsg13_hv_nmos[factuo]
print @n.xbgr.xm37_u11.nsg13_hv_nmos[w]
print @n.xbgr.xm37_u11.nsg13_hv_nmos[l]
print @n.xbgr.xm37_u11.nsg13_hv_nmos[delvto]
print @n.xbgr.xm37_u11.nsg13_hv_nmos[factuo]
print @n.xbgr.xm37_u12.nsg13_hv_nmos[w]
print @n.xbgr.xm37_u12.nsg13_hv_nmos[l]
print @n.xbgr.xm37_u12.nsg13_hv_nmos[delvto]
print @n.xbgr.xm37_u12.nsg13_hv_nmos[factuo]
print @n.xbgr.xm37_u13.nsg13_hv_nmos[w]
print @n.xbgr.xm37_u13.nsg13_hv_nmos[l]
print @n.xbgr.xm37_u13.nsg13_hv_nmos[delvto]
print @n.xbgr.xm37_u13.nsg13_hv_nmos[factuo]
print @n.xbgr.xm37_u14.nsg13_hv_nmos[w]
print @n.xbgr.xm37_u14.nsg13_hv_nmos[l]
print @n.xbgr.xm37_u14.nsg13_hv_nmos[delvto]
print @n.xbgr.xm37_u14.nsg13_hv_nmos[factuo]
print @n.xbgr.xm37_u15.nsg13_hv_nmos[w]
print @n.xbgr.xm37_u15.nsg13_hv_nmos[l]
print @n.xbgr.xm37_u15.nsg13_hv_nmos[delvto]
print @n.xbgr.xm37_u15.nsg13_hv_nmos[factuo]
print @n.xbgr.xm37_u16.nsg13_hv_nmos[w]
print @n.xbgr.xm37_u16.nsg13_hv_nmos[l]
print @n.xbgr.xm37_u16.nsg13_hv_nmos[delvto]
print @n.xbgr.xm37_u16.nsg13_hv_nmos[factuo]
print @n.xbgr.xm37_u17.nsg13_hv_nmos[w]
print @n.xbgr.xm37_u17.nsg13_hv_nmos[l]
print @n.xbgr.xm37_u17.nsg13_hv_nmos[delvto]
print @n.xbgr.xm37_u17.nsg13_hv_nmos[factuo]
print @n.xbgr.xm37_u18.nsg13_hv_nmos[w]
print @n.xbgr.xm37_u18.nsg13_hv_nmos[l]
print @n.xbgr.xm37_u18.nsg13_hv_nmos[delvto]
print @n.xbgr.xm37_u18.nsg13_hv_nmos[factuo]
print @n.xbgr.xm37_u19.nsg13_hv_nmos[w]
print @n.xbgr.xm37_u19.nsg13_hv_nmos[l]
print @n.xbgr.xm37_u19.nsg13_hv_nmos[delvto]
print @n.xbgr.xm37_u19.nsg13_hv_nmos[factuo]
print @n.xbgr.xm37_u20.nsg13_hv_nmos[w]
print @n.xbgr.xm37_u20.nsg13_hv_nmos[l]
print @n.xbgr.xm37_u20.nsg13_hv_nmos[delvto]
print @n.xbgr.xm37_u20.nsg13_hv_nmos[factuo]
print @n.xbgr.xm37_u21.nsg13_hv_nmos[w]
print @n.xbgr.xm37_u21.nsg13_hv_nmos[l]
print @n.xbgr.xm37_u21.nsg13_hv_nmos[delvto]
print @n.xbgr.xm37_u21.nsg13_hv_nmos[factuo]
print @n.xbgr.xm37_u22.nsg13_hv_nmos[w]
print @n.xbgr.xm37_u22.nsg13_hv_nmos[l]
print @n.xbgr.xm37_u22.nsg13_hv_nmos[delvto]
print @n.xbgr.xm37_u22.nsg13_hv_nmos[factuo]
print @n.xbgr.xm37_u23.nsg13_hv_nmos[w]
print @n.xbgr.xm37_u23.nsg13_hv_nmos[l]
print @n.xbgr.xm37_u23.nsg13_hv_nmos[delvto]
print @n.xbgr.xm37_u23.nsg13_hv_nmos[factuo]
print @n.xbgr.xm37_u24.nsg13_hv_nmos[w]
print @n.xbgr.xm37_u24.nsg13_hv_nmos[l]
print @n.xbgr.xm37_u24.nsg13_hv_nmos[delvto]
print @n.xbgr.xm37_u24.nsg13_hv_nmos[factuo]
print @n.xbgr.xm38_u2.nsg13_hv_pmos[w]
print @n.xbgr.xm38_u2.nsg13_hv_pmos[l]
print @n.xbgr.xm38_u2.nsg13_hv_pmos[delvto]
print @n.xbgr.xm38_u2.nsg13_hv_pmos[factuo]
print @n.xbgr.xm38_u3.nsg13_hv_pmos[w]
print @n.xbgr.xm38_u3.nsg13_hv_pmos[l]
print @n.xbgr.xm38_u3.nsg13_hv_pmos[delvto]
print @n.xbgr.xm38_u3.nsg13_hv_pmos[factuo]
print @n.xbgr.xm38_u4.nsg13_hv_pmos[w]
print @n.xbgr.xm38_u4.nsg13_hv_pmos[l]
print @n.xbgr.xm38_u4.nsg13_hv_pmos[delvto]
print @n.xbgr.xm38_u4.nsg13_hv_pmos[factuo]
print @n.xbgr.xm38_u5.nsg13_hv_pmos[w]
print @n.xbgr.xm38_u5.nsg13_hv_pmos[l]
print @n.xbgr.xm38_u5.nsg13_hv_pmos[delvto]
print @n.xbgr.xm38_u5.nsg13_hv_pmos[factuo]
print @n.xbgr.xm38_u6.nsg13_hv_pmos[w]
print @n.xbgr.xm38_u6.nsg13_hv_pmos[l]
print @n.xbgr.xm38_u6.nsg13_hv_pmos[delvto]
print @n.xbgr.xm38_u6.nsg13_hv_pmos[factuo]
print @n.xbgr.xm38_u7.nsg13_hv_pmos[w]
print @n.xbgr.xm38_u7.nsg13_hv_pmos[l]
print @n.xbgr.xm38_u7.nsg13_hv_pmos[delvto]
print @n.xbgr.xm38_u7.nsg13_hv_pmos[factuo]
print @n.xbgr.xm38_u8.nsg13_hv_pmos[w]
print @n.xbgr.xm38_u8.nsg13_hv_pmos[l]
print @n.xbgr.xm38_u8.nsg13_hv_pmos[delvto]
print @n.xbgr.xm38_u8.nsg13_hv_pmos[factuo]
print @n.xbgr.xm38_u9.nsg13_hv_pmos[w]
print @n.xbgr.xm38_u9.nsg13_hv_pmos[l]
print @n.xbgr.xm38_u9.nsg13_hv_pmos[delvto]
print @n.xbgr.xm38_u9.nsg13_hv_pmos[factuo]
print @n.xbgr.xm38_u10.nsg13_hv_pmos[w]
print @n.xbgr.xm38_u10.nsg13_hv_pmos[l]
print @n.xbgr.xm38_u10.nsg13_hv_pmos[delvto]
print @n.xbgr.xm38_u10.nsg13_hv_pmos[factuo]
print @n.xbgr.xm38_u11.nsg13_hv_pmos[w]
print @n.xbgr.xm38_u11.nsg13_hv_pmos[l]
print @n.xbgr.xm38_u11.nsg13_hv_pmos[delvto]
print @n.xbgr.xm38_u11.nsg13_hv_pmos[factuo]
print @n.xbgr.xm38_u12.nsg13_hv_pmos[w]
print @n.xbgr.xm38_u12.nsg13_hv_pmos[l]
print @n.xbgr.xm38_u12.nsg13_hv_pmos[delvto]
print @n.xbgr.xm38_u12.nsg13_hv_pmos[factuo]
print @n.xbgr.xm38_u13.nsg13_hv_pmos[w]
print @n.xbgr.xm38_u13.nsg13_hv_pmos[l]
print @n.xbgr.xm38_u13.nsg13_hv_pmos[delvto]
print @n.xbgr.xm38_u13.nsg13_hv_pmos[factuo]
print @n.xbgr.xm38_u14.nsg13_hv_pmos[w]
print @n.xbgr.xm38_u14.nsg13_hv_pmos[l]
print @n.xbgr.xm38_u14.nsg13_hv_pmos[delvto]
print @n.xbgr.xm38_u14.nsg13_hv_pmos[factuo]
print @n.xbgr.xm38_u15.nsg13_hv_pmos[w]
print @n.xbgr.xm38_u15.nsg13_hv_pmos[l]
print @n.xbgr.xm38_u15.nsg13_hv_pmos[delvto]
print @n.xbgr.xm38_u15.nsg13_hv_pmos[factuo]
print @n.xbgr.xm38_u16.nsg13_hv_pmos[w]
print @n.xbgr.xm38_u16.nsg13_hv_pmos[l]
print @n.xbgr.xm38_u16.nsg13_hv_pmos[delvto]
print @n.xbgr.xm38_u16.nsg13_hv_pmos[factuo]
print @n.xbgr.xm38_u17.nsg13_hv_pmos[w]
print @n.xbgr.xm38_u17.nsg13_hv_pmos[l]
print @n.xbgr.xm38_u17.nsg13_hv_pmos[delvto]
print @n.xbgr.xm38_u17.nsg13_hv_pmos[factuo]
print @n.xbgr.xm38_u18.nsg13_hv_pmos[w]
print @n.xbgr.xm38_u18.nsg13_hv_pmos[l]
print @n.xbgr.xm38_u18.nsg13_hv_pmos[delvto]
print @n.xbgr.xm38_u18.nsg13_hv_pmos[factuo]
print @n.xbgr.xm38_u19.nsg13_hv_pmos[w]
print @n.xbgr.xm38_u19.nsg13_hv_pmos[l]
print @n.xbgr.xm38_u19.nsg13_hv_pmos[delvto]
print @n.xbgr.xm38_u19.nsg13_hv_pmos[factuo]
print @n.xbgr.xm38_u20.nsg13_hv_pmos[w]
print @n.xbgr.xm38_u20.nsg13_hv_pmos[l]
print @n.xbgr.xm38_u20.nsg13_hv_pmos[delvto]
print @n.xbgr.xm38_u20.nsg13_hv_pmos[factuo]
print @n.xbgr.xm38_u21.nsg13_hv_pmos[w]
print @n.xbgr.xm38_u21.nsg13_hv_pmos[l]
print @n.xbgr.xm38_u21.nsg13_hv_pmos[delvto]
print @n.xbgr.xm38_u21.nsg13_hv_pmos[factuo]
print @n.xbgr.xm38_u22.nsg13_hv_pmos[w]
print @n.xbgr.xm38_u22.nsg13_hv_pmos[l]
print @n.xbgr.xm38_u22.nsg13_hv_pmos[delvto]
print @n.xbgr.xm38_u22.nsg13_hv_pmos[factuo]
print @n.xbgr.xm38_u23.nsg13_hv_pmos[w]
print @n.xbgr.xm38_u23.nsg13_hv_pmos[l]
print @n.xbgr.xm38_u23.nsg13_hv_pmos[delvto]
print @n.xbgr.xm38_u23.nsg13_hv_pmos[factuo]
print @n.xbgr.xm38_u24.nsg13_hv_pmos[w]
print @n.xbgr.xm38_u24.nsg13_hv_pmos[l]
print @n.xbgr.xm38_u24.nsg13_hv_pmos[delvto]
print @n.xbgr.xm38_u24.nsg13_hv_pmos[factuo]
print @n.xbgr.xm39_u2.nsg13_hv_pmos[w]
print @n.xbgr.xm39_u2.nsg13_hv_pmos[l]
print @n.xbgr.xm39_u2.nsg13_hv_pmos[delvto]
print @n.xbgr.xm39_u2.nsg13_hv_pmos[factuo]
print @n.xbgr.xm39_u3.nsg13_hv_pmos[w]
print @n.xbgr.xm39_u3.nsg13_hv_pmos[l]
print @n.xbgr.xm39_u3.nsg13_hv_pmos[delvto]
print @n.xbgr.xm39_u3.nsg13_hv_pmos[factuo]
print @n.xbgr.xm39_u4.nsg13_hv_pmos[w]
print @n.xbgr.xm39_u4.nsg13_hv_pmos[l]
print @n.xbgr.xm39_u4.nsg13_hv_pmos[delvto]
print @n.xbgr.xm39_u4.nsg13_hv_pmos[factuo]
print @n.xbgr.xm39_u5.nsg13_hv_pmos[w]
print @n.xbgr.xm39_u5.nsg13_hv_pmos[l]
print @n.xbgr.xm39_u5.nsg13_hv_pmos[delvto]
print @n.xbgr.xm39_u5.nsg13_hv_pmos[factuo]
print @n.xbgr.xm39_u6.nsg13_hv_pmos[w]
print @n.xbgr.xm39_u6.nsg13_hv_pmos[l]
print @n.xbgr.xm39_u6.nsg13_hv_pmos[delvto]
print @n.xbgr.xm39_u6.nsg13_hv_pmos[factuo]
print @n.xbgr.xm39_u7.nsg13_hv_pmos[w]
print @n.xbgr.xm39_u7.nsg13_hv_pmos[l]
print @n.xbgr.xm39_u7.nsg13_hv_pmos[delvto]
print @n.xbgr.xm39_u7.nsg13_hv_pmos[factuo]
print @n.xbgr.xm39_u8.nsg13_hv_pmos[w]
print @n.xbgr.xm39_u8.nsg13_hv_pmos[l]
print @n.xbgr.xm39_u8.nsg13_hv_pmos[delvto]
print @n.xbgr.xm39_u8.nsg13_hv_pmos[factuo]
print @n.xbgr.xm39_u9.nsg13_hv_pmos[w]
print @n.xbgr.xm39_u9.nsg13_hv_pmos[l]
print @n.xbgr.xm39_u9.nsg13_hv_pmos[delvto]
print @n.xbgr.xm39_u9.nsg13_hv_pmos[factuo]
print @n.xbgr.xm39_u10.nsg13_hv_pmos[w]
print @n.xbgr.xm39_u10.nsg13_hv_pmos[l]
print @n.xbgr.xm39_u10.nsg13_hv_pmos[delvto]
print @n.xbgr.xm39_u10.nsg13_hv_pmos[factuo]
print @n.xbgr.xm39_u11.nsg13_hv_pmos[w]
print @n.xbgr.xm39_u11.nsg13_hv_pmos[l]
print @n.xbgr.xm39_u11.nsg13_hv_pmos[delvto]
print @n.xbgr.xm39_u11.nsg13_hv_pmos[factuo]
print @n.xbgr.xm39_u12.nsg13_hv_pmos[w]
print @n.xbgr.xm39_u12.nsg13_hv_pmos[l]
print @n.xbgr.xm39_u12.nsg13_hv_pmos[delvto]
print @n.xbgr.xm39_u12.nsg13_hv_pmos[factuo]
print @n.xbgr.xm39_u13.nsg13_hv_pmos[w]
print @n.xbgr.xm39_u13.nsg13_hv_pmos[l]
print @n.xbgr.xm39_u13.nsg13_hv_pmos[delvto]
print @n.xbgr.xm39_u13.nsg13_hv_pmos[factuo]
print @n.xbgr.xm39_u14.nsg13_hv_pmos[w]
print @n.xbgr.xm39_u14.nsg13_hv_pmos[l]
print @n.xbgr.xm39_u14.nsg13_hv_pmos[delvto]
print @n.xbgr.xm39_u14.nsg13_hv_pmos[factuo]
print @n.xbgr.xm39_u15.nsg13_hv_pmos[w]
print @n.xbgr.xm39_u15.nsg13_hv_pmos[l]
print @n.xbgr.xm39_u15.nsg13_hv_pmos[delvto]
print @n.xbgr.xm39_u15.nsg13_hv_pmos[factuo]
print @n.xbgr.xm39_u16.nsg13_hv_pmos[w]
print @n.xbgr.xm39_u16.nsg13_hv_pmos[l]
print @n.xbgr.xm39_u16.nsg13_hv_pmos[delvto]
print @n.xbgr.xm39_u16.nsg13_hv_pmos[factuo]
print @n.xbgr.xm39_u17.nsg13_hv_pmos[w]
print @n.xbgr.xm39_u17.nsg13_hv_pmos[l]
print @n.xbgr.xm39_u17.nsg13_hv_pmos[delvto]
print @n.xbgr.xm39_u17.nsg13_hv_pmos[factuo]
print @n.xbgr.xm39_u18.nsg13_hv_pmos[w]
print @n.xbgr.xm39_u18.nsg13_hv_pmos[l]
print @n.xbgr.xm39_u18.nsg13_hv_pmos[delvto]
print @n.xbgr.xm39_u18.nsg13_hv_pmos[factuo]
print @n.xbgr.xm39_u19.nsg13_hv_pmos[w]
print @n.xbgr.xm39_u19.nsg13_hv_pmos[l]
print @n.xbgr.xm39_u19.nsg13_hv_pmos[delvto]
print @n.xbgr.xm39_u19.nsg13_hv_pmos[factuo]
print @n.xbgr.xm39_u20.nsg13_hv_pmos[w]
print @n.xbgr.xm39_u20.nsg13_hv_pmos[l]
print @n.xbgr.xm39_u20.nsg13_hv_pmos[delvto]
print @n.xbgr.xm39_u20.nsg13_hv_pmos[factuo]
print @n.xbgr.xm39_u21.nsg13_hv_pmos[w]
print @n.xbgr.xm39_u21.nsg13_hv_pmos[l]
print @n.xbgr.xm39_u21.nsg13_hv_pmos[delvto]
print @n.xbgr.xm39_u21.nsg13_hv_pmos[factuo]
print @n.xbgr.xm39_u22.nsg13_hv_pmos[w]
print @n.xbgr.xm39_u22.nsg13_hv_pmos[l]
print @n.xbgr.xm39_u22.nsg13_hv_pmos[delvto]
print @n.xbgr.xm39_u22.nsg13_hv_pmos[factuo]
print @n.xbgr.xm39_u23.nsg13_hv_pmos[w]
print @n.xbgr.xm39_u23.nsg13_hv_pmos[l]
print @n.xbgr.xm39_u23.nsg13_hv_pmos[delvto]
print @n.xbgr.xm39_u23.nsg13_hv_pmos[factuo]
print @n.xbgr.xm39_u24.nsg13_hv_pmos[w]
print @n.xbgr.xm39_u24.nsg13_hv_pmos[l]
print @n.xbgr.xm39_u24.nsg13_hv_pmos[delvto]
print @n.xbgr.xm39_u24.nsg13_hv_pmos[factuo]
print @n.xbgr.xm41_u2.nsg13_hv_pmos[w]
print @n.xbgr.xm41_u2.nsg13_hv_pmos[l]
print @n.xbgr.xm41_u2.nsg13_hv_pmos[delvto]
print @n.xbgr.xm41_u2.nsg13_hv_pmos[factuo]
print @n.xbgr.xm41_u3.nsg13_hv_pmos[w]
print @n.xbgr.xm41_u3.nsg13_hv_pmos[l]
print @n.xbgr.xm41_u3.nsg13_hv_pmos[delvto]
print @n.xbgr.xm41_u3.nsg13_hv_pmos[factuo]
print @n.xbgr.xm41_u4.nsg13_hv_pmos[w]
print @n.xbgr.xm41_u4.nsg13_hv_pmos[l]
print @n.xbgr.xm41_u4.nsg13_hv_pmos[delvto]
print @n.xbgr.xm41_u4.nsg13_hv_pmos[factuo]
print @n.xbgr.xm41_u5.nsg13_hv_pmos[w]
print @n.xbgr.xm41_u5.nsg13_hv_pmos[l]
print @n.xbgr.xm41_u5.nsg13_hv_pmos[delvto]
print @n.xbgr.xm41_u5.nsg13_hv_pmos[factuo]
print @n.xbgr.xm41_u6.nsg13_hv_pmos[w]
print @n.xbgr.xm41_u6.nsg13_hv_pmos[l]
print @n.xbgr.xm41_u6.nsg13_hv_pmos[delvto]
print @n.xbgr.xm41_u6.nsg13_hv_pmos[factuo]
print @n.xbgr.xm41_u7.nsg13_hv_pmos[w]
print @n.xbgr.xm41_u7.nsg13_hv_pmos[l]
print @n.xbgr.xm41_u7.nsg13_hv_pmos[delvto]
print @n.xbgr.xm41_u7.nsg13_hv_pmos[factuo]
print @n.xbgr.xm41_u8.nsg13_hv_pmos[w]
print @n.xbgr.xm41_u8.nsg13_hv_pmos[l]
print @n.xbgr.xm41_u8.nsg13_hv_pmos[delvto]
print @n.xbgr.xm41_u8.nsg13_hv_pmos[factuo]
print @n.xbgr.xm41_u9.nsg13_hv_pmos[w]
print @n.xbgr.xm41_u9.nsg13_hv_pmos[l]
print @n.xbgr.xm41_u9.nsg13_hv_pmos[delvto]
print @n.xbgr.xm41_u9.nsg13_hv_pmos[factuo]
print @n.xbgr.xm41_u10.nsg13_hv_pmos[w]
print @n.xbgr.xm41_u10.nsg13_hv_pmos[l]
print @n.xbgr.xm41_u10.nsg13_hv_pmos[delvto]
print @n.xbgr.xm41_u10.nsg13_hv_pmos[factuo]
print @n.xbgr.xm41_u11.nsg13_hv_pmos[w]
print @n.xbgr.xm41_u11.nsg13_hv_pmos[l]
print @n.xbgr.xm41_u11.nsg13_hv_pmos[delvto]
print @n.xbgr.xm41_u11.nsg13_hv_pmos[factuo]
print @n.xbgr.xm41_u12.nsg13_hv_pmos[w]
print @n.xbgr.xm41_u12.nsg13_hv_pmos[l]
print @n.xbgr.xm41_u12.nsg13_hv_pmos[delvto]
print @n.xbgr.xm41_u12.nsg13_hv_pmos[factuo]
print @n.xbgr.xm41_u13.nsg13_hv_pmos[w]
print @n.xbgr.xm41_u13.nsg13_hv_pmos[l]
print @n.xbgr.xm41_u13.nsg13_hv_pmos[delvto]
print @n.xbgr.xm41_u13.nsg13_hv_pmos[factuo]
print @n.xbgr.xm41_u14.nsg13_hv_pmos[w]
print @n.xbgr.xm41_u14.nsg13_hv_pmos[l]
print @n.xbgr.xm41_u14.nsg13_hv_pmos[delvto]
print @n.xbgr.xm41_u14.nsg13_hv_pmos[factuo]
print @n.xbgr.xm41_u15.nsg13_hv_pmos[w]
print @n.xbgr.xm41_u15.nsg13_hv_pmos[l]
print @n.xbgr.xm41_u15.nsg13_hv_pmos[delvto]
print @n.xbgr.xm41_u15.nsg13_hv_pmos[factuo]
print @n.xbgr.xm41_u16.nsg13_hv_pmos[w]
print @n.xbgr.xm41_u16.nsg13_hv_pmos[l]
print @n.xbgr.xm41_u16.nsg13_hv_pmos[delvto]
print @n.xbgr.xm41_u16.nsg13_hv_pmos[factuo]
print @n.xbgr.xm41_u17.nsg13_hv_pmos[w]
print @n.xbgr.xm41_u17.nsg13_hv_pmos[l]
print @n.xbgr.xm41_u17.nsg13_hv_pmos[delvto]
print @n.xbgr.xm41_u17.nsg13_hv_pmos[factuo]
print @n.xbgr.xm41_u18.nsg13_hv_pmos[w]
print @n.xbgr.xm41_u18.nsg13_hv_pmos[l]
print @n.xbgr.xm41_u18.nsg13_hv_pmos[delvto]
print @n.xbgr.xm41_u18.nsg13_hv_pmos[factuo]
print @n.xbgr.xm41_u19.nsg13_hv_pmos[w]
print @n.xbgr.xm41_u19.nsg13_hv_pmos[l]
print @n.xbgr.xm41_u19.nsg13_hv_pmos[delvto]
print @n.xbgr.xm41_u19.nsg13_hv_pmos[factuo]
print @n.xbgr.xm41_u20.nsg13_hv_pmos[w]
print @n.xbgr.xm41_u20.nsg13_hv_pmos[l]
print @n.xbgr.xm41_u20.nsg13_hv_pmos[delvto]
print @n.xbgr.xm41_u20.nsg13_hv_pmos[factuo]
print @n.xbgr.xm41_u21.nsg13_hv_pmos[w]
print @n.xbgr.xm41_u21.nsg13_hv_pmos[l]
print @n.xbgr.xm41_u21.nsg13_hv_pmos[delvto]
print @n.xbgr.xm41_u21.nsg13_hv_pmos[factuo]
print @n.xbgr.xm41_u22.nsg13_hv_pmos[w]
print @n.xbgr.xm41_u22.nsg13_hv_pmos[l]
print @n.xbgr.xm41_u22.nsg13_hv_pmos[delvto]
print @n.xbgr.xm41_u22.nsg13_hv_pmos[factuo]
print @n.xbgr.xm41_u23.nsg13_hv_pmos[w]
print @n.xbgr.xm41_u23.nsg13_hv_pmos[l]
print @n.xbgr.xm41_u23.nsg13_hv_pmos[delvto]
print @n.xbgr.xm41_u23.nsg13_hv_pmos[factuo]
print @n.xbgr.xm41_u24.nsg13_hv_pmos[w]
print @n.xbgr.xm41_u24.nsg13_hv_pmos[l]
print @n.xbgr.xm41_u24.nsg13_hv_pmos[delvto]
print @n.xbgr.xm41_u24.nsg13_hv_pmos[factuo]
print @n.xbgr.xm43_u2.nsg13_hv_pmos[w]
print @n.xbgr.xm43_u2.nsg13_hv_pmos[l]
print @n.xbgr.xm43_u2.nsg13_hv_pmos[delvto]
print @n.xbgr.xm43_u2.nsg13_hv_pmos[factuo]
print @n.xbgr.xm43_u3.nsg13_hv_pmos[w]
print @n.xbgr.xm43_u3.nsg13_hv_pmos[l]
print @n.xbgr.xm43_u3.nsg13_hv_pmos[delvto]
print @n.xbgr.xm43_u3.nsg13_hv_pmos[factuo]
print @n.xbgr.xm43_u4.nsg13_hv_pmos[w]
print @n.xbgr.xm43_u4.nsg13_hv_pmos[l]
print @n.xbgr.xm43_u4.nsg13_hv_pmos[delvto]
print @n.xbgr.xm43_u4.nsg13_hv_pmos[factuo]
print @n.xbgr.xm44_u2.nsg13_hv_pmos[w]
print @n.xbgr.xm44_u2.nsg13_hv_pmos[l]
print @n.xbgr.xm44_u2.nsg13_hv_pmos[delvto]
print @n.xbgr.xm44_u2.nsg13_hv_pmos[factuo]
print @n.xbgr.xm44_u3.nsg13_hv_pmos[w]
print @n.xbgr.xm44_u3.nsg13_hv_pmos[l]
print @n.xbgr.xm44_u3.nsg13_hv_pmos[delvto]
print @n.xbgr.xm44_u3.nsg13_hv_pmos[factuo]
print @n.xbgr.xm44_u4.nsg13_hv_pmos[w]
print @n.xbgr.xm44_u4.nsg13_hv_pmos[l]
print @n.xbgr.xm44_u4.nsg13_hv_pmos[delvto]
print @n.xbgr.xm44_u4.nsg13_hv_pmos[factuo]
print @n.xbgr.xm45_u2.nsg13_hv_pmos[w]
print @n.xbgr.xm45_u2.nsg13_hv_pmos[l]
print @n.xbgr.xm45_u2.nsg13_hv_pmos[delvto]
print @n.xbgr.xm45_u2.nsg13_hv_pmos[factuo]
print @n.xbgr.xm45_u3.nsg13_hv_pmos[w]
print @n.xbgr.xm45_u3.nsg13_hv_pmos[l]
print @n.xbgr.xm45_u3.nsg13_hv_pmos[delvto]
print @n.xbgr.xm45_u3.nsg13_hv_pmos[factuo]
print @n.xbgr.xm45_u4.nsg13_hv_pmos[w]
print @n.xbgr.xm45_u4.nsg13_hv_pmos[l]
print @n.xbgr.xm45_u4.nsg13_hv_pmos[delvto]
print @n.xbgr.xm45_u4.nsg13_hv_pmos[factuo]
print @n.xbgr.xm45_u5.nsg13_hv_pmos[w]
print @n.xbgr.xm45_u5.nsg13_hv_pmos[l]
print @n.xbgr.xm45_u5.nsg13_hv_pmos[delvto]
print @n.xbgr.xm45_u5.nsg13_hv_pmos[factuo]
print @n.xbgr.xm45_u6.nsg13_hv_pmos[w]
print @n.xbgr.xm45_u6.nsg13_hv_pmos[l]
print @n.xbgr.xm45_u6.nsg13_hv_pmos[delvto]
print @n.xbgr.xm45_u6.nsg13_hv_pmos[factuo]
print @n.xbgr.xm45_u7.nsg13_hv_pmos[w]
print @n.xbgr.xm45_u7.nsg13_hv_pmos[l]
print @n.xbgr.xm45_u7.nsg13_hv_pmos[delvto]
print @n.xbgr.xm45_u7.nsg13_hv_pmos[factuo]
print @n.xbgr.xm45_u8.nsg13_hv_pmos[w]
print @n.xbgr.xm45_u8.nsg13_hv_pmos[l]
print @n.xbgr.xm45_u8.nsg13_hv_pmos[delvto]
print @n.xbgr.xm45_u8.nsg13_hv_pmos[factuo]
print @n.xbgr.xm45_u9.nsg13_hv_pmos[w]
print @n.xbgr.xm45_u9.nsg13_hv_pmos[l]
print @n.xbgr.xm45_u9.nsg13_hv_pmos[delvto]
print @n.xbgr.xm45_u9.nsg13_hv_pmos[factuo]
print @n.xbgr.xm45_u10.nsg13_hv_pmos[w]
print @n.xbgr.xm45_u10.nsg13_hv_pmos[l]
print @n.xbgr.xm45_u10.nsg13_hv_pmos[delvto]
print @n.xbgr.xm45_u10.nsg13_hv_pmos[factuo]
print @n.xbgr.xm45_u11.nsg13_hv_pmos[w]
print @n.xbgr.xm45_u11.nsg13_hv_pmos[l]
print @n.xbgr.xm45_u11.nsg13_hv_pmos[delvto]
print @n.xbgr.xm45_u11.nsg13_hv_pmos[factuo]
print @n.xbgr.xm45_u12.nsg13_hv_pmos[w]
print @n.xbgr.xm45_u12.nsg13_hv_pmos[l]
print @n.xbgr.xm45_u12.nsg13_hv_pmos[delvto]
print @n.xbgr.xm45_u12.nsg13_hv_pmos[factuo]
print @n.xbgr.xm45_u13.nsg13_hv_pmos[w]
print @n.xbgr.xm45_u13.nsg13_hv_pmos[l]
print @n.xbgr.xm45_u13.nsg13_hv_pmos[delvto]
print @n.xbgr.xm45_u13.nsg13_hv_pmos[factuo]
print @n.xbgr.xm45_u14.nsg13_hv_pmos[w]
print @n.xbgr.xm45_u14.nsg13_hv_pmos[l]
print @n.xbgr.xm45_u14.nsg13_hv_pmos[delvto]
print @n.xbgr.xm45_u14.nsg13_hv_pmos[factuo]
print @n.xbgr.xm45_u15.nsg13_hv_pmos[w]
print @n.xbgr.xm45_u15.nsg13_hv_pmos[l]
print @n.xbgr.xm45_u15.nsg13_hv_pmos[delvto]
print @n.xbgr.xm45_u15.nsg13_hv_pmos[factuo]
print @n.xbgr.xm45_u16.nsg13_hv_pmos[w]
print @n.xbgr.xm45_u16.nsg13_hv_pmos[l]
print @n.xbgr.xm45_u16.nsg13_hv_pmos[delvto]
print @n.xbgr.xm45_u16.nsg13_hv_pmos[factuo]
print @n.xbgr.xm45_u17.nsg13_hv_pmos[w]
print @n.xbgr.xm45_u17.nsg13_hv_pmos[l]
print @n.xbgr.xm45_u17.nsg13_hv_pmos[delvto]
print @n.xbgr.xm45_u17.nsg13_hv_pmos[factuo]
print @n.xbgr.xm45_u18.nsg13_hv_pmos[w]
print @n.xbgr.xm45_u18.nsg13_hv_pmos[l]
print @n.xbgr.xm45_u18.nsg13_hv_pmos[delvto]
print @n.xbgr.xm45_u18.nsg13_hv_pmos[factuo]
print @n.xbgr.xm45_u19.nsg13_hv_pmos[w]
print @n.xbgr.xm45_u19.nsg13_hv_pmos[l]
print @n.xbgr.xm45_u19.nsg13_hv_pmos[delvto]
print @n.xbgr.xm45_u19.nsg13_hv_pmos[factuo]
print @n.xbgr.xm45_u20.nsg13_hv_pmos[w]
print @n.xbgr.xm45_u20.nsg13_hv_pmos[l]
print @n.xbgr.xm45_u20.nsg13_hv_pmos[delvto]
print @n.xbgr.xm45_u20.nsg13_hv_pmos[factuo]
print @n.xbgr.xm45_u21.nsg13_hv_pmos[w]
print @n.xbgr.xm45_u21.nsg13_hv_pmos[l]
print @n.xbgr.xm45_u21.nsg13_hv_pmos[delvto]
print @n.xbgr.xm45_u21.nsg13_hv_pmos[factuo]
print @n.xbgr.xm45_u22.nsg13_hv_pmos[w]
print @n.xbgr.xm45_u22.nsg13_hv_pmos[l]
print @n.xbgr.xm45_u22.nsg13_hv_pmos[delvto]
print @n.xbgr.xm45_u22.nsg13_hv_pmos[factuo]
print @n.xbgr.xm45_u23.nsg13_hv_pmos[w]
print @n.xbgr.xm45_u23.nsg13_hv_pmos[l]
print @n.xbgr.xm45_u23.nsg13_hv_pmos[delvto]
print @n.xbgr.xm45_u23.nsg13_hv_pmos[factuo]
print @n.xbgr.xm45_u24.nsg13_hv_pmos[w]
print @n.xbgr.xm45_u24.nsg13_hv_pmos[l]
print @n.xbgr.xm45_u24.nsg13_hv_pmos[delvto]
print @n.xbgr.xm45_u24.nsg13_hv_pmos[factuo]
print @n.xbgr.xm47_u2.nsg13_hv_pmos[w]
print @n.xbgr.xm47_u2.nsg13_hv_pmos[l]
print @n.xbgr.xm47_u2.nsg13_hv_pmos[delvto]
print @n.xbgr.xm47_u2.nsg13_hv_pmos[factuo]
print @n.xbgr.xm47_u3.nsg13_hv_pmos[w]
print @n.xbgr.xm47_u3.nsg13_hv_pmos[l]
print @n.xbgr.xm47_u3.nsg13_hv_pmos[delvto]
print @n.xbgr.xm47_u3.nsg13_hv_pmos[factuo]
print @n.xbgr.xm47_u4.nsg13_hv_pmos[w]
print @n.xbgr.xm47_u4.nsg13_hv_pmos[l]
print @n.xbgr.xm47_u4.nsg13_hv_pmos[delvto]
print @n.xbgr.xm47_u4.nsg13_hv_pmos[factuo]
print @n.xbgr.xm47_u5.nsg13_hv_pmos[w]
print @n.xbgr.xm47_u5.nsg13_hv_pmos[l]
print @n.xbgr.xm47_u5.nsg13_hv_pmos[delvto]
print @n.xbgr.xm47_u5.nsg13_hv_pmos[factuo]
print @n.xbgr.xm47_u6.nsg13_hv_pmos[w]
print @n.xbgr.xm47_u6.nsg13_hv_pmos[l]
print @n.xbgr.xm47_u6.nsg13_hv_pmos[delvto]
print @n.xbgr.xm47_u6.nsg13_hv_pmos[factuo]
print @n.xbgr.xm47_u7.nsg13_hv_pmos[w]
print @n.xbgr.xm47_u7.nsg13_hv_pmos[l]
print @n.xbgr.xm47_u7.nsg13_hv_pmos[delvto]
print @n.xbgr.xm47_u7.nsg13_hv_pmos[factuo]
print @n.xbgr.xm47_u8.nsg13_hv_pmos[w]
print @n.xbgr.xm47_u8.nsg13_hv_pmos[l]
print @n.xbgr.xm47_u8.nsg13_hv_pmos[delvto]
print @n.xbgr.xm47_u8.nsg13_hv_pmos[factuo]
print @n.xbgr.xm47_u9.nsg13_hv_pmos[w]
print @n.xbgr.xm47_u9.nsg13_hv_pmos[l]
print @n.xbgr.xm47_u9.nsg13_hv_pmos[delvto]
print @n.xbgr.xm47_u9.nsg13_hv_pmos[factuo]
print @n.xbgr.xm47_u10.nsg13_hv_pmos[w]
print @n.xbgr.xm47_u10.nsg13_hv_pmos[l]
print @n.xbgr.xm47_u10.nsg13_hv_pmos[delvto]
print @n.xbgr.xm47_u10.nsg13_hv_pmos[factuo]
print @n.xbgr.xm47_u11.nsg13_hv_pmos[w]
print @n.xbgr.xm47_u11.nsg13_hv_pmos[l]
print @n.xbgr.xm47_u11.nsg13_hv_pmos[delvto]
print @n.xbgr.xm47_u11.nsg13_hv_pmos[factuo]
print @n.xbgr.xm47_u12.nsg13_hv_pmos[w]
print @n.xbgr.xm47_u12.nsg13_hv_pmos[l]
print @n.xbgr.xm47_u12.nsg13_hv_pmos[delvto]
print @n.xbgr.xm47_u12.nsg13_hv_pmos[factuo]
print @n.xbgr.xm47_u13.nsg13_hv_pmos[w]
print @n.xbgr.xm47_u13.nsg13_hv_pmos[l]
print @n.xbgr.xm47_u13.nsg13_hv_pmos[delvto]
print @n.xbgr.xm47_u13.nsg13_hv_pmos[factuo]
print @n.xbgr.xm47_u14.nsg13_hv_pmos[w]
print @n.xbgr.xm47_u14.nsg13_hv_pmos[l]
print @n.xbgr.xm47_u14.nsg13_hv_pmos[delvto]
print @n.xbgr.xm47_u14.nsg13_hv_pmos[factuo]
print @n.xbgr.xm47_u15.nsg13_hv_pmos[w]
print @n.xbgr.xm47_u15.nsg13_hv_pmos[l]
print @n.xbgr.xm47_u15.nsg13_hv_pmos[delvto]
print @n.xbgr.xm47_u15.nsg13_hv_pmos[factuo]
print @n.xbgr.xm47_u16.nsg13_hv_pmos[w]
print @n.xbgr.xm47_u16.nsg13_hv_pmos[l]
print @n.xbgr.xm47_u16.nsg13_hv_pmos[delvto]
print @n.xbgr.xm47_u16.nsg13_hv_pmos[factuo]
print @n.xbgr.xm47_u17.nsg13_hv_pmos[w]
print @n.xbgr.xm47_u17.nsg13_hv_pmos[l]
print @n.xbgr.xm47_u17.nsg13_hv_pmos[delvto]
print @n.xbgr.xm47_u17.nsg13_hv_pmos[factuo]
print @n.xbgr.xm47_u18.nsg13_hv_pmos[w]
print @n.xbgr.xm47_u18.nsg13_hv_pmos[l]
print @n.xbgr.xm47_u18.nsg13_hv_pmos[delvto]
print @n.xbgr.xm47_u18.nsg13_hv_pmos[factuo]
print @n.xbgr.xm47_u19.nsg13_hv_pmos[w]
print @n.xbgr.xm47_u19.nsg13_hv_pmos[l]
print @n.xbgr.xm47_u19.nsg13_hv_pmos[delvto]
print @n.xbgr.xm47_u19.nsg13_hv_pmos[factuo]
print @n.xbgr.xm47_u20.nsg13_hv_pmos[w]
print @n.xbgr.xm47_u20.nsg13_hv_pmos[l]
print @n.xbgr.xm47_u20.nsg13_hv_pmos[delvto]
print @n.xbgr.xm47_u20.nsg13_hv_pmos[factuo]
print @n.xbgr.xm47_u21.nsg13_hv_pmos[w]
print @n.xbgr.xm47_u21.nsg13_hv_pmos[l]
print @n.xbgr.xm47_u21.nsg13_hv_pmos[delvto]
print @n.xbgr.xm47_u21.nsg13_hv_pmos[factuo]
print @n.xbgr.xm47_u22.nsg13_hv_pmos[w]
print @n.xbgr.xm47_u22.nsg13_hv_pmos[l]
print @n.xbgr.xm47_u22.nsg13_hv_pmos[delvto]
print @n.xbgr.xm47_u22.nsg13_hv_pmos[factuo]
print @n.xbgr.xm47_u23.nsg13_hv_pmos[w]
print @n.xbgr.xm47_u23.nsg13_hv_pmos[l]
print @n.xbgr.xm47_u23.nsg13_hv_pmos[delvto]
print @n.xbgr.xm47_u23.nsg13_hv_pmos[factuo]
print @n.xbgr.xm47_u24.nsg13_hv_pmos[w]
print @n.xbgr.xm47_u24.nsg13_hv_pmos[l]
print @n.xbgr.xm47_u24.nsg13_hv_pmos[delvto]
print @n.xbgr.xm47_u24.nsg13_hv_pmos[factuo]
print @n.xbgr.xm48_u2.nsg13_hv_pmos[w]
print @n.xbgr.xm48_u2.nsg13_hv_pmos[l]
print @n.xbgr.xm48_u2.nsg13_hv_pmos[delvto]
print @n.xbgr.xm48_u2.nsg13_hv_pmos[factuo]
print @n.xbgr.xm48_u3.nsg13_hv_pmos[w]
print @n.xbgr.xm48_u3.nsg13_hv_pmos[l]
print @n.xbgr.xm48_u3.nsg13_hv_pmos[delvto]
print @n.xbgr.xm48_u3.nsg13_hv_pmos[factuo]
print @n.xbgr.xm48_u4.nsg13_hv_pmos[w]
print @n.xbgr.xm48_u4.nsg13_hv_pmos[l]
print @n.xbgr.xm48_u4.nsg13_hv_pmos[delvto]
print @n.xbgr.xm48_u4.nsg13_hv_pmos[factuo]
print @n.xbgr.xm48_u5.nsg13_hv_pmos[w]
print @n.xbgr.xm48_u5.nsg13_hv_pmos[l]
print @n.xbgr.xm48_u5.nsg13_hv_pmos[delvto]
print @n.xbgr.xm48_u5.nsg13_hv_pmos[factuo]
print @n.xbgr.xm48_u6.nsg13_hv_pmos[w]
print @n.xbgr.xm48_u6.nsg13_hv_pmos[l]
print @n.xbgr.xm48_u6.nsg13_hv_pmos[delvto]
print @n.xbgr.xm48_u6.nsg13_hv_pmos[factuo]
print @n.xbgr.xm48_u7.nsg13_hv_pmos[w]
print @n.xbgr.xm48_u7.nsg13_hv_pmos[l]
print @n.xbgr.xm48_u7.nsg13_hv_pmos[delvto]
print @n.xbgr.xm48_u7.nsg13_hv_pmos[factuo]
print @n.xbgr.xm48_u8.nsg13_hv_pmos[w]
print @n.xbgr.xm48_u8.nsg13_hv_pmos[l]
print @n.xbgr.xm48_u8.nsg13_hv_pmos[delvto]
print @n.xbgr.xm48_u8.nsg13_hv_pmos[factuo]
print @n.xbgr.xm48_u9.nsg13_hv_pmos[w]
print @n.xbgr.xm48_u9.nsg13_hv_pmos[l]
print @n.xbgr.xm48_u9.nsg13_hv_pmos[delvto]
print @n.xbgr.xm48_u9.nsg13_hv_pmos[factuo]
print @n.xbgr.xm48_u10.nsg13_hv_pmos[w]
print @n.xbgr.xm48_u10.nsg13_hv_pmos[l]
print @n.xbgr.xm48_u10.nsg13_hv_pmos[delvto]
print @n.xbgr.xm48_u10.nsg13_hv_pmos[factuo]
print @n.xbgr.xm48_u11.nsg13_hv_pmos[w]
print @n.xbgr.xm48_u11.nsg13_hv_pmos[l]
print @n.xbgr.xm48_u11.nsg13_hv_pmos[delvto]
print @n.xbgr.xm48_u11.nsg13_hv_pmos[factuo]
print @n.xbgr.xm48_u12.nsg13_hv_pmos[w]
print @n.xbgr.xm48_u12.nsg13_hv_pmos[l]
print @n.xbgr.xm48_u12.nsg13_hv_pmos[delvto]
print @n.xbgr.xm48_u12.nsg13_hv_pmos[factuo]
print @n.xbgr.xm48_u13.nsg13_hv_pmos[w]
print @n.xbgr.xm48_u13.nsg13_hv_pmos[l]
print @n.xbgr.xm48_u13.nsg13_hv_pmos[delvto]
print @n.xbgr.xm48_u13.nsg13_hv_pmos[factuo]
print @n.xbgr.xm48_u14.nsg13_hv_pmos[w]
print @n.xbgr.xm48_u14.nsg13_hv_pmos[l]
print @n.xbgr.xm48_u14.nsg13_hv_pmos[delvto]
print @n.xbgr.xm48_u14.nsg13_hv_pmos[factuo]
print @n.xbgr.xm48_u15.nsg13_hv_pmos[w]
print @n.xbgr.xm48_u15.nsg13_hv_pmos[l]
print @n.xbgr.xm48_u15.nsg13_hv_pmos[delvto]
print @n.xbgr.xm48_u15.nsg13_hv_pmos[factuo]
print @n.xbgr.xm48_u16.nsg13_hv_pmos[w]
print @n.xbgr.xm48_u16.nsg13_hv_pmos[l]
print @n.xbgr.xm48_u16.nsg13_hv_pmos[delvto]
print @n.xbgr.xm48_u16.nsg13_hv_pmos[factuo]
print @n.xbgr.xm48_u17.nsg13_hv_pmos[w]
print @n.xbgr.xm48_u17.nsg13_hv_pmos[l]
print @n.xbgr.xm48_u17.nsg13_hv_pmos[delvto]
print @n.xbgr.xm48_u17.nsg13_hv_pmos[factuo]
print @n.xbgr.xm48_u18.nsg13_hv_pmos[w]
print @n.xbgr.xm48_u18.nsg13_hv_pmos[l]
print @n.xbgr.xm48_u18.nsg13_hv_pmos[delvto]
print @n.xbgr.xm48_u18.nsg13_hv_pmos[factuo]
print @n.xbgr.xm48_u19.nsg13_hv_pmos[w]
print @n.xbgr.xm48_u19.nsg13_hv_pmos[l]
print @n.xbgr.xm48_u19.nsg13_hv_pmos[delvto]
print @n.xbgr.xm48_u19.nsg13_hv_pmos[factuo]
print @n.xbgr.xm48_u20.nsg13_hv_pmos[w]
print @n.xbgr.xm48_u20.nsg13_hv_pmos[l]
print @n.xbgr.xm48_u20.nsg13_hv_pmos[delvto]
print @n.xbgr.xm48_u20.nsg13_hv_pmos[factuo]
print @n.xbgr.xm48_u21.nsg13_hv_pmos[w]
print @n.xbgr.xm48_u21.nsg13_hv_pmos[l]
print @n.xbgr.xm48_u21.nsg13_hv_pmos[delvto]
print @n.xbgr.xm48_u21.nsg13_hv_pmos[factuo]
print @n.xbgr.xm48_u22.nsg13_hv_pmos[w]
print @n.xbgr.xm48_u22.nsg13_hv_pmos[l]
print @n.xbgr.xm48_u22.nsg13_hv_pmos[delvto]
print @n.xbgr.xm48_u22.nsg13_hv_pmos[factuo]
print @n.xbgr.xm48_u23.nsg13_hv_pmos[w]
print @n.xbgr.xm48_u23.nsg13_hv_pmos[l]
print @n.xbgr.xm48_u23.nsg13_hv_pmos[delvto]
print @n.xbgr.xm48_u23.nsg13_hv_pmos[factuo]
print @n.xbgr.xm48_u24.nsg13_hv_pmos[w]
print @n.xbgr.xm48_u24.nsg13_hv_pmos[l]
print @n.xbgr.xm48_u24.nsg13_hv_pmos[delvto]
print @n.xbgr.xm48_u24.nsg13_hv_pmos[factuo]
print @n.xbgr.xm50_u2.nsg13_hv_pmos[w]
print @n.xbgr.xm50_u2.nsg13_hv_pmos[l]
print @n.xbgr.xm50_u2.nsg13_hv_pmos[delvto]
print @n.xbgr.xm50_u2.nsg13_hv_pmos[factuo]
print @n.xbgr.xm50_u3.nsg13_hv_pmos[w]
print @n.xbgr.xm50_u3.nsg13_hv_pmos[l]
print @n.xbgr.xm50_u3.nsg13_hv_pmos[delvto]
print @n.xbgr.xm50_u3.nsg13_hv_pmos[factuo]
print @n.xbgr.xm50_u4.nsg13_hv_pmos[w]
print @n.xbgr.xm50_u4.nsg13_hv_pmos[l]
print @n.xbgr.xm50_u4.nsg13_hv_pmos[delvto]
print @n.xbgr.xm50_u4.nsg13_hv_pmos[factuo]
print @n.xbgr.xm50_u5.nsg13_hv_pmos[w]
print @n.xbgr.xm50_u5.nsg13_hv_pmos[l]
print @n.xbgr.xm50_u5.nsg13_hv_pmos[delvto]
print @n.xbgr.xm50_u5.nsg13_hv_pmos[factuo]
print @n.xbgr.xm50_u6.nsg13_hv_pmos[w]
print @n.xbgr.xm50_u6.nsg13_hv_pmos[l]
print @n.xbgr.xm50_u6.nsg13_hv_pmos[delvto]
print @n.xbgr.xm50_u6.nsg13_hv_pmos[factuo]
print @n.xbgr.xm50_u7.nsg13_hv_pmos[w]
print @n.xbgr.xm50_u7.nsg13_hv_pmos[l]
print @n.xbgr.xm50_u7.nsg13_hv_pmos[delvto]
print @n.xbgr.xm50_u7.nsg13_hv_pmos[factuo]
print @n.xbgr.xm50_u8.nsg13_hv_pmos[w]
print @n.xbgr.xm50_u8.nsg13_hv_pmos[l]
print @n.xbgr.xm50_u8.nsg13_hv_pmos[delvto]
print @n.xbgr.xm50_u8.nsg13_hv_pmos[factuo]
print @n.xbgr.xm50_u9.nsg13_hv_pmos[w]
print @n.xbgr.xm50_u9.nsg13_hv_pmos[l]
print @n.xbgr.xm50_u9.nsg13_hv_pmos[delvto]
print @n.xbgr.xm50_u9.nsg13_hv_pmos[factuo]
print @n.xbgr.xm50_u10.nsg13_hv_pmos[w]
print @n.xbgr.xm50_u10.nsg13_hv_pmos[l]
print @n.xbgr.xm50_u10.nsg13_hv_pmos[delvto]
print @n.xbgr.xm50_u10.nsg13_hv_pmos[factuo]
print @n.xbgr.xm50_u11.nsg13_hv_pmos[w]
print @n.xbgr.xm50_u11.nsg13_hv_pmos[l]
print @n.xbgr.xm50_u11.nsg13_hv_pmos[delvto]
print @n.xbgr.xm50_u11.nsg13_hv_pmos[factuo]
print @n.xbgr.xm50_u12.nsg13_hv_pmos[w]
print @n.xbgr.xm50_u12.nsg13_hv_pmos[l]
print @n.xbgr.xm50_u12.nsg13_hv_pmos[delvto]
print @n.xbgr.xm50_u12.nsg13_hv_pmos[factuo]
print @n.xbgr.xm50_u13.nsg13_hv_pmos[w]
print @n.xbgr.xm50_u13.nsg13_hv_pmos[l]
print @n.xbgr.xm50_u13.nsg13_hv_pmos[delvto]
print @n.xbgr.xm50_u13.nsg13_hv_pmos[factuo]
print @n.xbgr.xm50_u14.nsg13_hv_pmos[w]
print @n.xbgr.xm50_u14.nsg13_hv_pmos[l]
print @n.xbgr.xm50_u14.nsg13_hv_pmos[delvto]
print @n.xbgr.xm50_u14.nsg13_hv_pmos[factuo]
print @n.xbgr.xm50_u15.nsg13_hv_pmos[w]
print @n.xbgr.xm50_u15.nsg13_hv_pmos[l]
print @n.xbgr.xm50_u15.nsg13_hv_pmos[delvto]
print @n.xbgr.xm50_u15.nsg13_hv_pmos[factuo]
print @n.xbgr.xm50_u16.nsg13_hv_pmos[w]
print @n.xbgr.xm50_u16.nsg13_hv_pmos[l]
print @n.xbgr.xm50_u16.nsg13_hv_pmos[delvto]
print @n.xbgr.xm50_u16.nsg13_hv_pmos[factuo]
print @n.xbgr.xm50_u17.nsg13_hv_pmos[w]
print @n.xbgr.xm50_u17.nsg13_hv_pmos[l]
print @n.xbgr.xm50_u17.nsg13_hv_pmos[delvto]
print @n.xbgr.xm50_u17.nsg13_hv_pmos[factuo]
print @n.xbgr.xm50_u18.nsg13_hv_pmos[w]
print @n.xbgr.xm50_u18.nsg13_hv_pmos[l]
print @n.xbgr.xm50_u18.nsg13_hv_pmos[delvto]
print @n.xbgr.xm50_u18.nsg13_hv_pmos[factuo]
print @n.xbgr.xm50_u19.nsg13_hv_pmos[w]
print @n.xbgr.xm50_u19.nsg13_hv_pmos[l]
print @n.xbgr.xm50_u19.nsg13_hv_pmos[delvto]
print @n.xbgr.xm50_u19.nsg13_hv_pmos[factuo]
print @n.xbgr.xm50_u20.nsg13_hv_pmos[w]
print @n.xbgr.xm50_u20.nsg13_hv_pmos[l]
print @n.xbgr.xm50_u20.nsg13_hv_pmos[delvto]
print @n.xbgr.xm50_u20.nsg13_hv_pmos[factuo]
print @n.xbgr.xm50_u21.nsg13_hv_pmos[w]
print @n.xbgr.xm50_u21.nsg13_hv_pmos[l]
print @n.xbgr.xm50_u21.nsg13_hv_pmos[delvto]
print @n.xbgr.xm50_u21.nsg13_hv_pmos[factuo]
print @n.xbgr.xm50_u22.nsg13_hv_pmos[w]
print @n.xbgr.xm50_u22.nsg13_hv_pmos[l]
print @n.xbgr.xm50_u22.nsg13_hv_pmos[delvto]
print @n.xbgr.xm50_u22.nsg13_hv_pmos[factuo]
print @n.xbgr.xm50_u23.nsg13_hv_pmos[w]
print @n.xbgr.xm50_u23.nsg13_hv_pmos[l]
print @n.xbgr.xm50_u23.nsg13_hv_pmos[delvto]
print @n.xbgr.xm50_u23.nsg13_hv_pmos[factuo]
print @n.xbgr.xm50_u24.nsg13_hv_pmos[w]
print @n.xbgr.xm50_u24.nsg13_hv_pmos[l]
print @n.xbgr.xm50_u24.nsg13_hv_pmos[delvto]
print @n.xbgr.xm50_u24.nsg13_hv_pmos[factuo]
print @n.xbgr.xm51_u2.nsg13_hv_pmos[w]
print @n.xbgr.xm51_u2.nsg13_hv_pmos[l]
print @n.xbgr.xm51_u2.nsg13_hv_pmos[delvto]
print @n.xbgr.xm51_u2.nsg13_hv_pmos[factuo]
print @n.xbgr.xm51_u3.nsg13_hv_pmos[w]
print @n.xbgr.xm51_u3.nsg13_hv_pmos[l]
print @n.xbgr.xm51_u3.nsg13_hv_pmos[delvto]
print @n.xbgr.xm51_u3.nsg13_hv_pmos[factuo]
print @n.xbgr.xm51_u4.nsg13_hv_pmos[w]
print @n.xbgr.xm51_u4.nsg13_hv_pmos[l]
print @n.xbgr.xm51_u4.nsg13_hv_pmos[delvto]
print @n.xbgr.xm51_u4.nsg13_hv_pmos[factuo]
print @n.xbgr.xm52_u2.nsg13_hv_pmos[w]
print @n.xbgr.xm52_u2.nsg13_hv_pmos[l]
print @n.xbgr.xm52_u2.nsg13_hv_pmos[delvto]
print @n.xbgr.xm52_u2.nsg13_hv_pmos[factuo]
print @n.xbgr.xm52_u3.nsg13_hv_pmos[w]
print @n.xbgr.xm52_u3.nsg13_hv_pmos[l]
print @n.xbgr.xm52_u3.nsg13_hv_pmos[delvto]
print @n.xbgr.xm52_u3.nsg13_hv_pmos[factuo]
print @n.xbgr.xm52_u4.nsg13_hv_pmos[w]
print @n.xbgr.xm52_u4.nsg13_hv_pmos[l]
print @n.xbgr.xm52_u4.nsg13_hv_pmos[delvto]
print @n.xbgr.xm52_u4.nsg13_hv_pmos[factuo]
print @n.xbgr.xm52_u5.nsg13_hv_pmos[w]
print @n.xbgr.xm52_u5.nsg13_hv_pmos[l]
print @n.xbgr.xm52_u5.nsg13_hv_pmos[delvto]
print @n.xbgr.xm52_u5.nsg13_hv_pmos[factuo]
print @n.xbgr.xm52_u6.nsg13_hv_pmos[w]
print @n.xbgr.xm52_u6.nsg13_hv_pmos[l]
print @n.xbgr.xm52_u6.nsg13_hv_pmos[delvto]
print @n.xbgr.xm52_u6.nsg13_hv_pmos[factuo]
print @n.xbgr.xm52_u7.nsg13_hv_pmos[w]
print @n.xbgr.xm52_u7.nsg13_hv_pmos[l]
print @n.xbgr.xm52_u7.nsg13_hv_pmos[delvto]
print @n.xbgr.xm52_u7.nsg13_hv_pmos[factuo]
print @n.xbgr.xm52_u8.nsg13_hv_pmos[w]
print @n.xbgr.xm52_u8.nsg13_hv_pmos[l]
print @n.xbgr.xm52_u8.nsg13_hv_pmos[delvto]
print @n.xbgr.xm52_u8.nsg13_hv_pmos[factuo]
print @n.xbgr.xm52_u9.nsg13_hv_pmos[w]
print @n.xbgr.xm52_u9.nsg13_hv_pmos[l]
print @n.xbgr.xm52_u9.nsg13_hv_pmos[delvto]
print @n.xbgr.xm52_u9.nsg13_hv_pmos[factuo]
print @n.xbgr.xm52_u10.nsg13_hv_pmos[w]
print @n.xbgr.xm52_u10.nsg13_hv_pmos[l]
print @n.xbgr.xm52_u10.nsg13_hv_pmos[delvto]
print @n.xbgr.xm52_u10.nsg13_hv_pmos[factuo]
print @n.xbgr.xm52_u11.nsg13_hv_pmos[w]
print @n.xbgr.xm52_u11.nsg13_hv_pmos[l]
print @n.xbgr.xm52_u11.nsg13_hv_pmos[delvto]
print @n.xbgr.xm52_u11.nsg13_hv_pmos[factuo]
print @n.xbgr.xm52_u12.nsg13_hv_pmos[w]
print @n.xbgr.xm52_u12.nsg13_hv_pmos[l]
print @n.xbgr.xm52_u12.nsg13_hv_pmos[delvto]
print @n.xbgr.xm52_u12.nsg13_hv_pmos[factuo]
print @n.xbgr.xm52_u13.nsg13_hv_pmos[w]
print @n.xbgr.xm52_u13.nsg13_hv_pmos[l]
print @n.xbgr.xm52_u13.nsg13_hv_pmos[delvto]
print @n.xbgr.xm52_u13.nsg13_hv_pmos[factuo]
print @n.xbgr.xm52_u14.nsg13_hv_pmos[w]
print @n.xbgr.xm52_u14.nsg13_hv_pmos[l]
print @n.xbgr.xm52_u14.nsg13_hv_pmos[delvto]
print @n.xbgr.xm52_u14.nsg13_hv_pmos[factuo]
print @n.xbgr.xm52_u15.nsg13_hv_pmos[w]
print @n.xbgr.xm52_u15.nsg13_hv_pmos[l]
print @n.xbgr.xm52_u15.nsg13_hv_pmos[delvto]
print @n.xbgr.xm52_u15.nsg13_hv_pmos[factuo]
print @n.xbgr.xm52_u16.nsg13_hv_pmos[w]
print @n.xbgr.xm52_u16.nsg13_hv_pmos[l]
print @n.xbgr.xm52_u16.nsg13_hv_pmos[delvto]
print @n.xbgr.xm52_u16.nsg13_hv_pmos[factuo]
print @n.xbgr.xm52_u17.nsg13_hv_pmos[w]
print @n.xbgr.xm52_u17.nsg13_hv_pmos[l]
print @n.xbgr.xm52_u17.nsg13_hv_pmos[delvto]
print @n.xbgr.xm52_u17.nsg13_hv_pmos[factuo]
print @n.xbgr.xm52_u18.nsg13_hv_pmos[w]
print @n.xbgr.xm52_u18.nsg13_hv_pmos[l]
print @n.xbgr.xm52_u18.nsg13_hv_pmos[delvto]
print @n.xbgr.xm52_u18.nsg13_hv_pmos[factuo]
print @n.xbgr.xm52_u19.nsg13_hv_pmos[w]
print @n.xbgr.xm52_u19.nsg13_hv_pmos[l]
print @n.xbgr.xm52_u19.nsg13_hv_pmos[delvto]
print @n.xbgr.xm52_u19.nsg13_hv_pmos[factuo]
print @n.xbgr.xm52_u20.nsg13_hv_pmos[w]
print @n.xbgr.xm52_u20.nsg13_hv_pmos[l]
print @n.xbgr.xm52_u20.nsg13_hv_pmos[delvto]
print @n.xbgr.xm52_u20.nsg13_hv_pmos[factuo]
print @n.xbgr.xm52_u21.nsg13_hv_pmos[w]
print @n.xbgr.xm52_u21.nsg13_hv_pmos[l]
print @n.xbgr.xm52_u21.nsg13_hv_pmos[delvto]
print @n.xbgr.xm52_u21.nsg13_hv_pmos[factuo]
print @n.xbgr.xm52_u22.nsg13_hv_pmos[w]
print @n.xbgr.xm52_u22.nsg13_hv_pmos[l]
print @n.xbgr.xm52_u22.nsg13_hv_pmos[delvto]
print @n.xbgr.xm52_u22.nsg13_hv_pmos[factuo]
print @n.xbgr.xm52_u23.nsg13_hv_pmos[w]
print @n.xbgr.xm52_u23.nsg13_hv_pmos[l]
print @n.xbgr.xm52_u23.nsg13_hv_pmos[delvto]
print @n.xbgr.xm52_u23.nsg13_hv_pmos[factuo]
print @n.xbgr.xm52_u24.nsg13_hv_pmos[w]
print @n.xbgr.xm52_u24.nsg13_hv_pmos[l]
print @n.xbgr.xm52_u24.nsg13_hv_pmos[delvto]
print @n.xbgr.xm52_u24.nsg13_hv_pmos[factuo]
print @n.xbgr.xm54_u2.nsg13_hv_pmos[w]
print @n.xbgr.xm54_u2.nsg13_hv_pmos[l]
print @n.xbgr.xm54_u2.nsg13_hv_pmos[delvto]
print @n.xbgr.xm54_u2.nsg13_hv_pmos[factuo]
print @n.xbgr.xm54_u3.nsg13_hv_pmos[w]
print @n.xbgr.xm54_u3.nsg13_hv_pmos[l]
print @n.xbgr.xm54_u3.nsg13_hv_pmos[delvto]
print @n.xbgr.xm54_u3.nsg13_hv_pmos[factuo]
print @n.xbgr.xm54_u4.nsg13_hv_pmos[w]
print @n.xbgr.xm54_u4.nsg13_hv_pmos[l]
print @n.xbgr.xm54_u4.nsg13_hv_pmos[delvto]
print @n.xbgr.xm54_u4.nsg13_hv_pmos[factuo]
print @n.xbgr.xm54_u5.nsg13_hv_pmos[w]
print @n.xbgr.xm54_u5.nsg13_hv_pmos[l]
print @n.xbgr.xm54_u5.nsg13_hv_pmos[delvto]
print @n.xbgr.xm54_u5.nsg13_hv_pmos[factuo]
print @n.xbgr.xm54_u6.nsg13_hv_pmos[w]
print @n.xbgr.xm54_u6.nsg13_hv_pmos[l]
print @n.xbgr.xm54_u6.nsg13_hv_pmos[delvto]
print @n.xbgr.xm54_u6.nsg13_hv_pmos[factuo]
print @n.xbgr.xm54_u7.nsg13_hv_pmos[w]
print @n.xbgr.xm54_u7.nsg13_hv_pmos[l]
print @n.xbgr.xm54_u7.nsg13_hv_pmos[delvto]
print @n.xbgr.xm54_u7.nsg13_hv_pmos[factuo]
print @n.xbgr.xm54_u8.nsg13_hv_pmos[w]
print @n.xbgr.xm54_u8.nsg13_hv_pmos[l]
print @n.xbgr.xm54_u8.nsg13_hv_pmos[delvto]
print @n.xbgr.xm54_u8.nsg13_hv_pmos[factuo]
print @n.xbgr.xm54_u9.nsg13_hv_pmos[w]
print @n.xbgr.xm54_u9.nsg13_hv_pmos[l]
print @n.xbgr.xm54_u9.nsg13_hv_pmos[delvto]
print @n.xbgr.xm54_u9.nsg13_hv_pmos[factuo]
print @n.xbgr.xm54_u10.nsg13_hv_pmos[w]
print @n.xbgr.xm54_u10.nsg13_hv_pmos[l]
print @n.xbgr.xm54_u10.nsg13_hv_pmos[delvto]
print @n.xbgr.xm54_u10.nsg13_hv_pmos[factuo]
print @n.xbgr.xm54_u11.nsg13_hv_pmos[w]
print @n.xbgr.xm54_u11.nsg13_hv_pmos[l]
print @n.xbgr.xm54_u11.nsg13_hv_pmos[delvto]
print @n.xbgr.xm54_u11.nsg13_hv_pmos[factuo]
print @n.xbgr.xm54_u12.nsg13_hv_pmos[w]
print @n.xbgr.xm54_u12.nsg13_hv_pmos[l]
print @n.xbgr.xm54_u12.nsg13_hv_pmos[delvto]
print @n.xbgr.xm54_u12.nsg13_hv_pmos[factuo]
print @n.xbgr.xm54_u13.nsg13_hv_pmos[w]
print @n.xbgr.xm54_u13.nsg13_hv_pmos[l]
print @n.xbgr.xm54_u13.nsg13_hv_pmos[delvto]
print @n.xbgr.xm54_u13.nsg13_hv_pmos[factuo]
print @n.xbgr.xm54_u14.nsg13_hv_pmos[w]
print @n.xbgr.xm54_u14.nsg13_hv_pmos[l]
print @n.xbgr.xm54_u14.nsg13_hv_pmos[delvto]
print @n.xbgr.xm54_u14.nsg13_hv_pmos[factuo]
print @n.xbgr.xm54_u15.nsg13_hv_pmos[w]
print @n.xbgr.xm54_u15.nsg13_hv_pmos[l]
print @n.xbgr.xm54_u15.nsg13_hv_pmos[delvto]
print @n.xbgr.xm54_u15.nsg13_hv_pmos[factuo]
print @n.xbgr.xm54_u16.nsg13_hv_pmos[w]
print @n.xbgr.xm54_u16.nsg13_hv_pmos[l]
print @n.xbgr.xm54_u16.nsg13_hv_pmos[delvto]
print @n.xbgr.xm54_u16.nsg13_hv_pmos[factuo]
print @n.xbgr.xm54_u17.nsg13_hv_pmos[w]
print @n.xbgr.xm54_u17.nsg13_hv_pmos[l]
print @n.xbgr.xm54_u17.nsg13_hv_pmos[delvto]
print @n.xbgr.xm54_u17.nsg13_hv_pmos[factuo]
print @n.xbgr.xm54_u18.nsg13_hv_pmos[w]
print @n.xbgr.xm54_u18.nsg13_hv_pmos[l]
print @n.xbgr.xm54_u18.nsg13_hv_pmos[delvto]
print @n.xbgr.xm54_u18.nsg13_hv_pmos[factuo]
print @n.xbgr.xm54_u19.nsg13_hv_pmos[w]
print @n.xbgr.xm54_u19.nsg13_hv_pmos[l]
print @n.xbgr.xm54_u19.nsg13_hv_pmos[delvto]
print @n.xbgr.xm54_u19.nsg13_hv_pmos[factuo]
print @n.xbgr.xm54_u20.nsg13_hv_pmos[w]
print @n.xbgr.xm54_u20.nsg13_hv_pmos[l]
print @n.xbgr.xm54_u20.nsg13_hv_pmos[delvto]
print @n.xbgr.xm54_u20.nsg13_hv_pmos[factuo]
print @n.xbgr.xm54_u21.nsg13_hv_pmos[w]
print @n.xbgr.xm54_u21.nsg13_hv_pmos[l]
print @n.xbgr.xm54_u21.nsg13_hv_pmos[delvto]
print @n.xbgr.xm54_u21.nsg13_hv_pmos[factuo]
print @n.xbgr.xm54_u22.nsg13_hv_pmos[w]
print @n.xbgr.xm54_u22.nsg13_hv_pmos[l]
print @n.xbgr.xm54_u22.nsg13_hv_pmos[delvto]
print @n.xbgr.xm54_u22.nsg13_hv_pmos[factuo]
print @n.xbgr.xm54_u23.nsg13_hv_pmos[w]
print @n.xbgr.xm54_u23.nsg13_hv_pmos[l]
print @n.xbgr.xm54_u23.nsg13_hv_pmos[delvto]
print @n.xbgr.xm54_u23.nsg13_hv_pmos[factuo]
print @n.xbgr.xm54_u24.nsg13_hv_pmos[w]
print @n.xbgr.xm54_u24.nsg13_hv_pmos[l]
print @n.xbgr.xm54_u24.nsg13_hv_pmos[delvto]
print @n.xbgr.xm54_u24.nsg13_hv_pmos[factuo]
print @q.xbgr.xq56_u2.qnpn13g2[area]
print @q.xbgr.xq56_u3.qnpn13g2[area]
print @q.xbgr.xq56_u4.qnpn13g2[area]
print @q.xbgr.xq56_u5.qnpn13g2[area]
print @q.xbgr.xq56_u6.qnpn13g2[area]
print @q.xbgr.xq56_u7.qnpn13g2[area]
print @q.xbgr.xq56_u8.qnpn13g2[area]
print @q.xbgr.xq56_u9.qnpn13g2[area]
print @q.xbgr.xq56_u10.qnpn13g2[area]
print @q.xbgr.xq56_u11.qnpn13g2[area]
print @q.xbgr.xq56_u12.qnpn13g2[area]
print @q.xbgr.xq56_u13.qnpn13g2[area]
print @q.xbgr.xq56_u14.qnpn13g2[area]
print @q.xbgr.xq56_u15.qnpn13g2[area]
print @q.xbgr.xq56_u16.qnpn13g2[area]
print @q.xbgr.xq56_u17.qnpn13g2[area]
print @q.xbgr.xq56_u18.qnpn13g2[area]
print @q.xbgr.xq56_u19.qnpn13g2[area]
print @q.xbgr.xq56_u20.qnpn13g2[area]
print @q.xbgr.xq56_u21.qnpn13g2[area]
print @q.xbgr.xq56_u22.qnpn13g2[area]
print @q.xbgr.xq56_u23.qnpn13g2[area]
print @q.xbgr.xq56_u24.qnpn13g2[area]
print @q.xbgr.xq60_u2.qnpn13g2[area]
print @q.xbgr.xq60_u3.qnpn13g2[area]
print @q.xbgr.xq60_u4.qnpn13g2[area]
print @q.xbgr.xq62_u2.qnpn13g2[area]
print @q.xbgr.xq62_u3.qnpn13g2[area]
print @q.xbgr.xq62_u4.qnpn13g2[area]
print @q.xbgr.xq62_u5.qnpn13g2[area]
print @q.xbgr.xq62_u6.qnpn13g2[area]
print @q.xbgr.xq62_u7.qnpn13g2[area]
print @q.xbgr.xq62_u8.qnpn13g2[area]
print @q.xbgr.xq62_u9.qnpn13g2[area]
print @q.xbgr.xq62_u10.qnpn13g2[area]
print @q.xbgr.xq62_u11.qnpn13g2[area]
print @q.xbgr.xq62_u12.qnpn13g2[area]
print @q.xbgr.xq62_u13.qnpn13g2[area]
print @q.xbgr.xq62_u14.qnpn13g2[area]
print @q.xbgr.xq62_u15.qnpn13g2[area]
print @q.xbgr.xq62_u16.qnpn13g2[area]
print @q.xbgr.xq62_u17.qnpn13g2[area]
print @q.xbgr.xq62_u18.qnpn13g2[area]
print @q.xbgr.xq62_u19.qnpn13g2[area]
print @q.xbgr.xq62_u20.qnpn13g2[area]
print @q.xbgr.xq62_u21.qnpn13g2[area]
print @q.xbgr.xq62_u22.qnpn13g2[area]
print @q.xbgr.xq62_u23.qnpn13g2[area]
print @q.xbgr.xq62_u24.qnpn13g2[area]
print @q.xbgr.xq67_u2.qnpn13g2[area]
print @q.xbgr.xq67_u3.qnpn13g2[area]
print @q.xbgr.xq67_u4.qnpn13g2[area]
print @q.xbgr.xq67_u5.qnpn13g2[area]
print @q.xbgr.xq67_u6.qnpn13g2[area]
print @q.xbgr.xq67_u7.qnpn13g2[area]
print @q.xbgr.xq67_u8.qnpn13g2[area]
print @q.xbgr.xq67_u9.qnpn13g2[area]
print @q.xbgr.xq67_u10.qnpn13g2[area]
print @q.xbgr.xq67_u11.qnpn13g2[area]
print @q.xbgr.xq67_u12.qnpn13g2[area]
print @q.xbgr.xq67_u13.qnpn13g2[area]
print @q.xbgr.xq67_u14.qnpn13g2[area]
print @q.xbgr.xq67_u15.qnpn13g2[area]
print @q.xbgr.xq67_u16.qnpn13g2[area]
print @q.xbgr.xq67_u17.qnpn13g2[area]
print @q.xbgr.xq67_u18.qnpn13g2[area]
print @q.xbgr.xq67_u19.qnpn13g2[area]
print @q.xbgr.xq67_u20.qnpn13g2[area]
print @q.xbgr.xq67_u21.qnpn13g2[area]
print @q.xbgr.xq67_u22.qnpn13g2[area]
print @q.xbgr.xq67_u23.qnpn13g2[area]
print @q.xbgr.xq67_u24.qnpn13g2[area]
print @q.xbgr.xq68_u2.qnpn13g2[area]
print @q.xbgr.xq68_u3.qnpn13g2[area]
print @q.xbgr.xq68_u4.qnpn13g2[area]
print @q.xbgr.xq68_u5.qnpn13g2[area]
print @q.xbgr.xq68_u6.qnpn13g2[area]
print @q.xbgr.xq68_u7.qnpn13g2[area]
print @q.xbgr.xq68_u8.qnpn13g2[area]
print @q.xbgr.xq68_u9.qnpn13g2[area]
print @q.xbgr.xq68_u10.qnpn13g2[area]
print @q.xbgr.xq68_u11.qnpn13g2[area]
print @q.xbgr.xq68_u12.qnpn13g2[area]
print @q.xbgr.xq68_u13.qnpn13g2[area]
print @q.xbgr.xq68_u14.qnpn13g2[area]
print @q.xbgr.xq68_u15.qnpn13g2[area]
print @q.xbgr.xq68_u16.qnpn13g2[area]
print @q.xbgr.xq68_u17.qnpn13g2[area]
print @q.xbgr.xq68_u18.qnpn13g2[area]
print @q.xbgr.xq68_u19.qnpn13g2[area]
print @q.xbgr.xq68_u20.qnpn13g2[area]
print @q.xbgr.xq68_u21.qnpn13g2[area]
print @q.xbgr.xq68_u22.qnpn13g2[area]
print @q.xbgr.xq68_u23.qnpn13g2[area]
print @q.xbgr.xq68_u24.qnpn13g2[area]
print @q.xbgr.xq69_u2.qnpn13g2[area]
print @q.xbgr.xq69_u3.qnpn13g2[area]
print @q.xbgr.xq69_u4.qnpn13g2[area]
print @q.xbgr.xq69_u5.qnpn13g2[area]
print @q.xbgr.xq69_u6.qnpn13g2[area]
print @q.xbgr.xq69_u7.qnpn13g2[area]
print @q.xbgr.xq69_u8.qnpn13g2[area]
print @q.xbgr.xq69_u9.qnpn13g2[area]
print @q.xbgr.xq69_u10.qnpn13g2[area]
print @q.xbgr.xq69_u11.qnpn13g2[area]
print @q.xbgr.xq69_u12.qnpn13g2[area]
print @q.xbgr.xq69_u13.qnpn13g2[area]
print @q.xbgr.xq69_u14.qnpn13g2[area]
print @q.xbgr.xq69_u15.qnpn13g2[area]
print @q.xbgr.xq69_u16.qnpn13g2[area]
print @q.xbgr.xq69_u17.qnpn13g2[area]
print @q.xbgr.xq69_u18.qnpn13g2[area]
print @q.xbgr.xq69_u19.qnpn13g2[area]
print @q.xbgr.xq69_u20.qnpn13g2[area]
print @q.xbgr.xq69_u21.qnpn13g2[area]
print @q.xbgr.xq69_u22.qnpn13g2[area]
print @q.xbgr.xq69_u23.qnpn13g2[area]
print @q.xbgr.xq69_u24.qnpn13g2[area]
print @q.xbgr.xq70_u2.qnpn13g2[area]
print @q.xbgr.xq70_u3.qnpn13g2[area]
print @q.xbgr.xq70_u4.qnpn13g2[area]
print @q.xbgr.xq70_u5.qnpn13g2[area]
print @q.xbgr.xq70_u6.qnpn13g2[area]
print @q.xbgr.xq70_u7.qnpn13g2[area]
print @q.xbgr.xq70_u8.qnpn13g2[area]
print @q.xbgr.xq70_u9.qnpn13g2[area]
print @q.xbgr.xq70_u10.qnpn13g2[area]
print @q.xbgr.xq70_u11.qnpn13g2[area]
print @q.xbgr.xq70_u12.qnpn13g2[area]
print @q.xbgr.xq70_u13.qnpn13g2[area]
print @q.xbgr.xq70_u14.qnpn13g2[area]
print @q.xbgr.xq70_u15.qnpn13g2[area]
print @q.xbgr.xq70_u16.qnpn13g2[area]
print @q.xbgr.xq70_u17.qnpn13g2[area]
print @q.xbgr.xq70_u18.qnpn13g2[area]
print @q.xbgr.xq70_u19.qnpn13g2[area]
print @q.xbgr.xq70_u20.qnpn13g2[area]
print @q.xbgr.xq70_u21.qnpn13g2[area]
print @q.xbgr.xq70_u22.qnpn13g2[area]
print @q.xbgr.xq70_u23.qnpn13g2[area]
print @q.xbgr.xq70_u24.qnpn13g2[area]
print @q.xbgr.xq71_u2.qnpn13g2[area]
print @q.xbgr.xq71_u3.qnpn13g2[area]
print @q.xbgr.xq71_u4.qnpn13g2[area]
print @q.xbgr.xq71_u5.qnpn13g2[area]
print @q.xbgr.xq71_u6.qnpn13g2[area]
print @q.xbgr.xq71_u7.qnpn13g2[area]
print @q.xbgr.xq71_u8.qnpn13g2[area]
print @q.xbgr.xq71_u9.qnpn13g2[area]
print @q.xbgr.xq71_u10.qnpn13g2[area]
print @q.xbgr.xq71_u11.qnpn13g2[area]
print @q.xbgr.xq71_u12.qnpn13g2[area]
print @q.xbgr.xq71_u13.qnpn13g2[area]
print @q.xbgr.xq71_u14.qnpn13g2[area]
print @q.xbgr.xq71_u15.qnpn13g2[area]
print @q.xbgr.xq71_u16.qnpn13g2[area]
print @q.xbgr.xq71_u17.qnpn13g2[area]
print @q.xbgr.xq71_u18.qnpn13g2[area]
print @q.xbgr.xq71_u19.qnpn13g2[area]
print @q.xbgr.xq71_u20.qnpn13g2[area]
print @q.xbgr.xq71_u21.qnpn13g2[area]
print @q.xbgr.xq71_u22.qnpn13g2[area]
print @q.xbgr.xq71_u23.qnpn13g2[area]
print @q.xbgr.xq71_u24.qnpn13g2[area]
print @q.xbgr.xq72_u2.qnpn13g2[area]
print @q.xbgr.xq72_u3.qnpn13g2[area]
print @q.xbgr.xq72_u4.qnpn13g2[area]
print @q.xbgr.xq72_u5.qnpn13g2[area]
print @q.xbgr.xq72_u6.qnpn13g2[area]
print @q.xbgr.xq72_u7.qnpn13g2[area]
print @q.xbgr.xq72_u8.qnpn13g2[area]
print @q.xbgr.xq72_u9.qnpn13g2[area]
print @q.xbgr.xq72_u10.qnpn13g2[area]
print @q.xbgr.xq72_u11.qnpn13g2[area]
print @q.xbgr.xq72_u12.qnpn13g2[area]
print @q.xbgr.xq72_u13.qnpn13g2[area]
print @q.xbgr.xq72_u14.qnpn13g2[area]
print @q.xbgr.xq72_u15.qnpn13g2[area]
print @q.xbgr.xq72_u16.qnpn13g2[area]
print @q.xbgr.xq72_u17.qnpn13g2[area]
print @q.xbgr.xq72_u18.qnpn13g2[area]
print @q.xbgr.xq72_u19.qnpn13g2[area]
print @q.xbgr.xq72_u20.qnpn13g2[area]
print @q.xbgr.xq72_u21.qnpn13g2[area]
print @q.xbgr.xq72_u22.qnpn13g2[area]
print @q.xbgr.xq72_u23.qnpn13g2[area]
print @q.xbgr.xq72_u24.qnpn13g2[area]
print @q.xbgr.xq73_u2.qnpn13g2[area]
print @q.xbgr.xq73_u3.qnpn13g2[area]
print @q.xbgr.xq73_u4.qnpn13g2[area]
print @q.xbgr.xq73_u5.qnpn13g2[area]
print @q.xbgr.xq73_u6.qnpn13g2[area]
print @q.xbgr.xq73_u7.qnpn13g2[area]
print @q.xbgr.xq73_u8.qnpn13g2[area]
print @q.xbgr.xq73_u9.qnpn13g2[area]
print @q.xbgr.xq73_u10.qnpn13g2[area]
print @q.xbgr.xq73_u11.qnpn13g2[area]
print @q.xbgr.xq73_u12.qnpn13g2[area]
print @q.xbgr.xq73_u13.qnpn13g2[area]
print @q.xbgr.xq73_u14.qnpn13g2[area]
print @q.xbgr.xq73_u15.qnpn13g2[area]
print @q.xbgr.xq73_u16.qnpn13g2[area]
print @q.xbgr.xq73_u17.qnpn13g2[area]
print @q.xbgr.xq73_u18.qnpn13g2[area]
print @q.xbgr.xq73_u19.qnpn13g2[area]
print @q.xbgr.xq73_u20.qnpn13g2[area]
print @q.xbgr.xq73_u21.qnpn13g2[area]
print @q.xbgr.xq73_u22.qnpn13g2[area]
print @q.xbgr.xq73_u23.qnpn13g2[area]
print @q.xbgr.xq73_u24.qnpn13g2[area]
print @q.xbgr.xq74_u2.qnpn13g2[area]
print @q.xbgr.xq74_u3.qnpn13g2[area]
print @q.xbgr.xq74_u4.qnpn13g2[area]
print @q.xbgr.xq74_u5.qnpn13g2[area]
print @q.xbgr.xq74_u6.qnpn13g2[area]
print @q.xbgr.xq74_u7.qnpn13g2[area]
print @q.xbgr.xq74_u8.qnpn13g2[area]
print @q.xbgr.xq74_u9.qnpn13g2[area]
print @q.xbgr.xq74_u10.qnpn13g2[area]
print @q.xbgr.xq74_u11.qnpn13g2[area]
print @q.xbgr.xq74_u12.qnpn13g2[area]
print @q.xbgr.xq74_u13.qnpn13g2[area]
print @q.xbgr.xq74_u14.qnpn13g2[area]
print @q.xbgr.xq74_u15.qnpn13g2[area]
print @q.xbgr.xq74_u16.qnpn13g2[area]
print @q.xbgr.xq74_u17.qnpn13g2[area]
print @q.xbgr.xq74_u18.qnpn13g2[area]
print @q.xbgr.xq74_u19.qnpn13g2[area]
print @q.xbgr.xq74_u20.qnpn13g2[area]
print @q.xbgr.xq74_u21.qnpn13g2[area]
print @q.xbgr.xq74_u22.qnpn13g2[area]
print @q.xbgr.xq74_u23.qnpn13g2[area]
print @q.xbgr.xq74_u24.qnpn13g2[area]
print @q.xbgr.xq75_u2.qnpn13g2[area]
print @q.xbgr.xq75_u3.qnpn13g2[area]
print @q.xbgr.xq75_u4.qnpn13g2[area]
print @q.xbgr.xq75_u5.qnpn13g2[area]
print @q.xbgr.xq75_u6.qnpn13g2[area]
print @q.xbgr.xq75_u7.qnpn13g2[area]
print @q.xbgr.xq75_u8.qnpn13g2[area]
print @q.xbgr.xq75_u9.qnpn13g2[area]
print @q.xbgr.xq75_u10.qnpn13g2[area]
print @q.xbgr.xq75_u11.qnpn13g2[area]
print @q.xbgr.xq75_u12.qnpn13g2[area]
print @q.xbgr.xq75_u13.qnpn13g2[area]
print @q.xbgr.xq75_u14.qnpn13g2[area]
print @q.xbgr.xq75_u15.qnpn13g2[area]
print @q.xbgr.xq75_u16.qnpn13g2[area]
print @q.xbgr.xq75_u17.qnpn13g2[area]
print @q.xbgr.xq75_u18.qnpn13g2[area]
print @q.xbgr.xq75_u19.qnpn13g2[area]
print @q.xbgr.xq75_u20.qnpn13g2[area]
print @q.xbgr.xq75_u21.qnpn13g2[area]
print @q.xbgr.xq75_u22.qnpn13g2[area]
print @q.xbgr.xq75_u23.qnpn13g2[area]
print @q.xbgr.xq75_u24.qnpn13g2[area]
print @q.xbgr.xq76_u2.qnpn13g2[area]
print @q.xbgr.xq76_u3.qnpn13g2[area]
print @q.xbgr.xq76_u4.qnpn13g2[area]
print @q.xbgr.xq76_u5.qnpn13g2[area]
print @q.xbgr.xq76_u6.qnpn13g2[area]
print @q.xbgr.xq76_u7.qnpn13g2[area]
print @q.xbgr.xq76_u8.qnpn13g2[area]
print @q.xbgr.xq76_u9.qnpn13g2[area]
print @q.xbgr.xq76_u10.qnpn13g2[area]
print @q.xbgr.xq76_u11.qnpn13g2[area]
print @q.xbgr.xq76_u12.qnpn13g2[area]
print @q.xbgr.xq76_u13.qnpn13g2[area]
print @q.xbgr.xq76_u14.qnpn13g2[area]
print @q.xbgr.xq76_u15.qnpn13g2[area]
print @q.xbgr.xq76_u16.qnpn13g2[area]
print @q.xbgr.xq76_u17.qnpn13g2[area]
print @q.xbgr.xq76_u18.qnpn13g2[area]
print @q.xbgr.xq76_u19.qnpn13g2[area]
print @q.xbgr.xq76_u20.qnpn13g2[area]
print @q.xbgr.xq76_u21.qnpn13g2[area]
print @q.xbgr.xq76_u22.qnpn13g2[area]
print @q.xbgr.xq76_u23.qnpn13g2[area]
print @q.xbgr.xq76_u24.qnpn13g2[area]
print @n.xbgr.xr77_u2.nr1[nsmm_rsh]
print @n.xbgr.xr77_u2.nr1[nsmm_w]
print @n.xbgr.xr77_u2.nr1[nsmm_l]
print @n.xbgr.xr77_u3.nr1[nsmm_rsh]
print @n.xbgr.xr77_u3.nr1[nsmm_w]
print @n.xbgr.xr77_u3.nr1[nsmm_l]
print @n.xbgr.xr77_u4.nr1[nsmm_rsh]
print @n.xbgr.xr77_u4.nr1[nsmm_w]
print @n.xbgr.xr77_u4.nr1[nsmm_l]
print @n.xbgr.xr77_u5.nr1[nsmm_rsh]
print @n.xbgr.xr77_u5.nr1[nsmm_w]
print @n.xbgr.xr77_u5.nr1[nsmm_l]
print @n.xbgr.xr77_u6.nr1[nsmm_rsh]
print @n.xbgr.xr77_u6.nr1[nsmm_w]
print @n.xbgr.xr77_u6.nr1[nsmm_l]
print @n.xbgr.xr77_u7.nr1[nsmm_rsh]
print @n.xbgr.xr77_u7.nr1[nsmm_w]
print @n.xbgr.xr77_u7.nr1[nsmm_l]
print @n.xbgr.xr77_u8.nr1[nsmm_rsh]
print @n.xbgr.xr77_u8.nr1[nsmm_w]
print @n.xbgr.xr77_u8.nr1[nsmm_l]
print @n.xbgr.xr77_u9.nr1[nsmm_rsh]
print @n.xbgr.xr77_u9.nr1[nsmm_w]
print @n.xbgr.xr77_u9.nr1[nsmm_l]
print @n.xbgr.xr77_u10.nr1[nsmm_rsh]
print @n.xbgr.xr77_u10.nr1[nsmm_w]
print @n.xbgr.xr77_u10.nr1[nsmm_l]
print @n.xbgr.xr77_u11.nr1[nsmm_rsh]
print @n.xbgr.xr77_u11.nr1[nsmm_w]
print @n.xbgr.xr77_u11.nr1[nsmm_l]
print @n.xbgr.xr77_u12.nr1[nsmm_rsh]
print @n.xbgr.xr77_u12.nr1[nsmm_w]
print @n.xbgr.xr77_u12.nr1[nsmm_l]
print @n.xbgr.xr77_u13.nr1[nsmm_rsh]
print @n.xbgr.xr77_u13.nr1[nsmm_w]
print @n.xbgr.xr77_u13.nr1[nsmm_l]
print @n.xbgr.xr77_u14.nr1[nsmm_rsh]
print @n.xbgr.xr77_u14.nr1[nsmm_w]
print @n.xbgr.xr77_u14.nr1[nsmm_l]
print @n.xbgr.xr77_u15.nr1[nsmm_rsh]
print @n.xbgr.xr77_u15.nr1[nsmm_w]
print @n.xbgr.xr77_u15.nr1[nsmm_l]
print @n.xbgr.xr77_u16.nr1[nsmm_rsh]
print @n.xbgr.xr77_u16.nr1[nsmm_w]
print @n.xbgr.xr77_u16.nr1[nsmm_l]
print @n.xbgr.xr77_u17.nr1[nsmm_rsh]
print @n.xbgr.xr77_u17.nr1[nsmm_w]
print @n.xbgr.xr77_u17.nr1[nsmm_l]
print @n.xbgr.xr77_u18.nr1[nsmm_rsh]
print @n.xbgr.xr77_u18.nr1[nsmm_w]
print @n.xbgr.xr77_u18.nr1[nsmm_l]
print @n.xbgr.xr77_u19.nr1[nsmm_rsh]
print @n.xbgr.xr77_u19.nr1[nsmm_w]
print @n.xbgr.xr77_u19.nr1[nsmm_l]
print @n.xbgr.xr77_u20.nr1[nsmm_rsh]
print @n.xbgr.xr77_u20.nr1[nsmm_w]
print @n.xbgr.xr77_u20.nr1[nsmm_l]
print @n.xbgr.xr77_u21.nr1[nsmm_rsh]
print @n.xbgr.xr77_u21.nr1[nsmm_w]
print @n.xbgr.xr77_u21.nr1[nsmm_l]
print @n.xbgr.xr77_u22.nr1[nsmm_rsh]
print @n.xbgr.xr77_u22.nr1[nsmm_w]
print @n.xbgr.xr77_u22.nr1[nsmm_l]
print @n.xbgr.xr77_u23.nr1[nsmm_rsh]
print @n.xbgr.xr77_u23.nr1[nsmm_w]
print @n.xbgr.xr77_u23.nr1[nsmm_l]
print @n.xbgr.xr77_u24.nr1[nsmm_rsh]
print @n.xbgr.xr77_u24.nr1[nsmm_w]
print @n.xbgr.xr77_u24.nr1[nsmm_l]
print @n.xbgr.xr78_u2.nr1[nsmm_rsh]
print @n.xbgr.xr78_u2.nr1[nsmm_w]
print @n.xbgr.xr78_u2.nr1[nsmm_l]
print @n.xbgr.xr78_u3.nr1[nsmm_rsh]
print @n.xbgr.xr78_u3.nr1[nsmm_w]
print @n.xbgr.xr78_u3.nr1[nsmm_l]
print @n.xbgr.xr78_u4.nr1[nsmm_rsh]
print @n.xbgr.xr78_u4.nr1[nsmm_w]
print @n.xbgr.xr78_u4.nr1[nsmm_l]
print @n.xbgr.xr78_u5.nr1[nsmm_rsh]
print @n.xbgr.xr78_u5.nr1[nsmm_w]
print @n.xbgr.xr78_u5.nr1[nsmm_l]
print @n.xbgr.xr78_u6.nr1[nsmm_rsh]
print @n.xbgr.xr78_u6.nr1[nsmm_w]
print @n.xbgr.xr78_u6.nr1[nsmm_l]
print @n.xbgr.xr78_u7.nr1[nsmm_rsh]
print @n.xbgr.xr78_u7.nr1[nsmm_w]
print @n.xbgr.xr78_u7.nr1[nsmm_l]
print @n.xbgr.xr78_u8.nr1[nsmm_rsh]
print @n.xbgr.xr78_u8.nr1[nsmm_w]
print @n.xbgr.xr78_u8.nr1[nsmm_l]
print @n.xbgr.xr78_u9.nr1[nsmm_rsh]
print @n.xbgr.xr78_u9.nr1[nsmm_w]
print @n.xbgr.xr78_u9.nr1[nsmm_l]
print @n.xbgr.xr78_u10.nr1[nsmm_rsh]
print @n.xbgr.xr78_u10.nr1[nsmm_w]
print @n.xbgr.xr78_u10.nr1[nsmm_l]
print @n.xbgr.xr78_u11.nr1[nsmm_rsh]
print @n.xbgr.xr78_u11.nr1[nsmm_w]
print @n.xbgr.xr78_u11.nr1[nsmm_l]
print @n.xbgr.xr78_u12.nr1[nsmm_rsh]
print @n.xbgr.xr78_u12.nr1[nsmm_w]
print @n.xbgr.xr78_u12.nr1[nsmm_l]
print @n.xbgr.xr78_u13.nr1[nsmm_rsh]
print @n.xbgr.xr78_u13.nr1[nsmm_w]
print @n.xbgr.xr78_u13.nr1[nsmm_l]
print @n.xbgr.xr78_u14.nr1[nsmm_rsh]
print @n.xbgr.xr78_u14.nr1[nsmm_w]
print @n.xbgr.xr78_u14.nr1[nsmm_l]
print @n.xbgr.xr78_u15.nr1[nsmm_rsh]
print @n.xbgr.xr78_u15.nr1[nsmm_w]
print @n.xbgr.xr78_u15.nr1[nsmm_l]
print @n.xbgr.xr78_u16.nr1[nsmm_rsh]
print @n.xbgr.xr78_u16.nr1[nsmm_w]
print @n.xbgr.xr78_u16.nr1[nsmm_l]
print @n.xbgr.xr78_u17.nr1[nsmm_rsh]
print @n.xbgr.xr78_u17.nr1[nsmm_w]
print @n.xbgr.xr78_u17.nr1[nsmm_l]
print @n.xbgr.xr78_u18.nr1[nsmm_rsh]
print @n.xbgr.xr78_u18.nr1[nsmm_w]
print @n.xbgr.xr78_u18.nr1[nsmm_l]
print @n.xbgr.xr78_u19.nr1[nsmm_rsh]
print @n.xbgr.xr78_u19.nr1[nsmm_w]
print @n.xbgr.xr78_u19.nr1[nsmm_l]
print @n.xbgr.xr78_u20.nr1[nsmm_rsh]
print @n.xbgr.xr78_u20.nr1[nsmm_w]
print @n.xbgr.xr78_u20.nr1[nsmm_l]
print @n.xbgr.xr78_u21.nr1[nsmm_rsh]
print @n.xbgr.xr78_u21.nr1[nsmm_w]
print @n.xbgr.xr78_u21.nr1[nsmm_l]
print @n.xbgr.xr78_u22.nr1[nsmm_rsh]
print @n.xbgr.xr78_u22.nr1[nsmm_w]
print @n.xbgr.xr78_u22.nr1[nsmm_l]
print @n.xbgr.xr78_u23.nr1[nsmm_rsh]
print @n.xbgr.xr78_u23.nr1[nsmm_w]
print @n.xbgr.xr78_u23.nr1[nsmm_l]
print @n.xbgr.xr78_u24.nr1[nsmm_rsh]
print @n.xbgr.xr78_u24.nr1[nsmm_w]
print @n.xbgr.xr78_u24.nr1[nsmm_l]
print @n.xbgr.xr79_u2.nr1[nsmm_rsh]
print @n.xbgr.xr79_u2.nr1[nsmm_w]
print @n.xbgr.xr79_u2.nr1[nsmm_l]
print @n.xbgr.xr79_u3.nr1[nsmm_rsh]
print @n.xbgr.xr79_u3.nr1[nsmm_w]
print @n.xbgr.xr79_u3.nr1[nsmm_l]
print @n.xbgr.xr79_u4.nr1[nsmm_rsh]
print @n.xbgr.xr79_u4.nr1[nsmm_w]
print @n.xbgr.xr79_u4.nr1[nsmm_l]
print @n.xbgr.xr79_u5.nr1[nsmm_rsh]
print @n.xbgr.xr79_u5.nr1[nsmm_w]
print @n.xbgr.xr79_u5.nr1[nsmm_l]
print @n.xbgr.xr79_u6.nr1[nsmm_rsh]
print @n.xbgr.xr79_u6.nr1[nsmm_w]
print @n.xbgr.xr79_u6.nr1[nsmm_l]
print @n.xbgr.xr79_u7.nr1[nsmm_rsh]
print @n.xbgr.xr79_u7.nr1[nsmm_w]
print @n.xbgr.xr79_u7.nr1[nsmm_l]
print @n.xbgr.xr79_u8.nr1[nsmm_rsh]
print @n.xbgr.xr79_u8.nr1[nsmm_w]
print @n.xbgr.xr79_u8.nr1[nsmm_l]
print @n.xbgr.xr79_u9.nr1[nsmm_rsh]
print @n.xbgr.xr79_u9.nr1[nsmm_w]
print @n.xbgr.xr79_u9.nr1[nsmm_l]
print @n.xbgr.xr79_u10.nr1[nsmm_rsh]
print @n.xbgr.xr79_u10.nr1[nsmm_w]
print @n.xbgr.xr79_u10.nr1[nsmm_l]
print @n.xbgr.xr79_u11.nr1[nsmm_rsh]
print @n.xbgr.xr79_u11.nr1[nsmm_w]
print @n.xbgr.xr79_u11.nr1[nsmm_l]
print @n.xbgr.xr79_u12.nr1[nsmm_rsh]
print @n.xbgr.xr79_u12.nr1[nsmm_w]
print @n.xbgr.xr79_u12.nr1[nsmm_l]
print @n.xbgr.xr79_u13.nr1[nsmm_rsh]
print @n.xbgr.xr79_u13.nr1[nsmm_w]
print @n.xbgr.xr79_u13.nr1[nsmm_l]
print @n.xbgr.xr79_u14.nr1[nsmm_rsh]
print @n.xbgr.xr79_u14.nr1[nsmm_w]
print @n.xbgr.xr79_u14.nr1[nsmm_l]
print @n.xbgr.xr79_u15.nr1[nsmm_rsh]
print @n.xbgr.xr79_u15.nr1[nsmm_w]
print @n.xbgr.xr79_u15.nr1[nsmm_l]
print @n.xbgr.xr79_u16.nr1[nsmm_rsh]
print @n.xbgr.xr79_u16.nr1[nsmm_w]
print @n.xbgr.xr79_u16.nr1[nsmm_l]
print @n.xbgr.xr79_u17.nr1[nsmm_rsh]
print @n.xbgr.xr79_u17.nr1[nsmm_w]
print @n.xbgr.xr79_u17.nr1[nsmm_l]
print @n.xbgr.xr79_u18.nr1[nsmm_rsh]
print @n.xbgr.xr79_u18.nr1[nsmm_w]
print @n.xbgr.xr79_u18.nr1[nsmm_l]
print @n.xbgr.xr79_u19.nr1[nsmm_rsh]
print @n.xbgr.xr79_u19.nr1[nsmm_w]
print @n.xbgr.xr79_u19.nr1[nsmm_l]
print @n.xbgr.xr79_u20.nr1[nsmm_rsh]
print @n.xbgr.xr79_u20.nr1[nsmm_w]
print @n.xbgr.xr79_u20.nr1[nsmm_l]
print @n.xbgr.xr79_u21.nr1[nsmm_rsh]
print @n.xbgr.xr79_u21.nr1[nsmm_w]
print @n.xbgr.xr79_u21.nr1[nsmm_l]
print @n.xbgr.xr79_u22.nr1[nsmm_rsh]
print @n.xbgr.xr79_u22.nr1[nsmm_w]
print @n.xbgr.xr79_u22.nr1[nsmm_l]
print @n.xbgr.xr79_u23.nr1[nsmm_rsh]
print @n.xbgr.xr79_u23.nr1[nsmm_w]
print @n.xbgr.xr79_u23.nr1[nsmm_l]
print @n.xbgr.xr79_u24.nr1[nsmm_rsh]
print @n.xbgr.xr79_u24.nr1[nsmm_w]
print @n.xbgr.xr79_u24.nr1[nsmm_l]
print @n.xbgr.xr80_u2.nr1[nsmm_rsh]
print @n.xbgr.xr80_u2.nr1[nsmm_w]
print @n.xbgr.xr80_u2.nr1[nsmm_l]
print @n.xbgr.xr80_u3.nr1[nsmm_rsh]
print @n.xbgr.xr80_u3.nr1[nsmm_w]
print @n.xbgr.xr80_u3.nr1[nsmm_l]
print @n.xbgr.xr80_u4.nr1[nsmm_rsh]
print @n.xbgr.xr80_u4.nr1[nsmm_w]
print @n.xbgr.xr80_u4.nr1[nsmm_l]
print @n.xbgr.xr80_u5.nr1[nsmm_rsh]
print @n.xbgr.xr80_u5.nr1[nsmm_w]
print @n.xbgr.xr80_u5.nr1[nsmm_l]
print @n.xbgr.xr80_u6.nr1[nsmm_rsh]
print @n.xbgr.xr80_u6.nr1[nsmm_w]
print @n.xbgr.xr80_u6.nr1[nsmm_l]
print @n.xbgr.xr80_u7.nr1[nsmm_rsh]
print @n.xbgr.xr80_u7.nr1[nsmm_w]
print @n.xbgr.xr80_u7.nr1[nsmm_l]
print @n.xbgr.xr80_u8.nr1[nsmm_rsh]
print @n.xbgr.xr80_u8.nr1[nsmm_w]
print @n.xbgr.xr80_u8.nr1[nsmm_l]
print @n.xbgr.xr80_u9.nr1[nsmm_rsh]
print @n.xbgr.xr80_u9.nr1[nsmm_w]
print @n.xbgr.xr80_u9.nr1[nsmm_l]
print @n.xbgr.xr80_u10.nr1[nsmm_rsh]
print @n.xbgr.xr80_u10.nr1[nsmm_w]
print @n.xbgr.xr80_u10.nr1[nsmm_l]
print @n.xbgr.xr80_u11.nr1[nsmm_rsh]
print @n.xbgr.xr80_u11.nr1[nsmm_w]
print @n.xbgr.xr80_u11.nr1[nsmm_l]
print @n.xbgr.xr80_u12.nr1[nsmm_rsh]
print @n.xbgr.xr80_u12.nr1[nsmm_w]
print @n.xbgr.xr80_u12.nr1[nsmm_l]
print @n.xbgr.xr80_u13.nr1[nsmm_rsh]
print @n.xbgr.xr80_u13.nr1[nsmm_w]
print @n.xbgr.xr80_u13.nr1[nsmm_l]
print @n.xbgr.xr80_u14.nr1[nsmm_rsh]
print @n.xbgr.xr80_u14.nr1[nsmm_w]
print @n.xbgr.xr80_u14.nr1[nsmm_l]
print @n.xbgr.xr80_u15.nr1[nsmm_rsh]
print @n.xbgr.xr80_u15.nr1[nsmm_w]
print @n.xbgr.xr80_u15.nr1[nsmm_l]
print @n.xbgr.xr80_u16.nr1[nsmm_rsh]
print @n.xbgr.xr80_u16.nr1[nsmm_w]
print @n.xbgr.xr80_u16.nr1[nsmm_l]
print @n.xbgr.xr80_u17.nr1[nsmm_rsh]
print @n.xbgr.xr80_u17.nr1[nsmm_w]
print @n.xbgr.xr80_u17.nr1[nsmm_l]
print @n.xbgr.xr80_u18.nr1[nsmm_rsh]
print @n.xbgr.xr80_u18.nr1[nsmm_w]
print @n.xbgr.xr80_u18.nr1[nsmm_l]
print @n.xbgr.xr80_u19.nr1[nsmm_rsh]
print @n.xbgr.xr80_u19.nr1[nsmm_w]
print @n.xbgr.xr80_u19.nr1[nsmm_l]
print @n.xbgr.xr80_u20.nr1[nsmm_rsh]
print @n.xbgr.xr80_u20.nr1[nsmm_w]
print @n.xbgr.xr80_u20.nr1[nsmm_l]
print @n.xbgr.xr80_u21.nr1[nsmm_rsh]
print @n.xbgr.xr80_u21.nr1[nsmm_w]
print @n.xbgr.xr80_u21.nr1[nsmm_l]
print @n.xbgr.xr80_u22.nr1[nsmm_rsh]
print @n.xbgr.xr80_u22.nr1[nsmm_w]
print @n.xbgr.xr80_u22.nr1[nsmm_l]
print @n.xbgr.xr80_u23.nr1[nsmm_rsh]
print @n.xbgr.xr80_u23.nr1[nsmm_w]
print @n.xbgr.xr80_u23.nr1[nsmm_l]
print @n.xbgr.xr80_u24.nr1[nsmm_rsh]
print @n.xbgr.xr80_u24.nr1[nsmm_w]
print @n.xbgr.xr80_u24.nr1[nsmm_l]
print @n.xbgr.xr81_u2.nr1[nsmm_rsh]
print @n.xbgr.xr81_u2.nr1[nsmm_w]
print @n.xbgr.xr81_u2.nr1[nsmm_l]
print @n.xbgr.xr81_u3.nr1[nsmm_rsh]
print @n.xbgr.xr81_u3.nr1[nsmm_w]
print @n.xbgr.xr81_u3.nr1[nsmm_l]
print @n.xbgr.xr81_u4.nr1[nsmm_rsh]
print @n.xbgr.xr81_u4.nr1[nsmm_w]
print @n.xbgr.xr81_u4.nr1[nsmm_l]
print @n.xbgr.xr81_u5.nr1[nsmm_rsh]
print @n.xbgr.xr81_u5.nr1[nsmm_w]
print @n.xbgr.xr81_u5.nr1[nsmm_l]
print @n.xbgr.xr81_u6.nr1[nsmm_rsh]
print @n.xbgr.xr81_u6.nr1[nsmm_w]
print @n.xbgr.xr81_u6.nr1[nsmm_l]
print @n.xbgr.xr81_u7.nr1[nsmm_rsh]
print @n.xbgr.xr81_u7.nr1[nsmm_w]
print @n.xbgr.xr81_u7.nr1[nsmm_l]
print @n.xbgr.xr81_u8.nr1[nsmm_rsh]
print @n.xbgr.xr81_u8.nr1[nsmm_w]
print @n.xbgr.xr81_u8.nr1[nsmm_l]
print @n.xbgr.xr81_u9.nr1[nsmm_rsh]
print @n.xbgr.xr81_u9.nr1[nsmm_w]
print @n.xbgr.xr81_u9.nr1[nsmm_l]
print @n.xbgr.xr81_u10.nr1[nsmm_rsh]
print @n.xbgr.xr81_u10.nr1[nsmm_w]
print @n.xbgr.xr81_u10.nr1[nsmm_l]
print @n.xbgr.xr81_u11.nr1[nsmm_rsh]
print @n.xbgr.xr81_u11.nr1[nsmm_w]
print @n.xbgr.xr81_u11.nr1[nsmm_l]
print @n.xbgr.xr81_u12.nr1[nsmm_rsh]
print @n.xbgr.xr81_u12.nr1[nsmm_w]
print @n.xbgr.xr81_u12.nr1[nsmm_l]
print @n.xbgr.xr81_u13.nr1[nsmm_rsh]
print @n.xbgr.xr81_u13.nr1[nsmm_w]
print @n.xbgr.xr81_u13.nr1[nsmm_l]
print @n.xbgr.xr81_u14.nr1[nsmm_rsh]
print @n.xbgr.xr81_u14.nr1[nsmm_w]
print @n.xbgr.xr81_u14.nr1[nsmm_l]
print @n.xbgr.xr81_u15.nr1[nsmm_rsh]
print @n.xbgr.xr81_u15.nr1[nsmm_w]
print @n.xbgr.xr81_u15.nr1[nsmm_l]
print @n.xbgr.xr81_u16.nr1[nsmm_rsh]
print @n.xbgr.xr81_u16.nr1[nsmm_w]
print @n.xbgr.xr81_u16.nr1[nsmm_l]
print @n.xbgr.xr81_u17.nr1[nsmm_rsh]
print @n.xbgr.xr81_u17.nr1[nsmm_w]
print @n.xbgr.xr81_u17.nr1[nsmm_l]
print @n.xbgr.xr81_u18.nr1[nsmm_rsh]
print @n.xbgr.xr81_u18.nr1[nsmm_w]
print @n.xbgr.xr81_u18.nr1[nsmm_l]
print @n.xbgr.xr81_u19.nr1[nsmm_rsh]
print @n.xbgr.xr81_u19.nr1[nsmm_w]
print @n.xbgr.xr81_u19.nr1[nsmm_l]
print @n.xbgr.xr81_u20.nr1[nsmm_rsh]
print @n.xbgr.xr81_u20.nr1[nsmm_w]
print @n.xbgr.xr81_u20.nr1[nsmm_l]
print @n.xbgr.xr81_u21.nr1[nsmm_rsh]
print @n.xbgr.xr81_u21.nr1[nsmm_w]
print @n.xbgr.xr81_u21.nr1[nsmm_l]
print @n.xbgr.xr81_u22.nr1[nsmm_rsh]
print @n.xbgr.xr81_u22.nr1[nsmm_w]
print @n.xbgr.xr81_u22.nr1[nsmm_l]
print @n.xbgr.xr81_u23.nr1[nsmm_rsh]
print @n.xbgr.xr81_u23.nr1[nsmm_w]
print @n.xbgr.xr81_u23.nr1[nsmm_l]
print @n.xbgr.xr81_u24.nr1[nsmm_rsh]
print @n.xbgr.xr81_u24.nr1[nsmm_w]
print @n.xbgr.xr81_u24.nr1[nsmm_l]
print @n.xbgr.xr82_u2.nr1[nsmm_rsh]
print @n.xbgr.xr82_u2.nr1[nsmm_w]
print @n.xbgr.xr82_u2.nr1[nsmm_l]
print @n.xbgr.xr82_u3.nr1[nsmm_rsh]
print @n.xbgr.xr82_u3.nr1[nsmm_w]
print @n.xbgr.xr82_u3.nr1[nsmm_l]
print @n.xbgr.xr82_u4.nr1[nsmm_rsh]
print @n.xbgr.xr82_u4.nr1[nsmm_w]
print @n.xbgr.xr82_u4.nr1[nsmm_l]
print @n.xbgr.xr82_u5.nr1[nsmm_rsh]
print @n.xbgr.xr82_u5.nr1[nsmm_w]
print @n.xbgr.xr82_u5.nr1[nsmm_l]
print @n.xbgr.xr82_u6.nr1[nsmm_rsh]
print @n.xbgr.xr82_u6.nr1[nsmm_w]
print @n.xbgr.xr82_u6.nr1[nsmm_l]
print @n.xbgr.xr82_u7.nr1[nsmm_rsh]
print @n.xbgr.xr82_u7.nr1[nsmm_w]
print @n.xbgr.xr82_u7.nr1[nsmm_l]
print @n.xbgr.xr82_u8.nr1[nsmm_rsh]
print @n.xbgr.xr82_u8.nr1[nsmm_w]
print @n.xbgr.xr82_u8.nr1[nsmm_l]
print @n.xbgr.xr82_u9.nr1[nsmm_rsh]
print @n.xbgr.xr82_u9.nr1[nsmm_w]
print @n.xbgr.xr82_u9.nr1[nsmm_l]
print @n.xbgr.xr82_u10.nr1[nsmm_rsh]
print @n.xbgr.xr82_u10.nr1[nsmm_w]
print @n.xbgr.xr82_u10.nr1[nsmm_l]
print @n.xbgr.xr82_u11.nr1[nsmm_rsh]
print @n.xbgr.xr82_u11.nr1[nsmm_w]
print @n.xbgr.xr82_u11.nr1[nsmm_l]
print @n.xbgr.xr82_u12.nr1[nsmm_rsh]
print @n.xbgr.xr82_u12.nr1[nsmm_w]
print @n.xbgr.xr82_u12.nr1[nsmm_l]
print @n.xbgr.xr82_u13.nr1[nsmm_rsh]
print @n.xbgr.xr82_u13.nr1[nsmm_w]
print @n.xbgr.xr82_u13.nr1[nsmm_l]
print @n.xbgr.xr82_u14.nr1[nsmm_rsh]
print @n.xbgr.xr82_u14.nr1[nsmm_w]
print @n.xbgr.xr82_u14.nr1[nsmm_l]
print @n.xbgr.xr82_u15.nr1[nsmm_rsh]
print @n.xbgr.xr82_u15.nr1[nsmm_w]
print @n.xbgr.xr82_u15.nr1[nsmm_l]
print @n.xbgr.xr82_u16.nr1[nsmm_rsh]
print @n.xbgr.xr82_u16.nr1[nsmm_w]
print @n.xbgr.xr82_u16.nr1[nsmm_l]
print @n.xbgr.xr82_u17.nr1[nsmm_rsh]
print @n.xbgr.xr82_u17.nr1[nsmm_w]
print @n.xbgr.xr82_u17.nr1[nsmm_l]
print @n.xbgr.xr82_u18.nr1[nsmm_rsh]
print @n.xbgr.xr82_u18.nr1[nsmm_w]
print @n.xbgr.xr82_u18.nr1[nsmm_l]
print @n.xbgr.xr82_u19.nr1[nsmm_rsh]
print @n.xbgr.xr82_u19.nr1[nsmm_w]
print @n.xbgr.xr82_u19.nr1[nsmm_l]
print @n.xbgr.xr82_u20.nr1[nsmm_rsh]
print @n.xbgr.xr82_u20.nr1[nsmm_w]
print @n.xbgr.xr82_u20.nr1[nsmm_l]
print @n.xbgr.xr82_u21.nr1[nsmm_rsh]
print @n.xbgr.xr82_u21.nr1[nsmm_w]
print @n.xbgr.xr82_u21.nr1[nsmm_l]
print @n.xbgr.xr82_u22.nr1[nsmm_rsh]
print @n.xbgr.xr82_u22.nr1[nsmm_w]
print @n.xbgr.xr82_u22.nr1[nsmm_l]
print @n.xbgr.xr82_u23.nr1[nsmm_rsh]
print @n.xbgr.xr82_u23.nr1[nsmm_w]
print @n.xbgr.xr82_u23.nr1[nsmm_l]
print @n.xbgr.xr82_u24.nr1[nsmm_rsh]
print @n.xbgr.xr82_u24.nr1[nsmm_w]
print @n.xbgr.xr82_u24.nr1[nsmm_l]
print @n.xbgr.xr83_u2.nr1[nsmm_rsh]
print @n.xbgr.xr83_u2.nr1[nsmm_w]
print @n.xbgr.xr83_u2.nr1[nsmm_l]
print @n.xbgr.xr83_u3.nr1[nsmm_rsh]
print @n.xbgr.xr83_u3.nr1[nsmm_w]
print @n.xbgr.xr83_u3.nr1[nsmm_l]
print @n.xbgr.xr83_u4.nr1[nsmm_rsh]
print @n.xbgr.xr83_u4.nr1[nsmm_w]
print @n.xbgr.xr83_u4.nr1[nsmm_l]
print @n.xbgr.xr83_u5.nr1[nsmm_rsh]
print @n.xbgr.xr83_u5.nr1[nsmm_w]
print @n.xbgr.xr83_u5.nr1[nsmm_l]
print @n.xbgr.xr83_u6.nr1[nsmm_rsh]
print @n.xbgr.xr83_u6.nr1[nsmm_w]
print @n.xbgr.xr83_u6.nr1[nsmm_l]
print @n.xbgr.xr83_u7.nr1[nsmm_rsh]
print @n.xbgr.xr83_u7.nr1[nsmm_w]
print @n.xbgr.xr83_u7.nr1[nsmm_l]
print @n.xbgr.xr83_u8.nr1[nsmm_rsh]
print @n.xbgr.xr83_u8.nr1[nsmm_w]
print @n.xbgr.xr83_u8.nr1[nsmm_l]
print @n.xbgr.xr83_u9.nr1[nsmm_rsh]
print @n.xbgr.xr83_u9.nr1[nsmm_w]
print @n.xbgr.xr83_u9.nr1[nsmm_l]
print @n.xbgr.xr83_u10.nr1[nsmm_rsh]
print @n.xbgr.xr83_u10.nr1[nsmm_w]
print @n.xbgr.xr83_u10.nr1[nsmm_l]
print @n.xbgr.xr83_u11.nr1[nsmm_rsh]
print @n.xbgr.xr83_u11.nr1[nsmm_w]
print @n.xbgr.xr83_u11.nr1[nsmm_l]
print @n.xbgr.xr83_u12.nr1[nsmm_rsh]
print @n.xbgr.xr83_u12.nr1[nsmm_w]
print @n.xbgr.xr83_u12.nr1[nsmm_l]
print @n.xbgr.xr83_u13.nr1[nsmm_rsh]
print @n.xbgr.xr83_u13.nr1[nsmm_w]
print @n.xbgr.xr83_u13.nr1[nsmm_l]
print @n.xbgr.xr83_u14.nr1[nsmm_rsh]
print @n.xbgr.xr83_u14.nr1[nsmm_w]
print @n.xbgr.xr83_u14.nr1[nsmm_l]
print @n.xbgr.xr83_u15.nr1[nsmm_rsh]
print @n.xbgr.xr83_u15.nr1[nsmm_w]
print @n.xbgr.xr83_u15.nr1[nsmm_l]
print @n.xbgr.xr83_u16.nr1[nsmm_rsh]
print @n.xbgr.xr83_u16.nr1[nsmm_w]
print @n.xbgr.xr83_u16.nr1[nsmm_l]
print @n.xbgr.xr83_u17.nr1[nsmm_rsh]
print @n.xbgr.xr83_u17.nr1[nsmm_w]
print @n.xbgr.xr83_u17.nr1[nsmm_l]
print @n.xbgr.xr83_u18.nr1[nsmm_rsh]
print @n.xbgr.xr83_u18.nr1[nsmm_w]
print @n.xbgr.xr83_u18.nr1[nsmm_l]
print @n.xbgr.xr83_u19.nr1[nsmm_rsh]
print @n.xbgr.xr83_u19.nr1[nsmm_w]
print @n.xbgr.xr83_u19.nr1[nsmm_l]
print @n.xbgr.xr83_u20.nr1[nsmm_rsh]
print @n.xbgr.xr83_u20.nr1[nsmm_w]
print @n.xbgr.xr83_u20.nr1[nsmm_l]
print @n.xbgr.xr83_u21.nr1[nsmm_rsh]
print @n.xbgr.xr83_u21.nr1[nsmm_w]
print @n.xbgr.xr83_u21.nr1[nsmm_l]
print @n.xbgr.xr83_u22.nr1[nsmm_rsh]
print @n.xbgr.xr83_u22.nr1[nsmm_w]
print @n.xbgr.xr83_u22.nr1[nsmm_l]
print @n.xbgr.xr83_u23.nr1[nsmm_rsh]
print @n.xbgr.xr83_u23.nr1[nsmm_w]
print @n.xbgr.xr83_u23.nr1[nsmm_l]
print @n.xbgr.xr83_u24.nr1[nsmm_rsh]
print @n.xbgr.xr83_u24.nr1[nsmm_w]
print @n.xbgr.xr83_u24.nr1[nsmm_l]
print @n.xbgr.xr84_u2.nr1[nsmm_rsh]
print @n.xbgr.xr84_u2.nr1[nsmm_w]
print @n.xbgr.xr84_u2.nr1[nsmm_l]
print @n.xbgr.xr84_u3.nr1[nsmm_rsh]
print @n.xbgr.xr84_u3.nr1[nsmm_w]
print @n.xbgr.xr84_u3.nr1[nsmm_l]
print @n.xbgr.xr84_u4.nr1[nsmm_rsh]
print @n.xbgr.xr84_u4.nr1[nsmm_w]
print @n.xbgr.xr84_u4.nr1[nsmm_l]
print @n.xbgr.xr84_u5.nr1[nsmm_rsh]
print @n.xbgr.xr84_u5.nr1[nsmm_w]
print @n.xbgr.xr84_u5.nr1[nsmm_l]
print @n.xbgr.xr84_u6.nr1[nsmm_rsh]
print @n.xbgr.xr84_u6.nr1[nsmm_w]
print @n.xbgr.xr84_u6.nr1[nsmm_l]
print @n.xbgr.xr84_u7.nr1[nsmm_rsh]
print @n.xbgr.xr84_u7.nr1[nsmm_w]
print @n.xbgr.xr84_u7.nr1[nsmm_l]
print @n.xbgr.xr84_u8.nr1[nsmm_rsh]
print @n.xbgr.xr84_u8.nr1[nsmm_w]
print @n.xbgr.xr84_u8.nr1[nsmm_l]
print @n.xbgr.xr84_u9.nr1[nsmm_rsh]
print @n.xbgr.xr84_u9.nr1[nsmm_w]
print @n.xbgr.xr84_u9.nr1[nsmm_l]
print @n.xbgr.xr84_u10.nr1[nsmm_rsh]
print @n.xbgr.xr84_u10.nr1[nsmm_w]
print @n.xbgr.xr84_u10.nr1[nsmm_l]
print @n.xbgr.xr84_u11.nr1[nsmm_rsh]
print @n.xbgr.xr84_u11.nr1[nsmm_w]
print @n.xbgr.xr84_u11.nr1[nsmm_l]
print @n.xbgr.xr84_u12.nr1[nsmm_rsh]
print @n.xbgr.xr84_u12.nr1[nsmm_w]
print @n.xbgr.xr84_u12.nr1[nsmm_l]
print @n.xbgr.xr84_u13.nr1[nsmm_rsh]
print @n.xbgr.xr84_u13.nr1[nsmm_w]
print @n.xbgr.xr84_u13.nr1[nsmm_l]
print @n.xbgr.xr84_u14.nr1[nsmm_rsh]
print @n.xbgr.xr84_u14.nr1[nsmm_w]
print @n.xbgr.xr84_u14.nr1[nsmm_l]
print @n.xbgr.xr84_u15.nr1[nsmm_rsh]
print @n.xbgr.xr84_u15.nr1[nsmm_w]
print @n.xbgr.xr84_u15.nr1[nsmm_l]
print @n.xbgr.xr84_u16.nr1[nsmm_rsh]
print @n.xbgr.xr84_u16.nr1[nsmm_w]
print @n.xbgr.xr84_u16.nr1[nsmm_l]
print @n.xbgr.xr84_u17.nr1[nsmm_rsh]
print @n.xbgr.xr84_u17.nr1[nsmm_w]
print @n.xbgr.xr84_u17.nr1[nsmm_l]
print @n.xbgr.xr84_u18.nr1[nsmm_rsh]
print @n.xbgr.xr84_u18.nr1[nsmm_w]
print @n.xbgr.xr84_u18.nr1[nsmm_l]
print @n.xbgr.xr84_u19.nr1[nsmm_rsh]
print @n.xbgr.xr84_u19.nr1[nsmm_w]
print @n.xbgr.xr84_u19.nr1[nsmm_l]
print @n.xbgr.xr84_u20.nr1[nsmm_rsh]
print @n.xbgr.xr84_u20.nr1[nsmm_w]
print @n.xbgr.xr84_u20.nr1[nsmm_l]
print @n.xbgr.xr84_u21.nr1[nsmm_rsh]
print @n.xbgr.xr84_u21.nr1[nsmm_w]
print @n.xbgr.xr84_u21.nr1[nsmm_l]
print @n.xbgr.xr84_u22.nr1[nsmm_rsh]
print @n.xbgr.xr84_u22.nr1[nsmm_w]
print @n.xbgr.xr84_u22.nr1[nsmm_l]
print @n.xbgr.xr84_u23.nr1[nsmm_rsh]
print @n.xbgr.xr84_u23.nr1[nsmm_w]
print @n.xbgr.xr84_u23.nr1[nsmm_l]
print @n.xbgr.xr84_u24.nr1[nsmm_rsh]
print @n.xbgr.xr84_u24.nr1[nsmm_w]
print @n.xbgr.xr84_u24.nr1[nsmm_l]
print @n.xbgr.xr85_u2.nr1[nsmm_rsh]
print @n.xbgr.xr85_u2.nr1[nsmm_w]
print @n.xbgr.xr85_u2.nr1[nsmm_l]
print @n.xbgr.xr85_u3.nr1[nsmm_rsh]
print @n.xbgr.xr85_u3.nr1[nsmm_w]
print @n.xbgr.xr85_u3.nr1[nsmm_l]
print @n.xbgr.xr85_u4.nr1[nsmm_rsh]
print @n.xbgr.xr85_u4.nr1[nsmm_w]
print @n.xbgr.xr85_u4.nr1[nsmm_l]
print @n.xbgr.xr85_u5.nr1[nsmm_rsh]
print @n.xbgr.xr85_u5.nr1[nsmm_w]
print @n.xbgr.xr85_u5.nr1[nsmm_l]
print @n.xbgr.xr85_u6.nr1[nsmm_rsh]
print @n.xbgr.xr85_u6.nr1[nsmm_w]
print @n.xbgr.xr85_u6.nr1[nsmm_l]
print @n.xbgr.xr85_u7.nr1[nsmm_rsh]
print @n.xbgr.xr85_u7.nr1[nsmm_w]
print @n.xbgr.xr85_u7.nr1[nsmm_l]
print @n.xbgr.xr85_u8.nr1[nsmm_rsh]
print @n.xbgr.xr85_u8.nr1[nsmm_w]
print @n.xbgr.xr85_u8.nr1[nsmm_l]
print @n.xbgr.xr85_u9.nr1[nsmm_rsh]
print @n.xbgr.xr85_u9.nr1[nsmm_w]
print @n.xbgr.xr85_u9.nr1[nsmm_l]
print @n.xbgr.xr85_u10.nr1[nsmm_rsh]
print @n.xbgr.xr85_u10.nr1[nsmm_w]
print @n.xbgr.xr85_u10.nr1[nsmm_l]
print @n.xbgr.xr85_u11.nr1[nsmm_rsh]
print @n.xbgr.xr85_u11.nr1[nsmm_w]
print @n.xbgr.xr85_u11.nr1[nsmm_l]
print @n.xbgr.xr85_u12.nr1[nsmm_rsh]
print @n.xbgr.xr85_u12.nr1[nsmm_w]
print @n.xbgr.xr85_u12.nr1[nsmm_l]
print @n.xbgr.xr85_u13.nr1[nsmm_rsh]
print @n.xbgr.xr85_u13.nr1[nsmm_w]
print @n.xbgr.xr85_u13.nr1[nsmm_l]
print @n.xbgr.xr85_u14.nr1[nsmm_rsh]
print @n.xbgr.xr85_u14.nr1[nsmm_w]
print @n.xbgr.xr85_u14.nr1[nsmm_l]
print @n.xbgr.xr85_u15.nr1[nsmm_rsh]
print @n.xbgr.xr85_u15.nr1[nsmm_w]
print @n.xbgr.xr85_u15.nr1[nsmm_l]
print @n.xbgr.xr85_u16.nr1[nsmm_rsh]
print @n.xbgr.xr85_u16.nr1[nsmm_w]
print @n.xbgr.xr85_u16.nr1[nsmm_l]
print @n.xbgr.xr85_u17.nr1[nsmm_rsh]
print @n.xbgr.xr85_u17.nr1[nsmm_w]
print @n.xbgr.xr85_u17.nr1[nsmm_l]
print @n.xbgr.xr85_u18.nr1[nsmm_rsh]
print @n.xbgr.xr85_u18.nr1[nsmm_w]
print @n.xbgr.xr85_u18.nr1[nsmm_l]
print @n.xbgr.xr85_u19.nr1[nsmm_rsh]
print @n.xbgr.xr85_u19.nr1[nsmm_w]
print @n.xbgr.xr85_u19.nr1[nsmm_l]
print @n.xbgr.xr85_u20.nr1[nsmm_rsh]
print @n.xbgr.xr85_u20.nr1[nsmm_w]
print @n.xbgr.xr85_u20.nr1[nsmm_l]
print @n.xbgr.xr85_u21.nr1[nsmm_rsh]
print @n.xbgr.xr85_u21.nr1[nsmm_w]
print @n.xbgr.xr85_u21.nr1[nsmm_l]
print @n.xbgr.xr85_u22.nr1[nsmm_rsh]
print @n.xbgr.xr85_u22.nr1[nsmm_w]
print @n.xbgr.xr85_u22.nr1[nsmm_l]
print @n.xbgr.xr85_u23.nr1[nsmm_rsh]
print @n.xbgr.xr85_u23.nr1[nsmm_w]
print @n.xbgr.xr85_u23.nr1[nsmm_l]
print @n.xbgr.xr85_u24.nr1[nsmm_rsh]
print @n.xbgr.xr85_u24.nr1[nsmm_w]
print @n.xbgr.xr85_u24.nr1[nsmm_l]
print @n.xbgr.xr86_u2.nr1[nsmm_rsh]
print @n.xbgr.xr86_u2.nr1[nsmm_w]
print @n.xbgr.xr86_u2.nr1[nsmm_l]
print @n.xbgr.xr86_u3.nr1[nsmm_rsh]
print @n.xbgr.xr86_u3.nr1[nsmm_w]
print @n.xbgr.xr86_u3.nr1[nsmm_l]
print @n.xbgr.xr86_u4.nr1[nsmm_rsh]
print @n.xbgr.xr86_u4.nr1[nsmm_w]
print @n.xbgr.xr86_u4.nr1[nsmm_l]
print @n.xbgr.xr86_u5.nr1[nsmm_rsh]
print @n.xbgr.xr86_u5.nr1[nsmm_w]
print @n.xbgr.xr86_u5.nr1[nsmm_l]
print @n.xbgr.xr86_u6.nr1[nsmm_rsh]
print @n.xbgr.xr86_u6.nr1[nsmm_w]
print @n.xbgr.xr86_u6.nr1[nsmm_l]
print @n.xbgr.xr86_u7.nr1[nsmm_rsh]
print @n.xbgr.xr86_u7.nr1[nsmm_w]
print @n.xbgr.xr86_u7.nr1[nsmm_l]
print @n.xbgr.xr86_u8.nr1[nsmm_rsh]
print @n.xbgr.xr86_u8.nr1[nsmm_w]
print @n.xbgr.xr86_u8.nr1[nsmm_l]
print @n.xbgr.xr86_u9.nr1[nsmm_rsh]
print @n.xbgr.xr86_u9.nr1[nsmm_w]
print @n.xbgr.xr86_u9.nr1[nsmm_l]
print @n.xbgr.xr86_u10.nr1[nsmm_rsh]
print @n.xbgr.xr86_u10.nr1[nsmm_w]
print @n.xbgr.xr86_u10.nr1[nsmm_l]
print @n.xbgr.xr86_u11.nr1[nsmm_rsh]
print @n.xbgr.xr86_u11.nr1[nsmm_w]
print @n.xbgr.xr86_u11.nr1[nsmm_l]
print @n.xbgr.xr86_u12.nr1[nsmm_rsh]
print @n.xbgr.xr86_u12.nr1[nsmm_w]
print @n.xbgr.xr86_u12.nr1[nsmm_l]
print @n.xbgr.xr86_u13.nr1[nsmm_rsh]
print @n.xbgr.xr86_u13.nr1[nsmm_w]
print @n.xbgr.xr86_u13.nr1[nsmm_l]
print @n.xbgr.xr86_u14.nr1[nsmm_rsh]
print @n.xbgr.xr86_u14.nr1[nsmm_w]
print @n.xbgr.xr86_u14.nr1[nsmm_l]
print @n.xbgr.xr86_u15.nr1[nsmm_rsh]
print @n.xbgr.xr86_u15.nr1[nsmm_w]
print @n.xbgr.xr86_u15.nr1[nsmm_l]
print @n.xbgr.xr86_u16.nr1[nsmm_rsh]
print @n.xbgr.xr86_u16.nr1[nsmm_w]
print @n.xbgr.xr86_u16.nr1[nsmm_l]
print @n.xbgr.xr86_u17.nr1[nsmm_rsh]
print @n.xbgr.xr86_u17.nr1[nsmm_w]
print @n.xbgr.xr86_u17.nr1[nsmm_l]
print @n.xbgr.xr86_u18.nr1[nsmm_rsh]
print @n.xbgr.xr86_u18.nr1[nsmm_w]
print @n.xbgr.xr86_u18.nr1[nsmm_l]
print @n.xbgr.xr86_u19.nr1[nsmm_rsh]
print @n.xbgr.xr86_u19.nr1[nsmm_w]
print @n.xbgr.xr86_u19.nr1[nsmm_l]
print @n.xbgr.xr86_u20.nr1[nsmm_rsh]
print @n.xbgr.xr86_u20.nr1[nsmm_w]
print @n.xbgr.xr86_u20.nr1[nsmm_l]
print @n.xbgr.xr86_u21.nr1[nsmm_rsh]
print @n.xbgr.xr86_u21.nr1[nsmm_w]
print @n.xbgr.xr86_u21.nr1[nsmm_l]
print @n.xbgr.xr86_u22.nr1[nsmm_rsh]
print @n.xbgr.xr86_u22.nr1[nsmm_w]
print @n.xbgr.xr86_u22.nr1[nsmm_l]
print @n.xbgr.xr86_u23.nr1[nsmm_rsh]
print @n.xbgr.xr86_u23.nr1[nsmm_w]
print @n.xbgr.xr86_u23.nr1[nsmm_l]
print @n.xbgr.xr86_u24.nr1[nsmm_rsh]
print @n.xbgr.xr86_u24.nr1[nsmm_w]
print @n.xbgr.xr86_u24.nr1[nsmm_l]
set numdgt=17
echo METALLIC_POINT_VOLTAGES_BEGIN
print v(xbgr.mr_n60826720)
print v(xbgr.vd2)
print v(xbgr.mr_n60968624)
print v(xbgr.c2)
print v(xbgr.mr_n61152304)
print v(xbgr.mr_n61258160)
print v(xbgr.mr_n61393376)
print v(xbgr.mr_n61502576)
print v(xbgr.mr_n61628640)
print v(xbgr.mr_n61769856)
print v(xbgr.mr_n61955648)
print v(xbgr.mr_n62082928)
print v(xbgr.mr_n62232608)
print v(xbgr.mr_n62408320)
print v(xbgr.mr_n62536112)
print v(xbgr.mr_n62718240)
print v(xbgr.mr_n62817744)
print v(xbgr.mr_n62888352)
print v(xbgr.mr_n60833216)
print v(xbgr.mr_n60896336)
print v(xbgr.mr_n60932096)
print v(xbgr.mr_n61038256)
print v(xbgr.mr_n61155440)
print v(xbgr.mr_n61259120)
print v(xbgr.mr_n61365728)
print v(xbgr.mr_n61510352)
print v(xbgr.mr_n61626384)
print v(xbgr.mr_n61781776)
print v(xbgr.mr_n61769184)
print v(xbgr.mr_n61958784)
print v(xbgr.mr_n62086320)
print v(xbgr.mr_n62233504)
print v(xbgr.mr_n62363248)
print v(xbgr.mr_n62508400)
print v(xbgr.mr_n62721472)
print v(xbgr.mr_n62843056)
print v(xbgr.mr_n63023584)
print v(xbgr.mr_n60827008)
print v(xbgr.mr_n60030416)
print v(xbgr.b1b)
print v(xbgr.mr_n60995968)
print v(xbgr.mr_n61112240)
print v(xbgr.mr_n61206864)
print v(xbgr.mr_n61241504)
print v(xbgr.mr_n61449280)
print v(xbgr.mr_n61576528)
print v(xbgr.mr_n61918720)
print v(xbgr.mr_n62043312)
print v(xbgr.mr_n62177984)
print v(xbgr.mr_n62289968)
print v(xbgr.mr_n62472336)
print v(xbgr.mr_n62643888)
print v(xbgr.mr_n62752544)
print v(xbgr.mr_n63020688)
print v(xbgr.mr_n60859696)
print v(xbgr.mr_n59984192)
print v(xbgr.mr_n60934032)
print v(xbgr.mr_n60136096)
print v(xbgr.mr_n61198592)
print v(xbgr.mr_n61323536)
print v(xbgr.mr_n61306832)
print v(xbgr.mr_n61554000)
print v(xbgr.mr_n61626272)
print v(xbgr.mr_n61674640)
print v(xbgr.mr_n61887216)
print v(xbgr.mr_n62020640)
print v(xbgr.mr_n62236400)
print v(xbgr.mr_n62274992)
print v(xbgr.mr_n62588336)
print v(xbgr.mr_n62639856)
print v(xbgr.mr_n62842320)
print v(xbgr.mr_n63022736)
print v(xbgr.mr_n60003664)
print v(xbgr.mr_n60074912)
print v(xbgr.n_13)
print v(xbgr.n_24)
print v(xbgr.mr_n60091872)
print v(xbgr.mr_n60079136)
print v(xbgr.n_14)
print v(xbgr.mr_n60701008)
print v(xbgr.mr_n60828976)
print v(xbgr.mr_n60892528)
print v(xbgr.mr_n60963104)
print v(xbgr.mr_n61067328)
print v(xbgr.mr_n61155552)
print v(xbgr.mr_n61236960)
print v(xbgr.mr_n61418752)
print v(xbgr.vd1)
print v(xbgr.mr_n61639152)
print v(xbgr.mr_n61645600)
print v(xbgr.mr_n61956608)
print v(xbgr.mr_n62083888)
print v(xbgr.mr_n62240192)
print v(xbgr.mr_n62395680)
print v(xbgr.mr_n62589120)
print v(xbgr.mr_n62720608)
print v(xbgr.mr_n62841328)
print v(xbgr.mr_n63021360)
print v(xbgr.mr_n60835792)
print v(xbgr.mr_n60895120)
print v(xbgr.mr_n60935120)
print v(xbgr.mr_n61064032)
print v(xbgr.mr_n61159328)
print v(xbgr.mr_n61262736)
print v(xbgr.mr_n61369344)
print v(xbgr.mr_n61516928)
print v(xbgr.mr_n61626496)
print v(xbgr.mr_n61773024)
print v(xbgr.mr_n61770528)
print v(xbgr.mr_n61968512)
print v(xbgr.mr_n62094512)
print v(xbgr.mr_n62237296)
print v(xbgr.mr_n62367360)
print v(xbgr.mr_n62505456)
print v(xbgr.mr_n62723536)
print v(xbgr.mr_n62845120)
print v(xbgr.mr_n63025904)
print v(xbgr.mr_n60819360)
print v(xbgr.mr_n60914816)
print v(xbgr.mr_n60023904)
print v(xbgr.mr_n61024368)
print v(xbgr.mr_n61113632)
print v(xbgr.mr_n61207136)
print v(xbgr.mr_n61307904)
print v(xbgr.mr_n61505824)
print v(xbgr.mr_n61578032)
print v(xbgr.mr_n61920112)
print v(xbgr.mr_n62044704)
print v(xbgr.mr_n62179376)
print v(xbgr.mr_n62343088)
print v(xbgr.mr_n62473792)
print v(xbgr.mr_n62644624)
print v(xbgr.mr_n62754384)
print v(xbgr.mr_n63021024)
print v(xbgr.mr_n60094672)
print v(xbgr.mr_n60360288)
print v(xbgr.mr_n60589264)
print v(xbgr.n_26)
print v(xbgr.mr_n60094208)
print v(xbgr.mr_n60360944)
print v(xbgr.n_15)
print v(xbgr.mr_n60702448)
print v(xbgr.mr_n60866976)
print v(xbgr.mr_n59996320)
print v(xbgr.mr_n60977712)
print v(xbgr.mr_n61093648)
print v(xbgr.mr_n61199392)
print v(xbgr.mr_n61324176)
print v(xbgr.mr_n61419984)
print v(xbgr.mr_n61554640)
print v(xbgr.mr_n61654304)
print v(xbgr.mr_n61770192)
print v(xbgr.mr_n61958896)
print v(xbgr.mr_n62083120)
print v(xbgr.mr_n62282944)
print v(xbgr.mr_n62388320)
print v(xbgr.mr_n62590272)
print v(xbgr.mr_n62717568)
print v(xbgr.mr_n62842944)
print v(xbgr.mr_n63023472)
print v(xbgr.mr_n60095600)
print v(xbgr.mr_n60357120)
print v(xbgr.mr_n60590192)
print v(xbgr.n_27)
print v(xbgr.mr_n60003776)
print v(xbgr.mr_n60362128)
print v(xbgr.n_16)
print v(xbgr.mr_n60703888)
print v(xbgr.mr_n60096528)
print v(xbgr.mr_n60362720)
print v(xbgr.mr_n60590656)
print v(xbgr.n_21)
print v(xbgr.mr_n60827392)
print v(xbgr.mr_n60028592)
print v(xbgr.mr_n60977280)
print v(xbgr.mr_n61067440)
print v(xbgr.mr_n61098928)
print v(xbgr.mr_n61285184)
print v(xbgr.mr_n61421168)
print v(xbgr.mr_n61433936)
print v(xbgr.mr_n61637696)
print v(xbgr.mr_n61956096)
print v(xbgr.mr_n62086432)
print v(xbgr.mr_n61727216)
print v(xbgr.mr_n62395904)
print v(xbgr.mr_n62591360)
print v(xbgr.mr_n62721248)
print v(xbgr.mr_n62843168)
print v(xbgr.mr_n63023696)
print v(xbgr.mr_n60096064)
print v(xbgr.mr_n60304976)
print v(xbgr.mr_n60838976)
print v(xbgr.mr_n60897952)
print v(xbgr.mr_n60938144)
print v(xbgr.mr_n61067552)
print v(xbgr.mr_n61152752)
print v(xbgr.mr_n61266784)
print v(xbgr.mr_n61373328)
print v(xbgr.mr_n61520880)
print v(xbgr.mr_n61632512)
print v(xbgr.mr_n61970576)
print v(xbgr.mr_n62096576)
print v(xbgr.mr_n62241088)
print v(xbgr.mr_n62370256)
print v(xbgr.mr_n62512192)
print v(xbgr.mr_n62725600)
print v(xbgr.mr_n62847184)
print v(xbgr.mr_n63028224)
print v(xbgr.mr_n60832384)
print v(xbgr.mr_n60894928)
print v(xbgr.mr_n60666448)
print v(xbgr.mr_n61025440)
print v(xbgr.mr_n61115024)
print v(xbgr.mr_n61207744)
print v(xbgr.mr_n61358192)
print v(xbgr.mr_n61503536)
print v(xbgr.mr_n61581968)
print v(xbgr.mr_n61919648)
print v(xbgr.mr_n62046096)
print v(xbgr.mr_n62180768)
print v(xbgr.mr_n62344864)
print v(xbgr.mr_n62475568)
print v(xbgr.mr_n62645200)
print v(xbgr.mr_n62786592)
print v(xbgr.mr_n63023248)
print v(xbgr.mr_n60097456)
print v(xbgr.mr_n60305888)
print v(xbgr.n_8)
print v(xbgr.vbe3)
print v(xbgr.mr_n60867856)
print v(xbgr.mr_n60342384)
print v(xbgr.mr_n60976848)
print v(xbgr.mr_n61094368)
print v(xbgr.mr_n61200192)
print v(xbgr.mr_n61324448)
print v(xbgr.mr_n61421840)
print v(xbgr.mr_n61555456)
print v(xbgr.mr_n61655184)
print v(xbgr.mr_n61920576)
print v(xbgr.mr_n62083376)
print v(xbgr.mr_n62283744)
print v(xbgr.mr_n62413104)
print v(xbgr.mr_n62591872)
print v(xbgr.mr_n62721360)
print v(xbgr.mr_n62845008)
print v(xbgr.mr_n63025792)
print v(xbgr.mr_n60096992)
print v(xbgr.mr_n60036896)
print v(xbgr.mr_n60432624)
print v(xbgr.mr_n60750048)
print v(xbgr.mr_n60098384)
print v(xbgr.mr_n60366864)
print v(xbgr.mr_n60441648)
print v(xbgr.n_37)
print v(xbgr.mr_n60097920)
print v(xbgr.mr_n60368640)
print v(xbgr.mr_n60442048)
print v(xbgr.mr_n60751232)
print v(xbgr.n_6)
print v(xbgr.vb2)
print v(xbgr.n_2)
print v(xbgr.mr_n60751824)
print v(xbgr.mr_n60833328)
print v(xbgr.mr_n60316080)
print v(xbgr.mr_n60950352)
print v(xbgr.mr_n61058016)
print v(xbgr.mr_n61163200)
print v(xbgr.mr_n61283344)
print v(xbgr.mr_n61422352)
print v(xbgr.mr_n61502768)
print v(xbgr.mr_n61655008)
print v(xbgr.mr_n61889232)
print v(xbgr.mr_n62094624)
print v(xbgr.mr_n62270656)
print v(xbgr.mr_n62406800)
print v(xbgr.mr_n62593200)
print v(xbgr.mr_n62641936)
print v(xbgr.mr_n62845232)
print v(xbgr.mr_n63026016)
print v(xbgr.mr_n60841552)
print v(xbgr.mr_n60900912)
print v(xbgr.mr_n60941168)
print v(xbgr.mr_n61070096)
print v(xbgr.mr_n61166624)
print v(xbgr.mr_n61272304)
print v(xbgr.mr_n61378656)
print v(xbgr.mr_n61523712)
print v(xbgr.mr_n61636368)
print v(xbgr.mr_n61972640)
print v(xbgr.mr_n62098640)
print v(xbgr.mr_n62244880)
print v(xbgr.mr_n62374048)
print v(xbgr.mr_n62517712)
print v(xbgr.mr_n62727664)
print v(xbgr.mr_n62849248)
print v(xbgr.mr_n63030544)
print v(xbgr.mr_n60200896)
print v(xbgr.mr_n60235792)
print v(xbgr.mr_n60442848)
print v(xbgr.mr_n60752416)
print v(xbgr.mr_n60836656)
print v(xbgr.mr_n60889904)
print v(xbgr.mr_n60697440)
print v(xbgr.mr_n61026832)
print v(xbgr.mr_n61116416)
print v(xbgr.mr_n61221872)
print v(xbgr.mr_n61359344)
print v(xbgr.mr_n61510464)
print v(xbgr.mr_n61583360)
print v(xbgr.mr_n61919184)
print v(xbgr.mr_n62047808)
print v(xbgr.mr_n62182480)
print v(xbgr.mr_n62346640)
print v(xbgr.mr_n62477344)
print v(xbgr.mr_n62646016)
print v(xbgr.mr_n62787984)
print v(xbgr.mr_n63023360)
print v(xbgr.mr_n60201632)
print v(xbgr.mr_n60236384)
print v(xbgr.n_7)
print v(xbgr.n_36)
print v(xbgr.mr_n60868816)
print v(xbgr.mr_n60671088)
print v(xbgr.mr_n60980048)
print v(xbgr.mr_n61095328)
print v(xbgr.mr_n61200992)
print v(xbgr.mr_n61324720)
print v(xbgr.mr_n61423696)
print v(xbgr.mr_n61556912)
print v(xbgr.mr_n61655984)
print v(xbgr.mr_n61956352)
print v(xbgr.mr_n62096464)
print v(xbgr.mr_n62284544)
print v(xbgr.mr_n62413904)
print v(xbgr.mr_n62593696)
print v(xbgr.mr_n62725488)
print v(xbgr.mr_n62847072)
print v(xbgr.mr_n63028112)
print v(xbgr.mr_n60202368)
print v(xbgr.mr_n60236976)
print v(xbgr.mr_n60441248)
print v(xbgr.mr_n60753600)
print v(xbgr.mr_n60203104)
print v(xbgr.mr_n60237568)
print v(xbgr.mr_n60436176)
print v(xbgr.mr_n60605200)
print v(xbgr.mr_n60203840)
print v(xbgr.mr_n60238160)
print v(xbgr.mr_n60427888)
print v(xbgr.mr_n60754720)
print v(xbgr.mr_n60204576)
print v(xbgr.mr_n60238752)
print v(xbgr.mr_n60440320)
print v(xbgr.mr_n60755376)
print v(xbgr.mr_n60835904)
print v(xbgr.mr_n60317296)
print v(xbgr.mr_n60980816)
print v(xbgr.mr_n61092912)
print v(xbgr.mr_n61159440)
print v(xbgr.mr_n61292272)
print v(xbgr.mr_n61424208)
print v(xbgr.mr_n61520992)
print v(xbgr.mr_n61640992)
print v(xbgr.mr_n61968624)
print v(xbgr.mr_n62096688)
print v(xbgr.mr_n62262720)
print v(xbgr.mr_n62372928)
print v(xbgr.mr_n62594208)
print v(xbgr.mr_n62723648)
print v(xbgr.mr_n62818336)
print v(xbgr.mr_n63028336)
print v(xbgr.mr_n60844736)
print v(xbgr.mr_n60904704)
print v(xbgr.mr_n60944192)
print v(xbgr.mr_n61074080)
print v(xbgr.mr_n61161872)
print v(xbgr.mr_n61277824)
print v(xbgr.mr_n61384176)
print v(xbgr.mr_n61527792)
print v(xbgr.mr_n61635040)
print v(xbgr.mr_n61974704)
print v(xbgr.mr_n62100704)
print v(xbgr.mr_n62248672)
print v(xbgr.mr_n62377840)
print v(xbgr.mr_n62523232)
print v(xbgr.mr_n62729728)
print v(xbgr.mr_n62851312)
print v(xbgr.mr_n63032864)
print v(xbgr.mr_n60838144)
print v(xbgr.mr_n60336752)
print v(xbgr.mr_n60916016)
print v(xbgr.mr_n61028224)
print v(xbgr.mr_n61117808)
print v(xbgr.mr_n61224240)
print v(xbgr.mr_n61360736)
print v(xbgr.mr_n61503280)
print v(xbgr.mr_n61584752)
print v(xbgr.mr_n61968400)
print v(xbgr.mr_n62049584)
print v(xbgr.mr_n62184256)
print v(xbgr.mr_n62348416)
print v(xbgr.mr_n62479120)
print v(xbgr.mr_n62646832)
print v(xbgr.mr_n62789568)
print v(xbgr.mr_n63025680)
print v(xbgr.mr_n60205088)
print v(xbgr.mr_n60239344)
print v(xbgr.mr_n60426032)
print v(xbgr.mr_n60756560)
print v(xbgr.mr_n60205632)
print v(xbgr.mr_n60058016)
print v(xbgr.n_11)
print v(xbgr.mr_n60755968)
print v(xbgr.mr_n60869616)
print v(xbgr.mr_n60654672)
print v(xbgr.mr_n60981424)
print v(xbgr.mr_n61096528)
print v(xbgr.mr_n61201792)
print v(xbgr.mr_n61324992)
print v(xbgr.mr_n61425552)
print v(xbgr.mr_n61557792)
print v(xbgr.mr_n61656784)
print v(xbgr.mr_n61976320)
print v(xbgr.mr_n62011296)
print v(xbgr.mr_n62285344)
print v(xbgr.mr_n62414704)
print v(xbgr.mr_n62595440)
print v(xbgr.mr_n62727552)
print v(xbgr.mr_n62819520)
print v(xbgr.mr_n63028000)
print v(xbgr.mr_n60206128)
print v(xbgr.mr_n60069280)
print v(xbgr.mr_n60521984)
print v(xbgr.mr_n60757152)
print v(xbgr.mr_n60207184)
print v(xbgr.mr_n60080544)
print v(xbgr.mr_n60476432)
print v(xbgr.mr_n60704496)
print v(xbgr.mr_n60207456)
print v(xbgr.mr_n59989616)
print v(xbgr.mr_n60523168)
print v(xbgr.mr_n60758256)
print v(xbgr.mr_n60842416)
print v(xbgr.mr_n60056880)
print v(xbgr.mr_n60982272)
print v(xbgr.mr_n61059456)
print v(xbgr.mr_n61170496)
print v(xbgr.mr_n61293072)
print v(xbgr.mr_n61391536)
print v(xbgr.mr_n61503024)
print v(xbgr.mr_n61653792)
print v(xbgr.mr_n61972528)
print v(xbgr.mr_n62083632)
print v(xbgr.mr_n62268528)
print v(xbgr.mr_n62414528)
print v(xbgr.mr_n62596176)
print v(xbgr.mr_n62723424)
print v(xbgr.mr_n62818928)
print v(xbgr.mr_n62892704)
print v(xbgr.n_9)
print v(xbgr.mr_n60067872)
print v(xbgr.mr_n60523760)
print v(xbgr.mr_n60758928)
print v(xbgr.mr_n60847312)
print v(xbgr.mr_n60908496)
print v(xbgr.mr_n60947216)
print v(xbgr.mr_n61078064)
print v(xbgr.mr_n61173920)
print v(xbgr.mr_n61281504)
print v(xbgr.mr_n61387856)
print v(xbgr.mr_n61530624)
print v(xbgr.mr_n61633712)
print v(xbgr.mr_n61977024)
print v(xbgr.mr_n62102768)
print v(xbgr.mr_n62252464)
print v(xbgr.mr_n62381632)
print v(xbgr.mr_n62528752)
print v(xbgr.mr_n62731792)
print v(xbgr.mr_n62853376)
print v(xbgr.mr_n63035184)
print v(xbgr.mr_n60834736)
print v(xbgr.mr_n60103744)
print v(xbgr.mr_n60917808)
print v(xbgr.mr_n61029616)
print v(xbgr.mr_n61119200)
print v(xbgr.mr_n61226960)
print v(xbgr.mr_n61362128)
print v(xbgr.mr_n61520048)
print v(xbgr.mr_n61586144)
print v(xbgr.mr_n61970464)
print v(xbgr.mr_n62051360)
print v(xbgr.mr_n62186032)
print v(xbgr.mr_n62350192)
print v(xbgr.mr_n62480896)
print v(xbgr.mr_n62647648)
print v(xbgr.mr_n62791344)
print v(xbgr.mr_n63030320)
print v(xbgr.mr_n60208544)
print v(xbgr.mr_n59991024)
print v(xbgr.mr_n60524352)
print v(xbgr.mr_n60759520)
print v(xbgr.mr_n60870176)
print v(xbgr.mr_n60344336)
print v(xbgr.mr_n60982880)
print v(xbgr.mr_n61097648)
print v(xbgr.mr_n61202592)
print v(xbgr.mr_n61325264)
print v(xbgr.mr_n61427408)
print v(xbgr.mr_n61558768)
print v(xbgr.mr_n61657584)
print v(xbgr.mr_n61890112)
print v(xbgr.mr_n62016912)
print v(xbgr.mr_n62286144)
print v(xbgr.mr_n62415504)
print v(xbgr.mr_n62597504)
print v(xbgr.mr_n62729616)
print v(xbgr.mr_n62851200)
print v(xbgr.mr_n63021696)
print v(xbgr.mr_n60209088)
print v(xbgr.mr_n60061536)
print v(xbgr.mr_n60524944)
print v(xbgr.mr_n60760112)
print v(xbgr.mr_n60209632)
print v(xbgr.mr_n59988912)
print v(xbgr.mr_n60525536)
print v(xbgr.mr_n60760704)
print v(xbgr.mr_n60210176)
print v(xbgr.mr_n60204352)
print v(xbgr.mr_n60526128)
print v(xbgr.mr_n60761296)
print v(xbgr.mr_n60210720)
print v(xbgr.mr_n60066464)
print v(xbgr.mr_n60526720)
print v(xbgr.mr_n60761888)
print v(xbgr.mr_n60841664)
print v(xbgr.mr_n60061040)
print v(xbgr.mr_n60978496)
print v(xbgr.mr_n61094192)
print v(xbgr.mr_n61166736)
print v(xbgr.mr_n61293872)
print v(xbgr.mr_n61427920)
print v(xbgr.mr_n61527904)
print v(xbgr.mr_n61642832)
print v(xbgr.mr_n61976912)
print v(xbgr.mr_n62102656)
print v(xbgr.mr_n62266736)
print v(xbgr.mr_n62415328)
print v(xbgr.mr_n62594768)
print v(xbgr.mr_n62680112)
print v(xbgr.mr_n62841664)
print v(xbgr.mr_n62891616)
print v(xbgr.mr_n60850496)
print v(xbgr.mr_n60909760)
print v(xbgr.mr_n60950240)
print v(xbgr.mr_n61082528)
print v(xbgr.mr_n61169168)
print v(xbgr.mr_n61279664)
print v(xbgr.mr_n61386016)
print v(xbgr.mr_n61534704)
print v(xbgr.mr_n61627440)
print v(xbgr.mr_n61979344)
print v(xbgr.mr_n62104832)
print v(xbgr.mr_n62256256)
print v(xbgr.mr_n62385424)
print v(xbgr.mr_n62530592)
print v(xbgr.mr_n62733856)
print v(xbgr.mr_n62855440)
print v(xbgr.mr_n63037504)
print v(xbgr.mr_n60211264)
print v(xbgr.mr_n60062944)
print v(xbgr.mr_n60527312)
print v(xbgr.mr_n60747232)
print v(xbgr.mr_n60843904)
print v(xbgr.mr_n60034992)
print v(xbgr.mr_n60917344)
print v(xbgr.mr_n61031008)
print v(xbgr.mr_n61118736)
print v(xbgr.mr_n61229504)
print v(xbgr.mr_n61361664)
print v(xbgr.mr_n61517040)
print v(xbgr.mr_n61587536)
print v(xbgr.mr_n61970688)
print v(xbgr.mr_n62050768)
print v(xbgr.mr_n62185440)
print v(xbgr.mr_n62351968)
print v(xbgr.mr_n62480304)
print v(xbgr.mr_n62647376)
print v(xbgr.mr_n62793120)
print v(xbgr.mr_n63032976)
print v(xbgr.mr_n60212080)
print v(xbgr.mr_n59990320)
print v(xbgr.mr_n60527904)
print v(xbgr.mr_n60762992)
print v(xbgr.mr_n60870816)
print v(xbgr.mr_n60023056)
print v(xbgr.mr_n60984416)
print v(xbgr.mr_n61097392)
print v(xbgr.mr_n61203392)
print v(xbgr.mr_n61325536)
print v(xbgr.mr_n61429264)
print v(xbgr.mr_n61559408)
print v(xbgr.mr_n61658384)
print v(xbgr.mr_n61981040)
print v(xbgr.mr_n62098528)
print v(xbgr.mr_n62286944)
print v(xbgr.mr_n62416304)
print v(xbgr.mr_n62598704)
print v(xbgr.mr_n62731680)
print v(xbgr.mr_n62853264)
print v(xbgr.mr_n63035072)
print v(xbgr.mr_n60212352)
print v(xbgr.mr_n60081984)
print v(xbgr.n_3)
print v(xbgr.n_33)
print v(xbgr.mr_n60212896)
print v(xbgr.mr_n60057312)
print v(xbgr.mr_n60529088)
print v(xbgr.mr_n60764256)
print v(xbgr.mr_n60213504)
print v(xbgr.mr_n60001648)
print v(xbgr.mr_n60444848)
print v(xbgr.mr_n60310608)
print v(xbgr.mr_n60214896)
print v(xbgr.mr_n60143584)
print v(xbgr.mr_n60530272)
print v(xbgr.mr_n60765440)
print v(xbgr.mr_n60848176)
print v(xbgr.mr_n60648592)
print v(xbgr.mr_n60981168)
print v(xbgr.mr_n61099616)
print v(xbgr.mr_n61177792)
print v(xbgr.mr_n61294992)
print v(xbgr.mr_n61428032)
print v(xbgr.mr_n61516096)
print v(xbgr.mr_n61623760)
print v(xbgr.mr_n61815584)
print v(xbgr.mr_n61979456)
print v(xbgr.mr_n62104720)
print v(xbgr.mr_n62285968)
print v(xbgr.mr_n62413728)
print v(xbgr.mr_n62597168)
print v(xbgr.mr_n62721584)
print v(xbgr.mr_n62842832)
print v(xbgr.mr_n63035296)
print v(xbgr.mr_n60853072)
print v(xbgr.mr_n60907232)
print v(xbgr.mr_n60953264)
print v(xbgr.mr_n61086240)
print v(xbgr.mr_n61181216)
print v(xbgr.mr_n61275984)
print v(xbgr.mr_n61382336)
print v(xbgr.mr_n61537536)
print v(xbgr.mr_n61631568)
print v(xbgr.mr_n61853152)
print v(xbgr.mr_n61981664)
print v(xbgr.mr_n62106896)
print v(xbgr.mr_n62260048)
print v(xbgr.mr_n62389216)
print v(xbgr.mr_n62526912)
print v(xbgr.mr_n62735920)
print v(xbgr.mr_n62857504)
print v(xbgr.mr_n63039824)
print v(xbgr.mr_n60840496)
print v(xbgr.mr_n60894272)
print v(xbgr.mr_n60916880)
print v(xbgr.mr_n61031472)
print v(xbgr.mr_n61118272)
print v(xbgr.mr_n61231872)
print v(xbgr.mr_n61361200)
print v(xbgr.mr_n61526960)
print v(xbgr.mr_n61588928)
print v(xbgr.mr_n61850016)
print v(xbgr.mr_n61974816)
print v(xbgr.mr_n62050176)
print v(xbgr.mr_n62184848)
print v(xbgr.mr_n62353744)
print v(xbgr.mr_n62479712)
print v(xbgr.mr_n62647104)
print v(xbgr.mr_n62794896)
print v(xbgr.mr_n63030432)
print v(xbgr.mr_n60215360)
print v(xbgr.n_19)
print v(xbgr.mr_n60530864)
print v(xbgr.mr_n60766032)
print v(xbgr.mr_n60871616)
print v(xbgr.mr_n60103504)
print v(xbgr.mr_n60985792)
print v(xbgr.mr_n61099968)
print v(xbgr.mr_n60921760)
print v(xbgr.mr_n61326768)
print v(xbgr.mr_n61430640)
print v(xbgr.mr_n61560048)
print v(xbgr.mr_n61659184)
print v(xbgr.mr_n61856624)
print v(xbgr.mr_n61979232)
print v(xbgr.mr_n62104944)
print v(xbgr.mr_n62286768)
print v(xbgr.mr_n62417104)
print v(xbgr.mr_n62600528)
print v(xbgr.mr_n62733744)
print v(xbgr.mr_n62855328)
print v(xbgr.mr_n63037392)
print v(xbgr.mr_n60216288)
print v(xbgr.mr_n60141296)
print v(xbgr.mr_n60531456)
print v(xbgr.mr_n60766624)
print v(xbgr.mr_n60217216)
print v(xbgr.mr_n60203728)
print v(xbgr.mr_n60532048)
print v(xbgr.mr_n60767216)
print v(xbgr.mr_n60218608)
print v(xbgr.mr_n60000128)
print v(xbgr.mr_n60532640)
print v(xbgr.mr_n60767808)
print v(xbgr.mr_n60218144)
print v(xbgr.mr_n60205904)
print v(xbgr.mr_n60533232)
print v(xbgr.mr_n60768400)
print v(xbgr.mr_n60847424)
print v(xbgr.mr_n60672976)
print v(xbgr.mr_n60985184)
print v(xbgr.mr_n61058656)
print v(xbgr.mr_n61174032)
print v(xbgr.mr_n61296176)
print v(xbgr.mr_n61426176)
print v(xbgr.mr_n61523824)
print v(xbgr.mr_n61590320)
print v(xbgr.mr_n61853264)
print v(xbgr.mr_n61981552)
print v(xbgr.mr_n62100816)
print v(xbgr.mr_n62284368)
print v(xbgr.mr_n62391888)
print v(xbgr.mr_n62600032)
print v(xbgr.mr_n62733968)
print v(xbgr.mr_n62855552)
print v(xbgr.mr_n63032752)
print v(xbgr.mr_n60217680)
print v(xbgr.mr_n60100112)
print v(xbgr.mr_n60533824)
print v(xbgr.mr_n60768992)
print v(xbgr.mr_n60856256)
print v(xbgr.mr_n60905968)
print v(xbgr.mr_n60956288)
print v(xbgr.mr_n61084400)
print v(xbgr.mr_n61176464)
print v(xbgr.mr_n61274144)
print v(xbgr.mr_n61380496)
print v(xbgr.mr_n61541616)
print v(xbgr.mr_n61632400)
print v(xbgr.mr_n61857376)
print v(xbgr.mr_n61983984)
print v(xbgr.mr_n62108960)
print v(xbgr.mr_n62263840)
print v(xbgr.mr_n62393008)
print v(xbgr.mr_n62525072)
print v(xbgr.mr_n62737984)
print v(xbgr.mr_n62859568)
print v(xbgr.mr_n63042144)
print v(xbgr.mr_n60849664)
print v(xbgr.mr_n60894000)
print v(xbgr.mr_n60915696)
print v(xbgr.mr_n61030544)
print v(xbgr.mr_n61117344)
print v(xbgr.mr_n61234592)
print v(xbgr.mr_n61360272)
print v(xbgr.mr_n61530736)
print v(xbgr.mr_n61624096)
print v(xbgr.mr_n61799648)
print v(xbgr.mr_n61977136)
print v(xbgr.mr_n62048992)
print v(xbgr.mr_n62183664)
print v(xbgr.mr_n62355520)
print v(xbgr.mr_n62478528)
print v(xbgr.mr_n62646560)
print v(xbgr.mr_n62796672)
print v(xbgr.mr_n63039600)
print v(xbgr.mr_n60216752)
print v(xbgr.mr_n60136832)
print v(xbgr.mr_n60534416)
print v(xbgr.mr_n60769584)
print v(xbgr.mr_n60872736)
print v(xbgr.mr_n60618016)
print v(xbgr.mr_n60987248)
print v(xbgr.mr_n61101568)
print v(xbgr.mr_n61204592)
print v(xbgr.mr_n61327232)
print v(xbgr.mr_n61432496)
print v(xbgr.mr_n61561024)
print v(xbgr.mr_n61659984)
print v(xbgr.mr_n61859600)
print v(xbgr.mr_n61985680)
print v(xbgr.mr_n62094400)
print v(xbgr.mr_n62288544)
print v(xbgr.mr_n62416928)
print v(xbgr.mr_n62602592)
print v(xbgr.mr_n62735808)
print v(xbgr.mr_n62857392)
print v(xbgr.mr_n63039712)
print v(xbgr.mr_n60215824)
print v(xbgr.mr_n60206016)
print v(xbgr.mr_n60535008)
print v(xbgr.mr_n60770176)
print v(xbgr.mr_n60214432)
print v(xbgr.mr_n60068576)
print v(xbgr.n_4)
print v(xbgr.n_30)
print v(xbgr.mr_n60213968)
print v(xbgr.mr_n60032672)
print v(xbgr.mr_n60536192)
print v(xbgr.mr_n60762480)
print v(xbgr.mr_n60213168)
print v(xbgr.mr_n59991584)
print v(xbgr.mr_n60431440)
print v(xbgr.mr_n60703776)
print v(xbgr.mr_n60853936)
print v(xbgr.mr_n60914448)
print v(xbgr.mr_n60987952)
print v(xbgr.mr_n61102352)
print v(xbgr.mr_n61179616)
print v(xbgr.mr_n61297360)
print v(xbgr.mr_n61433088)
print v(xbgr.mr_n61538848)
print v(xbgr.mr_n61568960)
print v(xbgr.mr_n61796720)
print v(xbgr.mr_n61972752)
print v(xbgr.mr_n62107008)
print v(xbgr.mr_n62285168)
print v(xbgr.mr_n62402032)
print v(xbgr.mr_n62603680)
print v(xbgr.mr_n62725712)
print v(xbgr.mr_n62849136)
print v(xbgr.mr_n63039936)
print v(xbgr.mr_n60858832)
print v(xbgr.mr_n60903440)
print v(xbgr.mr_n60953376)
print v(xbgr.mr_n61080720)
print v(xbgr.mr_n60923824)
print v(xbgr.mr_n61270464)
print v(xbgr.mr_n61376816)
print v(xbgr.mr_n61544512)
print v(xbgr.mr_n61627328)
print v(xbgr.mr_n61860304)
print v(xbgr.mr_n61986304)
print v(xbgr.mr_n62111024)
print v(xbgr.mr_n62256960)
print v(xbgr.mr_n62396800)
print v(xbgr.mr_n62521392)
print v(xbgr.mr_n62740048)
print v(xbgr.mr_n62861632)
print v(xbgr.mr_n63044464)
print v(xbgr.mr_n60212624)
print v(xbgr.mr_n60090336)
print v(xbgr.mr_n60537376)
print v(xbgr.mr_n60772480)
print v(xbgr.mr_n60846256)
print v(xbgr.mr_n60893728)
print v(xbgr.mr_n60699792)
print v(xbgr.mr_n61030080)
print v(xbgr.mr_n61116880)
print v(xbgr.mr_n61241856)
print v(xbgr.mr_n61359808)
print v(xbgr.mr_n61534816)
print v(xbgr.mr_n61579088)
print v(xbgr.mr_n61815120)
print v(xbgr.mr_n61978480)
print v(xbgr.mr_n62048400)
print v(xbgr.mr_n62183072)
print v(xbgr.mr_n62357296)
print v(xbgr.mr_n62477936)
print v(xbgr.mr_n62646288)
print v(xbgr.mr_n62798448)
print v(xbgr.mr_n63037616)
print v(xbgr.mr_n60211808)
print v(xbgr.mr_n59991872)
print v(xbgr.mr_n60515312)
print v(xbgr.mr_n60754192)
print v(xbgr.mr_n60873376)
print v(xbgr.mr_n60615968)
print v(xbgr.mr_n60989440)
print v(xbgr.mr_n61102528)
print v(xbgr.mr_n61203792)
print v(xbgr.mr_n61327632)
print v(xbgr.mr_n61434432)
print v(xbgr.mr_n61561904)
print v(xbgr.mr_n61660544)
print v(xbgr.mr_n61857264)
print v(xbgr.mr_n61987920)
print v(xbgr.mr_n62098752)
print v(xbgr.mr_n62289344)
print v(xbgr.mr_n62418704)
print v(xbgr.mr_n62604272)
print v(xbgr.mr_n62737872)
print v(xbgr.mr_n62859456)
print v(xbgr.mr_n63042032)
print v(xbgr.mr_n60211536)
print v(xbgr.mr_n60142336)
print v(xbgr.mr_n60538560)
print v(xbgr.mr_n60773728)
print v(xbgr.mr_n60210992)
print v(xbgr.mr_n60092880)
print v(xbgr.mr_n60539152)
print v(xbgr.mr_n60774320)
print v(xbgr.mr_n60210448)
print v(xbgr.mr_n59991440)
print v(xbgr.mr_n60539744)
print v(xbgr.mr_n60774912)
print v(xbgr.mr_n60853184)
print v(xbgr.mr_n60673584)
print v(xbgr.mr_n60988064)
print v(xbgr.mr_n61098752)
print v(xbgr.mr_n61185088)
print v(xbgr.mr_n61298544)
print v(xbgr.mr_n61433760)
print v(xbgr.mr_n61537648)
print v(xbgr.mr_n61659808)
print v(xbgr.mr_n61850208)
print v(xbgr.mr_n61955840)
print v(xbgr.mr_n62102880)
print v(xbgr.mr_n62288368)
print v(xbgr.mr_n62417904)
print v(xbgr.mr_n62603856)
print v(xbgr.mr_n62738096)
print v(xbgr.mr_n62849360)
print v(xbgr.mr_n63042256)
print v(xbgr.mr_n60209904)
print v(xbgr.mr_n59988208)
print v(xbgr.mr_n60540336)
print v(xbgr.mr_n60775504)
print v(xbgr.mr_n60862016)
print v(xbgr.mr_n60902176)
print v(xbgr.mr_n60959056)
print v(xbgr.mr_n61079392)
print v(xbgr.mr_n60921648)
print v(xbgr.mr_n61268624)
print v(xbgr.mr_n61374976)
print v(xbgr.mr_n61548336)
print v(xbgr.mr_n61659008)
print v(xbgr.mr_n61657408)
print v(xbgr.mr_n61783648)
print v(xbgr.mr_n61988624)
print v(xbgr.mr_n62113088)
print v(xbgr.mr_n61964544)
print v(xbgr.mr_n62400592)
print v(xbgr.mr_n62519552)
print v(xbgr.mr_n62742112)
print v(xbgr.mr_n62863808)
print v(xbgr.mr_n63046784)
print v(xbgr.mr_n60855424)
print v(xbgr.mr_n60893456)
print v(xbgr.mr_n60716176)
print v(xbgr.mr_n61029152)
print v(xbgr.mr_n61115952)
print v(xbgr.mr_n61242624)
print v(xbgr.mr_n61358880)
print v(xbgr.mr_n61540784)
print v(xbgr.mr_n61814656)
print v(xbgr.mr_n61983872)
print v(xbgr.mr_n62047216)
print v(xbgr.mr_n62181888)
print v(xbgr.mr_n62340464)
print v(xbgr.mr_n62476752)
print v(xbgr.mr_n62645744)
print v(xbgr.mr_n62851424)
print v(xbgr.mr_n63032640)
print v(xbgr.mr_n60209360)
print v(xbgr.mr_n60039712)
print v(xbgr.mr_n60540928)
print v(xbgr.mr_n60776096)
print v(xbgr.mr_n60874016)
print v(xbgr.mr_n60744192)
print v(xbgr.mr_n60990896)
print v(xbgr.mr_n61104048)
print v(xbgr.mr_n61202992)
print v(xbgr.mr_n61328032)
print v(xbgr.mr_n61436688)
print v(xbgr.mr_n61562880)
print v(xbgr.mr_n61655808)
print v(xbgr.mr_n61850464)
print v(xbgr.mr_n61990320)
print v(xbgr.mr_n62100592)
print v(xbgr.mr_n62290144)
print v(xbgr.mr_n62419504)
print v(xbgr.mr_n62605536)
print v(xbgr.mr_n62739936)
print v(xbgr.mr_n62861520)
print v(xbgr.mr_n63041920)
print v(xbgr.mr_n60208816)
print v(xbgr.mr_n60125328)
print v(xbgr.mr_n60541520)
print v(xbgr.mr_n60776672)
print v(xbgr.mr_n60208272)
print v(xbgr.mr_n60087856)
print v(xbgr.mr_n60542112)
print v(xbgr.mr_n60777264)
print v(xbgr.mr_n60207728)
print v(xbgr.mr_n60240048)
print v(xbgr.n_5)
print v(xbgr.mr_n60777840)
print v(xbgr.mr_n60206912)
print v(xbgr.mr_n60240672)
print v(xbgr.mr_n60543296)
print v(xbgr.mr_n60778432)
print v(xbgr.mr_n60852240)
print v(xbgr.mr_n60743152)
print v(xbgr.mr_n60990560)
print v(xbgr.mr_n61101392)
print v(xbgr.mr_n61157728)
print v(xbgr.mr_n61299728)
print v(xbgr.mr_n61438048)
print v(xbgr.mr_n61536704)
print v(xbgr.mr_n61687520)
print v(xbgr.mr_n61857488)
print v(xbgr.mr_n61988736)
print v(xbgr.mr_n62112976)
print v(xbgr.mr_n62289168)
print v(xbgr.mr_n62416128)
print v(xbgr.mr_n62605104)
print v(xbgr.mr_n62729840)
print v(xbgr.mr_n62861744)
print v(xbgr.mr_n63044576)
print v(xbgr.mr_n60857888)
print v(xbgr.mr_n60899648)
print v(xbgr.mr_n60961712)
print v(xbgr.mr_n61076736)
print v(xbgr.mr_n61187088)
print v(xbgr.mr_n61265392)
print v(xbgr.mr_n61372000)
print v(xbgr.mr_n61543568)
print v(xbgr.mr_n61686320)
print v(xbgr.mr_n61691056)
print v(xbgr.mr_n61752496)
print v(xbgr.mr_n61990944)
print v(xbgr.mr_n62115152)
print v(xbgr.mr_n62268416)
print v(xbgr.mr_n62397216)
print v(xbgr.mr_n62515872)
print v(xbgr.mr_n62744176)
print v(xbgr.mr_n62866128)
print v(xbgr.mr_n63049104)
print v(xbgr.mr_n60206640)
print v(xbgr.mr_n60241376)
print v(xbgr.mr_n60543888)
print v(xbgr.mr_n60747408)
print v(xbgr.mr_n60856368)
print v(xbgr.mr_n60893184)
print v(xbgr.mr_n60697808)
print v(xbgr.mr_n61028688)
print v(xbgr.mr_n61115488)
print v(xbgr.mr_n61243552)
print v(xbgr.mr_n61358496)
print v(xbgr.mr_n61541728)
print v(xbgr.mr_n61814192)
print v(xbgr.mr_n61986416)
print v(xbgr.mr_n62046624)
print v(xbgr.mr_n62181296)
print v(xbgr.mr_n62360384)
print v(xbgr.mr_n62476160)
print v(xbgr.mr_n62645472)
print v(xbgr.mr_n62859680)
print v(xbgr.mr_n63030656)
print v(xbgr.mr_n60205360)
print v(xbgr.mr_n60241840)
print v(xbgr.mr_n60544480)
print v(xbgr.mr_n60764848)
print v(xbgr.mr_n60874816)
print v(xbgr.mr_n60805968)
print v(xbgr.mr_n60991776)
print v(xbgr.mr_n61104928)
print v(xbgr.mr_n61202192)
print v(xbgr.mr_n61328432)
print v(xbgr.mr_n61438544)
print v(xbgr.mr_n61564336)
print v(xbgr.mr_n61686752)
print v(xbgr.mr_n61750032)
print v(xbgr.mr_n61992640)
print v(xbgr.mr_n62110912)
print v(xbgr.mr_n62290944)
print v(xbgr.mr_n62420304)
print v(xbgr.mr_n62607760)
print v(xbgr.mr_n62717904)
print v(xbgr.mr_n62863696)
print v(xbgr.mr_n63046672)
print v(xbgr.mr_n60166688)
print v(xbgr.mr_n60369232)
print v(xbgr.mr_n60545072)
print v(xbgr.mr_n60780128)
print v(xbgr.mr_n60167152)
print v(xbgr.mr_n60373968)
print v(xbgr.mr_n60545664)
print v(xbgr.mr_n60742896)
print v(xbgr.mr_n60167616)
print v(xbgr.mr_n60370416)
print v(xbgr.mr_n60546256)
print v(xbgr.mr_n60472592)
print v(xbgr.mr_n60168080)
print v(xbgr.mr_n60365680)
print v(xbgr.mr_n60546848)
print v(xbgr.mr_n60748688)
print v(xbgr.mr_n60846480)
print v(xbgr.mr_n60230272)
print v(xbgr.mr_n60988688)
print v(xbgr.mr_n61096352)
print v(xbgr.mr_n61153264)
print v(xbgr.mr_n61300912)
print v(xbgr.mr_n61439904)
print v(xbgr.mr_n61529792)
print v(xbgr.mr_n61656608)
print v(xbgr.mr_n61850720)
print v(xbgr.mr_n61990832)
print v(xbgr.mr_n62115040)
print v(xbgr.mr_n62287744)
print v(xbgr.mr_n62392112)
print v(xbgr.mr_n62605280)
print v(xbgr.mr_n62718576)
print v(xbgr.mr_n62817152)
print v(xbgr.mr_n63034960)
print v(xbgr.mr_n60852128)
print v(xbgr.mr_n60898704)
print v(xbgr.mr_n60960384)
print v(xbgr.mr_n61075408)
print v(xbgr.mr_n60923024)
print v(xbgr.mr_n61264064)
print v(xbgr.mr_n61370672)
print v(xbgr.mr_n61536592)
print v(xbgr.mr_n61686960)
print v(xbgr.mr_n61700240)
print v(xbgr.mr_n61759376)
print v(xbgr.mr_n61993264)
print v(xbgr.mr_n62117216)
print v(xbgr.mr_n62266512)
print v(xbgr.mr_n62400704)
print v(xbgr.mr_n62514032)
print v(xbgr.mr_n62746240)
print v(xbgr.mr_n62868448)
print v(xbgr.mr_n63051424)
print v(xbgr.mr_n60850608)
print v(xbgr.mr_n60892992)
print v(xbgr.mr_n60669680)
print v(xbgr.mr_n61027760)
print v(xbgr.mr_n61114560)
print v(xbgr.mr_n61243088)
print v(xbgr.mr_n61357888)
print v(xbgr.mr_n61531936)
print v(xbgr.mr_n61813728)
print v(xbgr.mr_n61986192)
print v(xbgr.mr_n62045632)
print v(xbgr.mr_n62180304)
print v(xbgr.mr_n62360992)
print v(xbgr.mr_n62474976)
print v(xbgr.mr_n62644928)
print v(xbgr.mr_n62865904)
print v(xbgr.mr_n63044352)
print v(xbgr.mr_n60168544)
print v(xbgr.mr_n60371600)
print v(xbgr.mr_n60529680)
print v(xbgr.mr_n60698256)
print v(xbgr.mr_n60169008)
print v(xbgr.mr_n60372192)
print v(xbgr.mr_n60548032)
print v(xbgr.mr_n60698624)
print v(xbgr.mr_n60875616)
print v(xbgr.mr_n60063920)
print v(xbgr.mr_n60993648)
print v(xbgr.mr_n61103088)
print v(xbgr.mr_n61201392)
print v(xbgr.mr_n61328832)
print v(xbgr.mr_n61440320)
print v(xbgr.mr_n61564976)
print v(xbgr.mr_n61685760)
print v(xbgr.mr_n61860416)
print v(xbgr.mr_n61994960)
print v(xbgr.mr_n62106784)
print v(xbgr.mr_n62291744)
print v(xbgr.mr_n62421104)
print v(xbgr.mr_n62609280)
print v(xbgr.mr_n62744064)
print v(xbgr.mr_n62866016)
print v(xbgr.mr_n63048992)
print v(xbgr.mr_n60169472)
print v(xbgr.mr_n60358400)
print v(xbgr.mr_n60548624)
print v(xbgr.mr_n60744480)
print v(xbgr.mr_n60169936)
print v(xbgr.mr_n60373376)
print v(xbgr.mr_n60549216)
print v(xbgr.mr_n60757744)
print v(xbgr.mr_n60170400)
print v(xbgr.mr_n60369824)
print v(xbgr.mr_n60549808)
print v(xbgr.n_31)
print v(xbgr.mr_n60840720)
print v(xbgr.mr_n60067440)
print v(xbgr.mr_n60986816)
print v(xbgr.mr_n61095152)
print v(xbgr.mr_n61103616)
print v(xbgr.mr_n61302096)
print v(xbgr.mr_n61441584)
print v(xbgr.mr_n61525024)
print v(xbgr.mr_n61693056)
print v(xbgr.mr_n61753808)
print v(xbgr.mr_n61993152)
print v(xbgr.mr_n62117104)
print v(xbgr.mr_n62259152)
print v(xbgr.mr_n62417728)
print v(xbgr.mr_n62606352)
print v(xbgr.mr_n62742224)
print v(xbgr.mr_n62863584)
print v(xbgr.mr_n63046560)
print v(xbgr.mr_n60095136)
print v(xbgr.mr_n60343952)
print v(xbgr.mr_n60550400)
print v(xbgr.mr_n60746368)
print v(xbgr.mr_n60846368)
print v(xbgr.mr_n60897200)
print v(xbgr.mr_n60957728)
print v(xbgr.mr_n61072752)
print v(xbgr.mr_n61183648)
print v(xbgr.mr_n61261408)
print v(xbgr.mr_n61368016)
print v(xbgr.mr_n61529680)
print v(xbgr.mr_n61705968)
print v(xbgr.mr_n61692944)
print v(xbgr.mr_n61733392)
print v(xbgr.mr_n61995584)
print v(xbgr.mr_n62119280)
print v(xbgr.mr_n62266624)
print v(xbgr.mr_n62399472)
print v(xbgr.mr_n62510352)
print v(xbgr.mr_n62748304)
print v(xbgr.mr_n62870768)
print v(xbgr.mr_n63054128)
print v(xbgr.mr_n60844848)
print v(xbgr.mr_n60892880)
print v(xbgr.mr_n60659344)
print v(xbgr.mr_n61027296)
print v(xbgr.mr_n61114096)
print v(xbgr.mr_n61242160)
print v(xbgr.mr_n61357584)
print v(xbgr.mr_n61451376)
print v(xbgr.mr_n61813264)
print v(xbgr.mr_n61988512)
print v(xbgr.mr_n62045168)
print v(xbgr.mr_n62179840)
print v(xbgr.mr_n62360656)
print v(xbgr.mr_n62474384)
print v(xbgr.mr_n62644736)
print v(xbgr.mr_n62816560)
print v(xbgr.mr_n63044240)
print v(xbgr.mr_n60171328)
print v(xbgr.mr_n60340288)
print v(xbgr.mr_n60550992)
print v(xbgr.mr_n60651696)
print v(xbgr.mr_n60876656)
print v(xbgr.mr_n60315840)
print v(xbgr.mr_n60994688)
print v(xbgr.mr_n61100688)
print v(xbgr.mr_n61200592)
print v(xbgr.mr_n61329232)
print v(xbgr.mr_n61442256)
print v(xbgr.mr_n61565616)
print v(xbgr.mr_n61658208)
print v(xbgr.mr_n61860192)
print v(xbgr.mr_n61995696)
print v(xbgr.mr_n62111136)
print v(xbgr.mr_n62292544)
print v(xbgr.mr_n62421904)
print v(xbgr.mr_n62611024)
print v(xbgr.mr_n62746128)
print v(xbgr.mr_n62868336)
print v(xbgr.mr_n63051312)
print v(xbgr.mr_n60171792)
print v(xbgr.mr_n60375136)
print v(xbgr.mr_n60551584)
print v(xbgr.mr_n60652912)
print v(xbgr.mr_n60172256)
print v(xbgr.n_34)
print v(xbgr.mr_n60552176)
print v(xbgr.mr_n60780528)
print v(xbgr.mr_n60172720)
print v(xbgr.mr_n60377568)
print v(xbgr.mr_n60552768)
print v(xbgr.mr_n60781072)
print v(xbgr.mr_n60173184)
print v(xbgr.mr_n60353536)
print v(xbgr.mr_n60553360)
print v(xbgr.mr_n60771872)
print v(xbgr.mr_n60834960)
print v(xbgr.mr_n60021840)
print v(xbgr.mr_n60995120)
print v(xbgr.mr_n61094016)
print v(xbgr.mr_n61119664)
print v(xbgr.mr_n61303280)
print v(xbgr.mr_n61440912)
print v(xbgr.mr_n61518112)
print v(xbgr.mr_n61687360)
print v(xbgr.mr_n61755664)
print v(xbgr.mr_n61981776)
print v(xbgr.mr_n62108848)
print v(xbgr.mr_n62283568)
print v(xbgr.mr_n62275280)
print v(xbgr.mr_n62606128)
print v(xbgr.mr_n62742000)
print v(xbgr.mr_n62870544)
print v(xbgr.mr_n63048880)
print v(xbgr.mr_n60840608)
print v(xbgr.mr_n60896448)
print v(xbgr.mr_n60956400)
print v(xbgr.mr_n61071424)
print v(xbgr.mr_n61176352)
print v(xbgr.mr_n61258608)
print v(xbgr.mr_n61365216)
print v(xbgr.mr_n61522768)
print v(xbgr.mr_n61699280)
print v(xbgr.mr_n61700960)
print v(xbgr.mr_n61763632)
print v(xbgr.mr_n61743952)
print v(xbgr.mr_n62121344)
print v(xbgr.mr_n62260432)
print v(xbgr.mr_n62276784)
print v(xbgr.mr_n62508512)
print v(xbgr.mr_n62750368)
print v(xbgr.mr_n62873088)
print v(xbgr.mr_n63058560)
print v(xbgr.mr_n60173648)
print v(xbgr.mr_n60378672)
print v(xbgr.mr_n60553952)
print v(xbgr.mr_n60783360)
print v(xbgr.mr_n60839088)
print v(xbgr.mr_n60891872)
print v(xbgr.mr_n60669072)
print v(xbgr.mr_n61026368)
print v(xbgr.mr_n61113168)
print v(xbgr.mr_n61241968)
print v(xbgr.mr_n61321296)
print v(xbgr.mr_n61451184)
print v(xbgr.mr_n61812800)
print v(xbgr.mr_n61993376)
print v(xbgr.mr_n62044240)
print v(xbgr.mr_n62178912)
print v(xbgr.mr_n62360112)
print v(xbgr.mr_n62473264)
print v(xbgr.mr_n62641024)
print v(xbgr.mr_n62863920)
print v(xbgr.mr_n63037280)
print v(xbgr.mr_n60174112)
print v(xbgr.mr_n60351456)
print v(xbgr.mr_n60536784)
print v(xbgr.mr_n60779552)
print v(xbgr.mr_n60877616)
print v(xbgr.mr_n60050544)
print v(xbgr.mr_n60996720)
print v(xbgr.mr_n61098288)
print v(xbgr.mr_n61199792)
print v(xbgr.mr_n61329632)
print v(xbgr.mr_n61443712)
print v(xbgr.mr_n61566592)
print v(xbgr.mr_n61686560)
print v(xbgr.mr_n61727600)
print v(xbgr.mr_n61493648)
print v(xbgr.mr_n62117328)
print v(xbgr.mr_n62293344)
print v(xbgr.mr_n62422704)
print v(xbgr.mr_n62612768)
print v(xbgr.mr_n62748192)
print v(xbgr.mr_n62870656)
print v(xbgr.mr_n63053632)
print v(xbgr.mr_n60174576)
print v(xbgr.mr_n60379872)
print v(xbgr.mr_n60555136)
print v(xbgr.mr_n60784528)
print v(xbgr.mr_n60175040)
print v(xbgr.mr_n60375024)
print v(xbgr.mr_n60555728)
print v(xbgr.mr_n60785200)
print v(xbgr.mr_n60175504)
print v(xbgr.mr_n60381120)
print v(xbgr.mr_n60556320)
print v(xbgr.mr_n60785792)
print v(xbgr.mr_n60175968)
print v(xbgr.mr_n60381712)
print v(xbgr.n_10)
print v(xbgr.mr_n60771360)
print v(xbgr.mr_n60827776)
print v(xbgr.mr_n60107088)
print v(xbgr.mr_n60992432)
print v(xbgr.mr_n61066544)
print v(xbgr.mr_n61152496)
print v(xbgr.mr_n61304464)
print v(xbgr.mr_n61444224)
print v(xbgr.mr_n61451072)
print v(xbgr.mr_n61699168)
print v(xbgr.mr_n61758448)
print v(xbgr.mr_n61895776)
print v(xbgr.mr_n62119392)
print v(xbgr.mr_n62292368)
print v(xbgr.mr_n62418528)
print v(xbgr.mr_n62611616)
print v(xbgr.mr_n62744288)
print v(xbgr.mr_n62853488)
print v(xbgr.mr_n63049216)
print v(xbgr.mr_n60834848)
print v(xbgr.mr_n60895504)
print v(xbgr.mr_n60955200)
print v(xbgr.mr_n61068896)
print v(xbgr.mr_n61169056)
print v(xbgr.mr_n61258864)
print v(xbgr.mr_n61365472)
print v(xbgr.mr_n61515984)
print v(xbgr.mr_n61712912)
print v(xbgr.mr_n61594832)
print v(xbgr.mr_n61858656)
print v(xbgr.mr_n61739728)
print v(xbgr.mr_n62123408)
print v(xbgr.mr_n61746160)
print v(xbgr.mr_n62399696)
print v(xbgr.mr_n62505968)
print v(xbgr.mr_n62752432)
print v(xbgr.mr_n62875408)
print v(xbgr.mr_n63062992)
print v(xbgr.mr_n60827584)
print v(xbgr.mr_n60891696)
print v(xbgr.mr_n60710800)
print v(xbgr.mr_n61025904)
print v(xbgr.mr_n61112704)
print v(xbgr.mr_n61240528)
print v(xbgr.mr_n61321568)
print v(xbgr.mr_n61450016)
print v(xbgr.mr_n61812336)
print v(xbgr.mr_n61996288)
print v(xbgr.mr_n62043776)
print v(xbgr.mr_n62178448)
print v(xbgr.mr_n62354688)
print v(xbgr.mr_n62472800)
print v(xbgr.mr_n62642544)
print v(xbgr.mr_n62868224)
print v(xbgr.mr_n63054240)
print v(xbgr.mr_n60176432)
print v(xbgr.mr_n60374560)
print v(xbgr.mr_n60557504)
print v(xbgr.mr_n60786896)
print v(xbgr.mr_n60176896)
print v(xbgr.mr_n60345968)
print v(xbgr.mr_n60558096)
print v(xbgr.mr_n60787568)
print v(xbgr.mr_n60878176)
print v(xbgr.mr_n60614944)
print v(xbgr.mr_n60998176)
print v(xbgr.mr_n61095888)
print v(xbgr.mr_n61198992)
print v(xbgr.mr_n61330032)
print v(xbgr.mr_n61445488)
print v(xbgr.mr_n61567472)
print v(xbgr.mr_n61695712)
print v(xbgr.mr_n61749760)
print v(xbgr.mr_n61997632)
print v(xbgr.mr_n62119168)
print v(xbgr.mr_n62262944)
print v(xbgr.mr_n62423504)
print v(xbgr.mr_n62612432)
print v(xbgr.mr_n62727776)
print v(xbgr.mr_n62872976)
print v(xbgr.mr_n63058000)
print v(xbgr.mr_n60177360)
print v(xbgr.mr_n60383408)
print v(xbgr.mr_n60558688)
print v(xbgr.mr_n60788160)
print v(xbgr.mr_n60177824)
print v(xbgr.mr_n60378160)
print v(xbgr.mr_n60559280)
print v(xbgr.mr_n60773136)
print v(xbgr.mr_n60178288)
print v(xbgr.mr_n60384592)
print v(xbgr.mr_n60559872)
print v(xbgr.mr_n60789344)
print v(xbgr.mr_n60827200)
print v(xbgr.mr_n60674192)
print v(xbgr.mr_n60994512)
print v(xbgr.mr_n61039328)
print v(xbgr.mr_n61097216)
print v(xbgr.mr_n61305648)
print v(xbgr.mr_n61445072)
print v(xbgr.mr_n61450384)
print v(xbgr.mr_n61706480)
print v(xbgr.mr_n61850976)
print v(xbgr.mr_n61997520)
print v(xbgr.mr_n62121456)
print v(xbgr.mr_n62287568)
print v(xbgr.mr_n62420928)
print v(xbgr.mr_n62608944)
print v(xbgr.mr_n62731904)
print v(xbgr.mr_n62868560)
print v(xbgr.mr_n63058672)
print v(xbgr.mr_n60178752)
print v(xbgr.mr_n60385264)
print v(xbgr.mr_n60560464)
print v(xbgr.mr_n60789936)
print v(xbgr.mr_n60828864)
print v(xbgr.mr_n60895312)
print v(xbgr.mr_n60926688)
print v(xbgr.mr_n61068144)
print v(xbgr.mr_n61161760)
print v(xbgr.mr_n61261296)
print v(xbgr.mr_n61367904)
print v(xbgr.mr_n61505712)
print v(xbgr.mr_n61719488)
print v(xbgr.mr_n61719296)
print v(xbgr.mr_n61736160)
print v(xbgr.mr_n61999216)
print v(xbgr.mr_n62125472)
print v(xbgr.mr_n62260752)
print v(xbgr.mr_n62399584)
print v(xbgr.mr_n62505712)
print v(xbgr.mr_n62754496)
print v(xbgr.mr_n62877728)
print v(xbgr.mr_n63067424)
print v(xbgr.mr_n60797040)
print v(xbgr.mr_n60892352)
print v(xbgr.mr_n60043680)
print v(xbgr.mr_n61024976)
print v(xbgr.mr_n61101216)
print v(xbgr.mr_n61232896)
print v(xbgr.mr_n61244016)
print v(xbgr.mr_n61448272)
print v(xbgr.mr_n61801200)
print v(xbgr.mr_n61888192)
print v(xbgr.mr_n62020016)
print v(xbgr.mr_n62148800)
print v(xbgr.mr_n62358240)
print v(xbgr.mr_n62421728)
print v(xbgr.mr_n62643280)
print v(xbgr.mr_n62875184)
print v(xbgr.mr_n63051200)
print v(xbgr.mr_n60179216)
print v(xbgr.mr_n60385856)
print v(xbgr.mr_n60561056)
print v(xbgr.mr_n60790528)
print v(xbgr.mr_n60879136)
print v(xbgr.mr_n60049840)
print v(xbgr.mr_n60999632)
print v(xbgr.mr_n61093088)
print v(xbgr.mr_n61195808)
print v(xbgr.mr_n61330432)
print v(xbgr.mr_n61447424)
print v(xbgr.mr_n61568448)
print v(xbgr.mr_n61699808)
print v(xbgr.mr_n61801760)
print v(xbgr.mr_n61974592)
print v(xbgr.mr_n62123296)
print v(xbgr.mr_n62294944)
print v(xbgr.mr_n62424304)
print v(xbgr.mr_n62616112)
print v(xbgr.mr_n62752320)
print v(xbgr.mr_n62875296)
print v(xbgr.mr_n63062432)
print v(xbgr.mr_n60179680)
print v(xbgr.mr_n60346976)
print v(xbgr.mr_n60561648)
print v(xbgr.mr_n60786384)
print v(xbgr.mr_n60180144)
print v(xbgr.mr_n60379344)
print v(xbgr.mr_n60562240)
print v(xbgr.mr_n60791776)
print v(xbgr.mr_n60180608)
print v(xbgr.mr_n60387568)
print v(xbgr.mr_n60562832)
print v(xbgr.mr_n60781776)
print v(xbgr.mr_n60181072)
print v(xbgr.mr_n60388224)
print v(xbgr.mr_n60563424)
print v(xbgr.mr_n60792896)
print v(xbgr.mr_n60181536)
print v(xbgr.mr_n60388816)
print v(xbgr.mr_n60564016)
print v(xbgr.mr_n60748928)
print v(xbgr.mr_n60154160)
print v(xbgr.mr_n60389408)
print v(xbgr.mr_n60564608)
print v(xbgr.mr_n60794080)
print v(xbgr.mr_n60182464)
print v(xbgr.mr_n60382304)
print v(xbgr.mr_n60565200)
print v(xbgr.mr_n60794672)
print v(xbgr.mr_n60182928)
print v(xbgr.mr_n60390656)
print v(xbgr.mr_n60565792)
print v(xbgr.mr_n60795264)
print v(xbgr.mr_n61065216)
print v(xbgr.mr_n62616704)
print v(xbgr.mr_n62875520)
print v(xbgr.mr_n63046896)
print v(xbgr.mr_n60183328)
print v(xbgr.mr_n60380528)
print v(xbgr.mr_n60566384)
print v(xbgr.mr_n60795856)
print v(xbgr.d5)
print v(xbgr.d1)
print v(xbgr.mr_n61063296)
print v(xbgr.mr_n61446752)
print v(xbgr.mr_n60890560)
print v(xbgr.mr_n60997840)
print v(xbgr.mr_n61441760)
print v(xbgr.mr_n62607344)
print v(xbgr.n1)
print v(xbgr.mr_n63066752)
print v(xbgr.mr_n60183792)
print v(xbgr.mr_n60391712)
print v(xbgr.mr_n60566976)
print v(xbgr.mr_n60796448)
print v(xbgr.mr_n62422528)
print v(xbgr.mr_n62647920)
print v(xbgr.mr_n62891072)
print v(xbgr.mr_n60825904)
print v(xbgr.mr_n60912288)
print v(xbgr.kick)
print v(xbgr.mr_n61258352)
print v(xbgr.mr_n62613360)
print v(xbgr.mr_n62808272)
print v(xbgr.mr_n63066864)
print v(xbgr.mr_n60184256)
print v(xbgr.mr_n60392368)
print v(xbgr.mr_n60567568)
print v(xbgr.mr_n60797632)
print v(xbgr.mr_n60184720)
print v(xbgr.mr_n60390000)
print v(xbgr.mr_n60568160)
print v(xbgr.mr_n60798224)
print v(xbgr.mr_n60878704)
print v(xbgr.mr_n60947328)
print v(xbgr.mr_n61040272)
print v(xbgr.mr_n61446928)
print v(xbgr.mr_n62615696)
print v(xbgr.mr_n62847296)
print v(xbgr.mr_n63067536)
print v(xbgr.mr_n61568096)
print v(xbgr.mr_n61712800)
print v(xbgr.mr_n61782000)
print v(xbgr.mr_n61740960)
print v(xbgr.mr_n62109072)
print v(xbgr.mr_n62251568)
print v(xbgr.mr_n62384304)
print v(xbgr.mr_n61566416)
print v(xbgr.mr_n61690208)
print v(xbgr.mr_n61784288)
print v(xbgr.mr_n61757520)
print v(xbgr.mr_n62115264)
print v(xbgr.mr_n62262832)
print v(xbgr.mr_n62395792)
print v(xbgr.mr_n60185168)
print v(xbgr.mr_n60356080)
print v(xbgr.mr_n60568752)
print v(xbgr.mr_n60798816)
print v(xbgr.mr_n62617280)
print v(xbgr.mr_n62807680)
print v(xbgr.mr_n63062320)
print v(xbgr.mr_n61465408)
print v(xbgr.mr_n61551552)
print v(xbgr.mr_n61666064)
print v(xbgr.mr_n61804384)
print v(xbgr.mr_n62017328)
print v(xbgr.mr_n62146112)
print v(xbgr.mr_n62290768)
print v(xbgr.mr_n62435760)
print v(xbgr.mr_n62679520)
print v(xbgr.mr_n62894240)
print v(xbgr.mr_n60185632)
print v(xbgr.mr_n60394064)
print v(xbgr.mr_n60569344)
print v(xbgr.mr_n60799408)
print v(xbgr.mr_n62614960)
print v(xbgr.mr_n62808160)
print v(xbgr.mr_n63053520)
print v(xbgr.mr_n61065104)
print v(xbgr.mr_n61568272)
print v(xbgr.d2)
print v(xbgr.mr_n61773824)
print v(xbgr.mr_n61758016)
print v(xbgr.mr_n62051952)
print v(xbgr.mr_n62222192)
print v(xbgr.mr_n62356464)
print v(xbgr.mr_n60889248)
print v(xbgr.mr_n60997232)
print v(xbgr.mr_n61448160)
print v(xbgr.mr_n60186096)
print v(xbgr.mr_n60394736)
print v(xbgr.mr_n60569936)
print v(xbgr.mr_n60800000)
print v(xbgr.mr_n60890384)
print v(xbgr.mr_n60993232)
print v(xbgr.mr_n61448656)
print v(xbgr.mr_n62617904)
print v(xbgr.mr_n62857616)
print v(xbgr.mr_n63057888)
print v(xbgr.mr_n61063920)
print v(xbgr.mr_n60186560)
print v(xbgr.mr_n60395328)
print v(xbgr.mr_n60570528)
print v(xbgr.mr_n60801184)
print v(xbgr.mr_n60826448)
print v(xbgr.mr_n60911024)
print v(xbgr.mr_n61308640)
print v(xbgr.det)
print v(xbgr.mr_n62617392)
print v(xbgr.mr_n62808384)
print v(xbgr.mr_n63051536)
print v(xbgr.mr_n61042720)
print v(xbgr.mr_n60187024)
print v(xbgr.mr_n60395920)
print v(xbgr.mr_n60571120)
print v(xbgr.mr_n60791120)
print v(xbgr.mr_n62437536)
print v(xbgr.mr_n62678928)
print v(xbgr.mr_n62895328)
print v(xbgr.mr_n60879648)
print v(xbgr.mr_n60229328)
print v(xbgr.mr_n61448928)
print v(xbgr.mr_n62618128)
print v(xbgr.mr_n62809088)
print v(xbgr.mr_n63070208)
print v(xbgr.mr_n61564000)
print v(xbgr.mr_n61714656)
print v(xbgr.mr_n61783392)
print v(xbgr.mr_n61733504)
print v(xbgr.mr_n62121232)
print v(xbgr.mr_n62258928)
print v(xbgr.mr_n62392000)
print v(xbgr.mr_n61569072)
print v(xbgr.mr_n61712688)
print v(xbgr.mr_n61781888)
print v(xbgr.mr_n61739248)
print v(xbgr.mr_n62127648)
print v(xbgr.mr_n62263952)
print v(xbgr.mr_n62396912)
print v(xbgr.mr_n60187488)
print v(xbgr.mr_n60396512)
print v(xbgr.mr_n60571712)
print v(xbgr.mr_n60788752)
print v(xbgr.mr_n61464944)
print v(xbgr.mr_n61550688)
print v(xbgr.mr_n61673104)
print v(xbgr.mr_n61805200)
print v(xbgr.mr_n62021360)
print v(xbgr.mr_n62150144)
print v(xbgr.mr_n62295488)
print v(xbgr.mr_n62615520)
print v(xbgr.mr_n62880192)
print v(xbgr.mr_n63063104)
print v(xbgr.mr_n60187952)
print v(xbgr.mr_n60386976)
print v(xbgr.mr_n60554544)
print v(xbgr.mr_n60806896)
print v(xbgr.mr_n62618016)
print v(xbgr.mr_n62811232)
print v(xbgr.mr_n63071712)
print v(xbgr.mr_n60188416)
print v(xbgr.mr_n60397696)
print v(xbgr.mr_n60572896)
print v(xbgr.mr_n60807008)
print v(xbgr.mr_n60999120)
print v(xbgr.mr_n61569408)
print v(xbgr.mr_n61718544)
print v(xbgr.mr_n61773328)
print v(xbgr.mr_n61770816)
print v(xbgr.mr_n62128144)
print v(xbgr.mr_n62218048)
print v(xbgr.mr_n62353568)
print v(xbgr.mr_n60888592)
print v(xbgr.mr_n60995344)
print v(xbgr.mr_n61447936)
print v(xbgr.mr_n62439392)
print v(xbgr.mr_n62678336)
print v(xbgr.mr_n62896736)
print v(xbgr.mr_n60891040)
print v(xbgr.mr_n60990384)
print v(xbgr.mr_n61449392)
print v(xbgr.mr_n62619600)
print v(xbgr.mr_n62811824)
print v(xbgr.mr_n63074240)
print v(xbgr.mr_n60188880)
print v(xbgr.mr_n60398288)
print v(xbgr.mr_n60537968)
print v(xbgr.mr_n60807232)
print v(xbgr.mr_n61058288)
print v(xbgr.mr_n60826176)
print v(xbgr.mr_n60913552)
print v(xbgr.mr_n60997664)
print v(xbgr.mr_n61308176)
print v(xbgr.r4n)
print v(xbgr.mr_n60189344)
print v(xbgr.mr_n60384080)
print v(xbgr.mr_n60574080)
print v(xbgr.mr_n60807344)
print v(xbgr.mr_n62616816)
print v(xbgr.mr_n62881824)
print v(xbgr.mr_n62892160)
print v(xbgr.mr_n60872304)
print v(xbgr.mr_n60944304)
print v(xbgr.mr_n61449664)
print v(xbgr.mr_n61570032)
print v(xbgr.mr_n61713456)
print v(xbgr.mr_n61773216)
print v(xbgr.mr_n61735472)
print v(xbgr.mr_n62128032)
print v(xbgr.mr_n62255360)
print v(xbgr.mr_n62369200)
print v(xbgr.mr_n61569184)
print v(xbgr.mr_n61710608)
print v(xbgr.mr_n61780896)
print v(xbgr.mr_n61753456)
print v(xbgr.mr_n62128608)
print v(xbgr.mr_n62259040)
print v(xbgr.mr_n62393120)
print v(xbgr.mr_n60189808)
print v(xbgr.mr_n60393472)
print v(xbgr.mr_n60574672)
print v(xbgr.mr_n60807536)
print v(xbgr.mr_n62618352)
print v(xbgr.mr_n62813008)
print v(xbgr.mr_n63072672)
print v(xbgr.mr_n62441248)
print v(xbgr.mr_n62677744)
print v(xbgr.mr_n62898592)
print v(xbgr.mr_n61464480)
print v(xbgr.mr_n61550976)
print v(xbgr.mr_n61668368)
print v(xbgr.mr_n61806016)
print v(xbgr.mr_n62022176)
print v(xbgr.mr_n62150960)
print v(xbgr.mr_n62295904)
print v(xbgr.mr_n60190272)
print v(xbgr.mr_n60392960)
print v(xbgr.mr_n60575264)
print v(xbgr.mr_n60807808)
print v(xbgr.mr_n62619168)
print v(xbgr.mr_n62813600)
print v(xbgr.mr_n63075232)
print v(xbgr.mr_n60190736)
print v(xbgr.mr_n60400592)
print v(xbgr.mr_n60522576)
print v(xbgr.mr_n60808080)
print v(xbgr.mr_n61039600)
print v(xbgr.mr_n61571344)
print v(xbgr.mr_n61695984)
print v(xbgr.mr_n61784400)
print v(xbgr.mr_n61738896)
print v(xbgr.mr_n62127760)
print v(xbgr.mr_n62219232)
print v(xbgr.mr_n62351136)
print v(xbgr.mr_n62616928)
print v(xbgr.mr_n62881280)
print v(xbgr.mr_n63000208)
print v(xbgr.mr_n60887936)
print v(xbgr.mr_n60989952)
print v(xbgr.mr_n61448048)
print v(xbgr.mr_n60885792)
print v(xbgr.mr_n60995232)
print v(xbgr.mr_n61448544)
print v(xbgr.mr_n60191200)
print v(xbgr.mr_n60401248)
print v(xbgr.mr_n60576448)
print v(xbgr.mr_n60808624)
print v(xbgr.mr_n62620512)
print v(xbgr.mr_n62814784)
print v(xbgr.mr_n63076800)
print v(xbgr.mr_n61039056)
print v(xbgr.mr_n60825632)
print v(xbgr.mr_n60118336)
print v(xbgr.mr_n61307712)
print v(xbgr.mr_n60996144)
print v(xbgr.mr_n62443104)
print v(xbgr.mr_n62677152)
print v(xbgr.mr_n62900448)
print v(xbgr.mr_n60191664)
print v(xbgr.mr_n60398880)
print v(xbgr.mr_n60577040)
print v(xbgr.mr_n60808896)
print v(xbgr.mr_n61031936)
print v(xbgr.mr_n62619776)
print v(xbgr.mr_n62815376)
print v(xbgr.mr_n63077792)
print v(xbgr.mr_n60858944)
print v(xbgr.mr_n60946128)
print v(xbgr.mr_n61450720)
print v(xbgr.mr_n60192128)
print v(xbgr.mr_n60402352)
print v(xbgr.mr_n60577632)
print v(xbgr.mr_n60809168)
print v(xbgr.mr_n61571168)
print v(xbgr.mr_n61719680)
print v(xbgr.mr_n61785984)
print v(xbgr.mr_n61861856)
print v(xbgr.mr_n62129424)
print v(xbgr.mr_n62255136)
print v(xbgr.mr_n62388096)
print v(xbgr.mr_n61572064)
print v(xbgr.mr_n61720064)
print v(xbgr.mr_n61770704)
print v(xbgr.mr_n61863232)
print v(xbgr.mr_n62127536)
print v(xbgr.mr_n62260160)
print v(xbgr.mr_n62388208)
print v(xbgr.mr_n62621120)
print v(xbgr.mr_n62884000)
print v(xbgr.mr_n63077616)
print v(xbgr.mr_n60192592)
print v(xbgr.mr_n60391184)
print v(xbgr.mr_n60578224)
print v(xbgr.mr_n60809440)
print v(xbgr.mr_n61464016)
print v(xbgr.mr_n61591248)
print v(xbgr.mr_n61663024)
print v(xbgr.mr_n61806752)
print v(xbgr.mr_n62022992)
print v(xbgr.mr_n62151776)
print v(xbgr.mr_n62296720)
print v(xbgr.mr_n62621856)
print v(xbgr.mr_n62815968)
print v(xbgr.mr_n62981776)
print v(xbgr.mr_n60193056)
print v(xbgr.mr_n60403552)
print v(xbgr.mr_n60578816)
print v(xbgr.mr_n60809712)
print v(xbgr.mr_n62444960)
print v(xbgr.mr_n62676176)
print v(xbgr.mr_n62902336)
print v(xbgr.mr_n61570688)
print v(xbgr.mr_n61716320)
print v(xbgr.mr_n61770960)
print v(xbgr.mr_n61861968)
print v(xbgr.mr_n62129856)
print v(xbgr.mr_n62218640)
print v(xbgr.mr_n62355344)
print v(xbgr.mr_n62623632)
print v(xbgr.mr_n62814192)
print v(xbgr.mr_n63075056)
print v(xbgr.mr_n60887280)
print v(xbgr.mr_n60992208)
print v(xbgr.d3)
print v(xbgr.mr_n61446080)
print v(xbgr.mr_n60889728)
print v(xbgr.mr_n60993056)
print v(xbgr.mr_n61241008)
print v(xbgr.mr_n61446576)
print v(xbgr.mr_n60193520)
print v(xbgr.mr_n60399984)
print v(xbgr.mr_n60579408)
print v(xbgr.mr_n60809984)
print v(xbgr.mr_n60825360)
print v(xbgr.mr_n60119552)
print v(xbgr.mr_n61108064)
print v(xbgr.mr_n61306528)
print v(xbgr.mr_n62622464)
print v(xbgr.mr_n62886720)
print v(xbgr.mr_n63011776)
print v(xbgr.mr_n60193984)
print v(xbgr.mr_n60404736)
print v(xbgr.mr_n60580000)
print v(xbgr.mr_n60810256)
print v(xbgr.mr_n62623200)
print v(xbgr.mr_n62812416)
print v(xbgr.mr_n63072496)
print v(xbgr.mr_n60194448)
print v(xbgr.mr_n60405392)
print v(xbgr.mr_n60580592)
print v(xbgr.mr_n60810960)
print v(xbgr.mr_n60877440)
print v(xbgr.mr_n60941280)
print v(xbgr.mr_n61205088)
print v(xbgr.mr_n61444720)
print v(xbgr.mr_n61572752)
print v(xbgr.mr_n61690320)
print v(xbgr.mr_n61773600)
print v(xbgr.mr_n61738288)
print v(xbgr.mr_n61998384)
print v(xbgr.mr_n62128496)
print v(xbgr.mr_n62256368)
print v(xbgr.mr_n62380736)
print v(xbgr.mr_n61570144)
print v(xbgr.mr_n61719024)
print v(xbgr.mr_n61785360)
print v(xbgr.mr_n61775856)
print v(xbgr.mr_n62000640)
print v(xbgr.mr_n61734944)
print v(xbgr.mr_n62255248)
print v(xbgr.mr_n62384528)
print v(xbgr.mr_n62446816)
print v(xbgr.mr_n62675552)
print v(xbgr.mr_n62904704)
print v(xbgr.mr_n62620944)
print v(xbgr.mr_n62809776)
print v(xbgr.mr_n62987824)
print v(xbgr.mr_n60194912)
print v(xbgr.mr_n60405984)
print v(xbgr.mr_n60581184)
print v(xbgr.mr_n60811360)
print v(xbgr.mr_n61463552)
print v(xbgr.mr_n61590784)
print v(xbgr.mr_n61621280)
print v(xbgr.mr_n61806288)
print v(xbgr.mr_n61888544)
print v(xbgr.mr_n62023808)
print v(xbgr.mr_n62152592)
print v(xbgr.mr_n62297536)
print v(xbgr.mr_n60195376)
print v(xbgr.mr_n60406576)
print v(xbgr.mr_n60581776)
print v(xbgr.mr_n60811760)
print v(xbgr.mr_n62623808)
print v(xbgr.mr_n62885632)
print v(xbgr.mr_n62990992)
print v(xbgr.mr_n61571696)
print v(xbgr.mr_n61719872)
print v(xbgr.mr_n61786448)
print v(xbgr.mr_n61865776)
print v(xbgr.mr_n62000976)
print v(xbgr.mr_n62127424)
print v(xbgr.mr_n62219824)
print v(xbgr.mr_n62352912)
print v(xbgr.mr_n60886624)
print v(xbgr.mr_n60991600)
print v(xbgr.mr_n61238960)
print v(xbgr.mr_n61443376)
print v(xbgr.mr_n60889072)
print v(xbgr.mr_n60992320)
print v(xbgr.mr_n61239680)
print v(xbgr.mr_n61443200)
print v(xbgr.mr_n60182000)
print v(xbgr.mr_n60407168)
print v(xbgr.mr_n60582368)
print v(xbgr.mr_n60812160)
print v(xbgr.mr_n62624544)
print v(xbgr.mr_n62707968)
print v(xbgr.mr_n63018800)
print v(xbgr.mr_n62447744)
print v(xbgr.mr_n62675088)
print v(xbgr.mr_n62905888)
print v(xbgr.mr_n60196304)
print v(xbgr.mr_n60401840)
print v(xbgr.mr_n60547440)
print v(xbgr.mr_n60812960)
print v(xbgr.mr_n60825088)
print v(xbgr.mr_n60341376)
print v(xbgr.mr_n61107792)
print v(xbgr.mr_n61305344)
print v(xbgr.mr_n62626320)
print v(xbgr.mr_n62808816)
print v(xbgr.mr_n63017072)
print v(xbgr.mr_n60196768)
print v(xbgr.mr_n60408272)
print v(xbgr.mr_n60583552)
print v(xbgr.mr_n60813360)
print v(xbgr.mr_n60866096)
print v(xbgr.mr_n60943104)
print v(xbgr.mr_n61206048)
print v(xbgr.mr_n61444896)
print v(xbgr.mr_n62614208)
print v(xbgr.mr_n62889984)
print v(xbgr.mr_n63009344)
print v(xbgr.mr_n61574336)
print v(xbgr.mr_n61722128)
print v(xbgr.mr_n61778400)
print v(xbgr.mr_n61863744)
print v(xbgr.mr_n62000752)
print v(xbgr.mr_n61676048)
print v(xbgr.mr_n62251344)
print v(xbgr.mr_n62384416)
print v(xbgr.mr_n61575232)
print v(xbgr.mr_n61716992)
print v(xbgr.mr_n61771632)
print v(xbgr.mr_n61867712)
print v(xbgr.mr_n62001936)
print v(xbgr.mr_n61736544)
print v(xbgr.mr_n62251456)
print v(xbgr.mr_n62389328)
print v(xbgr.mr_n60197232)
print v(xbgr.mr_n60408944)
print v(xbgr.mr_n60584144)
print v(xbgr.mr_n60813760)
print v(xbgr.mr_n62625152)
print v(xbgr.mr_n62808048)
print v(xbgr.mr_n63009232)
print v(xbgr.mr_n61463088)
print v(xbgr.mr_n61589856)
print v(xbgr.mr_n61661104)
print v(xbgr.mr_n61805744)
print v(xbgr.mr_n61891008)
print v(xbgr.mr_n62024624)
print v(xbgr.mr_n62153408)
print v(xbgr.mr_n62298352)
print v(xbgr.mr_n62447280)
print v(xbgr.mr_n62674624)
print v(xbgr.mr_n62905296)
print v(xbgr.mr_n60197696)
print v(xbgr.mr_n60409536)
print v(xbgr.mr_n60584736)
print v(xbgr.mr_n60814160)
print v(xbgr.mr_n62627664)
print v(xbgr.mr_n62708160)
print v(xbgr.mr_n62983216)
print v(xbgr.mr_n61573856)
print v(xbgr.mr_n61717808)
print v(xbgr.mr_n61772528)
print v(xbgr.mr_n61864096)
print v(xbgr.mr_n62002832)
print v(xbgr.mr_n61734640)
print v(xbgr.mr_n62217456)
print v(xbgr.mr_n62348240)
print v(xbgr.mr_n60198160)
print v(xbgr.mr_n60410128)
print v(xbgr.mr_n60585328)
print v(xbgr.mr_n60784016)
print v(xbgr.mr_n60885968)
print v(xbgr.mr_n60985536)
print v(xbgr.mr_n61235376)
print v(xbgr.mr_n61441024)
print v(xbgr.mr_n60888416)
print v(xbgr.mr_n60987840)
print v(xbgr.mr_n61238464)
print v(xbgr.mr_n61443024)
print v(xbgr.mr_n62626496)
print v(xbgr.mr_n62890528)
print v(xbgr.mr_n63022352)
print v(xbgr.mr_n60198624)
print v(xbgr.mr_n60403024)
print v(xbgr.mr_n60585920)
print v(xbgr.mr_n60815360)
print v(xbgr.mr_n60824816)
print v(xbgr.mr_n60337664)
print v(xbgr.mr_n61107520)
print v(xbgr.mr_n61304160)
print v(xbgr.mr_n62624976)
print v(xbgr.mr_n62711936)
print v(xbgr.mr_n63008224)
print v(xbgr.mr_n60199088)
print v(xbgr.mr_n60386448)
print v(xbgr.mr_n60586512)
print v(xbgr.mr_n60815760)
print v(xbgr.mr_n62446352)
print v(xbgr.mr_n62674160)
print v(xbgr.mr_n62904112)
print v(xbgr.mr_n60874640)
print v(xbgr.mr_n60938256)
print v(xbgr.mr_n61205776)
print v(xbgr.mr_n61436032)
print v(xbgr.mr_n61575920)
print v(xbgr.mr_n61717696)
print v(xbgr.mr_n61772416)
print v(xbgr.mr_n61868880)
print v(xbgr.mr_n62001824)
print v(xbgr.mr_n62130416)
print v(xbgr.mr_n62243984)
print v(xbgr.mr_n62376944)
print v(xbgr.mr_n62629008)
print v(xbgr.mr_n62712832)
print v(xbgr.mr_n63078608)
print v(xbgr.mr_n61572864)
print v(xbgr.mr_n61718272)
print v(xbgr.mr_n61788560)
print v(xbgr.mr_n61870416)
print v(xbgr.mr_n62002720)
print v(xbgr.mr_n61735936)
print v(xbgr.mr_n62247776)
print v(xbgr.mr_n62385536)
print v(xbgr.mr_n60199552)
print v(xbgr.mr_n60397104)
print v(xbgr.mr_n60587104)
print v(xbgr.mr_n60793488)
print v(xbgr.mr_n61462624)
print v(xbgr.mr_n61589392)
print v(xbgr.mr_n61621840)
print v(xbgr.mr_n61805472)
print v(xbgr.mr_n61891824)
print v(xbgr.mr_n62025440)
print v(xbgr.mr_n62154224)
print v(xbgr.mr_n62299168)
print v(xbgr.mr_n60166224)
print v(xbgr.mr_n60412432)
print v(xbgr.mr_n60587696)
print v(xbgr.mr_n60816480)
print v(xbgr.mr_n62627840)
print v(xbgr.mr_n62889440)
print v(xbgr.mr_n63078832)
print v(xbgr.mr_n62628576)
print v(xbgr.mr_n62706720)
print v(xbgr.mr_n63080656)
print v(xbgr.mr_n60165760)
print v(xbgr.mr_n60413088)
print v(xbgr.mr_n60520800)
print v(xbgr.mr_n60816960)
print v(xbgr.mr_n61577680)
print v(xbgr.mr_n61716768)
print v(xbgr.mr_n61772064)
print v(xbgr.mr_n61868400)
print v(xbgr.mr_n62003904)
print v(xbgr.mr_n62132304)
print v(xbgr.mr_n62216864)
print v(xbgr.mr_n62347584)
print v(xbgr.mr_n60886448)
print v(xbgr.mr_n60988864)
print v(xbgr.mr_n61236416)
print v(xbgr.mr_n61434944)
print v(xbgr.mr_n60887760)
print v(xbgr.mr_n60982624)
print v(xbgr.mr_n61237136)
print v(xbgr.mr_n61439728)
print v(xbgr.mr_n62445888)
print v(xbgr.mr_n62673376)
print v(xbgr.mr_n62903520)
print v(xbgr.mr_n62622288)
print v(xbgr.mr_n62715616)
print v(xbgr.mr_n63078720)
print v(xbgr.mr_n60165296)
print v(xbgr.mr_n60413680)
print v(xbgr.mr_n60520208)
print v(xbgr.mr_n60800592)
print v(xbgr.mr_n60824544)
print v(xbgr.mr_n60340464)
print v(xbgr.mr_n61107248)
print v(xbgr.mr_n61302976)
print v(xbgr.mr_n60164832)
print v(xbgr.mr_n60414272)
print v(xbgr.mr_n60519616)
print v(xbgr.mr_n60818080)
print v(xbgr.mr_n62625888)
print v(xbgr.mr_n62888896)
print v(xbgr.mr_n63081264)
print v(xbgr.mr_n60875440)
print v(xbgr.mr_n60801664)
print v(xbgr.mr_n61206320)
print v(xbgr.mr_n61439056)
print v(xbgr.mr_n61574864)
print v(xbgr.mr_n61723664)
print v(xbgr.mr_n61789248)
print v(xbgr.mr_n61871296)
print v(xbgr.mr_n62004784)
print v(xbgr.mr_n62130960)
print v(xbgr.mr_n62247552)
print v(xbgr.mr_n62380512)
print v(xbgr.mr_n60164368)
print v(xbgr.mr_n60414864)
print v(xbgr.mr_n60519024)
print v(xbgr.mr_n60818560)
print v(xbgr.mr_n61578400)
print v(xbgr.mr_n61716880)
print v(xbgr.mr_n61771520)
print v(xbgr.mr_n61867024)
print v(xbgr.mr_n61997296)
print v(xbgr.mr_n62132192)
print v(xbgr.mr_n62252576)
print v(xbgr.mr_n62380624)
print v(xbgr.mr_n62629920)
print v(xbgr.mr_n62805312)
print v(xbgr.mr_n63087296)
print v(xbgr.mr_n62445424)
print v(xbgr.mr_n62672976)
print v(xbgr.mr_n62902928)
print v(xbgr.mr_n60163904)
print v(xbgr.mr_n60407760)
print v(xbgr.mr_n60518432)
print v(xbgr.mr_n60818960)
print v(xbgr.mr_n61462160)
print v(xbgr.mr_n61588464)
print v(xbgr.mr_n61620640)
print v(xbgr.mr_n61804928)
print v(xbgr.mr_n61892640)
print v(xbgr.mr_n62025168)
print v(xbgr.mr_n62153952)
print v(xbgr.mr_n62298896)
print v(xbgr.mr_n62629184)
print v(xbgr.mr_n62806496)
print v(xbgr.mr_n63086448)
print v(xbgr.mr_n60163440)
print v(xbgr.mr_n60399408)
print v(xbgr.mr_n60517840)
print v(xbgr.mr_n60311824)
print v(xbgr.mr_n61576032)
print v(xbgr.mr_n61718160)
print v(xbgr.mr_n61789680)
print v(xbgr.mr_n61874016)
print v(xbgr.mr_n62007568)
print v(xbgr.mr_n62134816)
print v(xbgr.mr_n62214496)
print v(xbgr.mr_n62351792)
print v(xbgr.mr_n60884000)
print v(xbgr.mr_n60985360)
print v(xbgr.mr_n61234416)
print v(xbgr.mr_n61435168)
print v(xbgr.mr_n62630528)
print v(xbgr.mr_n62886176)
print v(xbgr.mr_n63084880)
print v(xbgr.mr_n60885312)
print v(xbgr.mr_n60986640)
print v(xbgr.mr_n61235920)
print v(xbgr.mr_n61439168)
print v(xbgr.mr_n60162976)
print v(xbgr.mr_n60416576)
print v(xbgr.mr_n60515568)
print v(xbgr.mr_n60820160)
print v(xbgr.mr_n62627232)
print v(xbgr.mr_n62807088)
print v(xbgr.mr_n63081152)
print v(xbgr.mr_n60824272)
print v(xbgr.mr_n60346176)
print v(xbgr.mr_n61106976)
print v(xbgr.mr_n61301792)
print v(xbgr.mr_n60162512)
print v(xbgr.mr_n60411376)
print v(xbgr.mr_n60592640)
print v(xbgr.mr_n60607728)
print v(xbgr.mr_n62444496)
print v(xbgr.mr_n62672864)
print v(xbgr.mr_n62901840)
print v(xbgr.mr_n62631264)
print v(xbgr.mr_n62804720)
print v(xbgr.mr_n63089040)
print v(xbgr.mr_n60858000)
print v(xbgr.mr_n60935232)
print v(xbgr.mr_n61153008)
print v(xbgr.mr_n61437200)
print v(xbgr.mr_n60162048)
print v(xbgr.mr_n60410720)
print v(xbgr.mr_n60594080)
print v(xbgr.mr_n60590544)
print v(xbgr.mr_n61574512)
print v(xbgr.mr_n61724096)
print v(xbgr.mr_n61789984)
print v(xbgr.mr_n61871728)
print v(xbgr.mr_n62003248)
print v(xbgr.mr_n62134448)
print v(xbgr.mr_n62248784)
print v(xbgr.mr_n62359072)
print v(xbgr.mr_n61577504)
print v(xbgr.mr_n61725376)
print v(xbgr.mr_n61772880)
print v(xbgr.mr_n61873584)
print v(xbgr.mr_n62008608)
print v(xbgr.mr_n62137392)
print v(xbgr.mr_n62247664)
print v(xbgr.mr_n62381744)
print v(xbgr.mr_n62630352)
print v(xbgr.mr_n62887264)
print v(xbgr.mr_n63087472)
print v(xbgr.mr_n60161584)
print v(xbgr.mr_n60418416)
print v(xbgr.mr_n60594480)
print v(xbgr.mr_n60049568)
print v(xbgr.mr_n61461696)
print v(xbgr.mr_n61588000)
print v(xbgr.mr_n61620368)
print v(xbgr.mr_n61804656)
print v(xbgr.mr_n61893456)
print v(xbgr.mr_n62024896)
print v(xbgr.mr_n62153680)
print v(xbgr.mr_n62298624)
print v(xbgr.mr_n62631872)
print v(xbgr.mr_n62804128)
print v(xbgr.mr_n63084704)
print v(xbgr.mr_n60161120)
print v(xbgr.mr_n60419008)
print v(xbgr.mr_n60592048)
print v(xbgr.mr_n60129776)
print v(xbgr.mr_n62444032)
print v(xbgr.mr_n62563088)
print v(xbgr.mr_n62901376)
print v(xbgr.mr_n61575568)
print v(xbgr.mr_n61726592)
print v(xbgr.mr_n61792176)
print v(xbgr.mr_n61873040)
print v(xbgr.mr_n62002368)
print v(xbgr.mr_n62134032)
print v(xbgr.mr_n62213904)
print v(xbgr.mr_n62349360)
print v(xbgr.mr_n60881856)
print v(xbgr.mr_n60979536)
print v(xbgr.mr_n61227744)
print v(xbgr.mr_n61437312)
print v(xbgr.mr_n62634304)
print v(xbgr.mr_n62803536)
print v(xbgr.mr_n63082768)
print v(xbgr.mr_n60884656)
print v(xbgr.mr_n60986992)
print v(xbgr.mr_n61233872)
print v(xbgr.mr_n61437872)
print v(xbgr.mr_n60160656)
print v(xbgr.mr_n60419600)
print v(xbgr.mr_n60596400)
print v(xbgr.mr_n60512272)
print v(xbgr.mr_n60824000)
print v(xbgr.mr_n60124416)
print v(xbgr.mr_n61106704)
print v(xbgr.mr_n61300608)
print v(xbgr.mr_n60160192)
print v(xbgr.mr_n60420192)
print v(xbgr.mr_n60596800)
print v(xbgr.mr_n60089840)
print v(xbgr.mr_n62633216)
print v(xbgr.mr_n63090032)
print v(xbgr.mr_n60159728)
print v(xbgr.mr_n60404208)
print v(xbgr.mr_n60598000)
print v(xbgr.mr_n60092688)
print v(xbgr.mr_n62633872)
print v(xbgr.mr_n63094976)
print v(xbgr.mr_n60872480)
print v(xbgr.mr_n60937056)
print v(xbgr.mr_n61205200)
print v(xbgr.mr_n61435056)
print v(xbgr.mr_n61573360)
print v(xbgr.mr_n61724960)
print v(xbgr.mr_n61792992)
print v(xbgr.mr_n61876000)
print v(xbgr.mr_n62005904)
print v(xbgr.mr_n62138272)
print v(xbgr.mr_n62221600)
print v(xbgr.mr_n62376720)
print v(xbgr.mr_n61569296)
print v(xbgr.mr_n61726160)
print v(xbgr.mr_n61791392)
print v(xbgr.mr_n61869728)
print v(xbgr.mr_n62010608)
print v(xbgr.mr_n62132416)
print v(xbgr.mr_n62243760)
print v(xbgr.mr_n62376832)
print v(xbgr.mr_n62443568)
print v(xbgr.mr_n62900912)
print v(xbgr.mr_n60159264)
print v(xbgr.mr_n60421312)
print v(xbgr.mr_n60598400)
print v(xbgr.mr_n60572304)
print v(xbgr.mr_n62631696)
print v(xbgr.mr_n63094160)
print v(xbgr.mr_n61461232)
print v(xbgr.mr_n61587072)
print v(xbgr.mr_n61621008)
print v(xbgr.mr_n61804112)
print v(xbgr.mr_n61894000)
print v(xbgr.mr_n62024352)
print v(xbgr.mr_n62153136)
print v(xbgr.mr_n62298080)
print v(xbgr.mr_n60158800)
print v(xbgr.mr_n60417744)
print v(xbgr.mr_n60599600)
print v(xbgr.mr_n60475248)
print v(xbgr.mr_n62633040)
print v(xbgr.mr_n63092592)
print v(xbgr.mr_n61572400)
print v(xbgr.mr_n60924896)
print v(xbgr.mr_n61795136)
print v(xbgr.mr_n61878720)
print v(xbgr.mr_n62012208)
print v(xbgr.mr_n62135232)
print v(xbgr.mr_n62215088)
print v(xbgr.mr_n62350016)
print v(xbgr.mr_n60883344)
print v(xbgr.mr_n60979712)
print v(xbgr.mr_n61230288)
print v(xbgr.mr_n61422464)
print v(xbgr.mr_n60158336)
print v(xbgr.mr_n60422560)
print v(xbgr.mr_n60600400)
print v(xbgr.mr_n60512752)
print v(xbgr.mr_n60881376)
print v(xbgr.mr_n60984080)
print v(xbgr.mr_n61233376)
print v(xbgr.mr_n61435856)
print v(xbgr.mr_n62634480)
print v(xbgr.mr_n63089856)
print v(xbgr.mr_n62442640)
print v(xbgr.mr_n62899984)
print v(xbgr.mr_n60157872)
print v(xbgr.mr_n60417232)
print v(xbgr.mr_n60600800)
print v(xbgr.mr_n60602800)
print v(xbgr.mr_n60823728)
print v(xbgr.mr_n59989120)
print v(xbgr.mr_n61106432)
print v(xbgr.mr_n61299424)
print v(xbgr.mr_n62636992)
print v(xbgr.mr_n63096720)
print v(xbgr.mr_n60157408)
print v(xbgr.mr_n60411840)
print v(xbgr.mr_n60601600)
print v(xbgr.mr_n60090592)
print v(xbgr.mr_n60868640)
print v(xbgr.mr_n60932208)
print v(xbgr.mr_n61205504)
print v(xbgr.mr_n61431232)
print v(xbgr.mr_n61570256)
print v(xbgr.mr_n61662448)
print v(xbgr.mr_n61793728)
print v(xbgr.mr_n61878288)
print v(xbgr.mr_n62011776)
print v(xbgr.mr_n62140560)
print v(xbgr.mr_n62244992)
print v(xbgr.mr_n62361840)
print v(xbgr.mr_n62632608)
print v(xbgr.mr_n63095152)
print v(xbgr.mr_n61569680)
print v(xbgr.mr_n61676368)
print v(xbgr.mr_n61791744)
print v(xbgr.mr_n61879824)
print v(xbgr.mr_n62013312)
print v(xbgr.mr_n62142096)
print v(xbgr.mr_n62243872)
print v(xbgr.mr_n62373152)
print v(xbgr.mr_n60156944)
print v(xbgr.mr_n60424272)
print v(xbgr.mr_n60602400)
print v(xbgr.mr_n60478320)
print v(xbgr.mr_n62635824)
print v(xbgr.mr_n63092416)
print v(xbgr.mr_n61460768)
print v(xbgr.mr_n61586608)
print v(xbgr.mr_n61647344)
print v(xbgr.mr_n61803840)
print v(xbgr.mr_n61893728)
print v(xbgr.mr_n62024080)
print v(xbgr.mr_n62152864)
print v(xbgr.mr_n62297808)
print v(xbgr.mr_n60156480)
print v(xbgr.mr_n60424928)
print v(xbgr.mr_n60603600)
print v(xbgr.mr_n59992864)
print v(xbgr.mr_n62442176)
print v(xbgr.mr_n62899520)
print v(xbgr.mr_n62636560)
print v(xbgr.mr_n63099280)
print v(xbgr.mr_n60156016)
print v(xbgr.mr_n60382832)
print v(xbgr.mr_n60604000)
print v(xbgr.mr_n60512432)
print v(xbgr.mr_n61565440)
print v(xbgr.mr_n61683024)
print v(xbgr.mr_n61795920)
print v(xbgr.mr_n61875120)
print v(xbgr.mr_n62009488)
print v(xbgr.mr_n61738032)
print v(xbgr.mr_n62216272)
print v(xbgr.mr_n62344032)
print v(xbgr.mr_n60882688)
print v(xbgr.mr_n60983728)
print v(xbgr.mr_n61231328)
print v(xbgr.mr_n61433584)
print v(xbgr.mr_n60885136)
print v(xbgr.mr_n60983904)
print v(xbgr.mr_n61232048)
print v(xbgr.mr_n61431904)
print v(xbgr.mr_n62635648)
print v(xbgr.mr_n62885088)
print v(xbgr.mr_n63097712)
print v(xbgr.mr_n60155552)
print v(xbgr.mr_n60423152)
print v(xbgr.mr_n60604800)
print v(xbgr.mr_n60297088)
print v(xbgr.mr_n60823456)
print v(xbgr.mr_n60021296)
print v(xbgr.mr_n61106160)
print v(xbgr.mr_n61298240)
print v(xbgr.mr_n62637168)
print v(xbgr.mr_n62802944)
print v(xbgr.mr_n63091600)
print v(xbgr.mr_n60155088)
print v(xbgr.mr_n60426624)
print v(xbgr.mr_n60606000)
print v(xbgr.mr_n60299840)
print v(xbgr.mr_n62441712)
print v(xbgr.mr_n62562896)
print v(xbgr.mr_n62899056)
print v(xbgr.mr_n60814560)
print v(xbgr.mr_n60930816)
print v(xbgr.mr_n61205312)
print v(xbgr.mr_n61432080)
print v(xbgr.mr_n61562528)
print v(xbgr.mr_n61645888)
print v(xbgr.mr_n61793424)
print v(xbgr.mr_n61880704)
print v(xbgr.mr_n62014192)
print v(xbgr.mr_n62142976)
print v(xbgr.mr_n62231056)
print v(xbgr.mr_n62373040)
print v(xbgr.mr_n62637904)
print v(xbgr.mr_n62802352)
print v(xbgr.mr_n63101840)
print v(xbgr.mr_n61563824)
print v(xbgr.mr_n61717344)
print v(xbgr.mr_n61797456)
print v(xbgr.mr_n61876432)
print v(xbgr.mr_n62009920)
print v(xbgr.mr_n62138704)
print v(xbgr.mr_n62239968)
print v(xbgr.mr_n62377952)
print v(xbgr.mr_n60154624)
print v(xbgr.mr_n60427296)
print v(xbgr.mr_n60606400)
print v(xbgr.mr_n60297440)
print v(xbgr.mr_n61460304)
print v(xbgr.mr_n61585680)
print v(xbgr.mr_n61622896)
print v(xbgr.mr_n61803568)
print v(xbgr.mr_n61893184)
print v(xbgr.mr_n62023536)
print v(xbgr.mr_n62152320)
print v(xbgr.mr_n62297264)
print v(xbgr.mr_n60004576)
print v(xbgr.mr_n60415984)
print v(xbgr.mr_n60595680)
print v(xbgr.mr_n60354224)
print v(xbgr.mr_n62638512)
print v(xbgr.mr_n62884544)
print v(xbgr.mr_n63100272)
print v(xbgr.mr_n60153696)
print v(xbgr.mr_n60420784)
print v(xbgr.mr_n60608320)
print v(xbgr.mr_n60088688)
print v(xbgr.mr_n62635216)
print v(xbgr.mr_n62801760)
print v(xbgr.mr_n63105216)
print v(xbgr.mr_n61522880)
print v(xbgr.mr_n61670032)
print v(xbgr.mr_n61797152)
print v(xbgr.mr_n61881136)
print v(xbgr.mr_n62012624)
print v(xbgr.mr_n62141408)
print v(xbgr.mr_n62215680)
print v(xbgr.mr_n62346464)
print v(xbgr.mr_n60882032)
print v(xbgr.mr_n60978672)
print v(xbgr.mr_n61229328)
print v(xbgr.mr_n61431728)
print v(xbgr.mr_n60884480)
print v(xbgr.mr_n60982448)
print v(xbgr.mr_n61230832)
print v(xbgr.mr_n61430384)
print v(xbgr.mr_n62440784)
print v(xbgr.mr_n62583856)
print v(xbgr.mr_n62898128)
print v(xbgr.mr_n60153232)
print v(xbgr.mr_n60429008)
print v(xbgr.mr_n60610096)
print v(xbgr.mr_n60297952)
print v(xbgr.mr_n62639248)
print v(xbgr.mr_n62801168)
print v(xbgr.mr_n63104400)
print v(xbgr.mr_n60823184)
print v(xbgr.mr_n60018864)
print v(xbgr.mr_n61105888)
print v(xbgr.mr_n61297056)
print v(xbgr.mr_n60152768)
print v(xbgr.mr_n60429664)
print v(xbgr.mr_n60611280)
print v(xbgr.mr_n60472448)
print v(xbgr.mr_n62638336)
print v(xbgr.mr_n62883456)
print v(xbgr.mr_n63102832)
print v(xbgr.mr_n60870640)
print v(xbgr.mr_n60930704)
print v(xbgr.mr_n61204864)
print v(xbgr.mr_n61430032)
print v(xbgr.mr_n60152304)
print v(xbgr.mr_n60430256)
print v(xbgr.mr_n60611872)
print v(xbgr.mr_n60644864)
print v(xbgr.mr_n61566240)
print v(xbgr.mr_n61683216)
print v(xbgr.mr_n61790544)
print v(xbgr.mr_n61881824)
print v(xbgr.mr_n62016480)
print v(xbgr.mr_n62146800)
print v(xbgr.mr_n62241200)
print v(xbgr.mr_n62366848)
print v(xbgr.mr_n61567296)
print v(xbgr.mr_n61665104)
print v(xbgr.mr_n61795488)
print v(xbgr.mr_n61879136)
print v(xbgr.mr_n62018016)
print v(xbgr.mr_n62145264)
print v(xbgr.mr_n62240080)
print v(xbgr.mr_n62369424)
print v(xbgr.mr_n62640592)
print v(xbgr.mr_n62800224)
print v(xbgr.mr_n63100096)
print v(xbgr.mr_n62440320)
print v(xbgr.mr_n62561840)
print v(xbgr.mr_n62897664)
print v(xbgr.mr_n60151840)
print v(xbgr.mr_n60430848)
print v(xbgr.mr_n60613056)
print v(xbgr.mr_n60644272)
print v(xbgr.mr_n61459840)
print v(xbgr.mr_n61585216)
print v(xbgr.mr_n61603760)
print v(xbgr.mr_n61803296)
print v(xbgr.mr_n61892912)
print v(xbgr.mr_n62023264)
print v(xbgr.mr_n62152048)
print v(xbgr.mr_n62296992)
print v(xbgr.mr_n62642368)
print v(xbgr.mr_n62799392)
print v(xbgr.mr_n63102656)
print v(xbgr.mr_n60151376)
print v(xbgr.mr_n60423664)
print v(xbgr.mr_n60613648)
print v(xbgr.mr_n60643680)
print v(xbgr.mr_n61563392)
print v(xbgr.mr_n61667376)
print v(xbgr.mr_n61798080)
print v(xbgr.mr_n61884528)
print v(xbgr.mr_n62015936)
print v(xbgr.mr_n62140016)
print v(xbgr.mr_n62211104)
print v(xbgr.mr_n62345808)
print v(xbgr.mr_n60882512)
print v(xbgr.mr_n60977456)
print v(xbgr.mr_n61225264)
print v(xbgr.mr_n61430208)
print v(xbgr.mr_n60883824)
print v(xbgr.mr_n60980992)
print v(xbgr.mr_n61228784)
print v(xbgr.mr_n61423200)
print v(xbgr.mr_n62639680)
print v(xbgr.mr_n62880736)
print v(xbgr.mr_n63105392)
print v(xbgr.mr_n60150912)
print v(xbgr.mr_n60432096)
print v(xbgr.mr_n60612464)
print v(xbgr.mr_n60643088)
print v(xbgr.mr_n62641200)
print v(xbgr.mr_n62748416)
print v(xbgr.mr_n63106960)
print v(xbgr.mr_n60822912)
print v(xbgr.mr_n60345168)
print v(xbgr.mr_n61105696)
print v(xbgr.mr_n61295872)
print v(xbgr.mr_n60150448)
print v(xbgr.mr_n60421968)
print v(xbgr.mr_n60610688)
print v(xbgr.mr_n60642496)
print v(xbgr.mr_n62439856)
print v(xbgr.mr_n62573968)
print v(xbgr.mr_n62897200)
print v(xbgr.mr_n62614032)
print v(xbgr.mr_n62750256)
print v(xbgr.mr_n63109520)
print v(xbgr.mr_n60149984)
print v(xbgr.mr_n60433152)
print v(xbgr.mr_n60609504)
print v(xbgr.mr_n60641904)
print v(xbgr.mr_n60867504)
print v(xbgr.mr_n60931008)
print v(xbgr.mr_n61186112)
print v(xbgr.mr_n61428768)
print v(xbgr.mr_n61557616)
print v(xbgr.mr_n61666352)
print v(xbgr.mr_n61800464)
print v(xbgr.mr_n61883488)
print v(xbgr.mr_n62018896)
print v(xbgr.mr_n62147680)
print v(xbgr.mr_n62223968)
print v(xbgr.mr_n62369312)
print v(xbgr.mr_n61561728)
print v(xbgr.mr_n61664816)
print v(xbgr.mr_n61798864)
print v(xbgr.mr_n61886528)
print v(xbgr.mr_n62014624)
print v(xbgr.mr_n62143408)
print v(xbgr.mr_n62236176)
print v(xbgr.mr_n62374160)
print v(xbgr.mr_n60149520)
print v(xbgr.mr_n60433808)
print v(xbgr.mr_n60608912)
print v(xbgr.mr_n60641312)
print v(xbgr.mr_n62613856)
print v(xbgr.mr_n62882912)
print v(xbgr.mr_n63097536)
print v(xbgr.mr_n61459376)
print v(xbgr.mr_n61584288)
print v(xbgr.mr_n61672688)
print v(xbgr.mr_n61803024)
print v(xbgr.mr_n61892368)
print v(xbgr.mr_n62022720)
print v(xbgr.mr_n62151504)
print v(xbgr.mr_n62296448)
print v(xbgr.mr_n62608768)
print v(xbgr.mr_n62792288)
print v(xbgr.mr_n63112896)
print v(xbgr.mr_n60149056)
print v(xbgr.mr_n60434400)
print v(xbgr.mr_n60607200)
print v(xbgr.mr_n60640720)
print v(xbgr.mr_n62438928)
print v(xbgr.mr_n62587360)
print v(xbgr.mr_n62896272)
print v(xbgr.mr_n61562704)
print v(xbgr.mr_n61669680)
print v(xbgr.mr_n61800048)
print v(xbgr.mr_n61885840)
print v(xbgr.mr_n62018544)
print v(xbgr.mr_n62147328)
print v(xbgr.mr_n62211440)
print v(xbgr.mr_n62344688)
print v(xbgr.mr_n60880448)
print v(xbgr.mr_n60979360)
print v(xbgr.mr_n61226784)
print v(xbgr.mr_n61428592)
print v(xbgr.mr_n60883168)
print v(xbgr.mr_n60964944)
print v(xbgr.mr_n61228288)
print v(xbgr.mr_n61426064)
print v(xbgr.mr_n62610432)
print v(xbgr.mr_n62800048)
print v(xbgr.mr_n63112080)
print v(xbgr.mr_n60148592)
print v(xbgr.mr_n60434992)
print v(xbgr.mr_n60606800)
print v(xbgr.mr_n60640128)
print v(xbgr.mr_n60822640)
print v(xbgr.mr_n60894544)
print v(xbgr.mr_n61105584)
print v(xbgr.mr_n61294688)
print v(xbgr.mr_n60148128)
print v(xbgr.mr_n60435584)
print v(xbgr.mr_n60605600)
print v(xbgr.mr_n60639536)
print v(xbgr.mr_n62610608)
print v(xbgr.mr_n62882368)
print v(xbgr.mr_n63107776)
print v(xbgr.mr_n60147664)
print v(xbgr.mr_n60415456)
print v(xbgr.mr_n60590080)
print v(xbgr.mr_n60638944)
print v(xbgr.mr_n62611728)
print v(xbgr.mr_n62797616)
print v(xbgr.mr_n63110512)
print v(xbgr.mr_n60857776)
print v(xbgr.mr_n60926512)
print v(xbgr.mr_n61204976)
print v(xbgr.mr_n61426912)
print v(xbgr.mr_n61560672)
print v(xbgr.mr_n61725744)
print v(xbgr.mr_n61794288)
print v(xbgr.mr_n61877664)
print v(xbgr.mr_n62015312)
print v(xbgr.mr_n62144096)
print v(xbgr.mr_n62237408)
print v(xbgr.mr_n62361648)
print v(xbgr.mr_n61555104)
print v(xbgr.mr_n61664304)
print v(xbgr.mr_n61798432)
print v(xbgr.mr_n61883840)
print v(xbgr.mr_n62013840)
print v(xbgr.mr_n62140992)
print v(xbgr.mr_n62236288)
print v(xbgr.mr_n62370368)
print v(xbgr.mr_n62438464)
print v(xbgr.mr_n62580032)
print v(xbgr.mr_n62895872)
print v(xbgr.mr_n60147200)
print v(xbgr.mr_n60436688)
print v(xbgr.mr_n60604400)
print v(xbgr.mr_n60638352)
print v(xbgr.mr_n62609872)
print v(xbgr.mr_n62798272)
print v(xbgr.mr_n63114640)
print v(xbgr.mr_n61458912)
print v(xbgr.mr_n61583824)
print v(xbgr.mr_n61666928)
print v(xbgr.mr_n61802752)
print v(xbgr.mr_n61892096)
print v(xbgr.mr_n62022448)
print v(xbgr.mr_n62151232)
print v(xbgr.mr_n62296176)
print v(xbgr.mr_n60146736)
print v(xbgr.mr_n60437360)
print v(xbgr.mr_n60603200)
print v(xbgr.mr_n60637760)
print v(xbgr.mr_n62608272)
print v(xbgr.mr_n62879104)
print v(xbgr.mr_n63113072)
print v(xbgr.mr_n61560848)
print v(xbgr.mr_n61668992)
print v(xbgr.mr_n61796304)
print v(xbgr.mr_n61885408)
print v(xbgr.mr_n62007920)
print v(xbgr.mr_n62142624)
print v(xbgr.mr_n62144720)
print v(xbgr.mr_n62293968)
print v(xbgr.mr_n60146272)
print v(xbgr.mr_n60437952)
print v(xbgr.mr_n60592304)
print v(xbgr.mr_n60637168)
print v(xbgr.mr_n60879984)
print v(xbgr.mr_n60966784)
print v(xbgr.mr_n61206592)
print v(xbgr.mr_n61420608)
print v(xbgr.mr_n60880912)
print v(xbgr.mr_n60940080)
print v(xbgr.mr_n61226240)
print v(xbgr.mr_n61426736)
print v(xbgr.mr_n62599856)
print v(xbgr.mr_n62795840)
print v(xbgr.mr_n63110336)
print v(xbgr.mr_n60145808)
print v(xbgr.mr_n60428416)
print v(xbgr.mr_n60602000)
print v(xbgr.mr_n60636576)
print v(xbgr.mr_n62438000)
print v(xbgr.mr_n62581024)
print v(xbgr.mr_n62895600)
print v(xbgr.mr_n60822368)
print v(xbgr.mr_n60894736)
print v(xbgr.mr_n61105472)
print v(xbgr.mr_n61293568)
print v(xbgr.mr_n62601152)
print v(xbgr.mr_n62796496)
print v(xbgr.mr_n63117200)
print v(xbgr.mr_n60145344)
print v(xbgr.mr_n60439136)
print v(xbgr.mr_n60601200)
print v(xbgr.mr_n60635984)
print v(xbgr.mr_n60869440)
print v(xbgr.mr_n60918272)
print v(xbgr.mr_n61186000)
print v(xbgr.mr_n61424880)
print v(xbgr.mr_n61558592)
print v(xbgr.mr_n61724400)
print v(xbgr.mr_n61792576)
print v(xbgr.mr_n61882448)
print v(xbgr.mr_n62005216)
print v(xbgr.mr_n62139392)
print v(xbgr.mr_n62232384)
print v(xbgr.mr_n62358896)
print v(xbgr.mr_n61556576)
print v(xbgr.mr_n61716432)
print v(xbgr.mr_n61794704)
print v(xbgr.mr_n61887696)
print v(xbgr.mr_n62006448)
print v(xbgr.mr_n62137920)
print v(xbgr.mr_n62232496)
print v(xbgr.mr_n62366624)
print v(xbgr.mr_n62602256)
print v(xbgr.mr_n62879648)
print v(xbgr.mr_n63115632)
print v(xbgr.mr_n60144880)
print v(xbgr.mr_n60439728)
print v(xbgr.mr_n60600000)
print v(xbgr.mr_n60635392)
print v(xbgr.mr_n62606240)
print v(xbgr.mr_n62794064)
print v(xbgr.mr_n63107952)
print v(xbgr.mr_n61458448)
print v(xbgr.mr_n61582896)
print v(xbgr.mr_n61673888)
print v(xbgr.mr_n61802480)
print v(xbgr.mr_n61891552)
print v(xbgr.mr_n62021904)
print v(xbgr.mr_n62150688)
print v(xbgr.mr_n62295712)
print v(xbgr.mr_n60142768)
print v(xbgr.mr_n60425520)
print v(xbgr.mr_n60599200)
print v(xbgr.mr_n60634800)
print v(xbgr.mr_n62437072)
print v(xbgr.mr_n62582064)
print v(xbgr.mr_n62895056)
print v(xbgr.mr_n62601040)
print v(xbgr.mr_n62794720)
print v(xbgr.mr_n63119760)
print v(xbgr.mr_n60011600)
print v(xbgr.mr_n60372784)
print v(xbgr.mr_n60598800)
print v(xbgr.mr_n60634208)
print v(xbgr.mr_n61558416)
print v(xbgr.mr_n61723312)
print v(xbgr.mr_n61771408)
print v(xbgr.mr_n61884992)
print v(xbgr.mr_n62009136)
print v(xbgr.mr_n62132528)
print v(xbgr.mr_n62213312)
print v(xbgr.mr_n62342912)
print v(xbgr.mr_n60880800)
print v(xbgr.mr_n60949152)
print v(xbgr.mr_n61222656)
print v(xbgr.mr_n61424320)
print v(xbgr.mr_n60880336)
print v(xbgr.mr_n60975712)
print v(xbgr.mr_n61225744)
print v(xbgr.mr_n61425056)
print v(xbgr.mr_n60011136)
print v(xbgr.mr_n60365088)
print v(xbgr.mr_n60597600)
print v(xbgr.mr_n60633616)
print v(xbgr.mr_n62603184)
print v(xbgr.mr_n62877504)
print v(xbgr.mr_n63118192)
print v(xbgr.mr_n60822096)
print v(xbgr.mr_n59995712)
print v(xbgr.mr_n61105360)
print v(xbgr.mr_n61292768)
print v(xbgr.mr_n60010672)
print v(xbgr.mr_n60367456)
print v(xbgr.mr_n60597200)
print v(xbgr.mr_n60633024)
print v(xbgr.mr_n62591184)
print v(xbgr.mr_n62754608)
print v(xbgr.mr_n63115456)
print v(xbgr.mr_n62436608)
print v(xbgr.mr_n62576320)
print v(xbgr.mr_n62894784)
print v(xbgr.mr_n60867680)
print v(xbgr.mr_n60927024)
print v(xbgr.mr_n61204192)
print v(xbgr.mr_n61423024)
print v(xbgr.mr_n61559872)
print v(xbgr.mr_n61721024)
print v(xbgr.mr_n61788896)
print v(xbgr.mr_n61874432)
print v(xbgr.mr_n62001712)
print v(xbgr.mr_n62133392)
print v(xbgr.mr_n62223376)
print v(xbgr.mr_n62362416)
print v(xbgr.mr_n60010208)
print v(xbgr.mr_n60363840)
print v(xbgr.mr_n60596000)
print v(xbgr.mr_n60632432)
print v(xbgr.mr_n61544624)
print v(xbgr.mr_n61716544)
print v(xbgr.mr_n61790960)
print v(xbgr.mr_n61882992)
print v(xbgr.mr_n62007072)
print v(xbgr.mr_n62133120)
print v(xbgr.mr_n62232032)
print v(xbgr.mr_n62366736)
print v(xbgr.mr_n62598528)
print v(xbgr.mr_n62792944)
print v(xbgr.mr_n63118016)
print v(xbgr.mr_n60009744)
print v(xbgr.mr_n60366208)
print v(xbgr.mr_n60595280)
print v(xbgr.mr_n60631840)
print v(xbgr.mr_n61457984)
print v(xbgr.mr_n61582432)
print v(xbgr.mr_n61668624)
print v(xbgr.mr_n61802288)
print v(xbgr.mr_n61891280)
print v(xbgr.mr_n62021632)
print v(xbgr.mr_n62150416)
print v(xbgr.mr_n62295600)
print v(xbgr.mr_n62598352)
print v(xbgr.mr_n62870880)
print v(xbgr.mr_n63120752)
print v(xbgr.mr_n60009280)
print v(xbgr.mr_n60361536)
print v(xbgr.mr_n60594880)
print v(xbgr.mr_n60631248)
print v(xbgr.mr_n62601264)
print v(xbgr.mr_n62790512)
print v(xbgr.mr_n63125696)
print v(xbgr.mr_n61556400)
print v(xbgr.mr_n61716656)
print v(xbgr.mr_n61771072)
print v(xbgr.d4)
print v(xbgr.mr_n62004368)
print v(xbgr.mr_n62132080)
print v(xbgr.mr_n62149424)
print v(xbgr.mr_n62340976)
print v(xbgr.mr_n60879872)
print v(xbgr.mr_n60952176)
print v(xbgr.mr_n61223696)
print v(xbgr.mr_n61389696)
print v(xbgr.mr_n60881264)
print v(xbgr.mr_n60930176)
print v(xbgr.mr_n61224416)
print v(xbgr.mr_n61421344)
print v(xbgr.mr_n62436144)
print v(xbgr.mr_n62574816)
print v(xbgr.mr_n62894512)
print v(xbgr.mr_n60008816)
print v(xbgr.mr_n60359760)
print v(xbgr.mr_n60593680)
print v(xbgr.mr_n60630736)
print v(xbgr.mr_n62599296)
print v(xbgr.mr_n62791168)
print v(xbgr.mr_n63124880)
print v(xbgr.mr_n60816160)
print v(xbgr.mr_n60891216)
print v(xbgr.mr_n61066816)
print v(xbgr.mr_n61291968)
print v(xbgr.mr_n60008352)
print v(xbgr.mr_n60368048)
print v(xbgr.mr_n60593280)
print v(xbgr.mr_n60629216)
print v(xbgr.mr_n62595952)
print v(xbgr.mr_n62877840)
print v(xbgr.mr_n63120576)
print v(xbgr.mr_n60852016)
print v(xbgr.mr_n60115968)
print v(xbgr.mr_n61165024)
print v(xbgr.mr_n61420496)
print v(xbgr.mr_n60007888)
print v(xbgr.mr_n60363312)
print v(xbgr.mr_n60478736)
print v(xbgr.mr_n60821760)
print v(xbgr.mr_n61555968)
print v(xbgr.mr_n61700752)
print v(xbgr.mr_n61786640)
print v(xbgr.mr_n61877120)
print v(xbgr.mr_n62001360)
print v(xbgr.mr_n61734752)
print v(xbgr.mr_n62221008)
print v(xbgr.mr_n62362032)
print v(xbgr.mr_n61555280)
print v(xbgr.mr_n61710848)
print v(xbgr.mr_n61771184)
print v(xbgr.mr_n61866592)
print v(xbgr.mr_n62001248)
print v(xbgr.mr_n61735248)
print v(xbgr.mr_n62233616)
print v(xbgr.mr_n62367472)
print v(xbgr.mr_n62596064)
print v(xbgr.mr_n62788800)
print v(xbgr.mr_n63123312)
print v(xbgr.mr_n60007424)
print v(xbgr.mr_n60357456)
print v(xbgr.mr_n60479392)
print v(xbgr.mr_n60821360)
print v(xbgr.mr_n62435456)
print v(xbgr.mr_n62584560)
print v(xbgr.mr_n62893968)
print v(xbgr.mr_n61457520)
print v(xbgr.mr_n61581504)
print v(xbgr.mr_n61670640)
print v(xbgr.mr_n61802176)
print v(xbgr.mr_n61890736)
print v(xbgr.mr_n62021168)
print v(xbgr.mr_n62149952)
print v(xbgr.mr_n62295376)
print v(xbgr.mr_n62591536)
print v(xbgr.mr_n62789392)
print v(xbgr.mr_n63127440)
print v(xbgr.mr_n60006960)
print v(xbgr.mr_n60356944)
print v(xbgr.mr_n60477552)
print v(xbgr.mr_n60820960)
print v(xbgr.mr_n61543680)
print v(xbgr.mr_n61705376)
print v(xbgr.mr_n61771296)
print v(xbgr.mr_n61875584)
print v(xbgr.mr_n61999328)
print v(xbgr.mr_n61618512)
print v(xbgr.mr_n62210928)
print v(xbgr.mr_n62293168)
print v(xbgr.mr_n60873840)
print v(xbgr.mr_n61221696)
print v(xbgr.mr_n61418640)
print v(xbgr.mr_n60876304)
print v(xbgr.mr_n61223200)
print v(xbgr.mr_n61364768)
print v(xbgr.mr_n62594944)
print v(xbgr.mr_n62877616)
print v(xbgr.mr_n63123136)
print v(xbgr.mr_n60004848)
print v(xbgr.mr_n60364496)
print v(xbgr.mr_n60475776)
print v(xbgr.mr_n60820560)
print v(xbgr.mr_n60698064)
print v(xbgr.mr_n60677168)
print v(xbgr.mr_n62419328)
print v(xbgr.mr_n62787408)
print v(xbgr.mr_n63125872)
print v(xbgr.mr_n60792304)
print v(xbgr.mr_n60513168)
print v(xbgr.mr_n61103792)
print v(xbgr.mr_n61287024)
print v(xbgr.mr_n60202992)
print v(xbgr.n_23)
print v(xbgr.mr_n60443648)
print v(xbgr.mr_n60819680)
print v(xbgr.mr_n60683856)
print v(xbgr.mr_n62435152)
print v(xbgr.mr_n62402624)
print v(xbgr.mr_n62893776)
print v(xbgr.mr_n62593024)
print v(xbgr.mr_n62787872)
print v(xbgr.mr_n63130000)
print v(xbgr.n_12)
print v(xbgr.n_25)
print v(xbgr.mr_n60444048)
print v(xbgr.mr_n60817360)
print v(xbgr.mr_n60861184)
print v(xbgr.mr_n61181328)
print v(xbgr.mr_n61320960)
print v(xbgr.mr_n61545568)
print v(xbgr.mr_n61721296)
print v(xbgr.mr_n61787664)
print v(xbgr.mr_n61872416)
print v(xbgr.mr_n61995472)
print v(xbgr.mr_n62125584)
print v(xbgr.mr_n62231536)
print v(xbgr.mr_n62357120)
print v(xbgr.mr_n61547504)
print v(xbgr.mr_n61700640)
print v(xbgr.mr_n61773712)
print v(xbgr.mr_n61869312)
print v(xbgr.mr_n62000864)
print v(xbgr.mr_n62131584)
print v(xbgr.mr_n62220416)
print v(xbgr.mr_n62362224)
print v(xbgr.mr_n60003888)
print v(xbgr.mr_n60304176)
print v(xbgr.mr_n60443248)
print v(xbgr.mr_n60814880)
print v(xbgr.mr_n62592848)
print v(xbgr.mr_n62866240)
print v(xbgr.mr_n63128432)
print v(xbgr.mr_n61457056)
print v(xbgr.mr_n61581120)
print v(xbgr.mr_n61666544)
print v(xbgr.mr_n61799216)
print v(xbgr.mr_n61890544)
print v(xbgr.mr_n62021056)
print v(xbgr.mr_n62149840)
print v(xbgr.mr_n62291568)
print v(xbgr.n_17)
print v(xbgr.n_22)
print v(xbgr.mr_n60445248)
print v(xbgr.mr_n60812560)
print v(xbgr.mr_n62423328)
print v(xbgr.mr_n62736032)
print v(xbgr.mr_n63133376)
print v(xbgr.mr_n62434848)
print v(xbgr.mr_n62578592)
print v(xbgr.mr_n62893664)
print v(xbgr.mr_n61548448)
print v(xbgr.mr_n61709168)
print v(xbgr.mr_n61786256)
print v(xbgr.mr_n61870944)
print v(xbgr.mr_n61984096)
print v(xbgr.mr_n62129072)
print v(xbgr.mr_n62186624)
print v(xbgr.mr_n62340640)
print v(xbgr.mr_n60876480)
print v(xbgr.mr_n61208144)
print v(xbgr.mr_n61419488)
print v(xbgr.n_18)
print v(xbgr.mr_n60302352)
print v(xbgr.mr_n60474064)
print v(xbgr.mr_n60810560)
print v(xbgr.mr_n60878880)
print v(xbgr.mr_n61221152)
print v(xbgr.mr_n61419312)
print v(xbgr.mr_n62586160)
print v(xbgr.mr_n62786480)
print v(xbgr.mr_n63132560)
print v(xbgr.mr_n60801776)
print v(xbgr.mr_n60068784)
print v(xbgr.mr_n60200128)
print v(xbgr.mr_n60301440)
print v(xbgr.mr_n60474656)
print v(xbgr.mr_n60808352)
print v(xbgr.mr_n60817760)
print v(xbgr.mr_n60805824)
print v(xbgr.mr_n61099792)
print v(xbgr.mr_n61288864)
print v(xbgr.mr_n62589680)
print v(xbgr.mr_n62873200)
print v(xbgr.mr_n63130992)
print v(xbgr.mr_n60729936)
print v(xbgr.mr_n60093744)
print v(xbgr.mr_n60300496)
print v(xbgr.mr_n60473472)
print v(xbgr.mr_n60807120)
print v(xbgr.mr_n60865680)
print v(xbgr.mr_n61183760)
print v(xbgr.mr_n61320624)
print v(xbgr.mr_n62420128)
print v(xbgr.mr_n62750480)
print v(xbgr.mr_n63135936)
print v(xbgr.mr_n61553344)
print v(xbgr.mr_n61623504)
print v(xbgr.mr_n61784944)
print v(xbgr.mr_n61862800)
print v(xbgr.mr_n61991056)
print v(xbgr.mr_n62113200)
print v(xbgr.mr_n62222784)
print v(xbgr.mr_n62361456)
print v(xbgr.mr_n61533872)
print v(xbgr.mr_n61626160)
print v(xbgr.mr_n61731088)
print v(xbgr.mr_n61619824)
print v(xbgr.mr_n61983120)
print v(xbgr.mr_n62123520)
print v(xbgr.mr_n62229136)
print v(xbgr.mr_n62363360)
print v(xbgr.mr_n62412928)
print v(xbgr.mr_n62579808)
print v(xbgr.mr_n62887808)
print v(xbgr.mr_n60142576)
print v(xbgr.mr_n60170864)
print v(xbgr.mr_n60471568)
print v(xbgr.mr_n60649872)
print v(xbgr.mr_n62589856)
print v(xbgr.mr_n62746352)
print v(xbgr.mr_n63135120)
print v(xbgr.mr_n61456592)
print v(xbgr.mr_n61578736)
print v(xbgr.mr_n61625168)
print v(xbgr.mr_n61800896)
print v(xbgr.mr_n61889616)
print v(xbgr.mr_n62019328)
print v(xbgr.mr_n62148112)
print v(xbgr.mr_n62294768)
print v(xbgr.mr_n62481488)
print v(xbgr.mr_n62872864)
print v(xbgr.mr_n63133552)
print v(xbgr.mr_n60697184)
print v(xbgr.mr_n61543456)
print v(xbgr.mr_n61577024)
print v(xbgr.mr_n61782112)
print v(xbgr.mr_n61866176)
print v(xbgr.mr_n61997408)
print v(xbgr.mr_n62125360)
print v(xbgr.mr_n62145696)
print v(xbgr.mr_n62294144)
print v(xbgr.mr_n60879760)
print v(xbgr.mr_n61219424)
print v(xbgr.mr_n61362592)
print v(xbgr.mr_n60871440)
print v(xbgr.mr_n61207408)
print v(xbgr.mr_n61395216)
print v(xbgr.mr_n62505200)
print v(xbgr.mr_n62643712)
print v(xbgr.mr_n63130816)
print v(xbgr.mr_n60029744)
print v(xbgr.mr_n62424128)
print v(xbgr.mr_n62579520)
print v(xbgr.mr_n62893248)
print v(xbgr.mr_n60805280)
print v(xbgr.mr_n60509040)
print v(xbgr.mr_n61104752)
print v(xbgr.mr_n61239504)
print v(xbgr.mr_n60289696)
print v(xbgr.mr_n62505008)
print v(xbgr.mr_n62740160)
print v(xbgr.mr_n63122320)
print v(xbgr.mr_n60862128)
print v(xbgr.mr_n61187200)
print v(xbgr.mr_n61364960)
print v(dvbe)
print v(iptat)
print v(pbias)
print v(pcasc)
print v(r4)
print v(vbe)
print v(vdd)
print v(vref)
print v(vdd)-v(vdd)
echo METALLIC_POINT_VOLTAGES_END
echo METALLIC_ALL_NODE_VOLTAGES_BEGIN
print v(xbgr.b1b)
print v(xbgr.c2)
print v(xbgr.d1)
print v(xbgr.d2)
print v(xbgr.d3)
print v(xbgr.d4)
print v(xbgr.d5)
print v(xbgr.det)
print v(dvbe)
print v(iptat)
print v(xbgr.kick)
print v(xbgr.mr_n46872368)
print v(xbgr.mr_n46917984)
print v(xbgr.mr_n49355840)
print v(xbgr.mr_n49396432)
print v(xbgr.mr_n49676832)
print v(xbgr.mr_n49676944)
print v(xbgr.mr_n49677264)
print v(xbgr.mr_n49677376)
print v(xbgr.mr_n49677792)
print v(xbgr.mr_n49677904)
print v(xbgr.mr_n49678224)
print v(xbgr.mr_n49678336)
print v(xbgr.mr_n49678768)
print v(xbgr.mr_n49679008)
print v(xbgr.mr_n49679120)
print v(xbgr.mr_n49679472)
print v(xbgr.mr_n49679792)
print v(xbgr.mr_n49679904)
print v(xbgr.mr_n49680336)
print v(xbgr.mr_n49680656)
print v(xbgr.mr_n49680768)
print v(xbgr.mr_n49681200)
print v(xbgr.mr_n49681520)
print v(xbgr.mr_n49681632)
print v(xbgr.mr_n49682064)
print v(xbgr.mr_n49682384)
print v(xbgr.mr_n49682496)
print v(xbgr.mr_n49682928)
print v(xbgr.mr_n49683248)
print v(xbgr.mr_n49683360)
print v(xbgr.mr_n49683792)
print v(xbgr.mr_n49684112)
print v(xbgr.mr_n49684224)
print v(xbgr.mr_n49684656)
print v(xbgr.mr_n49684976)
print v(xbgr.mr_n49685088)
print v(xbgr.mr_n49685520)
print v(xbgr.mr_n49685840)
print v(xbgr.mr_n49685952)
print v(xbgr.mr_n49686384)
print v(xbgr.mr_n49686704)
print v(xbgr.mr_n49686816)
print v(xbgr.mr_n49687248)
print v(xbgr.mr_n49687568)
print v(xbgr.mr_n49687680)
print v(xbgr.mr_n49688112)
print v(xbgr.mr_n49688432)
print v(xbgr.mr_n49688544)
print v(xbgr.mr_n49688976)
print v(xbgr.mr_n49689296)
print v(xbgr.mr_n49689408)
print v(xbgr.mr_n49689840)
print v(xbgr.mr_n49690160)
print v(xbgr.mr_n49690272)
print v(xbgr.mr_n49690704)
print v(xbgr.mr_n49691024)
print v(xbgr.mr_n49691136)
print v(xbgr.mr_n49691568)
print v(xbgr.mr_n49691888)
print v(xbgr.mr_n49692000)
print v(xbgr.mr_n49692432)
print v(xbgr.mr_n49692752)
print v(xbgr.mr_n49692864)
print v(xbgr.mr_n49693184)
print v(xbgr.mr_n49693296)
print v(xbgr.mr_n49693616)
print v(xbgr.mr_n49693728)
print v(xbgr.mr_n49694048)
print v(xbgr.mr_n49694160)
print v(xbgr.mr_n49694480)
print v(xbgr.mr_n49694592)
print v(xbgr.mr_n49694912)
print v(xbgr.mr_n49695024)
print v(xbgr.mr_n49695344)
print v(xbgr.mr_n49695456)
print v(xbgr.mr_n49695776)
print v(xbgr.mr_n49695888)
print v(xbgr.mr_n49696208)
print v(xbgr.mr_n49696320)
print v(xbgr.mr_n49696640)
print v(xbgr.mr_n49696752)
print v(xbgr.mr_n49697072)
print v(xbgr.mr_n49697184)
print v(xbgr.mr_n49697504)
print v(xbgr.mr_n49697616)
print v(xbgr.mr_n49697936)
print v(xbgr.mr_n49698048)
print v(xbgr.mr_n49698368)
print v(xbgr.mr_n49698480)
print v(xbgr.mr_n49698800)
print v(xbgr.mr_n49698912)
print v(xbgr.mr_n49699232)
print v(xbgr.mr_n49699344)
print v(xbgr.mr_n49699664)
print v(xbgr.mr_n49699776)
print v(xbgr.mr_n49700096)
print v(xbgr.mr_n49700208)
print v(xbgr.mr_n49700528)
print v(xbgr.mr_n49700640)
print v(xbgr.mr_n49700960)
print v(xbgr.mr_n49701072)
print v(xbgr.mr_n49701392)
print v(xbgr.mr_n49701504)
print v(xbgr.mr_n49701824)
print v(xbgr.mr_n49701936)
print v(xbgr.mr_n50277456)
print v(xbgr.mr_n50277568)
print v(xbgr.mr_n50277888)
print v(xbgr.mr_n50278000)
print v(xbgr.mr_n50278320)
print v(xbgr.mr_n50278432)
print v(xbgr.mr_n50278752)
print v(xbgr.mr_n50278864)
print v(xbgr.mr_n50279184)
print v(xbgr.mr_n50279296)
print v(xbgr.mr_n50279616)
print v(xbgr.mr_n50279728)
print v(xbgr.mr_n50280048)
print v(xbgr.mr_n50280160)
print v(xbgr.mr_n50280480)
print v(xbgr.mr_n50280592)
print v(xbgr.mr_n50280912)
print v(xbgr.mr_n50281024)
print v(xbgr.mr_n50281344)
print v(xbgr.mr_n50281456)
print v(xbgr.mr_n50281776)
print v(xbgr.mr_n50281888)
print v(xbgr.mr_n50282208)
print v(xbgr.mr_n50282320)
print v(xbgr.mr_n50282640)
print v(xbgr.mr_n50282752)
print v(xbgr.mr_n50283072)
print v(xbgr.mr_n50283184)
print v(xbgr.mr_n50283504)
print v(xbgr.mr_n50283616)
print v(xbgr.mr_n50283744)
print v(xbgr.mr_n50283856)
print v(xbgr.mr_n50284176)
print v(xbgr.mr_n50284288)
print v(xbgr.mr_n50284608)
print v(xbgr.mr_n50284720)
print v(xbgr.mr_n50285040)
print v(xbgr.mr_n50285152)
print v(xbgr.mr_n50285472)
print v(xbgr.mr_n50285584)
print v(xbgr.mr_n50285904)
print v(xbgr.mr_n50286016)
print v(xbgr.mr_n50286336)
print v(xbgr.mr_n50286448)
print v(xbgr.mr_n50286768)
print v(xbgr.mr_n50286880)
print v(xbgr.mr_n50287200)
print v(xbgr.mr_n50287312)
print v(xbgr.mr_n50287632)
print v(xbgr.mr_n50287744)
print v(xbgr.mr_n50288064)
print v(xbgr.mr_n50288176)
print v(xbgr.mr_n50288496)
print v(xbgr.mr_n50288608)
print v(xbgr.mr_n50288928)
print v(xbgr.mr_n50289040)
print v(xbgr.mr_n50289360)
print v(xbgr.mr_n50289472)
print v(xbgr.mr_n50289792)
print v(xbgr.mr_n50289904)
print v(xbgr.mr_n50290224)
print v(xbgr.mr_n50290336)
print v(xbgr.mr_n50290656)
print v(xbgr.mr_n50290768)
print v(xbgr.mr_n50291088)
print v(xbgr.mr_n50291200)
print v(xbgr.mr_n50291520)
print v(xbgr.mr_n50291632)
print v(xbgr.mr_n50291952)
print v(xbgr.mr_n50292064)
print v(xbgr.mr_n50292384)
print v(xbgr.mr_n50292496)
print v(xbgr.mr_n50292816)
print v(xbgr.mr_n50292928)
print v(xbgr.mr_n50293248)
print v(xbgr.mr_n50293360)
print v(xbgr.mr_n50293680)
print v(xbgr.mr_n50293792)
print v(xbgr.mr_n50294112)
print v(xbgr.mr_n50294224)
print v(xbgr.mr_n50294544)
print v(xbgr.mr_n50294656)
print v(xbgr.mr_n50294976)
print v(xbgr.mr_n50295088)
print v(xbgr.mr_n50295408)
print v(xbgr.mr_n50295520)
print v(xbgr.mr_n50295840)
print v(xbgr.mr_n50295952)
print v(xbgr.mr_n50296272)
print v(xbgr.mr_n50296384)
print v(xbgr.mr_n50296704)
print v(xbgr.mr_n50296816)
print v(xbgr.mr_n50297136)
print v(xbgr.mr_n50297248)
print v(xbgr.mr_n50297568)
print v(xbgr.mr_n50297680)
print v(xbgr.mr_n50298000)
print v(xbgr.mr_n50298112)
print v(xbgr.mr_n50298432)
print v(xbgr.mr_n50298544)
print v(xbgr.mr_n50298864)
print v(xbgr.mr_n50298976)
print v(xbgr.mr_n50299296)
print v(xbgr.mr_n50299408)
print v(xbgr.mr_n50299728)
print v(xbgr.mr_n50299840)
print v(xbgr.mr_n50300160)
print v(xbgr.mr_n50300272)
print v(xbgr.mr_n50300592)
print v(xbgr.mr_n50300704)
print v(xbgr.mr_n50301024)
print v(xbgr.mr_n50301136)
print v(xbgr.mr_n50301456)
print v(xbgr.mr_n50301568)
print v(xbgr.mr_n50301888)
print v(xbgr.mr_n50302000)
print v(xbgr.mr_n50302320)
print v(xbgr.mr_n50302432)
print v(xbgr.mr_n50302752)
print v(xbgr.mr_n50302864)
print v(xbgr.mr_n50303184)
print v(xbgr.mr_n50303296)
print v(xbgr.mr_n50303616)
print v(xbgr.mr_n50303728)
print v(xbgr.mr_n50304048)
print v(xbgr.mr_n50304160)
print v(xbgr.mr_n50304480)
print v(xbgr.mr_n50304592)
print v(xbgr.mr_n50304912)
print v(xbgr.mr_n50305024)
print v(xbgr.mr_n50305344)
print v(xbgr.mr_n50305456)
print v(xbgr.mr_n50305776)
print v(xbgr.mr_n50305888)
print v(xbgr.mr_n50306208)
print v(xbgr.mr_n50306320)
print v(xbgr.mr_n50306640)
print v(xbgr.mr_n50306752)
print v(xbgr.mr_n50307072)
print v(xbgr.mr_n50307184)
print v(xbgr.mr_n50307504)
print v(xbgr.mr_n50307616)
print v(xbgr.mr_n50307936)
print v(xbgr.mr_n50308048)
print v(xbgr.mr_n50308368)
print v(xbgr.mr_n50308480)
print v(xbgr.mr_n50308800)
print v(xbgr.mr_n50308912)
print v(xbgr.mr_n50309232)
print v(xbgr.mr_n50309344)
print v(xbgr.mr_n50309664)
print v(xbgr.mr_n50309776)
print v(xbgr.mr_n50310096)
print v(xbgr.mr_n50310208)
print v(xbgr.mr_n50310528)
print v(xbgr.mr_n50310640)
print v(xbgr.mr_n50310960)
print v(xbgr.mr_n50311072)
print v(xbgr.mr_n50311392)
print v(xbgr.mr_n50311504)
print v(xbgr.mr_n50311824)
print v(xbgr.mr_n50311936)
print v(xbgr.mr_n50312256)
print v(xbgr.mr_n50312368)
print v(xbgr.mr_n50312688)
print v(xbgr.mr_n50312800)
print v(xbgr.mr_n50313120)
print v(xbgr.mr_n50313232)
print v(xbgr.mr_n50313552)
print v(xbgr.mr_n50313664)
print v(xbgr.mr_n50313984)
print v(xbgr.mr_n50314096)
print v(xbgr.mr_n50314416)
print v(xbgr.mr_n50314528)
print v(xbgr.mr_n50314848)
print v(xbgr.mr_n50314960)
print v(xbgr.mr_n50315280)
print v(xbgr.mr_n50315392)
print v(xbgr.mr_n50315712)
print v(xbgr.mr_n50315824)
print v(xbgr.mr_n50316144)
print v(xbgr.mr_n50316256)
print v(xbgr.mr_n50316576)
print v(xbgr.mr_n50316688)
print v(xbgr.mr_n50317008)
print v(xbgr.mr_n50317120)
print v(xbgr.mr_n50317440)
print v(xbgr.mr_n50317552)
print v(xbgr.mr_n50317872)
print v(xbgr.mr_n50317984)
print v(xbgr.mr_n50318304)
print v(xbgr.mr_n50318416)
print v(xbgr.mr_n50318736)
print v(xbgr.mr_n50318848)
print v(xbgr.mr_n50319168)
print v(xbgr.mr_n50319280)
print v(xbgr.mr_n50319824)
print v(xbgr.mr_n50319936)
print v(xbgr.mr_n50320256)
print v(xbgr.mr_n50320368)
print v(xbgr.mr_n50320688)
print v(xbgr.mr_n50320800)
print v(xbgr.mr_n50321120)
print v(xbgr.mr_n50321232)
print v(xbgr.mr_n50321552)
print v(xbgr.mr_n50321664)
print v(xbgr.mr_n50321984)
print v(xbgr.mr_n50322096)
print v(xbgr.mr_n50322416)
print v(xbgr.mr_n50322528)
print v(xbgr.mr_n50322848)
print v(xbgr.mr_n50322960)
print v(xbgr.mr_n50323280)
print v(xbgr.mr_n50323392)
print v(xbgr.mr_n50323712)
print v(xbgr.mr_n50323824)
print v(xbgr.mr_n50324144)
print v(xbgr.mr_n50324256)
print v(xbgr.mr_n50324576)
print v(xbgr.mr_n50324688)
print v(xbgr.mr_n50325008)
print v(xbgr.mr_n50325120)
print v(xbgr.mr_n50325440)
print v(xbgr.mr_n50325552)
print v(xbgr.mr_n50325872)
print v(xbgr.mr_n50325984)
print v(xbgr.mr_n50326304)
print v(xbgr.mr_n50353216)
print v(xbgr.mr_n50353536)
print v(xbgr.mr_n50353648)
print v(xbgr.mr_n50353968)
print v(xbgr.mr_n50354080)
print v(xbgr.mr_n50354400)
print v(xbgr.mr_n50354512)
print v(xbgr.mr_n50354832)
print v(xbgr.mr_n50354944)
print v(xbgr.mr_n50355264)
print v(xbgr.mr_n50355376)
print v(xbgr.mr_n50355696)
print v(xbgr.mr_n50355808)
print v(xbgr.mr_n50356128)
print v(xbgr.mr_n50356240)
print v(xbgr.mr_n50356560)
print v(xbgr.mr_n50356672)
print v(xbgr.mr_n50356992)
print v(xbgr.mr_n50357104)
print v(xbgr.mr_n50357424)
print v(xbgr.mr_n50357536)
print v(xbgr.mr_n50357856)
print v(xbgr.mr_n50357968)
print v(xbgr.mr_n50358288)
print v(xbgr.mr_n50358400)
print v(xbgr.mr_n50358720)
print v(xbgr.mr_n50358832)
print v(xbgr.mr_n50359152)
print v(xbgr.mr_n50359264)
print v(xbgr.mr_n50359584)
print v(xbgr.mr_n50359696)
print v(xbgr.mr_n50360016)
print v(xbgr.mr_n50360128)
print v(xbgr.mr_n50360448)
print v(xbgr.mr_n50360560)
print v(xbgr.mr_n50360880)
print v(xbgr.mr_n50360992)
print v(xbgr.mr_n50361312)
print v(xbgr.mr_n50361424)
print v(xbgr.mr_n50361744)
print v(xbgr.mr_n50361856)
print v(xbgr.mr_n50362176)
print v(xbgr.mr_n50362288)
print v(xbgr.mr_n50362608)
print v(xbgr.mr_n50362720)
print v(xbgr.mr_n50363040)
print v(xbgr.mr_n50363152)
print v(xbgr.mr_n50363472)
print v(xbgr.mr_n50363584)
print v(xbgr.mr_n50363904)
print v(xbgr.mr_n50364016)
print v(xbgr.mr_n50364336)
print v(xbgr.mr_n50364448)
print v(xbgr.mr_n50364768)
print v(xbgr.mr_n50364880)
print v(xbgr.mr_n50365200)
print v(xbgr.mr_n50365312)
print v(xbgr.mr_n50365632)
print v(xbgr.mr_n50365744)
print v(xbgr.mr_n50366064)
print v(xbgr.mr_n50366176)
print v(xbgr.mr_n50366496)
print v(xbgr.mr_n50366608)
print v(xbgr.mr_n50366928)
print v(xbgr.mr_n50367040)
print v(xbgr.mr_n50367360)
print v(xbgr.mr_n50367472)
print v(xbgr.mr_n50367792)
print v(xbgr.mr_n50367904)
print v(xbgr.mr_n50368224)
print v(xbgr.mr_n50368336)
print v(xbgr.mr_n50368656)
print v(xbgr.mr_n50368768)
print v(xbgr.mr_n50369088)
print v(xbgr.mr_n50369200)
print v(xbgr.mr_n50369520)
print v(xbgr.mr_n50369632)
print v(xbgr.mr_n50369952)
print v(xbgr.mr_n50370064)
print v(xbgr.mr_n50370384)
print v(xbgr.mr_n50370496)
print v(xbgr.mr_n50370816)
print v(xbgr.mr_n50370928)
print v(xbgr.mr_n50371248)
print v(xbgr.mr_n50371360)
print v(xbgr.mr_n50371680)
print v(xbgr.mr_n50371792)
print v(xbgr.mr_n50372112)
print v(xbgr.mr_n50372224)
print v(xbgr.mr_n50372544)
print v(xbgr.mr_n50372656)
print v(xbgr.mr_n50372976)
print v(xbgr.mr_n50373088)
print v(xbgr.mr_n50373408)
print v(xbgr.mr_n50373520)
print v(xbgr.mr_n50373840)
print v(xbgr.mr_n50373952)
print v(xbgr.mr_n50374272)
print v(xbgr.mr_n50374384)
print v(xbgr.mr_n50374704)
print v(xbgr.mr_n50374816)
print v(xbgr.mr_n50375136)
print v(xbgr.mr_n50375248)
print v(xbgr.mr_n50375568)
print v(xbgr.mr_n50375680)
print v(xbgr.mr_n50376000)
print v(xbgr.mr_n50376112)
print v(xbgr.mr_n50376432)
print v(xbgr.mr_n50376544)
print v(xbgr.mr_n50376864)
print v(xbgr.mr_n50376976)
print v(xbgr.mr_n50377296)
print v(xbgr.mr_n50377408)
print v(xbgr.mr_n50377728)
print v(xbgr.mr_n50377840)
print v(xbgr.mr_n50378160)
print v(xbgr.mr_n50378272)
print v(xbgr.mr_n50378592)
print v(xbgr.mr_n50378704)
print v(xbgr.mr_n50379024)
print v(xbgr.mr_n50379136)
print v(xbgr.mr_n50379456)
print v(xbgr.mr_n50379568)
print v(xbgr.mr_n50379888)
print v(xbgr.mr_n50380000)
print v(xbgr.mr_n50380320)
print v(xbgr.mr_n50380432)
print v(xbgr.mr_n50380752)
print v(xbgr.mr_n50380864)
print v(xbgr.mr_n50381184)
print v(xbgr.mr_n50381296)
print v(xbgr.mr_n50381616)
print v(xbgr.mr_n50381728)
print v(xbgr.mr_n50382048)
print v(xbgr.mr_n50382160)
print v(xbgr.mr_n50382480)
print v(xbgr.mr_n50382592)
print v(xbgr.mr_n50382912)
print v(xbgr.mr_n50383024)
print v(xbgr.mr_n50383344)
print v(xbgr.mr_n50383456)
print v(xbgr.mr_n50383776)
print v(xbgr.mr_n50383888)
print v(xbgr.mr_n50384208)
print v(xbgr.mr_n50384320)
print v(xbgr.mr_n50384640)
print v(xbgr.mr_n50384752)
print v(xbgr.mr_n50385072)
print v(xbgr.mr_n50385184)
print v(xbgr.mr_n50385504)
print v(xbgr.mr_n50385616)
print v(xbgr.mr_n50385936)
print v(xbgr.mr_n50386048)
print v(xbgr.mr_n50386368)
print v(xbgr.mr_n50386480)
print v(xbgr.mr_n50386800)
print v(xbgr.mr_n50386912)
print v(xbgr.mr_n50387232)
print v(xbgr.mr_n50387344)
print v(xbgr.mr_n50387664)
print v(xbgr.mr_n50387776)
print v(xbgr.mr_n50388096)
print v(xbgr.mr_n50388208)
print v(xbgr.mr_n50388528)
print v(xbgr.mr_n50388640)
print v(xbgr.mr_n50388960)
print v(xbgr.mr_n50389072)
print v(xbgr.mr_n50389392)
print v(xbgr.mr_n50389504)
print v(xbgr.mr_n50389824)
print v(xbgr.mr_n50389936)
print v(xbgr.mr_n50390256)
print v(xbgr.mr_n50390368)
print v(xbgr.mr_n50390688)
print v(xbgr.mr_n50390800)
print v(xbgr.mr_n50391120)
print v(xbgr.mr_n50391232)
print v(xbgr.mr_n50391552)
print v(xbgr.mr_n50391664)
print v(xbgr.mr_n50391984)
print v(xbgr.mr_n50392096)
print v(xbgr.mr_n50392416)
print v(xbgr.mr_n50392528)
print v(xbgr.mr_n50392848)
print v(xbgr.mr_n50392960)
print v(xbgr.mr_n50393280)
print v(xbgr.mr_n50393392)
print v(xbgr.mr_n50393712)
print v(xbgr.mr_n50393824)
print v(xbgr.mr_n50394144)
print v(xbgr.mr_n50394256)
print v(xbgr.mr_n50394576)
print v(xbgr.mr_n50394688)
print v(xbgr.mr_n50395008)
print v(xbgr.mr_n50395120)
print v(xbgr.mr_n50395440)
print v(xbgr.mr_n50395552)
print v(xbgr.mr_n50395872)
print v(xbgr.mr_n50395984)
print v(xbgr.mr_n50396304)
print v(xbgr.mr_n50396416)
print v(xbgr.mr_n50396736)
print v(xbgr.mr_n50396848)
print v(xbgr.mr_n50397168)
print v(xbgr.mr_n50397280)
print v(xbgr.mr_n50397600)
print v(xbgr.mr_n50397712)
print v(xbgr.mr_n50398032)
print v(xbgr.mr_n50398144)
print v(xbgr.mr_n50398464)
print v(xbgr.mr_n50398576)
print v(xbgr.mr_n50398896)
print v(xbgr.mr_n50399008)
print v(xbgr.mr_n50399328)
print v(xbgr.mr_n50399440)
print v(xbgr.mr_n50399760)
print v(xbgr.mr_n50399872)
print v(xbgr.mr_n50400192)
print v(xbgr.mr_n50400304)
print v(xbgr.mr_n50400624)
print v(xbgr.mr_n50400736)
print v(xbgr.mr_n50401056)
print v(xbgr.mr_n50401168)
print v(xbgr.mr_n50401488)
print v(xbgr.mr_n50401600)
print v(xbgr.mr_n50401920)
print v(xbgr.mr_n50402032)
print v(xbgr.mr_n50402352)
print v(xbgr.mr_n50402464)
print v(xbgr.mr_n50402784)
print v(xbgr.mr_n50402896)
print v(xbgr.mr_n50403216)
print v(xbgr.mr_n50403328)
print v(xbgr.mr_n50403648)
print v(xbgr.mr_n50403760)
print v(xbgr.mr_n50404080)
print v(xbgr.mr_n50404192)
print v(xbgr.mr_n50404512)
print v(xbgr.mr_n50404624)
print v(xbgr.mr_n50404944)
print v(xbgr.mr_n50405056)
print v(xbgr.mr_n50405376)
print v(xbgr.mr_n50405488)
print v(xbgr.mr_n50405808)
print v(xbgr.mr_n50405920)
print v(xbgr.mr_n50406240)
print v(xbgr.mr_n50406352)
print v(xbgr.mr_n50406672)
print v(xbgr.mr_n50406784)
print v(xbgr.mr_n50407104)
print v(xbgr.mr_n50407216)
print v(xbgr.mr_n50407536)
print v(xbgr.mr_n50407648)
print v(xbgr.mr_n50407968)
print v(xbgr.mr_n50408080)
print v(xbgr.mr_n50408400)
print v(xbgr.mr_n50408512)
print v(xbgr.mr_n50408832)
print v(xbgr.mr_n50408944)
print v(xbgr.mr_n50409264)
print v(xbgr.mr_n50409376)
print v(xbgr.mr_n50409696)
print v(xbgr.mr_n50409808)
print v(xbgr.mr_n50410128)
print v(xbgr.mr_n50410240)
print v(xbgr.mr_n50410560)
print v(xbgr.mr_n50410672)
print v(xbgr.mr_n50410992)
print v(xbgr.mr_n50411104)
print v(xbgr.mr_n50411424)
print v(xbgr.mr_n50411536)
print v(xbgr.mr_n50411856)
print v(xbgr.mr_n50411968)
print v(xbgr.mr_n50412288)
print v(xbgr.mr_n50412400)
print v(xbgr.mr_n50412720)
print v(xbgr.mr_n50412832)
print v(xbgr.mr_n50413152)
print v(xbgr.mr_n50413264)
print v(xbgr.mr_n50413584)
print v(xbgr.mr_n50413696)
print v(xbgr.mr_n50414016)
print v(xbgr.mr_n50414128)
print v(xbgr.mr_n50414448)
print v(xbgr.mr_n50414560)
print v(xbgr.mr_n50414880)
print v(xbgr.mr_n50414992)
print v(xbgr.mr_n50415312)
print v(xbgr.mr_n50415424)
print v(xbgr.mr_n50415744)
print v(xbgr.mr_n50415856)
print v(xbgr.mr_n50416176)
print v(xbgr.mr_n50416288)
print v(xbgr.mr_n50416608)
print v(xbgr.mr_n50416720)
print v(xbgr.mr_n50417040)
print v(xbgr.mr_n50417152)
print v(xbgr.mr_n50417472)
print v(xbgr.mr_n50417584)
print v(xbgr.mr_n50417904)
print v(xbgr.mr_n50418016)
print v(xbgr.mr_n50418336)
print v(xbgr.mr_n50418448)
print v(xbgr.mr_n50418768)
print v(xbgr.mr_n50418880)
print v(xbgr.mr_n50419200)
print v(xbgr.mr_n50419312)
print v(xbgr.mr_n50419632)
print v(xbgr.mr_n50419744)
print v(xbgr.mr_n50420064)
print v(xbgr.mr_n50420176)
print v(xbgr.mr_n50420496)
print v(xbgr.mr_n50420608)
print v(xbgr.mr_n50420928)
print v(xbgr.mr_n50421040)
print v(xbgr.mr_n50421360)
print v(xbgr.mr_n50421472)
print v(xbgr.mr_n50421792)
print v(xbgr.mr_n50421904)
print v(xbgr.mr_n50422224)
print v(xbgr.mr_n50422336)
print v(xbgr.mr_n50422656)
print v(xbgr.mr_n50422768)
print v(xbgr.mr_n50423088)
print v(xbgr.mr_n50423200)
print v(xbgr.mr_n50423520)
print v(xbgr.mr_n50423632)
print v(xbgr.mr_n50423952)
print v(xbgr.mr_n50424064)
print v(xbgr.mr_n50424384)
print v(xbgr.mr_n50424496)
print v(xbgr.mr_n50424816)
print v(xbgr.mr_n50424928)
print v(xbgr.mr_n50425248)
print v(xbgr.mr_n50425360)
print v(xbgr.mr_n50425680)
print v(xbgr.mr_n50425792)
print v(xbgr.mr_n50426112)
print v(xbgr.mr_n50426224)
print v(xbgr.mr_n50426544)
print v(xbgr.mr_n50426656)
print v(xbgr.mr_n50426976)
print v(xbgr.mr_n50427088)
print v(xbgr.mr_n50427408)
print v(xbgr.mr_n50427520)
print v(xbgr.mr_n50427840)
print v(xbgr.mr_n50427952)
print v(xbgr.mr_n50428272)
print v(xbgr.mr_n50428384)
print v(xbgr.mr_n50428704)
print v(xbgr.mr_n50428816)
print v(xbgr.mr_n50429136)
print v(xbgr.mr_n50429248)
print v(xbgr.mr_n50429568)
print v(xbgr.mr_n50429680)
print v(xbgr.mr_n50430000)
print v(xbgr.mr_n50430112)
print v(xbgr.mr_n50430432)
print v(xbgr.mr_n50430544)
print v(xbgr.mr_n50430864)
print v(xbgr.mr_n50430976)
print v(xbgr.mr_n50431296)
print v(xbgr.mr_n50431408)
print v(xbgr.mr_n50431728)
print v(xbgr.mr_n50431840)
print v(xbgr.mr_n50432160)
print v(xbgr.mr_n50432272)
print v(xbgr.mr_n50432592)
print v(xbgr.mr_n50432704)
print v(xbgr.mr_n50433024)
print v(xbgr.mr_n50433136)
print v(xbgr.mr_n50433456)
print v(xbgr.mr_n50433568)
print v(xbgr.mr_n50433888)
print v(xbgr.mr_n50434000)
print v(xbgr.mr_n50434320)
print v(xbgr.mr_n50434432)
print v(xbgr.mr_n50434752)
print v(xbgr.mr_n50434864)
print v(xbgr.mr_n50435184)
print v(xbgr.mr_n50435296)
print v(xbgr.mr_n50435616)
print v(xbgr.mr_n50435728)
print v(xbgr.mr_n50436048)
print v(xbgr.mr_n50436160)
print v(xbgr.mr_n50436480)
print v(xbgr.mr_n50436592)
print v(xbgr.mr_n50436912)
print v(xbgr.mr_n50437024)
print v(xbgr.mr_n50437344)
print v(xbgr.mr_n50437456)
print v(xbgr.mr_n50437776)
print v(xbgr.mr_n50437888)
print v(xbgr.mr_n50438208)
print v(xbgr.mr_n50438320)
print v(xbgr.mr_n50438640)
print v(xbgr.mr_n50438752)
print v(xbgr.mr_n50439072)
print v(xbgr.mr_n50439184)
print v(xbgr.mr_n50439504)
print v(xbgr.mr_n50439616)
print v(xbgr.mr_n50439936)
print v(xbgr.mr_n50440048)
print v(xbgr.mr_n50440368)
print v(xbgr.mr_n50440480)
print v(xbgr.mr_n50440800)
print v(xbgr.mr_n50440912)
print v(xbgr.mr_n50441232)
print v(xbgr.mr_n50441344)
print v(xbgr.mr_n50441664)
print v(xbgr.mr_n50441776)
print v(xbgr.mr_n50442096)
print v(xbgr.mr_n50442208)
print v(xbgr.mr_n50442528)
print v(xbgr.mr_n50442640)
print v(xbgr.mr_n50442960)
print v(xbgr.mr_n50443072)
print v(xbgr.mr_n50443392)
print v(xbgr.mr_n50443504)
print v(xbgr.mr_n50443824)
print v(xbgr.mr_n50443936)
print v(xbgr.mr_n50444256)
print v(xbgr.mr_n50444368)
print v(xbgr.mr_n50444688)
print v(xbgr.mr_n50444800)
print v(xbgr.mr_n50445120)
print v(xbgr.mr_n50445232)
print v(xbgr.mr_n50445552)
print v(xbgr.mr_n50445664)
print v(xbgr.mr_n50445984)
print v(xbgr.mr_n50446096)
print v(xbgr.mr_n50446416)
print v(xbgr.mr_n50446528)
print v(xbgr.mr_n51451008)
print v(xbgr.mr_n51451120)
print v(xbgr.mr_n51451312)
print v(xbgr.mr_n51451424)
print v(xbgr.mr_n51451680)
print v(xbgr.mr_n51451792)
print v(xbgr.mr_n51452048)
print v(xbgr.mr_n51452160)
print v(xbgr.mr_n51452416)
print v(xbgr.mr_n51452528)
print v(xbgr.mr_n51452784)
print v(xbgr.mr_n51452896)
print v(xbgr.mr_n51453152)
print v(xbgr.mr_n51453264)
print v(xbgr.mr_n51453584)
print v(xbgr.mr_n51453696)
print v(xbgr.mr_n51454016)
print v(xbgr.mr_n51454128)
print v(xbgr.mr_n51454448)
print v(xbgr.mr_n51454560)
print v(xbgr.mr_n51454880)
print v(xbgr.mr_n51454992)
print v(xbgr.mr_n51455312)
print v(xbgr.mr_n51455424)
print v(xbgr.mr_n51455744)
print v(xbgr.mr_n51455856)
print v(xbgr.mr_n51456176)
print v(xbgr.mr_n51456288)
print v(xbgr.mr_n51456608)
print v(xbgr.mr_n51456720)
print v(xbgr.mr_n51457040)
print v(xbgr.mr_n51457152)
print v(xbgr.mr_n51457472)
print v(xbgr.mr_n51457584)
print v(xbgr.mr_n51457904)
print v(xbgr.mr_n51458016)
print v(xbgr.mr_n51458336)
print v(xbgr.mr_n51458448)
print v(xbgr.mr_n51458768)
print v(xbgr.mr_n51458880)
print v(xbgr.mr_n51459200)
print v(xbgr.mr_n51459312)
print v(xbgr.mr_n51459632)
print v(xbgr.mr_n51459744)
print v(xbgr.mr_n51460064)
print v(xbgr.mr_n51460176)
print v(xbgr.mr_n51460496)
print v(xbgr.mr_n51460608)
print v(xbgr.mr_n51460928)
print v(xbgr.mr_n51461040)
print v(xbgr.mr_n51461360)
print v(xbgr.mr_n51461472)
print v(xbgr.mr_n51461792)
print v(xbgr.mr_n51461904)
print v(xbgr.mr_n51462224)
print v(xbgr.mr_n51462336)
print v(xbgr.mr_n51462656)
print v(xbgr.mr_n51462768)
print v(xbgr.mr_n51463088)
print v(xbgr.mr_n51463200)
print v(xbgr.mr_n51463520)
print v(xbgr.mr_n51463632)
print v(xbgr.mr_n51463952)
print v(xbgr.mr_n51464064)
print v(xbgr.mr_n51464384)
print v(xbgr.mr_n51464496)
print v(xbgr.mr_n51464816)
print v(xbgr.mr_n51464928)
print v(xbgr.mr_n51465248)
print v(xbgr.mr_n51465360)
print v(xbgr.mr_n51465680)
print v(xbgr.mr_n51465792)
print v(xbgr.mr_n51466112)
print v(xbgr.mr_n51466224)
print v(xbgr.mr_n51466544)
print v(xbgr.mr_n51466656)
print v(xbgr.mr_n51466976)
print v(xbgr.mr_n51467088)
print v(xbgr.mr_n51467408)
print v(xbgr.mr_n51467520)
print v(xbgr.mr_n51467840)
print v(xbgr.mr_n51467952)
print v(xbgr.mr_n51468272)
print v(xbgr.mr_n51468384)
print v(xbgr.mr_n51468704)
print v(xbgr.mr_n51468816)
print v(xbgr.mr_n51469136)
print v(xbgr.mr_n51469248)
print v(xbgr.mr_n51469568)
print v(xbgr.mr_n51469680)
print v(xbgr.mr_n51470000)
print v(xbgr.mr_n51470112)
print v(xbgr.mr_n51470432)
print v(xbgr.mr_n51470544)
print v(xbgr.mr_n51470864)
print v(xbgr.mr_n51470976)
print v(xbgr.mr_n51471296)
print v(xbgr.mr_n51471408)
print v(xbgr.mr_n51471728)
print v(xbgr.mr_n51471840)
print v(xbgr.mr_n51472160)
print v(xbgr.mr_n51472272)
print v(xbgr.mr_n51472592)
print v(xbgr.mr_n51472704)
print v(xbgr.mr_n51473024)
print v(xbgr.mr_n51473136)
print v(xbgr.mr_n51473456)
print v(xbgr.mr_n51473568)
print v(xbgr.mr_n51473888)
print v(xbgr.mr_n51474000)
print v(xbgr.mr_n51474320)
print v(xbgr.mr_n51474432)
print v(xbgr.mr_n51474752)
print v(xbgr.mr_n51474864)
print v(xbgr.mr_n51475184)
print v(xbgr.mr_n51475296)
print v(xbgr.mr_n51475616)
print v(xbgr.mr_n51475728)
print v(xbgr.mr_n51476048)
print v(xbgr.mr_n51476160)
print v(xbgr.mr_n51476480)
print v(xbgr.mr_n51476592)
print v(xbgr.mr_n51476912)
print v(xbgr.mr_n51477024)
print v(xbgr.mr_n51477344)
print v(xbgr.mr_n51477456)
print v(xbgr.mr_n51477776)
print v(xbgr.mr_n51477888)
print v(xbgr.mr_n51478208)
print v(xbgr.mr_n51478320)
print v(xbgr.mr_n51478640)
print v(xbgr.mr_n51478752)
print v(xbgr.mr_n51479072)
print v(xbgr.mr_n51479184)
print v(xbgr.mr_n51479504)
print v(xbgr.mr_n51479616)
print v(xbgr.mr_n51479936)
print v(xbgr.mr_n51480048)
print v(xbgr.mr_n51480368)
print v(xbgr.mr_n51480480)
print v(xbgr.mr_n51480800)
print v(xbgr.mr_n51480912)
print v(xbgr.mr_n51481232)
print v(xbgr.mr_n51481344)
print v(xbgr.mr_n51481664)
print v(xbgr.mr_n51481776)
print v(xbgr.mr_n51482096)
print v(xbgr.mr_n51482208)
print v(xbgr.mr_n51482528)
print v(xbgr.mr_n51482640)
print v(xbgr.mr_n51482960)
print v(xbgr.mr_n51483072)
print v(xbgr.mr_n51483392)
print v(xbgr.mr_n51483504)
print v(xbgr.mr_n51483824)
print v(xbgr.mr_n51483936)
print v(xbgr.mr_n51484256)
print v(xbgr.mr_n51484368)
print v(xbgr.mr_n51484688)
print v(xbgr.mr_n51484800)
print v(xbgr.mr_n51485120)
print v(xbgr.mr_n51485232)
print v(xbgr.mr_n51485552)
print v(xbgr.mr_n51485664)
print v(xbgr.mr_n51485984)
print v(xbgr.mr_n51486096)
print v(xbgr.mr_n51486416)
print v(xbgr.mr_n51486528)
print v(xbgr.mr_n51486848)
print v(xbgr.mr_n51486960)
print v(xbgr.mr_n51487280)
print v(xbgr.mr_n51487392)
print v(xbgr.mr_n51487712)
print v(xbgr.mr_n51487824)
print v(xbgr.mr_n51488144)
print v(xbgr.mr_n51488256)
print v(xbgr.mr_n51488576)
print v(xbgr.mr_n51488688)
print v(xbgr.mr_n51489008)
print v(xbgr.mr_n51489120)
print v(xbgr.mr_n51489440)
print v(xbgr.mr_n51489552)
print v(xbgr.mr_n51489872)
print v(xbgr.mr_n51489984)
print v(xbgr.mr_n51490304)
print v(xbgr.mr_n51490416)
print v(xbgr.mr_n51490736)
print v(xbgr.mr_n51490848)
print v(xbgr.mr_n51491168)
print v(xbgr.mr_n51491280)
print v(xbgr.mr_n51491600)
print v(xbgr.mr_n51491712)
print v(xbgr.mr_n51492032)
print v(xbgr.mr_n51492144)
print v(xbgr.mr_n51492464)
print v(xbgr.mr_n51492576)
print v(xbgr.mr_n51492896)
print v(xbgr.mr_n51493008)
print v(xbgr.mr_n51493328)
print v(xbgr.mr_n51493440)
print v(xbgr.mr_n51493760)
print v(xbgr.mr_n51493872)
print v(xbgr.mr_n51494192)
print v(xbgr.mr_n51494304)
print v(xbgr.mr_n51494624)
print v(xbgr.mr_n51494736)
print v(xbgr.mr_n51495056)
print v(xbgr.mr_n51495168)
print v(xbgr.mr_n51495488)
print v(xbgr.mr_n51495600)
print v(xbgr.mr_n51495920)
print v(xbgr.mr_n51496032)
print v(xbgr.mr_n51496352)
print v(xbgr.mr_n51496464)
print v(xbgr.mr_n51496784)
print v(xbgr.mr_n51496896)
print v(xbgr.mr_n51497216)
print v(xbgr.mr_n51497328)
print v(xbgr.mr_n51497648)
print v(xbgr.mr_n51497760)
print v(xbgr.mr_n51498080)
print v(xbgr.mr_n51498192)
print v(xbgr.mr_n51498512)
print v(xbgr.mr_n51498624)
print v(xbgr.mr_n51498944)
print v(xbgr.mr_n51499056)
print v(xbgr.mr_n51499376)
print v(xbgr.mr_n51499488)
print v(xbgr.mr_n51499808)
print v(xbgr.mr_n51499920)
print v(xbgr.mr_n51500240)
print v(xbgr.mr_n51500352)
print v(xbgr.mr_n51500672)
print v(xbgr.mr_n51500784)
print v(xbgr.mr_n51501104)
print v(xbgr.mr_n51501216)
print v(xbgr.mr_n51501536)
print v(xbgr.mr_n51501648)
print v(xbgr.mr_n51501968)
print v(xbgr.mr_n51502080)
print v(xbgr.mr_n51502400)
print v(xbgr.mr_n51502512)
print v(xbgr.mr_n51502832)
print v(xbgr.mr_n51502944)
print v(xbgr.mr_n51503264)
print v(xbgr.mr_n51503376)
print v(xbgr.mr_n51503696)
print v(xbgr.mr_n51503808)
print v(xbgr.mr_n51504128)
print v(xbgr.mr_n51504240)
print v(xbgr.mr_n51504560)
print v(xbgr.mr_n51504672)
print v(xbgr.mr_n51504992)
print v(xbgr.mr_n51505104)
print v(xbgr.mr_n51505424)
print v(xbgr.mr_n51505536)
print v(xbgr.mr_n51505856)
print v(xbgr.mr_n51505968)
print v(xbgr.mr_n51506288)
print v(xbgr.mr_n51506400)
print v(xbgr.mr_n51506720)
print v(xbgr.mr_n51506832)
print v(xbgr.mr_n51507152)
print v(xbgr.mr_n51507264)
print v(xbgr.mr_n51507584)
print v(xbgr.mr_n51507696)
print v(xbgr.mr_n51508016)
print v(xbgr.mr_n51508128)
print v(xbgr.mr_n51508448)
print v(xbgr.mr_n51508560)
print v(xbgr.mr_n51508880)
print v(xbgr.mr_n51508992)
print v(xbgr.mr_n51509312)
print v(xbgr.mr_n51509424)
print v(xbgr.mr_n51509744)
print v(xbgr.mr_n51509856)
print v(xbgr.mr_n51510176)
print v(xbgr.mr_n51510288)
print v(xbgr.mr_n51510608)
print v(xbgr.mr_n51510720)
print v(xbgr.mr_n51511040)
print v(xbgr.mr_n51511152)
print v(xbgr.mr_n51511472)
print v(xbgr.mr_n51511584)
print v(xbgr.mr_n51511904)
print v(xbgr.mr_n51512016)
print v(xbgr.mr_n51512336)
print v(xbgr.mr_n51512448)
print v(xbgr.mr_n51512768)
print v(xbgr.mr_n51512880)
print v(xbgr.mr_n51513200)
print v(xbgr.mr_n51513312)
print v(xbgr.mr_n51513632)
print v(xbgr.mr_n51513744)
print v(xbgr.mr_n51514064)
print v(xbgr.mr_n51514176)
print v(xbgr.mr_n51514496)
print v(xbgr.mr_n51514608)
print v(xbgr.mr_n51514928)
print v(xbgr.mr_n51515040)
print v(xbgr.mr_n51515360)
print v(xbgr.mr_n51515472)
print v(xbgr.mr_n51515792)
print v(xbgr.mr_n51515904)
print v(xbgr.mr_n51516224)
print v(xbgr.mr_n51516336)
print v(xbgr.mr_n51516656)
print v(xbgr.mr_n51516768)
print v(xbgr.mr_n51517088)
print v(xbgr.mr_n51517200)
print v(xbgr.mr_n51517520)
print v(xbgr.mr_n51517632)
print v(xbgr.mr_n51517952)
print v(xbgr.mr_n51518064)
print v(xbgr.mr_n51518384)
print v(xbgr.mr_n51518496)
print v(xbgr.mr_n51518816)
print v(xbgr.mr_n51518928)
print v(xbgr.mr_n51519248)
print v(xbgr.mr_n51519360)
print v(xbgr.mr_n51519680)
print v(xbgr.mr_n51519792)
print v(xbgr.mr_n51520112)
print v(xbgr.mr_n51520224)
print v(xbgr.mr_n51520544)
print v(xbgr.mr_n51520656)
print v(xbgr.mr_n51520976)
print v(xbgr.mr_n51521088)
print v(xbgr.mr_n51521408)
print v(xbgr.mr_n51521520)
print v(xbgr.mr_n51521840)
print v(xbgr.mr_n51521952)
print v(xbgr.mr_n51522272)
print v(xbgr.mr_n51522384)
print v(xbgr.mr_n51522704)
print v(xbgr.mr_n51522816)
print v(xbgr.mr_n51523136)
print v(xbgr.mr_n51523248)
print v(xbgr.mr_n51523568)
print v(xbgr.mr_n51523680)
print v(xbgr.mr_n51524000)
print v(xbgr.mr_n51524112)
print v(xbgr.mr_n51524432)
print v(xbgr.mr_n51524544)
print v(xbgr.mr_n51524864)
print v(xbgr.mr_n51524976)
print v(xbgr.mr_n51525296)
print v(xbgr.mr_n51525408)
print v(xbgr.mr_n51525728)
print v(xbgr.mr_n51525840)
print v(xbgr.mr_n51526160)
print v(xbgr.mr_n51526272)
print v(xbgr.mr_n51526592)
print v(xbgr.mr_n51526704)
print v(xbgr.mr_n51527024)
print v(xbgr.mr_n51527136)
print v(xbgr.mr_n51527456)
print v(xbgr.mr_n51527568)
print v(xbgr.mr_n51527888)
print v(xbgr.mr_n51528000)
print v(xbgr.mr_n51528320)
print v(xbgr.mr_n51528432)
print v(xbgr.mr_n51528752)
print v(xbgr.mr_n51528864)
print v(xbgr.mr_n51529184)
print v(xbgr.mr_n51529296)
print v(xbgr.mr_n51529616)
print v(xbgr.mr_n51529728)
print v(xbgr.mr_n51530048)
print v(xbgr.mr_n51530160)
print v(xbgr.mr_n51530480)
print v(xbgr.mr_n51530592)
print v(xbgr.mr_n51530912)
print v(xbgr.mr_n51531024)
print v(xbgr.mr_n51531344)
print v(xbgr.mr_n51531456)
print v(xbgr.mr_n51531776)
print v(xbgr.mr_n51531888)
print v(xbgr.mr_n51532208)
print v(xbgr.mr_n51532320)
print v(xbgr.mr_n51532640)
print v(xbgr.mr_n51532752)
print v(xbgr.mr_n51533072)
print v(xbgr.mr_n51533184)
print v(xbgr.mr_n51533504)
print v(xbgr.mr_n51533616)
print v(xbgr.mr_n51533936)
print v(xbgr.mr_n51534048)
print v(xbgr.mr_n51534368)
print v(xbgr.mr_n51534480)
print v(xbgr.mr_n51534800)
print v(xbgr.mr_n51534912)
print v(xbgr.mr_n51535232)
print v(xbgr.mr_n51535344)
print v(xbgr.mr_n51535664)
print v(xbgr.mr_n51535776)
print v(xbgr.mr_n51536096)
print v(xbgr.mr_n51536208)
print v(xbgr.mr_n51536528)
print v(xbgr.mr_n51536640)
print v(xbgr.mr_n51536960)
print v(xbgr.mr_n51537072)
print v(xbgr.mr_n51537392)
print v(xbgr.mr_n51537504)
print v(xbgr.mr_n51537824)
print v(xbgr.mr_n51537936)
print v(xbgr.mr_n51538256)
print v(xbgr.mr_n51538368)
print v(xbgr.mr_n51538688)
print v(xbgr.mr_n51538800)
print v(xbgr.mr_n51539120)
print v(xbgr.mr_n51539232)
print v(xbgr.mr_n51539552)
print v(xbgr.mr_n51539664)
print v(xbgr.mr_n51539984)
print v(xbgr.mr_n51540096)
print v(xbgr.mr_n51540416)
print v(xbgr.mr_n51540528)
print v(xbgr.mr_n51540848)
print v(xbgr.mr_n51540960)
print v(xbgr.mr_n51541280)
print v(xbgr.mr_n51541392)
print v(xbgr.mr_n51541712)
print v(xbgr.mr_n51541824)
print v(xbgr.mr_n51542144)
print v(xbgr.mr_n51542256)
print v(xbgr.mr_n51542576)
print v(xbgr.mr_n51542688)
print v(xbgr.mr_n51543008)
print v(xbgr.mr_n51543120)
print v(xbgr.mr_n51543440)
print v(xbgr.mr_n51543552)
print v(xbgr.mr_n51543872)
print v(xbgr.mr_n51543984)
print v(xbgr.mr_n51544304)
print v(xbgr.mr_n51544416)
print v(xbgr.mr_n51544736)
print v(xbgr.mr_n51544848)
print v(xbgr.mr_n51545168)
print v(xbgr.mr_n51545280)
print v(xbgr.mr_n51545600)
print v(xbgr.mr_n51545712)
print v(xbgr.mr_n51546032)
print v(xbgr.mr_n51546144)
print v(xbgr.mr_n51546464)
print v(xbgr.mr_n51546576)
print v(xbgr.mr_n51546896)
print v(xbgr.mr_n51547008)
print v(xbgr.mr_n51547328)
print v(xbgr.mr_n51547440)
print v(xbgr.mr_n51547760)
print v(xbgr.mr_n51547872)
print v(xbgr.mr_n51548192)
print v(xbgr.mr_n51548304)
print v(xbgr.mr_n51548624)
print v(xbgr.mr_n51548736)
print v(xbgr.mr_n51549056)
print v(xbgr.mr_n51549168)
print v(xbgr.mr_n51549488)
print v(xbgr.mr_n51549600)
print v(xbgr.mr_n51549920)
print v(xbgr.mr_n51550032)
print v(xbgr.mr_n51550352)
print v(xbgr.mr_n51550464)
print v(xbgr.mr_n51550784)
print v(xbgr.mr_n51550896)
print v(xbgr.mr_n51551216)
print v(xbgr.mr_n51551328)
print v(xbgr.mr_n51551648)
print v(xbgr.mr_n51551760)
print v(xbgr.mr_n51552080)
print v(xbgr.mr_n51552192)
print v(xbgr.mr_n51552512)
print v(xbgr.mr_n51552624)
print v(xbgr.mr_n51552912)
print v(xbgr.mr_n51553024)
print v(xbgr.mr_n51553344)
print v(xbgr.mr_n51553456)
print v(xbgr.mr_n51553776)
print v(xbgr.mr_n51553888)
print v(xbgr.mr_n51554208)
print v(xbgr.mr_n51554320)
print v(xbgr.mr_n51554640)
print v(xbgr.mr_n51554752)
print v(xbgr.mr_n51555072)
print v(xbgr.mr_n51555184)
print v(xbgr.mr_n51555504)
print v(xbgr.mr_n51555616)
print v(xbgr.mr_n51555936)
print v(xbgr.mr_n51556048)
print v(xbgr.mr_n51556368)
print v(xbgr.mr_n51556480)
print v(xbgr.mr_n51556800)
print v(xbgr.mr_n51556912)
print v(xbgr.mr_n51557232)
print v(xbgr.mr_n51557344)
print v(xbgr.mr_n51557664)
print v(xbgr.mr_n51557776)
print v(xbgr.mr_n51558096)
print v(xbgr.mr_n51558208)
print v(xbgr.mr_n51558528)
print v(xbgr.mr_n51558640)
print v(xbgr.mr_n51558960)
print v(xbgr.mr_n51559072)
print v(xbgr.mr_n51559392)
print v(xbgr.mr_n51559504)
print v(xbgr.mr_n51559824)
print v(xbgr.mr_n51559936)
print v(xbgr.mr_n51560256)
print v(xbgr.mr_n51560368)
print v(xbgr.mr_n51560688)
print v(xbgr.mr_n51560800)
print v(xbgr.mr_n51561120)
print v(xbgr.mr_n51561232)
print v(xbgr.mr_n51561552)
print v(xbgr.mr_n51561664)
print v(xbgr.mr_n51561984)
print v(xbgr.mr_n51562096)
print v(xbgr.mr_n51562416)
print v(xbgr.mr_n51562528)
print v(xbgr.mr_n51562848)
print v(xbgr.mr_n51562960)
print v(xbgr.mr_n51563280)
print v(xbgr.mr_n51563392)
print v(xbgr.mr_n51563712)
print v(xbgr.mr_n51563824)
print v(xbgr.mr_n51564144)
print v(xbgr.mr_n51564256)
print v(xbgr.mr_n51564576)
print v(xbgr.mr_n51564688)
print v(xbgr.mr_n51565008)
print v(xbgr.mr_n51565120)
print v(xbgr.mr_n51565440)
print v(xbgr.mr_n51565552)
print v(xbgr.mr_n51565872)
print v(xbgr.mr_n51565984)
print v(xbgr.mr_n51566304)
print v(xbgr.mr_n51566416)
print v(xbgr.mr_n51566736)
print v(xbgr.mr_n51566848)
print v(xbgr.mr_n51567168)
print v(xbgr.mr_n51567280)
print v(xbgr.mr_n51567600)
print v(xbgr.mr_n51567712)
print v(xbgr.mr_n51568032)
print v(xbgr.mr_n51568144)
print v(xbgr.mr_n51568464)
print v(xbgr.mr_n51568576)
print v(xbgr.mr_n51568896)
print v(xbgr.mr_n51569008)
print v(xbgr.mr_n51569328)
print v(xbgr.mr_n51569440)
print v(xbgr.mr_n51569760)
print v(xbgr.mr_n51569872)
print v(xbgr.mr_n51570192)
print v(xbgr.mr_n51570304)
print v(xbgr.mr_n51570624)
print v(xbgr.mr_n51570736)
print v(xbgr.mr_n51571056)
print v(xbgr.mr_n51571168)
print v(xbgr.mr_n51571488)
print v(xbgr.mr_n51571600)
print v(xbgr.mr_n51571920)
print v(xbgr.mr_n51572032)
print v(xbgr.mr_n51572352)
print v(xbgr.mr_n51572464)
print v(xbgr.mr_n51572784)
print v(xbgr.mr_n51572896)
print v(xbgr.mr_n51573216)
print v(xbgr.mr_n51573328)
print v(xbgr.mr_n51573648)
print v(xbgr.mr_n51573760)
print v(xbgr.mr_n51574080)
print v(xbgr.mr_n51574192)
print v(xbgr.mr_n51574512)
print v(xbgr.mr_n51574624)
print v(xbgr.mr_n51574944)
print v(xbgr.mr_n51575056)
print v(xbgr.mr_n51575376)
print v(xbgr.mr_n51575488)
print v(xbgr.mr_n51575808)
print v(xbgr.mr_n51575920)
print v(xbgr.mr_n51576240)
print v(xbgr.mr_n51576352)
print v(xbgr.mr_n51576672)
print v(xbgr.mr_n51576784)
print v(xbgr.mr_n51577104)
print v(xbgr.mr_n51577216)
print v(xbgr.mr_n51577536)
print v(xbgr.mr_n51577648)
print v(xbgr.mr_n51577968)
print v(xbgr.mr_n51578080)
print v(xbgr.mr_n51578400)
print v(xbgr.mr_n51578512)
print v(xbgr.mr_n51578832)
print v(xbgr.mr_n51578944)
print v(xbgr.mr_n51579264)
print v(xbgr.mr_n51579376)
print v(xbgr.mr_n51579696)
print v(xbgr.mr_n51579808)
print v(xbgr.mr_n51580128)
print v(xbgr.mr_n51580240)
print v(xbgr.mr_n51580560)
print v(xbgr.mr_n51580672)
print v(xbgr.mr_n51580992)
print v(xbgr.mr_n51581104)
print v(xbgr.mr_n51581424)
print v(xbgr.mr_n51581536)
print v(xbgr.mr_n51581856)
print v(xbgr.mr_n51581968)
print v(xbgr.mr_n51582288)
print v(xbgr.mr_n51582400)
print v(xbgr.mr_n51582720)
print v(xbgr.mr_n51582832)
print v(xbgr.mr_n51583152)
print v(xbgr.mr_n51583264)
print v(xbgr.mr_n51583584)
print v(xbgr.mr_n51583696)
print v(xbgr.mr_n51584016)
print v(xbgr.mr_n51584128)
print v(xbgr.mr_n51584448)
print v(xbgr.mr_n51584560)
print v(xbgr.mr_n51584880)
print v(xbgr.mr_n51584992)
print v(xbgr.mr_n51585312)
print v(xbgr.mr_n51585424)
print v(xbgr.mr_n51585744)
print v(xbgr.mr_n51585856)
print v(xbgr.mr_n51586176)
print v(xbgr.mr_n51586288)
print v(xbgr.mr_n51586608)
print v(xbgr.mr_n51586720)
print v(xbgr.mr_n51587040)
print v(xbgr.mr_n51587152)
print v(xbgr.mr_n51587472)
print v(xbgr.mr_n51587584)
print v(xbgr.mr_n51587904)
print v(xbgr.mr_n51588016)
print v(xbgr.mr_n51588336)
print v(xbgr.mr_n51588448)
print v(xbgr.mr_n51588768)
print v(xbgr.mr_n51588880)
print v(xbgr.mr_n51589200)
print v(xbgr.mr_n51589312)
print v(xbgr.mr_n51589632)
print v(xbgr.mr_n51589744)
print v(xbgr.mr_n51590064)
print v(xbgr.mr_n51590176)
print v(xbgr.mr_n51590496)
print v(xbgr.mr_n51590608)
print v(xbgr.mr_n51590928)
print v(xbgr.mr_n51591040)
print v(xbgr.mr_n51591360)
print v(xbgr.mr_n51591472)
print v(xbgr.mr_n51591792)
print v(xbgr.mr_n51591904)
print v(xbgr.mr_n51592224)
print v(xbgr.mr_n51592336)
print v(xbgr.mr_n51592656)
print v(xbgr.mr_n51592768)
print v(xbgr.mr_n51593088)
print v(xbgr.mr_n51593200)
print v(xbgr.mr_n51593520)
print v(xbgr.mr_n51593632)
print v(xbgr.mr_n51593952)
print v(xbgr.mr_n51594064)
print v(xbgr.mr_n51594384)
print v(xbgr.mr_n51594496)
print v(xbgr.mr_n51594816)
print v(xbgr.mr_n51594928)
print v(xbgr.mr_n51595248)
print v(xbgr.mr_n51595360)
print v(xbgr.mr_n51595680)
print v(xbgr.mr_n51595792)
print v(xbgr.mr_n51596112)
print v(xbgr.mr_n51596224)
print v(xbgr.mr_n51596544)
print v(xbgr.mr_n51596656)
print v(xbgr.mr_n51596976)
print v(xbgr.mr_n51597088)
print v(xbgr.mr_n51597408)
print v(xbgr.mr_n51597520)
print v(xbgr.mr_n51597840)
print v(xbgr.mr_n51597952)
print v(xbgr.mr_n51598272)
print v(xbgr.mr_n51598384)
print v(xbgr.mr_n51598704)
print v(xbgr.mr_n51598816)
print v(xbgr.mr_n51599136)
print v(xbgr.mr_n51599248)
print v(xbgr.mr_n51599568)
print v(xbgr.mr_n51599680)
print v(xbgr.mr_n51600000)
print v(xbgr.mr_n51600112)
print v(xbgr.mr_n51600432)
print v(xbgr.mr_n51600544)
print v(xbgr.mr_n51600864)
print v(xbgr.mr_n51600976)
print v(xbgr.mr_n51601296)
print v(xbgr.mr_n51601408)
print v(xbgr.mr_n51601728)
print v(xbgr.mr_n51601840)
print v(xbgr.mr_n51602160)
print v(xbgr.mr_n51602272)
print v(xbgr.mr_n51602592)
print v(xbgr.mr_n51602704)
print v(xbgr.mr_n51603024)
print v(xbgr.mr_n51603136)
print v(xbgr.mr_n51603456)
print v(xbgr.mr_n51603568)
print v(xbgr.mr_n51603888)
print v(xbgr.mr_n51604000)
print v(xbgr.mr_n51604320)
print v(xbgr.mr_n51604432)
print v(xbgr.mr_n51604752)
print v(xbgr.mr_n51604864)
print v(xbgr.mr_n51605184)
print v(xbgr.mr_n51605296)
print v(xbgr.mr_n51605616)
print v(xbgr.mr_n51605728)
print v(xbgr.mr_n51606048)
print v(xbgr.mr_n51606160)
print v(xbgr.mr_n51606480)
print v(xbgr.mr_n51606592)
print v(xbgr.mr_n51606912)
print v(xbgr.mr_n51607024)
print v(xbgr.mr_n51607344)
print v(xbgr.mr_n51607456)
print v(xbgr.mr_n51607776)
print v(xbgr.mr_n51607888)
print v(xbgr.mr_n51608208)
print v(xbgr.mr_n51608320)
print v(xbgr.mr_n51608640)
print v(xbgr.mr_n51608752)
print v(xbgr.mr_n51609072)
print v(xbgr.mr_n51609184)
print v(xbgr.mr_n51609504)
print v(xbgr.mr_n51609616)
print v(xbgr.mr_n51609936)
print v(xbgr.mr_n51610048)
print v(xbgr.mr_n51610368)
print v(xbgr.mr_n51610480)
print v(xbgr.mr_n51610800)
print v(xbgr.mr_n51610912)
print v(xbgr.mr_n51611232)
print v(xbgr.mr_n51611344)
print v(xbgr.mr_n51611664)
print v(xbgr.mr_n51611776)
print v(xbgr.mr_n51612096)
print v(xbgr.mr_n51612208)
print v(xbgr.mr_n51612528)
print v(xbgr.mr_n51612640)
print v(xbgr.mr_n51612960)
print v(xbgr.mr_n51613072)
print v(xbgr.mr_n51613392)
print v(xbgr.mr_n51613504)
print v(xbgr.mr_n51613824)
print v(xbgr.mr_n51613936)
print v(xbgr.mr_n51614256)
print v(xbgr.mr_n51614368)
print v(xbgr.mr_n51614688)
print v(xbgr.mr_n51614800)
print v(xbgr.mr_n51615120)
print v(xbgr.mr_n51615232)
print v(xbgr.mr_n51615552)
print v(xbgr.mr_n51615664)
print v(xbgr.mr_n51615984)
print v(xbgr.mr_n51616096)
print v(xbgr.mr_n51616416)
print v(xbgr.mr_n51616528)
print v(xbgr.mr_n51616848)
print v(xbgr.mr_n51616960)
print v(xbgr.mr_n51617280)
print v(xbgr.mr_n51617392)
print v(xbgr.mr_n51617712)
print v(xbgr.mr_n51617824)
print v(xbgr.mr_n51618144)
print v(xbgr.mr_n51618256)
print v(xbgr.mr_n51618576)
print v(xbgr.mr_n51618688)
print v(xbgr.mr_n51619008)
print v(xbgr.mr_n51619120)
print v(xbgr.mr_n51619440)
print v(xbgr.mr_n51619552)
print v(xbgr.mr_n51619872)
print v(xbgr.mr_n51619984)
print v(xbgr.mr_n51620304)
print v(xbgr.mr_n51620416)
print v(xbgr.mr_n51620736)
print v(xbgr.mr_n51620848)
print v(xbgr.mr_n51621168)
print v(xbgr.mr_n51621280)
print v(xbgr.mr_n51621600)
print v(xbgr.mr_n51621712)
print v(xbgr.mr_n51622032)
print v(xbgr.mr_n51622144)
print v(xbgr.mr_n51622464)
print v(xbgr.mr_n51622576)
print v(xbgr.mr_n51622896)
print v(xbgr.mr_n51623008)
print v(xbgr.mr_n51623328)
print v(xbgr.mr_n51623440)
print v(xbgr.mr_n51623760)
print v(xbgr.mr_n51623872)
print v(xbgr.mr_n51624192)
print v(xbgr.mr_n51624304)
print v(xbgr.mr_n51624624)
print v(xbgr.mr_n51624736)
print v(xbgr.mr_n51625056)
print v(xbgr.mr_n51625168)
print v(xbgr.mr_n51625488)
print v(xbgr.mr_n51625600)
print v(xbgr.mr_n51625920)
print v(xbgr.mr_n51626032)
print v(xbgr.mr_n51626352)
print v(xbgr.mr_n51626464)
print v(xbgr.mr_n51626784)
print v(xbgr.mr_n51626896)
print v(xbgr.mr_n51627216)
print v(xbgr.mr_n51627328)
print v(xbgr.mr_n51627648)
print v(xbgr.mr_n51627760)
print v(xbgr.mr_n51628080)
print v(xbgr.mr_n51628192)
print v(xbgr.mr_n51628512)
print v(xbgr.mr_n51628624)
print v(xbgr.mr_n51628944)
print v(xbgr.mr_n51629056)
print v(xbgr.mr_n51629376)
print v(xbgr.mr_n51629488)
print v(xbgr.mr_n51629808)
print v(xbgr.mr_n51629920)
print v(xbgr.mr_n51630240)
print v(xbgr.mr_n51630352)
print v(xbgr.mr_n51630672)
print v(xbgr.mr_n51630784)
print v(xbgr.mr_n51631104)
print v(xbgr.mr_n51631216)
print v(xbgr.mr_n51631536)
print v(xbgr.mr_n51631648)
print v(xbgr.mr_n51631968)
print v(xbgr.mr_n51632080)
print v(xbgr.mr_n51632400)
print v(xbgr.mr_n51632512)
print v(xbgr.mr_n51632832)
print v(xbgr.mr_n51632944)
print v(xbgr.mr_n51633264)
print v(xbgr.mr_n51633376)
print v(xbgr.mr_n51633696)
print v(xbgr.mr_n51633808)
print v(xbgr.mr_n51634128)
print v(xbgr.mr_n51634240)
print v(xbgr.mr_n51634560)
print v(xbgr.mr_n51634672)
print v(xbgr.mr_n51634992)
print v(xbgr.mr_n51635104)
print v(xbgr.mr_n51635424)
print v(xbgr.mr_n51635536)
print v(xbgr.mr_n51635856)
print v(xbgr.mr_n51635968)
print v(xbgr.mr_n51636288)
print v(xbgr.mr_n51636400)
print v(xbgr.mr_n51636720)
print v(xbgr.mr_n51636832)
print v(xbgr.mr_n51637152)
print v(xbgr.mr_n51637264)
print v(xbgr.mr_n51637584)
print v(xbgr.mr_n51637696)
print v(xbgr.mr_n51638016)
print v(xbgr.mr_n51638128)
print v(xbgr.mr_n51638448)
print v(xbgr.mr_n51638560)
print v(xbgr.mr_n51638880)
print v(xbgr.mr_n51638992)
print v(xbgr.mr_n51639312)
print v(xbgr.mr_n51639424)
print v(xbgr.mr_n51639744)
print v(xbgr.mr_n51639856)
print v(xbgr.mr_n51640176)
print v(xbgr.mr_n51640288)
print v(xbgr.mr_n51640608)
print v(xbgr.mr_n51640720)
print v(xbgr.mr_n51641040)
print v(xbgr.mr_n51641152)
print v(xbgr.mr_n51641472)
print v(xbgr.mr_n51641584)
print v(xbgr.mr_n51641904)
print v(xbgr.mr_n51642016)
print v(xbgr.mr_n51642336)
print v(xbgr.mr_n51642448)
print v(xbgr.mr_n51642768)
print v(xbgr.mr_n51642880)
print v(xbgr.mr_n51643200)
print v(xbgr.mr_n51643312)
print v(xbgr.mr_n51643632)
print v(xbgr.mr_n51643744)
print v(xbgr.mr_n51644064)
print v(xbgr.mr_n51644176)
print v(xbgr.mr_n51644496)
print v(xbgr.mr_n51644608)
print v(xbgr.mr_n51644928)
print v(xbgr.mr_n51645040)
print v(xbgr.mr_n51645360)
print v(xbgr.mr_n51645472)
print v(xbgr.mr_n51645792)
print v(xbgr.mr_n51645904)
print v(xbgr.mr_n51646224)
print v(xbgr.mr_n51646336)
print v(xbgr.mr_n51646656)
print v(xbgr.mr_n51646768)
print v(xbgr.mr_n51647088)
print v(xbgr.mr_n51647200)
print v(xbgr.mr_n51647520)
print v(xbgr.mr_n51647632)
print v(xbgr.mr_n51647952)
print v(xbgr.mr_n51648064)
print v(xbgr.mr_n51648384)
print v(xbgr.mr_n51648496)
print v(xbgr.mr_n51648816)
print v(xbgr.mr_n51648928)
print v(xbgr.mr_n51649248)
print v(xbgr.mr_n51649360)
print v(xbgr.mr_n51649680)
print v(xbgr.mr_n51649792)
print v(xbgr.mr_n51650112)
print v(xbgr.mr_n51650224)
print v(xbgr.mr_n51650544)
print v(xbgr.mr_n51650656)
print v(xbgr.mr_n51650976)
print v(xbgr.mr_n51651088)
print v(xbgr.mr_n51651408)
print v(xbgr.mr_n51651520)
print v(xbgr.mr_n51651840)
print v(xbgr.mr_n51651952)
print v(xbgr.mr_n51652272)
print v(xbgr.mr_n51652384)
print v(xbgr.mr_n51652704)
print v(xbgr.mr_n51652816)
print v(xbgr.mr_n51653136)
print v(xbgr.mr_n51653248)
print v(xbgr.mr_n51653568)
print v(xbgr.mr_n51653680)
print v(xbgr.mr_n51654000)
print v(xbgr.mr_n51654112)
print v(xbgr.mr_n51654432)
print v(xbgr.mr_n51654544)
print v(xbgr.mr_n51654864)
print v(xbgr.mr_n51654976)
print v(xbgr.mr_n51655296)
print v(xbgr.mr_n51655408)
print v(xbgr.mr_n51655728)
print v(xbgr.mr_n51655840)
print v(xbgr.mr_n51656160)
print v(xbgr.mr_n51656272)
print v(xbgr.mr_n51656592)
print v(xbgr.mr_n51656704)
print v(xbgr.mr_n51657024)
print v(xbgr.mr_n51657136)
print v(xbgr.mr_n51657456)
print v(xbgr.mr_n51657568)
print v(xbgr.mr_n51657888)
print v(xbgr.mr_n51658000)
print v(xbgr.mr_n51658320)
print v(xbgr.mr_n51658432)
print v(xbgr.mr_n51658752)
print v(xbgr.mr_n51658864)
print v(xbgr.mr_n51659184)
print v(xbgr.mr_n51659296)
print v(xbgr.mr_n51659616)
print v(xbgr.mr_n51659728)
print v(xbgr.mr_n51660048)
print v(xbgr.mr_n51660160)
print v(xbgr.mr_n51660480)
print v(xbgr.mr_n51660592)
print v(xbgr.mr_n51660912)
print v(xbgr.mr_n51661024)
print v(xbgr.mr_n51661344)
print v(xbgr.mr_n51661456)
print v(xbgr.mr_n51661776)
print v(xbgr.mr_n51661888)
print v(xbgr.mr_n51662208)
print v(xbgr.mr_n51662320)
print v(xbgr.mr_n51662640)
print v(xbgr.mr_n51662752)
print v(xbgr.mr_n51663072)
print v(xbgr.mr_n51663184)
print v(xbgr.mr_n51663504)
print v(xbgr.mr_n51663616)
print v(xbgr.mr_n51663936)
print v(xbgr.mr_n51664048)
print v(xbgr.mr_n51664368)
print v(xbgr.mr_n51664480)
print v(xbgr.mr_n51664800)
print v(xbgr.mr_n51664912)
print v(xbgr.mr_n51665232)
print v(xbgr.mr_n51665344)
print v(xbgr.mr_n51665664)
print v(xbgr.mr_n51665776)
print v(xbgr.mr_n51666096)
print v(xbgr.mr_n51666208)
print v(xbgr.mr_n51666528)
print v(xbgr.mr_n51666640)
print v(xbgr.mr_n51666960)
print v(xbgr.mr_n51667072)
print v(xbgr.mr_n51667392)
print v(xbgr.mr_n51667504)
print v(xbgr.mr_n51667824)
print v(xbgr.mr_n51667936)
print v(xbgr.mr_n51668256)
print v(xbgr.mr_n51668368)
print v(xbgr.mr_n51668688)
print v(xbgr.mr_n51668800)
print v(xbgr.mr_n51669120)
print v(xbgr.mr_n51669232)
print v(xbgr.mr_n51669552)
print v(xbgr.mr_n51669664)
print v(xbgr.mr_n51669984)
print v(xbgr.mr_n51670096)
print v(xbgr.mr_n51670416)
print v(xbgr.mr_n51670528)
print v(xbgr.mr_n51670848)
print v(xbgr.mr_n51670960)
print v(xbgr.mr_n51671280)
print v(xbgr.mr_n51671392)
print v(xbgr.mr_n51671712)
print v(xbgr.mr_n51671824)
print v(xbgr.mr_n51672144)
print v(xbgr.mr_n51672256)
print v(xbgr.mr_n51672576)
print v(xbgr.mr_n51672688)
print v(xbgr.mr_n51673008)
print v(xbgr.mr_n51673120)
print v(xbgr.mr_n51673440)
print v(xbgr.mr_n51673552)
print v(xbgr.mr_n51673872)
print v(xbgr.mr_n51673984)
print v(xbgr.mr_n51674304)
print v(xbgr.mr_n51674416)
print v(xbgr.mr_n51674736)
print v(xbgr.mr_n51674848)
print v(xbgr.mr_n51675168)
print v(xbgr.mr_n51675280)
print v(xbgr.mr_n51675600)
print v(xbgr.mr_n51675712)
print v(xbgr.mr_n51676032)
print v(xbgr.mr_n51676144)
print v(xbgr.mr_n51676464)
print v(xbgr.mr_n51676576)
print v(xbgr.mr_n51676896)
print v(xbgr.mr_n51677008)
print v(xbgr.mr_n51677328)
print v(xbgr.mr_n51677440)
print v(xbgr.mr_n51677760)
print v(xbgr.mr_n51677872)
print v(xbgr.mr_n51678192)
print v(xbgr.mr_n51678304)
print v(xbgr.mr_n51678624)
print v(xbgr.mr_n51678736)
print v(xbgr.mr_n51679056)
print v(xbgr.mr_n51679168)
print v(xbgr.mr_n51679488)
print v(xbgr.mr_n51679600)
print v(xbgr.mr_n51679920)
print v(xbgr.mr_n51680032)
print v(xbgr.mr_n51680352)
print v(xbgr.mr_n51680464)
print v(xbgr.mr_n51680784)
print v(xbgr.mr_n51680896)
print v(xbgr.mr_n51681216)
print v(xbgr.mr_n51681328)
print v(xbgr.mr_n51681648)
print v(xbgr.mr_n51681760)
print v(xbgr.mr_n51682080)
print v(xbgr.mr_n51682192)
print v(xbgr.mr_n51682512)
print v(xbgr.mr_n51682624)
print v(xbgr.mr_n51682944)
print v(xbgr.mr_n51683056)
print v(xbgr.mr_n51683376)
print v(xbgr.mr_n51683488)
print v(xbgr.mr_n51683808)
print v(xbgr.mr_n51683920)
print v(xbgr.mr_n51684240)
print v(xbgr.mr_n51684352)
print v(xbgr.mr_n51684672)
print v(xbgr.mr_n51684784)
print v(xbgr.mr_n51685104)
print v(xbgr.mr_n51685216)
print v(xbgr.mr_n51685536)
print v(xbgr.mr_n51685648)
print v(xbgr.mr_n51685968)
print v(xbgr.mr_n51686080)
print v(xbgr.mr_n51686400)
print v(xbgr.mr_n51686512)
print v(xbgr.mr_n51686832)
print v(xbgr.mr_n51686944)
print v(xbgr.mr_n51687264)
print v(xbgr.mr_n51687376)
print v(xbgr.mr_n51687696)
print v(xbgr.mr_n51687808)
print v(xbgr.mr_n51688128)
print v(xbgr.mr_n51688240)
print v(xbgr.mr_n51688560)
print v(xbgr.mr_n51688672)
print v(xbgr.mr_n51688992)
print v(xbgr.mr_n51689104)
print v(xbgr.mr_n51689424)
print v(xbgr.mr_n51689536)
print v(xbgr.mr_n51689856)
print v(xbgr.mr_n51689968)
print v(xbgr.mr_n51690288)
print v(xbgr.mr_n51690400)
print v(xbgr.mr_n51690720)
print v(xbgr.mr_n51690832)
print v(xbgr.mr_n51691152)
print v(xbgr.mr_n51691264)
print v(xbgr.mr_n51691584)
print v(xbgr.mr_n51691696)
print v(xbgr.mr_n51692016)
print v(xbgr.mr_n51692128)
print v(xbgr.mr_n51692448)
print v(xbgr.mr_n51692560)
print v(xbgr.mr_n51692880)
print v(xbgr.mr_n51692992)
print v(xbgr.mr_n51693312)
print v(xbgr.mr_n51693424)
print v(xbgr.mr_n51693744)
print v(xbgr.mr_n51693856)
print v(xbgr.mr_n51694176)
print v(xbgr.mr_n51694288)
print v(xbgr.mr_n51694608)
print v(xbgr.mr_n51694720)
print v(xbgr.mr_n51695040)
print v(xbgr.mr_n51695152)
print v(xbgr.mr_n51695472)
print v(xbgr.mr_n51695584)
print v(xbgr.mr_n51695904)
print v(xbgr.mr_n51696016)
print v(xbgr.mr_n51696336)
print v(xbgr.mr_n51696448)
print v(xbgr.mr_n51696768)
print v(xbgr.mr_n51696880)
print v(xbgr.mr_n51697200)
print v(xbgr.mr_n51697312)
print v(xbgr.mr_n51697632)
print v(xbgr.mr_n51697744)
print v(xbgr.mr_n51698064)
print v(xbgr.mr_n51698176)
print v(xbgr.mr_n51698496)
print v(xbgr.mr_n51698608)
print v(xbgr.mr_n51698928)
print v(xbgr.mr_n51699040)
print v(xbgr.mr_n51699360)
print v(xbgr.mr_n51699472)
print v(xbgr.mr_n51699792)
print v(xbgr.mr_n51699904)
print v(xbgr.mr_n51700224)
print v(xbgr.mr_n51700336)
print v(xbgr.mr_n51700656)
print v(xbgr.mr_n51700768)
print v(xbgr.mr_n51701088)
print v(xbgr.mr_n51701200)
print v(xbgr.mr_n51701520)
print v(xbgr.mr_n51701632)
print v(xbgr.mr_n51701952)
print v(xbgr.mr_n51702064)
print v(xbgr.mr_n51702384)
print v(xbgr.mr_n51702496)
print v(xbgr.mr_n51702816)
print v(xbgr.mr_n51702928)
print v(xbgr.mr_n51703248)
print v(xbgr.mr_n51703360)
print v(xbgr.mr_n51703680)
print v(xbgr.mr_n51703792)
print v(xbgr.mr_n51704112)
print v(xbgr.mr_n51704224)
print v(xbgr.mr_n51704544)
print v(xbgr.mr_n51704656)
print v(xbgr.mr_n51704976)
print v(xbgr.mr_n51705088)
print v(xbgr.mr_n51705408)
print v(xbgr.mr_n51705520)
print v(xbgr.mr_n51705840)
print v(xbgr.mr_n51705952)
print v(xbgr.mr_n51706272)
print v(xbgr.mr_n51706384)
print v(xbgr.mr_n51706704)
print v(xbgr.mr_n51706816)
print v(xbgr.mr_n51707136)
print v(xbgr.mr_n51707248)
print v(xbgr.mr_n51707568)
print v(xbgr.mr_n51707680)
print v(xbgr.mr_n51708000)
print v(xbgr.mr_n51708112)
print v(xbgr.mr_n51708432)
print v(xbgr.mr_n51708544)
print v(xbgr.mr_n51708864)
print v(xbgr.mr_n51708976)
print v(xbgr.mr_n51709296)
print v(xbgr.mr_n51709408)
print v(xbgr.mr_n51709728)
print v(xbgr.mr_n51709840)
print v(xbgr.mr_n51710160)
print v(xbgr.mr_n51710272)
print v(xbgr.mr_n51710592)
print v(xbgr.mr_n51710704)
print v(xbgr.mr_n51711024)
print v(xbgr.mr_n51711136)
print v(xbgr.mr_n51711456)
print v(xbgr.mr_n51711568)
print v(xbgr.mr_n51711888)
print v(xbgr.mr_n51712000)
print v(xbgr.mr_n51712320)
print v(xbgr.mr_n51712432)
print v(xbgr.mr_n51712752)
print v(xbgr.mr_n51712864)
print v(xbgr.mr_n51713184)
print v(xbgr.mr_n51713296)
print v(xbgr.mr_n51713616)
print v(xbgr.mr_n51713728)
print v(xbgr.mr_n51714048)
print v(xbgr.mr_n51714160)
print v(xbgr.mr_n51714480)
print v(xbgr.mr_n51714592)
print v(xbgr.mr_n51714912)
print v(xbgr.mr_n51715024)
print v(xbgr.mr_n51715344)
print v(xbgr.mr_n51715456)
print v(xbgr.mr_n51715776)
print v(xbgr.mr_n51715888)
print v(xbgr.mr_n51716208)
print v(xbgr.mr_n51716320)
print v(xbgr.mr_n51716640)
print v(xbgr.mr_n51716752)
print v(xbgr.mr_n51717072)
print v(xbgr.mr_n51717184)
print v(xbgr.mr_n51717504)
print v(xbgr.mr_n51717616)
print v(xbgr.mr_n51717936)
print v(xbgr.mr_n51718048)
print v(xbgr.mr_n51718368)
print v(xbgr.mr_n51718480)
print v(xbgr.mr_n51718800)
print v(xbgr.mr_n51718912)
print v(xbgr.mr_n51719232)
print v(xbgr.mr_n51719344)
print v(xbgr.mr_n51719664)
print v(xbgr.mr_n51719776)
print v(xbgr.mr_n51720096)
print v(xbgr.mr_n51720208)
print v(xbgr.mr_n51720528)
print v(xbgr.mr_n51720640)
print v(xbgr.mr_n51720960)
print v(xbgr.mr_n51721072)
print v(xbgr.mr_n51721392)
print v(xbgr.mr_n51721504)
print v(xbgr.mr_n51721824)
print v(xbgr.mr_n51721936)
print v(xbgr.mr_n51722256)
print v(xbgr.mr_n51722368)
print v(xbgr.mr_n51722688)
print v(xbgr.mr_n51722800)
print v(xbgr.mr_n51723120)
print v(xbgr.mr_n51723232)
print v(xbgr.mr_n51723552)
print v(xbgr.mr_n51723664)
print v(xbgr.mr_n51723984)
print v(xbgr.mr_n51724096)
print v(xbgr.mr_n51724416)
print v(xbgr.mr_n51724528)
print v(xbgr.mr_n51724848)
print v(xbgr.mr_n51724960)
print v(xbgr.mr_n51725280)
print v(xbgr.mr_n51725392)
print v(xbgr.mr_n51725712)
print v(xbgr.mr_n51725824)
print v(xbgr.mr_n51726144)
print v(xbgr.mr_n51726256)
print v(xbgr.mr_n51726576)
print v(xbgr.mr_n51726688)
print v(xbgr.mr_n51727008)
print v(xbgr.mr_n51727120)
print v(xbgr.mr_n51727440)
print v(xbgr.mr_n51727552)
print v(xbgr.mr_n51727872)
print v(xbgr.mr_n51727984)
print v(xbgr.mr_n51728304)
print v(xbgr.mr_n51728416)
print v(xbgr.mr_n51728736)
print v(xbgr.mr_n51728848)
print v(xbgr.mr_n51729168)
print v(xbgr.mr_n51729280)
print v(xbgr.mr_n51729600)
print v(xbgr.mr_n51729712)
print v(xbgr.mr_n51730032)
print v(xbgr.mr_n51730144)
print v(xbgr.mr_n51730464)
print v(xbgr.mr_n51730576)
print v(xbgr.mr_n51730896)
print v(xbgr.mr_n51731008)
print v(xbgr.mr_n51731328)
print v(xbgr.mr_n51731440)
print v(xbgr.mr_n51731760)
print v(xbgr.mr_n51731872)
print v(xbgr.mr_n51732192)
print v(xbgr.mr_n51732304)
print v(xbgr.mr_n51732624)
print v(xbgr.mr_n51732736)
print v(xbgr.mr_n51733056)
print v(xbgr.mr_n51733168)
print v(xbgr.mr_n51733488)
print v(xbgr.mr_n51733600)
print v(xbgr.mr_n51733920)
print v(xbgr.mr_n51734032)
print v(xbgr.mr_n51734352)
print v(xbgr.mr_n51734464)
print v(xbgr.mr_n51734784)
print v(xbgr.mr_n51734896)
print v(xbgr.mr_n51735216)
print v(xbgr.mr_n51735328)
print v(xbgr.mr_n51735648)
print v(xbgr.mr_n51735760)
print v(xbgr.mr_n51736080)
print v(xbgr.mr_n51736192)
print v(xbgr.mr_n51736512)
print v(xbgr.mr_n51736624)
print v(xbgr.mr_n51736944)
print v(xbgr.mr_n51737056)
print v(xbgr.mr_n51737376)
print v(xbgr.mr_n51737488)
print v(xbgr.mr_n51737808)
print v(xbgr.mr_n51737920)
print v(xbgr.mr_n51738240)
print v(xbgr.mr_n51738352)
print v(xbgr.mr_n51738672)
print v(xbgr.mr_n51738784)
print v(xbgr.mr_n51739104)
print v(xbgr.mr_n51739216)
print v(xbgr.mr_n51739536)
print v(xbgr.mr_n51739648)
print v(xbgr.mr_n51739968)
print v(xbgr.mr_n51740080)
print v(xbgr.mr_n51740400)
print v(xbgr.mr_n51740512)
print v(xbgr.mr_n51740832)
print v(xbgr.mr_n51740944)
print v(xbgr.mr_n51741264)
print v(xbgr.mr_n51741376)
print v(xbgr.mr_n51741696)
print v(xbgr.mr_n51741808)
print v(xbgr.mr_n51742128)
print v(xbgr.mr_n51742240)
print v(xbgr.mr_n51742560)
print v(xbgr.mr_n51742672)
print v(xbgr.mr_n51742992)
print v(xbgr.mr_n51743104)
print v(xbgr.mr_n51743424)
print v(xbgr.mr_n51743536)
print v(xbgr.mr_n51743856)
print v(xbgr.mr_n51743968)
print v(xbgr.mr_n51744288)
print v(xbgr.mr_n51744400)
print v(xbgr.mr_n51744720)
print v(xbgr.mr_n51744832)
print v(xbgr.mr_n51745152)
print v(xbgr.mr_n51745264)
print v(xbgr.mr_n51745584)
print v(xbgr.mr_n51745696)
print v(xbgr.mr_n51746016)
print v(xbgr.mr_n51746128)
print v(xbgr.mr_n51746448)
print v(xbgr.mr_n51746560)
print v(xbgr.mr_n51746880)
print v(xbgr.mr_n51746992)
print v(xbgr.mr_n51747312)
print v(xbgr.mr_n51747424)
print v(xbgr.mr_n51747744)
print v(xbgr.mr_n51747856)
print v(xbgr.mr_n51748176)
print v(xbgr.mr_n51748288)
print v(xbgr.mr_n51748608)
print v(xbgr.mr_n51748720)
print v(xbgr.mr_n51749040)
print v(xbgr.mr_n51749152)
print v(xbgr.mr_n51749472)
print v(xbgr.mr_n51749584)
print v(xbgr.mr_n51749904)
print v(xbgr.mr_n51750016)
print v(xbgr.mr_n51750336)
print v(xbgr.mr_n51750448)
print v(xbgr.mr_n51750768)
print v(xbgr.mr_n51750880)
print v(xbgr.mr_n51751200)
print v(xbgr.mr_n51751312)
print v(xbgr.mr_n51751632)
print v(xbgr.mr_n51751744)
print v(xbgr.mr_n51752064)
print v(xbgr.mr_n51752176)
print v(xbgr.mr_n51752496)
print v(xbgr.mr_n51752608)
print v(xbgr.mr_n51752928)
print v(xbgr.mr_n51753040)
print v(xbgr.mr_n51753360)
print v(xbgr.mr_n51753472)
print v(xbgr.mr_n51753792)
print v(xbgr.mr_n51753904)
print v(xbgr.mr_n51754224)
print v(xbgr.mr_n51754336)
print v(xbgr.mr_n51754656)
print v(xbgr.mr_n51754768)
print v(xbgr.mr_n51755088)
print v(xbgr.mr_n51755200)
print v(xbgr.mr_n51755520)
print v(xbgr.mr_n51755632)
print v(xbgr.mr_n51755952)
print v(xbgr.mr_n51756064)
print v(xbgr.mr_n51756384)
print v(xbgr.mr_n51756496)
print v(xbgr.mr_n51756816)
print v(xbgr.mr_n51756928)
print v(xbgr.mr_n51757248)
print v(xbgr.mr_n51757360)
print v(xbgr.mr_n51757680)
print v(xbgr.mr_n51757792)
print v(xbgr.mr_n51758224)
print v(xbgr.mr_n51758544)
print v(xbgr.mr_n51758656)
print v(xbgr.mr_n51759088)
print v(xbgr.mr_n51759408)
print v(xbgr.mr_n51759520)
print v(xbgr.mr_n51759952)
print v(xbgr.mr_n51760272)
print v(xbgr.mr_n51761136)
print v(xbgr.mr_n51762000)
print v(xbgr.mr_n51762864)
print v(xbgr.mr_n51763728)
print v(xbgr.mr_n51764592)
print v(xbgr.mr_n51765456)
print v(xbgr.mr_n51765568)
print v(xbgr.mr_n51765888)
print v(xbgr.mr_n51766000)
print v(xbgr.mr_n51766320)
print v(xbgr.mr_n51766432)
print v(xbgr.mr_n51766752)
print v(xbgr.mr_n51766864)
print v(xbgr.mr_n51767184)
print v(xbgr.mr_n51768048)
print v(xbgr.mr_n51768912)
print v(xbgr.mr_n51769776)
print v(xbgr.mr_n51769888)
print v(xbgr.mr_n51770208)
print v(xbgr.mr_n51770320)
print v(xbgr.mr_n51770640)
print v(xbgr.mr_n51770752)
print v(xbgr.mr_n51771184)
print v(xbgr.mr_n51771616)
print v(xbgr.mr_n51772048)
print v(xbgr.mr_n51772368)
print v(xbgr.mr_n51772480)
print v(xbgr.mr_n51772800)
print v(xbgr.mr_n51772912)
print v(xbgr.mr_n51773232)
print v(xbgr.mr_n51773344)
print v(xbgr.mr_n51773664)
print v(xbgr.mr_n51773776)
print v(xbgr.mr_n51774096)
print v(xbgr.mr_n51774208)
print v(xbgr.mr_n51774528)
print v(xbgr.mr_n51774640)
print v(xbgr.mr_n51774960)
print v(xbgr.mr_n51775072)
print v(xbgr.mr_n51775392)
print v(xbgr.mr_n51775504)
print v(xbgr.mr_n51775824)
print v(xbgr.mr_n51775936)
print v(xbgr.mr_n51776256)
print v(xbgr.mr_n51776368)
print v(xbgr.mr_n51776688)
print v(xbgr.mr_n51776800)
print v(xbgr.mr_n51777120)
print v(xbgr.mr_n51777232)
print v(xbgr.mr_n51777552)
print v(xbgr.mr_n51777664)
print v(xbgr.mr_n51777984)
print v(xbgr.mr_n51778096)
print v(xbgr.mr_n51778416)
print v(xbgr.mr_n51778528)
print v(xbgr.mr_n51778848)
print v(xbgr.mr_n51778960)
print v(xbgr.mr_n51779280)
print v(xbgr.mr_n51779392)
print v(xbgr.mr_n51779712)
print v(xbgr.mr_n51779824)
print v(xbgr.mr_n51780144)
print v(xbgr.mr_n51780256)
print v(xbgr.mr_n51780576)
print v(xbgr.mr_n51780688)
print v(xbgr.mr_n51781008)
print v(xbgr.mr_n51781120)
print v(xbgr.mr_n51781440)
print v(xbgr.mr_n51781552)
print v(xbgr.mr_n51781872)
print v(xbgr.mr_n51781984)
print v(xbgr.mr_n51782304)
print v(xbgr.mr_n51782416)
print v(xbgr.mr_n51782736)
print v(xbgr.mr_n51782848)
print v(xbgr.mr_n51783168)
print v(xbgr.mr_n51783280)
print v(xbgr.mr_n51783600)
print v(xbgr.mr_n51783712)
print v(xbgr.mr_n51784032)
print v(xbgr.mr_n51784144)
print v(xbgr.mr_n51784464)
print v(xbgr.mr_n51784576)
print v(xbgr.mr_n51784896)
print v(xbgr.mr_n51785008)
print v(xbgr.mr_n51785328)
print v(xbgr.mr_n51785440)
print v(xbgr.mr_n51785872)
print v(xbgr.mr_n51786192)
print v(xbgr.mr_n51786304)
print v(xbgr.mr_n51786736)
print v(xbgr.mr_n51787056)
print v(xbgr.mr_n51787920)
print v(xbgr.mr_n51788784)
print v(xbgr.mr_n51789648)
print v(xbgr.mr_n51790512)
print v(xbgr.mr_n51790624)
print v(xbgr.mr_n51790944)
print v(xbgr.mr_n51791056)
print v(xbgr.mr_n51791376)
print v(xbgr.mr_n51791488)
print v(xbgr.mr_n51791808)
print v(xbgr.mr_n51791920)
print v(xbgr.mr_n51792240)
print v(xbgr.mr_n51793104)
print v(xbgr.mr_n51793968)
print v(xbgr.mr_n51794080)
print v(xbgr.mr_n51794400)
print v(xbgr.mr_n51794512)
print v(xbgr.mr_n51794832)
print v(xbgr.mr_n51794944)
print v(xbgr.mr_n51795264)
print v(xbgr.mr_n51795376)
print v(xbgr.mr_n51795696)
print v(xbgr.mr_n51795808)
print v(xbgr.mr_n51796240)
print v(xbgr.mr_n51796560)
print v(xbgr.mr_n51796672)
print v(xbgr.mr_n51797104)
print v(xbgr.mr_n51797424)
print v(xbgr.mr_n51798288)
print v(xbgr.mr_n51799152)
print v(xbgr.mr_n51800016)
print v(xbgr.mr_n51800880)
print v(xbgr.mr_n51800992)
print v(xbgr.mr_n51801312)
print v(xbgr.mr_n51801424)
print v(xbgr.mr_n51801744)
print v(xbgr.mr_n51801856)
print v(xbgr.mr_n51802176)
print v(xbgr.mr_n51802288)
print v(xbgr.mr_n51802608)
print v(xbgr.mr_n51803472)
print v(xbgr.mr_n51804336)
print v(xbgr.mr_n51804448)
print v(xbgr.mr_n51804880)
print v(xbgr.mr_n51805200)
print v(xbgr.mr_n51805312)
print v(xbgr.mr_n51805632)
print v(xbgr.mr_n51805744)
print v(xbgr.mr_n51806064)
print v(xbgr.mr_n51806176)
print v(xbgr.mr_n51806496)
print v(xbgr.mr_n51806608)
print v(xbgr.mr_n51806928)
print v(xbgr.mr_n51807040)
print v(xbgr.mr_n51807472)
print v(xbgr.mr_n51807792)
print v(xbgr.mr_n51808656)
print v(xbgr.mr_n51808768)
print v(xbgr.mr_n51809200)
print v(xbgr.mr_n51809520)
print v(xbgr.mr_n51809632)
print v(xbgr.mr_n51810064)
print v(xbgr.mr_n51810384)
print v(xbgr.mr_n51810496)
print v(xbgr.mr_n51810816)
print v(xbgr.mr_n51810928)
print v(xbgr.mr_n51811248)
print v(xbgr.mr_n51811360)
print v(xbgr.mr_n51811680)
print v(xbgr.mr_n51811792)
print v(xbgr.mr_n51812112)
print v(xbgr.mr_n51812976)
print v(xbgr.mr_n51813840)
print v(xbgr.mr_n51813952)
print v(xbgr.mr_n51814272)
print v(xbgr.mr_n51814384)
print v(xbgr.mr_n51814704)
print v(xbgr.mr_n51814816)
print v(xbgr.mr_n51815136)
print v(xbgr.mr_n51815248)
print v(xbgr.mr_n51815568)
print v(xbgr.mr_n51816432)
print v(xbgr.mr_n51817296)
print v(xbgr.mr_n51817408)
print v(xbgr.mr_n51817728)
print v(xbgr.mr_n51817840)
print v(xbgr.mr_n51818160)
print v(xbgr.mr_n51819024)
print v(xbgr.mr_n51819136)
print v(xbgr.mr_n51819456)
print v(xbgr.mr_n51819568)
print v(xbgr.mr_n51819888)
print v(xbgr.mr_n51820000)
print v(xbgr.mr_n51820320)
print v(xbgr.mr_n51820432)
print v(xbgr.mr_n51820752)
print v(xbgr.mr_n51820864)
print v(xbgr.mr_n51821184)
print v(xbgr.mr_n51821296)
print v(xbgr.mr_n51821616)
print v(xbgr.mr_n51822480)
print v(xbgr.mr_n51823280)
print v(xbgr.mr_n51823392)
print v(xbgr.mr_n51823712)
print v(xbgr.mr_n51823824)
print v(xbgr.mr_n51824144)
print v(xbgr.mr_n51824256)
print v(xbgr.mr_n51824576)
print v(xbgr.mr_n51824688)
print v(xbgr.mr_n51825008)
print v(xbgr.mr_n51825120)
print v(xbgr.mr_n51825440)
print v(xbgr.mr_n51825552)
print v(xbgr.mr_n51825872)
print v(xbgr.mr_n51825984)
print v(xbgr.mr_n51826304)
print v(xbgr.mr_n51826416)
print v(xbgr.mr_n51826736)
print v(xbgr.mr_n51826848)
print v(xbgr.mr_n51827168)
print v(xbgr.mr_n51827280)
print v(xbgr.mr_n51827600)
print v(xbgr.mr_n51827712)
print v(xbgr.mr_n51828032)
print v(xbgr.mr_n51828144)
print v(xbgr.mr_n51828464)
print v(xbgr.mr_n51828576)
print v(xbgr.mr_n51828896)
print v(xbgr.mr_n51829008)
print v(xbgr.mr_n51829328)
print v(xbgr.mr_n51829440)
print v(xbgr.mr_n51829760)
print v(xbgr.mr_n51829872)
print v(xbgr.mr_n51830192)
print v(xbgr.mr_n51830304)
print v(xbgr.mr_n51830624)
print v(xbgr.mr_n51830736)
print v(xbgr.mr_n51831056)
print v(xbgr.mr_n51831168)
print v(xbgr.mr_n51831488)
print v(xbgr.mr_n51831600)
print v(xbgr.mr_n51831920)
print v(xbgr.mr_n51832032)
print v(xbgr.mr_n51832352)
print v(xbgr.mr_n51832464)
print v(xbgr.mr_n51832784)
print v(xbgr.mr_n51832896)
print v(xbgr.mr_n51833216)
print v(xbgr.mr_n51833328)
print v(xbgr.mr_n51833648)
print v(xbgr.mr_n51833760)
print v(xbgr.mr_n51834080)
print v(xbgr.mr_n51834192)
print v(xbgr.mr_n51834512)
print v(xbgr.mr_n51834624)
print v(xbgr.mr_n51834944)
print v(xbgr.mr_n51835056)
print v(xbgr.mr_n51835376)
print v(xbgr.mr_n51835488)
print v(xbgr.mr_n51835808)
print v(xbgr.mr_n51835920)
print v(xbgr.mr_n51836240)
print v(xbgr.mr_n51836352)
print v(xbgr.mr_n51836672)
print v(xbgr.mr_n51836784)
print v(xbgr.mr_n51837104)
print v(xbgr.mr_n51837216)
print v(xbgr.mr_n51837536)
print v(xbgr.mr_n51837648)
print v(xbgr.mr_n51837968)
print v(xbgr.mr_n51838080)
print v(xbgr.mr_n51838400)
print v(xbgr.mr_n51838512)
print v(xbgr.mr_n51838832)
print v(xbgr.mr_n51838944)
print v(xbgr.mr_n51839264)
print v(xbgr.mr_n51839376)
print v(xbgr.mr_n51839696)
print v(xbgr.mr_n51839808)
print v(xbgr.mr_n51840128)
print v(xbgr.mr_n51840240)
print v(xbgr.mr_n51840560)
print v(xbgr.mr_n51840672)
print v(xbgr.mr_n51840992)
print v(xbgr.mr_n51841104)
print v(xbgr.mr_n51841424)
print v(xbgr.mr_n51841536)
print v(xbgr.mr_n51841856)
print v(xbgr.mr_n51841968)
print v(xbgr.mr_n51842288)
print v(xbgr.mr_n51842400)
print v(xbgr.mr_n51842720)
print v(xbgr.mr_n51842832)
print v(xbgr.mr_n51843152)
print v(xbgr.mr_n51843264)
print v(xbgr.mr_n51843584)
print v(xbgr.mr_n51843696)
print v(xbgr.mr_n51844016)
print v(xbgr.mr_n51844128)
print v(xbgr.mr_n51844448)
print v(xbgr.mr_n51844560)
print v(xbgr.mr_n51844880)
print v(xbgr.mr_n51844992)
print v(xbgr.mr_n51845312)
print v(xbgr.mr_n51845424)
print v(xbgr.mr_n51845744)
print v(xbgr.mr_n51845856)
print v(xbgr.mr_n51846176)
print v(xbgr.mr_n51846288)
print v(xbgr.mr_n51846608)
print v(xbgr.mr_n51846720)
print v(xbgr.mr_n51847040)
print v(xbgr.mr_n51847152)
print v(xbgr.mr_n51847472)
print v(xbgr.mr_n51847584)
print v(xbgr.mr_n51847904)
print v(xbgr.mr_n51848016)
print v(xbgr.mr_n51848336)
print v(xbgr.mr_n51848448)
print v(xbgr.mr_n51848768)
print v(xbgr.mr_n51848880)
print v(xbgr.mr_n51849200)
print v(xbgr.mr_n51849312)
print v(xbgr.mr_n51849632)
print v(xbgr.mr_n51849744)
print v(xbgr.mr_n51850064)
print v(xbgr.mr_n51850176)
print v(xbgr.mr_n51850496)
print v(xbgr.mr_n51850608)
print v(xbgr.mr_n51850928)
print v(xbgr.mr_n51851040)
print v(xbgr.mr_n51851360)
print v(xbgr.mr_n51851472)
print v(xbgr.mr_n51851792)
print v(xbgr.mr_n51851904)
print v(xbgr.mr_n51852224)
print v(xbgr.mr_n51852336)
print v(xbgr.mr_n51852656)
print v(xbgr.mr_n51852768)
print v(xbgr.mr_n51853088)
print v(xbgr.mr_n51853200)
print v(xbgr.mr_n51853520)
print v(xbgr.mr_n51853632)
print v(xbgr.mr_n51853952)
print v(xbgr.mr_n51854064)
print v(xbgr.mr_n51854384)
print v(xbgr.mr_n51854496)
print v(xbgr.mr_n51854816)
print v(xbgr.mr_n51854928)
print v(xbgr.mr_n51855248)
print v(xbgr.mr_n51855360)
print v(xbgr.mr_n51855680)
print v(xbgr.mr_n51855792)
print v(xbgr.mr_n51856112)
print v(xbgr.mr_n51856224)
print v(xbgr.mr_n51856544)
print v(xbgr.mr_n51856656)
print v(xbgr.mr_n51856976)
print v(xbgr.mr_n51857088)
print v(xbgr.mr_n51857408)
print v(xbgr.mr_n51857520)
print v(xbgr.mr_n51857840)
print v(xbgr.mr_n51857952)
print v(xbgr.mr_n51858272)
print v(xbgr.mr_n51858384)
print v(xbgr.mr_n51858704)
print v(xbgr.mr_n51858816)
print v(xbgr.mr_n51859136)
print v(xbgr.mr_n51859248)
print v(xbgr.mr_n51859568)
print v(xbgr.mr_n51859680)
print v(xbgr.mr_n51860000)
print v(xbgr.mr_n51860112)
print v(xbgr.mr_n51860432)
print v(xbgr.mr_n51860544)
print v(xbgr.mr_n51860864)
print v(xbgr.mr_n51860976)
print v(xbgr.mr_n51861296)
print v(xbgr.mr_n51861408)
print v(xbgr.mr_n51861728)
print v(xbgr.mr_n51861840)
print v(xbgr.mr_n51862160)
print v(xbgr.mr_n51862272)
print v(xbgr.mr_n51862592)
print v(xbgr.mr_n51862704)
print v(xbgr.mr_n51863024)
print v(xbgr.mr_n51863136)
print v(xbgr.mr_n51863456)
print v(xbgr.mr_n51863568)
print v(xbgr.mr_n51863888)
print v(xbgr.mr_n51864000)
print v(xbgr.mr_n51864320)
print v(xbgr.mr_n51864432)
print v(xbgr.mr_n51864752)
print v(xbgr.mr_n51864864)
print v(xbgr.mr_n51865184)
print v(xbgr.mr_n51865296)
print v(xbgr.mr_n51865616)
print v(xbgr.mr_n51865728)
print v(xbgr.mr_n51866048)
print v(xbgr.mr_n51866160)
print v(xbgr.mr_n51866480)
print v(xbgr.mr_n51866592)
print v(xbgr.mr_n51866912)
print v(xbgr.mr_n51867024)
print v(xbgr.mr_n51867344)
print v(xbgr.mr_n51867456)
print v(xbgr.mr_n51867776)
print v(xbgr.mr_n51867888)
print v(xbgr.mr_n51868208)
print v(xbgr.mr_n51868320)
print v(xbgr.mr_n51868640)
print v(xbgr.mr_n51868752)
print v(xbgr.mr_n51869072)
print v(xbgr.mr_n51869184)
print v(xbgr.mr_n51869504)
print v(xbgr.mr_n51869616)
print v(xbgr.mr_n51869936)
print v(xbgr.mr_n51870048)
print v(xbgr.mr_n51870368)
print v(xbgr.mr_n51870480)
print v(xbgr.mr_n51870800)
print v(xbgr.mr_n51870912)
print v(xbgr.mr_n51871232)
print v(xbgr.mr_n51871344)
print v(xbgr.mr_n51871664)
print v(xbgr.mr_n51871776)
print v(xbgr.mr_n51872096)
print v(xbgr.mr_n51872208)
print v(xbgr.mr_n51872528)
print v(xbgr.mr_n51872640)
print v(xbgr.mr_n51872960)
print v(xbgr.mr_n51873072)
print v(xbgr.mr_n51873392)
print v(xbgr.mr_n51873504)
print v(xbgr.mr_n51873824)
print v(xbgr.mr_n51873936)
print v(xbgr.mr_n51874256)
print v(xbgr.mr_n51874368)
print v(xbgr.mr_n51874688)
print v(xbgr.mr_n51874800)
print v(xbgr.mr_n51875120)
print v(xbgr.mr_n51875232)
print v(xbgr.mr_n51875552)
print v(xbgr.mr_n51875664)
print v(xbgr.mr_n51875984)
print v(xbgr.mr_n51876096)
print v(xbgr.mr_n51876416)
print v(xbgr.mr_n51876528)
print v(xbgr.mr_n51876848)
print v(xbgr.mr_n51876960)
print v(xbgr.mr_n51877280)
print v(xbgr.mr_n51877392)
print v(xbgr.mr_n51877712)
print v(xbgr.mr_n51877824)
print v(xbgr.mr_n51878144)
print v(xbgr.mr_n51878256)
print v(xbgr.mr_n51878576)
print v(xbgr.mr_n51878688)
print v(xbgr.mr_n51879008)
print v(xbgr.mr_n51879120)
print v(xbgr.mr_n51879440)
print v(xbgr.mr_n51879552)
print v(xbgr.mr_n51879872)
print v(xbgr.mr_n51879984)
print v(xbgr.mr_n51880304)
print v(xbgr.mr_n51880416)
print v(xbgr.mr_n51880736)
print v(xbgr.mr_n51880848)
print v(xbgr.mr_n51881168)
print v(xbgr.mr_n51881280)
print v(xbgr.mr_n51881600)
print v(xbgr.mr_n51881712)
print v(xbgr.mr_n51882032)
print v(xbgr.mr_n51882144)
print v(xbgr.mr_n51882464)
print v(xbgr.mr_n51882576)
print v(xbgr.mr_n51882896)
print v(xbgr.mr_n51883008)
print v(xbgr.mr_n51883328)
print v(xbgr.mr_n51883440)
print v(xbgr.mr_n51883760)
print v(xbgr.mr_n51883872)
print v(xbgr.mr_n51884192)
print v(xbgr.mr_n51884304)
print v(xbgr.mr_n51884624)
print v(xbgr.mr_n51884736)
print v(xbgr.mr_n51885056)
print v(xbgr.mr_n51885168)
print v(xbgr.mr_n51885488)
print v(xbgr.mr_n51885600)
print v(xbgr.mr_n51885920)
print v(xbgr.mr_n51886032)
print v(xbgr.mr_n51886352)
print v(xbgr.mr_n51886464)
print v(xbgr.mr_n51886784)
print v(xbgr.mr_n51886896)
print v(xbgr.mr_n51887216)
print v(xbgr.mr_n51887328)
print v(xbgr.mr_n51887648)
print v(xbgr.mr_n51887760)
print v(xbgr.mr_n51888080)
print v(xbgr.mr_n51888192)
print v(xbgr.mr_n51888512)
print v(xbgr.mr_n51888624)
print v(xbgr.mr_n51888944)
print v(xbgr.mr_n51889056)
print v(xbgr.mr_n51889376)
print v(xbgr.mr_n51889488)
print v(xbgr.mr_n51889808)
print v(xbgr.mr_n51889920)
print v(xbgr.mr_n51890240)
print v(xbgr.mr_n51890352)
print v(xbgr.mr_n51890672)
print v(xbgr.mr_n51890784)
print v(xbgr.mr_n51891104)
print v(xbgr.mr_n51891216)
print v(xbgr.mr_n51891536)
print v(xbgr.mr_n51891648)
print v(xbgr.mr_n51891968)
print v(xbgr.mr_n51892080)
print v(xbgr.mr_n51892400)
print v(xbgr.mr_n51892512)
print v(xbgr.mr_n51892832)
print v(xbgr.mr_n51892944)
print v(xbgr.mr_n51893264)
print v(xbgr.mr_n51893376)
print v(xbgr.mr_n51893696)
print v(xbgr.mr_n51893808)
print v(xbgr.mr_n51894128)
print v(xbgr.mr_n51894240)
print v(xbgr.mr_n51894560)
print v(xbgr.mr_n51894672)
print v(xbgr.mr_n51894992)
print v(xbgr.mr_n51895104)
print v(xbgr.mr_n51895424)
print v(xbgr.mr_n51895536)
print v(xbgr.mr_n51895856)
print v(xbgr.mr_n51895968)
print v(xbgr.mr_n51896288)
print v(xbgr.mr_n51896400)
print v(xbgr.mr_n51896720)
print v(xbgr.mr_n51896832)
print v(xbgr.mr_n51897152)
print v(xbgr.mr_n51897264)
print v(xbgr.mr_n51897584)
print v(xbgr.mr_n51897696)
print v(xbgr.mr_n51898016)
print v(xbgr.mr_n51898128)
print v(xbgr.mr_n51898448)
print v(xbgr.mr_n51898560)
print v(xbgr.mr_n51898880)
print v(xbgr.mr_n51898992)
print v(xbgr.mr_n51899312)
print v(xbgr.mr_n51899424)
print v(xbgr.mr_n51899744)
print v(xbgr.mr_n51899856)
print v(xbgr.mr_n51900176)
print v(xbgr.mr_n51900288)
print v(xbgr.mr_n51900608)
print v(xbgr.mr_n51900720)
print v(xbgr.mr_n51901040)
print v(xbgr.mr_n51901152)
print v(xbgr.mr_n51901472)
print v(xbgr.mr_n51901584)
print v(xbgr.mr_n51901904)
print v(xbgr.mr_n51902016)
print v(xbgr.mr_n51902336)
print v(xbgr.mr_n51902448)
print v(xbgr.mr_n51902768)
print v(xbgr.mr_n51902880)
print v(xbgr.mr_n51903200)
print v(xbgr.mr_n51903312)
print v(xbgr.mr_n51903632)
print v(xbgr.mr_n51903744)
print v(xbgr.mr_n51904064)
print v(xbgr.mr_n51904176)
print v(xbgr.mr_n51904496)
print v(xbgr.mr_n51904608)
print v(xbgr.mr_n51904928)
print v(xbgr.mr_n51905040)
print v(xbgr.mr_n51905360)
print v(xbgr.mr_n51905472)
print v(xbgr.mr_n51905792)
print v(xbgr.mr_n51905904)
print v(xbgr.mr_n51906224)
print v(xbgr.mr_n51906336)
print v(xbgr.mr_n51906656)
print v(xbgr.mr_n51906768)
print v(xbgr.mr_n51907088)
print v(xbgr.mr_n51907200)
print v(xbgr.mr_n51907520)
print v(xbgr.mr_n51907632)
print v(xbgr.mr_n51907952)
print v(xbgr.mr_n51908064)
print v(xbgr.mr_n51908384)
print v(xbgr.mr_n51908496)
print v(xbgr.mr_n51908816)
print v(xbgr.mr_n51908928)
print v(xbgr.mr_n51909248)
print v(xbgr.mr_n51909360)
print v(xbgr.mr_n51909680)
print v(xbgr.mr_n51909792)
print v(xbgr.mr_n51910112)
print v(xbgr.mr_n51910224)
print v(xbgr.mr_n51910544)
print v(xbgr.mr_n51910656)
print v(xbgr.mr_n51910976)
print v(xbgr.mr_n51911088)
print v(xbgr.mr_n51911408)
print v(xbgr.mr_n51911520)
print v(xbgr.mr_n51911840)
print v(xbgr.mr_n51911952)
print v(xbgr.mr_n51912272)
print v(xbgr.mr_n51912384)
print v(xbgr.mr_n51912704)
print v(xbgr.mr_n51912816)
print v(xbgr.mr_n51913136)
print v(xbgr.mr_n51913248)
print v(xbgr.mr_n51913568)
print v(xbgr.mr_n51913680)
print v(xbgr.mr_n51914000)
print v(xbgr.mr_n51914112)
print v(xbgr.mr_n51914432)
print v(xbgr.mr_n51914544)
print v(xbgr.mr_n51914864)
print v(xbgr.mr_n51914976)
print v(xbgr.mr_n51915296)
print v(xbgr.mr_n51915408)
print v(xbgr.mr_n51915728)
print v(xbgr.mr_n51915840)
print v(xbgr.mr_n51916160)
print v(xbgr.mr_n51916272)
print v(xbgr.mr_n51916592)
print v(xbgr.mr_n51916704)
print v(xbgr.mr_n51917024)
print v(xbgr.mr_n51917136)
print v(xbgr.mr_n51917456)
print v(xbgr.mr_n51917568)
print v(xbgr.mr_n51917888)
print v(xbgr.mr_n51918000)
print v(xbgr.mr_n51918320)
print v(xbgr.mr_n51918432)
print v(xbgr.mr_n51918752)
print v(xbgr.mr_n51918864)
print v(xbgr.mr_n51919184)
print v(xbgr.mr_n51919296)
print v(xbgr.mr_n51919616)
print v(xbgr.mr_n51919728)
print v(xbgr.mr_n51920048)
print v(xbgr.mr_n51920160)
print v(xbgr.mr_n51920480)
print v(xbgr.mr_n51920592)
print v(xbgr.mr_n51920912)
print v(xbgr.mr_n51921024)
print v(xbgr.mr_n51921344)
print v(xbgr.mr_n51921456)
print v(xbgr.mr_n51921776)
print v(xbgr.mr_n51921888)
print v(xbgr.mr_n51922208)
print v(xbgr.mr_n51922320)
print v(xbgr.mr_n51922640)
print v(xbgr.mr_n51922752)
print v(xbgr.mr_n51923072)
print v(xbgr.mr_n51923184)
print v(xbgr.mr_n51923504)
print v(xbgr.mr_n51923616)
print v(xbgr.mr_n51923936)
print v(xbgr.mr_n51924048)
print v(xbgr.mr_n51924368)
print v(xbgr.mr_n51924480)
print v(xbgr.mr_n51924800)
print v(xbgr.mr_n51924912)
print v(xbgr.mr_n51925232)
print v(xbgr.mr_n51925344)
print v(xbgr.mr_n51925664)
print v(xbgr.mr_n51925776)
print v(xbgr.mr_n51926096)
print v(xbgr.mr_n51926208)
print v(xbgr.mr_n51926528)
print v(xbgr.mr_n51926640)
print v(xbgr.mr_n51926960)
print v(xbgr.mr_n51927072)
print v(xbgr.mr_n51927392)
print v(xbgr.mr_n51927504)
print v(xbgr.mr_n51927824)
print v(xbgr.mr_n51927936)
print v(xbgr.mr_n51928256)
print v(xbgr.mr_n51928368)
print v(xbgr.mr_n51928688)
print v(xbgr.mr_n51928800)
print v(xbgr.mr_n51929120)
print v(xbgr.mr_n51929232)
print v(xbgr.mr_n51929552)
print v(xbgr.mr_n51929664)
print v(xbgr.mr_n51929984)
print v(xbgr.mr_n51930096)
print v(xbgr.mr_n51930416)
print v(xbgr.mr_n51930528)
print v(xbgr.mr_n51930848)
print v(xbgr.mr_n51930960)
print v(xbgr.mr_n51931280)
print v(xbgr.mr_n51931392)
print v(xbgr.mr_n51931712)
print v(xbgr.mr_n51931824)
print v(xbgr.mr_n51932144)
print v(xbgr.mr_n51932256)
print v(xbgr.mr_n51932576)
print v(xbgr.mr_n51932688)
print v(xbgr.mr_n51933008)
print v(xbgr.mr_n51933120)
print v(xbgr.mr_n51933440)
print v(xbgr.mr_n51933552)
print v(xbgr.mr_n51933872)
print v(xbgr.mr_n51933984)
print v(xbgr.mr_n51934304)
print v(xbgr.mr_n51934416)
print v(xbgr.mr_n51934736)
print v(xbgr.mr_n51934848)
print v(xbgr.mr_n51935168)
print v(xbgr.mr_n51935280)
print v(xbgr.mr_n51935600)
print v(xbgr.mr_n51935712)
print v(xbgr.mr_n51936032)
print v(xbgr.mr_n51936144)
print v(xbgr.mr_n51936464)
print v(xbgr.mr_n51936576)
print v(xbgr.mr_n51936896)
print v(xbgr.mr_n51937008)
print v(xbgr.mr_n51937328)
print v(xbgr.mr_n51937440)
print v(xbgr.mr_n51937760)
print v(xbgr.mr_n51937872)
print v(xbgr.mr_n51938192)
print v(xbgr.mr_n51938304)
print v(xbgr.mr_n51938624)
print v(xbgr.mr_n51938736)
print v(xbgr.mr_n51939056)
print v(xbgr.mr_n51939168)
print v(xbgr.mr_n51939488)
print v(xbgr.mr_n51939600)
print v(xbgr.mr_n51939920)
print v(xbgr.mr_n51940032)
print v(xbgr.mr_n51940352)
print v(xbgr.mr_n51940464)
print v(xbgr.mr_n51940784)
print v(xbgr.mr_n51940896)
print v(xbgr.mr_n51941216)
print v(xbgr.mr_n51941328)
print v(xbgr.mr_n51941648)
print v(xbgr.mr_n51941760)
print v(xbgr.mr_n51942080)
print v(xbgr.mr_n51942192)
print v(xbgr.mr_n51942512)
print v(xbgr.mr_n51942624)
print v(xbgr.mr_n51942944)
print v(xbgr.mr_n51943056)
print v(xbgr.mr_n51943376)
print v(xbgr.mr_n51943488)
print v(xbgr.mr_n51943808)
print v(xbgr.mr_n51943920)
print v(xbgr.mr_n51944240)
print v(xbgr.mr_n51944352)
print v(xbgr.mr_n51944672)
print v(xbgr.mr_n51944784)
print v(xbgr.mr_n51945104)
print v(xbgr.mr_n51945216)
print v(xbgr.mr_n51945536)
print v(xbgr.mr_n51945648)
print v(xbgr.mr_n51945968)
print v(xbgr.mr_n51946080)
print v(xbgr.mr_n51946400)
print v(xbgr.mr_n51946512)
print v(xbgr.mr_n51946832)
print v(xbgr.mr_n51946944)
print v(xbgr.mr_n51947264)
print v(xbgr.mr_n51947376)
print v(xbgr.mr_n51947696)
print v(xbgr.mr_n51947808)
print v(xbgr.mr_n51948128)
print v(xbgr.mr_n51948240)
print v(xbgr.mr_n51948560)
print v(xbgr.mr_n51948672)
print v(xbgr.mr_n51948992)
print v(xbgr.mr_n51949104)
print v(xbgr.mr_n51949424)
print v(xbgr.mr_n51949536)
print v(xbgr.mr_n51949856)
print v(xbgr.mr_n51949968)
print v(xbgr.mr_n51950288)
print v(xbgr.mr_n51950400)
print v(xbgr.mr_n51950720)
print v(xbgr.mr_n51950832)
print v(xbgr.mr_n51951152)
print v(xbgr.mr_n51951264)
print v(xbgr.mr_n51951584)
print v(xbgr.mr_n51951696)
print v(xbgr.mr_n51952016)
print v(xbgr.mr_n51952128)
print v(xbgr.mr_n51952448)
print v(xbgr.mr_n51952560)
print v(xbgr.mr_n51952880)
print v(xbgr.mr_n51952992)
print v(xbgr.mr_n51953312)
print v(xbgr.mr_n51953424)
print v(xbgr.mr_n51953744)
print v(xbgr.mr_n51953856)
print v(xbgr.mr_n51954176)
print v(xbgr.mr_n51954288)
print v(xbgr.mr_n51954608)
print v(xbgr.mr_n51954720)
print v(xbgr.mr_n51955040)
print v(xbgr.mr_n51955152)
print v(xbgr.mr_n51955472)
print v(xbgr.mr_n51955584)
print v(xbgr.mr_n51955904)
print v(xbgr.mr_n51956016)
print v(xbgr.mr_n51956336)
print v(xbgr.mr_n51956448)
print v(xbgr.mr_n51956768)
print v(xbgr.mr_n51956880)
print v(xbgr.mr_n51957200)
print v(xbgr.mr_n51957312)
print v(xbgr.mr_n51957632)
print v(xbgr.mr_n51957744)
print v(xbgr.mr_n51958064)
print v(xbgr.mr_n51958176)
print v(xbgr.mr_n51958496)
print v(xbgr.mr_n51958608)
print v(xbgr.mr_n51958928)
print v(xbgr.mr_n51959040)
print v(xbgr.mr_n51959360)
print v(xbgr.mr_n51959472)
print v(xbgr.mr_n51959792)
print v(xbgr.mr_n51959904)
print v(xbgr.mr_n51960224)
print v(xbgr.mr_n51960336)
print v(xbgr.mr_n51960656)
print v(xbgr.mr_n51960768)
print v(xbgr.mr_n51961088)
print v(xbgr.mr_n51961200)
print v(xbgr.mr_n51961520)
print v(xbgr.mr_n51961632)
print v(xbgr.mr_n51961952)
print v(xbgr.mr_n51962064)
print v(xbgr.mr_n51962384)
print v(xbgr.mr_n51962496)
print v(xbgr.mr_n51962816)
print v(xbgr.mr_n51962928)
print v(xbgr.mr_n51963248)
print v(xbgr.mr_n51963360)
print v(xbgr.mr_n51963680)
print v(xbgr.mr_n51963792)
print v(xbgr.mr_n51964112)
print v(xbgr.mr_n51964224)
print v(xbgr.mr_n51964544)
print v(xbgr.mr_n51964656)
print v(xbgr.mr_n51964976)
print v(xbgr.mr_n51965088)
print v(xbgr.mr_n51965408)
print v(xbgr.mr_n51965520)
print v(xbgr.mr_n51965840)
print v(xbgr.mr_n51965952)
print v(xbgr.mr_n51966272)
print v(xbgr.mr_n51966384)
print v(xbgr.mr_n51966704)
print v(xbgr.mr_n51966816)
print v(xbgr.mr_n51967136)
print v(xbgr.mr_n51967248)
print v(xbgr.mr_n51967568)
print v(xbgr.mr_n51967680)
print v(xbgr.mr_n51968000)
print v(xbgr.mr_n51968112)
print v(xbgr.mr_n51968432)
print v(xbgr.mr_n51968544)
print v(xbgr.mr_n51968864)
print v(xbgr.mr_n51968976)
print v(xbgr.mr_n51969296)
print v(xbgr.mr_n51969408)
print v(xbgr.mr_n51969728)
print v(xbgr.mr_n51969840)
print v(xbgr.mr_n51970160)
print v(xbgr.mr_n51970272)
print v(xbgr.mr_n51970592)
print v(xbgr.mr_n51970704)
print v(xbgr.mr_n51971024)
print v(xbgr.mr_n51971136)
print v(xbgr.mr_n51971456)
print v(xbgr.mr_n51971568)
print v(xbgr.mr_n51971888)
print v(xbgr.mr_n51972000)
print v(xbgr.mr_n51972320)
print v(xbgr.mr_n51972432)
print v(xbgr.mr_n51972752)
print v(xbgr.mr_n51972864)
print v(xbgr.mr_n51973184)
print v(xbgr.mr_n51973296)
print v(xbgr.mr_n51973616)
print v(xbgr.mr_n51973728)
print v(xbgr.mr_n51974048)
print v(xbgr.mr_n51974160)
print v(xbgr.mr_n51974480)
print v(xbgr.mr_n51974592)
print v(xbgr.mr_n51974912)
print v(xbgr.mr_n51975024)
print v(xbgr.mr_n51975344)
print v(xbgr.mr_n51975456)
print v(xbgr.mr_n51975776)
print v(xbgr.mr_n51975888)
print v(xbgr.mr_n51976208)
print v(xbgr.mr_n51976320)
print v(xbgr.mr_n51976640)
print v(xbgr.mr_n51976752)
print v(xbgr.mr_n51977072)
print v(xbgr.mr_n51977184)
print v(xbgr.mr_n51977504)
print v(xbgr.mr_n51977616)
print v(xbgr.mr_n51977936)
print v(xbgr.mr_n51978048)
print v(xbgr.mr_n51978368)
print v(xbgr.mr_n51978480)
print v(xbgr.mr_n51978800)
print v(xbgr.mr_n51978912)
print v(xbgr.mr_n51979232)
print v(xbgr.mr_n51979344)
print v(xbgr.mr_n51979664)
print v(xbgr.mr_n51979776)
print v(xbgr.mr_n51980096)
print v(xbgr.mr_n51980208)
print v(xbgr.mr_n51980528)
print v(xbgr.mr_n51980640)
print v(xbgr.mr_n51980960)
print v(xbgr.mr_n51981072)
print v(xbgr.mr_n51981392)
print v(xbgr.mr_n51981504)
print v(xbgr.mr_n51981824)
print v(xbgr.mr_n51981936)
print v(xbgr.mr_n51982256)
print v(xbgr.mr_n51982368)
print v(xbgr.mr_n51982688)
print v(xbgr.mr_n51982800)
print v(xbgr.mr_n51983120)
print v(xbgr.mr_n51983232)
print v(xbgr.mr_n51983552)
print v(xbgr.mr_n51983664)
print v(xbgr.mr_n51983984)
print v(xbgr.mr_n51984096)
print v(xbgr.mr_n51984416)
print v(xbgr.mr_n51984848)
print v(xbgr.mr_n51984960)
print v(xbgr.mr_n51985280)
print v(xbgr.mr_n51985712)
print v(xbgr.mr_n51985824)
print v(xbgr.mr_n51986144)
print v(xbgr.mr_n51986256)
print v(xbgr.mr_n51986576)
print v(xbgr.mr_n51986688)
print v(xbgr.mr_n51987008)
print v(xbgr.mr_n51987120)
print v(xbgr.mr_n51987440)
print v(xbgr.mr_n51987552)
print v(xbgr.mr_n51987872)
print v(xbgr.mr_n51987984)
print v(xbgr.mr_n51988304)
print v(xbgr.mr_n51988416)
print v(xbgr.mr_n51988736)
print v(xbgr.mr_n51988848)
print v(xbgr.mr_n51989168)
print v(xbgr.mr_n51989280)
print v(xbgr.mr_n51989600)
print v(xbgr.mr_n51989712)
print v(xbgr.mr_n51990032)
print v(xbgr.mr_n51990144)
print v(xbgr.mr_n51990464)
print v(xbgr.mr_n51990576)
print v(xbgr.mr_n51990896)
print v(xbgr.mr_n51991008)
print v(xbgr.mr_n51991328)
print v(xbgr.mr_n51991440)
print v(xbgr.mr_n51991760)
print v(xbgr.mr_n51991872)
print v(xbgr.mr_n51992192)
print v(xbgr.mr_n51992304)
print v(xbgr.mr_n51992624)
print v(xbgr.mr_n51992736)
print v(xbgr.mr_n51993056)
print v(xbgr.mr_n51993168)
print v(xbgr.mr_n51993488)
print v(xbgr.mr_n51993600)
print v(xbgr.mr_n51993920)
print v(xbgr.mr_n51994032)
print v(xbgr.mr_n51994352)
print v(xbgr.mr_n51994464)
print v(xbgr.mr_n51994784)
print v(xbgr.mr_n51994896)
print v(xbgr.mr_n51995216)
print v(xbgr.mr_n51995648)
print v(xbgr.mr_n51995760)
print v(xbgr.mr_n51996080)
print v(xbgr.mr_n51996512)
print v(xbgr.mr_n51996624)
print v(xbgr.mr_n51996944)
print v(xbgr.mr_n51997376)
print v(xbgr.mr_n51997488)
print v(xbgr.mr_n51997808)
print v(xbgr.mr_n51998240)
print v(xbgr.mr_n51998352)
print v(xbgr.mr_n51998672)
print v(xbgr.mr_n51999104)
print v(xbgr.mr_n51999216)
print v(xbgr.mr_n51999536)
print v(xbgr.mr_n51999648)
print v(xbgr.mr_n51999968)
print v(xbgr.mr_n52000080)
print v(xbgr.mr_n52000400)
print v(xbgr.mr_n52000512)
print v(xbgr.mr_n52000832)
print v(xbgr.mr_n52000944)
print v(xbgr.mr_n52001264)
print v(xbgr.mr_n52001376)
print v(xbgr.mr_n52001696)
print v(xbgr.mr_n52001808)
print v(xbgr.mr_n52002128)
print v(xbgr.mr_n52002240)
print v(xbgr.mr_n52002560)
print v(xbgr.mr_n52002672)
print v(xbgr.mr_n52002992)
print v(xbgr.mr_n52003104)
print v(xbgr.mr_n52003424)
print v(xbgr.mr_n52003536)
print v(xbgr.mr_n52003856)
print v(xbgr.mr_n52003968)
print v(xbgr.mr_n52004288)
print v(xbgr.mr_n52004400)
print v(xbgr.mr_n52004720)
print v(xbgr.mr_n52004832)
print v(xbgr.mr_n52005152)
print v(xbgr.mr_n52005264)
print v(xbgr.mr_n52005584)
print v(xbgr.mr_n52005696)
print v(xbgr.mr_n52006016)
print v(xbgr.mr_n52006128)
print v(xbgr.mr_n52006448)
print v(xbgr.mr_n52006560)
print v(xbgr.mr_n52006880)
print v(xbgr.mr_n52006992)
print v(xbgr.mr_n52007312)
print v(xbgr.mr_n52007424)
print v(xbgr.mr_n52007744)
print v(xbgr.mr_n52007856)
print v(xbgr.mr_n52008176)
print v(xbgr.mr_n52008288)
print v(xbgr.mr_n52008608)
print v(xbgr.mr_n52008720)
print v(xbgr.mr_n52009040)
print v(xbgr.mr_n52009152)
print v(xbgr.mr_n52009472)
print v(xbgr.mr_n52009584)
print v(xbgr.mr_n52009904)
print v(xbgr.mr_n52010016)
print v(xbgr.mr_n52010336)
print v(xbgr.mr_n52010448)
print v(xbgr.mr_n52010768)
print v(xbgr.mr_n52010880)
print v(xbgr.mr_n52011200)
print v(xbgr.mr_n52011312)
print v(xbgr.mr_n52011632)
print v(xbgr.mr_n52011744)
print v(xbgr.mr_n52012064)
print v(xbgr.mr_n52012176)
print v(xbgr.mr_n52012496)
print v(xbgr.mr_n52012608)
print v(xbgr.mr_n52012928)
print v(xbgr.mr_n52013040)
print v(xbgr.mr_n52013360)
print v(xbgr.mr_n52013472)
print v(xbgr.mr_n52013792)
print v(xbgr.mr_n52013904)
print v(xbgr.mr_n52014224)
print v(xbgr.mr_n52014336)
print v(xbgr.mr_n52014656)
print v(xbgr.mr_n52014768)
print v(xbgr.mr_n52015088)
print v(xbgr.mr_n52015200)
print v(xbgr.mr_n52015520)
print v(xbgr.mr_n52015632)
print v(xbgr.mr_n52015952)
print v(xbgr.mr_n52016064)
print v(xbgr.mr_n52016384)
print v(xbgr.mr_n52016496)
print v(xbgr.mr_n52016816)
print v(xbgr.mr_n52016928)
print v(xbgr.mr_n52017248)
print v(xbgr.mr_n52017360)
print v(xbgr.mr_n52017680)
print v(xbgr.mr_n52017792)
print v(xbgr.mr_n52018112)
print v(xbgr.mr_n52018224)
print v(xbgr.mr_n52018544)
print v(xbgr.mr_n52018656)
print v(xbgr.mr_n52018976)
print v(xbgr.mr_n52019408)
print v(xbgr.mr_n52019520)
print v(xbgr.mr_n52019840)
print v(xbgr.mr_n52020272)
print v(xbgr.mr_n52020384)
print v(xbgr.mr_n52020704)
print v(xbgr.mr_n52021136)
print v(xbgr.mr_n52021248)
print v(xbgr.mr_n52021568)
print v(xbgr.mr_n52021680)
print v(xbgr.mr_n52022000)
print v(xbgr.mr_n52022112)
print v(xbgr.mr_n52022432)
print v(xbgr.mr_n52022544)
print v(xbgr.mr_n52022864)
print v(xbgr.mr_n52022976)
print v(xbgr.mr_n52023296)
print v(xbgr.mr_n52023408)
print v(xbgr.mr_n52023728)
print v(xbgr.mr_n52023840)
print v(xbgr.mr_n52024160)
print v(xbgr.mr_n52024272)
print v(xbgr.mr_n52024592)
print v(xbgr.mr_n52024704)
print v(xbgr.mr_n52025024)
print v(xbgr.mr_n52025136)
print v(xbgr.mr_n52025456)
print v(xbgr.mr_n52025568)
print v(xbgr.mr_n52025888)
print v(xbgr.mr_n52026000)
print v(xbgr.mr_n52026320)
print v(xbgr.mr_n52026432)
print v(xbgr.mr_n52026752)
print v(xbgr.mr_n52026864)
print v(xbgr.mr_n52027184)
print v(xbgr.mr_n52027296)
print v(xbgr.mr_n52027616)
print v(xbgr.mr_n52027728)
print v(xbgr.mr_n52028048)
print v(xbgr.mr_n52028160)
print v(xbgr.mr_n52028480)
print v(xbgr.mr_n52028592)
print v(xbgr.mr_n52028912)
print v(xbgr.mr_n52029024)
print v(xbgr.mr_n52029344)
print v(xbgr.mr_n52029456)
print v(xbgr.mr_n52029776)
print v(xbgr.mr_n52029888)
print v(xbgr.mr_n52030208)
print v(xbgr.mr_n52030320)
print v(xbgr.mr_n52030640)
print v(xbgr.mr_n52030752)
print v(xbgr.mr_n52031072)
print v(xbgr.mr_n52031184)
print v(xbgr.mr_n52031504)
print v(xbgr.mr_n52031616)
print v(xbgr.mr_n52031936)
print v(xbgr.mr_n52032048)
print v(xbgr.mr_n52032368)
print v(xbgr.mr_n52032480)
print v(xbgr.mr_n52032800)
print v(xbgr.mr_n52032912)
print v(xbgr.mr_n52033232)
print v(xbgr.mr_n52033344)
print v(xbgr.mr_n52033664)
print v(xbgr.mr_n52033776)
print v(xbgr.mr_n52034096)
print v(xbgr.mr_n52034208)
print v(xbgr.mr_n52034528)
print v(xbgr.mr_n52034640)
print v(xbgr.mr_n52034960)
print v(xbgr.mr_n52035072)
print v(xbgr.mr_n52035392)
print v(xbgr.mr_n52035504)
print v(xbgr.mr_n52035824)
print v(xbgr.mr_n52035936)
print v(xbgr.mr_n52036256)
print v(xbgr.mr_n52036368)
print v(xbgr.mr_n52036688)
print v(xbgr.mr_n52036800)
print v(xbgr.mr_n52037120)
print v(xbgr.mr_n52037232)
print v(xbgr.mr_n52037552)
print v(xbgr.mr_n52037664)
print v(xbgr.mr_n52037984)
print v(xbgr.mr_n52038096)
print v(xbgr.mr_n52038416)
print v(xbgr.mr_n52038528)
print v(xbgr.mr_n52038848)
print v(xbgr.mr_n52038960)
print v(xbgr.mr_n52039280)
print v(xbgr.mr_n52039392)
print v(xbgr.mr_n52039712)
print v(xbgr.mr_n52039824)
print v(xbgr.mr_n52040144)
print v(xbgr.mr_n52040256)
print v(xbgr.mr_n52040576)
print v(xbgr.mr_n52040688)
print v(xbgr.mr_n52041008)
print v(xbgr.mr_n52041120)
print v(xbgr.mr_n52041440)
print v(xbgr.mr_n52041552)
print v(xbgr.mr_n52041872)
print v(xbgr.mr_n52041984)
print v(xbgr.mr_n52042304)
print v(xbgr.mr_n52042416)
print v(xbgr.mr_n52042736)
print v(xbgr.mr_n52042848)
print v(xbgr.mr_n52043168)
print v(xbgr.mr_n52043280)
print v(xbgr.mr_n52043600)
print v(xbgr.mr_n52043712)
print v(xbgr.mr_n52044032)
print v(xbgr.mr_n52044144)
print v(xbgr.mr_n52044464)
print v(xbgr.mr_n52044576)
print v(xbgr.mr_n52044896)
print v(xbgr.mr_n52045008)
print v(xbgr.mr_n52045328)
print v(xbgr.mr_n52045440)
print v(xbgr.mr_n52045760)
print v(xbgr.mr_n52045872)
print v(xbgr.mr_n52046192)
print v(xbgr.mr_n52046304)
print v(xbgr.mr_n52046624)
print v(xbgr.mr_n52046736)
print v(xbgr.mr_n52047056)
print v(xbgr.mr_n52047168)
print v(xbgr.mr_n52047488)
print v(xbgr.mr_n52047600)
print v(xbgr.mr_n52047920)
print v(xbgr.mr_n52048032)
print v(xbgr.mr_n52048352)
print v(xbgr.mr_n52048464)
print v(xbgr.mr_n52048784)
print v(xbgr.mr_n52048896)
print v(xbgr.mr_n52049216)
print v(xbgr.mr_n52049328)
print v(xbgr.mr_n52049648)
print v(xbgr.mr_n52049760)
print v(xbgr.mr_n52050080)
print v(xbgr.mr_n52050192)
print v(xbgr.mr_n52050512)
print v(xbgr.mr_n52050624)
print v(xbgr.mr_n52050944)
print v(xbgr.mr_n52051056)
print v(xbgr.mr_n52051376)
print v(xbgr.mr_n52051488)
print v(xbgr.mr_n52051808)
print v(xbgr.mr_n52051920)
print v(xbgr.mr_n52052240)
print v(xbgr.mr_n52052352)
print v(xbgr.mr_n52052672)
print v(xbgr.mr_n52052784)
print v(xbgr.mr_n52053104)
print v(xbgr.mr_n52053216)
print v(xbgr.mr_n52053536)
print v(xbgr.mr_n52053648)
print v(xbgr.mr_n52053968)
print v(xbgr.mr_n52054080)
print v(xbgr.mr_n52054400)
print v(xbgr.mr_n52054512)
print v(xbgr.mr_n52054832)
print v(xbgr.mr_n52054944)
print v(xbgr.mr_n52055264)
print v(xbgr.mr_n52055376)
print v(xbgr.mr_n52055696)
print v(xbgr.mr_n52055808)
print v(xbgr.mr_n52056128)
print v(xbgr.mr_n52056240)
print v(xbgr.mr_n52056560)
print v(xbgr.mr_n52056672)
print v(xbgr.mr_n52056992)
print v(xbgr.mr_n52057104)
print v(xbgr.mr_n52057424)
print v(xbgr.mr_n52057536)
print v(xbgr.mr_n52057856)
print v(xbgr.mr_n52057968)
print v(xbgr.mr_n52058288)
print v(xbgr.mr_n52058400)
print v(xbgr.mr_n52058720)
print v(xbgr.mr_n52058832)
print v(xbgr.mr_n52059152)
print v(xbgr.mr_n52059264)
print v(xbgr.mr_n52059584)
print v(xbgr.mr_n52059696)
print v(xbgr.mr_n52060016)
print v(xbgr.mr_n52060128)
print v(xbgr.mr_n52060448)
print v(xbgr.mr_n52060560)
print v(xbgr.mr_n52060880)
print v(xbgr.mr_n52060992)
print v(xbgr.mr_n52061312)
print v(xbgr.mr_n52061424)
print v(xbgr.mr_n52061744)
print v(xbgr.mr_n52061856)
print v(xbgr.mr_n52062176)
print v(xbgr.mr_n52062288)
print v(xbgr.mr_n52062608)
print v(xbgr.mr_n52062720)
print v(xbgr.mr_n52063040)
print v(xbgr.mr_n52063152)
print v(xbgr.mr_n52063472)
print v(xbgr.mr_n52063584)
print v(xbgr.mr_n52063904)
print v(xbgr.mr_n52064016)
print v(xbgr.mr_n52064336)
print v(xbgr.mr_n52064448)
print v(xbgr.mr_n52064768)
print v(xbgr.mr_n52064880)
print v(xbgr.mr_n52065200)
print v(xbgr.mr_n52065312)
print v(xbgr.mr_n52065632)
print v(xbgr.mr_n52065744)
print v(xbgr.mr_n52066064)
print v(xbgr.mr_n52066176)
print v(xbgr.mr_n52066496)
print v(xbgr.mr_n52066608)
print v(xbgr.mr_n52066928)
print v(xbgr.mr_n52067040)
print v(xbgr.mr_n52067360)
print v(xbgr.mr_n52067472)
print v(xbgr.mr_n52067792)
print v(xbgr.mr_n52067904)
print v(xbgr.mr_n52068224)
print v(xbgr.mr_n52068336)
print v(xbgr.mr_n52068656)
print v(xbgr.mr_n52068768)
print v(xbgr.mr_n52069088)
print v(xbgr.mr_n52069200)
print v(xbgr.mr_n52069520)
print v(xbgr.mr_n52069632)
print v(xbgr.mr_n52069952)
print v(xbgr.mr_n52070064)
print v(xbgr.mr_n52070384)
print v(xbgr.mr_n52070496)
print v(xbgr.mr_n52070816)
print v(xbgr.mr_n52070928)
print v(xbgr.mr_n52071248)
print v(xbgr.mr_n52071360)
print v(xbgr.mr_n52071680)
print v(xbgr.mr_n52071792)
print v(xbgr.mr_n52072112)
print v(xbgr.mr_n52072224)
print v(xbgr.mr_n52072544)
print v(xbgr.mr_n52072656)
print v(xbgr.mr_n52072976)
print v(xbgr.mr_n52073088)
print v(xbgr.mr_n52073408)
print v(xbgr.mr_n52073520)
print v(xbgr.mr_n52073840)
print v(xbgr.mr_n52073952)
print v(xbgr.mr_n52074272)
print v(xbgr.mr_n52074384)
print v(xbgr.mr_n52074704)
print v(xbgr.mr_n52074816)
print v(xbgr.mr_n52075136)
print v(xbgr.mr_n52075248)
print v(xbgr.mr_n52075568)
print v(xbgr.mr_n52075680)
print v(xbgr.mr_n52076000)
print v(xbgr.mr_n52076112)
print v(xbgr.mr_n52076432)
print v(xbgr.mr_n52076544)
print v(xbgr.mr_n52076864)
print v(xbgr.mr_n52076976)
print v(xbgr.mr_n52077296)
print v(xbgr.mr_n52077408)
print v(xbgr.mr_n52077728)
print v(xbgr.mr_n52077840)
print v(xbgr.mr_n52078160)
print v(xbgr.mr_n52078272)
print v(xbgr.mr_n52078592)
print v(xbgr.mr_n52078704)
print v(xbgr.mr_n52079024)
print v(xbgr.mr_n52079136)
print v(xbgr.mr_n52079456)
print v(xbgr.mr_n52079568)
print v(xbgr.mr_n52079888)
print v(xbgr.mr_n52080000)
print v(xbgr.mr_n52080320)
print v(xbgr.mr_n52080432)
print v(xbgr.mr_n52080752)
print v(xbgr.mr_n52080864)
print v(xbgr.mr_n52081184)
print v(xbgr.mr_n52081296)
print v(xbgr.mr_n52081616)
print v(xbgr.mr_n52081728)
print v(xbgr.mr_n52082048)
print v(xbgr.mr_n52082160)
print v(xbgr.mr_n52082480)
print v(xbgr.mr_n52082592)
print v(xbgr.mr_n52082912)
print v(xbgr.mr_n52083024)
print v(xbgr.mr_n52083344)
print v(xbgr.mr_n52083456)
print v(xbgr.mr_n52083776)
print v(xbgr.mr_n52083888)
print v(xbgr.mr_n52084208)
print v(xbgr.mr_n52084320)
print v(xbgr.mr_n52084640)
print v(xbgr.mr_n52084752)
print v(xbgr.mr_n52085072)
print v(xbgr.mr_n52085184)
print v(xbgr.mr_n52085504)
print v(xbgr.mr_n52085616)
print v(xbgr.mr_n52085936)
print v(xbgr.mr_n52086048)
print v(xbgr.mr_n52086368)
print v(xbgr.mr_n52086480)
print v(xbgr.mr_n52086800)
print v(xbgr.mr_n52086912)
print v(xbgr.mr_n52087232)
print v(xbgr.mr_n52087344)
print v(xbgr.mr_n52087664)
print v(xbgr.mr_n52087776)
print v(xbgr.mr_n52088096)
print v(xbgr.mr_n52088208)
print v(xbgr.mr_n52088528)
print v(xbgr.mr_n52088640)
print v(xbgr.mr_n52088960)
print v(xbgr.mr_n52089072)
print v(xbgr.mr_n52089392)
print v(xbgr.mr_n52089504)
print v(xbgr.mr_n52089824)
print v(xbgr.mr_n52089936)
print v(xbgr.mr_n52090256)
print v(xbgr.mr_n52090368)
print v(xbgr.mr_n52090688)
print v(xbgr.mr_n52090800)
print v(xbgr.mr_n52091120)
print v(xbgr.mr_n52091232)
print v(xbgr.mr_n52091552)
print v(xbgr.mr_n52091664)
print v(xbgr.mr_n52091984)
print v(xbgr.mr_n52092096)
print v(xbgr.mr_n52092416)
print v(xbgr.mr_n52092528)
print v(xbgr.mr_n52092848)
print v(xbgr.mr_n52092960)
print v(xbgr.mr_n52093280)
print v(xbgr.mr_n52093392)
print v(xbgr.mr_n52093712)
print v(xbgr.mr_n52093824)
print v(xbgr.mr_n52094144)
print v(xbgr.mr_n52094256)
print v(xbgr.mr_n52094576)
print v(xbgr.mr_n52094688)
print v(xbgr.mr_n52095008)
print v(xbgr.mr_n52095120)
print v(xbgr.mr_n52095440)
print v(xbgr.mr_n52095552)
print v(xbgr.mr_n52095872)
print v(xbgr.mr_n52095984)
print v(xbgr.mr_n52096304)
print v(xbgr.mr_n52096416)
print v(xbgr.mr_n52096736)
print v(xbgr.mr_n52096848)
print v(xbgr.mr_n52097168)
print v(xbgr.mr_n52097280)
print v(xbgr.mr_n52097600)
print v(xbgr.mr_n52097712)
print v(xbgr.mr_n52098032)
print v(xbgr.mr_n52098144)
print v(xbgr.mr_n52098464)
print v(xbgr.mr_n52098576)
print v(xbgr.mr_n52098896)
print v(xbgr.mr_n52099008)
print v(xbgr.mr_n52099328)
print v(xbgr.mr_n52099440)
print v(xbgr.mr_n52099760)
print v(xbgr.mr_n52099872)
print v(xbgr.mr_n52100192)
print v(xbgr.mr_n52100304)
print v(xbgr.mr_n52100624)
print v(xbgr.mr_n52100736)
print v(xbgr.mr_n52101056)
print v(xbgr.mr_n52101168)
print v(xbgr.mr_n52101488)
print v(xbgr.mr_n52101600)
print v(xbgr.mr_n52101920)
print v(xbgr.mr_n52102032)
print v(xbgr.mr_n52102352)
print v(xbgr.mr_n52102464)
print v(xbgr.mr_n52102784)
print v(xbgr.mr_n52102896)
print v(xbgr.mr_n52103216)
print v(xbgr.mr_n52103328)
print v(xbgr.mr_n52103648)
print v(xbgr.mr_n52103760)
print v(xbgr.mr_n52104080)
print v(xbgr.mr_n52104192)
print v(xbgr.mr_n52104512)
print v(xbgr.mr_n52104624)
print v(xbgr.mr_n52104944)
print v(xbgr.mr_n52105056)
print v(xbgr.mr_n52105376)
print v(xbgr.mr_n52105488)
print v(xbgr.mr_n52105808)
print v(xbgr.mr_n52105920)
print v(xbgr.mr_n52106240)
print v(xbgr.mr_n52106352)
print v(xbgr.mr_n52106672)
print v(xbgr.mr_n52106784)
print v(xbgr.mr_n52107104)
print v(xbgr.mr_n52107216)
print v(xbgr.mr_n52107536)
print v(xbgr.mr_n52107648)
print v(xbgr.mr_n52107968)
print v(xbgr.mr_n52108080)
print v(xbgr.mr_n52108400)
print v(xbgr.mr_n52108512)
print v(xbgr.mr_n52108832)
print v(xbgr.mr_n52108944)
print v(xbgr.mr_n52109264)
print v(xbgr.mr_n52109376)
print v(xbgr.mr_n52109696)
print v(xbgr.mr_n52109808)
print v(xbgr.mr_n52110128)
print v(xbgr.mr_n52110240)
print v(xbgr.mr_n52110560)
print v(xbgr.mr_n52110672)
print v(xbgr.mr_n52110992)
print v(xbgr.mr_n52111104)
print v(xbgr.mr_n52111424)
print v(xbgr.mr_n52111536)
print v(xbgr.mr_n52111856)
print v(xbgr.mr_n52111968)
print v(xbgr.mr_n52112288)
print v(xbgr.mr_n52112400)
print v(xbgr.mr_n52112720)
print v(xbgr.mr_n52112832)
print v(xbgr.mr_n52113152)
print v(xbgr.mr_n52113264)
print v(xbgr.mr_n52113584)
print v(xbgr.mr_n52113696)
print v(xbgr.mr_n52114016)
print v(xbgr.mr_n52114128)
print v(xbgr.mr_n52114448)
print v(xbgr.mr_n52114560)
print v(xbgr.mr_n52114880)
print v(xbgr.mr_n52114992)
print v(xbgr.mr_n52115312)
print v(xbgr.mr_n52115424)
print v(xbgr.mr_n52115744)
print v(xbgr.mr_n52115856)
print v(xbgr.mr_n52116176)
print v(xbgr.mr_n52116288)
print v(xbgr.mr_n52116608)
print v(xbgr.mr_n52116720)
print v(xbgr.mr_n52117040)
print v(xbgr.mr_n52117152)
print v(xbgr.mr_n52117472)
print v(xbgr.mr_n52117584)
print v(xbgr.mr_n52117904)
print v(xbgr.mr_n52118016)
print v(xbgr.mr_n52118336)
print v(xbgr.mr_n52118448)
print v(xbgr.mr_n52118768)
print v(xbgr.mr_n52118880)
print v(xbgr.mr_n52119200)
print v(xbgr.mr_n52119312)
print v(xbgr.mr_n52119632)
print v(xbgr.mr_n52119744)
print v(xbgr.mr_n52120064)
print v(xbgr.mr_n52120176)
print v(xbgr.mr_n52120496)
print v(xbgr.mr_n52120608)
print v(xbgr.mr_n52120928)
print v(xbgr.mr_n52121040)
print v(xbgr.mr_n52121360)
print v(xbgr.mr_n52121472)
print v(xbgr.mr_n52121792)
print v(xbgr.mr_n52121904)
print v(xbgr.mr_n52122224)
print v(xbgr.mr_n52122336)
print v(xbgr.mr_n52122656)
print v(xbgr.mr_n52122768)
print v(xbgr.mr_n52123088)
print v(xbgr.mr_n52123200)
print v(xbgr.mr_n52123520)
print v(xbgr.mr_n52123632)
print v(xbgr.mr_n52123952)
print v(xbgr.mr_n52124064)
print v(xbgr.mr_n52124384)
print v(xbgr.mr_n52124496)
print v(xbgr.mr_n52124816)
print v(xbgr.mr_n52124928)
print v(xbgr.mr_n52125248)
print v(xbgr.mr_n52125360)
print v(xbgr.mr_n52125680)
print v(xbgr.mr_n52125792)
print v(xbgr.mr_n52126112)
print v(xbgr.mr_n52126224)
print v(xbgr.mr_n52126544)
print v(xbgr.mr_n52126656)
print v(xbgr.mr_n52126976)
print v(xbgr.mr_n52127088)
print v(xbgr.mr_n52127408)
print v(xbgr.mr_n52127520)
print v(xbgr.mr_n52127840)
print v(xbgr.mr_n52127952)
print v(xbgr.mr_n52128272)
print v(xbgr.mr_n52128384)
print v(xbgr.mr_n52128704)
print v(xbgr.mr_n52128816)
print v(xbgr.mr_n52129136)
print v(xbgr.mr_n52129248)
print v(xbgr.mr_n52129568)
print v(xbgr.mr_n52129680)
print v(xbgr.mr_n52130000)
print v(xbgr.mr_n52130112)
print v(xbgr.mr_n52130432)
print v(xbgr.mr_n52130544)
print v(xbgr.mr_n52130864)
print v(xbgr.mr_n52130976)
print v(xbgr.mr_n52131296)
print v(xbgr.mr_n52131408)
print v(xbgr.mr_n52131728)
print v(xbgr.mr_n52131840)
print v(xbgr.mr_n52132160)
print v(xbgr.mr_n52132272)
print v(xbgr.mr_n52132592)
print v(xbgr.mr_n52132704)
print v(xbgr.mr_n52133024)
print v(xbgr.mr_n52133136)
print v(xbgr.mr_n52133456)
print v(xbgr.mr_n52133568)
print v(xbgr.mr_n52133888)
print v(xbgr.mr_n52134000)
print v(xbgr.mr_n52134320)
print v(xbgr.mr_n52134432)
print v(xbgr.mr_n52134752)
print v(xbgr.mr_n52134864)
print v(xbgr.mr_n52135184)
print v(xbgr.mr_n52135296)
print v(xbgr.mr_n52135616)
print v(xbgr.mr_n52135728)
print v(xbgr.mr_n52136048)
print v(xbgr.mr_n52136160)
print v(xbgr.mr_n52136480)
print v(xbgr.mr_n52136592)
print v(xbgr.mr_n52136912)
print v(xbgr.mr_n52137024)
print v(xbgr.mr_n52137344)
print v(xbgr.mr_n52137456)
print v(xbgr.mr_n52137776)
print v(xbgr.mr_n52137888)
print v(xbgr.mr_n52138208)
print v(xbgr.mr_n52138320)
print v(xbgr.mr_n52138640)
print v(xbgr.mr_n52138752)
print v(xbgr.mr_n52139072)
print v(xbgr.mr_n52139184)
print v(xbgr.mr_n52139504)
print v(xbgr.mr_n52139616)
print v(xbgr.mr_n52139936)
print v(xbgr.mr_n52140048)
print v(xbgr.mr_n52140368)
print v(xbgr.mr_n52140480)
print v(xbgr.mr_n52140800)
print v(xbgr.mr_n52140912)
print v(xbgr.mr_n52141232)
print v(xbgr.mr_n52141344)
print v(xbgr.mr_n52141664)
print v(xbgr.mr_n52141776)
print v(xbgr.mr_n52142096)
print v(xbgr.mr_n52142208)
print v(xbgr.mr_n52142528)
print v(xbgr.mr_n52142640)
print v(xbgr.mr_n52142960)
print v(xbgr.mr_n52143072)
print v(xbgr.mr_n52143392)
print v(xbgr.mr_n52143504)
print v(xbgr.mr_n52143824)
print v(xbgr.mr_n52143936)
print v(xbgr.mr_n52144256)
print v(xbgr.mr_n52144368)
print v(xbgr.mr_n52144688)
print v(xbgr.mr_n52144800)
print v(xbgr.mr_n52145120)
print v(xbgr.mr_n52145232)
print v(xbgr.mr_n52145552)
print v(xbgr.mr_n52145664)
print v(xbgr.mr_n52145984)
print v(xbgr.mr_n52146096)
print v(xbgr.mr_n52146416)
print v(xbgr.mr_n52146528)
print v(xbgr.mr_n52146848)
print v(xbgr.mr_n52146960)
print v(xbgr.mr_n52147280)
print v(xbgr.mr_n52147392)
print v(xbgr.mr_n52147712)
print v(xbgr.mr_n52147824)
print v(xbgr.mr_n52148144)
print v(xbgr.mr_n52148256)
print v(xbgr.mr_n52148576)
print v(xbgr.mr_n52148688)
print v(xbgr.mr_n52149008)
print v(xbgr.mr_n52149120)
print v(xbgr.mr_n52149440)
print v(xbgr.mr_n52149552)
print v(xbgr.mr_n52149872)
print v(xbgr.mr_n52149984)
print v(xbgr.mr_n52150304)
print v(xbgr.mr_n52150416)
print v(xbgr.mr_n52150736)
print v(xbgr.mr_n52150848)
print v(xbgr.mr_n52151168)
print v(xbgr.mr_n52151280)
print v(xbgr.mr_n52151600)
print v(xbgr.mr_n52151712)
print v(xbgr.mr_n52152032)
print v(xbgr.mr_n52152144)
print v(xbgr.mr_n52152464)
print v(xbgr.mr_n52152576)
print v(xbgr.mr_n52152896)
print v(xbgr.mr_n52153008)
print v(xbgr.mr_n52153328)
print v(xbgr.mr_n52153440)
print v(xbgr.mr_n52153760)
print v(xbgr.mr_n52153872)
print v(xbgr.mr_n52154192)
print v(xbgr.mr_n52154304)
print v(xbgr.mr_n52154624)
print v(xbgr.mr_n52154736)
print v(xbgr.mr_n52155056)
print v(xbgr.mr_n52155168)
print v(xbgr.mr_n52155488)
print v(xbgr.mr_n52155600)
print v(xbgr.mr_n52155920)
print v(xbgr.mr_n52156032)
print v(xbgr.mr_n52156352)
print v(xbgr.mr_n52156464)
print v(xbgr.mr_n52156784)
print v(xbgr.mr_n52156896)
print v(xbgr.mr_n52157216)
print v(xbgr.mr_n52157328)
print v(xbgr.mr_n52157648)
print v(xbgr.mr_n52157760)
print v(xbgr.mr_n52158080)
print v(xbgr.mr_n52158192)
print v(xbgr.mr_n52158512)
print v(xbgr.mr_n52158624)
print v(xbgr.mr_n52158944)
print v(xbgr.mr_n52159056)
print v(xbgr.mr_n52159376)
print v(xbgr.mr_n52159488)
print v(xbgr.mr_n52159808)
print v(xbgr.mr_n52159920)
print v(xbgr.mr_n52160240)
print v(xbgr.mr_n52160352)
print v(xbgr.mr_n52160672)
print v(xbgr.mr_n52160784)
print v(xbgr.mr_n52161104)
print v(xbgr.mr_n52161216)
print v(xbgr.mr_n52161536)
print v(xbgr.mr_n52161648)
print v(xbgr.mr_n52161968)
print v(xbgr.mr_n52162080)
print v(xbgr.mr_n52162400)
print v(xbgr.mr_n52162512)
print v(xbgr.mr_n52162832)
print v(xbgr.mr_n52162944)
print v(xbgr.mr_n52163264)
print v(xbgr.mr_n52163376)
print v(xbgr.mr_n52163696)
print v(xbgr.mr_n52163808)
print v(xbgr.mr_n52164128)
print v(xbgr.mr_n52164240)
print v(xbgr.mr_n52164560)
print v(xbgr.mr_n52164672)
print v(xbgr.mr_n52164992)
print v(xbgr.mr_n52165104)
print v(xbgr.mr_n52165424)
print v(xbgr.mr_n52165536)
print v(xbgr.mr_n52165856)
print v(xbgr.mr_n52165968)
print v(xbgr.mr_n52166288)
print v(xbgr.mr_n52166400)
print v(xbgr.mr_n52166720)
print v(xbgr.mr_n52166832)
print v(xbgr.mr_n52167152)
print v(xbgr.mr_n52167264)
print v(xbgr.mr_n52167584)
print v(xbgr.mr_n52167696)
print v(xbgr.mr_n52168016)
print v(xbgr.mr_n52168128)
print v(xbgr.mr_n52168448)
print v(xbgr.mr_n52168560)
print v(xbgr.mr_n52168880)
print v(xbgr.mr_n52168992)
print v(xbgr.mr_n52169312)
print v(xbgr.mr_n52169424)
print v(xbgr.mr_n52169744)
print v(xbgr.mr_n52169856)
print v(xbgr.mr_n52170176)
print v(xbgr.mr_n52170288)
print v(xbgr.mr_n52170608)
print v(xbgr.mr_n52170720)
print v(xbgr.mr_n52171040)
print v(xbgr.mr_n52171152)
print v(xbgr.mr_n52171472)
print v(xbgr.mr_n52171584)
print v(xbgr.mr_n52171904)
print v(xbgr.mr_n52172016)
print v(xbgr.mr_n52172336)
print v(xbgr.mr_n52172448)
print v(xbgr.mr_n52172768)
print v(xbgr.mr_n52172880)
print v(xbgr.mr_n52173200)
print v(xbgr.mr_n52173312)
print v(xbgr.mr_n52173632)
print v(xbgr.mr_n52173744)
print v(xbgr.mr_n52174064)
print v(xbgr.mr_n52174176)
print v(xbgr.mr_n52174496)
print v(xbgr.mr_n52174608)
print v(xbgr.mr_n52174928)
print v(xbgr.mr_n52175040)
print v(xbgr.mr_n52175360)
print v(xbgr.mr_n52175472)
print v(xbgr.mr_n52175792)
print v(xbgr.mr_n52175904)
print v(xbgr.mr_n52176224)
print v(xbgr.mr_n52176336)
print v(xbgr.mr_n52176656)
print v(xbgr.mr_n52176768)
print v(xbgr.mr_n52177088)
print v(xbgr.mr_n52177200)
print v(xbgr.mr_n52177520)
print v(xbgr.mr_n52177632)
print v(xbgr.mr_n52177952)
print v(xbgr.mr_n52178064)
print v(xbgr.mr_n52178384)
print v(xbgr.mr_n52178496)
print v(xbgr.mr_n52178816)
print v(xbgr.mr_n52178928)
print v(xbgr.mr_n52179248)
print v(xbgr.mr_n52179360)
print v(xbgr.mr_n52179680)
print v(xbgr.mr_n52179792)
print v(xbgr.mr_n52180112)
print v(xbgr.mr_n52180224)
print v(xbgr.mr_n52180544)
print v(xbgr.mr_n52180656)
print v(xbgr.mr_n52180976)
print v(xbgr.mr_n52181088)
print v(xbgr.mr_n52181408)
print v(xbgr.mr_n52181520)
print v(xbgr.mr_n52181840)
print v(xbgr.mr_n52181952)
print v(xbgr.mr_n52182272)
print v(xbgr.mr_n52182384)
print v(xbgr.mr_n52182704)
print v(xbgr.mr_n52182816)
print v(xbgr.mr_n52183136)
print v(xbgr.mr_n52183248)
print v(xbgr.mr_n52183568)
print v(xbgr.mr_n52183680)
print v(xbgr.mr_n52184000)
print v(xbgr.mr_n52184112)
print v(xbgr.mr_n52184432)
print v(xbgr.mr_n52184544)
print v(xbgr.mr_n52184864)
print v(xbgr.mr_n52184976)
print v(xbgr.mr_n52185296)
print v(xbgr.mr_n52185408)
print v(xbgr.mr_n52185728)
print v(xbgr.mr_n52185840)
print v(xbgr.mr_n52186160)
print v(xbgr.mr_n52186272)
print v(xbgr.mr_n52186704)
print v(xbgr.mr_n52187024)
print v(xbgr.mr_n52187136)
print v(xbgr.mr_n52187568)
print v(xbgr.mr_n52187888)
print v(xbgr.mr_n52188000)
print v(xbgr.mr_n52188432)
print v(xbgr.mr_n52188752)
print v(xbgr.mr_n52189616)
print v(xbgr.mr_n52190480)
print v(xbgr.mr_n52190592)
print v(xbgr.mr_n52190912)
print v(xbgr.mr_n52191024)
print v(xbgr.mr_n52191344)
print v(xbgr.mr_n52191456)
print v(xbgr.mr_n52191776)
print v(xbgr.mr_n52191888)
print v(xbgr.mr_n52192208)
print v(xbgr.mr_n52192320)
print v(xbgr.mr_n52192640)
print v(xbgr.mr_n52192752)
print v(xbgr.mr_n52193072)
print v(xbgr.mr_n52193936)
print v(xbgr.mr_n52194800)
print v(xbgr.mr_n52195664)
print v(xbgr.mr_n52195776)
print v(xbgr.mr_n52196096)
print v(xbgr.mr_n52196208)
print v(xbgr.mr_n52196528)
print v(xbgr.mr_n52196640)
print v(xbgr.mr_n52196960)
print v(xbgr.mr_n52197072)
print v(xbgr.mr_n52197392)
print v(xbgr.mr_n52198256)
print v(xbgr.mr_n52199120)
print v(xbgr.mr_n52199232)
print v(xbgr.mr_n52199552)
print v(xbgr.mr_n52199664)
print v(xbgr.mr_n52199984)
print v(xbgr.mr_n52200096)
print v(xbgr.mr_n52200416)
print v(xbgr.mr_n52200528)
print v(xbgr.mr_n52200848)
print v(xbgr.mr_n52200960)
print v(xbgr.mr_n52201280)
print v(xbgr.mr_n52201392)
print v(xbgr.mr_n52201712)
print v(xbgr.mr_n52202576)
print v(xbgr.mr_n52202688)
print v(xbgr.mr_n52203120)
print v(xbgr.mr_n52203440)
print v(xbgr.mr_n52203552)
print v(xbgr.mr_n52203984)
print v(xbgr.mr_n52204304)
print v(xbgr.mr_n52204416)
print v(xbgr.mr_n52204848)
print v(xbgr.mr_n52205168)
print v(xbgr.mr_n52206032)
print v(xbgr.mr_n52206896)
print v(xbgr.mr_n52207760)
print v(xbgr.mr_n52208624)
print v(xbgr.mr_n52209488)
print v(xbgr.mr_n52210352)
print v(xbgr.mr_n52210464)
print v(xbgr.mr_n52210784)
print v(xbgr.mr_n52210896)
print v(xbgr.mr_n52211216)
print v(xbgr.mr_n52211328)
print v(xbgr.mr_n52211648)
print v(xbgr.mr_n52211760)
print v(xbgr.mr_n52212080)
print v(xbgr.mr_n52212944)
print v(xbgr.mr_n52213808)
print v(xbgr.mr_n52214672)
print v(xbgr.mr_n52215536)
print v(xbgr.mr_n52215648)
print v(xbgr.mr_n52216080)
print v(xbgr.mr_n52216400)
print v(xbgr.mr_n52216512)
print v(xbgr.mr_n52216944)
print v(xbgr.mr_n52217264)
print v(xbgr.mr_n52217376)
print v(xbgr.mr_n52217808)
print v(xbgr.mr_n52218128)
print v(xbgr.mr_n52218992)
print v(xbgr.mr_n52219856)
print v(xbgr.mr_n52220720)
print v(xbgr.mr_n52221584)
print v(xbgr.mr_n52222448)
print v(xbgr.mr_n52223312)
print v(xbgr.mr_n52223424)
print v(xbgr.mr_n52223744)
print v(xbgr.mr_n52223856)
print v(xbgr.mr_n52224176)
print v(xbgr.mr_n52224288)
print v(xbgr.mr_n52224608)
print v(xbgr.mr_n52224720)
print v(xbgr.mr_n52225040)
print v(xbgr.mr_n52225904)
print v(xbgr.mr_n52226768)
print v(xbgr.mr_n52227632)
print v(xbgr.mr_n52227744)
print v(xbgr.mr_n52228064)
print v(xbgr.mr_n52228176)
print v(xbgr.mr_n52228496)
print v(xbgr.mr_n52228608)
print v(xbgr.mr_n52229040)
print v(xbgr.mr_n52229472)
print v(xbgr.mr_n52229904)
print v(xbgr.mr_n52230224)
print v(xbgr.mr_n52230336)
print v(xbgr.mr_n52230656)
print v(xbgr.mr_n52230768)
print v(xbgr.mr_n52231088)
print v(xbgr.mr_n52231200)
print v(xbgr.mr_n52231520)
print v(xbgr.mr_n52231632)
print v(xbgr.mr_n52231952)
print v(xbgr.mr_n52232064)
print v(xbgr.mr_n52232384)
print v(xbgr.mr_n52232496)
print v(xbgr.mr_n52232816)
print v(xbgr.mr_n52232928)
print v(xbgr.mr_n52233360)
print v(xbgr.mr_n52233680)
print v(xbgr.mr_n52234112)
print v(xbgr.mr_n52234224)
print v(xbgr.mr_n52234544)
print v(xbgr.mr_n52234656)
print v(xbgr.mr_n52234976)
print v(xbgr.mr_n52235088)
print v(xbgr.mr_n52235408)
print v(xbgr.mr_n52235520)
print v(xbgr.mr_n52235840)
print v(xbgr.mr_n52235952)
print v(xbgr.mr_n52236272)
print v(xbgr.mr_n52236384)
print v(xbgr.mr_n52236704)
print v(xbgr.mr_n52236816)
print v(xbgr.mr_n52237248)
print v(xbgr.mr_n52237568)
print v(xbgr.mr_n52237680)
print v(xbgr.mr_n52238112)
print v(xbgr.mr_n52238432)
print v(xbgr.mr_n52238544)
print v(xbgr.mr_n52238864)
print v(xbgr.mr_n52238976)
print v(xbgr.mr_n52239296)
print v(xbgr.mr_n52239408)
print v(xbgr.mr_n52239840)
print v(xbgr.mr_n52240272)
print v(xbgr.mr_n52240592)
print v(xbgr.mr_n52240704)
print v(xbgr.mr_n52241024)
print v(xbgr.mr_n52241136)
print v(xbgr.mr_n52241456)
print v(xbgr.mr_n52241568)
print v(xbgr.mr_n52241888)
print v(xbgr.mr_n52242000)
print v(xbgr.mr_n52242320)
print v(xbgr.mr_n52242432)
print v(xbgr.mr_n52242752)
print v(xbgr.mr_n52242864)
print v(xbgr.mr_n52243184)
print v(xbgr.mr_n52243296)
print v(xbgr.mr_n52243616)
print v(xbgr.mr_n52243728)
print v(xbgr.mr_n52244048)
print v(xbgr.mr_n52244160)
print v(xbgr.mr_n52244480)
print v(xbgr.mr_n52244592)
print v(xbgr.mr_n52244912)
print v(xbgr.mr_n52245024)
print v(xbgr.mr_n52245344)
print v(xbgr.mr_n52246208)
print v(xbgr.mr_n52247072)
print v(xbgr.mr_n52247184)
print v(xbgr.mr_n52247616)
print v(xbgr.mr_n52247936)
print v(xbgr.mr_n52248048)
print v(xbgr.mr_n52248800)
print v(xbgr.mr_n52249232)
print v(xbgr.mr_n52249344)
print v(xbgr.mr_n52249664)
print v(xbgr.mr_n52249776)
print v(xbgr.mr_n52250096)
print v(xbgr.mr_n52250208)
print v(xbgr.mr_n52250528)
print v(xbgr.mr_n52250640)
print v(xbgr.mr_n52250960)
print v(xbgr.mr_n52251824)
print v(xbgr.mr_n52252256)
print v(xbgr.mr_n52252368)
print v(xbgr.mr_n52252688)
print v(xbgr.mr_n52252800)
print v(xbgr.mr_n52253120)
print v(xbgr.mr_n52253984)
print v(xbgr.mr_n52255280)
print v(xbgr.mr_n52256144)
print v(xbgr.mr_n52257008)
print v(xbgr.mr_n52257120)
print v(xbgr.mr_n52257872)
print v(xbgr.mr_n52257984)
print v(xbgr.mr_n52258416)
print v(xbgr.mr_n52258848)
print v(xbgr.mr_n52259600)
print v(xbgr.mr_n52260464)
print v(xbgr.mr_n52261328)
print v(xbgr.mr_n52261440)
print v(xbgr.mr_n52261760)
print v(xbgr.mr_n52261872)
print v(xbgr.mr_n52262304)
print v(xbgr.mr_n52262624)
print v(xbgr.mr_n52262736)
print v(xbgr.mr_n52263168)
print v(xbgr.mr_n52263488)
print v(xbgr.mr_n52263600)
print v(xbgr.mr_n52263920)
print v(xbgr.mr_n52264032)
print v(xbgr.mr_n52264352)
print v(xbgr.mr_n52265216)
print v(xbgr.mr_n52265328)
print v(xbgr.mr_n52265760)
print v(xbgr.mr_n52266080)
print v(xbgr.mr_n52267056)
print v(xbgr.mr_n52267376)
print v(xbgr.mr_n52267488)
print v(xbgr.mr_n52267920)
print v(xbgr.mr_n52268240)
print v(xbgr.mr_n52268672)
print v(xbgr.mr_n52268784)
print v(xbgr.mr_n52269104)
print v(xbgr.mr_n52269216)
print v(xbgr.mr_n52269536)
print v(xbgr.mr_n52269968)
print v(xbgr.mr_n52270080)
print v(xbgr.mr_n52270400)
print v(xbgr.mr_n52270512)
print v(xbgr.mr_n52270832)
print v(xbgr.mr_n52270944)
print v(xbgr.mr_n52271264)
print v(xbgr.mr_n52271376)
print v(xbgr.mr_n52271696)
print v(xbgr.mr_n52271808)
print v(xbgr.mr_n52272240)
print v(xbgr.mr_n52272560)
print v(xbgr.mr_n52272672)
print v(xbgr.mr_n52272992)
print v(xbgr.mr_n52273104)
print v(xbgr.mr_n52273424)
print v(xbgr.mr_n52273968)
print v(xbgr.mr_n52274720)
print v(xbgr.mr_n52276016)
print v(xbgr.mr_n52276128)
print v(xbgr.mr_n52276448)
print v(xbgr.mr_n52276560)
print v(xbgr.mr_n52276880)
print v(xbgr.mr_n52277744)
print v(xbgr.mr_n52278608)
print v(xbgr.mr_n52279472)
print v(xbgr.mr_n52279584)
print v(xbgr.mr_n52279904)
print v(xbgr.mr_n52280016)
print v(xbgr.mr_n52280336)
print v(xbgr.mr_n52280448)
print v(xbgr.mr_n52280768)
print v(xbgr.mr_n52280880)
print v(xbgr.mr_n52281200)
print v(xbgr.mr_n52281312)
print v(xbgr.mr_n52281632)
print v(xbgr.mr_n52282496)
print v(xbgr.mr_n52283360)
print v(xbgr.mr_n52284224)
print v(xbgr.mr_n52284336)
print v(xbgr.mr_n52284656)
print v(xbgr.mr_n52284768)
print v(xbgr.mr_n52285088)
print v(xbgr.mr_n52285200)
print v(xbgr.mr_n52285520)
print v(xbgr.mr_n52285632)
print v(xbgr.mr_n52286064)
print v(xbgr.mr_n52286384)
print v(xbgr.mr_n52286496)
print v(xbgr.mr_n52286816)
print v(xbgr.mr_n52286928)
print v(xbgr.mr_n52287248)
print v(xbgr.mr_n52287360)
print v(xbgr.mr_n52287680)
print v(xbgr.mr_n52287792)
print v(xbgr.mr_n52288544)
print v(xbgr.mr_n52289088)
print v(xbgr.mr_n52289520)
print v(xbgr.mr_n52289952)
print v(xbgr.mr_n52290384)
print v(xbgr.mr_n52290704)
print v(xbgr.mr_n52290816)
print v(xbgr.mr_n52291568)
print v(xbgr.mr_n52292432)
print v(xbgr.mr_n52293296)
print v(xbgr.mr_n52294160)
print v(xbgr.mr_n52295024)
print v(xbgr.mr_n52295888)
print v(xbgr.mr_n52296752)
print v(xbgr.mr_n52296864)
print v(xbgr.mr_n52297184)
print v(xbgr.mr_n52297296)
print v(xbgr.mr_n52297728)
print v(xbgr.mr_n52298048)
print v(xbgr.mr_n52298160)
print v(xbgr.mr_n52298592)
print v(xbgr.mr_n52298912)
print v(xbgr.mr_n52299024)
print v(xbgr.mr_n52299344)
print v(xbgr.mr_n52299456)
print v(xbgr.mr_n52299776)
print v(xbgr.mr_n52299888)
print v(xbgr.mr_n52300208)
print v(xbgr.mr_n52300320)
print v(xbgr.mr_n52300640)
print v(xbgr.mr_n52300752)
print v(xbgr.mr_n52301072)
print v(xbgr.mr_n52301184)
print v(xbgr.mr_n52301504)
print v(xbgr.mr_n52302368)
print v(xbgr.mr_n52302800)
print v(xbgr.mr_n52303776)
print v(xbgr.mr_n52304208)
print v(xbgr.mr_n52304640)
print v(xbgr.mr_n52305072)
print v(xbgr.mr_n52305392)
print v(xbgr.mr_n52306256)
print v(xbgr.mr_n52307120)
print v(xbgr.mr_n52307984)
print v(xbgr.mr_n52308848)
print v(xbgr.mr_n52309712)
print v(xbgr.mr_n52310576)
print v(xbgr.mr_n52311872)
print v(xbgr.mr_n52312304)
print v(xbgr.mr_n52313600)
print v(xbgr.mr_n52313712)
print v(xbgr.mr_n52314032)
print v(xbgr.mr_n52314144)
print v(xbgr.mr_n52314464)
print v(xbgr.mr_n52314576)
print v(xbgr.mr_n52315008)
print v(xbgr.mr_n52315440)
print v(xbgr.mr_n52315760)
print v(xbgr.mr_n52315872)
print v(xbgr.mr_n52316192)
print v(xbgr.mr_n52316304)
print v(xbgr.mr_n52316624)
print v(xbgr.mr_n52316736)
print v(xbgr.mr_n52317056)
print v(xbgr.mr_n52317168)
print v(xbgr.mr_n52317600)
print v(xbgr.mr_n52317920)
print v(xbgr.mr_n52318784)
print v(xbgr.mr_n52318896)
print v(xbgr.mr_n52319216)
print v(xbgr.mr_n52319328)
print v(xbgr.mr_n52319648)
print v(xbgr.mr_n52319760)
print v(xbgr.mr_n52320080)
print v(xbgr.mr_n52320192)
print v(xbgr.mr_n52320512)
print v(xbgr.mr_n52321376)
print v(xbgr.mr_n52321808)
print v(xbgr.mr_n52323104)
print v(xbgr.mr_n52323216)
print v(xbgr.mr_n52323536)
print v(xbgr.mr_n52323648)
print v(xbgr.mr_n52323968)
print v(xbgr.mr_n52324080)
print v(xbgr.mr_n52324400)
print v(xbgr.mr_n52325264)
print v(xbgr.mr_n52325376)
print v(xbgr.mr_n52325808)
print v(xbgr.mr_n52326128)
print v(xbgr.mr_n52326240)
print v(xbgr.mr_n52326560)
print v(xbgr.mr_n52326672)
print v(xbgr.mr_n52326992)
print v(xbgr.mr_n52327104)
print v(xbgr.mr_n52327424)
print v(xbgr.mr_n52327536)
print v(xbgr.mr_n52327968)
print v(xbgr.mr_n52328288)
print v(xbgr.mr_n52329152)
print v(xbgr.mr_n52329264)
print v(xbgr.mr_n52329584)
print v(xbgr.mr_n52330448)
print v(xbgr.mr_n52330560)
print v(xbgr.mr_n52330880)
print v(xbgr.mr_n52330992)
print v(xbgr.mr_n52331312)
print v(xbgr.mr_n52331856)
print v(xbgr.mr_n52332288)
print v(xbgr.mr_n52332608)
print v(xbgr.mr_n52333040)
print v(xbgr.mr_n52333152)
print v(xbgr.mr_n52333472)
print v(xbgr.mr_n52333584)
print v(xbgr.mr_n52333904)
print v(xbgr.mr_n52334016)
print v(xbgr.mr_n52334336)
print v(xbgr.mr_n52334448)
print v(xbgr.mr_n52334768)
print v(xbgr.mr_n52334880)
print v(xbgr.mr_n52335632)
print v(xbgr.mr_n52335744)
print v(xbgr.mr_n52336064)
print v(xbgr.mr_n52336176)
print v(xbgr.mr_n52336496)
print v(xbgr.mr_n52337792)
print v(xbgr.mr_n52337904)
print v(xbgr.mr_n52338224)
print v(xbgr.mr_n52338336)
print v(xbgr.mr_n52338656)
print v(xbgr.mr_n52339632)
print v(xbgr.mr_n52339952)
print v(xbgr.mr_n52340816)
print v(xbgr.mr_n52341248)
print v(xbgr.mr_n52341360)
print v(xbgr.mr_n52341680)
print v(xbgr.mr_n52341792)
print v(xbgr.mr_n52342112)
print v(xbgr.mr_n52342224)
print v(xbgr.mr_n52342544)
print v(xbgr.mr_n52343408)
print v(xbgr.mr_n52344704)
print v(xbgr.mr_n52345568)
print v(xbgr.mr_n52346544)
print v(xbgr.mr_n52346864)
print v(xbgr.mr_n52346976)
print v(xbgr.mr_n52347408)
print v(xbgr.mr_n52347728)
print v(xbgr.mr_n52347840)
print v(xbgr.mr_n52348160)
print v(xbgr.mr_n52348272)
print v(xbgr.mr_n52348592)
print v(xbgr.mr_n52348704)
print v(xbgr.mr_n52349024)
print v(xbgr.mr_n52349136)
print v(xbgr.mr_n52349456)
print v(xbgr.mr_n52349568)
print v(xbgr.mr_n52349888)
print v(xbgr.mr_n52350000)
print v(xbgr.mr_n52350320)
print v(xbgr.mr_n52350432)
print v(xbgr.mr_n52350752)
print v(xbgr.mr_n52350864)
print v(xbgr.mr_n52351296)
print v(xbgr.mr_n52351616)
print v(xbgr.mr_n52351728)
print v(xbgr.mr_n52352160)
print v(xbgr.mr_n52352480)
print v(xbgr.mr_n52353344)
print v(xbgr.mr_n52354208)
print v(xbgr.mr_n52355072)
print v(xbgr.mr_n52355184)
print v(xbgr.mr_n52355504)
print v(xbgr.mr_n52355616)
print v(xbgr.mr_n52355936)
print v(xbgr.mr_n52356048)
print v(xbgr.mr_n52356368)
print v(xbgr.mr_n52356480)
print v(xbgr.mr_n52356912)
print v(xbgr.mr_n52357344)
print v(xbgr.mr_n52357776)
print v(xbgr.mr_n52358208)
print v(xbgr.mr_n52358528)
print v(xbgr.mr_n52358640)
print v(xbgr.mr_n52358960)
print v(xbgr.mr_n52359072)
print v(xbgr.mr_n52359392)
print v(xbgr.mr_n52359504)
print v(xbgr.mr_n52359824)
print v(xbgr.mr_n52359936)
print v(xbgr.mr_n52360256)
print v(xbgr.mr_n52360368)
print v(xbgr.mr_n52360688)
print v(xbgr.mr_n52360800)
print v(xbgr.mr_n52361120)
print v(xbgr.mr_n52361232)
print v(xbgr.mr_n52361664)
print v(xbgr.mr_n52361984)
print v(xbgr.mr_n52362096)
print v(xbgr.mr_n52362416)
print v(xbgr.mr_n52363280)
print v(xbgr.mr_n52364016)
print v(xbgr.mr_n52364880)
print v(xbgr.mr_n52365744)
print v(xbgr.mr_n52366608)
print v(xbgr.mr_n52367472)
print v(xbgr.mr_n52367584)
print v(xbgr.mr_n52368016)
print v(xbgr.mr_n52368336)
print v(xbgr.mr_n52368448)
print v(xbgr.mr_n52368880)
print v(xbgr.mr_n52369200)
print v(xbgr.mr_n52369312)
print v(xbgr.mr_n52369632)
print v(xbgr.mr_n52369744)
print v(xbgr.mr_n52370064)
print v(xbgr.mr_n52370176)
print v(xbgr.mr_n52370608)
print v(xbgr.mr_n52370928)
print v(xbgr.mr_n52371792)
print v(xbgr.mr_n52371904)
print v(xbgr.mr_n52372224)
print v(xbgr.mr_n52372336)
print v(xbgr.mr_n52372656)
print v(xbgr.mr_n52372768)
print v(xbgr.mr_n52373088)
print v(xbgr.mr_n52373200)
print v(xbgr.mr_n52373520)
print v(xbgr.mr_n52373632)
print v(xbgr.mr_n52373952)
print v(xbgr.mr_n52374064)
print v(xbgr.mr_n52374384)
print v(xbgr.mr_n52374496)
print v(xbgr.mr_n52374816)
print v(xbgr.mr_n52375248)
print v(xbgr.mr_n52375360)
print v(xbgr.mr_n52375680)
print v(xbgr.mr_n52375792)
print v(xbgr.mr_n52376112)
print v(xbgr.mr_n52376224)
print v(xbgr.mr_n52376544)
print v(xbgr.mr_n52376656)
print v(xbgr.mr_n52376976)
print v(xbgr.mr_n52378272)
print v(xbgr.mr_n52379136)
print v(xbgr.mr_n52379680)
print v(xbgr.mr_n52380112)
print v(xbgr.mr_n52380432)
print v(xbgr.mr_n52380544)
print v(xbgr.mr_n52380864)
print v(xbgr.mr_n52380976)
print v(xbgr.mr_n52381296)
print v(xbgr.mr_n52381408)
print v(xbgr.mr_n52381728)
print v(xbgr.mr_n52381840)
print v(xbgr.mr_n52382160)
print v(xbgr.mr_n52382272)
print v(xbgr.mr_n52382592)
print v(xbgr.mr_n52382704)
print v(xbgr.mr_n52383024)
print v(xbgr.mr_n52383136)
print v(xbgr.mr_n52383456)
print v(xbgr.mr_n52383568)
print v(xbgr.mr_n52383888)
print v(xbgr.mr_n52384000)
print v(xbgr.mr_n52384320)
print v(xbgr.mr_n52385184)
print v(xbgr.mr_n52386048)
print v(xbgr.mr_n52386160)
print v(xbgr.mr_n52386592)
print v(xbgr.mr_n52387344)
print v(xbgr.mr_n52388208)
print v(xbgr.mr_n52389072)
print v(xbgr.mr_n52390048)
print v(xbgr.mr_n52390480)
print v(xbgr.mr_n52390800)
print v(xbgr.mr_n52390912)
print v(xbgr.mr_n52391232)
print v(xbgr.mr_n52391344)
print v(xbgr.mr_n52391664)
print v(xbgr.mr_n52392528)
print v(xbgr.mr_n52393392)
print v(xbgr.mr_n52393504)
print v(xbgr.mr_n52393824)
print v(xbgr.mr_n52393936)
print v(xbgr.mr_n52394256)
print v(xbgr.mr_n52394368)
print v(xbgr.mr_n52394688)
print v(xbgr.mr_n52394800)
print v(xbgr.mr_n52395120)
print v(xbgr.mr_n52395232)
print v(xbgr.mr_n52395552)
print v(xbgr.mr_n52395664)
print v(xbgr.mr_n52395984)
print v(xbgr.mr_n52396096)
print v(xbgr.mr_n52396416)
print v(xbgr.mr_n52396528)
print v(xbgr.mr_n52396848)
print v(xbgr.mr_n52396960)
print v(xbgr.mr_n52397392)
print v(xbgr.mr_n52397712)
print v(xbgr.mr_n52398144)
print v(xbgr.mr_n52398256)
print v(xbgr.mr_n52399008)
print v(xbgr.mr_n52399120)
print v(xbgr.mr_n52399552)
print v(xbgr.mr_n52400304)
print v(xbgr.mr_n52400416)
print v(xbgr.mr_n52400736)
print v(xbgr.mr_n52400848)
print v(xbgr.mr_n52401280)
print v(xbgr.mr_n52401712)
print v(xbgr.mr_n52402144)
print v(xbgr.mr_n52402464)
print v(xbgr.mr_n52402576)
print v(xbgr.mr_n52402896)
print v(xbgr.mr_n52403008)
print v(xbgr.mr_n52403440)
print v(xbgr.mr_n52403760)
print v(xbgr.mr_n52404624)
print v(xbgr.mr_n52404736)
print v(xbgr.mr_n52405056)
print v(xbgr.mr_n52405168)
print v(xbgr.mr_n52405488)
print v(xbgr.mr_n52405600)
print v(xbgr.mr_n52405920)
print v(xbgr.mr_n52406032)
print v(xbgr.mr_n52406352)
print v(xbgr.mr_n52406464)
print v(xbgr.mr_n52406784)
print v(xbgr.mr_n52406896)
print v(xbgr.mr_n52407216)
print v(xbgr.mr_n52408080)
print v(xbgr.mr_n52408944)
print v(xbgr.mr_n52409056)
print v(xbgr.mr_n52409376)
print v(xbgr.mr_n52409488)
print v(xbgr.mr_n52409808)
print v(xbgr.mr_n52409920)
print v(xbgr.mr_n52410240)
print v(xbgr.mr_n52410352)
print v(xbgr.mr_n52410672)
print v(xbgr.mr_n52411536)
print v(xbgr.mr_n52412400)
print v(xbgr.mr_n52413264)
print v(xbgr.mr_n52414128)
print v(xbgr.mr_n52415536)
print v(xbgr.mr_n52415856)
print v(xbgr.mr_n52416720)
print v(xbgr.mr_n52417584)
print v(xbgr.mr_n52417696)
print v(xbgr.mr_n52418128)
print v(xbgr.mr_n52418448)
print v(xbgr.mr_n52418560)
print v(xbgr.mr_n52418992)
print v(xbgr.mr_n52419312)
print v(xbgr.mr_n52420176)
print v(xbgr.mr_n52421040)
print v(xbgr.mr_n52421904)
print v(xbgr.mr_n52422768)
print v(xbgr.mr_n52422880)
print v(xbgr.mr_n52423200)
print v(xbgr.mr_n52423312)
print v(xbgr.mr_n52423632)
print v(xbgr.mr_n52423744)
print v(xbgr.mr_n52424064)
print v(xbgr.mr_n52424176)
print v(xbgr.mr_n52424496)
print v(xbgr.mr_n52425360)
print v(xbgr.mr_n52426224)
print v(xbgr.mr_n52426336)
print v(xbgr.mr_n52426656)
print v(xbgr.mr_n52426768)
print v(xbgr.mr_n52427200)
print v(xbgr.mr_n52427632)
print v(xbgr.mr_n52427952)
print v(xbgr.mr_n52428064)
print v(xbgr.mr_n52428384)
print v(xbgr.mr_n52428496)
print v(xbgr.mr_n52428816)
print v(xbgr.mr_n52428928)
print v(xbgr.mr_n52429248)
print v(xbgr.mr_n52429360)
print v(xbgr.mr_n52429680)
print v(xbgr.mr_n52429792)
print v(xbgr.mr_n52430224)
print v(xbgr.mr_n52430544)
print v(xbgr.mr_n52430656)
print v(xbgr.mr_n52431088)
print v(xbgr.mr_n52431408)
print v(xbgr.mr_n52432272)
print v(xbgr.mr_n52433136)
print v(xbgr.mr_n52434000)
print v(xbgr.mr_n52434864)
print v(xbgr.mr_n52434976)
print v(xbgr.mr_n52435296)
print v(xbgr.mr_n52435408)
print v(xbgr.mr_n52435728)
print v(xbgr.mr_n52435840)
print v(xbgr.mr_n52436160)
print v(xbgr.mr_n52436272)
print v(xbgr.mr_n52436592)
print v(xbgr.mr_n52437456)
print v(xbgr.mr_n52438320)
print v(xbgr.mr_n52438432)
print v(xbgr.mr_n52438752)
print v(xbgr.mr_n52438864)
print v(xbgr.mr_n52439296)
print v(xbgr.mr_n52439728)
print v(xbgr.mr_n52440048)
print v(xbgr.mr_n52440160)
print v(xbgr.mr_n52440480)
print v(xbgr.mr_n52440592)
print v(xbgr.mr_n52440912)
print v(xbgr.mr_n52441024)
print v(xbgr.mr_n52441344)
print v(xbgr.mr_n52441456)
print v(xbgr.mr_n52441776)
print v(xbgr.mr_n52441888)
print v(xbgr.mr_n52442320)
print v(xbgr.mr_n52442640)
print v(xbgr.mr_n52442752)
print v(xbgr.mr_n52443184)
print v(xbgr.mr_n52443504)
print v(xbgr.mr_n52443616)
print v(xbgr.mr_n52444048)
print v(xbgr.mr_n52444368)
print v(xbgr.mr_n52444480)
print v(xbgr.mr_n52444912)
print v(xbgr.mr_n52445232)
print v(xbgr.mr_n52446096)
print v(xbgr.mr_n52446960)
print v(xbgr.mr_n52447824)
print v(xbgr.mr_n52448688)
print v(xbgr.mr_n52449552)
print v(xbgr.mr_n52450416)
print v(xbgr.mr_n52450528)
print v(xbgr.mr_n52450848)
print v(xbgr.mr_n52450960)
print v(xbgr.mr_n52451280)
print v(xbgr.mr_n52451392)
print v(xbgr.mr_n52451712)
print v(xbgr.mr_n52451824)
print v(xbgr.mr_n52452144)
print v(xbgr.mr_n52452256)
print v(xbgr.mr_n52452576)
print v(xbgr.mr_n52452688)
print v(xbgr.mr_n52453008)
print v(xbgr.mr_n52453120)
print v(xbgr.mr_n52453440)
print v(xbgr.mr_n52453552)
print v(xbgr.mr_n52453872)
print v(xbgr.mr_n52453984)
print v(xbgr.mr_n52454304)
print v(xbgr.mr_n52454416)
print v(xbgr.mr_n52454848)
print v(xbgr.mr_n52455280)
print v(xbgr.mr_n52455600)
print v(xbgr.mr_n52456464)
print v(xbgr.mr_n52457328)
print v(xbgr.mr_n52457440)
print v(xbgr.mr_n52457760)
print v(xbgr.mr_n52457872)
print v(xbgr.mr_n52458192)
print v(xbgr.mr_n52458304)
print v(xbgr.mr_n52458624)
print v(xbgr.mr_n52458736)
print v(xbgr.mr_n52459056)
print v(xbgr.mr_n52459168)
print v(xbgr.mr_n52459488)
print v(xbgr.mr_n52459600)
print v(xbgr.mr_n52459920)
print v(xbgr.mr_n52460032)
print v(xbgr.mr_n52460352)
print v(xbgr.mr_n52460464)
print v(xbgr.mr_n52460896)
print v(xbgr.mr_n52461328)
print v(xbgr.mr_n52461648)
print v(xbgr.mr_n52461760)
print v(xbgr.mr_n52462080)
print v(xbgr.mr_n52462192)
print v(xbgr.mr_n52462512)
print v(xbgr.mr_n52462624)
print v(xbgr.mr_n52462944)
print v(xbgr.mr_n52463056)
print v(xbgr.mr_n52463376)
print v(xbgr.mr_n52463488)
print v(xbgr.mr_n52463808)
print v(xbgr.mr_n52463920)
print v(xbgr.mr_n52464240)
print v(xbgr.mr_n52465104)
print v(xbgr.mr_n52465968)
print v(xbgr.mr_n52466832)
print v(xbgr.mr_n52467696)
print v(xbgr.mr_n52467808)
print v(xbgr.mr_n52468240)
print v(xbgr.mr_n52468560)
print v(xbgr.mr_n52468672)
print v(xbgr.mr_n52468992)
print v(xbgr.mr_n52469104)
print v(xbgr.mr_n52469424)
print v(xbgr.mr_n52469536)
print v(xbgr.mr_n52469856)
print v(xbgr.mr_n52469968)
print v(xbgr.mr_n52470288)
print v(xbgr.mr_n52470400)
print v(xbgr.mr_n52470720)
print v(xbgr.mr_n52470832)
print v(xbgr.mr_n52471152)
print v(xbgr.mr_n52471264)
print v(xbgr.mr_n52471696)
print v(xbgr.mr_n52472016)
print v(xbgr.mr_n52472880)
print v(xbgr.mr_n52472992)
print v(xbgr.mr_n52473312)
print v(xbgr.mr_n52473424)
print v(xbgr.mr_n52473744)
print v(xbgr.mr_n52473856)
print v(xbgr.mr_n52474176)
print v(xbgr.mr_n52474288)
print v(xbgr.mr_n52474608)
print v(xbgr.mr_n52474720)
print v(xbgr.mr_n52475152)
print v(xbgr.mr_n52475472)
print v(xbgr.mr_n52475584)
print v(xbgr.mr_n52476016)
print v(xbgr.mr_n52476336)
print v(xbgr.mr_n52477200)
print v(xbgr.mr_n52478064)
print v(xbgr.mr_n52478928)
print v(xbgr.mr_n52479792)
print v(xbgr.mr_n52479904)
print v(xbgr.mr_n52480224)
print v(xbgr.mr_n52480336)
print v(xbgr.mr_n52480656)
print v(xbgr.mr_n52480768)
print v(xbgr.mr_n52481088)
print v(xbgr.mr_n52481200)
print v(xbgr.mr_n52481520)
print v(xbgr.mr_n52481632)
print v(xbgr.mr_n52481952)
print v(xbgr.mr_n52482064)
print v(xbgr.mr_n52482384)
print v(xbgr.mr_n52483248)
print v(xbgr.mr_n52484112)
print v(xbgr.mr_n52484224)
print v(xbgr.mr_n52484544)
print v(xbgr.mr_n52484656)
print v(xbgr.mr_n52485088)
print v(xbgr.mr_n52485520)
print v(xbgr.mr_n52485840)
print v(xbgr.mr_n52485952)
print v(xbgr.mr_n52486272)
print v(xbgr.mr_n52486384)
print v(xbgr.mr_n52486704)
print v(xbgr.mr_n52486816)
print v(xbgr.mr_n52487136)
print v(xbgr.mr_n52487248)
print v(xbgr.mr_n52487568)
print v(xbgr.mr_n52488432)
print v(xbgr.mr_n52489296)
print v(xbgr.mr_n52490160)
print v(xbgr.mr_n52491024)
print v(xbgr.mr_n52491888)
print v(xbgr.mr_n52492000)
print v(xbgr.mr_n52492320)
print v(xbgr.mr_n52492432)
print v(xbgr.mr_n52492752)
print v(xbgr.mr_n52492864)
print v(xbgr.mr_n52493184)
print v(xbgr.mr_n52493296)
print v(xbgr.mr_n52493616)
print v(xbgr.mr_n52493728)
print v(xbgr.mr_n52494160)
print v(xbgr.mr_n52494480)
print v(xbgr.mr_n52494592)
print v(xbgr.mr_n52495024)
print v(xbgr.mr_n52495344)
print v(xbgr.mr_n52495456)
print v(xbgr.mr_n52495888)
print v(xbgr.mr_n52496208)
print v(xbgr.mr_n52496320)
print v(xbgr.mr_n52496752)
print v(xbgr.mr_n52497072)
print v(xbgr.mr_n52497936)
print v(xbgr.mr_n52498048)
print v(xbgr.mr_n52498368)
print v(xbgr.mr_n52498480)
print v(xbgr.mr_n52498800)
print v(xbgr.mr_n52498912)
print v(xbgr.mr_n52499232)
print v(xbgr.mr_n52499344)
print v(xbgr.mr_n52499664)
print v(xbgr.mr_n52500528)
print v(xbgr.mr_n52501392)
print v(xbgr.mr_n52502256)
print v(xbgr.mr_n52503120)
print v(xbgr.mr_n52503984)
print v(xbgr.mr_n52504096)
print v(xbgr.mr_n52504416)
print v(xbgr.mr_n52504528)
print v(xbgr.mr_n52504848)
print v(xbgr.mr_n52504960)
print v(xbgr.mr_n52505280)
print v(xbgr.mr_n52505392)
print v(xbgr.mr_n52505824)
print v(xbgr.mr_n52506256)
print v(xbgr.mr_n52506576)
print v(xbgr.mr_n52506688)
print v(xbgr.mr_n52507008)
print v(xbgr.mr_n52507120)
print v(xbgr.mr_n52507440)
print v(xbgr.mr_n52508304)
print v(xbgr.mr_n52508416)
print v(xbgr.mr_n52508736)
print v(xbgr.mr_n52508848)
print v(xbgr.mr_n52509168)
print v(xbgr.mr_n52510032)
print v(xbgr.mr_n52510896)
print v(xbgr.mr_n52511008)
print v(xbgr.mr_n52511328)
print v(xbgr.mr_n52511440)
print v(xbgr.mr_n52511760)
print v(xbgr.mr_n52512624)
print v(xbgr.mr_n52513488)
print v(xbgr.mr_n52514352)
print v(xbgr.mr_n52514464)
print v(xbgr.mr_n52514784)
print v(xbgr.mr_n52514896)
print v(xbgr.mr_n52515216)
print v(xbgr.mr_n52515328)
print v(xbgr.mr_n52515648)
print v(xbgr.mr_n52515760)
print v(xbgr.mr_n52516080)
print v(xbgr.mr_n52516192)
print v(xbgr.mr_n52516512)
print v(xbgr.mr_n52516624)
print v(xbgr.mr_n52516944)
print v(xbgr.mr_n52517056)
print v(xbgr.mr_n52517376)
print v(xbgr.mr_n52517488)
print v(xbgr.mr_n52517808)
print v(xbgr.mr_n52517920)
print v(xbgr.mr_n52518240)
print v(xbgr.mr_n52518352)
print v(xbgr.mr_n52518672)
print v(xbgr.mr_n52518784)
print v(xbgr.mr_n52519104)
print v(xbgr.mr_n52519216)
print v(xbgr.mr_n52519648)
print v(xbgr.mr_n52519968)
print v(xbgr.mr_n52520080)
print v(xbgr.mr_n52520512)
print v(xbgr.mr_n52520832)
print v(xbgr.mr_n52520944)
print v(xbgr.mr_n52521376)
print v(xbgr.mr_n52521696)
print v(xbgr.mr_n52522560)
print v(xbgr.mr_n52523424)
print v(xbgr.mr_n52524288)
print v(xbgr.mr_n52524400)
print v(xbgr.mr_n52524720)
print v(xbgr.mr_n52524832)
print v(xbgr.mr_n52525152)
print v(xbgr.mr_n52526016)
print v(xbgr.mr_n52526880)
print v(xbgr.mr_n52527744)
print v(xbgr.mr_n52527856)
print v(xbgr.mr_n52528176)
print v(xbgr.mr_n52528288)
print v(xbgr.mr_n52528608)
print v(xbgr.mr_n52528720)
print v(xbgr.mr_n52529040)
print v(xbgr.mr_n52529152)
print v(xbgr.mr_n52529472)
print v(xbgr.mr_n52529584)
print v(xbgr.mr_n52529904)
print v(xbgr.mr_n52530016)
print v(xbgr.mr_n52530336)
print v(xbgr.mr_n52530448)
print v(xbgr.mr_n52530768)
print v(xbgr.mr_n52530880)
print v(xbgr.mr_n52531200)
print v(xbgr.mr_n52531312)
print v(xbgr.mr_n52531632)
print v(xbgr.mr_n52531744)
print v(xbgr.mr_n52532064)
print v(xbgr.mr_n52532176)
print v(xbgr.mr_n52532496)
print v(xbgr.mr_n52532608)
print v(xbgr.mr_n52532928)
print v(xbgr.mr_n52533040)
print v(xbgr.mr_n52533472)
print v(xbgr.mr_n52533792)
print v(xbgr.mr_n52534656)
print v(xbgr.mr_n52535520)
print v(xbgr.mr_n52536384)
print v(xbgr.mr_n52536496)
print v(xbgr.mr_n52536928)
print v(xbgr.mr_n52537248)
print v(xbgr.mr_n52537360)
print v(xbgr.mr_n52537792)
print v(xbgr.mr_n52538112)
print v(xbgr.mr_n52538224)
print v(xbgr.mr_n52538544)
print v(xbgr.mr_n52538656)
print v(xbgr.mr_n52538976)
print v(xbgr.mr_n52539088)
print v(xbgr.mr_n52539520)
print v(xbgr.mr_n52539952)
print v(xbgr.mr_n52540384)
print v(xbgr.mr_n52540704)
print v(xbgr.mr_n52541568)
print v(xbgr.mr_n52542432)
print v(xbgr.mr_n52543296)
print v(xbgr.mr_n52544160)
print v(xbgr.mr_n52545024)
print v(xbgr.mr_n52545888)
print v(xbgr.mr_n52546000)
print v(xbgr.mr_n52546320)
print v(xbgr.mr_n52546432)
print v(xbgr.mr_n52546752)
print v(xbgr.mr_n52546864)
print v(xbgr.mr_n52547184)
print v(xbgr.mr_n52547296)
print v(xbgr.mr_n52547616)
print v(xbgr.mr_n52547728)
print v(xbgr.mr_n52548048)
print v(xbgr.mr_n52548160)
print v(xbgr.mr_n52548480)
print v(xbgr.mr_n52549344)
print v(xbgr.mr_n52550208)
print v(xbgr.mr_n52551184)
print v(xbgr.mr_n52551616)
print v(xbgr.mr_n52552048)
print v(xbgr.mr_n52552368)
print v(xbgr.mr_n52552480)
print v(xbgr.mr_n52552800)
print v(xbgr.mr_n52552912)
print v(xbgr.mr_n52553232)
print v(xbgr.mr_n52553344)
print v(xbgr.mr_n52553776)
print v(xbgr.mr_n52554096)
print v(xbgr.mr_n52554208)
print v(xbgr.mr_n52554528)
print v(xbgr.mr_n52554640)
print v(xbgr.mr_n52555072)
print v(xbgr.mr_n52555392)
print v(xbgr.mr_n52555504)
print v(xbgr.mr_n52555936)
print v(xbgr.mr_n52556256)
print v(xbgr.mr_n52556368)
print v(xbgr.mr_n52556800)
print v(xbgr.mr_n52557120)
print v(xbgr.mr_n52557984)
print v(xbgr.mr_n52558848)
print v(xbgr.mr_n52558960)
print v(xbgr.mr_n52559280)
print v(xbgr.mr_n52559392)
print v(xbgr.mr_n52559712)
print v(xbgr.mr_n52559824)
print v(xbgr.mr_n52560144)
print v(xbgr.mr_n52560256)
print v(xbgr.mr_n52560688)
print v(xbgr.mr_n52561008)
print v(xbgr.mr_n52561872)
print v(xbgr.mr_n52561984)
print v(xbgr.mr_n52562304)
print v(xbgr.mr_n52562416)
print v(xbgr.mr_n52562736)
print v(xbgr.mr_n52562848)
print v(xbgr.mr_n52563168)
print v(xbgr.mr_n52564032)
print v(xbgr.mr_n52564464)
print v(xbgr.mr_n52565328)
print v(xbgr.mr_n52565440)
print v(xbgr.mr_n52565760)
print v(xbgr.mr_n52565872)
print v(xbgr.mr_n52566192)
print v(xbgr.mr_n52566304)
print v(xbgr.mr_n52566624)
print v(xbgr.mr_n52566736)
print v(xbgr.mr_n52567056)
print v(xbgr.mr_n52567168)
print v(xbgr.mr_n52567600)
print v(xbgr.mr_n52568352)
print v(xbgr.mr_n52569216)
print v(xbgr.mr_n52569648)
print v(xbgr.mr_n52569760)
print v(xbgr.mr_n52570080)
print v(xbgr.mr_n52570512)
print v(xbgr.mr_n52571376)
print v(xbgr.mr_n52572240)
print v(xbgr.mr_n52573104)
print v(xbgr.mr_n52573968)
print v(xbgr.mr_n52575264)
print v(xbgr.mr_n52576128)
print v(xbgr.mr_n52577104)
print v(xbgr.mr_n52577424)
print v(xbgr.mr_n52577536)
print v(xbgr.mr_n52577968)
print v(xbgr.mr_n52578288)
print v(xbgr.mr_n52579152)
print v(xbgr.mr_n52579264)
print v(xbgr.mr_n52579584)
print v(xbgr.mr_n52579696)
print v(xbgr.mr_n52580128)
print v(xbgr.mr_n52580448)
print v(xbgr.mr_n52580560)
print v(xbgr.mr_n52580880)
print v(xbgr.mr_n52580992)
print v(xbgr.mr_n52581312)
print v(xbgr.mr_n52581424)
print v(xbgr.mr_n52581744)
print v(xbgr.mr_n52581856)
print v(xbgr.mr_n52582288)
print v(xbgr.mr_n52582608)
print v(xbgr.mr_n52582720)
print v(xbgr.mr_n52583040)
print v(xbgr.mr_n52583152)
print v(xbgr.mr_n52583472)
print v(xbgr.mr_n52584336)
print v(xbgr.mr_n52584448)
print v(xbgr.mr_n52585200)
print v(xbgr.mr_n52585312)
print v(xbgr.mr_n52585632)
print v(xbgr.mr_n52585744)
print v(xbgr.mr_n52586064)
print v(xbgr.mr_n52586176)
print v(xbgr.mr_n52586496)
print v(xbgr.mr_n52586608)
print v(xbgr.mr_n52586928)
print v(xbgr.mr_n52587040)
print v(xbgr.mr_n52587360)
print v(xbgr.mr_n52587472)
print v(xbgr.mr_n52587792)
print v(xbgr.mr_n52587904)
print v(xbgr.mr_n52588224)
print v(xbgr.mr_n52588336)
print v(xbgr.mr_n52588656)
print v(xbgr.mr_n52588768)
print v(xbgr.mr_n52589088)
print v(xbgr.mr_n52589200)
print v(xbgr.mr_n52589520)
print v(xbgr.mr_n52589632)
print v(xbgr.mr_n52589952)
print v(xbgr.mr_n52590064)
print v(xbgr.mr_n52590384)
print v(xbgr.mr_n52590496)
print v(xbgr.mr_n52590928)
print v(xbgr.mr_n52591248)
print v(xbgr.mr_n52591360)
print v(xbgr.mr_n52591792)
print v(xbgr.mr_n52592112)
print v(xbgr.mr_n52592224)
print v(xbgr.mr_n52592656)
print v(xbgr.mr_n52592976)
print v(xbgr.mr_n52593840)
print v(xbgr.mr_n52594704)
print v(xbgr.mr_n52595568)
print v(xbgr.mr_n52596432)
print v(xbgr.mr_n52597296)
print v(xbgr.mr_n52598160)
print v(xbgr.mr_n52598272)
print v(xbgr.mr_n52598592)
print v(xbgr.mr_n52598704)
print v(xbgr.mr_n52599024)
print v(xbgr.mr_n52599136)
print v(xbgr.mr_n52599456)
print v(xbgr.mr_n52599568)
print v(xbgr.mr_n52599888)
print v(xbgr.mr_n52600752)
print v(xbgr.mr_n52601616)
print v(xbgr.mr_n52602480)
print v(xbgr.mr_n52602592)
print v(xbgr.mr_n52602912)
print v(xbgr.mr_n52603024)
print v(xbgr.mr_n52603344)
print v(xbgr.mr_n52603456)
print v(xbgr.mr_n52603888)
print v(xbgr.mr_n52604320)
print v(xbgr.mr_n52604752)
print v(xbgr.mr_n52605072)
print v(xbgr.mr_n52605184)
print v(xbgr.mr_n52605504)
print v(xbgr.mr_n52605616)
print v(xbgr.mr_n52605936)
print v(xbgr.mr_n52606048)
print v(xbgr.mr_n52606368)
print v(xbgr.mr_n52606480)
print v(xbgr.mr_n52606800)
print v(xbgr.mr_n52606912)
print v(xbgr.mr_n52607232)
print v(xbgr.mr_n52607344)
print v(xbgr.mr_n52607664)
print v(xbgr.mr_n52607776)
print v(xbgr.mr_n52608208)
print v(xbgr.mr_n52608528)
print v(xbgr.mr_n52608640)
print v(xbgr.mr_n52609072)
print v(xbgr.mr_n52609392)
print v(xbgr.mr_n52609504)
print v(xbgr.mr_n52609936)
print v(xbgr.mr_n52610256)
print v(xbgr.mr_n52611120)
print v(xbgr.mr_n52611984)
print v(xbgr.mr_n52612848)
print v(xbgr.mr_n52613712)
print v(xbgr.mr_n52614576)
print v(xbgr.mr_n52615440)
print v(xbgr.mr_n52615552)
print v(xbgr.mr_n52615872)
print v(xbgr.mr_n52615984)
print v(xbgr.mr_n52616304)
print v(xbgr.mr_n52616416)
print v(xbgr.mr_n52616736)
print v(xbgr.mr_n52616848)
print v(xbgr.mr_n52617168)
print v(xbgr.mr_n52618032)
print v(xbgr.mr_n52618896)
print v(xbgr.mr_n52619760)
print v(xbgr.mr_n52619872)
print v(xbgr.mr_n52620192)
print v(xbgr.mr_n52620304)
print v(xbgr.mr_n52620624)
print v(xbgr.mr_n52620736)
print v(xbgr.mr_n52621168)
print v(xbgr.mr_n52621488)
print v(xbgr.mr_n52621600)
print v(xbgr.mr_n52622032)
print v(xbgr.mr_n52622352)
print v(xbgr.mr_n52622464)
print v(xbgr.mr_n52622896)
print v(xbgr.mr_n52623216)
print v(xbgr.mr_n52623328)
print v(xbgr.mr_n52623648)
print v(xbgr.mr_n52623760)
print v(xbgr.mr_n52624080)
print v(xbgr.mr_n52624192)
print v(xbgr.mr_n52624624)
print v(xbgr.mr_n52624944)
print v(xbgr.mr_n52625808)
print v(xbgr.mr_n52626672)
print v(xbgr.mr_n52627536)
print v(xbgr.mr_n52627648)
print v(xbgr.mr_n52627968)
print v(xbgr.mr_n52628080)
print v(xbgr.mr_n52628400)
print v(xbgr.mr_n52629264)
print v(xbgr.mr_n52630128)
print v(xbgr.mr_n52630992)
print v(xbgr.mr_n52631856)
print v(xbgr.mr_n52631968)
print v(xbgr.mr_n52632288)
print v(xbgr.mr_n52632400)
print v(xbgr.mr_n52632720)
print v(xbgr.mr_n52633584)
print v(xbgr.mr_n52634128)
print v(xbgr.mr_n52634448)
print v(xbgr.mr_n52634560)
print v(xbgr.mr_n52634880)
print v(xbgr.mr_n52634992)
print v(xbgr.mr_n52635312)
print v(xbgr.mr_n52635424)
print v(xbgr.mr_n52635744)
print v(xbgr.mr_n52635856)
print v(xbgr.mr_n52636288)
print v(xbgr.mr_n52637040)
print v(xbgr.mr_n52637904)
print v(xbgr.mr_n52638768)
print v(xbgr.mr_n52639632)
print v(xbgr.mr_n52639744)
print v(xbgr.mr_n52640064)
print v(xbgr.mr_n52640176)
print v(xbgr.mr_n52640496)
print v(xbgr.mr_n52640608)
print v(xbgr.mr_n52640928)
print v(xbgr.mr_n52641040)
print v(xbgr.mr_n52641360)
print v(xbgr.mr_n52641472)
print v(xbgr.mr_n52641792)
print v(xbgr.mr_n52641904)
print v(xbgr.mr_n52642224)
print v(xbgr.mr_n52642336)
print v(xbgr.mr_n52642768)
print v(xbgr.mr_n52643088)
print v(xbgr.mr_n52643200)
print v(xbgr.mr_n52643520)
print v(xbgr.mr_n52643632)
print v(xbgr.mr_n52643952)
print v(xbgr.mr_n52644064)
print v(xbgr.mr_n52644384)
print v(xbgr.mr_n52644496)
print v(xbgr.mr_n52644816)
print v(xbgr.mr_n52644928)
print v(xbgr.mr_n52645360)
print v(xbgr.mr_n52645680)
print v(xbgr.mr_n52646544)
print v(xbgr.mr_n52646656)
print v(xbgr.mr_n52646976)
print v(xbgr.mr_n52647088)
print v(xbgr.mr_n52647520)
print v(xbgr.mr_n52647952)
print v(xbgr.mr_n52648272)
print v(xbgr.mr_n52648384)
print v(xbgr.mr_n52648704)
print v(xbgr.mr_n52648816)
print v(xbgr.mr_n52649136)
print v(xbgr.mr_n52649248)
print v(xbgr.mr_n52649568)
print v(xbgr.mr_n52649680)
print v(xbgr.mr_n52650000)
print v(xbgr.mr_n52650112)
print v(xbgr.mr_n52650544)
print v(xbgr.mr_n52650864)
print v(xbgr.mr_n52650976)
print v(xbgr.mr_n52651408)
print v(xbgr.mr_n52651728)
print v(xbgr.mr_n52652592)
print v(xbgr.mr_n52653456)
print v(xbgr.mr_n52654320)
print v(xbgr.mr_n52655184)
print v(xbgr.mr_n52655296)
print v(xbgr.mr_n52655616)
print v(xbgr.mr_n52655728)
print v(xbgr.mr_n52656048)
print v(xbgr.mr_n52656160)
print v(xbgr.mr_n52656480)
print v(xbgr.mr_n52656592)
print v(xbgr.mr_n52656912)
print v(xbgr.mr_n52657776)
print v(xbgr.mr_n52658640)
print v(xbgr.mr_n52658752)
print v(xbgr.mr_n52659072)
print v(xbgr.mr_n52659184)
print v(xbgr.mr_n52659616)
print v(xbgr.mr_n52660048)
print v(xbgr.mr_n52660368)
print v(xbgr.mr_n52660480)
print v(xbgr.mr_n52660800)
print v(xbgr.mr_n52660912)
print v(xbgr.mr_n52661232)
print v(xbgr.mr_n52661344)
print v(xbgr.mr_n52661664)
print v(xbgr.mr_n52661776)
print v(xbgr.mr_n52662096)
print v(xbgr.mr_n52662960)
print v(xbgr.mr_n52663824)
print v(xbgr.mr_n52664688)
print v(xbgr.mr_n52665552)
print v(xbgr.mr_n52666416)
print v(xbgr.mr_n52666528)
print v(xbgr.mr_n52666960)
print v(xbgr.mr_n52667280)
print v(xbgr.mr_n52667392)
print v(xbgr.mr_n52667824)
print v(xbgr.mr_n52668144)
print v(xbgr.mr_n52668256)
print v(xbgr.mr_n52668688)
print v(xbgr.mr_n52669008)
print v(xbgr.mr_n52669120)
print v(xbgr.mr_n52669440)
print v(xbgr.mr_n52669552)
print v(xbgr.mr_n52669872)
print v(xbgr.mr_n52669984)
print v(xbgr.mr_n52670304)
print v(xbgr.mr_n52670416)
print v(xbgr.mr_n52670736)
print v(xbgr.mr_n52670848)
print v(xbgr.mr_n52671168)
print v(xbgr.mr_n52671280)
print v(xbgr.mr_n52671600)
print v(xbgr.mr_n52671712)
print v(xbgr.mr_n52672032)
print v(xbgr.mr_n52672144)
print v(xbgr.mr_n52672464)
print v(xbgr.mr_n52672576)
print v(xbgr.mr_n52672896)
print v(xbgr.mr_n52673008)
print v(xbgr.mr_n52673328)
print v(xbgr.mr_n52673440)
print v(xbgr.mr_n52673760)
print v(xbgr.mr_n52673872)
print v(xbgr.mr_n52674192)
print v(xbgr.mr_n52675056)
print v(xbgr.mr_n52675920)
print v(xbgr.mr_n52676784)
print v(xbgr.mr_n52676896)
print v(xbgr.mr_n52677328)
print v(xbgr.mr_n52677648)
print v(xbgr.mr_n52677760)
print v(xbgr.mr_n52678080)
print v(xbgr.mr_n52678192)
print v(xbgr.mr_n52678512)
print v(xbgr.mr_n52678624)
print v(xbgr.mr_n52678944)
print v(xbgr.mr_n52679056)
print v(xbgr.mr_n52679488)
print v(xbgr.mr_n52679920)
print v(xbgr.mr_n52680352)
print v(xbgr.mr_n52680784)
print v(xbgr.mr_n52681104)
print v(xbgr.mr_n52681216)
print v(xbgr.mr_n52681648)
print v(xbgr.mr_n52681968)
print v(xbgr.mr_n52682832)
print v(xbgr.mr_n52682944)
print v(xbgr.mr_n52683264)
print v(xbgr.mr_n52683376)
print v(xbgr.mr_n52683696)
print v(xbgr.mr_n52683808)
print v(xbgr.mr_n52684128)
print v(xbgr.mr_n52685104)
print v(xbgr.mr_n52685536)
print v(xbgr.mr_n52685968)
print v(xbgr.mr_n52686288)
print v(xbgr.mr_n52687152)
print v(xbgr.mr_n52687264)
print v(xbgr.mr_n52687584)
print v(xbgr.mr_n52687696)
print v(xbgr.mr_n52688016)
print v(xbgr.mr_n52688128)
print v(xbgr.mr_n52688448)
print v(xbgr.mr_n52688560)
print v(xbgr.mr_n52688880)
print v(xbgr.mr_n52688992)
print v(xbgr.mr_n52689312)
print v(xbgr.mr_n52689424)
print v(xbgr.mr_n52689744)
print v(xbgr.mr_n52689856)
print v(xbgr.mr_n52690176)
print v(xbgr.mr_n52690288)
print v(xbgr.mr_n52690608)
print v(xbgr.mr_n52691472)
print v(xbgr.mr_n52692336)
print v(xbgr.mr_n52693200)
print v(xbgr.mr_n52694064)
print v(xbgr.mr_n52694928)
print v(xbgr.mr_n52695792)
print v(xbgr.mr_n52696656)
print v(xbgr.mr_n52697520)
print v(xbgr.mr_n52698384)
print v(xbgr.mr_n52699248)
print v(xbgr.mr_n52700112)
print v(xbgr.mr_n52700976)
print v(xbgr.mr_n52701088)
print v(xbgr.mr_n52701408)
print v(xbgr.mr_n52701520)
print v(xbgr.mr_n52701840)
print v(xbgr.mr_n52701952)
print v(xbgr.mr_n52702272)
print v(xbgr.mr_n52702384)
print v(xbgr.mr_n52702704)
print v(xbgr.mr_n52702816)
print v(xbgr.mr_n52703248)
print v(xbgr.mr_n52703568)
print v(xbgr.mr_n52703680)
print v(xbgr.mr_n52704112)
print v(xbgr.mr_n52704432)
print v(xbgr.mr_n52705296)
print v(xbgr.mr_n52706160)
print v(xbgr.mr_n52707024)
print v(xbgr.mr_n52707888)
print v(xbgr.mr_n52708000)
print v(xbgr.mr_n52708320)
print v(xbgr.mr_n52708432)
print v(xbgr.mr_n52708752)
print v(xbgr.mr_n52708864)
print v(xbgr.mr_n52709184)
print v(xbgr.mr_n52709296)
print v(xbgr.mr_n52709616)
print v(xbgr.mr_n52709728)
print v(xbgr.mr_n52710048)
print v(xbgr.mr_n52710160)
print v(xbgr.mr_n52710480)
print v(xbgr.mr_n52710592)
print v(xbgr.mr_n52710912)
print v(xbgr.mr_n52711776)
print v(xbgr.mr_n52712640)
print v(xbgr.mr_n52712752)
print v(xbgr.mr_n52713072)
print v(xbgr.mr_n52713184)
print v(xbgr.mr_n52713616)
print v(xbgr.mr_n52714048)
print v(xbgr.mr_n52714368)
print v(xbgr.mr_n52714480)
print v(xbgr.mr_n52714800)
print v(xbgr.mr_n52714912)
print v(xbgr.mr_n52715232)
print v(xbgr.mr_n52715344)
print v(xbgr.mr_n52715664)
print v(xbgr.mr_n52715776)
print v(xbgr.mr_n52716096)
print v(xbgr.mr_n52716208)
print v(xbgr.mr_n52716640)
print v(xbgr.mr_n52716960)
print v(xbgr.mr_n52717072)
print v(xbgr.mr_n52717504)
print v(xbgr.mr_n52717824)
print v(xbgr.mr_n52717936)
print v(xbgr.mr_n52718256)
print v(xbgr.mr_n52719120)
print v(xbgr.mr_n52719984)
print v(xbgr.mr_n52720848)
print v(xbgr.mr_n52721712)
print v(xbgr.mr_n52721824)
print v(xbgr.mr_n52722144)
print v(xbgr.mr_n52722256)
print v(xbgr.mr_n52722576)
print v(xbgr.mr_n52722688)
print v(xbgr.mr_n52723008)
print v(xbgr.mr_n52723120)
print v(xbgr.mr_n52723440)
print v(xbgr.mr_n52723552)
print v(xbgr.mr_n52723872)
print v(xbgr.mr_n52723984)
print v(xbgr.mr_n52724304)
print v(xbgr.mr_n52725168)
print v(xbgr.mr_n52726032)
print v(xbgr.mr_n52726144)
print v(xbgr.mr_n52726576)
print v(xbgr.mr_n52726896)
print v(xbgr.mr_n52727008)
print v(xbgr.mr_n52727328)
print v(xbgr.mr_n52727440)
print v(xbgr.mr_n52727760)
print v(xbgr.mr_n52727872)
print v(xbgr.mr_n52728192)
print v(xbgr.mr_n52728304)
print v(xbgr.mr_n52728624)
print v(xbgr.mr_n52728736)
print v(xbgr.mr_n52729056)
print v(xbgr.mr_n52729168)
print v(xbgr.mr_n52729600)
print v(xbgr.mr_n52730032)
print v(xbgr.mr_n52730464)
print v(xbgr.mr_n52730896)
print v(xbgr.mr_n52731216)
print v(xbgr.mr_n52731648)
print v(xbgr.mr_n52731760)
print v(xbgr.mr_n52732080)
print v(xbgr.mr_n52732192)
print v(xbgr.mr_n52732512)
print v(xbgr.mr_n52732624)
print v(xbgr.mr_n52732944)
print v(xbgr.mr_n52733056)
print v(xbgr.mr_n52733376)
print v(xbgr.mr_n52733488)
print v(xbgr.mr_n52733808)
print v(xbgr.mr_n52733920)
print v(xbgr.mr_n52734672)
print v(xbgr.mr_n52734784)
print v(xbgr.mr_n52735216)
print v(xbgr.mr_n52735536)
print v(xbgr.mr_n52735968)
print v(xbgr.mr_n52736080)
print v(xbgr.mr_n52736512)
print v(xbgr.mr_n52736832)
print v(xbgr.mr_n52736944)
print v(xbgr.mr_n52737376)
print v(xbgr.mr_n52737696)
print v(xbgr.mr_n52737808)
print v(xbgr.mr_n52738240)
print v(xbgr.mr_n52738992)
print v(xbgr.mr_n52739856)
print v(xbgr.mr_n52740720)
print v(xbgr.mr_n52741584)
print v(xbgr.mr_n52742448)
print v(xbgr.mr_n52743312)
print v(xbgr.mr_n52743424)
print v(xbgr.mr_n52743744)
print v(xbgr.mr_n52743856)
print v(xbgr.mr_n52744176)
print v(xbgr.mr_n52744288)
print v(xbgr.mr_n52744608)
print v(xbgr.mr_n52744720)
print v(xbgr.mr_n52745040)
print v(xbgr.mr_n52745904)
print v(xbgr.mr_n52746768)
print v(xbgr.mr_n52747632)
print v(xbgr.mr_n52747744)
print v(xbgr.mr_n52748064)
print v(xbgr.mr_n52748176)
print v(xbgr.mr_n52748496)
print v(xbgr.mr_n52748608)
print v(xbgr.mr_n52748928)
print v(xbgr.mr_n52749040)
print v(xbgr.mr_n52749360)
print v(xbgr.mr_n52749472)
print v(xbgr.mr_n52749792)
print v(xbgr.mr_n52749904)
print v(xbgr.mr_n52750224)
print v(xbgr.mr_n52750336)
print v(xbgr.mr_n52750656)
print v(xbgr.mr_n52750768)
print v(xbgr.mr_n52751088)
print v(xbgr.mr_n52751952)
print v(xbgr.mr_n52752384)
print v(xbgr.mr_n52753248)
print v(xbgr.mr_n52753680)
print v(xbgr.mr_n52754544)
print v(xbgr.mr_n52755408)
print v(xbgr.mr_n52756704)
print v(xbgr.mr_n52758000)
print v(xbgr.mr_n52758112)
print v(xbgr.mr_n52758432)
print v(xbgr.mr_n52758544)
print v(xbgr.mr_n52758976)
print v(xbgr.mr_n52759296)
print v(xbgr.mr_n52759408)
print v(xbgr.mr_n52759840)
print v(xbgr.mr_n52760160)
print v(xbgr.mr_n52760272)
print v(xbgr.mr_n52760592)
print v(xbgr.mr_n52760704)
print v(xbgr.mr_n52761024)
print v(xbgr.mr_n52761136)
print v(xbgr.mr_n52761568)
print v(xbgr.mr_n52761888)
print v(xbgr.mr_n52762000)
print v(xbgr.mr_n52762432)
print v(xbgr.mr_n52762752)
print v(xbgr.mr_n52762864)
print v(xbgr.mr_n52763296)
print v(xbgr.mr_n52763616)
print v(xbgr.mr_n52763728)
print v(xbgr.mr_n52764048)
print v(xbgr.mr_n52764480)
print v(xbgr.mr_n52764592)
print v(xbgr.mr_n52764912)
print v(xbgr.mr_n52765024)
print v(xbgr.mr_n52765344)
print v(xbgr.mr_n52765456)
print v(xbgr.mr_n52765776)
print v(xbgr.mr_n52765888)
print v(xbgr.mr_n52766640)
print v(xbgr.mr_n52767504)
print v(xbgr.mr_n52768368)
print v(xbgr.mr_n52768480)
print v(xbgr.mr_n52768800)
print v(xbgr.mr_n52768912)
print v(xbgr.mr_n52769232)
print v(xbgr.mr_n52769344)
print v(xbgr.mr_n52769664)
print v(xbgr.mr_n52769776)
print v(xbgr.mr_n52770528)
print v(xbgr.mr_n52770960)
print v(xbgr.mr_n52771824)
print v(xbgr.mr_n52773120)
print v(xbgr.mr_n52773552)
print v(xbgr.mr_n52774416)
print v(xbgr.mr_n52774528)
print v(xbgr.mr_n52774848)
print v(xbgr.mr_n52774960)
print v(xbgr.mr_n52775280)
print v(xbgr.mr_n52776144)
print v(xbgr.mr_n52776576)
print v(xbgr.mr_n52776688)
print v(xbgr.mr_n52777008)
print v(xbgr.mr_n52777872)
print v(xbgr.mr_n52778736)
print v(xbgr.mr_n52779600)
print v(xbgr.mr_n52780464)
print v(xbgr.mr_n52780576)
print v(xbgr.mr_n52780896)
print v(xbgr.mr_n52781008)
print v(xbgr.mr_n52781328)
print v(xbgr.mr_n52781440)
print v(xbgr.mr_n52781760)
print v(xbgr.mr_n52781872)
print v(xbgr.mr_n52782624)
print v(xbgr.mr_n52783488)
print v(xbgr.mr_n52784352)
print v(xbgr.mr_n52784464)
print v(xbgr.mr_n52784896)
print v(xbgr.mr_n52785328)
print v(xbgr.mr_n52785760)
print v(xbgr.mr_n52786080)
print v(xbgr.mr_n52786192)
print v(xbgr.mr_n52786512)
print v(xbgr.mr_n52786624)
print v(xbgr.mr_n52786944)
print v(xbgr.mr_n52787056)
print v(xbgr.mr_n52787376)
print v(xbgr.mr_n52787488)
print v(xbgr.mr_n52787808)
print v(xbgr.mr_n52787920)
print v(xbgr.mr_n52788240)
print v(xbgr.mr_n52788352)
print v(xbgr.mr_n52788672)
print v(xbgr.mr_n52788784)
print v(xbgr.mr_n52789104)
print v(xbgr.mr_n52789216)
print v(xbgr.mr_n52790400)
print v(xbgr.mr_n52790944)
print v(xbgr.mr_n52791376)
print v(xbgr.mr_n52791808)
print v(xbgr.mr_n52792560)
print v(xbgr.mr_n52792672)
print v(xbgr.mr_n52792992)
print v(xbgr.mr_n52793104)
print v(xbgr.mr_n52793424)
print v(xbgr.mr_n52793536)
print v(xbgr.mr_n52793856)
print v(xbgr.mr_n52793968)
print v(xbgr.mr_n52794288)
print v(xbgr.mr_n52794400)
print v(xbgr.mr_n52794720)
print v(xbgr.mr_n52794832)
print v(xbgr.mr_n52795264)
print v(xbgr.mr_n52795584)
print v(xbgr.mr_n52795696)
print v(xbgr.mr_n52796016)
print v(xbgr.mr_n52796128)
print v(xbgr.mr_n52796560)
print v(xbgr.mr_n52796880)
print v(xbgr.mr_n52796992)
print v(xbgr.mr_n52797312)
print v(xbgr.mr_n52797424)
print v(xbgr.mr_n52797744)
print v(xbgr.mr_n52797856)
print v(xbgr.mr_n52798176)
print v(xbgr.mr_n52798288)
print v(xbgr.mr_n52798608)
print v(xbgr.mr_n52798720)
print v(xbgr.mr_n52799040)
print v(xbgr.mr_n52799152)
print v(xbgr.mr_n52799472)
print v(xbgr.mr_n52800336)
print v(xbgr.mr_n52800880)
print v(xbgr.mr_n52801200)
print v(xbgr.mr_n52801312)
print v(xbgr.mr_n52801744)
print v(xbgr.mr_n52802064)
print v(xbgr.mr_n52802176)
print v(xbgr.mr_n52802928)
print v(xbgr.mr_n52803792)
print v(xbgr.mr_n52803904)
print v(xbgr.mr_n52804224)
print v(xbgr.mr_n52804336)
print v(xbgr.mr_n52804656)
print v(xbgr.mr_n52804768)
print v(xbgr.mr_n52805088)
print v(xbgr.mr_n52805520)
print v(xbgr.mr_n52806384)
print v(xbgr.mr_n52807680)
print v(xbgr.mr_n52808656)
print v(xbgr.mr_n52808976)
print v(xbgr.mr_n52809088)
print v(xbgr.mr_n52809408)
print v(xbgr.mr_n52809520)
print v(xbgr.mr_n52809840)
print v(xbgr.mr_n52810704)
print v(xbgr.mr_n52810816)
print v(xbgr.mr_n52811136)
print v(xbgr.mr_n52811248)
print v(xbgr.mr_n52811568)
print v(xbgr.mr_n52811680)
print v(xbgr.mr_n52812000)
print v(xbgr.mr_n52812112)
print v(xbgr.mr_n52812432)
print v(xbgr.mr_n52812544)
print v(xbgr.mr_n52812864)
print v(xbgr.mr_n52813408)
print v(xbgr.mr_n52813728)
print v(xbgr.mr_n52815024)
print v(xbgr.mr_n52815888)
print v(xbgr.mr_n52816432)
print v(xbgr.mr_n52816864)
print v(xbgr.mr_n52817616)
print v(xbgr.mr_n52817728)
print v(xbgr.mr_n52818048)
print v(xbgr.mr_n52818160)
print v(xbgr.mr_n52818480)
print v(xbgr.mr_n52818592)
print v(xbgr.mr_n52818912)
print v(xbgr.mr_n52819024)
print v(xbgr.mr_n52819344)
print v(xbgr.mr_n52819456)
print v(xbgr.mr_n52819776)
print v(xbgr.mr_n52819888)
print v(xbgr.mr_n52820320)
print v(xbgr.mr_n52820640)
print v(xbgr.mr_n52820752)
print v(xbgr.mr_n52821072)
print v(xbgr.mr_n52821184)
print v(xbgr.mr_n52821504)
print v(xbgr.mr_n52821616)
print v(xbgr.mr_n52821936)
print v(xbgr.mr_n52822048)
print v(xbgr.mr_n52822368)
print v(xbgr.mr_n52822480)
print v(xbgr.mr_n52822800)
print v(xbgr.mr_n52822912)
print v(xbgr.mr_n52823232)
print v(xbgr.mr_n52823344)
print v(xbgr.mr_n52823664)
print v(xbgr.mr_n52823776)
print v(xbgr.mr_n52824208)
print v(xbgr.mr_n52824640)
print v(xbgr.mr_n52825072)
print v(xbgr.mr_n52825392)
print v(xbgr.mr_n52825504)
print v(xbgr.mr_n52825824)
print v(xbgr.mr_n52825936)
print v(xbgr.mr_n52826256)
print v(xbgr.mr_n52826368)
print v(xbgr.mr_n52826688)
print v(xbgr.mr_n52826800)
print v(xbgr.mr_n52827120)
print v(xbgr.mr_n52827232)
print v(xbgr.mr_n52827664)
print v(xbgr.mr_n52827984)
print v(xbgr.mr_n52828848)
print v(xbgr.mr_n52829712)
print v(xbgr.mr_n52829824)
print v(xbgr.mr_n52830144)
print v(xbgr.mr_n52830256)
print v(xbgr.mr_n52830576)
print v(xbgr.mr_n52830688)
print v(xbgr.mr_n52831008)
print v(xbgr.mr_n52831120)
print v(xbgr.mr_n52831440)
print v(xbgr.mr_n52832416)
print v(xbgr.mr_n52832736)
print v(xbgr.mr_n52832848)
print v(xbgr.mr_n52833168)
print v(xbgr.mr_n52833280)
print v(xbgr.mr_n52833600)
print v(xbgr.mr_n52833712)
print v(xbgr.mr_n52834032)
print v(xbgr.mr_n52834144)
print v(xbgr.mr_n52834464)
print v(xbgr.mr_n52834576)
print v(xbgr.mr_n52834896)
print v(xbgr.mr_n52835760)
print v(xbgr.mr_n52836624)
print v(xbgr.mr_n52837488)
print v(xbgr.mr_n52838352)
print v(xbgr.mr_n52838464)
print v(xbgr.mr_n52838784)
print v(xbgr.mr_n52838896)
print v(xbgr.mr_n52839216)
print v(xbgr.mr_n52840192)
print v(xbgr.mr_n52840624)
print v(xbgr.mr_n52840944)
print v(xbgr.mr_n52841808)
print v(xbgr.mr_n52842672)
print v(xbgr.mr_n52843536)
print v(xbgr.mr_n52844400)
print v(xbgr.mr_n52844512)
print v(xbgr.mr_n52844944)
print v(xbgr.mr_n52845264)
print v(xbgr.mr_n52845376)
print v(xbgr.mr_n52845696)
print v(xbgr.mr_n52845808)
print v(xbgr.mr_n52846128)
print v(xbgr.mr_n52846240)
print v(xbgr.mr_n52846672)
print v(xbgr.mr_n52846992)
print v(xbgr.mr_n52847104)
print v(xbgr.mr_n52847536)
print v(xbgr.mr_n52847856)
print v(xbgr.mr_n52847968)
print v(xbgr.mr_n52848288)
print v(xbgr.mr_n52848400)
print v(xbgr.mr_n52848720)
print v(xbgr.mr_n52848832)
print v(xbgr.mr_n52849152)
print v(xbgr.mr_n52849264)
print v(xbgr.mr_n52849584)
print v(xbgr.mr_n52849696)
print v(xbgr.mr_n52850016)
print v(xbgr.mr_n52850128)
print v(xbgr.mr_n52850560)
print v(xbgr.mr_n52850880)
print v(xbgr.mr_n52851744)
print v(xbgr.mr_n52852288)
print v(xbgr.mr_n52852608)
print v(xbgr.mr_n52852720)
print v(xbgr.mr_n52853040)
print v(xbgr.mr_n52853152)
print v(xbgr.mr_n52853472)
print v(xbgr.mr_n52853584)
print v(xbgr.mr_n52853904)
print v(xbgr.mr_n52854016)
print v(xbgr.mr_n52854336)
print v(xbgr.mr_n52854448)
print v(xbgr.mr_n52854768)
print v(xbgr.mr_n52854880)
print v(xbgr.mr_n52855312)
print v(xbgr.mr_n52855632)
print v(xbgr.mr_n52856496)
print v(xbgr.mr_n52856928)
print v(xbgr.mr_n52857792)
print v(xbgr.mr_n52858656)
print v(xbgr.mr_n52860064)
print v(xbgr.mr_n52860928)
print v(xbgr.mr_n52861360)
print v(xbgr.mr_n52861680)
print v(xbgr.mr_n52862544)
print v(xbgr.mr_n52862656)
print v(xbgr.mr_n52862976)
print v(xbgr.mr_n52863088)
print v(xbgr.mr_n52863408)
print v(xbgr.mr_n52863520)
print v(xbgr.mr_n52863840)
print v(xbgr.mr_n52863952)
print v(xbgr.mr_n52864272)
print v(xbgr.mr_n52864384)
print v(xbgr.mr_n52864704)
print v(xbgr.mr_n52864816)
print v(xbgr.mr_n52865136)
print v(xbgr.mr_n52865248)
print v(xbgr.mr_n52865568)
print v(xbgr.mr_n52866432)
print v(xbgr.mr_n52867408)
print v(xbgr.mr_n52867840)
print v(xbgr.mr_n52868272)
print v(xbgr.mr_n52868592)
print v(xbgr.mr_n52868704)
print v(xbgr.mr_n52869024)
print v(xbgr.mr_n52869136)
print v(xbgr.mr_n52869456)
print v(xbgr.mr_n52870320)
print v(xbgr.mr_n52871184)
print v(xbgr.mr_n52872048)
print v(xbgr.mr_n52872160)
print v(xbgr.mr_n52872480)
print v(xbgr.mr_n52872592)
print v(xbgr.mr_n52872912)
print v(xbgr.mr_n52873776)
print v(xbgr.mr_n52874640)
print v(xbgr.mr_n52875504)
print v(xbgr.mr_n52875616)
print v(xbgr.mr_n52875936)
print v(xbgr.mr_n52876048)
print v(xbgr.mr_n52876368)
print v(xbgr.mr_n52876480)
print v(xbgr.mr_n52876800)
print v(xbgr.mr_n52876912)
print v(xbgr.mr_n52877232)
print v(xbgr.mr_n52878096)
print v(xbgr.mr_n52878960)
print v(xbgr.mr_n52879072)
print v(xbgr.mr_n52879392)
print v(xbgr.mr_n52879504)
print v(xbgr.mr_n52879824)
print v(xbgr.mr_n52879936)
print v(xbgr.mr_n52880256)
print v(xbgr.mr_n52880368)
print v(xbgr.mr_n52880688)
print v(xbgr.mr_n52880800)
print v(xbgr.mr_n52881232)
print v(xbgr.mr_n52881552)
print v(xbgr.mr_n52881664)
print v(xbgr.mr_n52881984)
print v(xbgr.mr_n52882096)
print v(xbgr.mr_n52882416)
print v(xbgr.mr_n52882528)
print v(xbgr.mr_n52882848)
print v(xbgr.mr_n52882960)
print v(xbgr.mr_n52883280)
print v(xbgr.mr_n52884144)
print v(xbgr.mr_n52884256)
print v(xbgr.mr_n52884688)
print v(xbgr.mr_n52885008)
print v(xbgr.mr_n52885120)
print v(xbgr.mr_n52885440)
print v(xbgr.mr_n52885552)
print v(xbgr.mr_n52885872)
print v(xbgr.mr_n52885984)
print v(xbgr.mr_n52886304)
print v(xbgr.mr_n52886416)
print v(xbgr.mr_n52886736)
print v(xbgr.mr_n52886848)
print v(xbgr.mr_n52887168)
print v(xbgr.mr_n52887280)
print v(xbgr.mr_n52887600)
print v(xbgr.mr_n52888032)
print v(xbgr.mr_n52888144)
print v(xbgr.mr_n52888464)
print v(xbgr.mr_n52889008)
print v(xbgr.mr_n52889328)
print v(xbgr.mr_n52889440)
print v(xbgr.mr_n52889872)
print v(xbgr.mr_n52890304)
print v(xbgr.mr_n52890736)
print v(xbgr.mr_n52891168)
print v(xbgr.mr_n52891600)
print v(xbgr.mr_n52891920)
print v(xbgr.mr_n52892032)
print v(xbgr.mr_n52892464)
print v(xbgr.mr_n52892784)
print v(xbgr.mr_n52892896)
print v(xbgr.mr_n52893328)
print v(xbgr.mr_n52893648)
print v(xbgr.mr_n52894512)
print v(xbgr.mr_n52895808)
print v(xbgr.mr_n52896352)
print v(xbgr.mr_n52896672)
print v(xbgr.mr_n52897216)
print v(xbgr.mr_n52897536)
print v(xbgr.mr_n52897648)
print v(xbgr.mr_n52898400)
print v(xbgr.mr_n52898832)
print v(xbgr.mr_n52899696)
print v(xbgr.mr_n52900560)
print v(xbgr.mr_n52901856)
print v(xbgr.mr_n52902720)
print v(xbgr.mr_n52903152)
print v(xbgr.mr_n52903264)
print v(xbgr.mr_n52904016)
print v(xbgr.mr_n52904128)
print v(xbgr.mr_n52904448)
print v(xbgr.mr_n52904560)
print v(xbgr.mr_n52904880)
print v(xbgr.mr_n52904992)
print v(xbgr.mr_n52905744)
print v(xbgr.mr_n52907040)
print v(xbgr.mr_n52907904)
print v(xbgr.mr_n52908768)
print v(xbgr.mr_n52909200)
print v(xbgr.mr_n52909312)
print v(xbgr.mr_n52909632)
print v(xbgr.mr_n52909744)
print v(xbgr.mr_n52910064)
print v(xbgr.mr_n52910176)
print v(xbgr.mr_n52910496)
print v(xbgr.mr_n52910608)
print v(xbgr.mr_n52911360)
print v(xbgr.mr_n52911472)
print v(xbgr.mr_n52911792)
print v(xbgr.mr_n52911904)
print v(xbgr.mr_n52912224)
print v(xbgr.mr_n52912336)
print v(xbgr.mr_n52912656)
print v(xbgr.mr_n52913520)
print v(xbgr.mr_n52913632)
print v(xbgr.mr_n52913952)
print v(xbgr.mr_n52914064)
print v(xbgr.mr_n52914496)
print v(xbgr.mr_n52914816)
print v(xbgr.mr_n52914928)
print v(xbgr.mr_n52915248)
print v(xbgr.mr_n52915360)
print v(xbgr.mr_n52915680)
print v(xbgr.mr_n52915792)
print v(xbgr.mr_n52916224)
print v(xbgr.mr_n52916656)
print v(xbgr.mr_n52916976)
print v(xbgr.mr_n52917088)
print v(xbgr.mr_n52917408)
print v(xbgr.mr_n52917520)
print v(xbgr.mr_n52917840)
print v(xbgr.mr_n52917952)
print v(xbgr.mr_n52918384)
print v(xbgr.mr_n52918704)
print v(xbgr.mr_n52918816)
print v(xbgr.mr_n52919248)
print v(xbgr.mr_n52919568)
print v(xbgr.mr_n52919680)
print v(xbgr.mr_n52920000)
print v(xbgr.mr_n52920112)
print v(xbgr.mr_n52920432)
print v(xbgr.mr_n52920544)
print v(xbgr.mr_n52920864)
print v(xbgr.mr_n52920976)
print v(xbgr.mr_n52921296)
print v(xbgr.mr_n52922160)
print v(xbgr.mr_n52923024)
print v(xbgr.mr_n52923136)
print v(xbgr.mr_n52923456)
print v(xbgr.mr_n52924000)
print v(xbgr.mr_n52924320)
print v(xbgr.mr_n52924752)
print v(xbgr.mr_n52926048)
print v(xbgr.mr_n52927344)
print v(xbgr.mr_n52927456)
print v(xbgr.mr_n52927776)
print v(xbgr.mr_n52927888)
print v(xbgr.mr_n52928208)
print v(xbgr.mr_n52928320)
print v(xbgr.mr_n52928640)
print v(xbgr.mr_n52928752)
print v(xbgr.mr_n52929072)
print v(xbgr.mr_n52929184)
print v(xbgr.mr_n52929504)
print v(xbgr.mr_n52929616)
print v(xbgr.mr_n52929936)
print v(xbgr.mr_n52930048)
print v(xbgr.mr_n52930480)
print v(xbgr.mr_n52930800)
print v(xbgr.mr_n52931664)
print v(xbgr.mr_n52931776)
print v(xbgr.mr_n52932096)
print v(xbgr.mr_n52932208)
print v(xbgr.mr_n52932528)
print v(xbgr.mr_n52932640)
print v(xbgr.mr_n52932960)
print v(xbgr.mr_n52933072)
print v(xbgr.mr_n52933392)
print v(xbgr.mr_n52934256)
print v(xbgr.mr_n52935120)
print v(xbgr.mr_n52935984)
print v(xbgr.mr_n52936848)
print v(xbgr.mr_n52937712)
print v(xbgr.mr_n52937824)
print v(xbgr.mr_n52938144)
print v(xbgr.mr_n52938256)
print v(xbgr.mr_n52938576)
print v(xbgr.mr_n52938688)
print v(xbgr.mr_n52939008)
print v(xbgr.mr_n52939120)
print v(xbgr.mr_n52939440)
print v(xbgr.mr_n52939552)
print v(xbgr.mr_n52939872)
print v(xbgr.mr_n52939984)
print v(xbgr.mr_n52940304)
print v(xbgr.mr_n52940416)
print v(xbgr.mr_n52940736)
print v(xbgr.mr_n52940848)
print v(xbgr.mr_n52941168)
print v(xbgr.mr_n52941280)
print v(xbgr.mr_n52941600)
print v(xbgr.mr_n52941712)
print v(xbgr.mr_n52942144)
print v(xbgr.mr_n52942464)
print v(xbgr.mr_n52942576)
print v(xbgr.mr_n52942896)
print v(xbgr.mr_n52943008)
print v(xbgr.mr_n52943440)
print v(xbgr.mr_n52943760)
print v(xbgr.mr_n52943872)
print v(xbgr.mr_n52944304)
print v(xbgr.mr_n52944624)
print v(xbgr.mr_n52944736)
print v(xbgr.mr_n52945168)
print v(xbgr.mr_n52945600)
print v(xbgr.mr_n52945920)
print v(xbgr.mr_n52946032)
print v(xbgr.mr_n52946464)
print v(xbgr.mr_n52946784)
print v(xbgr.mr_n52946896)
print v(xbgr.mr_n52947216)
print v(xbgr.mr_n52947328)
print v(xbgr.mr_n52947648)
print v(xbgr.mr_n52947760)
print v(xbgr.mr_n52948080)
print v(xbgr.mr_n52948192)
print v(xbgr.mr_n52948512)
print v(xbgr.mr_n52948624)
print v(xbgr.mr_n52948944)
print v(xbgr.mr_n52949056)
print v(xbgr.mr_n52949376)
print v(xbgr.mr_n52949488)
print v(xbgr.mr_n52949808)
print v(xbgr.mr_n52949920)
print v(xbgr.mr_n52950240)
print v(xbgr.mr_n52951104)
print v(xbgr.mr_n52951216)
print v(xbgr.mr_n52951536)
print v(xbgr.mr_n52951648)
print v(xbgr.mr_n52951968)
print v(xbgr.mr_n52952832)
print v(xbgr.mr_n52953696)
print v(xbgr.mr_n52954560)
print v(xbgr.mr_n52955424)
print v(xbgr.mr_n52956288)
print v(xbgr.mr_n52956400)
print v(xbgr.mr_n52956720)
print v(xbgr.mr_n52956832)
print v(xbgr.mr_n52957152)
print v(xbgr.mr_n52957264)
print v(xbgr.mr_n52957584)
print v(xbgr.mr_n52958448)
print v(xbgr.mr_n52959312)
print v(xbgr.mr_n52960176)
print v(xbgr.mr_n52961040)
print v(xbgr.mr_n52961904)
print v(xbgr.mr_n52962768)
print v(xbgr.mr_n52963632)
print v(xbgr.mr_n52963744)
print v(xbgr.mr_n52964064)
print v(xbgr.mr_n52964176)
print v(xbgr.mr_n52964608)
print v(xbgr.mr_n52964928)
print v(xbgr.mr_n52965792)
print v(xbgr.mr_n52966336)
print v(xbgr.mr_n52966768)
print v(xbgr.mr_n52967200)
print v(xbgr.mr_n52967952)
print v(xbgr.mr_n52968816)
print v(xbgr.mr_n52969680)
print v(xbgr.mr_n52969792)
print v(xbgr.mr_n52970112)
print v(xbgr.mr_n52970224)
print v(xbgr.mr_n52970656)
print v(xbgr.mr_n52971088)
print v(xbgr.mr_n52971408)
print v(xbgr.mr_n52972272)
print v(xbgr.mr_n52972384)
print v(xbgr.mr_n52972816)
print v(xbgr.mr_n52973136)
print v(xbgr.mr_n52973248)
print v(xbgr.mr_n52973680)
print v(xbgr.mr_n52974000)
print v(xbgr.mr_n52974864)
print v(xbgr.mr_n52974976)
print v(xbgr.mr_n52975296)
print v(xbgr.mr_n52976160)
print v(xbgr.mr_n52977024)
print v(xbgr.mr_n52977136)
print v(xbgr.mr_n52977456)
print v(xbgr.mr_n52977568)
print v(xbgr.mr_n52977888)
print v(xbgr.mr_n52978752)
print v(xbgr.mr_n52979184)
print v(xbgr.mr_n52979296)
print v(xbgr.mr_n52979728)
print v(xbgr.mr_n52980048)
print v(xbgr.mr_n52980160)
print v(xbgr.mr_n52980592)
print v(xbgr.mr_n52981344)
print v(xbgr.mr_n52981456)
print v(xbgr.mr_n52981776)
print v(xbgr.mr_n52981888)
print v(xbgr.mr_n52982208)
print v(xbgr.mr_n52982320)
print v(xbgr.mr_n52982640)
print v(xbgr.mr_n52983072)
print v(xbgr.mr_n52983184)
print v(xbgr.mr_n52983936)
print v(xbgr.mr_n52984368)
print v(xbgr.mr_n52984480)
print v(xbgr.mr_n52985344)
print v(xbgr.mr_n52985664)
print v(xbgr.mr_n52985776)
print v(xbgr.mr_n52986096)
print v(xbgr.mr_n52986960)
print v(xbgr.mr_n52987824)
print v(xbgr.mr_n52988688)
print v(xbgr.mr_n52989552)
print v(xbgr.mr_n52989664)
print v(xbgr.mr_n52989984)
print v(xbgr.mr_n52990096)
print v(xbgr.mr_n52990416)
print v(xbgr.mr_n52990528)
print v(xbgr.mr_n52990848)
print v(xbgr.mr_n52990960)
print v(xbgr.mr_n52991280)
print v(xbgr.mr_n52991392)
print v(xbgr.mr_n52991712)
print v(xbgr.mr_n52991824)
print v(xbgr.mr_n52992144)
print v(xbgr.mr_n52992256)
print v(xbgr.mr_n52992576)
print v(xbgr.mr_n52992688)
print v(xbgr.mr_n52993008)
print v(xbgr.mr_n52993120)
print v(xbgr.mr_n52993440)
print v(xbgr.mr_n52993552)
print v(xbgr.mr_n52993984)
print v(xbgr.mr_n52994416)
print v(xbgr.mr_n52994848)
print v(xbgr.mr_n52995168)
print v(xbgr.mr_n52995280)
print v(xbgr.mr_n52995600)
print v(xbgr.mr_n52996464)
print v(xbgr.mr_n52996576)
print v(xbgr.mr_n52996896)
print v(xbgr.mr_n52997008)
print v(xbgr.mr_n52997328)
print v(xbgr.mr_n52997440)
print v(xbgr.mr_n52997872)
print v(xbgr.mr_n52998192)
print v(xbgr.mr_n52998304)
print v(xbgr.mr_n52998624)
print v(xbgr.mr_n52998736)
print v(xbgr.mr_n52999168)
print v(xbgr.mr_n52999488)
print v(xbgr.mr_n52999920)
print v(xbgr.mr_n53000032)
print v(xbgr.mr_n53000352)
print v(xbgr.mr_n53000464)
print v(xbgr.mr_n53000784)
print v(xbgr.mr_n53000896)
print v(xbgr.mr_n53001216)
print v(xbgr.mr_n53001328)
print v(xbgr.mr_n53001760)
print v(xbgr.mr_n53002080)
print v(xbgr.mr_n53002192)
print v(xbgr.mr_n53002512)
print v(xbgr.mr_n53002624)
print v(xbgr.mr_n53002944)
print v(xbgr.mr_n53003056)
print v(xbgr.mr_n53003376)
print v(xbgr.mr_n53003488)
print v(xbgr.mr_n53003808)
print v(xbgr.mr_n53003920)
print v(xbgr.mr_n53004240)
print v(xbgr.mr_n53004352)
print v(xbgr.mr_n53004672)
print v(xbgr.mr_n53004784)
print v(xbgr.mr_n53005536)
print v(xbgr.mr_n53005968)
print v(xbgr.mr_n53006832)
print v(xbgr.mr_n53006944)
print v(xbgr.mr_n53007264)
print v(xbgr.mr_n53007808)
print v(xbgr.mr_n53008240)
print v(xbgr.mr_n53008672)
print v(xbgr.mr_n53008992)
print v(xbgr.mr_n53009424)
print v(xbgr.mr_n53010288)
print v(xbgr.mr_n53012448)
print v(xbgr.mr_n53013312)
print v(xbgr.mr_n53013424)
print v(xbgr.mr_n53013744)
print v(xbgr.mr_n53014608)
print v(xbgr.mr_n53015472)
print v(xbgr.mr_n53015584)
print v(xbgr.mr_n53015904)
print v(xbgr.mr_n53016016)
print v(xbgr.mr_n53016336)
print v(xbgr.mr_n53016448)
print v(xbgr.mr_n53016768)
print v(xbgr.mr_n53016880)
print v(xbgr.mr_n53017200)
print v(xbgr.mr_n53018064)
print v(xbgr.mr_n53018928)
print v(xbgr.mr_n53019040)
print v(xbgr.mr_n53019360)
print v(xbgr.mr_n53019472)
print v(xbgr.mr_n53019792)
print v(xbgr.mr_n53019904)
print v(xbgr.mr_n53020224)
print v(xbgr.mr_n53020336)
print v(xbgr.mr_n53020656)
print v(xbgr.mr_n53020768)
print v(xbgr.mr_n53021088)
print v(xbgr.mr_n53021200)
print v(xbgr.mr_n53021520)
print v(xbgr.mr_n53021632)
print v(xbgr.mr_n53022064)
print v(xbgr.mr_n53022384)
print v(xbgr.mr_n53022496)
print v(xbgr.mr_n53022928)
print v(xbgr.mr_n53023248)
print v(xbgr.mr_n53023792)
print v(xbgr.mr_n53024656)
print v(xbgr.mr_n53024976)
print v(xbgr.mr_n53025088)
print v(xbgr.mr_n53026272)
print v(xbgr.mr_n53026384)
print v(xbgr.mr_n53026704)
print v(xbgr.mr_n53026816)
print v(xbgr.mr_n53027136)
print v(xbgr.mr_n53027248)
print v(xbgr.mr_n53027568)
print v(xbgr.mr_n53027680)
print v(xbgr.mr_n53028000)
print v(xbgr.mr_n53028864)
print v(xbgr.mr_n53029728)
print v(xbgr.mr_n53029840)
print v(xbgr.mr_n53030272)
print v(xbgr.mr_n53030704)
print v(xbgr.mr_n53031136)
print v(xbgr.mr_n53031456)
print v(xbgr.mr_n53031568)
print v(xbgr.mr_n53031888)
print v(xbgr.mr_n53032000)
print v(xbgr.mr_n53032320)
print v(xbgr.mr_n53032432)
print v(xbgr.mr_n53032752)
print v(xbgr.mr_n53032864)
print v(xbgr.mr_n53033184)
print v(xbgr.mr_n53033296)
print v(xbgr.mr_n53033616)
print v(xbgr.mr_n53033728)
print v(xbgr.mr_n53034048)
print v(xbgr.mr_n53034912)
print v(xbgr.mr_n53035024)
print v(xbgr.mr_n53035344)
print v(xbgr.mr_n53035456)
print v(xbgr.mr_n53035776)
print v(xbgr.mr_n53035888)
print v(xbgr.mr_n53036208)
print v(xbgr.mr_n53036320)
print v(xbgr.mr_n53036640)
print v(xbgr.mr_n53037184)
print v(xbgr.mr_n53037936)
print v(xbgr.mr_n53038800)
print v(xbgr.mr_n53039664)
print v(xbgr.mr_n53040528)
print v(xbgr.mr_n53041392)
print v(xbgr.mr_n53042256)
print v(xbgr.mr_n53042368)
print v(xbgr.mr_n53042688)
print v(xbgr.mr_n53042800)
print v(xbgr.mr_n53043120)
print v(xbgr.mr_n53043232)
print v(xbgr.mr_n53043552)
print v(xbgr.mr_n53043664)
print v(xbgr.mr_n53043984)
print v(xbgr.mr_n53044096)
print v(xbgr.mr_n53044416)
print v(xbgr.mr_n53044528)
print v(xbgr.mr_n53044848)
print v(xbgr.mr_n53045712)
print v(xbgr.mr_n53046576)
print v(xbgr.mr_n53047440)
print v(xbgr.mr_n53048304)
print v(xbgr.mr_n53049168)
print v(xbgr.mr_n53050032)
print v(xbgr.mr_n53050896)
print v(xbgr.mr_n53051008)
print v(xbgr.mr_n53051328)
print v(xbgr.mr_n53051440)
print v(xbgr.mr_n53051760)
print v(xbgr.mr_n53051872)
print v(xbgr.mr_n53052192)
print v(xbgr.mr_n53052304)
print v(xbgr.mr_n53052624)
print v(xbgr.mr_n53052736)
print v(xbgr.mr_n53053056)
print v(xbgr.mr_n53053168)
print v(xbgr.mr_n53053488)
print v(xbgr.mr_n53053600)
print v(xbgr.mr_n53054032)
print v(xbgr.mr_n53054352)
print v(xbgr.mr_n53054464)
print v(xbgr.mr_n53054896)
print v(xbgr.mr_n53055216)
print v(xbgr.mr_n53055328)
print v(xbgr.mr_n53055760)
print v(xbgr.mr_n53056080)
print v(xbgr.mr_n53056944)
print v(xbgr.mr_n53057808)
print v(xbgr.mr_n53058672)
print v(xbgr.mr_n53059536)
print v(xbgr.mr_n53060400)
print v(xbgr.mr_n53061264)
print v(xbgr.mr_n53061376)
print v(xbgr.mr_n53061696)
print v(xbgr.mr_n53061808)
print v(xbgr.mr_n53062128)
print v(xbgr.mr_n53062240)
print v(xbgr.mr_n53062560)
print v(xbgr.mr_n53062672)
print v(xbgr.mr_n53062992)
print v(xbgr.mr_n53063856)
print v(xbgr.mr_n53064720)
print v(xbgr.mr_n53065584)
print v(xbgr.mr_n53065696)
print v(xbgr.mr_n53066128)
print v(xbgr.mr_n53066448)
print v(xbgr.mr_n53066560)
print v(xbgr.mr_n53066880)
print v(xbgr.mr_n53066992)
print v(xbgr.mr_n53067312)
print v(xbgr.mr_n53067424)
print v(xbgr.mr_n53067744)
print v(xbgr.mr_n53067856)
print v(xbgr.mr_n53068176)
print v(xbgr.mr_n53068288)
print v(xbgr.mr_n53068720)
print v(xbgr.mr_n53069040)
print v(xbgr.mr_n53069152)
print v(xbgr.mr_n53069584)
print v(xbgr.mr_n53069904)
print v(xbgr.mr_n53070016)
print v(xbgr.mr_n53070336)
print v(xbgr.mr_n53070448)
print v(xbgr.mr_n53070880)
print v(xbgr.mr_n53071312)
print v(xbgr.mr_n53071632)
print v(xbgr.mr_n53071744)
print v(xbgr.mr_n53072176)
print v(xbgr.mr_n53072496)
print v(xbgr.mr_n53072608)
print v(xbgr.mr_n53073040)
print v(xbgr.mr_n53073360)
print v(xbgr.mr_n53074224)
print v(xbgr.mr_n53075088)
print v(xbgr.mr_n53075952)
print v(xbgr.mr_n53076816)
print v(xbgr.mr_n53076928)
print v(xbgr.mr_n53077248)
print v(xbgr.mr_n53077360)
print v(xbgr.mr_n53077680)
print v(xbgr.mr_n53077792)
print v(xbgr.mr_n53078112)
print v(xbgr.mr_n53078224)
print v(xbgr.mr_n53078544)
print v(xbgr.mr_n53079408)
print v(xbgr.mr_n53080272)
print v(xbgr.mr_n53081136)
print v(xbgr.mr_n53082000)
print v(xbgr.mr_n53082864)
print v(xbgr.mr_n53083728)
print v(xbgr.mr_n53084592)
print v(xbgr.mr_n53085456)
print v(xbgr.mr_n53085568)
print v(xbgr.mr_n53085888)
print v(xbgr.mr_n53086000)
print v(xbgr.mr_n53086320)
print v(xbgr.mr_n53086432)
print v(xbgr.mr_n53086752)
print v(xbgr.mr_n53086864)
print v(xbgr.mr_n53087184)
print v(xbgr.mr_n53087296)
print v(xbgr.mr_n53087616)
print v(xbgr.mr_n53087728)
print v(xbgr.mr_n53088048)
print v(xbgr.mr_n53088160)
print v(xbgr.mr_n53088480)
print v(xbgr.mr_n53088592)
print v(xbgr.mr_n53088912)
print v(xbgr.mr_n53089024)
print v(xbgr.mr_n53089344)
print v(xbgr.mr_n53089456)
print v(xbgr.mr_n53089888)
print v(xbgr.mr_n53090208)
print v(xbgr.mr_n53090320)
print v(xbgr.mr_n53090640)
print v(xbgr.mr_n53090752)
print v(xbgr.mr_n53091072)
print v(xbgr.mr_n53091184)
print v(xbgr.mr_n53091504)
print v(xbgr.mr_n53091616)
print v(xbgr.mr_n53091936)
print v(xbgr.mr_n53092048)
print v(xbgr.mr_n53092480)
print v(xbgr.mr_n53092800)
print v(xbgr.mr_n53092912)
print v(xbgr.mr_n53093344)
print v(xbgr.mr_n53093664)
print v(xbgr.mr_n53093776)
print v(xbgr.mr_n53094096)
print v(xbgr.mr_n53094960)
print v(xbgr.mr_n53095824)
print v(xbgr.mr_n53096368)
print v(xbgr.mr_n53097120)
print v(xbgr.mr_n53097552)
print v(xbgr.mr_n53097664)
print v(xbgr.mr_n53098416)
print v(xbgr.mr_n53098528)
print v(xbgr.mr_n53098960)
print v(xbgr.mr_n53099392)
print v(xbgr.mr_n53099712)
print v(xbgr.mr_n53100576)
print v(xbgr.mr_n53101008)
print v(xbgr.mr_n53101872)
print v(xbgr.mr_n53101984)
print v(xbgr.mr_n53102736)
print v(xbgr.mr_n53104032)
print v(xbgr.mr_n53104896)
print v(xbgr.mr_n53105008)
print v(xbgr.mr_n53105328)
print v(xbgr.mr_n53105440)
print v(xbgr.mr_n53105760)
print v(xbgr.mr_n53105872)
print v(xbgr.mr_n53106192)
print v(xbgr.mr_n53106304)
print v(xbgr.mr_n53106624)
print v(xbgr.mr_n53107488)
print v(xbgr.mr_n53108352)
print v(xbgr.mr_n53109216)
print v(xbgr.mr_n53109328)
print v(xbgr.mr_n53109648)
print v(xbgr.mr_n53109760)
print v(xbgr.mr_n53110080)
print v(xbgr.mr_n53110944)
print v(xbgr.mr_n53111056)
print v(xbgr.mr_n53111376)
print v(xbgr.mr_n53111488)
print v(xbgr.mr_n53111808)
print v(xbgr.mr_n53111920)
print v(xbgr.mr_n53112240)
print v(xbgr.mr_n53112352)
print v(xbgr.mr_n53112672)
print v(xbgr.mr_n53113536)
print v(xbgr.mr_n53114400)
print v(xbgr.mr_n53114512)
print v(xbgr.mr_n53114832)
print v(xbgr.mr_n53114944)
print v(xbgr.mr_n53115264)
print v(xbgr.mr_n53115376)
print v(xbgr.mr_n53115696)
print v(xbgr.mr_n53115808)
print v(xbgr.mr_n53116128)
print v(xbgr.mr_n53116240)
print v(xbgr.mr_n53116560)
print v(xbgr.mr_n53116672)
print v(xbgr.mr_n53117424)
print v(xbgr.mr_n53118288)
print v(xbgr.mr_n53119152)
print v(xbgr.mr_n53119264)
print v(xbgr.mr_n53119584)
print v(xbgr.mr_n53119696)
print v(xbgr.mr_n53120016)
print v(xbgr.mr_n53120128)
print v(xbgr.mr_n53120448)
print v(xbgr.mr_n53120560)
print v(xbgr.mr_n53120992)
print v(xbgr.mr_n53121312)
print v(xbgr.mr_n53121424)
print v(xbgr.mr_n53122176)
print v(xbgr.mr_n53123040)
print v(xbgr.mr_n53123904)
print v(xbgr.mr_n53124768)
print v(xbgr.mr_n53124880)
print v(xbgr.mr_n53125200)
print v(xbgr.mr_n53125312)
print v(xbgr.mr_n53125632)
print v(xbgr.mr_n53125744)
print v(xbgr.mr_n53126064)
print v(xbgr.mr_n53126176)
print v(xbgr.mr_n53126496)
print v(xbgr.mr_n53127360)
print v(xbgr.mr_n53128656)
print v(xbgr.mr_n53128768)
print v(xbgr.mr_n53129088)
print v(xbgr.mr_n53129200)
print v(xbgr.mr_n53129632)
print v(xbgr.mr_n53129952)
print v(xbgr.mr_n53130064)
print v(xbgr.mr_n53130496)
print v(xbgr.mr_n53130816)
print v(xbgr.mr_n53131248)
print v(xbgr.mr_n53132112)
print v(xbgr.mr_n53132976)
print v(xbgr.mr_n53133088)
print v(xbgr.mr_n53133408)
print v(xbgr.mr_n53133520)
print v(xbgr.mr_n53133952)
print v(xbgr.mr_n53134272)
print v(xbgr.mr_n53134384)
print v(xbgr.mr_n53134704)
print v(xbgr.mr_n53134816)
print v(xbgr.mr_n53135136)
print v(xbgr.mr_n53135248)
print v(xbgr.mr_n53135568)
print v(xbgr.mr_n53135680)
print v(xbgr.mr_n53136112)
print v(xbgr.mr_n53136544)
print v(xbgr.mr_n53136976)
print v(xbgr.mr_n53137408)
print v(xbgr.mr_n53137728)
print v(xbgr.mr_n53137840)
print v(xbgr.mr_n53138272)
print v(xbgr.mr_n53138592)
print v(xbgr.mr_n53139456)
print v(xbgr.mr_n53140320)
print v(xbgr.mr_n53140752)
print v(xbgr.mr_n53141616)
print v(xbgr.mr_n53142048)
print v(xbgr.mr_n53142160)
print v(xbgr.mr_n53142912)
print v(xbgr.mr_n53143776)
print v(xbgr.mr_n53144640)
print v(xbgr.mr_n53144752)
print v(xbgr.mr_n53145184)
print v(xbgr.mr_n53145504)
print v(xbgr.mr_n53146368)
print v(xbgr.mr_n53146480)
print v(xbgr.mr_n53146800)
print v(xbgr.mr_n53146912)
print v(xbgr.mr_n53147232)
print v(xbgr.mr_n53147344)
print v(xbgr.mr_n53147664)
print v(xbgr.mr_n53147776)
print v(xbgr.mr_n53148096)
print v(xbgr.mr_n53148208)
print v(xbgr.mr_n53148528)
print v(xbgr.mr_n53148640)
print v(xbgr.mr_n53148960)
print v(xbgr.mr_n53149072)
print v(xbgr.mr_n53149392)
print v(xbgr.mr_n53149504)
print v(xbgr.mr_n53149824)
print v(xbgr.mr_n53149936)
print v(xbgr.mr_n53150256)
print v(xbgr.mr_n53150368)
print v(xbgr.mr_n53151120)
print v(xbgr.mr_n53152416)
print v(xbgr.mr_n53153280)
print v(xbgr.mr_n53154576)
print v(xbgr.mr_n53154688)
print v(xbgr.mr_n53155008)
print v(xbgr.mr_n53155120)
print v(xbgr.mr_n53155440)
print v(xbgr.mr_n53155552)
print v(xbgr.mr_n53155872)
print v(xbgr.mr_n53155984)
print v(xbgr.mr_n53156736)
print v(xbgr.mr_n53157600)
print v(xbgr.mr_n53158464)
print v(xbgr.mr_n53159328)
print v(xbgr.mr_n53159440)
print v(xbgr.mr_n53159760)
print v(xbgr.mr_n53159872)
print v(xbgr.mr_n53160192)
print v(xbgr.mr_n53160304)
print v(xbgr.mr_n53160624)
print v(xbgr.mr_n53160736)
print v(xbgr.mr_n53161056)
print v(xbgr.mr_n53161168)
print v(xbgr.mr_n53161488)
print v(xbgr.mr_n53162032)
print v(xbgr.mr_n53162784)
print v(xbgr.mr_n53163648)
print v(xbgr.mr_n53163760)
print v(xbgr.mr_n53164080)
print v(xbgr.mr_n53164192)
print v(xbgr.mr_n53164624)
print v(xbgr.mr_n53164944)
print v(xbgr.mr_n53165056)
print v(xbgr.mr_n53165376)
print v(xbgr.mr_n53165488)
print v(xbgr.mr_n53165808)
print v(xbgr.mr_n53165920)
print v(xbgr.mr_n53166240)
print v(xbgr.mr_n53166352)
print v(xbgr.mr_n53166672)
print v(xbgr.mr_n53167104)
print v(xbgr.mr_n53167216)
print v(xbgr.mr_n53167536)
print v(xbgr.mr_n53167648)
print v(xbgr.mr_n53168400)
print v(xbgr.mr_n53168512)
print v(xbgr.mr_n53168832)
print v(xbgr.mr_n53168944)
print v(xbgr.mr_n53169696)
print v(xbgr.mr_n53170560)
print v(xbgr.mr_n53170672)
print v(xbgr.mr_n53170992)
print v(xbgr.mr_n53171856)
print v(xbgr.mr_n53172400)
print v(xbgr.mr_n53172720)
print v(xbgr.mr_n53173264)
print v(xbgr.mr_n53173696)
print v(xbgr.mr_n53174016)
print v(xbgr.mr_n53174128)
print v(xbgr.mr_n53174880)
print v(xbgr.mr_n53174992)
print v(xbgr.mr_n53175312)
print v(xbgr.mr_n53175424)
print v(xbgr.mr_n53175744)
print v(xbgr.mr_n53176608)
print v(xbgr.mr_n53177040)
print v(xbgr.mr_n53177152)
print v(xbgr.mr_n53177472)
print v(xbgr.mr_n53177584)
print v(xbgr.mr_n53177904)
print v(xbgr.mr_n53178016)
print v(xbgr.mr_n53178336)
print v(xbgr.mr_n53178448)
print v(xbgr.mr_n53178768)
print v(xbgr.mr_n53178880)
print v(xbgr.mr_n53180064)
print v(xbgr.mr_n53180176)
print v(xbgr.mr_n53180496)
print v(xbgr.mr_n53180608)
print v(xbgr.mr_n53180928)
print v(xbgr.mr_n53181040)
print v(xbgr.mr_n53181360)
print v(xbgr.mr_n53181792)
print v(xbgr.mr_n53314176)
print v(xbgr.mr_n53314288)
print v(xbgr.mr_n53314608)
print v(xbgr.mr_n53314720)
print v(xbgr.mr_n53315040)
print v(xbgr.mr_n53315152)
print v(xbgr.mr_n53315472)
print v(xbgr.mr_n53315584)
print v(xbgr.mr_n53315904)
print v(xbgr.mr_n53316016)
print v(xbgr.mr_n53316336)
print v(xbgr.mr_n53316448)
print v(xbgr.mr_n53316768)
print v(xbgr.mr_n53316880)
print v(xbgr.mr_n53317200)
print v(xbgr.mr_n53317312)
print v(xbgr.mr_n53317632)
print v(xbgr.mr_n53317744)
print v(xbgr.mr_n53318064)
print v(xbgr.mr_n53318176)
print v(xbgr.mr_n53318496)
print v(xbgr.mr_n53318608)
print v(xbgr.mr_n53318928)
print v(xbgr.mr_n53319040)
print v(xbgr.mr_n53319360)
print v(xbgr.mr_n53319472)
print v(xbgr.mr_n53319792)
print v(xbgr.mr_n53319904)
print v(xbgr.mr_n53320224)
print v(xbgr.mr_n53320336)
print v(xbgr.mr_n53320656)
print v(xbgr.mr_n53320768)
print v(xbgr.mr_n53321088)
print v(xbgr.mr_n53321200)
print v(xbgr.mr_n53321520)
print v(xbgr.mr_n53321632)
print v(xbgr.mr_n53321952)
print v(xbgr.mr_n53322064)
print v(xbgr.mr_n53322384)
print v(xbgr.mr_n53322496)
print v(xbgr.mr_n53322816)
print v(xbgr.mr_n53322928)
print v(xbgr.mr_n53323248)
print v(xbgr.mr_n53323360)
print v(xbgr.mr_n53323680)
print v(xbgr.mr_n53323792)
print v(xbgr.mr_n53324112)
print v(xbgr.mr_n53324224)
print v(xbgr.mr_n53324544)
print v(xbgr.mr_n53324656)
print v(xbgr.mr_n53324976)
print v(xbgr.mr_n53325088)
print v(xbgr.mr_n53325408)
print v(xbgr.mr_n53325520)
print v(xbgr.mr_n53325840)
print v(xbgr.mr_n53325952)
print v(xbgr.mr_n53326272)
print v(xbgr.mr_n53326384)
print v(xbgr.mr_n53326704)
print v(xbgr.mr_n53326816)
print v(xbgr.mr_n53327136)
print v(xbgr.mr_n53327248)
print v(xbgr.mr_n53327568)
print v(xbgr.mr_n53327680)
print v(xbgr.mr_n53328000)
print v(xbgr.mr_n53328112)
print v(xbgr.mr_n53328432)
print v(xbgr.mr_n53328544)
print v(xbgr.mr_n53328864)
print v(xbgr.mr_n53328976)
print v(xbgr.mr_n53329296)
print v(xbgr.mr_n53329408)
print v(xbgr.mr_n53329728)
print v(xbgr.mr_n53329840)
print v(xbgr.mr_n53330160)
print v(xbgr.mr_n53330272)
print v(xbgr.mr_n53330592)
print v(xbgr.mr_n53330704)
print v(xbgr.mr_n53331024)
print v(xbgr.mr_n53331136)
print v(xbgr.mr_n53331456)
print v(xbgr.mr_n53331568)
print v(xbgr.mr_n53331888)
print v(xbgr.mr_n53332000)
print v(xbgr.mr_n53332320)
print v(xbgr.mr_n53332432)
print v(xbgr.mr_n53332752)
print v(xbgr.mr_n53332864)
print v(xbgr.mr_n53333184)
print v(xbgr.mr_n53333296)
print v(xbgr.mr_n53333616)
print v(xbgr.mr_n53333728)
print v(xbgr.mr_n53334048)
print v(xbgr.mr_n53334160)
print v(xbgr.mr_n53334480)
print v(xbgr.mr_n53334592)
print v(xbgr.mr_n53334912)
print v(xbgr.mr_n53335024)
print v(xbgr.mr_n53335344)
print v(xbgr.mr_n53335456)
print v(xbgr.mr_n53335776)
print v(xbgr.mr_n53335888)
print v(xbgr.mr_n53336208)
print v(xbgr.mr_n53336320)
print v(xbgr.mr_n53336640)
print v(xbgr.mr_n53336752)
print v(xbgr.mr_n53337072)
print v(xbgr.mr_n53337184)
print v(xbgr.mr_n53337504)
print v(xbgr.mr_n53337616)
print v(xbgr.mr_n53337936)
print v(xbgr.mr_n53338048)
print v(xbgr.mr_n53338368)
print v(xbgr.mr_n53338480)
print v(xbgr.mr_n53338800)
print v(xbgr.mr_n53338912)
print v(xbgr.mr_n53339232)
print v(xbgr.mr_n53339344)
print v(xbgr.mr_n53339664)
print v(xbgr.mr_n53339776)
print v(xbgr.mr_n53340096)
print v(xbgr.mr_n53340208)
print v(xbgr.mr_n53340528)
print v(xbgr.mr_n53340640)
print v(xbgr.mr_n53340960)
print v(xbgr.mr_n53341072)
print v(xbgr.mr_n53341392)
print v(xbgr.mr_n53341504)
print v(xbgr.mr_n53341824)
print v(xbgr.mr_n53341936)
print v(xbgr.mr_n53342256)
print v(xbgr.mr_n53342368)
print v(xbgr.mr_n53342688)
print v(xbgr.mr_n53342800)
print v(xbgr.mr_n53343120)
print v(xbgr.mr_n53343232)
print v(xbgr.mr_n53343552)
print v(xbgr.mr_n53343664)
print v(xbgr.mr_n53343984)
print v(xbgr.mr_n53344096)
print v(xbgr.mr_n53344416)
print v(xbgr.mr_n53344528)
print v(xbgr.mr_n53344848)
print v(xbgr.mr_n53344960)
print v(xbgr.mr_n53345280)
print v(xbgr.mr_n53345392)
print v(xbgr.mr_n53345712)
print v(xbgr.mr_n53345824)
print v(xbgr.mr_n53346144)
print v(xbgr.mr_n53346256)
print v(xbgr.mr_n53346576)
print v(xbgr.mr_n53346688)
print v(xbgr.mr_n53347008)
print v(xbgr.mr_n53347120)
print v(xbgr.mr_n53347440)
print v(xbgr.mr_n53347552)
print v(xbgr.mr_n53347872)
print v(xbgr.mr_n53347984)
print v(xbgr.mr_n53348304)
print v(xbgr.mr_n53348416)
print v(xbgr.mr_n53348736)
print v(xbgr.mr_n53348848)
print v(xbgr.mr_n53349168)
print v(xbgr.mr_n53349280)
print v(xbgr.mr_n53349600)
print v(xbgr.mr_n53349712)
print v(xbgr.mr_n53350032)
print v(xbgr.mr_n53350144)
print v(xbgr.mr_n53350464)
print v(xbgr.mr_n53350576)
print v(xbgr.mr_n53350896)
print v(xbgr.mr_n53351008)
print v(xbgr.mr_n53351328)
print v(xbgr.mr_n53351440)
print v(xbgr.mr_n53351760)
print v(xbgr.mr_n53351872)
print v(xbgr.mr_n53352192)
print v(xbgr.mr_n53352304)
print v(xbgr.mr_n53352624)
print v(xbgr.mr_n53352736)
print v(xbgr.mr_n53353056)
print v(xbgr.mr_n53353168)
print v(xbgr.mr_n53353488)
print v(xbgr.mr_n53353600)
print v(xbgr.mr_n53353920)
print v(xbgr.mr_n53354032)
print v(xbgr.mr_n53354352)
print v(xbgr.mr_n53354464)
print v(xbgr.mr_n53354784)
print v(xbgr.mr_n53354896)
print v(xbgr.mr_n53355216)
print v(xbgr.mr_n53355328)
print v(xbgr.mr_n53355648)
print v(xbgr.mr_n53355760)
print v(xbgr.mr_n53356080)
print v(xbgr.mr_n53356192)
print v(xbgr.mr_n53356512)
print v(xbgr.mr_n53356624)
print v(xbgr.mr_n53356944)
print v(xbgr.mr_n53357056)
print v(xbgr.mr_n53357376)
print v(xbgr.mr_n53357488)
print v(xbgr.mr_n53357808)
print v(xbgr.mr_n53357920)
print v(xbgr.mr_n53358240)
print v(xbgr.mr_n53358352)
print v(xbgr.mr_n53358672)
print v(xbgr.mr_n53358784)
print v(xbgr.mr_n53359104)
print v(xbgr.mr_n53359216)
print v(xbgr.mr_n53359536)
print v(xbgr.mr_n53359648)
print v(xbgr.mr_n53359968)
print v(xbgr.mr_n53360080)
print v(xbgr.mr_n53360400)
print v(xbgr.mr_n53360512)
print v(xbgr.mr_n53360832)
print v(xbgr.mr_n53360944)
print v(xbgr.mr_n53361264)
print v(xbgr.mr_n53361376)
print v(xbgr.mr_n53361696)
print v(xbgr.mr_n53361808)
print v(xbgr.mr_n53362128)
print v(xbgr.mr_n53362240)
print v(xbgr.mr_n53362560)
print v(xbgr.mr_n53362672)
print v(xbgr.mr_n53362992)
print v(xbgr.mr_n53363104)
print v(xbgr.mr_n53363424)
print v(xbgr.mr_n53363536)
print v(xbgr.mr_n53363856)
print v(xbgr.mr_n53363968)
print v(xbgr.mr_n53364288)
print v(xbgr.mr_n53364400)
print v(xbgr.mr_n53364720)
print v(xbgr.mr_n53364832)
print v(xbgr.mr_n53365152)
print v(xbgr.mr_n53365264)
print v(xbgr.mr_n53365584)
print v(xbgr.mr_n53365696)
print v(xbgr.mr_n53366016)
print v(xbgr.mr_n53366128)
print v(xbgr.mr_n53366448)
print v(xbgr.mr_n53366560)
print v(xbgr.mr_n53366880)
print v(xbgr.mr_n53366992)
print v(xbgr.mr_n53367312)
print v(xbgr.mr_n53367424)
print v(xbgr.mr_n53367744)
print v(xbgr.mr_n53367856)
print v(xbgr.mr_n53368176)
print v(xbgr.mr_n53368288)
print v(xbgr.mr_n53368608)
print v(xbgr.mr_n53368720)
print v(xbgr.mr_n53369040)
print v(xbgr.mr_n53369152)
print v(xbgr.mr_n53369472)
print v(xbgr.mr_n53369584)
print v(xbgr.mr_n53369904)
print v(xbgr.mr_n53370016)
print v(xbgr.mr_n53370336)
print v(xbgr.mr_n53370448)
print v(xbgr.mr_n53370768)
print v(xbgr.mr_n53370880)
print v(xbgr.mr_n53371200)
print v(xbgr.mr_n53371312)
print v(xbgr.mr_n53371632)
print v(xbgr.mr_n53371744)
print v(xbgr.mr_n53372064)
print v(xbgr.mr_n53372176)
print v(xbgr.mr_n53372496)
print v(xbgr.mr_n53372608)
print v(xbgr.mr_n53372928)
print v(xbgr.mr_n53373040)
print v(xbgr.mr_n53373360)
print v(xbgr.mr_n53373472)
print v(xbgr.mr_n53373792)
print v(xbgr.mr_n53373904)
print v(xbgr.mr_n53374224)
print v(xbgr.mr_n53374336)
print v(xbgr.mr_n53374656)
print v(xbgr.mr_n53374768)
print v(xbgr.mr_n53375088)
print v(xbgr.mr_n53375200)
print v(xbgr.mr_n53375520)
print v(xbgr.mr_n53375632)
print v(xbgr.mr_n53375952)
print v(xbgr.mr_n53376064)
print v(xbgr.mr_n53376384)
print v(xbgr.mr_n53376496)
print v(xbgr.mr_n53376816)
print v(xbgr.mr_n53376928)
print v(xbgr.mr_n53377248)
print v(xbgr.mr_n53377360)
print v(xbgr.mr_n53377680)
print v(xbgr.mr_n53377792)
print v(xbgr.mr_n53378112)
print v(xbgr.mr_n53378224)
print v(xbgr.mr_n53378544)
print v(xbgr.mr_n53378656)
print v(xbgr.mr_n53378976)
print v(xbgr.mr_n53379088)
print v(xbgr.mr_n53379408)
print v(xbgr.mr_n53379520)
print v(xbgr.mr_n53379840)
print v(xbgr.mr_n53379952)
print v(xbgr.mr_n53380272)
print v(xbgr.mr_n53380384)
print v(xbgr.mr_n53380704)
print v(xbgr.mr_n53380816)
print v(xbgr.mr_n53381136)
print v(xbgr.mr_n53381248)
print v(xbgr.mr_n53381568)
print v(xbgr.mr_n53381680)
print v(xbgr.mr_n53382000)
print v(xbgr.mr_n53382112)
print v(xbgr.mr_n53382432)
print v(xbgr.mr_n53382544)
print v(xbgr.mr_n53382864)
print v(xbgr.mr_n53382976)
print v(xbgr.mr_n53383296)
print v(xbgr.mr_n53383408)
print v(xbgr.mr_n53383728)
print v(xbgr.mr_n53383840)
print v(xbgr.mr_n53384160)
print v(xbgr.mr_n53384272)
print v(xbgr.mr_n53384592)
print v(xbgr.mr_n53384704)
print v(xbgr.mr_n53385024)
print v(xbgr.mr_n53385136)
print v(xbgr.mr_n53385456)
print v(xbgr.mr_n53385568)
print v(xbgr.mr_n53385888)
print v(xbgr.mr_n53386000)
print v(xbgr.mr_n53386320)
print v(xbgr.mr_n53386432)
print v(xbgr.mr_n53386752)
print v(xbgr.mr_n53386864)
print v(xbgr.mr_n53387184)
print v(xbgr.mr_n53387296)
print v(xbgr.mr_n53387616)
print v(xbgr.mr_n53387728)
print v(xbgr.mr_n53388048)
print v(xbgr.mr_n53388160)
print v(xbgr.mr_n53388480)
print v(xbgr.mr_n53388592)
print v(xbgr.mr_n53388912)
print v(xbgr.mr_n53389024)
print v(xbgr.mr_n53389344)
print v(xbgr.mr_n53389456)
print v(xbgr.mr_n53389776)
print v(xbgr.mr_n53389888)
print v(xbgr.mr_n53390208)
print v(xbgr.mr_n53390320)
print v(xbgr.mr_n53390640)
print v(xbgr.mr_n53390752)
print v(xbgr.mr_n53391072)
print v(xbgr.mr_n53391184)
print v(xbgr.mr_n53391504)
print v(xbgr.mr_n53391616)
print v(xbgr.mr_n53391936)
print v(xbgr.mr_n53392048)
print v(xbgr.mr_n53392368)
print v(xbgr.mr_n53392480)
print v(xbgr.mr_n53392800)
print v(xbgr.mr_n53392912)
print v(xbgr.mr_n53393232)
print v(xbgr.mr_n53393344)
print v(xbgr.mr_n53393664)
print v(xbgr.mr_n53393776)
print v(xbgr.mr_n53394096)
print v(xbgr.mr_n53394208)
print v(xbgr.mr_n53394528)
print v(xbgr.mr_n53394640)
print v(xbgr.mr_n53394960)
print v(xbgr.mr_n53395072)
print v(xbgr.mr_n53395392)
print v(xbgr.mr_n53395504)
print v(xbgr.mr_n53395824)
print v(xbgr.mr_n53395936)
print v(xbgr.mr_n53396256)
print v(xbgr.mr_n53396368)
print v(xbgr.mr_n53396688)
print v(xbgr.mr_n53396800)
print v(xbgr.mr_n53397104)
print v(xbgr.mr_n53397216)
print v(xbgr.mr_n53397536)
print v(xbgr.mr_n53397648)
print v(xbgr.mr_n53397968)
print v(xbgr.mr_n53398080)
print v(xbgr.mr_n53398400)
print v(xbgr.mr_n53398512)
print v(xbgr.mr_n53398832)
print v(xbgr.mr_n53398944)
print v(xbgr.mr_n53399264)
print v(xbgr.mr_n53399376)
print v(xbgr.mr_n53399696)
print v(xbgr.mr_n53399808)
print v(xbgr.mr_n53400128)
print v(xbgr.mr_n53400240)
print v(xbgr.mr_n53400560)
print v(xbgr.mr_n53400672)
print v(xbgr.mr_n53400992)
print v(xbgr.mr_n53401104)
print v(xbgr.mr_n53401424)
print v(xbgr.mr_n53401536)
print v(xbgr.mr_n53401856)
print v(xbgr.mr_n53401968)
print v(xbgr.mr_n53402288)
print v(xbgr.mr_n53402400)
print v(xbgr.mr_n53402720)
print v(xbgr.mr_n53402832)
print v(xbgr.mr_n53403152)
print v(xbgr.mr_n53403264)
print v(xbgr.mr_n53403584)
print v(xbgr.mr_n53403696)
print v(xbgr.mr_n53404016)
print v(xbgr.mr_n53404128)
print v(xbgr.mr_n53404448)
print v(xbgr.mr_n53404560)
print v(xbgr.mr_n53404880)
print v(xbgr.mr_n53404992)
print v(xbgr.mr_n53405312)
print v(xbgr.mr_n53405424)
print v(xbgr.mr_n53405744)
print v(xbgr.mr_n53405856)
print v(xbgr.mr_n53406176)
print v(xbgr.mr_n53406288)
print v(xbgr.mr_n53406608)
print v(xbgr.mr_n53406720)
print v(xbgr.mr_n53407040)
print v(xbgr.mr_n53407152)
print v(xbgr.mr_n53407472)
print v(xbgr.mr_n53407584)
print v(xbgr.mr_n53407904)
print v(xbgr.mr_n53408016)
print v(xbgr.mr_n53408336)
print v(xbgr.mr_n53408448)
print v(xbgr.mr_n53408768)
print v(xbgr.mr_n53408880)
print v(xbgr.mr_n53409200)
print v(xbgr.mr_n53409312)
print v(xbgr.mr_n53409632)
print v(xbgr.mr_n53409744)
print v(xbgr.mr_n53410064)
print v(xbgr.mr_n53410176)
print v(xbgr.mr_n53410496)
print v(xbgr.mr_n53410608)
print v(xbgr.mr_n53410928)
print v(xbgr.mr_n53411040)
print v(xbgr.mr_n53411360)
print v(xbgr.mr_n53411472)
print v(xbgr.mr_n53411792)
print v(xbgr.mr_n53411904)
print v(xbgr.mr_n53412224)
print v(xbgr.mr_n53412336)
print v(xbgr.mr_n53412656)
print v(xbgr.mr_n53412768)
print v(xbgr.mr_n53413088)
print v(xbgr.mr_n53413200)
print v(xbgr.mr_n53413520)
print v(xbgr.mr_n53413632)
print v(xbgr.mr_n53413952)
print v(xbgr.mr_n53414064)
print v(xbgr.mr_n53414384)
print v(xbgr.mr_n53414496)
print v(xbgr.mr_n53414816)
print v(xbgr.mr_n53414928)
print v(xbgr.mr_n53415248)
print v(xbgr.mr_n53415360)
print v(xbgr.mr_n53415680)
print v(xbgr.mr_n53415792)
print v(xbgr.mr_n53416112)
print v(xbgr.mr_n53416224)
print v(xbgr.mr_n53416544)
print v(xbgr.mr_n53416656)
print v(xbgr.mr_n53416976)
print v(xbgr.mr_n53417088)
print v(xbgr.mr_n53417408)
print v(xbgr.mr_n53417520)
print v(xbgr.mr_n53417840)
print v(xbgr.mr_n53417952)
print v(xbgr.mr_n53418272)
print v(xbgr.mr_n53418384)
print v(xbgr.mr_n53418704)
print v(xbgr.mr_n53418816)
print v(xbgr.mr_n53419136)
print v(xbgr.mr_n53419248)
print v(xbgr.mr_n53419568)
print v(xbgr.mr_n53419680)
print v(xbgr.mr_n53420000)
print v(xbgr.mr_n53420112)
print v(xbgr.mr_n53420432)
print v(xbgr.mr_n53420544)
print v(xbgr.mr_n53420864)
print v(xbgr.mr_n53420976)
print v(xbgr.mr_n53421296)
print v(xbgr.mr_n53421408)
print v(xbgr.mr_n53421728)
print v(xbgr.mr_n53421840)
print v(xbgr.mr_n53422160)
print v(xbgr.mr_n53422272)
print v(xbgr.mr_n53422592)
print v(xbgr.mr_n53422704)
print v(xbgr.mr_n53423024)
print v(xbgr.mr_n53423136)
print v(xbgr.mr_n53423456)
print v(xbgr.mr_n53423568)
print v(xbgr.mr_n53423888)
print v(xbgr.mr_n53424000)
print v(xbgr.mr_n53424320)
print v(xbgr.mr_n53424432)
print v(xbgr.mr_n53424752)
print v(xbgr.mr_n53424864)
print v(xbgr.mr_n53425184)
print v(xbgr.mr_n53425296)
print v(xbgr.mr_n53425616)
print v(xbgr.mr_n53425728)
print v(xbgr.mr_n53426048)
print v(xbgr.mr_n53426160)
print v(xbgr.mr_n53426480)
print v(xbgr.mr_n53426592)
print v(xbgr.mr_n53426912)
print v(xbgr.mr_n53427024)
print v(xbgr.mr_n53427344)
print v(xbgr.mr_n53427456)
print v(xbgr.mr_n53427776)
print v(xbgr.mr_n53427888)
print v(xbgr.mr_n53428208)
print v(xbgr.mr_n53428320)
print v(xbgr.mr_n53428640)
print v(xbgr.mr_n53428752)
print v(xbgr.mr_n53429072)
print v(xbgr.mr_n53429184)
print v(xbgr.mr_n53429504)
print v(xbgr.mr_n53429616)
print v(xbgr.mr_n53429936)
print v(xbgr.mr_n53430048)
print v(xbgr.mr_n53430368)
print v(xbgr.mr_n53430480)
print v(xbgr.mr_n53430800)
print v(xbgr.mr_n53430912)
print v(xbgr.mr_n53431232)
print v(xbgr.mr_n53431344)
print v(xbgr.mr_n53431664)
print v(xbgr.mr_n53431776)
print v(xbgr.mr_n53432096)
print v(xbgr.mr_n53432208)
print v(xbgr.mr_n53432528)
print v(xbgr.mr_n53432640)
print v(xbgr.mr_n53432960)
print v(xbgr.mr_n53433072)
print v(xbgr.mr_n53433392)
print v(xbgr.mr_n53433504)
print v(xbgr.mr_n53433824)
print v(xbgr.mr_n53433936)
print v(xbgr.mr_n53434256)
print v(xbgr.mr_n53434368)
print v(xbgr.mr_n53434688)
print v(xbgr.mr_n53434800)
print v(xbgr.mr_n53435120)
print v(xbgr.mr_n53435232)
print v(xbgr.mr_n53435552)
print v(xbgr.mr_n53435664)
print v(xbgr.mr_n53435984)
print v(xbgr.mr_n53436096)
print v(xbgr.mr_n53436416)
print v(xbgr.mr_n53436528)
print v(xbgr.mr_n53436848)
print v(xbgr.mr_n53436960)
print v(xbgr.mr_n53437280)
print v(xbgr.mr_n53437392)
print v(xbgr.mr_n53437712)
print v(xbgr.mr_n53437824)
print v(xbgr.mr_n53438144)
print v(xbgr.mr_n53438256)
print v(xbgr.mr_n53438576)
print v(xbgr.mr_n53438688)
print v(xbgr.mr_n53439008)
print v(xbgr.mr_n53439120)
print v(xbgr.mr_n53439440)
print v(xbgr.mr_n53439552)
print v(xbgr.mr_n53439872)
print v(xbgr.mr_n53439984)
print v(xbgr.mr_n53440304)
print v(xbgr.mr_n53440416)
print v(xbgr.mr_n53440736)
print v(xbgr.mr_n53440848)
print v(xbgr.mr_n53441168)
print v(xbgr.mr_n53441280)
print v(xbgr.mr_n53441600)
print v(xbgr.mr_n53441712)
print v(xbgr.mr_n53442032)
print v(xbgr.mr_n53442144)
print v(xbgr.mr_n53442464)
print v(xbgr.mr_n53442576)
print v(xbgr.mr_n53442896)
print v(xbgr.mr_n53443008)
print v(xbgr.mr_n53443328)
print v(xbgr.mr_n53443440)
print v(xbgr.mr_n53443760)
print v(xbgr.mr_n53443872)
print v(xbgr.mr_n53444192)
print v(xbgr.mr_n53444304)
print v(xbgr.mr_n53444624)
print v(xbgr.mr_n53444736)
print v(xbgr.mr_n53445056)
print v(xbgr.mr_n53445264)
print v(xbgr.mr_n53445504)
print v(xbgr.mr_n53446368)
print v(xbgr.mr_n53446480)
print v(xbgr.mr_n53446800)
print v(xbgr.mr_n53446912)
print v(xbgr.mr_n53447232)
print v(xbgr.mr_n53447344)
print v(xbgr.mr_n53447664)
print v(xbgr.mr_n53447776)
print v(xbgr.mr_n53448096)
print v(xbgr.mr_n53448208)
print v(xbgr.mr_n53448528)
print v(xbgr.mr_n53448640)
print v(xbgr.mr_n53448960)
print v(xbgr.mr_n53449824)
print v(xbgr.mr_n53450688)
print v(xbgr.mr_n53451552)
print v(xbgr.mr_n53451664)
print v(xbgr.mr_n53452416)
print v(xbgr.mr_n53452528)
print v(xbgr.mr_n53452848)
print v(xbgr.mr_n53453712)
print v(xbgr.mr_n53454576)
print v(xbgr.mr_n53455440)
print v(xbgr.mr_n53456304)
print v(xbgr.mr_n53456848)
print v(xbgr.mr_n53457600)
print v(xbgr.mr_n53458144)
print v(xbgr.mr_n53458576)
print v(xbgr.mr_n53459328)
print v(xbgr.mr_n53459440)
print v(xbgr.mr_n53459760)
print v(xbgr.mr_n53459872)
print v(xbgr.mr_n53460192)
print v(xbgr.mr_n53461056)
print v(xbgr.mr_n53461920)
print v(xbgr.mr_n53462784)
print v(xbgr.mr_n53462896)
print v(xbgr.mr_n53463216)
print v(xbgr.mr_n53463328)
print v(xbgr.mr_n53463760)
print v(xbgr.mr_n53464080)
print v(xbgr.mr_n53464192)
print v(xbgr.mr_n53464512)
print v(xbgr.mr_n53465376)
print v(xbgr.mr_n53465488)
print v(xbgr.mr_n53465920)
print v(xbgr.mr_n53466240)
print v(xbgr.mr_n53466352)
print v(xbgr.mr_n53466672)
print v(xbgr.mr_n53466784)
print v(xbgr.mr_n53467104)
print v(xbgr.mr_n53467216)
print v(xbgr.mr_n53467536)
print v(xbgr.mr_n53467648)
print v(xbgr.mr_n53467968)
print v(xbgr.mr_n53468944)
print v(xbgr.mr_n53469264)
print v(xbgr.mr_n53469376)
print v(xbgr.mr_n53469696)
print v(xbgr.mr_n53469808)
print v(xbgr.mr_n53470128)
print v(xbgr.mr_n53470240)
print v(xbgr.mr_n53470560)
print v(xbgr.mr_n53470672)
print v(xbgr.mr_n53470992)
print v(xbgr.mr_n53471424)
print v(xbgr.mr_n53472400)
print v(xbgr.mr_n53472720)
print v(xbgr.mr_n53473584)
print v(xbgr.mr_n53474448)
print v(xbgr.mr_n53474560)
print v(xbgr.mr_n53475312)
print v(xbgr.mr_n53476176)
print v(xbgr.mr_n53476288)
print v(xbgr.mr_n53476608)
print v(xbgr.mr_n53477472)
print v(xbgr.mr_n53477584)
print v(xbgr.mr_n53477904)
print v(xbgr.mr_n53478016)
print v(xbgr.mr_n53478336)
print v(xbgr.mr_n53479200)
print v(xbgr.mr_n53479312)
print v(xbgr.mr_n53479632)
print v(xbgr.mr_n53479744)
print v(xbgr.mr_n53480064)
print v(xbgr.mr_n53480176)
print v(xbgr.mr_n53480496)
print v(xbgr.mr_n53480608)
print v(xbgr.mr_n53480928)
print v(xbgr.mr_n53481904)
print v(xbgr.mr_n53482336)
print v(xbgr.mr_n53482656)
print v(xbgr.mr_n53483520)
print v(xbgr.mr_n53484384)
print v(xbgr.mr_n53484496)
print v(xbgr.mr_n53484816)
print v(xbgr.mr_n53484928)
print v(xbgr.mr_n53485248)
print v(xbgr.mr_n53485360)
print v(xbgr.mr_n53485680)
print v(xbgr.mr_n53485792)
print v(xbgr.mr_n53486224)
print v(xbgr.mr_n53486656)
print v(xbgr.mr_n53486976)
print v(xbgr.mr_n53487088)
print v(xbgr.mr_n53487408)
print v(xbgr.mr_n53487520)
print v(xbgr.mr_n53487840)
print v(xbgr.mr_n53487952)
print v(xbgr.mr_n53488272)
print v(xbgr.mr_n53488384)
print v(xbgr.mr_n53488704)
print v(xbgr.mr_n53489568)
print v(xbgr.mr_n53490432)
print v(xbgr.mr_n53490544)
print v(xbgr.mr_n53490864)
print v(xbgr.mr_n53491728)
print v(xbgr.mr_n53492592)
print v(xbgr.mr_n53492704)
print v(xbgr.mr_n53493024)
print v(xbgr.mr_n53493136)
print v(xbgr.mr_n53493568)
print v(xbgr.mr_n53493888)
print v(xbgr.mr_n53494000)
print v(xbgr.mr_n53494432)
print v(xbgr.mr_n53494752)
print v(xbgr.mr_n53495184)
print v(xbgr.mr_n53495296)
print v(xbgr.mr_n53495616)
print v(xbgr.mr_n53495728)
print v(xbgr.mr_n53496048)
print v(xbgr.mr_n53496480)
print v(xbgr.mr_n53496592)
print v(xbgr.mr_n53497344)
print v(xbgr.mr_n53497456)
print v(xbgr.mr_n53497776)
print v(xbgr.mr_n53497888)
print v(xbgr.mr_n53498208)
print v(xbgr.mr_n53498640)
print v(xbgr.mr_n53498752)
print v(xbgr.mr_n53499072)
print v(xbgr.mr_n53499504)
print v(xbgr.mr_n53500368)
print v(xbgr.mr_n53502096)
print v(xbgr.mr_n53502208)
print v(xbgr.mr_n53502528)
print v(xbgr.mr_n53502640)
print v(xbgr.mr_n53502960)
print v(xbgr.mr_n53503072)
print v(xbgr.mr_n53503504)
print v(xbgr.mr_n53503936)
print v(xbgr.mr_n53504256)
print v(xbgr.mr_n53504368)
print v(xbgr.mr_n53504688)
print v(xbgr.mr_n53506096)
print v(xbgr.mr_n53506416)
print v(xbgr.mr_n53507392)
print v(xbgr.mr_n53507712)
print v(xbgr.mr_n53507824)
print v(xbgr.mr_n53508144)
print v(xbgr.mr_n53508256)
print v(xbgr.mr_n53508688)
print v(xbgr.mr_n53509008)
print v(xbgr.mr_n53509120)
print v(xbgr.mr_n53509552)
print v(xbgr.mr_n53509872)
print v(xbgr.mr_n53509984)
print v(xbgr.mr_n53510304)
print v(xbgr.mr_n53510416)
print v(xbgr.mr_n53510736)
print v(xbgr.mr_n53511600)
print v(xbgr.mr_n53512032)
print v(xbgr.mr_n53512896)
print v(xbgr.mr_n53513008)
print v(xbgr.mr_n53513328)
print v(xbgr.mr_n53513440)
print v(xbgr.mr_n53513760)
print v(xbgr.mr_n53513872)
print v(xbgr.mr_n53514624)
print v(xbgr.mr_n53515056)
print v(xbgr.mr_n53515168)
print v(xbgr.mr_n53515488)
print v(xbgr.mr_n53515920)
print v(xbgr.mr_n53516032)
print v(xbgr.mr_n53516352)
print v(xbgr.mr_n53516464)
print v(xbgr.mr_n53516784)
print v(xbgr.mr_n53516896)
print v(xbgr.mr_n53517216)
print v(xbgr.mr_n53517328)
print v(xbgr.mr_n53517648)
print v(xbgr.mr_n53517760)
print v(xbgr.mr_n53518080)
print v(xbgr.mr_n53519488)
print v(xbgr.mr_n53519808)
print v(xbgr.mr_n53519920)
print v(xbgr.mr_n53520352)
print v(xbgr.mr_n53520672)
print v(xbgr.mr_n53520784)
print v(xbgr.mr_n53521104)
print v(xbgr.mr_n53521536)
print v(xbgr.mr_n53522400)
print v(xbgr.mr_n53523264)
print v(xbgr.mr_n53524128)
print v(xbgr.mr_n53524992)
print v(xbgr.mr_n53525856)
print v(xbgr.mr_n53527152)
print v(xbgr.mr_n53527584)
print v(xbgr.mr_n53527696)
print v(xbgr.mr_n53528016)
print v(xbgr.mr_n53528448)
print v(xbgr.mr_n53528560)
print v(xbgr.mr_n53528880)
print v(xbgr.mr_n53529744)
print v(xbgr.mr_n53529856)
print v(xbgr.mr_n53530176)
print v(xbgr.mr_n53530288)
print v(xbgr.mr_n53530608)
print v(xbgr.mr_n53531472)
print v(xbgr.mr_n53531584)
print v(xbgr.mr_n53532448)
print v(xbgr.mr_n53532880)
print v(xbgr.mr_n53533312)
print v(xbgr.mr_n53534064)
print v(xbgr.mr_n53534176)
print v(xbgr.mr_n53534608)
print v(xbgr.mr_n53535360)
print v(xbgr.mr_n53535792)
print v(xbgr.mr_n53535904)
print v(xbgr.mr_n53536336)
print v(xbgr.mr_n53537088)
print v(xbgr.mr_n53537200)
print v(xbgr.mr_n53537520)
print v(xbgr.mr_n53537632)
print v(xbgr.mr_n53537952)
print v(xbgr.mr_n53538064)
print v(xbgr.mr_n53538384)
print v(xbgr.mr_n53538496)
print v(xbgr.mr_n53538816)
print v(xbgr.mr_n53538928)
print v(xbgr.mr_n53539248)
print v(xbgr.mr_n53539360)
print v(xbgr.mr_n53539680)
print v(xbgr.mr_n53539792)
print v(xbgr.mr_n53540112)
print v(xbgr.mr_n53540224)
print v(xbgr.mr_n53540544)
print v(xbgr.mr_n53540656)
print v(xbgr.mr_n53540976)
print v(xbgr.mr_n53541088)
print v(xbgr.mr_n53541408)
print v(xbgr.mr_n53541520)
print v(xbgr.mr_n53541840)
print v(xbgr.mr_n53541952)
print v(xbgr.mr_n53542272)
print v(xbgr.mr_n53542384)
print v(xbgr.mr_n53542704)
print v(xbgr.mr_n53542816)
print v(xbgr.mr_n53543248)
print v(xbgr.mr_n53543568)
print v(xbgr.mr_n53543680)
print v(xbgr.mr_n53544112)
print v(xbgr.mr_n53544432)
print v(xbgr.mr_n53544544)
print v(xbgr.mr_n53545296)
print v(xbgr.mr_n53545728)
print v(xbgr.mr_n53546592)
print v(xbgr.mr_n53547456)
print v(xbgr.mr_n53548320)
print v(xbgr.mr_n53548432)
print v(xbgr.mr_n53548752)
print v(xbgr.mr_n53548864)
print v(xbgr.mr_n53549184)
print v(xbgr.mr_n53549296)
print v(xbgr.mr_n53549616)
print v(xbgr.mr_n53549728)
print v(xbgr.mr_n53550480)
print v(xbgr.mr_n53551344)
print v(xbgr.mr_n53552208)
print v(xbgr.mr_n53553072)
print v(xbgr.mr_n53554368)
print v(xbgr.mr_n53554480)
print v(xbgr.mr_n53554800)
print v(xbgr.mr_n53554912)
print v(xbgr.mr_n53555232)
print v(xbgr.mr_n53555344)
print v(xbgr.mr_n53555776)
print v(xbgr.mr_n53556208)
print v(xbgr.mr_n53556640)
print v(xbgr.mr_n53556960)
print v(xbgr.mr_n53557072)
print v(xbgr.mr_n53557504)
print v(xbgr.mr_n53557824)
print v(xbgr.mr_n53557936)
print v(xbgr.mr_n53558256)
print v(xbgr.mr_n53558368)
print v(xbgr.mr_n53558688)
print v(xbgr.mr_n53558800)
print v(xbgr.mr_n53559120)
print v(xbgr.mr_n53559232)
print v(xbgr.mr_n53559552)
print v(xbgr.mr_n53559664)
print v(xbgr.mr_n53560096)
print v(xbgr.mr_n53560416)
print v(xbgr.mr_n53560528)
print v(xbgr.mr_n53560960)
print v(xbgr.mr_n53561280)
print v(xbgr.mr_n53561712)
print v(xbgr.mr_n53561824)
print v(xbgr.mr_n53562256)
print v(xbgr.mr_n53562576)
print v(xbgr.mr_n53562688)
print v(xbgr.mr_n53563120)
print v(xbgr.mr_n53563440)
print v(xbgr.mr_n53563552)
print v(xbgr.mr_n53563984)
print v(xbgr.mr_n53564304)
print v(xbgr.mr_n53564416)
print v(xbgr.mr_n53564736)
print v(xbgr.mr_n53564848)
print v(xbgr.mr_n53565168)
print v(xbgr.mr_n53566032)
print v(xbgr.mr_n53566896)
print v(xbgr.mr_n53567760)
print v(xbgr.mr_n53568624)
print v(xbgr.mr_n53569488)
print v(xbgr.mr_n53570352)
print v(xbgr.mr_n53570464)
print v(xbgr.mr_n53571216)
print v(xbgr.mr_n53572080)
print v(xbgr.mr_n53572944)
print v(xbgr.mr_n53573808)
print v(xbgr.mr_n53574672)
print v(xbgr.mr_n53575536)
print v(xbgr.mr_n53575648)
print v(xbgr.mr_n53575968)
print v(xbgr.mr_n53576080)
print v(xbgr.mr_n53576400)
print v(xbgr.mr_n53576512)
print v(xbgr.mr_n53576832)
print v(xbgr.mr_n53576944)
print v(xbgr.mr_n53577264)
print v(xbgr.mr_n53578128)
print v(xbgr.mr_n53578992)
print v(xbgr.mr_n53579856)
print v(xbgr.mr_n53579968)
print v(xbgr.mr_n53580288)
print v(xbgr.mr_n53580400)
print v(xbgr.mr_n53580720)
print v(xbgr.mr_n53580832)
print v(xbgr.mr_n53581152)
print v(xbgr.mr_n53582016)
print v(xbgr.mr_n53582880)
print v(xbgr.mr_n53583744)
print v(xbgr.mr_n53583856)
print v(xbgr.mr_n53584176)
print v(xbgr.mr_n53584288)
print v(xbgr.mr_n53584608)
print v(xbgr.mr_n53584720)
print v(xbgr.mr_n53585152)
print v(xbgr.mr_n53585584)
print v(xbgr.mr_n53586016)
print v(xbgr.mr_n53586336)
print v(xbgr.mr_n53586448)
print v(xbgr.mr_n53586768)
print v(xbgr.mr_n53586880)
print v(xbgr.mr_n53587200)
print v(xbgr.mr_n53587312)
print v(xbgr.mr_n53587632)
print v(xbgr.mr_n53587744)
print v(xbgr.mr_n53588064)
print v(xbgr.mr_n53588176)
print v(xbgr.mr_n53588496)
print v(xbgr.mr_n53588608)
print v(xbgr.mr_n53588928)
print v(xbgr.mr_n53589040)
print v(xbgr.mr_n53589360)
print v(xbgr.mr_n53589472)
print v(xbgr.mr_n53589792)
print v(xbgr.mr_n53589904)
print v(xbgr.mr_n53590336)
print v(xbgr.mr_n53590656)
print v(xbgr.mr_n53590768)
print v(xbgr.mr_n53591088)
print v(xbgr.mr_n53591520)
print v(xbgr.mr_n53591632)
print v(xbgr.mr_n53591952)
print v(xbgr.mr_n53592064)
print v(xbgr.mr_n53592384)
print v(xbgr.mr_n53592496)
print v(xbgr.mr_n53592816)
print v(xbgr.mr_n53592928)
print v(xbgr.mr_n53593680)
print v(xbgr.mr_n53593792)
print v(xbgr.mr_n53594544)
print v(xbgr.mr_n53595408)
print v(xbgr.mr_n53595520)
print v(xbgr.mr_n53595840)
print v(xbgr.mr_n53595952)
print v(xbgr.mr_n53596272)
print v(xbgr.mr_n53596384)
print v(xbgr.mr_n53596704)
print v(xbgr.mr_n53596816)
print v(xbgr.mr_n53597248)
print v(xbgr.mr_n53597680)
print v(xbgr.mr_n53598000)
print v(xbgr.mr_n53598112)
print v(xbgr.mr_n53598432)
print v(xbgr.mr_n53598544)
print v(xbgr.mr_n53598864)
print v(xbgr.mr_n53599728)
print v(xbgr.mr_n53601024)
print v(xbgr.mr_n53601888)
print v(xbgr.mr_n53602000)
print v(xbgr.mr_n53602320)
print v(xbgr.mr_n53602432)
print v(xbgr.mr_n53602752)
print v(xbgr.mr_n53602864)
print v(xbgr.mr_n53603184)
print v(xbgr.mr_n53603296)
print v(xbgr.mr_n53603728)
print v(xbgr.mr_n53604048)
print v(xbgr.mr_n53604160)
print v(xbgr.mr_n53604480)
print v(xbgr.mr_n53604592)
print v(xbgr.mr_n53604912)
print v(xbgr.mr_n53605024)
print v(xbgr.mr_n53605456)
print v(xbgr.mr_n53605776)
print v(xbgr.mr_n53605888)
print v(xbgr.mr_n53606208)
print v(xbgr.mr_n53606320)
print v(xbgr.mr_n53606640)
print v(xbgr.mr_n53607504)
print v(xbgr.mr_n53608368)
print v(xbgr.mr_n53609232)
print v(xbgr.mr_n53610096)
print v(xbgr.mr_n53610208)
print v(xbgr.mr_n53610528)
print v(xbgr.mr_n53610640)
print v(xbgr.mr_n53611072)
print v(xbgr.mr_n53611504)
print v(xbgr.mr_n53611824)
print v(xbgr.mr_n53611936)
print v(xbgr.mr_n53612256)
print v(xbgr.mr_n53613120)
print v(xbgr.mr_n53613984)
print v(xbgr.mr_n53614096)
print v(xbgr.mr_n53614416)
print v(xbgr.mr_n53614528)
print v(xbgr.mr_n53614848)
print v(xbgr.mr_n53614960)
print v(xbgr.mr_n53615280)
print v(xbgr.mr_n53615392)
print v(xbgr.mr_n53615712)
print v(xbgr.mr_n53615824)
print v(xbgr.mr_n53616256)
print v(xbgr.mr_n53616576)
print v(xbgr.mr_n53616688)
print v(xbgr.mr_n53617440)
print v(xbgr.mr_n53618304)
print v(xbgr.mr_n53618416)
print v(xbgr.mr_n53618736)
print v(xbgr.mr_n53618848)
print v(xbgr.mr_n53619280)
print v(xbgr.mr_n53619600)
print v(xbgr.mr_n53619712)
print v(xbgr.mr_n53620032)
print v(xbgr.mr_n53620144)
print v(xbgr.mr_n53620464)
print v(xbgr.mr_n53620576)
print v(xbgr.mr_n53620896)
print v(xbgr.mr_n53621008)
print v(xbgr.mr_n53621328)
print v(xbgr.mr_n53621440)
print v(xbgr.mr_n53621760)
print v(xbgr.mr_n53622624)
print v(xbgr.mr_n53623600)
print v(xbgr.mr_n53623920)
print v(xbgr.mr_n53624784)
print v(xbgr.mr_n53625648)
print v(xbgr.mr_n53626512)
print v(xbgr.mr_n53626944)
print v(xbgr.mr_n53627376)
print v(xbgr.mr_n53627488)
print v(xbgr.mr_n53627808)
print v(xbgr.mr_n53627920)
print v(xbgr.mr_n53628240)
print v(xbgr.mr_n53628352)
print v(xbgr.mr_n53628672)
print v(xbgr.mr_n53628784)
print v(xbgr.mr_n53629104)
print v(xbgr.mr_n53629216)
print v(xbgr.mr_n53629536)
print v(xbgr.mr_n53629648)
print v(xbgr.mr_n53629968)
print v(xbgr.mr_n53630832)
print v(xbgr.mr_n53631696)
print v(xbgr.mr_n53631808)
print v(xbgr.mr_n53632128)
print v(xbgr.mr_n53632240)
print v(xbgr.mr_n53632560)
print v(xbgr.mr_n53632672)
print v(xbgr.mr_n53632992)
print v(xbgr.mr_n53633104)
print v(xbgr.mr_n53634720)
print v(xbgr.mr_n53635584)
print v(xbgr.mr_n53635696)
print v(xbgr.mr_n53636016)
print v(xbgr.mr_n53636128)
print v(xbgr.mr_n53636448)
print v(xbgr.mr_n53636880)
print v(xbgr.mr_n53636992)
print v(xbgr.mr_n53637312)
print v(xbgr.mr_n53637424)
print v(xbgr.mr_n53637744)
print v(xbgr.mr_n53637856)
print v(xbgr.mr_n53638288)
print v(xbgr.mr_n53638608)
print v(xbgr.mr_n53638720)
print v(xbgr.mr_n53639152)
print v(xbgr.mr_n53639904)
print v(xbgr.mr_n53640768)
print v(xbgr.mr_n53642064)
print v(xbgr.mr_n53642176)
print v(xbgr.mr_n53642608)
print v(xbgr.mr_n53642928)
print v(xbgr.mr_n53643792)
print v(xbgr.mr_n53644656)
print v(xbgr.mr_n53645088)
print v(xbgr.mr_n53646384)
print v(xbgr.mr_n53647248)
print v(xbgr.mr_n53647680)
print v(xbgr.mr_n53648544)
print v(xbgr.mr_n53649840)
print v(xbgr.mr_n53649952)
print v(xbgr.mr_n53650272)
print v(xbgr.mr_n53650384)
print v(xbgr.mr_n53650704)
print v(xbgr.mr_n53650816)
print v(xbgr.mr_n53651136)
print v(xbgr.mr_n53651248)
print v(xbgr.mr_n53651568)
print v(xbgr.mr_n53651680)
print v(xbgr.mr_n53652000)
print v(xbgr.mr_n53652112)
print v(xbgr.mr_n53652432)
print v(xbgr.mr_n53652544)
print v(xbgr.mr_n53653296)
print v(xbgr.mr_n53653408)
print v(xbgr.mr_n53653840)
print v(xbgr.mr_n53654160)
print v(xbgr.mr_n53654272)
print v(xbgr.mr_n53654592)
print v(xbgr.mr_n53654704)
print v(xbgr.mr_n53655024)
print v(xbgr.mr_n53655136)
print v(xbgr.mr_n53655456)
print v(xbgr.mr_n53655568)
print v(xbgr.mr_n53655888)
print v(xbgr.mr_n53656000)
print v(xbgr.mr_n53656432)
print v(xbgr.mr_n53656752)
print v(xbgr.mr_n53657296)
print v(xbgr.mr_n53657616)
print v(xbgr.mr_n53657728)
print v(xbgr.mr_n53658160)
print v(xbgr.mr_n53658480)
print v(xbgr.mr_n53658592)
print v(xbgr.mr_n53659024)
print v(xbgr.mr_n53659344)
print v(xbgr.mr_n53659456)
print v(xbgr.mr_n53659776)
print v(xbgr.mr_n53659888)
print v(xbgr.mr_n53660208)
print v(xbgr.mr_n53660320)
print v(xbgr.mr_n53660640)
print v(xbgr.mr_n53660752)
print v(xbgr.mr_n53661072)
print v(xbgr.mr_n53661184)
print v(xbgr.mr_n53661504)
print v(xbgr.mr_n53661616)
print v(xbgr.mr_n53661936)
print v(xbgr.mr_n53662048)
print v(xbgr.mr_n53662368)
print v(xbgr.mr_n53662480)
print v(xbgr.mr_n53662800)
print v(xbgr.mr_n53663664)
print v(xbgr.mr_n53663776)
print v(xbgr.mr_n53664096)
print v(xbgr.mr_n53664208)
print v(xbgr.mr_n53664528)
print v(xbgr.mr_n53664640)
print v(xbgr.mr_n53664960)
print v(xbgr.mr_n53665072)
print v(xbgr.mr_n53665392)
print v(xbgr.mr_n53666256)
print v(xbgr.mr_n53667120)
print v(xbgr.mr_n53667984)
print v(xbgr.mr_n53668528)
print v(xbgr.mr_n53668960)
print v(xbgr.mr_n53669280)
print v(xbgr.mr_n53669392)
print v(xbgr.mr_n53669712)
print v(xbgr.mr_n53669824)
print v(xbgr.mr_n53670144)
print v(xbgr.mr_n53670256)
print v(xbgr.mr_n53670576)
print v(xbgr.mr_n53670688)
print v(xbgr.mr_n53671008)
print v(xbgr.mr_n53672304)
print v(xbgr.mr_n53673168)
print v(xbgr.mr_n53674144)
print v(xbgr.mr_n53674576)
print v(xbgr.mr_n53674896)
print v(xbgr.mr_n53675328)
print v(xbgr.mr_n53676192)
print v(xbgr.mr_n53677056)
print v(xbgr.mr_n53677168)
print v(xbgr.mr_n53677488)
print v(xbgr.mr_n53677600)
print v(xbgr.mr_n53677920)
print v(xbgr.mr_n53678032)
print v(xbgr.mr_n53678352)
print v(xbgr.mr_n53678464)
print v(xbgr.mr_n53679648)
print v(xbgr.mr_n53679760)
print v(xbgr.mr_n53680080)
print v(xbgr.mr_n53680192)
print v(xbgr.mr_n53680512)
print v(xbgr.mr_n53680624)
print v(xbgr.mr_n53681056)
print v(xbgr.mr_n53681376)
print v(xbgr.mr_n53681808)
print v(xbgr.mr_n53681920)
print v(xbgr.mr_n53682352)
print v(xbgr.mr_n53682672)
print v(xbgr.mr_n53683536)
print v(xbgr.mr_n53683648)
print v(xbgr.mr_n53684080)
print v(xbgr.mr_n53684400)
print v(xbgr.mr_n53684512)
print v(xbgr.mr_n53685264)
print v(xbgr.mr_n53685808)
print v(xbgr.mr_n53686128)
print v(xbgr.mr_n53686240)
print v(xbgr.mr_n53686560)
print v(xbgr.mr_n53686672)
print v(xbgr.mr_n53686992)
print v(xbgr.mr_n53687104)
print v(xbgr.mr_n53687424)
print v(xbgr.mr_n53687856)
print v(xbgr.mr_n53687968)
print v(xbgr.mr_n53688288)
print v(xbgr.mr_n53688400)
print v(xbgr.mr_n53688720)
print v(xbgr.mr_n53688832)
print v(xbgr.mr_n53689584)
print v(xbgr.mr_n53689696)
print v(xbgr.mr_n53690128)
print v(xbgr.mr_n53690448)
print v(xbgr.mr_n53690560)
print v(xbgr.mr_n53690880)
print v(xbgr.mr_n53690992)
print v(xbgr.mr_n53691312)
print v(xbgr.mr_n53691424)
print v(xbgr.mr_n53691744)
print v(xbgr.mr_n53692608)
print v(xbgr.mr_n53693040)
print v(xbgr.mr_n53693472)
print v(xbgr.mr_n53693584)
print v(xbgr.mr_n53693904)
print v(xbgr.mr_n53694016)
print v(xbgr.mr_n53694768)
print v(xbgr.mr_n53694880)
print v(xbgr.mr_n53695200)
print v(xbgr.mr_n53695312)
print v(xbgr.mr_n53696064)
print v(xbgr.mr_n53696928)
print v(xbgr.mr_n53697040)
print v(xbgr.mr_n53697360)
print v(xbgr.mr_n53698224)
print v(xbgr.mr_n53698336)
print v(xbgr.mr_n53698656)
print v(xbgr.mr_n53698768)
print v(xbgr.mr_n53699088)
print v(xbgr.mr_n53699200)
print v(xbgr.mr_n53699520)
print v(xbgr.mr_n53699632)
print v(xbgr.mr_n53699952)
print v(xbgr.mr_n53700064)
print v(xbgr.mr_n53700384)
print v(xbgr.mr_n53700496)
print v(xbgr.mr_n53700816)
print v(xbgr.mr_n53700928)
print v(xbgr.mr_n53701360)
print v(xbgr.mr_n53701792)
print v(xbgr.mr_n53702112)
print v(xbgr.mr_n53702544)
print v(xbgr.mr_n53702656)
print v(xbgr.mr_n53703840)
print v(xbgr.mr_n53705568)
print v(xbgr.mr_n53705680)
print v(xbgr.mr_n53706112)
print v(xbgr.mr_n53706432)
print v(xbgr.mr_n53706544)
print v(xbgr.mr_n53706864)
print v(xbgr.mr_n53706976)
print v(xbgr.mr_n53707408)
print v(xbgr.mr_n53707728)
print v(xbgr.mr_n53707840)
print v(xbgr.mr_n53708160)
print v(xbgr.mr_n53708592)
print v(xbgr.mr_n53708704)
print v(xbgr.mr_n53709456)
print v(xbgr.mr_n53709568)
print v(xbgr.mr_n53709888)
print v(xbgr.mr_n53710000)
print v(xbgr.mr_n53710320)
print v(xbgr.mr_n53710432)
print v(xbgr.mr_n53710752)
print v(xbgr.mr_n53710864)
print v(xbgr.mr_n53711184)
print v(xbgr.mr_n53711296)
print v(xbgr.mr_n53711616)
print v(xbgr.mr_n53712480)
print v(xbgr.mr_n53713344)
print v(xbgr.mr_n53714208)
print v(xbgr.mr_n53714320)
print v(xbgr.mr_n53714640)
print v(xbgr.mr_n53715072)
print v(xbgr.mr_n53715184)
print v(xbgr.mr_n53715504)
print v(xbgr.mr_n53715616)
print v(xbgr.mr_n53715936)
print v(xbgr.mr_n53716048)
print v(xbgr.mr_n53716368)
print v(xbgr.mr_n53717232)
print v(xbgr.mr_n53718208)
print v(xbgr.mr_n53718528)
print v(xbgr.mr_n53718640)
print v(xbgr.mr_n53718960)
print v(xbgr.mr_n53719072)
print v(xbgr.mr_n53719392)
print v(xbgr.mr_n53719504)
print v(xbgr.mr_n53719824)
print v(xbgr.mr_n53719936)
print v(xbgr.mr_n53720256)
print v(xbgr.mr_n53720800)
print v(xbgr.mr_n53721232)
print v(xbgr.mr_n53721664)
print v(xbgr.mr_n53722848)
print v(xbgr.mr_n53722960)
print v(xbgr.mr_n53723280)
print v(xbgr.mr_n53723392)
print v(xbgr.mr_n53723712)
print v(xbgr.mr_n53724576)
print v(xbgr.mr_n53724688)
print v(xbgr.mr_n53725008)
print v(xbgr.mr_n53725120)
print v(xbgr.mr_n53725440)
print v(xbgr.mr_n53725872)
print v(xbgr.mr_n53726736)
print v(xbgr.mr_n53728032)
print v(xbgr.mr_n53728144)
print v(xbgr.mr_n53728464)
print v(xbgr.mr_n53728576)
print v(xbgr.mr_n53728896)
print v(xbgr.mr_n53729328)
print v(xbgr.mr_n53730192)
print v(xbgr.mr_n53730624)
print v(xbgr.mr_n53730736)
print v(xbgr.mr_n53731056)
print v(xbgr.mr_n53731168)
print v(xbgr.mr_n53731488)
print v(xbgr.mr_n53731600)
print v(xbgr.mr_n53731920)
print v(xbgr.mr_n53732032)
print v(xbgr.mr_n53732784)
print v(xbgr.mr_n53732896)
print v(xbgr.mr_n53733648)
print v(xbgr.mr_n53734624)
print v(xbgr.mr_n53734944)
print v(xbgr.mr_n53735056)
print v(xbgr.mr_n53735376)
print v(xbgr.mr_n53735488)
print v(xbgr.mr_n53735808)
print v(xbgr.mr_n53736240)
print v(xbgr.mr_n53737104)
print v(xbgr.mr_n53737216)
print v(xbgr.mr_n53737536)
print v(xbgr.mr_n53737648)
print v(xbgr.mr_n53737968)
print v(xbgr.mr_n53738080)
print v(xbgr.mr_n53738400)
print v(xbgr.mr_n53738512)
print v(xbgr.mr_n53738832)
print v(xbgr.mr_n53738944)
print v(xbgr.mr_n53739376)
print v(xbgr.mr_n53740128)
print v(xbgr.mr_n53741104)
print v(xbgr.mr_n53741536)
print v(xbgr.mr_n53741856)
print v(xbgr.mr_n53742288)
print v(xbgr.mr_n53743264)
print v(xbgr.mr_n53743696)
print v(xbgr.mr_n53744016)
print v(xbgr.mr_n53744448)
print v(xbgr.mr_n53744560)
print v(xbgr.mr_n53744880)
print v(xbgr.mr_n53744992)
print v(xbgr.mr_n53745312)
print v(xbgr.mr_n53745424)
print v(xbgr.mr_n53745744)
print v(xbgr.mr_n53745856)
print v(xbgr.mr_n53746608)
print v(xbgr.mr_n53747472)
print v(xbgr.mr_n53748768)
print v(xbgr.mr_n53748880)
print v(xbgr.mr_n53749200)
print v(xbgr.mr_n53749312)
print v(xbgr.mr_n53749632)
print v(xbgr.mr_n53749744)
print v(xbgr.mr_n53750064)
print v(xbgr.mr_n53750176)
print v(xbgr.mr_n53750496)
print v(xbgr.mr_n53750608)
print v(xbgr.mr_n53750928)
print v(xbgr.mr_n53751360)
print v(xbgr.mr_n53751472)
print v(xbgr.mr_n53751792)
print v(xbgr.mr_n53751904)
print v(xbgr.mr_n53752224)
print v(xbgr.mr_n53752336)
print v(xbgr.mr_n53752656)
print v(xbgr.mr_n53752768)
print v(xbgr.mr_n53753088)
print v(xbgr.mr_n53753200)
print v(xbgr.mr_n53753520)
print v(xbgr.mr_n53753632)
print v(xbgr.mr_n53753952)
print v(xbgr.mr_n53754064)
print v(xbgr.mr_n53754384)
print v(xbgr.mr_n53754496)
print v(xbgr.mr_n53754816)
print v(xbgr.mr_n53754928)
print v(xbgr.mr_n53755360)
print v(xbgr.mr_n53755680)
print v(xbgr.mr_n53755792)
print v(xbgr.mr_n53756224)
print v(xbgr.mr_n53756656)
print v(xbgr.mr_n53756976)
print v(xbgr.mr_n53757088)
print v(xbgr.mr_n53757408)
print v(xbgr.mr_n53757520)
print v(xbgr.mr_n53757840)
print v(xbgr.mr_n53757952)
print v(xbgr.mr_n53758272)
print v(xbgr.mr_n53758384)
print v(xbgr.mr_n53759136)
print v(xbgr.mr_n53759248)
print v(xbgr.mr_n53759680)
print v(xbgr.mr_n53760000)
print v(xbgr.mr_n53760544)
print v(xbgr.mr_n53760864)
print v(xbgr.mr_n53761728)
print v(xbgr.mr_n53761840)
print v(xbgr.mr_n53762160)
print v(xbgr.mr_n53762592)
print v(xbgr.mr_n53763024)
print v(xbgr.mr_n53763456)
print v(xbgr.mr_n53763568)
print v(xbgr.mr_n53764320)
print v(xbgr.mr_n53764432)
print v(xbgr.mr_n53764752)
print v(xbgr.mr_n53764864)
print v(xbgr.mr_n53765184)
print v(xbgr.mr_n53765616)
print v(xbgr.mr_n53765728)
print v(xbgr.mr_n53766048)
print v(xbgr.mr_n53766160)
print v(xbgr.mr_n53766480)
print v(xbgr.mr_n53766592)
print v(xbgr.mr_n53766912)
print v(xbgr.mr_n53767344)
print v(xbgr.mr_n53768208)
print v(xbgr.mr_n53769072)
print v(xbgr.mr_n53770368)
print v(xbgr.mr_n53771232)
print v(xbgr.mr_n53772096)
print v(xbgr.mr_n53772960)
print v(xbgr.mr_n53773072)
print v(xbgr.mr_n53773392)
print v(xbgr.mr_n53774256)
print v(xbgr.mr_n53775120)
print v(xbgr.mr_n53775984)
print v(xbgr.mr_n53776096)
print v(xbgr.mr_n53776416)
print v(xbgr.mr_n53776528)
print v(xbgr.mr_n53776848)
print v(xbgr.mr_n53776960)
print v(xbgr.mr_n53777280)
print v(xbgr.mr_n53777392)
print v(xbgr.mr_n53777712)
print v(xbgr.mr_n53777824)
print v(xbgr.mr_n53778144)
print v(xbgr.mr_n53778256)
print v(xbgr.mr_n53779872)
print v(xbgr.mr_n53780848)
print v(xbgr.mr_n53781280)
print v(xbgr.mr_n53781712)
print v(xbgr.mr_n53782032)
print v(xbgr.mr_n53782144)
print v(xbgr.mr_n53782464)
print v(xbgr.mr_n53782576)
print v(xbgr.mr_n53782896)
print v(xbgr.mr_n53783008)
print v(xbgr.mr_n53783328)
print v(xbgr.mr_n53783440)
print v(xbgr.mr_n53783760)
print v(xbgr.mr_n53783872)
print v(xbgr.mr_n53784192)
print v(xbgr.mr_n53784304)
print v(xbgr.mr_n53784624)
print v(xbgr.mr_n53784736)
print v(xbgr.mr_n53785168)
print v(xbgr.mr_n53785488)
print v(xbgr.mr_n53785600)
print v(xbgr.mr_n53786032)
print v(xbgr.mr_n53786464)
print v(xbgr.mr_n53787648)
print v(xbgr.mr_n53787760)
print v(xbgr.mr_n53788080)
print v(xbgr.mr_n53788192)
print v(xbgr.mr_n53788512)
print v(xbgr.mr_n53788624)
print v(xbgr.mr_n53788944)
print v(xbgr.mr_n53789056)
print v(xbgr.mr_n53789376)
print v(xbgr.mr_n53789488)
print v(xbgr.mr_n53789808)
print v(xbgr.mr_n53790240)
print v(xbgr.mr_n53790352)
print v(xbgr.mr_n53790672)
print v(xbgr.mr_n53790784)
print v(xbgr.mr_n53791104)
print v(xbgr.mr_n53791216)
print v(xbgr.mr_n53791536)
print v(xbgr.mr_n53791648)
print v(xbgr.mr_n53792080)
print v(xbgr.mr_n53792400)
print v(xbgr.mr_n53792832)
print v(xbgr.mr_n53793696)
print v(xbgr.mr_n53793808)
print v(xbgr.mr_n53794128)
print v(xbgr.mr_n53794560)
print v(xbgr.mr_n53794992)
print v(xbgr.mr_n53795536)
print v(xbgr.mr_n53795856)
print v(xbgr.mr_n53796720)
print v(xbgr.mr_n53796832)
print v(xbgr.mr_n53797152)
print v(xbgr.mr_n53797264)
print v(xbgr.mr_n53797696)
print v(xbgr.mr_n53798448)
print v(xbgr.mr_n53798880)
print v(xbgr.mr_n53799312)
print v(xbgr.mr_n53799744)
print v(xbgr.mr_n53799856)
print v(xbgr.mr_n53801040)
print v(xbgr.mr_n53801904)
print v(xbgr.mr_n53802880)
print v(xbgr.mr_n53803200)
print v(xbgr.mr_n53803312)
print v(xbgr.mr_n53803744)
print v(xbgr.mr_n53804064)
print v(xbgr.mr_n53804176)
print v(xbgr.mr_n53804496)
print v(xbgr.mr_n53804608)
print v(xbgr.mr_n53804928)
print v(xbgr.mr_n53805040)
print v(xbgr.mr_n53805360)
print v(xbgr.mr_n53805472)
print v(xbgr.mr_n53805792)
print v(xbgr.mr_n53805904)
print v(xbgr.mr_n53806224)
print v(xbgr.mr_n53806336)
print v(xbgr.mr_n53806768)
print v(xbgr.mr_n53807200)
print v(xbgr.mr_n53807632)
print v(xbgr.mr_n53808384)
print v(xbgr.mr_n53808816)
print v(xbgr.mr_n53809680)
print v(xbgr.mr_n53810544)
print v(xbgr.mr_n53812272)
print v(xbgr.mr_n53813136)
print v(xbgr.mr_n53813248)
print v(xbgr.mr_n53814000)
print v(xbgr.mr_n53814112)
print v(xbgr.mr_n53814432)
print v(xbgr.mr_n53814544)
print v(xbgr.mr_n53814864)
print v(xbgr.mr_n53814976)
print v(xbgr.mr_n53817024)
print v(xbgr.mr_n53817136)
print v(xbgr.mr_n53817456)
print v(xbgr.mr_n53817568)
print v(xbgr.mr_n53817888)
print v(xbgr.mr_n53818000)
print v(xbgr.mr_n53818320)
print v(xbgr.mr_n53818432)
print v(xbgr.mr_n53818752)
print v(xbgr.mr_n53818864)
print v(xbgr.mr_n53819184)
print v(xbgr.mr_n53819296)
print v(xbgr.mr_n53819616)
print v(xbgr.mr_n53819728)
print v(xbgr.mr_n53820160)
print v(xbgr.mr_n53820480)
print v(xbgr.mr_n53820592)
print v(xbgr.mr_n53821024)
print v(xbgr.mr_n53821344)
print v(xbgr.mr_n53821456)
print v(xbgr.mr_n53821888)
print v(xbgr.mr_n53822208)
print v(xbgr.mr_n53822320)
print v(xbgr.mr_n53822640)
print v(xbgr.mr_n53822752)
print v(xbgr.mr_n53823072)
print v(xbgr.mr_n53823184)
print v(xbgr.mr_n53823504)
print v(xbgr.mr_n53823616)
print v(xbgr.mr_n53823936)
print v(xbgr.mr_n53824048)
print v(xbgr.mr_n53824368)
print v(xbgr.mr_n53824480)
print v(xbgr.mr_n53824800)
print v(xbgr.mr_n53824912)
print v(xbgr.mr_n53825232)
print v(xbgr.mr_n53825344)
print v(xbgr.mr_n53825664)
print v(xbgr.mr_n53825776)
print v(xbgr.mr_n53826096)
print v(xbgr.mr_n53826208)
print v(xbgr.mr_n53826528)
print v(xbgr.mr_n53826640)
print v(xbgr.mr_n53826960)
print v(xbgr.mr_n53827072)
print v(xbgr.mr_n53827392)
print v(xbgr.mr_n53827504)
print v(xbgr.mr_n53827824)
print v(xbgr.mr_n53827936)
print v(xbgr.mr_n53828256)
print v(xbgr.mr_n53828368)
print v(xbgr.mr_n53828688)
print v(xbgr.mr_n53828800)
print v(xbgr.mr_n53829120)
print v(xbgr.mr_n53829232)
print v(xbgr.mr_n53829552)
print v(xbgr.mr_n53829664)
print v(xbgr.mr_n53830096)
print v(xbgr.mr_n53830416)
print v(xbgr.mr_n53830528)
print v(xbgr.mr_n53830960)
print v(xbgr.mr_n53831280)
print v(xbgr.mr_n53831392)
print v(xbgr.mr_n53831824)
print v(xbgr.mr_n53832144)
print v(xbgr.mr_n53833008)
print v(xbgr.mr_n53833872)
print v(xbgr.mr_n53834736)
print v(xbgr.mr_n53835600)
print v(xbgr.mr_n53836464)
print v(xbgr.mr_n53837328)
print v(xbgr.mr_n53837440)
print v(xbgr.mr_n53837760)
print v(xbgr.mr_n53837872)
print v(xbgr.mr_n53838192)
print v(xbgr.mr_n53838304)
print v(xbgr.mr_n53838624)
print v(xbgr.mr_n53838736)
print v(xbgr.mr_n53839056)
print v(xbgr.mr_n53839168)
print v(xbgr.mr_n53839488)
print v(xbgr.mr_n53839600)
print v(xbgr.mr_n53839920)
print v(xbgr.mr_n53840784)
print v(xbgr.mr_n53841648)
print v(xbgr.mr_n53842512)
print v(xbgr.mr_n53842624)
print v(xbgr.mr_n53842944)
print v(xbgr.mr_n53843056)
print v(xbgr.mr_n53843376)
print v(xbgr.mr_n53843488)
print v(xbgr.mr_n53843920)
print v(xbgr.mr_n53844352)
print v(xbgr.mr_n53844784)
print v(xbgr.mr_n53845104)
print v(xbgr.mr_n53845216)
print v(xbgr.mr_n53845648)
print v(xbgr.mr_n53845968)
print v(xbgr.mr_n53846080)
print v(xbgr.mr_n53846400)
print v(xbgr.mr_n53846512)
print v(xbgr.mr_n53846832)
print v(xbgr.mr_n53846944)
print v(xbgr.mr_n53847264)
print v(xbgr.mr_n53847376)
print v(xbgr.mr_n53847696)
print v(xbgr.mr_n53847808)
print v(xbgr.mr_n53848128)
print v(xbgr.mr_n53848240)
print v(xbgr.mr_n53848672)
print v(xbgr.mr_n53849104)
print v(xbgr.mr_n53849424)
print v(xbgr.mr_n53849536)
print v(xbgr.mr_n53849968)
print v(xbgr.mr_n53850288)
print v(xbgr.mr_n53850400)
print v(xbgr.mr_n53850832)
print v(xbgr.mr_n53851152)
print v(xbgr.mr_n53851264)
print v(xbgr.mr_n53851696)
print v(xbgr.mr_n53852016)
print v(xbgr.mr_n53852880)
print v(xbgr.mr_n53853744)
print v(xbgr.mr_n53854608)
print v(xbgr.mr_n53855472)
print v(xbgr.mr_n53856336)
print v(xbgr.mr_n53856448)
print v(xbgr.mr_n53856768)
print v(xbgr.mr_n53856880)
print v(xbgr.mr_n53857200)
print v(xbgr.mr_n53857312)
print v(xbgr.mr_n53857632)
print v(xbgr.mr_n53857744)
print v(xbgr.mr_n53858064)
print v(xbgr.mr_n53858928)
print v(xbgr.mr_n53859792)
print v(xbgr.mr_n53860656)
print v(xbgr.mr_n53860768)
print v(xbgr.mr_n53861088)
print v(xbgr.mr_n53861200)
print v(xbgr.mr_n53861520)
print v(xbgr.mr_n53861632)
print v(xbgr.mr_n53861952)
print v(xbgr.mr_n53862064)
print v(xbgr.mr_n53862384)
print v(xbgr.mr_n53862496)
print v(xbgr.mr_n53862816)
print v(xbgr.mr_n53862928)
print v(xbgr.mr_n53863248)
print v(xbgr.mr_n53864112)
print v(xbgr.mr_n53864976)
print v(xbgr.mr_n53865840)
print v(xbgr.mr_n53866704)
print v(xbgr.mr_n53867568)
print v(xbgr.mr_n53868432)
print v(xbgr.mr_n53869296)
print v(xbgr.mr_n53870160)
print v(xbgr.mr_n53871024)
print v(xbgr.mr_n53871136)
print v(xbgr.mr_n53871456)
print v(xbgr.mr_n53871568)
print v(xbgr.mr_n53871888)
print v(xbgr.mr_n53872000)
print v(xbgr.mr_n53872320)
print v(xbgr.mr_n53872432)
print v(xbgr.mr_n53872752)
print v(xbgr.mr_n53872864)
print v(xbgr.mr_n53873184)
print v(xbgr.mr_n53873296)
print v(xbgr.mr_n53873616)
print v(xbgr.mr_n53873728)
print v(xbgr.mr_n53874048)
print v(xbgr.mr_n53874160)
print v(xbgr.mr_n53874480)
print v(xbgr.mr_n53874592)
print v(xbgr.mr_n53874912)
print v(xbgr.mr_n53875024)
print v(xbgr.mr_n53875344)
print v(xbgr.mr_n53876208)
print v(xbgr.mr_n53876320)
print v(xbgr.mr_n53876640)
print v(xbgr.mr_n53876752)
print v(xbgr.mr_n53877072)
print v(xbgr.mr_n53877184)
print v(xbgr.mr_n53877504)
print v(xbgr.mr_n53877616)
print v(xbgr.mr_n53877936)
print v(xbgr.mr_n53878048)
print v(xbgr.mr_n53878368)
print v(xbgr.mr_n53878480)
print v(xbgr.mr_n53878800)
print v(xbgr.mr_n53878912)
print v(xbgr.mr_n53879232)
print v(xbgr.mr_n53879344)
print v(xbgr.mr_n53879664)
print v(xbgr.mr_n53879776)
print v(xbgr.mr_n53880096)
print v(xbgr.mr_n53880208)
print v(xbgr.mr_n53880528)
print v(xbgr.mr_n53880640)
print v(xbgr.mr_n53881072)
print v(xbgr.mr_n53881392)
print v(xbgr.mr_n53881504)
print v(xbgr.mr_n53881936)
print v(xbgr.mr_n53882256)
print v(xbgr.mr_n53882368)
print v(xbgr.mr_n53882800)
print v(xbgr.mr_n53883120)
print v(xbgr.mr_n53883232)
print v(xbgr.mr_n53883664)
print v(xbgr.mr_n53883984)
print v(xbgr.mr_n53884096)
print v(xbgr.mr_n53884416)
print v(xbgr.mr_n53884528)
print v(xbgr.mr_n53884960)
print v(xbgr.mr_n53885392)
print v(xbgr.mr_n53885712)
print v(xbgr.mr_n53885824)
print v(xbgr.mr_n53886144)
print v(xbgr.mr_n53886256)
print v(xbgr.mr_n53886576)
print v(xbgr.mr_n53886688)
print v(xbgr.mr_n53887008)
print v(xbgr.mr_n53887120)
print v(xbgr.mr_n53887440)
print v(xbgr.mr_n53887552)
print v(xbgr.mr_n53887984)
print v(xbgr.mr_n53888304)
print v(xbgr.mr_n53888416)
print v(xbgr.mr_n53888848)
print v(xbgr.mr_n53889168)
print v(xbgr.mr_n53890032)
print v(xbgr.mr_n53890896)
print v(xbgr.mr_n53891760)
print v(xbgr.mr_n53892624)
print v(xbgr.mr_n53892736)
print v(xbgr.mr_n53893056)
print v(xbgr.mr_n53893168)
print v(xbgr.mr_n53893488)
print v(xbgr.mr_n53893600)
print v(xbgr.mr_n53893920)
print v(xbgr.mr_n53894032)
print v(xbgr.mr_n53894352)
print v(xbgr.mr_n53895216)
print v(xbgr.mr_n53896080)
print v(xbgr.mr_n53896192)
print v(xbgr.mr_n53896512)
print v(xbgr.mr_n53896624)
print v(xbgr.mr_n53897056)
print v(xbgr.mr_n53897488)
print v(xbgr.mr_n53897808)
print v(xbgr.mr_n53897920)
print v(xbgr.mr_n53898240)
print v(xbgr.mr_n53898352)
print v(xbgr.mr_n53898672)
print v(xbgr.mr_n53898784)
print v(xbgr.mr_n53899104)
print v(xbgr.mr_n53899216)
print v(xbgr.mr_n53899536)
print v(xbgr.mr_n53899648)
print v(xbgr.mr_n53900080)
print v(xbgr.mr_n53900400)
print v(xbgr.mr_n53900512)
print v(xbgr.mr_n53900944)
print v(xbgr.mr_n53901264)
print v(xbgr.mr_n53901376)
print v(xbgr.mr_n53901696)
print v(xbgr.mr_n53901808)
print v(xbgr.mr_n53902128)
print v(xbgr.mr_n53902240)
print v(xbgr.mr_n53902560)
print v(xbgr.mr_n53902672)
print v(xbgr.mr_n53902992)
print v(xbgr.mr_n53903104)
print v(xbgr.mr_n53903424)
print v(xbgr.mr_n53903536)
print v(xbgr.mr_n53903856)
print v(xbgr.mr_n53903968)
print v(xbgr.mr_n53904288)
print v(xbgr.mr_n53904400)
print v(xbgr.mr_n53904720)
print v(xbgr.mr_n53904832)
print v(xbgr.mr_n53905152)
print v(xbgr.mr_n53905264)
print v(xbgr.mr_n53905584)
print v(xbgr.mr_n53906448)
print v(xbgr.mr_n53907312)
print v(xbgr.mr_n53908176)
print v(xbgr.mr_n53909040)
print v(xbgr.mr_n53909152)
print v(xbgr.mr_n53909472)
print v(xbgr.mr_n53909584)
print v(xbgr.mr_n53909904)
print v(xbgr.mr_n53910016)
print v(xbgr.mr_n53910336)
print v(xbgr.mr_n53910448)
print v(xbgr.mr_n53910880)
print v(xbgr.mr_n53911312)
print v(xbgr.mr_n53911744)
print v(xbgr.mr_n53912176)
print v(xbgr.mr_n53912496)
print v(xbgr.mr_n53912608)
print v(xbgr.mr_n53912928)
print v(xbgr.mr_n53913040)
print v(xbgr.mr_n53913360)
print v(xbgr.mr_n53913472)
print v(xbgr.mr_n53913792)
print v(xbgr.mr_n53913904)
print v(xbgr.mr_n53914224)
print v(xbgr.mr_n53915088)
print v(xbgr.mr_n53915952)
print v(xbgr.mr_n53916064)
print v(xbgr.mr_n53916496)
print v(xbgr.mr_n53916816)
print v(xbgr.mr_n53917680)
print v(xbgr.mr_n53917792)
print v(xbgr.mr_n53918112)
print v(xbgr.mr_n53918224)
print v(xbgr.mr_n53918544)
print v(xbgr.mr_n53918656)
print v(xbgr.mr_n53918976)
print v(xbgr.mr_n53919088)
print v(xbgr.mr_n53919408)
print v(xbgr.mr_n53920272)
print v(xbgr.mr_n53920384)
print v(xbgr.mr_n53920816)
print v(xbgr.mr_n53921136)
print v(xbgr.mr_n53921248)
print v(xbgr.mr_n53921568)
print v(xbgr.mr_n53921680)
print v(xbgr.mr_n53922000)
print v(xbgr.mr_n53922112)
print v(xbgr.mr_n53922432)
print v(xbgr.mr_n53922544)
print v(xbgr.mr_n53922864)
print v(xbgr.mr_n53923728)
print v(xbgr.mr_n53924160)
print v(xbgr.mr_n53924272)
print v(xbgr.mr_n53924592)
print v(xbgr.mr_n53924704)
print v(xbgr.mr_n53925024)
print v(xbgr.mr_n53925456)
print v(xbgr.mr_n53926320)
print v(xbgr.mr_n53927184)
print v(xbgr.mr_n53927296)
print v(xbgr.mr_n53928048)
print v(xbgr.mr_n53928160)
print v(xbgr.mr_n53928480)
print v(xbgr.mr_n53928592)
print v(xbgr.mr_n53928912)
print v(xbgr.mr_n53929776)
print v(xbgr.mr_n53930640)
print v(xbgr.mr_n53930752)
print v(xbgr.mr_n53931072)
print v(xbgr.mr_n53931184)
print v(xbgr.mr_n53931504)
print v(xbgr.mr_n53932368)
print v(xbgr.mr_n53932480)
print v(xbgr.mr_n53932800)
print v(xbgr.mr_n53932912)
print v(xbgr.mr_n53933232)
print v(xbgr.mr_n53933344)
print v(xbgr.mr_n53933664)
print v(xbgr.mr_n53933776)
print v(xbgr.mr_n53934096)
print v(xbgr.mr_n53934208)
print v(xbgr.mr_n53934960)
print v(xbgr.mr_n53935824)
print v(xbgr.mr_n53936688)
print v(xbgr.mr_n53936800)
print v(xbgr.mr_n53937120)
print v(xbgr.mr_n53937232)
print v(xbgr.mr_n53937552)
print v(xbgr.mr_n53937664)
print v(xbgr.mr_n53937984)
print v(xbgr.mr_n53938096)
print v(xbgr.mr_n53938416)
print v(xbgr.mr_n53938528)
print v(xbgr.mr_n53938848)
print v(xbgr.mr_n53938960)
print v(xbgr.mr_n53939280)
print v(xbgr.mr_n53939392)
print v(xbgr.mr_n53939824)
print v(xbgr.mr_n53940144)
print v(xbgr.mr_n53940256)
print v(xbgr.mr_n53940576)
print v(xbgr.mr_n53940688)
print v(xbgr.mr_n53941008)
print v(xbgr.mr_n53941872)
print v(xbgr.mr_n53942736)
print v(xbgr.mr_n53943600)
print v(xbgr.mr_n53944464)
print v(xbgr.mr_n53944896)
print v(xbgr.mr_n53945008)
print v(xbgr.mr_n53945328)
print v(xbgr.mr_n53945440)
print v(xbgr.mr_n53945760)
print v(xbgr.mr_n53945872)
print v(xbgr.mr_n53946304)
print v(xbgr.mr_n53947056)
print v(xbgr.mr_n53947168)
print v(xbgr.mr_n53947488)
print v(xbgr.mr_n53947600)
print v(xbgr.mr_n53947920)
print v(xbgr.mr_n53948784)
print v(xbgr.mr_n53949648)
print v(xbgr.mr_n53949760)
print v(xbgr.mr_n53950080)
print v(xbgr.mr_n53950192)
print v(xbgr.mr_n53950512)
print v(xbgr.mr_n53951376)
print v(xbgr.mr_n53952240)
print v(xbgr.mr_n53953104)
print v(xbgr.mr_n53953216)
print v(xbgr.mr_n53953536)
print v(xbgr.mr_n53953648)
print v(xbgr.mr_n53953968)
print v(xbgr.mr_n53954832)
print v(xbgr.mr_n53955696)
print v(xbgr.mr_n53955808)
print v(xbgr.mr_n53956128)
print v(xbgr.mr_n53956240)
print v(xbgr.mr_n53956560)
print v(xbgr.mr_n53956672)
print v(xbgr.mr_n53956992)
print v(xbgr.mr_n53957104)
print v(xbgr.mr_n53957424)
print v(xbgr.mr_n53957536)
print v(xbgr.mr_n53957856)
print v(xbgr.mr_n53957968)
print v(xbgr.mr_n53958288)
print v(xbgr.mr_n53958400)
print v(xbgr.mr_n53958720)
print v(xbgr.mr_n53958832)
print v(xbgr.mr_n53959152)
print v(xbgr.mr_n53959264)
print v(xbgr.mr_n53959584)
print v(xbgr.mr_n53959696)
print v(xbgr.mr_n53960016)
print v(xbgr.mr_n53960128)
print v(xbgr.mr_n53960448)
print v(xbgr.mr_n53960560)
print v(xbgr.mr_n53960880)
print v(xbgr.mr_n53960992)
print v(xbgr.mr_n53961312)
print v(xbgr.mr_n53961424)
print v(xbgr.mr_n53961744)
print v(xbgr.mr_n53961856)
print v(xbgr.mr_n53962176)
print v(xbgr.mr_n53962288)
print v(xbgr.mr_n53962608)
print v(xbgr.mr_n53962720)
print v(xbgr.mr_n53963040)
print v(xbgr.mr_n53963152)
print v(xbgr.mr_n53963472)
print v(xbgr.mr_n53963584)
print v(xbgr.mr_n53963904)
print v(xbgr.mr_n53964016)
print v(xbgr.mr_n53964336)
print v(xbgr.mr_n53964448)
print v(xbgr.mr_n53964768)
print v(xbgr.mr_n53964880)
print v(xbgr.mr_n53965200)
print v(xbgr.mr_n53965312)
print v(xbgr.mr_n53965632)
print v(xbgr.mr_n53965744)
print v(xbgr.mr_n53966064)
print v(xbgr.mr_n53966176)
print v(xbgr.mr_n53966496)
print v(xbgr.mr_n53966608)
print v(xbgr.mr_n53967040)
print v(xbgr.mr_n53967472)
print v(xbgr.mr_n53967904)
print v(xbgr.mr_n53968336)
print v(xbgr.mr_n53968768)
print v(xbgr.mr_n53969200)
print v(xbgr.mr_n53969632)
print v(xbgr.mr_n53970064)
print v(xbgr.mr_n53970496)
print v(xbgr.mr_n53970928)
print v(xbgr.mr_n53971360)
print v(xbgr.mr_n53971792)
print v(xbgr.mr_n53972224)
print v(xbgr.mr_n53972656)
print v(xbgr.mr_n53973088)
print v(xbgr.mr_n53973520)
print v(xbgr.mr_n53973952)
print v(xbgr.mr_n53974384)
print v(xbgr.mr_n53974816)
print v(xbgr.mr_n53975248)
print v(xbgr.mr_n53975680)
print v(xbgr.mr_n53976112)
print v(xbgr.mr_n53976544)
print v(xbgr.mr_n53976976)
print v(xbgr.mr_n53977408)
print v(xbgr.mr_n53977840)
print v(xbgr.mr_n53978160)
print v(xbgr.mr_n53978272)
print v(xbgr.mr_n53978592)
print v(xbgr.mr_n53978704)
print v(xbgr.mr_n53979024)
print v(xbgr.mr_n53979136)
print v(xbgr.mr_n53979456)
print v(xbgr.mr_n53979568)
print v(xbgr.mr_n53979888)
print v(xbgr.mr_n53980000)
print v(xbgr.mr_n53980320)
print v(xbgr.mr_n53980432)
print v(xbgr.mr_n53980752)
print v(xbgr.mr_n53980864)
print v(xbgr.mr_n53981184)
print v(xbgr.mr_n53981296)
print v(xbgr.mr_n53981616)
print v(xbgr.mr_n53981728)
print v(xbgr.mr_n53982048)
print v(xbgr.mr_n53982160)
print v(xbgr.mr_n53982480)
print v(xbgr.mr_n53982592)
print v(xbgr.mr_n53982912)
print v(xbgr.mr_n53983024)
print v(xbgr.mr_n53983344)
print v(xbgr.mr_n53983456)
print v(xbgr.mr_n53983776)
print v(xbgr.mr_n53983888)
print v(xbgr.mr_n53984208)
print v(xbgr.mr_n53984320)
print v(xbgr.mr_n53984640)
print v(xbgr.mr_n53984752)
print v(xbgr.mr_n53985072)
print v(xbgr.mr_n53985184)
print v(xbgr.mr_n53985504)
print v(xbgr.mr_n53985616)
print v(xbgr.mr_n53985936)
print v(xbgr.mr_n53986048)
print v(xbgr.mr_n53986368)
print v(xbgr.mr_n53986480)
print v(xbgr.mr_n53986800)
print v(xbgr.mr_n53986912)
print v(xbgr.mr_n53987232)
print v(xbgr.mr_n53987344)
print v(xbgr.mr_n53987664)
print v(xbgr.mr_n53987776)
print v(xbgr.mr_n53988096)
print v(xbgr.mr_n53988208)
print v(xbgr.mr_n53988640)
print v(xbgr.mr_n53989072)
print v(xbgr.mr_n53989504)
print v(xbgr.mr_n53989936)
print v(xbgr.mr_n53990256)
print v(xbgr.mr_n53990368)
print v(xbgr.mr_n53990688)
print v(xbgr.mr_n53990800)
print v(xbgr.mr_n53991232)
print v(xbgr.mr_n53991664)
print v(xbgr.mr_n53992096)
print v(xbgr.mr_n53992528)
print v(xbgr.mr_n53992960)
print v(xbgr.mr_n53993392)
print v(xbgr.mr_n53993824)
print v(xbgr.mr_n53994256)
print v(xbgr.mr_n53994688)
print v(xbgr.mr_n53995120)
print v(xbgr.mr_n53995552)
print v(xbgr.mr_n53995984)
print v(xbgr.mr_n53996416)
print v(xbgr.mr_n53996848)
print v(xbgr.mr_n53997280)
print v(xbgr.mr_n53997712)
print v(xbgr.mr_n53998144)
print v(xbgr.mr_n53998576)
print v(xbgr.mr_n53999008)
print v(xbgr.mr_n53999440)
print v(xbgr.mr_n53999872)
print v(xbgr.mr_n54000304)
print v(xbgr.mr_n54000624)
print v(xbgr.mr_n54000736)
print v(xbgr.mr_n54001168)
print v(xbgr.mr_n54001488)
print v(xbgr.mr_n54001600)
print v(xbgr.mr_n54002032)
print v(xbgr.mr_n54002352)
print v(xbgr.mr_n54002464)
print v(xbgr.mr_n54002896)
print v(xbgr.mr_n54003216)
print v(xbgr.mr_n54003328)
print v(xbgr.mr_n54003760)
print v(xbgr.mr_n54004080)
print v(xbgr.mr_n54004192)
print v(xbgr.mr_n54004624)
print v(xbgr.mr_n54004944)
print v(xbgr.mr_n54005056)
print v(xbgr.mr_n54005376)
print v(xbgr.mr_n54005488)
print v(xbgr.mr_n54005808)
print v(xbgr.mr_n54005920)
print v(xbgr.mr_n54006352)
print v(xbgr.mr_n54006784)
print v(xbgr.mr_n54007216)
print v(xbgr.mr_n54007536)
print v(xbgr.mr_n54007648)
print v(xbgr.mr_n54007968)
print v(xbgr.mr_n54008080)
print v(xbgr.mr_n54008400)
print v(xbgr.mr_n54008512)
print v(xbgr.mr_n54008832)
print v(xbgr.mr_n54008944)
print v(xbgr.mr_n54009264)
print v(xbgr.mr_n54009376)
print v(xbgr.mr_n54009696)
print v(xbgr.mr_n54009808)
print v(xbgr.mr_n54010128)
print v(xbgr.mr_n54010240)
print v(xbgr.mr_n54010672)
print v(xbgr.mr_n54010992)
print v(xbgr.mr_n54011104)
print v(xbgr.mr_n54011536)
print v(xbgr.mr_n54011856)
print v(xbgr.mr_n54011968)
print v(xbgr.mr_n54012400)
print v(xbgr.mr_n54012720)
print v(xbgr.mr_n54013584)
print v(xbgr.mr_n54014448)
print v(xbgr.mr_n54015312)
print v(xbgr.mr_n54016176)
print v(xbgr.mr_n54017040)
print v(xbgr.mr_n54017904)
print v(xbgr.mr_n54018016)
print v(xbgr.mr_n54018336)
print v(xbgr.mr_n54018448)
print v(xbgr.mr_n54018768)
print v(xbgr.mr_n54018880)
print v(xbgr.mr_n54019200)
print v(xbgr.mr_n54019312)
print v(xbgr.mr_n54019632)
print v(xbgr.mr_n54020496)
print v(xbgr.mr_n54021360)
print v(xbgr.mr_n54022224)
print v(xbgr.mr_n54022336)
print v(xbgr.mr_n54022656)
print v(xbgr.mr_n54022768)
print v(xbgr.mr_n54023088)
print v(xbgr.mr_n54023200)
print v(xbgr.mr_n54023632)
print v(xbgr.mr_n54024064)
print v(xbgr.mr_n54024496)
print v(xbgr.mr_n54024816)
print v(xbgr.mr_n54024928)
print v(xbgr.mr_n54025248)
print v(xbgr.mr_n54025360)
print v(xbgr.mr_n54025680)
print v(xbgr.mr_n54025792)
print v(xbgr.mr_n54026112)
print v(xbgr.mr_n54026224)
print v(xbgr.mr_n54026544)
print v(xbgr.mr_n54026656)
print v(xbgr.mr_n54026976)
print v(xbgr.mr_n54027088)
print v(xbgr.mr_n54027408)
print v(xbgr.mr_n54027520)
print v(xbgr.mr_n54027840)
print v(xbgr.mr_n54027952)
print v(xbgr.mr_n54028272)
print v(xbgr.mr_n54028384)
print v(xbgr.mr_n54028816)
print v(xbgr.mr_n54029136)
print v(xbgr.mr_n54029248)
print v(xbgr.mr_n54029680)
print v(xbgr.mr_n54030000)
print v(xbgr.mr_n54030112)
print v(xbgr.mr_n54030432)
print v(xbgr.mr_n54030544)
print v(xbgr.mr_n54030864)
print v(xbgr.mr_n54031728)
print v(xbgr.mr_n54032592)
print v(xbgr.mr_n54032704)
print v(xbgr.mr_n54033024)
print v(xbgr.mr_n54033136)
print v(xbgr.mr_n54033456)
print v(xbgr.mr_n54034320)
print v(xbgr.mr_n54034864)
print v(xbgr.mr_n54035296)
print v(xbgr.mr_n54036048)
print v(xbgr.mr_n54036912)
print v(xbgr.mr_n54037024)
print v(xbgr.mr_n54037344)
print v(xbgr.mr_n54037456)
print v(xbgr.mr_n54037776)
print v(xbgr.mr_n54037888)
print v(xbgr.mr_n54038208)
print v(xbgr.mr_n54038320)
print v(xbgr.mr_n54038640)
print v(xbgr.mr_n54038752)
print v(xbgr.mr_n54039072)
print v(xbgr.mr_n54039184)
print v(xbgr.mr_n54039504)
print v(xbgr.mr_n54039616)
print v(xbgr.mr_n54039936)
print v(xbgr.mr_n54040048)
print v(xbgr.mr_n54040368)
print v(xbgr.mr_n54041232)
print v(xbgr.mr_n54041344)
print v(xbgr.mr_n54041664)
print v(xbgr.mr_n54041776)
print v(xbgr.mr_n54042096)
print v(xbgr.mr_n54042960)
print v(xbgr.mr_n54043824)
print v(xbgr.mr_n54043936)
print v(xbgr.mr_n54044256)
print v(xbgr.mr_n54044368)
print v(xbgr.mr_n54044688)
print v(xbgr.mr_n54044800)
print v(xbgr.mr_n54045232)
print v(xbgr.mr_n54045552)
print v(xbgr.mr_n54045984)
print v(xbgr.mr_n54047280)
print v(xbgr.mr_n54047392)
print v(xbgr.mr_n54047712)
print v(xbgr.mr_n54047824)
print v(xbgr.mr_n54048144)
print v(xbgr.mr_n54048256)
print v(xbgr.mr_n54048576)
print v(xbgr.mr_n54048688)
print v(xbgr.mr_n54049008)
print v(xbgr.mr_n54049120)
print v(xbgr.mr_n54049552)
print v(xbgr.mr_n54049872)
print v(xbgr.mr_n54049984)
print v(xbgr.mr_n54050304)
print v(xbgr.mr_n54050416)
print v(xbgr.mr_n54050736)
print v(xbgr.mr_n54050848)
print v(xbgr.mr_n54051168)
print v(xbgr.mr_n54051280)
print v(xbgr.mr_n54051600)
print v(xbgr.mr_n54052464)
print v(xbgr.mr_n54053328)
print v(xbgr.mr_n54054192)
print v(xbgr.mr_n54055056)
print v(xbgr.mr_n54055168)
print v(xbgr.mr_n54055488)
print v(xbgr.mr_n54055600)
print v(xbgr.mr_n54055920)
print v(xbgr.mr_n54056032)
print v(xbgr.mr_n54056352)
print v(xbgr.mr_n54056464)
print v(xbgr.mr_n54056784)
print v(xbgr.mr_n54057648)
print v(xbgr.mr_n54058512)
print v(xbgr.mr_n54059376)
print v(xbgr.mr_n54060240)
print v(xbgr.mr_n54060672)
print v(xbgr.mr_n54060784)
print v(xbgr.mr_n54061104)
print v(xbgr.mr_n54061216)
print v(xbgr.mr_n54061536)
print v(xbgr.mr_n54061648)
print v(xbgr.mr_n54061968)
print v(xbgr.mr_n54062080)
print v(xbgr.mr_n54062400)
print v(xbgr.mr_n54062512)
print v(xbgr.mr_n54062832)
print v(xbgr.mr_n54062944)
print v(xbgr.mr_n54063264)
print v(xbgr.mr_n54063376)
print v(xbgr.mr_n54063696)
print v(xbgr.mr_n54063808)
print v(xbgr.mr_n54064240)
print v(xbgr.mr_n54064560)
print v(xbgr.mr_n54064672)
print v(xbgr.mr_n54065104)
print v(xbgr.mr_n54065424)
print v(xbgr.mr_n54065536)
print v(xbgr.mr_n54065968)
print v(xbgr.mr_n54066288)
print v(xbgr.mr_n54066400)
print v(xbgr.mr_n54066720)
print v(xbgr.mr_n54066832)
print v(xbgr.mr_n54067152)
print v(xbgr.mr_n54068016)
print v(xbgr.mr_n54068880)
print v(xbgr.mr_n54069744)
print v(xbgr.mr_n54070608)
print v(xbgr.mr_n54071472)
print v(xbgr.mr_n54072336)
print v(xbgr.mr_n54073200)
print v(xbgr.mr_n54074064)
print v(xbgr.mr_n54074928)
print v(xbgr.mr_n54075040)
print v(xbgr.mr_n54075360)
print v(xbgr.mr_n54075472)
print v(xbgr.mr_n54075792)
print v(xbgr.mr_n54076656)
print v(xbgr.mr_n54076768)
print v(xbgr.mr_n54077088)
print v(xbgr.mr_n54077200)
print v(xbgr.mr_n54077520)
print v(xbgr.mr_n54077632)
print v(xbgr.mr_n54077952)
print v(xbgr.mr_n54078064)
print v(xbgr.mr_n54078384)
print v(xbgr.mr_n54078496)
print v(xbgr.mr_n54078816)
print v(xbgr.mr_n54078928)
print v(xbgr.mr_n54079248)
print v(xbgr.mr_n54079360)
print v(xbgr.mr_n54079680)
print v(xbgr.mr_n54079792)
print v(xbgr.mr_n54080112)
print v(xbgr.mr_n54080976)
print v(xbgr.mr_n54081840)
print v(xbgr.mr_n54082704)
print v(xbgr.mr_n54082816)
print v(xbgr.mr_n54083136)
print v(xbgr.mr_n54084432)
print v(xbgr.mr_n54085296)
print v(xbgr.mr_n54086160)
print v(xbgr.mr_n54087024)
print v(xbgr.mr_n54087136)
print v(xbgr.mr_n54087456)
print v(xbgr.mr_n54087568)
print v(xbgr.mr_n54088000)
print v(xbgr.mr_n54088320)
print v(xbgr.mr_n54088432)
print v(xbgr.mr_n54088864)
print v(xbgr.mr_n54089184)
print v(xbgr.mr_n54089296)
print v(xbgr.mr_n54089728)
print v(xbgr.mr_n54090048)
print v(xbgr.mr_n54090160)
print v(xbgr.mr_n54090592)
print v(xbgr.mr_n54090912)
print v(xbgr.mr_n54091024)
print v(xbgr.mr_n54091456)
print v(xbgr.mr_n54091776)
print v(xbgr.mr_n54091888)
print v(xbgr.mr_n54092208)
print v(xbgr.mr_n54092320)
print v(xbgr.mr_n54092640)
print v(xbgr.mr_n54092752)
print v(xbgr.mr_n54093184)
print v(xbgr.mr_n54093504)
print v(xbgr.mr_n54093616)
print v(xbgr.mr_n54093936)
print v(xbgr.mr_n54094048)
print v(xbgr.mr_n54094368)
print v(xbgr.mr_n54094480)
print v(xbgr.mr_n54094800)
print v(xbgr.mr_n54094912)
print v(xbgr.mr_n54095232)
print v(xbgr.mr_n54095344)
print v(xbgr.mr_n54095664)
print v(xbgr.mr_n54095776)
print v(xbgr.mr_n54096096)
print v(xbgr.mr_n54096208)
print v(xbgr.mr_n54096528)
print v(xbgr.mr_n54096640)
print v(xbgr.mr_n54097072)
print v(xbgr.mr_n54097392)
print v(xbgr.mr_n54098368)
print v(xbgr.mr_n54098800)
print v(xbgr.mr_n54099120)
print v(xbgr.mr_n54099984)
print v(xbgr.mr_n54100096)
print v(xbgr.mr_n54100416)
print v(xbgr.mr_n54100528)
print v(xbgr.mr_n54100848)
print v(xbgr.mr_n54100960)
print v(xbgr.mr_n54101280)
print v(xbgr.mr_n54101392)
print v(xbgr.mr_n54101712)
print v(xbgr.mr_n54102576)
print v(xbgr.mr_n54103008)
print v(xbgr.mr_n54103872)
print v(xbgr.mr_n54104736)
print v(xbgr.mr_n54104848)
print v(xbgr.mr_n54105168)
print v(xbgr.mr_n54105280)
print v(xbgr.mr_n54105600)
print v(xbgr.mr_n54105712)
print v(xbgr.mr_n54106032)
print v(xbgr.mr_n54106144)
print v(xbgr.mr_n54106896)
print v(xbgr.mr_n54107008)
print v(xbgr.mr_n54107328)
print v(xbgr.mr_n54107440)
print v(xbgr.mr_n54107760)
print v(xbgr.mr_n54107872)
print v(xbgr.mr_n54108192)
print v(xbgr.mr_n54108304)
print v(xbgr.mr_n54108624)
print v(xbgr.mr_n54109168)
print v(xbgr.mr_n54109488)
print v(xbgr.mr_n54109600)
print v(xbgr.mr_n54110032)
print v(xbgr.mr_n54110352)
print v(xbgr.mr_n54110464)
print v(xbgr.mr_n54111648)
print v(xbgr.mr_n54112080)
print v(xbgr.mr_n54112192)
print v(xbgr.mr_n54112512)
print v(xbgr.mr_n54112624)
print v(xbgr.mr_n54112944)
print v(xbgr.mr_n54113056)
print v(xbgr.mr_n54113376)
print v(xbgr.mr_n54113488)
print v(xbgr.mr_n54113808)
print v(xbgr.mr_n54113920)
print v(xbgr.mr_n54114240)
print v(xbgr.mr_n54114352)
print v(xbgr.mr_n54115104)
print v(xbgr.mr_n54115968)
print v(xbgr.mr_n54116080)
print v(xbgr.mr_n54116400)
print v(xbgr.mr_n54116512)
print v(xbgr.mr_n54116832)
print v(xbgr.mr_n54116944)
print v(xbgr.mr_n54117264)
print v(xbgr.mr_n54117376)
print v(xbgr.mr_n54117696)
print v(xbgr.mr_n54117808)
print v(xbgr.mr_n54118128)
print v(xbgr.mr_n54118240)
print v(xbgr.mr_n54118560)
print v(xbgr.mr_n54118672)
print v(xbgr.mr_n54118992)
print v(xbgr.mr_n54119104)
print v(xbgr.mr_n54119424)
print v(xbgr.mr_n54120288)
print v(xbgr.mr_n54121152)
print v(xbgr.mr_n54122016)
print v(xbgr.mr_n54122128)
print v(xbgr.mr_n54122560)
print v(xbgr.mr_n54122992)
print v(xbgr.mr_n54123312)
print v(xbgr.mr_n54123744)
print v(xbgr.mr_n54123856)
print v(xbgr.mr_n54124176)
print v(xbgr.mr_n54124288)
print v(xbgr.mr_n54125040)
print v(xbgr.mr_n54126448)
print v(xbgr.mr_n54126768)
print v(xbgr.mr_n54126880)
print v(xbgr.mr_n54127200)
print v(xbgr.mr_n54127312)
print v(xbgr.mr_n54127632)
print v(xbgr.mr_n54127744)
print v(xbgr.mr_n54128176)
print v(xbgr.mr_n54128496)
print v(xbgr.mr_n54128608)
print v(xbgr.mr_n54129040)
print v(xbgr.mr_n54129360)
print v(xbgr.mr_n54129792)
print v(xbgr.mr_n54130224)
print v(xbgr.mr_n54130336)
print v(xbgr.mr_n54130656)
print v(xbgr.mr_n54130768)
print v(xbgr.mr_n54131088)
print v(xbgr.mr_n54131200)
print v(xbgr.mr_n54131952)
print v(xbgr.mr_n54132816)
print v(xbgr.mr_n54132928)
print v(xbgr.mr_n54133360)
print v(xbgr.mr_n54133680)
print v(xbgr.mr_n54134544)
print v(xbgr.mr_n54135408)
print v(xbgr.mr_n54136704)
print v(xbgr.mr_n54137136)
print v(xbgr.mr_n54137248)
print v(xbgr.mr_n54137568)
print v(xbgr.mr_n54137680)
print v(xbgr.mr_n54138000)
print v(xbgr.mr_n54138112)
print v(xbgr.mr_n54138432)
print v(xbgr.mr_n54138544)
print v(xbgr.mr_n54138864)
print v(xbgr.mr_n54138976)
print v(xbgr.mr_n54139296)
print v(xbgr.mr_n54139408)
print v(xbgr.mr_n54139728)
print v(xbgr.mr_n54139840)
print v(xbgr.mr_n54140160)
print v(xbgr.mr_n54140272)
print v(xbgr.mr_n54141024)
print v(xbgr.mr_n54141888)
print v(xbgr.mr_n54142752)
print v(xbgr.mr_n54142864)
print v(xbgr.mr_n54143184)
print v(xbgr.mr_n54143296)
print v(xbgr.mr_n54143616)
print v(xbgr.mr_n54143728)
print v(xbgr.mr_n54144048)
print v(xbgr.mr_n54144912)
print v(xbgr.mr_n54145776)
print v(xbgr.mr_n54146640)
print v(xbgr.mr_n54147504)
print v(xbgr.mr_n54148368)
print v(xbgr.mr_n54149232)
print v(xbgr.mr_n54149344)
print v(xbgr.mr_n54149664)
print v(xbgr.mr_n54150528)
print v(xbgr.mr_n54150640)
print v(xbgr.mr_n54150960)
print v(xbgr.mr_n54151072)
print v(xbgr.mr_n54151392)
print v(xbgr.mr_n54152256)
print v(xbgr.mr_n54152688)
print v(xbgr.mr_n54152800)
print v(xbgr.mr_n54153552)
print v(xbgr.mr_n54153664)
print v(xbgr.mr_n54153984)
print v(xbgr.mr_n54154096)
print v(xbgr.mr_n54154416)
print v(xbgr.mr_n54154528)
print v(xbgr.mr_n54154848)
print v(xbgr.mr_n54154960)
print v(xbgr.mr_n54155280)
print v(xbgr.mr_n54155392)
print v(xbgr.mr_n54155712)
print v(xbgr.mr_n54155824)
print v(xbgr.mr_n54156144)
print v(xbgr.mr_n54156256)
print v(xbgr.mr_n54156576)
print v(xbgr.mr_n54156688)
print v(xbgr.mr_n54157008)
print v(xbgr.mr_n54157120)
print v(xbgr.mr_n54157440)
print v(xbgr.mr_n54157984)
print v(xbgr.mr_n54158736)
print v(xbgr.mr_n54159600)
print v(xbgr.mr_n54160464)
print v(xbgr.mr_n54160576)
print v(xbgr.mr_n54161008)
print v(xbgr.mr_n54161328)
print v(xbgr.mr_n54162192)
print v(xbgr.mr_n54163056)
print v(xbgr.mr_n54163920)
print v(xbgr.mr_n54164784)
print v(xbgr.mr_n54165648)
print v(xbgr.mr_n54166512)
print v(xbgr.mr_n54166624)
print v(xbgr.mr_n54166944)
print v(xbgr.mr_n54167056)
print v(xbgr.mr_n54167376)
print v(xbgr.mr_n54168240)
print v(xbgr.mr_n54169104)
print v(xbgr.mr_n54169216)
print v(xbgr.mr_n54169536)
print v(xbgr.mr_n54169648)
print v(xbgr.mr_n54169968)
print v(xbgr.mr_n54170080)
print v(xbgr.mr_n54170400)
print v(xbgr.mr_n54170512)
print v(xbgr.mr_n54170832)
print v(xbgr.mr_n54170944)
print v(xbgr.mr_n54171264)
print v(xbgr.mr_n54171376)
print v(xbgr.mr_n54171696)
print v(xbgr.mr_n54171808)
print v(xbgr.mr_n54172128)
print v(xbgr.mr_n54172992)
print v(xbgr.mr_n54173104)
print v(xbgr.mr_n54173424)
print v(xbgr.mr_n54173536)
print v(xbgr.mr_n54173856)
print v(xbgr.mr_n54173968)
print v(xbgr.mr_n54174288)
print v(xbgr.mr_n54174400)
print v(xbgr.mr_n54174720)
print v(xbgr.mr_n54174832)
print v(xbgr.mr_n54175152)
print v(xbgr.mr_n54175264)
print v(xbgr.mr_n54175584)
print v(xbgr.mr_n54175696)
print v(xbgr.mr_n54176016)
print v(xbgr.mr_n54176128)
print v(xbgr.mr_n54176560)
print v(xbgr.mr_n54176992)
print v(xbgr.mr_n54177424)
print v(xbgr.mr_n54177744)
print v(xbgr.mr_n54177856)
print v(xbgr.mr_n54178176)
print v(xbgr.mr_n54178288)
print v(xbgr.mr_n54178608)
print v(xbgr.mr_n54178720)
print v(xbgr.mr_n54179040)
print v(xbgr.mr_n54179152)
print v(xbgr.mr_n54179472)
print v(xbgr.mr_n54179584)
print v(xbgr.mr_n54179904)
print v(xbgr.mr_n54180016)
print v(xbgr.mr_n54180336)
print v(xbgr.mr_n54180448)
print v(xbgr.mr_n54180768)
print v(xbgr.mr_n54180880)
print v(xbgr.mr_n54181200)
print v(xbgr.mr_n54181312)
print v(xbgr.mr_n54181632)
print v(xbgr.mr_n54181744)
print v(xbgr.mr_n54182064)
print v(xbgr.mr_n54182176)
print v(xbgr.mr_n54182496)
print v(xbgr.mr_n54182608)
print v(xbgr.mr_n54182928)
print v(xbgr.mr_n54183040)
print v(xbgr.mr_n54183360)
print v(xbgr.mr_n54183472)
print v(xbgr.mr_n54183792)
print v(xbgr.mr_n54183904)
print v(xbgr.mr_n54184224)
print v(xbgr.mr_n54184336)
print v(xbgr.mr_n54184768)
print v(xbgr.mr_n54185088)
print v(xbgr.mr_n54185200)
print v(xbgr.mr_n54185632)
print v(xbgr.mr_n54186064)
print v(xbgr.mr_n54186384)
print v(xbgr.mr_n54186496)
print v(xbgr.mr_n54186816)
print v(xbgr.mr_n54186928)
print v(xbgr.mr_n54187248)
print v(xbgr.mr_n54187360)
print v(xbgr.mr_n54187680)
print v(xbgr.mr_n54187792)
print v(xbgr.mr_n54188224)
print v(xbgr.mr_n54188656)
print v(xbgr.mr_n54189088)
print v(xbgr.mr_n54189520)
print v(xbgr.mr_n54189952)
print v(xbgr.mr_n54190384)
print v(xbgr.mr_n54190816)
print v(xbgr.mr_n54191248)
print v(xbgr.mr_n54191568)
print v(xbgr.mr_n54191680)
print v(xbgr.mr_n54192000)
print v(xbgr.mr_n54192112)
print v(xbgr.mr_n54192432)
print v(xbgr.mr_n54192544)
print v(xbgr.mr_n54192864)
print v(xbgr.mr_n54192976)
print v(xbgr.mr_n54193296)
print v(xbgr.mr_n54193408)
print v(xbgr.mr_n54193728)
print v(xbgr.mr_n54193840)
print v(xbgr.mr_n54194160)
print v(xbgr.mr_n54194272)
print v(xbgr.mr_n54194592)
print v(xbgr.mr_n54194704)
print v(xbgr.mr_n54195024)
print v(xbgr.mr_n54195136)
print v(xbgr.mr_n54195456)
print v(xbgr.mr_n54195568)
print v(xbgr.mr_n54195888)
print v(xbgr.mr_n54196000)
print v(xbgr.mr_n54196320)
print v(xbgr.mr_n54196432)
print v(xbgr.mr_n54196752)
print v(xbgr.mr_n54196864)
print v(xbgr.mr_n54197184)
print v(xbgr.mr_n54197296)
print v(xbgr.mr_n54197616)
print v(xbgr.mr_n54197728)
print v(xbgr.mr_n54198048)
print v(xbgr.mr_n54198160)
print v(xbgr.mr_n54198480)
print v(xbgr.mr_n54198592)
print v(xbgr.mr_n54198912)
print v(xbgr.mr_n54199024)
print v(xbgr.mr_n54199344)
print v(xbgr.mr_n54199456)
print v(xbgr.mr_n54199776)
print v(xbgr.mr_n54199888)
print v(xbgr.mr_n54200208)
print v(xbgr.mr_n54200320)
print v(xbgr.mr_n54200640)
print v(xbgr.mr_n54200752)
print v(xbgr.mr_n54201072)
print v(xbgr.mr_n54201184)
print v(xbgr.mr_n54201504)
print v(xbgr.mr_n54201616)
print v(xbgr.mr_n54202048)
print v(xbgr.mr_n54202480)
print v(xbgr.mr_n54202800)
print v(xbgr.mr_n54202912)
print v(xbgr.mr_n54203232)
print v(xbgr.mr_n54203344)
print v(xbgr.mr_n54203776)
print v(xbgr.mr_n54204208)
print v(xbgr.mr_n54204640)
print v(xbgr.mr_n54205072)
print v(xbgr.mr_n54205504)
print v(xbgr.mr_n54205936)
print v(xbgr.mr_n54206368)
print v(xbgr.mr_n54206800)
print v(xbgr.mr_n54207232)
print v(xbgr.mr_n54207664)
print v(xbgr.mr_n54208096)
print v(xbgr.mr_n54208528)
print v(xbgr.mr_n54208960)
print v(xbgr.mr_n54209392)
print v(xbgr.mr_n54209824)
print v(xbgr.mr_n54210256)
print v(xbgr.mr_n54210688)
print v(xbgr.mr_n54211120)
print v(xbgr.mr_n54211552)
print v(xbgr.mr_n54211984)
print v(xbgr.mr_n54212416)
print v(xbgr.mr_n54212848)
print v(xbgr.mr_n54213280)
print v(xbgr.mr_n54213712)
print v(xbgr.mr_n54214032)
print v(xbgr.mr_n54214144)
print v(xbgr.mr_n54214464)
print v(xbgr.mr_n54214576)
print v(xbgr.mr_n54214896)
print v(xbgr.mr_n54215008)
print v(xbgr.mr_n54215328)
print v(xbgr.mr_n54215440)
print v(xbgr.mr_n54215760)
print v(xbgr.mr_n54215872)
print v(xbgr.mr_n54216192)
print v(xbgr.mr_n54216304)
print v(xbgr.mr_n54216624)
print v(xbgr.mr_n54216736)
print v(xbgr.mr_n54217056)
print v(xbgr.mr_n54217168)
print v(xbgr.mr_n54217488)
print v(xbgr.mr_n54217600)
print v(xbgr.mr_n54217920)
print v(xbgr.mr_n54218032)
print v(xbgr.mr_n54218352)
print v(xbgr.mr_n54218464)
print v(xbgr.mr_n54218784)
print v(xbgr.mr_n54218896)
print v(xbgr.mr_n54219216)
print v(xbgr.mr_n54219328)
print v(xbgr.mr_n54219760)
print v(xbgr.mr_n54220192)
print v(xbgr.mr_n54220624)
print v(xbgr.mr_n54221056)
print v(xbgr.mr_n54221488)
print v(xbgr.mr_n54221920)
print v(xbgr.mr_n54222352)
print v(xbgr.mr_n54222784)
print v(xbgr.mr_n54223216)
print v(xbgr.mr_n54223648)
print v(xbgr.mr_n54224080)
print v(xbgr.mr_n54224512)
print v(xbgr.mr_n54224944)
print v(xbgr.mr_n54225264)
print v(xbgr.mr_n54225376)
print v(xbgr.mr_n54225696)
print v(xbgr.mr_n54225808)
print v(xbgr.mr_n54226128)
print v(xbgr.mr_n54226240)
print v(xbgr.mr_n54226560)
print v(xbgr.mr_n54226672)
print v(xbgr.mr_n54226992)
print v(xbgr.mr_n54227104)
print v(xbgr.mr_n54227424)
print v(xbgr.mr_n54227536)
print v(xbgr.mr_n54227856)
print v(xbgr.mr_n54227968)
print v(xbgr.mr_n54228288)
print v(xbgr.mr_n54228400)
print v(xbgr.mr_n54228720)
print v(xbgr.mr_n54228832)
print v(xbgr.mr_n54229152)
print v(xbgr.mr_n54229264)
print v(xbgr.mr_n54229584)
print v(xbgr.mr_n54229696)
print v(xbgr.mr_n54230016)
print v(xbgr.mr_n54230128)
print v(xbgr.mr_n54230448)
print v(xbgr.mr_n54230560)
print v(xbgr.mr_n54230992)
print v(xbgr.mr_n54231424)
print v(xbgr.mr_n54231856)
print v(xbgr.mr_n54232288)
print v(xbgr.mr_n54232720)
print v(xbgr.mr_n54233152)
print v(xbgr.mr_n54233584)
print v(xbgr.mr_n54234016)
print v(xbgr.mr_n54234448)
print v(xbgr.mr_n54234880)
print v(xbgr.mr_n54235312)
print v(xbgr.mr_n54235744)
print v(xbgr.mr_n54236176)
print v(xbgr.mr_n54236496)
print v(xbgr.mr_n54236608)
print v(xbgr.mr_n54236928)
print v(xbgr.mr_n54237040)
print v(xbgr.mr_n54237360)
print v(xbgr.mr_n54237472)
print v(xbgr.mr_n54237792)
print v(xbgr.mr_n54237904)
print v(xbgr.mr_n54238224)
print v(xbgr.mr_n54238336)
print v(xbgr.mr_n54238656)
print v(xbgr.mr_n54238768)
print v(xbgr.mr_n54239088)
print v(xbgr.mr_n54239200)
print v(xbgr.mr_n54239520)
print v(xbgr.mr_n54239632)
print v(xbgr.mr_n54239952)
print v(xbgr.mr_n54240064)
print v(xbgr.mr_n54240384)
print v(xbgr.mr_n54240496)
print v(xbgr.mr_n54240816)
print v(xbgr.mr_n54240928)
print v(xbgr.mr_n54241248)
print v(xbgr.mr_n54241360)
print v(xbgr.mr_n54241680)
print v(xbgr.mr_n54241792)
print v(xbgr.mr_n54242224)
print v(xbgr.mr_n54242656)
print v(xbgr.mr_n54243088)
print v(xbgr.mr_n54243520)
print v(xbgr.mr_n54243952)
print v(xbgr.mr_n54244384)
print v(xbgr.mr_n54244816)
print v(xbgr.mr_n54245248)
print v(xbgr.mr_n54245680)
print v(xbgr.mr_n54246112)
print v(xbgr.mr_n54246544)
print v(xbgr.mr_n54246976)
print v(xbgr.mr_n54247408)
print v(xbgr.mr_n54247728)
print v(xbgr.mr_n54247840)
print v(xbgr.mr_n54248160)
print v(xbgr.mr_n54248272)
print v(xbgr.mr_n54248592)
print v(xbgr.mr_n54248704)
print v(xbgr.mr_n54249024)
print v(xbgr.mr_n54249136)
print v(xbgr.mr_n54249456)
print v(xbgr.mr_n54249568)
print v(xbgr.mr_n54249888)
print v(xbgr.mr_n54250000)
print v(xbgr.mr_n54250320)
print v(xbgr.mr_n54250432)
print v(xbgr.mr_n54250864)
print v(xbgr.mr_n54251296)
print v(xbgr.mr_n54251728)
print v(xbgr.mr_n54252160)
print v(xbgr.mr_n54252480)
print v(xbgr.mr_n54252592)
print v(xbgr.mr_n54252912)
print v(xbgr.mr_n54253024)
print v(xbgr.mr_n54253344)
print v(xbgr.mr_n54253456)
print v(xbgr.mr_n54253776)
print v(xbgr.mr_n54253888)
print v(xbgr.mr_n54254208)
print v(xbgr.mr_n54254320)
print v(xbgr.mr_n54254640)
print v(xbgr.mr_n54254752)
print v(xbgr.mr_n54255184)
print v(xbgr.mr_n54255616)
print v(xbgr.mr_n54256048)
print v(xbgr.mr_n54256480)
print v(xbgr.mr_n54256912)
print v(xbgr.mr_n54257344)
print v(xbgr.mr_n54257776)
print v(xbgr.mr_n54258208)
print v(xbgr.mr_n54258640)
print v(xbgr.mr_n54258960)
print v(xbgr.mr_n54259072)
print v(xbgr.mr_n54259392)
print v(xbgr.mr_n54259504)
print v(xbgr.mr_n54259824)
print v(xbgr.mr_n54259936)
print v(xbgr.mr_n54260256)
print v(xbgr.mr_n54260368)
print v(xbgr.mr_n54260688)
print v(xbgr.mr_n54260800)
print v(xbgr.mr_n54261120)
print v(xbgr.mr_n54261232)
print v(xbgr.mr_n54261552)
print v(xbgr.mr_n54261664)
print v(xbgr.mr_n54261984)
print v(xbgr.mr_n54262096)
print v(xbgr.mr_n54262416)
print v(xbgr.mr_n54262528)
print v(xbgr.mr_n54262848)
print v(xbgr.mr_n54262960)
print v(xbgr.mr_n54263280)
print v(xbgr.mr_n54263392)
print v(xbgr.mr_n54263712)
print v(xbgr.mr_n54263824)
print v(xbgr.mr_n54264144)
print v(xbgr.mr_n54264256)
print v(xbgr.mr_n54264576)
print v(xbgr.mr_n54264688)
print v(xbgr.mr_n54265120)
print v(xbgr.mr_n54265552)
print v(xbgr.mr_n54265984)
print v(xbgr.mr_n54266416)
print v(xbgr.mr_n54266736)
print v(xbgr.mr_n54266848)
print v(xbgr.mr_n54267168)
print v(xbgr.mr_n54267280)
print v(xbgr.mr_n54267712)
print v(xbgr.mr_n54268144)
print v(xbgr.mr_n54268576)
print v(xbgr.mr_n54269008)
print v(xbgr.mr_n54269440)
print v(xbgr.mr_n54269872)
print v(xbgr.mr_n54270304)
print v(xbgr.mr_n54270736)
print v(xbgr.mr_n54271056)
print v(xbgr.mr_n54271168)
print v(xbgr.mr_n54271488)
print v(xbgr.mr_n54271600)
print v(xbgr.mr_n54271920)
print v(xbgr.mr_n54272032)
print v(xbgr.mr_n54272352)
print v(xbgr.mr_n54272464)
print v(xbgr.mr_n54272784)
print v(xbgr.mr_n54272896)
print v(xbgr.mr_n54273216)
print v(xbgr.mr_n54273328)
print v(xbgr.mr_n54273648)
print v(xbgr.mr_n54273760)
print v(xbgr.mr_n54274080)
print v(xbgr.mr_n54274192)
print v(xbgr.mr_n54274512)
print v(xbgr.mr_n54274624)
print v(xbgr.mr_n54274944)
print v(xbgr.mr_n54275056)
print v(xbgr.mr_n54275376)
print v(xbgr.mr_n54275488)
print v(xbgr.mr_n54275808)
print v(xbgr.mr_n54275920)
print v(xbgr.mr_n54276352)
print v(xbgr.mr_n54276784)
print v(xbgr.mr_n54277216)
print v(xbgr.mr_n54277648)
print v(xbgr.mr_n54278080)
print v(xbgr.mr_n54278512)
print v(xbgr.mr_n54278832)
print v(xbgr.mr_n54278944)
print v(xbgr.mr_n54279264)
print v(xbgr.mr_n54279376)
print v(xbgr.mr_n54279696)
print v(xbgr.mr_n54279808)
print v(xbgr.mr_n54280128)
print v(xbgr.mr_n54280240)
print v(xbgr.mr_n54280560)
print v(xbgr.mr_n54280672)
print v(xbgr.mr_n54280992)
print v(xbgr.mr_n54281104)
print v(xbgr.mr_n54281424)
print v(xbgr.mr_n54281536)
print v(xbgr.mr_n54281856)
print v(xbgr.mr_n54281968)
print v(xbgr.mr_n54282288)
print v(xbgr.mr_n54282400)
print v(xbgr.mr_n54282720)
print v(xbgr.mr_n54282832)
print v(xbgr.mr_n54283152)
print v(xbgr.mr_n54283264)
print v(xbgr.mr_n54283584)
print v(xbgr.mr_n54283696)
print v(xbgr.mr_n54284016)
print v(xbgr.mr_n54284128)
print v(xbgr.mr_n54284448)
print v(xbgr.mr_n54284560)
print v(xbgr.mr_n54284880)
print v(xbgr.mr_n54284992)
print v(xbgr.mr_n54285312)
print v(xbgr.mr_n54285424)
print v(xbgr.mr_n54285744)
print v(xbgr.mr_n54285856)
print v(xbgr.mr_n54286176)
print v(xbgr.mr_n54286288)
print v(xbgr.mr_n54286720)
print v(xbgr.mr_n54287152)
print v(xbgr.mr_n54287472)
print v(xbgr.mr_n54287584)
print v(xbgr.mr_n54287904)
print v(xbgr.mr_n54288016)
print v(xbgr.mr_n54288336)
print v(xbgr.mr_n54288448)
print v(xbgr.mr_n54288768)
print v(xbgr.mr_n54288880)
print v(xbgr.mr_n54289312)
print v(xbgr.mr_n54289744)
print v(xbgr.mr_n54290176)
print v(xbgr.mr_n54290608)
print v(xbgr.mr_n54291040)
print v(xbgr.mr_n54291472)
print v(xbgr.mr_n54291904)
print v(xbgr.mr_n54292336)
print v(xbgr.mr_n54292768)
print v(xbgr.mr_n54293200)
print v(xbgr.mr_n54293632)
print v(xbgr.mr_n54294064)
print v(xbgr.mr_n54294496)
print v(xbgr.mr_n54294928)
print v(xbgr.mr_n54295360)
print v(xbgr.mr_n54295792)
print v(xbgr.mr_n54296112)
print v(xbgr.mr_n54296224)
print v(xbgr.mr_n54296544)
print v(xbgr.mr_n54296656)
print v(xbgr.mr_n54296976)
print v(xbgr.mr_n54297088)
print v(xbgr.mr_n54297408)
print v(xbgr.mr_n54297520)
print v(xbgr.mr_n54297840)
print v(xbgr.mr_n54297952)
print v(xbgr.mr_n54298272)
print v(xbgr.mr_n54298384)
print v(xbgr.mr_n54298704)
print v(xbgr.mr_n54298816)
print v(xbgr.mr_n54299136)
print v(xbgr.mr_n54299248)
print v(xbgr.mr_n54299568)
print v(xbgr.mr_n54299680)
print v(xbgr.mr_n54300000)
print v(xbgr.mr_n54300112)
print v(xbgr.mr_n54300544)
print v(xbgr.mr_n54300976)
print v(xbgr.mr_n54301408)
print v(xbgr.mr_n54301840)
print v(xbgr.mr_n54302272)
print v(xbgr.mr_n54302704)
print v(xbgr.mr_n54303136)
print v(xbgr.mr_n54303568)
print v(xbgr.mr_n54303888)
print v(xbgr.mr_n54304000)
print v(xbgr.mr_n54304320)
print v(xbgr.mr_n54304432)
print v(xbgr.mr_n54304752)
print v(xbgr.mr_n54304864)
print v(xbgr.mr_n54305184)
print v(xbgr.mr_n54305296)
print v(xbgr.mr_n54305616)
print v(xbgr.mr_n54305728)
print v(xbgr.mr_n54306048)
print v(xbgr.mr_n54306160)
print v(xbgr.mr_n54306480)
print v(xbgr.mr_n54306592)
print v(xbgr.mr_n54306912)
print v(xbgr.mr_n54307024)
print v(xbgr.mr_n54307344)
print v(xbgr.mr_n54307456)
print v(xbgr.mr_n54307776)
print v(xbgr.mr_n54307888)
print v(xbgr.mr_n54308208)
print v(xbgr.mr_n54308320)
print v(xbgr.mr_n54308640)
print v(xbgr.mr_n54308752)
print v(xbgr.mr_n54309072)
print v(xbgr.mr_n54309184)
print v(xbgr.mr_n54309504)
print v(xbgr.mr_n54309616)
print v(xbgr.mr_n54310048)
print v(xbgr.mr_n54310480)
print v(xbgr.mr_n54310912)
print v(xbgr.mr_n54311344)
print v(xbgr.mr_n54311776)
print v(xbgr.mr_n54312208)
print v(xbgr.mr_n54312640)
print v(xbgr.mr_n54313072)
print v(xbgr.mr_n54313504)
print v(xbgr.mr_n54313936)
print v(xbgr.mr_n54314368)
print v(xbgr.mr_n54314800)
print v(xbgr.mr_n54315232)
print v(xbgr.mr_n54315664)
print v(xbgr.mr_n54315984)
print v(xbgr.mr_n54316096)
print v(xbgr.mr_n54316416)
print v(xbgr.mr_n54316528)
print v(xbgr.mr_n54316848)
print v(xbgr.mr_n54316960)
print v(xbgr.mr_n54317280)
print v(xbgr.mr_n54317392)
print v(xbgr.mr_n54317712)
print v(xbgr.mr_n54317824)
print v(xbgr.mr_n54318144)
print v(xbgr.mr_n54318256)
print v(xbgr.mr_n54318576)
print v(xbgr.mr_n54318688)
print v(xbgr.mr_n54319008)
print v(xbgr.mr_n54319120)
print v(xbgr.mr_n54319440)
print v(xbgr.mr_n54319552)
print v(xbgr.mr_n54319872)
print v(xbgr.mr_n54319984)
print v(xbgr.mr_n54320304)
print v(xbgr.mr_n54320416)
print v(xbgr.mr_n54320736)
print v(xbgr.mr_n54320848)
print v(xbgr.mr_n54321168)
print v(xbgr.mr_n54321280)
print v(xbgr.mr_n54321600)
print v(xbgr.mr_n54321712)
print v(xbgr.mr_n54322032)
print v(xbgr.mr_n54322144)
print v(xbgr.mr_n54322464)
print v(xbgr.mr_n54322576)
print v(xbgr.mr_n54322896)
print v(xbgr.mr_n54323008)
print v(xbgr.mr_n54323328)
print v(xbgr.mr_n54323440)
print v(xbgr.mr_n54323760)
print v(xbgr.mr_n54323872)
print v(xbgr.mr_n54324192)
print v(xbgr.mr_n54324304)
print v(xbgr.mr_n54324624)
print v(xbgr.mr_n54324736)
print v(xbgr.mr_n54325056)
print v(xbgr.mr_n54325168)
print v(xbgr.mr_n54325488)
print v(xbgr.mr_n54325600)
print v(xbgr.mr_n54325920)
print v(xbgr.mr_n54326032)
print v(xbgr.mr_n54326464)
print v(xbgr.mr_n54326896)
print v(xbgr.mr_n54327328)
print v(xbgr.mr_n54327760)
print v(xbgr.mr_n54328192)
print v(xbgr.mr_n54328624)
print v(xbgr.mr_n54329056)
print v(xbgr.mr_n54329488)
print v(xbgr.mr_n54329920)
print v(xbgr.mr_n54330352)
print v(xbgr.mr_n54330784)
print v(xbgr.mr_n54331216)
print v(xbgr.mr_n54331648)
print v(xbgr.mr_n54332080)
print v(xbgr.mr_n54332512)
print v(xbgr.mr_n54332944)
print v(xbgr.mr_n54333264)
print v(xbgr.mr_n54333376)
print v(xbgr.mr_n54333696)
print v(xbgr.mr_n54333808)
print v(xbgr.mr_n54334240)
print v(xbgr.mr_n54334672)
print v(xbgr.mr_n54335104)
print v(xbgr.mr_n54335536)
print v(xbgr.mr_n54335968)
print v(xbgr.mr_n54336400)
print v(xbgr.mr_n54336832)
print v(xbgr.mr_n54337264)
print v(xbgr.mr_n54337696)
print v(xbgr.mr_n54338128)
print v(xbgr.mr_n54338448)
print v(xbgr.mr_n54338560)
print v(xbgr.mr_n54338880)
print v(xbgr.mr_n54338992)
print v(xbgr.mr_n54339312)
print v(xbgr.mr_n54339424)
print v(xbgr.mr_n54339744)
print v(xbgr.mr_n54339856)
print v(xbgr.mr_n54340176)
print v(xbgr.mr_n54340288)
print v(xbgr.mr_n54340608)
print v(xbgr.mr_n54340720)
print v(xbgr.mr_n54341040)
print v(xbgr.mr_n54341152)
print v(xbgr.mr_n54341472)
print v(xbgr.mr_n54341584)
print v(xbgr.mr_n54341904)
print v(xbgr.mr_n54342016)
print v(xbgr.mr_n54342336)
print v(xbgr.mr_n54342448)
print v(xbgr.mr_n54342768)
print v(xbgr.mr_n54342880)
print v(xbgr.mr_n54343200)
print v(xbgr.mr_n54343312)
print v(xbgr.mr_n54343632)
print v(xbgr.mr_n54343744)
print v(xbgr.mr_n54344176)
print v(xbgr.mr_n54344608)
print v(xbgr.mr_n54345040)
print v(xbgr.mr_n54345472)
print v(xbgr.mr_n54345904)
print v(xbgr.mr_n54346336)
print v(xbgr.mr_n54346768)
print v(xbgr.mr_n54347200)
print v(xbgr.mr_n54347632)
print v(xbgr.mr_n54348064)
print v(xbgr.mr_n54348496)
print v(xbgr.mr_n54348928)
print v(xbgr.mr_n54349360)
print v(xbgr.mr_n54349680)
print v(xbgr.mr_n54349792)
print v(xbgr.mr_n54350112)
print v(xbgr.mr_n54350224)
print v(xbgr.mr_n54350544)
print v(xbgr.mr_n54350656)
print v(xbgr.mr_n54350976)
print v(xbgr.mr_n54351088)
print v(xbgr.mr_n54351408)
print v(xbgr.mr_n54351520)
print v(xbgr.mr_n54351840)
print v(xbgr.mr_n54351952)
print v(xbgr.mr_n54352272)
print v(xbgr.mr_n54352384)
print v(xbgr.mr_n54352704)
print v(xbgr.mr_n54352816)
print v(xbgr.mr_n54353136)
print v(xbgr.mr_n54353248)
print v(xbgr.mr_n54353568)
print v(xbgr.mr_n54353680)
print v(xbgr.mr_n54354000)
print v(xbgr.mr_n54354112)
print v(xbgr.mr_n54354432)
print v(xbgr.mr_n54354544)
print v(xbgr.mr_n54354864)
print v(xbgr.mr_n54354976)
print v(xbgr.mr_n54355408)
print v(xbgr.mr_n54355840)
print v(xbgr.mr_n54356272)
print v(xbgr.mr_n54356704)
print v(xbgr.mr_n54357136)
print v(xbgr.mr_n54357568)
print v(xbgr.mr_n54358000)
print v(xbgr.mr_n54358432)
print v(xbgr.mr_n54358864)
print v(xbgr.mr_n54359296)
print v(xbgr.mr_n54359728)
print v(xbgr.mr_n54360160)
print v(xbgr.mr_n54360592)
print v(xbgr.mr_n54360912)
print v(xbgr.mr_n54361024)
print v(xbgr.mr_n54361344)
print v(xbgr.mr_n54361456)
print v(xbgr.mr_n54361776)
print v(xbgr.mr_n54361888)
print v(xbgr.mr_n54362208)
print v(xbgr.mr_n54362320)
print v(xbgr.mr_n54362640)
print v(xbgr.mr_n54362752)
print v(xbgr.mr_n54363072)
print v(xbgr.mr_n54363184)
print v(xbgr.mr_n54363504)
print v(xbgr.mr_n54363616)
print v(xbgr.mr_n54363936)
print v(xbgr.mr_n54364048)
print v(xbgr.mr_n54364368)
print v(xbgr.mr_n54364480)
print v(xbgr.mr_n54364800)
print v(xbgr.mr_n54364912)
print v(xbgr.mr_n54365232)
print v(xbgr.mr_n54365344)
print v(xbgr.mr_n54365664)
print v(xbgr.mr_n54365776)
print v(xbgr.mr_n54366096)
print v(xbgr.mr_n54366208)
print v(xbgr.mr_n54366640)
print v(xbgr.mr_n54367072)
print v(xbgr.mr_n54367504)
print v(xbgr.mr_n54367936)
print v(xbgr.mr_n54368368)
print v(xbgr.mr_n54368800)
print v(xbgr.mr_n54369232)
print v(xbgr.mr_n54369664)
print v(xbgr.mr_n54370096)
print v(xbgr.mr_n54370528)
print v(xbgr.mr_n54370960)
print v(xbgr.mr_n54371392)
print v(xbgr.mr_n54371824)
print v(xbgr.mr_n54372144)
print v(xbgr.mr_n54372256)
print v(xbgr.mr_n54372576)
print v(xbgr.mr_n54372688)
print v(xbgr.mr_n54373008)
print v(xbgr.mr_n54373120)
print v(xbgr.mr_n54373440)
print v(xbgr.mr_n54373552)
print v(xbgr.mr_n54373872)
print v(xbgr.mr_n54373984)
print v(xbgr.mr_n54374304)
print v(xbgr.mr_n54374416)
print v(xbgr.mr_n54374736)
print v(xbgr.mr_n54374848)
print v(xbgr.mr_n54375168)
print v(xbgr.mr_n54375280)
print v(xbgr.mr_n54375600)
print v(xbgr.mr_n54375712)
print v(xbgr.mr_n54376032)
print v(xbgr.mr_n54376144)
print v(xbgr.mr_n54376464)
print v(xbgr.mr_n54376576)
print v(xbgr.mr_n54376896)
print v(xbgr.mr_n54377008)
print v(xbgr.mr_n54377328)
print v(xbgr.mr_n54377440)
print v(xbgr.mr_n54377872)
print v(xbgr.mr_n54378304)
print v(xbgr.mr_n54378736)
print v(xbgr.mr_n54379168)
print v(xbgr.mr_n54379600)
print v(xbgr.mr_n54380032)
print v(xbgr.mr_n54380464)
print v(xbgr.mr_n54380896)
print v(xbgr.mr_n54381328)
print v(xbgr.mr_n54381760)
print v(xbgr.mr_n54382192)
print v(xbgr.mr_n54382624)
print v(xbgr.mr_n54383056)
print v(xbgr.mr_n54383376)
print v(xbgr.mr_n54383488)
print v(xbgr.mr_n54383808)
print v(xbgr.mr_n54383920)
print v(xbgr.mr_n54384240)
print v(xbgr.mr_n54384352)
print v(xbgr.mr_n54384672)
print v(xbgr.mr_n54384784)
print v(xbgr.mr_n54385104)
print v(xbgr.mr_n54385216)
print v(xbgr.mr_n54385648)
print v(xbgr.mr_n54386080)
print v(xbgr.mr_n54386512)
print v(xbgr.mr_n54386944)
print v(xbgr.mr_n54387376)
print v(xbgr.mr_n54387696)
print v(xbgr.mr_n54387808)
print v(xbgr.mr_n54388128)
print v(xbgr.mr_n54388240)
print v(xbgr.mr_n54388560)
print v(xbgr.mr_n54388672)
print v(xbgr.mr_n54388992)
print v(xbgr.mr_n54389104)
print v(xbgr.mr_n54389424)
print v(xbgr.mr_n54389536)
print v(xbgr.mr_n54389856)
print v(xbgr.mr_n54389968)
print v(xbgr.mr_n54390288)
print v(xbgr.mr_n54390400)
print v(xbgr.mr_n54390720)
print v(xbgr.mr_n54390832)
print v(xbgr.mr_n54391264)
print v(xbgr.mr_n54391696)
print v(xbgr.mr_n54392128)
print v(xbgr.mr_n54392560)
print v(xbgr.mr_n54392992)
print v(xbgr.mr_n54393424)
print v(xbgr.mr_n54393856)
print v(xbgr.mr_n54394288)
print v(xbgr.mr_n54394608)
print v(xbgr.mr_n54394720)
print v(xbgr.mr_n54395040)
print v(xbgr.mr_n54395152)
print v(xbgr.mr_n54395472)
print v(xbgr.mr_n54395584)
print v(xbgr.mr_n54395904)
print v(xbgr.mr_n54396016)
print v(xbgr.mr_n54396336)
print v(xbgr.mr_n54396448)
print v(xbgr.mr_n54396768)
print v(xbgr.mr_n54396880)
print v(xbgr.mr_n54397200)
print v(xbgr.mr_n54397312)
print v(xbgr.mr_n54397632)
print v(xbgr.mr_n54397744)
print v(xbgr.mr_n54398176)
print v(xbgr.mr_n54398608)
print v(xbgr.mr_n54399040)
print v(xbgr.mr_n54399472)
print v(xbgr.mr_n54399904)
print v(xbgr.mr_n54400224)
print v(xbgr.mr_n54400336)
print v(xbgr.mr_n54400656)
print v(xbgr.mr_n54400768)
print v(xbgr.mr_n54401088)
print v(xbgr.mr_n54401200)
print v(xbgr.mr_n54401520)
print v(xbgr.mr_n54401632)
print v(xbgr.mr_n54401952)
print v(xbgr.mr_n54402064)
print v(xbgr.mr_n54402496)
print v(xbgr.mr_n54402928)
print v(xbgr.mr_n54403360)
print v(xbgr.mr_n54403792)
print v(xbgr.mr_n54404224)
print v(xbgr.mr_n54404656)
print v(xbgr.mr_n54405088)
print v(xbgr.mr_n54405520)
print v(xbgr.mr_n54405840)
print v(xbgr.mr_n54405952)
print v(xbgr.mr_n54406272)
print v(xbgr.mr_n54406384)
print v(xbgr.mr_n54406704)
print v(xbgr.mr_n54406816)
print v(xbgr.mr_n54407136)
print v(xbgr.mr_n54407248)
print v(xbgr.mr_n54407568)
print v(xbgr.mr_n54407680)
print v(xbgr.mr_n54408000)
print v(xbgr.mr_n54408112)
print v(xbgr.mr_n54408432)
print v(xbgr.mr_n54408544)
print v(xbgr.mr_n54408976)
print v(xbgr.mr_n54409408)
print v(xbgr.mr_n54409840)
print v(xbgr.mr_n54410272)
print v(xbgr.mr_n54410592)
print v(xbgr.mr_n54410704)
print v(xbgr.mr_n54411136)
print v(xbgr.mr_n54411568)
print v(xbgr.mr_n54411888)
print v(xbgr.mr_n54412000)
print v(xbgr.mr_n54412320)
print v(xbgr.mr_n54412432)
print v(xbgr.mr_n54412752)
print v(xbgr.mr_n54412864)
print v(xbgr.mr_n54413184)
print v(xbgr.mr_n54413296)
print v(xbgr.mr_n54413616)
print v(xbgr.mr_n54413728)
print v(xbgr.mr_n54414160)
print v(xbgr.mr_n54414592)
print v(xbgr.mr_n54415024)
print v(xbgr.mr_n54415456)
print v(xbgr.mr_n54415888)
print v(xbgr.mr_n54416320)
print v(xbgr.mr_n54416752)
print v(xbgr.mr_n54417072)
print v(xbgr.mr_n54417184)
print v(xbgr.mr_n54417504)
print v(xbgr.mr_n54417616)
print v(xbgr.mr_n54417936)
print v(xbgr.mr_n54418048)
print v(xbgr.mr_n54418368)
print v(xbgr.mr_n54418480)
print v(xbgr.mr_n54418800)
print v(xbgr.mr_n54418912)
print v(xbgr.mr_n54419232)
print v(xbgr.mr_n54419344)
print v(xbgr.mr_n54419664)
print v(xbgr.mr_n54419776)
print v(xbgr.mr_n54420096)
print v(xbgr.mr_n54420208)
print v(xbgr.mr_n54420528)
print v(xbgr.mr_n54420640)
print v(xbgr.mr_n54420960)
print v(xbgr.mr_n54421072)
print v(xbgr.mr_n54421392)
print v(xbgr.mr_n54421504)
print v(xbgr.mr_n54421824)
print v(xbgr.mr_n54421936)
print v(xbgr.mr_n54422256)
print v(xbgr.mr_n54422368)
print v(xbgr.mr_n54422800)
print v(xbgr.mr_n54423232)
print v(xbgr.mr_n54423664)
print v(xbgr.mr_n54424096)
print v(xbgr.mr_n54424528)
print v(xbgr.mr_n54424960)
print v(xbgr.mr_n54425392)
print v(xbgr.mr_n54425824)
print v(xbgr.mr_n54426256)
print v(xbgr.mr_n54426688)
print v(xbgr.mr_n54427120)
print v(xbgr.mr_n54427552)
print v(xbgr.mr_n54427984)
print v(xbgr.mr_n54428304)
print v(xbgr.mr_n54428416)
print v(xbgr.mr_n54428736)
print v(xbgr.mr_n54428848)
print v(xbgr.mr_n54429168)
print v(xbgr.mr_n54429280)
print v(xbgr.mr_n54429600)
print v(xbgr.mr_n54429712)
print v(xbgr.mr_n54430032)
print v(xbgr.mr_n54430144)
print v(xbgr.mr_n54430464)
print v(xbgr.mr_n54430576)
print v(xbgr.mr_n54430896)
print v(xbgr.mr_n54431008)
print v(xbgr.mr_n54431328)
print v(xbgr.mr_n54431440)
print v(xbgr.mr_n54431760)
print v(xbgr.mr_n54431872)
print v(xbgr.mr_n54432192)
print v(xbgr.mr_n54432304)
print v(xbgr.mr_n54432624)
print v(xbgr.mr_n54432736)
print v(xbgr.mr_n54433056)
print v(xbgr.mr_n54433168)
print v(xbgr.mr_n54433488)
print v(xbgr.mr_n54433600)
print v(xbgr.mr_n54433920)
print v(xbgr.mr_n54434032)
print v(xbgr.mr_n54434352)
print v(xbgr.mr_n54434464)
print v(xbgr.mr_n54434784)
print v(xbgr.mr_n54434896)
print v(xbgr.mr_n54435328)
print v(xbgr.mr_n54435760)
print v(xbgr.mr_n54436192)
print v(xbgr.mr_n54436624)
print v(xbgr.mr_n54437056)
print v(xbgr.mr_n54437488)
print v(xbgr.mr_n54437808)
print v(xbgr.mr_n54437920)
print v(xbgr.mr_n54438240)
print v(xbgr.mr_n54438352)
print v(xbgr.mr_n54438672)
print v(xbgr.mr_n54438784)
print v(xbgr.mr_n54439104)
print v(xbgr.mr_n54439216)
print v(xbgr.mr_n54439536)
print v(xbgr.mr_n54439648)
print v(xbgr.mr_n54439968)
print v(xbgr.mr_n54440080)
print v(xbgr.mr_n54440400)
print v(xbgr.mr_n54440512)
print v(xbgr.mr_n54440832)
print v(xbgr.mr_n54440944)
print v(xbgr.mr_n54441264)
print v(xbgr.mr_n54441376)
print v(xbgr.mr_n54441696)
print v(xbgr.mr_n54441808)
print v(xbgr.mr_n54442240)
print v(xbgr.mr_n54442672)
print v(xbgr.mr_n54443104)
print v(xbgr.mr_n54443536)
print v(xbgr.mr_n54443968)
print v(xbgr.mr_n54444400)
print v(xbgr.mr_n54444832)
print v(xbgr.mr_n54445264)
print v(xbgr.mr_n54445696)
print v(xbgr.mr_n54446128)
print v(xbgr.mr_n54446560)
print v(xbgr.mr_n54446992)
print v(xbgr.mr_n54447424)
print v(xbgr.mr_n54447856)
print v(xbgr.mr_n54448288)
print v(xbgr.mr_n54448720)
print v(xbgr.mr_n54449152)
print v(xbgr.mr_n54449584)
print v(xbgr.mr_n54450016)
print v(xbgr.mr_n54450448)
print v(xbgr.mr_n54450768)
print v(xbgr.mr_n54450880)
print v(xbgr.mr_n54451200)
print v(xbgr.mr_n54451312)
print v(xbgr.mr_n54451632)
print v(xbgr.mr_n54451744)
print v(xbgr.mr_n54452064)
print v(xbgr.mr_n54452176)
print v(xbgr.mr_n54452496)
print v(xbgr.mr_n54452608)
print v(xbgr.mr_n54452928)
print v(xbgr.mr_n54453040)
print v(xbgr.mr_n54453360)
print v(xbgr.mr_n54453472)
print v(xbgr.mr_n54453792)
print v(xbgr.mr_n54453904)
print v(xbgr.mr_n54454224)
print v(xbgr.mr_n54454336)
print v(xbgr.mr_n54454656)
print v(xbgr.mr_n54454768)
print v(xbgr.mr_n54455088)
print v(xbgr.mr_n54455200)
print v(xbgr.mr_n54455520)
print v(xbgr.mr_n54455632)
print v(xbgr.mr_n54455952)
print v(xbgr.mr_n54456064)
print v(xbgr.mr_n54456384)
print v(xbgr.mr_n54456496)
print v(xbgr.mr_n54456928)
print v(xbgr.mr_n54457360)
print v(xbgr.mr_n54457792)
print v(xbgr.mr_n54458224)
print v(xbgr.mr_n54458544)
print v(xbgr.mr_n54458656)
print v(xbgr.mr_n54458976)
print v(xbgr.mr_n54459088)
print v(xbgr.mr_n54459408)
print v(xbgr.mr_n54459520)
print v(xbgr.mr_n54459840)
print v(xbgr.mr_n54459952)
print v(xbgr.mr_n54460272)
print v(xbgr.mr_n54460384)
print v(xbgr.mr_n54460704)
print v(xbgr.mr_n54460816)
print v(xbgr.mr_n54461248)
print v(xbgr.mr_n54461680)
print v(xbgr.mr_n54462112)
print v(xbgr.mr_n54462544)
print v(xbgr.mr_n54462976)
print v(xbgr.mr_n54463408)
print v(xbgr.mr_n54463840)
print v(xbgr.mr_n54464272)
print v(xbgr.mr_n54464704)
print v(xbgr.mr_n54465136)
print v(xbgr.mr_n54465456)
print v(xbgr.mr_n54465568)
print v(xbgr.mr_n54465888)
print v(xbgr.mr_n54466000)
print v(xbgr.mr_n54466432)
print v(xbgr.mr_n54466864)
print v(xbgr.mr_n54467184)
print v(xbgr.mr_n54467296)
print v(xbgr.mr_n54467616)
print v(xbgr.mr_n54467728)
print v(xbgr.mr_n54468048)
print v(xbgr.mr_n54468160)
print v(xbgr.mr_n54468480)
print v(xbgr.mr_n54468592)
print v(xbgr.mr_n54469024)
print v(xbgr.mr_n54469456)
print v(xbgr.mr_n54469888)
print v(xbgr.mr_n54470320)
print v(xbgr.mr_n54470752)
print v(xbgr.mr_n54471184)
print v(xbgr.mr_n54471616)
print v(xbgr.mr_n54472048)
print v(xbgr.mr_n54472480)
print v(xbgr.mr_n54472912)
print v(xbgr.mr_n54473232)
print v(xbgr.mr_n54473344)
print v(xbgr.mr_n54473664)
print v(xbgr.mr_n54473776)
print v(xbgr.mr_n54474096)
print v(xbgr.mr_n54474208)
print v(xbgr.mr_n54474528)
print v(xbgr.mr_n54474640)
print v(xbgr.mr_n54474960)
print v(xbgr.mr_n54475072)
print v(xbgr.mr_n54475392)
print v(xbgr.mr_n54475504)
print v(xbgr.mr_n54475824)
print v(xbgr.mr_n54475936)
print v(xbgr.mr_n54476256)
print v(xbgr.mr_n54476368)
print v(xbgr.mr_n54476688)
print v(xbgr.mr_n54476800)
print v(xbgr.mr_n54477120)
print v(xbgr.mr_n54477232)
print v(xbgr.mr_n54477552)
print v(xbgr.mr_n54477664)
print v(xbgr.mr_n54477984)
print v(xbgr.mr_n54478096)
print v(xbgr.mr_n54478416)
print v(xbgr.mr_n54478528)
print v(xbgr.mr_n54478848)
print v(xbgr.mr_n54478960)
print v(xbgr.mr_n54479280)
print v(xbgr.mr_n54479392)
print v(xbgr.mr_n54479712)
print v(xbgr.mr_n54479824)
print v(xbgr.mr_n54480144)
print v(xbgr.mr_n54480256)
print v(xbgr.mr_n54480576)
print v(xbgr.mr_n54480688)
print v(xbgr.mr_n54481008)
print v(xbgr.mr_n54481120)
print v(xbgr.mr_n54481440)
print v(xbgr.mr_n54481552)
print v(xbgr.mr_n54481872)
print v(xbgr.mr_n54481984)
print v(xbgr.mr_n54482304)
print v(xbgr.mr_n54482736)
print v(xbgr.mr_n54482848)
print v(xbgr.mr_n54483168)
print v(xbgr.mr_n54483600)
print v(xbgr.mr_n54483712)
print v(xbgr.mr_n54484032)
print v(xbgr.mr_n54484464)
print v(xbgr.mr_n54484576)
print v(xbgr.mr_n54484896)
print v(xbgr.mr_n54485328)
print v(xbgr.mr_n54485440)
print v(xbgr.mr_n54485760)
print v(xbgr.mr_n54486192)
print v(xbgr.mr_n54486304)
print v(xbgr.mr_n54486624)
print v(xbgr.mr_n54486736)
print v(xbgr.mr_n54487056)
print v(xbgr.mr_n54487168)
print v(xbgr.mr_n54487488)
print v(xbgr.mr_n54487600)
print v(xbgr.mr_n54487920)
print v(xbgr.mr_n54488032)
print v(xbgr.mr_n54488352)
print v(xbgr.mr_n54488464)
print v(xbgr.mr_n54488784)
print v(xbgr.mr_n54488896)
print v(xbgr.mr_n54489216)
print v(xbgr.mr_n54489328)
print v(xbgr.mr_n54489648)
print v(xbgr.mr_n54489760)
print v(xbgr.mr_n54490080)
print v(xbgr.mr_n54490192)
print v(xbgr.mr_n54490512)
print v(xbgr.mr_n54490624)
print v(xbgr.mr_n54490944)
print v(xbgr.mr_n54491056)
print v(xbgr.mr_n54491376)
print v(xbgr.mr_n54491488)
print v(xbgr.mr_n54491808)
print v(xbgr.mr_n54491920)
print v(xbgr.mr_n54492240)
print v(xbgr.mr_n54492352)
print v(xbgr.mr_n54492672)
print v(xbgr.mr_n54492784)
print v(xbgr.mr_n54493104)
print v(xbgr.mr_n54493216)
print v(xbgr.mr_n54493536)
print v(xbgr.mr_n54493648)
print v(xbgr.mr_n54493968)
print v(xbgr.mr_n54494080)
print v(xbgr.mr_n54494400)
print v(xbgr.mr_n54494512)
print v(xbgr.mr_n54494832)
print v(xbgr.mr_n54494944)
print v(xbgr.mr_n54495264)
print v(xbgr.mr_n54495376)
print v(xbgr.mr_n54495696)
print v(xbgr.mr_n54495808)
print v(xbgr.mr_n54496128)
print v(xbgr.mr_n54496240)
print v(xbgr.mr_n54496560)
print v(xbgr.mr_n54496672)
print v(xbgr.mr_n54496992)
print v(xbgr.mr_n54497104)
print v(xbgr.mr_n54497424)
print v(xbgr.mr_n54497536)
print v(xbgr.mr_n54497856)
print v(xbgr.mr_n54497968)
print v(xbgr.mr_n54498288)
print v(xbgr.mr_n54498400)
print v(xbgr.mr_n54498720)
print v(xbgr.mr_n54498832)
print v(xbgr.mr_n54499152)
print v(xbgr.mr_n54499264)
print v(xbgr.mr_n54499584)
print v(xbgr.mr_n54499696)
print v(xbgr.mr_n54500016)
print v(xbgr.mr_n54500128)
print v(xbgr.mr_n54500448)
print v(xbgr.mr_n54500560)
print v(xbgr.mr_n54500880)
print v(xbgr.mr_n54500992)
print v(xbgr.mr_n54501312)
print v(xbgr.mr_n54501424)
print v(xbgr.mr_n54501744)
print v(xbgr.mr_n54501856)
print v(xbgr.mr_n54502176)
print v(xbgr.mr_n54502288)
print v(xbgr.mr_n54502608)
print v(xbgr.mr_n54502720)
print v(xbgr.mr_n54503040)
print v(xbgr.mr_n54503152)
print v(xbgr.mr_n54503472)
print v(xbgr.mr_n54503584)
print v(xbgr.mr_n54503904)
print v(xbgr.mr_n54504016)
print v(xbgr.mr_n54504336)
print v(xbgr.mr_n54504448)
print v(xbgr.mr_n54504768)
print v(xbgr.mr_n54504880)
print v(xbgr.mr_n54505200)
print v(xbgr.mr_n54505312)
print v(xbgr.mr_n54505632)
print v(xbgr.mr_n54505744)
print v(xbgr.mr_n54506064)
print v(xbgr.mr_n54506176)
print v(xbgr.mr_n54506496)
print v(xbgr.mr_n54506608)
print v(xbgr.mr_n54506928)
print v(xbgr.mr_n54507040)
print v(xbgr.mr_n54507360)
print v(xbgr.mr_n54507472)
print v(xbgr.mr_n54507792)
print v(xbgr.mr_n54507904)
print v(xbgr.mr_n54508224)
print v(xbgr.mr_n54508336)
print v(xbgr.mr_n54508656)
print v(xbgr.mr_n54508768)
print v(xbgr.mr_n54509088)
print v(xbgr.mr_n54509200)
print v(xbgr.mr_n54509520)
print v(xbgr.mr_n54509632)
print v(xbgr.mr_n54509952)
print v(xbgr.mr_n54510064)
print v(xbgr.mr_n54510384)
print v(xbgr.mr_n54510496)
print v(xbgr.mr_n54510816)
print v(xbgr.mr_n54510928)
print v(xbgr.mr_n54511248)
print v(xbgr.mr_n54511360)
print v(xbgr.mr_n54511680)
print v(xbgr.mr_n54511792)
print v(xbgr.mr_n54512112)
print v(xbgr.mr_n54512224)
print v(xbgr.mr_n54512544)
print v(xbgr.mr_n54512656)
print v(xbgr.mr_n54512976)
print v(xbgr.mr_n54513088)
print v(xbgr.mr_n54513408)
print v(xbgr.mr_n54513520)
print v(xbgr.mr_n54513840)
print v(xbgr.mr_n54513952)
print v(xbgr.mr_n54514272)
print v(xbgr.mr_n54514384)
print v(xbgr.mr_n54514704)
print v(xbgr.mr_n54514816)
print v(xbgr.mr_n54515136)
print v(xbgr.mr_n54515248)
print v(xbgr.mr_n54515568)
print v(xbgr.mr_n54515680)
print v(xbgr.mr_n54516000)
print v(xbgr.mr_n54516112)
print v(xbgr.mr_n54516432)
print v(xbgr.mr_n54516544)
print v(xbgr.mr_n54516864)
print v(xbgr.mr_n54516976)
print v(xbgr.mr_n54517296)
print v(xbgr.mr_n54517728)
print v(xbgr.mr_n54517840)
print v(xbgr.mr_n54518160)
print v(xbgr.mr_n54518592)
print v(xbgr.mr_n54518704)
print v(xbgr.mr_n54519024)
print v(xbgr.mr_n54519456)
print v(xbgr.mr_n54519568)
print v(xbgr.mr_n54519888)
print v(xbgr.mr_n54520320)
print v(xbgr.mr_n54520432)
print v(xbgr.mr_n54520752)
print v(xbgr.mr_n54520864)
print v(xbgr.mr_n54521184)
print v(xbgr.mr_n54521296)
print v(xbgr.mr_n54521616)
print v(xbgr.mr_n54521728)
print v(xbgr.mr_n54522048)
print v(xbgr.mr_n54522480)
print v(xbgr.mr_n54522592)
print v(xbgr.mr_n54522912)
print v(xbgr.mr_n54523344)
print v(xbgr.mr_n54523456)
print v(xbgr.mr_n54523776)
print v(xbgr.mr_n54524208)
print v(xbgr.mr_n54524320)
print v(xbgr.mr_n54524640)
print v(xbgr.mr_n54525072)
print v(xbgr.mr_n54525184)
print v(xbgr.mr_n54525504)
print v(xbgr.mr_n54525616)
print v(xbgr.mr_n54525936)
print v(xbgr.mr_n54526048)
print v(xbgr.mr_n54526368)
print v(xbgr.mr_n54526480)
print v(xbgr.mr_n54526800)
print v(xbgr.mr_n54526912)
print v(xbgr.mr_n54527232)
print v(xbgr.mr_n54527344)
print v(xbgr.mr_n54527664)
print v(xbgr.mr_n54527776)
print v(xbgr.mr_n54528096)
print v(xbgr.mr_n54528208)
print v(xbgr.mr_n54528528)
print v(xbgr.mr_n54528640)
print v(xbgr.mr_n54528960)
print v(xbgr.mr_n54529072)
print v(xbgr.mr_n54529392)
print v(xbgr.mr_n54529504)
print v(xbgr.mr_n54529824)
print v(xbgr.mr_n54529936)
print v(xbgr.mr_n54530256)
print v(xbgr.mr_n54530368)
print v(xbgr.mr_n54530688)
print v(xbgr.mr_n54530800)
print v(xbgr.mr_n54531120)
print v(xbgr.mr_n54531232)
print v(xbgr.mr_n54531552)
print v(xbgr.mr_n54531664)
print v(xbgr.mr_n54531984)
print v(xbgr.mr_n54532096)
print v(xbgr.mr_n54532416)
print v(xbgr.mr_n54532528)
print v(xbgr.mr_n54532848)
print v(xbgr.mr_n54532960)
print v(xbgr.mr_n54533280)
print v(xbgr.mr_n54533392)
print v(xbgr.mr_n54533712)
print v(xbgr.mr_n54533824)
print v(xbgr.mr_n54534144)
print v(xbgr.mr_n54534256)
print v(xbgr.mr_n54534576)
print v(xbgr.mr_n54534688)
print v(xbgr.mr_n54535008)
print v(xbgr.mr_n54535120)
print v(xbgr.mr_n54535440)
print v(xbgr.mr_n54535552)
print v(xbgr.mr_n54535872)
print v(xbgr.mr_n54535984)
print v(xbgr.mr_n54536304)
print v(xbgr.mr_n54536416)
print v(xbgr.mr_n54536736)
print v(xbgr.mr_n54536848)
print v(xbgr.mr_n54537280)
print v(xbgr.mr_n54537712)
print v(xbgr.mr_n54538144)
print v(xbgr.mr_n54538576)
print v(xbgr.mr_n54539008)
print v(xbgr.mr_n54539440)
print v(xbgr.mr_n54539872)
print v(xbgr.mr_n54540304)
print v(xbgr.mr_n54540736)
print v(xbgr.mr_n54541168)
print v(xbgr.mr_n54541600)
print v(xbgr.mr_n54542032)
print v(xbgr.mr_n54542464)
print v(xbgr.mr_n54542896)
print v(xbgr.mr_n54543328)
print v(xbgr.mr_n54543760)
print v(xbgr.mr_n54544192)
print v(xbgr.mr_n54544624)
print v(xbgr.mr_n54545056)
print v(xbgr.mr_n54545488)
print v(xbgr.mr_n54545920)
print v(xbgr.mr_n54546352)
print v(xbgr.mr_n54546784)
print v(xbgr.mr_n54547216)
print v(xbgr.mr_n54547648)
print v(xbgr.mr_n54548080)
print v(xbgr.mr_n54548400)
print v(xbgr.mr_n54548512)
print v(xbgr.mr_n54548832)
print v(xbgr.mr_n54548944)
print v(xbgr.mr_n54549264)
print v(xbgr.mr_n54549376)
print v(xbgr.mr_n54549696)
print v(xbgr.mr_n54549808)
print v(xbgr.mr_n54550128)
print v(xbgr.mr_n54550240)
print v(xbgr.mr_n54550560)
print v(xbgr.mr_n54550672)
print v(xbgr.mr_n54550992)
print v(xbgr.mr_n54551104)
print v(xbgr.mr_n54551424)
print v(xbgr.mr_n54551536)
print v(xbgr.mr_n54551856)
print v(xbgr.mr_n54551968)
print v(xbgr.mr_n54552288)
print v(xbgr.mr_n54552400)
print v(xbgr.mr_n54552720)
print v(xbgr.mr_n54552832)
print v(xbgr.mr_n54553152)
print v(xbgr.mr_n54553264)
print v(xbgr.mr_n54553584)
print v(xbgr.mr_n54553696)
print v(xbgr.mr_n54554016)
print v(xbgr.mr_n54554128)
print v(xbgr.mr_n54554448)
print v(xbgr.mr_n54554560)
print v(xbgr.mr_n54554880)
print v(xbgr.mr_n54554992)
print v(xbgr.mr_n54555312)
print v(xbgr.mr_n54555424)
print v(xbgr.mr_n54555744)
print v(xbgr.mr_n54555856)
print v(xbgr.mr_n54556176)
print v(xbgr.mr_n54556288)
print v(xbgr.mr_n54556608)
print v(xbgr.mr_n54556720)
print v(xbgr.mr_n54557152)
print v(xbgr.mr_n54557584)
print v(xbgr.mr_n54558016)
print v(xbgr.mr_n54558448)
print v(xbgr.mr_n54558880)
print v(xbgr.mr_n54559312)
print v(xbgr.mr_n54559744)
print v(xbgr.mr_n54560176)
print v(xbgr.mr_n54560608)
print v(xbgr.mr_n54561040)
print v(xbgr.mr_n54561472)
print v(xbgr.mr_n54561904)
print v(xbgr.mr_n54562224)
print v(xbgr.mr_n54562336)
print v(xbgr.mr_n54562656)
print v(xbgr.mr_n54562768)
print v(xbgr.mr_n54563200)
print v(xbgr.mr_n54563632)
print v(xbgr.mr_n54564064)
print v(xbgr.mr_n54564496)
print v(xbgr.mr_n54564928)
print v(xbgr.mr_n54565360)
print v(xbgr.mr_n54565792)
print v(xbgr.mr_n54566224)
print v(xbgr.mr_n54566656)
print v(xbgr.mr_n54567088)
print v(xbgr.mr_n54567408)
print v(xbgr.mr_n54567520)
print v(xbgr.mr_n54567840)
print v(xbgr.mr_n54567952)
print v(xbgr.mr_n54568272)
print v(xbgr.mr_n54568384)
print v(xbgr.mr_n54568704)
print v(xbgr.mr_n54568816)
print v(xbgr.mr_n54569136)
print v(xbgr.mr_n54569248)
print v(xbgr.mr_n54569568)
print v(xbgr.mr_n54569680)
print v(xbgr.mr_n54570000)
print v(xbgr.mr_n54570112)
print v(xbgr.mr_n54570432)
print v(xbgr.mr_n54570544)
print v(xbgr.mr_n54570864)
print v(xbgr.mr_n54570976)
print v(xbgr.mr_n54571296)
print v(xbgr.mr_n54571408)
print v(xbgr.mr_n54571728)
print v(xbgr.mr_n54571840)
print v(xbgr.mr_n54572160)
print v(xbgr.mr_n54572272)
print v(xbgr.mr_n54572592)
print v(xbgr.mr_n54572704)
print v(xbgr.mr_n54573024)
print v(xbgr.mr_n54573136)
print v(xbgr.mr_n54573456)
print v(xbgr.mr_n54573568)
print v(xbgr.mr_n54573888)
print v(xbgr.mr_n54574000)
print v(xbgr.mr_n54574320)
print v(xbgr.mr_n54574432)
print v(xbgr.mr_n54574752)
print v(xbgr.mr_n54574864)
print v(xbgr.mr_n54575184)
print v(xbgr.mr_n54575296)
print v(xbgr.mr_n54575616)
print v(xbgr.mr_n54575728)
print v(xbgr.mr_n54576048)
print v(xbgr.mr_n54576160)
print v(xbgr.mr_n54576480)
print v(xbgr.mr_n54576592)
print v(xbgr.mr_n54576912)
print v(xbgr.mr_n54577024)
print v(xbgr.mr_n54577344)
print v(xbgr.mr_n54577456)
print v(xbgr.mr_n54577776)
print v(xbgr.mr_n54577888)
print v(xbgr.mr_n54578208)
print v(xbgr.mr_n54578320)
print v(xbgr.mr_n54578640)
print v(xbgr.mr_n54579072)
print v(xbgr.mr_n54579184)
print v(xbgr.mr_n54579504)
print v(xbgr.mr_n54579936)
print v(xbgr.mr_n54580048)
print v(xbgr.mr_n54580368)
print v(xbgr.mr_n54580800)
print v(xbgr.mr_n54580912)
print v(xbgr.mr_n54581232)
print v(xbgr.mr_n54581664)
print v(xbgr.mr_n54581776)
print v(xbgr.mr_n54582096)
print v(xbgr.mr_n54582528)
print v(xbgr.mr_n54582640)
print v(xbgr.mr_n54582960)
print v(xbgr.mr_n54583072)
print v(xbgr.mr_n54583392)
print v(xbgr.mr_n54583504)
print v(xbgr.mr_n54583824)
print v(xbgr.mr_n54583936)
print v(xbgr.mr_n54584256)
print v(xbgr.mr_n54584368)
print v(xbgr.mr_n54584688)
print v(xbgr.mr_n54584800)
print v(xbgr.mr_n54585120)
print v(xbgr.mr_n54585232)
print v(xbgr.mr_n54585552)
print v(xbgr.mr_n54585664)
print v(xbgr.mr_n54585984)
print v(xbgr.mr_n54586096)
print v(xbgr.mr_n54586416)
print v(xbgr.mr_n54586528)
print v(xbgr.mr_n54586848)
print v(xbgr.mr_n54586960)
print v(xbgr.mr_n54587280)
print v(xbgr.mr_n54587392)
print v(xbgr.mr_n54587712)
print v(xbgr.mr_n54587824)
print v(xbgr.mr_n54588144)
print v(xbgr.mr_n54588256)
print v(xbgr.mr_n54588576)
print v(xbgr.mr_n54588688)
print v(xbgr.mr_n54589008)
print v(xbgr.mr_n54589120)
print v(xbgr.mr_n54589440)
print v(xbgr.mr_n54589552)
print v(xbgr.mr_n54589872)
print v(xbgr.mr_n54589984)
print v(xbgr.mr_n54590304)
print v(xbgr.mr_n54590416)
print v(xbgr.mr_n54590736)
print v(xbgr.mr_n54590848)
print v(xbgr.mr_n54591168)
print v(xbgr.mr_n54591280)
print v(xbgr.mr_n54591600)
print v(xbgr.mr_n54591712)
print v(xbgr.mr_n54592032)
print v(xbgr.mr_n54592144)
print v(xbgr.mr_n54592464)
print v(xbgr.mr_n54592576)
print v(xbgr.mr_n54592896)
print v(xbgr.mr_n54593008)
print v(xbgr.mr_n54593328)
print v(xbgr.mr_n54593440)
print v(xbgr.mr_n54593760)
print v(xbgr.mr_n54593872)
print v(xbgr.mr_n54594192)
print v(xbgr.mr_n54594304)
print v(xbgr.mr_n54594624)
print v(xbgr.mr_n54594736)
print v(xbgr.mr_n54595056)
print v(xbgr.mr_n54595168)
print v(xbgr.mr_n54595488)
print v(xbgr.mr_n54595600)
print v(xbgr.mr_n54595920)
print v(xbgr.mr_n54596032)
print v(xbgr.mr_n54596352)
print v(xbgr.mr_n54596464)
print v(xbgr.mr_n54596784)
print v(xbgr.mr_n54596896)
print v(xbgr.mr_n54597216)
print v(xbgr.mr_n54597328)
print v(xbgr.mr_n54597648)
print v(xbgr.mr_n54597760)
print v(xbgr.mr_n54598080)
print v(xbgr.mr_n54598192)
print v(xbgr.mr_n54598512)
print v(xbgr.mr_n54598624)
print v(xbgr.mr_n54598944)
print v(xbgr.mr_n54599056)
print v(xbgr.mr_n54599376)
print v(xbgr.mr_n54599488)
print v(xbgr.mr_n54599808)
print v(xbgr.mr_n54599920)
print v(xbgr.mr_n54600240)
print v(xbgr.mr_n54600352)
print v(xbgr.mr_n54600672)
print v(xbgr.mr_n54600784)
print v(xbgr.mr_n54601104)
print v(xbgr.mr_n54601536)
print v(xbgr.mr_n54601648)
print v(xbgr.mr_n54601968)
print v(xbgr.mr_n54602080)
print v(xbgr.mr_n54602400)
print v(xbgr.mr_n54602512)
print v(xbgr.mr_n54602832)
print v(xbgr.mr_n54603264)
print v(xbgr.mr_n54603376)
print v(xbgr.mr_n54603696)
print v(xbgr.mr_n54604128)
print v(xbgr.mr_n54604240)
print v(xbgr.mr_n54604560)
print v(xbgr.mr_n54604672)
print v(xbgr.mr_n54604992)
print v(xbgr.mr_n54605104)
print v(xbgr.mr_n54605424)
print v(xbgr.mr_n54605536)
print v(xbgr.mr_n54605856)
print v(xbgr.mr_n54605968)
print v(xbgr.mr_n54606288)
print v(xbgr.mr_n54606400)
print v(xbgr.mr_n54606720)
print v(xbgr.mr_n54606832)
print v(xbgr.mr_n54607152)
print v(xbgr.mr_n54607264)
print v(xbgr.mr_n54607584)
print v(xbgr.mr_n54607696)
print v(xbgr.mr_n54608016)
print v(xbgr.mr_n54608128)
print v(xbgr.mr_n54608448)
print v(xbgr.mr_n54608560)
print v(xbgr.mr_n54608880)
print v(xbgr.mr_n54608992)
print v(xbgr.mr_n54609312)
print v(xbgr.mr_n54609424)
print v(xbgr.mr_n54609744)
print v(xbgr.mr_n54610176)
print v(xbgr.mr_n54610288)
print v(xbgr.mr_n54610608)
print v(xbgr.mr_n54610720)
print v(xbgr.mr_n54611040)
print v(xbgr.mr_n54611152)
print v(xbgr.mr_n54611472)
print v(xbgr.mr_n54611584)
print v(xbgr.mr_n54611904)
print v(xbgr.mr_n54612016)
print v(xbgr.mr_n54612336)
print v(xbgr.mr_n54612448)
print v(xbgr.mr_n54612768)
print v(xbgr.mr_n54612880)
print v(xbgr.mr_n54613200)
print v(xbgr.mr_n54613312)
print v(xbgr.mr_n54613632)
print v(xbgr.mr_n54613744)
print v(xbgr.mr_n54614064)
print v(xbgr.mr_n54614176)
print v(xbgr.mr_n54614496)
print v(xbgr.mr_n54614608)
print v(xbgr.mr_n54614928)
print v(xbgr.mr_n54615040)
print v(xbgr.mr_n54615360)
print v(xbgr.mr_n54615472)
print v(xbgr.mr_n54615792)
print v(xbgr.mr_n54615904)
print v(xbgr.mr_n54616224)
print v(xbgr.mr_n54616336)
print v(xbgr.mr_n54616656)
print v(xbgr.mr_n54616768)
print v(xbgr.mr_n54617088)
print v(xbgr.mr_n54617200)
print v(xbgr.mr_n54617520)
print v(xbgr.mr_n54617632)
print v(xbgr.mr_n54617952)
print v(xbgr.mr_n54618064)
print v(xbgr.mr_n54618384)
print v(xbgr.mr_n54618496)
print v(xbgr.mr_n54618816)
print v(xbgr.mr_n54618928)
print v(xbgr.mr_n54619248)
print v(xbgr.mr_n54619360)
print v(xbgr.mr_n54619680)
print v(xbgr.mr_n54619792)
print v(xbgr.mr_n54620112)
print v(xbgr.mr_n54620224)
print v(xbgr.mr_n54620544)
print v(xbgr.mr_n54620656)
print v(xbgr.mr_n54620976)
print v(xbgr.mr_n54621088)
print v(xbgr.mr_n54621408)
print v(xbgr.mr_n54621520)
print v(xbgr.mr_n54621840)
print v(xbgr.mr_n54621952)
print v(xbgr.mr_n54622272)
print v(xbgr.mr_n54622384)
print v(xbgr.mr_n54622704)
print v(xbgr.mr_n54622816)
print v(xbgr.mr_n54623136)
print v(xbgr.mr_n54623248)
print v(xbgr.mr_n54623568)
print v(xbgr.mr_n54623680)
print v(xbgr.mr_n54624000)
print v(xbgr.mr_n54624112)
print v(xbgr.mr_n54624432)
print v(xbgr.mr_n54624544)
print v(xbgr.mr_n54624864)
print v(xbgr.mr_n54624976)
print v(xbgr.mr_n54625296)
print v(xbgr.mr_n54625408)
print v(xbgr.mr_n54625728)
print v(xbgr.mr_n54625840)
print v(xbgr.mr_n54626160)
print v(xbgr.mr_n54626272)
print v(xbgr.mr_n54626592)
print v(xbgr.mr_n54626704)
print v(xbgr.mr_n54627024)
print v(xbgr.mr_n54627136)
print v(xbgr.mr_n54627456)
print v(xbgr.mr_n54627568)
print v(xbgr.mr_n54627888)
print v(xbgr.mr_n54628000)
print v(xbgr.mr_n54628320)
print v(xbgr.mr_n54628432)
print v(xbgr.mr_n54628752)
print v(xbgr.mr_n54628864)
print v(xbgr.mr_n54629184)
print v(xbgr.mr_n54629296)
print v(xbgr.mr_n54629616)
print v(xbgr.mr_n54629728)
print v(xbgr.mr_n54630048)
print v(xbgr.mr_n54630160)
print v(xbgr.mr_n54630480)
print v(xbgr.mr_n54630592)
print v(xbgr.mr_n54630912)
print v(xbgr.mr_n54631024)
print v(xbgr.mr_n54631344)
print v(xbgr.mr_n54631456)
print v(xbgr.mr_n54631888)
print v(xbgr.mr_n54632320)
print v(xbgr.mr_n54632752)
print v(xbgr.mr_n54633184)
print v(xbgr.mr_n54633616)
print v(xbgr.mr_n54634048)
print v(xbgr.mr_n54634480)
print v(xbgr.mr_n54634912)
print v(xbgr.mr_n54635232)
print v(xbgr.mr_n54635344)
print v(xbgr.mr_n54635664)
print v(xbgr.mr_n54635776)
print v(xbgr.mr_n54636096)
print v(xbgr.mr_n54636208)
print v(xbgr.mr_n54636528)
print v(xbgr.mr_n54636640)
print v(xbgr.mr_n54636960)
print v(xbgr.mr_n54637072)
print v(xbgr.mr_n54637392)
print v(xbgr.mr_n54637504)
print v(xbgr.mr_n54637824)
print v(xbgr.mr_n54637936)
print v(xbgr.mr_n54638256)
print v(xbgr.mr_n54638368)
print v(xbgr.mr_n54638800)
print v(xbgr.mr_n54639232)
print v(xbgr.mr_n54639664)
print v(xbgr.mr_n54640096)
print v(xbgr.mr_n54640528)
print v(xbgr.mr_n54640960)
print v(xbgr.mr_n54641280)
print v(xbgr.mr_n54641392)
print v(xbgr.mr_n54641824)
print v(xbgr.mr_n54642256)
print v(xbgr.mr_n54642688)
print v(xbgr.mr_n54643120)
print v(xbgr.mr_n54643552)
print v(xbgr.mr_n54643984)
print v(xbgr.mr_n54644416)
print v(xbgr.mr_n54644848)
print v(xbgr.mr_n54645280)
print v(xbgr.mr_n54645712)
print v(xbgr.mr_n54646144)
print v(xbgr.mr_n54646576)
print v(xbgr.mr_n54646896)
print v(xbgr.mr_n54647008)
print v(xbgr.mr_n54647328)
print v(xbgr.mr_n54647440)
print v(xbgr.mr_n54647760)
print v(xbgr.mr_n54647872)
print v(xbgr.mr_n54648192)
print v(xbgr.mr_n54648304)
print v(xbgr.mr_n54648624)
print v(xbgr.mr_n54648736)
print v(xbgr.mr_n54649056)
print v(xbgr.mr_n54649168)
print v(xbgr.mr_n54649488)
print v(xbgr.mr_n54649600)
print v(xbgr.mr_n54649920)
print v(xbgr.mr_n54650032)
print v(xbgr.mr_n54650352)
print v(xbgr.mr_n54650464)
print v(xbgr.mr_n54650784)
print v(xbgr.mr_n54650896)
print v(xbgr.mr_n54651216)
print v(xbgr.mr_n54651328)
print v(xbgr.mr_n54651648)
print v(xbgr.mr_n54651760)
print v(xbgr.mr_n54652080)
print v(xbgr.mr_n54652192)
print v(xbgr.mr_n54652512)
print v(xbgr.mr_n54652624)
print v(xbgr.mr_n54652944)
print v(xbgr.mr_n54653056)
print v(xbgr.mr_n54653376)
print v(xbgr.mr_n54653488)
print v(xbgr.mr_n54653808)
print v(xbgr.mr_n54653920)
print v(xbgr.mr_n54654240)
print v(xbgr.mr_n54654352)
print v(xbgr.mr_n54654672)
print v(xbgr.mr_n54654784)
print v(xbgr.mr_n54655104)
print v(xbgr.mr_n54655216)
print v(xbgr.mr_n54655536)
print v(xbgr.mr_n54655648)
print v(xbgr.mr_n54656080)
print v(xbgr.mr_n54656512)
print v(xbgr.mr_n54656944)
print v(xbgr.mr_n54657376)
print v(xbgr.mr_n54657808)
print v(xbgr.mr_n54658240)
print v(xbgr.mr_n54658672)
print v(xbgr.mr_n54659104)
print v(xbgr.mr_n54659536)
print v(xbgr.mr_n54659968)
print v(xbgr.mr_n54660400)
print v(xbgr.mr_n54660832)
print v(xbgr.mr_n54661264)
print v(xbgr.mr_n54661696)
print v(xbgr.mr_n54662128)
print v(xbgr.mr_n54662560)
print v(xbgr.mr_n54662992)
print v(xbgr.mr_n54663424)
print v(xbgr.mr_n54663856)
print v(xbgr.mr_n54664176)
print v(xbgr.mr_n54664288)
print v(xbgr.mr_n54664608)
print v(xbgr.mr_n54664720)
print v(xbgr.mr_n54665040)
print v(xbgr.mr_n54665152)
print v(xbgr.mr_n54665472)
print v(xbgr.mr_n54665584)
print v(xbgr.mr_n54665904)
print v(xbgr.mr_n54666016)
print v(xbgr.mr_n54666448)
print v(xbgr.mr_n54666880)
print v(xbgr.mr_n54667312)
print v(xbgr.mr_n54667744)
print v(xbgr.mr_n54668176)
print v(xbgr.mr_n54668608)
print v(xbgr.mr_n54669040)
print v(xbgr.mr_n54669360)
print v(xbgr.mr_n54669472)
print v(xbgr.mr_n54669792)
print v(xbgr.mr_n54669904)
print v(xbgr.mr_n54670224)
print v(xbgr.mr_n54670336)
print v(xbgr.mr_n54670656)
print v(xbgr.mr_n54670768)
print v(xbgr.mr_n54671088)
print v(xbgr.mr_n54671200)
print v(xbgr.mr_n54671520)
print v(xbgr.mr_n54671632)
print v(xbgr.mr_n54671952)
print v(xbgr.mr_n54672064)
print v(xbgr.mr_n54672384)
print v(xbgr.mr_n54672496)
print v(xbgr.mr_n54672816)
print v(xbgr.mr_n54672928)
print v(xbgr.mr_n54673248)
print v(xbgr.mr_n54673360)
print v(xbgr.mr_n54673680)
print v(xbgr.mr_n54673792)
print v(xbgr.mr_n54674112)
print v(xbgr.mr_n54674224)
print v(xbgr.mr_n54674544)
print v(xbgr.mr_n54674656)
print v(xbgr.mr_n54675088)
print v(xbgr.mr_n54675520)
print v(xbgr.mr_n54675952)
print v(xbgr.mr_n54676384)
print v(xbgr.mr_n54676816)
print v(xbgr.mr_n54677248)
print v(xbgr.mr_n54677680)
print v(xbgr.mr_n54678112)
print v(xbgr.mr_n54678544)
print v(xbgr.mr_n54678976)
print v(xbgr.mr_n54679408)
print v(xbgr.mr_n54679840)
print v(xbgr.mr_n54680272)
print v(xbgr.mr_n54680592)
print v(xbgr.mr_n54680704)
print v(xbgr.mr_n54681024)
print v(xbgr.mr_n54681136)
print v(xbgr.mr_n54681456)
print v(xbgr.mr_n54681568)
print v(xbgr.mr_n54681888)
print v(xbgr.mr_n54682000)
print v(xbgr.mr_n54682320)
print v(xbgr.mr_n54682432)
print v(xbgr.mr_n54682752)
print v(xbgr.mr_n54682864)
print v(xbgr.mr_n54683184)
print v(xbgr.mr_n54683296)
print v(xbgr.mr_n54683616)
print v(xbgr.mr_n54683728)
print v(xbgr.mr_n54684048)
print v(xbgr.mr_n54684160)
print v(xbgr.mr_n54684480)
print v(xbgr.mr_n54684592)
print v(xbgr.mr_n54684912)
print v(xbgr.mr_n54685024)
print v(xbgr.mr_n54685344)
print v(xbgr.mr_n54685456)
print v(xbgr.mr_n54685888)
print v(xbgr.mr_n54686320)
print v(xbgr.mr_n54686752)
print v(xbgr.mr_n54687184)
print v(xbgr.mr_n54687616)
print v(xbgr.mr_n54688048)
print v(xbgr.mr_n54688480)
print v(xbgr.mr_n54688912)
print v(xbgr.mr_n54689344)
print v(xbgr.mr_n54689776)
print v(xbgr.mr_n54690208)
print v(xbgr.mr_n54690640)
print v(xbgr.mr_n54690960)
print v(xbgr.mr_n54691072)
print v(xbgr.mr_n54691504)
print v(xbgr.mr_n54691824)
print v(xbgr.mr_n54691936)
print v(xbgr.mr_n54692256)
print v(xbgr.mr_n54692368)
print v(xbgr.mr_n54692688)
print v(xbgr.mr_n54692800)
print v(xbgr.mr_n54693120)
print v(xbgr.mr_n54693232)
print v(xbgr.mr_n54693552)
print v(xbgr.mr_n54693664)
print v(xbgr.mr_n54694096)
print v(xbgr.mr_n54694528)
print v(xbgr.mr_n54694848)
print v(xbgr.mr_n54694960)
print v(xbgr.mr_n54695280)
print v(xbgr.mr_n54695392)
print v(xbgr.mr_n54695712)
print v(xbgr.mr_n54695824)
print v(xbgr.mr_n54696144)
print v(xbgr.mr_n54696256)
print v(xbgr.mr_n54696576)
print v(xbgr.mr_n54696688)
print v(xbgr.mr_n54697008)
print v(xbgr.mr_n54697120)
print v(xbgr.mr_n54697440)
print v(xbgr.mr_n54697552)
print v(xbgr.mr_n54697872)
print v(xbgr.mr_n54697984)
print v(xbgr.mr_n54698416)
print v(xbgr.mr_n54698848)
print v(xbgr.mr_n54699280)
print v(xbgr.mr_n54699712)
print v(xbgr.mr_n54700144)
print v(xbgr.mr_n54700576)
print v(xbgr.mr_n54701008)
print v(xbgr.mr_n54701440)
print v(xbgr.mr_n54701872)
print v(xbgr.mr_n54702304)
print v(xbgr.mr_n54702736)
print v(xbgr.mr_n54703056)
print v(xbgr.mr_n54703168)
print v(xbgr.mr_n54703488)
print v(xbgr.mr_n54703600)
print v(xbgr.mr_n54703920)
print v(xbgr.mr_n54704032)
print v(xbgr.mr_n54704464)
print v(xbgr.mr_n54704896)
print v(xbgr.mr_n54705216)
print v(xbgr.mr_n54705328)
print v(xbgr.mr_n54705648)
print v(xbgr.mr_n54705760)
print v(xbgr.mr_n54706080)
print v(xbgr.mr_n54706192)
print v(xbgr.mr_n54706512)
print v(xbgr.mr_n54706624)
print v(xbgr.mr_n54707056)
print v(xbgr.mr_n54707376)
print v(xbgr.mr_n54707488)
print v(xbgr.mr_n54707808)
print v(xbgr.mr_n54707920)
print v(xbgr.mr_n54708240)
print v(xbgr.mr_n54708352)
print v(xbgr.mr_n54708672)
print v(xbgr.mr_n54708784)
print v(xbgr.mr_n54709104)
print v(xbgr.mr_n54709216)
print v(xbgr.mr_n54709536)
print v(xbgr.mr_n54709648)
print v(xbgr.mr_n54710080)
print v(xbgr.mr_n54710512)
print v(xbgr.mr_n54710944)
print v(xbgr.mr_n54711376)
print v(xbgr.mr_n54711808)
print v(xbgr.mr_n54712240)
print v(xbgr.mr_n54712672)
print v(xbgr.mr_n54713104)
print v(xbgr.mr_n54713536)
print v(xbgr.mr_n54713968)
print v(xbgr.mr_n54714288)
print v(xbgr.mr_n54714400)
print v(xbgr.mr_n54714720)
print v(xbgr.mr_n54714832)
print v(xbgr.mr_n54715152)
print v(xbgr.mr_n54715264)
print v(xbgr.mr_n54715584)
print v(xbgr.mr_n54715696)
print v(xbgr.mr_n54716016)
print v(xbgr.mr_n54716128)
print v(xbgr.mr_n54716448)
print v(xbgr.mr_n54716560)
print v(xbgr.mr_n54716880)
print v(xbgr.mr_n54716992)
print v(xbgr.mr_n54717312)
print v(xbgr.mr_n54717424)
print v(xbgr.mr_n54717744)
print v(xbgr.mr_n54717856)
print v(xbgr.mr_n54718176)
print v(xbgr.mr_n54718288)
print v(xbgr.mr_n54718608)
print v(xbgr.mr_n54718720)
print v(xbgr.mr_n54719040)
print v(xbgr.mr_n54719152)
print v(xbgr.mr_n54719472)
print v(xbgr.mr_n54719584)
print v(xbgr.mr_n54720016)
print v(xbgr.mr_n54720448)
print v(xbgr.mr_n54720880)
print v(xbgr.mr_n54721312)
print v(xbgr.mr_n54721744)
print v(xbgr.mr_n54722176)
print v(xbgr.mr_n54722608)
print v(xbgr.mr_n54723040)
print v(xbgr.mr_n54723472)
print v(xbgr.mr_n54723904)
print v(xbgr.mr_n54724336)
print v(xbgr.mr_n54724768)
print v(xbgr.mr_n54725200)
print v(xbgr.mr_n54725520)
print v(xbgr.mr_n54725632)
print v(xbgr.mr_n54725952)
print v(xbgr.mr_n54726064)
print v(xbgr.mr_n54726384)
print v(xbgr.mr_n54726496)
print v(xbgr.mr_n54726816)
print v(xbgr.mr_n54726928)
print v(xbgr.mr_n54727248)
print v(xbgr.mr_n54727360)
print v(xbgr.mr_n54727680)
print v(xbgr.mr_n54727792)
print v(xbgr.mr_n54728112)
print v(xbgr.mr_n54728224)
print v(xbgr.mr_n54728544)
print v(xbgr.mr_n54728656)
print v(xbgr.mr_n54728976)
print v(xbgr.mr_n54729088)
print v(xbgr.mr_n54729408)
print v(xbgr.mr_n54729520)
print v(xbgr.mr_n54729840)
print v(xbgr.mr_n54729952)
print v(xbgr.mr_n54730272)
print v(xbgr.mr_n54730384)
print v(xbgr.mr_n54730704)
print v(xbgr.mr_n54730816)
print v(xbgr.mr_n54731248)
print v(xbgr.mr_n54731680)
print v(xbgr.mr_n54732112)
print v(xbgr.mr_n54732544)
print v(xbgr.mr_n54732976)
print v(xbgr.mr_n54733408)
print v(xbgr.mr_n54733840)
print v(xbgr.mr_n54734272)
print v(xbgr.mr_n54734704)
print v(xbgr.mr_n54735136)
print v(xbgr.mr_n54735568)
print v(xbgr.mr_n54736000)
print v(xbgr.mr_n54736432)
print v(xbgr.mr_n54736752)
print v(xbgr.mr_n54736864)
print v(xbgr.mr_n54737184)
print v(xbgr.mr_n54737296)
print v(xbgr.mr_n54737616)
print v(xbgr.mr_n54737728)
print v(xbgr.mr_n54738048)
print v(xbgr.mr_n54738160)
print v(xbgr.mr_n54738480)
print v(xbgr.mr_n54738592)
print v(xbgr.mr_n54738912)
print v(xbgr.mr_n54739024)
print v(xbgr.mr_n54739344)
print v(xbgr.mr_n54739456)
print v(xbgr.mr_n54739776)
print v(xbgr.mr_n54739888)
print v(xbgr.mr_n54740208)
print v(xbgr.mr_n54740320)
print v(xbgr.mr_n54740640)
print v(xbgr.mr_n54740752)
print v(xbgr.mr_n54741072)
print v(xbgr.mr_n54741184)
print v(xbgr.mr_n54741504)
print v(xbgr.mr_n54741616)
print v(xbgr.mr_n54741936)
print v(xbgr.mr_n54742048)
print v(xbgr.mr_n54742480)
print v(xbgr.mr_n54742912)
print v(xbgr.mr_n54743344)
print v(xbgr.mr_n54743776)
print v(xbgr.mr_n54744208)
print v(xbgr.mr_n54744640)
print v(xbgr.mr_n54745072)
print v(xbgr.mr_n54745504)
print v(xbgr.mr_n54745936)
print v(xbgr.mr_n54746368)
print v(xbgr.mr_n54746800)
print v(xbgr.mr_n54747232)
print v(xbgr.mr_n54747664)
print v(xbgr.mr_n54747984)
print v(xbgr.mr_n54748096)
print v(xbgr.mr_n54748416)
print v(xbgr.mr_n54748528)
print v(xbgr.mr_n54748960)
print v(xbgr.mr_n54749280)
print v(xbgr.mr_n54749392)
print v(xbgr.mr_n54749712)
print v(xbgr.mr_n54749824)
print v(xbgr.mr_n54750144)
print v(xbgr.mr_n54750256)
print v(xbgr.mr_n54750576)
print v(xbgr.mr_n54750688)
print v(xbgr.mr_n54751120)
print v(xbgr.mr_n54751552)
print v(xbgr.mr_n54751984)
print v(xbgr.mr_n54752416)
print v(xbgr.mr_n54752736)
print v(xbgr.mr_n54752848)
print v(xbgr.mr_n54753168)
print v(xbgr.mr_n54753280)
print v(xbgr.mr_n54753712)
print v(xbgr.mr_n54754144)
print v(xbgr.mr_n54754464)
print v(xbgr.mr_n54754576)
print v(xbgr.mr_n54754896)
print v(xbgr.mr_n54755008)
print v(xbgr.mr_n54755328)
print v(xbgr.mr_n54755440)
print v(xbgr.mr_n54755760)
print v(xbgr.mr_n54755872)
print v(xbgr.mr_n54756192)
print v(xbgr.mr_n54756304)
print v(xbgr.mr_n54756736)
print v(xbgr.mr_n54757168)
print v(xbgr.mr_n54757600)
print v(xbgr.mr_n54758032)
print v(xbgr.mr_n54758464)
print v(xbgr.mr_n54758896)
print v(xbgr.mr_n54759216)
print v(xbgr.mr_n54759328)
print v(xbgr.mr_n54759648)
print v(xbgr.mr_n54759760)
print v(xbgr.mr_n54760080)
print v(xbgr.mr_n54760192)
print v(xbgr.mr_n54760512)
print v(xbgr.mr_n54760624)
print v(xbgr.mr_n54760944)
print v(xbgr.mr_n54761056)
print v(xbgr.mr_n54761376)
print v(xbgr.mr_n54761488)
print v(xbgr.mr_n54761808)
print v(xbgr.mr_n54761920)
print v(xbgr.mr_n54762240)
print v(xbgr.mr_n54762352)
print v(xbgr.mr_n54762672)
print v(xbgr.mr_n54762784)
print v(xbgr.mr_n54763104)
print v(xbgr.mr_n54763216)
print v(xbgr.mr_n54763536)
print v(xbgr.mr_n54763648)
print v(xbgr.mr_n54763968)
print v(xbgr.mr_n54764080)
print v(xbgr.mr_n54764512)
print v(xbgr.mr_n54764944)
print v(xbgr.mr_n54765376)
print v(xbgr.mr_n54765808)
print v(xbgr.mr_n54766240)
print v(xbgr.mr_n54766672)
print v(xbgr.mr_n54767104)
print v(xbgr.mr_n54767536)
print v(xbgr.mr_n54767856)
print v(xbgr.mr_n54767968)
print v(xbgr.mr_n54768288)
print v(xbgr.mr_n54768400)
print v(xbgr.mr_n54768720)
print v(xbgr.mr_n54768832)
print v(xbgr.mr_n54769152)
print v(xbgr.mr_n54769264)
print v(xbgr.mr_n54769584)
print v(xbgr.mr_n54769696)
print v(xbgr.mr_n54770016)
print v(xbgr.mr_n54770128)
print v(xbgr.mr_n54770448)
print v(xbgr.mr_n54770560)
print v(xbgr.mr_n54770880)
print v(xbgr.mr_n54770992)
print v(xbgr.mr_n54771424)
print v(xbgr.mr_n54771856)
print v(xbgr.mr_n54772176)
print v(xbgr.mr_n54772288)
print v(xbgr.mr_n54772608)
print v(xbgr.mr_n54772720)
print v(xbgr.mr_n54773040)
print v(xbgr.mr_n54773152)
print v(xbgr.mr_n54773472)
print v(xbgr.mr_n54773584)
print v(xbgr.mr_n54773904)
print v(xbgr.mr_n54774016)
print v(xbgr.mr_n54774336)
print v(xbgr.mr_n54774448)
print v(xbgr.mr_n54774880)
print v(xbgr.mr_n54775312)
print v(xbgr.mr_n54775744)
print v(xbgr.mr_n54776176)
print v(xbgr.mr_n54776608)
print v(xbgr.mr_n54777040)
print v(xbgr.mr_n54777472)
print v(xbgr.mr_n54777904)
print v(xbgr.mr_n54778336)
print v(xbgr.mr_n54778768)
print v(xbgr.mr_n54779200)
print v(xbgr.mr_n54779632)
print v(xbgr.mr_n54780064)
print v(xbgr.mr_n54780496)
print v(xbgr.mr_n54780928)
print v(xbgr.mr_n54781360)
print v(xbgr.mr_n54781680)
print v(xbgr.mr_n54781792)
print v(xbgr.mr_n54782112)
print v(xbgr.mr_n54782224)
print v(xbgr.mr_n54782544)
print v(xbgr.mr_n54782656)
print v(xbgr.mr_n54782976)
print v(xbgr.mr_n54783088)
print v(xbgr.mr_n54783408)
print v(xbgr.mr_n54783520)
print v(xbgr.mr_n54783840)
print v(xbgr.mr_n54783952)
print v(xbgr.mr_n54784272)
print v(xbgr.mr_n54784384)
print v(xbgr.mr_n54784704)
print v(xbgr.mr_n54784816)
print v(xbgr.mr_n54785136)
print v(xbgr.mr_n54785248)
print v(xbgr.mr_n54785568)
print v(xbgr.mr_n54785680)
print v(xbgr.mr_n54786000)
print v(xbgr.mr_n54786112)
print v(xbgr.mr_n54786432)
print v(xbgr.mr_n54786544)
print v(xbgr.mr_n54786864)
print v(xbgr.mr_n54786976)
print v(xbgr.mr_n54787296)
print v(xbgr.mr_n54787408)
print v(xbgr.mr_n54787728)
print v(xbgr.mr_n54787840)
print v(xbgr.mr_n54788160)
print v(xbgr.mr_n54788272)
print v(xbgr.mr_n54788592)
print v(xbgr.mr_n54788704)
print v(xbgr.mr_n54789024)
print v(xbgr.mr_n54789136)
print v(xbgr.mr_n54789456)
print v(xbgr.mr_n54789568)
print v(xbgr.mr_n54789888)
print v(xbgr.mr_n54790000)
print v(xbgr.mr_n54790432)
print v(xbgr.mr_n54790864)
print v(xbgr.mr_n54791296)
print v(xbgr.mr_n54791728)
print v(xbgr.mr_n54792160)
print v(xbgr.mr_n54792592)
print v(xbgr.mr_n54792912)
print v(xbgr.mr_n54793024)
print v(xbgr.mr_n54793344)
print v(xbgr.mr_n54793456)
print v(xbgr.mr_n54793776)
print v(xbgr.mr_n54793888)
print v(xbgr.mr_n54794208)
print v(xbgr.mr_n54794320)
print v(xbgr.mr_n54794640)
print v(xbgr.mr_n54794752)
print v(xbgr.mr_n54795072)
print v(xbgr.mr_n54795184)
print v(xbgr.mr_n54795616)
print v(xbgr.mr_n54796048)
print v(xbgr.mr_n54796480)
print v(xbgr.mr_n54796912)
print v(xbgr.mr_n54797344)
print v(xbgr.mr_n54797776)
print v(xbgr.mr_n54798208)
print v(xbgr.mr_n54798640)
print v(xbgr.mr_n54799072)
print v(xbgr.mr_n54799504)
print v(xbgr.mr_n54799936)
print v(xbgr.mr_n54800368)
print v(xbgr.mr_n54800800)
print v(xbgr.mr_n54801232)
print v(xbgr.mr_n54801664)
print v(xbgr.mr_n54802096)
print v(xbgr.mr_n54802528)
print v(xbgr.mr_n54802960)
print v(xbgr.mr_n54803392)
print v(xbgr.mr_n54803824)
print v(xbgr.mr_n54804144)
print v(xbgr.mr_n54804256)
print v(xbgr.mr_n54804576)
print v(xbgr.mr_n54804688)
print v(xbgr.mr_n54805008)
print v(xbgr.mr_n54805120)
print v(xbgr.mr_n54805440)
print v(xbgr.mr_n54805552)
print v(xbgr.mr_n54805872)
print v(xbgr.mr_n54805984)
print v(xbgr.mr_n54806304)
print v(xbgr.mr_n54806416)
print v(xbgr.mr_n54806736)
print v(xbgr.mr_n54806848)
print v(xbgr.mr_n54807168)
print v(xbgr.mr_n54807280)
print v(xbgr.mr_n54807600)
print v(xbgr.mr_n54807712)
print v(xbgr.mr_n54808032)
print v(xbgr.mr_n54808144)
print v(xbgr.mr_n54808464)
print v(xbgr.mr_n54808576)
print v(xbgr.mr_n54808896)
print v(xbgr.mr_n54809008)
print v(xbgr.mr_n54809328)
print v(xbgr.mr_n54809440)
print v(xbgr.mr_n54809760)
print v(xbgr.mr_n54809872)
print v(xbgr.mr_n54810192)
print v(xbgr.mr_n54810304)
print v(xbgr.mr_n54810624)
print v(xbgr.mr_n54810736)
print v(xbgr.mr_n54811056)
print v(xbgr.mr_n54811168)
print v(xbgr.mr_n54811488)
print v(xbgr.mr_n54811600)
print v(xbgr.mr_n54811920)
print v(xbgr.mr_n54812032)
print v(xbgr.mr_n54812352)
print v(xbgr.mr_n54812464)
print v(xbgr.mr_n54812784)
print v(xbgr.mr_n54812896)
print v(xbgr.mr_n54813216)
print v(xbgr.mr_n54813328)
print v(xbgr.mr_n54813648)
print v(xbgr.mr_n54813760)
print v(xbgr.mr_n54814080)
print v(xbgr.mr_n54814192)
print v(xbgr.mr_n54814512)
print v(xbgr.mr_n54814624)
print v(xbgr.mr_n54814944)
print v(xbgr.mr_n54815056)
print v(xbgr.mr_n54815376)
print v(xbgr.mr_n54815488)
print v(xbgr.mr_n54815808)
print v(xbgr.mr_n54815920)
print v(xbgr.mr_n54816240)
print v(xbgr.mr_n54816352)
print v(xbgr.mr_n54816672)
print v(xbgr.mr_n54816784)
print v(xbgr.mr_n54817104)
print v(xbgr.mr_n54817216)
print v(xbgr.mr_n54817536)
print v(xbgr.mr_n54817648)
print v(xbgr.mr_n54818080)
print v(xbgr.mr_n54818512)
print v(xbgr.mr_n54818832)
print v(xbgr.mr_n54818944)
print v(xbgr.mr_n54819264)
print v(xbgr.mr_n54819376)
print v(xbgr.mr_n54819696)
print v(xbgr.mr_n54819808)
print v(xbgr.mr_n54820128)
print v(xbgr.mr_n54820240)
print v(xbgr.mr_n54820560)
print v(xbgr.mr_n54820672)
print v(xbgr.mr_n54820992)
print v(xbgr.mr_n54821104)
print v(xbgr.mr_n54821424)
print v(xbgr.mr_n54821536)
print v(xbgr.mr_n54821856)
print v(xbgr.mr_n54821968)
print v(xbgr.mr_n54822288)
print v(xbgr.mr_n54822400)
print v(xbgr.mr_n54822720)
print v(xbgr.mr_n54822832)
print v(xbgr.mr_n54823264)
print v(xbgr.mr_n54823696)
print v(xbgr.mr_n54824128)
print v(xbgr.mr_n54824448)
print v(xbgr.mr_n54824560)
print v(xbgr.mr_n54824880)
print v(xbgr.mr_n54824992)
print v(xbgr.mr_n54825424)
print v(xbgr.mr_n54825856)
print v(xbgr.mr_n54826288)
print v(xbgr.mr_n54826720)
print v(xbgr.mr_n54827152)
print v(xbgr.mr_n54827584)
print v(xbgr.mr_n54828016)
print v(xbgr.mr_n54828448)
print v(xbgr.mr_n54828880)
print v(xbgr.mr_n54829312)
print v(xbgr.mr_n54829744)
print v(xbgr.mr_n54830064)
print v(xbgr.mr_n54830176)
print v(xbgr.mr_n54830496)
print v(xbgr.mr_n54830608)
print v(xbgr.mr_n54830928)
print v(xbgr.mr_n54831040)
print v(xbgr.mr_n54831360)
print v(xbgr.mr_n54831472)
print v(xbgr.mr_n54831792)
print v(xbgr.mr_n54831904)
print v(xbgr.mr_n54832224)
print v(xbgr.mr_n54832336)
print v(xbgr.mr_n54832656)
print v(xbgr.mr_n54832768)
print v(xbgr.mr_n54833088)
print v(xbgr.mr_n54833200)
print v(xbgr.mr_n54833632)
print v(xbgr.mr_n54834064)
print v(xbgr.mr_n54834496)
print v(xbgr.mr_n54834928)
print v(xbgr.mr_n54835360)
print v(xbgr.mr_n54835792)
print v(xbgr.mr_n54836224)
print v(xbgr.mr_n54836656)
print v(xbgr.mr_n54837088)
print v(xbgr.mr_n54837520)
print v(xbgr.mr_n54837952)
print v(xbgr.mr_n54838384)
print v(xbgr.mr_n54838816)
print v(xbgr.mr_n54839248)
print v(xbgr.mr_n54839680)
print v(xbgr.mr_n54840112)
print v(xbgr.mr_n54840544)
print v(xbgr.mr_n54840976)
print v(xbgr.mr_n54841408)
print v(xbgr.mr_n54841840)
print v(xbgr.mr_n54842160)
print v(xbgr.mr_n54842272)
print v(xbgr.mr_n54842592)
print v(xbgr.mr_n54842704)
print v(xbgr.mr_n54843024)
print v(xbgr.mr_n54843136)
print v(xbgr.mr_n54843456)
print v(xbgr.mr_n54843568)
print v(xbgr.mr_n54843888)
print v(xbgr.mr_n54844000)
print v(xbgr.mr_n54844320)
print v(xbgr.mr_n54844432)
print v(xbgr.mr_n54844752)
print v(xbgr.mr_n54844864)
print v(xbgr.mr_n54845184)
print v(xbgr.mr_n54845296)
print v(xbgr.mr_n54845616)
print v(xbgr.mr_n54845728)
print v(xbgr.mr_n54846048)
print v(xbgr.mr_n54846160)
print v(xbgr.mr_n54846480)
print v(xbgr.mr_n54846592)
print v(xbgr.mr_n54846912)
print v(xbgr.mr_n54847024)
print v(xbgr.mr_n54847344)
print v(xbgr.mr_n54847456)
print v(xbgr.mr_n54847888)
print v(xbgr.mr_n54848320)
print v(xbgr.mr_n54848752)
print v(xbgr.mr_n54849184)
print v(xbgr.mr_n54849616)
print v(xbgr.mr_n54850048)
print v(xbgr.mr_n54850480)
print v(xbgr.mr_n54850912)
print v(xbgr.mr_n54851344)
print v(xbgr.mr_n54851776)
print v(xbgr.mr_n54852208)
print v(xbgr.mr_n54852640)
print v(xbgr.mr_n54853072)
print v(xbgr.mr_n54853392)
print v(xbgr.mr_n54853504)
print v(xbgr.mr_n54853824)
print v(xbgr.mr_n54853936)
print v(xbgr.mr_n54854256)
print v(xbgr.mr_n54854368)
print v(xbgr.mr_n54854688)
print v(xbgr.mr_n54854800)
print v(xbgr.mr_n54855120)
print v(xbgr.mr_n54855232)
print v(xbgr.mr_n54855552)
print v(xbgr.mr_n54855664)
print v(xbgr.mr_n54855984)
print v(xbgr.mr_n54856096)
print v(xbgr.mr_n54856416)
print v(xbgr.mr_n54856528)
print v(xbgr.mr_n54856848)
print v(xbgr.mr_n54856960)
print v(xbgr.mr_n54857280)
print v(xbgr.mr_n54857392)
print v(xbgr.mr_n54857712)
print v(xbgr.mr_n54857824)
print v(xbgr.mr_n54858144)
print v(xbgr.mr_n54858256)
print v(xbgr.mr_n54858688)
print v(xbgr.mr_n54859008)
print v(xbgr.mr_n54859120)
print v(xbgr.mr_n54859552)
print v(xbgr.mr_n54859984)
print v(xbgr.mr_n54860416)
print v(xbgr.mr_n54860848)
print v(xbgr.mr_n54861280)
print v(xbgr.mr_n54861712)
print v(xbgr.mr_n54862144)
print v(xbgr.mr_n54862576)
print v(xbgr.mr_n54863008)
print v(xbgr.mr_n54863440)
print v(xbgr.mr_n54863872)
print v(xbgr.mr_n54864304)
print v(xbgr.mr_n54864624)
print v(xbgr.mr_n54864736)
print v(xbgr.mr_n54865056)
print v(xbgr.mr_n54865168)
print v(xbgr.mr_n54865488)
print v(xbgr.mr_n54865600)
print v(xbgr.mr_n54865920)
print v(xbgr.mr_n54866032)
print v(xbgr.mr_n54866352)
print v(xbgr.mr_n54866464)
print v(xbgr.mr_n54866784)
print v(xbgr.mr_n54866896)
print v(xbgr.mr_n54867216)
print v(xbgr.mr_n54867328)
print v(xbgr.mr_n54867648)
print v(xbgr.mr_n54867760)
print v(xbgr.mr_n54868080)
print v(xbgr.mr_n54868192)
print v(xbgr.mr_n54868512)
print v(xbgr.mr_n54868624)
print v(xbgr.mr_n54868944)
print v(xbgr.mr_n54869056)
print v(xbgr.mr_n54869488)
print v(xbgr.mr_n54869920)
print v(xbgr.mr_n54870352)
print v(xbgr.mr_n54870672)
print v(xbgr.mr_n54870784)
print v(xbgr.mr_n54871104)
print v(xbgr.mr_n54871216)
print v(xbgr.mr_n54871648)
print v(xbgr.mr_n54872080)
print v(xbgr.mr_n54872512)
print v(xbgr.mr_n54872944)
print v(xbgr.mr_n54873376)
print v(xbgr.mr_n54873808)
print v(xbgr.mr_n54874240)
print v(xbgr.mr_n54874672)
print v(xbgr.mr_n54875104)
print v(xbgr.mr_n54875536)
print v(xbgr.mr_n54875856)
print v(xbgr.mr_n54875968)
print v(xbgr.mr_n54876288)
print v(xbgr.mr_n54876400)
print v(xbgr.mr_n54876720)
print v(xbgr.mr_n54876832)
print v(xbgr.mr_n54877152)
print v(xbgr.mr_n54877264)
print v(xbgr.mr_n54877584)
print v(xbgr.mr_n54877696)
print v(xbgr.mr_n54878016)
print v(xbgr.mr_n54878128)
print v(xbgr.mr_n54878448)
print v(xbgr.mr_n54878560)
print v(xbgr.mr_n54878880)
print v(xbgr.mr_n54878992)
print v(xbgr.mr_n54879312)
print v(xbgr.mr_n54879424)
print v(xbgr.mr_n54879744)
print v(xbgr.mr_n54879856)
print v(xbgr.mr_n54880176)
print v(xbgr.mr_n54880288)
print v(xbgr.mr_n54880608)
print v(xbgr.mr_n54880720)
print v(xbgr.mr_n54881152)
print v(xbgr.mr_n54881584)
print v(xbgr.mr_n54882016)
print v(xbgr.mr_n54882448)
print v(xbgr.mr_n54882880)
print v(xbgr.mr_n54883312)
print v(xbgr.mr_n54883744)
print v(xbgr.mr_n54884064)
print v(xbgr.mr_n54884176)
print v(xbgr.mr_n54884608)
print v(xbgr.mr_n54885040)
print v(xbgr.mr_n54885472)
print v(xbgr.mr_n54885904)
print v(xbgr.mr_n54886336)
print v(xbgr.mr_n54886768)
print v(xbgr.mr_n54887088)
print v(xbgr.mr_n54887200)
print v(xbgr.mr_n54887520)
print v(xbgr.mr_n54887632)
print v(xbgr.mr_n54887952)
print v(xbgr.mr_n54888064)
print v(xbgr.mr_n54888384)
print v(xbgr.mr_n54888496)
print v(xbgr.mr_n54888816)
print v(xbgr.mr_n54888928)
print v(xbgr.mr_n54889248)
print v(xbgr.mr_n54889360)
print v(xbgr.mr_n54889680)
print v(xbgr.mr_n54889792)
print v(xbgr.mr_n54890112)
print v(xbgr.mr_n54890224)
print v(xbgr.mr_n54890544)
print v(xbgr.mr_n54890656)
print v(xbgr.mr_n54890976)
print v(xbgr.mr_n54891088)
print v(xbgr.mr_n54891408)
print v(xbgr.mr_n54891520)
print v(xbgr.mr_n54891840)
print v(xbgr.mr_n54891952)
print v(xbgr.mr_n54892272)
print v(xbgr.mr_n54892384)
print v(xbgr.mr_n54892704)
print v(xbgr.mr_n54892816)
print v(xbgr.mr_n54893136)
print v(xbgr.mr_n54893248)
print v(xbgr.mr_n54893568)
print v(xbgr.mr_n54893680)
print v(xbgr.mr_n54894000)
print v(xbgr.mr_n54894112)
print v(xbgr.mr_n54894432)
print v(xbgr.mr_n54894544)
print v(xbgr.mr_n54894864)
print v(xbgr.mr_n54894976)
print v(xbgr.mr_n54895296)
print v(xbgr.mr_n54895408)
print v(xbgr.mr_n54895728)
print v(xbgr.mr_n54895840)
print v(xbgr.mr_n54896160)
print v(xbgr.mr_n54896272)
print v(xbgr.mr_n54896592)
print v(xbgr.mr_n54896704)
print v(xbgr.mr_n54897024)
print v(xbgr.mr_n54897136)
print v(xbgr.mr_n54897568)
print v(xbgr.mr_n54898000)
print v(xbgr.mr_n54898432)
print v(xbgr.mr_n54898752)
print v(xbgr.mr_n54898864)
print v(xbgr.mr_n54899184)
print v(xbgr.mr_n54899296)
print v(xbgr.mr_n54899728)
print v(xbgr.mr_n54900160)
print v(xbgr.mr_n54900592)
print v(xbgr.mr_n54901024)
print v(xbgr.mr_n54901456)
print v(xbgr.mr_n54901888)
print v(xbgr.mr_n54902320)
print v(xbgr.mr_n54902752)
print v(xbgr.mr_n54903184)
print v(xbgr.mr_n54903616)
print v(xbgr.mr_n54904048)
print v(xbgr.mr_n54904480)
print v(xbgr.mr_n54904912)
print v(xbgr.mr_n54905344)
print v(xbgr.mr_n54905776)
print v(xbgr.mr_n54906208)
print v(xbgr.mr_n54906640)
print v(xbgr.mr_n54907072)
print v(xbgr.mr_n54907504)
print v(xbgr.mr_n54907936)
print v(xbgr.mr_n54908368)
print v(xbgr.mr_n54908800)
print v(xbgr.mr_n54909232)
print v(xbgr.mr_n54909552)
print v(xbgr.mr_n54909664)
print v(xbgr.mr_n54909984)
print v(xbgr.mr_n54910096)
print v(xbgr.mr_n54910416)
print v(xbgr.mr_n54910528)
print v(xbgr.mr_n54910848)
print v(xbgr.mr_n54910960)
print v(xbgr.mr_n54911280)
print v(xbgr.mr_n54911392)
print v(xbgr.mr_n54911712)
print v(xbgr.mr_n54911824)
print v(xbgr.mr_n54912144)
print v(xbgr.mr_n54912256)
print v(xbgr.mr_n54912576)
print v(xbgr.mr_n54912688)
print v(xbgr.mr_n54913008)
print v(xbgr.mr_n54913120)
print v(xbgr.mr_n54913440)
print v(xbgr.mr_n54913552)
print v(xbgr.mr_n54913872)
print v(xbgr.mr_n54913984)
print v(xbgr.mr_n54914304)
print v(xbgr.mr_n54914416)
print v(xbgr.mr_n54914736)
print v(xbgr.mr_n54914848)
print v(xbgr.mr_n54915168)
print v(xbgr.mr_n54915280)
print v(xbgr.mr_n54915712)
print v(xbgr.mr_n54916144)
print v(xbgr.mr_n54916464)
print v(xbgr.mr_n54916576)
print v(xbgr.mr_n54916896)
print v(xbgr.mr_n54917008)
print v(xbgr.mr_n54917328)
print v(xbgr.mr_n54917440)
print v(xbgr.mr_n54917760)
print v(xbgr.mr_n54917872)
print v(xbgr.mr_n54918304)
print v(xbgr.mr_n54918736)
print v(xbgr.mr_n54919056)
print v(xbgr.mr_n54919168)
print v(xbgr.mr_n54919488)
print v(xbgr.mr_n54919600)
print v(xbgr.mr_n54919920)
print v(xbgr.mr_n54920032)
print v(xbgr.mr_n54920352)
print v(xbgr.mr_n54920464)
print v(xbgr.mr_n54920784)
print v(xbgr.mr_n54920896)
print v(xbgr.mr_n54921216)
print v(xbgr.mr_n54921328)
print v(xbgr.mr_n54921648)
print v(xbgr.mr_n54921760)
print v(xbgr.mr_n54922080)
print v(xbgr.mr_n54922192)
print v(xbgr.mr_n54922624)
print v(xbgr.mr_n54923056)
print v(xbgr.mr_n54923488)
print v(xbgr.mr_n54923920)
print v(xbgr.mr_n54924352)
print v(xbgr.mr_n54924784)
print v(xbgr.mr_n54925216)
print v(xbgr.mr_n54925648)
print v(xbgr.mr_n54926080)
print v(xbgr.mr_n54926512)
print v(xbgr.mr_n54926832)
print v(xbgr.mr_n54926944)
print v(xbgr.mr_n54927264)
print v(xbgr.mr_n54927376)
print v(xbgr.mr_n54927696)
print v(xbgr.mr_n54927808)
print v(xbgr.mr_n54928128)
print v(xbgr.mr_n54928240)
print v(xbgr.mr_n54933296)
print v(xbgr.mr_n54933408)
print v(xbgr.mr_n54933744)
print v(xbgr.mr_n54933856)
print v(xbgr.mr_n54934176)
print v(xbgr.mr_n54934288)
print v(xbgr.mr_n54934656)
print v(xbgr.mr_n54934768)
print v(xbgr.mr_n54935088)
print v(xbgr.mr_n54935200)
print v(xbgr.mr_n54935520)
print v(xbgr.mr_n54935632)
print v(xbgr.mr_n54935872)
print v(xbgr.mr_n54935984)
print v(xbgr.mr_n54936304)
print v(xbgr.mr_n54936416)
print v(xbgr.mr_n54936736)
print v(xbgr.mr_n54936848)
print v(xbgr.mr_n54937168)
print v(xbgr.mr_n54937280)
print v(xbgr.mr_n54937600)
print v(xbgr.mr_n54937712)
print v(xbgr.mr_n54938032)
print v(xbgr.mr_n54938144)
print v(xbgr.mr_n54938464)
print v(xbgr.mr_n54938576)
print v(xbgr.mr_n54938896)
print v(xbgr.mr_n54939008)
print v(xbgr.mr_n54939328)
print v(xbgr.mr_n54939440)
print v(xbgr.mr_n54939760)
print v(xbgr.mr_n54939872)
print v(xbgr.mr_n54940192)
print v(xbgr.mr_n54940304)
print v(xbgr.mr_n54940624)
print v(xbgr.mr_n54940736)
print v(xbgr.mr_n54941056)
print v(xbgr.mr_n54941168)
print v(xbgr.mr_n54941488)
print v(xbgr.mr_n54941600)
print v(xbgr.mr_n54941920)
print v(xbgr.mr_n54942032)
print v(xbgr.mr_n54942352)
print v(xbgr.mr_n54942464)
print v(xbgr.mr_n54942784)
print v(xbgr.mr_n54942896)
print v(xbgr.mr_n54943216)
print v(xbgr.mr_n54943328)
print v(xbgr.mr_n54943648)
print v(xbgr.mr_n54943760)
print v(xbgr.mr_n54944080)
print v(xbgr.mr_n54944192)
print v(xbgr.mr_n54944512)
print v(xbgr.mr_n54944624)
print v(xbgr.mr_n54944944)
print v(xbgr.mr_n54945056)
print v(xbgr.mr_n54945376)
print v(xbgr.mr_n54945488)
print v(xbgr.mr_n54945808)
print v(xbgr.mr_n54945920)
print v(xbgr.mr_n54946240)
print v(xbgr.mr_n54946352)
print v(xbgr.mr_n54946672)
print v(xbgr.mr_n54946784)
print v(xbgr.mr_n54947104)
print v(xbgr.mr_n54947216)
print v(xbgr.mr_n54947536)
print v(xbgr.mr_n54947648)
print v(xbgr.mr_n54947968)
print v(xbgr.mr_n54948080)
print v(xbgr.mr_n54948400)
print v(xbgr.mr_n54948512)
print v(xbgr.mr_n54948832)
print v(xbgr.mr_n54948944)
print v(xbgr.mr_n54949264)
print v(xbgr.mr_n54949376)
print v(xbgr.mr_n54949696)
print v(xbgr.mr_n54949808)
print v(xbgr.mr_n54950128)
print v(xbgr.mr_n54950240)
print v(xbgr.mr_n54950560)
print v(xbgr.mr_n54950672)
print v(xbgr.mr_n54950992)
print v(xbgr.mr_n54951104)
print v(xbgr.mr_n54951424)
print v(xbgr.mr_n54951536)
print v(xbgr.mr_n54951856)
print v(xbgr.mr_n54951968)
print v(xbgr.mr_n54952288)
print v(xbgr.mr_n54952400)
print v(xbgr.mr_n54952720)
print v(xbgr.mr_n54952832)
print v(xbgr.mr_n54953152)
print v(xbgr.mr_n54953264)
print v(xbgr.mr_n54953584)
print v(xbgr.mr_n54953696)
print v(xbgr.mr_n54954016)
print v(xbgr.mr_n54954128)
print v(xbgr.mr_n54954448)
print v(xbgr.mr_n54954560)
print v(xbgr.mr_n54954880)
print v(xbgr.mr_n54954992)
print v(xbgr.mr_n54955312)
print v(xbgr.mr_n54955424)
print v(xbgr.mr_n54955744)
print v(xbgr.mr_n54955856)
print v(xbgr.mr_n54956176)
print v(xbgr.mr_n54956288)
print v(xbgr.mr_n54956608)
print v(xbgr.mr_n54956720)
print v(xbgr.mr_n54957040)
print v(xbgr.mr_n54957152)
print v(xbgr.mr_n54957472)
print v(xbgr.mr_n54957584)
print v(xbgr.mr_n54957904)
print v(xbgr.mr_n54958016)
print v(xbgr.mr_n54958336)
print v(xbgr.mr_n54958448)
print v(xbgr.mr_n54958768)
print v(xbgr.mr_n54958880)
print v(xbgr.mr_n54959200)
print v(xbgr.mr_n54959312)
print v(xbgr.mr_n54959632)
print v(xbgr.mr_n54959744)
print v(xbgr.mr_n54960064)
print v(xbgr.mr_n54960176)
print v(xbgr.mr_n54960496)
print v(xbgr.mr_n54960608)
print v(xbgr.mr_n54960928)
print v(xbgr.mr_n54961040)
print v(xbgr.mr_n54961360)
print v(xbgr.mr_n54961472)
print v(xbgr.mr_n54961792)
print v(xbgr.mr_n54961904)
print v(xbgr.mr_n54962224)
print v(xbgr.mr_n54962336)
print v(xbgr.mr_n54962656)
print v(xbgr.mr_n54962768)
print v(xbgr.mr_n54963088)
print v(xbgr.mr_n54963200)
print v(xbgr.mr_n54963424)
print v(xbgr.mr_n54963536)
print v(xbgr.mr_n54963792)
print v(xbgr.mr_n54963904)
print v(xbgr.mr_n54964160)
print v(xbgr.mr_n54964272)
print v(xbgr.mr_n54964528)
print v(xbgr.mr_n54964640)
print v(xbgr.mr_n54964896)
print v(xbgr.mr_n54965008)
print v(xbgr.mr_n54965264)
print v(xbgr.mr_n54965376)
print v(xbgr.mr_n54965632)
print v(xbgr.mr_n54965744)
print v(xbgr.mr_n54966000)
print v(xbgr.mr_n54966112)
print v(xbgr.mr_n54966368)
print v(xbgr.mr_n54966480)
print v(xbgr.mr_n54966736)
print v(xbgr.mr_n54966848)
print v(xbgr.mr_n54967168)
print v(xbgr.mr_n54967280)
print v(xbgr.mr_n54967600)
print v(xbgr.mr_n54967712)
print v(xbgr.mr_n54968032)
print v(xbgr.mr_n54968144)
print v(xbgr.mr_n54968464)
print v(xbgr.mr_n54968576)
print v(xbgr.mr_n54968896)
print v(xbgr.mr_n54969008)
print v(xbgr.mr_n54969328)
print v(xbgr.mr_n54969440)
print v(xbgr.mr_n54969760)
print v(xbgr.mr_n54969872)
print v(xbgr.mr_n54970192)
print v(xbgr.mr_n54970304)
print v(xbgr.mr_n54970624)
print v(xbgr.mr_n54970736)
print v(xbgr.mr_n54971056)
print v(xbgr.mr_n54971168)
print v(xbgr.mr_n54971488)
print v(xbgr.mr_n54971600)
print v(xbgr.mr_n54971920)
print v(xbgr.mr_n54972032)
print v(xbgr.mr_n54972352)
print v(xbgr.mr_n54972464)
print v(xbgr.mr_n54972784)
print v(xbgr.mr_n54972896)
print v(xbgr.mr_n54973216)
print v(xbgr.mr_n54973328)
print v(xbgr.mr_n54973648)
print v(xbgr.mr_n54973760)
print v(xbgr.mr_n54974080)
print v(xbgr.mr_n54974192)
print v(xbgr.mr_n54974512)
print v(xbgr.mr_n54974624)
print v(xbgr.mr_n54974944)
print v(xbgr.mr_n54975056)
print v(xbgr.mr_n54975376)
print v(xbgr.mr_n54975488)
print v(xbgr.mr_n54975808)
print v(xbgr.mr_n54975920)
print v(xbgr.mr_n54976240)
print v(xbgr.mr_n54976352)
print v(xbgr.mr_n54976672)
print v(xbgr.mr_n54976784)
print v(xbgr.mr_n54977104)
print v(xbgr.mr_n54977216)
print v(xbgr.mr_n54977536)
print v(xbgr.mr_n54977648)
print v(xbgr.mr_n54977968)
print v(xbgr.mr_n54978080)
print v(xbgr.mr_n54978400)
print v(xbgr.mr_n54978512)
print v(xbgr.mr_n54978832)
print v(xbgr.mr_n54978944)
print v(xbgr.mr_n54979264)
print v(xbgr.mr_n54979376)
print v(xbgr.mr_n54979696)
print v(xbgr.mr_n54979808)
print v(xbgr.mr_n54980128)
print v(xbgr.mr_n54980240)
print v(xbgr.mr_n54980560)
print v(xbgr.mr_n54980672)
print v(xbgr.mr_n54980992)
print v(xbgr.mr_n54981104)
print v(xbgr.mr_n54981424)
print v(xbgr.mr_n54981536)
print v(xbgr.mr_n54981856)
print v(xbgr.mr_n54981968)
print v(xbgr.mr_n54982288)
print v(xbgr.mr_n54982400)
print v(xbgr.mr_n54982720)
print v(xbgr.mr_n54982832)
print v(xbgr.mr_n54983152)
print v(xbgr.mr_n54983264)
print v(xbgr.mr_n54983584)
print v(xbgr.mr_n54983696)
print v(xbgr.mr_n54984016)
print v(xbgr.mr_n54984128)
print v(xbgr.mr_n54984448)
print v(xbgr.mr_n54984560)
print v(xbgr.mr_n54984880)
print v(xbgr.mr_n54984992)
print v(xbgr.mr_n54985312)
print v(xbgr.mr_n54985424)
print v(xbgr.mr_n54985744)
print v(xbgr.mr_n54985856)
print v(xbgr.mr_n54986176)
print v(xbgr.mr_n54986288)
print v(xbgr.mr_n54986608)
print v(xbgr.mr_n54986720)
print v(xbgr.mr_n54987040)
print v(xbgr.mr_n54987152)
print v(xbgr.mr_n54987472)
print v(xbgr.mr_n54987584)
print v(xbgr.mr_n54987904)
print v(xbgr.mr_n54988016)
print v(xbgr.mr_n54988336)
print v(xbgr.mr_n54988448)
print v(xbgr.mr_n54988768)
print v(xbgr.mr_n54988880)
print v(xbgr.mr_n54989200)
print v(xbgr.mr_n54989312)
print v(xbgr.mr_n54989632)
print v(xbgr.mr_n54989744)
print v(xbgr.mr_n54990064)
print v(xbgr.mr_n54990176)
print v(xbgr.mr_n54990496)
print v(xbgr.mr_n54990608)
print v(xbgr.mr_n54990928)
print v(xbgr.mr_n54991040)
print v(xbgr.mr_n54991360)
print v(xbgr.mr_n54991472)
print v(xbgr.mr_n54991792)
print v(xbgr.mr_n54991904)
print v(xbgr.mr_n54992224)
print v(xbgr.mr_n54992336)
print v(xbgr.mr_n54992656)
print v(xbgr.mr_n54992768)
print v(xbgr.mr_n54993088)
print v(xbgr.mr_n54993200)
print v(xbgr.mr_n54993520)
print v(xbgr.mr_n54993632)
print v(xbgr.mr_n54993952)
print v(xbgr.mr_n54994064)
print v(xbgr.mr_n54994384)
print v(xbgr.mr_n54994496)
print v(xbgr.mr_n54994704)
print v(xbgr.mr_n54994816)
print v(xbgr.mr_n54995136)
print v(xbgr.mr_n54995248)
print v(xbgr.mr_n54995568)
print v(xbgr.mr_n54995680)
print v(xbgr.mr_n54996000)
print v(xbgr.mr_n54996112)
print v(xbgr.mr_n54996432)
print v(xbgr.mr_n54996544)
print v(xbgr.mr_n54996864)
print v(xbgr.mr_n54996976)
print v(xbgr.mr_n54997296)
print v(xbgr.mr_n54997408)
print v(xbgr.mr_n54997728)
print v(xbgr.mr_n54997840)
print v(xbgr.mr_n54998160)
print v(xbgr.mr_n54998272)
print v(xbgr.mr_n54998592)
print v(xbgr.mr_n54998704)
print v(xbgr.mr_n54999024)
print v(xbgr.mr_n54999136)
print v(xbgr.mr_n54999456)
print v(xbgr.mr_n54999568)
print v(xbgr.mr_n54999888)
print v(xbgr.mr_n55000000)
print v(xbgr.mr_n55000320)
print v(xbgr.mr_n55000432)
print v(xbgr.mr_n55000752)
print v(xbgr.mr_n55000864)
print v(xbgr.mr_n55001184)
print v(xbgr.mr_n55001296)
print v(xbgr.mr_n55001616)
print v(xbgr.mr_n55001728)
print v(xbgr.mr_n55002048)
print v(xbgr.mr_n55002160)
print v(xbgr.mr_n55002480)
print v(xbgr.mr_n55002592)
print v(xbgr.mr_n55002912)
print v(xbgr.mr_n55003024)
print v(xbgr.mr_n55003344)
print v(xbgr.mr_n55003456)
print v(xbgr.mr_n55003776)
print v(xbgr.mr_n55003888)
print v(xbgr.mr_n55004208)
print v(xbgr.mr_n55004320)
print v(xbgr.mr_n55004640)
print v(xbgr.mr_n55004752)
print v(xbgr.mr_n55005072)
print v(xbgr.mr_n55005184)
print v(xbgr.mr_n55005504)
print v(xbgr.mr_n55005616)
print v(xbgr.mr_n55005936)
print v(xbgr.mr_n55006048)
print v(xbgr.mr_n55006368)
print v(xbgr.mr_n55006480)
print v(xbgr.mr_n55006800)
print v(xbgr.mr_n55006912)
print v(xbgr.mr_n55007232)
print v(xbgr.mr_n55007344)
print v(xbgr.mr_n55007664)
print v(xbgr.mr_n55007776)
print v(xbgr.mr_n55008096)
print v(xbgr.mr_n55008208)
print v(xbgr.mr_n55008528)
print v(xbgr.mr_n55008640)
print v(xbgr.mr_n55008960)
print v(xbgr.mr_n55009072)
print v(xbgr.mr_n55009392)
print v(xbgr.mr_n55009504)
print v(xbgr.mr_n55009824)
print v(xbgr.mr_n55009936)
print v(xbgr.mr_n55010256)
print v(xbgr.mr_n55010368)
print v(xbgr.mr_n55010688)
print v(xbgr.mr_n55010800)
print v(xbgr.mr_n55011120)
print v(xbgr.mr_n55011232)
print v(xbgr.mr_n55011552)
print v(xbgr.mr_n55011664)
print v(xbgr.mr_n55011984)
print v(xbgr.mr_n55012096)
print v(xbgr.mr_n55012416)
print v(xbgr.mr_n55012528)
print v(xbgr.mr_n55012848)
print v(xbgr.mr_n55012960)
print v(xbgr.mr_n55013280)
print v(xbgr.mr_n55013392)
print v(xbgr.mr_n55013712)
print v(xbgr.mr_n55013824)
print v(xbgr.mr_n55014144)
print v(xbgr.mr_n55014256)
print v(xbgr.mr_n55014576)
print v(xbgr.mr_n55014688)
print v(xbgr.mr_n55015008)
print v(xbgr.mr_n55015120)
print v(xbgr.mr_n55015440)
print v(xbgr.mr_n55015552)
print v(xbgr.mr_n55015872)
print v(xbgr.mr_n55015984)
print v(xbgr.mr_n55016304)
print v(xbgr.mr_n55016416)
print v(xbgr.mr_n55016736)
print v(xbgr.mr_n55016848)
print v(xbgr.mr_n55017168)
print v(xbgr.mr_n55017280)
print v(xbgr.mr_n55017600)
print v(xbgr.mr_n55017712)
print v(xbgr.mr_n55018032)
print v(xbgr.mr_n55018144)
print v(xbgr.mr_n55018464)
print v(xbgr.mr_n55018576)
print v(xbgr.mr_n55018896)
print v(xbgr.mr_n55019008)
print v(xbgr.mr_n55019328)
print v(xbgr.mr_n55019440)
print v(xbgr.mr_n55019760)
print v(xbgr.mr_n55019872)
print v(xbgr.mr_n55020192)
print v(xbgr.mr_n55020304)
print v(xbgr.mr_n55020624)
print v(xbgr.mr_n55020736)
print v(xbgr.mr_n55021056)
print v(xbgr.mr_n55021168)
print v(xbgr.mr_n55021488)
print v(xbgr.mr_n55021600)
print v(xbgr.mr_n55021920)
print v(xbgr.mr_n55022032)
print v(xbgr.mr_n55022352)
print v(xbgr.mr_n55022464)
print v(xbgr.mr_n55022784)
print v(xbgr.mr_n55022896)
print v(xbgr.mr_n55023216)
print v(xbgr.mr_n55023328)
print v(xbgr.mr_n55023648)
print v(xbgr.mr_n55023760)
print v(xbgr.mr_n55024080)
print v(xbgr.mr_n55024192)
print v(xbgr.mr_n55024512)
print v(xbgr.mr_n55024624)
print v(xbgr.mr_n55024944)
print v(xbgr.mr_n55025056)
print v(xbgr.mr_n55025376)
print v(xbgr.mr_n55025488)
print v(xbgr.mr_n55025808)
print v(xbgr.mr_n55025920)
print v(xbgr.mr_n55026240)
print v(xbgr.mr_n55026352)
print v(xbgr.mr_n55026672)
print v(xbgr.mr_n55026784)
print v(xbgr.mr_n55027104)
print v(xbgr.mr_n55027216)
print v(xbgr.mr_n55027536)
print v(xbgr.mr_n55027648)
print v(xbgr.mr_n55027968)
print v(xbgr.mr_n55028080)
print v(xbgr.mr_n55028400)
print v(xbgr.mr_n55028512)
print v(xbgr.mr_n55028832)
print v(xbgr.mr_n55028944)
print v(xbgr.mr_n55029264)
print v(xbgr.mr_n55029376)
print v(xbgr.mr_n55029696)
print v(xbgr.mr_n55029808)
print v(xbgr.mr_n55030128)
print v(xbgr.mr_n55030240)
print v(xbgr.mr_n55030560)
print v(xbgr.mr_n55030672)
print v(xbgr.mr_n55030992)
print v(xbgr.mr_n55031104)
print v(xbgr.mr_n55031424)
print v(xbgr.mr_n55031536)
print v(xbgr.mr_n55031856)
print v(xbgr.mr_n55031968)
print v(xbgr.mr_n55032288)
print v(xbgr.mr_n55032400)
print v(xbgr.mr_n55032720)
print v(xbgr.mr_n55032832)
print v(xbgr.mr_n55033152)
print v(xbgr.mr_n55033264)
print v(xbgr.mr_n55033584)
print v(xbgr.mr_n55033696)
print v(xbgr.mr_n55034016)
print v(xbgr.mr_n55034128)
print v(xbgr.mr_n55034448)
print v(xbgr.mr_n55034560)
print v(xbgr.mr_n55034880)
print v(xbgr.mr_n55034992)
print v(xbgr.mr_n55035312)
print v(xbgr.mr_n55035424)
print v(xbgr.mr_n55035744)
print v(xbgr.mr_n55035856)
print v(xbgr.mr_n55036176)
print v(xbgr.mr_n55036288)
print v(xbgr.mr_n55036608)
print v(xbgr.mr_n55036720)
print v(xbgr.mr_n55037040)
print v(xbgr.mr_n55037152)
print v(xbgr.mr_n55037472)
print v(xbgr.mr_n55037584)
print v(xbgr.mr_n55037904)
print v(xbgr.mr_n55038016)
print v(xbgr.mr_n55038336)
print v(xbgr.mr_n55038448)
print v(xbgr.mr_n55038768)
print v(xbgr.mr_n55038880)
print v(xbgr.mr_n55039200)
print v(xbgr.mr_n55039312)
print v(xbgr.mr_n55039632)
print v(xbgr.mr_n55039744)
print v(xbgr.mr_n55040064)
print v(xbgr.mr_n55040176)
print v(xbgr.mr_n55040496)
print v(xbgr.mr_n55040608)
print v(xbgr.mr_n55040928)
print v(xbgr.mr_n55041040)
print v(xbgr.mr_n55041360)
print v(xbgr.mr_n55041472)
print v(xbgr.mr_n55041792)
print v(xbgr.mr_n55041904)
print v(xbgr.mr_n55042224)
print v(xbgr.mr_n55042336)
print v(xbgr.mr_n55042656)
print v(xbgr.mr_n55042768)
print v(xbgr.mr_n55043088)
print v(xbgr.mr_n55043200)
print v(xbgr.mr_n55043520)
print v(xbgr.mr_n55043632)
print v(xbgr.mr_n55043952)
print v(xbgr.mr_n55044064)
print v(xbgr.mr_n55044384)
print v(xbgr.mr_n55044496)
print v(xbgr.mr_n55044816)
print v(xbgr.mr_n55044928)
print v(xbgr.mr_n55045248)
print v(xbgr.mr_n55045360)
print v(xbgr.mr_n55045680)
print v(xbgr.mr_n55045792)
print v(xbgr.mr_n55046112)
print v(xbgr.mr_n55046224)
print v(xbgr.mr_n55046544)
print v(xbgr.mr_n55046656)
print v(xbgr.mr_n55046976)
print v(xbgr.mr_n55047088)
print v(xbgr.mr_n55047408)
print v(xbgr.mr_n55047520)
print v(xbgr.mr_n55047840)
print v(xbgr.mr_n55047952)
print v(xbgr.mr_n55048272)
print v(xbgr.mr_n55048384)
print v(xbgr.mr_n55048704)
print v(xbgr.mr_n55048816)
print v(xbgr.mr_n55049136)
print v(xbgr.mr_n55049248)
print v(xbgr.mr_n55049568)
print v(xbgr.mr_n55049680)
print v(xbgr.mr_n55050000)
print v(xbgr.mr_n55050112)
print v(xbgr.mr_n55050432)
print v(xbgr.mr_n55050544)
print v(xbgr.mr_n55050864)
print v(xbgr.mr_n55050976)
print v(xbgr.mr_n55051296)
print v(xbgr.mr_n55051408)
print v(xbgr.mr_n55051728)
print v(xbgr.mr_n55051840)
print v(xbgr.mr_n55052160)
print v(xbgr.mr_n55052272)
print v(xbgr.mr_n55052592)
print v(xbgr.mr_n55052704)
print v(xbgr.mr_n55053024)
print v(xbgr.mr_n55053136)
print v(xbgr.mr_n55053456)
print v(xbgr.mr_n55053568)
print v(xbgr.mr_n55053888)
print v(xbgr.mr_n55054000)
print v(xbgr.mr_n55054320)
print v(xbgr.mr_n55054432)
print v(xbgr.mr_n55054752)
print v(xbgr.mr_n55054864)
print v(xbgr.mr_n55055184)
print v(xbgr.mr_n55055296)
print v(xbgr.mr_n55055616)
print v(xbgr.mr_n55055728)
print v(xbgr.mr_n55056256)
print v(xbgr.mr_n55056368)
print v(xbgr.mr_n55056688)
print v(xbgr.mr_n55056800)
print v(xbgr.mr_n55057120)
print v(xbgr.mr_n55057232)
print v(xbgr.mr_n55057552)
print v(xbgr.mr_n55057664)
print v(xbgr.mr_n55057984)
print v(xbgr.mr_n55058096)
print v(xbgr.mr_n55058416)
print v(xbgr.mr_n55058528)
print v(xbgr.mr_n55058848)
print v(xbgr.mr_n55058960)
print v(xbgr.mr_n55059280)
print v(xbgr.mr_n55059392)
print v(xbgr.mr_n55059712)
print v(xbgr.mr_n55059824)
print v(xbgr.mr_n55060144)
print v(xbgr.mr_n55060256)
print v(xbgr.mr_n55060576)
print v(xbgr.mr_n55060688)
print v(xbgr.mr_n55061008)
print v(xbgr.mr_n55061120)
print v(xbgr.mr_n55061440)
print v(xbgr.mr_n55061552)
print v(xbgr.mr_n55061872)
print v(xbgr.mr_n55061984)
print v(xbgr.mr_n55062304)
print v(xbgr.mr_n55062416)
print v(xbgr.mr_n55062736)
print v(xbgr.mr_n55062848)
print v(xbgr.mr_n55063168)
print v(xbgr.mr_n55063280)
print v(xbgr.mr_n55063600)
print v(xbgr.mr_n55063712)
print v(xbgr.mr_n55064032)
print v(xbgr.mr_n55064144)
print v(xbgr.mr_n55064464)
print v(xbgr.mr_n55064576)
print v(xbgr.mr_n55064896)
print v(xbgr.mr_n55065008)
print v(xbgr.mr_n55065328)
print v(xbgr.mr_n55065440)
print v(xbgr.mr_n55065760)
print v(xbgr.mr_n55065872)
print v(xbgr.mr_n55066192)
print v(xbgr.mr_n55066304)
print v(xbgr.mr_n55066624)
print v(xbgr.mr_n55066736)
print v(xbgr.mr_n55067056)
print v(xbgr.mr_n55067168)
print v(xbgr.mr_n55067488)
print v(xbgr.mr_n55067600)
print v(xbgr.mr_n55067920)
print v(xbgr.mr_n55068032)
print v(xbgr.mr_n55068352)
print v(xbgr.mr_n55068464)
print v(xbgr.mr_n55068784)
print v(xbgr.mr_n55068896)
print v(xbgr.mr_n55069216)
print v(xbgr.mr_n55069328)
print v(xbgr.mr_n55069648)
print v(xbgr.mr_n55069760)
print v(xbgr.mr_n55070080)
print v(xbgr.mr_n55070192)
print v(xbgr.mr_n55070512)
print v(xbgr.mr_n55070624)
print v(xbgr.mr_n55070944)
print v(xbgr.mr_n55071056)
print v(xbgr.mr_n55071376)
print v(xbgr.mr_n55071488)
print v(xbgr.mr_n55071808)
print v(xbgr.mr_n55071920)
print v(xbgr.mr_n55072240)
print v(xbgr.mr_n55072352)
print v(xbgr.mr_n55072672)
print v(xbgr.mr_n55072784)
print v(xbgr.mr_n55073104)
print v(xbgr.mr_n55073216)
print v(xbgr.mr_n55073536)
print v(xbgr.mr_n55073648)
print v(xbgr.mr_n55073968)
print v(xbgr.mr_n55074080)
print v(xbgr.mr_n55074400)
print v(xbgr.mr_n55074512)
print v(xbgr.mr_n55074832)
print v(xbgr.mr_n55074944)
print v(xbgr.mr_n55075264)
print v(xbgr.mr_n55075376)
print v(xbgr.mr_n55075696)
print v(xbgr.mr_n55075808)
print v(xbgr.mr_n55076128)
print v(xbgr.mr_n55076240)
print v(xbgr.mr_n55076560)
print v(xbgr.mr_n55076672)
print v(xbgr.mr_n55076992)
print v(xbgr.mr_n55077104)
print v(xbgr.mr_n55077424)
print v(xbgr.mr_n55077536)
print v(xbgr.mr_n55077856)
print v(xbgr.mr_n55077968)
print v(xbgr.mr_n55078288)
print v(xbgr.mr_n55078400)
print v(xbgr.mr_n55078720)
print v(xbgr.mr_n55078832)
print v(xbgr.mr_n55079152)
print v(xbgr.mr_n55079264)
print v(xbgr.mr_n55079584)
print v(xbgr.mr_n55079696)
print v(xbgr.mr_n55080016)
print v(xbgr.mr_n55080128)
print v(xbgr.mr_n55080448)
print v(xbgr.mr_n55080560)
print v(xbgr.mr_n55080880)
print v(xbgr.mr_n55080992)
print v(xbgr.mr_n55081312)
print v(xbgr.mr_n55081424)
print v(xbgr.mr_n55081744)
print v(xbgr.mr_n55081856)
print v(xbgr.mr_n55082176)
print v(xbgr.mr_n55082288)
print v(xbgr.mr_n55082608)
print v(xbgr.mr_n55082720)
print v(xbgr.mr_n55083040)
print v(xbgr.mr_n55083152)
print v(xbgr.mr_n55083472)
print v(xbgr.mr_n55083584)
print v(xbgr.mr_n55083904)
print v(xbgr.mr_n55084016)
print v(xbgr.mr_n55084336)
print v(xbgr.mr_n55084448)
print v(xbgr.mr_n55084768)
print v(xbgr.mr_n55084880)
print v(xbgr.mr_n55085200)
print v(xbgr.mr_n55085312)
print v(xbgr.mr_n55085632)
print v(xbgr.mr_n55085744)
print v(xbgr.mr_n55086064)
print v(xbgr.mr_n55086176)
print v(xbgr.mr_n55086496)
print v(xbgr.mr_n55086608)
print v(xbgr.mr_n55086928)
print v(xbgr.mr_n55087040)
print v(xbgr.mr_n55087360)
print v(xbgr.mr_n55087472)
print v(xbgr.mr_n55087792)
print v(xbgr.mr_n55087904)
print v(xbgr.mr_n55088224)
print v(xbgr.mr_n55088336)
print v(xbgr.mr_n55088656)
print v(xbgr.mr_n55088768)
print v(xbgr.mr_n55089088)
print v(xbgr.mr_n55089200)
print v(xbgr.mr_n55089520)
print v(xbgr.mr_n55089632)
print v(xbgr.mr_n55089952)
print v(xbgr.mr_n55090064)
print v(xbgr.mr_n55090384)
print v(xbgr.mr_n55090496)
print v(xbgr.mr_n55090816)
print v(xbgr.mr_n55090928)
print v(xbgr.mr_n55091248)
print v(xbgr.mr_n55091360)
print v(xbgr.mr_n55091680)
print v(xbgr.mr_n55091792)
print v(xbgr.mr_n55092112)
print v(xbgr.mr_n55092224)
print v(xbgr.mr_n55092544)
print v(xbgr.mr_n55092656)
print v(xbgr.mr_n55092976)
print v(xbgr.mr_n55093088)
print v(xbgr.mr_n55093408)
print v(xbgr.mr_n55093520)
print v(xbgr.mr_n55093840)
print v(xbgr.mr_n55093952)
print v(xbgr.mr_n55094272)
print v(xbgr.mr_n55094384)
print v(xbgr.mr_n55094704)
print v(xbgr.mr_n55094816)
print v(xbgr.mr_n55095136)
print v(xbgr.mr_n55095248)
print v(xbgr.mr_n55095568)
print v(xbgr.mr_n55095680)
print v(xbgr.mr_n55358160)
print v(xbgr.mr_n55358400)
print v(xbgr.mr_n55358512)
print v(xbgr.mr_n55358832)
print v(xbgr.mr_n55358944)
print v(xbgr.mr_n55359264)
print v(xbgr.mr_n55359376)
print v(xbgr.mr_n55359696)
print v(xbgr.mr_n55359808)
print v(xbgr.mr_n55360128)
print v(xbgr.mr_n55360240)
print v(xbgr.mr_n55360560)
print v(xbgr.mr_n55360672)
print v(xbgr.mr_n55360992)
print v(xbgr.mr_n55361104)
print v(xbgr.mr_n55361424)
print v(xbgr.mr_n55361536)
print v(xbgr.mr_n55361856)
print v(xbgr.mr_n55361968)
print v(xbgr.mr_n55362288)
print v(xbgr.mr_n55362400)
print v(xbgr.mr_n55362720)
print v(xbgr.mr_n55362832)
print v(xbgr.mr_n55363152)
print v(xbgr.mr_n55363264)
print v(xbgr.mr_n55363584)
print v(xbgr.mr_n55363696)
print v(xbgr.mr_n55364016)
print v(xbgr.mr_n55364128)
print v(xbgr.mr_n55364448)
print v(xbgr.mr_n55364560)
print v(xbgr.mr_n55364880)
print v(xbgr.mr_n55364992)
print v(xbgr.mr_n55365312)
print v(xbgr.mr_n55365424)
print v(xbgr.mr_n55365744)
print v(xbgr.mr_n55365856)
print v(xbgr.mr_n55366176)
print v(xbgr.mr_n55366288)
print v(xbgr.mr_n55366608)
print v(xbgr.mr_n55366720)
print v(xbgr.mr_n55367040)
print v(xbgr.mr_n55367152)
print v(xbgr.mr_n55367472)
print v(xbgr.mr_n55367584)
print v(xbgr.mr_n55367904)
print v(xbgr.mr_n55368016)
print v(xbgr.mr_n55368336)
print v(xbgr.mr_n55368448)
print v(xbgr.mr_n55368768)
print v(xbgr.mr_n55368880)
print v(xbgr.mr_n55369200)
print v(xbgr.mr_n55369312)
print v(xbgr.mr_n55369632)
print v(xbgr.mr_n55369744)
print v(xbgr.mr_n55370064)
print v(xbgr.mr_n55370176)
print v(xbgr.mr_n55370496)
print v(xbgr.mr_n55370608)
print v(xbgr.mr_n55370928)
print v(xbgr.mr_n55371040)
print v(xbgr.mr_n55371360)
print v(xbgr.mr_n55371472)
print v(xbgr.mr_n55371792)
print v(xbgr.mr_n55371904)
print v(xbgr.mr_n55372224)
print v(xbgr.mr_n55372336)
print v(xbgr.mr_n55372656)
print v(xbgr.mr_n55372768)
print v(xbgr.mr_n55373088)
print v(xbgr.mr_n55373200)
print v(xbgr.mr_n55373520)
print v(xbgr.mr_n55373632)
print v(xbgr.mr_n55373952)
print v(xbgr.mr_n55374064)
print v(xbgr.mr_n55374384)
print v(xbgr.mr_n55374496)
print v(xbgr.mr_n55374816)
print v(xbgr.mr_n55374928)
print v(xbgr.mr_n55375248)
print v(xbgr.mr_n55375360)
print v(xbgr.mr_n55375680)
print v(xbgr.mr_n55375792)
print v(xbgr.mr_n55376112)
print v(xbgr.mr_n55376224)
print v(xbgr.mr_n55376544)
print v(xbgr.mr_n55376656)
print v(xbgr.mr_n55376976)
print v(xbgr.mr_n55377088)
print v(xbgr.mr_n55377408)
print v(xbgr.mr_n55377520)
print v(xbgr.mr_n55377840)
print v(xbgr.mr_n55377952)
print v(xbgr.mr_n55378272)
print v(xbgr.mr_n55378384)
print v(xbgr.mr_n55378704)
print v(xbgr.mr_n55378816)
print v(xbgr.mr_n55379136)
print v(xbgr.mr_n55379248)
print v(xbgr.mr_n55379568)
print v(xbgr.mr_n55379680)
print v(xbgr.mr_n55380000)
print v(xbgr.mr_n55380112)
print v(xbgr.mr_n55380432)
print v(xbgr.mr_n55380544)
print v(xbgr.mr_n55380864)
print v(xbgr.mr_n55380976)
print v(xbgr.mr_n55381296)
print v(xbgr.mr_n55381408)
print v(xbgr.mr_n55381728)
print v(xbgr.mr_n55381840)
print v(xbgr.mr_n55382160)
print v(xbgr.mr_n55382272)
print v(xbgr.mr_n55382592)
print v(xbgr.mr_n55382704)
print v(xbgr.mr_n55383024)
print v(xbgr.mr_n55383136)
print v(xbgr.mr_n55383456)
print v(xbgr.mr_n55383568)
print v(xbgr.mr_n55383888)
print v(xbgr.mr_n55384000)
print v(xbgr.mr_n55384320)
print v(xbgr.mr_n55384432)
print v(xbgr.mr_n55384752)
print v(xbgr.mr_n55384864)
print v(xbgr.mr_n55385184)
print v(xbgr.mr_n55385296)
print v(xbgr.mr_n55385616)
print v(xbgr.mr_n55385728)
print v(xbgr.mr_n55386048)
print v(xbgr.mr_n55386160)
print v(xbgr.mr_n55386480)
print v(xbgr.mr_n55386592)
print v(xbgr.mr_n55386912)
print v(xbgr.mr_n55387024)
print v(xbgr.mr_n55387344)
print v(xbgr.mr_n55387456)
print v(xbgr.mr_n55387776)
print v(xbgr.mr_n55387888)
print v(xbgr.mr_n55388208)
print v(xbgr.mr_n55388320)
print v(xbgr.mr_n55388640)
print v(xbgr.mr_n55388752)
print v(xbgr.mr_n55389072)
print v(xbgr.mr_n55389184)
print v(xbgr.mr_n55389504)
print v(xbgr.mr_n55389616)
print v(xbgr.mr_n55389936)
print v(xbgr.mr_n55390048)
print v(xbgr.mr_n55390368)
print v(xbgr.mr_n55390480)
print v(xbgr.mr_n55390800)
print v(xbgr.mr_n55390912)
print v(xbgr.mr_n55391232)
print v(xbgr.mr_n55391344)
print v(xbgr.mr_n55391664)
print v(xbgr.mr_n55391776)
print v(xbgr.mr_n55392096)
print v(xbgr.mr_n55392208)
print v(xbgr.mr_n55392528)
print v(xbgr.mr_n55392640)
print v(xbgr.mr_n55392960)
print v(xbgr.mr_n55393072)
print v(xbgr.mr_n55393392)
print v(xbgr.mr_n55393504)
print v(xbgr.mr_n55393824)
print v(xbgr.mr_n55393936)
print v(xbgr.mr_n55394256)
print v(xbgr.mr_n55394368)
print v(xbgr.mr_n55394688)
print v(xbgr.mr_n55394800)
print v(xbgr.mr_n55395120)
print v(xbgr.mr_n55395232)
print v(xbgr.mr_n55395552)
print v(xbgr.mr_n55395664)
print v(xbgr.mr_n55395984)
print v(xbgr.mr_n55396096)
print v(xbgr.mr_n55396416)
print v(xbgr.mr_n55396528)
print v(xbgr.mr_n55396848)
print v(xbgr.mr_n55396960)
print v(xbgr.mr_n55397280)
print v(xbgr.mr_n55397392)
print v(xbgr.mr_n55397712)
print v(xbgr.mr_n55397824)
print v(xbgr.mr_n55398144)
print v(xbgr.mr_n55398256)
print v(xbgr.mr_n55398576)
print v(xbgr.mr_n55398688)
print v(xbgr.mr_n55399008)
print v(xbgr.mr_n55399120)
print v(xbgr.mr_n55399440)
print v(xbgr.mr_n55399552)
print v(xbgr.mr_n55399872)
print v(xbgr.mr_n55399984)
print v(xbgr.mr_n55400304)
print v(xbgr.mr_n55400416)
print v(xbgr.mr_n55400736)
print v(xbgr.mr_n55400848)
print v(xbgr.mr_n55401168)
print v(xbgr.mr_n55401280)
print v(xbgr.mr_n55401600)
print v(xbgr.mr_n55401712)
print v(xbgr.mr_n55402032)
print v(xbgr.mr_n55402144)
print v(xbgr.mr_n55402464)
print v(xbgr.mr_n55402576)
print v(xbgr.mr_n55402896)
print v(xbgr.mr_n55403008)
print v(xbgr.mr_n55403328)
print v(xbgr.mr_n55403440)
print v(xbgr.mr_n55403760)
print v(xbgr.mr_n55403872)
print v(xbgr.mr_n55404192)
print v(xbgr.mr_n55404304)
print v(xbgr.mr_n55404624)
print v(xbgr.mr_n55404736)
print v(xbgr.mr_n55405056)
print v(xbgr.mr_n55405168)
print v(xbgr.mr_n55405488)
print v(xbgr.mr_n55405600)
print v(xbgr.mr_n55405920)
print v(xbgr.mr_n55406032)
print v(xbgr.mr_n55406352)
print v(xbgr.mr_n55406464)
print v(xbgr.mr_n55406784)
print v(xbgr.mr_n55406896)
print v(xbgr.mr_n55407216)
print v(xbgr.mr_n55407328)
print v(xbgr.mr_n55407648)
print v(xbgr.mr_n55407760)
print v(xbgr.mr_n55408080)
print v(xbgr.mr_n55408192)
print v(xbgr.mr_n55408512)
print v(xbgr.mr_n55408624)
print v(xbgr.mr_n55408944)
print v(xbgr.mr_n55409056)
print v(xbgr.mr_n55409376)
print v(xbgr.mr_n55409488)
print v(xbgr.mr_n55409808)
print v(xbgr.mr_n55409920)
print v(xbgr.mr_n55410240)
print v(xbgr.mr_n55410352)
print v(xbgr.mr_n55410672)
print v(xbgr.mr_n55410784)
print v(xbgr.mr_n55411104)
print v(xbgr.mr_n55411216)
print v(xbgr.mr_n55411536)
print v(xbgr.mr_n55411648)
print v(xbgr.mr_n55411968)
print v(xbgr.mr_n55412080)
print v(xbgr.mr_n55412400)
print v(xbgr.mr_n55412512)
print v(xbgr.mr_n55412832)
print v(xbgr.mr_n55412944)
print v(xbgr.mr_n55413264)
print v(xbgr.mr_n55413376)
print v(xbgr.mr_n55413696)
print v(xbgr.mr_n55413808)
print v(xbgr.mr_n55414128)
print v(xbgr.mr_n55414240)
print v(xbgr.mr_n55414560)
print v(xbgr.mr_n55414672)
print v(xbgr.mr_n55414992)
print v(xbgr.mr_n55415104)
print v(xbgr.mr_n55415424)
print v(xbgr.mr_n55415536)
print v(xbgr.mr_n55415856)
print v(xbgr.mr_n55415968)
print v(xbgr.mr_n55416288)
print v(xbgr.mr_n55416400)
print v(xbgr.mr_n55416720)
print v(xbgr.mr_n55416832)
print v(xbgr.mr_n55417152)
print v(xbgr.mr_n55417264)
print v(xbgr.mr_n55417584)
print v(xbgr.mr_n55417696)
print v(xbgr.mr_n55418016)
print v(xbgr.mr_n55418128)
print v(xbgr.mr_n55418448)
print v(xbgr.mr_n55418560)
print v(xbgr.mr_n55418880)
print v(xbgr.mr_n55418992)
print v(xbgr.mr_n55419312)
print v(xbgr.mr_n55419424)
print v(xbgr.mr_n55419744)
print v(xbgr.mr_n55419856)
print v(xbgr.mr_n55420176)
print v(xbgr.mr_n55420288)
print v(xbgr.mr_n55420608)
print v(xbgr.mr_n55420720)
print v(xbgr.mr_n55421040)
print v(xbgr.mr_n55421152)
print v(xbgr.mr_n55421472)
print v(xbgr.mr_n55421584)
print v(xbgr.mr_n55421904)
print v(xbgr.mr_n55422016)
print v(xbgr.mr_n55422336)
print v(xbgr.mr_n55422448)
print v(xbgr.mr_n55422768)
print v(xbgr.mr_n55422880)
print v(xbgr.mr_n55423200)
print v(xbgr.mr_n55423312)
print v(xbgr.mr_n55423632)
print v(xbgr.mr_n55423744)
print v(xbgr.mr_n55424064)
print v(xbgr.mr_n55424176)
print v(xbgr.mr_n55424496)
print v(xbgr.mr_n55424608)
print v(xbgr.mr_n55424928)
print v(xbgr.mr_n55425040)
print v(xbgr.mr_n55425360)
print v(xbgr.mr_n55425472)
print v(xbgr.mr_n55425792)
print v(xbgr.mr_n55425904)
print v(xbgr.mr_n55426224)
print v(xbgr.mr_n55426336)
print v(xbgr.mr_n55426656)
print v(xbgr.mr_n55426768)
print v(xbgr.mr_n55427088)
print v(xbgr.mr_n55427200)
print v(xbgr.mr_n55427520)
print v(xbgr.mr_n55427632)
print v(xbgr.mr_n55427952)
print v(xbgr.mr_n55428064)
print v(xbgr.mr_n55428384)
print v(xbgr.mr_n55428496)
print v(xbgr.mr_n55428816)
print v(xbgr.mr_n55428928)
print v(xbgr.mr_n55429248)
print v(xbgr.mr_n55429360)
print v(xbgr.mr_n55429680)
print v(xbgr.mr_n55429792)
print v(xbgr.mr_n55430112)
print v(xbgr.mr_n55430224)
print v(xbgr.mr_n55430544)
print v(xbgr.mr_n55430656)
print v(xbgr.mr_n55430976)
print v(xbgr.mr_n55431088)
print v(xbgr.mr_n55431408)
print v(xbgr.mr_n55431520)
print v(xbgr.mr_n55431840)
print v(xbgr.mr_n55431952)
print v(xbgr.mr_n55432272)
print v(xbgr.mr_n55432384)
print v(xbgr.mr_n55432704)
print v(xbgr.mr_n55432816)
print v(xbgr.mr_n55433136)
print v(xbgr.mr_n55433248)
print v(xbgr.mr_n55433568)
print v(xbgr.mr_n55433680)
print v(xbgr.mr_n55434000)
print v(xbgr.mr_n55434112)
print v(xbgr.mr_n55434432)
print v(xbgr.mr_n55434544)
print v(xbgr.mr_n55434864)
print v(xbgr.mr_n55434976)
print v(xbgr.mr_n55435296)
print v(xbgr.mr_n55435408)
print v(xbgr.mr_n55435728)
print v(xbgr.mr_n55435840)
print v(xbgr.mr_n55436160)
print v(xbgr.mr_n55436272)
print v(xbgr.mr_n55436592)
print v(xbgr.mr_n55436704)
print v(xbgr.mr_n55437024)
print v(xbgr.mr_n55437136)
print v(xbgr.mr_n55437456)
print v(xbgr.mr_n55437568)
print v(xbgr.mr_n55437888)
print v(xbgr.mr_n55438000)
print v(xbgr.mr_n55438320)
print v(xbgr.mr_n55438432)
print v(xbgr.mr_n55438752)
print v(xbgr.mr_n55438864)
print v(xbgr.mr_n55439184)
print v(xbgr.mr_n55439296)
print v(xbgr.mr_n55439616)
print v(xbgr.mr_n55439728)
print v(xbgr.mr_n55440048)
print v(xbgr.mr_n55440160)
print v(xbgr.mr_n55440480)
print v(xbgr.mr_n55440592)
print v(xbgr.mr_n55440912)
print v(xbgr.mr_n55441024)
print v(xbgr.mr_n55441344)
print v(xbgr.mr_n55441456)
print v(xbgr.mr_n55441776)
print v(xbgr.mr_n55441888)
print v(xbgr.mr_n55442208)
print v(xbgr.mr_n55442320)
print v(xbgr.mr_n55442640)
print v(xbgr.mr_n55442752)
print v(xbgr.mr_n55443072)
print v(xbgr.mr_n55443184)
print v(xbgr.mr_n55443504)
print v(xbgr.mr_n55443616)
print v(xbgr.mr_n55443936)
print v(xbgr.mr_n55444048)
print v(xbgr.mr_n55444368)
print v(xbgr.mr_n55444480)
print v(xbgr.mr_n55444800)
print v(xbgr.mr_n55444912)
print v(xbgr.mr_n55445232)
print v(xbgr.mr_n55445344)
print v(xbgr.mr_n55445664)
print v(xbgr.mr_n55445776)
print v(xbgr.mr_n55446096)
print v(xbgr.mr_n55446208)
print v(xbgr.mr_n55446528)
print v(xbgr.mr_n55446640)
print v(xbgr.mr_n55446960)
print v(xbgr.mr_n55447072)
print v(xbgr.mr_n55447392)
print v(xbgr.mr_n55447504)
print v(xbgr.mr_n55447824)
print v(xbgr.mr_n55447936)
print v(xbgr.mr_n55448256)
print v(xbgr.mr_n55448368)
print v(xbgr.mr_n55448688)
print v(xbgr.mr_n55448800)
print v(xbgr.mr_n55449120)
print v(xbgr.mr_n55449232)
print v(xbgr.mr_n55449552)
print v(xbgr.mr_n55449664)
print v(xbgr.mr_n55449984)
print v(xbgr.mr_n55450096)
print v(xbgr.mr_n55450416)
print v(xbgr.mr_n55450528)
print v(xbgr.mr_n55450848)
print v(xbgr.mr_n55450960)
print v(xbgr.mr_n55451280)
print v(xbgr.mr_n55451392)
print v(xbgr.mr_n55451712)
print v(xbgr.mr_n55451824)
print v(xbgr.mr_n55452144)
print v(xbgr.mr_n55452256)
print v(xbgr.mr_n55452576)
print v(xbgr.mr_n55452688)
print v(xbgr.mr_n55453008)
print v(xbgr.mr_n55453120)
print v(xbgr.mr_n55453440)
print v(xbgr.mr_n55453552)
print v(xbgr.mr_n55453872)
print v(xbgr.mr_n55453984)
print v(xbgr.mr_n55454304)
print v(xbgr.mr_n55454416)
print v(xbgr.mr_n55454736)
print v(xbgr.mr_n55454848)
print v(xbgr.mr_n55455168)
print v(xbgr.mr_n55455280)
print v(xbgr.mr_n55455600)
print v(xbgr.mr_n55455712)
print v(xbgr.mr_n55456032)
print v(xbgr.mr_n55456144)
print v(xbgr.mr_n55456464)
print v(xbgr.mr_n55456576)
print v(xbgr.mr_n55456896)
print v(xbgr.mr_n55457008)
print v(xbgr.mr_n55457328)
print v(xbgr.mr_n55457440)
print v(xbgr.mr_n55457760)
print v(xbgr.mr_n55457872)
print v(xbgr.mr_n55458192)
print v(xbgr.mr_n55458304)
print v(xbgr.mr_n55458624)
print v(xbgr.mr_n55458736)
print v(xbgr.mr_n55459056)
print v(xbgr.mr_n55459168)
print v(xbgr.mr_n55459488)
print v(xbgr.mr_n55459600)
print v(xbgr.mr_n55459920)
print v(xbgr.mr_n55460032)
print v(xbgr.mr_n55460352)
print v(xbgr.mr_n55460464)
print v(xbgr.mr_n55460784)
print v(xbgr.mr_n55460896)
print v(xbgr.mr_n55461216)
print v(xbgr.mr_n55461328)
print v(xbgr.mr_n55461648)
print v(xbgr.mr_n55461760)
print v(xbgr.mr_n55462080)
print v(xbgr.mr_n55462192)
print v(xbgr.mr_n55462512)
print v(xbgr.mr_n55462624)
print v(xbgr.mr_n55462944)
print v(xbgr.mr_n55463056)
print v(xbgr.mr_n55463376)
print v(xbgr.mr_n55463488)
print v(xbgr.mr_n55463808)
print v(xbgr.mr_n55463920)
print v(xbgr.mr_n55464240)
print v(xbgr.mr_n55464352)
print v(xbgr.mr_n55464672)
print v(xbgr.mr_n55464784)
print v(xbgr.mr_n55465104)
print v(xbgr.mr_n55465216)
print v(xbgr.mr_n55465536)
print v(xbgr.mr_n55465648)
print v(xbgr.mr_n55465968)
print v(xbgr.mr_n55466080)
print v(xbgr.mr_n55466400)
print v(xbgr.mr_n55466512)
print v(xbgr.mr_n55466832)
print v(xbgr.mr_n55466944)
print v(xbgr.mr_n55467264)
print v(xbgr.mr_n55467376)
print v(xbgr.mr_n55467696)
print v(xbgr.mr_n55467808)
print v(xbgr.mr_n55468128)
print v(xbgr.mr_n55468240)
print v(xbgr.mr_n55468560)
print v(xbgr.mr_n55468672)
print v(xbgr.mr_n55468992)
print v(xbgr.mr_n55469104)
print v(xbgr.mr_n55469424)
print v(xbgr.mr_n55469536)
print v(xbgr.mr_n55469856)
print v(xbgr.mr_n55469968)
print v(xbgr.mr_n55470288)
print v(xbgr.mr_n55470400)
print v(xbgr.mr_n55470720)
print v(xbgr.mr_n55470832)
print v(xbgr.mr_n55471152)
print v(xbgr.mr_n55471264)
print v(xbgr.mr_n55471584)
print v(xbgr.mr_n55471696)
print v(xbgr.mr_n55472016)
print v(xbgr.mr_n55472128)
print v(xbgr.mr_n55472448)
print v(xbgr.mr_n55472560)
print v(xbgr.mr_n55472880)
print v(xbgr.mr_n55472992)
print v(xbgr.mr_n55473312)
print v(xbgr.mr_n55473424)
print v(xbgr.mr_n55473744)
print v(xbgr.mr_n55473856)
print v(xbgr.mr_n55474176)
print v(xbgr.mr_n55474288)
print v(xbgr.mr_n55474608)
print v(xbgr.mr_n55474720)
print v(xbgr.mr_n55475040)
print v(xbgr.mr_n55475152)
print v(xbgr.mr_n55475472)
print v(xbgr.mr_n55475584)
print v(xbgr.mr_n55475904)
print v(xbgr.mr_n55476016)
print v(xbgr.mr_n55476336)
print v(xbgr.mr_n55476448)
print v(xbgr.mr_n55476768)
print v(xbgr.mr_n55476880)
print v(xbgr.mr_n55477200)
print v(xbgr.mr_n55477312)
print v(xbgr.mr_n55477632)
print v(xbgr.mr_n55477744)
print v(xbgr.mr_n55478064)
print v(xbgr.mr_n55478176)
print v(xbgr.mr_n55478496)
print v(xbgr.mr_n55478608)
print v(xbgr.mr_n55478928)
print v(xbgr.mr_n55479040)
print v(xbgr.mr_n55479360)
print v(xbgr.mr_n55479472)
print v(xbgr.mr_n55479792)
print v(xbgr.mr_n55479904)
print v(xbgr.mr_n55480224)
print v(xbgr.mr_n55480336)
print v(xbgr.mr_n55480656)
print v(xbgr.mr_n55480768)
print v(xbgr.mr_n55481088)
print v(xbgr.mr_n55481200)
print v(xbgr.mr_n55481520)
print v(xbgr.mr_n55481632)
print v(xbgr.mr_n55481952)
print v(xbgr.mr_n55482064)
print v(xbgr.mr_n55482384)
print v(xbgr.mr_n55482496)
print v(xbgr.mr_n55482816)
print v(xbgr.mr_n55482928)
print v(xbgr.mr_n55483248)
print v(xbgr.mr_n55483360)
print v(xbgr.mr_n55483680)
print v(xbgr.mr_n55483792)
print v(xbgr.mr_n55484112)
print v(xbgr.mr_n55484224)
print v(xbgr.mr_n55484544)
print v(xbgr.mr_n55484656)
print v(xbgr.mr_n55484976)
print v(xbgr.mr_n55485088)
print v(xbgr.mr_n55485408)
print v(xbgr.mr_n55485520)
print v(xbgr.mr_n55485840)
print v(xbgr.mr_n55485952)
print v(xbgr.mr_n55486272)
print v(xbgr.mr_n55486384)
print v(xbgr.mr_n55486704)
print v(xbgr.mr_n55486816)
print v(xbgr.mr_n55487136)
print v(xbgr.mr_n55487248)
print v(xbgr.mr_n55487568)
print v(xbgr.mr_n55487680)
print v(xbgr.mr_n55488000)
print v(xbgr.mr_n55488112)
print v(xbgr.mr_n55488432)
print v(xbgr.mr_n55488544)
print v(xbgr.mr_n55488864)
print v(xbgr.mr_n55488976)
print v(xbgr.mr_n55489296)
print v(xbgr.mr_n55489408)
print v(xbgr.mr_n55489728)
print v(xbgr.mr_n55489840)
print v(xbgr.mr_n55490160)
print v(xbgr.mr_n55490272)
print v(xbgr.mr_n55490592)
print v(xbgr.mr_n55490704)
print v(xbgr.mr_n55491024)
print v(xbgr.mr_n55491136)
print v(xbgr.mr_n55491456)
print v(xbgr.mr_n55491568)
print v(xbgr.mr_n55491888)
print v(xbgr.mr_n55492000)
print v(xbgr.mr_n55492320)
print v(xbgr.mr_n55492432)
print v(xbgr.mr_n55492752)
print v(xbgr.mr_n55492864)
print v(xbgr.mr_n55493184)
print v(xbgr.mr_n55493296)
print v(xbgr.mr_n55493616)
print v(xbgr.mr_n55493728)
print v(xbgr.mr_n55494048)
print v(xbgr.mr_n55494160)
print v(xbgr.mr_n55494480)
print v(xbgr.mr_n55494592)
print v(xbgr.mr_n55494912)
print v(xbgr.mr_n55495024)
print v(xbgr.mr_n55495344)
print v(xbgr.mr_n55495456)
print v(xbgr.mr_n55495776)
print v(xbgr.mr_n55495888)
print v(xbgr.mr_n55496208)
print v(xbgr.mr_n55496320)
print v(xbgr.mr_n55496640)
print v(xbgr.mr_n55496752)
print v(xbgr.mr_n55497072)
print v(xbgr.mr_n55497184)
print v(xbgr.mr_n55497504)
print v(xbgr.mr_n55497616)
print v(xbgr.mr_n55497936)
print v(xbgr.mr_n55498048)
print v(xbgr.mr_n55498368)
print v(xbgr.mr_n55498480)
print v(xbgr.mr_n55498800)
print v(xbgr.mr_n55498912)
print v(xbgr.mr_n55499232)
print v(xbgr.mr_n55499344)
print v(xbgr.mr_n55499664)
print v(xbgr.mr_n55499776)
print v(xbgr.mr_n55500096)
print v(xbgr.mr_n55500208)
print v(xbgr.mr_n55500528)
print v(xbgr.mr_n55500640)
print v(xbgr.mr_n55500960)
print v(xbgr.mr_n55501072)
print v(xbgr.mr_n55501392)
print v(xbgr.mr_n55501504)
print v(xbgr.mr_n55501824)
print v(xbgr.mr_n55501936)
print v(xbgr.mr_n55502256)
print v(xbgr.mr_n55502368)
print v(xbgr.mr_n55502688)
print v(xbgr.mr_n55502800)
print v(xbgr.mr_n55503120)
print v(xbgr.mr_n55503232)
print v(xbgr.mr_n55503552)
print v(xbgr.mr_n55503664)
print v(xbgr.mr_n55503984)
print v(xbgr.mr_n55504096)
print v(xbgr.mr_n55504416)
print v(xbgr.mr_n55504528)
print v(xbgr.mr_n55504848)
print v(xbgr.mr_n55504960)
print v(xbgr.mr_n55505280)
print v(xbgr.mr_n55505392)
print v(xbgr.mr_n55505712)
print v(xbgr.mr_n55505824)
print v(xbgr.mr_n55506144)
print v(xbgr.mr_n55506256)
print v(xbgr.mr_n55506576)
print v(xbgr.mr_n55506688)
print v(xbgr.mr_n55507008)
print v(xbgr.mr_n55507120)
print v(xbgr.mr_n55507440)
print v(xbgr.mr_n55507552)
print v(xbgr.mr_n55507872)
print v(xbgr.mr_n55507984)
print v(xbgr.mr_n55508304)
print v(xbgr.mr_n55508416)
print v(xbgr.mr_n55508736)
print v(xbgr.mr_n55508848)
print v(xbgr.mr_n55509168)
print v(xbgr.mr_n55509280)
print v(xbgr.mr_n55509600)
print v(xbgr.mr_n55509712)
print v(xbgr.mr_n55510032)
print v(xbgr.mr_n55510144)
print v(xbgr.mr_n55510464)
print v(xbgr.mr_n55510576)
print v(xbgr.mr_n55510896)
print v(xbgr.mr_n55511008)
print v(xbgr.mr_n55511328)
print v(xbgr.mr_n55511440)
print v(xbgr.mr_n55511760)
print v(xbgr.mr_n55511872)
print v(xbgr.mr_n55512192)
print v(xbgr.mr_n55512304)
print v(xbgr.mr_n55512624)
print v(xbgr.mr_n55512736)
print v(xbgr.mr_n55513056)
print v(xbgr.mr_n55513168)
print v(xbgr.mr_n55513488)
print v(xbgr.mr_n55513600)
print v(xbgr.mr_n55513920)
print v(xbgr.mr_n55514032)
print v(xbgr.mr_n55514352)
print v(xbgr.mr_n55514464)
print v(xbgr.mr_n55514784)
print v(xbgr.mr_n55514896)
print v(xbgr.mr_n55515216)
print v(xbgr.mr_n55515328)
print v(xbgr.mr_n55515648)
print v(xbgr.mr_n55515760)
print v(xbgr.mr_n55516080)
print v(xbgr.mr_n55516192)
print v(xbgr.mr_n55516512)
print v(xbgr.mr_n55516624)
print v(xbgr.mr_n55516944)
print v(xbgr.mr_n55517056)
print v(xbgr.mr_n55517376)
print v(xbgr.mr_n55517488)
print v(xbgr.mr_n55517808)
print v(xbgr.mr_n55517920)
print v(xbgr.mr_n55518240)
print v(xbgr.mr_n55518352)
print v(xbgr.mr_n55518672)
print v(xbgr.mr_n55518784)
print v(xbgr.mr_n55519104)
print v(xbgr.mr_n55519216)
print v(xbgr.mr_n55519536)
print v(xbgr.mr_n55519648)
print v(xbgr.mr_n55519968)
print v(xbgr.mr_n55520080)
print v(xbgr.mr_n55520400)
print v(xbgr.mr_n55520512)
print v(xbgr.mr_n55520832)
print v(xbgr.mr_n55520944)
print v(xbgr.mr_n55521264)
print v(xbgr.mr_n55521376)
print v(xbgr.mr_n55521696)
print v(xbgr.mr_n55521808)
print v(xbgr.mr_n55522128)
print v(xbgr.mr_n55522240)
print v(xbgr.mr_n55522560)
print v(xbgr.mr_n55522672)
print v(xbgr.mr_n55522992)
print v(xbgr.mr_n55523104)
print v(xbgr.mr_n55523424)
print v(xbgr.mr_n55523536)
print v(xbgr.mr_n55523856)
print v(xbgr.mr_n55523968)
print v(xbgr.mr_n55524288)
print v(xbgr.mr_n55524400)
print v(xbgr.mr_n55524720)
print v(xbgr.mr_n55524832)
print v(xbgr.mr_n55525152)
print v(xbgr.mr_n55525264)
print v(xbgr.mr_n55525584)
print v(xbgr.mr_n55525696)
print v(xbgr.mr_n55526016)
print v(xbgr.mr_n55526128)
print v(xbgr.mr_n55526448)
print v(xbgr.mr_n55526560)
print v(xbgr.mr_n55526880)
print v(xbgr.mr_n55526992)
print v(xbgr.mr_n55527312)
print v(xbgr.mr_n55527424)
print v(xbgr.mr_n55527744)
print v(xbgr.mr_n55527856)
print v(xbgr.mr_n55528176)
print v(xbgr.mr_n55528288)
print v(xbgr.mr_n55528608)
print v(xbgr.mr_n55528720)
print v(xbgr.mr_n55529040)
print v(xbgr.mr_n55529152)
print v(xbgr.mr_n55529472)
print v(xbgr.mr_n55529584)
print v(xbgr.mr_n55529904)
print v(xbgr.mr_n55530016)
print v(xbgr.mr_n55530336)
print v(xbgr.mr_n55530448)
print v(xbgr.mr_n55530768)
print v(xbgr.mr_n55530880)
print v(xbgr.mr_n55531200)
print v(xbgr.mr_n55531312)
print v(xbgr.mr_n55531632)
print v(xbgr.mr_n55531744)
print v(xbgr.mr_n55532064)
print v(xbgr.mr_n55532176)
print v(xbgr.mr_n55532496)
print v(xbgr.mr_n55532608)
print v(xbgr.mr_n55532928)
print v(xbgr.mr_n55533040)
print v(xbgr.mr_n55533360)
print v(xbgr.mr_n55533472)
print v(xbgr.mr_n55533792)
print v(xbgr.mr_n55533904)
print v(xbgr.mr_n55534224)
print v(xbgr.mr_n55534336)
print v(xbgr.mr_n55534656)
print v(xbgr.mr_n55534768)
print v(xbgr.mr_n55535088)
print v(xbgr.mr_n55535200)
print v(xbgr.mr_n55535520)
print v(xbgr.mr_n55535632)
print v(xbgr.mr_n55535952)
print v(xbgr.mr_n55536064)
print v(xbgr.mr_n55536384)
print v(xbgr.mr_n55536496)
print v(xbgr.mr_n55536816)
print v(xbgr.mr_n55536928)
print v(xbgr.mr_n55537248)
print v(xbgr.mr_n55537360)
print v(xbgr.mr_n55537680)
print v(xbgr.mr_n55537792)
print v(xbgr.mr_n55538112)
print v(xbgr.mr_n55538224)
print v(xbgr.mr_n55538544)
print v(xbgr.mr_n55538656)
print v(xbgr.mr_n55538976)
print v(xbgr.mr_n55539088)
print v(xbgr.mr_n55539408)
print v(xbgr.mr_n55539520)
print v(xbgr.mr_n55539840)
print v(xbgr.mr_n55539952)
print v(xbgr.mr_n55540272)
print v(xbgr.mr_n55540384)
print v(xbgr.mr_n55540704)
print v(xbgr.mr_n55540816)
print v(xbgr.mr_n55541136)
print v(xbgr.mr_n55541248)
print v(xbgr.mr_n55541568)
print v(xbgr.mr_n55541680)
print v(xbgr.mr_n55542000)
print v(xbgr.mr_n55542112)
print v(xbgr.mr_n55542432)
print v(xbgr.mr_n55542544)
print v(xbgr.mr_n55542864)
print v(xbgr.mr_n55542976)
print v(xbgr.mr_n55543296)
print v(xbgr.mr_n55543408)
print v(xbgr.mr_n55543728)
print v(xbgr.mr_n55543840)
print v(xbgr.mr_n55544160)
print v(xbgr.mr_n55544272)
print v(xbgr.mr_n55544592)
print v(xbgr.mr_n55544704)
print v(xbgr.mr_n55545024)
print v(xbgr.mr_n55545136)
print v(xbgr.mr_n55545456)
print v(xbgr.mr_n55545568)
print v(xbgr.mr_n55545888)
print v(xbgr.mr_n55546000)
print v(xbgr.mr_n55546320)
print v(xbgr.mr_n55546432)
print v(xbgr.mr_n55546752)
print v(xbgr.mr_n55546864)
print v(xbgr.mr_n55547184)
print v(xbgr.mr_n55547296)
print v(xbgr.mr_n55547616)
print v(xbgr.mr_n55547728)
print v(xbgr.mr_n55548048)
print v(xbgr.mr_n55548160)
print v(xbgr.mr_n55548480)
print v(xbgr.mr_n55548592)
print v(xbgr.mr_n55548912)
print v(xbgr.mr_n55549024)
print v(xbgr.mr_n55549344)
print v(xbgr.mr_n55549456)
print v(xbgr.mr_n55549776)
print v(xbgr.mr_n55549888)
print v(xbgr.mr_n55550208)
print v(xbgr.mr_n55550320)
print v(xbgr.mr_n55550640)
print v(xbgr.mr_n55550752)
print v(xbgr.mr_n55551072)
print v(xbgr.mr_n55551184)
print v(xbgr.mr_n55551504)
print v(xbgr.mr_n55551616)
print v(xbgr.mr_n55551936)
print v(xbgr.mr_n55552048)
print v(xbgr.mr_n55552368)
print v(xbgr.mr_n55552480)
print v(xbgr.mr_n55552800)
print v(xbgr.mr_n55552912)
print v(xbgr.mr_n55553232)
print v(xbgr.mr_n55553344)
print v(xbgr.mr_n55553664)
print v(xbgr.mr_n55553776)
print v(xbgr.mr_n55554096)
print v(xbgr.mr_n55554208)
print v(xbgr.mr_n55554528)
print v(xbgr.mr_n55554640)
print v(xbgr.mr_n55554960)
print v(xbgr.mr_n55555072)
print v(xbgr.mr_n55555392)
print v(xbgr.mr_n55555504)
print v(xbgr.mr_n55555808)
print v(xbgr.mr_n55555920)
print v(xbgr.mr_n55556240)
print v(xbgr.mr_n55556352)
print v(xbgr.mr_n55556672)
print v(xbgr.mr_n55556784)
print v(xbgr.mr_n55557104)
print v(xbgr.mr_n55557216)
print v(xbgr.mr_n55557536)
print v(xbgr.mr_n55557648)
print v(xbgr.mr_n55557968)
print v(xbgr.mr_n55558080)
print v(xbgr.mr_n55558400)
print v(xbgr.mr_n55558512)
print v(xbgr.mr_n55558832)
print v(xbgr.mr_n55558944)
print v(xbgr.mr_n55559264)
print v(xbgr.mr_n55559376)
print v(xbgr.mr_n55559696)
print v(xbgr.mr_n55559808)
print v(xbgr.mr_n55560128)
print v(xbgr.mr_n55560240)
print v(xbgr.mr_n55560560)
print v(xbgr.mr_n55560672)
print v(xbgr.mr_n55560992)
print v(xbgr.mr_n55561104)
print v(xbgr.mr_n55561424)
print v(xbgr.mr_n55561536)
print v(xbgr.mr_n55561856)
print v(xbgr.mr_n55561968)
print v(xbgr.mr_n55562288)
print v(xbgr.mr_n55562400)
print v(xbgr.mr_n55562720)
print v(xbgr.mr_n55562832)
print v(xbgr.mr_n55563152)
print v(xbgr.mr_n55563264)
print v(xbgr.mr_n55563584)
print v(xbgr.mr_n55563696)
print v(xbgr.mr_n55564016)
print v(xbgr.mr_n55564128)
print v(xbgr.mr_n55564448)
print v(xbgr.mr_n55564560)
print v(xbgr.mr_n55564880)
print v(xbgr.mr_n55564992)
print v(xbgr.mr_n55565312)
print v(xbgr.mr_n55565424)
print v(xbgr.mr_n55565744)
print v(xbgr.mr_n55565856)
print v(xbgr.mr_n55566176)
print v(xbgr.mr_n55566288)
print v(xbgr.mr_n55566608)
print v(xbgr.mr_n55566720)
print v(xbgr.mr_n55567040)
print v(xbgr.mr_n55567152)
print v(xbgr.mr_n55567472)
print v(xbgr.mr_n55567584)
print v(xbgr.mr_n55567904)
print v(xbgr.mr_n55568016)
print v(xbgr.mr_n55568336)
print v(xbgr.mr_n55568448)
print v(xbgr.mr_n55568768)
print v(xbgr.mr_n55568880)
print v(xbgr.mr_n55569200)
print v(xbgr.mr_n55569312)
print v(xbgr.mr_n55569632)
print v(xbgr.mr_n55569744)
print v(xbgr.mr_n55570064)
print v(xbgr.mr_n55570176)
print v(xbgr.mr_n55570496)
print v(xbgr.mr_n55570608)
print v(xbgr.mr_n55570928)
print v(xbgr.mr_n55571040)
print v(xbgr.mr_n55571360)
print v(xbgr.mr_n55571472)
print v(xbgr.mr_n55571792)
print v(xbgr.mr_n55571904)
print v(xbgr.mr_n55572224)
print v(xbgr.mr_n55572336)
print v(xbgr.mr_n55572656)
print v(xbgr.mr_n55572768)
print v(xbgr.mr_n55573088)
print v(xbgr.mr_n55573200)
print v(xbgr.mr_n55573520)
print v(xbgr.mr_n55573632)
print v(xbgr.mr_n55573952)
print v(xbgr.mr_n55574064)
print v(xbgr.mr_n55574384)
print v(xbgr.mr_n55574496)
print v(xbgr.mr_n55574816)
print v(xbgr.mr_n55574928)
print v(xbgr.mr_n55575248)
print v(xbgr.mr_n55575360)
print v(xbgr.mr_n55575680)
print v(xbgr.mr_n55575792)
print v(xbgr.mr_n55576112)
print v(xbgr.mr_n55576224)
print v(xbgr.mr_n55576544)
print v(xbgr.mr_n55576656)
print v(xbgr.mr_n55576976)
print v(xbgr.mr_n55577088)
print v(xbgr.mr_n55577408)
print v(xbgr.mr_n55577520)
print v(xbgr.mr_n55577840)
print v(xbgr.mr_n55577952)
print v(xbgr.mr_n55578272)
print v(xbgr.mr_n55578384)
print v(xbgr.mr_n55578704)
print v(xbgr.mr_n55578816)
print v(xbgr.mr_n55579136)
print v(xbgr.mr_n55579248)
print v(xbgr.mr_n55579568)
print v(xbgr.mr_n55579680)
print v(xbgr.mr_n55580000)
print v(xbgr.mr_n55580112)
print v(xbgr.mr_n55580432)
print v(xbgr.mr_n55580544)
print v(xbgr.mr_n55580864)
print v(xbgr.mr_n55580976)
print v(xbgr.mr_n55581296)
print v(xbgr.mr_n55581408)
print v(xbgr.mr_n55581728)
print v(xbgr.mr_n55581840)
print v(xbgr.mr_n55582160)
print v(xbgr.mr_n55582272)
print v(xbgr.mr_n55582592)
print v(xbgr.mr_n55582704)
print v(xbgr.mr_n55583024)
print v(xbgr.mr_n55583136)
print v(xbgr.mr_n55583456)
print v(xbgr.mr_n55583568)
print v(xbgr.mr_n55583888)
print v(xbgr.mr_n55584000)
print v(xbgr.mr_n55584320)
print v(xbgr.mr_n55584432)
print v(xbgr.mr_n55584752)
print v(xbgr.mr_n55584864)
print v(xbgr.mr_n55585184)
print v(xbgr.mr_n55585296)
print v(xbgr.mr_n55585616)
print v(xbgr.mr_n55585728)
print v(xbgr.mr_n55586048)
print v(xbgr.mr_n55586160)
print v(xbgr.mr_n55586480)
print v(xbgr.mr_n55586592)
print v(xbgr.mr_n55586912)
print v(xbgr.mr_n55587024)
print v(xbgr.mr_n55587344)
print v(xbgr.mr_n55587456)
print v(xbgr.mr_n55587776)
print v(xbgr.mr_n55587888)
print v(xbgr.mr_n55588208)
print v(xbgr.mr_n55588320)
print v(xbgr.mr_n55588640)
print v(xbgr.mr_n55588752)
print v(xbgr.mr_n55589072)
print v(xbgr.mr_n55589184)
print v(xbgr.mr_n55589504)
print v(xbgr.mr_n55589616)
print v(xbgr.mr_n55589936)
print v(xbgr.mr_n55590048)
print v(xbgr.mr_n55590368)
print v(xbgr.mr_n55590480)
print v(xbgr.mr_n55590800)
print v(xbgr.mr_n55590912)
print v(xbgr.mr_n55591232)
print v(xbgr.mr_n55591344)
print v(xbgr.mr_n55591664)
print v(xbgr.mr_n55591776)
print v(xbgr.mr_n55592096)
print v(xbgr.mr_n55592208)
print v(xbgr.mr_n55592528)
print v(xbgr.mr_n55592640)
print v(xbgr.mr_n55592960)
print v(xbgr.mr_n55593072)
print v(xbgr.mr_n55593392)
print v(xbgr.mr_n55593504)
print v(xbgr.mr_n55593824)
print v(xbgr.mr_n55593936)
print v(xbgr.mr_n55594256)
print v(xbgr.mr_n55594368)
print v(xbgr.mr_n55594688)
print v(xbgr.mr_n55594800)
print v(xbgr.mr_n55595120)
print v(xbgr.mr_n55595232)
print v(xbgr.mr_n55595552)
print v(xbgr.mr_n55595664)
print v(xbgr.mr_n55595984)
print v(xbgr.mr_n55596096)
print v(xbgr.mr_n55596416)
print v(xbgr.mr_n55596528)
print v(xbgr.mr_n55596848)
print v(xbgr.mr_n55596960)
print v(xbgr.mr_n55597280)
print v(xbgr.mr_n55597392)
print v(xbgr.mr_n55597712)
print v(xbgr.mr_n55597824)
print v(xbgr.mr_n55598144)
print v(xbgr.mr_n55598256)
print v(xbgr.mr_n55598576)
print v(xbgr.mr_n55598688)
print v(xbgr.mr_n55599008)
print v(xbgr.mr_n55599120)
print v(xbgr.mr_n55599440)
print v(xbgr.mr_n55599552)
print v(xbgr.mr_n55599872)
print v(xbgr.mr_n55599984)
print v(xbgr.mr_n55600304)
print v(xbgr.mr_n55600416)
print v(xbgr.mr_n55600736)
print v(xbgr.mr_n55600848)
print v(xbgr.mr_n55601168)
print v(xbgr.mr_n55601280)
print v(xbgr.mr_n55601600)
print v(xbgr.mr_n55601712)
print v(xbgr.mr_n55602032)
print v(xbgr.mr_n55602144)
print v(xbgr.mr_n55602464)
print v(xbgr.mr_n55602576)
print v(xbgr.mr_n55602896)
print v(xbgr.mr_n55603008)
print v(xbgr.mr_n55603328)
print v(xbgr.mr_n55603440)
print v(xbgr.mr_n55603760)
print v(xbgr.mr_n55603872)
print v(xbgr.mr_n55604192)
print v(xbgr.mr_n55604304)
print v(xbgr.mr_n55604624)
print v(xbgr.mr_n55604736)
print v(xbgr.mr_n55605056)
print v(xbgr.mr_n55605168)
print v(xbgr.mr_n55605488)
print v(xbgr.mr_n55605600)
print v(xbgr.mr_n55605920)
print v(xbgr.mr_n55606032)
print v(xbgr.mr_n55606352)
print v(xbgr.mr_n55606464)
print v(xbgr.mr_n55606784)
print v(xbgr.mr_n55606896)
print v(xbgr.mr_n55607216)
print v(xbgr.mr_n55607328)
print v(xbgr.mr_n55607648)
print v(xbgr.mr_n55607760)
print v(xbgr.mr_n55608080)
print v(xbgr.mr_n55608192)
print v(xbgr.mr_n55608512)
print v(xbgr.mr_n55608624)
print v(xbgr.mr_n55608944)
print v(xbgr.mr_n55609056)
print v(xbgr.mr_n55609376)
print v(xbgr.mr_n55609488)
print v(xbgr.mr_n55609808)
print v(xbgr.mr_n55609920)
print v(xbgr.mr_n55610240)
print v(xbgr.mr_n55610352)
print v(xbgr.mr_n55610672)
print v(xbgr.mr_n55610784)
print v(xbgr.mr_n55611104)
print v(xbgr.mr_n55611216)
print v(xbgr.mr_n55611536)
print v(xbgr.mr_n55611648)
print v(xbgr.mr_n55611968)
print v(xbgr.mr_n55612080)
print v(xbgr.mr_n55612400)
print v(xbgr.mr_n55612512)
print v(xbgr.mr_n55612832)
print v(xbgr.mr_n55612944)
print v(xbgr.mr_n55613264)
print v(xbgr.mr_n55613376)
print v(xbgr.mr_n55613696)
print v(xbgr.mr_n55613808)
print v(xbgr.mr_n55614128)
print v(xbgr.mr_n55614240)
print v(xbgr.mr_n55614560)
print v(xbgr.mr_n55614672)
print v(xbgr.mr_n55614992)
print v(xbgr.mr_n55615104)
print v(xbgr.mr_n55615424)
print v(xbgr.mr_n55615536)
print v(xbgr.mr_n55615856)
print v(xbgr.mr_n55615968)
print v(xbgr.mr_n55616288)
print v(xbgr.mr_n55616400)
print v(xbgr.mr_n55616720)
print v(xbgr.mr_n55616832)
print v(xbgr.mr_n55617152)
print v(xbgr.mr_n55617264)
print v(xbgr.mr_n55617584)
print v(xbgr.mr_n55617696)
print v(xbgr.mr_n55618016)
print v(xbgr.mr_n55618128)
print v(xbgr.mr_n55618448)
print v(xbgr.mr_n55618560)
print v(xbgr.mr_n55618880)
print v(xbgr.mr_n55618992)
print v(xbgr.mr_n55619312)
print v(xbgr.mr_n55619424)
print v(xbgr.mr_n55619744)
print v(xbgr.mr_n55619856)
print v(xbgr.mr_n55620176)
print v(xbgr.mr_n55620288)
print v(xbgr.mr_n55620608)
print v(xbgr.mr_n55620720)
print v(xbgr.mr_n55621040)
print v(xbgr.mr_n55621152)
print v(xbgr.mr_n55621472)
print v(xbgr.mr_n55621584)
print v(xbgr.mr_n55621904)
print v(xbgr.mr_n55622016)
print v(xbgr.mr_n55622336)
print v(xbgr.mr_n55622448)
print v(xbgr.mr_n55622768)
print v(xbgr.mr_n55622880)
print v(xbgr.mr_n55623200)
print v(xbgr.mr_n55623312)
print v(xbgr.mr_n55623632)
print v(xbgr.mr_n55623744)
print v(xbgr.mr_n55624064)
print v(xbgr.mr_n55624176)
print v(xbgr.mr_n55624496)
print v(xbgr.mr_n55624608)
print v(xbgr.mr_n55624928)
print v(xbgr.mr_n55625040)
print v(xbgr.mr_n55625360)
print v(xbgr.mr_n55625472)
print v(xbgr.mr_n55625792)
print v(xbgr.mr_n55625904)
print v(xbgr.mr_n55626224)
print v(xbgr.mr_n55626336)
print v(xbgr.mr_n55626656)
print v(xbgr.mr_n55626768)
print v(xbgr.mr_n55627088)
print v(xbgr.mr_n55627200)
print v(xbgr.mr_n55627520)
print v(xbgr.mr_n55627632)
print v(xbgr.mr_n55627952)
print v(xbgr.mr_n55628064)
print v(xbgr.mr_n55628384)
print v(xbgr.mr_n55628496)
print v(xbgr.mr_n55628816)
print v(xbgr.mr_n55628928)
print v(xbgr.mr_n55629248)
print v(xbgr.mr_n55629360)
print v(xbgr.mr_n55629680)
print v(xbgr.mr_n55629792)
print v(xbgr.mr_n55630112)
print v(xbgr.mr_n55630224)
print v(xbgr.mr_n55630544)
print v(xbgr.mr_n55630656)
print v(xbgr.mr_n55630976)
print v(xbgr.mr_n55631088)
print v(xbgr.mr_n55631408)
print v(xbgr.mr_n55631520)
print v(xbgr.mr_n55631840)
print v(xbgr.mr_n55631952)
print v(xbgr.mr_n55632272)
print v(xbgr.mr_n55632384)
print v(xbgr.mr_n55632704)
print v(xbgr.mr_n55632816)
print v(xbgr.mr_n55633136)
print v(xbgr.mr_n55633248)
print v(xbgr.mr_n55633568)
print v(xbgr.mr_n55633680)
print v(xbgr.mr_n55634000)
print v(xbgr.mr_n55634112)
print v(xbgr.mr_n55634432)
print v(xbgr.mr_n55634544)
print v(xbgr.mr_n55634864)
print v(xbgr.mr_n55634976)
print v(xbgr.mr_n55635296)
print v(xbgr.mr_n55635408)
print v(xbgr.mr_n55635728)
print v(xbgr.mr_n55635840)
print v(xbgr.mr_n55636160)
print v(xbgr.mr_n55636272)
print v(xbgr.mr_n55636592)
print v(xbgr.mr_n55636704)
print v(xbgr.mr_n55637024)
print v(xbgr.mr_n55637136)
print v(xbgr.mr_n55637456)
print v(xbgr.mr_n55637568)
print v(xbgr.mr_n55637888)
print v(xbgr.mr_n55638000)
print v(xbgr.mr_n55638320)
print v(xbgr.mr_n55638432)
print v(xbgr.mr_n55638752)
print v(xbgr.mr_n55638864)
print v(xbgr.mr_n55639184)
print v(xbgr.mr_n55639296)
print v(xbgr.mr_n55639616)
print v(xbgr.mr_n55639728)
print v(xbgr.mr_n55640048)
print v(xbgr.mr_n55640160)
print v(xbgr.mr_n55640480)
print v(xbgr.mr_n55640592)
print v(xbgr.mr_n55640912)
print v(xbgr.mr_n55641024)
print v(xbgr.mr_n55641344)
print v(xbgr.mr_n55641456)
print v(xbgr.mr_n55641776)
print v(xbgr.mr_n55641888)
print v(xbgr.mr_n55642208)
print v(xbgr.mr_n55642320)
print v(xbgr.mr_n55642640)
print v(xbgr.mr_n55642752)
print v(xbgr.mr_n55643072)
print v(xbgr.mr_n55643184)
print v(xbgr.mr_n55643504)
print v(xbgr.mr_n55643616)
print v(xbgr.mr_n55643936)
print v(xbgr.mr_n55644048)
print v(xbgr.mr_n55644368)
print v(xbgr.mr_n55644480)
print v(xbgr.mr_n55644800)
print v(xbgr.mr_n55644912)
print v(xbgr.mr_n55645232)
print v(xbgr.mr_n55645344)
print v(xbgr.mr_n55645664)
print v(xbgr.mr_n55645776)
print v(xbgr.mr_n55646096)
print v(xbgr.mr_n55646208)
print v(xbgr.mr_n55646528)
print v(xbgr.mr_n55646640)
print v(xbgr.mr_n55646960)
print v(xbgr.mr_n55647072)
print v(xbgr.mr_n55647392)
print v(xbgr.mr_n55647504)
print v(xbgr.mr_n55647824)
print v(xbgr.mr_n55647936)
print v(xbgr.mr_n55648256)
print v(xbgr.mr_n55648368)
print v(xbgr.mr_n55648688)
print v(xbgr.mr_n55648800)
print v(xbgr.mr_n55649120)
print v(xbgr.mr_n55649232)
print v(xbgr.mr_n55649552)
print v(xbgr.mr_n55649664)
print v(xbgr.mr_n55649984)
print v(xbgr.mr_n55650096)
print v(xbgr.mr_n55650416)
print v(xbgr.mr_n55650528)
print v(xbgr.mr_n55650848)
print v(xbgr.mr_n55650960)
print v(xbgr.mr_n55651280)
print v(xbgr.mr_n55651392)
print v(xbgr.mr_n55651712)
print v(xbgr.mr_n55651824)
print v(xbgr.mr_n55652144)
print v(xbgr.mr_n55652256)
print v(xbgr.mr_n55652576)
print v(xbgr.mr_n55652688)
print v(xbgr.mr_n55653008)
print v(xbgr.mr_n55653120)
print v(xbgr.mr_n55653440)
print v(xbgr.mr_n55653552)
print v(xbgr.mr_n55653872)
print v(xbgr.mr_n55653984)
print v(xbgr.mr_n55654304)
print v(xbgr.mr_n55654416)
print v(xbgr.mr_n55654736)
print v(xbgr.mr_n55654848)
print v(xbgr.mr_n55655168)
print v(xbgr.mr_n55655280)
print v(xbgr.mr_n55655600)
print v(xbgr.mr_n55655712)
print v(xbgr.mr_n55656032)
print v(xbgr.mr_n55656144)
print v(xbgr.mr_n55656464)
print v(xbgr.mr_n55656576)
print v(xbgr.mr_n55656896)
print v(xbgr.mr_n55657008)
print v(xbgr.mr_n55657328)
print v(xbgr.mr_n55657440)
print v(xbgr.mr_n55657760)
print v(xbgr.mr_n55657872)
print v(xbgr.mr_n55658192)
print v(xbgr.mr_n55658304)
print v(xbgr.mr_n55658624)
print v(xbgr.mr_n55658736)
print v(xbgr.mr_n55659056)
print v(xbgr.mr_n55659168)
print v(xbgr.mr_n55659488)
print v(xbgr.mr_n55659600)
print v(xbgr.mr_n55659920)
print v(xbgr.mr_n55660032)
print v(xbgr.mr_n55660352)
print v(xbgr.mr_n55660464)
print v(xbgr.mr_n55660784)
print v(xbgr.mr_n55660896)
print v(xbgr.mr_n55661216)
print v(xbgr.mr_n55661328)
print v(xbgr.mr_n55661648)
print v(xbgr.mr_n55661760)
print v(xbgr.mr_n55662080)
print v(xbgr.mr_n55662192)
print v(xbgr.mr_n55662512)
print v(xbgr.mr_n55662624)
print v(xbgr.mr_n55662944)
print v(xbgr.mr_n55663056)
print v(xbgr.mr_n55663376)
print v(xbgr.mr_n55663488)
print v(xbgr.mr_n55663808)
print v(xbgr.mr_n55663920)
print v(xbgr.mr_n55664240)
print v(xbgr.mr_n55664352)
print v(xbgr.mr_n55664672)
print v(xbgr.mr_n55664784)
print v(xbgr.mr_n55665104)
print v(xbgr.mr_n55665216)
print v(xbgr.mr_n55665536)
print v(xbgr.mr_n55665648)
print v(xbgr.mr_n55665968)
print v(xbgr.mr_n55666080)
print v(xbgr.mr_n55666400)
print v(xbgr.mr_n55666512)
print v(xbgr.mr_n55666832)
print v(xbgr.mr_n55666944)
print v(xbgr.mr_n55667264)
print v(xbgr.mr_n55667376)
print v(xbgr.mr_n55667696)
print v(xbgr.mr_n55667808)
print v(xbgr.mr_n55668128)
print v(xbgr.mr_n55668240)
print v(xbgr.mr_n55668560)
print v(xbgr.mr_n55668672)
print v(xbgr.mr_n55668992)
print v(xbgr.mr_n55669104)
print v(xbgr.mr_n55669424)
print v(xbgr.mr_n55669536)
print v(xbgr.mr_n55669856)
print v(xbgr.mr_n55669968)
print v(xbgr.mr_n55670288)
print v(xbgr.mr_n55670400)
print v(xbgr.mr_n55670720)
print v(xbgr.mr_n55670832)
print v(xbgr.mr_n55671152)
print v(xbgr.mr_n55671264)
print v(xbgr.mr_n55671584)
print v(xbgr.mr_n55671696)
print v(xbgr.mr_n55672016)
print v(xbgr.mr_n55672128)
print v(xbgr.mr_n55672448)
print v(xbgr.mr_n55672560)
print v(xbgr.mr_n55672880)
print v(xbgr.mr_n55672992)
print v(xbgr.mr_n55673312)
print v(xbgr.mr_n55673424)
print v(xbgr.mr_n55673744)
print v(xbgr.mr_n55673856)
print v(xbgr.mr_n55674176)
print v(xbgr.mr_n55674288)
print v(xbgr.mr_n55674608)
print v(xbgr.mr_n55674720)
print v(xbgr.mr_n55675040)
print v(xbgr.mr_n55675152)
print v(xbgr.mr_n55675472)
print v(xbgr.mr_n55675584)
print v(xbgr.mr_n55675904)
print v(xbgr.mr_n55676016)
print v(xbgr.mr_n55676336)
print v(xbgr.mr_n55676448)
print v(xbgr.mr_n55676768)
print v(xbgr.mr_n55676880)
print v(xbgr.mr_n55677200)
print v(xbgr.mr_n55677312)
print v(xbgr.mr_n55677632)
print v(xbgr.mr_n55677744)
print v(xbgr.mr_n55678064)
print v(xbgr.mr_n55678176)
print v(xbgr.mr_n55678496)
print v(xbgr.mr_n55678608)
print v(xbgr.mr_n55678928)
print v(xbgr.mr_n55679040)
print v(xbgr.mr_n55679360)
print v(xbgr.mr_n55679472)
print v(xbgr.mr_n55679792)
print v(xbgr.mr_n55679904)
print v(xbgr.mr_n55680224)
print v(xbgr.mr_n55680336)
print v(xbgr.mr_n55680656)
print v(xbgr.mr_n55680768)
print v(xbgr.mr_n55681088)
print v(xbgr.mr_n55681200)
print v(xbgr.mr_n55681520)
print v(xbgr.mr_n55681632)
print v(xbgr.mr_n55681952)
print v(xbgr.mr_n55682064)
print v(xbgr.mr_n55682384)
print v(xbgr.mr_n55682496)
print v(xbgr.mr_n55682816)
print v(xbgr.mr_n55682928)
print v(xbgr.mr_n55683248)
print v(xbgr.mr_n55683360)
print v(xbgr.mr_n55683680)
print v(xbgr.mr_n55683792)
print v(xbgr.mr_n55684112)
print v(xbgr.mr_n55684224)
print v(xbgr.mr_n55684544)
print v(xbgr.mr_n55684656)
print v(xbgr.mr_n55684976)
print v(xbgr.mr_n55685088)
print v(xbgr.mr_n55685408)
print v(xbgr.mr_n55685520)
print v(xbgr.mr_n55685840)
print v(xbgr.mr_n55685952)
print v(xbgr.mr_n55686272)
print v(xbgr.mr_n55686384)
print v(xbgr.mr_n55686704)
print v(xbgr.mr_n55686816)
print v(xbgr.mr_n55687136)
print v(xbgr.mr_n55687248)
print v(xbgr.mr_n55687568)
print v(xbgr.mr_n55687680)
print v(xbgr.mr_n55688000)
print v(xbgr.mr_n55688112)
print v(xbgr.mr_n55688432)
print v(xbgr.mr_n55688544)
print v(xbgr.mr_n55688864)
print v(xbgr.mr_n55688976)
print v(xbgr.mr_n55689296)
print v(xbgr.mr_n55689408)
print v(xbgr.mr_n55689728)
print v(xbgr.mr_n55689840)
print v(xbgr.mr_n55690160)
print v(xbgr.mr_n55690272)
print v(xbgr.mr_n55690592)
print v(xbgr.mr_n55690704)
print v(xbgr.mr_n55691024)
print v(xbgr.mr_n55691136)
print v(xbgr.mr_n55691456)
print v(xbgr.mr_n55691568)
print v(xbgr.mr_n55691888)
print v(xbgr.mr_n55692000)
print v(xbgr.mr_n55692320)
print v(xbgr.mr_n55692432)
print v(xbgr.mr_n55692752)
print v(xbgr.mr_n55692864)
print v(xbgr.mr_n55693184)
print v(xbgr.mr_n55693296)
print v(xbgr.mr_n55693616)
print v(xbgr.mr_n55693728)
print v(xbgr.mr_n55694048)
print v(xbgr.mr_n55694160)
print v(xbgr.mr_n55694480)
print v(xbgr.mr_n55694592)
print v(xbgr.mr_n55694912)
print v(xbgr.mr_n55695024)
print v(xbgr.mr_n55695344)
print v(xbgr.mr_n55695456)
print v(xbgr.mr_n55695776)
print v(xbgr.mr_n55695888)
print v(xbgr.mr_n55696208)
print v(xbgr.mr_n55696320)
print v(xbgr.mr_n55696640)
print v(xbgr.mr_n55696752)
print v(xbgr.mr_n55697072)
print v(xbgr.mr_n55697184)
print v(xbgr.mr_n55697504)
print v(xbgr.mr_n55697616)
print v(xbgr.mr_n55697936)
print v(xbgr.mr_n55698048)
print v(xbgr.mr_n55698368)
print v(xbgr.mr_n55698480)
print v(xbgr.mr_n55698800)
print v(xbgr.mr_n55698912)
print v(xbgr.mr_n55699232)
print v(xbgr.mr_n55699344)
print v(xbgr.mr_n55699664)
print v(xbgr.mr_n55699776)
print v(xbgr.mr_n55700096)
print v(xbgr.mr_n55700208)
print v(xbgr.mr_n55700528)
print v(xbgr.mr_n55700640)
print v(xbgr.mr_n55700960)
print v(xbgr.mr_n55701072)
print v(xbgr.mr_n55701392)
print v(xbgr.mr_n55701504)
print v(xbgr.mr_n55701824)
print v(xbgr.mr_n55701936)
print v(xbgr.mr_n55702256)
print v(xbgr.mr_n55702368)
print v(xbgr.mr_n55702688)
print v(xbgr.mr_n55702800)
print v(xbgr.mr_n55703120)
print v(xbgr.mr_n55703232)
print v(xbgr.mr_n55703552)
print v(xbgr.mr_n55703664)
print v(xbgr.mr_n55703984)
print v(xbgr.mr_n55704096)
print v(xbgr.mr_n55704416)
print v(xbgr.mr_n55704528)
print v(xbgr.mr_n55704848)
print v(xbgr.mr_n55704960)
print v(xbgr.mr_n55705280)
print v(xbgr.mr_n55705392)
print v(xbgr.mr_n55705712)
print v(xbgr.mr_n55705824)
print v(xbgr.mr_n55706144)
print v(xbgr.mr_n55706256)
print v(xbgr.mr_n55706576)
print v(xbgr.mr_n55706688)
print v(xbgr.mr_n55707008)
print v(xbgr.mr_n55707120)
print v(xbgr.mr_n55707440)
print v(xbgr.mr_n55707552)
print v(xbgr.mr_n55707872)
print v(xbgr.mr_n55707984)
print v(xbgr.mr_n55708304)
print v(xbgr.mr_n55708416)
print v(xbgr.mr_n55708736)
print v(xbgr.mr_n55708848)
print v(xbgr.mr_n55709168)
print v(xbgr.mr_n55709280)
print v(xbgr.mr_n55709600)
print v(xbgr.mr_n55709712)
print v(xbgr.mr_n55710032)
print v(xbgr.mr_n55710144)
print v(xbgr.mr_n55710464)
print v(xbgr.mr_n55710576)
print v(xbgr.mr_n55710896)
print v(xbgr.mr_n55711008)
print v(xbgr.mr_n55711328)
print v(xbgr.mr_n55711440)
print v(xbgr.mr_n55711760)
print v(xbgr.mr_n55711872)
print v(xbgr.mr_n55712192)
print v(xbgr.mr_n55712304)
print v(xbgr.mr_n55712624)
print v(xbgr.mr_n55712736)
print v(xbgr.mr_n55713056)
print v(xbgr.mr_n55713168)
print v(xbgr.mr_n55713488)
print v(xbgr.mr_n55713600)
print v(xbgr.mr_n55713920)
print v(xbgr.mr_n55714032)
print v(xbgr.mr_n55714352)
print v(xbgr.mr_n55714464)
print v(xbgr.mr_n55714784)
print v(xbgr.mr_n55714896)
print v(xbgr.mr_n55715216)
print v(xbgr.mr_n55715328)
print v(xbgr.mr_n55715648)
print v(xbgr.mr_n55715760)
print v(xbgr.mr_n55716080)
print v(xbgr.mr_n55716192)
print v(xbgr.mr_n55716512)
print v(xbgr.mr_n55716624)
print v(xbgr.mr_n55716944)
print v(xbgr.mr_n55717056)
print v(xbgr.mr_n55717376)
print v(xbgr.mr_n55717488)
print v(xbgr.mr_n55717808)
print v(xbgr.mr_n55717920)
print v(xbgr.mr_n55718240)
print v(xbgr.mr_n55718352)
print v(xbgr.mr_n55718672)
print v(xbgr.mr_n55718784)
print v(xbgr.mr_n55719104)
print v(xbgr.mr_n55719216)
print v(xbgr.mr_n55719536)
print v(xbgr.mr_n55719648)
print v(xbgr.mr_n55719968)
print v(xbgr.mr_n55720080)
print v(xbgr.mr_n55720400)
print v(xbgr.mr_n55720512)
print v(xbgr.mr_n55720832)
print v(xbgr.mr_n55720944)
print v(xbgr.mr_n55721264)
print v(xbgr.mr_n55721376)
print v(xbgr.mr_n55721696)
print v(xbgr.mr_n55721808)
print v(xbgr.mr_n55722128)
print v(xbgr.mr_n55722240)
print v(xbgr.mr_n55722560)
print v(xbgr.mr_n55722672)
print v(xbgr.mr_n55722992)
print v(xbgr.mr_n55723104)
print v(xbgr.mr_n55723424)
print v(xbgr.mr_n55723536)
print v(xbgr.mr_n55723856)
print v(xbgr.mr_n55723968)
print v(xbgr.mr_n55724288)
print v(xbgr.mr_n55724400)
print v(xbgr.mr_n55724720)
print v(xbgr.mr_n55724832)
print v(xbgr.mr_n55725152)
print v(xbgr.mr_n55725264)
print v(xbgr.mr_n55725584)
print v(xbgr.mr_n55725696)
print v(xbgr.mr_n55726016)
print v(xbgr.mr_n55726128)
print v(xbgr.mr_n55726448)
print v(xbgr.mr_n55726560)
print v(xbgr.mr_n55726880)
print v(xbgr.mr_n55726992)
print v(xbgr.mr_n55727312)
print v(xbgr.mr_n55727424)
print v(xbgr.mr_n55727744)
print v(xbgr.mr_n55727856)
print v(xbgr.mr_n55728176)
print v(xbgr.mr_n55728288)
print v(xbgr.mr_n55728608)
print v(xbgr.mr_n55728720)
print v(xbgr.mr_n55729040)
print v(xbgr.mr_n55729152)
print v(xbgr.mr_n55729472)
print v(xbgr.mr_n55729584)
print v(xbgr.mr_n55729904)
print v(xbgr.mr_n55730016)
print v(xbgr.mr_n55730336)
print v(xbgr.mr_n55730448)
print v(xbgr.mr_n55730768)
print v(xbgr.mr_n55730880)
print v(xbgr.mr_n55731200)
print v(xbgr.mr_n55731312)
print v(xbgr.mr_n55731632)
print v(xbgr.mr_n55731744)
print v(xbgr.mr_n55732064)
print v(xbgr.mr_n55732176)
print v(xbgr.mr_n55732496)
print v(xbgr.mr_n55732608)
print v(xbgr.mr_n55732928)
print v(xbgr.mr_n55733040)
print v(xbgr.mr_n55733360)
print v(xbgr.mr_n55733472)
print v(xbgr.mr_n55733792)
print v(xbgr.mr_n55733904)
print v(xbgr.mr_n55734224)
print v(xbgr.mr_n55734336)
print v(xbgr.mr_n55734656)
print v(xbgr.mr_n55734768)
print v(xbgr.mr_n55735088)
print v(xbgr.mr_n55735200)
print v(xbgr.mr_n55735520)
print v(xbgr.mr_n55735632)
print v(xbgr.mr_n55735952)
print v(xbgr.mr_n55736064)
print v(xbgr.mr_n55736384)
print v(xbgr.mr_n55736496)
print v(xbgr.mr_n55736816)
print v(xbgr.mr_n55736928)
print v(xbgr.mr_n55737248)
print v(xbgr.mr_n55737360)
print v(xbgr.mr_n55737680)
print v(xbgr.mr_n55737792)
print v(xbgr.mr_n55738112)
print v(xbgr.mr_n55738224)
print v(xbgr.mr_n55738544)
print v(xbgr.mr_n55738656)
print v(xbgr.mr_n55738976)
print v(xbgr.mr_n55739088)
print v(xbgr.mr_n55739408)
print v(xbgr.mr_n55739520)
print v(xbgr.mr_n55739840)
print v(xbgr.mr_n55739952)
print v(xbgr.mr_n55740272)
print v(xbgr.mr_n55740384)
print v(xbgr.mr_n55740704)
print v(xbgr.mr_n55740816)
print v(xbgr.mr_n55741136)
print v(xbgr.mr_n55741248)
print v(xbgr.mr_n55741568)
print v(xbgr.mr_n55741680)
print v(xbgr.mr_n55742000)
print v(xbgr.mr_n55742112)
print v(xbgr.mr_n55742432)
print v(xbgr.mr_n55742544)
print v(xbgr.mr_n55742864)
print v(xbgr.mr_n55742976)
print v(xbgr.mr_n55743296)
print v(xbgr.mr_n55743408)
print v(xbgr.mr_n55743728)
print v(xbgr.mr_n55743840)
print v(xbgr.mr_n55744160)
print v(xbgr.mr_n55744272)
print v(xbgr.mr_n55744592)
print v(xbgr.mr_n55744704)
print v(xbgr.mr_n55745024)
print v(xbgr.mr_n55745136)
print v(xbgr.mr_n55745456)
print v(xbgr.mr_n55745568)
print v(xbgr.mr_n55745888)
print v(xbgr.mr_n55746000)
print v(xbgr.mr_n55746320)
print v(xbgr.mr_n55746432)
print v(xbgr.mr_n55746752)
print v(xbgr.mr_n55746864)
print v(xbgr.mr_n55747184)
print v(xbgr.mr_n55747296)
print v(xbgr.mr_n55747616)
print v(xbgr.mr_n55747728)
print v(xbgr.mr_n55748048)
print v(xbgr.mr_n55748160)
print v(xbgr.mr_n55748480)
print v(xbgr.mr_n55748592)
print v(xbgr.mr_n55748912)
print v(xbgr.mr_n55749024)
print v(xbgr.mr_n55749344)
print v(xbgr.mr_n55749456)
print v(xbgr.mr_n55749776)
print v(xbgr.mr_n55749888)
print v(xbgr.mr_n55750208)
print v(xbgr.mr_n55750320)
print v(xbgr.mr_n55750640)
print v(xbgr.mr_n55750752)
print v(xbgr.mr_n55751072)
print v(xbgr.mr_n55751184)
print v(xbgr.mr_n55751504)
print v(xbgr.mr_n55751616)
print v(xbgr.mr_n55751936)
print v(xbgr.mr_n55752048)
print v(xbgr.mr_n55752368)
print v(xbgr.mr_n55752480)
print v(xbgr.mr_n55752800)
print v(xbgr.mr_n55752912)
print v(xbgr.mr_n55753232)
print v(xbgr.mr_n55753344)
print v(xbgr.mr_n55753664)
print v(xbgr.mr_n55753776)
print v(xbgr.mr_n55754096)
print v(xbgr.mr_n55754208)
print v(xbgr.mr_n55754528)
print v(xbgr.mr_n55754640)
print v(xbgr.mr_n55754960)
print v(xbgr.mr_n55755072)
print v(xbgr.mr_n55755392)
print v(xbgr.mr_n55755504)
print v(xbgr.mr_n55755824)
print v(xbgr.mr_n55755936)
print v(xbgr.mr_n55756256)
print v(xbgr.mr_n55756368)
print v(xbgr.mr_n55756688)
print v(xbgr.mr_n55756800)
print v(xbgr.mr_n55757120)
print v(xbgr.mr_n55757232)
print v(xbgr.mr_n55757552)
print v(xbgr.mr_n55757664)
print v(xbgr.mr_n55757984)
print v(xbgr.mr_n55758096)
print v(xbgr.mr_n55758416)
print v(xbgr.mr_n55758528)
print v(xbgr.mr_n55758848)
print v(xbgr.mr_n55758960)
print v(xbgr.mr_n55759280)
print v(xbgr.mr_n55759392)
print v(xbgr.mr_n55759712)
print v(xbgr.mr_n55759824)
print v(xbgr.mr_n55760144)
print v(xbgr.mr_n55760256)
print v(xbgr.mr_n55760576)
print v(xbgr.mr_n55760688)
print v(xbgr.mr_n55761008)
print v(xbgr.mr_n55761120)
print v(xbgr.mr_n55761440)
print v(xbgr.mr_n55761552)
print v(xbgr.mr_n55761872)
print v(xbgr.mr_n55761984)
print v(xbgr.mr_n55762304)
print v(xbgr.mr_n55762416)
print v(xbgr.mr_n55762736)
print v(xbgr.mr_n55762848)
print v(xbgr.mr_n55763168)
print v(xbgr.mr_n55763280)
print v(xbgr.mr_n55763600)
print v(xbgr.mr_n55763712)
print v(xbgr.mr_n55764032)
print v(xbgr.mr_n55764144)
print v(xbgr.mr_n55764464)
print v(xbgr.mr_n55764576)
print v(xbgr.mr_n55764896)
print v(xbgr.mr_n55765008)
print v(xbgr.mr_n55765328)
print v(xbgr.mr_n55765440)
print v(xbgr.mr_n55765760)
print v(xbgr.mr_n55765872)
print v(xbgr.mr_n55766192)
print v(xbgr.mr_n55766304)
print v(xbgr.mr_n55766624)
print v(xbgr.mr_n55766736)
print v(xbgr.mr_n55767056)
print v(xbgr.mr_n55767168)
print v(xbgr.mr_n55767488)
print v(xbgr.mr_n55767600)
print v(xbgr.mr_n55767920)
print v(xbgr.mr_n55768032)
print v(xbgr.mr_n55768352)
print v(xbgr.mr_n55768464)
print v(xbgr.mr_n55768784)
print v(xbgr.mr_n55768896)
print v(xbgr.mr_n55769216)
print v(xbgr.mr_n55769328)
print v(xbgr.mr_n55769648)
print v(xbgr.mr_n55769760)
print v(xbgr.mr_n55770080)
print v(xbgr.mr_n55770192)
print v(xbgr.mr_n55770512)
print v(xbgr.mr_n55770624)
print v(xbgr.mr_n55770944)
print v(xbgr.mr_n55771056)
print v(xbgr.mr_n55771376)
print v(xbgr.mr_n55771488)
print v(xbgr.mr_n55771808)
print v(xbgr.mr_n55771920)
print v(xbgr.mr_n55772240)
print v(xbgr.mr_n55772352)
print v(xbgr.mr_n55772672)
print v(xbgr.mr_n55772784)
print v(xbgr.mr_n55773104)
print v(xbgr.mr_n55773216)
print v(xbgr.mr_n55773536)
print v(xbgr.mr_n55773648)
print v(xbgr.mr_n55773968)
print v(xbgr.mr_n55774080)
print v(xbgr.mr_n55774400)
print v(xbgr.mr_n55774512)
print v(xbgr.mr_n55774832)
print v(xbgr.mr_n55774944)
print v(xbgr.mr_n55775264)
print v(xbgr.mr_n55775376)
print v(xbgr.mr_n55775696)
print v(xbgr.mr_n55775808)
print v(xbgr.mr_n55776128)
print v(xbgr.mr_n55776240)
print v(xbgr.mr_n55776560)
print v(xbgr.mr_n55776672)
print v(xbgr.mr_n55776992)
print v(xbgr.mr_n55777104)
print v(xbgr.mr_n55777424)
print v(xbgr.mr_n55777536)
print v(xbgr.mr_n55777856)
print v(xbgr.mr_n55777968)
print v(xbgr.mr_n55778288)
print v(xbgr.mr_n55778400)
print v(xbgr.mr_n55778720)
print v(xbgr.mr_n55778832)
print v(xbgr.mr_n55779152)
print v(xbgr.mr_n55779264)
print v(xbgr.mr_n55779584)
print v(xbgr.mr_n55779696)
print v(xbgr.mr_n55780016)
print v(xbgr.mr_n55780128)
print v(xbgr.mr_n55780448)
print v(xbgr.mr_n55780560)
print v(xbgr.mr_n55780880)
print v(xbgr.mr_n55780992)
print v(xbgr.mr_n55781312)
print v(xbgr.mr_n55781424)
print v(xbgr.mr_n55781744)
print v(xbgr.mr_n55781856)
print v(xbgr.mr_n55782176)
print v(xbgr.mr_n55782288)
print v(xbgr.mr_n55782608)
print v(xbgr.mr_n55782720)
print v(xbgr.mr_n55783040)
print v(xbgr.mr_n55783152)
print v(xbgr.mr_n55783472)
print v(xbgr.mr_n55783584)
print v(xbgr.mr_n55783904)
print v(xbgr.mr_n55784016)
print v(xbgr.mr_n55784336)
print v(xbgr.mr_n55784448)
print v(xbgr.mr_n55784768)
print v(xbgr.mr_n55784880)
print v(xbgr.mr_n55785200)
print v(xbgr.mr_n55785312)
print v(xbgr.mr_n55785632)
print v(xbgr.mr_n55785744)
print v(xbgr.mr_n55786064)
print v(xbgr.mr_n55786176)
print v(xbgr.mr_n55786496)
print v(xbgr.mr_n55786608)
print v(xbgr.mr_n55786928)
print v(xbgr.mr_n55787040)
print v(xbgr.mr_n55787360)
print v(xbgr.mr_n55787472)
print v(xbgr.mr_n55787792)
print v(xbgr.mr_n55787904)
print v(xbgr.mr_n55788224)
print v(xbgr.mr_n55788336)
print v(xbgr.mr_n55788656)
print v(xbgr.mr_n55788768)
print v(xbgr.mr_n55789088)
print v(xbgr.mr_n55789200)
print v(xbgr.mr_n55789520)
print v(xbgr.mr_n55789632)
print v(xbgr.mr_n55789952)
print v(xbgr.mr_n55790064)
print v(xbgr.mr_n55790384)
print v(xbgr.mr_n55790496)
print v(xbgr.mr_n55790816)
print v(xbgr.mr_n55790928)
print v(xbgr.mr_n55791248)
print v(xbgr.mr_n55791360)
print v(xbgr.mr_n55791680)
print v(xbgr.mr_n55791792)
print v(xbgr.mr_n55792112)
print v(xbgr.mr_n55792224)
print v(xbgr.mr_n55792544)
print v(xbgr.mr_n55792656)
print v(xbgr.mr_n55792976)
print v(xbgr.mr_n55793088)
print v(xbgr.mr_n55793408)
print v(xbgr.mr_n55793520)
print v(xbgr.mr_n55793840)
print v(xbgr.mr_n55793952)
print v(xbgr.mr_n55794272)
print v(xbgr.mr_n55794384)
print v(xbgr.mr_n55794704)
print v(xbgr.mr_n55794816)
print v(xbgr.mr_n55795136)
print v(xbgr.mr_n55795248)
print v(xbgr.mr_n55795568)
print v(xbgr.mr_n55795680)
print v(xbgr.mr_n55796000)
print v(xbgr.mr_n55796112)
print v(xbgr.mr_n55796432)
print v(xbgr.mr_n55796544)
print v(xbgr.mr_n55796864)
print v(xbgr.mr_n55796976)
print v(xbgr.mr_n55797296)
print v(xbgr.mr_n55797408)
print v(xbgr.mr_n55797728)
print v(xbgr.mr_n55797840)
print v(xbgr.mr_n55798160)
print v(xbgr.mr_n55798272)
print v(xbgr.mr_n55798592)
print v(xbgr.mr_n55798704)
print v(xbgr.mr_n55799024)
print v(xbgr.mr_n55799136)
print v(xbgr.mr_n55799456)
print v(xbgr.mr_n55799568)
print v(xbgr.mr_n55799888)
print v(xbgr.mr_n55800000)
print v(xbgr.mr_n55800320)
print v(xbgr.mr_n55800432)
print v(xbgr.mr_n55800752)
print v(xbgr.mr_n55800864)
print v(xbgr.mr_n55801184)
print v(xbgr.mr_n55801296)
print v(xbgr.mr_n55801616)
print v(xbgr.mr_n55801728)
print v(xbgr.mr_n55802048)
print v(xbgr.mr_n55802160)
print v(xbgr.mr_n55802480)
print v(xbgr.mr_n55802592)
print v(xbgr.mr_n55802912)
print v(xbgr.mr_n55803024)
print v(xbgr.mr_n55803344)
print v(xbgr.mr_n55803456)
print v(xbgr.mr_n55803776)
print v(xbgr.mr_n55803888)
print v(xbgr.mr_n55804208)
print v(xbgr.mr_n55804320)
print v(xbgr.mr_n55804640)
print v(xbgr.mr_n55804752)
print v(xbgr.mr_n55805072)
print v(xbgr.mr_n55805184)
print v(xbgr.mr_n55805504)
print v(xbgr.mr_n55805616)
print v(xbgr.mr_n55805936)
print v(xbgr.mr_n55806048)
print v(xbgr.mr_n55806368)
print v(xbgr.mr_n55806480)
print v(xbgr.mr_n55806800)
print v(xbgr.mr_n55806912)
print v(xbgr.mr_n55807232)
print v(xbgr.mr_n55807344)
print v(xbgr.mr_n55807664)
print v(xbgr.mr_n55807776)
print v(xbgr.mr_n55808096)
print v(xbgr.mr_n55808208)
print v(xbgr.mr_n55808528)
print v(xbgr.mr_n55808640)
print v(xbgr.mr_n55808960)
print v(xbgr.mr_n55809072)
print v(xbgr.mr_n55809392)
print v(xbgr.mr_n55809504)
print v(xbgr.mr_n55809824)
print v(xbgr.mr_n55809936)
print v(xbgr.mr_n55810256)
print v(xbgr.mr_n55810368)
print v(xbgr.mr_n55810688)
print v(xbgr.mr_n55810800)
print v(xbgr.mr_n55811120)
print v(xbgr.mr_n55811232)
print v(xbgr.mr_n55811552)
print v(xbgr.mr_n55811664)
print v(xbgr.mr_n55811984)
print v(xbgr.mr_n55812096)
print v(xbgr.mr_n55812416)
print v(xbgr.mr_n55812528)
print v(xbgr.mr_n55812848)
print v(xbgr.mr_n55812960)
print v(xbgr.mr_n55813280)
print v(xbgr.mr_n55813392)
print v(xbgr.mr_n55813712)
print v(xbgr.mr_n55813824)
print v(xbgr.mr_n55814144)
print v(xbgr.mr_n55814256)
print v(xbgr.mr_n55814576)
print v(xbgr.mr_n55814688)
print v(xbgr.mr_n55815008)
print v(xbgr.mr_n55815120)
print v(xbgr.mr_n55815440)
print v(xbgr.mr_n55815552)
print v(xbgr.mr_n55815872)
print v(xbgr.mr_n55815984)
print v(xbgr.mr_n55816304)
print v(xbgr.mr_n55816416)
print v(xbgr.mr_n55816736)
print v(xbgr.mr_n55816848)
print v(xbgr.mr_n55817168)
print v(xbgr.mr_n55817280)
print v(xbgr.mr_n55817600)
print v(xbgr.mr_n55817712)
print v(xbgr.mr_n55818032)
print v(xbgr.mr_n55818144)
print v(xbgr.mr_n55818464)
print v(xbgr.mr_n55818576)
print v(xbgr.mr_n55818896)
print v(xbgr.mr_n55819008)
print v(xbgr.mr_n55819328)
print v(xbgr.mr_n55819440)
print v(xbgr.mr_n55819760)
print v(xbgr.mr_n55819872)
print v(xbgr.mr_n55820192)
print v(xbgr.mr_n55820304)
print v(xbgr.mr_n55820624)
print v(xbgr.mr_n55820736)
print v(xbgr.mr_n55821056)
print v(xbgr.mr_n55821168)
print v(xbgr.mr_n55821488)
print v(xbgr.mr_n55821600)
print v(xbgr.mr_n55821920)
print v(xbgr.mr_n55822032)
print v(xbgr.mr_n55822352)
print v(xbgr.mr_n55822464)
print v(xbgr.mr_n55822784)
print v(xbgr.mr_n55822896)
print v(xbgr.mr_n55823216)
print v(xbgr.mr_n55823328)
print v(xbgr.mr_n55823648)
print v(xbgr.mr_n55823760)
print v(xbgr.mr_n55824080)
print v(xbgr.mr_n55824192)
print v(xbgr.mr_n55824512)
print v(xbgr.mr_n55824624)
print v(xbgr.mr_n55824944)
print v(xbgr.mr_n55825056)
print v(xbgr.mr_n55825376)
print v(xbgr.mr_n55825488)
print v(xbgr.mr_n55825808)
print v(xbgr.mr_n55825920)
print v(xbgr.mr_n55826240)
print v(xbgr.mr_n55826352)
print v(xbgr.mr_n55826672)
print v(xbgr.mr_n55826784)
print v(xbgr.mr_n55827104)
print v(xbgr.mr_n55827216)
print v(xbgr.mr_n55827536)
print v(xbgr.mr_n55827648)
print v(xbgr.mr_n55827968)
print v(xbgr.mr_n55828080)
print v(xbgr.mr_n55828400)
print v(xbgr.mr_n55828512)
print v(xbgr.mr_n55828832)
print v(xbgr.mr_n55828944)
print v(xbgr.mr_n55829264)
print v(xbgr.mr_n55829376)
print v(xbgr.mr_n55829696)
print v(xbgr.mr_n55829808)
print v(xbgr.mr_n55830128)
print v(xbgr.mr_n55830240)
print v(xbgr.mr_n55830560)
print v(xbgr.mr_n55830672)
print v(xbgr.mr_n55830992)
print v(xbgr.mr_n55831104)
print v(xbgr.mr_n55831424)
print v(xbgr.mr_n55831536)
print v(xbgr.mr_n55831856)
print v(xbgr.mr_n55831968)
print v(xbgr.mr_n55832288)
print v(xbgr.mr_n55832400)
print v(xbgr.mr_n55832720)
print v(xbgr.mr_n55832832)
print v(xbgr.mr_n55833152)
print v(xbgr.mr_n55833264)
print v(xbgr.mr_n55833584)
print v(xbgr.mr_n55833696)
print v(xbgr.mr_n55834016)
print v(xbgr.mr_n55834128)
print v(xbgr.mr_n55834448)
print v(xbgr.mr_n55834560)
print v(xbgr.mr_n55834880)
print v(xbgr.mr_n55834992)
print v(xbgr.mr_n55835312)
print v(xbgr.mr_n55835424)
print v(xbgr.mr_n55835744)
print v(xbgr.mr_n55835856)
print v(xbgr.mr_n55836176)
print v(xbgr.mr_n55836288)
print v(xbgr.mr_n55836608)
print v(xbgr.mr_n55836720)
print v(xbgr.mr_n55837040)
print v(xbgr.mr_n55837152)
print v(xbgr.mr_n55837472)
print v(xbgr.mr_n55837584)
print v(xbgr.mr_n55837904)
print v(xbgr.mr_n55838016)
print v(xbgr.mr_n55838336)
print v(xbgr.mr_n55838448)
print v(xbgr.mr_n55838768)
print v(xbgr.mr_n55838880)
print v(xbgr.mr_n55839200)
print v(xbgr.mr_n55839312)
print v(xbgr.mr_n55839632)
print v(xbgr.mr_n55839744)
print v(xbgr.mr_n55840064)
print v(xbgr.mr_n55840176)
print v(xbgr.mr_n55840496)
print v(xbgr.mr_n55840608)
print v(xbgr.mr_n55840928)
print v(xbgr.mr_n55841040)
print v(xbgr.mr_n55841360)
print v(xbgr.mr_n55841472)
print v(xbgr.mr_n55841792)
print v(xbgr.mr_n55841904)
print v(xbgr.mr_n55842224)
print v(xbgr.mr_n55842336)
print v(xbgr.mr_n55842656)
print v(xbgr.mr_n55842768)
print v(xbgr.mr_n55843088)
print v(xbgr.mr_n55843200)
print v(xbgr.mr_n55843520)
print v(xbgr.mr_n55843632)
print v(xbgr.mr_n55843952)
print v(xbgr.mr_n55844064)
print v(xbgr.mr_n55844384)
print v(xbgr.mr_n55844496)
print v(xbgr.mr_n55844816)
print v(xbgr.mr_n55844928)
print v(xbgr.mr_n55845248)
print v(xbgr.mr_n55845360)
print v(xbgr.mr_n55845680)
print v(xbgr.mr_n55845792)
print v(xbgr.mr_n55846112)
print v(xbgr.mr_n55846224)
print v(xbgr.mr_n55846544)
print v(xbgr.mr_n55846656)
print v(xbgr.mr_n55846976)
print v(xbgr.mr_n55847088)
print v(xbgr.mr_n55847408)
print v(xbgr.mr_n55847520)
print v(xbgr.mr_n55847840)
print v(xbgr.mr_n55847952)
print v(xbgr.mr_n55848272)
print v(xbgr.mr_n55848384)
print v(xbgr.mr_n55848704)
print v(xbgr.mr_n55848816)
print v(xbgr.mr_n55849136)
print v(xbgr.mr_n55849248)
print v(xbgr.mr_n55849568)
print v(xbgr.mr_n55849680)
print v(xbgr.mr_n55850000)
print v(xbgr.mr_n55850112)
print v(xbgr.mr_n55850432)
print v(xbgr.mr_n55850544)
print v(xbgr.mr_n55850864)
print v(xbgr.mr_n55850976)
print v(xbgr.mr_n55851296)
print v(xbgr.mr_n55851408)
print v(xbgr.mr_n55851728)
print v(xbgr.mr_n55851840)
print v(xbgr.mr_n55852160)
print v(xbgr.mr_n55852272)
print v(xbgr.mr_n55852592)
print v(xbgr.mr_n55852704)
print v(xbgr.mr_n55853024)
print v(xbgr.mr_n55853136)
print v(xbgr.mr_n55853456)
print v(xbgr.mr_n55853568)
print v(xbgr.mr_n55853888)
print v(xbgr.mr_n55854000)
print v(xbgr.mr_n55854320)
print v(xbgr.mr_n55854432)
print v(xbgr.mr_n55854752)
print v(xbgr.mr_n55854864)
print v(xbgr.mr_n55855184)
print v(xbgr.mr_n55855296)
print v(xbgr.mr_n55855616)
print v(xbgr.mr_n55855728)
print v(xbgr.mr_n55856048)
print v(xbgr.mr_n55856160)
print v(xbgr.mr_n55856480)
print v(xbgr.mr_n55856592)
print v(xbgr.mr_n55856912)
print v(xbgr.mr_n55857024)
print v(xbgr.mr_n55857344)
print v(xbgr.mr_n55857456)
print v(xbgr.mr_n55857776)
print v(xbgr.mr_n55857888)
print v(xbgr.mr_n55858208)
print v(xbgr.mr_n55858320)
print v(xbgr.mr_n55858640)
print v(xbgr.mr_n55858752)
print v(xbgr.mr_n55859072)
print v(xbgr.mr_n55859184)
print v(xbgr.mr_n55859504)
print v(xbgr.mr_n55859616)
print v(xbgr.mr_n55859936)
print v(xbgr.mr_n55860048)
print v(xbgr.mr_n55860368)
print v(xbgr.mr_n55860480)
print v(xbgr.mr_n55860800)
print v(xbgr.mr_n55860912)
print v(xbgr.mr_n55861232)
print v(xbgr.mr_n55861344)
print v(xbgr.mr_n55861664)
print v(xbgr.mr_n55861776)
print v(xbgr.mr_n55862096)
print v(xbgr.mr_n55862208)
print v(xbgr.mr_n55862528)
print v(xbgr.mr_n55862640)
print v(xbgr.mr_n55862960)
print v(xbgr.mr_n55863072)
print v(xbgr.mr_n55863392)
print v(xbgr.mr_n55863504)
print v(xbgr.mr_n55863824)
print v(xbgr.mr_n55863936)
print v(xbgr.mr_n55864256)
print v(xbgr.mr_n55864368)
print v(xbgr.mr_n55864688)
print v(xbgr.mr_n55864800)
print v(xbgr.mr_n55865120)
print v(xbgr.mr_n55865232)
print v(xbgr.mr_n55865552)
print v(xbgr.mr_n55865664)
print v(xbgr.mr_n55865984)
print v(xbgr.mr_n55866096)
print v(xbgr.mr_n55866416)
print v(xbgr.mr_n55866528)
print v(xbgr.mr_n55866848)
print v(xbgr.mr_n55866960)
print v(xbgr.mr_n55867280)
print v(xbgr.mr_n55867392)
print v(xbgr.mr_n55867712)
print v(xbgr.mr_n55867824)
print v(xbgr.mr_n55868144)
print v(xbgr.mr_n55868256)
print v(xbgr.mr_n55868576)
print v(xbgr.mr_n55868688)
print v(xbgr.mr_n55869008)
print v(xbgr.mr_n55869120)
print v(xbgr.mr_n55869440)
print v(xbgr.mr_n55869552)
print v(xbgr.mr_n55869872)
print v(xbgr.mr_n55869984)
print v(xbgr.mr_n55870304)
print v(xbgr.mr_n55870416)
print v(xbgr.mr_n55870736)
print v(xbgr.mr_n55870848)
print v(xbgr.mr_n55871168)
print v(xbgr.mr_n55871280)
print v(xbgr.mr_n55871600)
print v(xbgr.mr_n55871712)
print v(xbgr.mr_n55872032)
print v(xbgr.mr_n55872144)
print v(xbgr.mr_n55872464)
print v(xbgr.mr_n55872576)
print v(xbgr.mr_n55872896)
print v(xbgr.mr_n55873008)
print v(xbgr.mr_n55873328)
print v(xbgr.mr_n55873440)
print v(xbgr.mr_n55873760)
print v(xbgr.mr_n55873872)
print v(xbgr.mr_n55874192)
print v(xbgr.mr_n55874304)
print v(xbgr.mr_n55874624)
print v(xbgr.mr_n55874736)
print v(xbgr.mr_n55875056)
print v(xbgr.mr_n55875168)
print v(xbgr.mr_n55875488)
print v(xbgr.mr_n55875600)
print v(xbgr.mr_n55875920)
print v(xbgr.mr_n55876032)
print v(xbgr.mr_n55876352)
print v(xbgr.mr_n55876464)
print v(xbgr.mr_n55876784)
print v(xbgr.mr_n55876896)
print v(xbgr.mr_n55877216)
print v(xbgr.mr_n55877328)
print v(xbgr.mr_n55877648)
print v(xbgr.mr_n55877760)
print v(xbgr.mr_n55878080)
print v(xbgr.mr_n55878192)
print v(xbgr.mr_n55878512)
print v(xbgr.mr_n55878624)
print v(xbgr.mr_n55878944)
print v(xbgr.mr_n55879056)
print v(xbgr.mr_n55879376)
print v(xbgr.mr_n55879488)
print v(xbgr.mr_n55879808)
print v(xbgr.mr_n55879920)
print v(xbgr.mr_n55880240)
print v(xbgr.mr_n55880352)
print v(xbgr.mr_n55880672)
print v(xbgr.mr_n55880784)
print v(xbgr.mr_n55881104)
print v(xbgr.mr_n55881216)
print v(xbgr.mr_n55881536)
print v(xbgr.mr_n55881648)
print v(xbgr.mr_n55881968)
print v(xbgr.mr_n55882080)
print v(xbgr.mr_n55882400)
print v(xbgr.mr_n55882512)
print v(xbgr.mr_n55882832)
print v(xbgr.mr_n55882944)
print v(xbgr.mr_n55883264)
print v(xbgr.mr_n55883376)
print v(xbgr.mr_n55883696)
print v(xbgr.mr_n55883808)
print v(xbgr.mr_n55884128)
print v(xbgr.mr_n55884240)
print v(xbgr.mr_n55884560)
print v(xbgr.mr_n55884672)
print v(xbgr.mr_n55884992)
print v(xbgr.mr_n55885104)
print v(xbgr.mr_n55885424)
print v(xbgr.mr_n55885536)
print v(xbgr.mr_n55885856)
print v(xbgr.mr_n55885968)
print v(xbgr.mr_n55886288)
print v(xbgr.mr_n55886400)
print v(xbgr.mr_n55886720)
print v(xbgr.mr_n55886832)
print v(xbgr.mr_n55887152)
print v(xbgr.mr_n55887264)
print v(xbgr.mr_n55887584)
print v(xbgr.mr_n55887696)
print v(xbgr.mr_n55888016)
print v(xbgr.mr_n55888128)
print v(xbgr.mr_n55888448)
print v(xbgr.mr_n55888560)
print v(xbgr.mr_n55888880)
print v(xbgr.mr_n55888992)
print v(xbgr.mr_n55889312)
print v(xbgr.mr_n55889424)
print v(xbgr.mr_n55889744)
print v(xbgr.mr_n55889856)
print v(xbgr.mr_n55890176)
print v(xbgr.mr_n55890288)
print v(xbgr.mr_n55890608)
print v(xbgr.mr_n55890720)
print v(xbgr.mr_n55891040)
print v(xbgr.mr_n55891152)
print v(xbgr.mr_n55891472)
print v(xbgr.mr_n55891584)
print v(xbgr.mr_n55891904)
print v(xbgr.mr_n55892016)
print v(xbgr.mr_n55892336)
print v(xbgr.mr_n55892448)
print v(xbgr.mr_n55892768)
print v(xbgr.mr_n55892880)
print v(xbgr.mr_n55893200)
print v(xbgr.mr_n55893312)
print v(xbgr.mr_n55893632)
print v(xbgr.mr_n55893744)
print v(xbgr.mr_n55894064)
print v(xbgr.mr_n55894176)
print v(xbgr.mr_n55894496)
print v(xbgr.mr_n55894608)
print v(xbgr.mr_n55894928)
print v(xbgr.mr_n55895040)
print v(xbgr.mr_n55895360)
print v(xbgr.mr_n55895472)
print v(xbgr.mr_n55895792)
print v(xbgr.mr_n55895904)
print v(xbgr.mr_n55896224)
print v(xbgr.mr_n55896336)
print v(xbgr.mr_n55896656)
print v(xbgr.mr_n55896768)
print v(xbgr.mr_n55897088)
print v(xbgr.mr_n55897200)
print v(xbgr.mr_n55897520)
print v(xbgr.mr_n55897632)
print v(xbgr.mr_n55897952)
print v(xbgr.mr_n55898064)
print v(xbgr.mr_n55898384)
print v(xbgr.mr_n55898496)
print v(xbgr.mr_n55898816)
print v(xbgr.mr_n55898928)
print v(xbgr.mr_n55899248)
print v(xbgr.mr_n55899360)
print v(xbgr.mr_n55899680)
print v(xbgr.mr_n55899792)
print v(xbgr.mr_n55900112)
print v(xbgr.mr_n55900224)
print v(xbgr.mr_n55900544)
print v(xbgr.mr_n55900656)
print v(xbgr.mr_n55900976)
print v(xbgr.mr_n55901088)
print v(xbgr.mr_n55901408)
print v(xbgr.mr_n55901520)
print v(xbgr.mr_n55901840)
print v(xbgr.mr_n55901952)
print v(xbgr.mr_n55902272)
print v(xbgr.mr_n55902384)
print v(xbgr.mr_n55902704)
print v(xbgr.mr_n55902816)
print v(xbgr.mr_n55903136)
print v(xbgr.mr_n55903248)
print v(xbgr.mr_n55903568)
print v(xbgr.mr_n55903680)
print v(xbgr.mr_n55904000)
print v(xbgr.mr_n55904112)
print v(xbgr.mr_n55904432)
print v(xbgr.mr_n55904544)
print v(xbgr.mr_n55904864)
print v(xbgr.mr_n55904976)
print v(xbgr.mr_n55905296)
print v(xbgr.mr_n55905408)
print v(xbgr.mr_n55905728)
print v(xbgr.mr_n55905840)
print v(xbgr.mr_n55906160)
print v(xbgr.mr_n55906272)
print v(xbgr.mr_n55906592)
print v(xbgr.mr_n55906704)
print v(xbgr.mr_n55907024)
print v(xbgr.mr_n55907136)
print v(xbgr.mr_n55907456)
print v(xbgr.mr_n55907568)
print v(xbgr.mr_n55907888)
print v(xbgr.mr_n55908000)
print v(xbgr.mr_n55908320)
print v(xbgr.mr_n55908432)
print v(xbgr.mr_n55908752)
print v(xbgr.mr_n55908864)
print v(xbgr.mr_n55909184)
print v(xbgr.mr_n55909296)
print v(xbgr.mr_n55909616)
print v(xbgr.mr_n55909728)
print v(xbgr.mr_n55910048)
print v(xbgr.mr_n55910160)
print v(xbgr.mr_n55910480)
print v(xbgr.mr_n55910592)
print v(xbgr.mr_n55910912)
print v(xbgr.mr_n55911024)
print v(xbgr.mr_n55911344)
print v(xbgr.mr_n55911456)
print v(xbgr.mr_n55911776)
print v(xbgr.mr_n55911888)
print v(xbgr.mr_n55912208)
print v(xbgr.mr_n55912320)
print v(xbgr.mr_n55912640)
print v(xbgr.mr_n55912752)
print v(xbgr.mr_n55913072)
print v(xbgr.mr_n55913184)
print v(xbgr.mr_n55913504)
print v(xbgr.mr_n55913616)
print v(xbgr.mr_n55913936)
print v(xbgr.mr_n55914048)
print v(xbgr.mr_n55914368)
print v(xbgr.mr_n55914480)
print v(xbgr.mr_n55914800)
print v(xbgr.mr_n55914912)
print v(xbgr.mr_n55915232)
print v(xbgr.mr_n55915344)
print v(xbgr.mr_n55915664)
print v(xbgr.mr_n55915776)
print v(xbgr.mr_n55916096)
print v(xbgr.mr_n55916208)
print v(xbgr.mr_n55916528)
print v(xbgr.mr_n55916640)
print v(xbgr.mr_n55916960)
print v(xbgr.mr_n55917072)
print v(xbgr.mr_n55917392)
print v(xbgr.mr_n55917504)
print v(xbgr.mr_n55917824)
print v(xbgr.mr_n55917936)
print v(xbgr.mr_n55918256)
print v(xbgr.mr_n55918368)
print v(xbgr.mr_n55918688)
print v(xbgr.mr_n55918800)
print v(xbgr.mr_n55919120)
print v(xbgr.mr_n55919232)
print v(xbgr.mr_n55919552)
print v(xbgr.mr_n55919664)
print v(xbgr.mr_n55919984)
print v(xbgr.mr_n55920096)
print v(xbgr.mr_n55920416)
print v(xbgr.mr_n55920528)
print v(xbgr.mr_n55920848)
print v(xbgr.mr_n55920960)
print v(xbgr.mr_n55921280)
print v(xbgr.mr_n55921392)
print v(xbgr.mr_n55921712)
print v(xbgr.mr_n55921824)
print v(xbgr.mr_n55922144)
print v(xbgr.mr_n55922256)
print v(xbgr.mr_n55922576)
print v(xbgr.mr_n55922688)
print v(xbgr.mr_n55923008)
print v(xbgr.mr_n55923120)
print v(xbgr.mr_n55923440)
print v(xbgr.mr_n55923552)
print v(xbgr.mr_n55923872)
print v(xbgr.mr_n55923984)
print v(xbgr.mr_n55924304)
print v(xbgr.mr_n55924416)
print v(xbgr.mr_n55924736)
print v(xbgr.mr_n55924848)
print v(xbgr.mr_n55925168)
print v(xbgr.mr_n55925280)
print v(xbgr.mr_n55925600)
print v(xbgr.mr_n55925712)
print v(xbgr.mr_n55926032)
print v(xbgr.mr_n55926144)
print v(xbgr.mr_n55926464)
print v(xbgr.mr_n55926576)
print v(xbgr.mr_n55926896)
print v(xbgr.mr_n55927008)
print v(xbgr.mr_n55927328)
print v(xbgr.mr_n55927440)
print v(xbgr.mr_n55927760)
print v(xbgr.mr_n55927872)
print v(xbgr.mr_n55928192)
print v(xbgr.mr_n55928304)
print v(xbgr.mr_n55928624)
print v(xbgr.mr_n55928736)
print v(xbgr.mr_n55929056)
print v(xbgr.mr_n55929168)
print v(xbgr.mr_n55929488)
print v(xbgr.mr_n55929600)
print v(xbgr.mr_n55929920)
print v(xbgr.mr_n55930032)
print v(xbgr.mr_n55930352)
print v(xbgr.mr_n55930464)
print v(xbgr.mr_n55930784)
print v(xbgr.mr_n55930896)
print v(xbgr.mr_n55931216)
print v(xbgr.mr_n55931328)
print v(xbgr.mr_n55931648)
print v(xbgr.mr_n55931760)
print v(xbgr.mr_n55932080)
print v(xbgr.mr_n55932192)
print v(xbgr.mr_n55932512)
print v(xbgr.mr_n55932624)
print v(xbgr.mr_n55932944)
print v(xbgr.mr_n55933056)
print v(xbgr.mr_n55933488)
print v(xbgr.mr_n55933808)
print v(xbgr.mr_n55933920)
print v(xbgr.mr_n55934240)
print v(xbgr.mr_n55934352)
print v(xbgr.mr_n55934672)
print v(xbgr.mr_n55934784)
print v(xbgr.mr_n55935104)
print v(xbgr.mr_n55935216)
print v(xbgr.mr_n55935536)
print v(xbgr.mr_n55935648)
print v(xbgr.mr_n55935968)
print v(xbgr.mr_n55936080)
print v(xbgr.mr_n55936400)
print v(xbgr.mr_n55936512)
print v(xbgr.mr_n55936832)
print v(xbgr.mr_n55936944)
print v(xbgr.mr_n55937264)
print v(xbgr.mr_n55937376)
print v(xbgr.mr_n55937696)
print v(xbgr.mr_n55937808)
print v(xbgr.mr_n55938128)
print v(xbgr.mr_n55938240)
print v(xbgr.mr_n55938560)
print v(xbgr.mr_n55938672)
print v(xbgr.mr_n55938992)
print v(xbgr.mr_n55939104)
print v(xbgr.mr_n55939536)
print v(xbgr.mr_n55939856)
print v(xbgr.mr_n55939968)
print v(xbgr.mr_n55940288)
print v(xbgr.mr_n55940400)
print v(xbgr.mr_n55940720)
print v(xbgr.mr_n55940832)
print v(xbgr.mr_n55941152)
print v(xbgr.mr_n55941264)
print v(xbgr.mr_n55941584)
print v(xbgr.mr_n55941696)
print v(xbgr.mr_n55942016)
print v(xbgr.mr_n55942128)
print v(xbgr.mr_n55942448)
print v(xbgr.mr_n55942560)
print v(xbgr.mr_n55942880)
print v(xbgr.mr_n55942992)
print v(xbgr.mr_n55943312)
print v(xbgr.mr_n55943424)
print v(xbgr.mr_n55943744)
print v(xbgr.mr_n55943856)
print v(xbgr.mr_n55944176)
print v(xbgr.mr_n55944288)
print v(xbgr.mr_n55944608)
print v(xbgr.mr_n55944720)
print v(xbgr.mr_n55945040)
print v(xbgr.mr_n55945152)
print v(xbgr.mr_n55945472)
print v(xbgr.mr_n55945584)
print v(xbgr.mr_n55945904)
print v(xbgr.mr_n55946016)
print v(xbgr.mr_n55946336)
print v(xbgr.mr_n55946448)
print v(xbgr.mr_n55946768)
print v(xbgr.mr_n55946880)
print v(xbgr.mr_n55947200)
print v(xbgr.mr_n55947312)
print v(xbgr.mr_n55947632)
print v(xbgr.mr_n55947744)
print v(xbgr.mr_n55948064)
print v(xbgr.mr_n55948176)
print v(xbgr.mr_n55948496)
print v(xbgr.mr_n55948608)
print v(xbgr.mr_n55948928)
print v(xbgr.mr_n55949040)
print v(xbgr.mr_n55949360)
print v(xbgr.mr_n55949472)
print v(xbgr.mr_n55949792)
print v(xbgr.mr_n55949904)
print v(xbgr.mr_n55950224)
print v(xbgr.mr_n55950336)
print v(xbgr.mr_n55950656)
print v(xbgr.mr_n55950768)
print v(xbgr.mr_n55951088)
print v(xbgr.mr_n55951200)
print v(xbgr.mr_n55951520)
print v(xbgr.mr_n55951632)
print v(xbgr.mr_n55951952)
print v(xbgr.mr_n55952064)
print v(xbgr.mr_n55952384)
print v(xbgr.mr_n55952496)
print v(xbgr.mr_n55952816)
print v(xbgr.mr_n55952928)
print v(xbgr.mr_n55953248)
print v(xbgr.mr_n55953360)
print v(xbgr.mr_n55953680)
print v(xbgr.mr_n55953792)
print v(xbgr.mr_n55954112)
print v(xbgr.mr_n55954224)
print v(xbgr.mr_n55954544)
print v(xbgr.mr_n55954656)
print v(xbgr.mr_n55954976)
print v(xbgr.mr_n55955088)
print v(xbgr.mr_n55955408)
print v(xbgr.mr_n55955520)
print v(xbgr.mr_n55955840)
print v(xbgr.mr_n55955952)
print v(xbgr.mr_n55956272)
print v(xbgr.mr_n55956384)
print v(xbgr.mr_n55956704)
print v(xbgr.mr_n55956816)
print v(xbgr.mr_n55957136)
print v(xbgr.mr_n55957248)
print v(xbgr.mr_n55957568)
print v(xbgr.mr_n55957680)
print v(xbgr.mr_n55958000)
print v(xbgr.mr_n55958112)
print v(xbgr.mr_n55958432)
print v(xbgr.mr_n55958544)
print v(xbgr.mr_n55958864)
print v(xbgr.mr_n55958976)
print v(xbgr.mr_n55959296)
print v(xbgr.mr_n55959408)
print v(xbgr.mr_n55959728)
print v(xbgr.mr_n55959840)
print v(xbgr.mr_n55960160)
print v(xbgr.mr_n55960272)
print v(xbgr.mr_n55960592)
print v(xbgr.mr_n55960704)
print v(xbgr.mr_n55961024)
print v(xbgr.mr_n55961136)
print v(xbgr.mr_n55961456)
print v(xbgr.mr_n55961568)
print v(xbgr.mr_n55961888)
print v(xbgr.mr_n55962000)
print v(xbgr.mr_n55962320)
print v(xbgr.mr_n55962432)
print v(xbgr.mr_n55962752)
print v(xbgr.mr_n55962864)
print v(xbgr.mr_n55963184)
print v(xbgr.mr_n55963296)
print v(xbgr.mr_n55963616)
print v(xbgr.mr_n55963728)
print v(xbgr.mr_n55964048)
print v(xbgr.mr_n55964160)
print v(xbgr.mr_n55964480)
print v(xbgr.mr_n55964592)
print v(xbgr.mr_n55964912)
print v(xbgr.mr_n55965024)
print v(xbgr.mr_n55965344)
print v(xbgr.mr_n55965456)
print v(xbgr.mr_n55965776)
print v(xbgr.mr_n55965888)
print v(xbgr.mr_n55966208)
print v(xbgr.mr_n55966320)
print v(xbgr.mr_n55966640)
print v(xbgr.mr_n55966752)
print v(xbgr.mr_n55967072)
print v(xbgr.mr_n55967184)
print v(xbgr.mr_n55967504)
print v(xbgr.mr_n55967616)
print v(xbgr.mr_n55967936)
print v(xbgr.mr_n55968048)
print v(xbgr.mr_n55968368)
print v(xbgr.mr_n55968480)
print v(xbgr.mr_n55968800)
print v(xbgr.mr_n55968912)
print v(xbgr.mr_n55969232)
print v(xbgr.mr_n55969344)
print v(xbgr.mr_n55969664)
print v(xbgr.mr_n55969776)
print v(xbgr.mr_n55970096)
print v(xbgr.mr_n55970208)
print v(xbgr.mr_n55970528)
print v(xbgr.mr_n55970640)
print v(xbgr.mr_n55970960)
print v(xbgr.mr_n55971072)
print v(xbgr.mr_n55971392)
print v(xbgr.mr_n55971504)
print v(xbgr.mr_n55971824)
print v(xbgr.mr_n55971936)
print v(xbgr.mr_n55972368)
print v(xbgr.mr_n55972688)
print v(xbgr.mr_n55972800)
print v(xbgr.mr_n55973120)
print v(xbgr.mr_n55973232)
print v(xbgr.mr_n55973552)
print v(xbgr.mr_n55973664)
print v(xbgr.mr_n55974096)
print v(xbgr.mr_n55974416)
print v(xbgr.mr_n55974528)
print v(xbgr.mr_n55974848)
print v(xbgr.mr_n55974960)
print v(xbgr.mr_n55975280)
print v(xbgr.mr_n55975392)
print v(xbgr.mr_n55975824)
print v(xbgr.mr_n55976144)
print v(xbgr.mr_n55976256)
print v(xbgr.mr_n55976576)
print v(xbgr.mr_n55976688)
print v(xbgr.mr_n55977008)
print v(xbgr.mr_n55977120)
print v(xbgr.mr_n55977440)
print v(xbgr.mr_n55977552)
print v(xbgr.mr_n55977872)
print v(xbgr.mr_n55977984)
print v(xbgr.mr_n55978304)
print v(xbgr.mr_n55978416)
print v(xbgr.mr_n55978736)
print v(xbgr.mr_n55978848)
print v(xbgr.mr_n55979168)
print v(xbgr.mr_n55979280)
print v(xbgr.mr_n55979600)
print v(xbgr.mr_n55979712)
print v(xbgr.mr_n55980032)
print v(xbgr.mr_n55980144)
print v(xbgr.mr_n55980464)
print v(xbgr.mr_n55980576)
print v(xbgr.mr_n55980896)
print v(xbgr.mr_n55981008)
print v(xbgr.mr_n55981328)
print v(xbgr.mr_n55981440)
print v(xbgr.mr_n55981760)
print v(xbgr.mr_n55981872)
print v(xbgr.mr_n55982192)
print v(xbgr.mr_n55982304)
print v(xbgr.mr_n55982624)
print v(xbgr.mr_n55982736)
print v(xbgr.mr_n55983056)
print v(xbgr.mr_n55983168)
print v(xbgr.mr_n55983488)
print v(xbgr.mr_n55983600)
print v(xbgr.mr_n55983920)
print v(xbgr.mr_n55984032)
print v(xbgr.mr_n55984352)
print v(xbgr.mr_n55984464)
print v(xbgr.mr_n55984784)
print v(xbgr.mr_n55984896)
print v(xbgr.mr_n55985216)
print v(xbgr.mr_n55985328)
print v(xbgr.mr_n55985648)
print v(xbgr.mr_n55985760)
print v(xbgr.mr_n55986080)
print v(xbgr.mr_n55986192)
print v(xbgr.mr_n55986512)
print v(xbgr.mr_n55986624)
print v(xbgr.mr_n55986944)
print v(xbgr.mr_n55987056)
print v(xbgr.mr_n55987376)
print v(xbgr.mr_n55987488)
print v(xbgr.mr_n55987808)
print v(xbgr.mr_n55987920)
print v(xbgr.mr_n55988240)
print v(xbgr.mr_n55988352)
print v(xbgr.mr_n55988672)
print v(xbgr.mr_n55988784)
print v(xbgr.mr_n55989104)
print v(xbgr.mr_n55989216)
print v(xbgr.mr_n55989536)
print v(xbgr.mr_n55989648)
print v(xbgr.mr_n55989968)
print v(xbgr.mr_n55990080)
print v(xbgr.mr_n55990400)
print v(xbgr.mr_n55990512)
print v(xbgr.mr_n55990832)
print v(xbgr.mr_n55990944)
print v(xbgr.mr_n55991264)
print v(xbgr.mr_n55991376)
print v(xbgr.mr_n55991696)
print v(xbgr.mr_n55991808)
print v(xbgr.mr_n55992128)
print v(xbgr.mr_n55992240)
print v(xbgr.mr_n55992560)
print v(xbgr.mr_n55992672)
print v(xbgr.mr_n55992992)
print v(xbgr.mr_n55993104)
print v(xbgr.mr_n55993424)
print v(xbgr.mr_n55993536)
print v(xbgr.mr_n55993856)
print v(xbgr.mr_n55993968)
print v(xbgr.mr_n55994288)
print v(xbgr.mr_n55994400)
print v(xbgr.mr_n55994720)
print v(xbgr.mr_n55994832)
print v(xbgr.mr_n55995152)
print v(xbgr.mr_n55995264)
print v(xbgr.mr_n55995584)
print v(xbgr.mr_n55995696)
print v(xbgr.mr_n55996128)
print v(xbgr.mr_n55996560)
print v(xbgr.mr_n55996992)
print v(xbgr.mr_n55997424)
print v(xbgr.mr_n55997856)
print v(xbgr.mr_n55998288)
print v(xbgr.mr_n55998720)
print v(xbgr.mr_n55999152)
print v(xbgr.mr_n55999584)
print v(xbgr.mr_n56000016)
print v(xbgr.mr_n56000448)
print v(xbgr.mr_n56000880)
print v(xbgr.mr_n56001312)
print v(xbgr.mr_n56001744)
print v(xbgr.mr_n56002176)
print v(xbgr.mr_n56002608)
print v(xbgr.mr_n56003040)
print v(xbgr.mr_n56003472)
print v(xbgr.mr_n56003904)
print v(xbgr.mr_n56004336)
print v(xbgr.mr_n56004768)
print v(xbgr.mr_n56005200)
print v(xbgr.mr_n56005632)
print v(xbgr.mr_n56006064)
print v(xbgr.mr_n56006496)
print v(xbgr.mr_n56006928)
print v(xbgr.mr_n56007360)
print v(xbgr.mr_n56007792)
print v(xbgr.mr_n56008224)
print v(xbgr.mr_n56008656)
print v(xbgr.mr_n56009088)
print v(xbgr.mr_n56009520)
print v(xbgr.mr_n56009952)
print v(xbgr.mr_n56010384)
print v(xbgr.mr_n56010816)
print v(xbgr.mr_n56011248)
print v(xbgr.mr_n56011680)
print v(xbgr.mr_n56012112)
print v(xbgr.mr_n56012544)
print v(xbgr.mr_n56012976)
print v(xbgr.mr_n56013408)
print v(xbgr.mr_n56013840)
print v(xbgr.mr_n56014272)
print v(xbgr.mr_n56014704)
print v(xbgr.mr_n56015136)
print v(xbgr.mr_n56015568)
print v(xbgr.mr_n56016000)
print v(xbgr.mr_n56016432)
print v(xbgr.mr_n56016864)
print v(xbgr.mr_n56017296)
print v(xbgr.mr_n56017728)
print v(xbgr.mr_n56018160)
print v(xbgr.mr_n56018592)
print v(xbgr.mr_n56019024)
print v(xbgr.mr_n56019456)
print v(xbgr.mr_n56019888)
print v(xbgr.mr_n56020320)
print v(xbgr.mr_n56020752)
print v(xbgr.mr_n56021184)
print v(xbgr.mr_n56021616)
print v(xbgr.mr_n56022048)
print v(xbgr.mr_n56022480)
print v(xbgr.mr_n56022912)
print v(xbgr.mr_n56023344)
print v(xbgr.mr_n56023776)
print v(xbgr.mr_n56024208)
print v(xbgr.mr_n56024640)
print v(xbgr.mr_n56025072)
print v(xbgr.mr_n56025504)
print v(xbgr.mr_n56025936)
print v(xbgr.mr_n56026368)
print v(xbgr.mr_n56026800)
print v(xbgr.mr_n56027232)
print v(xbgr.mr_n56027664)
print v(xbgr.mr_n56028096)
print v(xbgr.mr_n56028528)
print v(xbgr.mr_n56028960)
print v(xbgr.mr_n56029392)
print v(xbgr.mr_n56029824)
print v(xbgr.mr_n56030256)
print v(xbgr.mr_n56030576)
print v(xbgr.mr_n56030688)
print v(xbgr.mr_n56031120)
print v(xbgr.mr_n56031440)
print v(xbgr.mr_n56031552)
print v(xbgr.mr_n56031872)
print v(xbgr.mr_n56031984)
print v(xbgr.mr_n56032304)
print v(xbgr.mr_n56032416)
print v(xbgr.mr_n56032736)
print v(xbgr.mr_n56032848)
print v(xbgr.mr_n56033168)
print v(xbgr.mr_n56033280)
print v(xbgr.mr_n56033600)
print v(xbgr.mr_n56033712)
print v(xbgr.mr_n56034032)
print v(xbgr.mr_n56034144)
print v(xbgr.mr_n56034464)
print v(xbgr.mr_n56034576)
print v(xbgr.mr_n56034896)
print v(xbgr.mr_n56035008)
print v(xbgr.mr_n56035328)
print v(xbgr.mr_n56035440)
print v(xbgr.mr_n56035872)
print v(xbgr.mr_n56036304)
print v(xbgr.mr_n56036736)
print v(xbgr.mr_n56037168)
print v(xbgr.mr_n56037600)
print v(xbgr.mr_n56038032)
print v(xbgr.mr_n56038464)
print v(xbgr.mr_n56038896)
print v(xbgr.mr_n56039328)
print v(xbgr.mr_n56039760)
print v(xbgr.mr_n56040192)
print v(xbgr.mr_n56040624)
print v(xbgr.mr_n56041056)
print v(xbgr.mr_n56041488)
print v(xbgr.mr_n56041920)
print v(xbgr.mr_n56042352)
print v(xbgr.mr_n56042784)
print v(xbgr.mr_n56043216)
print v(xbgr.mr_n56043648)
print v(xbgr.mr_n56044080)
print v(xbgr.mr_n56044512)
print v(xbgr.mr_n56044944)
print v(xbgr.mr_n56045376)
print v(xbgr.mr_n56045808)
print v(xbgr.mr_n56046240)
print v(xbgr.mr_n56046672)
print v(xbgr.mr_n56047104)
print v(xbgr.mr_n56047376)
print v(xbgr.mr_n56047488)
print v(xbgr.mr_n56047808)
print v(xbgr.mr_n56047920)
print v(xbgr.mr_n56048240)
print v(xbgr.mr_n56048352)
print v(xbgr.mr_n56048672)
print v(xbgr.mr_n56048784)
print v(xbgr.mr_n56049104)
print v(xbgr.mr_n56049216)
print v(xbgr.mr_n56049536)
print v(xbgr.mr_n56049648)
print v(xbgr.mr_n56049968)
print v(xbgr.mr_n56050080)
print v(xbgr.mr_n56050400)
print v(xbgr.mr_n56050512)
print v(xbgr.mr_n56050832)
print v(xbgr.mr_n56050944)
print v(xbgr.mr_n56051264)
print v(xbgr.mr_n56051376)
print v(xbgr.mr_n56051696)
print v(xbgr.mr_n56051808)
print v(xbgr.mr_n56052128)
print v(xbgr.mr_n56052240)
print v(xbgr.mr_n56052560)
print v(xbgr.mr_n56052672)
print v(xbgr.mr_n56052992)
print v(xbgr.mr_n56053104)
print v(xbgr.mr_n56053424)
print v(xbgr.mr_n56053536)
print v(xbgr.mr_n56053856)
print v(xbgr.mr_n56053968)
print v(xbgr.mr_n56054288)
print v(xbgr.mr_n56054400)
print v(xbgr.mr_n56054720)
print v(xbgr.mr_n56054832)
print v(xbgr.mr_n56055152)
print v(xbgr.mr_n56055264)
print v(xbgr.mr_n56055584)
print v(xbgr.mr_n56055696)
print v(xbgr.mr_n56056016)
print v(xbgr.mr_n56056128)
print v(xbgr.mr_n56056448)
print v(xbgr.mr_n56056560)
print v(xbgr.mr_n56056880)
print v(xbgr.mr_n56056992)
print v(xbgr.mr_n56057312)
print v(xbgr.mr_n56057424)
print v(xbgr.mr_n56057744)
print v(xbgr.mr_n56057856)
print v(xbgr.mr_n56058176)
print v(xbgr.mr_n56058288)
print v(xbgr.mr_n56058608)
print v(xbgr.mr_n56058720)
print v(xbgr.mr_n56059040)
print v(xbgr.mr_n56059152)
print v(xbgr.mr_n56059472)
print v(xbgr.mr_n56059584)
print v(xbgr.mr_n56059904)
print v(xbgr.mr_n56060016)
print v(xbgr.mr_n56060336)
print v(xbgr.mr_n56060448)
print v(xbgr.mr_n56060768)
print v(xbgr.mr_n56060880)
print v(xbgr.mr_n56061200)
print v(xbgr.mr_n56061312)
print v(xbgr.mr_n56061632)
print v(xbgr.mr_n56061744)
print v(xbgr.mr_n56062064)
print v(xbgr.mr_n56062176)
print v(xbgr.mr_n56062496)
print v(xbgr.mr_n56062608)
print v(xbgr.mr_n56062928)
print v(xbgr.mr_n56063040)
print v(xbgr.mr_n56063360)
print v(xbgr.mr_n56063472)
print v(xbgr.mr_n56063792)
print v(xbgr.mr_n56063904)
print v(xbgr.mr_n56064224)
print v(xbgr.mr_n56064336)
print v(xbgr.mr_n56064656)
print v(xbgr.mr_n56064768)
print v(xbgr.mr_n56065088)
print v(xbgr.mr_n56065200)
print v(xbgr.mr_n56065520)
print v(xbgr.mr_n56065632)
print v(xbgr.mr_n56065952)
print v(xbgr.mr_n56066064)
print v(xbgr.mr_n56066384)
print v(xbgr.mr_n56066496)
print v(xbgr.mr_n56066816)
print v(xbgr.mr_n56066928)
print v(xbgr.mr_n56067248)
print v(xbgr.mr_n56067360)
print v(xbgr.mr_n56067680)
print v(xbgr.mr_n56067792)
print v(xbgr.mr_n56068112)
print v(xbgr.mr_n56068224)
print v(xbgr.mr_n56068544)
print v(xbgr.mr_n56068656)
print v(xbgr.mr_n56068976)
print v(xbgr.mr_n56069088)
print v(xbgr.mr_n56069408)
print v(xbgr.mr_n56069520)
print v(xbgr.mr_n56069840)
print v(xbgr.mr_n56069952)
print v(xbgr.mr_n56070272)
print v(xbgr.mr_n56070384)
print v(xbgr.mr_n56070704)
print v(xbgr.mr_n56070816)
print v(xbgr.mr_n56071136)
print v(xbgr.mr_n56071248)
print v(xbgr.mr_n56071568)
print v(xbgr.mr_n56071680)
print v(xbgr.mr_n56072000)
print v(xbgr.mr_n56072112)
print v(xbgr.mr_n56072432)
print v(xbgr.mr_n56072544)
print v(xbgr.mr_n56072864)
print v(xbgr.mr_n56072976)
print v(xbgr.mr_n56073296)
print v(xbgr.mr_n56073408)
print v(xbgr.mr_n56073728)
print v(xbgr.mr_n56073840)
print v(xbgr.mr_n56074160)
print v(xbgr.mr_n56074272)
print v(xbgr.mr_n56074592)
print v(xbgr.mr_n56074704)
print v(xbgr.mr_n56075024)
print v(xbgr.mr_n56075136)
print v(xbgr.mr_n56075456)
print v(xbgr.mr_n56075568)
print v(xbgr.mr_n56075888)
print v(xbgr.mr_n56076000)
print v(xbgr.mr_n56076320)
print v(xbgr.mr_n56076432)
print v(xbgr.mr_n56076752)
print v(xbgr.mr_n56076864)
print v(xbgr.mr_n56077184)
print v(xbgr.mr_n56077296)
print v(xbgr.mr_n56077616)
print v(xbgr.mr_n56077728)
print v(xbgr.mr_n56078048)
print v(xbgr.mr_n56078160)
print v(xbgr.mr_n56078480)
print v(xbgr.mr_n56078592)
print v(xbgr.mr_n56078912)
print v(xbgr.mr_n56079024)
print v(xbgr.mr_n56079344)
print v(xbgr.mr_n56079456)
print v(xbgr.mr_n56079776)
print v(xbgr.mr_n56079888)
print v(xbgr.mr_n56080208)
print v(xbgr.mr_n56080320)
print v(xbgr.mr_n56080640)
print v(xbgr.mr_n56080752)
print v(xbgr.mr_n56081072)
print v(xbgr.mr_n56081184)
print v(xbgr.mr_n56081504)
print v(xbgr.mr_n56081616)
print v(xbgr.mr_n56081936)
print v(xbgr.mr_n56082048)
print v(xbgr.mr_n56082368)
print v(xbgr.mr_n56082480)
print v(xbgr.mr_n56082800)
print v(xbgr.mr_n56082912)
print v(xbgr.mr_n56083232)
print v(xbgr.mr_n56083344)
print v(xbgr.mr_n56083664)
print v(xbgr.mr_n56083776)
print v(xbgr.mr_n56084096)
print v(xbgr.mr_n56084208)
print v(xbgr.mr_n56084528)
print v(xbgr.mr_n56084640)
print v(xbgr.mr_n56084960)
print v(xbgr.mr_n56085072)
print v(xbgr.mr_n56085392)
print v(xbgr.mr_n56085504)
print v(xbgr.mr_n56085824)
print v(xbgr.mr_n56085936)
print v(xbgr.mr_n56086256)
print v(xbgr.mr_n56086368)
print v(xbgr.mr_n56086688)
print v(xbgr.mr_n56086800)
print v(xbgr.mr_n56087120)
print v(xbgr.mr_n56087232)
print v(xbgr.mr_n56087552)
print v(xbgr.mr_n56087664)
print v(xbgr.mr_n56087984)
print v(xbgr.mr_n56088096)
print v(xbgr.mr_n56088416)
print v(xbgr.mr_n56088528)
print v(xbgr.mr_n56088848)
print v(xbgr.mr_n56088960)
print v(xbgr.mr_n56089280)
print v(xbgr.mr_n56089392)
print v(xbgr.mr_n56089712)
print v(xbgr.mr_n56089824)
print v(xbgr.mr_n56090144)
print v(xbgr.mr_n56090256)
print v(xbgr.mr_n56090576)
print v(xbgr.mr_n56090688)
print v(xbgr.mr_n56091008)
print v(xbgr.mr_n56091120)
print v(xbgr.mr_n56091440)
print v(xbgr.mr_n56091552)
print v(xbgr.mr_n56091872)
print v(xbgr.mr_n56091984)
print v(xbgr.mr_n56092304)
print v(xbgr.mr_n56092416)
print v(xbgr.mr_n56092736)
print v(xbgr.mr_n56092848)
print v(xbgr.mr_n56093168)
print v(xbgr.mr_n56093280)
print v(xbgr.mr_n56093600)
print v(xbgr.mr_n56093712)
print v(xbgr.mr_n56094032)
print v(xbgr.mr_n56094144)
print v(xbgr.mr_n56094464)
print v(xbgr.mr_n56094576)
print v(xbgr.mr_n56094896)
print v(xbgr.mr_n56095008)
print v(xbgr.mr_n56095328)
print v(xbgr.mr_n56095440)
print v(xbgr.mr_n56095760)
print v(xbgr.mr_n56095872)
print v(xbgr.mr_n56096192)
print v(xbgr.mr_n56096304)
print v(xbgr.mr_n56096624)
print v(xbgr.mr_n56096736)
print v(xbgr.mr_n56097056)
print v(xbgr.mr_n56097168)
print v(xbgr.mr_n56097488)
print v(xbgr.mr_n56097600)
print v(xbgr.mr_n56097920)
print v(xbgr.mr_n56098032)
print v(xbgr.mr_n56098352)
print v(xbgr.mr_n56098464)
print v(xbgr.mr_n56098784)
print v(xbgr.mr_n56098896)
print v(xbgr.mr_n56099216)
print v(xbgr.mr_n56099328)
print v(xbgr.mr_n56099648)
print v(xbgr.mr_n56099760)
print v(xbgr.mr_n56100080)
print v(xbgr.mr_n56100192)
print v(xbgr.mr_n56100512)
print v(xbgr.mr_n56100624)
print v(xbgr.mr_n56100944)
print v(xbgr.mr_n56101056)
print v(xbgr.mr_n56101376)
print v(xbgr.mr_n56101488)
print v(xbgr.mr_n56101808)
print v(xbgr.mr_n56101920)
print v(xbgr.mr_n56102240)
print v(xbgr.mr_n56102352)
print v(xbgr.mr_n56102672)
print v(xbgr.mr_n56102784)
print v(xbgr.mr_n56103104)
print v(xbgr.mr_n56103216)
print v(xbgr.mr_n56103536)
print v(xbgr.mr_n56103648)
print v(xbgr.mr_n56103968)
print v(xbgr.mr_n56104080)
print v(xbgr.mr_n56104400)
print v(xbgr.mr_n56104512)
print v(xbgr.mr_n56104832)
print v(xbgr.mr_n56104944)
print v(xbgr.mr_n56105264)
print v(xbgr.mr_n56105376)
print v(xbgr.mr_n56105696)
print v(xbgr.mr_n56105808)
print v(xbgr.mr_n56106128)
print v(xbgr.mr_n56106240)
print v(xbgr.mr_n56106560)
print v(xbgr.mr_n56106672)
print v(xbgr.mr_n56106992)
print v(xbgr.mr_n56107104)
print v(xbgr.mr_n56107424)
print v(xbgr.mr_n56107536)
print v(xbgr.mr_n56107856)
print v(xbgr.mr_n56107968)
print v(xbgr.mr_n56108288)
print v(xbgr.mr_n56108400)
print v(xbgr.mr_n56108720)
print v(xbgr.mr_n56108832)
print v(xbgr.mr_n56109152)
print v(xbgr.mr_n56109264)
print v(xbgr.mr_n56109584)
print v(xbgr.mr_n56109696)
print v(xbgr.mr_n56110016)
print v(xbgr.mr_n56110128)
print v(xbgr.mr_n56110448)
print v(xbgr.mr_n56110560)
print v(xbgr.mr_n56110880)
print v(xbgr.mr_n56110992)
print v(xbgr.mr_n56111312)
print v(xbgr.mr_n56111424)
print v(xbgr.mr_n56111744)
print v(xbgr.mr_n56111856)
print v(xbgr.mr_n56112176)
print v(xbgr.mr_n56112288)
print v(xbgr.mr_n56112608)
print v(xbgr.mr_n56112720)
print v(xbgr.mr_n56113040)
print v(xbgr.mr_n56113152)
print v(xbgr.mr_n56113472)
print v(xbgr.mr_n56113584)
print v(xbgr.mr_n56113904)
print v(xbgr.mr_n56114016)
print v(xbgr.mr_n56114336)
print v(xbgr.mr_n56114448)
print v(xbgr.mr_n56114768)
print v(xbgr.mr_n56114880)
print v(xbgr.mr_n56115200)
print v(xbgr.mr_n56115312)
print v(xbgr.mr_n56115632)
print v(xbgr.mr_n56115744)
print v(xbgr.mr_n56116064)
print v(xbgr.mr_n56116176)
print v(xbgr.mr_n56116496)
print v(xbgr.mr_n56116608)
print v(xbgr.mr_n56116928)
print v(xbgr.mr_n56117040)
print v(xbgr.mr_n56117360)
print v(xbgr.mr_n56117472)
print v(xbgr.mr_n56117792)
print v(xbgr.mr_n56117904)
print v(xbgr.mr_n56118224)
print v(xbgr.mr_n56118336)
print v(xbgr.mr_n56118656)
print v(xbgr.mr_n56118768)
print v(xbgr.mr_n56119088)
print v(xbgr.mr_n56119200)
print v(xbgr.mr_n56119520)
print v(xbgr.mr_n56119632)
print v(xbgr.mr_n56119952)
print v(xbgr.mr_n56120064)
print v(xbgr.mr_n56120384)
print v(xbgr.mr_n56120496)
print v(xbgr.mr_n56120816)
print v(xbgr.mr_n56120928)
print v(xbgr.mr_n56121248)
print v(xbgr.mr_n56121360)
print v(xbgr.mr_n56121680)
print v(xbgr.mr_n56121792)
print v(xbgr.mr_n56122112)
print v(xbgr.mr_n56122224)
print v(xbgr.mr_n56122544)
print v(xbgr.mr_n56122656)
print v(xbgr.mr_n56122976)
print v(xbgr.mr_n56123088)
print v(xbgr.mr_n56123408)
print v(xbgr.mr_n56123520)
print v(xbgr.mr_n56123840)
print v(xbgr.mr_n56123952)
print v(xbgr.mr_n56124272)
print v(xbgr.mr_n56124384)
print v(xbgr.mr_n56124704)
print v(xbgr.mr_n56124816)
print v(xbgr.mr_n56125136)
print v(xbgr.mr_n56125248)
print v(xbgr.mr_n56125568)
print v(xbgr.mr_n56125680)
print v(xbgr.mr_n56126000)
print v(xbgr.mr_n56126112)
print v(xbgr.mr_n56126432)
print v(xbgr.mr_n56126544)
print v(xbgr.mr_n56126864)
print v(xbgr.mr_n56126976)
print v(xbgr.mr_n56127296)
print v(xbgr.mr_n56127408)
print v(xbgr.mr_n56127728)
print v(xbgr.mr_n56127840)
print v(xbgr.mr_n56128160)
print v(xbgr.mr_n56128272)
print v(xbgr.mr_n56128592)
print v(xbgr.mr_n56128704)
print v(xbgr.mr_n56129024)
print v(xbgr.mr_n56129136)
print v(xbgr.mr_n56129456)
print v(xbgr.mr_n56129568)
print v(xbgr.mr_n56129888)
print v(xbgr.mr_n56130000)
print v(xbgr.mr_n56130320)
print v(xbgr.mr_n56130432)
print v(xbgr.mr_n56130752)
print v(xbgr.mr_n56130864)
print v(xbgr.mr_n56131184)
print v(xbgr.mr_n56131296)
print v(xbgr.mr_n56131616)
print v(xbgr.mr_n56131728)
print v(xbgr.mr_n56132160)
print v(xbgr.mr_n56132480)
print v(xbgr.mr_n56132592)
print v(xbgr.mr_n56132912)
print v(xbgr.mr_n56133024)
print v(xbgr.mr_n56133344)
print v(xbgr.mr_n56133456)
print v(xbgr.mr_n56133888)
print v(xbgr.mr_n56134208)
print v(xbgr.mr_n56134320)
print v(xbgr.mr_n56134640)
print v(xbgr.mr_n56134752)
print v(xbgr.mr_n56135072)
print v(xbgr.mr_n56135184)
print v(xbgr.mr_n56135616)
print v(xbgr.mr_n56135936)
print v(xbgr.mr_n56136048)
print v(xbgr.mr_n56136368)
print v(xbgr.mr_n56136480)
print v(xbgr.mr_n56136800)
print v(xbgr.mr_n56136912)
print v(xbgr.mr_n56137344)
print v(xbgr.mr_n56137664)
print v(xbgr.mr_n56137776)
print v(xbgr.mr_n56138096)
print v(xbgr.mr_n56138208)
print v(xbgr.mr_n56138528)
print v(xbgr.mr_n56138640)
print v(xbgr.mr_n56139072)
print v(xbgr.mr_n56139392)
print v(xbgr.mr_n56139504)
print v(xbgr.mr_n56139824)
print v(xbgr.mr_n56139936)
print v(xbgr.mr_n56140256)
print v(xbgr.mr_n56140368)
print v(xbgr.mr_n56140800)
print v(xbgr.mr_n56141120)
print v(xbgr.mr_n56141232)
print v(xbgr.mr_n56141552)
print v(xbgr.mr_n56141664)
print v(xbgr.mr_n56141984)
print v(xbgr.mr_n56142096)
print v(xbgr.mr_n56142528)
print v(xbgr.mr_n56142848)
print v(xbgr.mr_n56142960)
print v(xbgr.mr_n56143280)
print v(xbgr.mr_n56143392)
print v(xbgr.mr_n56143712)
print v(xbgr.mr_n56143824)
print v(xbgr.mr_n56144256)
print v(xbgr.mr_n56144576)
print v(xbgr.mr_n56144688)
print v(xbgr.mr_n56145008)
print v(xbgr.mr_n56145120)
print v(xbgr.mr_n56145440)
print v(xbgr.mr_n56145552)
print v(xbgr.mr_n56145872)
print v(xbgr.mr_n56145984)
print v(xbgr.mr_n56146304)
print v(xbgr.mr_n56146416)
print v(xbgr.mr_n56146736)
print v(xbgr.mr_n56146848)
print v(xbgr.mr_n56147168)
print v(xbgr.mr_n56147280)
print v(xbgr.mr_n56147600)
print v(xbgr.mr_n56147712)
print v(xbgr.mr_n56148032)
print v(xbgr.mr_n56148144)
print v(xbgr.mr_n56148464)
print v(xbgr.mr_n56148576)
print v(xbgr.mr_n56148896)
print v(xbgr.mr_n56149008)
print v(xbgr.mr_n56149328)
print v(xbgr.mr_n56149440)
print v(xbgr.mr_n56149760)
print v(xbgr.mr_n56149872)
print v(xbgr.mr_n56150192)
print v(xbgr.mr_n56150304)
print v(xbgr.mr_n56150624)
print v(xbgr.mr_n56150736)
print v(xbgr.mr_n56151056)
print v(xbgr.mr_n56151168)
print v(xbgr.mr_n56151488)
print v(xbgr.mr_n56151600)
print v(xbgr.mr_n56151920)
print v(xbgr.mr_n56152032)
print v(xbgr.mr_n56152352)
print v(xbgr.mr_n56152464)
print v(xbgr.mr_n56152784)
print v(xbgr.mr_n56152896)
print v(xbgr.mr_n56153216)
print v(xbgr.mr_n56153328)
print v(xbgr.mr_n56153648)
print v(xbgr.mr_n56153760)
print v(xbgr.mr_n56154080)
print v(xbgr.mr_n56154192)
print v(xbgr.mr_n56154512)
print v(xbgr.mr_n56154624)
print v(xbgr.mr_n56154944)
print v(xbgr.mr_n56155056)
print v(xbgr.mr_n56155376)
print v(xbgr.mr_n56155488)
print v(xbgr.mr_n56155808)
print v(xbgr.mr_n56155920)
print v(xbgr.mr_n56156240)
print v(xbgr.mr_n56156352)
print v(xbgr.mr_n56156672)
print v(xbgr.mr_n56156784)
print v(xbgr.mr_n56157104)
print v(xbgr.mr_n56157216)
print v(xbgr.mr_n56157536)
print v(xbgr.mr_n56157648)
print v(xbgr.mr_n56157968)
print v(xbgr.mr_n56158080)
print v(xbgr.mr_n56158400)
print v(xbgr.mr_n56158512)
print v(xbgr.mr_n56158832)
print v(xbgr.mr_n56158944)
print v(xbgr.mr_n56159264)
print v(xbgr.mr_n56159376)
print v(xbgr.mr_n56159696)
print v(xbgr.mr_n56159808)
print v(xbgr.mr_n56160128)
print v(xbgr.mr_n56160240)
print v(xbgr.mr_n56160560)
print v(xbgr.mr_n56160672)
print v(xbgr.mr_n56160992)
print v(xbgr.mr_n56161104)
print v(xbgr.mr_n56161424)
print v(xbgr.mr_n56161536)
print v(xbgr.mr_n56161856)
print v(xbgr.mr_n56161968)
print v(xbgr.mr_n56162288)
print v(xbgr.mr_n56162400)
print v(xbgr.mr_n56162720)
print v(xbgr.mr_n56162832)
print v(xbgr.mr_n56163152)
print v(xbgr.mr_n56163264)
print v(xbgr.mr_n56163584)
print v(xbgr.mr_n56163696)
print v(xbgr.mr_n56164016)
print v(xbgr.mr_n56164128)
print v(xbgr.mr_n56164448)
print v(xbgr.mr_n56164560)
print v(xbgr.mr_n56164880)
print v(xbgr.mr_n56164992)
print v(xbgr.mr_n56165312)
print v(xbgr.mr_n56165424)
print v(xbgr.mr_n56165744)
print v(xbgr.mr_n56165856)
print v(xbgr.mr_n56166176)
print v(xbgr.mr_n56166288)
print v(xbgr.mr_n56166608)
print v(xbgr.mr_n56166720)
print v(xbgr.mr_n56167040)
print v(xbgr.mr_n56167152)
print v(xbgr.mr_n56167472)
print v(xbgr.mr_n56167584)
print v(xbgr.mr_n56167904)
print v(xbgr.mr_n56168016)
print v(xbgr.mr_n56168336)
print v(xbgr.mr_n56168448)
print v(xbgr.mr_n56168768)
print v(xbgr.mr_n56168880)
print v(xbgr.mr_n56169200)
print v(xbgr.mr_n56169312)
print v(xbgr.mr_n56169632)
print v(xbgr.mr_n56169744)
print v(xbgr.mr_n56170064)
print v(xbgr.mr_n56170176)
print v(xbgr.mr_n56170496)
print v(xbgr.mr_n56170608)
print v(xbgr.mr_n56170928)
print v(xbgr.mr_n56171040)
print v(xbgr.mr_n56171360)
print v(xbgr.mr_n56171472)
print v(xbgr.mr_n56171792)
print v(xbgr.mr_n56171904)
print v(xbgr.mr_n56172224)
print v(xbgr.mr_n56172336)
print v(xbgr.mr_n56172656)
print v(xbgr.mr_n56172768)
print v(xbgr.mr_n56173088)
print v(xbgr.mr_n56173200)
print v(xbgr.mr_n56173520)
print v(xbgr.mr_n56173632)
print v(xbgr.mr_n56173952)
print v(xbgr.mr_n56174064)
print v(xbgr.mr_n56174496)
print v(xbgr.mr_n56174816)
print v(xbgr.mr_n56174928)
print v(xbgr.mr_n56175248)
print v(xbgr.mr_n56175360)
print v(xbgr.mr_n56175680)
print v(xbgr.mr_n56175792)
print v(xbgr.mr_n56176224)
print v(xbgr.mr_n56176544)
print v(xbgr.mr_n56176656)
print v(xbgr.mr_n56176976)
print v(xbgr.mr_n56177088)
print v(xbgr.mr_n56177408)
print v(xbgr.mr_n56177520)
print v(xbgr.mr_n56177952)
print v(xbgr.mr_n56178272)
print v(xbgr.mr_n56178384)
print v(xbgr.mr_n56178704)
print v(xbgr.mr_n56178816)
print v(xbgr.mr_n56179136)
print v(xbgr.mr_n56179248)
print v(xbgr.mr_n56179568)
print v(xbgr.mr_n56179680)
print v(xbgr.mr_n56180000)
print v(xbgr.mr_n56180112)
print v(xbgr.mr_n56180432)
print v(xbgr.mr_n56180544)
print v(xbgr.mr_n56180864)
print v(xbgr.mr_n56180976)
print v(xbgr.mr_n56181296)
print v(xbgr.mr_n56181408)
print v(xbgr.mr_n56181728)
print v(xbgr.mr_n56181840)
print v(xbgr.mr_n56182272)
print v(xbgr.mr_n56182592)
print v(xbgr.mr_n56182704)
print v(xbgr.mr_n56183136)
print v(xbgr.mr_n56183456)
print v(xbgr.mr_n56183568)
print v(xbgr.mr_n56184000)
print v(xbgr.mr_n56184320)
print v(xbgr.mr_n56184432)
print v(xbgr.mr_n56184752)
print v(xbgr.mr_n56184864)
print v(xbgr.mr_n56185184)
print v(xbgr.mr_n56185296)
print v(xbgr.mr_n56185728)
print v(xbgr.mr_n56186048)
print v(xbgr.mr_n56186160)
print v(xbgr.mr_n56186480)
print v(xbgr.mr_n56186592)
print v(xbgr.mr_n56186912)
print v(xbgr.mr_n56187024)
print v(xbgr.mr_n56187344)
print v(xbgr.mr_n56187456)
print v(xbgr.mr_n56187776)
print v(xbgr.mr_n56187888)
print v(xbgr.mr_n56188320)
print v(xbgr.mr_n56188640)
print v(xbgr.mr_n56188752)
print v(xbgr.mr_n56189072)
print v(xbgr.mr_n56189184)
print v(xbgr.mr_n56189504)
print v(xbgr.mr_n56189616)
print v(xbgr.mr_n56189936)
print v(xbgr.mr_n56190048)
print v(xbgr.mr_n56190368)
print v(xbgr.mr_n56190480)
print v(xbgr.mr_n56190800)
print v(xbgr.mr_n56190912)
print v(xbgr.mr_n56191232)
print v(xbgr.mr_n56191344)
print v(xbgr.mr_n56191664)
print v(xbgr.mr_n56191776)
print v(xbgr.mr_n56192096)
print v(xbgr.mr_n56192208)
print v(xbgr.mr_n56192528)
print v(xbgr.mr_n56192640)
print v(xbgr.mr_n56192960)
print v(xbgr.mr_n56193072)
print v(xbgr.mr_n56193392)
print v(xbgr.mr_n56193504)
print v(xbgr.mr_n56193824)
print v(xbgr.mr_n56193936)
print v(xbgr.mr_n56194256)
print v(xbgr.mr_n56194368)
print v(xbgr.mr_n56194688)
print v(xbgr.mr_n56194800)
print v(xbgr.mr_n56195120)
print v(xbgr.mr_n56195232)
print v(xbgr.mr_n56195552)
print v(xbgr.mr_n56195664)
print v(xbgr.mr_n56195984)
print v(xbgr.mr_n56196096)
print v(xbgr.mr_n56196416)
print v(xbgr.mr_n56196528)
print v(xbgr.mr_n56196848)
print v(xbgr.mr_n56196960)
print v(xbgr.mr_n56197280)
print v(xbgr.mr_n56197392)
print v(xbgr.mr_n56197712)
print v(xbgr.mr_n56197824)
print v(xbgr.mr_n56198144)
print v(xbgr.mr_n56198256)
print v(xbgr.mr_n56198576)
print v(xbgr.mr_n56198688)
print v(xbgr.mr_n56199008)
print v(xbgr.mr_n56199120)
print v(xbgr.mr_n56199440)
print v(xbgr.mr_n56199552)
print v(xbgr.mr_n56199872)
print v(xbgr.mr_n56199984)
print v(xbgr.mr_n56200304)
print v(xbgr.mr_n56200416)
print v(xbgr.mr_n56200736)
print v(xbgr.mr_n56200848)
print v(xbgr.mr_n56201168)
print v(xbgr.mr_n56201280)
print v(xbgr.mr_n56201600)
print v(xbgr.mr_n56201712)
print v(xbgr.mr_n56202032)
print v(xbgr.mr_n56202144)
print v(xbgr.mr_n56202464)
print v(xbgr.mr_n56202576)
print v(xbgr.mr_n56202896)
print v(xbgr.mr_n56203008)
print v(xbgr.mr_n56203328)
print v(xbgr.mr_n56203440)
print v(xbgr.mr_n56203760)
print v(xbgr.mr_n56203872)
print v(xbgr.mr_n56204192)
print v(xbgr.mr_n56204304)
print v(xbgr.mr_n56204624)
print v(xbgr.mr_n56204736)
print v(xbgr.mr_n56205056)
print v(xbgr.mr_n56205168)
print v(xbgr.mr_n56205488)
print v(xbgr.mr_n56205600)
print v(xbgr.mr_n56205920)
print v(xbgr.mr_n56206032)
print v(xbgr.mr_n56206352)
print v(xbgr.mr_n56206464)
print v(xbgr.mr_n56206784)
print v(xbgr.mr_n56206896)
print v(xbgr.mr_n56207216)
print v(xbgr.mr_n56207328)
print v(xbgr.mr_n56207648)
print v(xbgr.mr_n56207760)
print v(xbgr.mr_n56208080)
print v(xbgr.mr_n56208192)
print v(xbgr.mr_n56208512)
print v(xbgr.mr_n56208624)
print v(xbgr.mr_n56208944)
print v(xbgr.mr_n56209056)
print v(xbgr.mr_n56209376)
print v(xbgr.mr_n56209488)
print v(xbgr.mr_n56209808)
print v(xbgr.mr_n56209920)
print v(xbgr.mr_n56210240)
print v(xbgr.mr_n56210352)
print v(xbgr.mr_n56210672)
print v(xbgr.mr_n56210784)
print v(xbgr.mr_n56211104)
print v(xbgr.mr_n56211216)
print v(xbgr.mr_n56211536)
print v(xbgr.mr_n56211648)
print v(xbgr.mr_n56211968)
print v(xbgr.mr_n56212080)
print v(xbgr.mr_n56212400)
print v(xbgr.mr_n56212512)
print v(xbgr.mr_n56212832)
print v(xbgr.mr_n56212944)
print v(xbgr.mr_n56213264)
print v(xbgr.mr_n56213376)
print v(xbgr.mr_n56213696)
print v(xbgr.mr_n56213808)
print v(xbgr.mr_n56214128)
print v(xbgr.mr_n56214240)
print v(xbgr.mr_n56214560)
print v(xbgr.mr_n56214672)
print v(xbgr.mr_n56214992)
print v(xbgr.mr_n56215104)
print v(xbgr.mr_n56215424)
print v(xbgr.mr_n56215536)
print v(xbgr.mr_n56215856)
print v(xbgr.mr_n56215968)
print v(xbgr.mr_n56216288)
print v(xbgr.mr_n56216400)
print v(xbgr.mr_n56216720)
print v(xbgr.mr_n56216832)
print v(xbgr.mr_n56217152)
print v(xbgr.mr_n56217264)
print v(xbgr.mr_n56217584)
print v(xbgr.mr_n56217696)
print v(xbgr.mr_n56218016)
print v(xbgr.mr_n56218128)
print v(xbgr.mr_n56218448)
print v(xbgr.mr_n56218560)
print v(xbgr.mr_n56218880)
print v(xbgr.mr_n56218992)
print v(xbgr.mr_n56219312)
print v(xbgr.mr_n56219424)
print v(xbgr.mr_n56219744)
print v(xbgr.mr_n56219856)
print v(xbgr.mr_n56220176)
print v(xbgr.mr_n56220288)
print v(xbgr.mr_n56220608)
print v(xbgr.mr_n56220720)
print v(xbgr.mr_n56221040)
print v(xbgr.mr_n56221152)
print v(xbgr.mr_n56221472)
print v(xbgr.mr_n56221584)
print v(xbgr.mr_n56221904)
print v(xbgr.mr_n56222016)
print v(xbgr.mr_n56222336)
print v(xbgr.mr_n56222448)
print v(xbgr.mr_n56222768)
print v(xbgr.mr_n56222880)
print v(xbgr.mr_n56223200)
print v(xbgr.mr_n56223312)
print v(xbgr.mr_n56223632)
print v(xbgr.mr_n56223744)
print v(xbgr.mr_n56224064)
print v(xbgr.mr_n56224176)
print v(xbgr.mr_n56224496)
print v(xbgr.mr_n56224608)
print v(xbgr.mr_n56224928)
print v(xbgr.mr_n56225040)
print v(xbgr.mr_n56225360)
print v(xbgr.mr_n56225472)
print v(xbgr.mr_n56225792)
print v(xbgr.mr_n56225904)
print v(xbgr.mr_n56226224)
print v(xbgr.mr_n56226336)
print v(xbgr.mr_n56226656)
print v(xbgr.mr_n56226768)
print v(xbgr.mr_n56227088)
print v(xbgr.mr_n56227200)
print v(xbgr.mr_n56227520)
print v(xbgr.mr_n56227632)
print v(xbgr.mr_n56227952)
print v(xbgr.mr_n56228064)
print v(xbgr.mr_n56228384)
print v(xbgr.mr_n56228496)
print v(xbgr.mr_n56228816)
print v(xbgr.mr_n56228928)
print v(xbgr.mr_n56229248)
print v(xbgr.mr_n56229360)
print v(xbgr.mr_n56229680)
print v(xbgr.mr_n56229792)
print v(xbgr.mr_n56230112)
print v(xbgr.mr_n56230224)
print v(xbgr.mr_n56230544)
print v(xbgr.mr_n56230656)
print v(xbgr.mr_n56230976)
print v(xbgr.mr_n56231088)
print v(xbgr.mr_n56231408)
print v(xbgr.mr_n56231520)
print v(xbgr.mr_n56231840)
print v(xbgr.mr_n56231952)
print v(xbgr.mr_n56232272)
print v(xbgr.mr_n56232384)
print v(xbgr.mr_n56232704)
print v(xbgr.mr_n56232816)
print v(xbgr.mr_n56233136)
print v(xbgr.mr_n56233248)
print v(xbgr.mr_n56233568)
print v(xbgr.mr_n56233680)
print v(xbgr.mr_n56234000)
print v(xbgr.mr_n56234112)
print v(xbgr.mr_n56234432)
print v(xbgr.mr_n56234544)
print v(xbgr.mr_n56234864)
print v(xbgr.mr_n56234976)
print v(xbgr.mr_n56235296)
print v(xbgr.mr_n56235408)
print v(xbgr.mr_n56235728)
print v(xbgr.mr_n56235840)
print v(xbgr.mr_n56236160)
print v(xbgr.mr_n56236272)
print v(xbgr.mr_n56236592)
print v(xbgr.mr_n56236704)
print v(xbgr.mr_n56237024)
print v(xbgr.mr_n56237136)
print v(xbgr.mr_n56237456)
print v(xbgr.mr_n56237568)
print v(xbgr.mr_n56237888)
print v(xbgr.mr_n56238000)
print v(xbgr.mr_n56238320)
print v(xbgr.mr_n56238432)
print v(xbgr.mr_n56238752)
print v(xbgr.mr_n56238864)
print v(xbgr.mr_n56239184)
print v(xbgr.mr_n56239296)
print v(xbgr.mr_n56239616)
print v(xbgr.mr_n56239728)
print v(xbgr.mr_n56240048)
print v(xbgr.mr_n56240160)
print v(xbgr.mr_n56240480)
print v(xbgr.mr_n56240592)
print v(xbgr.mr_n56240912)
print v(xbgr.mr_n56241024)
print v(xbgr.mr_n56241344)
print v(xbgr.mr_n56241456)
print v(xbgr.mr_n56241776)
print v(xbgr.mr_n56241888)
print v(xbgr.mr_n56242208)
print v(xbgr.mr_n56242320)
print v(xbgr.mr_n56242640)
print v(xbgr.mr_n56242752)
print v(xbgr.mr_n56243072)
print v(xbgr.mr_n56243184)
print v(xbgr.mr_n56243504)
print v(xbgr.mr_n56243616)
print v(xbgr.mr_n56243936)
print v(xbgr.mr_n56244048)
print v(xbgr.mr_n56244368)
print v(xbgr.mr_n56244480)
print v(xbgr.mr_n56244800)
print v(xbgr.mr_n56244912)
print v(xbgr.mr_n56245232)
print v(xbgr.mr_n56245344)
print v(xbgr.mr_n56245664)
print v(xbgr.mr_n56245776)
print v(xbgr.mr_n56246096)
print v(xbgr.mr_n56246208)
print v(xbgr.mr_n56246528)
print v(xbgr.mr_n56246640)
print v(xbgr.mr_n56246960)
print v(xbgr.mr_n56247072)
print v(xbgr.mr_n56247392)
print v(xbgr.mr_n56247504)
print v(xbgr.mr_n56247824)
print v(xbgr.mr_n56247936)
print v(xbgr.mr_n56248256)
print v(xbgr.mr_n56248368)
print v(xbgr.mr_n56248688)
print v(xbgr.mr_n56248800)
print v(xbgr.mr_n56249120)
print v(xbgr.mr_n56249232)
print v(xbgr.mr_n56249552)
print v(xbgr.mr_n56249664)
print v(xbgr.mr_n56249984)
print v(xbgr.mr_n56250096)
print v(xbgr.mr_n56250416)
print v(xbgr.mr_n56250528)
print v(xbgr.mr_n56250848)
print v(xbgr.mr_n56250960)
print v(xbgr.mr_n56251280)
print v(xbgr.mr_n56251392)
print v(xbgr.mr_n56251712)
print v(xbgr.mr_n56251824)
print v(xbgr.mr_n56252144)
print v(xbgr.mr_n56252256)
print v(xbgr.mr_n56252576)
print v(xbgr.mr_n56252688)
print v(xbgr.mr_n56253008)
print v(xbgr.mr_n56253120)
print v(xbgr.mr_n56253440)
print v(xbgr.mr_n56253552)
print v(xbgr.mr_n56253872)
print v(xbgr.mr_n56253984)
print v(xbgr.mr_n56254304)
print v(xbgr.mr_n56254416)
print v(xbgr.mr_n56254736)
print v(xbgr.mr_n56254848)
print v(xbgr.mr_n56255168)
print v(xbgr.mr_n56255280)
print v(xbgr.mr_n56255600)
print v(xbgr.mr_n56255712)
print v(xbgr.mr_n56256032)
print v(xbgr.mr_n56256144)
print v(xbgr.mr_n56256464)
print v(xbgr.mr_n56256576)
print v(xbgr.mr_n56256896)
print v(xbgr.mr_n56257008)
print v(xbgr.mr_n56257328)
print v(xbgr.mr_n56257440)
print v(xbgr.mr_n56257760)
print v(xbgr.mr_n56257872)
print v(xbgr.mr_n56258192)
print v(xbgr.mr_n56258304)
print v(xbgr.mr_n56258624)
print v(xbgr.mr_n56258736)
print v(xbgr.mr_n56259056)
print v(xbgr.mr_n56259168)
print v(xbgr.mr_n56259488)
print v(xbgr.mr_n56259600)
print v(xbgr.mr_n56259920)
print v(xbgr.mr_n56260032)
print v(xbgr.mr_n56260352)
print v(xbgr.mr_n56260464)
print v(xbgr.mr_n56260784)
print v(xbgr.mr_n56260896)
print v(xbgr.mr_n56261216)
print v(xbgr.mr_n56261328)
print v(xbgr.mr_n56261648)
print v(xbgr.mr_n56261760)
print v(xbgr.mr_n56262080)
print v(xbgr.mr_n56262192)
print v(xbgr.mr_n56262512)
print v(xbgr.mr_n56262624)
print v(xbgr.mr_n56262944)
print v(xbgr.mr_n56263056)
print v(xbgr.mr_n56263488)
print v(xbgr.mr_n56263808)
print v(xbgr.mr_n56263920)
print v(xbgr.mr_n56264352)
print v(xbgr.mr_n56264672)
print v(xbgr.mr_n56264784)
print v(xbgr.mr_n56265216)
print v(xbgr.mr_n56265536)
print v(xbgr.mr_n56266400)
print v(xbgr.mr_n56266512)
print v(xbgr.mr_n56266944)
print v(xbgr.mr_n56267264)
print v(xbgr.mr_n56267376)
print v(xbgr.mr_n56267696)
print v(xbgr.mr_n56267808)
print v(xbgr.mr_n56268128)
print v(xbgr.mr_n56268240)
print v(xbgr.mr_n56268560)
print v(xbgr.mr_n56268672)
print v(xbgr.mr_n56268992)
print v(xbgr.mr_n56269104)
print v(xbgr.mr_n56269424)
print v(xbgr.mr_n56269536)
print v(xbgr.mr_n56269856)
print v(xbgr.mr_n56269968)
print v(xbgr.mr_n56270288)
print v(xbgr.mr_n56270400)
print v(xbgr.mr_n56270720)
print v(xbgr.mr_n56271584)
print v(xbgr.mr_n56272448)
print v(xbgr.mr_n56272560)
print v(xbgr.mr_n56272880)
print v(xbgr.mr_n56272992)
print v(xbgr.mr_n56273312)
print v(xbgr.mr_n56274176)
print v(xbgr.mr_n56274288)
print v(xbgr.mr_n56274608)
print v(xbgr.mr_n56274720)
print v(xbgr.mr_n56275040)
print v(xbgr.mr_n56275152)
print v(xbgr.mr_n56275472)
print v(xbgr.mr_n56275584)
print v(xbgr.mr_n56275904)
print v(xbgr.mr_n56276016)
print v(xbgr.mr_n56276336)
print v(xbgr.mr_n56276448)
print v(xbgr.mr_n56276768)
print v(xbgr.mr_n56276880)
print v(xbgr.mr_n56277200)
print v(xbgr.mr_n56277312)
print v(xbgr.mr_n56277632)
print v(xbgr.mr_n56277744)
print v(xbgr.mr_n56278064)
print v(xbgr.mr_n56278176)
print v(xbgr.mr_n56278496)
print v(xbgr.mr_n56278608)
print v(xbgr.mr_n56278928)
print v(xbgr.mr_n56279040)
print v(xbgr.mr_n56279360)
print v(xbgr.mr_n56279472)
print v(xbgr.mr_n56279792)
print v(xbgr.mr_n56279904)
print v(xbgr.mr_n56280224)
print v(xbgr.mr_n56280336)
print v(xbgr.mr_n56280656)
print v(xbgr.mr_n56280768)
print v(xbgr.mr_n56281088)
print v(xbgr.mr_n56281200)
print v(xbgr.mr_n56281520)
print v(xbgr.mr_n56281632)
print v(xbgr.mr_n56281952)
print v(xbgr.mr_n56282064)
print v(xbgr.mr_n56282384)
print v(xbgr.mr_n56282496)
print v(xbgr.mr_n56282816)
print v(xbgr.mr_n56282928)
print v(xbgr.mr_n56283248)
print v(xbgr.mr_n56283360)
print v(xbgr.mr_n56283680)
print v(xbgr.mr_n56283792)
print v(xbgr.mr_n56284112)
print v(xbgr.mr_n56284224)
print v(xbgr.mr_n56284544)
print v(xbgr.mr_n56284656)
print v(xbgr.mr_n56285088)
print v(xbgr.mr_n56285408)
print v(xbgr.mr_n56285520)
print v(xbgr.mr_n56285840)
print v(xbgr.mr_n56285952)
print v(xbgr.mr_n56286272)
print v(xbgr.mr_n56286384)
print v(xbgr.mr_n56286704)
print v(xbgr.mr_n56286816)
print v(xbgr.mr_n56287136)
print v(xbgr.mr_n56287248)
print v(xbgr.mr_n56287568)
print v(xbgr.mr_n56287680)
print v(xbgr.mr_n56288000)
print v(xbgr.mr_n56288112)
print v(xbgr.mr_n56288432)
print v(xbgr.mr_n56288544)
print v(xbgr.mr_n56288864)
print v(xbgr.mr_n56288976)
print v(xbgr.mr_n56289296)
print v(xbgr.mr_n56289408)
print v(xbgr.mr_n56289728)
print v(xbgr.mr_n56289840)
print v(xbgr.mr_n56290160)
print v(xbgr.mr_n56290272)
print v(xbgr.mr_n56290592)
print v(xbgr.mr_n56290704)
print v(xbgr.mr_n56291024)
print v(xbgr.mr_n56291136)
print v(xbgr.mr_n56291456)
print v(xbgr.mr_n56292320)
print v(xbgr.mr_n56292432)
print v(xbgr.mr_n56292752)
print v(xbgr.mr_n56292864)
print v(xbgr.mr_n56293184)
print v(xbgr.mr_n56293296)
print v(xbgr.mr_n56293616)
print v(xbgr.mr_n56293728)
print v(xbgr.mr_n56294048)
print v(xbgr.mr_n56294160)
print v(xbgr.mr_n56294480)
print v(xbgr.mr_n56294592)
print v(xbgr.mr_n56294912)
print v(xbgr.mr_n56295024)
print v(xbgr.mr_n56295344)
print v(xbgr.mr_n56295456)
print v(xbgr.mr_n56295776)
print v(xbgr.mr_n56295888)
print v(xbgr.mr_n56296208)
print v(xbgr.mr_n56296320)
print v(xbgr.mr_n56296640)
print v(xbgr.mr_n56296752)
print v(xbgr.mr_n56297072)
print v(xbgr.mr_n56297184)
print v(xbgr.mr_n56297504)
print v(xbgr.mr_n56297616)
print v(xbgr.mr_n56297936)
print v(xbgr.mr_n56298048)
print v(xbgr.mr_n56298368)
print v(xbgr.mr_n56298480)
print v(xbgr.mr_n56298800)
print v(xbgr.mr_n56298912)
print v(xbgr.mr_n56299232)
print v(xbgr.mr_n56299344)
print v(xbgr.mr_n56299664)
print v(xbgr.mr_n56299776)
print v(xbgr.mr_n56300096)
print v(xbgr.mr_n56300208)
print v(xbgr.mr_n56300528)
print v(xbgr.mr_n56300640)
print v(xbgr.mr_n56300960)
print v(xbgr.mr_n56301072)
print v(xbgr.mr_n56301392)
print v(xbgr.mr_n56301504)
print v(xbgr.mr_n56301824)
print v(xbgr.mr_n56301936)
print v(xbgr.mr_n56302256)
print v(xbgr.mr_n56302368)
print v(xbgr.mr_n56302688)
print v(xbgr.mr_n56302800)
print v(xbgr.mr_n56303120)
print v(xbgr.mr_n56303232)
print v(xbgr.mr_n56303552)
print v(xbgr.mr_n56303664)
print v(xbgr.mr_n56303984)
print v(xbgr.mr_n56304096)
print v(xbgr.mr_n56304416)
print v(xbgr.mr_n56304528)
print v(xbgr.mr_n56304848)
print v(xbgr.mr_n56304960)
print v(xbgr.mr_n56305280)
print v(xbgr.mr_n56305392)
print v(xbgr.mr_n56305712)
print v(xbgr.mr_n56305824)
print v(xbgr.mr_n56306144)
print v(xbgr.mr_n56306256)
print v(xbgr.mr_n56306576)
print v(xbgr.mr_n56306688)
print v(xbgr.mr_n56307008)
print v(xbgr.mr_n56307120)
print v(xbgr.mr_n56307440)
print v(xbgr.mr_n56307552)
print v(xbgr.mr_n56307872)
print v(xbgr.mr_n56307984)
print v(xbgr.mr_n56308304)
print v(xbgr.mr_n56308416)
print v(xbgr.mr_n56308736)
print v(xbgr.mr_n56308848)
print v(xbgr.mr_n56309168)
print v(xbgr.mr_n56309280)
print v(xbgr.mr_n56309600)
print v(xbgr.mr_n56309712)
print v(xbgr.mr_n56310032)
print v(xbgr.mr_n56310144)
print v(xbgr.mr_n56310464)
print v(xbgr.mr_n56310576)
print v(xbgr.mr_n56310896)
print v(xbgr.mr_n56311008)
print v(xbgr.mr_n56311328)
print v(xbgr.mr_n56311440)
print v(xbgr.mr_n56311760)
print v(xbgr.mr_n56311872)
print v(xbgr.mr_n56312192)
print v(xbgr.mr_n56312304)
print v(xbgr.mr_n56312624)
print v(xbgr.mr_n56312736)
print v(xbgr.mr_n56313056)
print v(xbgr.mr_n56313168)
print v(xbgr.mr_n56313488)
print v(xbgr.mr_n56313600)
print v(xbgr.mr_n56313920)
print v(xbgr.mr_n56314032)
print v(xbgr.mr_n56314352)
print v(xbgr.mr_n56314464)
print v(xbgr.mr_n56314784)
print v(xbgr.mr_n56314896)
print v(xbgr.mr_n56315216)
print v(xbgr.mr_n56315328)
print v(xbgr.mr_n56315648)
print v(xbgr.mr_n56315760)
print v(xbgr.mr_n56316080)
print v(xbgr.mr_n56316192)
print v(xbgr.mr_n56316512)
print v(xbgr.mr_n56316624)
print v(xbgr.mr_n56316944)
print v(xbgr.mr_n56317056)
print v(xbgr.mr_n56317376)
print v(xbgr.mr_n56317488)
print v(xbgr.mr_n56317808)
print v(xbgr.mr_n56317920)
print v(xbgr.mr_n56318240)
print v(xbgr.mr_n56318352)
print v(xbgr.mr_n56318672)
print v(xbgr.mr_n56318784)
print v(xbgr.mr_n56319104)
print v(xbgr.mr_n56319216)
print v(xbgr.mr_n56319536)
print v(xbgr.mr_n56319648)
print v(xbgr.mr_n56319968)
print v(xbgr.mr_n56320080)
print v(xbgr.mr_n56320400)
print v(xbgr.mr_n56320512)
print v(xbgr.mr_n56320832)
print v(xbgr.mr_n56320944)
print v(xbgr.mr_n56321264)
print v(xbgr.mr_n56321376)
print v(xbgr.mr_n56321696)
print v(xbgr.mr_n56321808)
print v(xbgr.mr_n56322128)
print v(xbgr.mr_n56322240)
print v(xbgr.mr_n56322560)
print v(xbgr.mr_n56322672)
print v(xbgr.mr_n56322992)
print v(xbgr.mr_n56323104)
print v(xbgr.mr_n56323424)
print v(xbgr.mr_n56323536)
print v(xbgr.mr_n56323856)
print v(xbgr.mr_n56323968)
print v(xbgr.mr_n56324288)
print v(xbgr.mr_n56324400)
print v(xbgr.mr_n56324720)
print v(xbgr.mr_n56324832)
print v(xbgr.mr_n56325152)
print v(xbgr.mr_n56325264)
print v(xbgr.mr_n56325584)
print v(xbgr.mr_n56325696)
print v(xbgr.mr_n56326016)
print v(xbgr.mr_n56326128)
print v(xbgr.mr_n56326448)
print v(xbgr.mr_n56326560)
print v(xbgr.mr_n56326880)
print v(xbgr.mr_n56326992)
print v(xbgr.mr_n56327312)
print v(xbgr.mr_n56327424)
print v(xbgr.mr_n56327744)
print v(xbgr.mr_n56327856)
print v(xbgr.mr_n56328176)
print v(xbgr.mr_n56328288)
print v(xbgr.mr_n56328608)
print v(xbgr.mr_n56328720)
print v(xbgr.mr_n56329040)
print v(xbgr.mr_n56329152)
print v(xbgr.mr_n56329472)
print v(xbgr.mr_n56329584)
print v(xbgr.mr_n56329904)
print v(xbgr.mr_n56330016)
print v(xbgr.mr_n56330336)
print v(xbgr.mr_n56330448)
print v(xbgr.mr_n56330768)
print v(xbgr.mr_n56330880)
print v(xbgr.mr_n56331200)
print v(xbgr.mr_n56331312)
print v(xbgr.mr_n56331632)
print v(xbgr.mr_n56331744)
print v(xbgr.mr_n56332064)
print v(xbgr.mr_n56332176)
print v(xbgr.mr_n56332496)
print v(xbgr.mr_n56332608)
print v(xbgr.mr_n56332928)
print v(xbgr.mr_n56333040)
print v(xbgr.mr_n56333360)
print v(xbgr.mr_n56333472)
print v(xbgr.mr_n56333792)
print v(xbgr.mr_n56333904)
print v(xbgr.mr_n56334224)
print v(xbgr.mr_n56334336)
print v(xbgr.mr_n56334656)
print v(xbgr.mr_n56334768)
print v(xbgr.mr_n56335088)
print v(xbgr.mr_n56335200)
print v(xbgr.mr_n56335520)
print v(xbgr.mr_n56335632)
print v(xbgr.mr_n56335952)
print v(xbgr.mr_n56336064)
print v(xbgr.mr_n56336384)
print v(xbgr.mr_n56336496)
print v(xbgr.mr_n56336816)
print v(xbgr.mr_n56336928)
print v(xbgr.mr_n56337248)
print v(xbgr.mr_n56337360)
print v(xbgr.mr_n56337680)
print v(xbgr.mr_n56337792)
print v(xbgr.mr_n56338112)
print v(xbgr.mr_n56338224)
print v(xbgr.mr_n56338544)
print v(xbgr.mr_n56338656)
print v(xbgr.mr_n56338976)
print v(xbgr.mr_n56339088)
print v(xbgr.mr_n56339408)
print v(xbgr.mr_n56339520)
print v(xbgr.mr_n56339840)
print v(xbgr.mr_n56339952)
print v(xbgr.mr_n56340272)
print v(xbgr.mr_n56340384)
print v(xbgr.mr_n56340704)
print v(xbgr.mr_n56340816)
print v(xbgr.mr_n56341136)
print v(xbgr.mr_n56341248)
print v(xbgr.mr_n56341568)
print v(xbgr.mr_n56341680)
print v(xbgr.mr_n56342000)
print v(xbgr.mr_n56342112)
print v(xbgr.mr_n56342432)
print v(xbgr.mr_n56342544)
print v(xbgr.mr_n56342864)
print v(xbgr.mr_n56342976)
print v(xbgr.mr_n56343296)
print v(xbgr.mr_n56343408)
print v(xbgr.mr_n56343728)
print v(xbgr.mr_n56343840)
print v(xbgr.mr_n56344160)
print v(xbgr.mr_n56344272)
print v(xbgr.mr_n56344592)
print v(xbgr.mr_n56344704)
print v(xbgr.mr_n56345024)
print v(xbgr.mr_n56345136)
print v(xbgr.mr_n56345456)
print v(xbgr.mr_n56345568)
print v(xbgr.mr_n56345888)
print v(xbgr.mr_n56346000)
print v(xbgr.mr_n56346320)
print v(xbgr.mr_n56346432)
print v(xbgr.mr_n56346752)
print v(xbgr.mr_n56346864)
print v(xbgr.mr_n56347184)
print v(xbgr.mr_n56347296)
print v(xbgr.mr_n56347616)
print v(xbgr.mr_n56347728)
print v(xbgr.mr_n56348048)
print v(xbgr.mr_n56348160)
print v(xbgr.mr_n56348480)
print v(xbgr.mr_n56348592)
print v(xbgr.mr_n56348912)
print v(xbgr.mr_n56349024)
print v(xbgr.mr_n56349344)
print v(xbgr.mr_n56349456)
print v(xbgr.mr_n56349776)
print v(xbgr.mr_n56349888)
print v(xbgr.mr_n56350208)
print v(xbgr.mr_n56350320)
print v(xbgr.mr_n56350640)
print v(xbgr.mr_n56350752)
print v(xbgr.mr_n56351072)
print v(xbgr.mr_n56351184)
print v(xbgr.mr_n56351504)
print v(xbgr.mr_n56351616)
print v(xbgr.mr_n56351936)
print v(xbgr.mr_n56352048)
print v(xbgr.mr_n56352368)
print v(xbgr.mr_n56352480)
print v(xbgr.mr_n56352800)
print v(xbgr.mr_n56352912)
print v(xbgr.mr_n56353232)
print v(xbgr.mr_n56353344)
print v(xbgr.mr_n56353664)
print v(xbgr.mr_n56353776)
print v(xbgr.mr_n56354096)
print v(xbgr.mr_n56354208)
print v(xbgr.mr_n56354528)
print v(xbgr.mr_n56354640)
print v(xbgr.mr_n56354960)
print v(xbgr.mr_n56355072)
print v(xbgr.mr_n56355392)
print v(xbgr.mr_n56355504)
print v(xbgr.mr_n56355824)
print v(xbgr.mr_n56355936)
print v(xbgr.mr_n56356256)
print v(xbgr.mr_n56356368)
print v(xbgr.mr_n56356688)
print v(xbgr.mr_n56356800)
print v(xbgr.mr_n56357120)
print v(xbgr.mr_n56357232)
print v(xbgr.mr_n56357552)
print v(xbgr.mr_n56357664)
print v(xbgr.mr_n56357984)
print v(xbgr.mr_n56358096)
print v(xbgr.mr_n56358416)
print v(xbgr.mr_n56358528)
print v(xbgr.mr_n56358848)
print v(xbgr.mr_n56358960)
print v(xbgr.mr_n56359280)
print v(xbgr.mr_n56359392)
print v(xbgr.mr_n56359712)
print v(xbgr.mr_n56359824)
print v(xbgr.mr_n56360144)
print v(xbgr.mr_n56360256)
print v(xbgr.mr_n56360576)
print v(xbgr.mr_n56360688)
print v(xbgr.mr_n56361008)
print v(xbgr.mr_n56361120)
print v(xbgr.mr_n56361440)
print v(xbgr.mr_n56361552)
print v(xbgr.mr_n56361872)
print v(xbgr.mr_n56361984)
print v(xbgr.mr_n56362304)
print v(xbgr.mr_n56362416)
print v(xbgr.mr_n56362736)
print v(xbgr.mr_n56362848)
print v(xbgr.mr_n56363168)
print v(xbgr.mr_n56363280)
print v(xbgr.mr_n56363600)
print v(xbgr.mr_n56363712)
print v(xbgr.mr_n56364032)
print v(xbgr.mr_n56364144)
print v(xbgr.mr_n56364464)
print v(xbgr.mr_n56364576)
print v(xbgr.mr_n56364896)
print v(xbgr.mr_n56365008)
print v(xbgr.mr_n56365328)
print v(xbgr.mr_n56365440)
print v(xbgr.mr_n56365760)
print v(xbgr.mr_n56365872)
print v(xbgr.mr_n56366192)
print v(xbgr.mr_n56366304)
print v(xbgr.mr_n56366624)
print v(xbgr.mr_n56366736)
print v(xbgr.mr_n56367056)
print v(xbgr.mr_n56367168)
print v(xbgr.mr_n56367488)
print v(xbgr.mr_n56367600)
print v(xbgr.mr_n56367920)
print v(xbgr.mr_n56368032)
print v(xbgr.mr_n56368352)
print v(xbgr.mr_n56368464)
print v(xbgr.mr_n56368784)
print v(xbgr.mr_n56368896)
print v(xbgr.mr_n56369216)
print v(xbgr.mr_n56369328)
print v(xbgr.mr_n56369648)
print v(xbgr.mr_n56369760)
print v(xbgr.mr_n56370080)
print v(xbgr.mr_n56370192)
print v(xbgr.mr_n56370512)
print v(xbgr.mr_n56370624)
print v(xbgr.mr_n56370944)
print v(xbgr.mr_n56371056)
print v(xbgr.mr_n56371376)
print v(xbgr.mr_n56371488)
print v(xbgr.mr_n56371808)
print v(xbgr.mr_n56371920)
print v(xbgr.mr_n56372240)
print v(xbgr.mr_n56372352)
print v(xbgr.mr_n56372672)
print v(xbgr.mr_n56372784)
print v(xbgr.mr_n56373104)
print v(xbgr.mr_n56373216)
print v(xbgr.mr_n56373536)
print v(xbgr.mr_n56373648)
print v(xbgr.mr_n56373968)
print v(xbgr.mr_n56374080)
print v(xbgr.mr_n56374400)
print v(xbgr.mr_n56374512)
print v(xbgr.mr_n56374832)
print v(xbgr.mr_n56374944)
print v(xbgr.mr_n56375264)
print v(xbgr.mr_n56375376)
print v(xbgr.mr_n56375696)
print v(xbgr.mr_n56375808)
print v(xbgr.mr_n56376128)
print v(xbgr.mr_n56376240)
print v(xbgr.mr_n56376560)
print v(xbgr.mr_n56376672)
print v(xbgr.mr_n56376992)
print v(xbgr.mr_n56377104)
print v(xbgr.mr_n56377424)
print v(xbgr.mr_n56377536)
print v(xbgr.mr_n56377856)
print v(xbgr.mr_n56377968)
print v(xbgr.mr_n56378288)
print v(xbgr.mr_n56378400)
print v(xbgr.mr_n56378720)
print v(xbgr.mr_n56378832)
print v(xbgr.mr_n56379152)
print v(xbgr.mr_n56379264)
print v(xbgr.mr_n56379584)
print v(xbgr.mr_n56379696)
print v(xbgr.mr_n56380016)
print v(xbgr.mr_n56380128)
print v(xbgr.mr_n56380448)
print v(xbgr.mr_n56380560)
print v(xbgr.mr_n56380880)
print v(xbgr.mr_n56380992)
print v(xbgr.mr_n56381312)
print v(xbgr.mr_n56381424)
print v(xbgr.mr_n56381744)
print v(xbgr.mr_n56381856)
print v(xbgr.mr_n56382176)
print v(xbgr.mr_n56382288)
print v(xbgr.mr_n56382608)
print v(xbgr.mr_n56382720)
print v(xbgr.mr_n56383040)
print v(xbgr.mr_n56383152)
print v(xbgr.mr_n56383472)
print v(xbgr.mr_n56383584)
print v(xbgr.mr_n56383904)
print v(xbgr.mr_n56384016)
print v(xbgr.mr_n56384336)
print v(xbgr.mr_n56384448)
print v(xbgr.mr_n56384768)
print v(xbgr.mr_n56384880)
print v(xbgr.mr_n56385200)
print v(xbgr.mr_n56385312)
print v(xbgr.mr_n56385632)
print v(xbgr.mr_n56385744)
print v(xbgr.mr_n56386064)
print v(xbgr.mr_n56386176)
print v(xbgr.mr_n56386496)
print v(xbgr.mr_n56386608)
print v(xbgr.mr_n56386928)
print v(xbgr.mr_n56387040)
print v(xbgr.mr_n56387360)
print v(xbgr.mr_n56387472)
print v(xbgr.mr_n56387792)
print v(xbgr.mr_n56387904)
print v(xbgr.mr_n56388224)
print v(xbgr.mr_n56388336)
print v(xbgr.mr_n56388656)
print v(xbgr.mr_n56388768)
print v(xbgr.mr_n56389088)
print v(xbgr.mr_n56389200)
print v(xbgr.mr_n56389520)
print v(xbgr.mr_n56389632)
print v(xbgr.mr_n56389952)
print v(xbgr.mr_n56390064)
print v(xbgr.mr_n56390384)
print v(xbgr.mr_n56390496)
print v(xbgr.mr_n56390816)
print v(xbgr.mr_n56390928)
print v(xbgr.mr_n56391248)
print v(xbgr.mr_n56391360)
print v(xbgr.mr_n56391680)
print v(xbgr.mr_n56391792)
print v(xbgr.mr_n56392112)
print v(xbgr.mr_n56392224)
print v(xbgr.mr_n56392544)
print v(xbgr.mr_n56392656)
print v(xbgr.mr_n56392976)
print v(xbgr.mr_n56393088)
print v(xbgr.mr_n56393408)
print v(xbgr.mr_n56393520)
print v(xbgr.mr_n56393840)
print v(xbgr.mr_n56393952)
print v(xbgr.mr_n56394272)
print v(xbgr.mr_n56394384)
print v(xbgr.mr_n56394704)
print v(xbgr.mr_n56394816)
print v(xbgr.mr_n56395136)
print v(xbgr.mr_n56395248)
print v(xbgr.mr_n56395568)
print v(xbgr.mr_n56395680)
print v(xbgr.mr_n56396000)
print v(xbgr.mr_n56396112)
print v(xbgr.mr_n56396432)
print v(xbgr.mr_n56396544)
print v(xbgr.mr_n56396864)
print v(xbgr.mr_n56396976)
print v(xbgr.mr_n56397296)
print v(xbgr.mr_n56397408)
print v(xbgr.mr_n56397728)
print v(xbgr.mr_n56397840)
print v(xbgr.mr_n56398160)
print v(xbgr.mr_n56398272)
print v(xbgr.mr_n56398592)
print v(xbgr.mr_n56398704)
print v(xbgr.mr_n56399024)
print v(xbgr.mr_n56399136)
print v(xbgr.mr_n56399456)
print v(xbgr.mr_n56399568)
print v(xbgr.mr_n56399888)
print v(xbgr.mr_n56400000)
print v(xbgr.mr_n56400320)
print v(xbgr.mr_n56400432)
print v(xbgr.mr_n56400752)
print v(xbgr.mr_n56400864)
print v(xbgr.mr_n56401184)
print v(xbgr.mr_n56401296)
print v(xbgr.mr_n56401616)
print v(xbgr.mr_n56401728)
print v(xbgr.mr_n56402048)
print v(xbgr.mr_n56402160)
print v(xbgr.mr_n56402480)
print v(xbgr.mr_n56402592)
print v(xbgr.mr_n56402912)
print v(xbgr.mr_n56403024)
print v(xbgr.mr_n56403344)
print v(xbgr.mr_n56403456)
print v(xbgr.mr_n56403776)
print v(xbgr.mr_n56403888)
print v(xbgr.mr_n56404208)
print v(xbgr.mr_n56404320)
print v(xbgr.mr_n56404640)
print v(xbgr.mr_n56404752)
print v(xbgr.mr_n56405072)
print v(xbgr.mr_n56405184)
print v(xbgr.mr_n56405504)
print v(xbgr.mr_n56405616)
print v(xbgr.mr_n56405936)
print v(xbgr.mr_n56406048)
print v(xbgr.mr_n56406368)
print v(xbgr.mr_n56406480)
print v(xbgr.mr_n56406800)
print v(xbgr.mr_n56406912)
print v(xbgr.mr_n56407232)
print v(xbgr.mr_n56407344)
print v(xbgr.mr_n56407664)
print v(xbgr.mr_n56407776)
print v(xbgr.mr_n56408096)
print v(xbgr.mr_n56408208)
print v(xbgr.mr_n56408528)
print v(xbgr.mr_n56408640)
print v(xbgr.mr_n56408960)
print v(xbgr.mr_n56409072)
print v(xbgr.mr_n56409392)
print v(xbgr.mr_n56409504)
print v(xbgr.mr_n56409824)
print v(xbgr.mr_n56409936)
print v(xbgr.mr_n56410256)
print v(xbgr.mr_n56410368)
print v(xbgr.mr_n56410688)
print v(xbgr.mr_n56410800)
print v(xbgr.mr_n56411120)
print v(xbgr.mr_n56411232)
print v(xbgr.mr_n56411552)
print v(xbgr.mr_n56411664)
print v(xbgr.mr_n56411984)
print v(xbgr.mr_n56412096)
print v(xbgr.mr_n56412416)
print v(xbgr.mr_n56412528)
print v(xbgr.mr_n56412848)
print v(xbgr.mr_n56412960)
print v(xbgr.mr_n56413280)
print v(xbgr.mr_n56413392)
print v(xbgr.mr_n56413712)
print v(xbgr.mr_n56413824)
print v(xbgr.mr_n56414144)
print v(xbgr.mr_n56414256)
print v(xbgr.mr_n56414576)
print v(xbgr.mr_n56414688)
print v(xbgr.mr_n56415008)
print v(xbgr.mr_n56415120)
print v(xbgr.mr_n56415440)
print v(xbgr.mr_n56415552)
print v(xbgr.mr_n56415872)
print v(xbgr.mr_n56415984)
print v(xbgr.mr_n56416304)
print v(xbgr.mr_n56416416)
print v(xbgr.mr_n56416736)
print v(xbgr.mr_n56416848)
print v(xbgr.mr_n56417168)
print v(xbgr.mr_n56417280)
print v(xbgr.mr_n56417600)
print v(xbgr.mr_n56417712)
print v(xbgr.mr_n56418032)
print v(xbgr.mr_n56418144)
print v(xbgr.mr_n56418464)
print v(xbgr.mr_n56418576)
print v(xbgr.mr_n56418896)
print v(xbgr.mr_n56419008)
print v(xbgr.mr_n56419328)
print v(xbgr.mr_n56419440)
print v(xbgr.mr_n56419760)
print v(xbgr.mr_n56419872)
print v(xbgr.mr_n56420192)
print v(xbgr.mr_n56420304)
print v(xbgr.mr_n56420624)
print v(xbgr.mr_n56420736)
print v(xbgr.mr_n56421056)
print v(xbgr.mr_n56421168)
print v(xbgr.mr_n56421488)
print v(xbgr.mr_n56421600)
print v(xbgr.mr_n56421920)
print v(xbgr.mr_n56422032)
print v(xbgr.mr_n56422352)
print v(xbgr.mr_n56422464)
print v(xbgr.mr_n56422784)
print v(xbgr.mr_n56422896)
print v(xbgr.mr_n56423216)
print v(xbgr.mr_n56423328)
print v(xbgr.mr_n56423648)
print v(xbgr.mr_n56423760)
print v(xbgr.mr_n56424080)
print v(xbgr.mr_n56424192)
print v(xbgr.mr_n56424512)
print v(xbgr.mr_n56424624)
print v(xbgr.mr_n56424944)
print v(xbgr.mr_n56425056)
print v(xbgr.mr_n56425376)
print v(xbgr.mr_n56425488)
print v(xbgr.mr_n56425808)
print v(xbgr.mr_n56425920)
print v(xbgr.mr_n56426240)
print v(xbgr.mr_n56426352)
print v(xbgr.mr_n56426672)
print v(xbgr.mr_n56426784)
print v(xbgr.mr_n56427104)
print v(xbgr.mr_n56427216)
print v(xbgr.mr_n56427536)
print v(xbgr.mr_n56427648)
print v(xbgr.mr_n56427968)
print v(xbgr.mr_n56428080)
print v(xbgr.mr_n56428400)
print v(xbgr.mr_n56428512)
print v(xbgr.mr_n56428832)
print v(xbgr.mr_n56428944)
print v(xbgr.mr_n56429264)
print v(xbgr.mr_n56429376)
print v(xbgr.mr_n56429696)
print v(xbgr.mr_n56429808)
print v(xbgr.mr_n56430128)
print v(xbgr.mr_n56430240)
print v(xbgr.mr_n56430560)
print v(xbgr.mr_n56430672)
print v(xbgr.mr_n56430992)
print v(xbgr.mr_n56431104)
print v(xbgr.mr_n56431424)
print v(xbgr.mr_n56431536)
print v(xbgr.mr_n56431856)
print v(xbgr.mr_n56431968)
print v(xbgr.mr_n56432288)
print v(xbgr.mr_n56432400)
print v(xbgr.mr_n56432720)
print v(xbgr.mr_n56432832)
print v(xbgr.mr_n56433152)
print v(xbgr.mr_n56433264)
print v(xbgr.mr_n56433584)
print v(xbgr.mr_n56433696)
print v(xbgr.mr_n56434016)
print v(xbgr.mr_n56434128)
print v(xbgr.mr_n56434448)
print v(xbgr.mr_n56434560)
print v(xbgr.mr_n56434880)
print v(xbgr.mr_n56434992)
print v(xbgr.mr_n56435312)
print v(xbgr.mr_n56435424)
print v(xbgr.mr_n56435744)
print v(xbgr.mr_n56435856)
print v(xbgr.mr_n56436176)
print v(xbgr.mr_n56436288)
print v(xbgr.mr_n56436608)
print v(xbgr.mr_n56436720)
print v(xbgr.mr_n56437040)
print v(xbgr.mr_n56437152)
print v(xbgr.mr_n56437472)
print v(xbgr.mr_n56437584)
print v(xbgr.mr_n56437904)
print v(xbgr.mr_n56438016)
print v(xbgr.mr_n56438336)
print v(xbgr.mr_n56438448)
print v(xbgr.mr_n56438768)
print v(xbgr.mr_n56438880)
print v(xbgr.mr_n56439200)
print v(xbgr.mr_n56439312)
print v(xbgr.mr_n56439632)
print v(xbgr.mr_n56439744)
print v(xbgr.mr_n56440064)
print v(xbgr.mr_n56440176)
print v(xbgr.mr_n56440496)
print v(xbgr.mr_n56440608)
print v(xbgr.mr_n56440928)
print v(xbgr.mr_n56441040)
print v(xbgr.mr_n56441360)
print v(xbgr.mr_n56441472)
print v(xbgr.mr_n56441792)
print v(xbgr.mr_n56441904)
print v(xbgr.mr_n56442224)
print v(xbgr.mr_n56442336)
print v(xbgr.mr_n56442656)
print v(xbgr.mr_n56442768)
print v(xbgr.mr_n56443088)
print v(xbgr.mr_n56443200)
print v(xbgr.mr_n56443520)
print v(xbgr.mr_n56443632)
print v(xbgr.mr_n56443952)
print v(xbgr.mr_n56444064)
print v(xbgr.mr_n56444384)
print v(xbgr.mr_n56444496)
print v(xbgr.mr_n56444816)
print v(xbgr.mr_n56444928)
print v(xbgr.mr_n56445248)
print v(xbgr.mr_n56445360)
print v(xbgr.mr_n56445680)
print v(xbgr.mr_n56445792)
print v(xbgr.mr_n56446112)
print v(xbgr.mr_n56446224)
print v(xbgr.mr_n56446544)
print v(xbgr.mr_n56446656)
print v(xbgr.mr_n56446976)
print v(xbgr.mr_n56447088)
print v(xbgr.mr_n56447408)
print v(xbgr.mr_n56447520)
print v(xbgr.mr_n56447840)
print v(xbgr.mr_n56447952)
print v(xbgr.mr_n56448272)
print v(xbgr.mr_n56448384)
print v(xbgr.mr_n56448704)
print v(xbgr.mr_n56448816)
print v(xbgr.mr_n56449136)
print v(xbgr.mr_n56449248)
print v(xbgr.mr_n56449568)
print v(xbgr.mr_n56449680)
print v(xbgr.mr_n56450000)
print v(xbgr.mr_n56450112)
print v(xbgr.mr_n56450432)
print v(xbgr.mr_n56450544)
print v(xbgr.mr_n56450864)
print v(xbgr.mr_n56450976)
print v(xbgr.mr_n56451296)
print v(xbgr.mr_n56451408)
print v(xbgr.mr_n56451728)
print v(xbgr.mr_n56451840)
print v(xbgr.mr_n56452160)
print v(xbgr.mr_n56452272)
print v(xbgr.mr_n56452592)
print v(xbgr.mr_n56452704)
print v(xbgr.mr_n56453024)
print v(xbgr.mr_n56453136)
print v(xbgr.mr_n56453456)
print v(xbgr.mr_n56453568)
print v(xbgr.mr_n56453888)
print v(xbgr.mr_n56454000)
print v(xbgr.mr_n56454320)
print v(xbgr.mr_n56454432)
print v(xbgr.mr_n56454752)
print v(xbgr.mr_n56454864)
print v(xbgr.mr_n56455184)
print v(xbgr.mr_n56455296)
print v(xbgr.mr_n56455616)
print v(xbgr.mr_n56455728)
print v(xbgr.mr_n56456048)
print v(xbgr.mr_n56456160)
print v(xbgr.mr_n56456480)
print v(xbgr.mr_n56456592)
print v(xbgr.mr_n56456912)
print v(xbgr.mr_n56457024)
print v(xbgr.mr_n56457344)
print v(xbgr.mr_n56457456)
print v(xbgr.mr_n56457776)
print v(xbgr.mr_n56457888)
print v(xbgr.mr_n56458208)
print v(xbgr.mr_n56458320)
print v(xbgr.mr_n56458640)
print v(xbgr.mr_n56458752)
print v(xbgr.mr_n56459072)
print v(xbgr.mr_n56459184)
print v(xbgr.mr_n56459504)
print v(xbgr.mr_n56459616)
print v(xbgr.mr_n56459936)
print v(xbgr.mr_n56460048)
print v(xbgr.mr_n56460368)
print v(xbgr.mr_n56460480)
print v(xbgr.mr_n56460800)
print v(xbgr.mr_n56460912)
print v(xbgr.mr_n56461232)
print v(xbgr.mr_n56461344)
print v(xbgr.mr_n56461664)
print v(xbgr.mr_n56461776)
print v(xbgr.mr_n56462096)
print v(xbgr.mr_n56462208)
print v(xbgr.mr_n56462528)
print v(xbgr.mr_n56462640)
print v(xbgr.mr_n56462960)
print v(xbgr.mr_n56463072)
print v(xbgr.mr_n56463392)
print v(xbgr.mr_n56463504)
print v(xbgr.mr_n56463936)
print v(xbgr.mr_n56464256)
print v(xbgr.mr_n56464368)
print v(xbgr.mr_n56464688)
print v(xbgr.mr_n56464800)
print v(xbgr.mr_n56465120)
print v(xbgr.mr_n56465232)
print v(xbgr.mr_n56465552)
print v(xbgr.mr_n56465664)
print v(xbgr.mr_n56465984)
print v(xbgr.mr_n56466848)
print v(xbgr.mr_n56466960)
print v(xbgr.mr_n56467280)
print v(xbgr.mr_n56467392)
print v(xbgr.mr_n56467712)
print v(xbgr.mr_n56467824)
print v(xbgr.mr_n56468144)
print v(xbgr.mr_n56468256)
print v(xbgr.mr_n56468576)
print v(xbgr.mr_n56468688)
print v(xbgr.mr_n56469008)
print v(xbgr.mr_n56469120)
print v(xbgr.mr_n56469440)
print v(xbgr.mr_n56469552)
print v(xbgr.mr_n56469872)
print v(xbgr.mr_n56469984)
print v(xbgr.mr_n56470304)
print v(xbgr.mr_n56470416)
print v(xbgr.mr_n56470736)
print v(xbgr.mr_n56470848)
print v(xbgr.mr_n56471168)
print v(xbgr.mr_n56471280)
print v(xbgr.mr_n56471712)
print v(xbgr.mr_n56472032)
print v(xbgr.mr_n56472144)
print v(xbgr.mr_n56472464)
print v(xbgr.mr_n56472576)
print v(xbgr.mr_n56472896)
print v(xbgr.mr_n56473008)
print v(xbgr.mr_n56473328)
print v(xbgr.mr_n56473440)
print v(xbgr.mr_n56473760)
print v(xbgr.mr_n56473872)
print v(xbgr.mr_n56474192)
print v(xbgr.mr_n56474304)
print v(xbgr.mr_n56474624)
print v(xbgr.mr_n56474736)
print v(xbgr.mr_n56475056)
print v(xbgr.mr_n56475168)
print v(xbgr.mr_n56475488)
print v(xbgr.mr_n56475600)
print v(xbgr.mr_n56475920)
print v(xbgr.mr_n56476032)
print v(xbgr.mr_n56476352)
print v(xbgr.mr_n56476464)
print v(xbgr.mr_n56476784)
print v(xbgr.mr_n56476896)
print v(xbgr.mr_n56477216)
print v(xbgr.mr_n56477328)
print v(xbgr.mr_n56477648)
print v(xbgr.mr_n56477760)
print v(xbgr.mr_n56478080)
print v(xbgr.mr_n56478192)
print v(xbgr.mr_n56478512)
print v(xbgr.mr_n56478624)
print v(xbgr.mr_n56478944)
print v(xbgr.mr_n56479056)
print v(xbgr.mr_n56479376)
print v(xbgr.mr_n56479488)
print v(xbgr.mr_n56479808)
print v(xbgr.mr_n56479920)
print v(xbgr.mr_n56480240)
print v(xbgr.mr_n56480352)
print v(xbgr.mr_n56480672)
print v(xbgr.mr_n56480784)
print v(xbgr.mr_n56481104)
print v(xbgr.mr_n56481216)
print v(xbgr.mr_n56481536)
print v(xbgr.mr_n56481648)
print v(xbgr.mr_n56481968)
print v(xbgr.mr_n56482080)
print v(xbgr.mr_n56482400)
print v(xbgr.mr_n56482512)
print v(xbgr.mr_n56482832)
print v(xbgr.mr_n56482944)
print v(xbgr.mr_n56483264)
print v(xbgr.mr_n56483376)
print v(xbgr.mr_n56483696)
print v(xbgr.mr_n56483808)
print v(xbgr.mr_n56484128)
print v(xbgr.mr_n56484240)
print v(xbgr.mr_n56484560)
print v(xbgr.mr_n56484672)
print v(xbgr.mr_n56484992)
print v(xbgr.mr_n56485104)
print v(xbgr.mr_n56485424)
print v(xbgr.mr_n56485536)
print v(xbgr.mr_n56485856)
print v(xbgr.mr_n56485968)
print v(xbgr.mr_n56486288)
print v(xbgr.mr_n56486400)
print v(xbgr.mr_n56486720)
print v(xbgr.mr_n56486832)
print v(xbgr.mr_n56487152)
print v(xbgr.mr_n56487264)
print v(xbgr.mr_n56487584)
print v(xbgr.mr_n56487696)
print v(xbgr.mr_n56488016)
print v(xbgr.mr_n56488128)
print v(xbgr.mr_n56488448)
print v(xbgr.mr_n56489312)
print v(xbgr.mr_n56489424)
print v(xbgr.mr_n56489744)
print v(xbgr.mr_n56489856)
print v(xbgr.mr_n56490176)
print v(xbgr.mr_n56490288)
print v(xbgr.mr_n56490608)
print v(xbgr.mr_n56490720)
print v(xbgr.mr_n56491040)
print v(xbgr.mr_n56491152)
print v(xbgr.mr_n56491472)
print v(xbgr.mr_n56491584)
print v(xbgr.mr_n56491904)
print v(xbgr.mr_n56492016)
print v(xbgr.mr_n56492336)
print v(xbgr.mr_n56492448)
print v(xbgr.mr_n56492768)
print v(xbgr.mr_n56492880)
print v(xbgr.mr_n56493200)
print v(xbgr.mr_n56493312)
print v(xbgr.mr_n56493632)
print v(xbgr.mr_n56493744)
print v(xbgr.mr_n56494064)
print v(xbgr.mr_n56494176)
print v(xbgr.mr_n56494496)
print v(xbgr.mr_n56494608)
print v(xbgr.mr_n56494928)
print v(xbgr.mr_n56495040)
print v(xbgr.mr_n56495360)
print v(xbgr.mr_n56495472)
print v(xbgr.mr_n56495792)
print v(xbgr.mr_n56495904)
print v(xbgr.mr_n56496224)
print v(xbgr.mr_n56496336)
print v(xbgr.mr_n56496656)
print v(xbgr.mr_n56496768)
print v(xbgr.mr_n56497088)
print v(xbgr.mr_n56497200)
print v(xbgr.mr_n56497520)
print v(xbgr.mr_n56497632)
print v(xbgr.mr_n56497952)
print v(xbgr.mr_n56498064)
print v(xbgr.mr_n56498384)
print v(xbgr.mr_n56498496)
print v(xbgr.mr_n56498816)
print v(xbgr.mr_n56498928)
print v(xbgr.mr_n56499248)
print v(xbgr.mr_n56499360)
print v(xbgr.mr_n56499680)
print v(xbgr.mr_n56499792)
print v(xbgr.mr_n56500112)
print v(xbgr.mr_n56500224)
print v(xbgr.mr_n56500544)
print v(xbgr.mr_n56500656)
print v(xbgr.mr_n56500976)
print v(xbgr.mr_n56501088)
print v(xbgr.mr_n56501408)
print v(xbgr.mr_n56501520)
print v(xbgr.mr_n56501840)
print v(xbgr.mr_n56501952)
print v(xbgr.mr_n56502272)
print v(xbgr.mr_n56502384)
print v(xbgr.mr_n56502704)
print v(xbgr.mr_n56502816)
print v(xbgr.mr_n56503136)
print v(xbgr.mr_n56503248)
print v(xbgr.mr_n56503568)
print v(xbgr.mr_n56503680)
print v(xbgr.mr_n56504000)
print v(xbgr.mr_n56504112)
print v(xbgr.mr_n56504432)
print v(xbgr.mr_n56504544)
print v(xbgr.mr_n56504864)
print v(xbgr.mr_n56504976)
print v(xbgr.mr_n56505296)
print v(xbgr.mr_n56505408)
print v(xbgr.mr_n56505728)
print v(xbgr.mr_n56505840)
print v(xbgr.mr_n56506160)
print v(xbgr.mr_n56506272)
print v(xbgr.mr_n56506592)
print v(xbgr.mr_n56506704)
print v(xbgr.mr_n56507024)
print v(xbgr.mr_n56507136)
print v(xbgr.mr_n56507456)
print v(xbgr.mr_n56507568)
print v(xbgr.mr_n56507888)
print v(xbgr.mr_n56508000)
print v(xbgr.mr_n56508320)
print v(xbgr.mr_n56508432)
print v(xbgr.mr_n56508752)
print v(xbgr.mr_n56508864)
print v(xbgr.mr_n56509184)
print v(xbgr.mr_n56509296)
print v(xbgr.mr_n56509616)
print v(xbgr.mr_n56509728)
print v(xbgr.mr_n56510048)
print v(xbgr.mr_n56510160)
print v(xbgr.mr_n56510480)
print v(xbgr.mr_n56510592)
print v(xbgr.mr_n56510912)
print v(xbgr.mr_n56511024)
print v(xbgr.mr_n56511344)
print v(xbgr.mr_n56511456)
print v(xbgr.mr_n56511776)
print v(xbgr.mr_n56511888)
print v(xbgr.mr_n56512208)
print v(xbgr.mr_n56512320)
print v(xbgr.mr_n56512640)
print v(xbgr.mr_n56512752)
print v(xbgr.mr_n56513072)
print v(xbgr.mr_n56513184)
print v(xbgr.mr_n56513504)
print v(xbgr.mr_n56513616)
print v(xbgr.mr_n56513936)
print v(xbgr.mr_n56514048)
print v(xbgr.mr_n56514368)
print v(xbgr.mr_n56514480)
print v(xbgr.mr_n56514800)
print v(xbgr.mr_n56514912)
print v(xbgr.mr_n56515232)
print v(xbgr.mr_n56515344)
print v(xbgr.mr_n56515664)
print v(xbgr.mr_n56515776)
print v(xbgr.mr_n56516096)
print v(xbgr.mr_n56516208)
print v(xbgr.mr_n56516528)
print v(xbgr.mr_n56516640)
print v(xbgr.mr_n56516960)
print v(xbgr.mr_n56517072)
print v(xbgr.mr_n56517392)
print v(xbgr.mr_n56517504)
print v(xbgr.mr_n56517824)
print v(xbgr.mr_n56517936)
print v(xbgr.mr_n56518256)
print v(xbgr.mr_n56518368)
print v(xbgr.mr_n56518688)
print v(xbgr.mr_n56518800)
print v(xbgr.mr_n56519120)
print v(xbgr.mr_n56519232)
print v(xbgr.mr_n56519552)
print v(xbgr.mr_n56519664)
print v(xbgr.mr_n56519984)
print v(xbgr.mr_n56520096)
print v(xbgr.mr_n56520416)
print v(xbgr.mr_n56520528)
print v(xbgr.mr_n56520848)
print v(xbgr.mr_n56520960)
print v(xbgr.mr_n56521280)
print v(xbgr.mr_n56521392)
print v(xbgr.mr_n56521712)
print v(xbgr.mr_n56521824)
print v(xbgr.mr_n56522144)
print v(xbgr.mr_n56522256)
print v(xbgr.mr_n56522576)
print v(xbgr.mr_n56522688)
print v(xbgr.mr_n56523008)
print v(xbgr.mr_n56523120)
print v(xbgr.mr_n56523440)
print v(xbgr.mr_n56523552)
print v(xbgr.mr_n56523872)
print v(xbgr.mr_n56523984)
print v(xbgr.mr_n56524304)
print v(xbgr.mr_n56524416)
print v(xbgr.mr_n56524736)
print v(xbgr.mr_n56524848)
print v(xbgr.mr_n56525168)
print v(xbgr.mr_n56525280)
print v(xbgr.mr_n56525600)
print v(xbgr.mr_n56525712)
print v(xbgr.mr_n56526032)
print v(xbgr.mr_n56526144)
print v(xbgr.mr_n56526464)
print v(xbgr.mr_n56526576)
print v(xbgr.mr_n56526896)
print v(xbgr.mr_n56527008)
print v(xbgr.mr_n56527328)
print v(xbgr.mr_n56527440)
print v(xbgr.mr_n56527760)
print v(xbgr.mr_n56527872)
print v(xbgr.mr_n56528192)
print v(xbgr.mr_n56528304)
print v(xbgr.mr_n56528624)
print v(xbgr.mr_n56528736)
print v(xbgr.mr_n56529056)
print v(xbgr.mr_n56529168)
print v(xbgr.mr_n56529488)
print v(xbgr.mr_n56529600)
print v(xbgr.mr_n56529920)
print v(xbgr.mr_n56530032)
print v(xbgr.mr_n56530352)
print v(xbgr.mr_n56530464)
print v(xbgr.mr_n56530784)
print v(xbgr.mr_n56530896)
print v(xbgr.mr_n56531216)
print v(xbgr.mr_n56531328)
print v(xbgr.mr_n56531648)
print v(xbgr.mr_n56531760)
print v(xbgr.mr_n56532080)
print v(xbgr.mr_n56532192)
print v(xbgr.mr_n56532512)
print v(xbgr.mr_n56532624)
print v(xbgr.mr_n56532944)
print v(xbgr.mr_n56533056)
print v(xbgr.mr_n56533376)
print v(xbgr.mr_n56533488)
print v(xbgr.mr_n56533808)
print v(xbgr.mr_n56533920)
print v(xbgr.mr_n56534240)
print v(xbgr.mr_n56534352)
print v(xbgr.mr_n56534672)
print v(xbgr.mr_n56534784)
print v(xbgr.mr_n56535104)
print v(xbgr.mr_n56535216)
print v(xbgr.mr_n56535536)
print v(xbgr.mr_n56535648)
print v(xbgr.mr_n56535968)
print v(xbgr.mr_n56536080)
print v(xbgr.mr_n56536400)
print v(xbgr.mr_n56536512)
print v(xbgr.mr_n56536832)
print v(xbgr.mr_n56536944)
print v(xbgr.mr_n56537264)
print v(xbgr.mr_n56537376)
print v(xbgr.mr_n56537696)
print v(xbgr.mr_n56537808)
print v(xbgr.mr_n56538128)
print v(xbgr.mr_n56538240)
print v(xbgr.mr_n56538560)
print v(xbgr.mr_n56538672)
print v(xbgr.mr_n56538992)
print v(xbgr.mr_n56539104)
print v(xbgr.mr_n56539424)
print v(xbgr.mr_n56539536)
print v(xbgr.mr_n56539856)
print v(xbgr.mr_n56539968)
print v(xbgr.mr_n56540288)
print v(xbgr.mr_n56540400)
print v(xbgr.mr_n56540720)
print v(xbgr.mr_n56540832)
print v(xbgr.mr_n56541152)
print v(xbgr.mr_n56541264)
print v(xbgr.mr_n56541584)
print v(xbgr.mr_n56541696)
print v(xbgr.mr_n56542016)
print v(xbgr.mr_n56542128)
print v(xbgr.mr_n56542448)
print v(xbgr.mr_n56542560)
print v(xbgr.mr_n56542880)
print v(xbgr.mr_n56542992)
print v(xbgr.mr_n56543312)
print v(xbgr.mr_n56543424)
print v(xbgr.mr_n56543744)
print v(xbgr.mr_n56543856)
print v(xbgr.mr_n56544176)
print v(xbgr.mr_n56544288)
print v(xbgr.mr_n56544608)
print v(xbgr.mr_n56544720)
print v(xbgr.mr_n56545040)
print v(xbgr.mr_n56545152)
print v(xbgr.mr_n56545472)
print v(xbgr.mr_n56545584)
print v(xbgr.mr_n56545904)
print v(xbgr.mr_n56546016)
print v(xbgr.mr_n56546336)
print v(xbgr.mr_n56546448)
print v(xbgr.mr_n56546768)
print v(xbgr.mr_n56546880)
print v(xbgr.mr_n56547200)
print v(xbgr.mr_n56547312)
print v(xbgr.mr_n56547632)
print v(xbgr.mr_n56547744)
print v(xbgr.mr_n56548064)
print v(xbgr.mr_n56548176)
print v(xbgr.mr_n56548496)
print v(xbgr.mr_n56548608)
print v(xbgr.mr_n56548928)
print v(xbgr.mr_n56549040)
print v(xbgr.mr_n56549360)
print v(xbgr.mr_n56549472)
print v(xbgr.mr_n56549792)
print v(xbgr.mr_n56549904)
print v(xbgr.mr_n56550224)
print v(xbgr.mr_n56550336)
print v(xbgr.mr_n56550656)
print v(xbgr.mr_n56550768)
print v(xbgr.mr_n56551088)
print v(xbgr.mr_n56551200)
print v(xbgr.mr_n56551520)
print v(xbgr.mr_n56551632)
print v(xbgr.mr_n56551952)
print v(xbgr.mr_n56552064)
print v(xbgr.mr_n56552384)
print v(xbgr.mr_n56552496)
print v(xbgr.mr_n56552816)
print v(xbgr.mr_n56552928)
print v(xbgr.mr_n56553248)
print v(xbgr.mr_n56553360)
print v(xbgr.mr_n56553680)
print v(xbgr.mr_n56553792)
print v(xbgr.mr_n56554112)
print v(xbgr.mr_n56554224)
print v(xbgr.mr_n56554544)
print v(xbgr.mr_n56554656)
print v(xbgr.mr_n56554976)
print v(xbgr.mr_n56555088)
print v(xbgr.mr_n56555408)
print v(xbgr.mr_n56555520)
print v(xbgr.mr_n56555840)
print v(xbgr.mr_n56555952)
print v(xbgr.mr_n56556272)
print v(xbgr.mr_n56556384)
print v(xbgr.mr_n56556704)
print v(xbgr.mr_n56556816)
print v(xbgr.mr_n56557136)
print v(xbgr.mr_n56557248)
print v(xbgr.mr_n56557568)
print v(xbgr.mr_n56557680)
print v(xbgr.mr_n56558000)
print v(xbgr.mr_n56558112)
print v(xbgr.mr_n56558432)
print v(xbgr.mr_n56558544)
print v(xbgr.mr_n56558864)
print v(xbgr.mr_n56558976)
print v(xbgr.mr_n56559296)
print v(xbgr.mr_n56559408)
print v(xbgr.mr_n56559728)
print v(xbgr.mr_n56559840)
print v(xbgr.mr_n56560160)
print v(xbgr.mr_n56560272)
print v(xbgr.mr_n56560592)
print v(xbgr.mr_n56560704)
print v(xbgr.mr_n56561024)
print v(xbgr.mr_n56561136)
print v(xbgr.mr_n56561456)
print v(xbgr.mr_n56561568)
print v(xbgr.mr_n56561888)
print v(xbgr.mr_n56562000)
print v(xbgr.mr_n56562320)
print v(xbgr.mr_n56562432)
print v(xbgr.mr_n56562752)
print v(xbgr.mr_n56562864)
print v(xbgr.mr_n56563184)
print v(xbgr.mr_n56563296)
print v(xbgr.mr_n56563616)
print v(xbgr.mr_n56563728)
print v(xbgr.mr_n56564048)
print v(xbgr.mr_n56564160)
print v(xbgr.mr_n56564480)
print v(xbgr.mr_n56564592)
print v(xbgr.mr_n56564912)
print v(xbgr.mr_n56565024)
print v(xbgr.mr_n56565344)
print v(xbgr.mr_n56565456)
print v(xbgr.mr_n56565776)
print v(xbgr.mr_n56565888)
print v(xbgr.mr_n56566208)
print v(xbgr.mr_n56566320)
print v(xbgr.mr_n56566640)
print v(xbgr.mr_n56566752)
print v(xbgr.mr_n56567072)
print v(xbgr.mr_n56567184)
print v(xbgr.mr_n56567504)
print v(xbgr.mr_n56567616)
print v(xbgr.mr_n56567936)
print v(xbgr.mr_n56568048)
print v(xbgr.mr_n56568368)
print v(xbgr.mr_n56568480)
print v(xbgr.mr_n56568800)
print v(xbgr.mr_n56568912)
print v(xbgr.mr_n56569232)
print v(xbgr.mr_n56569344)
print v(xbgr.mr_n56569664)
print v(xbgr.mr_n56569776)
print v(xbgr.mr_n56570096)
print v(xbgr.mr_n56570208)
print v(xbgr.mr_n56570528)
print v(xbgr.mr_n56570640)
print v(xbgr.mr_n56570960)
print v(xbgr.mr_n56571072)
print v(xbgr.mr_n56571392)
print v(xbgr.mr_n56571504)
print v(xbgr.mr_n56571824)
print v(xbgr.mr_n56571936)
print v(xbgr.mr_n56572256)
print v(xbgr.mr_n56572368)
print v(xbgr.mr_n56572688)
print v(xbgr.mr_n56572800)
print v(xbgr.mr_n56573120)
print v(xbgr.mr_n56573232)
print v(xbgr.mr_n56573552)
print v(xbgr.mr_n56573664)
print v(xbgr.mr_n56573984)
print v(xbgr.mr_n56574096)
print v(xbgr.mr_n56574416)
print v(xbgr.mr_n56574528)
print v(xbgr.mr_n56574848)
print v(xbgr.mr_n56574960)
print v(xbgr.mr_n56575280)
print v(xbgr.mr_n56575392)
print v(xbgr.mr_n56575712)
print v(xbgr.mr_n56575824)
print v(xbgr.mr_n56576144)
print v(xbgr.mr_n56576256)
print v(xbgr.mr_n56576576)
print v(xbgr.mr_n56576688)
print v(xbgr.mr_n56577008)
print v(xbgr.mr_n56577120)
print v(xbgr.mr_n56577440)
print v(xbgr.mr_n56577552)
print v(xbgr.mr_n56577872)
print v(xbgr.mr_n56577984)
print v(xbgr.mr_n56578304)
print v(xbgr.mr_n56578416)
print v(xbgr.mr_n56578736)
print v(xbgr.mr_n56578848)
print v(xbgr.mr_n56579168)
print v(xbgr.mr_n56579280)
print v(xbgr.mr_n56579600)
print v(xbgr.mr_n56579712)
print v(xbgr.mr_n56580032)
print v(xbgr.mr_n56580144)
print v(xbgr.mr_n56580464)
print v(xbgr.mr_n56580576)
print v(xbgr.mr_n56580896)
print v(xbgr.mr_n56581008)
print v(xbgr.mr_n56581328)
print v(xbgr.mr_n56581440)
print v(xbgr.mr_n56581760)
print v(xbgr.mr_n56581872)
print v(xbgr.mr_n56582192)
print v(xbgr.mr_n56582304)
print v(xbgr.mr_n56582624)
print v(xbgr.mr_n56582736)
print v(xbgr.mr_n56583056)
print v(xbgr.mr_n56583168)
print v(xbgr.mr_n56583488)
print v(xbgr.mr_n56583600)
print v(xbgr.mr_n56583920)
print v(xbgr.mr_n56584032)
print v(xbgr.mr_n56584352)
print v(xbgr.mr_n56584464)
print v(xbgr.mr_n56584784)
print v(xbgr.mr_n56584896)
print v(xbgr.mr_n56585216)
print v(xbgr.mr_n56585328)
print v(xbgr.mr_n56585648)
print v(xbgr.mr_n56585760)
print v(xbgr.mr_n56586080)
print v(xbgr.mr_n56586192)
print v(xbgr.mr_n56586512)
print v(xbgr.mr_n56586624)
print v(xbgr.mr_n56586944)
print v(xbgr.mr_n56587056)
print v(xbgr.mr_n56587376)
print v(xbgr.mr_n56587488)
print v(xbgr.mr_n56587808)
print v(xbgr.mr_n56587920)
print v(xbgr.mr_n56588240)
print v(xbgr.mr_n56588352)
print v(xbgr.mr_n56588672)
print v(xbgr.mr_n56588784)
print v(xbgr.mr_n56589104)
print v(xbgr.mr_n56589216)
print v(xbgr.mr_n56589536)
print v(xbgr.mr_n56589648)
print v(xbgr.mr_n56589968)
print v(xbgr.mr_n56590080)
print v(xbgr.mr_n56590400)
print v(xbgr.mr_n56590512)
print v(xbgr.mr_n56590832)
print v(xbgr.mr_n56590944)
print v(xbgr.mr_n56591264)
print v(xbgr.mr_n56591376)
print v(xbgr.mr_n56591696)
print v(xbgr.mr_n56591808)
print v(xbgr.mr_n56592128)
print v(xbgr.mr_n56592240)
print v(xbgr.mr_n56592560)
print v(xbgr.mr_n56592672)
print v(xbgr.mr_n56592992)
print v(xbgr.mr_n56593104)
print v(xbgr.mr_n56593424)
print v(xbgr.mr_n56593536)
print v(xbgr.mr_n56593856)
print v(xbgr.mr_n56593968)
print v(xbgr.mr_n56594288)
print v(xbgr.mr_n56594400)
print v(xbgr.mr_n56594720)
print v(xbgr.mr_n56594832)
print v(xbgr.mr_n56595152)
print v(xbgr.mr_n56595264)
print v(xbgr.mr_n56595584)
print v(xbgr.mr_n56595696)
print v(xbgr.mr_n56596016)
print v(xbgr.mr_n56596128)
print v(xbgr.mr_n56596448)
print v(xbgr.mr_n56596560)
print v(xbgr.mr_n56596880)
print v(xbgr.mr_n56596992)
print v(xbgr.mr_n56597312)
print v(xbgr.mr_n56597424)
print v(xbgr.mr_n56597744)
print v(xbgr.mr_n56597856)
print v(xbgr.mr_n56598176)
print v(xbgr.mr_n56598288)
print v(xbgr.mr_n56598608)
print v(xbgr.mr_n56598720)
print v(xbgr.mr_n56599040)
print v(xbgr.mr_n56599152)
print v(xbgr.mr_n56599472)
print v(xbgr.mr_n56599584)
print v(xbgr.mr_n56599904)
print v(xbgr.mr_n56600016)
print v(xbgr.mr_n56600336)
print v(xbgr.mr_n56600448)
print v(xbgr.mr_n56600768)
print v(xbgr.mr_n56600880)
print v(xbgr.mr_n56601200)
print v(xbgr.mr_n56601312)
print v(xbgr.mr_n56601632)
print v(xbgr.mr_n56601744)
print v(xbgr.mr_n56602064)
print v(xbgr.mr_n56602176)
print v(xbgr.mr_n56602496)
print v(xbgr.mr_n56602608)
print v(xbgr.mr_n56602928)
print v(xbgr.mr_n56603040)
print v(xbgr.mr_n56603360)
print v(xbgr.mr_n56603472)
print v(xbgr.mr_n56603792)
print v(xbgr.mr_n56603904)
print v(xbgr.mr_n56604224)
print v(xbgr.mr_n56604336)
print v(xbgr.mr_n56604656)
print v(xbgr.mr_n56604768)
print v(xbgr.mr_n56605088)
print v(xbgr.mr_n56605200)
print v(xbgr.mr_n56605520)
print v(xbgr.mr_n56605632)
print v(xbgr.mr_n56605952)
print v(xbgr.mr_n56606064)
print v(xbgr.mr_n56606384)
print v(xbgr.mr_n56606496)
print v(xbgr.mr_n56606816)
print v(xbgr.mr_n56606928)
print v(xbgr.mr_n56607248)
print v(xbgr.mr_n56607360)
print v(xbgr.mr_n56607680)
print v(xbgr.mr_n56607792)
print v(xbgr.mr_n56608112)
print v(xbgr.mr_n56608224)
print v(xbgr.mr_n56608544)
print v(xbgr.mr_n56608656)
print v(xbgr.mr_n56608976)
print v(xbgr.mr_n56609088)
print v(xbgr.mr_n56609408)
print v(xbgr.mr_n56609520)
print v(xbgr.mr_n56609840)
print v(xbgr.mr_n56609952)
print v(xbgr.mr_n56610272)
print v(xbgr.mr_n56610384)
print v(xbgr.mr_n56610704)
print v(xbgr.mr_n56610816)
print v(xbgr.mr_n56611136)
print v(xbgr.mr_n56611248)
print v(xbgr.mr_n56611568)
print v(xbgr.mr_n56611680)
print v(xbgr.mr_n56612000)
print v(xbgr.mr_n56612112)
print v(xbgr.mr_n56612432)
print v(xbgr.mr_n56612544)
print v(xbgr.mr_n56612864)
print v(xbgr.mr_n56612976)
print v(xbgr.mr_n56613296)
print v(xbgr.mr_n56613408)
print v(xbgr.mr_n56613728)
print v(xbgr.mr_n56613840)
print v(xbgr.mr_n56614160)
print v(xbgr.mr_n56614272)
print v(xbgr.mr_n56614592)
print v(xbgr.mr_n56614704)
print v(xbgr.mr_n56615024)
print v(xbgr.mr_n56615136)
print v(xbgr.mr_n56615456)
print v(xbgr.mr_n56615568)
print v(xbgr.mr_n56616000)
print v(xbgr.mr_n56616320)
print v(xbgr.mr_n56616432)
print v(xbgr.mr_n56616752)
print v(xbgr.mr_n56616864)
print v(xbgr.mr_n56617184)
print v(xbgr.mr_n56617296)
print v(xbgr.mr_n56617728)
print v(xbgr.mr_n56618048)
print v(xbgr.mr_n56618160)
print v(xbgr.mr_n56618480)
print v(xbgr.mr_n56618592)
print v(xbgr.mr_n56618912)
print v(xbgr.mr_n56619024)
print v(xbgr.mr_n56619344)
print v(xbgr.mr_n56619456)
print v(xbgr.mr_n56619776)
print v(xbgr.mr_n56619888)
print v(xbgr.mr_n56620208)
print v(xbgr.mr_n56620320)
print v(xbgr.mr_n56620640)
print v(xbgr.mr_n56620752)
print v(xbgr.mr_n56621072)
print v(xbgr.mr_n56621184)
print v(xbgr.mr_n56621504)
print v(xbgr.mr_n56621616)
print v(xbgr.mr_n56621936)
print v(xbgr.mr_n56622048)
print v(xbgr.mr_n56622368)
print v(xbgr.mr_n56622480)
print v(xbgr.mr_n56622800)
print v(xbgr.mr_n56622912)
print v(xbgr.mr_n56623232)
print v(xbgr.mr_n56623344)
print v(xbgr.mr_n56623664)
print v(xbgr.mr_n56623776)
print v(xbgr.mr_n56624096)
print v(xbgr.mr_n56624208)
print v(xbgr.mr_n56624640)
print v(xbgr.mr_n56624960)
print v(xbgr.mr_n56625072)
print v(xbgr.mr_n56625392)
print v(xbgr.mr_n56625504)
print v(xbgr.mr_n56625824)
print v(xbgr.mr_n56625936)
print v(xbgr.mr_n56626256)
print v(xbgr.mr_n56626368)
print v(xbgr.mr_n56626688)
print v(xbgr.mr_n56626800)
print v(xbgr.mr_n56627120)
print v(xbgr.mr_n56627232)
print v(xbgr.mr_n56627552)
print v(xbgr.mr_n56627664)
print v(xbgr.mr_n56628096)
print v(xbgr.mr_n56628416)
print v(xbgr.mr_n56628528)
print v(xbgr.mr_n56628848)
print v(xbgr.mr_n56628960)
print v(xbgr.mr_n56629280)
print v(xbgr.mr_n56629392)
print v(xbgr.mr_n56629712)
print v(xbgr.mr_n56629824)
print v(xbgr.mr_n56630144)
print v(xbgr.mr_n56630256)
print v(xbgr.mr_n56630576)
print v(xbgr.mr_n56630688)
print v(xbgr.mr_n56631008)
print v(xbgr.mr_n56631120)
print v(xbgr.mr_n56631440)
print v(xbgr.mr_n56631552)
print v(xbgr.mr_n56631872)
print v(xbgr.mr_n56631984)
print v(xbgr.mr_n56632304)
print v(xbgr.mr_n56632416)
print v(xbgr.mr_n56632736)
print v(xbgr.mr_n56632848)
print v(xbgr.mr_n56633168)
print v(xbgr.mr_n56633280)
print v(xbgr.mr_n56633600)
print v(xbgr.mr_n56633712)
print v(xbgr.mr_n56634144)
print v(xbgr.mr_n56634464)
print v(xbgr.mr_n56634576)
print v(xbgr.mr_n56634896)
print v(xbgr.mr_n56635008)
print v(xbgr.mr_n56635328)
print v(xbgr.mr_n56635440)
print v(xbgr.mr_n56635872)
print v(xbgr.mr_n56636192)
print v(xbgr.mr_n56636304)
print v(xbgr.mr_n56636624)
print v(xbgr.mr_n56636736)
print v(xbgr.mr_n56637056)
print v(xbgr.mr_n56637168)
print v(xbgr.mr_n56637488)
print v(xbgr.mr_n56637600)
print v(xbgr.mr_n56637920)
print v(xbgr.mr_n56638032)
print v(xbgr.mr_n56638464)
print v(xbgr.mr_n56638784)
print v(xbgr.mr_n56638896)
print v(xbgr.mr_n56639216)
print v(xbgr.mr_n56639328)
print v(xbgr.mr_n56639648)
print v(xbgr.mr_n56639760)
print v(xbgr.mr_n56640080)
print v(xbgr.mr_n56640192)
print v(xbgr.mr_n56640512)
print v(xbgr.mr_n56640624)
print v(xbgr.mr_n56640944)
print v(xbgr.mr_n56641056)
print v(xbgr.mr_n56641376)
print v(xbgr.mr_n56641488)
print v(xbgr.mr_n56641808)
print v(xbgr.mr_n56641920)
print v(xbgr.mr_n56642240)
print v(xbgr.mr_n56642352)
print v(xbgr.mr_n56642672)
print v(xbgr.mr_n56642784)
print v(xbgr.mr_n56643104)
print v(xbgr.mr_n56643216)
print v(xbgr.mr_n56643536)
print v(xbgr.mr_n56643648)
print v(xbgr.mr_n56643968)
print v(xbgr.mr_n56644080)
print v(xbgr.mr_n56644512)
print v(xbgr.mr_n56644832)
print v(xbgr.mr_n56644944)
print v(xbgr.mr_n56645264)
print v(xbgr.mr_n56645376)
print v(xbgr.mr_n56645696)
print v(xbgr.mr_n56645808)
print v(xbgr.mr_n56646240)
print v(xbgr.mr_n56646560)
print v(xbgr.mr_n56646672)
print v(xbgr.mr_n56647104)
print v(xbgr.mr_n56647424)
print v(xbgr.mr_n56647536)
print v(xbgr.mr_n56647856)
print v(xbgr.mr_n56647968)
print v(xbgr.mr_n56648288)
print v(xbgr.mr_n56648400)
print v(xbgr.mr_n56648832)
print v(xbgr.mr_n56649152)
print v(xbgr.mr_n56649264)
print v(xbgr.mr_n56649584)
print v(xbgr.mr_n56649696)
print v(xbgr.mr_n56650016)
print v(xbgr.mr_n56650128)
print v(xbgr.mr_n56650448)
print v(xbgr.mr_n56650560)
print v(xbgr.mr_n56650880)
print v(xbgr.mr_n56650992)
print v(xbgr.mr_n56651312)
print v(xbgr.mr_n56651424)
print v(xbgr.mr_n56651744)
print v(xbgr.mr_n56651856)
print v(xbgr.mr_n56652176)
print v(xbgr.mr_n56652288)
print v(xbgr.mr_n56652608)
print v(xbgr.mr_n56652720)
print v(xbgr.mr_n56653152)
print v(xbgr.mr_n56653472)
print v(xbgr.mr_n56653584)
print v(xbgr.mr_n56653904)
print v(xbgr.mr_n56654016)
print v(xbgr.mr_n56654336)
print v(xbgr.mr_n56654448)
print v(xbgr.mr_n56654768)
print v(xbgr.mr_n56654880)
print v(xbgr.mr_n56655200)
print v(xbgr.mr_n56655312)
print v(xbgr.mr_n56655632)
print v(xbgr.mr_n56655744)
print v(xbgr.mr_n56656064)
print v(xbgr.mr_n56656176)
print v(xbgr.mr_n56656496)
print v(xbgr.mr_n56656608)
print v(xbgr.mr_n56656928)
print v(xbgr.mr_n56657040)
print v(xbgr.mr_n56657360)
print v(xbgr.mr_n56657472)
print v(xbgr.mr_n56657792)
print v(xbgr.mr_n56657904)
print v(xbgr.mr_n56658224)
print v(xbgr.mr_n56658336)
print v(xbgr.mr_n56658656)
print v(xbgr.mr_n56658768)
print v(xbgr.mr_n56659088)
print v(xbgr.mr_n56659200)
print v(xbgr.mr_n56659520)
print v(xbgr.mr_n56659632)
print v(xbgr.mr_n56659952)
print v(xbgr.mr_n56660064)
print v(xbgr.mr_n56660384)
print v(xbgr.mr_n56660496)
print v(xbgr.mr_n56660816)
print v(xbgr.mr_n56660928)
print v(xbgr.mr_n56661248)
print v(xbgr.mr_n56661360)
print v(xbgr.mr_n56661680)
print v(xbgr.mr_n56661792)
print v(xbgr.mr_n56662112)
print v(xbgr.mr_n56662224)
print v(xbgr.mr_n56662544)
print v(xbgr.mr_n56662656)
print v(xbgr.mr_n56662976)
print v(xbgr.mr_n56663088)
print v(xbgr.mr_n56663408)
print v(xbgr.mr_n56663520)
print v(xbgr.mr_n56663840)
print v(xbgr.mr_n56663952)
print v(xbgr.mr_n56664272)
print v(xbgr.mr_n56664384)
print v(xbgr.mr_n56664704)
print v(xbgr.mr_n56664816)
print v(xbgr.mr_n56665136)
print v(xbgr.mr_n56665248)
print v(xbgr.mr_n56665568)
print v(xbgr.mr_n56665680)
print v(xbgr.mr_n56666000)
print v(xbgr.mr_n56666112)
print v(xbgr.mr_n56666432)
print v(xbgr.mr_n56666544)
print v(xbgr.mr_n56666864)
print v(xbgr.mr_n56666976)
print v(xbgr.mr_n56667296)
print v(xbgr.mr_n56667408)
print v(xbgr.mr_n56667728)
print v(xbgr.mr_n56667840)
print v(xbgr.mr_n56668160)
print v(xbgr.mr_n56668272)
print v(xbgr.mr_n56668592)
print v(xbgr.mr_n56668704)
print v(xbgr.mr_n56669024)
print v(xbgr.mr_n56669136)
print v(xbgr.mr_n56669456)
print v(xbgr.mr_n56669568)
print v(xbgr.mr_n56669888)
print v(xbgr.mr_n56670000)
print v(xbgr.mr_n56670320)
print v(xbgr.mr_n56670432)
print v(xbgr.mr_n56670752)
print v(xbgr.mr_n56670864)
print v(xbgr.mr_n56671184)
print v(xbgr.mr_n56671296)
print v(xbgr.mr_n56671616)
print v(xbgr.mr_n56671728)
print v(xbgr.mr_n56672048)
print v(xbgr.mr_n56672160)
print v(xbgr.mr_n56672480)
print v(xbgr.mr_n56672592)
print v(xbgr.mr_n56672912)
print v(xbgr.mr_n56673024)
print v(xbgr.mr_n56673344)
print v(xbgr.mr_n56673456)
print v(xbgr.mr_n56673776)
print v(xbgr.mr_n56673888)
print v(xbgr.mr_n56674208)
print v(xbgr.mr_n56674320)
print v(xbgr.mr_n56674640)
print v(xbgr.mr_n56674752)
print v(xbgr.mr_n56675072)
print v(xbgr.mr_n56675184)
print v(xbgr.mr_n56675504)
print v(xbgr.mr_n56675616)
print v(xbgr.mr_n56675936)
print v(xbgr.mr_n56676048)
print v(xbgr.mr_n56676368)
print v(xbgr.mr_n56676480)
print v(xbgr.mr_n56676800)
print v(xbgr.mr_n56676912)
print v(xbgr.mr_n56677232)
print v(xbgr.mr_n56677344)
print v(xbgr.mr_n56677664)
print v(xbgr.mr_n56677776)
print v(xbgr.mr_n56678096)
print v(xbgr.mr_n56678208)
print v(xbgr.mr_n56678528)
print v(xbgr.mr_n56678640)
print v(xbgr.mr_n56678960)
print v(xbgr.mr_n56679072)
print v(xbgr.mr_n56679392)
print v(xbgr.mr_n56679504)
print v(xbgr.mr_n56679824)
print v(xbgr.mr_n56679936)
print v(xbgr.mr_n56680256)
print v(xbgr.mr_n56680368)
print v(xbgr.mr_n56680688)
print v(xbgr.mr_n56680800)
print v(xbgr.mr_n56681120)
print v(xbgr.mr_n56681232)
print v(xbgr.mr_n56681552)
print v(xbgr.mr_n56681664)
print v(xbgr.mr_n56681984)
print v(xbgr.mr_n56682096)
print v(xbgr.mr_n56682416)
print v(xbgr.mr_n56682528)
print v(xbgr.mr_n56682848)
print v(xbgr.mr_n56682960)
print v(xbgr.mr_n56683280)
print v(xbgr.mr_n56683392)
print v(xbgr.mr_n56683712)
print v(xbgr.mr_n56683824)
print v(xbgr.mr_n56684144)
print v(xbgr.mr_n56684256)
print v(xbgr.mr_n56684576)
print v(xbgr.mr_n56684688)
print v(xbgr.mr_n56685008)
print v(xbgr.mr_n56685120)
print v(xbgr.mr_n56685440)
print v(xbgr.mr_n56685552)
print v(xbgr.mr_n56685872)
print v(xbgr.mr_n56685984)
print v(xbgr.mr_n56686304)
print v(xbgr.mr_n56686416)
print v(xbgr.mr_n56686736)
print v(xbgr.mr_n56686848)
print v(xbgr.mr_n56687168)
print v(xbgr.mr_n56687280)
print v(xbgr.mr_n56687600)
print v(xbgr.mr_n56687712)
print v(xbgr.mr_n56688032)
print v(xbgr.mr_n56688144)
print v(xbgr.mr_n56688464)
print v(xbgr.mr_n56688576)
print v(xbgr.mr_n56688896)
print v(xbgr.mr_n56689008)
print v(xbgr.mr_n56689328)
print v(xbgr.mr_n56689440)
print v(xbgr.mr_n56689760)
print v(xbgr.mr_n56689872)
print v(xbgr.mr_n56690192)
print v(xbgr.mr_n56690304)
print v(xbgr.mr_n56690624)
print v(xbgr.mr_n56690736)
print v(xbgr.mr_n56691056)
print v(xbgr.mr_n56691168)
print v(xbgr.mr_n56691488)
print v(xbgr.mr_n56691600)
print v(xbgr.mr_n56691920)
print v(xbgr.mr_n56692032)
print v(xbgr.mr_n56692352)
print v(xbgr.mr_n56692464)
print v(xbgr.mr_n56692784)
print v(xbgr.mr_n56692896)
print v(xbgr.mr_n56693216)
print v(xbgr.mr_n56693328)
print v(xbgr.mr_n56693648)
print v(xbgr.mr_n56693760)
print v(xbgr.mr_n56694080)
print v(xbgr.mr_n56694192)
print v(xbgr.mr_n56694512)
print v(xbgr.mr_n56694624)
print v(xbgr.mr_n56694944)
print v(xbgr.mr_n56695056)
print v(xbgr.mr_n56695376)
print v(xbgr.mr_n56695488)
print v(xbgr.mr_n56695808)
print v(xbgr.mr_n56695920)
print v(xbgr.mr_n56696240)
print v(xbgr.mr_n56696352)
print v(xbgr.mr_n56696672)
print v(xbgr.mr_n56696784)
print v(xbgr.mr_n56697104)
print v(xbgr.mr_n56697216)
print v(xbgr.mr_n56697536)
print v(xbgr.mr_n56697648)
print v(xbgr.mr_n56697968)
print v(xbgr.mr_n56698080)
print v(xbgr.mr_n56698400)
print v(xbgr.mr_n56698512)
print v(xbgr.mr_n56698832)
print v(xbgr.mr_n56698944)
print v(xbgr.mr_n56699264)
print v(xbgr.mr_n56699376)
print v(xbgr.mr_n56699696)
print v(xbgr.mr_n56699808)
print v(xbgr.mr_n56700128)
print v(xbgr.mr_n56700240)
print v(xbgr.mr_n56700560)
print v(xbgr.mr_n56700672)
print v(xbgr.mr_n56700992)
print v(xbgr.mr_n56701104)
print v(xbgr.mr_n56701424)
print v(xbgr.mr_n56701536)
print v(xbgr.mr_n56701856)
print v(xbgr.mr_n56701968)
print v(xbgr.mr_n56702288)
print v(xbgr.mr_n56702400)
print v(xbgr.mr_n56702720)
print v(xbgr.mr_n56702832)
print v(xbgr.mr_n56703152)
print v(xbgr.mr_n56703264)
print v(xbgr.mr_n56703584)
print v(xbgr.mr_n56703696)
print v(xbgr.mr_n56704016)
print v(xbgr.mr_n56704128)
print v(xbgr.mr_n56704448)
print v(xbgr.mr_n56704560)
print v(xbgr.mr_n56704880)
print v(xbgr.mr_n56704992)
print v(xbgr.mr_n56705312)
print v(xbgr.mr_n56705424)
print v(xbgr.mr_n56705744)
print v(xbgr.mr_n56705856)
print v(xbgr.mr_n56706176)
print v(xbgr.mr_n56706288)
print v(xbgr.mr_n56706608)
print v(xbgr.mr_n56706720)
print v(xbgr.mr_n56707040)
print v(xbgr.mr_n56707152)
print v(xbgr.mr_n56707472)
print v(xbgr.mr_n56707584)
print v(xbgr.mr_n56707904)
print v(xbgr.mr_n56708016)
print v(xbgr.mr_n56708336)
print v(xbgr.mr_n56708448)
print v(xbgr.mr_n56708768)
print v(xbgr.mr_n56708880)
print v(xbgr.mr_n56709200)
print v(xbgr.mr_n56709312)
print v(xbgr.mr_n56709632)
print v(xbgr.mr_n56709744)
print v(xbgr.mr_n56710064)
print v(xbgr.mr_n56710176)
print v(xbgr.mr_n56710496)
print v(xbgr.mr_n56710608)
print v(xbgr.mr_n56710928)
print v(xbgr.mr_n56711040)
print v(xbgr.mr_n56711360)
print v(xbgr.mr_n56711472)
print v(xbgr.mr_n56711792)
print v(xbgr.mr_n56711904)
print v(xbgr.mr_n56712224)
print v(xbgr.mr_n56712336)
print v(xbgr.mr_n56712656)
print v(xbgr.mr_n56712768)
print v(xbgr.mr_n56713088)
print v(xbgr.mr_n56713200)
print v(xbgr.mr_n56713520)
print v(xbgr.mr_n56713632)
print v(xbgr.mr_n56713952)
print v(xbgr.mr_n56714064)
print v(xbgr.mr_n56714384)
print v(xbgr.mr_n56714496)
print v(xbgr.mr_n56714816)
print v(xbgr.mr_n56714928)
print v(xbgr.mr_n56715248)
print v(xbgr.mr_n56715360)
print v(xbgr.mr_n56715680)
print v(xbgr.mr_n56715792)
print v(xbgr.mr_n56716112)
print v(xbgr.mr_n56716224)
print v(xbgr.mr_n56716544)
print v(xbgr.mr_n56716656)
print v(xbgr.mr_n56716976)
print v(xbgr.mr_n56717088)
print v(xbgr.mr_n56717408)
print v(xbgr.mr_n56717520)
print v(xbgr.mr_n56717840)
print v(xbgr.mr_n56717952)
print v(xbgr.mr_n56718272)
print v(xbgr.mr_n56718384)
print v(xbgr.mr_n56718704)
print v(xbgr.mr_n56718816)
print v(xbgr.mr_n56719136)
print v(xbgr.mr_n56719248)
print v(xbgr.mr_n56719568)
print v(xbgr.mr_n56719680)
print v(xbgr.mr_n56720000)
print v(xbgr.mr_n56720112)
print v(xbgr.mr_n56720432)
print v(xbgr.mr_n56720544)
print v(xbgr.mr_n56720864)
print v(xbgr.mr_n56720976)
print v(xbgr.mr_n56721296)
print v(xbgr.mr_n56721408)
print v(xbgr.mr_n56721728)
print v(xbgr.mr_n56721840)
print v(xbgr.mr_n56722160)
print v(xbgr.mr_n56722272)
print v(xbgr.mr_n56722592)
print v(xbgr.mr_n56722704)
print v(xbgr.mr_n56723024)
print v(xbgr.mr_n56723136)
print v(xbgr.mr_n56723456)
print v(xbgr.mr_n56723568)
print v(xbgr.mr_n56723888)
print v(xbgr.mr_n56724000)
print v(xbgr.mr_n56724320)
print v(xbgr.mr_n56724432)
print v(xbgr.mr_n56724752)
print v(xbgr.mr_n56724864)
print v(xbgr.mr_n56725184)
print v(xbgr.mr_n56725296)
print v(xbgr.mr_n56725616)
print v(xbgr.mr_n56725728)
print v(xbgr.mr_n56726048)
print v(xbgr.mr_n56726160)
print v(xbgr.mr_n56726480)
print v(xbgr.mr_n56726592)
print v(xbgr.mr_n56726912)
print v(xbgr.mr_n56727024)
print v(xbgr.mr_n56727344)
print v(xbgr.mr_n56727456)
print v(xbgr.mr_n56727776)
print v(xbgr.mr_n56727888)
print v(xbgr.mr_n56728208)
print v(xbgr.mr_n56728320)
print v(xbgr.mr_n56728640)
print v(xbgr.mr_n56728752)
print v(xbgr.mr_n56729072)
print v(xbgr.mr_n56729184)
print v(xbgr.mr_n56729504)
print v(xbgr.mr_n56729616)
print v(xbgr.mr_n56729936)
print v(xbgr.mr_n56730048)
print v(xbgr.mr_n56730368)
print v(xbgr.mr_n56730480)
print v(xbgr.mr_n56730800)
print v(xbgr.mr_n56730912)
print v(xbgr.mr_n56731232)
print v(xbgr.mr_n56731344)
print v(xbgr.mr_n56731664)
print v(xbgr.mr_n56731776)
print v(xbgr.mr_n56732096)
print v(xbgr.mr_n56732208)
print v(xbgr.mr_n56732528)
print v(xbgr.mr_n56732640)
print v(xbgr.mr_n56732960)
print v(xbgr.mr_n56733072)
print v(xbgr.mr_n56733392)
print v(xbgr.mr_n56733504)
print v(xbgr.mr_n56733824)
print v(xbgr.mr_n56733936)
print v(xbgr.mr_n56734256)
print v(xbgr.mr_n56734368)
print v(xbgr.mr_n56734688)
print v(xbgr.mr_n56734800)
print v(xbgr.mr_n56735120)
print v(xbgr.mr_n56735232)
print v(xbgr.mr_n56735552)
print v(xbgr.mr_n56735664)
print v(xbgr.mr_n56735984)
print v(xbgr.mr_n56736096)
print v(xbgr.mr_n56736416)
print v(xbgr.mr_n56736528)
print v(xbgr.mr_n56736848)
print v(xbgr.mr_n56736960)
print v(xbgr.mr_n56737280)
print v(xbgr.mr_n56737392)
print v(xbgr.mr_n56737712)
print v(xbgr.mr_n56737824)
print v(xbgr.mr_n56738144)
print v(xbgr.mr_n56738256)
print v(xbgr.mr_n56738576)
print v(xbgr.mr_n56738688)
print v(xbgr.mr_n56739008)
print v(xbgr.mr_n56739120)
print v(xbgr.mr_n56739440)
print v(xbgr.mr_n56739552)
print v(xbgr.mr_n56739872)
print v(xbgr.mr_n56739984)
print v(xbgr.mr_n56740304)
print v(xbgr.mr_n56740416)
print v(xbgr.mr_n56740736)
print v(xbgr.mr_n56740848)
print v(xbgr.mr_n56741168)
print v(xbgr.mr_n56741280)
print v(xbgr.mr_n56741600)
print v(xbgr.mr_n56741712)
print v(xbgr.mr_n56742032)
print v(xbgr.mr_n56742144)
print v(xbgr.mr_n56742464)
print v(xbgr.mr_n56742576)
print v(xbgr.mr_n56742896)
print v(xbgr.mr_n56743008)
print v(xbgr.mr_n56743328)
print v(xbgr.mr_n56743440)
print v(xbgr.mr_n56743760)
print v(xbgr.mr_n56743872)
print v(xbgr.mr_n56744192)
print v(xbgr.mr_n56744304)
print v(xbgr.mr_n56744624)
print v(xbgr.mr_n56744736)
print v(xbgr.mr_n56745056)
print v(xbgr.mr_n56745168)
print v(xbgr.mr_n56745488)
print v(xbgr.mr_n56745600)
print v(xbgr.mr_n56745920)
print v(xbgr.mr_n56746032)
print v(xbgr.mr_n56746352)
print v(xbgr.mr_n56746464)
print v(xbgr.mr_n56746784)
print v(xbgr.mr_n56746896)
print v(xbgr.mr_n56747216)
print v(xbgr.mr_n56747328)
print v(xbgr.mr_n56747648)
print v(xbgr.mr_n56747760)
print v(xbgr.mr_n56748080)
print v(xbgr.mr_n56748192)
print v(xbgr.mr_n56748512)
print v(xbgr.mr_n56748624)
print v(xbgr.mr_n56748944)
print v(xbgr.mr_n56749056)
print v(xbgr.mr_n56749376)
print v(xbgr.mr_n56749488)
print v(xbgr.mr_n56749808)
print v(xbgr.mr_n56749920)
print v(xbgr.mr_n56750240)
print v(xbgr.mr_n56750352)
print v(xbgr.mr_n56750672)
print v(xbgr.mr_n56750784)
print v(xbgr.mr_n56751104)
print v(xbgr.mr_n56751216)
print v(xbgr.mr_n56751536)
print v(xbgr.mr_n56751648)
print v(xbgr.mr_n56751968)
print v(xbgr.mr_n56752080)
print v(xbgr.mr_n56752400)
print v(xbgr.mr_n56752512)
print v(xbgr.mr_n56752832)
print v(xbgr.mr_n56752944)
print v(xbgr.mr_n56753264)
print v(xbgr.mr_n56753376)
print v(xbgr.mr_n56753696)
print v(xbgr.mr_n56753808)
print v(xbgr.mr_n56754128)
print v(xbgr.mr_n56754240)
print v(xbgr.mr_n56754560)
print v(xbgr.mr_n56754672)
print v(xbgr.mr_n56754992)
print v(xbgr.mr_n56755104)
print v(xbgr.mr_n56755424)
print v(xbgr.mr_n56755536)
print v(xbgr.mr_n56755856)
print v(xbgr.mr_n56755968)
print v(xbgr.mr_n56756288)
print v(xbgr.mr_n56756400)
print v(xbgr.mr_n56756720)
print v(xbgr.mr_n56756832)
print v(xbgr.mr_n56757152)
print v(xbgr.mr_n56757264)
print v(xbgr.mr_n56757696)
print v(xbgr.mr_n56758016)
print v(xbgr.mr_n56758128)
print v(xbgr.mr_n56758448)
print v(xbgr.mr_n56758560)
print v(xbgr.mr_n56758880)
print v(xbgr.mr_n56758992)
print v(xbgr.mr_n56759312)
print v(xbgr.mr_n56759424)
print v(xbgr.mr_n56759744)
print v(xbgr.mr_n56759856)
print v(xbgr.mr_n56760288)
print v(xbgr.mr_n56760608)
print v(xbgr.mr_n56760720)
print v(xbgr.mr_n56761040)
print v(xbgr.mr_n56761152)
print v(xbgr.mr_n56761472)
print v(xbgr.mr_n56761584)
print v(xbgr.mr_n56761904)
print v(xbgr.mr_n56762016)
print v(xbgr.mr_n56762336)
print v(xbgr.mr_n56762448)
print v(xbgr.mr_n56762880)
print v(xbgr.mr_n56763200)
print v(xbgr.mr_n56763312)
print v(xbgr.mr_n56763632)
print v(xbgr.mr_n56763744)
print v(xbgr.mr_n56764064)
print v(xbgr.mr_n56764176)
print v(xbgr.mr_n56764496)
print v(xbgr.mr_n56764608)
print v(xbgr.mr_n56764928)
print v(xbgr.mr_n56765040)
print v(xbgr.mr_n56765360)
print v(xbgr.mr_n56765472)
print v(xbgr.mr_n56765792)
print v(xbgr.mr_n56765904)
print v(xbgr.mr_n56766336)
print v(xbgr.mr_n56766656)
print v(xbgr.mr_n56766768)
print v(xbgr.mr_n56767200)
print v(xbgr.mr_n56767520)
print v(xbgr.mr_n56767632)
print v(xbgr.mr_n56767952)
print v(xbgr.mr_n56768064)
print v(xbgr.mr_n56768384)
print v(xbgr.mr_n56768496)
print v(xbgr.mr_n56768816)
print v(xbgr.mr_n56768928)
print v(xbgr.mr_n56769248)
print v(xbgr.mr_n56769360)
print v(xbgr.mr_n56769792)
print v(xbgr.mr_n56770112)
print v(xbgr.mr_n56770224)
print v(xbgr.mr_n56770656)
print v(xbgr.mr_n56770976)
print v(xbgr.mr_n56771088)
print v(xbgr.mr_n56771408)
print v(xbgr.mr_n56771520)
print v(xbgr.mr_n56771840)
print v(xbgr.mr_n56771952)
print v(xbgr.mr_n56772272)
print v(xbgr.mr_n56772384)
print v(xbgr.mr_n56772704)
print v(xbgr.mr_n56772816)
print v(xbgr.mr_n56773136)
print v(xbgr.mr_n56773248)
print v(xbgr.mr_n56773568)
print v(xbgr.mr_n56773680)
print v(xbgr.mr_n56774000)
print v(xbgr.mr_n56774112)
print v(xbgr.mr_n56774432)
print v(xbgr.mr_n56774544)
print v(xbgr.mr_n56774864)
print v(xbgr.mr_n56774976)
print v(xbgr.mr_n56775296)
print v(xbgr.mr_n56775408)
print v(xbgr.mr_n56775728)
print v(xbgr.mr_n56775840)
print v(xbgr.mr_n56776160)
print v(xbgr.mr_n56776272)
print v(xbgr.mr_n56776592)
print v(xbgr.mr_n56776704)
print v(xbgr.mr_n56777024)
print v(xbgr.mr_n56777136)
print v(xbgr.mr_n56777456)
print v(xbgr.mr_n56777568)
print v(xbgr.mr_n56777888)
print v(xbgr.mr_n56778000)
print v(xbgr.mr_n56778320)
print v(xbgr.mr_n56778432)
print v(xbgr.mr_n56778752)
print v(xbgr.mr_n56778864)
print v(xbgr.mr_n56779184)
print v(xbgr.mr_n56779296)
print v(xbgr.mr_n56779616)
print v(xbgr.mr_n56779728)
print v(xbgr.mr_n56780048)
print v(xbgr.mr_n56780160)
print v(xbgr.mr_n56780480)
print v(xbgr.mr_n56780592)
print v(xbgr.mr_n56780912)
print v(xbgr.mr_n56781024)
print v(xbgr.mr_n56781344)
print v(xbgr.mr_n56781456)
print v(xbgr.mr_n56781776)
print v(xbgr.mr_n56781888)
print v(xbgr.mr_n56782208)
print v(xbgr.mr_n56782320)
print v(xbgr.mr_n56782640)
print v(xbgr.mr_n56782752)
print v(xbgr.mr_n56783072)
print v(xbgr.mr_n56783184)
print v(xbgr.mr_n56783504)
print v(xbgr.mr_n56783616)
print v(xbgr.mr_n56783936)
print v(xbgr.mr_n56784048)
print v(xbgr.mr_n56784368)
print v(xbgr.mr_n56784480)
print v(xbgr.mr_n56784800)
print v(xbgr.mr_n56784912)
print v(xbgr.mr_n56785232)
print v(xbgr.mr_n56785344)
print v(xbgr.mr_n56785664)
print v(xbgr.mr_n56785776)
print v(xbgr.mr_n56786096)
print v(xbgr.mr_n56786208)
print v(xbgr.mr_n56786528)
print v(xbgr.mr_n56786640)
print v(xbgr.mr_n56786960)
print v(xbgr.mr_n56787072)
print v(xbgr.mr_n56787392)
print v(xbgr.mr_n56787504)
print v(xbgr.mr_n56787824)
print v(xbgr.mr_n56787936)
print v(xbgr.mr_n56788256)
print v(xbgr.mr_n56788368)
print v(xbgr.mr_n56788688)
print v(xbgr.mr_n56788800)
print v(xbgr.mr_n56789120)
print v(xbgr.mr_n56789232)
print v(xbgr.mr_n56789552)
print v(xbgr.mr_n56789664)
print v(xbgr.mr_n56789984)
print v(xbgr.mr_n56790096)
print v(xbgr.mr_n56790416)
print v(xbgr.mr_n56790528)
print v(xbgr.mr_n56790848)
print v(xbgr.mr_n56790960)
print v(xbgr.mr_n56791280)
print v(xbgr.mr_n56791392)
print v(xbgr.mr_n56791712)
print v(xbgr.mr_n56791824)
print v(xbgr.mr_n56792144)
print v(xbgr.mr_n56792256)
print v(xbgr.mr_n56792576)
print v(xbgr.mr_n56792688)
print v(xbgr.mr_n56793008)
print v(xbgr.mr_n56793120)
print v(xbgr.mr_n56793440)
print v(xbgr.mr_n56793552)
print v(xbgr.mr_n56793872)
print v(xbgr.mr_n56793984)
print v(xbgr.mr_n56794304)
print v(xbgr.mr_n56794416)
print v(xbgr.mr_n56794736)
print v(xbgr.mr_n56794848)
print v(xbgr.mr_n56795168)
print v(xbgr.mr_n56795280)
print v(xbgr.mr_n56795600)
print v(xbgr.mr_n56795712)
print v(xbgr.mr_n56796032)
print v(xbgr.mr_n56796144)
print v(xbgr.mr_n56796464)
print v(xbgr.mr_n56796576)
print v(xbgr.mr_n56796896)
print v(xbgr.mr_n56797008)
print v(xbgr.mr_n56797328)
print v(xbgr.mr_n56797440)
print v(xbgr.mr_n56797760)
print v(xbgr.mr_n56797872)
print v(xbgr.mr_n56798192)
print v(xbgr.mr_n56798304)
print v(xbgr.mr_n56798624)
print v(xbgr.mr_n56798736)
print v(xbgr.mr_n56799056)
print v(xbgr.mr_n56799168)
print v(xbgr.mr_n56799488)
print v(xbgr.mr_n56799600)
print v(xbgr.mr_n56799920)
print v(xbgr.mr_n56800032)
print v(xbgr.mr_n56800352)
print v(xbgr.mr_n56800464)
print v(xbgr.mr_n56800784)
print v(xbgr.mr_n56800896)
print v(xbgr.mr_n56801216)
print v(xbgr.mr_n56801328)
print v(xbgr.mr_n56801648)
print v(xbgr.mr_n56801760)
print v(xbgr.mr_n56802080)
print v(xbgr.mr_n56802192)
print v(xbgr.mr_n56802512)
print v(xbgr.mr_n56802624)
print v(xbgr.mr_n56802944)
print v(xbgr.mr_n56803056)
print v(xbgr.mr_n56803376)
print v(xbgr.mr_n56803488)
print v(xbgr.mr_n56803808)
print v(xbgr.mr_n56803920)
print v(xbgr.mr_n56804352)
print v(xbgr.mr_n56804672)
print v(xbgr.mr_n56804784)
print v(xbgr.mr_n56805104)
print v(xbgr.mr_n56805216)
print v(xbgr.mr_n56805536)
print v(xbgr.mr_n56805648)
print v(xbgr.mr_n56806080)
print v(xbgr.mr_n56806400)
print v(xbgr.mr_n56806512)
print v(xbgr.mr_n56806944)
print v(xbgr.mr_n56807264)
print v(xbgr.mr_n56807376)
print v(xbgr.mr_n56807696)
print v(xbgr.mr_n56807808)
print v(xbgr.mr_n56808128)
print v(xbgr.mr_n56808240)
print v(xbgr.mr_n56808560)
print v(xbgr.mr_n56808672)
print v(xbgr.mr_n56808992)
print v(xbgr.mr_n56809104)
print v(xbgr.mr_n56809424)
print v(xbgr.mr_n56809536)
print v(xbgr.mr_n56809856)
print v(xbgr.mr_n56809968)
print v(xbgr.mr_n56810288)
print v(xbgr.mr_n56810400)
print v(xbgr.mr_n56810720)
print v(xbgr.mr_n56810832)
print v(xbgr.mr_n56811152)
print v(xbgr.mr_n56811264)
print v(xbgr.mr_n56811584)
print v(xbgr.mr_n56811696)
print v(xbgr.mr_n56812016)
print v(xbgr.mr_n56812128)
print v(xbgr.mr_n56812448)
print v(xbgr.mr_n56812560)
print v(xbgr.mr_n56812880)
print v(xbgr.mr_n56812992)
print v(xbgr.mr_n56813312)
print v(xbgr.mr_n56813424)
print v(xbgr.mr_n56813744)
print v(xbgr.mr_n56813856)
print v(xbgr.mr_n56814176)
print v(xbgr.mr_n56814288)
print v(xbgr.mr_n56814608)
print v(xbgr.mr_n56814720)
print v(xbgr.mr_n56815040)
print v(xbgr.mr_n56815152)
print v(xbgr.mr_n56815472)
print v(xbgr.mr_n56815584)
print v(xbgr.mr_n56815904)
print v(xbgr.mr_n56816016)
print v(xbgr.mr_n56816336)
print v(xbgr.mr_n56816448)
print v(xbgr.mr_n56816768)
print v(xbgr.mr_n56816880)
print v(xbgr.mr_n56817200)
print v(xbgr.mr_n56817312)
print v(xbgr.mr_n56817632)
print v(xbgr.mr_n56817744)
print v(xbgr.mr_n56818064)
print v(xbgr.mr_n56818176)
print v(xbgr.mr_n56818496)
print v(xbgr.mr_n56818608)
print v(xbgr.mr_n56819040)
print v(xbgr.mr_n56819360)
print v(xbgr.mr_n56819472)
print v(xbgr.mr_n56819792)
print v(xbgr.mr_n56819904)
print v(xbgr.mr_n56820224)
print v(xbgr.mr_n56820336)
print v(xbgr.mr_n56820656)
print v(xbgr.mr_n56820768)
print v(xbgr.mr_n56821088)
print v(xbgr.mr_n56821200)
print v(xbgr.mr_n56821520)
print v(xbgr.mr_n56821632)
print v(xbgr.mr_n56821952)
print v(xbgr.mr_n56822064)
print v(xbgr.mr_n56822384)
print v(xbgr.mr_n56822496)
print v(xbgr.mr_n56822816)
print v(xbgr.mr_n56822928)
print v(xbgr.mr_n56823360)
print v(xbgr.mr_n56823680)
print v(xbgr.mr_n56823792)
print v(xbgr.mr_n56824112)
print v(xbgr.mr_n56824224)
print v(xbgr.mr_n56824544)
print v(xbgr.mr_n56824656)
print v(xbgr.mr_n56825088)
print v(xbgr.mr_n56825408)
print v(xbgr.mr_n56825520)
print v(xbgr.mr_n56825840)
print v(xbgr.mr_n56825952)
print v(xbgr.mr_n56826272)
print v(xbgr.mr_n56826384)
print v(xbgr.mr_n56826704)
print v(xbgr.mr_n56826816)
print v(xbgr.mr_n56827136)
print v(xbgr.mr_n56827248)
print v(xbgr.mr_n56827680)
print v(xbgr.mr_n56828000)
print v(xbgr.mr_n56828112)
print v(xbgr.mr_n56828432)
print v(xbgr.mr_n56828544)
print v(xbgr.mr_n56828864)
print v(xbgr.mr_n56828976)
print v(xbgr.mr_n56829296)
print v(xbgr.mr_n56829408)
print v(xbgr.mr_n56829728)
print v(xbgr.mr_n56829840)
print v(xbgr.mr_n56830160)
print v(xbgr.mr_n56830272)
print v(xbgr.mr_n56830592)
print v(xbgr.mr_n56830704)
print v(xbgr.mr_n56831024)
print v(xbgr.mr_n56831136)
print v(xbgr.mr_n56831456)
print v(xbgr.mr_n56831568)
print v(xbgr.mr_n56831888)
print v(xbgr.mr_n56832000)
print v(xbgr.mr_n56832320)
print v(xbgr.mr_n56832432)
print v(xbgr.mr_n56832752)
print v(xbgr.mr_n56832864)
print v(xbgr.mr_n56833184)
print v(xbgr.mr_n56833296)
print v(xbgr.mr_n56833616)
print v(xbgr.mr_n56833728)
print v(xbgr.mr_n56834048)
print v(xbgr.mr_n56834160)
print v(xbgr.mr_n56834480)
print v(xbgr.mr_n56834592)
print v(xbgr.mr_n56834912)
print v(xbgr.mr_n56835024)
print v(xbgr.mr_n56835344)
print v(xbgr.mr_n56835456)
print v(xbgr.mr_n56835776)
print v(xbgr.mr_n56835888)
print v(xbgr.mr_n56836208)
print v(xbgr.mr_n56836320)
print v(xbgr.mr_n56836640)
print v(xbgr.mr_n56836752)
print v(xbgr.mr_n56837072)
print v(xbgr.mr_n56837184)
print v(xbgr.mr_n56837504)
print v(xbgr.mr_n56837616)
print v(xbgr.mr_n56837936)
print v(xbgr.mr_n56838048)
print v(xbgr.mr_n56838368)
print v(xbgr.mr_n56838480)
print v(xbgr.mr_n56838800)
print v(xbgr.mr_n56838912)
print v(xbgr.mr_n56839232)
print v(xbgr.mr_n56839344)
print v(xbgr.mr_n56839664)
print v(xbgr.mr_n56839776)
print v(xbgr.mr_n56840096)
print v(xbgr.mr_n56840208)
print v(xbgr.mr_n56840528)
print v(xbgr.mr_n56840640)
print v(xbgr.mr_n56840960)
print v(xbgr.mr_n56841072)
print v(xbgr.mr_n56841392)
print v(xbgr.mr_n56841504)
print v(xbgr.mr_n56841824)
print v(xbgr.mr_n56841936)
print v(xbgr.mr_n56842256)
print v(xbgr.mr_n56842368)
print v(xbgr.mr_n56842688)
print v(xbgr.mr_n56842800)
print v(xbgr.mr_n56843120)
print v(xbgr.mr_n56843232)
print v(xbgr.mr_n56843552)
print v(xbgr.mr_n56843664)
print v(xbgr.mr_n56843984)
print v(xbgr.mr_n56844096)
print v(xbgr.mr_n56844416)
print v(xbgr.mr_n56844528)
print v(xbgr.mr_n56844848)
print v(xbgr.mr_n56844960)
print v(xbgr.mr_n56845280)
print v(xbgr.mr_n56845392)
print v(xbgr.mr_n56845712)
print v(xbgr.mr_n56845824)
print v(xbgr.mr_n56846144)
print v(xbgr.mr_n56846256)
print v(xbgr.mr_n56846576)
print v(xbgr.mr_n56846688)
print v(xbgr.mr_n56847008)
print v(xbgr.mr_n56847120)
print v(xbgr.mr_n56847440)
print v(xbgr.mr_n56847552)
print v(xbgr.mr_n56847872)
print v(xbgr.mr_n56847984)
print v(xbgr.mr_n56848304)
print v(xbgr.mr_n56848416)
print v(xbgr.mr_n56848736)
print v(xbgr.mr_n56848848)
print v(xbgr.mr_n56849168)
print v(xbgr.mr_n56849280)
print v(xbgr.mr_n56849600)
print v(xbgr.mr_n56849712)
print v(xbgr.mr_n56850032)
print v(xbgr.mr_n56850144)
print v(xbgr.mr_n56850464)
print v(xbgr.mr_n56850576)
print v(xbgr.mr_n56850896)
print v(xbgr.mr_n56851008)
print v(xbgr.mr_n56851328)
print v(xbgr.mr_n56851440)
print v(xbgr.mr_n56851760)
print v(xbgr.mr_n56851872)
print v(xbgr.mr_n56852192)
print v(xbgr.mr_n56852304)
print v(xbgr.mr_n56852624)
print v(xbgr.mr_n56852736)
print v(xbgr.mr_n56853056)
print v(xbgr.mr_n56853168)
print v(xbgr.mr_n56853488)
print v(xbgr.mr_n56853600)
print v(xbgr.mr_n56853920)
print v(xbgr.mr_n56854032)
print v(xbgr.mr_n56854352)
print v(xbgr.mr_n56854464)
print v(xbgr.mr_n56854784)
print v(xbgr.mr_n56854896)
print v(xbgr.mr_n56855216)
print v(xbgr.mr_n56855328)
print v(xbgr.mr_n56855648)
print v(xbgr.mr_n56855760)
print v(xbgr.mr_n56856080)
print v(xbgr.mr_n56856192)
print v(xbgr.mr_n56856512)
print v(xbgr.mr_n56856624)
print v(xbgr.mr_n56856944)
print v(xbgr.mr_n56857056)
print v(xbgr.mr_n56857376)
print v(xbgr.mr_n56857488)
print v(xbgr.mr_n56857920)
print v(xbgr.mr_n56858240)
print v(xbgr.mr_n56858352)
print v(xbgr.mr_n56858672)
print v(xbgr.mr_n56858784)
print v(xbgr.mr_n56859104)
print v(xbgr.mr_n56859216)
print v(xbgr.mr_n56859648)
print v(xbgr.mr_n56859968)
print v(xbgr.mr_n56860080)
print v(xbgr.mr_n56860512)
print v(xbgr.mr_n56860832)
print v(xbgr.mr_n56860944)
print v(xbgr.mr_n56861264)
print v(xbgr.mr_n56861376)
print v(xbgr.mr_n56861696)
print v(xbgr.mr_n56861808)
print v(xbgr.mr_n56862128)
print v(xbgr.mr_n56862240)
print v(xbgr.mr_n56862560)
print v(xbgr.mr_n56862672)
print v(xbgr.mr_n56862992)
print v(xbgr.mr_n56863104)
print v(xbgr.mr_n56863424)
print v(xbgr.mr_n56863536)
print v(xbgr.mr_n56863856)
print v(xbgr.mr_n56863968)
print v(xbgr.mr_n56864288)
print v(xbgr.mr_n56864400)
print v(xbgr.mr_n56864720)
print v(xbgr.mr_n56864832)
print v(xbgr.mr_n56865152)
print v(xbgr.mr_n56865264)
print v(xbgr.mr_n56865584)
print v(xbgr.mr_n56865696)
print v(xbgr.mr_n56866016)
print v(xbgr.mr_n56866128)
print v(xbgr.mr_n56866448)
print v(xbgr.mr_n56866560)
print v(xbgr.mr_n56866880)
print v(xbgr.mr_n56866992)
print v(xbgr.mr_n56867312)
print v(xbgr.mr_n56867424)
print v(xbgr.mr_n56867744)
print v(xbgr.mr_n56867856)
print v(xbgr.mr_n56868176)
print v(xbgr.mr_n56868288)
print v(xbgr.mr_n56868608)
print v(xbgr.mr_n56868720)
print v(xbgr.mr_n56869040)
print v(xbgr.mr_n56869152)
print v(xbgr.mr_n56869472)
print v(xbgr.mr_n56869584)
print v(xbgr.mr_n56869904)
print v(xbgr.mr_n56870016)
print v(xbgr.mr_n56870336)
print v(xbgr.mr_n56870448)
print v(xbgr.mr_n56870768)
print v(xbgr.mr_n56870880)
print v(xbgr.mr_n56871200)
print v(xbgr.mr_n56871312)
print v(xbgr.mr_n56871632)
print v(xbgr.mr_n56871744)
print v(xbgr.mr_n56872064)
print v(xbgr.mr_n56872176)
print v(xbgr.mr_n56872496)
print v(xbgr.mr_n56872608)
print v(xbgr.mr_n56872928)
print v(xbgr.mr_n56873040)
print v(xbgr.mr_n56873360)
print v(xbgr.mr_n56873472)
print v(xbgr.mr_n56873792)
print v(xbgr.mr_n56873904)
print v(xbgr.mr_n56874224)
print v(xbgr.mr_n56874336)
print v(xbgr.mr_n56874656)
print v(xbgr.mr_n56874768)
print v(xbgr.mr_n56875088)
print v(xbgr.mr_n56875200)
print v(xbgr.mr_n56875520)
print v(xbgr.mr_n56875632)
print v(xbgr.mr_n56875952)
print v(xbgr.mr_n56876064)
print v(xbgr.mr_n56876384)
print v(xbgr.mr_n56876496)
print v(xbgr.mr_n56876816)
print v(xbgr.mr_n56876928)
print v(xbgr.mr_n56877248)
print v(xbgr.mr_n56877360)
print v(xbgr.mr_n56877680)
print v(xbgr.mr_n56877792)
print v(xbgr.mr_n56878112)
print v(xbgr.mr_n56878224)
print v(xbgr.mr_n56878544)
print v(xbgr.mr_n56878656)
print v(xbgr.mr_n56878976)
print v(xbgr.mr_n56879088)
print v(xbgr.mr_n56879408)
print v(xbgr.mr_n56879520)
print v(xbgr.mr_n56879840)
print v(xbgr.mr_n56879952)
print v(xbgr.mr_n56880272)
print v(xbgr.mr_n56880384)
print v(xbgr.mr_n56880704)
print v(xbgr.mr_n56880816)
print v(xbgr.mr_n56881136)
print v(xbgr.mr_n56881248)
print v(xbgr.mr_n56881568)
print v(xbgr.mr_n56881680)
print v(xbgr.mr_n56882000)
print v(xbgr.mr_n56882112)
print v(xbgr.mr_n56882432)
print v(xbgr.mr_n56882544)
print v(xbgr.mr_n56882864)
print v(xbgr.mr_n56882976)
print v(xbgr.mr_n56883296)
print v(xbgr.mr_n56883408)
print v(xbgr.mr_n56883728)
print v(xbgr.mr_n56883840)
print v(xbgr.mr_n56884160)
print v(xbgr.mr_n56884272)
print v(xbgr.mr_n56884592)
print v(xbgr.mr_n56884704)
print v(xbgr.mr_n56885024)
print v(xbgr.mr_n56885136)
print v(xbgr.mr_n56885456)
print v(xbgr.mr_n56885568)
print v(xbgr.mr_n56885888)
print v(xbgr.mr_n56886000)
print v(xbgr.mr_n56886320)
print v(xbgr.mr_n56886432)
print v(xbgr.mr_n56886752)
print v(xbgr.mr_n56886864)
print v(xbgr.mr_n56887184)
print v(xbgr.mr_n56887296)
print v(xbgr.mr_n56887616)
print v(xbgr.mr_n56887728)
print v(xbgr.mr_n56888048)
print v(xbgr.mr_n56888160)
print v(xbgr.mr_n56888480)
print v(xbgr.mr_n56888592)
print v(xbgr.mr_n56888912)
print v(xbgr.mr_n56889024)
print v(xbgr.mr_n56889344)
print v(xbgr.mr_n56889456)
print v(xbgr.mr_n56889776)
print v(xbgr.mr_n56889888)
print v(xbgr.mr_n56890208)
print v(xbgr.mr_n56890320)
print v(xbgr.mr_n56890640)
print v(xbgr.mr_n56890752)
print v(xbgr.mr_n56891072)
print v(xbgr.mr_n56891184)
print v(xbgr.mr_n56891504)
print v(xbgr.mr_n56891616)
print v(xbgr.mr_n56891936)
print v(xbgr.mr_n56892048)
print v(xbgr.mr_n56892368)
print v(xbgr.mr_n56892480)
print v(xbgr.mr_n56892800)
print v(xbgr.mr_n56892912)
print v(xbgr.mr_n56893232)
print v(xbgr.mr_n56893344)
print v(xbgr.mr_n56893664)
print v(xbgr.mr_n56893776)
print v(xbgr.mr_n56894096)
print v(xbgr.mr_n56894208)
print v(xbgr.mr_n56894528)
print v(xbgr.mr_n56894640)
print v(xbgr.mr_n56894960)
print v(xbgr.mr_n56895072)
print v(xbgr.mr_n56895392)
print v(xbgr.mr_n56895504)
print v(xbgr.mr_n56895824)
print v(xbgr.mr_n56895936)
print v(xbgr.mr_n56896256)
print v(xbgr.mr_n56896368)
print v(xbgr.mr_n56896688)
print v(xbgr.mr_n56896800)
print v(xbgr.mr_n56897120)
print v(xbgr.mr_n56897232)
print v(xbgr.mr_n56897552)
print v(xbgr.mr_n56897664)
print v(xbgr.mr_n56897984)
print v(xbgr.mr_n56898096)
print v(xbgr.mr_n56898416)
print v(xbgr.mr_n56898528)
print v(xbgr.mr_n56898848)
print v(xbgr.mr_n56898960)
print v(xbgr.mr_n56899280)
print v(xbgr.mr_n56899392)
print v(xbgr.mr_n56899712)
print v(xbgr.mr_n56899824)
print v(xbgr.mr_n56900144)
print v(xbgr.mr_n56900256)
print v(xbgr.mr_n56900576)
print v(xbgr.mr_n56900688)
print v(xbgr.mr_n56901008)
print v(xbgr.mr_n56901120)
print v(xbgr.mr_n56901440)
print v(xbgr.mr_n56901552)
print v(xbgr.mr_n56901872)
print v(xbgr.mr_n56901984)
print v(xbgr.mr_n56902304)
print v(xbgr.mr_n56902416)
print v(xbgr.mr_n56902736)
print v(xbgr.mr_n56902848)
print v(xbgr.mr_n56903168)
print v(xbgr.mr_n56903280)
print v(xbgr.mr_n56903600)
print v(xbgr.mr_n56903712)
print v(xbgr.mr_n56904032)
print v(xbgr.mr_n56904144)
print v(xbgr.mr_n56904464)
print v(xbgr.mr_n56904576)
print v(xbgr.mr_n56904896)
print v(xbgr.mr_n56905008)
print v(xbgr.mr_n56905328)
print v(xbgr.mr_n56905440)
print v(xbgr.mr_n56905760)
print v(xbgr.mr_n56905872)
print v(xbgr.mr_n56906192)
print v(xbgr.mr_n56906304)
print v(xbgr.mr_n56906624)
print v(xbgr.mr_n56906736)
print v(xbgr.mr_n56907056)
print v(xbgr.mr_n56907168)
print v(xbgr.mr_n56907488)
print v(xbgr.mr_n56907600)
print v(xbgr.mr_n56907920)
print v(xbgr.mr_n56908032)
print v(xbgr.mr_n56908352)
print v(xbgr.mr_n56908464)
print v(xbgr.mr_n56908784)
print v(xbgr.mr_n56908896)
print v(xbgr.mr_n56909216)
print v(xbgr.mr_n56909328)
print v(xbgr.mr_n56909648)
print v(xbgr.mr_n56909760)
print v(xbgr.mr_n56910080)
print v(xbgr.mr_n56910192)
print v(xbgr.mr_n56910512)
print v(xbgr.mr_n56910624)
print v(xbgr.mr_n56910944)
print v(xbgr.mr_n56911056)
print v(xbgr.mr_n56911376)
print v(xbgr.mr_n56911488)
print v(xbgr.mr_n56911808)
print v(xbgr.mr_n56911920)
print v(xbgr.mr_n56912240)
print v(xbgr.mr_n56912352)
print v(xbgr.mr_n56912672)
print v(xbgr.mr_n56912784)
print v(xbgr.mr_n56913104)
print v(xbgr.mr_n56913216)
print v(xbgr.mr_n56913536)
print v(xbgr.mr_n56913648)
print v(xbgr.mr_n56913968)
print v(xbgr.mr_n56914080)
print v(xbgr.mr_n56914400)
print v(xbgr.mr_n56914512)
print v(xbgr.mr_n56914832)
print v(xbgr.mr_n56914944)
print v(xbgr.mr_n56915264)
print v(xbgr.mr_n56915376)
print v(xbgr.mr_n56915696)
print v(xbgr.mr_n56915808)
print v(xbgr.mr_n56916128)
print v(xbgr.mr_n56916240)
print v(xbgr.mr_n56916560)
print v(xbgr.mr_n56916672)
print v(xbgr.mr_n56916992)
print v(xbgr.mr_n56917104)
print v(xbgr.mr_n56917424)
print v(xbgr.mr_n56917536)
print v(xbgr.mr_n56917856)
print v(xbgr.mr_n56917968)
print v(xbgr.mr_n56918288)
print v(xbgr.mr_n56918400)
print v(xbgr.mr_n56918720)
print v(xbgr.mr_n56918832)
print v(xbgr.mr_n56919152)
print v(xbgr.mr_n56919264)
print v(xbgr.mr_n56919584)
print v(xbgr.mr_n56919696)
print v(xbgr.mr_n56920016)
print v(xbgr.mr_n56920128)
print v(xbgr.mr_n56920448)
print v(xbgr.mr_n56920560)
print v(xbgr.mr_n56920880)
print v(xbgr.mr_n56920992)
print v(xbgr.mr_n56921312)
print v(xbgr.mr_n56921424)
print v(xbgr.mr_n56921744)
print v(xbgr.mr_n56921856)
print v(xbgr.mr_n56922176)
print v(xbgr.mr_n56922288)
print v(xbgr.mr_n56922608)
print v(xbgr.mr_n56922720)
print v(xbgr.mr_n56923040)
print v(xbgr.mr_n56923152)
print v(xbgr.mr_n56923472)
print v(xbgr.mr_n56923584)
print v(xbgr.mr_n56923904)
print v(xbgr.mr_n56924016)
print v(xbgr.mr_n56924336)
print v(xbgr.mr_n56924448)
print v(xbgr.mr_n56924768)
print v(xbgr.mr_n56924880)
print v(xbgr.mr_n56925200)
print v(xbgr.mr_n56925312)
print v(xbgr.mr_n56925632)
print v(xbgr.mr_n56925744)
print v(xbgr.mr_n56926064)
print v(xbgr.mr_n56926176)
print v(xbgr.mr_n56926496)
print v(xbgr.mr_n56926608)
print v(xbgr.mr_n56926928)
print v(xbgr.mr_n56927040)
print v(xbgr.mr_n56927360)
print v(xbgr.mr_n56927472)
print v(xbgr.mr_n56927792)
print v(xbgr.mr_n56927904)
print v(xbgr.mr_n56928224)
print v(xbgr.mr_n56928336)
print v(xbgr.mr_n56928656)
print v(xbgr.mr_n56928768)
print v(xbgr.mr_n56929088)
print v(xbgr.mr_n56929200)
print v(xbgr.mr_n56929520)
print v(xbgr.mr_n56929632)
print v(xbgr.mr_n56929952)
print v(xbgr.mr_n56930064)
print v(xbgr.mr_n56930384)
print v(xbgr.mr_n56930496)
print v(xbgr.mr_n56930816)
print v(xbgr.mr_n56930928)
print v(xbgr.mr_n56931248)
print v(xbgr.mr_n56931360)
print v(xbgr.mr_n56931680)
print v(xbgr.mr_n56931792)
print v(xbgr.mr_n56932112)
print v(xbgr.mr_n56932224)
print v(xbgr.mr_n56932544)
print v(xbgr.mr_n56932656)
print v(xbgr.mr_n56932976)
print v(xbgr.mr_n56933088)
print v(xbgr.mr_n56933408)
print v(xbgr.mr_n56933520)
print v(xbgr.mr_n56933840)
print v(xbgr.mr_n56933952)
print v(xbgr.mr_n56934272)
print v(xbgr.mr_n56934384)
print v(xbgr.mr_n56934704)
print v(xbgr.mr_n56934816)
print v(xbgr.mr_n56935136)
print v(xbgr.mr_n56935248)
print v(xbgr.mr_n56935568)
print v(xbgr.mr_n56935680)
print v(xbgr.mr_n56936000)
print v(xbgr.mr_n56936112)
print v(xbgr.mr_n56936432)
print v(xbgr.mr_n56936544)
print v(xbgr.mr_n56936864)
print v(xbgr.mr_n56936976)
print v(xbgr.mr_n56937296)
print v(xbgr.mr_n56937408)
print v(xbgr.mr_n56937728)
print v(xbgr.mr_n56937840)
print v(xbgr.mr_n56938160)
print v(xbgr.mr_n56938272)
print v(xbgr.mr_n56938592)
print v(xbgr.mr_n56938704)
print v(xbgr.mr_n56939024)
print v(xbgr.mr_n56939136)
print v(xbgr.mr_n56939456)
print v(xbgr.mr_n56939568)
print v(xbgr.mr_n56939888)
print v(xbgr.mr_n56940000)
print v(xbgr.mr_n56940320)
print v(xbgr.mr_n56940432)
print v(xbgr.mr_n56940752)
print v(xbgr.mr_n56940864)
print v(xbgr.mr_n56941184)
print v(xbgr.mr_n56941296)
print v(xbgr.mr_n56941616)
print v(xbgr.mr_n56941728)
print v(xbgr.mr_n56942048)
print v(xbgr.mr_n56942160)
print v(xbgr.mr_n56942480)
print v(xbgr.mr_n56942592)
print v(xbgr.mr_n56942912)
print v(xbgr.mr_n56943024)
print v(xbgr.mr_n56943344)
print v(xbgr.mr_n56943456)
print v(xbgr.mr_n56943776)
print v(xbgr.mr_n56943888)
print v(xbgr.mr_n56944208)
print v(xbgr.mr_n56944320)
print v(xbgr.mr_n56944640)
print v(xbgr.mr_n56944752)
print v(xbgr.mr_n56945072)
print v(xbgr.mr_n56945184)
print v(xbgr.mr_n56945504)
print v(xbgr.mr_n56945616)
print v(xbgr.mr_n56945936)
print v(xbgr.mr_n56946048)
print v(xbgr.mr_n56946368)
print v(xbgr.mr_n56946480)
print v(xbgr.mr_n56946800)
print v(xbgr.mr_n56946912)
print v(xbgr.mr_n56947232)
print v(xbgr.mr_n56947344)
print v(xbgr.mr_n56947664)
print v(xbgr.mr_n56947776)
print v(xbgr.mr_n56948096)
print v(xbgr.mr_n56948208)
print v(xbgr.mr_n56948528)
print v(xbgr.mr_n56948640)
print v(xbgr.mr_n56948960)
print v(xbgr.mr_n56949072)
print v(xbgr.mr_n56949392)
print v(xbgr.mr_n56949504)
print v(xbgr.mr_n56949824)
print v(xbgr.mr_n56949936)
print v(xbgr.mr_n56950256)
print v(xbgr.mr_n56950368)
print v(xbgr.mr_n56950688)
print v(xbgr.mr_n56950800)
print v(xbgr.mr_n57016672)
print v(xbgr.mr_n57016784)
print v(xbgr.mr_n57017104)
print v(xbgr.mr_n57017216)
print v(xbgr.mr_n57017536)
print v(xbgr.mr_n57017648)
print v(xbgr.mr_n57018080)
print v(xbgr.mr_n57018400)
print v(xbgr.mr_n57018512)
print v(xbgr.mr_n57018832)
print v(xbgr.mr_n57018944)
print v(xbgr.mr_n57019376)
print v(xbgr.mr_n57019808)
print v(xbgr.mr_n57020128)
print v(xbgr.mr_n57020240)
print v(xbgr.mr_n57020560)
print v(xbgr.mr_n57020672)
print v(xbgr.mr_n57020992)
print v(xbgr.mr_n57021104)
print v(xbgr.mr_n57021424)
print v(xbgr.mr_n57021536)
print v(xbgr.mr_n57021856)
print v(xbgr.mr_n57021968)
print v(xbgr.mr_n57022288)
print v(xbgr.mr_n57022400)
print v(xbgr.mr_n57022720)
print v(xbgr.mr_n57022832)
print v(xbgr.mr_n57023152)
print v(xbgr.mr_n57023264)
print v(xbgr.mr_n57023584)
print v(xbgr.mr_n57023696)
print v(xbgr.mr_n57024016)
print v(xbgr.mr_n57024128)
print v(xbgr.mr_n57024448)
print v(xbgr.mr_n57024560)
print v(xbgr.mr_n57024880)
print v(xbgr.mr_n57024992)
print v(xbgr.mr_n57025424)
print v(xbgr.mr_n57025744)
print v(xbgr.mr_n57025856)
print v(xbgr.mr_n57026176)
print v(xbgr.mr_n57026288)
print v(xbgr.mr_n57026608)
print v(xbgr.mr_n57026720)
print v(xbgr.mr_n57027040)
print v(xbgr.mr_n57027152)
print v(xbgr.mr_n57027472)
print v(xbgr.mr_n57027584)
print v(xbgr.mr_n57027904)
print v(xbgr.mr_n57028016)
print v(xbgr.mr_n57028336)
print v(xbgr.mr_n57028448)
print v(xbgr.mr_n57028768)
print v(xbgr.mr_n57028880)
print v(xbgr.mr_n57029200)
print v(xbgr.mr_n57029312)
print v(xbgr.mr_n57029632)
print v(xbgr.mr_n57029744)
print v(xbgr.mr_n57030176)
print v(xbgr.mr_n57030608)
print v(xbgr.mr_n57030928)
print v(xbgr.mr_n57031040)
print v(xbgr.mr_n57031360)
print v(xbgr.mr_n57031472)
print v(xbgr.mr_n57031792)
print v(xbgr.mr_n57031904)
print v(xbgr.mr_n57032224)
print v(xbgr.mr_n57032336)
print v(xbgr.mr_n57032656)
print v(xbgr.mr_n57032768)
print v(xbgr.mr_n57033088)
print v(xbgr.mr_n57033200)
print v(xbgr.mr_n57033520)
print v(xbgr.mr_n57033632)
print v(xbgr.mr_n57033952)
print v(xbgr.mr_n57034064)
print v(xbgr.mr_n57034384)
print v(xbgr.mr_n57034496)
print v(xbgr.mr_n57034816)
print v(xbgr.mr_n57034928)
print v(xbgr.mr_n57035248)
print v(xbgr.mr_n57035360)
print v(xbgr.mr_n57035680)
print v(xbgr.mr_n57035792)
print v(xbgr.mr_n57036112)
print v(xbgr.mr_n57036224)
print v(xbgr.mr_n57036544)
print v(xbgr.mr_n57036656)
print v(xbgr.mr_n57036976)
print v(xbgr.mr_n57037088)
print v(xbgr.mr_n57037408)
print v(xbgr.mr_n57037520)
print v(xbgr.mr_n57037840)
print v(xbgr.mr_n57037952)
print v(xbgr.mr_n57038272)
print v(xbgr.mr_n57038384)
print v(xbgr.mr_n57038704)
print v(xbgr.mr_n57038816)
print v(xbgr.mr_n57039136)
print v(xbgr.mr_n57039248)
print v(xbgr.mr_n57039568)
print v(xbgr.mr_n57039680)
print v(xbgr.mr_n57040000)
print v(xbgr.mr_n57040112)
print v(xbgr.mr_n57040432)
print v(xbgr.mr_n57040544)
print v(xbgr.mr_n57040864)
print v(xbgr.mr_n57040976)
print v(xbgr.mr_n57041296)
print v(xbgr.mr_n57041408)
print v(xbgr.mr_n57041728)
print v(xbgr.mr_n57041840)
print v(xbgr.mr_n57042160)
print v(xbgr.mr_n57042272)
print v(xbgr.mr_n57042592)
print v(xbgr.mr_n57042704)
print v(xbgr.mr_n57043024)
print v(xbgr.mr_n57043136)
print v(xbgr.mr_n57043456)
print v(xbgr.mr_n57043568)
print v(xbgr.mr_n57043888)
print v(xbgr.mr_n57044000)
print v(xbgr.mr_n57044320)
print v(xbgr.mr_n57044432)
print v(xbgr.mr_n57044752)
print v(xbgr.mr_n57044864)
print v(xbgr.mr_n57045184)
print v(xbgr.mr_n57045296)
print v(xbgr.mr_n57045616)
print v(xbgr.mr_n57045728)
print v(xbgr.mr_n57046048)
print v(xbgr.mr_n57046160)
print v(xbgr.mr_n57046480)
print v(xbgr.mr_n57046592)
print v(xbgr.mr_n57046912)
print v(xbgr.mr_n57047024)
print v(xbgr.mr_n57047344)
print v(xbgr.mr_n57047456)
print v(xbgr.mr_n57047776)
print v(xbgr.mr_n57047888)
print v(xbgr.mr_n57048208)
print v(xbgr.mr_n57048320)
print v(xbgr.mr_n57048640)
print v(xbgr.mr_n57048752)
print v(xbgr.mr_n57049072)
print v(xbgr.mr_n57049184)
print v(xbgr.mr_n57049504)
print v(xbgr.mr_n57049616)
print v(xbgr.mr_n57049936)
print v(xbgr.mr_n57050048)
print v(xbgr.mr_n57050368)
print v(xbgr.mr_n57050480)
print v(xbgr.mr_n57050800)
print v(xbgr.mr_n57050912)
print v(xbgr.mr_n57051232)
print v(xbgr.mr_n57051344)
print v(xbgr.mr_n57051664)
print v(xbgr.mr_n57051776)
print v(xbgr.mr_n57052096)
print v(xbgr.mr_n57052208)
print v(xbgr.mr_n57052528)
print v(xbgr.mr_n57052640)
print v(xbgr.mr_n57052960)
print v(xbgr.mr_n57053072)
print v(xbgr.mr_n57053392)
print v(xbgr.mr_n57053504)
print v(xbgr.mr_n57053824)
print v(xbgr.mr_n57053936)
print v(xbgr.mr_n57054256)
print v(xbgr.mr_n57054368)
print v(xbgr.mr_n57054688)
print v(xbgr.mr_n57054800)
print v(xbgr.mr_n57055120)
print v(xbgr.mr_n57055232)
print v(xbgr.mr_n57055552)
print v(xbgr.mr_n57055664)
print v(xbgr.mr_n57055984)
print v(xbgr.mr_n57056096)
print v(xbgr.mr_n57056416)
print v(xbgr.mr_n57056528)
print v(xbgr.mr_n57056848)
print v(xbgr.mr_n57056960)
print v(xbgr.mr_n57057280)
print v(xbgr.mr_n57057392)
print v(xbgr.mr_n57057712)
print v(xbgr.mr_n57057824)
print v(xbgr.mr_n57058144)
print v(xbgr.mr_n57058256)
print v(xbgr.mr_n57058576)
print v(xbgr.mr_n57058688)
print v(xbgr.mr_n57059008)
print v(xbgr.mr_n57059120)
print v(xbgr.mr_n57059440)
print v(xbgr.mr_n57059552)
print v(xbgr.mr_n57059872)
print v(xbgr.mr_n57059984)
print v(xbgr.mr_n57060304)
print v(xbgr.mr_n57060416)
print v(xbgr.mr_n57060736)
print v(xbgr.mr_n57060848)
print v(xbgr.mr_n57061168)
print v(xbgr.mr_n57061280)
print v(xbgr.mr_n57061600)
print v(xbgr.mr_n57061712)
print v(xbgr.mr_n57062032)
print v(xbgr.mr_n57062144)
print v(xbgr.mr_n57062464)
print v(xbgr.mr_n57062576)
print v(xbgr.mr_n57062896)
print v(xbgr.mr_n57063008)
print v(xbgr.mr_n57063328)
print v(xbgr.mr_n57063440)
print v(xbgr.mr_n57063760)
print v(xbgr.mr_n57063872)
print v(xbgr.mr_n57064192)
print v(xbgr.mr_n57064304)
print v(xbgr.mr_n57064624)
print v(xbgr.mr_n57064736)
print v(xbgr.mr_n57065056)
print v(xbgr.mr_n57065168)
print v(xbgr.mr_n57065488)
print v(xbgr.mr_n57065600)
print v(xbgr.mr_n57065920)
print v(xbgr.mr_n57066032)
print v(xbgr.mr_n57066352)
print v(xbgr.mr_n57066464)
print v(xbgr.mr_n57066784)
print v(xbgr.mr_n57066896)
print v(xbgr.mr_n57067216)
print v(xbgr.mr_n57067328)
print v(xbgr.mr_n57067648)
print v(xbgr.mr_n57067760)
print v(xbgr.mr_n57068080)
print v(xbgr.mr_n57068192)
print v(xbgr.mr_n57068512)
print v(xbgr.mr_n57068624)
print v(xbgr.mr_n57068944)
print v(xbgr.mr_n57069056)
print v(xbgr.mr_n57069376)
print v(xbgr.mr_n57069488)
print v(xbgr.mr_n57069808)
print v(xbgr.mr_n57069920)
print v(xbgr.mr_n57070240)
print v(xbgr.mr_n57070352)
print v(xbgr.mr_n57070672)
print v(xbgr.mr_n57070784)
print v(xbgr.mr_n57071104)
print v(xbgr.mr_n57071216)
print v(xbgr.mr_n57071536)
print v(xbgr.mr_n57071648)
print v(xbgr.mr_n57071968)
print v(xbgr.mr_n57072080)
print v(xbgr.mr_n57072400)
print v(xbgr.mr_n57072512)
print v(xbgr.mr_n57072832)
print v(xbgr.mr_n57072944)
print v(xbgr.mr_n57073264)
print v(xbgr.mr_n57073376)
print v(xbgr.mr_n57073696)
print v(xbgr.mr_n57073808)
print v(xbgr.mr_n57074128)
print v(xbgr.mr_n57074240)
print v(xbgr.mr_n57074560)
print v(xbgr.mr_n57074672)
print v(xbgr.mr_n57074992)
print v(xbgr.mr_n57075104)
print v(xbgr.mr_n57075424)
print v(xbgr.mr_n57075536)
print v(xbgr.mr_n57075856)
print v(xbgr.mr_n57075968)
print v(xbgr.mr_n57076288)
print v(xbgr.mr_n57076400)
print v(xbgr.mr_n57076720)
print v(xbgr.mr_n57076832)
print v(xbgr.mr_n57077152)
print v(xbgr.mr_n57077264)
print v(xbgr.mr_n57077584)
print v(xbgr.mr_n57077696)
print v(xbgr.mr_n57078016)
print v(xbgr.mr_n57078128)
print v(xbgr.mr_n57078448)
print v(xbgr.mr_n57078560)
print v(xbgr.mr_n57078880)
print v(xbgr.mr_n57078992)
print v(xbgr.mr_n57079312)
print v(xbgr.mr_n57079424)
print v(xbgr.mr_n57079744)
print v(xbgr.mr_n57079856)
print v(xbgr.mr_n57080176)
print v(xbgr.mr_n57080288)
print v(xbgr.mr_n57080608)
print v(xbgr.mr_n57080720)
print v(xbgr.mr_n57081040)
print v(xbgr.mr_n57081152)
print v(xbgr.mr_n57081472)
print v(xbgr.mr_n57081584)
print v(xbgr.mr_n57081904)
print v(xbgr.mr_n57082016)
print v(xbgr.mr_n57082336)
print v(xbgr.mr_n57082448)
print v(xbgr.mr_n57082768)
print v(xbgr.mr_n57082880)
print v(xbgr.mr_n57083200)
print v(xbgr.mr_n57083312)
print v(xbgr.mr_n57083632)
print v(xbgr.mr_n57083744)
print v(xbgr.mr_n57084064)
print v(xbgr.mr_n57084176)
print v(xbgr.mr_n57084496)
print v(xbgr.mr_n57084608)
print v(xbgr.mr_n57084928)
print v(xbgr.mr_n57085040)
print v(xbgr.mr_n57085360)
print v(xbgr.mr_n57085472)
print v(xbgr.mr_n57085792)
print v(xbgr.mr_n57085904)
print v(xbgr.mr_n57086224)
print v(xbgr.mr_n57086336)
print v(xbgr.mr_n57086656)
print v(xbgr.mr_n57086768)
print v(xbgr.mr_n57087088)
print v(xbgr.mr_n57087200)
print v(xbgr.mr_n57087520)
print v(xbgr.mr_n57087632)
print v(xbgr.mr_n57087952)
print v(xbgr.mr_n57088064)
print v(xbgr.mr_n57088384)
print v(xbgr.mr_n57088496)
print v(xbgr.mr_n57088816)
print v(xbgr.mr_n57088928)
print v(xbgr.mr_n57089248)
print v(xbgr.mr_n57089360)
print v(xbgr.mr_n57089680)
print v(xbgr.mr_n57089792)
print v(xbgr.mr_n57090112)
print v(xbgr.mr_n57090224)
print v(xbgr.mr_n57090544)
print v(xbgr.mr_n57090656)
print v(xbgr.mr_n57090976)
print v(xbgr.mr_n57091088)
print v(xbgr.mr_n57091408)
print v(xbgr.mr_n57091520)
print v(xbgr.mr_n57091840)
print v(xbgr.mr_n57091952)
print v(xbgr.mr_n57092272)
print v(xbgr.mr_n57092384)
print v(xbgr.mr_n57092704)
print v(xbgr.mr_n57092816)
print v(xbgr.mr_n57093136)
print v(xbgr.mr_n57093248)
print v(xbgr.mr_n57093568)
print v(xbgr.mr_n57093680)
print v(xbgr.mr_n57094000)
print v(xbgr.mr_n57094112)
print v(xbgr.mr_n57094432)
print v(xbgr.mr_n57094544)
print v(xbgr.mr_n57094864)
print v(xbgr.mr_n57094976)
print v(xbgr.mr_n57095296)
print v(xbgr.mr_n57095408)
print v(xbgr.mr_n57095728)
print v(xbgr.mr_n57095840)
print v(xbgr.mr_n57096160)
print v(xbgr.mr_n57096272)
print v(xbgr.mr_n57096592)
print v(xbgr.mr_n57096704)
print v(xbgr.mr_n57097024)
print v(xbgr.mr_n57097136)
print v(xbgr.mr_n57097456)
print v(xbgr.mr_n57097568)
print v(xbgr.mr_n57097888)
print v(xbgr.mr_n57098000)
print v(xbgr.mr_n57098320)
print v(xbgr.mr_n57098432)
print v(xbgr.mr_n57098864)
print v(xbgr.mr_n57099184)
print v(xbgr.mr_n57099296)
print v(xbgr.mr_n57099616)
print v(xbgr.mr_n57099728)
print v(xbgr.mr_n57100048)
print v(xbgr.mr_n57100160)
print v(xbgr.mr_n57100480)
print v(xbgr.mr_n57100592)
print v(xbgr.mr_n57100912)
print v(xbgr.mr_n57101776)
print v(xbgr.mr_n57101888)
print v(xbgr.mr_n57102208)
print v(xbgr.mr_n57102320)
print v(xbgr.mr_n57102640)
print v(xbgr.mr_n57102752)
print v(xbgr.mr_n57103072)
print v(xbgr.mr_n57103184)
print v(xbgr.mr_n57103504)
print v(xbgr.mr_n57103616)
print v(xbgr.mr_n57104048)
print v(xbgr.mr_n57104368)
print v(xbgr.mr_n57104480)
print v(xbgr.mr_n57104800)
print v(xbgr.mr_n57104912)
print v(xbgr.mr_n57105232)
print v(xbgr.mr_n57105344)
print v(xbgr.mr_n57105664)
print v(xbgr.mr_n57105776)
print v(xbgr.mr_n57106096)
print v(xbgr.mr_n57106208)
print v(xbgr.mr_n57106640)
print v(xbgr.mr_n57106960)
print v(xbgr.mr_n57107824)
print v(xbgr.mr_n57107936)
print v(xbgr.mr_n57108368)
print v(xbgr.mr_n57108688)
print v(xbgr.mr_n57109552)
print v(xbgr.mr_n57109664)
print v(xbgr.mr_n57110096)
print v(xbgr.mr_n57110416)
print v(xbgr.mr_n57110528)
print v(xbgr.mr_n57110848)
print v(xbgr.mr_n57110960)
print v(xbgr.mr_n57111280)
print v(xbgr.mr_n57111392)
print v(xbgr.mr_n57111712)
print v(xbgr.mr_n57111824)
print v(xbgr.mr_n57112144)
print v(xbgr.mr_n57112256)
print v(xbgr.mr_n57112576)
print v(xbgr.mr_n57112688)
print v(xbgr.mr_n57113008)
print v(xbgr.mr_n57113872)
print v(xbgr.mr_n57113984)
print v(xbgr.mr_n57114304)
print v(xbgr.mr_n57114416)
print v(xbgr.mr_n57114736)
print v(xbgr.mr_n57115600)
print v(xbgr.mr_n57115712)
print v(xbgr.mr_n57116032)
print v(xbgr.mr_n57116144)
print v(xbgr.mr_n57116464)
print v(xbgr.mr_n57116576)
print v(xbgr.mr_n57116896)
print v(xbgr.mr_n57117008)
print v(xbgr.mr_n57117328)
print v(xbgr.mr_n57117440)
print v(xbgr.mr_n57117760)
print v(xbgr.mr_n57117872)
print v(xbgr.mr_n57118192)
print v(xbgr.mr_n57118304)
print v(xbgr.mr_n57118624)
print v(xbgr.mr_n57118736)
print v(xbgr.mr_n57119056)
print v(xbgr.mr_n57119168)
print v(xbgr.mr_n57119488)
print v(xbgr.mr_n57119600)
print v(xbgr.mr_n57119920)
print v(xbgr.mr_n57120032)
print v(xbgr.mr_n57120352)
print v(xbgr.mr_n57120464)
print v(xbgr.mr_n57120784)
print v(xbgr.mr_n57120896)
print v(xbgr.mr_n57121216)
print v(xbgr.mr_n57121328)
print v(xbgr.mr_n57121648)
print v(xbgr.mr_n57121760)
print v(xbgr.mr_n57122080)
print v(xbgr.mr_n57122192)
print v(xbgr.mr_n57122512)
print v(xbgr.mr_n57122624)
print v(xbgr.mr_n57122944)
print v(xbgr.mr_n57123056)
print v(xbgr.mr_n57123376)
print v(xbgr.mr_n57123488)
print v(xbgr.mr_n57123808)
print v(xbgr.mr_n57123920)
print v(xbgr.mr_n57124240)
print v(xbgr.mr_n57124352)
print v(xbgr.mr_n57124672)
print v(xbgr.mr_n57124784)
print v(xbgr.mr_n57125104)
print v(xbgr.mr_n57125216)
print v(xbgr.mr_n57125536)
print v(xbgr.mr_n57125648)
print v(xbgr.mr_n57125968)
print v(xbgr.mr_n57126080)
print v(xbgr.mr_n57126400)
print v(xbgr.mr_n57126512)
print v(xbgr.mr_n57126944)
print v(xbgr.mr_n57127376)
print v(xbgr.mr_n57127808)
print v(xbgr.mr_n57128240)
print v(xbgr.mr_n57128672)
print v(xbgr.mr_n57129104)
print v(xbgr.mr_n57129536)
print v(xbgr.mr_n57129968)
print v(xbgr.mr_n57130400)
print v(xbgr.mr_n57130832)
print v(xbgr.mr_n57131264)
print v(xbgr.mr_n57131696)
print v(xbgr.mr_n57132128)
print v(xbgr.mr_n57132560)
print v(xbgr.mr_n57132992)
print v(xbgr.mr_n57133424)
print v(xbgr.mr_n57133856)
print v(xbgr.mr_n57134288)
print v(xbgr.mr_n57134720)
print v(xbgr.mr_n57135152)
print v(xbgr.mr_n57135584)
print v(xbgr.mr_n57136016)
print v(xbgr.mr_n57136336)
print v(xbgr.mr_n57136448)
print v(xbgr.mr_n57136880)
print v(xbgr.mr_n57137312)
print v(xbgr.mr_n57137744)
print v(xbgr.mr_n57138176)
print v(xbgr.mr_n57138608)
print v(xbgr.mr_n57139040)
print v(xbgr.mr_n57139472)
print v(xbgr.mr_n57139904)
print v(xbgr.mr_n57140336)
print v(xbgr.mr_n57140768)
print v(xbgr.mr_n57141200)
print v(xbgr.mr_n57141632)
print v(xbgr.mr_n57142064)
print v(xbgr.mr_n57142496)
print v(xbgr.mr_n57142928)
print v(xbgr.mr_n57143360)
print v(xbgr.mr_n57143792)
print v(xbgr.mr_n57144224)
print v(xbgr.mr_n57144656)
print v(xbgr.mr_n57145088)
print v(xbgr.mr_n57145520)
print v(xbgr.mr_n57145952)
print v(xbgr.mr_n57146384)
print v(xbgr.mr_n57146816)
print v(xbgr.mr_n57147248)
print v(xbgr.mr_n57147680)
print v(xbgr.mr_n57148112)
print v(xbgr.mr_n57148544)
print v(xbgr.mr_n57148976)
print v(xbgr.mr_n57149408)
print v(xbgr.mr_n57149840)
print v(xbgr.mr_n57150272)
print v(xbgr.mr_n57150704)
print v(xbgr.mr_n57151136)
print v(xbgr.mr_n57151568)
print v(xbgr.mr_n57152000)
print v(xbgr.mr_n57152432)
print v(xbgr.mr_n57152864)
print v(xbgr.mr_n57153296)
print v(xbgr.mr_n57153728)
print v(xbgr.mr_n57154160)
print v(xbgr.mr_n57154592)
print v(xbgr.mr_n57155024)
print v(xbgr.mr_n57155456)
print v(xbgr.mr_n57155888)
print v(xbgr.mr_n57156320)
print v(xbgr.mr_n57156752)
print v(xbgr.mr_n57157184)
print v(xbgr.mr_n57157616)
print v(xbgr.mr_n57158048)
print v(xbgr.mr_n57158480)
print v(xbgr.mr_n57158912)
print v(xbgr.mr_n57159344)
print v(xbgr.mr_n57159776)
print v(xbgr.mr_n57160208)
print v(xbgr.mr_n57160640)
print v(xbgr.mr_n57161072)
print v(xbgr.mr_n57161504)
print v(xbgr.mr_n57161936)
print v(xbgr.mr_n57162368)
print v(xbgr.mr_n57162800)
print v(xbgr.mr_n57163232)
print v(xbgr.mr_n57163664)
print v(xbgr.mr_n57163984)
print v(xbgr.mr_n57164096)
print v(xbgr.mr_n57164416)
print v(xbgr.mr_n57164528)
print v(xbgr.mr_n57164848)
print v(xbgr.mr_n57164960)
print v(xbgr.mr_n57165280)
print v(xbgr.mr_n57165392)
print v(xbgr.mr_n57165712)
print v(xbgr.mr_n57165824)
print v(xbgr.mr_n57166144)
print v(xbgr.mr_n57166256)
print v(xbgr.mr_n57166576)
print v(xbgr.mr_n57166688)
print v(xbgr.mr_n57167008)
print v(xbgr.mr_n57167120)
print v(xbgr.mr_n57167440)
print v(xbgr.mr_n57167552)
print v(xbgr.mr_n57167872)
print v(xbgr.mr_n57167984)
print v(xbgr.mr_n57168304)
print v(xbgr.mr_n57168416)
print v(xbgr.mr_n57168736)
print v(xbgr.mr_n57168848)
print v(xbgr.mr_n57169168)
print v(xbgr.mr_n57169600)
print v(xbgr.mr_n57169712)
print v(xbgr.mr_n57170032)
print v(xbgr.mr_n57170144)
print v(xbgr.mr_n57170464)
print v(xbgr.mr_n57170576)
print v(xbgr.mr_n57170896)
print v(xbgr.mr_n57171008)
print v(xbgr.mr_n57171328)
print v(xbgr.mr_n57171440)
print v(xbgr.mr_n57171760)
print v(xbgr.mr_n57171872)
print v(xbgr.mr_n57172192)
print v(xbgr.mr_n57172304)
print v(xbgr.mr_n57172624)
print v(xbgr.mr_n57172736)
print v(xbgr.mr_n57173056)
print v(xbgr.mr_n57173168)
print v(xbgr.mr_n57173488)
print v(xbgr.mr_n57173600)
print v(xbgr.mr_n57173920)
print v(xbgr.mr_n57174032)
print v(xbgr.mr_n57174464)
print v(xbgr.mr_n57174896)
print v(xbgr.mr_n57175328)
print v(xbgr.mr_n57175760)
print v(xbgr.mr_n57176192)
print v(xbgr.mr_n57176624)
print v(xbgr.mr_n57177056)
print v(xbgr.mr_n57177488)
print v(xbgr.mr_n57177920)
print v(xbgr.mr_n57178352)
print v(xbgr.mr_n57178784)
print v(xbgr.mr_n57179216)
print v(xbgr.mr_n57179648)
print v(xbgr.mr_n57180080)
print v(xbgr.mr_n57180512)
print v(xbgr.mr_n57180944)
print v(xbgr.mr_n57181376)
print v(xbgr.mr_n57181808)
print v(xbgr.mr_n57182240)
print v(xbgr.mr_n57182672)
print v(xbgr.mr_n57183104)
print v(xbgr.mr_n57183536)
print v(xbgr.mr_n57183968)
print v(xbgr.mr_n57184400)
print v(xbgr.mr_n57184832)
print v(xbgr.mr_n57185264)
print v(xbgr.mr_n57185696)
print v(xbgr.mr_n57186128)
print v(xbgr.mr_n57186560)
print v(xbgr.mr_n57186992)
print v(xbgr.mr_n57187424)
print v(xbgr.mr_n57187856)
print v(xbgr.mr_n57188288)
print v(xbgr.mr_n57188720)
print v(xbgr.mr_n57189152)
print v(xbgr.mr_n57189584)
print v(xbgr.mr_n57190016)
print v(xbgr.mr_n57190448)
print v(xbgr.mr_n57190880)
print v(xbgr.mr_n57191312)
print v(xbgr.mr_n57191744)
print v(xbgr.mr_n57192176)
print v(xbgr.mr_n57192608)
print v(xbgr.mr_n57193040)
print v(xbgr.mr_n57193472)
print v(xbgr.mr_n57193904)
print v(xbgr.mr_n57194336)
print v(xbgr.mr_n57194768)
print v(xbgr.mr_n57195200)
print v(xbgr.mr_n57195632)
print v(xbgr.mr_n57196064)
print v(xbgr.mr_n57196496)
print v(xbgr.mr_n57196928)
print v(xbgr.mr_n57197360)
print v(xbgr.mr_n57197792)
print v(xbgr.mr_n57198224)
print v(xbgr.mr_n57198656)
print v(xbgr.mr_n57199088)
print v(xbgr.mr_n57199520)
print v(xbgr.mr_n57199952)
print v(xbgr.mr_n57200384)
print v(xbgr.mr_n57200816)
print v(xbgr.mr_n57201248)
print v(xbgr.mr_n57201680)
print v(xbgr.mr_n57202112)
print v(xbgr.mr_n57202544)
print v(xbgr.mr_n57202976)
print v(xbgr.mr_n57203408)
print v(xbgr.mr_n57203840)
print v(xbgr.mr_n57204272)
print v(xbgr.mr_n57204704)
print v(xbgr.mr_n57205136)
print v(xbgr.mr_n57205568)
print v(xbgr.mr_n57206000)
print v(xbgr.mr_n57206432)
print v(xbgr.mr_n57206864)
print v(xbgr.mr_n57207296)
print v(xbgr.mr_n57207728)
print v(xbgr.mr_n57208160)
print v(xbgr.mr_n57208592)
print v(xbgr.mr_n57209024)
print v(xbgr.mr_n57209456)
print v(xbgr.mr_n57209888)
print v(xbgr.mr_n57210320)
print v(xbgr.mr_n57210752)
print v(xbgr.mr_n57211184)
print v(xbgr.mr_n57211504)
print v(xbgr.mr_n57211616)
print v(xbgr.mr_n57211936)
print v(xbgr.mr_n57212048)
print v(xbgr.mr_n57212368)
print v(xbgr.mr_n57212480)
print v(xbgr.mr_n57212800)
print v(xbgr.mr_n57212912)
print v(xbgr.mr_n57213232)
print v(xbgr.mr_n57213344)
print v(xbgr.mr_n57213664)
print v(xbgr.mr_n57213776)
print v(xbgr.mr_n57214096)
print v(xbgr.mr_n57214208)
print v(xbgr.mr_n57214528)
print v(xbgr.mr_n57214640)
print v(xbgr.mr_n57214960)
print v(xbgr.mr_n57215072)
print v(xbgr.mr_n57215392)
print v(xbgr.mr_n57215504)
print v(xbgr.mr_n57215824)
print v(xbgr.mr_n57215936)
print v(xbgr.mr_n57216256)
print v(xbgr.mr_n57216368)
print v(xbgr.mr_n57216688)
print v(xbgr.mr_n57216800)
print v(xbgr.mr_n57217120)
print v(xbgr.mr_n57217232)
print v(xbgr.mr_n57217552)
print v(xbgr.mr_n57217664)
print v(xbgr.mr_n57217984)
print v(xbgr.mr_n57218096)
print v(xbgr.mr_n57218416)
print v(xbgr.mr_n57218528)
print v(xbgr.mr_n57218848)
print v(xbgr.mr_n57218960)
print v(xbgr.mr_n57219280)
print v(xbgr.mr_n57219824)
print v(xbgr.mr_n57220144)
print v(xbgr.mr_n57220576)
print v(xbgr.mr_n57220688)
print v(xbgr.mr_n57221008)
print v(xbgr.mr_n57221120)
print v(xbgr.mr_n57221552)
print v(xbgr.mr_n57221872)
print v(xbgr.mr_n57222736)
print v(xbgr.mr_n57222848)
print v(xbgr.mr_n57223280)
print v(xbgr.mr_n57223600)
print v(xbgr.mr_n57224464)
print v(xbgr.mr_n57224576)
print v(xbgr.mr_n57225008)
print v(xbgr.mr_n57225328)
print v(xbgr.mr_n57225440)
print v(xbgr.mr_n57225872)
print v(xbgr.mr_n57226304)
print v(xbgr.mr_n57226624)
print v(xbgr.mr_n57227488)
print v(xbgr.mr_n57228464)
print v(xbgr.mr_n57228784)
print v(xbgr.mr_n57228896)
print v(xbgr.mr_n57229328)
print v(xbgr.mr_n57229648)
print v(xbgr.mr_n57229760)
print v(xbgr.mr_n57230192)
print v(xbgr.mr_n57230512)
print v(xbgr.mr_n57230624)
print v(xbgr.mr_n57230944)
print v(xbgr.mr_n57231056)
print v(xbgr.mr_n57231376)
print v(xbgr.mr_n57231488)
print v(xbgr.mr_n57231808)
print v(xbgr.mr_n57231920)
print v(xbgr.mr_n57232240)
print v(xbgr.mr_n57232352)
print v(xbgr.mr_n57232672)
print v(xbgr.mr_n57232784)
print v(xbgr.mr_n57233104)
print v(xbgr.mr_n57233216)
print v(xbgr.mr_n57233536)
print v(xbgr.mr_n57233648)
print v(xbgr.mr_n57233968)
print v(xbgr.mr_n57234080)
print v(xbgr.mr_n57234400)
print v(xbgr.mr_n57234512)
print v(xbgr.mr_n57234832)
print v(xbgr.mr_n57234944)
print v(xbgr.mr_n57235264)
print v(xbgr.mr_n57235376)
print v(xbgr.mr_n57235696)
print v(xbgr.mr_n57236560)
print v(xbgr.mr_n57237424)
print v(xbgr.mr_n57237856)
print v(xbgr.mr_n57238288)
print v(xbgr.mr_n57238720)
print v(xbgr.mr_n57239152)
print v(xbgr.mr_n57239584)
print v(xbgr.mr_n57240016)
print v(xbgr.mr_n57240448)
print v(xbgr.mr_n57240880)
print v(xbgr.mr_n57241312)
print v(xbgr.mr_n57241744)
print v(xbgr.mr_n57242176)
print v(xbgr.mr_n57242608)
print v(xbgr.mr_n57242720)
print v(xbgr.mr_n57243040)
print v(xbgr.mr_n57243152)
print v(xbgr.mr_n57243472)
print v(xbgr.mr_n57243584)
print v(xbgr.mr_n57243904)
print v(xbgr.mr_n57244016)
print v(xbgr.mr_n57244336)
print v(xbgr.mr_n57244448)
print v(xbgr.mr_n57244768)
print v(xbgr.mr_n57244880)
print v(xbgr.mr_n57245200)
print v(xbgr.mr_n57245312)
print v(xbgr.mr_n57245632)
print v(xbgr.mr_n57245744)
print v(xbgr.mr_n57246064)
print v(xbgr.mr_n57246176)
print v(xbgr.mr_n57246496)
print v(xbgr.mr_n57246608)
print v(xbgr.mr_n57246928)
print v(xbgr.mr_n57247040)
print v(xbgr.mr_n57247360)
print v(xbgr.mr_n57247472)
print v(xbgr.mr_n57247792)
print v(xbgr.mr_n57248224)
print v(xbgr.mr_n57248336)
print v(xbgr.mr_n57248656)
print v(xbgr.mr_n57248768)
print v(xbgr.mr_n57249088)
print v(xbgr.mr_n57249200)
print v(xbgr.mr_n57249520)
print v(xbgr.mr_n57249632)
print v(xbgr.mr_n57249952)
print v(xbgr.mr_n57250064)
print v(xbgr.mr_n57250384)
print v(xbgr.mr_n57250496)
print v(xbgr.mr_n57250816)
print v(xbgr.mr_n57250928)
print v(xbgr.mr_n57251248)
print v(xbgr.mr_n57251360)
print v(xbgr.mr_n57251680)
print v(xbgr.mr_n57251792)
print v(xbgr.mr_n57252112)
print v(xbgr.mr_n57252224)
print v(xbgr.mr_n57252544)
print v(xbgr.mr_n57252656)
print v(xbgr.mr_n57252976)
print v(xbgr.mr_n57253088)
print v(xbgr.mr_n57253408)
print v(xbgr.mr_n57253520)
print v(xbgr.mr_n57253840)
print v(xbgr.mr_n57253952)
print v(xbgr.mr_n57254272)
print v(xbgr.mr_n57254384)
print v(xbgr.mr_n57254704)
print v(xbgr.mr_n57254816)
print v(xbgr.mr_n57255136)
print v(xbgr.mr_n57255248)
print v(xbgr.mr_n57255568)
print v(xbgr.mr_n57255680)
print v(xbgr.mr_n57256000)
print v(xbgr.mr_n57256112)
print v(xbgr.mr_n57256432)
print v(xbgr.mr_n57256544)
print v(xbgr.mr_n57256864)
print v(xbgr.mr_n57256976)
print v(xbgr.mr_n57257296)
print v(xbgr.mr_n57257408)
print v(xbgr.mr_n57257728)
print v(xbgr.mr_n57257840)
print v(xbgr.mr_n57258160)
print v(xbgr.mr_n57258272)
print v(xbgr.mr_n57258592)
print v(xbgr.mr_n57258704)
print v(xbgr.mr_n57259024)
print v(xbgr.mr_n57259136)
print v(xbgr.mr_n57259456)
print v(xbgr.mr_n57259568)
print v(xbgr.mr_n57259888)
print v(xbgr.mr_n57260000)
print v(xbgr.mr_n57260320)
print v(xbgr.mr_n57260432)
print v(xbgr.mr_n57260752)
print v(xbgr.mr_n57260864)
print v(xbgr.mr_n57261184)
print v(xbgr.mr_n57261296)
print v(xbgr.mr_n57261616)
print v(xbgr.mr_n57261728)
print v(xbgr.mr_n57262048)
print v(xbgr.mr_n57262160)
print v(xbgr.mr_n57262480)
print v(xbgr.mr_n57262592)
print v(xbgr.mr_n57262912)
print v(xbgr.mr_n57263024)
print v(xbgr.mr_n57263344)
print v(xbgr.mr_n57263456)
print v(xbgr.mr_n57263776)
print v(xbgr.mr_n57263888)
print v(xbgr.mr_n57264208)
print v(xbgr.mr_n57264320)
print v(xbgr.mr_n57264640)
print v(xbgr.mr_n57264752)
print v(xbgr.mr_n57265072)
print v(xbgr.mr_n57265184)
print v(xbgr.mr_n57265504)
print v(xbgr.mr_n57265616)
print v(xbgr.mr_n57265936)
print v(xbgr.mr_n57266048)
print v(xbgr.mr_n57266368)
print v(xbgr.mr_n57266480)
print v(xbgr.mr_n57266800)
print v(xbgr.mr_n57266912)
print v(xbgr.mr_n57267232)
print v(xbgr.mr_n57267344)
print v(xbgr.mr_n57267664)
print v(xbgr.mr_n57267776)
print v(xbgr.mr_n57268096)
print v(xbgr.mr_n57268208)
print v(xbgr.mr_n57268528)
print v(xbgr.mr_n57268640)
print v(xbgr.mr_n57268960)
print v(xbgr.mr_n57269072)
print v(xbgr.mr_n57269392)
print v(xbgr.mr_n57269504)
print v(xbgr.mr_n57269824)
print v(xbgr.mr_n57269936)
print v(xbgr.mr_n57270256)
print v(xbgr.mr_n57270368)
print v(xbgr.mr_n57270688)
print v(xbgr.mr_n57270800)
print v(xbgr.mr_n57271120)
print v(xbgr.mr_n57271232)
print v(xbgr.mr_n57271552)
print v(xbgr.mr_n57271664)
print v(xbgr.mr_n57271984)
print v(xbgr.mr_n57272096)
print v(xbgr.mr_n57272416)
print v(xbgr.mr_n57272528)
print v(xbgr.mr_n57272848)
print v(xbgr.mr_n57272960)
print v(xbgr.mr_n57273280)
print v(xbgr.mr_n57273392)
print v(xbgr.mr_n57273712)
print v(xbgr.mr_n57273824)
print v(xbgr.mr_n57274144)
print v(xbgr.mr_n57274256)
print v(xbgr.mr_n57274576)
print v(xbgr.mr_n57274688)
print v(xbgr.mr_n57275008)
print v(xbgr.mr_n57275120)
print v(xbgr.mr_n57275440)
print v(xbgr.mr_n57275552)
print v(xbgr.mr_n57275872)
print v(xbgr.mr_n57275984)
print v(xbgr.mr_n57276304)
print v(xbgr.mr_n57276416)
print v(xbgr.mr_n57276736)
print v(xbgr.mr_n57276848)
print v(xbgr.mr_n57277168)
print v(xbgr.mr_n57277280)
print v(xbgr.mr_n57277600)
print v(xbgr.mr_n57277712)
print v(xbgr.mr_n57278032)
print v(xbgr.mr_n57278144)
print v(xbgr.mr_n57278464)
print v(xbgr.mr_n57278576)
print v(xbgr.mr_n57278896)
print v(xbgr.mr_n57279008)
print v(xbgr.mr_n57279328)
print v(xbgr.mr_n57279440)
print v(xbgr.mr_n57279760)
print v(xbgr.mr_n57280192)
print v(xbgr.mr_n57280304)
print v(xbgr.mr_n57280624)
print v(xbgr.mr_n57280736)
print v(xbgr.mr_n57281056)
print v(xbgr.mr_n57281168)
print v(xbgr.mr_n57281488)
print v(xbgr.mr_n57281600)
print v(xbgr.mr_n57281920)
print v(xbgr.mr_n57282032)
print v(xbgr.mr_n57282352)
print v(xbgr.mr_n57282464)
print v(xbgr.mr_n57282784)
print v(xbgr.mr_n57282896)
print v(xbgr.mr_n57283216)
print v(xbgr.mr_n57283328)
print v(xbgr.mr_n57283648)
print v(xbgr.mr_n57283760)
print v(xbgr.mr_n57284080)
print v(xbgr.mr_n57284192)
print v(xbgr.mr_n57284512)
print v(xbgr.mr_n57284624)
print v(xbgr.mr_n57284944)
print v(xbgr.mr_n57285056)
print v(xbgr.mr_n57285376)
print v(xbgr.mr_n57285488)
print v(xbgr.mr_n57285808)
print v(xbgr.mr_n57285920)
print v(xbgr.mr_n57286240)
print v(xbgr.mr_n57286352)
print v(xbgr.mr_n57286672)
print v(xbgr.mr_n57286784)
print v(xbgr.mr_n57287104)
print v(xbgr.mr_n57287216)
print v(xbgr.mr_n57287536)
print v(xbgr.mr_n57287648)
print v(xbgr.mr_n57287968)
print v(xbgr.mr_n57288512)
print v(xbgr.mr_n57288832)
print v(xbgr.mr_n57288944)
print v(xbgr.mr_n57289264)
print v(xbgr.mr_n57289376)
print v(xbgr.mr_n57289808)
print v(xbgr.mr_n57290240)
print v(xbgr.mr_n57290672)
print v(xbgr.mr_n57291104)
print v(xbgr.mr_n57291536)
print v(xbgr.mr_n57291968)
print v(xbgr.mr_n57292400)
print v(xbgr.mr_n57292832)
print v(xbgr.mr_n57293264)
print v(xbgr.mr_n57293696)
print v(xbgr.mr_n57294128)
print v(xbgr.mr_n57294560)
print v(xbgr.mr_n57294992)
print v(xbgr.mr_n57295424)
print v(xbgr.mr_n57295856)
print v(xbgr.mr_n57296288)
print v(xbgr.mr_n57296720)
print v(xbgr.mr_n57297152)
print v(xbgr.mr_n57297584)
print v(xbgr.mr_n57298016)
print v(xbgr.mr_n57298448)
print v(xbgr.mr_n57298880)
print v(xbgr.mr_n57299312)
print v(xbgr.mr_n57299744)
print v(xbgr.mr_n57300176)
print v(xbgr.mr_n57300608)
print v(xbgr.mr_n57301040)
print v(xbgr.mr_n57301472)
print v(xbgr.mr_n57301904)
print v(xbgr.mr_n57302336)
print v(xbgr.mr_n57302768)
print v(xbgr.mr_n57303200)
print v(xbgr.mr_n57303632)
print v(xbgr.mr_n57304064)
print v(xbgr.mr_n57304496)
print v(xbgr.mr_n57304928)
print v(xbgr.mr_n57305360)
print v(xbgr.mr_n57305792)
print v(xbgr.mr_n57306224)
print v(xbgr.mr_n57306656)
print v(xbgr.mr_n57307088)
print v(xbgr.mr_n57307520)
print v(xbgr.mr_n57307952)
print v(xbgr.mr_n57308384)
print v(xbgr.mr_n57308816)
print v(xbgr.mr_n57309248)
print v(xbgr.mr_n57309680)
print v(xbgr.mr_n57310112)
print v(xbgr.mr_n57310544)
print v(xbgr.mr_n57310976)
print v(xbgr.mr_n57311408)
print v(xbgr.mr_n57311840)
print v(xbgr.mr_n57312272)
print v(xbgr.mr_n57312704)
print v(xbgr.mr_n57313136)
print v(xbgr.mr_n57313568)
print v(xbgr.mr_n57314000)
print v(xbgr.mr_n57314432)
print v(xbgr.mr_n57314864)
print v(xbgr.mr_n57315296)
print v(xbgr.mr_n57315728)
print v(xbgr.mr_n57316160)
print v(xbgr.mr_n57316592)
print v(xbgr.mr_n57317024)
print v(xbgr.mr_n57317456)
print v(xbgr.mr_n57317888)
print v(xbgr.mr_n57318320)
print v(xbgr.mr_n57318752)
print v(xbgr.mr_n57319184)
print v(xbgr.mr_n57319616)
print v(xbgr.mr_n57320048)
print v(xbgr.mr_n57320480)
print v(xbgr.mr_n57320912)
print v(xbgr.mr_n57321344)
print v(xbgr.mr_n57321776)
print v(xbgr.mr_n57322208)
print v(xbgr.mr_n57322640)
print v(xbgr.mr_n57323072)
print v(xbgr.mr_n57323504)
print v(xbgr.mr_n57323936)
print v(xbgr.mr_n57324368)
print v(xbgr.mr_n57324800)
print v(xbgr.mr_n57325232)
print v(xbgr.mr_n57325664)
print v(xbgr.mr_n57326096)
print v(xbgr.mr_n57326528)
print v(xbgr.mr_n57326960)
print v(xbgr.mr_n57327392)
print v(xbgr.mr_n57327824)
print v(xbgr.mr_n57328256)
print v(xbgr.mr_n57328688)
print v(xbgr.mr_n57329120)
print v(xbgr.mr_n57329552)
print v(xbgr.mr_n57329984)
print v(xbgr.mr_n57330416)
print v(xbgr.mr_n57330848)
print v(xbgr.mr_n57331280)
print v(xbgr.mr_n57331712)
print v(xbgr.mr_n57332144)
print v(xbgr.mr_n57332576)
print v(xbgr.mr_n57333008)
print v(xbgr.mr_n57333440)
print v(xbgr.mr_n57333872)
print v(xbgr.mr_n57334304)
print v(xbgr.mr_n57334736)
print v(xbgr.mr_n57335056)
print v(xbgr.mr_n57335168)
print v(xbgr.mr_n57335488)
print v(xbgr.mr_n57335600)
print v(xbgr.mr_n57335920)
print v(xbgr.mr_n57336032)
print v(xbgr.mr_n57336352)
print v(xbgr.mr_n57336464)
print v(xbgr.mr_n57336784)
print v(xbgr.mr_n57336896)
print v(xbgr.mr_n57337216)
print v(xbgr.mr_n57337328)
print v(xbgr.mr_n57337648)
print v(xbgr.mr_n57337760)
print v(xbgr.mr_n57338080)
print v(xbgr.mr_n57338192)
print v(xbgr.mr_n57338512)
print v(xbgr.mr_n57338624)
print v(xbgr.mr_n57338944)
print v(xbgr.mr_n57339056)
print v(xbgr.mr_n57339376)
print v(xbgr.mr_n57339488)
print v(xbgr.mr_n57339808)
print v(xbgr.mr_n57339920)
print v(xbgr.mr_n57340240)
print v(xbgr.mr_n57340352)
print v(xbgr.mr_n57340672)
print v(xbgr.mr_n57340784)
print v(xbgr.mr_n57341104)
print v(xbgr.mr_n57341216)
print v(xbgr.mr_n57341536)
print v(xbgr.mr_n57341648)
print v(xbgr.mr_n57341968)
print v(xbgr.mr_n57342080)
print v(xbgr.mr_n57342400)
print v(xbgr.mr_n57342512)
print v(xbgr.mr_n57342832)
print v(xbgr.mr_n57342944)
print v(xbgr.mr_n57343264)
print v(xbgr.mr_n57343376)
print v(xbgr.mr_n57343696)
print v(xbgr.mr_n57343808)
print v(xbgr.mr_n57344128)
print v(xbgr.mr_n57344240)
print v(xbgr.mr_n57344560)
print v(xbgr.mr_n57344672)
print v(xbgr.mr_n57344992)
print v(xbgr.mr_n57345104)
print v(xbgr.mr_n57345424)
print v(xbgr.mr_n57345536)
print v(xbgr.mr_n57345856)
print v(xbgr.mr_n57345968)
print v(xbgr.mr_n57346288)
print v(xbgr.mr_n57346400)
print v(xbgr.mr_n57346720)
print v(xbgr.mr_n57346832)
print v(xbgr.mr_n57347152)
print v(xbgr.mr_n57347264)
print v(xbgr.mr_n57347584)
print v(xbgr.mr_n57347696)
print v(xbgr.mr_n57348016)
print v(xbgr.mr_n57348128)
print v(xbgr.mr_n57348448)
print v(xbgr.mr_n57348560)
print v(xbgr.mr_n57348880)
print v(xbgr.mr_n57348992)
print v(xbgr.mr_n57349312)
print v(xbgr.mr_n57349424)
print v(xbgr.mr_n57349744)
print v(xbgr.mr_n57349856)
print v(xbgr.mr_n57350176)
print v(xbgr.mr_n57350288)
print v(xbgr.mr_n57350608)
print v(xbgr.mr_n57350720)
print v(xbgr.mr_n57351040)
print v(xbgr.mr_n57351152)
print v(xbgr.mr_n57351472)
print v(xbgr.mr_n57351584)
print v(xbgr.mr_n57351904)
print v(xbgr.mr_n57352016)
print v(xbgr.mr_n57352336)
print v(xbgr.mr_n57352448)
print v(xbgr.mr_n57352768)
print v(xbgr.mr_n57352880)
print v(xbgr.mr_n57353200)
print v(xbgr.mr_n57353632)
print v(xbgr.mr_n57353744)
print v(xbgr.mr_n57354064)
print v(xbgr.mr_n57354176)
print v(xbgr.mr_n57354496)
print v(xbgr.mr_n57354608)
print v(xbgr.mr_n57354928)
print v(xbgr.mr_n57355040)
print v(xbgr.mr_n57355360)
print v(xbgr.mr_n57355472)
print v(xbgr.mr_n57355792)
print v(xbgr.mr_n57355904)
print v(xbgr.mr_n57356224)
print v(xbgr.mr_n57356336)
print v(xbgr.mr_n57356656)
print v(xbgr.mr_n57356768)
print v(xbgr.mr_n57357088)
print v(xbgr.mr_n57357200)
print v(xbgr.mr_n57357520)
print v(xbgr.mr_n57357632)
print v(xbgr.mr_n57357952)
print v(xbgr.mr_n57358064)
print v(xbgr.mr_n57358384)
print v(xbgr.mr_n57358496)
print v(xbgr.mr_n57358816)
print v(xbgr.mr_n57358928)
print v(xbgr.mr_n57359248)
print v(xbgr.mr_n57359360)
print v(xbgr.mr_n57359680)
print v(xbgr.mr_n57359792)
print v(xbgr.mr_n57360112)
print v(xbgr.mr_n57360224)
print v(xbgr.mr_n57360544)
print v(xbgr.mr_n57360656)
print v(xbgr.mr_n57360976)
print v(xbgr.mr_n57361088)
print v(xbgr.mr_n57361408)
print v(xbgr.mr_n57361520)
print v(xbgr.mr_n57361840)
print v(xbgr.mr_n57361952)
print v(xbgr.mr_n57362272)
print v(xbgr.mr_n57362384)
print v(xbgr.mr_n57362704)
print v(xbgr.mr_n57362816)
print v(xbgr.mr_n57363136)
print v(xbgr.mr_n57363248)
print v(xbgr.mr_n57363568)
print v(xbgr.mr_n57363680)
print v(xbgr.mr_n57364000)
print v(xbgr.mr_n57364112)
print v(xbgr.mr_n57364432)
print v(xbgr.mr_n57364544)
print v(xbgr.mr_n57364864)
print v(xbgr.mr_n57364976)
print v(xbgr.mr_n57365296)
print v(xbgr.mr_n57365408)
print v(xbgr.mr_n57365728)
print v(xbgr.mr_n57365840)
print v(xbgr.mr_n57366160)
print v(xbgr.mr_n57366272)
print v(xbgr.mr_n57366592)
print v(xbgr.mr_n57366704)
print v(xbgr.mr_n57367024)
print v(xbgr.mr_n57367136)
print v(xbgr.mr_n57367456)
print v(xbgr.mr_n57367568)
print v(xbgr.mr_n57367888)
print v(xbgr.mr_n57368000)
print v(xbgr.mr_n57368320)
print v(xbgr.mr_n57368432)
print v(xbgr.mr_n57368752)
print v(xbgr.mr_n57368864)
print v(xbgr.mr_n57369184)
print v(xbgr.mr_n57369296)
print v(xbgr.mr_n57369616)
print v(xbgr.mr_n57369728)
print v(xbgr.mr_n57370048)
print v(xbgr.mr_n57370160)
print v(xbgr.mr_n57370480)
print v(xbgr.mr_n57370592)
print v(xbgr.mr_n57370912)
print v(xbgr.mr_n57371024)
print v(xbgr.mr_n57371344)
print v(xbgr.mr_n57371456)
print v(xbgr.mr_n57371776)
print v(xbgr.mr_n57371888)
print v(xbgr.mr_n57372208)
print v(xbgr.mr_n57372320)
print v(xbgr.mr_n57372640)
print v(xbgr.mr_n57372752)
print v(xbgr.mr_n57373072)
print v(xbgr.mr_n57373184)
print v(xbgr.mr_n57373504)
print v(xbgr.mr_n57373616)
print v(xbgr.mr_n57373936)
print v(xbgr.mr_n57374048)
print v(xbgr.mr_n57374368)
print v(xbgr.mr_n57374480)
print v(xbgr.mr_n57374800)
print v(xbgr.mr_n57374912)
print v(xbgr.mr_n57375232)
print v(xbgr.mr_n57375344)
print v(xbgr.mr_n57375664)
print v(xbgr.mr_n57375776)
print v(xbgr.mr_n57376096)
print v(xbgr.mr_n57376208)
print v(xbgr.mr_n57376528)
print v(xbgr.mr_n57376640)
print v(xbgr.mr_n57376960)
print v(xbgr.mr_n57377072)
print v(xbgr.mr_n57377392)
print v(xbgr.mr_n57377504)
print v(xbgr.mr_n57377824)
print v(xbgr.mr_n57377936)
print v(xbgr.mr_n57378256)
print v(xbgr.mr_n57378368)
print v(xbgr.mr_n57378688)
print v(xbgr.mr_n57378800)
print v(xbgr.mr_n57379120)
print v(xbgr.mr_n57379232)
print v(xbgr.mr_n57379552)
print v(xbgr.mr_n57379664)
print v(xbgr.mr_n57379984)
print v(xbgr.mr_n57380096)
print v(xbgr.mr_n57380416)
print v(xbgr.mr_n57380528)
print v(xbgr.mr_n57380848)
print v(xbgr.mr_n57380960)
print v(xbgr.mr_n57381280)
print v(xbgr.mr_n57381392)
print v(xbgr.mr_n57381712)
print v(xbgr.mr_n57381824)
print v(xbgr.mr_n57382144)
print v(xbgr.mr_n57382256)
print v(xbgr.mr_n57382576)
print v(xbgr.mr_n57382688)
print v(xbgr.mr_n57383008)
print v(xbgr.mr_n57383120)
print v(xbgr.mr_n57383440)
print v(xbgr.mr_n57383552)
print v(xbgr.mr_n57383872)
print v(xbgr.mr_n57383984)
print v(xbgr.mr_n57384304)
print v(xbgr.mr_n57384416)
print v(xbgr.mr_n57384736)
print v(xbgr.mr_n57384848)
print v(xbgr.mr_n57385168)
print v(xbgr.mr_n57385280)
print v(xbgr.mr_n57385600)
print v(xbgr.mr_n57385712)
print v(xbgr.mr_n57386032)
print v(xbgr.mr_n57386144)
print v(xbgr.mr_n57386464)
print v(xbgr.mr_n57386576)
print v(xbgr.mr_n57386896)
print v(xbgr.mr_n57387008)
print v(xbgr.mr_n57387328)
print v(xbgr.mr_n57387440)
print v(xbgr.mr_n57387760)
print v(xbgr.mr_n57387872)
print v(xbgr.mr_n57388192)
print v(xbgr.mr_n57388304)
print v(xbgr.mr_n57388624)
print v(xbgr.mr_n57388736)
print v(xbgr.mr_n57389056)
print v(xbgr.mr_n57389168)
print v(xbgr.mr_n57389488)
print v(xbgr.mr_n57389600)
print v(xbgr.mr_n57389920)
print v(xbgr.mr_n57390032)
print v(xbgr.mr_n57390352)
print v(xbgr.mr_n57390464)
print v(xbgr.mr_n57390784)
print v(xbgr.mr_n57390896)
print v(xbgr.mr_n57391216)
print v(xbgr.mr_n57391328)
print v(xbgr.mr_n57391648)
print v(xbgr.mr_n57391760)
print v(xbgr.mr_n57392080)
print v(xbgr.mr_n57392192)
print v(xbgr.mr_n57392512)
print v(xbgr.mr_n57392624)
print v(xbgr.mr_n57392944)
print v(xbgr.mr_n57393056)
print v(xbgr.mr_n57393376)
print v(xbgr.mr_n57393488)
print v(xbgr.mr_n57393808)
print v(xbgr.mr_n57393920)
print v(xbgr.mr_n57394240)
print v(xbgr.mr_n57394352)
print v(xbgr.mr_n57394672)
print v(xbgr.mr_n57394784)
print v(xbgr.mr_n57395104)
print v(xbgr.mr_n57395216)
print v(xbgr.mr_n57395536)
print v(xbgr.mr_n57395648)
print v(xbgr.mr_n57395968)
print v(xbgr.mr_n57396080)
print v(xbgr.mr_n57396400)
print v(xbgr.mr_n57396512)
print v(xbgr.mr_n57396832)
print v(xbgr.mr_n57396944)
print v(xbgr.mr_n57397264)
print v(xbgr.mr_n57397376)
print v(xbgr.mr_n57397696)
print v(xbgr.mr_n57397808)
print v(xbgr.mr_n57398128)
print v(xbgr.mr_n57398240)
print v(xbgr.mr_n57398560)
print v(xbgr.mr_n57398672)
print v(xbgr.mr_n57398992)
print v(xbgr.mr_n57399104)
print v(xbgr.mr_n57399424)
print v(xbgr.mr_n57399536)
print v(xbgr.mr_n57399856)
print v(xbgr.mr_n57399968)
print v(xbgr.mr_n57400288)
print v(xbgr.mr_n57400400)
print v(xbgr.mr_n57400720)
print v(xbgr.mr_n57400832)
print v(xbgr.mr_n57401152)
print v(xbgr.mr_n57401264)
print v(xbgr.mr_n57401584)
print v(xbgr.mr_n57401696)
print v(xbgr.mr_n57402016)
print v(xbgr.mr_n57402128)
print v(xbgr.mr_n57402448)
print v(xbgr.mr_n57402560)
print v(xbgr.mr_n57402880)
print v(xbgr.mr_n57402992)
print v(xbgr.mr_n57403312)
print v(xbgr.mr_n57403744)
print v(xbgr.mr_n57403856)
print v(xbgr.mr_n57404176)
print v(xbgr.mr_n57404288)
print v(xbgr.mr_n57404608)
print v(xbgr.mr_n57404720)
print v(xbgr.mr_n57405040)
print v(xbgr.mr_n57405152)
print v(xbgr.mr_n57405472)
print v(xbgr.mr_n57405584)
print v(xbgr.mr_n57405904)
print v(xbgr.mr_n57406016)
print v(xbgr.mr_n57406336)
print v(xbgr.mr_n57406448)
print v(xbgr.mr_n57406768)
print v(xbgr.mr_n57406880)
print v(xbgr.mr_n57407200)
print v(xbgr.mr_n57407312)
print v(xbgr.mr_n57407632)
print v(xbgr.mr_n57407744)
print v(xbgr.mr_n57408064)
print v(xbgr.mr_n57408176)
print v(xbgr.mr_n57408496)
print v(xbgr.mr_n57408608)
print v(xbgr.mr_n57408928)
print v(xbgr.mr_n57409040)
print v(xbgr.mr_n57409360)
print v(xbgr.mr_n57409472)
print v(xbgr.mr_n57409792)
print v(xbgr.mr_n57409904)
print v(xbgr.mr_n57410224)
print v(xbgr.mr_n57410336)
print v(xbgr.mr_n57410656)
print v(xbgr.mr_n57410768)
print v(xbgr.mr_n57411088)
print v(xbgr.mr_n57411200)
print v(xbgr.mr_n57411520)
print v(xbgr.mr_n57411632)
print v(xbgr.mr_n57411952)
print v(xbgr.mr_n57412064)
print v(xbgr.mr_n57412384)
print v(xbgr.mr_n57412496)
print v(xbgr.mr_n57412816)
print v(xbgr.mr_n57412928)
print v(xbgr.mr_n57413248)
print v(xbgr.mr_n57413360)
print v(xbgr.mr_n57413680)
print v(xbgr.mr_n57413792)
print v(xbgr.mr_n57414112)
print v(xbgr.mr_n57414224)
print v(xbgr.mr_n57414544)
print v(xbgr.mr_n57414656)
print v(xbgr.mr_n57414976)
print v(xbgr.mr_n57415088)
print v(xbgr.mr_n57415408)
print v(xbgr.mr_n57415520)
print v(xbgr.mr_n57415840)
print v(xbgr.mr_n57415952)
print v(xbgr.mr_n57416272)
print v(xbgr.mr_n57416384)
print v(xbgr.mr_n57416704)
print v(xbgr.mr_n57416816)
print v(xbgr.mr_n57417136)
print v(xbgr.mr_n57417248)
print v(xbgr.mr_n57417568)
print v(xbgr.mr_n57417680)
print v(xbgr.mr_n57418000)
print v(xbgr.mr_n57418112)
print v(xbgr.mr_n57418432)
print v(xbgr.mr_n57418544)
print v(xbgr.mr_n57418864)
print v(xbgr.mr_n57418976)
print v(xbgr.mr_n57419296)
print v(xbgr.mr_n57419408)
print v(xbgr.mr_n57419728)
print v(xbgr.mr_n57419840)
print v(xbgr.mr_n57420160)
print v(xbgr.mr_n57420272)
print v(xbgr.mr_n57420592)
print v(xbgr.mr_n57420704)
print v(xbgr.mr_n57421024)
print v(xbgr.mr_n57421136)
print v(xbgr.mr_n57421456)
print v(xbgr.mr_n57421568)
print v(xbgr.mr_n57421888)
print v(xbgr.mr_n57422000)
print v(xbgr.mr_n57422320)
print v(xbgr.mr_n57422432)
print v(xbgr.mr_n57422752)
print v(xbgr.mr_n57422864)
print v(xbgr.mr_n57423184)
print v(xbgr.mr_n57423296)
print v(xbgr.mr_n57423616)
print v(xbgr.mr_n57423728)
print v(xbgr.mr_n57424048)
print v(xbgr.mr_n57424480)
print v(xbgr.mr_n57424592)
print v(xbgr.mr_n57424912)
print v(xbgr.mr_n57425024)
print v(xbgr.mr_n57425344)
print v(xbgr.mr_n57425456)
print v(xbgr.mr_n57425776)
print v(xbgr.mr_n57425888)
print v(xbgr.mr_n57426208)
print v(xbgr.mr_n57426320)
print v(xbgr.mr_n57426640)
print v(xbgr.mr_n57426752)
print v(xbgr.mr_n57427184)
print v(xbgr.mr_n57427616)
print v(xbgr.mr_n57427936)
print v(xbgr.mr_n57428048)
print v(xbgr.mr_n57428368)
print v(xbgr.mr_n57428480)
print v(xbgr.mr_n57428800)
print v(xbgr.mr_n57428912)
print v(xbgr.mr_n57429232)
print v(xbgr.mr_n57429344)
print v(xbgr.mr_n57429664)
print v(xbgr.mr_n57429776)
print v(xbgr.mr_n57430096)
print v(xbgr.mr_n57430208)
print v(xbgr.mr_n57430528)
print v(xbgr.mr_n57430640)
print v(xbgr.mr_n57430960)
print v(xbgr.mr_n57431072)
print v(xbgr.mr_n57431392)
print v(xbgr.mr_n57431504)
print v(xbgr.mr_n57431824)
print v(xbgr.mr_n57431936)
print v(xbgr.mr_n57432256)
print v(xbgr.mr_n57432368)
print v(xbgr.mr_n57432688)
print v(xbgr.mr_n57432800)
print v(xbgr.mr_n57433120)
print v(xbgr.mr_n57433232)
print v(xbgr.mr_n57433552)
print v(xbgr.mr_n57433664)
print v(xbgr.mr_n57433984)
print v(xbgr.mr_n57434096)
print v(xbgr.mr_n57434416)
print v(xbgr.mr_n57434528)
print v(xbgr.mr_n57434848)
print v(xbgr.mr_n57434960)
print v(xbgr.mr_n57435280)
print v(xbgr.mr_n57435392)
print v(xbgr.mr_n57435712)
print v(xbgr.mr_n57435824)
print v(xbgr.mr_n57436144)
print v(xbgr.mr_n57436256)
print v(xbgr.mr_n57436576)
print v(xbgr.mr_n57436688)
print v(xbgr.mr_n57437008)
print v(xbgr.mr_n57437120)
print v(xbgr.mr_n57437440)
print v(xbgr.mr_n57437552)
print v(xbgr.mr_n57437872)
print v(xbgr.mr_n57437984)
print v(xbgr.mr_n57438304)
print v(xbgr.mr_n57438416)
print v(xbgr.mr_n57438736)
print v(xbgr.mr_n57438848)
print v(xbgr.mr_n57439168)
print v(xbgr.mr_n57439280)
print v(xbgr.mr_n57439600)
print v(xbgr.mr_n57439712)
print v(xbgr.mr_n57440032)
print v(xbgr.mr_n57440144)
print v(xbgr.mr_n57440464)
print v(xbgr.mr_n57440576)
print v(xbgr.mr_n57440896)
print v(xbgr.mr_n57441008)
print v(xbgr.mr_n57441328)
print v(xbgr.mr_n57441440)
print v(xbgr.mr_n57441760)
print v(xbgr.mr_n57441872)
print v(xbgr.mr_n57442192)
print v(xbgr.mr_n57442304)
print v(xbgr.mr_n57442624)
print v(xbgr.mr_n57442736)
print v(xbgr.mr_n57443056)
print v(xbgr.mr_n57443168)
print v(xbgr.mr_n57443488)
print v(xbgr.mr_n57443600)
print v(xbgr.mr_n57443920)
print v(xbgr.mr_n57444032)
print v(xbgr.mr_n57444352)
print v(xbgr.mr_n57444464)
print v(xbgr.mr_n57444784)
print v(xbgr.mr_n57444896)
print v(xbgr.mr_n57445216)
print v(xbgr.mr_n57445328)
print v(xbgr.mr_n57445648)
print v(xbgr.mr_n57445760)
print v(xbgr.mr_n57446080)
print v(xbgr.mr_n57446192)
print v(xbgr.mr_n57446512)
print v(xbgr.mr_n57446624)
print v(xbgr.mr_n57446944)
print v(xbgr.mr_n57447056)
print v(xbgr.mr_n57447376)
print v(xbgr.mr_n57447488)
print v(xbgr.mr_n57447808)
print v(xbgr.mr_n57447920)
print v(xbgr.mr_n57448240)
print v(xbgr.mr_n57448352)
print v(xbgr.mr_n57448672)
print v(xbgr.mr_n57448784)
print v(xbgr.mr_n57449104)
print v(xbgr.mr_n57449216)
print v(xbgr.mr_n57449536)
print v(xbgr.mr_n57449648)
print v(xbgr.mr_n57449968)
print v(xbgr.mr_n57450080)
print v(xbgr.mr_n57450400)
print v(xbgr.mr_n57450512)
print v(xbgr.mr_n57450832)
print v(xbgr.mr_n57450944)
print v(xbgr.mr_n57451264)
print v(xbgr.mr_n57451376)
print v(xbgr.mr_n57451696)
print v(xbgr.mr_n57451808)
print v(xbgr.mr_n57452128)
print v(xbgr.mr_n57452240)
print v(xbgr.mr_n57452560)
print v(xbgr.mr_n57452672)
print v(xbgr.mr_n57452992)
print v(xbgr.mr_n57453104)
print v(xbgr.mr_n57453424)
print v(xbgr.mr_n57453536)
print v(xbgr.mr_n57453856)
print v(xbgr.mr_n57453968)
print v(xbgr.mr_n57454288)
print v(xbgr.mr_n57454400)
print v(xbgr.mr_n57454720)
print v(xbgr.mr_n57454832)
print v(xbgr.mr_n57455152)
print v(xbgr.mr_n57455264)
print v(xbgr.mr_n57455584)
print v(xbgr.mr_n57455696)
print v(xbgr.mr_n57456016)
print v(xbgr.mr_n57456128)
print v(xbgr.mr_n57456448)
print v(xbgr.mr_n57456560)
print v(xbgr.mr_n57456880)
print v(xbgr.mr_n57456992)
print v(xbgr.mr_n57457312)
print v(xbgr.mr_n57457424)
print v(xbgr.mr_n57457744)
print v(xbgr.mr_n57457856)
print v(xbgr.mr_n57458176)
print v(xbgr.mr_n57458288)
print v(xbgr.mr_n57458608)
print v(xbgr.mr_n57458720)
print v(xbgr.mr_n57459040)
print v(xbgr.mr_n57459152)
print v(xbgr.mr_n57459472)
print v(xbgr.mr_n57459584)
print v(xbgr.mr_n57459904)
print v(xbgr.mr_n57460016)
print v(xbgr.mr_n57460336)
print v(xbgr.mr_n57460448)
print v(xbgr.mr_n57460768)
print v(xbgr.mr_n57460880)
print v(xbgr.mr_n57461200)
print v(xbgr.mr_n57461312)
print v(xbgr.mr_n57461632)
print v(xbgr.mr_n57461744)
print v(xbgr.mr_n57462064)
print v(xbgr.mr_n57462176)
print v(xbgr.mr_n57462496)
print v(xbgr.mr_n57462608)
print v(xbgr.mr_n57462928)
print v(xbgr.mr_n57463040)
print v(xbgr.mr_n57463360)
print v(xbgr.mr_n57463472)
print v(xbgr.mr_n57463792)
print v(xbgr.mr_n57463904)
print v(xbgr.mr_n57464224)
print v(xbgr.mr_n57464336)
print v(xbgr.mr_n57464656)
print v(xbgr.mr_n57464768)
print v(xbgr.mr_n57465088)
print v(xbgr.mr_n57465200)
print v(xbgr.mr_n57465520)
print v(xbgr.mr_n57465632)
print v(xbgr.mr_n57465952)
print v(xbgr.mr_n57466064)
print v(xbgr.mr_n57466384)
print v(xbgr.mr_n57466496)
print v(xbgr.mr_n57466816)
print v(xbgr.mr_n57466928)
print v(xbgr.mr_n57467248)
print v(xbgr.mr_n57467360)
print v(xbgr.mr_n57467680)
print v(xbgr.mr_n57467792)
print v(xbgr.mr_n57468112)
print v(xbgr.mr_n57468224)
print v(xbgr.mr_n57468544)
print v(xbgr.mr_n57468656)
print v(xbgr.mr_n57468976)
print v(xbgr.mr_n57469088)
print v(xbgr.mr_n57469408)
print v(xbgr.mr_n57469520)
print v(xbgr.mr_n57469840)
print v(xbgr.mr_n57469952)
print v(xbgr.mr_n57470272)
print v(xbgr.mr_n57470384)
print v(xbgr.mr_n57470704)
print v(xbgr.mr_n57470816)
print v(xbgr.mr_n57471136)
print v(xbgr.mr_n57471248)
print v(xbgr.mr_n57471568)
print v(xbgr.mr_n57471680)
print v(xbgr.mr_n57472000)
print v(xbgr.mr_n57472112)
print v(xbgr.mr_n57472432)
print v(xbgr.mr_n57472544)
print v(xbgr.mr_n57472864)
print v(xbgr.mr_n57472976)
print v(xbgr.mr_n57473296)
print v(xbgr.mr_n57473408)
print v(xbgr.mr_n57473728)
print v(xbgr.mr_n57473840)
print v(xbgr.mr_n57474160)
print v(xbgr.mr_n57474272)
print v(xbgr.mr_n57474592)
print v(xbgr.mr_n57474704)
print v(xbgr.mr_n57475024)
print v(xbgr.mr_n57475136)
print v(xbgr.mr_n57475456)
print v(xbgr.mr_n57475568)
print v(xbgr.mr_n57475888)
print v(xbgr.mr_n57476000)
print v(xbgr.mr_n57476320)
print v(xbgr.mr_n57476432)
print v(xbgr.mr_n57476752)
print v(xbgr.mr_n57476864)
print v(xbgr.mr_n57477184)
print v(xbgr.mr_n57477296)
print v(xbgr.mr_n57477616)
print v(xbgr.mr_n57477728)
print v(xbgr.mr_n57478048)
print v(xbgr.mr_n57478160)
print v(xbgr.mr_n57478480)
print v(xbgr.mr_n57478592)
print v(xbgr.mr_n57478912)
print v(xbgr.mr_n57479024)
print v(xbgr.mr_n57479344)
print v(xbgr.mr_n57479456)
print v(xbgr.mr_n57479776)
print v(xbgr.mr_n57479888)
print v(xbgr.mr_n57480208)
print v(xbgr.mr_n57480320)
print v(xbgr.mr_n57480640)
print v(xbgr.mr_n57480752)
print v(xbgr.mr_n57481072)
print v(xbgr.mr_n57481184)
print v(xbgr.mr_n57481504)
print v(xbgr.mr_n57481616)
print v(xbgr.mr_n57481936)
print v(xbgr.mr_n57482048)
print v(xbgr.mr_n57482368)
print v(xbgr.mr_n57482480)
print v(xbgr.mr_n57482800)
print v(xbgr.mr_n57482912)
print v(xbgr.mr_n57483232)
print v(xbgr.mr_n57483344)
print v(xbgr.mr_n57483776)
print v(xbgr.mr_n57484208)
print v(xbgr.mr_n57484640)
print v(xbgr.mr_n57485072)
print v(xbgr.mr_n57485504)
print v(xbgr.mr_n57485936)
print v(xbgr.mr_n57486368)
print v(xbgr.mr_n57486800)
print v(xbgr.mr_n57487232)
print v(xbgr.mr_n57487664)
print v(xbgr.mr_n57488096)
print v(xbgr.mr_n57488528)
print v(xbgr.mr_n57488960)
print v(xbgr.mr_n57489392)
print v(xbgr.mr_n57489824)
print v(xbgr.mr_n57490256)
print v(xbgr.mr_n57490688)
print v(xbgr.mr_n57491120)
print v(xbgr.mr_n57491552)
print v(xbgr.mr_n57491984)
print v(xbgr.mr_n57492416)
print v(xbgr.mr_n57492848)
print v(xbgr.mr_n57493280)
print v(xbgr.mr_n57493712)
print v(xbgr.mr_n57494144)
print v(xbgr.mr_n57494576)
print v(xbgr.mr_n57495008)
print v(xbgr.mr_n57495440)
print v(xbgr.mr_n57495872)
print v(xbgr.mr_n57496304)
print v(xbgr.mr_n57496736)
print v(xbgr.mr_n57497168)
print v(xbgr.mr_n57497600)
print v(xbgr.mr_n57498032)
print v(xbgr.mr_n57498464)
print v(xbgr.mr_n57498896)
print v(xbgr.mr_n57499328)
print v(xbgr.mr_n57499760)
print v(xbgr.mr_n57500192)
print v(xbgr.mr_n57500624)
print v(xbgr.mr_n57501056)
print v(xbgr.mr_n57501488)
print v(xbgr.mr_n57501920)
print v(xbgr.mr_n57502352)
print v(xbgr.mr_n57502784)
print v(xbgr.mr_n57503216)
print v(xbgr.mr_n57503648)
print v(xbgr.mr_n57504080)
print v(xbgr.mr_n57504512)
print v(xbgr.mr_n57504944)
print v(xbgr.mr_n57505376)
print v(xbgr.mr_n57505808)
print v(xbgr.mr_n57506240)
print v(xbgr.mr_n57506672)
print v(xbgr.mr_n57507104)
print v(xbgr.mr_n57507536)
print v(xbgr.mr_n57507968)
print v(xbgr.mr_n57508400)
print v(xbgr.mr_n57508832)
print v(xbgr.mr_n57509264)
print v(xbgr.mr_n57509696)
print v(xbgr.mr_n57510128)
print v(xbgr.mr_n57510560)
print v(xbgr.mr_n57510992)
print v(xbgr.mr_n57511424)
print v(xbgr.mr_n57511856)
print v(xbgr.mr_n57512288)
print v(xbgr.mr_n57512720)
print v(xbgr.mr_n57513152)
print v(xbgr.mr_n57513584)
print v(xbgr.mr_n57514016)
print v(xbgr.mr_n57514448)
print v(xbgr.mr_n57514880)
print v(xbgr.mr_n57515312)
print v(xbgr.mr_n57515744)
print v(xbgr.mr_n57516176)
print v(xbgr.mr_n57516608)
print v(xbgr.mr_n57517040)
print v(xbgr.mr_n57517472)
print v(xbgr.mr_n57517904)
print v(xbgr.mr_n57518336)
print v(xbgr.mr_n57518768)
print v(xbgr.mr_n57519200)
print v(xbgr.mr_n57519632)
print v(xbgr.mr_n57520064)
print v(xbgr.mr_n57520496)
print v(xbgr.mr_n57520928)
print v(xbgr.mr_n57521360)
print v(xbgr.mr_n57521792)
print v(xbgr.mr_n57522224)
print v(xbgr.mr_n57522656)
print v(xbgr.mr_n57523088)
print v(xbgr.mr_n57523520)
print v(xbgr.mr_n57523952)
print v(xbgr.mr_n57524384)
print v(xbgr.mr_n57524816)
print v(xbgr.mr_n57525248)
print v(xbgr.mr_n57525680)
print v(xbgr.mr_n57526000)
print v(xbgr.mr_n57526112)
print v(xbgr.mr_n57526432)
print v(xbgr.mr_n57526544)
print v(xbgr.mr_n57526864)
print v(xbgr.mr_n57526976)
print v(xbgr.mr_n57527296)
print v(xbgr.mr_n57527408)
print v(xbgr.mr_n57527728)
print v(xbgr.mr_n57527840)
print v(xbgr.mr_n57528160)
print v(xbgr.mr_n57528272)
print v(xbgr.mr_n57528592)
print v(xbgr.mr_n57528704)
print v(xbgr.mr_n57529024)
print v(xbgr.mr_n57529136)
print v(xbgr.mr_n57529456)
print v(xbgr.mr_n57529568)
print v(xbgr.mr_n57529888)
print v(xbgr.mr_n57530000)
print v(xbgr.mr_n57530320)
print v(xbgr.mr_n57530432)
print v(xbgr.mr_n57530752)
print v(xbgr.mr_n57530864)
print v(xbgr.mr_n57531184)
print v(xbgr.mr_n57531296)
print v(xbgr.mr_n57531616)
print v(xbgr.mr_n57531728)
print v(xbgr.mr_n57532048)
print v(xbgr.mr_n57532160)
print v(xbgr.mr_n57532480)
print v(xbgr.mr_n57532592)
print v(xbgr.mr_n57532912)
print v(xbgr.mr_n57533024)
print v(xbgr.mr_n57533344)
print v(xbgr.mr_n57533456)
print v(xbgr.mr_n57533776)
print v(xbgr.mr_n57533888)
print v(xbgr.mr_n57534208)
print v(xbgr.mr_n57534320)
print v(xbgr.mr_n57534640)
print v(xbgr.mr_n57534752)
print v(xbgr.mr_n57535072)
print v(xbgr.mr_n57535184)
print v(xbgr.mr_n57535504)
print v(xbgr.mr_n57535616)
print v(xbgr.mr_n57535936)
print v(xbgr.mr_n57536048)
print v(xbgr.mr_n57536368)
print v(xbgr.mr_n57536480)
print v(xbgr.mr_n57536800)
print v(xbgr.mr_n57536912)
print v(xbgr.mr_n57537232)
print v(xbgr.mr_n57537344)
print v(xbgr.mr_n57537664)
print v(xbgr.mr_n57537776)
print v(xbgr.mr_n57538096)
print v(xbgr.mr_n57538208)
print v(xbgr.mr_n57538528)
print v(xbgr.mr_n57538640)
print v(xbgr.mr_n57538960)
print v(xbgr.mr_n57539072)
print v(xbgr.mr_n57539392)
print v(xbgr.mr_n57539504)
print v(xbgr.mr_n57539824)
print v(xbgr.mr_n57539936)
print v(xbgr.mr_n57540256)
print v(xbgr.mr_n57540368)
print v(xbgr.mr_n57540688)
print v(xbgr.mr_n57540800)
print v(xbgr.mr_n57541120)
print v(xbgr.mr_n57541232)
print v(xbgr.mr_n57541552)
print v(xbgr.mr_n57541664)
print v(xbgr.mr_n57541984)
print v(xbgr.mr_n57542096)
print v(xbgr.mr_n57542416)
print v(xbgr.mr_n57542528)
print v(xbgr.mr_n57542848)
print v(xbgr.mr_n57542960)
print v(xbgr.mr_n57543280)
print v(xbgr.mr_n57543392)
print v(xbgr.mr_n57543712)
print v(xbgr.mr_n57543824)
print v(xbgr.mr_n57544144)
print v(xbgr.mr_n57544256)
print v(xbgr.mr_n57544576)
print v(xbgr.mr_n57544688)
print v(xbgr.mr_n57545008)
print v(xbgr.mr_n57545120)
print v(xbgr.mr_n57545440)
print v(xbgr.mr_n57545552)
print v(xbgr.mr_n57545872)
print v(xbgr.mr_n57545984)
print v(xbgr.mr_n57546304)
print v(xbgr.mr_n57546416)
print v(xbgr.mr_n57546736)
print v(xbgr.mr_n57546848)
print v(xbgr.mr_n57547168)
print v(xbgr.mr_n57547280)
print v(xbgr.mr_n57547600)
print v(xbgr.mr_n57547712)
print v(xbgr.mr_n57548032)
print v(xbgr.mr_n57548144)
print v(xbgr.mr_n57548464)
print v(xbgr.mr_n57548576)
print v(xbgr.mr_n57548896)
print v(xbgr.mr_n57549008)
print v(xbgr.mr_n57549328)
print v(xbgr.mr_n57549440)
print v(xbgr.mr_n57549760)
print v(xbgr.mr_n57549872)
print v(xbgr.mr_n57550192)
print v(xbgr.mr_n57550304)
print v(xbgr.mr_n57550624)
print v(xbgr.mr_n57550736)
print v(xbgr.mr_n57551056)
print v(xbgr.mr_n57551168)
print v(xbgr.mr_n57551488)
print v(xbgr.mr_n57551600)
print v(xbgr.mr_n57551920)
print v(xbgr.mr_n57552032)
print v(xbgr.mr_n57552352)
print v(xbgr.mr_n57552464)
print v(xbgr.mr_n57552784)
print v(xbgr.mr_n57552896)
print v(xbgr.mr_n57553216)
print v(xbgr.mr_n57553328)
print v(xbgr.mr_n57553648)
print v(xbgr.mr_n57553760)
print v(xbgr.mr_n57554080)
print v(xbgr.mr_n57554192)
print v(xbgr.mr_n57554512)
print v(xbgr.mr_n57554624)
print v(xbgr.mr_n57554944)
print v(xbgr.mr_n57555056)
print v(xbgr.mr_n57555376)
print v(xbgr.mr_n57555488)
print v(xbgr.mr_n57555808)
print v(xbgr.mr_n57555920)
print v(xbgr.mr_n57556240)
print v(xbgr.mr_n57556352)
print v(xbgr.mr_n57556672)
print v(xbgr.mr_n57556784)
print v(xbgr.mr_n57557104)
print v(xbgr.mr_n57557216)
print v(xbgr.mr_n57557536)
print v(xbgr.mr_n57557648)
print v(xbgr.mr_n57557968)
print v(xbgr.mr_n57558080)
print v(xbgr.mr_n57558400)
print v(xbgr.mr_n57558512)
print v(xbgr.mr_n57558832)
print v(xbgr.mr_n57558944)
print v(xbgr.mr_n57559264)
print v(xbgr.mr_n57559376)
print v(xbgr.mr_n57559696)
print v(xbgr.mr_n57559808)
print v(xbgr.mr_n57560128)
print v(xbgr.mr_n57560240)
print v(xbgr.mr_n57560560)
print v(xbgr.mr_n57560672)
print v(xbgr.mr_n57560992)
print v(xbgr.mr_n57561104)
print v(xbgr.mr_n57561424)
print v(xbgr.mr_n57561536)
print v(xbgr.mr_n57561856)
print v(xbgr.mr_n57561968)
print v(xbgr.mr_n57562288)
print v(xbgr.mr_n57562400)
print v(xbgr.mr_n57562720)
print v(xbgr.mr_n57562832)
print v(xbgr.mr_n57563152)
print v(xbgr.mr_n57563264)
print v(xbgr.mr_n57563584)
print v(xbgr.mr_n57563696)
print v(xbgr.mr_n57564016)
print v(xbgr.mr_n57564128)
print v(xbgr.mr_n57564448)
print v(xbgr.mr_n57564560)
print v(xbgr.mr_n57564880)
print v(xbgr.mr_n57564992)
print v(xbgr.mr_n57565312)
print v(xbgr.mr_n57565424)
print v(xbgr.mr_n57565744)
print v(xbgr.mr_n57565856)
print v(xbgr.mr_n57566176)
print v(xbgr.mr_n57566288)
print v(xbgr.mr_n57566608)
print v(xbgr.mr_n57566720)
print v(xbgr.mr_n57567040)
print v(xbgr.mr_n57567152)
print v(xbgr.mr_n57567472)
print v(xbgr.mr_n57567584)
print v(xbgr.mr_n57567904)
print v(xbgr.mr_n57568016)
print v(xbgr.mr_n57568336)
print v(xbgr.mr_n57568448)
print v(xbgr.mr_n57568768)
print v(xbgr.mr_n57568880)
print v(xbgr.mr_n57569200)
print v(xbgr.mr_n57569312)
print v(xbgr.mr_n57569632)
print v(xbgr.mr_n57569744)
print v(xbgr.mr_n57570064)
print v(xbgr.mr_n57570176)
print v(xbgr.mr_n57570496)
print v(xbgr.mr_n57570608)
print v(xbgr.mr_n57570928)
print v(xbgr.mr_n57571040)
print v(xbgr.mr_n57571360)
print v(xbgr.mr_n57571472)
print v(xbgr.mr_n57571792)
print v(xbgr.mr_n57571904)
print v(xbgr.mr_n57572224)
print v(xbgr.mr_n57572336)
print v(xbgr.mr_n57572656)
print v(xbgr.mr_n57572768)
print v(xbgr.mr_n57573088)
print v(xbgr.mr_n57573200)
print v(xbgr.mr_n57573520)
print v(xbgr.mr_n57573632)
print v(xbgr.mr_n57573952)
print v(xbgr.mr_n57574064)
print v(xbgr.mr_n57574384)
print v(xbgr.mr_n57574496)
print v(xbgr.mr_n57574816)
print v(xbgr.mr_n57574928)
print v(xbgr.mr_n57575248)
print v(xbgr.mr_n57575360)
print v(xbgr.mr_n57575680)
print v(xbgr.mr_n57575792)
print v(xbgr.mr_n57576112)
print v(xbgr.mr_n57576224)
print v(xbgr.mr_n57576544)
print v(xbgr.mr_n57576656)
print v(xbgr.mr_n57576976)
print v(xbgr.mr_n57577088)
print v(xbgr.mr_n57577408)
print v(xbgr.mr_n57577520)
print v(xbgr.mr_n57577840)
print v(xbgr.mr_n57577952)
print v(xbgr.mr_n57578272)
print v(xbgr.mr_n57578384)
print v(xbgr.mr_n57578704)
print v(xbgr.mr_n57578816)
print v(xbgr.mr_n57579136)
print v(xbgr.mr_n57579248)
print v(xbgr.mr_n57579568)
print v(xbgr.mr_n57579680)
print v(xbgr.mr_n57580000)
print v(xbgr.mr_n57580112)
print v(xbgr.mr_n57580432)
print v(xbgr.mr_n57580544)
print v(xbgr.mr_n57580864)
print v(xbgr.mr_n57580976)
print v(xbgr.mr_n57581296)
print v(xbgr.mr_n57581408)
print v(xbgr.mr_n57581728)
print v(xbgr.mr_n57581840)
print v(xbgr.mr_n57582160)
print v(xbgr.mr_n57582272)
print v(xbgr.mr_n57582592)
print v(xbgr.mr_n57582704)
print v(xbgr.mr_n57583024)
print v(xbgr.mr_n57583136)
print v(xbgr.mr_n57583456)
print v(xbgr.mr_n57583568)
print v(xbgr.mr_n57583888)
print v(xbgr.mr_n57584000)
print v(xbgr.mr_n57584320)
print v(xbgr.mr_n57584432)
print v(xbgr.mr_n57584752)
print v(xbgr.mr_n57584864)
print v(xbgr.mr_n57585184)
print v(xbgr.mr_n57585296)
print v(xbgr.mr_n57585616)
print v(xbgr.mr_n57585728)
print v(xbgr.mr_n57586048)
print v(xbgr.mr_n57586160)
print v(xbgr.mr_n57586480)
print v(xbgr.mr_n57586592)
print v(xbgr.mr_n57586912)
print v(xbgr.mr_n57587024)
print v(xbgr.mr_n57587344)
print v(xbgr.mr_n57587456)
print v(xbgr.mr_n57587776)
print v(xbgr.mr_n57587888)
print v(xbgr.mr_n57588208)
print v(xbgr.mr_n57588320)
print v(xbgr.mr_n57588640)
print v(xbgr.mr_n57588752)
print v(xbgr.mr_n57589184)
print v(xbgr.mr_n57589616)
print v(xbgr.mr_n57590048)
print v(xbgr.mr_n57590480)
print v(xbgr.mr_n57590912)
print v(xbgr.mr_n57591344)
print v(xbgr.mr_n57591776)
print v(xbgr.mr_n57592208)
print v(xbgr.mr_n57592640)
print v(xbgr.mr_n57593072)
print v(xbgr.mr_n57593504)
print v(xbgr.mr_n57593936)
print v(xbgr.mr_n57594368)
print v(xbgr.mr_n57594800)
print v(xbgr.mr_n57595232)
print v(xbgr.mr_n57595664)
print v(xbgr.mr_n57596096)
print v(xbgr.mr_n57596528)
print v(xbgr.mr_n57596960)
print v(xbgr.mr_n57597392)
print v(xbgr.mr_n57597824)
print v(xbgr.mr_n57598256)
print v(xbgr.mr_n57598688)
print v(xbgr.mr_n57599120)
print v(xbgr.mr_n57599552)
print v(xbgr.mr_n57599984)
print v(xbgr.mr_n57600416)
print v(xbgr.mr_n57600848)
print v(xbgr.mr_n57601280)
print v(xbgr.mr_n57601712)
print v(xbgr.mr_n57602144)
print v(xbgr.mr_n57602576)
print v(xbgr.mr_n57603008)
print v(xbgr.mr_n57603440)
print v(xbgr.mr_n57603872)
print v(xbgr.mr_n57604304)
print v(xbgr.mr_n57604736)
print v(xbgr.mr_n57605168)
print v(xbgr.mr_n57605600)
print v(xbgr.mr_n57606032)
print v(xbgr.mr_n57606464)
print v(xbgr.mr_n57606896)
print v(xbgr.mr_n57607328)
print v(xbgr.mr_n57607760)
print v(xbgr.mr_n57608192)
print v(xbgr.mr_n57608624)
print v(xbgr.mr_n57609056)
print v(xbgr.mr_n57609488)
print v(xbgr.mr_n57609920)
print v(xbgr.mr_n57610352)
print v(xbgr.mr_n57610784)
print v(xbgr.mr_n57611216)
print v(xbgr.mr_n57611648)
print v(xbgr.mr_n57612080)
print v(xbgr.mr_n57612512)
print v(xbgr.mr_n57612944)
print v(xbgr.mr_n57613376)
print v(xbgr.mr_n57613808)
print v(xbgr.mr_n57614240)
print v(xbgr.mr_n57614672)
print v(xbgr.mr_n57615104)
print v(xbgr.mr_n57615536)
print v(xbgr.mr_n57615968)
print v(xbgr.mr_n57616400)
print v(xbgr.mr_n57616832)
print v(xbgr.mr_n57617264)
print v(xbgr.mr_n57617696)
print v(xbgr.mr_n57618128)
print v(xbgr.mr_n57618560)
print v(xbgr.mr_n57618992)
print v(xbgr.mr_n57619424)
print v(xbgr.mr_n57619856)
print v(xbgr.mr_n57620288)
print v(xbgr.mr_n57620720)
print v(xbgr.mr_n57621152)
print v(xbgr.mr_n57621584)
print v(xbgr.mr_n57622016)
print v(xbgr.mr_n57622448)
print v(xbgr.mr_n57622880)
print v(xbgr.mr_n57623312)
print v(xbgr.mr_n57623744)
print v(xbgr.mr_n57624176)
print v(xbgr.mr_n57624608)
print v(xbgr.mr_n57625040)
print v(xbgr.mr_n57625472)
print v(xbgr.mr_n57625904)
print v(xbgr.mr_n57626336)
print v(xbgr.mr_n57626768)
print v(xbgr.mr_n57627200)
print v(xbgr.mr_n57627632)
print v(xbgr.mr_n57628064)
print v(xbgr.mr_n57628496)
print v(xbgr.mr_n57628928)
print v(xbgr.mr_n57629360)
print v(xbgr.mr_n57629792)
print v(xbgr.mr_n57630224)
print v(xbgr.mr_n57630656)
print v(xbgr.mr_n57631088)
print v(xbgr.mr_n57631520)
print v(xbgr.mr_n57631952)
print v(xbgr.mr_n57632384)
print v(xbgr.mr_n57632816)
print v(xbgr.mr_n57633248)
print v(xbgr.mr_n57633680)
print v(xbgr.mr_n57634112)
print v(xbgr.mr_n57634544)
print v(xbgr.mr_n57634976)
print v(xbgr.mr_n57635408)
print v(xbgr.mr_n57635840)
print v(xbgr.mr_n57636272)
print v(xbgr.mr_n57636704)
print v(xbgr.mr_n57637136)
print v(xbgr.mr_n57637568)
print v(xbgr.mr_n57638000)
print v(xbgr.mr_n57638432)
print v(xbgr.mr_n57638864)
print v(xbgr.mr_n57639296)
print v(xbgr.mr_n57639728)
print v(xbgr.mr_n57640160)
print v(xbgr.mr_n57640592)
print v(xbgr.mr_n57641024)
print v(xbgr.mr_n57641456)
print v(xbgr.mr_n57641888)
print v(xbgr.mr_n57642320)
print v(xbgr.mr_n57642752)
print v(xbgr.mr_n57643184)
print v(xbgr.mr_n57643616)
print v(xbgr.mr_n57644048)
print v(xbgr.mr_n57644480)
print v(xbgr.mr_n57644912)
print v(xbgr.mr_n57645344)
print v(xbgr.mr_n57645776)
print v(xbgr.mr_n57646208)
print v(xbgr.mr_n57646640)
print v(xbgr.mr_n57647072)
print v(xbgr.mr_n57647504)
print v(xbgr.mr_n57647936)
print v(xbgr.mr_n57648368)
print v(xbgr.mr_n57648800)
print v(xbgr.mr_n57649232)
print v(xbgr.mr_n57649664)
print v(xbgr.mr_n57650096)
print v(xbgr.mr_n57650528)
print v(xbgr.mr_n57650960)
print v(xbgr.mr_n57651392)
print v(xbgr.mr_n57651824)
print v(xbgr.mr_n57652256)
print v(xbgr.mr_n57652688)
print v(xbgr.mr_n57653120)
print v(xbgr.mr_n57653552)
print v(xbgr.mr_n57653984)
print v(xbgr.mr_n57654416)
print v(xbgr.mr_n57654848)
print v(xbgr.mr_n57655280)
print v(xbgr.mr_n57655712)
print v(xbgr.mr_n57656144)
print v(xbgr.mr_n57656576)
print v(xbgr.mr_n57657008)
print v(xbgr.mr_n57657440)
print v(xbgr.mr_n57657872)
print v(xbgr.mr_n57658304)
print v(xbgr.mr_n57658736)
print v(xbgr.mr_n57659168)
print v(xbgr.mr_n57659600)
print v(xbgr.mr_n57660032)
print v(xbgr.mr_n57660464)
print v(xbgr.mr_n57660896)
print v(xbgr.mr_n57661328)
print v(xbgr.mr_n57661760)
print v(xbgr.mr_n57662192)
print v(xbgr.mr_n57662624)
print v(xbgr.mr_n57663056)
print v(xbgr.mr_n57663488)
print v(xbgr.mr_n57663920)
print v(xbgr.mr_n57664352)
print v(xbgr.mr_n57664784)
print v(xbgr.mr_n57665216)
print v(xbgr.mr_n57665648)
print v(xbgr.mr_n57666080)
print v(xbgr.mr_n57666512)
print v(xbgr.mr_n57666944)
print v(xbgr.mr_n57667376)
print v(xbgr.mr_n57667808)
print v(xbgr.mr_n57668240)
print v(xbgr.mr_n57668672)
print v(xbgr.mr_n57669104)
print v(xbgr.mr_n57669536)
print v(xbgr.mr_n57669968)
print v(xbgr.mr_n57670400)
print v(xbgr.mr_n57670832)
print v(xbgr.mr_n57671264)
print v(xbgr.mr_n57671696)
print v(xbgr.mr_n57672128)
print v(xbgr.mr_n57672560)
print v(xbgr.mr_n57672992)
print v(xbgr.mr_n57673424)
print v(xbgr.mr_n57673856)
print v(xbgr.mr_n57674288)
print v(xbgr.mr_n57674720)
print v(xbgr.mr_n57675152)
print v(xbgr.mr_n57675584)
print v(xbgr.mr_n57676016)
print v(xbgr.mr_n57676448)
print v(xbgr.mr_n57676880)
print v(xbgr.mr_n57677312)
print v(xbgr.mr_n57677744)
print v(xbgr.mr_n57678176)
print v(xbgr.mr_n57678608)
print v(xbgr.mr_n57679040)
print v(xbgr.mr_n57679472)
print v(xbgr.mr_n57679904)
print v(xbgr.mr_n57680336)
print v(xbgr.mr_n57680768)
print v(xbgr.mr_n57681200)
print v(xbgr.mr_n57681520)
print v(xbgr.mr_n57681632)
print v(xbgr.mr_n57681952)
print v(xbgr.mr_n57682064)
print v(xbgr.mr_n57682384)
print v(xbgr.mr_n57682496)
print v(xbgr.mr_n57682816)
print v(xbgr.mr_n57682928)
print v(xbgr.mr_n57683248)
print v(xbgr.mr_n57683360)
print v(xbgr.mr_n57683680)
print v(xbgr.mr_n57683792)
print v(xbgr.mr_n57684112)
print v(xbgr.mr_n57684224)
print v(xbgr.mr_n57684544)
print v(xbgr.mr_n57684656)
print v(xbgr.mr_n57684976)
print v(xbgr.mr_n57685088)
print v(xbgr.mr_n57685408)
print v(xbgr.mr_n57685520)
print v(xbgr.mr_n57685840)
print v(xbgr.mr_n57685952)
print v(xbgr.mr_n57686272)
print v(xbgr.mr_n57686384)
print v(xbgr.mr_n57686704)
print v(xbgr.mr_n57686816)
print v(xbgr.mr_n57687136)
print v(xbgr.mr_n57687248)
print v(xbgr.mr_n57687568)
print v(xbgr.mr_n57687680)
print v(xbgr.mr_n57688000)
print v(xbgr.mr_n57688112)
print v(xbgr.mr_n57688432)
print v(xbgr.mr_n57688544)
print v(xbgr.mr_n57688864)
print v(xbgr.mr_n57688976)
print v(xbgr.mr_n57689296)
print v(xbgr.mr_n57689408)
print v(xbgr.mr_n57689728)
print v(xbgr.mr_n57689840)
print v(xbgr.mr_n57690160)
print v(xbgr.mr_n57690272)
print v(xbgr.mr_n57690592)
print v(xbgr.mr_n57690704)
print v(xbgr.mr_n57691024)
print v(xbgr.mr_n57691136)
print v(xbgr.mr_n57691456)
print v(xbgr.mr_n57691568)
print v(xbgr.mr_n57691888)
print v(xbgr.mr_n57692000)
print v(xbgr.mr_n57692320)
print v(xbgr.mr_n57692432)
print v(xbgr.mr_n57692752)
print v(xbgr.mr_n57692864)
print v(xbgr.mr_n57693184)
print v(xbgr.mr_n57693296)
print v(xbgr.mr_n57693616)
print v(xbgr.mr_n57693728)
print v(xbgr.mr_n57694048)
print v(xbgr.mr_n57694160)
print v(xbgr.mr_n57694480)
print v(xbgr.mr_n57694592)
print v(xbgr.mr_n57694912)
print v(xbgr.mr_n57695024)
print v(xbgr.mr_n57695344)
print v(xbgr.mr_n57695456)
print v(xbgr.mr_n57695776)
print v(xbgr.mr_n57695888)
print v(xbgr.mr_n57696208)
print v(xbgr.mr_n57696320)
print v(xbgr.mr_n57696640)
print v(xbgr.mr_n57696752)
print v(xbgr.mr_n57697072)
print v(xbgr.mr_n57697184)
print v(xbgr.mr_n57697504)
print v(xbgr.mr_n57697616)
print v(xbgr.mr_n57697936)
print v(xbgr.mr_n57698048)
print v(xbgr.mr_n57698368)
print v(xbgr.mr_n57698480)
print v(xbgr.mr_n57698800)
print v(xbgr.mr_n57698912)
print v(xbgr.mr_n57699232)
print v(xbgr.mr_n57699344)
print v(xbgr.mr_n57699664)
print v(xbgr.mr_n57699776)
print v(xbgr.mr_n57700096)
print v(xbgr.mr_n57700208)
print v(xbgr.mr_n57700528)
print v(xbgr.mr_n57700640)
print v(xbgr.mr_n57700960)
print v(xbgr.mr_n57701072)
print v(xbgr.mr_n57701392)
print v(xbgr.mr_n57701504)
print v(xbgr.mr_n57701824)
print v(xbgr.mr_n57701936)
print v(xbgr.mr_n57702256)
print v(xbgr.mr_n57702368)
print v(xbgr.mr_n57702688)
print v(xbgr.mr_n57702800)
print v(xbgr.mr_n57703120)
print v(xbgr.mr_n57703232)
print v(xbgr.mr_n57703552)
print v(xbgr.mr_n57703664)
print v(xbgr.mr_n57703984)
print v(xbgr.mr_n57704096)
print v(xbgr.mr_n57704416)
print v(xbgr.mr_n57704528)
print v(xbgr.mr_n57704848)
print v(xbgr.mr_n57704960)
print v(xbgr.mr_n57705280)
print v(xbgr.mr_n57705392)
print v(xbgr.mr_n57705712)
print v(xbgr.mr_n57705824)
print v(xbgr.mr_n57706144)
print v(xbgr.mr_n57706256)
print v(xbgr.mr_n57706576)
print v(xbgr.mr_n57706688)
print v(xbgr.mr_n57707008)
print v(xbgr.mr_n57707120)
print v(xbgr.mr_n57707440)
print v(xbgr.mr_n57707552)
print v(xbgr.mr_n57707872)
print v(xbgr.mr_n57707984)
print v(xbgr.mr_n57708304)
print v(xbgr.mr_n57708416)
print v(xbgr.mr_n57708736)
print v(xbgr.mr_n57708848)
print v(xbgr.mr_n57709168)
print v(xbgr.mr_n57709280)
print v(xbgr.mr_n57709600)
print v(xbgr.mr_n57709712)
print v(xbgr.mr_n57710032)
print v(xbgr.mr_n57710144)
print v(xbgr.mr_n57710464)
print v(xbgr.mr_n57710576)
print v(xbgr.mr_n57710896)
print v(xbgr.mr_n57711008)
print v(xbgr.mr_n57711328)
print v(xbgr.mr_n57711440)
print v(xbgr.mr_n57711760)
print v(xbgr.mr_n57711872)
print v(xbgr.mr_n57712192)
print v(xbgr.mr_n57712304)
print v(xbgr.mr_n57712624)
print v(xbgr.mr_n57712736)
print v(xbgr.mr_n57713056)
print v(xbgr.mr_n57713168)
print v(xbgr.mr_n57713488)
print v(xbgr.mr_n57713600)
print v(xbgr.mr_n57713920)
print v(xbgr.mr_n57714032)
print v(xbgr.mr_n57714352)
print v(xbgr.mr_n57714464)
print v(xbgr.mr_n57714784)
print v(xbgr.mr_n57714896)
print v(xbgr.mr_n57715216)
print v(xbgr.mr_n57715328)
print v(xbgr.mr_n57715648)
print v(xbgr.mr_n57715760)
print v(xbgr.mr_n57716080)
print v(xbgr.mr_n57716192)
print v(xbgr.mr_n57716512)
print v(xbgr.mr_n57716624)
print v(xbgr.mr_n57716944)
print v(xbgr.mr_n57717056)
print v(xbgr.mr_n57717376)
print v(xbgr.mr_n57717488)
print v(xbgr.mr_n57717808)
print v(xbgr.mr_n57717920)
print v(xbgr.mr_n57718240)
print v(xbgr.mr_n57718352)
print v(xbgr.mr_n57718672)
print v(xbgr.mr_n57718784)
print v(xbgr.mr_n57719104)
print v(xbgr.mr_n57719216)
print v(xbgr.mr_n57719536)
print v(xbgr.mr_n57719648)
print v(xbgr.mr_n57719968)
print v(xbgr.mr_n57720080)
print v(xbgr.mr_n57720400)
print v(xbgr.mr_n57720512)
print v(xbgr.mr_n57720832)
print v(xbgr.mr_n57720944)
print v(xbgr.mr_n57721264)
print v(xbgr.mr_n57721376)
print v(xbgr.mr_n57721696)
print v(xbgr.mr_n57721808)
print v(xbgr.mr_n57722128)
print v(xbgr.mr_n57722240)
print v(xbgr.mr_n57722560)
print v(xbgr.mr_n57722672)
print v(xbgr.mr_n57722992)
print v(xbgr.mr_n57723104)
print v(xbgr.mr_n57723424)
print v(xbgr.mr_n57723536)
print v(xbgr.mr_n57723856)
print v(xbgr.mr_n57723968)
print v(xbgr.mr_n57724288)
print v(xbgr.mr_n57724400)
print v(xbgr.mr_n57724720)
print v(xbgr.mr_n57724832)
print v(xbgr.mr_n57725152)
print v(xbgr.mr_n57725264)
print v(xbgr.mr_n57725584)
print v(xbgr.mr_n57725696)
print v(xbgr.mr_n57726016)
print v(xbgr.mr_n57726128)
print v(xbgr.mr_n57726448)
print v(xbgr.mr_n57726560)
print v(xbgr.mr_n57726880)
print v(xbgr.mr_n57726992)
print v(xbgr.mr_n57727312)
print v(xbgr.mr_n57727424)
print v(xbgr.mr_n57727744)
print v(xbgr.mr_n57727856)
print v(xbgr.mr_n57728176)
print v(xbgr.mr_n57728288)
print v(xbgr.mr_n57728608)
print v(xbgr.mr_n57728720)
print v(xbgr.mr_n57729040)
print v(xbgr.mr_n57729152)
print v(xbgr.mr_n57729472)
print v(xbgr.mr_n57729584)
print v(xbgr.mr_n57729904)
print v(xbgr.mr_n57730016)
print v(xbgr.mr_n57730336)
print v(xbgr.mr_n57730448)
print v(xbgr.mr_n57730768)
print v(xbgr.mr_n57730880)
print v(xbgr.mr_n57731200)
print v(xbgr.mr_n57731312)
print v(xbgr.mr_n57731632)
print v(xbgr.mr_n57731744)
print v(xbgr.mr_n57732064)
print v(xbgr.mr_n57732176)
print v(xbgr.mr_n57732496)
print v(xbgr.mr_n57732608)
print v(xbgr.mr_n57732928)
print v(xbgr.mr_n57733040)
print v(xbgr.mr_n57733360)
print v(xbgr.mr_n57733472)
print v(xbgr.mr_n57733792)
print v(xbgr.mr_n57733904)
print v(xbgr.mr_n57734224)
print v(xbgr.mr_n57734336)
print v(xbgr.mr_n57734656)
print v(xbgr.mr_n57734768)
print v(xbgr.mr_n57735088)
print v(xbgr.mr_n57735200)
print v(xbgr.mr_n57735520)
print v(xbgr.mr_n57735632)
print v(xbgr.mr_n57735952)
print v(xbgr.mr_n57736064)
print v(xbgr.mr_n57736384)
print v(xbgr.mr_n57736496)
print v(xbgr.mr_n57736816)
print v(xbgr.mr_n57736928)
print v(xbgr.mr_n57737248)
print v(xbgr.mr_n57737360)
print v(xbgr.mr_n57737680)
print v(xbgr.mr_n57737792)
print v(xbgr.mr_n57738112)
print v(xbgr.mr_n57738224)
print v(xbgr.mr_n57738544)
print v(xbgr.mr_n57738656)
print v(xbgr.mr_n57738976)
print v(xbgr.mr_n57739088)
print v(xbgr.mr_n57739408)
print v(xbgr.mr_n57739520)
print v(xbgr.mr_n57739840)
print v(xbgr.mr_n57739952)
print v(xbgr.mr_n57740272)
print v(xbgr.mr_n57740384)
print v(xbgr.mr_n57740704)
print v(xbgr.mr_n57740816)
print v(xbgr.mr_n57741136)
print v(xbgr.mr_n57741248)
print v(xbgr.mr_n57741568)
print v(xbgr.mr_n57741680)
print v(xbgr.mr_n57742000)
print v(xbgr.mr_n57742112)
print v(xbgr.mr_n57742432)
print v(xbgr.mr_n57742544)
print v(xbgr.mr_n57742864)
print v(xbgr.mr_n57742976)
print v(xbgr.mr_n57743296)
print v(xbgr.mr_n57743408)
print v(xbgr.mr_n57743728)
print v(xbgr.mr_n57743840)
print v(xbgr.mr_n57744160)
print v(xbgr.mr_n57744272)
print v(xbgr.mr_n57744592)
print v(xbgr.mr_n57744704)
print v(xbgr.mr_n57745024)
print v(xbgr.mr_n57745136)
print v(xbgr.mr_n57745456)
print v(xbgr.mr_n57745568)
print v(xbgr.mr_n57745888)
print v(xbgr.mr_n57746000)
print v(xbgr.mr_n57746320)
print v(xbgr.mr_n57746432)
print v(xbgr.mr_n57746752)
print v(xbgr.mr_n57746864)
print v(xbgr.mr_n57747184)
print v(xbgr.mr_n57747296)
print v(xbgr.mr_n57747616)
print v(xbgr.mr_n57747728)
print v(xbgr.mr_n57748048)
print v(xbgr.mr_n57748160)
print v(xbgr.mr_n57748480)
print v(xbgr.mr_n57748592)
print v(xbgr.mr_n57748912)
print v(xbgr.mr_n57749024)
print v(xbgr.mr_n57749344)
print v(xbgr.mr_n57749456)
print v(xbgr.mr_n57749776)
print v(xbgr.mr_n57749888)
print v(xbgr.mr_n57750208)
print v(xbgr.mr_n57750320)
print v(xbgr.mr_n57750640)
print v(xbgr.mr_n57750752)
print v(xbgr.mr_n57751072)
print v(xbgr.mr_n57751184)
print v(xbgr.mr_n57751504)
print v(xbgr.mr_n57751616)
print v(xbgr.mr_n57751936)
print v(xbgr.mr_n57752048)
print v(xbgr.mr_n57752368)
print v(xbgr.mr_n57752480)
print v(xbgr.mr_n57752800)
print v(xbgr.mr_n57752912)
print v(xbgr.mr_n57753232)
print v(xbgr.mr_n57753344)
print v(xbgr.mr_n57753664)
print v(xbgr.mr_n57753776)
print v(xbgr.mr_n57754096)
print v(xbgr.mr_n57754208)
print v(xbgr.mr_n57754528)
print v(xbgr.mr_n57754640)
print v(xbgr.mr_n57754960)
print v(xbgr.mr_n57755072)
print v(xbgr.mr_n57755392)
print v(xbgr.mr_n57755504)
print v(xbgr.mr_n57755824)
print v(xbgr.mr_n57755936)
print v(xbgr.mr_n57756256)
print v(xbgr.mr_n57756368)
print v(xbgr.mr_n57756688)
print v(xbgr.mr_n57756800)
print v(xbgr.mr_n57757120)
print v(xbgr.mr_n57757232)
print v(xbgr.mr_n57757552)
print v(xbgr.mr_n57757664)
print v(xbgr.mr_n57757984)
print v(xbgr.mr_n57758096)
print v(xbgr.mr_n57758416)
print v(xbgr.mr_n57758528)
print v(xbgr.mr_n57758848)
print v(xbgr.mr_n57758960)
print v(xbgr.mr_n57759280)
print v(xbgr.mr_n57759392)
print v(xbgr.mr_n57759712)
print v(xbgr.mr_n57759824)
print v(xbgr.mr_n57760144)
print v(xbgr.mr_n57760256)
print v(xbgr.mr_n57760576)
print v(xbgr.mr_n57760688)
print v(xbgr.mr_n57761008)
print v(xbgr.mr_n57761120)
print v(xbgr.mr_n57761440)
print v(xbgr.mr_n57761552)
print v(xbgr.mr_n57761872)
print v(xbgr.mr_n57761984)
print v(xbgr.mr_n57762304)
print v(xbgr.mr_n57762416)
print v(xbgr.mr_n57762736)
print v(xbgr.mr_n57762848)
print v(xbgr.mr_n57763168)
print v(xbgr.mr_n57763280)
print v(xbgr.mr_n57763600)
print v(xbgr.mr_n57763712)
print v(xbgr.mr_n57764032)
print v(xbgr.mr_n57764144)
print v(xbgr.mr_n57764464)
print v(xbgr.mr_n57764576)
print v(xbgr.mr_n57764896)
print v(xbgr.mr_n57765008)
print v(xbgr.mr_n57765328)
print v(xbgr.mr_n57765440)
print v(xbgr.mr_n57765760)
print v(xbgr.mr_n57765872)
print v(xbgr.mr_n57766192)
print v(xbgr.mr_n57766304)
print v(xbgr.mr_n57766624)
print v(xbgr.mr_n57766736)
print v(xbgr.mr_n57767056)
print v(xbgr.mr_n57767168)
print v(xbgr.mr_n57767488)
print v(xbgr.mr_n57767600)
print v(xbgr.mr_n57767920)
print v(xbgr.mr_n57768032)
print v(xbgr.mr_n57768352)
print v(xbgr.mr_n57768464)
print v(xbgr.mr_n57768784)
print v(xbgr.mr_n57768896)
print v(xbgr.mr_n57769216)
print v(xbgr.mr_n57769328)
print v(xbgr.mr_n57769648)
print v(xbgr.mr_n57769760)
print v(xbgr.mr_n57770080)
print v(xbgr.mr_n57770192)
print v(xbgr.mr_n57770512)
print v(xbgr.mr_n57770624)
print v(xbgr.mr_n57770944)
print v(xbgr.mr_n57771056)
print v(xbgr.mr_n57771376)
print v(xbgr.mr_n57771488)
print v(xbgr.mr_n57771808)
print v(xbgr.mr_n57771920)
print v(xbgr.mr_n57772240)
print v(xbgr.mr_n57772352)
print v(xbgr.mr_n57772672)
print v(xbgr.mr_n57772784)
print v(xbgr.mr_n57773104)
print v(xbgr.mr_n57773216)
print v(xbgr.mr_n57773536)
print v(xbgr.mr_n57773648)
print v(xbgr.mr_n57773968)
print v(xbgr.mr_n57774080)
print v(xbgr.mr_n57774400)
print v(xbgr.mr_n57774512)
print v(xbgr.mr_n57774832)
print v(xbgr.mr_n57774944)
print v(xbgr.mr_n57775264)
print v(xbgr.mr_n57775376)
print v(xbgr.mr_n57776240)
print v(xbgr.mr_n57776672)
print v(xbgr.mr_n57777104)
print v(xbgr.mr_n57777536)
print v(xbgr.mr_n57777968)
print v(xbgr.mr_n57778400)
print v(xbgr.mr_n57778832)
print v(xbgr.mr_n57779264)
print v(xbgr.mr_n57779696)
print v(xbgr.mr_n57780128)
print v(xbgr.mr_n57780560)
print v(xbgr.mr_n57780992)
print v(xbgr.mr_n57781424)
print v(xbgr.mr_n57781856)
print v(xbgr.mr_n57782288)
print v(xbgr.mr_n57782720)
print v(xbgr.mr_n57783152)
print v(xbgr.mr_n57783584)
print v(xbgr.mr_n57784016)
print v(xbgr.mr_n57784448)
print v(xbgr.mr_n57784880)
print v(xbgr.mr_n57785312)
print v(xbgr.mr_n57785744)
print v(xbgr.mr_n57786176)
print v(xbgr.mr_n57788336)
print v(xbgr.mr_n57788768)
print v(xbgr.mr_n57789200)
print v(xbgr.mr_n57789632)
print v(xbgr.mr_n57790064)
print v(xbgr.mr_n57790496)
print v(xbgr.mr_n57790928)
print v(xbgr.mr_n57791360)
print v(xbgr.mr_n57791792)
print v(xbgr.mr_n57792224)
print v(xbgr.mr_n57792656)
print v(xbgr.mr_n57793088)
print v(xbgr.mr_n57793520)
print v(xbgr.mr_n57793952)
print v(xbgr.mr_n57794384)
print v(xbgr.mr_n57794816)
print v(xbgr.mr_n57795248)
print v(xbgr.mr_n57795680)
print v(xbgr.mr_n57796112)
print v(xbgr.mr_n57796544)
print v(xbgr.mr_n57796976)
print v(xbgr.mr_n57797408)
print v(xbgr.mr_n57797840)
print v(xbgr.mr_n57798272)
print v(xbgr.mr_n57802160)
print v(xbgr.mr_n57802592)
print v(xbgr.mr_n57803024)
print v(xbgr.mr_n57803456)
print v(xbgr.mr_n57803888)
print v(xbgr.mr_n57804320)
print v(xbgr.mr_n57804752)
print v(xbgr.mr_n57805184)
print v(xbgr.mr_n57805616)
print v(xbgr.mr_n57806048)
print v(xbgr.mr_n57806480)
print v(xbgr.mr_n57806912)
print v(xbgr.mr_n57807344)
print v(xbgr.mr_n57807776)
print v(xbgr.mr_n57808208)
print v(xbgr.mr_n57809504)
print v(xbgr.mr_n57809936)
print v(xbgr.mr_n57810368)
print v(xbgr.mr_n57810800)
print v(xbgr.mr_n57811232)
print v(xbgr.mr_n57811664)
print v(xbgr.mr_n57812096)
print v(xbgr.mr_n57812528)
print v(xbgr.mr_n57812960)
print v(xbgr.mr_n57813392)
print v(xbgr.mr_n57814688)
print v(xbgr.mr_n57815120)
print v(xbgr.mr_n57815552)
print v(xbgr.mr_n57815984)
print v(xbgr.mr_n57816416)
print v(xbgr.mr_n57816848)
print v(xbgr.mr_n57817280)
print v(xbgr.mr_n57817712)
print v(xbgr.mr_n57818032)
print v(xbgr.mr_n57818144)
print v(xbgr.mr_n57818464)
print v(xbgr.mr_n57818576)
print v(xbgr.mr_n57818896)
print v(xbgr.mr_n57819008)
print v(xbgr.mr_n57819328)
print v(xbgr.mr_n57819440)
print v(xbgr.mr_n57819760)
print v(xbgr.mr_n57819872)
print v(xbgr.mr_n57820192)
print v(xbgr.mr_n57820304)
print v(xbgr.mr_n57820624)
print v(xbgr.mr_n57820736)
print v(xbgr.mr_n57821056)
print v(xbgr.mr_n57821168)
print v(xbgr.mr_n57821488)
print v(xbgr.mr_n57821600)
print v(xbgr.mr_n57821920)
print v(xbgr.mr_n57822032)
print v(xbgr.mr_n57822352)
print v(xbgr.mr_n57822464)
print v(xbgr.mr_n57822784)
print v(xbgr.mr_n57822896)
print v(xbgr.mr_n57823216)
print v(xbgr.mr_n57823328)
print v(xbgr.mr_n57823648)
print v(xbgr.mr_n57823760)
print v(xbgr.mr_n57824080)
print v(xbgr.mr_n57824192)
print v(xbgr.mr_n57824512)
print v(xbgr.mr_n57824624)
print v(xbgr.mr_n57824944)
print v(xbgr.mr_n57825056)
print v(xbgr.mr_n57825376)
print v(xbgr.mr_n57825488)
print v(xbgr.mr_n57825808)
print v(xbgr.mr_n57825920)
print v(xbgr.mr_n57826240)
print v(xbgr.mr_n57826352)
print v(xbgr.mr_n57826672)
print v(xbgr.mr_n57826784)
print v(xbgr.mr_n57827104)
print v(xbgr.mr_n57827216)
print v(xbgr.mr_n57827536)
print v(xbgr.mr_n57827648)
print v(xbgr.mr_n57827968)
print v(xbgr.mr_n57828080)
print v(xbgr.mr_n57828400)
print v(xbgr.mr_n57828512)
print v(xbgr.mr_n57828832)
print v(xbgr.mr_n57828944)
print v(xbgr.mr_n57829264)
print v(xbgr.mr_n57829376)
print v(xbgr.mr_n57829696)
print v(xbgr.mr_n57829808)
print v(xbgr.mr_n57830128)
print v(xbgr.mr_n57830240)
print v(xbgr.mr_n57830560)
print v(xbgr.mr_n57830672)
print v(xbgr.mr_n57830992)
print v(xbgr.mr_n57831104)
print v(xbgr.mr_n57831424)
print v(xbgr.mr_n57831536)
print v(xbgr.mr_n57831856)
print v(xbgr.mr_n57831968)
print v(xbgr.mr_n57832288)
print v(xbgr.mr_n57832400)
print v(xbgr.mr_n57832720)
print v(xbgr.mr_n57832832)
print v(xbgr.mr_n57833152)
print v(xbgr.mr_n57833264)
print v(xbgr.mr_n57833584)
print v(xbgr.mr_n57833696)
print v(xbgr.mr_n57834016)
print v(xbgr.mr_n57834128)
print v(xbgr.mr_n57834448)
print v(xbgr.mr_n57834560)
print v(xbgr.mr_n57834880)
print v(xbgr.mr_n57834992)
print v(xbgr.mr_n57835312)
print v(xbgr.mr_n57835424)
print v(xbgr.mr_n57835744)
print v(xbgr.mr_n57835856)
print v(xbgr.mr_n57836176)
print v(xbgr.mr_n57836288)
print v(xbgr.mr_n57836608)
print v(xbgr.mr_n57836720)
print v(xbgr.mr_n57837040)
print v(xbgr.mr_n57837152)
print v(xbgr.mr_n57837472)
print v(xbgr.mr_n57837584)
print v(xbgr.mr_n57837904)
print v(xbgr.mr_n57838016)
print v(xbgr.mr_n57838336)
print v(xbgr.mr_n57838448)
print v(xbgr.mr_n57838768)
print v(xbgr.mr_n57838880)
print v(xbgr.mr_n57839200)
print v(xbgr.mr_n57839312)
print v(xbgr.mr_n57839632)
print v(xbgr.mr_n57839744)
print v(xbgr.mr_n57840064)
print v(xbgr.mr_n57840176)
print v(xbgr.mr_n57840496)
print v(xbgr.mr_n57840608)
print v(xbgr.mr_n57840928)
print v(xbgr.mr_n57841040)
print v(xbgr.mr_n57841360)
print v(xbgr.mr_n57841472)
print v(xbgr.mr_n57841792)
print v(xbgr.mr_n57841904)
print v(xbgr.mr_n57842224)
print v(xbgr.mr_n57842336)
print v(xbgr.mr_n57842656)
print v(xbgr.mr_n57842768)
print v(xbgr.mr_n57843088)
print v(xbgr.mr_n57843200)
print v(xbgr.mr_n57843520)
print v(xbgr.mr_n57843632)
print v(xbgr.mr_n57843952)
print v(xbgr.mr_n57844064)
print v(xbgr.mr_n57844384)
print v(xbgr.mr_n57844496)
print v(xbgr.mr_n57844816)
print v(xbgr.mr_n57844928)
print v(xbgr.mr_n57845248)
print v(xbgr.mr_n57845360)
print v(xbgr.mr_n57845680)
print v(xbgr.mr_n57845792)
print v(xbgr.mr_n57846112)
print v(xbgr.mr_n57846224)
print v(xbgr.mr_n57846544)
print v(xbgr.mr_n57846656)
print v(xbgr.mr_n57846976)
print v(xbgr.mr_n57847088)
print v(xbgr.mr_n57847408)
print v(xbgr.mr_n57847520)
print v(xbgr.mr_n57847840)
print v(xbgr.mr_n57847952)
print v(xbgr.mr_n57848272)
print v(xbgr.mr_n57848384)
print v(xbgr.mr_n57848704)
print v(xbgr.mr_n57848816)
print v(xbgr.mr_n57849136)
print v(xbgr.mr_n57849248)
print v(xbgr.mr_n57849568)
print v(xbgr.mr_n57849680)
print v(xbgr.mr_n57850000)
print v(xbgr.mr_n57850112)
print v(xbgr.mr_n57850432)
print v(xbgr.mr_n57850544)
print v(xbgr.mr_n57850864)
print v(xbgr.mr_n57850976)
print v(xbgr.mr_n57851296)
print v(xbgr.mr_n57851408)
print v(xbgr.mr_n57851728)
print v(xbgr.mr_n57851840)
print v(xbgr.mr_n57852160)
print v(xbgr.mr_n57852272)
print v(xbgr.mr_n57852592)
print v(xbgr.mr_n57852704)
print v(xbgr.mr_n57853024)
print v(xbgr.mr_n57853136)
print v(xbgr.mr_n57853456)
print v(xbgr.mr_n57853568)
print v(xbgr.mr_n57853888)
print v(xbgr.mr_n57854000)
print v(xbgr.mr_n57854320)
print v(xbgr.mr_n57854432)
print v(xbgr.mr_n57854752)
print v(xbgr.mr_n57854864)
print v(xbgr.mr_n57855184)
print v(xbgr.mr_n57855296)
print v(xbgr.mr_n57855616)
print v(xbgr.mr_n57855728)
print v(xbgr.mr_n57856048)
print v(xbgr.mr_n57856160)
print v(xbgr.mr_n57856480)
print v(xbgr.mr_n57856592)
print v(xbgr.mr_n57856912)
print v(xbgr.mr_n57857024)
print v(xbgr.mr_n57857344)
print v(xbgr.mr_n57857456)
print v(xbgr.mr_n57857776)
print v(xbgr.mr_n57857888)
print v(xbgr.mr_n57858208)
print v(xbgr.mr_n57858320)
print v(xbgr.mr_n57858640)
print v(xbgr.mr_n57858752)
print v(xbgr.mr_n57859072)
print v(xbgr.mr_n57859184)
print v(xbgr.mr_n57859504)
print v(xbgr.mr_n57859616)
print v(xbgr.mr_n57859936)
print v(xbgr.mr_n57860048)
print v(xbgr.mr_n57860368)
print v(xbgr.mr_n57860480)
print v(xbgr.mr_n57860800)
print v(xbgr.mr_n57860912)
print v(xbgr.mr_n57861232)
print v(xbgr.mr_n57861344)
print v(xbgr.mr_n57861664)
print v(xbgr.mr_n57861776)
print v(xbgr.mr_n57862096)
print v(xbgr.mr_n57862208)
print v(xbgr.mr_n57862528)
print v(xbgr.mr_n57862640)
print v(xbgr.mr_n57862960)
print v(xbgr.mr_n57863072)
print v(xbgr.mr_n57863392)
print v(xbgr.mr_n57863504)
print v(xbgr.mr_n57863824)
print v(xbgr.mr_n57863936)
print v(xbgr.mr_n57864256)
print v(xbgr.mr_n57864368)
print v(xbgr.mr_n57864688)
print v(xbgr.mr_n57865120)
print v(xbgr.mr_n57865232)
print v(xbgr.mr_n57865552)
print v(xbgr.mr_n57865664)
print v(xbgr.mr_n57865984)
print v(xbgr.mr_n57866096)
print v(xbgr.mr_n57866416)
print v(xbgr.mr_n57866528)
print v(xbgr.mr_n57866848)
print v(xbgr.mr_n57866960)
print v(xbgr.mr_n57867280)
print v(xbgr.mr_n57867392)
print v(xbgr.mr_n57867712)
print v(xbgr.mr_n57867824)
print v(xbgr.mr_n57868144)
print v(xbgr.mr_n57868256)
print v(xbgr.mr_n57868576)
print v(xbgr.mr_n57868688)
print v(xbgr.mr_n57869008)
print v(xbgr.mr_n57869120)
print v(xbgr.mr_n57869440)
print v(xbgr.mr_n57869552)
print v(xbgr.mr_n57869872)
print v(xbgr.mr_n57869984)
print v(xbgr.mr_n57870304)
print v(xbgr.mr_n57870416)
print v(xbgr.mr_n57870736)
print v(xbgr.mr_n57870848)
print v(xbgr.mr_n57871168)
print v(xbgr.mr_n57871280)
print v(xbgr.mr_n57871600)
print v(xbgr.mr_n57871712)
print v(xbgr.mr_n57872032)
print v(xbgr.mr_n57872144)
print v(xbgr.mr_n57872464)
print v(xbgr.mr_n57872576)
print v(xbgr.mr_n57872896)
print v(xbgr.mr_n57873008)
print v(xbgr.mr_n57873328)
print v(xbgr.mr_n57873440)
print v(xbgr.mr_n57873760)
print v(xbgr.mr_n57873872)
print v(xbgr.mr_n57874192)
print v(xbgr.mr_n57874304)
print v(xbgr.mr_n57874624)
print v(xbgr.mr_n57874736)
print v(xbgr.mr_n57875056)
print v(xbgr.mr_n57875168)
print v(xbgr.mr_n57875488)
print v(xbgr.mr_n57875600)
print v(xbgr.mr_n57875920)
print v(xbgr.mr_n57876032)
print v(xbgr.mr_n57876352)
print v(xbgr.mr_n57876464)
print v(xbgr.mr_n57876784)
print v(xbgr.mr_n57876896)
print v(xbgr.mr_n57877216)
print v(xbgr.mr_n57877328)
print v(xbgr.mr_n57877648)
print v(xbgr.mr_n57877760)
print v(xbgr.mr_n57878080)
print v(xbgr.mr_n57878192)
print v(xbgr.mr_n57878512)
print v(xbgr.mr_n57878624)
print v(xbgr.mr_n57878944)
print v(xbgr.mr_n57879056)
print v(xbgr.mr_n57879376)
print v(xbgr.mr_n57879488)
print v(xbgr.mr_n57879808)
print v(xbgr.mr_n57879920)
print v(xbgr.mr_n57880240)
print v(xbgr.mr_n57880672)
print v(xbgr.mr_n57880784)
print v(xbgr.mr_n57881104)
print v(xbgr.mr_n57881216)
print v(xbgr.mr_n57881536)
print v(xbgr.mr_n57881648)
print v(xbgr.mr_n57881968)
print v(xbgr.mr_n57882400)
print v(xbgr.mr_n57882512)
print v(xbgr.mr_n57882832)
print v(xbgr.mr_n57882944)
print v(xbgr.mr_n57883264)
print v(xbgr.mr_n57883376)
print v(xbgr.mr_n57883696)
print v(xbgr.mr_n57884128)
print v(xbgr.mr_n57884240)
print v(xbgr.mr_n57884560)
print v(xbgr.mr_n57884672)
print v(xbgr.mr_n57884992)
print v(xbgr.mr_n57885104)
print v(xbgr.mr_n57885424)
print v(xbgr.mr_n57885536)
print v(xbgr.mr_n57885856)
print v(xbgr.mr_n57885968)
print v(xbgr.mr_n57886288)
print v(xbgr.mr_n57886400)
print v(xbgr.mr_n57886720)
print v(xbgr.mr_n57886832)
print v(xbgr.mr_n57887152)
print v(xbgr.mr_n57887264)
print v(xbgr.mr_n57887584)
print v(xbgr.mr_n57887696)
print v(xbgr.mr_n57888016)
print v(xbgr.mr_n57888128)
print v(xbgr.mr_n57888448)
print v(xbgr.mr_n57888560)
print v(xbgr.mr_n57888880)
print v(xbgr.mr_n57888992)
print v(xbgr.mr_n57889312)
print v(xbgr.mr_n57889424)
print v(xbgr.mr_n57889744)
print v(xbgr.mr_n57889856)
print v(xbgr.mr_n57890176)
print v(xbgr.mr_n57890288)
print v(xbgr.mr_n57890608)
print v(xbgr.mr_n57890720)
print v(xbgr.mr_n57891040)
print v(xbgr.mr_n57891472)
print v(xbgr.mr_n57891584)
print v(xbgr.mr_n57891904)
print v(xbgr.mr_n57892016)
print v(xbgr.mr_n57892336)
print v(xbgr.mr_n57892448)
print v(xbgr.mr_n57892768)
print v(xbgr.mr_n57892880)
print v(xbgr.mr_n57893200)
print v(xbgr.mr_n57893312)
print v(xbgr.mr_n57893632)
print v(xbgr.mr_n57893744)
print v(xbgr.mr_n57894064)
print v(xbgr.mr_n57894176)
print v(xbgr.mr_n57894496)
print v(xbgr.mr_n57894608)
print v(xbgr.mr_n57894928)
print v(xbgr.mr_n57895040)
print v(xbgr.mr_n57895360)
print v(xbgr.mr_n57895472)
print v(xbgr.mr_n57895792)
print v(xbgr.mr_n57896224)
print v(xbgr.mr_n57896336)
print v(xbgr.mr_n57896656)
print v(xbgr.mr_n57897088)
print v(xbgr.mr_n57897200)
print v(xbgr.mr_n57897520)
print v(xbgr.mr_n57897632)
print v(xbgr.mr_n57897952)
print v(xbgr.mr_n57898064)
print v(xbgr.mr_n57898384)
print v(xbgr.mr_n57898496)
print v(xbgr.mr_n57898816)
print v(xbgr.mr_n57898928)
print v(xbgr.mr_n57899248)
print v(xbgr.mr_n57899680)
print v(xbgr.mr_n57899792)
print v(xbgr.mr_n57900112)
print v(xbgr.mr_n57900224)
print v(xbgr.mr_n57900544)
print v(xbgr.mr_n57900656)
print v(xbgr.mr_n57904720)
print v(xbgr.mr_n57904832)
print v(xbgr.mr_n57905168)
print v(xbgr.mr_n57905280)
print v(xbgr.mr_n57905600)
print v(xbgr.mr_n57905712)
print v(xbgr.mr_n57906080)
print v(xbgr.mr_n57906192)
print v(xbgr.mr_n57906512)
print v(xbgr.mr_n57906624)
print v(xbgr.mr_n57906944)
print v(xbgr.mr_n57907296)
print v(xbgr.mr_n57907408)
print v(xbgr.mr_n57907728)
print v(xbgr.mr_n57908160)
print v(xbgr.mr_n57908272)
print v(xbgr.mr_n57908592)
print v(xbgr.mr_n57908704)
print v(xbgr.mr_n57909024)
print v(xbgr.mr_n57909136)
print v(xbgr.mr_n57909456)
print v(xbgr.mr_n57909568)
print v(xbgr.mr_n57909888)
print v(xbgr.mr_n57910000)
print v(xbgr.mr_n57910320)
print v(xbgr.mr_n57910752)
print v(xbgr.mr_n57910864)
print v(xbgr.mr_n57911184)
print v(xbgr.mr_n57911616)
print v(xbgr.mr_n57911728)
print v(xbgr.mr_n57912048)
print v(xbgr.mr_n57912160)
print v(xbgr.mr_n57912480)
print v(xbgr.mr_n57912592)
print v(xbgr.mr_n57912912)
print v(xbgr.mr_n57913024)
print v(xbgr.mr_n57913344)
print v(xbgr.mr_n57913456)
print v(xbgr.mr_n57913776)
print v(xbgr.mr_n57913888)
print v(xbgr.mr_n57914208)
print v(xbgr.mr_n57914320)
print v(xbgr.mr_n57914640)
print v(xbgr.mr_n57915072)
print v(xbgr.mr_n57915184)
print v(xbgr.mr_n57915504)
print v(xbgr.mr_n57915616)
print v(xbgr.mr_n57915936)
print v(xbgr.mr_n57916048)
print v(xbgr.mr_n57916368)
print v(xbgr.mr_n57916480)
print v(xbgr.mr_n57916800)
print v(xbgr.mr_n57916912)
print v(xbgr.mr_n57917232)
print v(xbgr.mr_n57917344)
print v(xbgr.mr_n57917664)
print v(xbgr.mr_n57917776)
print v(xbgr.mr_n57918096)
print v(xbgr.mr_n57918528)
print v(xbgr.mr_n57918640)
print v(xbgr.mr_n57918960)
print v(xbgr.mr_n57919392)
print v(xbgr.mr_n57919504)
print v(xbgr.mr_n57919824)
print v(xbgr.mr_n57919936)
print v(xbgr.mr_n57920256)
print v(xbgr.mr_n57920368)
print v(xbgr.mr_n57920688)
print v(xbgr.mr_n57920800)
print v(xbgr.mr_n57921120)
print v(xbgr.mr_n57921232)
print v(xbgr.mr_n57921552)
print v(xbgr.mr_n57921664)
print v(xbgr.mr_n57921984)
print v(xbgr.mr_n57922096)
print v(xbgr.mr_n57922416)
print v(xbgr.mr_n57922848)
print v(xbgr.mr_n57922960)
print v(xbgr.mr_n57923280)
print v(xbgr.mr_n57923392)
print v(xbgr.mr_n57923712)
print v(xbgr.mr_n57923824)
print v(xbgr.mr_n57924144)
print v(xbgr.mr_n57924576)
print v(xbgr.mr_n57924688)
print v(xbgr.mr_n57925008)
print v(xbgr.mr_n57925120)
print v(xbgr.mr_n57925440)
print v(xbgr.mr_n57925552)
print v(xbgr.mr_n57925872)
print v(xbgr.mr_n57925984)
print v(xbgr.mr_n57926304)
print v(xbgr.mr_n57926416)
print v(xbgr.mr_n57926736)
print v(xbgr.mr_n57926848)
print v(xbgr.mr_n57927168)
print v(xbgr.mr_n57927280)
print v(xbgr.mr_n57927600)
print v(xbgr.mr_n57928032)
print v(xbgr.mr_n57928144)
print v(xbgr.mr_n57928464)
print v(xbgr.mr_n57928576)
print v(xbgr.mr_n57928896)
print v(xbgr.mr_n57929008)
print v(xbgr.mr_n57929328)
print v(xbgr.mr_n57929760)
print v(xbgr.mr_n57929872)
print v(xbgr.mr_n57930192)
print v(xbgr.mr_n57930304)
print v(xbgr.mr_n57930624)
print v(xbgr.mr_n57930736)
print v(xbgr.mr_n57931056)
print v(xbgr.mr_n57931168)
print v(xbgr.mr_n57931488)
print v(xbgr.mr_n57931600)
print v(xbgr.mr_n57931920)
print v(xbgr.mr_n57932032)
print v(xbgr.mr_n57932352)
print v(xbgr.mr_n57932464)
print v(xbgr.mr_n57932784)
print v(xbgr.mr_n57932896)
print v(xbgr.mr_n57933216)
print v(xbgr.mr_n57933328)
print v(xbgr.mr_n57933648)
print v(xbgr.mr_n57934080)
print v(xbgr.mr_n57934192)
print v(xbgr.mr_n57934512)
print v(xbgr.mr_n57934624)
print v(xbgr.mr_n57934848)
print v(xbgr.mr_n57935216)
print v(xbgr.mr_n57935328)
print v(xbgr.mr_n57935584)
print v(xbgr.mr_n57935696)
print v(xbgr.mr_n57935952)
print v(xbgr.mr_n57936064)
print v(xbgr.mr_n57936320)
print v(xbgr.mr_n57936432)
print v(xbgr.mr_n57936688)
print v(xbgr.mr_n57936800)
print v(xbgr.mr_n57937056)
print v(xbgr.mr_n57937424)
print v(xbgr.mr_n57937536)
print v(xbgr.mr_n57937792)
print v(xbgr.mr_n57938160)
print v(xbgr.mr_n57938272)
print v(xbgr.mr_n57938528)
print v(xbgr.mr_n57938896)
print v(xbgr.mr_n57939008)
print v(xbgr.mr_n57939264)
print v(xbgr.mr_n57939376)
print v(xbgr.mr_n57939632)
print v(xbgr.mr_n57939744)
print v(xbgr.mr_n57940000)
print v(xbgr.mr_n57940368)
print v(xbgr.mr_n57940480)
print v(xbgr.mr_n57940736)
print v(xbgr.mr_n57941104)
print v(xbgr.mr_n57941216)
print v(xbgr.mr_n57941472)
print v(xbgr.mr_n57941840)
print v(xbgr.mr_n57941952)
print v(xbgr.mr_n57942208)
print v(xbgr.mr_n57942320)
print v(xbgr.mr_n57942576)
print v(xbgr.mr_n57942688)
print v(xbgr.mr_n57942944)
print v(xbgr.mr_n57943056)
print v(xbgr.mr_n57943312)
print v(xbgr.mr_n57943424)
print v(xbgr.mr_n57943680)
print v(xbgr.mr_n57944048)
print v(xbgr.mr_n57944160)
print v(xbgr.mr_n57944416)
print v(xbgr.mr_n57944528)
print v(xbgr.mr_n57944784)
print v(xbgr.mr_n57944896)
print v(xbgr.mr_n57945152)
print v(xbgr.mr_n57945264)
print v(xbgr.mr_n57945520)
print v(xbgr.mr_n57945632)
print v(xbgr.mr_n57945888)
print v(xbgr.mr_n57946256)
print v(xbgr.mr_n57946368)
print v(xbgr.mr_n57946624)
print v(xbgr.mr_n57946992)
print v(xbgr.mr_n57947104)
print v(xbgr.mr_n57947360)
print v(xbgr.mr_n57947472)
print v(xbgr.mr_n57947760)
print v(xbgr.mr_n57947872)
print v(xbgr.mr_n57948192)
print v(xbgr.mr_n57948624)
print v(xbgr.mr_n57948736)
print v(xbgr.mr_n57949056)
print v(xbgr.mr_n57949488)
print v(xbgr.mr_n57949600)
print v(xbgr.mr_n57949920)
print v(xbgr.mr_n57950032)
print v(xbgr.mr_n57950352)
print v(xbgr.mr_n57950464)
print v(xbgr.mr_n57950784)
print v(xbgr.mr_n57950896)
print v(xbgr.mr_n57951216)
print v(xbgr.mr_n57951328)
print v(xbgr.mr_n57951648)
print v(xbgr.mr_n57951760)
print v(xbgr.mr_n57952080)
print v(xbgr.mr_n57952192)
print v(xbgr.mr_n57952512)
print v(xbgr.mr_n57952944)
print v(xbgr.mr_n57953056)
print v(xbgr.mr_n57953376)
print v(xbgr.mr_n57953488)
print v(xbgr.mr_n57953808)
print v(xbgr.mr_n57953920)
print v(xbgr.mr_n57954240)
print v(xbgr.mr_n57954352)
print v(xbgr.mr_n57954672)
print v(xbgr.mr_n57954784)
print v(xbgr.mr_n57955104)
print v(xbgr.mr_n57955536)
print v(xbgr.mr_n57955648)
print v(xbgr.mr_n57955968)
print v(xbgr.mr_n57956400)
print v(xbgr.mr_n57956512)
print v(xbgr.mr_n57956832)
print v(xbgr.mr_n57956944)
print v(xbgr.mr_n57957264)
print v(xbgr.mr_n57957376)
print v(xbgr.mr_n57957696)
print v(xbgr.mr_n57957808)
print v(xbgr.mr_n57958128)
print v(xbgr.mr_n57958240)
print v(xbgr.mr_n57958560)
print v(xbgr.mr_n57958672)
print v(xbgr.mr_n57958992)
print v(xbgr.mr_n57959104)
print v(xbgr.mr_n57959424)
print v(xbgr.mr_n57959536)
print v(xbgr.mr_n57959856)
print v(xbgr.mr_n57960400)
print v(xbgr.mr_n57960832)
print v(xbgr.mr_n57961264)
print v(xbgr.mr_n57961696)
print v(xbgr.mr_n57962128)
print v(xbgr.mr_n57962560)
print v(xbgr.mr_n57962992)
print v(xbgr.mr_n57963424)
print v(xbgr.mr_n57963856)
print v(xbgr.mr_n57964288)
print v(xbgr.mr_n57964608)
print v(xbgr.mr_n57965040)
print v(xbgr.mr_n57965472)
print v(xbgr.mr_n57965904)
print v(xbgr.mr_n57966336)
print v(xbgr.mr_n57966768)
print v(xbgr.mr_n57967200)
print v(xbgr.mr_n57967632)
print v(xbgr.mr_n57968064)
print v(xbgr.mr_n57968496)
print v(xbgr.mr_n57968928)
print v(xbgr.mr_n57969360)
print v(xbgr.mr_n57969792)
print v(xbgr.mr_n57970224)
print v(xbgr.mr_n57970656)
print v(xbgr.mr_n57971088)
print v(xbgr.mr_n57971520)
print v(xbgr.mr_n57971952)
print v(xbgr.mr_n57972384)
print v(xbgr.mr_n57972816)
print v(xbgr.mr_n57973248)
print v(xbgr.mr_n57973680)
print v(xbgr.mr_n57974112)
print v(xbgr.mr_n57974544)
print v(xbgr.mr_n57974976)
print v(xbgr.mr_n57975408)
print v(xbgr.mr_n57975840)
print v(xbgr.mr_n57976272)
print v(xbgr.mr_n57976704)
print v(xbgr.mr_n57977136)
print v(xbgr.mr_n57977568)
print v(xbgr.mr_n57978000)
print v(xbgr.mr_n57978432)
print v(xbgr.mr_n57978864)
print v(xbgr.mr_n57979296)
print v(xbgr.mr_n57979728)
print v(xbgr.mr_n57980160)
print v(xbgr.mr_n57980592)
print v(xbgr.mr_n57981024)
print v(xbgr.mr_n57981456)
print v(xbgr.mr_n57981888)
print v(xbgr.mr_n57982320)
print v(xbgr.mr_n57982752)
print v(xbgr.mr_n57983184)
print v(xbgr.mr_n57983616)
print v(xbgr.mr_n57984048)
print v(xbgr.mr_n57984480)
print v(xbgr.mr_n57984912)
print v(xbgr.mr_n57986208)
print v(xbgr.mr_n57986640)
print v(xbgr.mr_n57987072)
print v(xbgr.mr_n57987504)
print v(xbgr.mr_n57987936)
print v(xbgr.mr_n57988368)
print v(xbgr.mr_n57988800)
print v(xbgr.mr_n57989232)
print v(xbgr.mr_n57989664)
print v(xbgr.mr_n57990096)
print v(xbgr.mr_n57990528)
print v(xbgr.mr_n57990960)
print v(xbgr.mr_n57993120)
print v(xbgr.mr_n57993552)
print v(xbgr.mr_n57993984)
print v(xbgr.mr_n57994416)
print v(xbgr.mr_n57994848)
print v(xbgr.mr_n57995280)
print v(xbgr.mr_n57995712)
print v(xbgr.mr_n57996144)
print v(xbgr.mr_n57996576)
print v(xbgr.mr_n57997008)
print v(xbgr.mr_n57998304)
print v(xbgr.mr_n57998736)
print v(xbgr.mr_n57999168)
print v(xbgr.mr_n57999600)
print v(xbgr.mr_n58000032)
print v(xbgr.mr_n58000464)
print v(xbgr.mr_n58000896)
print v(xbgr.mr_n58001328)
print v(xbgr.mr_n58001760)
print v(xbgr.mr_n58002192)
print v(xbgr.mr_n58002624)
print v(xbgr.mr_n58003056)
print v(xbgr.mr_n58004352)
print v(xbgr.mr_n58004784)
print v(xbgr.mr_n58006080)
print v(xbgr.mr_n58006512)
print v(xbgr.mr_n58006944)
print v(xbgr.mr_n58007376)
print v(xbgr.mr_n58007808)
print v(xbgr.mr_n58008240)
print v(xbgr.mr_n58008672)
print v(xbgr.mr_n58009104)
print v(xbgr.mr_n58010400)
print v(xbgr.mr_n58010832)
print v(xbgr.mr_n58011152)
print v(xbgr.mr_n58011264)
print v(xbgr.mr_n58011584)
print v(xbgr.mr_n58011696)
print v(xbgr.mr_n58012016)
print v(xbgr.mr_n58012128)
print v(xbgr.mr_n58012448)
print v(xbgr.mr_n58012560)
print v(xbgr.mr_n58012880)
print v(xbgr.mr_n58012992)
print v(xbgr.mr_n58013312)
print v(xbgr.mr_n58013424)
print v(xbgr.mr_n58013744)
print v(xbgr.mr_n58013856)
print v(xbgr.mr_n58014176)
print v(xbgr.mr_n58014288)
print v(xbgr.mr_n58014720)
print v(xbgr.mr_n58015152)
print v(xbgr.mr_n58015584)
print v(xbgr.mr_n58016016)
print v(xbgr.mr_n58016448)
print v(xbgr.mr_n58016880)
print v(xbgr.mr_n58017312)
print v(xbgr.mr_n58017744)
print v(xbgr.mr_n58018176)
print v(xbgr.mr_n58018608)
print v(xbgr.mr_n58019040)
print v(xbgr.mr_n58019472)
print v(xbgr.mr_n58019904)
print v(xbgr.mr_n58020336)
print v(xbgr.mr_n58020768)
print v(xbgr.mr_n58021200)
print v(xbgr.mr_n58021632)
print v(xbgr.mr_n58022064)
print v(xbgr.mr_n58022496)
print v(xbgr.mr_n58022928)
print v(xbgr.mr_n58023360)
print v(xbgr.mr_n58023792)
print v(xbgr.mr_n58024224)
print v(xbgr.mr_n58024656)
print v(xbgr.mr_n58025088)
print v(xbgr.mr_n58025520)
print v(xbgr.mr_n58026160)
print v(xbgr.mr_n58026592)
print v(xbgr.mr_n58027024)
print v(xbgr.mr_n58027456)
print v(xbgr.mr_n58027888)
print v(xbgr.mr_n58028320)
print v(xbgr.mr_n58028752)
print v(xbgr.mr_n58029184)
print v(xbgr.mr_n58029616)
print v(xbgr.mr_n58030048)
print v(xbgr.mr_n58030480)
print v(xbgr.mr_n58030912)
print v(xbgr.mr_n58031344)
print v(xbgr.mr_n58031776)
print v(xbgr.mr_n58032208)
print v(xbgr.mr_n58032640)
print v(xbgr.mr_n58033072)
print v(xbgr.mr_n58033504)
print v(xbgr.mr_n58033936)
print v(xbgr.mr_n58034368)
print v(xbgr.mr_n58034800)
print v(xbgr.mr_n58035232)
print v(xbgr.mr_n58035664)
print v(xbgr.mr_n58036096)
print v(xbgr.mr_n58036528)
print v(xbgr.mr_n58036960)
print v(xbgr.mr_n58037392)
print v(xbgr.mr_n58037824)
print v(xbgr.mr_n58038256)
print v(xbgr.mr_n58038688)
print v(xbgr.mr_n58039120)
print v(xbgr.mr_n58039552)
print v(xbgr.mr_n58039984)
print v(xbgr.mr_n58040416)
print v(xbgr.mr_n58040848)
print v(xbgr.mr_n58041280)
print v(xbgr.mr_n58041712)
print v(xbgr.mr_n58042144)
print v(xbgr.mr_n58042576)
print v(xbgr.mr_n58043008)
print v(xbgr.mr_n58043440)
print v(xbgr.mr_n58043872)
print v(xbgr.mr_n58044304)
print v(xbgr.mr_n58044736)
print v(xbgr.mr_n58045168)
print v(xbgr.mr_n58045600)
print v(xbgr.mr_n58046032)
print v(xbgr.mr_n58046464)
print v(xbgr.mr_n58046896)
print v(xbgr.mr_n58047328)
print v(xbgr.mr_n58047760)
print v(xbgr.mr_n58048192)
print v(xbgr.mr_n58048624)
print v(xbgr.mr_n58049056)
print v(xbgr.mr_n58049488)
print v(xbgr.mr_n58049920)
print v(xbgr.mr_n58050352)
print v(xbgr.mr_n58050784)
print v(xbgr.mr_n58051216)
print v(xbgr.mr_n58051648)
print v(xbgr.mr_n58052080)
print v(xbgr.mr_n58052512)
print v(xbgr.mr_n58052944)
print v(xbgr.mr_n58053376)
print v(xbgr.mr_n58053808)
print v(xbgr.mr_n58054240)
print v(xbgr.mr_n58054672)
print v(xbgr.mr_n58055104)
print v(xbgr.mr_n58055536)
print v(xbgr.mr_n58055968)
print v(xbgr.mr_n58056400)
print v(xbgr.mr_n58056832)
print v(xbgr.mr_n58057264)
print v(xbgr.mr_n58057696)
print v(xbgr.mr_n58058128)
print v(xbgr.mr_n58058560)
print v(xbgr.mr_n58058992)
print v(xbgr.mr_n58059424)
print v(xbgr.mr_n58059856)
print v(xbgr.mr_n58060288)
print v(xbgr.mr_n58060720)
print v(xbgr.mr_n58061152)
print v(xbgr.mr_n58061584)
print v(xbgr.mr_n58062016)
print v(xbgr.mr_n58062448)
print v(xbgr.mr_n58062768)
print v(xbgr.mr_n58062880)
print v(xbgr.mr_n58063200)
print v(xbgr.mr_n58063312)
print v(xbgr.mr_n58063632)
print v(xbgr.mr_n58063744)
print v(xbgr.mr_n58064064)
print v(xbgr.mr_n58064176)
print v(xbgr.mr_n58064608)
print v(xbgr.mr_n58065040)
print v(xbgr.mr_n58065472)
print v(xbgr.mr_n58065904)
print v(xbgr.mr_n58066336)
print v(xbgr.mr_n58066768)
print v(xbgr.mr_n58067200)
print v(xbgr.mr_n58067632)
print v(xbgr.mr_n58068064)
print v(xbgr.mr_n58068496)
print v(xbgr.mr_n58068928)
print v(xbgr.mr_n58069360)
print v(xbgr.mr_n58069792)
print v(xbgr.mr_n58070224)
print v(xbgr.mr_n58070656)
print v(xbgr.mr_n58071088)
print v(xbgr.mr_n58071520)
print v(xbgr.mr_n58071952)
print v(xbgr.mr_n58072384)
print v(xbgr.mr_n58072816)
print v(xbgr.mr_n58073248)
print v(xbgr.mr_n58073680)
print v(xbgr.mr_n58074112)
print v(xbgr.mr_n58074544)
print v(xbgr.mr_n58074976)
print v(xbgr.mr_n58075408)
print v(xbgr.mr_n58075840)
print v(xbgr.mr_n58076272)
print v(xbgr.mr_n58076704)
print v(xbgr.mr_n58077136)
print v(xbgr.mr_n58077568)
print v(xbgr.mr_n58078000)
print v(xbgr.mr_n58078432)
print v(xbgr.mr_n58078864)
print v(xbgr.mr_n58079296)
print v(xbgr.mr_n58079728)
print v(xbgr.mr_n58080160)
print v(xbgr.mr_n58080592)
print v(xbgr.mr_n58081024)
print v(xbgr.mr_n58081456)
print v(xbgr.mr_n58081888)
print v(xbgr.mr_n58082320)
print v(xbgr.mr_n58082752)
print v(xbgr.mr_n58083184)
print v(xbgr.mr_n58083616)
print v(xbgr.mr_n58084048)
print v(xbgr.mr_n58084480)
print v(xbgr.mr_n58084912)
print v(xbgr.mr_n58085344)
print v(xbgr.mr_n58085776)
print v(xbgr.mr_n58086208)
print v(xbgr.mr_n58086640)
print v(xbgr.mr_n58087072)
print v(xbgr.mr_n58087504)
print v(xbgr.mr_n58087936)
print v(xbgr.mr_n58088368)
print v(xbgr.mr_n58088800)
print v(xbgr.mr_n58089232)
print v(xbgr.mr_n58089664)
print v(xbgr.mr_n58090096)
print v(xbgr.mr_n58090528)
print v(xbgr.mr_n58090960)
print v(xbgr.mr_n58091392)
print v(xbgr.mr_n58091824)
print v(xbgr.mr_n58093120)
print v(xbgr.mr_n58093552)
print v(xbgr.mr_n58094848)
print v(xbgr.mr_n58095280)
print v(xbgr.mr_n58096576)
print v(xbgr.mr_n58097008)
print v(xbgr.mr_n58097440)
print v(xbgr.mr_n58097872)
print v(xbgr.mr_n58098304)
print v(xbgr.mr_n58098736)
print v(xbgr.mr_n58099168)
print v(xbgr.mr_n58099600)
print v(xbgr.mr_n58100032)
print v(xbgr.mr_n58100464)
print v(xbgr.mr_n58100896)
print v(xbgr.mr_n58101328)
print v(xbgr.mr_n58101760)
print v(xbgr.mr_n58102192)
print v(xbgr.mr_n58102624)
print v(xbgr.mr_n58103056)
print v(xbgr.mr_n58104352)
print v(xbgr.mr_n58104784)
print v(xbgr.mr_n58105216)
print v(xbgr.mr_n58105648)
print v(xbgr.mr_n58106080)
print v(xbgr.mr_n58106512)
print v(xbgr.mr_n58107808)
print v(xbgr.mr_n58108240)
print v(xbgr.mr_n58108672)
print v(xbgr.mr_n58109104)
print v(xbgr.mr_n58109536)
print v(xbgr.mr_n58109968)
print v(xbgr.mr_n58110400)
print v(xbgr.mr_n58110832)
print v(xbgr.mr_n58111264)
print v(xbgr.mr_n58111696)
print v(xbgr.mr_n58112128)
print v(xbgr.mr_n58112560)
print v(xbgr.mr_n58112992)
print v(xbgr.mr_n58113424)
print v(xbgr.mr_n58113856)
print v(xbgr.mr_n58114288)
print v(xbgr.mr_n58114720)
print v(xbgr.mr_n58115152)
print v(xbgr.mr_n58115584)
print v(xbgr.mr_n58116016)
print v(xbgr.mr_n58116448)
print v(xbgr.mr_n58116880)
print v(xbgr.mr_n58117312)
print v(xbgr.mr_n58117744)
print v(xbgr.mr_n58118176)
print v(xbgr.mr_n58118608)
print v(xbgr.mr_n58119040)
print v(xbgr.mr_n58119472)
print v(xbgr.mr_n58119904)
print v(xbgr.mr_n58120336)
print v(xbgr.mr_n58120768)
print v(xbgr.mr_n58121200)
print v(xbgr.mr_n58121632)
print v(xbgr.mr_n58122064)
print v(xbgr.mr_n58122496)
print v(xbgr.mr_n58122928)
print v(xbgr.mr_n58123360)
print v(xbgr.mr_n58123792)
print v(xbgr.mr_n58124224)
print v(xbgr.mr_n58124656)
print v(xbgr.mr_n58125088)
print v(xbgr.mr_n58125520)
print v(xbgr.mr_n58125952)
print v(xbgr.mr_n58126384)
print v(xbgr.mr_n58126816)
print v(xbgr.mr_n58127248)
print v(xbgr.mr_n58127680)
print v(xbgr.mr_n58128112)
print v(xbgr.mr_n58128544)
print v(xbgr.mr_n58128976)
print v(xbgr.mr_n58129408)
print v(xbgr.mr_n58129840)
print v(xbgr.mr_n58130272)
print v(xbgr.mr_n58130704)
print v(xbgr.mr_n58131136)
print v(xbgr.mr_n58131568)
print v(xbgr.mr_n58132000)
print v(xbgr.mr_n58132320)
print v(xbgr.mr_n58132432)
print v(xbgr.mr_n58132752)
print v(xbgr.mr_n58132864)
print v(xbgr.mr_n58133184)
print v(xbgr.mr_n58133296)
print v(xbgr.mr_n58133616)
print v(xbgr.mr_n58133728)
print v(xbgr.mr_n58134048)
print v(xbgr.mr_n58134160)
print v(xbgr.mr_n58134480)
print v(xbgr.mr_n58134592)
print v(xbgr.mr_n58134912)
print v(xbgr.mr_n58135024)
print v(xbgr.mr_n58135344)
print v(xbgr.mr_n58135456)
print v(xbgr.mr_n58135776)
print v(xbgr.mr_n58135888)
print v(xbgr.mr_n58136208)
print v(xbgr.mr_n58136320)
print v(xbgr.mr_n58136640)
print v(xbgr.mr_n58136752)
print v(xbgr.mr_n58137072)
print v(xbgr.mr_n58137184)
print v(xbgr.mr_n58137504)
print v(xbgr.mr_n58137616)
print v(xbgr.mr_n58137936)
print v(xbgr.mr_n58138048)
print v(xbgr.mr_n58138368)
print v(xbgr.mr_n58138480)
print v(xbgr.mr_n58138800)
print v(xbgr.mr_n58138912)
print v(xbgr.mr_n58139232)
print v(xbgr.mr_n58139344)
print v(xbgr.mr_n58139664)
print v(xbgr.mr_n58139776)
print v(xbgr.mr_n58140096)
print v(xbgr.mr_n58140208)
print v(xbgr.mr_n58140528)
print v(xbgr.mr_n58140640)
print v(xbgr.mr_n58140960)
print v(xbgr.mr_n58141072)
print v(xbgr.mr_n58141392)
print v(xbgr.mr_n58141504)
print v(xbgr.mr_n58141824)
print v(xbgr.mr_n58141936)
print v(xbgr.mr_n58142256)
print v(xbgr.mr_n58142368)
print v(xbgr.mr_n58142688)
print v(xbgr.mr_n58142800)
print v(xbgr.mr_n58143120)
print v(xbgr.mr_n58143232)
print v(xbgr.mr_n58143552)
print v(xbgr.mr_n58143664)
print v(xbgr.mr_n58143984)
print v(xbgr.mr_n58144096)
print v(xbgr.mr_n58144416)
print v(xbgr.mr_n58144528)
print v(xbgr.mr_n58144848)
print v(xbgr.mr_n58144960)
print v(xbgr.mr_n58145280)
print v(xbgr.mr_n58145392)
print v(xbgr.mr_n58145712)
print v(xbgr.mr_n58145824)
print v(xbgr.mr_n58146144)
print v(xbgr.mr_n58146256)
print v(xbgr.mr_n58146576)
print v(xbgr.mr_n58146688)
print v(xbgr.mr_n58147008)
print v(xbgr.mr_n58147120)
print v(xbgr.mr_n58147440)
print v(xbgr.mr_n58147552)
print v(xbgr.mr_n58147872)
print v(xbgr.mr_n58147984)
print v(xbgr.mr_n58148304)
print v(xbgr.mr_n58148416)
print v(xbgr.mr_n58148832)
print v(xbgr.mr_n58149264)
print v(xbgr.mr_n58149696)
print v(xbgr.mr_n58150128)
print v(xbgr.mr_n58150560)
print v(xbgr.mr_n58150992)
print v(xbgr.mr_n58151424)
print v(xbgr.mr_n58151856)
print v(xbgr.mr_n58152288)
print v(xbgr.mr_n58152720)
print v(xbgr.mr_n58153152)
print v(xbgr.mr_n58153584)
print v(xbgr.mr_n58153904)
print v(xbgr.mr_n58154016)
print v(xbgr.mr_n58154336)
print v(xbgr.mr_n58154448)
print v(xbgr.mr_n58154880)
print v(xbgr.mr_n58155312)
print v(xbgr.mr_n58155744)
print v(xbgr.mr_n58156176)
print v(xbgr.mr_n58156608)
print v(xbgr.mr_n58157040)
print v(xbgr.mr_n58157472)
print v(xbgr.mr_n58157904)
print v(xbgr.mr_n58158336)
print v(xbgr.mr_n58158768)
print v(xbgr.mr_n58159200)
print v(xbgr.mr_n58159632)
print v(xbgr.mr_n58160064)
print v(xbgr.mr_n58160496)
print v(xbgr.mr_n58160928)
print v(xbgr.mr_n58161360)
print v(xbgr.mr_n58161792)
print v(xbgr.mr_n58162224)
print v(xbgr.mr_n58162656)
print v(xbgr.mr_n58163088)
print v(xbgr.mr_n58163520)
print v(xbgr.mr_n58163952)
print v(xbgr.mr_n58164384)
print v(xbgr.mr_n58164816)
print v(xbgr.mr_n58165248)
print v(xbgr.mr_n58165680)
print v(xbgr.mr_n58166112)
print v(xbgr.mr_n58166544)
print v(xbgr.mr_n58166976)
print v(xbgr.mr_n58167408)
print v(xbgr.mr_n58167840)
print v(xbgr.mr_n58168272)
print v(xbgr.mr_n58168704)
print v(xbgr.mr_n58169136)
print v(xbgr.mr_n58169568)
print v(xbgr.mr_n58170000)
print v(xbgr.mr_n58170432)
print v(xbgr.mr_n58170864)
print v(xbgr.mr_n58171296)
print v(xbgr.mr_n58171728)
print v(xbgr.mr_n58172048)
print v(xbgr.mr_n58172160)
print v(xbgr.mr_n58172480)
print v(xbgr.mr_n58172592)
print v(xbgr.mr_n58173024)
print v(xbgr.mr_n58173344)
print v(xbgr.mr_n58173456)
print v(xbgr.mr_n58173888)
print v(xbgr.mr_n58174320)
print v(xbgr.mr_n58174752)
print v(xbgr.mr_n58175184)
print v(xbgr.mr_n58175616)
print v(xbgr.mr_n58176048)
print v(xbgr.mr_n58176480)
print v(xbgr.mr_n58176912)
print v(xbgr.mr_n58177344)
print v(xbgr.mr_n58177776)
print v(xbgr.mr_n58178208)
print v(xbgr.mr_n58178640)
print v(xbgr.mr_n58179072)
print v(xbgr.mr_n58179504)
print v(xbgr.mr_n58179936)
print v(xbgr.mr_n58180368)
print v(xbgr.mr_n58180800)
print v(xbgr.mr_n58181232)
print v(xbgr.mr_n58181664)
print v(xbgr.mr_n58182096)
print v(xbgr.mr_n58182528)
print v(xbgr.mr_n58182960)
print v(xbgr.mr_n58183392)
print v(xbgr.mr_n58183824)
print v(xbgr.mr_n58184256)
print v(xbgr.mr_n58184688)
print v(xbgr.mr_n58185120)
print v(xbgr.mr_n58185552)
print v(xbgr.mr_n58185984)
print v(xbgr.mr_n58186416)
print v(xbgr.mr_n58186848)
print v(xbgr.mr_n58187280)
print v(xbgr.mr_n58187712)
print v(xbgr.mr_n58188144)
print v(xbgr.mr_n58188576)
print v(xbgr.mr_n58189008)
print v(xbgr.mr_n58189440)
print v(xbgr.mr_n58189872)
print v(xbgr.mr_n58190304)
print v(xbgr.mr_n58190736)
print v(xbgr.mr_n58191168)
print v(xbgr.mr_n58191600)
print v(xbgr.mr_n58192032)
print v(xbgr.mr_n58192464)
print v(xbgr.mr_n58192896)
print v(xbgr.mr_n58193328)
print v(xbgr.mr_n58193760)
print v(xbgr.mr_n58194080)
print v(xbgr.mr_n58194192)
print v(xbgr.mr_n58194624)
print v(xbgr.mr_n58195056)
print v(xbgr.mr_n58195376)
print v(xbgr.mr_n58195488)
print v(xbgr.mr_n58195808)
print v(xbgr.mr_n58195920)
print v(xbgr.mr_n58196240)
print v(xbgr.mr_n58196352)
print v(xbgr.mr_n58196672)
print v(xbgr.mr_n58196784)
print v(xbgr.mr_n58197104)
print v(xbgr.mr_n58197216)
print v(xbgr.mr_n58197536)
print v(xbgr.mr_n58197648)
print v(xbgr.mr_n58198080)
print v(xbgr.mr_n58198400)
print v(xbgr.mr_n58198512)
print v(xbgr.mr_n58198832)
print v(xbgr.mr_n58198944)
print v(xbgr.mr_n58199264)
print v(xbgr.mr_n58199376)
print v(xbgr.mr_n58199696)
print v(xbgr.mr_n58199808)
print v(xbgr.mr_n58200128)
print v(xbgr.mr_n58200240)
print v(xbgr.mr_n58200560)
print v(xbgr.mr_n58200672)
print v(xbgr.mr_n58201104)
print v(xbgr.mr_n58201424)
print v(xbgr.mr_n58201536)
print v(xbgr.mr_n58201856)
print v(xbgr.mr_n58201968)
print v(xbgr.mr_n58202288)
print v(xbgr.mr_n58202400)
print v(xbgr.mr_n58202720)
print v(xbgr.mr_n58202832)
print v(xbgr.mr_n58203152)
print v(xbgr.mr_n58203264)
print v(xbgr.mr_n58203584)
print v(xbgr.mr_n58203696)
print v(xbgr.mr_n58204128)
print v(xbgr.mr_n58204448)
print v(xbgr.mr_n58204560)
print v(xbgr.mr_n58204880)
print v(xbgr.mr_n58204992)
print v(xbgr.mr_n58205312)
print v(xbgr.mr_n58205424)
print v(xbgr.mr_n58205856)
print v(xbgr.mr_n58206176)
print v(xbgr.mr_n58206288)
print v(xbgr.mr_n58206720)
print v(xbgr.mr_n58207152)
print v(xbgr.mr_n58207584)
print v(xbgr.mr_n58208016)
print v(xbgr.mr_n58209312)
print v(xbgr.mr_n58209744)
print v(xbgr.mr_n58211040)
print v(xbgr.mr_n58211472)
print v(xbgr.mr_n58211792)
print v(xbgr.mr_n58211904)
print v(xbgr.mr_n58212224)
print v(xbgr.mr_n58212336)
print v(xbgr.mr_n58212656)
print v(xbgr.mr_n58212768)
print v(xbgr.mr_n58213088)
print v(xbgr.mr_n58213632)
print v(xbgr.mr_n58214384)
print v(xbgr.mr_n58214496)
print v(xbgr.mr_n58214816)
print v(xbgr.mr_n58217088)
print v(xbgr.mr_n58217952)
print v(xbgr.mr_n58218816)
print v(xbgr.mr_n58219248)
print v(xbgr.mr_n58219680)
print v(xbgr.mr_n58220112)
print v(xbgr.mr_n58222160)
print v(xbgr.mr_n58222272)
print v(xbgr.mr_n58222704)
print v(xbgr.mr_n58223024)
print v(xbgr.mr_n58223136)
print v(xbgr.mr_n58223456)
print v(xbgr.mr_n58223568)
print v(xbgr.mr_n58224000)
print v(xbgr.mr_n58224320)
print v(xbgr.mr_n58224432)
print v(xbgr.mr_n58224752)
print v(xbgr.mr_n58224864)
print v(xbgr.mr_n58225184)
print v(xbgr.mr_n58225296)
print v(xbgr.mr_n58225728)
print v(xbgr.mr_n58226048)
print v(xbgr.mr_n58226160)
print v(xbgr.mr_n58226480)
print v(xbgr.mr_n58226592)
print v(xbgr.mr_n58226912)
print v(xbgr.mr_n58227024)
print v(xbgr.mr_n58227456)
print v(xbgr.mr_n58227776)
print v(xbgr.mr_n58227888)
print v(xbgr.mr_n58228208)
print v(xbgr.mr_n58228320)
print v(xbgr.mr_n58228640)
print v(xbgr.mr_n58228752)
print v(xbgr.mr_n58229072)
print v(xbgr.mr_n58229184)
print v(xbgr.mr_n58229504)
print v(xbgr.mr_n58229616)
print v(xbgr.mr_n58230048)
print v(xbgr.mr_n58230368)
print v(xbgr.mr_n58230480)
print v(xbgr.mr_n58230800)
print v(xbgr.mr_n58230912)
print v(xbgr.mr_n58231232)
print v(xbgr.mr_n58231344)
print v(xbgr.mr_n58231664)
print v(xbgr.mr_n58231776)
print v(xbgr.mr_n58232208)
print v(xbgr.mr_n58232528)
print v(xbgr.mr_n58232640)
print v(xbgr.mr_n58232960)
print v(xbgr.mr_n58233072)
print v(xbgr.mr_n58233504)
print v(xbgr.mr_n58233824)
print v(xbgr.mr_n58233936)
print v(xbgr.mr_n58234256)
print v(xbgr.mr_n58234368)
print v(xbgr.mr_n58234688)
print v(xbgr.mr_n58234800)
print v(xbgr.mr_n58235232)
print v(xbgr.mr_n58235552)
print v(xbgr.mr_n58235664)
print v(xbgr.mr_n58235984)
print v(xbgr.mr_n58236096)
print v(xbgr.mr_n58236416)
print v(xbgr.mr_n58236528)
print v(xbgr.mr_n58236960)
print v(xbgr.mr_n58237280)
print v(xbgr.mr_n58237392)
print v(xbgr.mr_n58237712)
print v(xbgr.mr_n58237824)
print v(xbgr.mr_n58238144)
print v(xbgr.mr_n58238256)
print v(xbgr.mr_n58238576)
print v(xbgr.mr_n58238688)
print v(xbgr.mr_n58239008)
print v(xbgr.mr_n58239120)
print v(xbgr.mr_n58239440)
print v(xbgr.mr_n58239552)
print v(xbgr.mr_n58239872)
print v(xbgr.mr_n58239984)
print v(xbgr.mr_n58240304)
print v(xbgr.mr_n58240416)
print v(xbgr.mr_n58240736)
print v(xbgr.mr_n58240848)
print v(xbgr.mr_n58241168)
print v(xbgr.mr_n58241280)
print v(xbgr.mr_n58241600)
print v(xbgr.mr_n58241712)
print v(xbgr.mr_n58242032)
print v(xbgr.mr_n58242144)
print v(xbgr.mr_n58242464)
print v(xbgr.mr_n58242576)
print v(xbgr.mr_n58243008)
print v(xbgr.mr_n58243328)
print v(xbgr.mr_n58243440)
print v(xbgr.mr_n58243760)
print v(xbgr.mr_n58243872)
print v(xbgr.mr_n58244192)
print v(xbgr.mr_n58244304)
print v(xbgr.mr_n58244624)
print v(xbgr.mr_n58244736)
print v(xbgr.mr_n58245056)
print v(xbgr.mr_n58245168)
print v(xbgr.mr_n58245488)
print v(xbgr.mr_n58245600)
print v(xbgr.mr_n58245920)
print v(xbgr.mr_n58246032)
print v(xbgr.mr_n58246352)
print v(xbgr.mr_n58246464)
print v(xbgr.mr_n58246784)
print v(xbgr.mr_n58246896)
print v(xbgr.mr_n58247216)
print v(xbgr.mr_n58247328)
print v(xbgr.mr_n58247760)
print v(xbgr.mr_n58248080)
print v(xbgr.mr_n58248192)
print v(xbgr.mr_n58248512)
print v(xbgr.mr_n58248624)
print v(xbgr.mr_n58248944)
print v(xbgr.mr_n58249056)
print v(xbgr.mr_n58249376)
print v(xbgr.mr_n58249488)
print v(xbgr.mr_n58249808)
print v(xbgr.mr_n58249920)
print v(xbgr.mr_n58250240)
print v(xbgr.mr_n58250352)
print v(xbgr.mr_n58250672)
print v(xbgr.mr_n58250784)
print v(xbgr.mr_n58251104)
print v(xbgr.mr_n58251216)
print v(xbgr.mr_n58251536)
print v(xbgr.mr_n58251648)
print v(xbgr.mr_n58251968)
print v(xbgr.mr_n58252080)
print v(xbgr.mr_n58252400)
print v(xbgr.mr_n58252512)
print v(xbgr.mr_n58252832)
print v(xbgr.mr_n58252944)
print v(xbgr.mr_n58253264)
print v(xbgr.mr_n58253376)
print v(xbgr.mr_n58253696)
print v(xbgr.mr_n58253808)
print v(xbgr.mr_n58254128)
print v(xbgr.mr_n58254240)
print v(xbgr.mr_n58254560)
print v(xbgr.mr_n58254672)
print v(xbgr.mr_n58255104)
print v(xbgr.mr_n58255424)
print v(xbgr.mr_n58255536)
print v(xbgr.mr_n58255856)
print v(xbgr.mr_n58255968)
print v(xbgr.mr_n58256288)
print v(xbgr.mr_n58256400)
print v(xbgr.mr_n58256720)
print v(xbgr.mr_n58256832)
print v(xbgr.mr_n58257152)
print v(xbgr.mr_n58257264)
print v(xbgr.mr_n58257584)
print v(xbgr.mr_n58257696)
print v(xbgr.mr_n58258016)
print v(xbgr.mr_n58258128)
print v(xbgr.mr_n58258448)
print v(xbgr.mr_n58258560)
print v(xbgr.mr_n58258880)
print v(xbgr.mr_n58258992)
print v(xbgr.mr_n58259312)
print v(xbgr.mr_n58259424)
print v(xbgr.mr_n58259744)
print v(xbgr.mr_n58259856)
print v(xbgr.mr_n58260176)
print v(xbgr.mr_n58260288)
print v(xbgr.mr_n58260720)
print v(xbgr.mr_n58261040)
print v(xbgr.mr_n58261152)
print v(xbgr.mr_n58261472)
print v(xbgr.mr_n58261584)
print v(xbgr.mr_n58261904)
print v(xbgr.mr_n58262016)
print v(xbgr.mr_n58262336)
print v(xbgr.mr_n58262448)
print v(xbgr.mr_n58262768)
print v(xbgr.mr_n58262880)
print v(xbgr.mr_n58263200)
print v(xbgr.mr_n58263312)
print v(xbgr.mr_n58263632)
print v(xbgr.mr_n58263744)
print v(xbgr.mr_n58264064)
print v(xbgr.mr_n58264176)
print v(xbgr.mr_n58264496)
print v(xbgr.mr_n58264608)
print v(xbgr.mr_n58264928)
print v(xbgr.mr_n58265040)
print v(xbgr.mr_n58265360)
print v(xbgr.mr_n58265472)
print v(xbgr.mr_n58265792)
print v(xbgr.mr_n58265904)
print v(xbgr.mr_n58266224)
print v(xbgr.mr_n58266336)
print v(xbgr.mr_n58266656)
print v(xbgr.mr_n58266768)
print v(xbgr.mr_n58267088)
print v(xbgr.mr_n58267200)
print v(xbgr.mr_n58267520)
print v(xbgr.mr_n58267632)
print v(xbgr.mr_n58267952)
print v(xbgr.mr_n58268064)
print v(xbgr.mr_n58268384)
print v(xbgr.mr_n58268496)
print v(xbgr.mr_n58268816)
print v(xbgr.mr_n58268928)
print v(xbgr.mr_n58269248)
print v(xbgr.mr_n58269360)
print v(xbgr.mr_n58269792)
print v(xbgr.mr_n58270112)
print v(xbgr.mr_n58270224)
print v(xbgr.mr_n58270544)
print v(xbgr.mr_n58270656)
print v(xbgr.mr_n58270976)
print v(xbgr.mr_n58271088)
print v(xbgr.mr_n58271408)
print v(xbgr.mr_n58271520)
print v(xbgr.mr_n58271840)
print v(xbgr.mr_n58271952)
print v(xbgr.mr_n58272272)
print v(xbgr.mr_n58272384)
print v(xbgr.mr_n58272704)
print v(xbgr.mr_n58272816)
print v(xbgr.mr_n58273136)
print v(xbgr.mr_n58273248)
print v(xbgr.mr_n58273568)
print v(xbgr.mr_n58273680)
print v(xbgr.mr_n58274000)
print v(xbgr.mr_n58274112)
print v(xbgr.mr_n58274432)
print v(xbgr.mr_n58274544)
print v(xbgr.mr_n58274864)
print v(xbgr.mr_n58274976)
print v(xbgr.mr_n58275296)
print v(xbgr.mr_n58275408)
print v(xbgr.mr_n58275728)
print v(xbgr.mr_n58275840)
print v(xbgr.mr_n58276160)
print v(xbgr.mr_n58276272)
print v(xbgr.mr_n58276592)
print v(xbgr.mr_n58276704)
print v(xbgr.mr_n58277024)
print v(xbgr.mr_n58277136)
print v(xbgr.mr_n58277456)
print v(xbgr.mr_n58277568)
print v(xbgr.mr_n58277888)
print v(xbgr.mr_n58278000)
print v(xbgr.mr_n58278320)
print v(xbgr.mr_n58278432)
print v(xbgr.mr_n58278752)
print v(xbgr.mr_n58278864)
print v(xbgr.mr_n58279184)
print v(xbgr.mr_n58279296)
print v(xbgr.mr_n58279728)
print v(xbgr.mr_n58280048)
print v(xbgr.mr_n58280160)
print v(xbgr.mr_n58280480)
print v(xbgr.mr_n58280592)
print v(xbgr.mr_n58280912)
print v(xbgr.mr_n58281024)
print v(xbgr.mr_n58281344)
print v(xbgr.mr_n58281456)
print v(xbgr.mr_n58281776)
print v(xbgr.mr_n58281888)
print v(xbgr.mr_n58282208)
print v(xbgr.mr_n58282320)
print v(xbgr.mr_n58282640)
print v(xbgr.mr_n58282752)
print v(xbgr.mr_n58283072)
print v(xbgr.mr_n58283184)
print v(xbgr.mr_n58283504)
print v(xbgr.mr_n58283616)
print v(xbgr.mr_n58283936)
print v(xbgr.mr_n58284048)
print v(xbgr.mr_n58284368)
print v(xbgr.mr_n58284480)
print v(xbgr.mr_n58284800)
print v(xbgr.mr_n58284912)
print v(xbgr.mr_n58285344)
print v(xbgr.mr_n58285776)
print v(xbgr.mr_n58286208)
print v(xbgr.mr_n58286640)
print v(xbgr.mr_n58287072)
print v(xbgr.mr_n58287504)
print v(xbgr.mr_n58287936)
print v(xbgr.mr_n58288368)
print v(xbgr.mr_n58288800)
print v(xbgr.mr_n58289232)
print v(xbgr.mr_n58289664)
print v(xbgr.mr_n58290096)
print v(xbgr.mr_n58290528)
print v(xbgr.mr_n58290960)
print v(xbgr.mr_n58291392)
print v(xbgr.mr_n58291824)
print v(xbgr.mr_n58292256)
print v(xbgr.mr_n58292688)
print v(xbgr.mr_n58293120)
print v(xbgr.mr_n58293552)
print v(xbgr.mr_n58293984)
print v(xbgr.mr_n58294416)
print v(xbgr.mr_n58294848)
print v(xbgr.mr_n58295280)
print v(xbgr.mr_n58295712)
print v(xbgr.mr_n58296144)
print v(xbgr.mr_n58296576)
print v(xbgr.mr_n58297008)
print v(xbgr.mr_n58297440)
print v(xbgr.mr_n58297872)
print v(xbgr.mr_n58298304)
print v(xbgr.mr_n58298736)
print v(xbgr.mr_n58299168)
print v(xbgr.mr_n58299600)
print v(xbgr.mr_n58300032)
print v(xbgr.mr_n58300464)
print v(xbgr.mr_n58300896)
print v(xbgr.mr_n58301328)
print v(xbgr.mr_n58301760)
print v(xbgr.mr_n58302192)
print v(xbgr.mr_n58302624)
print v(xbgr.mr_n58303056)
print v(xbgr.mr_n58303488)
print v(xbgr.mr_n58303920)
print v(xbgr.mr_n58304352)
print v(xbgr.mr_n58304784)
print v(xbgr.mr_n58305216)
print v(xbgr.mr_n58305648)
print v(xbgr.mr_n58306080)
print v(xbgr.mr_n58306512)
print v(xbgr.mr_n58306944)
print v(xbgr.mr_n58307376)
print v(xbgr.mr_n58307808)
print v(xbgr.mr_n58308240)
print v(xbgr.mr_n58308672)
print v(xbgr.mr_n58309104)
print v(xbgr.mr_n58309536)
print v(xbgr.mr_n58309968)
print v(xbgr.mr_n58310400)
print v(xbgr.mr_n58310832)
print v(xbgr.mr_n58311264)
print v(xbgr.mr_n58311696)
print v(xbgr.mr_n58312128)
print v(xbgr.mr_n58312560)
print v(xbgr.mr_n58312992)
print v(xbgr.mr_n58313424)
print v(xbgr.mr_n58313856)
print v(xbgr.mr_n58314288)
print v(xbgr.mr_n58314720)
print v(xbgr.mr_n58315152)
print v(xbgr.mr_n58315584)
print v(xbgr.mr_n58316016)
print v(xbgr.mr_n58316448)
print v(xbgr.mr_n58316880)
print v(xbgr.mr_n58317312)
print v(xbgr.mr_n58317744)
print v(xbgr.mr_n58318176)
print v(xbgr.mr_n58318608)
print v(xbgr.mr_n58319040)
print v(xbgr.mr_n58319472)
print v(xbgr.mr_n58319904)
print v(xbgr.mr_n58320336)
print v(xbgr.mr_n58320768)
print v(xbgr.mr_n58321200)
print v(xbgr.mr_n58321632)
print v(xbgr.mr_n58322064)
print v(xbgr.mr_n58322496)
print v(xbgr.mr_n58322928)
print v(xbgr.mr_n58323360)
print v(xbgr.mr_n58323792)
print v(xbgr.mr_n58324224)
print v(xbgr.mr_n58324656)
print v(xbgr.mr_n58325088)
print v(xbgr.mr_n58325520)
print v(xbgr.mr_n58325952)
print v(xbgr.mr_n58326384)
print v(xbgr.mr_n58326816)
print v(xbgr.mr_n58327248)
print v(xbgr.mr_n58327680)
print v(xbgr.mr_n58328112)
print v(xbgr.mr_n58328544)
print v(xbgr.mr_n58328976)
print v(xbgr.mr_n58329408)
print v(xbgr.mr_n58329840)
print v(xbgr.mr_n58330272)
print v(xbgr.mr_n58330704)
print v(xbgr.mr_n58331136)
print v(xbgr.mr_n58331568)
print v(xbgr.mr_n58332000)
print v(xbgr.mr_n58332432)
print v(xbgr.mr_n58332752)
print v(xbgr.mr_n58332864)
print v(xbgr.mr_n58333184)
print v(xbgr.mr_n58333296)
print v(xbgr.mr_n58333616)
print v(xbgr.mr_n58333728)
print v(xbgr.mr_n58334048)
print v(xbgr.mr_n58334160)
print v(xbgr.mr_n58334480)
print v(xbgr.mr_n58334592)
print v(xbgr.mr_n58334912)
print v(xbgr.mr_n58335024)
print v(xbgr.mr_n58335344)
print v(xbgr.mr_n58335456)
print v(xbgr.mr_n58335776)
print v(xbgr.mr_n58335888)
print v(xbgr.mr_n58336208)
print v(xbgr.mr_n58336320)
print v(xbgr.mr_n58336640)
print v(xbgr.mr_n58336752)
print v(xbgr.mr_n58337072)
print v(xbgr.mr_n58337184)
print v(xbgr.mr_n58337504)
print v(xbgr.mr_n58337616)
print v(xbgr.mr_n58337936)
print v(xbgr.mr_n58338048)
print v(xbgr.mr_n58338368)
print v(xbgr.mr_n58338480)
print v(xbgr.mr_n58338800)
print v(xbgr.mr_n58338912)
print v(xbgr.mr_n58339232)
print v(xbgr.mr_n58339344)
print v(xbgr.mr_n58339664)
print v(xbgr.mr_n58339776)
print v(xbgr.mr_n58340096)
print v(xbgr.mr_n58340208)
print v(xbgr.mr_n58340528)
print v(xbgr.mr_n58340640)
print v(xbgr.mr_n58340960)
print v(xbgr.mr_n58341072)
print v(xbgr.mr_n58341392)
print v(xbgr.mr_n58341504)
print v(xbgr.mr_n58341824)
print v(xbgr.mr_n58341936)
print v(xbgr.mr_n58342256)
print v(xbgr.mr_n58342368)
print v(xbgr.mr_n58342688)
print v(xbgr.mr_n58342800)
print v(xbgr.mr_n58343120)
print v(xbgr.mr_n58343232)
print v(xbgr.mr_n58343552)
print v(xbgr.mr_n58343664)
print v(xbgr.mr_n58343984)
print v(xbgr.mr_n58344096)
print v(xbgr.mr_n58344416)
print v(xbgr.mr_n58344528)
print v(xbgr.mr_n58344848)
print v(xbgr.mr_n58344960)
print v(xbgr.mr_n58345280)
print v(xbgr.mr_n58345392)
print v(xbgr.mr_n58345712)
print v(xbgr.mr_n58345824)
print v(xbgr.mr_n58346144)
print v(xbgr.mr_n58346256)
print v(xbgr.mr_n58346576)
print v(xbgr.mr_n58346688)
print v(xbgr.mr_n58347008)
print v(xbgr.mr_n58347120)
print v(xbgr.mr_n58347440)
print v(xbgr.mr_n58347552)
print v(xbgr.mr_n58347872)
print v(xbgr.mr_n58347984)
print v(xbgr.mr_n58348304)
print v(xbgr.mr_n58348416)
print v(xbgr.mr_n58348736)
print v(xbgr.mr_n58348848)
print v(xbgr.mr_n58349168)
print v(xbgr.mr_n58349280)
print v(xbgr.mr_n58349600)
print v(xbgr.mr_n58349712)
print v(xbgr.mr_n58350032)
print v(xbgr.mr_n58350144)
print v(xbgr.mr_n58350464)
print v(xbgr.mr_n58350576)
print v(xbgr.mr_n58350896)
print v(xbgr.mr_n58351008)
print v(xbgr.mr_n58351328)
print v(xbgr.mr_n58351440)
print v(xbgr.mr_n58351760)
print v(xbgr.mr_n58351872)
print v(xbgr.mr_n58352192)
print v(xbgr.mr_n58352304)
print v(xbgr.mr_n58352624)
print v(xbgr.mr_n58352736)
print v(xbgr.mr_n58353056)
print v(xbgr.mr_n58353168)
print v(xbgr.mr_n58353488)
print v(xbgr.mr_n58353600)
print v(xbgr.mr_n58353920)
print v(xbgr.mr_n58354032)
print v(xbgr.mr_n58354464)
print v(xbgr.mr_n58354784)
print v(xbgr.mr_n58354896)
print v(xbgr.mr_n58355216)
print v(xbgr.mr_n58355328)
print v(xbgr.mr_n58355648)
print v(xbgr.mr_n58355760)
print v(xbgr.mr_n58356080)
print v(xbgr.mr_n58356192)
print v(xbgr.mr_n58356512)
print v(xbgr.mr_n58356624)
print v(xbgr.mr_n58356944)
print v(xbgr.mr_n58357056)
print v(xbgr.mr_n58357376)
print v(xbgr.mr_n58357488)
print v(xbgr.mr_n58357808)
print v(xbgr.mr_n58357920)
print v(xbgr.mr_n58358240)
print v(xbgr.mr_n58358352)
print v(xbgr.mr_n58358672)
print v(xbgr.mr_n58358784)
print v(xbgr.mr_n58359104)
print v(xbgr.mr_n58359216)
print v(xbgr.mr_n58359536)
print v(xbgr.mr_n58359648)
print v(xbgr.mr_n58359968)
print v(xbgr.mr_n58360080)
print v(xbgr.mr_n58360400)
print v(xbgr.mr_n58360512)
print v(xbgr.mr_n58360832)
print v(xbgr.mr_n58360944)
print v(xbgr.mr_n58361264)
print v(xbgr.mr_n58361376)
print v(xbgr.mr_n58361824)
print v(xbgr.mr_n58361936)
print v(xbgr.mr_n58362256)
print v(xbgr.mr_n58362368)
print v(xbgr.mr_n58362688)
print v(xbgr.mr_n58362800)
print v(xbgr.mr_n58363120)
print v(xbgr.mr_n58363232)
print v(xbgr.mr_n58363552)
print v(xbgr.mr_n58363664)
print v(xbgr.mr_n58363984)
print v(xbgr.mr_n58364096)
print v(xbgr.mr_n58364416)
print v(xbgr.mr_n58364528)
print v(xbgr.mr_n58364848)
print v(xbgr.mr_n58364960)
print v(xbgr.mr_n58365280)
print v(xbgr.mr_n58365392)
print v(xbgr.mr_n58365712)
print v(xbgr.mr_n58365824)
print v(xbgr.mr_n58366144)
print v(xbgr.mr_n58366256)
print v(xbgr.mr_n58366576)
print v(xbgr.mr_n58366688)
print v(xbgr.mr_n58367008)
print v(xbgr.mr_n58367120)
print v(xbgr.mr_n58367440)
print v(xbgr.mr_n58367552)
print v(xbgr.mr_n58367872)
print v(xbgr.mr_n58367984)
print v(xbgr.mr_n58368304)
print v(xbgr.mr_n58368416)
print v(xbgr.mr_n58368848)
print v(xbgr.mr_n58369280)
print v(xbgr.mr_n58369600)
print v(xbgr.mr_n58369712)
print v(xbgr.mr_n58370032)
print v(xbgr.mr_n58370144)
print v(xbgr.mr_n58370464)
print v(xbgr.mr_n58370576)
print v(xbgr.mr_n58370896)
print v(xbgr.mr_n58371008)
print v(xbgr.mr_n58371328)
print v(xbgr.mr_n58371440)
print v(xbgr.mr_n58371760)
print v(xbgr.mr_n58371872)
print v(xbgr.mr_n58372304)
print v(xbgr.mr_n58372624)
print v(xbgr.mr_n58372736)
print v(xbgr.mr_n58373056)
print v(xbgr.mr_n58373168)
print v(xbgr.mr_n58373488)
print v(xbgr.mr_n58373600)
print v(xbgr.mr_n58373920)
print v(xbgr.mr_n58374032)
print v(xbgr.mr_n58374352)
print v(xbgr.mr_n58374464)
print v(xbgr.mr_n58374784)
print v(xbgr.mr_n58374896)
print v(xbgr.mr_n58375216)
print v(xbgr.mr_n58375328)
print v(xbgr.mr_n58375648)
print v(xbgr.mr_n58375760)
print v(xbgr.mr_n58376080)
print v(xbgr.mr_n58376192)
print v(xbgr.mr_n58376512)
print v(xbgr.mr_n58376624)
print v(xbgr.mr_n58376944)
print v(xbgr.mr_n58377056)
print v(xbgr.mr_n58377376)
print v(xbgr.mr_n58377488)
print v(xbgr.mr_n58377920)
print v(xbgr.mr_n58378352)
print v(xbgr.mr_n58378784)
print v(xbgr.mr_n58379216)
print v(xbgr.mr_n58379712)
print v(xbgr.mr_n58379824)
print v(xbgr.mr_n58380160)
print v(xbgr.mr_n58380272)
print v(xbgr.mr_n58380592)
print v(xbgr.mr_n58380704)
print v(xbgr.mr_n58381072)
print v(xbgr.mr_n58381184)
print v(xbgr.mr_n58381504)
print v(xbgr.mr_n58381616)
print v(xbgr.mr_n58381936)
print v(xbgr.mr_n58382048)
print v(xbgr.mr_n58382288)
print v(xbgr.mr_n58382400)
print v(xbgr.mr_n58382720)
print v(xbgr.mr_n58382832)
print v(xbgr.mr_n58383152)
print v(xbgr.mr_n58383264)
print v(xbgr.mr_n58383584)
print v(xbgr.mr_n58383696)
print v(xbgr.mr_n58384016)
print v(xbgr.mr_n58384128)
print v(xbgr.mr_n58384448)
print v(xbgr.mr_n58384560)
print v(xbgr.mr_n58384880)
print v(xbgr.mr_n58384992)
print v(xbgr.mr_n58385312)
print v(xbgr.mr_n58385424)
print v(xbgr.mr_n58385744)
print v(xbgr.mr_n58385856)
print v(xbgr.mr_n58386176)
print v(xbgr.mr_n58386288)
print v(xbgr.mr_n58386608)
print v(xbgr.mr_n58386720)
print v(xbgr.mr_n58387040)
print v(xbgr.mr_n58387152)
print v(xbgr.mr_n58387472)
print v(xbgr.mr_n58387584)
print v(xbgr.mr_n58387904)
print v(xbgr.mr_n58388016)
print v(xbgr.mr_n58388336)
print v(xbgr.mr_n58388448)
print v(xbgr.mr_n58388768)
print v(xbgr.mr_n58388880)
print v(xbgr.mr_n58389200)
print v(xbgr.mr_n58389312)
print v(xbgr.mr_n58389632)
print v(xbgr.mr_n58389744)
print v(xbgr.mr_n58390064)
print v(xbgr.mr_n58390176)
print v(xbgr.mr_n58390496)
print v(xbgr.mr_n58390608)
print v(xbgr.mr_n58390928)
print v(xbgr.mr_n58391040)
print v(xbgr.mr_n58391360)
print v(xbgr.mr_n58391472)
print v(xbgr.mr_n58391792)
print v(xbgr.mr_n58391904)
print v(xbgr.mr_n58392224)
print v(xbgr.mr_n58392336)
print v(xbgr.mr_n58392656)
print v(xbgr.mr_n58392768)
print v(xbgr.mr_n58393200)
print v(xbgr.mr_n58393520)
print v(xbgr.mr_n58394512)
print v(xbgr.mr_n58394624)
print v(xbgr.mr_n58394944)
print v(xbgr.mr_n58395056)
print v(xbgr.mr_n58395376)
print v(xbgr.mr_n58395488)
print v(xbgr.mr_n58395920)
print v(xbgr.mr_n58396240)
print v(xbgr.mr_n58396352)
print v(xbgr.mr_n58396672)
print v(xbgr.mr_n58396784)
print v(xbgr.mr_n58397104)
print v(xbgr.mr_n58397216)
print v(xbgr.mr_n58397536)
print v(xbgr.mr_n58397648)
print v(xbgr.mr_n58397968)
print v(xbgr.mr_n58398080)
print v(xbgr.mr_n58398512)
print v(xbgr.mr_n58398944)
print v(xbgr.mr_n58399376)
print v(xbgr.mr_n58399808)
print v(xbgr.mr_n58400128)
print v(xbgr.mr_n58400240)
print v(xbgr.mr_n58400560)
print v(xbgr.mr_n58400672)
print v(xbgr.mr_n58400992)
print v(xbgr.mr_n58401104)
print v(xbgr.mr_n58401536)
print v(xbgr.mr_n58401968)
print v(xbgr.mr_n58402288)
print v(xbgr.mr_n58402400)
print v(xbgr.mr_n58402720)
print v(xbgr.mr_n58402832)
print v(xbgr.mr_n58403152)
print v(xbgr.mr_n58403264)
print v(xbgr.mr_n58403584)
print v(xbgr.mr_n58403696)
print v(xbgr.mr_n58404128)
print v(xbgr.mr_n58404560)
print v(xbgr.mr_n58404992)
print v(xbgr.mr_n58405424)
print v(xbgr.mr_n58405856)
print v(xbgr.mr_n58406176)
print v(xbgr.mr_n58406288)
print v(xbgr.mr_n58406608)
print v(xbgr.mr_n58406720)
print v(xbgr.mr_n58407040)
print v(xbgr.mr_n58407152)
print v(xbgr.mr_n58407472)
print v(xbgr.mr_n58407584)
print v(xbgr.mr_n58407904)
print v(xbgr.mr_n58408016)
print v(xbgr.mr_n58408336)
print v(xbgr.mr_n58408448)
print v(xbgr.mr_n58408768)
print v(xbgr.mr_n58408880)
print v(xbgr.mr_n58409200)
print v(xbgr.mr_n58409312)
print v(xbgr.mr_n58409632)
print v(xbgr.mr_n58409744)
print v(xbgr.mr_n58410064)
print v(xbgr.mr_n58410176)
print v(xbgr.mr_n58410496)
print v(xbgr.mr_n58410608)
print v(xbgr.mr_n58410928)
print v(xbgr.mr_n58411040)
print v(xbgr.mr_n58411472)
print v(xbgr.mr_n58411792)
print v(xbgr.mr_n58411904)
print v(xbgr.mr_n58412224)
print v(xbgr.mr_n58412336)
print v(xbgr.mr_n58412656)
print v(xbgr.mr_n58412768)
print v(xbgr.mr_n58413088)
print v(xbgr.mr_n58413200)
print v(xbgr.mr_n58413520)
print v(xbgr.mr_n58413632)
print v(xbgr.mr_n58414064)
print v(xbgr.mr_n58414496)
print v(xbgr.mr_n58414928)
print v(xbgr.mr_n58415360)
print v(xbgr.mr_n58415680)
print v(xbgr.mr_n58415792)
print v(xbgr.mr_n58416112)
print v(xbgr.mr_n58416224)
print v(xbgr.mr_n58416544)
print v(xbgr.mr_n58416656)
print v(xbgr.mr_n58416976)
print v(xbgr.mr_n58417088)
print v(xbgr.mr_n58417408)
print v(xbgr.mr_n58417520)
print v(xbgr.mr_n58417840)
print v(xbgr.mr_n58417952)
print v(xbgr.mr_n58418272)
print v(xbgr.mr_n58418384)
print v(xbgr.mr_n58418704)
print v(xbgr.mr_n58418816)
print v(xbgr.mr_n58419136)
print v(xbgr.mr_n58419248)
print v(xbgr.mr_n58419568)
print v(xbgr.mr_n58419680)
print v(xbgr.mr_n58420000)
print v(xbgr.mr_n58420112)
print v(xbgr.mr_n58420432)
print v(xbgr.mr_n58420544)
print v(xbgr.mr_n58420864)
print v(xbgr.mr_n58420976)
print v(xbgr.mr_n58421296)
print v(xbgr.mr_n58421408)
print v(xbgr.mr_n58421728)
print v(xbgr.mr_n58421840)
print v(xbgr.mr_n58422160)
print v(xbgr.mr_n58422272)
print v(xbgr.mr_n58422592)
print v(xbgr.mr_n58422704)
print v(xbgr.mr_n58423024)
print v(xbgr.mr_n58423136)
print v(xbgr.mr_n58423456)
print v(xbgr.mr_n58423568)
print v(xbgr.mr_n58423888)
print v(xbgr.mr_n58424000)
print v(xbgr.mr_n58424320)
print v(xbgr.mr_n58424432)
print v(xbgr.mr_n58424752)
print v(xbgr.mr_n58424864)
print v(xbgr.mr_n58425184)
print v(xbgr.mr_n58425296)
print v(xbgr.mr_n58425616)
print v(xbgr.mr_n58425728)
print v(xbgr.mr_n58426048)
print v(xbgr.mr_n58426160)
print v(xbgr.mr_n58426480)
print v(xbgr.mr_n58426592)
print v(xbgr.mr_n58426912)
print v(xbgr.mr_n58427024)
print v(xbgr.mr_n58427344)
print v(xbgr.mr_n58427456)
print v(xbgr.mr_n58427776)
print v(xbgr.mr_n58427888)
print v(xbgr.mr_n58428208)
print v(xbgr.mr_n58428320)
print v(xbgr.mr_n58428640)
print v(xbgr.mr_n58428752)
print v(xbgr.mr_n58429072)
print v(xbgr.mr_n58429184)
print v(xbgr.mr_n58429504)
print v(xbgr.mr_n58429616)
print v(xbgr.mr_n58429936)
print v(xbgr.mr_n58430048)
print v(xbgr.mr_n58430368)
print v(xbgr.mr_n58430480)
print v(xbgr.mr_n58430800)
print v(xbgr.mr_n58430912)
print v(xbgr.mr_n58431232)
print v(xbgr.mr_n58431344)
print v(xbgr.mr_n58431664)
print v(xbgr.mr_n58431776)
print v(xbgr.mr_n58432096)
print v(xbgr.mr_n58432208)
print v(xbgr.mr_n58432528)
print v(xbgr.mr_n58432640)
print v(xbgr.mr_n58432960)
print v(xbgr.mr_n58433072)
print v(xbgr.mr_n58433392)
print v(xbgr.mr_n58433504)
print v(xbgr.mr_n58433824)
print v(xbgr.mr_n58433936)
print v(xbgr.mr_n58434256)
print v(xbgr.mr_n58434368)
print v(xbgr.mr_n58434800)
print v(xbgr.mr_n58435232)
print v(xbgr.mr_n58435552)
print v(xbgr.mr_n58435664)
print v(xbgr.mr_n58435984)
print v(xbgr.mr_n58436096)
print v(xbgr.mr_n58436416)
print v(xbgr.mr_n58436528)
print v(xbgr.mr_n58436848)
print v(xbgr.mr_n58436960)
print v(xbgr.mr_n58437392)
print v(xbgr.mr_n58437824)
print v(xbgr.mr_n58438144)
print v(xbgr.mr_n58438256)
print v(xbgr.mr_n58438576)
print v(xbgr.mr_n58438688)
print v(xbgr.mr_n58439008)
print v(xbgr.mr_n58439120)
print v(xbgr.mr_n58439440)
print v(xbgr.mr_n58439552)
print v(xbgr.mr_n58439984)
print v(xbgr.mr_n58440416)
print v(xbgr.mr_n58440848)
print v(xbgr.mr_n58441280)
print v(xbgr.mr_n58441712)
print v(xbgr.mr_n58442144)
print v(xbgr.mr_n58442576)
print v(xbgr.mr_n58443008)
print v(xbgr.mr_n58443440)
print v(xbgr.mr_n58443872)
print v(xbgr.mr_n58444304)
print v(xbgr.mr_n58444736)
print v(xbgr.mr_n58445056)
print v(xbgr.mr_n58445488)
print v(xbgr.mr_n58445920)
print v(xbgr.mr_n58446352)
print v(xbgr.mr_n58446784)
print v(xbgr.mr_n58447216)
print v(xbgr.mr_n58447648)
print v(xbgr.mr_n58448080)
print v(xbgr.mr_n58448512)
print v(xbgr.mr_n58448624)
print v(xbgr.mr_n58448944)
print v(xbgr.mr_n58449056)
print v(xbgr.mr_n58449376)
print v(xbgr.mr_n58449488)
print v(xbgr.mr_n58449808)
print v(xbgr.mr_n58449920)
print v(xbgr.mr_n58450240)
print v(xbgr.mr_n58450352)
print v(xbgr.mr_n58450672)
print v(xbgr.mr_n58450784)
print v(xbgr.mr_n58451104)
print v(xbgr.mr_n58451216)
print v(xbgr.mr_n58451536)
print v(xbgr.mr_n58451648)
print v(xbgr.mr_n58451968)
print v(xbgr.mr_n58452400)
print v(xbgr.mr_n58452832)
print v(xbgr.mr_n58453264)
print v(xbgr.mr_n58453696)
print v(xbgr.mr_n58454128)
print v(xbgr.mr_n58454560)
print v(xbgr.mr_n58454992)
print v(xbgr.mr_n58455424)
print v(xbgr.mr_n58455856)
print v(xbgr.mr_n58456400)
print v(xbgr.mr_n58456832)
print v(xbgr.mr_n58457264)
print v(xbgr.mr_n58457696)
print v(xbgr.mr_n58458128)
print v(xbgr.mr_n58458560)
print v(xbgr.mr_n58458992)
print v(xbgr.mr_n58459424)
print v(xbgr.mr_n58459856)
print v(xbgr.mr_n58460288)
print v(xbgr.mr_n58460720)
print v(xbgr.mr_n58461152)
print v(xbgr.mr_n58461584)
print v(xbgr.mr_n58462016)
print v(xbgr.mr_n58462448)
print v(xbgr.mr_n58462880)
print v(xbgr.mr_n58463312)
print v(xbgr.mr_n58463744)
print v(xbgr.mr_n58464176)
print v(xbgr.mr_n58464608)
print v(xbgr.mr_n58465040)
print v(xbgr.mr_n58465472)
print v(xbgr.mr_n58465904)
print v(xbgr.mr_n58466336)
print v(xbgr.mr_n58466768)
print v(xbgr.mr_n58467200)
print v(xbgr.mr_n58467632)
print v(xbgr.mr_n58468064)
print v(xbgr.mr_n58468496)
print v(xbgr.mr_n58468928)
print v(xbgr.mr_n58469360)
print v(xbgr.mr_n58469792)
print v(xbgr.mr_n58470224)
print v(xbgr.mr_n58470656)
print v(xbgr.mr_n58471088)
print v(xbgr.mr_n58471520)
print v(xbgr.mr_n58471952)
print v(xbgr.mr_n58472384)
print v(xbgr.mr_n58472816)
print v(xbgr.mr_n58473248)
print v(xbgr.mr_n58473680)
print v(xbgr.mr_n58474112)
print v(xbgr.mr_n58474544)
print v(xbgr.mr_n58474976)
print v(xbgr.mr_n58475408)
print v(xbgr.mr_n58475840)
print v(xbgr.mr_n58476272)
print v(xbgr.mr_n58476704)
print v(xbgr.mr_n58477136)
print v(xbgr.mr_n58477568)
print v(xbgr.mr_n58478000)
print v(xbgr.mr_n58478432)
print v(xbgr.mr_n58478864)
print v(xbgr.mr_n58479296)
print v(xbgr.mr_n58479728)
print v(xbgr.mr_n58480160)
print v(xbgr.mr_n58480592)
print v(xbgr.mr_n58481024)
print v(xbgr.mr_n58481456)
print v(xbgr.mr_n58481888)
print v(xbgr.mr_n58482320)
print v(xbgr.mr_n58482752)
print v(xbgr.mr_n58483184)
print v(xbgr.mr_n58483616)
print v(xbgr.mr_n58483936)
print v(xbgr.mr_n58484368)
print v(xbgr.mr_n58484800)
print v(xbgr.mr_n58485232)
print v(xbgr.mr_n58485664)
print v(xbgr.mr_n58486096)
print v(xbgr.mr_n58486640)
print v(xbgr.mr_n58487072)
print v(xbgr.mr_n58487504)
print v(xbgr.mr_n58487936)
print v(xbgr.mr_n58488368)
print v(xbgr.mr_n58488800)
print v(xbgr.mr_n58489232)
print v(xbgr.mr_n58489664)
print v(xbgr.mr_n58490096)
print v(xbgr.mr_n58490528)
print v(xbgr.mr_n58490960)
print v(xbgr.mr_n58491392)
print v(xbgr.mr_n58491824)
print v(xbgr.mr_n58492256)
print v(xbgr.mr_n58492688)
print v(xbgr.mr_n58493120)
print v(xbgr.mr_n58493552)
print v(xbgr.mr_n58493984)
print v(xbgr.mr_n58494416)
print v(xbgr.mr_n58494848)
print v(xbgr.mr_n58495280)
print v(xbgr.mr_n58495712)
print v(xbgr.mr_n58496144)
print v(xbgr.mr_n58496576)
print v(xbgr.mr_n58497008)
print v(xbgr.mr_n58497440)
print v(xbgr.mr_n58497760)
print v(xbgr.mr_n58497872)
print v(xbgr.mr_n58498192)
print v(xbgr.mr_n58498304)
print v(xbgr.mr_n58498624)
print v(xbgr.mr_n58498736)
print v(xbgr.mr_n58499056)
print v(xbgr.mr_n58499168)
print v(xbgr.mr_n58499488)
print v(xbgr.mr_n58499600)
print v(xbgr.mr_n58499920)
print v(xbgr.mr_n58500032)
print v(xbgr.mr_n58500352)
print v(xbgr.mr_n58500464)
print v(xbgr.mr_n58500784)
print v(xbgr.mr_n58500896)
print v(xbgr.mr_n58501216)
print v(xbgr.mr_n58501328)
print v(xbgr.mr_n58501648)
print v(xbgr.mr_n58501760)
print v(xbgr.mr_n58502080)
print v(xbgr.mr_n58502192)
print v(xbgr.mr_n58502512)
print v(xbgr.mr_n58502624)
print v(xbgr.mr_n58502944)
print v(xbgr.mr_n58503056)
print v(xbgr.mr_n58503376)
print v(xbgr.mr_n58503488)
print v(xbgr.mr_n58503808)
print v(xbgr.mr_n58503920)
print v(xbgr.mr_n58504240)
print v(xbgr.mr_n58504672)
print v(xbgr.mr_n58504784)
print v(xbgr.mr_n58505104)
print v(xbgr.mr_n58505536)
print v(xbgr.mr_n58505648)
print v(xbgr.mr_n58505968)
print v(xbgr.mr_n58506080)
print v(xbgr.mr_n58506400)
print v(xbgr.mr_n58506512)
print v(xbgr.mr_n58506832)
print v(xbgr.mr_n58506944)
print v(xbgr.mr_n58507264)
print v(xbgr.mr_n58507376)
print v(xbgr.mr_n58507696)
print v(xbgr.mr_n58507808)
print v(xbgr.mr_n58508128)
print v(xbgr.mr_n58508240)
print v(xbgr.mr_n58508560)
print v(xbgr.mr_n58508992)
print v(xbgr.mr_n58509104)
print v(xbgr.mr_n58509424)
print v(xbgr.mr_n58509536)
print v(xbgr.mr_n58509856)
print v(xbgr.mr_n58509968)
print v(xbgr.mr_n58510288)
print v(xbgr.mr_n58510400)
print v(xbgr.mr_n58510720)
print v(xbgr.mr_n58510832)
print v(xbgr.mr_n58511152)
print v(xbgr.mr_n58511264)
print v(xbgr.mr_n58511584)
print v(xbgr.mr_n58511696)
print v(xbgr.mr_n58512016)
print v(xbgr.mr_n58512128)
print v(xbgr.mr_n58512448)
print v(xbgr.mr_n58512560)
print v(xbgr.mr_n58512880)
print v(xbgr.mr_n58512992)
print v(xbgr.mr_n58513312)
print v(xbgr.mr_n58513424)
print v(xbgr.mr_n58513744)
print v(xbgr.mr_n58514176)
print v(xbgr.mr_n58514288)
print v(xbgr.mr_n58514608)
print v(xbgr.mr_n58514720)
print v(xbgr.mr_n58515040)
print v(xbgr.mr_n58515152)
print v(xbgr.mr_n58515472)
print v(xbgr.mr_n58515584)
print v(xbgr.mr_n58515904)
print v(xbgr.mr_n58516016)
print v(xbgr.mr_n58516336)
print v(xbgr.mr_n58516448)
print v(xbgr.mr_n58516768)
print v(xbgr.mr_n58516880)
print v(xbgr.mr_n58517200)
print v(xbgr.mr_n58517312)
print v(xbgr.mr_n58517632)
print v(xbgr.mr_n58517744)
print v(xbgr.mr_n58518064)
print v(xbgr.mr_n58518176)
print v(xbgr.mr_n58518496)
print v(xbgr.mr_n58518608)
print v(xbgr.mr_n58518928)
print v(xbgr.mr_n58519040)
print v(xbgr.mr_n58519360)
print v(xbgr.mr_n58519472)
print v(xbgr.mr_n58519792)
print v(xbgr.mr_n58520224)
print v(xbgr.mr_n58520336)
print v(xbgr.mr_n58520656)
print v(xbgr.mr_n58520768)
print v(xbgr.mr_n58521088)
print v(xbgr.mr_n58521200)
print v(xbgr.mr_n58521520)
print v(xbgr.mr_n58521632)
print v(xbgr.mr_n58521952)
print v(xbgr.mr_n58522064)
print v(xbgr.mr_n58522384)
print v(xbgr.mr_n58522496)
print v(xbgr.mr_n58522816)
print v(xbgr.mr_n58522928)
print v(xbgr.mr_n58523248)
print v(xbgr.mr_n58523680)
print v(xbgr.mr_n58523792)
print v(xbgr.mr_n58524112)
print v(xbgr.mr_n58524544)
print v(xbgr.mr_n58524656)
print v(xbgr.mr_n58524976)
print v(xbgr.mr_n58525088)
print v(xbgr.mr_n58525408)
print v(xbgr.mr_n58525520)
print v(xbgr.mr_n58525840)
print v(xbgr.mr_n58525952)
print v(xbgr.mr_n58526272)
print v(xbgr.mr_n58526384)
print v(xbgr.mr_n58526704)
print v(xbgr.mr_n58526816)
print v(xbgr.mr_n58527136)
print v(xbgr.mr_n58527248)
print v(xbgr.mr_n58527568)
print v(xbgr.mr_n58527680)
print v(xbgr.mr_n58528000)
print v(xbgr.mr_n58528112)
print v(xbgr.mr_n58528432)
print v(xbgr.mr_n58528544)
print v(xbgr.mr_n58528864)
print v(xbgr.mr_n58528976)
print v(xbgr.mr_n58529296)
print v(xbgr.mr_n58529408)
print v(xbgr.mr_n58529840)
print v(xbgr.mr_n58530272)
print v(xbgr.mr_n58530704)
print v(xbgr.mr_n58531136)
print v(xbgr.mr_n58531568)
print v(xbgr.mr_n58532000)
print v(xbgr.mr_n58532432)
print v(xbgr.mr_n58532864)
print v(xbgr.mr_n58533296)
print v(xbgr.mr_n58533728)
print v(xbgr.mr_n58534160)
print v(xbgr.mr_n58534592)
print v(xbgr.mr_n58535024)
print v(xbgr.mr_n58535456)
print v(xbgr.mr_n58535888)
print v(xbgr.mr_n58536320)
print v(xbgr.mr_n58536752)
print v(xbgr.mr_n58537184)
print v(xbgr.mr_n58537616)
print v(xbgr.mr_n58538048)
print v(xbgr.mr_n58538480)
print v(xbgr.mr_n58538912)
print v(xbgr.mr_n58539344)
print v(xbgr.mr_n58539776)
print v(xbgr.mr_n58540208)
print v(xbgr.mr_n58540640)
print v(xbgr.mr_n58541072)
print v(xbgr.mr_n58541504)
print v(xbgr.mr_n58541936)
print v(xbgr.mr_n58542368)
print v(xbgr.mr_n58542800)
print v(xbgr.mr_n58543232)
print v(xbgr.mr_n58543664)
print v(xbgr.mr_n58544096)
print v(xbgr.mr_n58544528)
print v(xbgr.mr_n58544960)
print v(xbgr.mr_n58545392)
print v(xbgr.mr_n58545824)
print v(xbgr.mr_n58546256)
print v(xbgr.mr_n58546688)
print v(xbgr.mr_n58547120)
print v(xbgr.mr_n58547552)
print v(xbgr.mr_n58547984)
print v(xbgr.mr_n58548416)
print v(xbgr.mr_n58548848)
print v(xbgr.mr_n58549280)
print v(xbgr.mr_n58549712)
print v(xbgr.mr_n58550144)
print v(xbgr.mr_n58550576)
print v(xbgr.mr_n58551008)
print v(xbgr.mr_n58551440)
print v(xbgr.mr_n58551872)
print v(xbgr.mr_n58552304)
print v(xbgr.mr_n58552736)
print v(xbgr.mr_n58553168)
print v(xbgr.mr_n58553600)
print v(xbgr.mr_n58554032)
print v(xbgr.mr_n58554464)
print v(xbgr.mr_n58554896)
print v(xbgr.mr_n58555328)
print v(xbgr.mr_n58555760)
print v(xbgr.mr_n58556192)
print v(xbgr.mr_n58556624)
print v(xbgr.mr_n58557056)
print v(xbgr.mr_n58557488)
print v(xbgr.mr_n58557920)
print v(xbgr.mr_n58558352)
print v(xbgr.mr_n58558784)
print v(xbgr.mr_n58559216)
print v(xbgr.mr_n58559648)
print v(xbgr.mr_n58560080)
print v(xbgr.mr_n58560512)
print v(xbgr.mr_n58560944)
print v(xbgr.mr_n58561376)
print v(xbgr.mr_n58561808)
print v(xbgr.mr_n58562240)
print v(xbgr.mr_n58562672)
print v(xbgr.mr_n58563104)
print v(xbgr.mr_n58563424)
print v(xbgr.mr_n58563536)
print v(xbgr.mr_n58563856)
print v(xbgr.mr_n58563968)
print v(xbgr.mr_n58564400)
print v(xbgr.mr_n58564832)
print v(xbgr.mr_n58565152)
print v(xbgr.mr_n58565264)
print v(xbgr.mr_n58565584)
print v(xbgr.mr_n58566128)
print v(xbgr.mr_n58566560)
print v(xbgr.mr_n58566880)
print v(xbgr.mr_n58566992)
print v(xbgr.mr_n58567312)
print v(xbgr.mr_n58567424)
print v(xbgr.mr_n58567744)
print v(xbgr.mr_n58567856)
print v(xbgr.mr_n58568176)
print v(xbgr.mr_n58568288)
print v(xbgr.mr_n58568608)
print v(xbgr.mr_n58568720)
print v(xbgr.mr_n58569040)
print v(xbgr.mr_n58569152)
print v(xbgr.mr_n58569472)
print v(xbgr.mr_n58569584)
print v(xbgr.mr_n58569904)
print v(xbgr.mr_n58570016)
print v(xbgr.mr_n58570336)
print v(xbgr.mr_n58570448)
print v(xbgr.mr_n58570768)
print v(xbgr.mr_n58570880)
print v(xbgr.mr_n58571200)
print v(xbgr.mr_n58571312)
print v(xbgr.mr_n58571632)
print v(xbgr.mr_n58571744)
print v(xbgr.mr_n58572176)
print v(xbgr.mr_n58572608)
print v(xbgr.mr_n58572928)
print v(xbgr.mr_n58573040)
print v(xbgr.mr_n58573360)
print v(xbgr.mr_n58573472)
print v(xbgr.mr_n58573904)
print v(xbgr.mr_n58574336)
print v(xbgr.mr_n58574768)
print v(xbgr.mr_n58575200)
print v(xbgr.mr_n58575632)
print v(xbgr.mr_n58576064)
print v(xbgr.mr_n58576496)
print v(xbgr.mr_n58576928)
print v(xbgr.mr_n58577360)
print v(xbgr.mr_n58577792)
print v(xbgr.mr_n58578224)
print v(xbgr.mr_n58578656)
print v(xbgr.mr_n58579088)
print v(xbgr.mr_n58579520)
print v(xbgr.mr_n58579952)
print v(xbgr.mr_n58580384)
print v(xbgr.mr_n58580816)
print v(xbgr.mr_n58581248)
print v(xbgr.mr_n58581680)
print v(xbgr.mr_n58582112)
print v(xbgr.mr_n58582544)
print v(xbgr.mr_n58582976)
print v(xbgr.mr_n58583408)
print v(xbgr.mr_n58583840)
print v(xbgr.mr_n58584272)
print v(xbgr.mr_n58584704)
print v(xbgr.mr_n58585136)
print v(xbgr.mr_n58585568)
print v(xbgr.mr_n58586000)
print v(xbgr.mr_n58586432)
print v(xbgr.mr_n58586864)
print v(xbgr.mr_n58587296)
print v(xbgr.mr_n58587728)
print v(xbgr.mr_n58588160)
print v(xbgr.mr_n58588592)
print v(xbgr.mr_n58589024)
print v(xbgr.mr_n58589456)
print v(xbgr.mr_n58589888)
print v(xbgr.mr_n58590320)
print v(xbgr.mr_n58590752)
print v(xbgr.mr_n58591184)
print v(xbgr.mr_n58591616)
print v(xbgr.mr_n58592048)
print v(xbgr.mr_n58592480)
print v(xbgr.mr_n58592912)
print v(xbgr.mr_n58593344)
print v(xbgr.mr_n58593776)
print v(xbgr.mr_n58594208)
print v(xbgr.mr_n58594640)
print v(xbgr.mr_n58595072)
print v(xbgr.mr_n58595504)
print v(xbgr.mr_n58595936)
print v(xbgr.mr_n58596368)
print v(xbgr.mr_n58596800)
print v(xbgr.mr_n58597232)
print v(xbgr.mr_n58597664)
print v(xbgr.mr_n58598096)
print v(xbgr.mr_n58598528)
print v(xbgr.mr_n58598960)
print v(xbgr.mr_n58599392)
print v(xbgr.mr_n58599824)
print v(xbgr.mr_n58600256)
print v(xbgr.mr_n58600688)
print v(xbgr.mr_n58601120)
print v(xbgr.mr_n58601552)
print v(xbgr.mr_n58601984)
print v(xbgr.mr_n58602416)
print v(xbgr.mr_n58602848)
print v(xbgr.mr_n58603280)
print v(xbgr.mr_n58603712)
print v(xbgr.mr_n58604144)
print v(xbgr.mr_n58604576)
print v(xbgr.mr_n58605008)
print v(xbgr.mr_n58605440)
print v(xbgr.mr_n58605872)
print v(xbgr.mr_n58606304)
print v(xbgr.mr_n58606736)
print v(xbgr.mr_n58607168)
print v(xbgr.mr_n58607600)
print v(xbgr.mr_n58608032)
print v(xbgr.mr_n58608464)
print v(xbgr.mr_n58608896)
print v(xbgr.mr_n58609328)
print v(xbgr.mr_n58609760)
print v(xbgr.mr_n58610192)
print v(xbgr.mr_n58610624)
print v(xbgr.mr_n58611056)
print v(xbgr.mr_n58611488)
print v(xbgr.mr_n58611920)
print v(xbgr.mr_n58612352)
print v(xbgr.mr_n58612784)
print v(xbgr.mr_n58613216)
print v(xbgr.mr_n58613648)
print v(xbgr.mr_n58614080)
print v(xbgr.mr_n58614512)
print v(xbgr.mr_n58614944)
print v(xbgr.mr_n58615376)
print v(xbgr.mr_n58615808)
print v(xbgr.mr_n58616240)
print v(xbgr.mr_n58616672)
print v(xbgr.mr_n58617104)
print v(xbgr.mr_n58617536)
print v(xbgr.mr_n58617968)
print v(xbgr.mr_n58618400)
print v(xbgr.mr_n58618832)
print v(xbgr.mr_n58619264)
print v(xbgr.mr_n58619696)
print v(xbgr.mr_n58620128)
print v(xbgr.mr_n58620560)
print v(xbgr.mr_n58620992)
print v(xbgr.mr_n58621424)
print v(xbgr.mr_n58621856)
print v(xbgr.mr_n58622288)
print v(xbgr.mr_n58622720)
print v(xbgr.mr_n58623152)
print v(xbgr.mr_n58623584)
print v(xbgr.mr_n58624016)
print v(xbgr.mr_n58624448)
print v(xbgr.mr_n58624880)
print v(xbgr.mr_n58625312)
print v(xbgr.mr_n58625744)
print v(xbgr.mr_n58626176)
print v(xbgr.mr_n58626608)
print v(xbgr.mr_n58627040)
print v(xbgr.mr_n58627472)
print v(xbgr.mr_n58627904)
print v(xbgr.mr_n58628336)
print v(xbgr.mr_n58628768)
print v(xbgr.mr_n58629200)
print v(xbgr.mr_n58629632)
print v(xbgr.mr_n58630064)
print v(xbgr.mr_n58630496)
print v(xbgr.mr_n58630928)
print v(xbgr.mr_n58631360)
print v(xbgr.mr_n58631792)
print v(xbgr.mr_n58632224)
print v(xbgr.mr_n58632544)
print v(xbgr.mr_n58632656)
print v(xbgr.mr_n58632976)
print v(xbgr.mr_n58633088)
print v(xbgr.mr_n58633408)
print v(xbgr.mr_n58633520)
print v(xbgr.mr_n58633840)
print v(xbgr.mr_n58633952)
print v(xbgr.mr_n58634272)
print v(xbgr.mr_n58634384)
print v(xbgr.mr_n58634704)
print v(xbgr.mr_n58634816)
print v(xbgr.mr_n58635136)
print v(xbgr.mr_n58635248)
print v(xbgr.mr_n58635568)
print v(xbgr.mr_n58635680)
print v(xbgr.mr_n58636000)
print v(xbgr.mr_n58636112)
print v(xbgr.mr_n58636432)
print v(xbgr.mr_n58636544)
print v(xbgr.mr_n58636864)
print v(xbgr.mr_n58636976)
print v(xbgr.mr_n58637296)
print v(xbgr.mr_n58637408)
print v(xbgr.mr_n58637728)
print v(xbgr.mr_n58637840)
print v(xbgr.mr_n58638160)
print v(xbgr.mr_n58638272)
print v(xbgr.mr_n58638592)
print v(xbgr.mr_n58638704)
print v(xbgr.mr_n58639024)
print v(xbgr.mr_n58639136)
print v(xbgr.mr_n58639456)
print v(xbgr.mr_n58639568)
print v(xbgr.mr_n58639888)
print v(xbgr.mr_n58640000)
print v(xbgr.mr_n58640320)
print v(xbgr.mr_n58640432)
print v(xbgr.mr_n58640752)
print v(xbgr.mr_n58640864)
print v(xbgr.mr_n58641184)
print v(xbgr.mr_n58641296)
print v(xbgr.mr_n58641616)
print v(xbgr.mr_n58641728)
print v(xbgr.mr_n58642048)
print v(xbgr.mr_n58642160)
print v(xbgr.mr_n58642480)
print v(xbgr.mr_n58642592)
print v(xbgr.mr_n58642912)
print v(xbgr.mr_n58643024)
print v(xbgr.mr_n58643344)
print v(xbgr.mr_n58643456)
print v(xbgr.mr_n58643776)
print v(xbgr.mr_n58643888)
print v(xbgr.mr_n58644208)
print v(xbgr.mr_n58644320)
print v(xbgr.mr_n58644640)
print v(xbgr.mr_n58644752)
print v(xbgr.mr_n58645072)
print v(xbgr.mr_n58645184)
print v(xbgr.mr_n58645616)
print v(xbgr.mr_n58646048)
print v(xbgr.mr_n58646480)
print v(xbgr.mr_n58646912)
print v(xbgr.mr_n58647232)
print v(xbgr.mr_n58647344)
print v(xbgr.mr_n58647664)
print v(xbgr.mr_n58647776)
print v(xbgr.mr_n58648096)
print v(xbgr.mr_n58648208)
print v(xbgr.mr_n58648528)
print v(xbgr.mr_n58648640)
print v(xbgr.mr_n58648960)
print v(xbgr.mr_n58649072)
print v(xbgr.mr_n58649392)
print v(xbgr.mr_n58649504)
print v(xbgr.mr_n58649936)
print v(xbgr.mr_n58650368)
print v(xbgr.mr_n58650800)
print v(xbgr.mr_n58651120)
print v(xbgr.mr_n58651232)
print v(xbgr.mr_n58651552)
print v(xbgr.mr_n58651664)
print v(xbgr.mr_n58651984)
print v(xbgr.mr_n58652096)
print v(xbgr.mr_n58652416)
print v(xbgr.mr_n58652528)
print v(xbgr.mr_n58652848)
print v(xbgr.mr_n58652960)
print v(xbgr.mr_n58653280)
print v(xbgr.mr_n58653392)
print v(xbgr.mr_n58653712)
print v(xbgr.mr_n58653824)
print v(xbgr.mr_n58654144)
print v(xbgr.mr_n58654256)
print v(xbgr.mr_n58654576)
print v(xbgr.mr_n58654688)
print v(xbgr.mr_n58655008)
print v(xbgr.mr_n58655120)
print v(xbgr.mr_n58655552)
print v(xbgr.mr_n58655984)
print v(xbgr.mr_n58656416)
print v(xbgr.mr_n58656848)
print v(xbgr.mr_n58657280)
print v(xbgr.mr_n58657712)
print v(xbgr.mr_n58658144)
print v(xbgr.mr_n58658576)
print v(xbgr.mr_n58659008)
print v(xbgr.mr_n58659440)
print v(xbgr.mr_n58659872)
print v(xbgr.mr_n58660304)
print v(xbgr.mr_n58660736)
print v(xbgr.mr_n58661056)
print v(xbgr.mr_n58661168)
print v(xbgr.mr_n58661488)
print v(xbgr.mr_n58661600)
print v(xbgr.mr_n58661920)
print v(xbgr.mr_n58662032)
print v(xbgr.mr_n58662352)
print v(xbgr.mr_n58662464)
print v(xbgr.mr_n58662784)
print v(xbgr.mr_n58662896)
print v(xbgr.mr_n58663328)
print v(xbgr.mr_n58663760)
print v(xbgr.mr_n58664192)
print v(xbgr.mr_n58664624)
print v(xbgr.mr_n58665056)
print v(xbgr.mr_n58665488)
print v(xbgr.mr_n58665808)
print v(xbgr.mr_n58665920)
print v(xbgr.mr_n58666240)
print v(xbgr.mr_n58666352)
print v(xbgr.mr_n58666784)
print v(xbgr.mr_n58667216)
print v(xbgr.mr_n58667536)
print v(xbgr.mr_n58667648)
print v(xbgr.mr_n58667968)
print v(xbgr.mr_n58668080)
print v(xbgr.mr_n58668400)
print v(xbgr.mr_n58668512)
print v(xbgr.mr_n58668832)
print v(xbgr.mr_n58668944)
print v(xbgr.mr_n58669264)
print v(xbgr.mr_n58669376)
print v(xbgr.mr_n58669696)
print v(xbgr.mr_n58669808)
print v(xbgr.mr_n58670128)
print v(xbgr.mr_n58670240)
print v(xbgr.mr_n58670560)
print v(xbgr.mr_n58670672)
print v(xbgr.mr_n58670992)
print v(xbgr.mr_n58671104)
print v(xbgr.mr_n58671424)
print v(xbgr.mr_n58671536)
print v(xbgr.mr_n58671856)
print v(xbgr.mr_n58671968)
print v(xbgr.mr_n58672288)
print v(xbgr.mr_n58672400)
print v(xbgr.mr_n58672720)
print v(xbgr.mr_n58672832)
print v(xbgr.mr_n58673152)
print v(xbgr.mr_n58673264)
print v(xbgr.mr_n58673696)
print v(xbgr.mr_n58674128)
print v(xbgr.mr_n58674448)
print v(xbgr.mr_n58674560)
print v(xbgr.mr_n58674880)
print v(xbgr.mr_n58674992)
print v(xbgr.mr_n58675312)
print v(xbgr.mr_n58675424)
print v(xbgr.mr_n58675744)
print v(xbgr.mr_n58675856)
print v(xbgr.mr_n58676176)
print v(xbgr.mr_n58676288)
print v(xbgr.mr_n58676608)
print v(xbgr.mr_n58676720)
print v(xbgr.mr_n58677152)
print v(xbgr.mr_n58677584)
print v(xbgr.mr_n58677904)
print v(xbgr.mr_n58678016)
print v(xbgr.mr_n58678336)
print v(xbgr.mr_n58678448)
print v(xbgr.mr_n58678768)
print v(xbgr.mr_n58678880)
print v(xbgr.mr_n58679200)
print v(xbgr.mr_n58679312)
print v(xbgr.mr_n58679632)
print v(xbgr.mr_n58679744)
print v(xbgr.mr_n58680064)
print v(xbgr.mr_n58680176)
print v(xbgr.mr_n58680496)
print v(xbgr.mr_n58680608)
print v(xbgr.mr_n58680928)
print v(xbgr.mr_n58681040)
print v(xbgr.mr_n58681360)
print v(xbgr.mr_n58681472)
print v(xbgr.mr_n58681792)
print v(xbgr.mr_n58681904)
print v(xbgr.mr_n58682224)
print v(xbgr.mr_n58682336)
print v(xbgr.mr_n58682656)
print v(xbgr.mr_n58682768)
print v(xbgr.mr_n58683088)
print v(xbgr.mr_n58683200)
print v(xbgr.mr_n58683520)
print v(xbgr.mr_n58683632)
print v(xbgr.mr_n58683952)
print v(xbgr.mr_n58684064)
print v(xbgr.mr_n58684384)
print v(xbgr.mr_n58684496)
print v(xbgr.mr_n58684816)
print v(xbgr.mr_n58684928)
print v(xbgr.mr_n58685248)
print v(xbgr.mr_n58685360)
print v(xbgr.mr_n58685680)
print v(xbgr.mr_n58685792)
print v(xbgr.mr_n58686112)
print v(xbgr.mr_n58686224)
print v(xbgr.mr_n58686544)
print v(xbgr.mr_n58686656)
print v(xbgr.mr_n58686976)
print v(xbgr.mr_n58687088)
print v(xbgr.mr_n58687408)
print v(xbgr.mr_n58687520)
print v(xbgr.mr_n58687840)
print v(xbgr.mr_n58687952)
print v(xbgr.mr_n58688272)
print v(xbgr.mr_n58688384)
print v(xbgr.mr_n58688704)
print v(xbgr.mr_n58688816)
print v(xbgr.mr_n58689136)
print v(xbgr.mr_n58689248)
print v(xbgr.mr_n58689568)
print v(xbgr.mr_n58689680)
print v(xbgr.mr_n58690000)
print v(xbgr.mr_n58690112)
print v(xbgr.mr_n58690432)
print v(xbgr.mr_n58690544)
print v(xbgr.mr_n58690864)
print v(xbgr.mr_n58690976)
print v(xbgr.mr_n58691296)
print v(xbgr.mr_n58691408)
print v(xbgr.mr_n58691728)
print v(xbgr.mr_n58691840)
print v(xbgr.mr_n58692160)
print v(xbgr.mr_n58692272)
print v(xbgr.mr_n58692592)
print v(xbgr.mr_n58692704)
print v(xbgr.mr_n58693024)
print v(xbgr.mr_n58693136)
print v(xbgr.mr_n58693456)
print v(xbgr.mr_n58693568)
print v(xbgr.mr_n58693888)
print v(xbgr.mr_n58694000)
print v(xbgr.mr_n58694320)
print v(xbgr.mr_n58694432)
print v(xbgr.mr_n58694752)
print v(xbgr.mr_n58694864)
print v(xbgr.mr_n58695184)
print v(xbgr.mr_n58695296)
print v(xbgr.mr_n58695616)
print v(xbgr.mr_n58695728)
print v(xbgr.mr_n58696048)
print v(xbgr.mr_n58696160)
print v(xbgr.mr_n58696480)
print v(xbgr.mr_n58696592)
print v(xbgr.mr_n58696912)
print v(xbgr.mr_n58697024)
print v(xbgr.mr_n58697344)
print v(xbgr.mr_n58697456)
print v(xbgr.mr_n58697776)
print v(xbgr.mr_n58697888)
print v(xbgr.mr_n58698208)
print v(xbgr.mr_n58698320)
print v(xbgr.mr_n58698640)
print v(xbgr.mr_n58698752)
print v(xbgr.mr_n58699072)
print v(xbgr.mr_n58699184)
print v(xbgr.mr_n58699504)
print v(xbgr.mr_n58699616)
print v(xbgr.mr_n58699936)
print v(xbgr.mr_n58700048)
print v(xbgr.mr_n58700368)
print v(xbgr.mr_n58700480)
print v(xbgr.mr_n58700800)
print v(xbgr.mr_n58700912)
print v(xbgr.mr_n58701232)
print v(xbgr.mr_n58701344)
print v(xbgr.mr_n58701664)
print v(xbgr.mr_n58701776)
print v(xbgr.mr_n58702096)
print v(xbgr.mr_n58702208)
print v(xbgr.mr_n58702528)
print v(xbgr.mr_n58702640)
print v(xbgr.mr_n58702960)
print v(xbgr.mr_n58703072)
print v(xbgr.mr_n58703392)
print v(xbgr.mr_n58703504)
print v(xbgr.mr_n58703824)
print v(xbgr.mr_n58703936)
print v(xbgr.mr_n58704256)
print v(xbgr.mr_n58704368)
print v(xbgr.mr_n58704688)
print v(xbgr.mr_n58704800)
print v(xbgr.mr_n58705120)
print v(xbgr.mr_n58705232)
print v(xbgr.mr_n58705552)
print v(xbgr.mr_n58705664)
print v(xbgr.mr_n58705984)
print v(xbgr.mr_n58706096)
print v(xbgr.mr_n58706416)
print v(xbgr.mr_n58706528)
print v(xbgr.mr_n58706848)
print v(xbgr.mr_n58706960)
print v(xbgr.mr_n58707280)
print v(xbgr.mr_n58707392)
print v(xbgr.mr_n58707712)
print v(xbgr.mr_n58707824)
print v(xbgr.mr_n58708144)
print v(xbgr.mr_n58708256)
print v(xbgr.mr_n58708576)
print v(xbgr.mr_n58708688)
print v(xbgr.mr_n58709008)
print v(xbgr.mr_n58709120)
print v(xbgr.mr_n58709440)
print v(xbgr.mr_n58709552)
print v(xbgr.mr_n58709872)
print v(xbgr.mr_n58709984)
print v(xbgr.mr_n58710304)
print v(xbgr.mr_n58710416)
print v(xbgr.mr_n58710736)
print v(xbgr.mr_n58710848)
print v(xbgr.mr_n58711168)
print v(xbgr.mr_n58711280)
print v(xbgr.mr_n58711600)
print v(xbgr.mr_n58711712)
print v(xbgr.mr_n58712032)
print v(xbgr.mr_n58712144)
print v(xbgr.mr_n58712464)
print v(xbgr.mr_n58712576)
print v(xbgr.mr_n58712896)
print v(xbgr.mr_n58713008)
print v(xbgr.mr_n58713328)
print v(xbgr.mr_n58713440)
print v(xbgr.mr_n58713760)
print v(xbgr.mr_n58713872)
print v(xbgr.mr_n58714192)
print v(xbgr.mr_n58714304)
print v(xbgr.mr_n58714624)
print v(xbgr.mr_n58714736)
print v(xbgr.mr_n58715056)
print v(xbgr.mr_n58715168)
print v(xbgr.mr_n58715488)
print v(xbgr.mr_n58715600)
print v(xbgr.mr_n58715920)
print v(xbgr.mr_n58716032)
print v(xbgr.mr_n58716352)
print v(xbgr.mr_n58716464)
print v(xbgr.mr_n58716784)
print v(xbgr.mr_n58716896)
print v(xbgr.mr_n58717216)
print v(xbgr.mr_n58717328)
print v(xbgr.mr_n58717648)
print v(xbgr.mr_n58717760)
print v(xbgr.mr_n58718080)
print v(xbgr.mr_n58718192)
print v(xbgr.mr_n58718512)
print v(xbgr.mr_n58718624)
print v(xbgr.mr_n58718944)
print v(xbgr.mr_n58719056)
print v(xbgr.mr_n58719376)
print v(xbgr.mr_n58719488)
print v(xbgr.mr_n58719808)
print v(xbgr.mr_n58719920)
print v(xbgr.mr_n58720240)
print v(xbgr.mr_n58720352)
print v(xbgr.mr_n58720672)
print v(xbgr.mr_n58720784)
print v(xbgr.mr_n58721104)
print v(xbgr.mr_n58721216)
print v(xbgr.mr_n58721536)
print v(xbgr.mr_n58721648)
print v(xbgr.mr_n58721968)
print v(xbgr.mr_n58722080)
print v(xbgr.mr_n58722400)
print v(xbgr.mr_n58722512)
print v(xbgr.mr_n58722832)
print v(xbgr.mr_n58722944)
print v(xbgr.mr_n58723264)
print v(xbgr.mr_n58723376)
print v(xbgr.mr_n58723696)
print v(xbgr.mr_n58723808)
print v(xbgr.mr_n58724128)
print v(xbgr.mr_n58724240)
print v(xbgr.mr_n58724560)
print v(xbgr.mr_n58724672)
print v(xbgr.mr_n58724992)
print v(xbgr.mr_n58725104)
print v(xbgr.mr_n58725424)
print v(xbgr.mr_n58725536)
print v(xbgr.mr_n58725856)
print v(xbgr.mr_n58725968)
print v(xbgr.mr_n58726288)
print v(xbgr.mr_n58726400)
print v(xbgr.mr_n58726720)
print v(xbgr.mr_n58726832)
print v(xbgr.mr_n58727152)
print v(xbgr.mr_n58727264)
print v(xbgr.mr_n58727584)
print v(xbgr.mr_n58727696)
print v(xbgr.mr_n58728016)
print v(xbgr.mr_n58728128)
print v(xbgr.mr_n58728560)
print v(xbgr.mr_n58728992)
print v(xbgr.mr_n58729424)
print v(xbgr.mr_n58729856)
print v(xbgr.mr_n58730288)
print v(xbgr.mr_n58730720)
print v(xbgr.mr_n58731152)
print v(xbgr.mr_n58731584)
print v(xbgr.mr_n58732016)
print v(xbgr.mr_n58732448)
print v(xbgr.mr_n58732880)
print v(xbgr.mr_n58733312)
print v(xbgr.mr_n58733744)
print v(xbgr.mr_n58734176)
print v(xbgr.mr_n58734608)
print v(xbgr.mr_n58735040)
print v(xbgr.mr_n58735472)
print v(xbgr.mr_n58735904)
print v(xbgr.mr_n58736336)
print v(xbgr.mr_n58736768)
print v(xbgr.mr_n58737200)
print v(xbgr.mr_n58737632)
print v(xbgr.mr_n58738064)
print v(xbgr.mr_n58738496)
print v(xbgr.mr_n58738928)
print v(xbgr.mr_n58739360)
print v(xbgr.mr_n58739792)
print v(xbgr.mr_n58740224)
print v(xbgr.mr_n58740656)
print v(xbgr.mr_n58741088)
print v(xbgr.mr_n58741520)
print v(xbgr.mr_n58741952)
print v(xbgr.mr_n58742384)
print v(xbgr.mr_n58742816)
print v(xbgr.mr_n58743136)
print v(xbgr.mr_n58743248)
print v(xbgr.mr_n58743568)
print v(xbgr.mr_n58743680)
print v(xbgr.mr_n58744112)
print v(xbgr.mr_n58744432)
print v(xbgr.mr_n58744544)
print v(xbgr.mr_n58744864)
print v(xbgr.mr_n58744976)
print v(xbgr.mr_n58745296)
print v(xbgr.mr_n58745408)
print v(xbgr.mr_n58745728)
print v(xbgr.mr_n58745840)
print v(xbgr.mr_n58746160)
print v(xbgr.mr_n58746272)
print v(xbgr.mr_n58746592)
print v(xbgr.mr_n58746704)
print v(xbgr.mr_n58747024)
print v(xbgr.mr_n58747136)
print v(xbgr.mr_n58747456)
print v(xbgr.mr_n58747568)
print v(xbgr.mr_n58748000)
print v(xbgr.mr_n58748432)
print v(xbgr.mr_n58748864)
print v(xbgr.mr_n58749296)
print v(xbgr.mr_n58749728)
print v(xbgr.mr_n58750160)
print v(xbgr.mr_n58750592)
print v(xbgr.mr_n58751024)
print v(xbgr.mr_n58751456)
print v(xbgr.mr_n58751776)
print v(xbgr.mr_n58751888)
print v(xbgr.mr_n58752208)
print v(xbgr.mr_n58752320)
print v(xbgr.mr_n58752640)
print v(xbgr.mr_n58752752)
print v(xbgr.mr_n58753072)
print v(xbgr.mr_n58753184)
print v(xbgr.mr_n58753616)
print v(xbgr.mr_n58754048)
print v(xbgr.mr_n58754480)
print v(xbgr.mr_n58754912)
print v(xbgr.mr_n58755344)
print v(xbgr.mr_n58755776)
print v(xbgr.mr_n58756208)
print v(xbgr.mr_n58756640)
print v(xbgr.mr_n58757072)
print v(xbgr.mr_n58757504)
print v(xbgr.mr_n58757936)
print v(xbgr.mr_n58758368)
print v(xbgr.mr_n58758800)
print v(xbgr.mr_n58759232)
print v(xbgr.mr_n58759664)
print v(xbgr.mr_n58760096)
print v(xbgr.mr_n58760528)
print v(xbgr.mr_n58760960)
print v(xbgr.mr_n58761392)
print v(xbgr.mr_n58761824)
print v(xbgr.mr_n58762256)
print v(xbgr.mr_n58762688)
print v(xbgr.mr_n58763120)
print v(xbgr.mr_n58763552)
print v(xbgr.mr_n58763984)
print v(xbgr.mr_n58764416)
print v(xbgr.mr_n58764848)
print v(xbgr.mr_n58765280)
print v(xbgr.mr_n58765712)
print v(xbgr.mr_n58766032)
print v(xbgr.mr_n58766144)
print v(xbgr.mr_n58766464)
print v(xbgr.mr_n58766576)
print v(xbgr.mr_n58766896)
print v(xbgr.mr_n58767008)
print v(xbgr.mr_n58767328)
print v(xbgr.mr_n58767440)
print v(xbgr.mr_n58767760)
print v(xbgr.mr_n58767872)
print v(xbgr.mr_n58768192)
print v(xbgr.mr_n58768304)
print v(xbgr.mr_n59030784)
print v(xbgr.mr_n59031568)
print v(xbgr.mr_n59032432)
print v(xbgr.mr_n59032544)
print v(xbgr.mr_n59032864)
print v(xbgr.mr_n59033296)
print v(xbgr.mr_n59033728)
print v(xbgr.mr_n59034160)
print v(xbgr.mr_n59034272)
print v(xbgr.mr_n59034592)
print v(xbgr.mr_n59035024)
print v(xbgr.mr_n59035456)
print v(xbgr.mr_n59035888)
print v(xbgr.mr_n59036000)
print v(xbgr.mr_n59036320)
print v(xbgr.mr_n59036432)
print v(xbgr.mr_n59036752)
print v(xbgr.mr_n59036864)
print v(xbgr.mr_n59037296)
print v(xbgr.mr_n59037728)
print v(xbgr.mr_n59038160)
print v(xbgr.mr_n59038480)
print v(xbgr.mr_n59039344)
print v(xbgr.mr_n59039456)
print v(xbgr.mr_n59039776)
print v(xbgr.mr_n59039888)
print v(xbgr.mr_n59040208)
print v(xbgr.mr_n59041184)
print v(xbgr.mr_n59041616)
print v(xbgr.mr_n59041936)
print v(xbgr.mr_n59042800)
print v(xbgr.mr_n59042912)
print v(xbgr.mr_n59043232)
print v(xbgr.mr_n59043344)
print v(xbgr.mr_n59043664)
print v(xbgr.mr_n59043776)
print v(xbgr.mr_n59046272)
print v(xbgr.mr_n59046704)
print v(xbgr.mr_n59047024)
print v(xbgr.mr_n59048000)
print v(xbgr.mr_n59048320)
print v(xbgr.mr_n59049296)
print v(xbgr.mr_n59049616)
print v(xbgr.mr_n59050592)
print v(xbgr.mr_n59050912)
print v(xbgr.mr_n59051024)
print v(xbgr.mr_n59051456)
print v(xbgr.mr_n59051888)
print v(xbgr.mr_n59052208)
print v(xbgr.mr_n59053184)
print v(xbgr.mr_n59053504)
print v(xbgr.mr_n59054480)
print v(xbgr.mr_n59054800)
print v(xbgr.mr_n59055776)
print v(xbgr.mr_n59056208)
print v(xbgr.mr_n59056640)
print v(xbgr.mr_n59057072)
print v(xbgr.mr_n59057504)
print v(xbgr.mr_n59057936)
print v(xbgr.mr_n59058368)
print v(xbgr.mr_n59058800)
print v(xbgr.mr_n59059232)
print v(xbgr.mr_n59059664)
print v(xbgr.mr_n59060096)
print v(xbgr.mr_n59060528)
print v(xbgr.mr_n59060960)
print v(xbgr.mr_n59061392)
print v(xbgr.mr_n59061824)
print v(xbgr.mr_n59062256)
print v(xbgr.mr_n59062688)
print v(xbgr.mr_n59063120)
print v(xbgr.mr_n59063552)
print v(xbgr.mr_n59063984)
print v(xbgr.mr_n59064416)
print v(xbgr.mr_n59064848)
print v(xbgr.mr_n59065280)
print v(xbgr.mr_n59065712)
print v(xbgr.mr_n59066144)
print v(xbgr.mr_n59126288)
print v(xbgr.mr_n59127920)
print v(xbgr.mr_n59128368)
print v(xbgr.mr_n59129360)
print v(xbgr.mr_n59129808)
print v(xbgr.mr_n59131600)
print v(xbgr.mr_n59132048)
print v(xbgr.mr_n59132320)
print v(xbgr.mr_n59133072)
print v(xbgr.mr_n59133952)
print v(xbgr.mr_n59136128)
print v(xbgr.mr_n59136304)
print v(xbgr.mr_n59139696)
print v(xbgr.mr_n59139936)
print v(xbgr.mr_n59140384)
print v(xbgr.mr_n59142608)
print v(xbgr.mr_n59142784)
print v(xbgr.mr_n59149488)
print v(xbgr.mr_n59150880)
print v(xbgr.mr_n59155520)
print v(xbgr.mr_n59156080)
print v(xbgr.mr_n59156688)
print v(xbgr.mr_n59156912)
print v(xbgr.mr_n59158016)
print v(xbgr.mr_n59160416)
print v(xbgr.mr_n59160944)
print v(xbgr.mr_n59162176)
print v(xbgr.mr_n59162352)
print v(xbgr.mr_n59162592)
print v(xbgr.mr_n59163472)
print v(xbgr.mr_n59163760)
print v(xbgr.mr_n59164176)
print v(xbgr.mr_n59164640)
print v(xbgr.mr_n59165232)
print v(xbgr.mr_n59165584)
print v(xbgr.mr_n59165760)
print v(xbgr.mr_n59167136)
print v(xbgr.mr_n59169712)
print v(xbgr.mr_n59170160)
print v(xbgr.mr_n59170336)
print v(xbgr.mr_n59170992)
print v(xbgr.mr_n59172128)
print v(xbgr.mr_n59172784)
print v(xbgr.mr_n59173296)
print v(xbgr.mr_n59173680)
print v(xbgr.mr_n59174192)
print v(xbgr.mr_n59175344)
print v(xbgr.mr_n59178224)
print v(xbgr.mr_n59180016)
print v(xbgr.mr_n59180816)
print v(xbgr.mr_n59181616)
print v(xbgr.mr_n59182848)
print v(xbgr.mr_n59183296)
print v(xbgr.mr_n59184304)
print v(xbgr.mr_n59185200)
print v(xbgr.mr_n59186880)
print v(xbgr.mr_n59187952)
print v(xbgr.mr_n59189024)
print v(xbgr.mr_n59189232)
print v(xbgr.mr_n59192912)
print v(xbgr.mr_n59193264)
print v(xbgr.mr_n59193648)
print v(xbgr.mr_n59194160)
print v(xbgr.mr_n59195120)
print v(xbgr.mr_n59196288)
print v(xbgr.mr_n59196464)
print v(xbgr.mr_n59197296)
print v(xbgr.mr_n59199216)
print v(xbgr.mr_n59199424)
print v(xbgr.mr_n59214240)
print v(xbgr.mr_n59214800)
print v(xbgr.mr_n59215840)
print v(xbgr.mr_n59216240)
print v(xbgr.mr_n59221440)
print v(xbgr.mr_n59225712)
print v(xbgr.mr_n59226912)
print v(xbgr.mr_n59227680)
print v(xbgr.mr_n59228656)
print v(xbgr.mr_n59229136)
print v(xbgr.mr_n59292336)
print v(xbgr.mr_n59309072)
print v(xbgr.mr_n59312480)
print v(xbgr.mr_n59314512)
print v(xbgr.mr_n59323728)
print v(xbgr.mr_n59324016)
print v(xbgr.mr_n59324720)
print v(xbgr.mr_n59325312)
print v(xbgr.mr_n59325488)
print v(xbgr.mr_n59325664)
print v(xbgr.mr_n59327264)
print v(xbgr.mr_n59327904)
print v(xbgr.mr_n59378000)
print v(xbgr.mr_n59382672)
print v(xbgr.mr_n59384224)
print v(xbgr.mr_n59392464)
print v(xbgr.mr_n59426832)
print v(xbgr.mr_n59427088)
print v(xbgr.mr_n59427936)
print v(xbgr.mr_n59439440)
print v(xbgr.mr_n59439760)
print v(xbgr.mr_n59441312)
print v(xbgr.mr_n59442016)
print v(xbgr.mr_n59443664)
print v(xbgr.mr_n59444368)
print v(xbgr.mr_n59445952)
print v(xbgr.mr_n59560752)
print v(xbgr.mr_n59560944)
print v(xbgr.mr_n59561136)
print v(xbgr.mr_n59561328)
print v(xbgr.mr_n59561520)
print v(xbgr.mr_n59561712)
print v(xbgr.mr_n59620464)
print v(xbgr.mr_n59672016)
print v(xbgr.mr_n59724464)
print v(xbgr.mr_n59724656)
print v(xbgr.mr_n59810736)
print v(xbgr.mr_n59815328)
print v(xbgr.mr_n59823920)
print v(xbgr.mr_n59825632)
print v(xbgr.mr_n59826224)
print v(xbgr.mr_n59836960)
print v(xbgr.mr_n59839200)
print v(xbgr.mr_n59842784)
print v(xbgr.mr_n59846688)
print v(xbgr.mr_n59852528)
print v(xbgr.mr_n59983280)
print v(xbgr.mr_n59984192)
print v(xbgr.mr_n59986416)
print v(xbgr.mr_n59986752)
print v(xbgr.mr_n59988208)
print v(xbgr.mr_n59988912)
print v(xbgr.mr_n59989120)
print v(xbgr.mr_n59989616)
print v(xbgr.mr_n59990320)
print v(xbgr.mr_n59991024)
print v(xbgr.mr_n59991296)
print v(xbgr.mr_n59991440)
print v(xbgr.mr_n59991584)
print v(xbgr.mr_n59991872)
print v(xbgr.mr_n59992160)
print v(xbgr.mr_n59992864)
print v(xbgr.mr_n59995712)
print v(xbgr.mr_n59996320)
print v(xbgr.mr_n59997232)
print v(xbgr.mr_n59997728)
print v(xbgr.mr_n59997904)
print v(xbgr.mr_n59998144)
print v(xbgr.mr_n59999744)
print v(xbgr.mr_n60000128)
print v(xbgr.mr_n60001200)
print v(xbgr.mr_n60001648)
print v(xbgr.mr_n60001760)
print v(xbgr.mr_n60002016)
print v(xbgr.mr_n60003664)
print v(xbgr.mr_n60003776)
print v(xbgr.mr_n60003888)
print v(xbgr.mr_n60004000)
print v(xbgr.mr_n60004576)
print v(xbgr.mr_n60004848)
print v(xbgr.mr_n60006960)
print v(xbgr.mr_n60007424)
print v(xbgr.mr_n60007888)
print v(xbgr.mr_n60008352)
print v(xbgr.mr_n60008816)
print v(xbgr.mr_n60009280)
print v(xbgr.mr_n60009744)
print v(xbgr.mr_n60010208)
print v(xbgr.mr_n60010672)
print v(xbgr.mr_n60011136)
print v(xbgr.mr_n60011600)
print v(xbgr.mr_n60014384)
print v(xbgr.mr_n60015952)
print v(xbgr.mr_n60016736)
print v(xbgr.mr_n60018864)
print v(xbgr.mr_n60019296)
print v(xbgr.mr_n60021296)
print v(xbgr.mr_n60021840)
print v(xbgr.mr_n60023056)
print v(xbgr.mr_n60023904)
print v(xbgr.mr_n60025120)
print v(xbgr.mr_n60026160)
print v(xbgr.mr_n60027312)
print v(xbgr.mr_n60028240)
print v(xbgr.mr_n60028416)
print v(xbgr.mr_n60028592)
print v(xbgr.mr_n60029744)
print v(xbgr.mr_n60030416)
print v(xbgr.mr_n60030960)
print v(xbgr.mr_n60032672)
print v(xbgr.mr_n60034176)
print v(xbgr.mr_n60034656)
print v(xbgr.mr_n60034992)
print v(xbgr.mr_n60036464)
print v(xbgr.mr_n60036896)
print v(xbgr.mr_n60037904)
print v(xbgr.mr_n60039712)
print v(xbgr.mr_n60043680)
print v(xbgr.mr_n60044032)
print v(xbgr.mr_n60044208)
print v(xbgr.mr_n60044640)
print v(xbgr.mr_n60044912)
print v(xbgr.mr_n60048112)
print v(xbgr.mr_n60048864)
print v(xbgr.mr_n60049568)
print v(xbgr.mr_n60049840)
print v(xbgr.mr_n60050544)
print v(xbgr.mr_n60051072)
print v(xbgr.mr_n60053360)
print v(xbgr.mr_n60055472)
print v(xbgr.mr_n60056880)
print v(xbgr.mr_n60057312)
print v(xbgr.mr_n60058016)
print v(xbgr.mr_n60061040)
print v(xbgr.mr_n60061536)
print v(xbgr.mr_n60062944)
print v(xbgr.mr_n60063920)
print v(xbgr.mr_n60066464)
print v(xbgr.mr_n60066672)
print v(xbgr.mr_n60067440)
print v(xbgr.mr_n60067872)
print v(xbgr.mr_n60068576)
print v(xbgr.mr_n60068784)
print v(xbgr.mr_n60069280)
print v(xbgr.mr_n60070080)
print v(xbgr.mr_n60070256)
print v(xbgr.mr_n60074912)
print v(xbgr.mr_n60075712)
print v(xbgr.mr_n60075920)
print v(xbgr.mr_n60079136)
print v(xbgr.mr_n60079344)
print v(xbgr.mr_n60080544)
print v(xbgr.mr_n60081424)
print v(xbgr.mr_n60081984)
print v(xbgr.mr_n60083248)
print v(xbgr.mr_n60083568)
print v(xbgr.mr_n60085616)
print v(xbgr.mr_n60087856)
print v(xbgr.mr_n60088128)
print v(xbgr.mr_n60088688)
print v(xbgr.mr_n60089840)
print v(xbgr.mr_n60090336)
print v(xbgr.mr_n60090592)
print v(xbgr.mr_n60090736)
print v(xbgr.mr_n60091872)
print v(xbgr.mr_n60092688)
print v(xbgr.mr_n60092880)
print v(xbgr.mr_n60093744)
print v(xbgr.mr_n60094208)
print v(xbgr.mr_n60094672)
print v(xbgr.mr_n60095136)
print v(xbgr.mr_n60095600)
print v(xbgr.mr_n60096064)
print v(xbgr.mr_n60096528)
print v(xbgr.mr_n60096992)
print v(xbgr.mr_n60097456)
print v(xbgr.mr_n60097920)
print v(xbgr.mr_n60098384)
print v(xbgr.mr_n60100112)
print v(xbgr.mr_n60103504)
print v(xbgr.mr_n60103744)
print v(xbgr.mr_n60103984)
print v(xbgr.mr_n60104960)
print v(xbgr.mr_n60105328)
print v(xbgr.mr_n60105904)
print v(xbgr.mr_n60107088)
print v(xbgr.mr_n60110800)
print v(xbgr.mr_n60111040)
print v(xbgr.mr_n60115968)
print v(xbgr.mr_n60116576)
print v(xbgr.mr_n60118336)
print v(xbgr.mr_n60119248)
print v(xbgr.mr_n60119552)
print v(xbgr.mr_n60119920)
print v(xbgr.mr_n60120352)
print v(xbgr.mr_n60120832)
print v(xbgr.mr_n60122048)
print v(xbgr.mr_n60124416)
print v(xbgr.mr_n60124528)
print v(xbgr.mr_n60125328)
print v(xbgr.mr_n60126848)
print v(xbgr.mr_n60127152)
print v(xbgr.mr_n60127952)
print v(xbgr.mr_n60128768)
print v(xbgr.mr_n60128976)
print v(xbgr.mr_n60129776)
print v(xbgr.mr_n60130912)
print v(xbgr.mr_n60132176)
print v(xbgr.mr_n60133632)
print v(xbgr.mr_n60133904)
print v(xbgr.mr_n60134208)
print v(xbgr.mr_n60135584)
print v(xbgr.mr_n60136096)
print v(xbgr.mr_n60136832)
print v(xbgr.mr_n60141296)
print v(xbgr.mr_n60142336)
print v(xbgr.mr_n60142576)
print v(xbgr.mr_n60142768)
print v(xbgr.mr_n60143584)
print v(xbgr.mr_n60144880)
print v(xbgr.mr_n60145344)
print v(xbgr.mr_n60145808)
print v(xbgr.mr_n60146272)
print v(xbgr.mr_n60146736)
print v(xbgr.mr_n60147200)
print v(xbgr.mr_n60147664)
print v(xbgr.mr_n60148128)
print v(xbgr.mr_n60148592)
print v(xbgr.mr_n60149056)
print v(xbgr.mr_n60149520)
print v(xbgr.mr_n60149984)
print v(xbgr.mr_n60150448)
print v(xbgr.mr_n60150912)
print v(xbgr.mr_n60151376)
print v(xbgr.mr_n60151840)
print v(xbgr.mr_n60152304)
print v(xbgr.mr_n60152768)
print v(xbgr.mr_n60153232)
print v(xbgr.mr_n60153696)
print v(xbgr.mr_n60154160)
print v(xbgr.mr_n60154624)
print v(xbgr.mr_n60155088)
print v(xbgr.mr_n60155552)
print v(xbgr.mr_n60156016)
print v(xbgr.mr_n60156480)
print v(xbgr.mr_n60156752)
print v(xbgr.mr_n60156944)
print v(xbgr.mr_n60157408)
print v(xbgr.mr_n60157872)
print v(xbgr.mr_n60158336)
print v(xbgr.mr_n60158800)
print v(xbgr.mr_n60159264)
print v(xbgr.mr_n60159728)
print v(xbgr.mr_n60160192)
print v(xbgr.mr_n60160656)
print v(xbgr.mr_n60161120)
print v(xbgr.mr_n60161584)
print v(xbgr.mr_n60162048)
print v(xbgr.mr_n60162512)
print v(xbgr.mr_n60162976)
print v(xbgr.mr_n60163440)
print v(xbgr.mr_n60163904)
print v(xbgr.mr_n60164368)
print v(xbgr.mr_n60164832)
print v(xbgr.mr_n60165296)
print v(xbgr.mr_n60165760)
print v(xbgr.mr_n60166224)
print v(xbgr.mr_n60166688)
print v(xbgr.mr_n60167152)
print v(xbgr.mr_n60167616)
print v(xbgr.mr_n60168080)
print v(xbgr.mr_n60168544)
print v(xbgr.mr_n60169008)
print v(xbgr.mr_n60169472)
print v(xbgr.mr_n60169936)
print v(xbgr.mr_n60170400)
print v(xbgr.mr_n60170864)
print v(xbgr.mr_n60171328)
print v(xbgr.mr_n60171792)
print v(xbgr.mr_n60172256)
print v(xbgr.mr_n60172720)
print v(xbgr.mr_n60173184)
print v(xbgr.mr_n60173648)
print v(xbgr.mr_n60174112)
print v(xbgr.mr_n60174576)
print v(xbgr.mr_n60175040)
print v(xbgr.mr_n60175504)
print v(xbgr.mr_n60175968)
print v(xbgr.mr_n60176432)
print v(xbgr.mr_n60176896)
print v(xbgr.mr_n60177360)
print v(xbgr.mr_n60177824)
print v(xbgr.mr_n60178288)
print v(xbgr.mr_n60178752)
print v(xbgr.mr_n60179104)
print v(xbgr.mr_n60179216)
print v(xbgr.mr_n60179680)
print v(xbgr.mr_n60180144)
print v(xbgr.mr_n60180608)
print v(xbgr.mr_n60181072)
print v(xbgr.mr_n60181536)
print v(xbgr.mr_n60182000)
print v(xbgr.mr_n60182464)
print v(xbgr.mr_n60182928)
print v(xbgr.mr_n60183328)
print v(xbgr.mr_n60183792)
print v(xbgr.mr_n60184256)
print v(xbgr.mr_n60184720)
print v(xbgr.mr_n60185168)
print v(xbgr.mr_n60185632)
print v(xbgr.mr_n60186096)
print v(xbgr.mr_n60186560)
print v(xbgr.mr_n60187024)
print v(xbgr.mr_n60187376)
print v(xbgr.mr_n60187488)
print v(xbgr.mr_n60187952)
print v(xbgr.mr_n60188416)
print v(xbgr.mr_n60188880)
print v(xbgr.mr_n60189344)
print v(xbgr.mr_n60189808)
print v(xbgr.mr_n60190272)
print v(xbgr.mr_n60190736)
print v(xbgr.mr_n60191200)
print v(xbgr.mr_n60191664)
print v(xbgr.mr_n60192128)
print v(xbgr.mr_n60192592)
print v(xbgr.mr_n60193056)
print v(xbgr.mr_n60193520)
print v(xbgr.mr_n60193984)
print v(xbgr.mr_n60194448)
print v(xbgr.mr_n60194912)
print v(xbgr.mr_n60195376)
print v(xbgr.mr_n60195840)
print v(xbgr.mr_n60196304)
print v(xbgr.mr_n60196768)
print v(xbgr.mr_n60197232)
print v(xbgr.mr_n60197696)
print v(xbgr.mr_n60198160)
print v(xbgr.mr_n60198432)
print v(xbgr.mr_n60198624)
print v(xbgr.mr_n60199088)
print v(xbgr.mr_n60199552)
print v(xbgr.mr_n60200016)
print v(xbgr.mr_n60200128)
print v(xbgr.mr_n60200672)
print v(xbgr.mr_n60200896)
print v(xbgr.mr_n60201408)
print v(xbgr.mr_n60201632)
print v(xbgr.mr_n60202144)
print v(xbgr.mr_n60202368)
print v(xbgr.mr_n60202880)
print v(xbgr.mr_n60202992)
print v(xbgr.mr_n60203104)
print v(xbgr.mr_n60203616)
print v(xbgr.mr_n60203728)
print v(xbgr.mr_n60203840)
print v(xbgr.mr_n60204352)
print v(xbgr.mr_n60204464)
print v(xbgr.mr_n60204576)
print v(xbgr.mr_n60205088)
print v(xbgr.mr_n60205360)
print v(xbgr.mr_n60205632)
print v(xbgr.mr_n60205904)
print v(xbgr.mr_n60206016)
print v(xbgr.mr_n60206128)
print v(xbgr.mr_n60206640)
print v(xbgr.mr_n60206912)
print v(xbgr.mr_n60207184)
print v(xbgr.mr_n60207456)
print v(xbgr.mr_n60207728)
print v(xbgr.mr_n60208272)
print v(xbgr.mr_n60208544)
print v(xbgr.mr_n60208816)
print v(xbgr.mr_n60209088)
print v(xbgr.mr_n60209360)
print v(xbgr.mr_n60209632)
print v(xbgr.mr_n60209904)
print v(xbgr.mr_n60210176)
print v(xbgr.mr_n60210448)
print v(xbgr.mr_n60210720)
print v(xbgr.mr_n60210992)
print v(xbgr.mr_n60211264)
print v(xbgr.mr_n60211536)
print v(xbgr.mr_n60211808)
print v(xbgr.mr_n60212080)
print v(xbgr.mr_n60212352)
print v(xbgr.mr_n60212624)
print v(xbgr.mr_n60212896)
print v(xbgr.mr_n60213168)
print v(xbgr.mr_n60213504)
print v(xbgr.mr_n60213968)
print v(xbgr.mr_n60214432)
print v(xbgr.mr_n60214896)
print v(xbgr.mr_n60215360)
print v(xbgr.mr_n60215824)
print v(xbgr.mr_n60216176)
print v(xbgr.mr_n60216288)
print v(xbgr.mr_n60216752)
print v(xbgr.mr_n60217216)
print v(xbgr.mr_n60217680)
print v(xbgr.mr_n60218144)
print v(xbgr.mr_n60218608)
print v(xbgr.mr_n60226304)
print v(xbgr.mr_n60229328)
print v(xbgr.mr_n60230272)
print v(xbgr.mr_n60231168)
print v(xbgr.mr_n60235600)
print v(xbgr.mr_n60235792)
print v(xbgr.mr_n60236384)
print v(xbgr.mr_n60236976)
print v(xbgr.mr_n60237568)
print v(xbgr.mr_n60238160)
print v(xbgr.mr_n60238752)
print v(xbgr.mr_n60239344)
print v(xbgr.mr_n60239936)
print v(xbgr.mr_n60240048)
print v(xbgr.mr_n60240672)
print v(xbgr.mr_n60241376)
print v(xbgr.mr_n60241840)
print v(xbgr.mr_n60250480)
print v(xbgr.mr_n60252560)
print v(xbgr.mr_n60255584)
print v(xbgr.mr_n60267360)
print v(xbgr.mr_n60267680)
print v(xbgr.mr_n60271680)
print v(xbgr.mr_n60274368)
print v(xbgr.mr_n60277904)
print v(xbgr.mr_n60287760)
print v(xbgr.mr_n60289696)
print v(xbgr.mr_n60297088)
print v(xbgr.mr_n60297440)
print v(xbgr.mr_n60297952)
print v(xbgr.mr_n60299840)
print v(xbgr.mr_n60300384)
print v(xbgr.mr_n60300496)
print v(xbgr.mr_n60301328)
print v(xbgr.mr_n60301440)
print v(xbgr.mr_n60302240)
print v(xbgr.mr_n60302352)
print v(xbgr.mr_n60303152)
print v(xbgr.mr_n60304064)
print v(xbgr.mr_n60304176)
print v(xbgr.mr_n60304976)
print v(xbgr.mr_n60305888)
print v(xbgr.mr_n60307520)
print v(xbgr.mr_n60308224)
print v(xbgr.mr_n60309152)
print v(xbgr.mr_n60309456)
print v(xbgr.mr_n60310000)
print v(xbgr.mr_n60310608)
print v(xbgr.mr_n60311824)
print v(xbgr.mr_n60312688)
print v(xbgr.mr_n60314752)
print v(xbgr.mr_n60315840)
print v(xbgr.mr_n60316080)
print v(xbgr.mr_n60316992)
print v(xbgr.mr_n60317296)
print v(xbgr.mr_n60322112)
print v(xbgr.mr_n60324592)
print v(xbgr.mr_n60325200)
print v(xbgr.mr_n60326352)
print v(xbgr.mr_n60326784)
print v(xbgr.mr_n60328912)
print v(xbgr.mr_n60329760)
print v(xbgr.mr_n60330672)
print v(xbgr.mr_n60331152)
print v(xbgr.mr_n60333200)
print v(xbgr.mr_n60335232)
print v(xbgr.mr_n60336752)
print v(xbgr.mr_n60337120)
print v(xbgr.mr_n60337360)
print v(xbgr.mr_n60337664)
print v(xbgr.mr_n60339504)
print v(xbgr.mr_n60339680)
print v(xbgr.mr_n60340288)
print v(xbgr.mr_n60340464)
print v(xbgr.mr_n60340960)
print v(xbgr.mr_n60341376)
print v(xbgr.mr_n60342208)
print v(xbgr.mr_n60342384)
print v(xbgr.mr_n60343952)
print v(xbgr.mr_n60344336)
print v(xbgr.mr_n60344768)
print v(xbgr.mr_n60345168)
print v(xbgr.mr_n60345968)
print v(xbgr.mr_n60346176)
print v(xbgr.mr_n60346976)
print v(xbgr.mr_n60351456)
print v(xbgr.mr_n60353536)
print v(xbgr.mr_n60354224)
print v(xbgr.mr_n60355424)
print v(xbgr.mr_n60356080)
print v(xbgr.mr_n60356944)
print v(xbgr.mr_n60357120)
print v(xbgr.mr_n60357456)
print v(xbgr.mr_n60358400)
print v(xbgr.mr_n60359760)
print v(xbgr.mr_n60360288)
print v(xbgr.mr_n60360944)
print v(xbgr.mr_n60361536)
print v(xbgr.mr_n60362128)
print v(xbgr.mr_n60362720)
print v(xbgr.mr_n60363312)
print v(xbgr.mr_n60363840)
print v(xbgr.mr_n60364272)
print v(xbgr.mr_n60364496)
print v(xbgr.mr_n60365088)
print v(xbgr.mr_n60365680)
print v(xbgr.mr_n60366208)
print v(xbgr.mr_n60366864)
print v(xbgr.mr_n60367456)
print v(xbgr.mr_n60368048)
print v(xbgr.mr_n60368640)
print v(xbgr.mr_n60369232)
print v(xbgr.mr_n60369824)
print v(xbgr.mr_n60370416)
print v(xbgr.mr_n60370944)
print v(xbgr.mr_n60371600)
print v(xbgr.mr_n60372192)
print v(xbgr.mr_n60372784)
print v(xbgr.mr_n60373376)
print v(xbgr.mr_n60373968)
print v(xbgr.mr_n60374560)
print v(xbgr.mr_n60375024)
print v(xbgr.mr_n60375136)
print v(xbgr.mr_n60377568)
print v(xbgr.mr_n60378160)
print v(xbgr.mr_n60378672)
print v(xbgr.mr_n60379344)
print v(xbgr.mr_n60379872)
print v(xbgr.mr_n60380528)
print v(xbgr.mr_n60381120)
print v(xbgr.mr_n60381712)
print v(xbgr.mr_n60382304)
print v(xbgr.mr_n60382832)
print v(xbgr.mr_n60383408)
print v(xbgr.mr_n60384080)
print v(xbgr.mr_n60384592)
print v(xbgr.mr_n60385264)
print v(xbgr.mr_n60385856)
print v(xbgr.mr_n60386448)
print v(xbgr.mr_n60386976)
print v(xbgr.mr_n60387568)
print v(xbgr.mr_n60388224)
print v(xbgr.mr_n60388816)
print v(xbgr.mr_n60389408)
print v(xbgr.mr_n60390000)
print v(xbgr.mr_n60390656)
print v(xbgr.mr_n60391184)
print v(xbgr.mr_n60391712)
print v(xbgr.mr_n60392368)
print v(xbgr.mr_n60392960)
print v(xbgr.mr_n60393472)
print v(xbgr.mr_n60394064)
print v(xbgr.mr_n60394736)
print v(xbgr.mr_n60395328)
print v(xbgr.mr_n60395920)
print v(xbgr.mr_n60396336)
print v(xbgr.mr_n60396512)
print v(xbgr.mr_n60397104)
print v(xbgr.mr_n60397696)
print v(xbgr.mr_n60398288)
print v(xbgr.mr_n60398880)
print v(xbgr.mr_n60399408)
print v(xbgr.mr_n60399984)
print v(xbgr.mr_n60400592)
print v(xbgr.mr_n60401248)
print v(xbgr.mr_n60401840)
print v(xbgr.mr_n60402352)
print v(xbgr.mr_n60403024)
print v(xbgr.mr_n60403552)
print v(xbgr.mr_n60404208)
print v(xbgr.mr_n60404736)
print v(xbgr.mr_n60405392)
print v(xbgr.mr_n60405984)
print v(xbgr.mr_n60406576)
print v(xbgr.mr_n60407168)
print v(xbgr.mr_n60407504)
print v(xbgr.mr_n60407760)
print v(xbgr.mr_n60408272)
print v(xbgr.mr_n60408944)
print v(xbgr.mr_n60409536)
print v(xbgr.mr_n60410128)
print v(xbgr.mr_n60410720)
print v(xbgr.mr_n60411376)
print v(xbgr.mr_n60411840)
print v(xbgr.mr_n60412432)
print v(xbgr.mr_n60413088)
print v(xbgr.mr_n60413680)
print v(xbgr.mr_n60414272)
print v(xbgr.mr_n60414864)
print v(xbgr.mr_n60415456)
print v(xbgr.mr_n60415984)
print v(xbgr.mr_n60416576)
print v(xbgr.mr_n60417232)
print v(xbgr.mr_n60417744)
print v(xbgr.mr_n60418416)
print v(xbgr.mr_n60419008)
print v(xbgr.mr_n60419600)
print v(xbgr.mr_n60420192)
print v(xbgr.mr_n60420784)
print v(xbgr.mr_n60421312)
print v(xbgr.mr_n60421968)
print v(xbgr.mr_n60422560)
print v(xbgr.mr_n60422976)
print v(xbgr.mr_n60423152)
print v(xbgr.mr_n60423664)
print v(xbgr.mr_n60424272)
print v(xbgr.mr_n60424928)
print v(xbgr.mr_n60425520)
print v(xbgr.mr_n60426032)
print v(xbgr.mr_n60426624)
print v(xbgr.mr_n60427296)
print v(xbgr.mr_n60427888)
print v(xbgr.mr_n60428416)
print v(xbgr.mr_n60429008)
print v(xbgr.mr_n60429664)
print v(xbgr.mr_n60430256)
print v(xbgr.mr_n60430848)
print v(xbgr.mr_n60431440)
print v(xbgr.mr_n60432096)
print v(xbgr.mr_n60432624)
print v(xbgr.mr_n60433152)
print v(xbgr.mr_n60433808)
print v(xbgr.mr_n60434400)
print v(xbgr.mr_n60434992)
print v(xbgr.mr_n60435584)
print v(xbgr.mr_n60436176)
print v(xbgr.mr_n60436688)
print v(xbgr.mr_n60437360)
print v(xbgr.mr_n60437952)
print v(xbgr.mr_n60439136)
print v(xbgr.mr_n60439728)
print v(xbgr.mr_n60440320)
print v(xbgr.mr_n60441248)
print v(xbgr.mr_n60441648)
print v(xbgr.mr_n60442048)
print v(xbgr.mr_n60442848)
print v(xbgr.mr_n60443248)
print v(xbgr.mr_n60443648)
print v(xbgr.mr_n60444048)
print v(xbgr.mr_n60444448)
print v(xbgr.mr_n60444848)
print v(xbgr.mr_n60445248)
print v(xbgr.mr_n60450720)
print v(xbgr.mr_n60450976)
print v(xbgr.mr_n60465872)
print v(xbgr.mr_n60466800)
print v(xbgr.mr_n60468976)
print v(xbgr.mr_n60471568)
print v(xbgr.mr_n60472448)
print v(xbgr.mr_n60472592)
print v(xbgr.mr_n60473472)
print v(xbgr.mr_n60474064)
print v(xbgr.mr_n60474656)
print v(xbgr.mr_n60475248)
print v(xbgr.mr_n60475776)
print v(xbgr.mr_n60476432)
print v(xbgr.mr_n60477552)
print v(xbgr.mr_n60478208)
print v(xbgr.mr_n60478320)
print v(xbgr.mr_n60478736)
print v(xbgr.mr_n60479392)
print v(xbgr.mr_n60490800)
print v(xbgr.mr_n60493824)
print v(xbgr.mr_n60502640)
print v(xbgr.mr_n60508144)
print v(xbgr.mr_n60509040)
print v(xbgr.mr_n60509152)
print v(xbgr.mr_n60510800)
print v(xbgr.mr_n60510944)
print v(xbgr.mr_n60512272)
print v(xbgr.mr_n60512432)
print v(xbgr.mr_n60512752)
print v(xbgr.mr_n60513168)
print v(xbgr.mr_n60515312)
print v(xbgr.mr_n60515568)
print v(xbgr.mr_n60517840)
print v(xbgr.mr_n60518432)
print v(xbgr.mr_n60519024)
print v(xbgr.mr_n60519616)
print v(xbgr.mr_n60520208)
print v(xbgr.mr_n60520800)
print v(xbgr.mr_n60521216)
print v(xbgr.mr_n60521984)
print v(xbgr.mr_n60522576)
print v(xbgr.mr_n60523168)
print v(xbgr.mr_n60523760)
print v(xbgr.mr_n60524352)
print v(xbgr.mr_n60524944)
print v(xbgr.mr_n60525536)
print v(xbgr.mr_n60526128)
print v(xbgr.mr_n60526720)
print v(xbgr.mr_n60527312)
print v(xbgr.mr_n60527904)
print v(xbgr.mr_n60529088)
print v(xbgr.mr_n60529680)
print v(xbgr.mr_n60530272)
print v(xbgr.mr_n60530864)
print v(xbgr.mr_n60531456)
print v(xbgr.mr_n60532048)
print v(xbgr.mr_n60532640)
print v(xbgr.mr_n60533232)
print v(xbgr.mr_n60533824)
print v(xbgr.mr_n60534416)
print v(xbgr.mr_n60535008)
print v(xbgr.mr_n60536192)
print v(xbgr.mr_n60536784)
print v(xbgr.mr_n60537376)
print v(xbgr.mr_n60537968)
print v(xbgr.mr_n60538560)
print v(xbgr.mr_n60539152)
print v(xbgr.mr_n60539744)
print v(xbgr.mr_n60540336)
print v(xbgr.mr_n60540928)
print v(xbgr.mr_n60541520)
print v(xbgr.mr_n60542112)
print v(xbgr.mr_n60543296)
print v(xbgr.mr_n60543888)
print v(xbgr.mr_n60544480)
print v(xbgr.mr_n60545072)
print v(xbgr.mr_n60545664)
print v(xbgr.mr_n60546256)
print v(xbgr.mr_n60546848)
print v(xbgr.mr_n60547440)
print v(xbgr.mr_n60547856)
print v(xbgr.mr_n60548032)
print v(xbgr.mr_n60548624)
print v(xbgr.mr_n60549216)
print v(xbgr.mr_n60549808)
print v(xbgr.mr_n60550400)
print v(xbgr.mr_n60550992)
print v(xbgr.mr_n60551584)
print v(xbgr.mr_n60551920)
print v(xbgr.mr_n60552176)
print v(xbgr.mr_n60552768)
print v(xbgr.mr_n60553360)
print v(xbgr.mr_n60553952)
print v(xbgr.mr_n60554544)
print v(xbgr.mr_n60555136)
print v(xbgr.mr_n60555728)
print v(xbgr.mr_n60556320)
print v(xbgr.mr_n60557504)
print v(xbgr.mr_n60557920)
print v(xbgr.mr_n60558096)
print v(xbgr.mr_n60558688)
print v(xbgr.mr_n60559280)
print v(xbgr.mr_n60559872)
print v(xbgr.mr_n60560464)
print v(xbgr.mr_n60561056)
print v(xbgr.mr_n60561648)
print v(xbgr.mr_n60562240)
print v(xbgr.mr_n60562832)
print v(xbgr.mr_n60563424)
print v(xbgr.mr_n60564016)
print v(xbgr.mr_n60564608)
print v(xbgr.mr_n60565200)
print v(xbgr.mr_n60565792)
print v(xbgr.mr_n60566384)
print v(xbgr.mr_n60566976)
print v(xbgr.mr_n60567568)
print v(xbgr.mr_n60568160)
print v(xbgr.mr_n60568752)
print v(xbgr.mr_n60569344)
print v(xbgr.mr_n60569936)
print v(xbgr.mr_n60570528)
print v(xbgr.mr_n60571120)
print v(xbgr.mr_n60571712)
print v(xbgr.mr_n60572304)
print v(xbgr.mr_n60572896)
print v(xbgr.mr_n60574080)
print v(xbgr.mr_n60574672)
print v(xbgr.mr_n60575264)
print v(xbgr.mr_n60575856)
print v(xbgr.mr_n60576448)
print v(xbgr.mr_n60577040)
print v(xbgr.mr_n60577632)
print v(xbgr.mr_n60578224)
print v(xbgr.mr_n60578816)
print v(xbgr.mr_n60579408)
print v(xbgr.mr_n60580000)
print v(xbgr.mr_n60580592)
print v(xbgr.mr_n60581184)
print v(xbgr.mr_n60581776)
print v(xbgr.mr_n60582368)
print v(xbgr.mr_n60582960)
print v(xbgr.mr_n60583552)
print v(xbgr.mr_n60584144)
print v(xbgr.mr_n60584736)
print v(xbgr.mr_n60585328)
print v(xbgr.mr_n60585920)
print v(xbgr.mr_n60586512)
print v(xbgr.mr_n60587104)
print v(xbgr.mr_n60587696)
print v(xbgr.mr_n60588224)
print v(xbgr.mr_n60588688)
print v(xbgr.mr_n60589152)
print v(xbgr.mr_n60589264)
print v(xbgr.mr_n60589616)
print v(xbgr.mr_n60590080)
print v(xbgr.mr_n60590192)
print v(xbgr.mr_n60590544)
print v(xbgr.mr_n60590656)
print v(xbgr.mr_n60592048)
print v(xbgr.mr_n60592304)
print v(xbgr.mr_n60592640)
print v(xbgr.mr_n60593280)
print v(xbgr.mr_n60593680)
print v(xbgr.mr_n60594080)
print v(xbgr.mr_n60594480)
print v(xbgr.mr_n60594880)
print v(xbgr.mr_n60595280)
print v(xbgr.mr_n60595680)
print v(xbgr.mr_n60596000)
print v(xbgr.mr_n60596400)
print v(xbgr.mr_n60596800)
print v(xbgr.mr_n60597200)
print v(xbgr.mr_n60597600)
print v(xbgr.mr_n60598000)
print v(xbgr.mr_n60598400)
print v(xbgr.mr_n60598800)
print v(xbgr.mr_n60599200)
print v(xbgr.mr_n60599600)
print v(xbgr.mr_n60600000)
print v(xbgr.mr_n60600400)
print v(xbgr.mr_n60600800)
print v(xbgr.mr_n60601200)
print v(xbgr.mr_n60601600)
print v(xbgr.mr_n60602000)
print v(xbgr.mr_n60602400)
print v(xbgr.mr_n60602800)
print v(xbgr.mr_n60603200)
print v(xbgr.mr_n60603600)
print v(xbgr.mr_n60604000)
print v(xbgr.mr_n60604400)
print v(xbgr.mr_n60604800)
print v(xbgr.mr_n60605200)
print v(xbgr.mr_n60605600)
print v(xbgr.mr_n60606000)
print v(xbgr.mr_n60606400)
print v(xbgr.mr_n60606800)
print v(xbgr.mr_n60607200)
print v(xbgr.mr_n60607728)
print v(xbgr.mr_n60608320)
print v(xbgr.mr_n60608912)
print v(xbgr.mr_n60609504)
print v(xbgr.mr_n60610096)
print v(xbgr.mr_n60610688)
print v(xbgr.mr_n60611280)
print v(xbgr.mr_n60611872)
print v(xbgr.mr_n60612464)
print v(xbgr.mr_n60613056)
print v(xbgr.mr_n60613392)
print v(xbgr.mr_n60613648)
print v(xbgr.mr_n60614944)
print v(xbgr.mr_n60615600)
print v(xbgr.mr_n60615968)
print v(xbgr.mr_n60618016)
print v(xbgr.mr_n60618656)
print v(xbgr.mr_n60627680)
print v(xbgr.mr_n60628128)
print v(xbgr.mr_n60629216)
print v(xbgr.mr_n60630736)
print v(xbgr.mr_n60631248)
print v(xbgr.mr_n60631840)
print v(xbgr.mr_n60632432)
print v(xbgr.mr_n60633024)
print v(xbgr.mr_n60633616)
print v(xbgr.mr_n60634208)
print v(xbgr.mr_n60634800)
print v(xbgr.mr_n60635392)
print v(xbgr.mr_n60635984)
print v(xbgr.mr_n60636576)
print v(xbgr.mr_n60637168)
print v(xbgr.mr_n60637760)
print v(xbgr.mr_n60638352)
print v(xbgr.mr_n60638944)
print v(xbgr.mr_n60639536)
print v(xbgr.mr_n60640128)
print v(xbgr.mr_n60640720)
print v(xbgr.mr_n60641312)
print v(xbgr.mr_n60641904)
print v(xbgr.mr_n60642496)
print v(xbgr.mr_n60643088)
print v(xbgr.mr_n60643680)
print v(xbgr.mr_n60644272)
print v(xbgr.mr_n60644864)
print v(xbgr.mr_n60648592)
print v(xbgr.mr_n60649152)
print v(xbgr.mr_n60649872)
print v(xbgr.mr_n60651696)
print v(xbgr.mr_n60652912)
print v(xbgr.mr_n60654672)
print v(xbgr.mr_n60655152)
print v(xbgr.mr_n60658336)
print v(xbgr.mr_n60659168)
print v(xbgr.mr_n60659344)
print v(xbgr.mr_n60662800)
print v(xbgr.mr_n60663200)
print v(xbgr.mr_n60664704)
print v(xbgr.mr_n60665504)
print v(xbgr.mr_n60666448)
print v(xbgr.mr_n60666720)
print v(xbgr.mr_n60667744)
print v(xbgr.mr_n60669072)
print v(xbgr.mr_n60669680)
print v(xbgr.mr_n60671088)
print v(xbgr.mr_n60672000)
print v(xbgr.mr_n60672976)
print v(xbgr.mr_n60673584)
print v(xbgr.mr_n60674192)
print v(xbgr.mr_n60674688)
print v(xbgr.mr_n60677056)
print v(xbgr.mr_n60677168)
print v(xbgr.mr_n60678080)
print v(xbgr.mr_n60681376)
print v(xbgr.mr_n60682992)
print v(xbgr.mr_n60683856)
print v(xbgr.mr_n60686848)
print v(xbgr.mr_n60694064)
print v(xbgr.mr_n60696240)
print v(xbgr.mr_n60697184)
print v(xbgr.mr_n60697440)
print v(xbgr.mr_n60697808)
print v(xbgr.mr_n60698064)
print v(xbgr.mr_n60698256)
print v(xbgr.mr_n60698624)
print v(xbgr.mr_n60699792)
print v(xbgr.mr_n60700896)
print v(xbgr.mr_n60701008)
print v(xbgr.mr_n60701616)
print v(xbgr.mr_n60702336)
print v(xbgr.mr_n60702448)
print v(xbgr.mr_n60703056)
print v(xbgr.mr_n60703776)
print v(xbgr.mr_n60703888)
print v(xbgr.mr_n60704496)
print v(xbgr.mr_n60705184)
print v(xbgr.mr_n60710288)
print v(xbgr.mr_n60710800)
print v(xbgr.mr_n60711776)
print v(xbgr.mr_n60713056)
print v(xbgr.mr_n60716176)
print v(xbgr.mr_n60724112)
print v(xbgr.mr_n60727008)
print v(xbgr.mr_n60729936)
print v(xbgr.mr_n60731104)
print v(xbgr.mr_n60732368)
print v(xbgr.mr_n60739232)
print v(xbgr.mr_n60741600)
print v(xbgr.mr_n60742896)
print v(xbgr.mr_n60743152)
print v(xbgr.mr_n60743536)
print v(xbgr.mr_n60744192)
print v(xbgr.mr_n60744480)
print v(xbgr.mr_n60744816)
print v(xbgr.mr_n60746368)
print v(xbgr.mr_n60747232)
print v(xbgr.mr_n60747408)
print v(xbgr.mr_n60748688)
print v(xbgr.mr_n60748928)
print v(xbgr.mr_n60750048)
print v(xbgr.mr_n60751232)
print v(xbgr.mr_n60751824)
print v(xbgr.mr_n60752416)
print v(xbgr.mr_n60753600)
print v(xbgr.mr_n60754192)
print v(xbgr.mr_n60754720)
print v(xbgr.mr_n60755376)
print v(xbgr.mr_n60755968)
print v(xbgr.mr_n60756560)
print v(xbgr.mr_n60757152)
print v(xbgr.mr_n60757744)
print v(xbgr.mr_n60758256)
print v(xbgr.mr_n60758928)
print v(xbgr.mr_n60759520)
print v(xbgr.mr_n60760112)
print v(xbgr.mr_n60760704)
print v(xbgr.mr_n60761296)
print v(xbgr.mr_n60761888)
print v(xbgr.mr_n60762480)
print v(xbgr.mr_n60762992)
print v(xbgr.mr_n60764256)
print v(xbgr.mr_n60764848)
print v(xbgr.mr_n60765440)
print v(xbgr.mr_n60766032)
print v(xbgr.mr_n60766624)
print v(xbgr.mr_n60767216)
print v(xbgr.mr_n60767808)
print v(xbgr.mr_n60768400)
print v(xbgr.mr_n60768992)
print v(xbgr.mr_n60769584)
print v(xbgr.mr_n60770176)
print v(xbgr.mr_n60771360)
print v(xbgr.mr_n60771872)
print v(xbgr.mr_n60772480)
print v(xbgr.mr_n60773136)
print v(xbgr.mr_n60773728)
print v(xbgr.mr_n60774320)
print v(xbgr.mr_n60774912)
print v(xbgr.mr_n60775504)
print v(xbgr.mr_n60776096)
print v(xbgr.mr_n60776672)
print v(xbgr.mr_n60777264)
print v(xbgr.mr_n60777840)
print v(xbgr.mr_n60778432)
print v(xbgr.mr_n60779552)
print v(xbgr.mr_n60780128)
print v(xbgr.mr_n60780528)
print v(xbgr.mr_n60781072)
print v(xbgr.mr_n60781776)
print v(xbgr.mr_n60783360)
print v(xbgr.mr_n60784016)
print v(xbgr.mr_n60784528)
print v(xbgr.mr_n60785200)
print v(xbgr.mr_n60785792)
print v(xbgr.mr_n60786384)
print v(xbgr.mr_n60786896)
print v(xbgr.mr_n60787568)
print v(xbgr.mr_n60788160)
print v(xbgr.mr_n60788752)
print v(xbgr.mr_n60789344)
print v(xbgr.mr_n60789936)
print v(xbgr.mr_n60790528)
print v(xbgr.mr_n60791120)
print v(xbgr.mr_n60791776)
print v(xbgr.mr_n60792304)
print v(xbgr.mr_n60792896)
print v(xbgr.mr_n60793488)
print v(xbgr.mr_n60794080)
print v(xbgr.mr_n60794672)
print v(xbgr.mr_n60795264)
print v(xbgr.mr_n60795856)
print v(xbgr.mr_n60796448)
print v(xbgr.mr_n60797040)
print v(xbgr.mr_n60797632)
print v(xbgr.mr_n60798224)
print v(xbgr.mr_n60798816)
print v(xbgr.mr_n60799408)
print v(xbgr.mr_n60800000)
print v(xbgr.mr_n60800592)
print v(xbgr.mr_n60801184)
print v(xbgr.mr_n60801664)
print v(xbgr.mr_n60801776)
print v(xbgr.mr_n60805280)
print v(xbgr.mr_n60805824)
print v(xbgr.mr_n60805968)
print v(xbgr.mr_n60806896)
print v(xbgr.mr_n60807008)
print v(xbgr.mr_n60807120)
print v(xbgr.mr_n60807232)
print v(xbgr.mr_n60807344)
print v(xbgr.mr_n60807536)
print v(xbgr.mr_n60807808)
print v(xbgr.mr_n60808080)
print v(xbgr.mr_n60808352)
print v(xbgr.mr_n60808624)
print v(xbgr.mr_n60808896)
print v(xbgr.mr_n60809168)
print v(xbgr.mr_n60809440)
print v(xbgr.mr_n60809712)
print v(xbgr.mr_n60809984)
print v(xbgr.mr_n60810256)
print v(xbgr.mr_n60810560)
print v(xbgr.mr_n60810960)
print v(xbgr.mr_n60811360)
print v(xbgr.mr_n60811760)
print v(xbgr.mr_n60812160)
print v(xbgr.mr_n60812560)
print v(xbgr.mr_n60812960)
print v(xbgr.mr_n60813360)
print v(xbgr.mr_n60813760)
print v(xbgr.mr_n60814160)
print v(xbgr.mr_n60814560)
print v(xbgr.mr_n60814880)
print v(xbgr.mr_n60815360)
print v(xbgr.mr_n60815760)
print v(xbgr.mr_n60816160)
print v(xbgr.mr_n60816480)
print v(xbgr.mr_n60816960)
print v(xbgr.mr_n60817360)
print v(xbgr.mr_n60817760)
print v(xbgr.mr_n60818080)
print v(xbgr.mr_n60818560)
print v(xbgr.mr_n60818960)
print v(xbgr.mr_n60819360)
print v(xbgr.mr_n60819680)
print v(xbgr.mr_n60820160)
print v(xbgr.mr_n60820560)
print v(xbgr.mr_n60820960)
print v(xbgr.mr_n60821360)
print v(xbgr.mr_n60821760)
print v(xbgr.mr_n60822096)
print v(xbgr.mr_n60822368)
print v(xbgr.mr_n60822640)
print v(xbgr.mr_n60822912)
print v(xbgr.mr_n60823184)
print v(xbgr.mr_n60823456)
print v(xbgr.mr_n60823728)
print v(xbgr.mr_n60824000)
print v(xbgr.mr_n60824272)
print v(xbgr.mr_n60824544)
print v(xbgr.mr_n60824816)
print v(xbgr.mr_n60825088)
print v(xbgr.mr_n60825360)
print v(xbgr.mr_n60825632)
print v(xbgr.mr_n60825904)
print v(xbgr.mr_n60826176)
print v(xbgr.mr_n60826448)
print v(xbgr.mr_n60826720)
print v(xbgr.mr_n60827008)
print v(xbgr.mr_n60827200)
print v(xbgr.mr_n60827392)
print v(xbgr.mr_n60827584)
print v(xbgr.mr_n60827776)
print v(xbgr.mr_n60828864)
print v(xbgr.mr_n60828976)
print v(xbgr.mr_n60832384)
print v(xbgr.mr_n60833216)
print v(xbgr.mr_n60833328)
print v(xbgr.mr_n60834736)
print v(xbgr.mr_n60834848)
print v(xbgr.mr_n60834960)
print v(xbgr.mr_n60835792)
print v(xbgr.mr_n60835904)
print v(xbgr.mr_n60836656)
print v(xbgr.mr_n60838144)
print v(xbgr.mr_n60838976)
print v(xbgr.mr_n60839088)
print v(xbgr.mr_n60840496)
print v(xbgr.mr_n60840608)
print v(xbgr.mr_n60840720)
print v(xbgr.mr_n60841552)
print v(xbgr.mr_n60841664)
print v(xbgr.mr_n60842416)
print v(xbgr.mr_n60843904)
print v(xbgr.mr_n60844736)
print v(xbgr.mr_n60844848)
print v(xbgr.mr_n60846256)
print v(xbgr.mr_n60846368)
print v(xbgr.mr_n60846480)
print v(xbgr.mr_n60847312)
print v(xbgr.mr_n60847424)
print v(xbgr.mr_n60848176)
print v(xbgr.mr_n60849664)
print v(xbgr.mr_n60850496)
print v(xbgr.mr_n60850608)
print v(xbgr.mr_n60852016)
print v(xbgr.mr_n60852128)
print v(xbgr.mr_n60852240)
print v(xbgr.mr_n60853072)
print v(xbgr.mr_n60853184)
print v(xbgr.mr_n60853936)
print v(xbgr.mr_n60855424)
print v(xbgr.mr_n60856256)
print v(xbgr.mr_n60856368)
print v(xbgr.mr_n60857776)
print v(xbgr.mr_n60857888)
print v(xbgr.mr_n60858000)
print v(xbgr.mr_n60858832)
print v(xbgr.mr_n60858944)
print v(xbgr.mr_n60859696)
print v(xbgr.mr_n60861184)
print v(xbgr.mr_n60862016)
print v(xbgr.mr_n60862128)
print v(xbgr.mr_n60865680)
print v(xbgr.mr_n60866096)
print v(xbgr.mr_n60866976)
print v(xbgr.mr_n60867504)
print v(xbgr.mr_n60867680)
print v(xbgr.mr_n60867856)
print v(xbgr.mr_n60868640)
print v(xbgr.mr_n60868816)
print v(xbgr.mr_n60869440)
print v(xbgr.mr_n60869616)
print v(xbgr.mr_n60870176)
print v(xbgr.mr_n60870640)
print v(xbgr.mr_n60870816)
print v(xbgr.mr_n60871440)
print v(xbgr.mr_n60871616)
print v(xbgr.mr_n60872304)
print v(xbgr.mr_n60872480)
print v(xbgr.mr_n60872736)
print v(xbgr.mr_n60873376)
print v(xbgr.mr_n60873840)
print v(xbgr.mr_n60874016)
print v(xbgr.mr_n60874640)
print v(xbgr.mr_n60874816)
print v(xbgr.mr_n60875440)
print v(xbgr.mr_n60875616)
print v(xbgr.mr_n60876304)
print v(xbgr.mr_n60876480)
print v(xbgr.mr_n60876656)
print v(xbgr.mr_n60877440)
print v(xbgr.mr_n60877616)
print v(xbgr.mr_n60878176)
print v(xbgr.mr_n60878704)
print v(xbgr.mr_n60878880)
print v(xbgr.mr_n60879136)
print v(xbgr.mr_n60879648)
print v(xbgr.mr_n60879760)
print v(xbgr.mr_n60879872)
print v(xbgr.mr_n60879984)
print v(xbgr.mr_n60880336)
print v(xbgr.mr_n60880448)
print v(xbgr.mr_n60880800)
print v(xbgr.mr_n60880912)
print v(xbgr.mr_n60881264)
print v(xbgr.mr_n60881376)
print v(xbgr.mr_n60881856)
print v(xbgr.mr_n60882032)
print v(xbgr.mr_n60882512)
print v(xbgr.mr_n60882688)
print v(xbgr.mr_n60883168)
print v(xbgr.mr_n60883344)
print v(xbgr.mr_n60883824)
print v(xbgr.mr_n60884000)
print v(xbgr.mr_n60884480)
print v(xbgr.mr_n60884656)
print v(xbgr.mr_n60885136)
print v(xbgr.mr_n60885312)
print v(xbgr.mr_n60885792)
print v(xbgr.mr_n60885968)
print v(xbgr.mr_n60886448)
print v(xbgr.mr_n60886624)
print v(xbgr.mr_n60887280)
print v(xbgr.mr_n60887760)
print v(xbgr.mr_n60887936)
print v(xbgr.mr_n60888416)
print v(xbgr.mr_n60888592)
print v(xbgr.mr_n60889072)
print v(xbgr.mr_n60889248)
print v(xbgr.mr_n60889728)
print v(xbgr.mr_n60889904)
print v(xbgr.mr_n60890384)
print v(xbgr.mr_n60890560)
print v(xbgr.mr_n60891040)
print v(xbgr.mr_n60891216)
print v(xbgr.mr_n60891696)
print v(xbgr.mr_n60891872)
print v(xbgr.mr_n60892352)
print v(xbgr.mr_n60892528)
print v(xbgr.mr_n60892880)
print v(xbgr.mr_n60892992)
print v(xbgr.mr_n60893184)
print v(xbgr.mr_n60893456)
print v(xbgr.mr_n60893728)
print v(xbgr.mr_n60894000)
print v(xbgr.mr_n60894272)
print v(xbgr.mr_n60894544)
print v(xbgr.mr_n60894736)
print v(xbgr.mr_n60894928)
print v(xbgr.mr_n60895120)
print v(xbgr.mr_n60895312)
print v(xbgr.mr_n60895504)
print v(xbgr.mr_n60896336)
print v(xbgr.mr_n60896448)
print v(xbgr.mr_n60897200)
print v(xbgr.mr_n60897952)
print v(xbgr.mr_n60898704)
print v(xbgr.mr_n60899648)
print v(xbgr.mr_n60900912)
print v(xbgr.mr_n60902176)
print v(xbgr.mr_n60903440)
print v(xbgr.mr_n60904704)
print v(xbgr.mr_n60905968)
print v(xbgr.mr_n60907232)
print v(xbgr.mr_n60908496)
print v(xbgr.mr_n60909760)
print v(xbgr.mr_n60911024)
print v(xbgr.mr_n60912288)
print v(xbgr.mr_n60913552)
print v(xbgr.mr_n60914448)
print v(xbgr.mr_n60914816)
print v(xbgr.mr_n60915696)
print v(xbgr.mr_n60916016)
print v(xbgr.mr_n60916880)
print v(xbgr.mr_n60917344)
print v(xbgr.mr_n60917808)
print v(xbgr.mr_n60918272)
print v(xbgr.mr_n60921648)
print v(xbgr.mr_n60921760)
print v(xbgr.mr_n60923024)
print v(xbgr.mr_n60923824)
print v(xbgr.mr_n60924896)
print v(xbgr.mr_n60926512)
print v(xbgr.mr_n60926688)
print v(xbgr.mr_n60927024)
print v(xbgr.mr_n60930176)
print v(xbgr.mr_n60930704)
print v(xbgr.mr_n60930816)
print v(xbgr.mr_n60931008)
print v(xbgr.mr_n60932096)
print v(xbgr.mr_n60932208)
print v(xbgr.mr_n60934032)
print v(xbgr.mr_n60935120)
print v(xbgr.mr_n60935232)
print v(xbgr.mr_n60937056)
print v(xbgr.mr_n60938144)
print v(xbgr.mr_n60938256)
print v(xbgr.mr_n60940080)
print v(xbgr.mr_n60941168)
print v(xbgr.mr_n60941280)
print v(xbgr.mr_n60943104)
print v(xbgr.mr_n60944192)
print v(xbgr.mr_n60944304)
print v(xbgr.mr_n60946128)
print v(xbgr.mr_n60947216)
print v(xbgr.mr_n60947328)
print v(xbgr.mr_n60948416)
print v(xbgr.mr_n60949152)
print v(xbgr.mr_n60950240)
print v(xbgr.mr_n60950352)
print v(xbgr.mr_n60952176)
print v(xbgr.mr_n60953264)
print v(xbgr.mr_n60953376)
print v(xbgr.mr_n60955200)
print v(xbgr.mr_n60956288)
print v(xbgr.mr_n60956400)
print v(xbgr.mr_n60957728)
print v(xbgr.mr_n60959056)
print v(xbgr.mr_n60960384)
print v(xbgr.mr_n60961712)
print v(xbgr.mr_n60963104)
print v(xbgr.mr_n60964944)
print v(xbgr.mr_n60966784)
print v(xbgr.mr_n60968624)
print v(xbgr.mr_n60975712)
print v(xbgr.mr_n60976848)
print v(xbgr.mr_n60977280)
print v(xbgr.mr_n60977456)
print v(xbgr.mr_n60977712)
print v(xbgr.mr_n60978496)
print v(xbgr.mr_n60978672)
print v(xbgr.mr_n60979360)
print v(xbgr.mr_n60979536)
print v(xbgr.mr_n60979712)
print v(xbgr.mr_n60980048)
print v(xbgr.mr_n60980816)
print v(xbgr.mr_n60980992)
print v(xbgr.mr_n60981168)
print v(xbgr.mr_n60981424)
print v(xbgr.mr_n60982272)
print v(xbgr.mr_n60982448)
print v(xbgr.mr_n60982624)
print v(xbgr.mr_n60982880)
print v(xbgr.mr_n60983728)
print v(xbgr.mr_n60983904)
print v(xbgr.mr_n60984080)
print v(xbgr.mr_n60984416)
print v(xbgr.mr_n60985184)
print v(xbgr.mr_n60985360)
print v(xbgr.mr_n60985536)
print v(xbgr.mr_n60985792)
print v(xbgr.mr_n60986640)
print v(xbgr.mr_n60986816)
print v(xbgr.mr_n60986992)
print v(xbgr.mr_n60987248)
print v(xbgr.mr_n60987840)
print v(xbgr.mr_n60987952)
print v(xbgr.mr_n60988064)
print v(xbgr.mr_n60988688)
print v(xbgr.mr_n60988864)
print v(xbgr.mr_n60989440)
print v(xbgr.mr_n60989952)
print v(xbgr.mr_n60990384)
print v(xbgr.mr_n60990560)
print v(xbgr.mr_n60990896)
print v(xbgr.mr_n60991600)
print v(xbgr.mr_n60991776)
print v(xbgr.mr_n60992208)
print v(xbgr.mr_n60992320)
print v(xbgr.mr_n60992432)
print v(xbgr.mr_n60993056)
print v(xbgr.mr_n60993232)
print v(xbgr.mr_n60993648)
print v(xbgr.mr_n60994512)
print v(xbgr.mr_n60994688)
print v(xbgr.mr_n60995120)
print v(xbgr.mr_n60995232)
print v(xbgr.mr_n60995344)
print v(xbgr.mr_n60995968)
print v(xbgr.mr_n60996144)
print v(xbgr.mr_n60996720)
print v(xbgr.mr_n60997232)
print v(xbgr.mr_n60997664)
print v(xbgr.mr_n60997840)
print v(xbgr.mr_n60998176)
print v(xbgr.mr_n60999120)
print v(xbgr.mr_n60999296)
print v(xbgr.mr_n60999632)
print v(xbgr.mr_n61008016)
print v(xbgr.mr_n61012416)
print v(xbgr.mr_n61012736)
print v(xbgr.mr_n61024368)
print v(xbgr.mr_n61024560)
print v(xbgr.mr_n61024976)
print v(xbgr.mr_n61025440)
print v(xbgr.mr_n61025904)
print v(xbgr.mr_n61026368)
print v(xbgr.mr_n61026832)
print v(xbgr.mr_n61027296)
print v(xbgr.mr_n61027760)
print v(xbgr.mr_n61028224)
print v(xbgr.mr_n61028688)
print v(xbgr.mr_n61029152)
print v(xbgr.mr_n61029616)
print v(xbgr.mr_n61030080)
print v(xbgr.mr_n61030544)
print v(xbgr.mr_n61031008)
print v(xbgr.mr_n61031472)
print v(xbgr.mr_n61031936)
print v(xbgr.mr_n61032944)
print v(xbgr.mr_n61037808)
print v(xbgr.mr_n61038256)
print v(xbgr.mr_n61039056)
print v(xbgr.mr_n61039328)
print v(xbgr.mr_n61039600)
print v(xbgr.mr_n61040272)
print v(xbgr.mr_n61040560)
print v(xbgr.mr_n61040944)
print v(xbgr.mr_n61042000)
print v(xbgr.mr_n61042720)
print v(xbgr.mr_n61043312)
print v(xbgr.mr_n61046000)
print v(xbgr.mr_n61058016)
print v(xbgr.mr_n61058288)
print v(xbgr.mr_n61058656)
print v(xbgr.mr_n61059456)
print v(xbgr.mr_n61060880)
print v(xbgr.mr_n61063296)
print v(xbgr.mr_n61063920)
print v(xbgr.mr_n61064032)
print v(xbgr.mr_n61064208)
print v(xbgr.mr_n61065104)
print v(xbgr.mr_n61065216)
print v(xbgr.mr_n61066544)
print v(xbgr.mr_n61066816)
print v(xbgr.mr_n61067328)
print v(xbgr.mr_n61067440)
print v(xbgr.mr_n61067552)
print v(xbgr.mr_n61068144)
print v(xbgr.mr_n61068896)
print v(xbgr.mr_n61070096)
print v(xbgr.mr_n61071424)
print v(xbgr.mr_n61072752)
print v(xbgr.mr_n61074080)
print v(xbgr.mr_n61075408)
print v(xbgr.mr_n61076736)
print v(xbgr.mr_n61078064)
print v(xbgr.mr_n61079392)
print v(xbgr.mr_n61080720)
print v(xbgr.mr_n61082528)
print v(xbgr.mr_n61084400)
print v(xbgr.mr_n61086240)
print v(xbgr.mr_n61092912)
print v(xbgr.mr_n61093088)
print v(xbgr.mr_n61093648)
print v(xbgr.mr_n61094016)
print v(xbgr.mr_n61094192)
print v(xbgr.mr_n61094368)
print v(xbgr.mr_n61095152)
print v(xbgr.mr_n61095328)
print v(xbgr.mr_n61095888)
print v(xbgr.mr_n61096352)
print v(xbgr.mr_n61096528)
print v(xbgr.mr_n61097216)
print v(xbgr.mr_n61097392)
print v(xbgr.mr_n61097648)
print v(xbgr.mr_n61098288)
print v(xbgr.mr_n61098752)
print v(xbgr.mr_n61098928)
print v(xbgr.mr_n61099616)
print v(xbgr.mr_n61099792)
print v(xbgr.mr_n61099968)
print v(xbgr.mr_n61100688)
print v(xbgr.mr_n61101216)
print v(xbgr.mr_n61101392)
print v(xbgr.mr_n61101568)
print v(xbgr.mr_n61102352)
print v(xbgr.mr_n61102528)
print v(xbgr.mr_n61103088)
print v(xbgr.mr_n61103616)
print v(xbgr.mr_n61103792)
print v(xbgr.mr_n61104048)
print v(xbgr.mr_n61104752)
print v(xbgr.mr_n61104928)
print v(xbgr.mr_n61105360)
print v(xbgr.mr_n61105472)
print v(xbgr.mr_n61105584)
print v(xbgr.mr_n61105696)
print v(xbgr.mr_n61105888)
print v(xbgr.mr_n61106160)
print v(xbgr.mr_n61106432)
print v(xbgr.mr_n61106704)
print v(xbgr.mr_n61106976)
print v(xbgr.mr_n61107248)
print v(xbgr.mr_n61107520)
print v(xbgr.mr_n61107792)
print v(xbgr.mr_n61108064)
print v(xbgr.mr_n61112240)
print v(xbgr.mr_n61112704)
print v(xbgr.mr_n61113168)
print v(xbgr.mr_n61113632)
print v(xbgr.mr_n61114096)
print v(xbgr.mr_n61114560)
print v(xbgr.mr_n61115024)
print v(xbgr.mr_n61115488)
print v(xbgr.mr_n61115952)
print v(xbgr.mr_n61116416)
print v(xbgr.mr_n61116880)
print v(xbgr.mr_n61117344)
print v(xbgr.mr_n61117808)
print v(xbgr.mr_n61118272)
print v(xbgr.mr_n61118736)
print v(xbgr.mr_n61119200)
print v(xbgr.mr_n61119664)
print v(xbgr.mr_n61135984)
print v(xbgr.mr_n61137248)
print v(xbgr.mr_n61137952)
print v(xbgr.mr_n61143136)
print v(xbgr.mr_n61147872)
print v(xbgr.mr_n61149040)
print v(xbgr.mr_n61149472)
print v(xbgr.mr_n61152304)
print v(xbgr.mr_n61152496)
print v(xbgr.mr_n61152752)
print v(xbgr.mr_n61153008)
print v(xbgr.mr_n61153264)
print v(xbgr.mr_n61153712)
print v(xbgr.mr_n61155440)
print v(xbgr.mr_n61155552)
print v(xbgr.mr_n61157728)
print v(xbgr.mr_n61157984)
print v(xbgr.mr_n61159328)
print v(xbgr.mr_n61159440)
print v(xbgr.mr_n61161760)
print v(xbgr.mr_n61161872)
print v(xbgr.mr_n61163200)
print v(xbgr.mr_n61165024)
print v(xbgr.mr_n61166624)
print v(xbgr.mr_n61166736)
print v(xbgr.mr_n61169056)
print v(xbgr.mr_n61169168)
print v(xbgr.mr_n61170496)
print v(xbgr.mr_n61173920)
print v(xbgr.mr_n61174032)
print v(xbgr.mr_n61176352)
print v(xbgr.mr_n61176464)
print v(xbgr.mr_n61177792)
print v(xbgr.mr_n61179616)
print v(xbgr.mr_n61181216)
print v(xbgr.mr_n61181328)
print v(xbgr.mr_n61183648)
print v(xbgr.mr_n61183760)
print v(xbgr.mr_n61184976)
print v(xbgr.mr_n61185088)
print v(xbgr.mr_n61186000)
print v(xbgr.mr_n61186112)
print v(xbgr.mr_n61187088)
print v(xbgr.mr_n61187200)
print v(xbgr.mr_n61195808)
print v(xbgr.mr_n61198592)
print v(xbgr.mr_n61198992)
print v(xbgr.mr_n61199392)
print v(xbgr.mr_n61199792)
print v(xbgr.mr_n61200192)
print v(xbgr.mr_n61200592)
print v(xbgr.mr_n61200992)
print v(xbgr.mr_n61201392)
print v(xbgr.mr_n61201792)
print v(xbgr.mr_n61202192)
print v(xbgr.mr_n61202592)
print v(xbgr.mr_n61202992)
print v(xbgr.mr_n61203392)
print v(xbgr.mr_n61203792)
print v(xbgr.mr_n61204192)
print v(xbgr.mr_n61204592)
print v(xbgr.mr_n61204864)
print v(xbgr.mr_n61204976)
print v(xbgr.mr_n61205088)
print v(xbgr.mr_n61205200)
print v(xbgr.mr_n61205312)
print v(xbgr.mr_n61205504)
print v(xbgr.mr_n61205776)
print v(xbgr.mr_n61206048)
print v(xbgr.mr_n61206320)
print v(xbgr.mr_n61206592)
print v(xbgr.mr_n61206864)
print v(xbgr.mr_n61207136)
print v(xbgr.mr_n61207408)
print v(xbgr.mr_n61207744)
print v(xbgr.mr_n61208144)
print v(xbgr.mr_n61219424)
print v(xbgr.mr_n61221152)
print v(xbgr.mr_n61221696)
print v(xbgr.mr_n61221872)
print v(xbgr.mr_n61222240)
print v(xbgr.mr_n61222656)
print v(xbgr.mr_n61223200)
print v(xbgr.mr_n61223696)
print v(xbgr.mr_n61224240)
print v(xbgr.mr_n61224416)
print v(xbgr.mr_n61225264)
print v(xbgr.mr_n61225744)
print v(xbgr.mr_n61226240)
print v(xbgr.mr_n61226784)
print v(xbgr.mr_n61226960)
print v(xbgr.mr_n61227744)
print v(xbgr.mr_n61228288)
print v(xbgr.mr_n61228784)
print v(xbgr.mr_n61229328)
print v(xbgr.mr_n61229504)
print v(xbgr.mr_n61230288)
print v(xbgr.mr_n61230832)
print v(xbgr.mr_n61231328)
print v(xbgr.mr_n61231872)
print v(xbgr.mr_n61232048)
print v(xbgr.mr_n61232896)
print v(xbgr.mr_n61233376)
print v(xbgr.mr_n61233872)
print v(xbgr.mr_n61234416)
print v(xbgr.mr_n61234592)
print v(xbgr.mr_n61235376)
print v(xbgr.mr_n61235920)
print v(xbgr.mr_n61236416)
print v(xbgr.mr_n61236960)
print v(xbgr.mr_n61237136)
print v(xbgr.mr_n61238464)
print v(xbgr.mr_n61238704)
print v(xbgr.mr_n61238960)
print v(xbgr.mr_n61239504)
print v(xbgr.mr_n61239680)
print v(xbgr.mr_n61240528)
print v(xbgr.mr_n61241008)
print v(xbgr.mr_n61241504)
print v(xbgr.mr_n61241856)
print v(xbgr.mr_n61241968)
print v(xbgr.mr_n61242160)
print v(xbgr.mr_n61242624)
print v(xbgr.mr_n61243088)
print v(xbgr.mr_n61243552)
print v(xbgr.mr_n61244016)
print v(xbgr.mr_n61248112)
print v(xbgr.mr_n61250032)
print v(xbgr.mr_n61252656)
print v(xbgr.mr_n61253728)
print v(xbgr.mr_n61257264)
print v(xbgr.mr_n61258160)
print v(xbgr.mr_n61258352)
print v(xbgr.mr_n61258608)
print v(xbgr.mr_n61258864)
print v(xbgr.mr_n61259120)
print v(xbgr.mr_n61259648)
print v(xbgr.mr_n61261296)
print v(xbgr.mr_n61261408)
print v(xbgr.mr_n61262736)
print v(xbgr.mr_n61264064)
print v(xbgr.mr_n61265392)
print v(xbgr.mr_n61266784)
print v(xbgr.mr_n61268624)
print v(xbgr.mr_n61270464)
print v(xbgr.mr_n61272304)
print v(xbgr.mr_n61274144)
print v(xbgr.mr_n61275984)
print v(xbgr.mr_n61277824)
print v(xbgr.mr_n61279664)
print v(xbgr.mr_n61281504)
print v(xbgr.mr_n61283344)
print v(xbgr.mr_n61285184)
print v(xbgr.mr_n61287024)
print v(xbgr.mr_n61288864)
print v(xbgr.mr_n61291968)
print v(xbgr.mr_n61292272)
print v(xbgr.mr_n61292768)
print v(xbgr.mr_n61293072)
print v(xbgr.mr_n61293568)
print v(xbgr.mr_n61293872)
print v(xbgr.mr_n61294688)
print v(xbgr.mr_n61294992)
print v(xbgr.mr_n61295872)
print v(xbgr.mr_n61296176)
print v(xbgr.mr_n61297056)
print v(xbgr.mr_n61297360)
print v(xbgr.mr_n61298240)
print v(xbgr.mr_n61298544)
print v(xbgr.mr_n61299424)
print v(xbgr.mr_n61299728)
print v(xbgr.mr_n61300608)
print v(xbgr.mr_n61300912)
print v(xbgr.mr_n61301792)
print v(xbgr.mr_n61302096)
print v(xbgr.mr_n61302976)
print v(xbgr.mr_n61303280)
print v(xbgr.mr_n61304160)
print v(xbgr.mr_n61304464)
print v(xbgr.mr_n61305344)
print v(xbgr.mr_n61305648)
print v(xbgr.mr_n61306528)
print v(xbgr.mr_n61306832)
print v(xbgr.mr_n61307712)
print v(xbgr.mr_n61307904)
print v(xbgr.mr_n61308176)
print v(xbgr.mr_n61308640)
print v(xbgr.mr_n61315088)
print v(xbgr.mr_n61320624)
print v(xbgr.mr_n61320960)
print v(xbgr.mr_n61321296)
print v(xbgr.mr_n61321568)
print v(xbgr.mr_n61323536)
print v(xbgr.mr_n61324176)
print v(xbgr.mr_n61324448)
print v(xbgr.mr_n61324720)
print v(xbgr.mr_n61324992)
print v(xbgr.mr_n61325264)
print v(xbgr.mr_n61325536)
print v(xbgr.mr_n61326768)
print v(xbgr.mr_n61327232)
print v(xbgr.mr_n61327632)
print v(xbgr.mr_n61328032)
print v(xbgr.mr_n61328432)
print v(xbgr.mr_n61328832)
print v(xbgr.mr_n61329232)
print v(xbgr.mr_n61329632)
print v(xbgr.mr_n61330032)
print v(xbgr.mr_n61330432)
print v(xbgr.mr_n61334944)
print v(xbgr.mr_n61336944)
print v(xbgr.mr_n61337312)
print v(xbgr.mr_n61341648)
print v(xbgr.mr_n61343200)
print v(xbgr.mr_n61343824)
print v(xbgr.mr_n61345104)
print v(xbgr.mr_n61349264)
print v(xbgr.mr_n61357408)
print v(xbgr.mr_n61357584)
print v(xbgr.mr_n61357888)
print v(xbgr.mr_n61358192)
print v(xbgr.mr_n61358496)
print v(xbgr.mr_n61358880)
print v(xbgr.mr_n61359344)
print v(xbgr.mr_n61359808)
print v(xbgr.mr_n61360272)
print v(xbgr.mr_n61360736)
print v(xbgr.mr_n61361200)
print v(xbgr.mr_n61361664)
print v(xbgr.mr_n61362128)
print v(xbgr.mr_n61362592)
print v(xbgr.mr_n61364768)
print v(xbgr.mr_n61364960)
print v(xbgr.mr_n61365216)
print v(xbgr.mr_n61365472)
print v(xbgr.mr_n61365728)
print v(xbgr.mr_n61367904)
print v(xbgr.mr_n61368016)
print v(xbgr.mr_n61369344)
print v(xbgr.mr_n61370672)
print v(xbgr.mr_n61372000)
print v(xbgr.mr_n61373328)
print v(xbgr.mr_n61374976)
print v(xbgr.mr_n61376816)
print v(xbgr.mr_n61378656)
print v(xbgr.mr_n61380496)
print v(xbgr.mr_n61382336)
print v(xbgr.mr_n61384176)
print v(xbgr.mr_n61386016)
print v(xbgr.mr_n61387856)
print v(xbgr.mr_n61389696)
print v(xbgr.mr_n61391536)
print v(xbgr.mr_n61393376)
print v(xbgr.mr_n61395216)
print v(xbgr.mr_n61397904)
print v(xbgr.mr_n61412256)
print v(xbgr.mr_n61418640)
print v(xbgr.mr_n61418752)
print v(xbgr.mr_n61419312)
print v(xbgr.mr_n61419488)
print v(xbgr.mr_n61419984)
print v(xbgr.mr_n61420496)
print v(xbgr.mr_n61420608)
print v(xbgr.mr_n61421168)
print v(xbgr.mr_n61421344)
print v(xbgr.mr_n61421840)
print v(xbgr.mr_n61422352)
print v(xbgr.mr_n61422464)
print v(xbgr.mr_n61423024)
print v(xbgr.mr_n61423200)
print v(xbgr.mr_n61423696)
print v(xbgr.mr_n61424208)
print v(xbgr.mr_n61424320)
print v(xbgr.mr_n61424880)
print v(xbgr.mr_n61425056)
print v(xbgr.mr_n61425552)
print v(xbgr.mr_n61426064)
print v(xbgr.mr_n61426176)
print v(xbgr.mr_n61426736)
print v(xbgr.mr_n61426912)
print v(xbgr.mr_n61427408)
print v(xbgr.mr_n61427920)
print v(xbgr.mr_n61428032)
print v(xbgr.mr_n61428592)
print v(xbgr.mr_n61428768)
print v(xbgr.mr_n61429264)
print v(xbgr.mr_n61430032)
print v(xbgr.mr_n61430208)
print v(xbgr.mr_n61430384)
print v(xbgr.mr_n61430640)
print v(xbgr.mr_n61431232)
print v(xbgr.mr_n61431728)
print v(xbgr.mr_n61431904)
print v(xbgr.mr_n61432080)
print v(xbgr.mr_n61432496)
print v(xbgr.mr_n61433088)
print v(xbgr.mr_n61433584)
print v(xbgr.mr_n61433760)
print v(xbgr.mr_n61433936)
print v(xbgr.mr_n61434432)
print v(xbgr.mr_n61434944)
print v(xbgr.mr_n61435056)
print v(xbgr.mr_n61435168)
print v(xbgr.mr_n61435856)
print v(xbgr.mr_n61436032)
print v(xbgr.mr_n61436688)
print v(xbgr.mr_n61437200)
print v(xbgr.mr_n61437312)
print v(xbgr.mr_n61437872)
print v(xbgr.mr_n61438048)
print v(xbgr.mr_n61438544)
print v(xbgr.mr_n61439056)
print v(xbgr.mr_n61439168)
print v(xbgr.mr_n61439728)
print v(xbgr.mr_n61439904)
print v(xbgr.mr_n61440320)
print v(xbgr.mr_n61440912)
print v(xbgr.mr_n61441024)
print v(xbgr.mr_n61441584)
print v(xbgr.mr_n61441760)
print v(xbgr.mr_n61442256)
print v(xbgr.mr_n61443024)
print v(xbgr.mr_n61443200)
print v(xbgr.mr_n61443376)
print v(xbgr.mr_n61443712)
print v(xbgr.mr_n61444224)
print v(xbgr.mr_n61444720)
print v(xbgr.mr_n61444896)
print v(xbgr.mr_n61445072)
print v(xbgr.mr_n61445488)
print v(xbgr.mr_n61446080)
print v(xbgr.mr_n61446576)
print v(xbgr.mr_n61446752)
print v(xbgr.mr_n61446928)
print v(xbgr.mr_n61447424)
print v(xbgr.mr_n61447936)
print v(xbgr.mr_n61448048)
print v(xbgr.mr_n61448160)
print v(xbgr.mr_n61448272)
print v(xbgr.mr_n61448544)
print v(xbgr.mr_n61448656)
print v(xbgr.mr_n61448928)
print v(xbgr.mr_n61449280)
print v(xbgr.mr_n61449392)
print v(xbgr.mr_n61449664)
print v(xbgr.mr_n61450016)
print v(xbgr.mr_n61450384)
print v(xbgr.mr_n61450720)
print v(xbgr.mr_n61451072)
print v(xbgr.mr_n61451184)
print v(xbgr.mr_n61451376)
print v(xbgr.mr_n61453760)
print v(xbgr.mr_n61456064)
print v(xbgr.mr_n61456592)
print v(xbgr.mr_n61457056)
print v(xbgr.mr_n61457520)
print v(xbgr.mr_n61457984)
print v(xbgr.mr_n61458448)
print v(xbgr.mr_n61458912)
print v(xbgr.mr_n61459376)
print v(xbgr.mr_n61459840)
print v(xbgr.mr_n61460304)
print v(xbgr.mr_n61460768)
print v(xbgr.mr_n61461232)
print v(xbgr.mr_n61461696)
print v(xbgr.mr_n61462160)
print v(xbgr.mr_n61462624)
print v(xbgr.mr_n61463088)
print v(xbgr.mr_n61463552)
print v(xbgr.mr_n61464016)
print v(xbgr.mr_n61464480)
print v(xbgr.mr_n61464944)
print v(xbgr.mr_n61465408)
print v(xbgr.mr_n61466432)
print v(xbgr.mr_n61468400)
print v(xbgr.mr_n61471232)
print v(xbgr.mr_n61474240)
print v(xbgr.mr_n61479472)
print v(xbgr.mr_n61482880)
print v(xbgr.mr_n61491120)
print v(xbgr.mr_n61493648)
print v(xbgr.mr_n61495552)
print v(xbgr.mr_n61496240)
print v(xbgr.mr_n61502576)
print v(xbgr.mr_n61502768)
print v(xbgr.mr_n61503024)
print v(xbgr.mr_n61503280)
print v(xbgr.mr_n61503536)
print v(xbgr.mr_n61505712)
print v(xbgr.mr_n61505824)
print v(xbgr.mr_n61510352)
print v(xbgr.mr_n61510464)
print v(xbgr.mr_n61515984)
print v(xbgr.mr_n61516096)
print v(xbgr.mr_n61516928)
print v(xbgr.mr_n61517040)
print v(xbgr.mr_n61518112)
print v(xbgr.mr_n61520048)
print v(xbgr.mr_n61520880)
print v(xbgr.mr_n61520992)
print v(xbgr.mr_n61522768)
print v(xbgr.mr_n61522880)
print v(xbgr.mr_n61523712)
print v(xbgr.mr_n61523824)
print v(xbgr.mr_n61525024)
print v(xbgr.mr_n61526960)
print v(xbgr.mr_n61527792)
print v(xbgr.mr_n61527904)
print v(xbgr.mr_n61529680)
print v(xbgr.mr_n61529792)
print v(xbgr.mr_n61530624)
print v(xbgr.mr_n61530736)
print v(xbgr.mr_n61531936)
print v(xbgr.mr_n61533872)
print v(xbgr.mr_n61534704)
print v(xbgr.mr_n61534816)
print v(xbgr.mr_n61536016)
print v(xbgr.mr_n61536592)
print v(xbgr.mr_n61536704)
print v(xbgr.mr_n61537536)
print v(xbgr.mr_n61537648)
print v(xbgr.mr_n61538848)
print v(xbgr.mr_n61540784)
print v(xbgr.mr_n61541616)
print v(xbgr.mr_n61541728)
print v(xbgr.mr_n61543456)
print v(xbgr.mr_n61543568)
print v(xbgr.mr_n61543680)
print v(xbgr.mr_n61544512)
print v(xbgr.mr_n61544624)
print v(xbgr.mr_n61545568)
print v(xbgr.mr_n61547504)
print v(xbgr.mr_n61548336)
print v(xbgr.mr_n61548448)
print v(xbgr.mr_n61550688)
print v(xbgr.mr_n61550976)
print v(xbgr.mr_n61551552)
print v(xbgr.mr_n61553344)
print v(xbgr.mr_n61554000)
print v(xbgr.mr_n61554640)
print v(xbgr.mr_n61555104)
print v(xbgr.mr_n61555280)
print v(xbgr.mr_n61555456)
print v(xbgr.mr_n61555968)
print v(xbgr.mr_n61556400)
print v(xbgr.mr_n61556576)
print v(xbgr.mr_n61556912)
print v(xbgr.mr_n61557616)
print v(xbgr.mr_n61557792)
print v(xbgr.mr_n61558416)
print v(xbgr.mr_n61558592)
print v(xbgr.mr_n61558768)
print v(xbgr.mr_n61559408)
print v(xbgr.mr_n61559872)
print v(xbgr.mr_n61560048)
print v(xbgr.mr_n61560672)
print v(xbgr.mr_n61560848)
print v(xbgr.mr_n61561024)
print v(xbgr.mr_n61561728)
print v(xbgr.mr_n61561904)
print v(xbgr.mr_n61562528)
print v(xbgr.mr_n61562704)
print v(xbgr.mr_n61562880)
print v(xbgr.mr_n61563392)
print v(xbgr.mr_n61563824)
print v(xbgr.mr_n61564000)
print v(xbgr.mr_n61564336)
print v(xbgr.mr_n61564976)
print v(xbgr.mr_n61565440)
print v(xbgr.mr_n61565616)
print v(xbgr.mr_n61566240)
print v(xbgr.mr_n61566416)
print v(xbgr.mr_n61566592)
print v(xbgr.mr_n61567296)
print v(xbgr.mr_n61567472)
print v(xbgr.mr_n61568096)
print v(xbgr.mr_n61568272)
print v(xbgr.mr_n61568448)
print v(xbgr.mr_n61568960)
print v(xbgr.mr_n61569072)
print v(xbgr.mr_n61569184)
print v(xbgr.mr_n61569296)
print v(xbgr.mr_n61569408)
print v(xbgr.mr_n61569680)
print v(xbgr.mr_n61570032)
print v(xbgr.mr_n61570144)
print v(xbgr.mr_n61570256)
print v(xbgr.mr_n61570688)
print v(xbgr.mr_n61571168)
print v(xbgr.mr_n61571344)
print v(xbgr.mr_n61571696)
print v(xbgr.mr_n61572064)
print v(xbgr.mr_n61572400)
print v(xbgr.mr_n61572752)
print v(xbgr.mr_n61572864)
print v(xbgr.mr_n61573360)
print v(xbgr.mr_n61573856)
print v(xbgr.mr_n61574336)
print v(xbgr.mr_n61574512)
print v(xbgr.mr_n61574864)
print v(xbgr.mr_n61575232)
print v(xbgr.mr_n61575568)
print v(xbgr.mr_n61575920)
print v(xbgr.mr_n61576032)
print v(xbgr.mr_n61576528)
print v(xbgr.mr_n61577024)
print v(xbgr.mr_n61577504)
print v(xbgr.mr_n61577680)
print v(xbgr.mr_n61578032)
print v(xbgr.mr_n61578400)
print v(xbgr.mr_n61578736)
print v(xbgr.mr_n61579088)
print v(xbgr.mr_n61579904)
print v(xbgr.mr_n61581120)
print v(xbgr.mr_n61581504)
print v(xbgr.mr_n61581968)
print v(xbgr.mr_n61582432)
print v(xbgr.mr_n61582896)
print v(xbgr.mr_n61583360)
print v(xbgr.mr_n61583824)
print v(xbgr.mr_n61584288)
print v(xbgr.mr_n61584752)
print v(xbgr.mr_n61585216)
print v(xbgr.mr_n61585680)
print v(xbgr.mr_n61586144)
print v(xbgr.mr_n61586608)
print v(xbgr.mr_n61587072)
print v(xbgr.mr_n61587536)
print v(xbgr.mr_n61588000)
print v(xbgr.mr_n61588464)
print v(xbgr.mr_n61588928)
print v(xbgr.mr_n61589392)
print v(xbgr.mr_n61589856)
print v(xbgr.mr_n61590320)
print v(xbgr.mr_n61590784)
print v(xbgr.mr_n61591248)
print v(xbgr.mr_n61592480)
print v(xbgr.mr_n61594016)
print v(xbgr.mr_n61594832)
print v(xbgr.mr_n61596000)
print v(xbgr.mr_n61596784)
print v(xbgr.mr_n61597904)
print v(xbgr.mr_n61598608)
print v(xbgr.mr_n61603760)
print v(xbgr.mr_n61609184)
print v(xbgr.mr_n61611648)
print v(xbgr.mr_n61613408)
print v(xbgr.mr_n61615088)
print v(xbgr.mr_n61618512)
print v(xbgr.mr_n61619824)
print v(xbgr.mr_n61619968)
print v(xbgr.mr_n61620368)
print v(xbgr.mr_n61620640)
print v(xbgr.mr_n61621008)
print v(xbgr.mr_n61621280)
print v(xbgr.mr_n61621840)
print v(xbgr.mr_n61622896)
print v(xbgr.mr_n61623504)
print v(xbgr.mr_n61623760)
print v(xbgr.mr_n61624096)
print v(xbgr.mr_n61624336)
print v(xbgr.mr_n61624480)
print v(xbgr.mr_n61625168)
print v(xbgr.mr_n61626160)
print v(xbgr.mr_n61626272)
print v(xbgr.mr_n61626384)
print v(xbgr.mr_n61626496)
print v(xbgr.mr_n61627328)
print v(xbgr.mr_n61627440)
print v(xbgr.mr_n61628640)
print v(xbgr.mr_n61631568)
print v(xbgr.mr_n61632400)
print v(xbgr.mr_n61632512)
print v(xbgr.mr_n61633712)
print v(xbgr.mr_n61635040)
print v(xbgr.mr_n61636368)
print v(xbgr.mr_n61637696)
print v(xbgr.mr_n61639152)
print v(xbgr.mr_n61640992)
print v(xbgr.mr_n61642832)
print v(xbgr.mr_n61645600)
print v(xbgr.mr_n61645888)
print v(xbgr.mr_n61647344)
print v(xbgr.mr_n61649376)
print v(xbgr.mr_n61651360)
print v(xbgr.mr_n61653360)
print v(xbgr.mr_n61653792)
print v(xbgr.mr_n61653968)
print v(xbgr.mr_n61654304)
print v(xbgr.mr_n61655008)
print v(xbgr.mr_n61655184)
print v(xbgr.mr_n61655808)
print v(xbgr.mr_n61655984)
print v(xbgr.mr_n61656608)
print v(xbgr.mr_n61656784)
print v(xbgr.mr_n61657136)
print v(xbgr.mr_n61657408)
print v(xbgr.mr_n61657584)
print v(xbgr.mr_n61658208)
print v(xbgr.mr_n61658384)
print v(xbgr.mr_n61659008)
print v(xbgr.mr_n61659184)
print v(xbgr.mr_n61659808)
print v(xbgr.mr_n61659984)
print v(xbgr.mr_n61660544)
print v(xbgr.mr_n61661104)
print v(xbgr.mr_n61662448)
print v(xbgr.mr_n61663024)
print v(xbgr.mr_n61664304)
print v(xbgr.mr_n61664816)
print v(xbgr.mr_n61665104)
print v(xbgr.mr_n61666064)
print v(xbgr.mr_n61666352)
print v(xbgr.mr_n61666544)
print v(xbgr.mr_n61666928)
print v(xbgr.mr_n61667376)
print v(xbgr.mr_n61668368)
print v(xbgr.mr_n61668624)
print v(xbgr.mr_n61668992)
print v(xbgr.mr_n61669680)
print v(xbgr.mr_n61670032)
print v(xbgr.mr_n61670144)
print v(xbgr.mr_n61670640)
print v(xbgr.mr_n61672688)
print v(xbgr.mr_n61673104)
print v(xbgr.mr_n61673888)
print v(xbgr.mr_n61674640)
print v(xbgr.mr_n61674832)
print v(xbgr.mr_n61676048)
print v(xbgr.mr_n61676368)
print v(xbgr.mr_n61683024)
print v(xbgr.mr_n61683216)
print v(xbgr.mr_n61685488)
print v(xbgr.mr_n61685760)
print v(xbgr.mr_n61686320)
print v(xbgr.mr_n61686560)
print v(xbgr.mr_n61686752)
print v(xbgr.mr_n61686960)
print v(xbgr.mr_n61687120)
print v(xbgr.mr_n61687360)
print v(xbgr.mr_n61687520)
print v(xbgr.mr_n61689472)
print v(xbgr.mr_n61690208)
print v(xbgr.mr_n61690320)
print v(xbgr.mr_n61691056)
print v(xbgr.mr_n61691600)
print v(xbgr.mr_n61692560)
print v(xbgr.mr_n61692944)
print v(xbgr.mr_n61693056)
print v(xbgr.mr_n61693344)
print v(xbgr.mr_n61694208)
print v(xbgr.mr_n61695600)
print v(xbgr.mr_n61695712)
print v(xbgr.mr_n61695984)
print v(xbgr.mr_n61696096)
print v(xbgr.mr_n61698752)
print v(xbgr.mr_n61699168)
print v(xbgr.mr_n61699280)
print v(xbgr.mr_n61699456)
print v(xbgr.mr_n61699632)
print v(xbgr.mr_n61699808)
print v(xbgr.mr_n61700240)
print v(xbgr.mr_n61700416)
print v(xbgr.mr_n61700528)
print v(xbgr.mr_n61700640)
print v(xbgr.mr_n61700752)
print v(xbgr.mr_n61700960)
print v(xbgr.mr_n61702816)
print v(xbgr.mr_n61703792)
print v(xbgr.mr_n61704832)
print v(xbgr.mr_n61705376)
print v(xbgr.mr_n61705968)
print v(xbgr.mr_n61706480)
print v(xbgr.mr_n61708336)
print v(xbgr.mr_n61709168)
print v(xbgr.mr_n61710608)
print v(xbgr.mr_n61710848)
print v(xbgr.mr_n61712688)
print v(xbgr.mr_n61712800)
print v(xbgr.mr_n61712912)
print v(xbgr.mr_n61713024)
print v(xbgr.mr_n61713456)
print v(xbgr.mr_n61714656)
print v(xbgr.mr_n61716320)
print v(xbgr.mr_n61716432)
print v(xbgr.mr_n61716544)
print v(xbgr.mr_n61716656)
print v(xbgr.mr_n61716768)
print v(xbgr.mr_n61716880)
print v(xbgr.mr_n61716992)
print v(xbgr.mr_n61717344)
print v(xbgr.mr_n61717696)
print v(xbgr.mr_n61717808)
print v(xbgr.mr_n61718160)
print v(xbgr.mr_n61718272)
print v(xbgr.mr_n61718544)
print v(xbgr.mr_n61719024)
print v(xbgr.mr_n61719296)
print v(xbgr.mr_n61719488)
print v(xbgr.mr_n61719680)
print v(xbgr.mr_n61719872)
print v(xbgr.mr_n61720064)
print v(xbgr.mr_n61721024)
print v(xbgr.mr_n61721296)
print v(xbgr.mr_n61722128)
print v(xbgr.mr_n61723312)
print v(xbgr.mr_n61723664)
print v(xbgr.mr_n61724096)
print v(xbgr.mr_n61724288)
print v(xbgr.mr_n61724400)
print v(xbgr.mr_n61724960)
print v(xbgr.mr_n61725376)
print v(xbgr.mr_n61725744)
print v(xbgr.mr_n61726160)
print v(xbgr.mr_n61726592)
print v(xbgr.mr_n61727216)
print v(xbgr.mr_n61727600)
print v(xbgr.mr_n61730256)
print v(xbgr.mr_n61731088)
print v(xbgr.mr_n61733392)
print v(xbgr.mr_n61733504)
print v(xbgr.mr_n61734640)
print v(xbgr.mr_n61734752)
print v(xbgr.mr_n61734944)
print v(xbgr.mr_n61735248)
print v(xbgr.mr_n61735472)
print v(xbgr.mr_n61735936)
print v(xbgr.mr_n61736160)
print v(xbgr.mr_n61736544)
print v(xbgr.mr_n61738032)
print v(xbgr.mr_n61738288)
print v(xbgr.mr_n61738896)
print v(xbgr.mr_n61739248)
print v(xbgr.mr_n61739728)
print v(xbgr.mr_n61740960)
print v(xbgr.mr_n61743952)
print v(xbgr.mr_n61746160)
print v(xbgr.mr_n61749760)
print v(xbgr.mr_n61750032)
print v(xbgr.mr_n61752496)
print v(xbgr.mr_n61753456)
print v(xbgr.mr_n61753808)
print v(xbgr.mr_n61753952)
print v(xbgr.mr_n61755664)
print v(xbgr.mr_n61757520)
print v(xbgr.mr_n61757664)
print v(xbgr.mr_n61758016)
print v(xbgr.mr_n61758448)
print v(xbgr.mr_n61758592)
print v(xbgr.mr_n61759376)
print v(xbgr.mr_n61763632)
print v(xbgr.mr_n61769184)
print v(xbgr.mr_n61769520)
print v(xbgr.mr_n61769856)
print v(xbgr.mr_n61770192)
print v(xbgr.mr_n61770528)
print v(xbgr.mr_n61770704)
print v(xbgr.mr_n61770816)
print v(xbgr.mr_n61770960)
print v(xbgr.mr_n61771072)
print v(xbgr.mr_n61771184)
print v(xbgr.mr_n61771296)
print v(xbgr.mr_n61771408)
print v(xbgr.mr_n61771520)
print v(xbgr.mr_n61771632)
print v(xbgr.mr_n61772064)
print v(xbgr.mr_n61772416)
print v(xbgr.mr_n61772528)
print v(xbgr.mr_n61772880)
print v(xbgr.mr_n61773024)
print v(xbgr.mr_n61773216)
print v(xbgr.mr_n61773328)
print v(xbgr.mr_n61773488)
print v(xbgr.mr_n61773600)
print v(xbgr.mr_n61773712)
print v(xbgr.mr_n61773824)
print v(xbgr.mr_n61775856)
print v(xbgr.mr_n61777776)
print v(xbgr.mr_n61778400)
print v(xbgr.mr_n61779776)
print v(xbgr.mr_n61780896)
print v(xbgr.mr_n61781776)
print v(xbgr.mr_n61781888)
print v(xbgr.mr_n61782000)
print v(xbgr.mr_n61782112)
print v(xbgr.mr_n61783392)
print v(xbgr.mr_n61783648)
print v(xbgr.mr_n61784288)
print v(xbgr.mr_n61784400)
print v(xbgr.mr_n61784512)
print v(xbgr.mr_n61784944)
print v(xbgr.mr_n61785360)
print v(xbgr.mr_n61785984)
print v(xbgr.mr_n61786256)
print v(xbgr.mr_n61786448)
print v(xbgr.mr_n61786640)
print v(xbgr.mr_n61787664)
print v(xbgr.mr_n61788256)
print v(xbgr.mr_n61788560)
print v(xbgr.mr_n61788896)
print v(xbgr.mr_n61789248)
print v(xbgr.mr_n61789680)
print v(xbgr.mr_n61789872)
print v(xbgr.mr_n61789984)
print v(xbgr.mr_n61790544)
print v(xbgr.mr_n61790960)
print v(xbgr.mr_n61791392)
print v(xbgr.mr_n61791744)
print v(xbgr.mr_n61792176)
print v(xbgr.mr_n61792576)
print v(xbgr.mr_n61792992)
print v(xbgr.mr_n61793312)
print v(xbgr.mr_n61793424)
print v(xbgr.mr_n61793728)
print v(xbgr.mr_n61794288)
print v(xbgr.mr_n61794704)
print v(xbgr.mr_n61794880)
print v(xbgr.mr_n61795136)
print v(xbgr.mr_n61795488)
print v(xbgr.mr_n61795920)
print v(xbgr.mr_n61796112)
print v(xbgr.mr_n61796304)
print v(xbgr.mr_n61796720)
print v(xbgr.mr_n61797152)
print v(xbgr.mr_n61797456)
print v(xbgr.mr_n61798080)
print v(xbgr.mr_n61798432)
print v(xbgr.mr_n61798864)
print v(xbgr.mr_n61799216)
print v(xbgr.mr_n61799648)
print v(xbgr.mr_n61800048)
print v(xbgr.mr_n61800464)
print v(xbgr.mr_n61800896)
print v(xbgr.mr_n61801200)
print v(xbgr.mr_n61801760)
print v(xbgr.mr_n61802176)
print v(xbgr.mr_n61802288)
print v(xbgr.mr_n61802480)
print v(xbgr.mr_n61802752)
print v(xbgr.mr_n61803024)
print v(xbgr.mr_n61803296)
print v(xbgr.mr_n61803568)
print v(xbgr.mr_n61803840)
print v(xbgr.mr_n61804112)
print v(xbgr.mr_n61804384)
print v(xbgr.mr_n61804656)
print v(xbgr.mr_n61804928)
print v(xbgr.mr_n61805200)
print v(xbgr.mr_n61805472)
print v(xbgr.mr_n61805744)
print v(xbgr.mr_n61806016)
print v(xbgr.mr_n61806288)
print v(xbgr.mr_n61806752)
print v(xbgr.mr_n61812336)
print v(xbgr.mr_n61812800)
print v(xbgr.mr_n61813264)
print v(xbgr.mr_n61813728)
print v(xbgr.mr_n61814192)
print v(xbgr.mr_n61814656)
print v(xbgr.mr_n61815120)
print v(xbgr.mr_n61815584)
print v(xbgr.mr_n61816016)
print v(xbgr.mr_n61825504)
print v(xbgr.mr_n61827696)
print v(xbgr.mr_n61847968)
print v(xbgr.mr_n61849760)
print v(xbgr.mr_n61850016)
print v(xbgr.mr_n61850208)
print v(xbgr.mr_n61850464)
print v(xbgr.mr_n61850720)
print v(xbgr.mr_n61850976)
print v(xbgr.mr_n61853152)
print v(xbgr.mr_n61853264)
print v(xbgr.mr_n61856624)
print v(xbgr.mr_n61857264)
print v(xbgr.mr_n61857376)
print v(xbgr.mr_n61857488)
print v(xbgr.mr_n61858656)
print v(xbgr.mr_n61859600)
print v(xbgr.mr_n61860192)
print v(xbgr.mr_n61860304)
print v(xbgr.mr_n61860416)
print v(xbgr.mr_n61861856)
print v(xbgr.mr_n61861968)
print v(xbgr.mr_n61862800)
print v(xbgr.mr_n61863232)
print v(xbgr.mr_n61863744)
print v(xbgr.mr_n61864096)
print v(xbgr.mr_n61865776)
print v(xbgr.mr_n61866176)
print v(xbgr.mr_n61866592)
print v(xbgr.mr_n61867024)
print v(xbgr.mr_n61867136)
print v(xbgr.mr_n61867712)
print v(xbgr.mr_n61868400)
print v(xbgr.mr_n61868880)
print v(xbgr.mr_n61869312)
print v(xbgr.mr_n61869728)
print v(xbgr.mr_n61870416)
print v(xbgr.mr_n61870944)
print v(xbgr.mr_n61871296)
print v(xbgr.mr_n61871728)
print v(xbgr.mr_n61872416)
print v(xbgr.mr_n61873040)
print v(xbgr.mr_n61873584)
print v(xbgr.mr_n61874016)
print v(xbgr.mr_n61874432)
print v(xbgr.mr_n61875120)
print v(xbgr.mr_n61875584)
print v(xbgr.mr_n61876000)
print v(xbgr.mr_n61876432)
print v(xbgr.mr_n61877120)
print v(xbgr.mr_n61877664)
print v(xbgr.mr_n61878288)
print v(xbgr.mr_n61878720)
print v(xbgr.mr_n61879136)
print v(xbgr.mr_n61879824)
print v(xbgr.mr_n61880704)
print v(xbgr.mr_n61881136)
print v(xbgr.mr_n61881824)
print v(xbgr.mr_n61882448)
print v(xbgr.mr_n61882992)
print v(xbgr.mr_n61883488)
print v(xbgr.mr_n61883840)
print v(xbgr.mr_n61884528)
print v(xbgr.mr_n61884992)
print v(xbgr.mr_n61885408)
print v(xbgr.mr_n61885840)
print v(xbgr.mr_n61886528)
print v(xbgr.mr_n61887216)
print v(xbgr.mr_n61887696)
print v(xbgr.mr_n61888192)
print v(xbgr.mr_n61888544)
print v(xbgr.mr_n61889232)
print v(xbgr.mr_n61889616)
print v(xbgr.mr_n61890112)
print v(xbgr.mr_n61890544)
print v(xbgr.mr_n61890736)
print v(xbgr.mr_n61891008)
print v(xbgr.mr_n61891280)
print v(xbgr.mr_n61891552)
print v(xbgr.mr_n61891824)
print v(xbgr.mr_n61892096)
print v(xbgr.mr_n61892368)
print v(xbgr.mr_n61892640)
print v(xbgr.mr_n61892912)
print v(xbgr.mr_n61893184)
print v(xbgr.mr_n61893456)
print v(xbgr.mr_n61893728)
print v(xbgr.mr_n61894000)
print v(xbgr.mr_n61895776)
print v(xbgr.mr_n61902144)
print v(xbgr.mr_n61903200)
print v(xbgr.mr_n61903536)
print v(xbgr.mr_n61905136)
print v(xbgr.mr_n61911920)
print v(xbgr.mr_n61912096)
print v(xbgr.mr_n61916704)
print v(xbgr.mr_n61918112)
print v(xbgr.mr_n61918720)
print v(xbgr.mr_n61919184)
print v(xbgr.mr_n61919648)
print v(xbgr.mr_n61920112)
print v(xbgr.mr_n61920576)
print v(xbgr.mr_n61923520)
print v(xbgr.mr_n61924864)
print v(xbgr.mr_n61926656)
print v(xbgr.mr_n61930928)
print v(xbgr.mr_n61933696)
print v(xbgr.mr_n61935600)
print v(xbgr.mr_n61951040)
print v(xbgr.mr_n61952192)
print v(xbgr.mr_n61953280)
print v(xbgr.mr_n61955648)
print v(xbgr.mr_n61955840)
print v(xbgr.mr_n61956096)
print v(xbgr.mr_n61956352)
print v(xbgr.mr_n61956608)
print v(xbgr.mr_n61958784)
print v(xbgr.mr_n61958896)
print v(xbgr.mr_n61964544)
print v(xbgr.mr_n61968400)
print v(xbgr.mr_n61968512)
print v(xbgr.mr_n61968624)
print v(xbgr.mr_n61970464)
print v(xbgr.mr_n61970576)
print v(xbgr.mr_n61970688)
print v(xbgr.mr_n61972528)
print v(xbgr.mr_n61972640)
print v(xbgr.mr_n61972752)
print v(xbgr.mr_n61974592)
print v(xbgr.mr_n61974704)
print v(xbgr.mr_n61974816)
print v(xbgr.mr_n61976320)
print v(xbgr.mr_n61976912)
print v(xbgr.mr_n61977024)
print v(xbgr.mr_n61977136)
print v(xbgr.mr_n61978480)
print v(xbgr.mr_n61979232)
print v(xbgr.mr_n61979344)
print v(xbgr.mr_n61979456)
print v(xbgr.mr_n61981040)
print v(xbgr.mr_n61981552)
print v(xbgr.mr_n61981664)
print v(xbgr.mr_n61981776)
print v(xbgr.mr_n61983120)
print v(xbgr.mr_n61983872)
print v(xbgr.mr_n61983984)
print v(xbgr.mr_n61984096)
print v(xbgr.mr_n61985680)
print v(xbgr.mr_n61986192)
print v(xbgr.mr_n61986304)
print v(xbgr.mr_n61986416)
print v(xbgr.mr_n61987920)
print v(xbgr.mr_n61988512)
print v(xbgr.mr_n61988624)
print v(xbgr.mr_n61988736)
print v(xbgr.mr_n61990320)
print v(xbgr.mr_n61990832)
print v(xbgr.mr_n61990944)
print v(xbgr.mr_n61991056)
print v(xbgr.mr_n61992640)
print v(xbgr.mr_n61993152)
print v(xbgr.mr_n61993264)
print v(xbgr.mr_n61993376)
print v(xbgr.mr_n61994960)
print v(xbgr.mr_n61995472)
print v(xbgr.mr_n61995584)
print v(xbgr.mr_n61995696)
print v(xbgr.mr_n61996288)
print v(xbgr.mr_n61997296)
print v(xbgr.mr_n61997408)
print v(xbgr.mr_n61997520)
print v(xbgr.mr_n61997632)
print v(xbgr.mr_n61998384)
print v(xbgr.mr_n61999216)
print v(xbgr.mr_n61999328)
print v(xbgr.mr_n62000640)
print v(xbgr.mr_n62000752)
print v(xbgr.mr_n62000864)
print v(xbgr.mr_n62000976)
print v(xbgr.mr_n62001248)
print v(xbgr.mr_n62001360)
print v(xbgr.mr_n62001712)
print v(xbgr.mr_n62001824)
print v(xbgr.mr_n62001936)
print v(xbgr.mr_n62002368)
print v(xbgr.mr_n62002720)
print v(xbgr.mr_n62002832)
print v(xbgr.mr_n62003248)
print v(xbgr.mr_n62003904)
print v(xbgr.mr_n62004368)
print v(xbgr.mr_n62004784)
print v(xbgr.mr_n62005216)
print v(xbgr.mr_n62005904)
print v(xbgr.mr_n62006448)
print v(xbgr.mr_n62007072)
print v(xbgr.mr_n62007568)
print v(xbgr.mr_n62007920)
print v(xbgr.mr_n62008608)
print v(xbgr.mr_n62009136)
print v(xbgr.mr_n62009488)
print v(xbgr.mr_n62009920)
print v(xbgr.mr_n62010032)
print v(xbgr.mr_n62010608)
print v(xbgr.mr_n62011296)
print v(xbgr.mr_n62011776)
print v(xbgr.mr_n62012208)
print v(xbgr.mr_n62012624)
print v(xbgr.mr_n62013312)
print v(xbgr.mr_n62013840)
print v(xbgr.mr_n62014192)
print v(xbgr.mr_n62014624)
print v(xbgr.mr_n62015312)
print v(xbgr.mr_n62015936)
print v(xbgr.mr_n62016480)
print v(xbgr.mr_n62016912)
print v(xbgr.mr_n62017328)
print v(xbgr.mr_n62018016)
print v(xbgr.mr_n62018544)
print v(xbgr.mr_n62018896)
print v(xbgr.mr_n62019328)
print v(xbgr.mr_n62020016)
print v(xbgr.mr_n62020640)
print v(xbgr.mr_n62021056)
print v(xbgr.mr_n62021168)
print v(xbgr.mr_n62021360)
print v(xbgr.mr_n62021632)
print v(xbgr.mr_n62021904)
print v(xbgr.mr_n62022176)
print v(xbgr.mr_n62022448)
print v(xbgr.mr_n62022720)
print v(xbgr.mr_n62022992)
print v(xbgr.mr_n62023264)
print v(xbgr.mr_n62023536)
print v(xbgr.mr_n62023808)
print v(xbgr.mr_n62024080)
print v(xbgr.mr_n62024352)
print v(xbgr.mr_n62024624)
print v(xbgr.mr_n62024896)
print v(xbgr.mr_n62025168)
print v(xbgr.mr_n62025440)
print v(xbgr.mr_n62025616)
print v(xbgr.mr_n62027232)
print v(xbgr.mr_n62032016)
print v(xbgr.mr_n62035856)
print v(xbgr.mr_n62043312)
print v(xbgr.mr_n62043776)
print v(xbgr.mr_n62044240)
print v(xbgr.mr_n62044704)
print v(xbgr.mr_n62045168)
print v(xbgr.mr_n62045632)
print v(xbgr.mr_n62046096)
print v(xbgr.mr_n62046624)
print v(xbgr.mr_n62047216)
print v(xbgr.mr_n62047808)
print v(xbgr.mr_n62048400)
print v(xbgr.mr_n62048992)
print v(xbgr.mr_n62049584)
print v(xbgr.mr_n62050176)
print v(xbgr.mr_n62050768)
print v(xbgr.mr_n62051360)
print v(xbgr.mr_n62051952)
print v(xbgr.mr_n62053728)
print v(xbgr.mr_n62055280)
print v(xbgr.mr_n62070128)
print v(xbgr.mr_n62074240)
print v(xbgr.mr_n62075248)
print v(xbgr.mr_n62076400)
print v(xbgr.mr_n62081312)
print v(xbgr.mr_n62082928)
print v(xbgr.mr_n62083120)
print v(xbgr.mr_n62083376)
print v(xbgr.mr_n62083632)
print v(xbgr.mr_n62083888)
print v(xbgr.mr_n62086320)
print v(xbgr.mr_n62086432)
print v(xbgr.mr_n62094400)
print v(xbgr.mr_n62094512)
print v(xbgr.mr_n62094624)
print v(xbgr.mr_n62096464)
print v(xbgr.mr_n62096576)
print v(xbgr.mr_n62096688)
print v(xbgr.mr_n62098528)
print v(xbgr.mr_n62098640)
print v(xbgr.mr_n62098752)
print v(xbgr.mr_n62100592)
print v(xbgr.mr_n62100704)
print v(xbgr.mr_n62100816)
print v(xbgr.mr_n62102656)
print v(xbgr.mr_n62102768)
print v(xbgr.mr_n62102880)
print v(xbgr.mr_n62104720)
print v(xbgr.mr_n62104832)
print v(xbgr.mr_n62104944)
print v(xbgr.mr_n62106784)
print v(xbgr.mr_n62106896)
print v(xbgr.mr_n62107008)
print v(xbgr.mr_n62108848)
print v(xbgr.mr_n62108960)
print v(xbgr.mr_n62109072)
print v(xbgr.mr_n62110912)
print v(xbgr.mr_n62111024)
print v(xbgr.mr_n62111136)
print v(xbgr.mr_n62112976)
print v(xbgr.mr_n62113088)
print v(xbgr.mr_n62113200)
print v(xbgr.mr_n62115040)
print v(xbgr.mr_n62115152)
print v(xbgr.mr_n62115264)
print v(xbgr.mr_n62117104)
print v(xbgr.mr_n62117216)
print v(xbgr.mr_n62117328)
print v(xbgr.mr_n62119168)
print v(xbgr.mr_n62119280)
print v(xbgr.mr_n62119392)
print v(xbgr.mr_n62121232)
print v(xbgr.mr_n62121344)
print v(xbgr.mr_n62121456)
print v(xbgr.mr_n62123296)
print v(xbgr.mr_n62123408)
print v(xbgr.mr_n62123520)
print v(xbgr.mr_n62125360)
print v(xbgr.mr_n62125472)
print v(xbgr.mr_n62125584)
print v(xbgr.mr_n62127424)
print v(xbgr.mr_n62127536)
print v(xbgr.mr_n62127648)
print v(xbgr.mr_n62127760)
print v(xbgr.mr_n62128032)
print v(xbgr.mr_n62128144)
print v(xbgr.mr_n62128496)
print v(xbgr.mr_n62128608)
print v(xbgr.mr_n62129072)
print v(xbgr.mr_n62129424)
print v(xbgr.mr_n62129856)
print v(xbgr.mr_n62130416)
print v(xbgr.mr_n62130960)
print v(xbgr.mr_n62131584)
print v(xbgr.mr_n62132080)
print v(xbgr.mr_n62132192)
print v(xbgr.mr_n62132304)
print v(xbgr.mr_n62132416)
print v(xbgr.mr_n62132528)
print v(xbgr.mr_n62133120)
print v(xbgr.mr_n62133392)
print v(xbgr.mr_n62134032)
print v(xbgr.mr_n62134448)
print v(xbgr.mr_n62134816)
print v(xbgr.mr_n62135232)
print v(xbgr.mr_n62137392)
print v(xbgr.mr_n62137920)
print v(xbgr.mr_n62138272)
print v(xbgr.mr_n62138704)
print v(xbgr.mr_n62139392)
print v(xbgr.mr_n62140016)
print v(xbgr.mr_n62140560)
print v(xbgr.mr_n62140992)
print v(xbgr.mr_n62141408)
print v(xbgr.mr_n62142096)
print v(xbgr.mr_n62142624)
print v(xbgr.mr_n62142976)
print v(xbgr.mr_n62143408)
print v(xbgr.mr_n62144096)
print v(xbgr.mr_n62144720)
print v(xbgr.mr_n62145264)
print v(xbgr.mr_n62145696)
print v(xbgr.mr_n62146112)
print v(xbgr.mr_n62146800)
print v(xbgr.mr_n62147328)
print v(xbgr.mr_n62147680)
print v(xbgr.mr_n62148112)
print v(xbgr.mr_n62148800)
print v(xbgr.mr_n62149424)
print v(xbgr.mr_n62149840)
print v(xbgr.mr_n62149952)
print v(xbgr.mr_n62150144)
print v(xbgr.mr_n62150416)
print v(xbgr.mr_n62150688)
print v(xbgr.mr_n62150960)
print v(xbgr.mr_n62151232)
print v(xbgr.mr_n62151504)
print v(xbgr.mr_n62151776)
print v(xbgr.mr_n62152048)
print v(xbgr.mr_n62152320)
print v(xbgr.mr_n62152592)
print v(xbgr.mr_n62152864)
print v(xbgr.mr_n62153136)
print v(xbgr.mr_n62153408)
print v(xbgr.mr_n62153680)
print v(xbgr.mr_n62153952)
print v(xbgr.mr_n62154224)
print v(xbgr.mr_n62156848)
print v(xbgr.mr_n62161584)
print v(xbgr.mr_n62163440)
print v(xbgr.mr_n62177984)
print v(xbgr.mr_n62178448)
print v(xbgr.mr_n62178912)
print v(xbgr.mr_n62179376)
print v(xbgr.mr_n62179840)
print v(xbgr.mr_n62180304)
print v(xbgr.mr_n62180768)
print v(xbgr.mr_n62181296)
print v(xbgr.mr_n62181888)
print v(xbgr.mr_n62182480)
print v(xbgr.mr_n62183072)
print v(xbgr.mr_n62183664)
print v(xbgr.mr_n62184256)
print v(xbgr.mr_n62184848)
print v(xbgr.mr_n62185440)
print v(xbgr.mr_n62186032)
print v(xbgr.mr_n62186624)
print v(xbgr.mr_n62190400)
print v(xbgr.mr_n62195968)
print v(xbgr.mr_n62196528)
print v(xbgr.mr_n62197552)
print v(xbgr.mr_n62210928)
print v(xbgr.mr_n62211104)
print v(xbgr.mr_n62211440)
print v(xbgr.mr_n62212448)
print v(xbgr.mr_n62213312)
print v(xbgr.mr_n62213904)
print v(xbgr.mr_n62214496)
print v(xbgr.mr_n62215088)
print v(xbgr.mr_n62215680)
print v(xbgr.mr_n62216272)
print v(xbgr.mr_n62216864)
print v(xbgr.mr_n62217456)
print v(xbgr.mr_n62218048)
print v(xbgr.mr_n62218640)
print v(xbgr.mr_n62219232)
print v(xbgr.mr_n62219824)
print v(xbgr.mr_n62220416)
print v(xbgr.mr_n62221008)
print v(xbgr.mr_n62221600)
print v(xbgr.mr_n62222192)
print v(xbgr.mr_n62222784)
print v(xbgr.mr_n62223376)
print v(xbgr.mr_n62223968)
print v(xbgr.mr_n62225920)
print v(xbgr.mr_n62229136)
print v(xbgr.mr_n62231056)
print v(xbgr.mr_n62231536)
print v(xbgr.mr_n62232032)
print v(xbgr.mr_n62232384)
print v(xbgr.mr_n62232496)
print v(xbgr.mr_n62232608)
print v(xbgr.mr_n62233504)
print v(xbgr.mr_n62233616)
print v(xbgr.mr_n62236176)
print v(xbgr.mr_n62236288)
print v(xbgr.mr_n62236400)
print v(xbgr.mr_n62237296)
print v(xbgr.mr_n62237408)
print v(xbgr.mr_n62239968)
print v(xbgr.mr_n62240080)
print v(xbgr.mr_n62240192)
print v(xbgr.mr_n62241088)
print v(xbgr.mr_n62241200)
print v(xbgr.mr_n62242352)
print v(xbgr.mr_n62243760)
print v(xbgr.mr_n62243872)
print v(xbgr.mr_n62243984)
print v(xbgr.mr_n62244880)
print v(xbgr.mr_n62244992)
print v(xbgr.mr_n62247200)
print v(xbgr.mr_n62247552)
print v(xbgr.mr_n62247664)
print v(xbgr.mr_n62247776)
print v(xbgr.mr_n62248672)
print v(xbgr.mr_n62248784)
print v(xbgr.mr_n62251344)
print v(xbgr.mr_n62251456)
print v(xbgr.mr_n62251568)
print v(xbgr.mr_n62252464)
print v(xbgr.mr_n62252576)
print v(xbgr.mr_n62255136)
print v(xbgr.mr_n62255248)
print v(xbgr.mr_n62255360)
print v(xbgr.mr_n62256256)
print v(xbgr.mr_n62256368)
print v(xbgr.mr_n62256960)
print v(xbgr.mr_n62258576)
print v(xbgr.mr_n62258928)
print v(xbgr.mr_n62259040)
print v(xbgr.mr_n62259152)
print v(xbgr.mr_n62260048)
print v(xbgr.mr_n62260160)
print v(xbgr.mr_n62260432)
print v(xbgr.mr_n62260752)
print v(xbgr.mr_n62262720)
print v(xbgr.mr_n62262832)
print v(xbgr.mr_n62262944)
print v(xbgr.mr_n62263840)
print v(xbgr.mr_n62263952)
print v(xbgr.mr_n62266512)
print v(xbgr.mr_n62266624)
print v(xbgr.mr_n62266736)
print v(xbgr.mr_n62268416)
print v(xbgr.mr_n62268528)
print v(xbgr.mr_n62270656)
print v(xbgr.mr_n62271808)
print v(xbgr.mr_n62272864)
print v(xbgr.mr_n62274992)
print v(xbgr.mr_n62275280)
print v(xbgr.mr_n62276784)
print v(xbgr.mr_n62282944)
print v(xbgr.mr_n62283568)
print v(xbgr.mr_n62283744)
print v(xbgr.mr_n62284368)
print v(xbgr.mr_n62284544)
print v(xbgr.mr_n62285168)
print v(xbgr.mr_n62285344)
print v(xbgr.mr_n62285968)
print v(xbgr.mr_n62286144)
print v(xbgr.mr_n62286768)
print v(xbgr.mr_n62286944)
print v(xbgr.mr_n62287568)
print v(xbgr.mr_n62287744)
print v(xbgr.mr_n62288368)
print v(xbgr.mr_n62288544)
print v(xbgr.mr_n62289168)
print v(xbgr.mr_n62289344)
print v(xbgr.mr_n62289968)
print v(xbgr.mr_n62290144)
print v(xbgr.mr_n62290768)
print v(xbgr.mr_n62290944)
print v(xbgr.mr_n62291568)
print v(xbgr.mr_n62291744)
print v(xbgr.mr_n62292368)
print v(xbgr.mr_n62292544)
print v(xbgr.mr_n62293168)
print v(xbgr.mr_n62293344)
print v(xbgr.mr_n62293968)
print v(xbgr.mr_n62294144)
print v(xbgr.mr_n62294768)
print v(xbgr.mr_n62294944)
print v(xbgr.mr_n62295376)
print v(xbgr.mr_n62295488)
print v(xbgr.mr_n62295600)
print v(xbgr.mr_n62295712)
print v(xbgr.mr_n62295904)
print v(xbgr.mr_n62296176)
print v(xbgr.mr_n62296448)
print v(xbgr.mr_n62296720)
print v(xbgr.mr_n62296992)
print v(xbgr.mr_n62297264)
print v(xbgr.mr_n62297536)
print v(xbgr.mr_n62297808)
print v(xbgr.mr_n62298080)
print v(xbgr.mr_n62298352)
print v(xbgr.mr_n62298624)
print v(xbgr.mr_n62298896)
print v(xbgr.mr_n62299168)
print v(xbgr.mr_n62307920)
print v(xbgr.mr_n62308320)
print v(xbgr.mr_n62314064)
print v(xbgr.mr_n62330576)
print v(xbgr.mr_n62331808)
print v(xbgr.mr_n62335136)
print v(xbgr.mr_n62336672)
print v(xbgr.mr_n62338528)
print v(xbgr.mr_n62338704)
print v(xbgr.mr_n62340464)
print v(xbgr.mr_n62340640)
print v(xbgr.mr_n62340976)
print v(xbgr.mr_n62342912)
print v(xbgr.mr_n62343088)
print v(xbgr.mr_n62344032)
print v(xbgr.mr_n62344688)
print v(xbgr.mr_n62344864)
print v(xbgr.mr_n62345808)
print v(xbgr.mr_n62346464)
print v(xbgr.mr_n62346640)
print v(xbgr.mr_n62347584)
print v(xbgr.mr_n62348240)
print v(xbgr.mr_n62348416)
print v(xbgr.mr_n62349360)
print v(xbgr.mr_n62350016)
print v(xbgr.mr_n62350192)
print v(xbgr.mr_n62351136)
print v(xbgr.mr_n62351792)
print v(xbgr.mr_n62351968)
print v(xbgr.mr_n62352912)
print v(xbgr.mr_n62353568)
print v(xbgr.mr_n62353744)
print v(xbgr.mr_n62354688)
print v(xbgr.mr_n62355344)
print v(xbgr.mr_n62355520)
print v(xbgr.mr_n62356464)
print v(xbgr.mr_n62357120)
print v(xbgr.mr_n62357296)
print v(xbgr.mr_n62358240)
print v(xbgr.mr_n62358896)
print v(xbgr.mr_n62359072)
print v(xbgr.mr_n62360112)
print v(xbgr.mr_n62360384)
print v(xbgr.mr_n62360656)
print v(xbgr.mr_n62360992)
print v(xbgr.mr_n62361456)
print v(xbgr.mr_n62361648)
print v(xbgr.mr_n62361840)
print v(xbgr.mr_n62362032)
print v(xbgr.mr_n62362224)
print v(xbgr.mr_n62362416)
print v(xbgr.mr_n62363248)
print v(xbgr.mr_n62363360)
print v(xbgr.mr_n62366624)
print v(xbgr.mr_n62366736)
print v(xbgr.mr_n62366848)
print v(xbgr.mr_n62367360)
print v(xbgr.mr_n62367472)
print v(xbgr.mr_n62369200)
print v(xbgr.mr_n62369312)
print v(xbgr.mr_n62369424)
print v(xbgr.mr_n62370256)
print v(xbgr.mr_n62370368)
print v(xbgr.mr_n62372928)
print v(xbgr.mr_n62373040)
print v(xbgr.mr_n62373152)
print v(xbgr.mr_n62374048)
print v(xbgr.mr_n62374160)
print v(xbgr.mr_n62376720)
print v(xbgr.mr_n62376832)
print v(xbgr.mr_n62376944)
print v(xbgr.mr_n62377840)
print v(xbgr.mr_n62377952)
print v(xbgr.mr_n62380512)
print v(xbgr.mr_n62380624)
print v(xbgr.mr_n62380736)
print v(xbgr.mr_n62381632)
print v(xbgr.mr_n62381744)
print v(xbgr.mr_n62384304)
print v(xbgr.mr_n62384416)
print v(xbgr.mr_n62384528)
print v(xbgr.mr_n62385424)
print v(xbgr.mr_n62385536)
print v(xbgr.mr_n62387600)
print v(xbgr.mr_n62388096)
print v(xbgr.mr_n62388208)
print v(xbgr.mr_n62388320)
print v(xbgr.mr_n62389216)
print v(xbgr.mr_n62389328)
print v(xbgr.mr_n62391888)
print v(xbgr.mr_n62392000)
print v(xbgr.mr_n62392112)
print v(xbgr.mr_n62393008)
print v(xbgr.mr_n62393120)
print v(xbgr.mr_n62395680)
print v(xbgr.mr_n62395792)
print v(xbgr.mr_n62395904)
print v(xbgr.mr_n62396800)
print v(xbgr.mr_n62396912)
print v(xbgr.mr_n62397216)
print v(xbgr.mr_n62399472)
print v(xbgr.mr_n62399584)
print v(xbgr.mr_n62399696)
print v(xbgr.mr_n62400592)
print v(xbgr.mr_n62400704)
print v(xbgr.mr_n62402032)
print v(xbgr.mr_n62402624)
print v(xbgr.mr_n62406800)
print v(xbgr.mr_n62408320)
print v(xbgr.mr_n62412928)
print v(xbgr.mr_n62413104)
print v(xbgr.mr_n62413728)
print v(xbgr.mr_n62413904)
print v(xbgr.mr_n62414528)
print v(xbgr.mr_n62414704)
print v(xbgr.mr_n62415328)
print v(xbgr.mr_n62415504)
print v(xbgr.mr_n62416128)
print v(xbgr.mr_n62416304)
print v(xbgr.mr_n62416928)
print v(xbgr.mr_n62417104)
print v(xbgr.mr_n62417728)
print v(xbgr.mr_n62417904)
print v(xbgr.mr_n62418528)
print v(xbgr.mr_n62418704)
print v(xbgr.mr_n62419328)
print v(xbgr.mr_n62419504)
print v(xbgr.mr_n62420128)
print v(xbgr.mr_n62420304)
print v(xbgr.mr_n62420928)
print v(xbgr.mr_n62421104)
print v(xbgr.mr_n62421728)
print v(xbgr.mr_n62421904)
print v(xbgr.mr_n62422528)
print v(xbgr.mr_n62422704)
print v(xbgr.mr_n62423328)
print v(xbgr.mr_n62423504)
print v(xbgr.mr_n62424128)
print v(xbgr.mr_n62424304)
print v(xbgr.mr_n62426224)
print v(xbgr.mr_n62427168)
print v(xbgr.mr_n62427408)
print v(xbgr.mr_n62433072)
print v(xbgr.mr_n62434848)
print v(xbgr.mr_n62435152)
print v(xbgr.mr_n62435456)
print v(xbgr.mr_n62435760)
print v(xbgr.mr_n62436144)
print v(xbgr.mr_n62436608)
print v(xbgr.mr_n62437072)
print v(xbgr.mr_n62437536)
print v(xbgr.mr_n62438000)
print v(xbgr.mr_n62438464)
print v(xbgr.mr_n62438928)
print v(xbgr.mr_n62439392)
print v(xbgr.mr_n62439856)
print v(xbgr.mr_n62440320)
print v(xbgr.mr_n62440784)
print v(xbgr.mr_n62441248)
print v(xbgr.mr_n62441712)
print v(xbgr.mr_n62442176)
print v(xbgr.mr_n62442640)
print v(xbgr.mr_n62443104)
print v(xbgr.mr_n62443568)
print v(xbgr.mr_n62444032)
print v(xbgr.mr_n62444496)
print v(xbgr.mr_n62444960)
print v(xbgr.mr_n62445424)
print v(xbgr.mr_n62445888)
print v(xbgr.mr_n62446352)
print v(xbgr.mr_n62446816)
print v(xbgr.mr_n62447280)
print v(xbgr.mr_n62447744)
print v(xbgr.mr_n62457712)
print v(xbgr.mr_n62462128)
print v(xbgr.mr_n62469296)
print v(xbgr.mr_n62469696)
print v(xbgr.mr_n62471808)
print v(xbgr.mr_n62472336)
print v(xbgr.mr_n62472800)
print v(xbgr.mr_n62473264)
print v(xbgr.mr_n62473792)
print v(xbgr.mr_n62474384)
print v(xbgr.mr_n62474976)
print v(xbgr.mr_n62475568)
print v(xbgr.mr_n62476160)
print v(xbgr.mr_n62476752)
print v(xbgr.mr_n62477344)
print v(xbgr.mr_n62477936)
print v(xbgr.mr_n62478528)
print v(xbgr.mr_n62479120)
print v(xbgr.mr_n62479712)
print v(xbgr.mr_n62480304)
print v(xbgr.mr_n62480896)
print v(xbgr.mr_n62481488)
print v(xbgr.mr_n62491984)
print v(xbgr.mr_n62494016)
print v(xbgr.mr_n62494832)
print v(xbgr.mr_n62501040)
print v(xbgr.mr_n62501968)
print v(xbgr.mr_n62505008)
print v(xbgr.mr_n62505200)
print v(xbgr.mr_n62505456)
print v(xbgr.mr_n62505712)
print v(xbgr.mr_n62505968)
print v(xbgr.mr_n62508400)
print v(xbgr.mr_n62508512)
print v(xbgr.mr_n62510352)
print v(xbgr.mr_n62512192)
print v(xbgr.mr_n62514032)
print v(xbgr.mr_n62515872)
print v(xbgr.mr_n62517712)
print v(xbgr.mr_n62519552)
print v(xbgr.mr_n62521392)
print v(xbgr.mr_n62523232)
print v(xbgr.mr_n62525072)
print v(xbgr.mr_n62526912)
print v(xbgr.mr_n62528752)
print v(xbgr.mr_n62530592)
print v(xbgr.mr_n62534272)
print v(xbgr.mr_n62536112)
print v(xbgr.mr_n62543152)
print v(xbgr.mr_n62544384)
print v(xbgr.mr_n62547888)
print v(xbgr.mr_n62549248)
print v(xbgr.mr_n62550752)
print v(xbgr.mr_n62561840)
print v(xbgr.mr_n62562896)
print v(xbgr.mr_n62563088)
print v(xbgr.mr_n62564672)
print v(xbgr.mr_n62567120)
print v(xbgr.mr_n62567296)
print v(xbgr.mr_n62567680)
print v(xbgr.mr_n62569264)
print v(xbgr.mr_n62570112)
print v(xbgr.mr_n62573968)
print v(xbgr.mr_n62574816)
print v(xbgr.mr_n62576320)
print v(xbgr.mr_n62577200)
print v(xbgr.mr_n62578592)
print v(xbgr.mr_n62579248)
print v(xbgr.mr_n62579520)
print v(xbgr.mr_n62579808)
print v(xbgr.mr_n62580032)
print v(xbgr.mr_n62581024)
print v(xbgr.mr_n62582064)
print v(xbgr.mr_n62583856)
print v(xbgr.mr_n62584560)
print v(xbgr.mr_n62586160)
print v(xbgr.mr_n62587360)
print v(xbgr.mr_n62588336)
print v(xbgr.mr_n62589120)
print v(xbgr.mr_n62589680)
print v(xbgr.mr_n62589856)
print v(xbgr.mr_n62590272)
print v(xbgr.mr_n62591184)
print v(xbgr.mr_n62591360)
print v(xbgr.mr_n62591536)
print v(xbgr.mr_n62591872)
print v(xbgr.mr_n62592848)
print v(xbgr.mr_n62593024)
print v(xbgr.mr_n62593200)
print v(xbgr.mr_n62593696)
print v(xbgr.mr_n62594208)
print v(xbgr.mr_n62594768)
print v(xbgr.mr_n62594944)
print v(xbgr.mr_n62595440)
print v(xbgr.mr_n62595952)
print v(xbgr.mr_n62596064)
print v(xbgr.mr_n62596176)
print v(xbgr.mr_n62597168)
print v(xbgr.mr_n62597504)
print v(xbgr.mr_n62598352)
print v(xbgr.mr_n62598528)
print v(xbgr.mr_n62598704)
print v(xbgr.mr_n62599296)
print v(xbgr.mr_n62599856)
print v(xbgr.mr_n62600032)
print v(xbgr.mr_n62600528)
print v(xbgr.mr_n62601040)
print v(xbgr.mr_n62601152)
print v(xbgr.mr_n62601264)
print v(xbgr.mr_n62602256)
print v(xbgr.mr_n62602592)
print v(xbgr.mr_n62603184)
print v(xbgr.mr_n62603680)
print v(xbgr.mr_n62603856)
print v(xbgr.mr_n62604272)
print v(xbgr.mr_n62605104)
print v(xbgr.mr_n62605280)
print v(xbgr.mr_n62605536)
print v(xbgr.mr_n62606128)
print v(xbgr.mr_n62606240)
print v(xbgr.mr_n62606352)
print v(xbgr.mr_n62607344)
print v(xbgr.mr_n62607760)
print v(xbgr.mr_n62608272)
print v(xbgr.mr_n62608768)
print v(xbgr.mr_n62608944)
print v(xbgr.mr_n62609280)
print v(xbgr.mr_n62609872)
print v(xbgr.mr_n62610432)
print v(xbgr.mr_n62610608)
print v(xbgr.mr_n62611024)
print v(xbgr.mr_n62611616)
print v(xbgr.mr_n62611728)
print v(xbgr.mr_n62612432)
print v(xbgr.mr_n62612768)
print v(xbgr.mr_n62613360)
print v(xbgr.mr_n62613856)
print v(xbgr.mr_n62614032)
print v(xbgr.mr_n62614208)
print v(xbgr.mr_n62614960)
print v(xbgr.mr_n62615520)
print v(xbgr.mr_n62615696)
print v(xbgr.mr_n62616112)
print v(xbgr.mr_n62616704)
print v(xbgr.mr_n62616816)
print v(xbgr.mr_n62616928)
print v(xbgr.mr_n62617280)
print v(xbgr.mr_n62617392)
print v(xbgr.mr_n62617904)
print v(xbgr.mr_n62618016)
print v(xbgr.mr_n62618128)
print v(xbgr.mr_n62618352)
print v(xbgr.mr_n62619168)
print v(xbgr.mr_n62619600)
print v(xbgr.mr_n62619776)
print v(xbgr.mr_n62620512)
print v(xbgr.mr_n62620944)
print v(xbgr.mr_n62621120)
print v(xbgr.mr_n62621856)
print v(xbgr.mr_n62622288)
print v(xbgr.mr_n62622464)
print v(xbgr.mr_n62623200)
print v(xbgr.mr_n62623632)
print v(xbgr.mr_n62623808)
print v(xbgr.mr_n62624544)
print v(xbgr.mr_n62624976)
print v(xbgr.mr_n62625152)
print v(xbgr.mr_n62625888)
print v(xbgr.mr_n62626320)
print v(xbgr.mr_n62626496)
print v(xbgr.mr_n62627232)
print v(xbgr.mr_n62627664)
print v(xbgr.mr_n62627840)
print v(xbgr.mr_n62628576)
print v(xbgr.mr_n62629008)
print v(xbgr.mr_n62629184)
print v(xbgr.mr_n62629920)
print v(xbgr.mr_n62630352)
print v(xbgr.mr_n62630528)
print v(xbgr.mr_n62631264)
print v(xbgr.mr_n62631696)
print v(xbgr.mr_n62631872)
print v(xbgr.mr_n62632608)
print v(xbgr.mr_n62633040)
print v(xbgr.mr_n62633216)
print v(xbgr.mr_n62633872)
print v(xbgr.mr_n62634304)
print v(xbgr.mr_n62634480)
print v(xbgr.mr_n62635216)
print v(xbgr.mr_n62635648)
print v(xbgr.mr_n62635824)
print v(xbgr.mr_n62636560)
print v(xbgr.mr_n62636992)
print v(xbgr.mr_n62637168)
print v(xbgr.mr_n62637904)
print v(xbgr.mr_n62638336)
print v(xbgr.mr_n62638512)
print v(xbgr.mr_n62639248)
print v(xbgr.mr_n62639680)
print v(xbgr.mr_n62639856)
print v(xbgr.mr_n62640592)
print v(xbgr.mr_n62641024)
print v(xbgr.mr_n62641200)
print v(xbgr.mr_n62641936)
print v(xbgr.mr_n62642368)
print v(xbgr.mr_n62642544)
print v(xbgr.mr_n62643280)
print v(xbgr.mr_n62643712)
print v(xbgr.mr_n62643888)
print v(xbgr.mr_n62644624)
print v(xbgr.mr_n62644736)
print v(xbgr.mr_n62644928)
print v(xbgr.mr_n62645200)
print v(xbgr.mr_n62645472)
print v(xbgr.mr_n62645744)
print v(xbgr.mr_n62646016)
print v(xbgr.mr_n62646288)
print v(xbgr.mr_n62646560)
print v(xbgr.mr_n62646832)
print v(xbgr.mr_n62647104)
print v(xbgr.mr_n62647376)
print v(xbgr.mr_n62647648)
print v(xbgr.mr_n62647920)
print v(xbgr.mr_n62648864)
print v(xbgr.mr_n62652256)
print v(xbgr.mr_n62655072)
print v(xbgr.mr_n62659744)
print v(xbgr.mr_n62665568)
print v(xbgr.mr_n62672864)
print v(xbgr.mr_n62672976)
print v(xbgr.mr_n62673376)
print v(xbgr.mr_n62674160)
print v(xbgr.mr_n62674624)
print v(xbgr.mr_n62675088)
print v(xbgr.mr_n62675552)
print v(xbgr.mr_n62676176)
print v(xbgr.mr_n62677152)
print v(xbgr.mr_n62677744)
print v(xbgr.mr_n62678336)
print v(xbgr.mr_n62678928)
print v(xbgr.mr_n62679520)
print v(xbgr.mr_n62680112)
print v(xbgr.mr_n62687408)
print v(xbgr.mr_n62689136)
print v(xbgr.mr_n62690032)
print v(xbgr.mr_n62696992)
print v(xbgr.mr_n62698320)
print v(xbgr.mr_n62706720)
print v(xbgr.mr_n62707968)
print v(xbgr.mr_n62708160)
print v(xbgr.mr_n62709248)
print v(xbgr.mr_n62711936)
print v(xbgr.mr_n62712832)
print v(xbgr.mr_n62715616)
print v(xbgr.mr_n62717568)
print v(xbgr.mr_n62717904)
print v(xbgr.mr_n62718240)
print v(xbgr.mr_n62718576)
print v(xbgr.mr_n62719104)
print v(xbgr.mr_n62720608)
print v(xbgr.mr_n62721248)
print v(xbgr.mr_n62721360)
print v(xbgr.mr_n62721472)
print v(xbgr.mr_n62721584)
print v(xbgr.mr_n62723424)
print v(xbgr.mr_n62723536)
print v(xbgr.mr_n62723648)
print v(xbgr.mr_n62725488)
print v(xbgr.mr_n62725600)
print v(xbgr.mr_n62725712)
print v(xbgr.mr_n62727552)
print v(xbgr.mr_n62727664)
print v(xbgr.mr_n62727776)
print v(xbgr.mr_n62729616)
print v(xbgr.mr_n62729728)
print v(xbgr.mr_n62729840)
print v(xbgr.mr_n62731680)
print v(xbgr.mr_n62731792)
print v(xbgr.mr_n62731904)
print v(xbgr.mr_n62733744)
print v(xbgr.mr_n62733856)
print v(xbgr.mr_n62733968)
print v(xbgr.mr_n62735808)
print v(xbgr.mr_n62735920)
print v(xbgr.mr_n62736032)
print v(xbgr.mr_n62737872)
print v(xbgr.mr_n62737984)
print v(xbgr.mr_n62738096)
print v(xbgr.mr_n62739936)
print v(xbgr.mr_n62740048)
print v(xbgr.mr_n62740160)
print v(xbgr.mr_n62742000)
print v(xbgr.mr_n62742112)
print v(xbgr.mr_n62742224)
print v(xbgr.mr_n62744064)
print v(xbgr.mr_n62744176)
print v(xbgr.mr_n62744288)
print v(xbgr.mr_n62746128)
print v(xbgr.mr_n62746240)
print v(xbgr.mr_n62746352)
print v(xbgr.mr_n62748192)
print v(xbgr.mr_n62748304)
print v(xbgr.mr_n62748416)
print v(xbgr.mr_n62750256)
print v(xbgr.mr_n62750368)
print v(xbgr.mr_n62750480)
print v(xbgr.mr_n62752320)
print v(xbgr.mr_n62752432)
print v(xbgr.mr_n62752544)
print v(xbgr.mr_n62754384)
print v(xbgr.mr_n62754496)
print v(xbgr.mr_n62754608)
print v(xbgr.mr_n62777136)
print v(xbgr.mr_n62781472)
print v(xbgr.mr_n62786480)
print v(xbgr.mr_n62786592)
print v(xbgr.mr_n62787408)
print v(xbgr.mr_n62787872)
print v(xbgr.mr_n62787984)
print v(xbgr.mr_n62788800)
print v(xbgr.mr_n62789392)
print v(xbgr.mr_n62789568)
print v(xbgr.mr_n62790512)
print v(xbgr.mr_n62791168)
print v(xbgr.mr_n62791344)
print v(xbgr.mr_n62792288)
print v(xbgr.mr_n62792944)
print v(xbgr.mr_n62793120)
print v(xbgr.mr_n62794064)
print v(xbgr.mr_n62794720)
print v(xbgr.mr_n62794896)
print v(xbgr.mr_n62795840)
print v(xbgr.mr_n62796496)
print v(xbgr.mr_n62796672)
print v(xbgr.mr_n62797616)
print v(xbgr.mr_n62798272)
print v(xbgr.mr_n62798448)
print v(xbgr.mr_n62799392)
print v(xbgr.mr_n62800048)
print v(xbgr.mr_n62800224)
print v(xbgr.mr_n62801168)
print v(xbgr.mr_n62801760)
print v(xbgr.mr_n62802352)
print v(xbgr.mr_n62802944)
print v(xbgr.mr_n62803536)
print v(xbgr.mr_n62804128)
print v(xbgr.mr_n62804720)
print v(xbgr.mr_n62805312)
print v(xbgr.mr_n62806496)
print v(xbgr.mr_n62807088)
print v(xbgr.mr_n62807680)
print v(xbgr.mr_n62808048)
print v(xbgr.mr_n62808160)
print v(xbgr.mr_n62808272)
print v(xbgr.mr_n62808384)
print v(xbgr.mr_n62808816)
print v(xbgr.mr_n62809088)
print v(xbgr.mr_n62809776)
print v(xbgr.mr_n62811232)
print v(xbgr.mr_n62811824)
print v(xbgr.mr_n62812416)
print v(xbgr.mr_n62813008)
print v(xbgr.mr_n62813600)
print v(xbgr.mr_n62814192)
print v(xbgr.mr_n62814784)
print v(xbgr.mr_n62815376)
print v(xbgr.mr_n62815968)
print v(xbgr.mr_n62816560)
print v(xbgr.mr_n62817152)
print v(xbgr.mr_n62817744)
print v(xbgr.mr_n62818336)
print v(xbgr.mr_n62818928)
print v(xbgr.mr_n62819520)
print v(xbgr.mr_n62825168)
print v(xbgr.mr_n62841328)
print v(xbgr.mr_n62841664)
print v(xbgr.mr_n62842320)
print v(xbgr.mr_n62842832)
print v(xbgr.mr_n62842944)
print v(xbgr.mr_n62843056)
print v(xbgr.mr_n62843168)
print v(xbgr.mr_n62845008)
print v(xbgr.mr_n62845120)
print v(xbgr.mr_n62845232)
print v(xbgr.mr_n62847072)
print v(xbgr.mr_n62847184)
print v(xbgr.mr_n62847296)
print v(xbgr.mr_n62849136)
print v(xbgr.mr_n62849248)
print v(xbgr.mr_n62849360)
print v(xbgr.mr_n62851200)
print v(xbgr.mr_n62851312)
print v(xbgr.mr_n62851424)
print v(xbgr.mr_n62853264)
print v(xbgr.mr_n62853376)
print v(xbgr.mr_n62853488)
print v(xbgr.mr_n62855328)
print v(xbgr.mr_n62855440)
print v(xbgr.mr_n62855552)
print v(xbgr.mr_n62857392)
print v(xbgr.mr_n62857504)
print v(xbgr.mr_n62857616)
print v(xbgr.mr_n62859456)
print v(xbgr.mr_n62859568)
print v(xbgr.mr_n62859680)
print v(xbgr.mr_n62861520)
print v(xbgr.mr_n62861632)
print v(xbgr.mr_n62861744)
print v(xbgr.mr_n62863584)
print v(xbgr.mr_n62863696)
print v(xbgr.mr_n62863808)
print v(xbgr.mr_n62863920)
print v(xbgr.mr_n62865904)
print v(xbgr.mr_n62866016)
print v(xbgr.mr_n62866128)
print v(xbgr.mr_n62866240)
print v(xbgr.mr_n62868224)
print v(xbgr.mr_n62868336)
print v(xbgr.mr_n62868448)
print v(xbgr.mr_n62868560)
print v(xbgr.mr_n62870544)
print v(xbgr.mr_n62870656)
print v(xbgr.mr_n62870768)
print v(xbgr.mr_n62870880)
print v(xbgr.mr_n62872864)
print v(xbgr.mr_n62872976)
print v(xbgr.mr_n62873088)
print v(xbgr.mr_n62873200)
print v(xbgr.mr_n62875184)
print v(xbgr.mr_n62875296)
print v(xbgr.mr_n62875408)
print v(xbgr.mr_n62875520)
print v(xbgr.mr_n62877504)
print v(xbgr.mr_n62877616)
print v(xbgr.mr_n62877728)
print v(xbgr.mr_n62877840)
print v(xbgr.mr_n62879104)
print v(xbgr.mr_n62879648)
print v(xbgr.mr_n62880192)
print v(xbgr.mr_n62880736)
print v(xbgr.mr_n62881280)
print v(xbgr.mr_n62881824)
print v(xbgr.mr_n62882368)
print v(xbgr.mr_n62882912)
print v(xbgr.mr_n62883456)
print v(xbgr.mr_n62884000)
print v(xbgr.mr_n62884544)
print v(xbgr.mr_n62885088)
print v(xbgr.mr_n62885632)
print v(xbgr.mr_n62886176)
print v(xbgr.mr_n62886720)
print v(xbgr.mr_n62887264)
print v(xbgr.mr_n62887808)
print v(xbgr.mr_n62888352)
print v(xbgr.mr_n62888896)
print v(xbgr.mr_n62889440)
print v(xbgr.mr_n62889984)
print v(xbgr.mr_n62890528)
print v(xbgr.mr_n62891072)
print v(xbgr.mr_n62891616)
print v(xbgr.mr_n62892160)
print v(xbgr.mr_n62892704)
print v(xbgr.mr_n62893248)
print v(xbgr.mr_n62893664)
print v(xbgr.mr_n62893776)
print v(xbgr.mr_n62893968)
print v(xbgr.mr_n62894240)
print v(xbgr.mr_n62894512)
print v(xbgr.mr_n62894784)
print v(xbgr.mr_n62895056)
print v(xbgr.mr_n62895328)
print v(xbgr.mr_n62895600)
print v(xbgr.mr_n62895872)
print v(xbgr.mr_n62896272)
print v(xbgr.mr_n62896736)
print v(xbgr.mr_n62897200)
print v(xbgr.mr_n62897664)
print v(xbgr.mr_n62898128)
print v(xbgr.mr_n62898592)
print v(xbgr.mr_n62899056)
print v(xbgr.mr_n62899520)
print v(xbgr.mr_n62899984)
print v(xbgr.mr_n62900448)
print v(xbgr.mr_n62900912)
print v(xbgr.mr_n62901376)
print v(xbgr.mr_n62901840)
print v(xbgr.mr_n62902336)
print v(xbgr.mr_n62902928)
print v(xbgr.mr_n62903520)
print v(xbgr.mr_n62904112)
print v(xbgr.mr_n62904704)
print v(xbgr.mr_n62905296)
print v(xbgr.mr_n62905888)
print v(xbgr.mr_n62906480)
print v(xbgr.mr_n62907536)
print v(xbgr.mr_n62907744)
print v(xbgr.mr_n62910864)
print v(xbgr.mr_n62911312)
print v(xbgr.mr_n62913824)
print v(xbgr.mr_n62914784)
print v(xbgr.mr_n62915232)
print v(xbgr.mr_n62918480)
print v(xbgr.mr_n62919360)
print v(xbgr.mr_n62921888)
print v(xbgr.mr_n62922128)
print v(xbgr.mr_n62924704)
print v(xbgr.mr_n62925664)
print v(xbgr.mr_n62927200)
print v(xbgr.mr_n62927776)
print v(xbgr.mr_n62931952)
print v(xbgr.mr_n62932128)
print v(xbgr.mr_n62934368)
print v(xbgr.mr_n62936272)
print v(xbgr.mr_n62940496)
print v(xbgr.mr_n62941664)
print v(xbgr.mr_n62942048)
print v(xbgr.mr_n62944320)
print v(xbgr.mr_n62944976)
print v(xbgr.mr_n62945824)
print v(xbgr.mr_n62951968)
print v(xbgr.mr_n62954016)
print v(xbgr.mr_n62957008)
print v(xbgr.mr_n62969088)
print v(xbgr.mr_n62975776)
print v(xbgr.mr_n62976608)
print v(xbgr.mr_n62977440)
print v(xbgr.mr_n62978880)
print v(xbgr.mr_n62980400)
print v(xbgr.mr_n62981776)
print v(xbgr.mr_n62983040)
print v(xbgr.mr_n62983216)
print v(xbgr.mr_n62984128)
print v(xbgr.mr_n62984480)
print v(xbgr.mr_n62985184)
print v(xbgr.mr_n62985600)
print v(xbgr.mr_n62987824)
print v(xbgr.mr_n62988928)
print v(xbgr.mr_n62989312)
print v(xbgr.mr_n62989616)
print v(xbgr.mr_n62990224)
print v(xbgr.mr_n62990992)
print v(xbgr.mr_n62991424)
print v(xbgr.mr_n62991600)
print v(xbgr.mr_n62992576)
print v(xbgr.mr_n62993664)
print v(xbgr.mr_n62994224)
print v(xbgr.mr_n62996864)
print v(xbgr.mr_n62997712)
print v(xbgr.mr_n62998128)
print v(xbgr.mr_n63000208)
print v(xbgr.mr_n63001216)
print v(xbgr.mr_n63008224)
print v(xbgr.mr_n63009232)
print v(xbgr.mr_n63009344)
print v(xbgr.mr_n63011776)
print v(xbgr.mr_n63016288)
print v(xbgr.mr_n63017072)
print v(xbgr.mr_n63018032)
print v(xbgr.mr_n63018800)
print v(xbgr.mr_n63019152)
print v(xbgr.mr_n63020688)
print v(xbgr.mr_n63021024)
print v(xbgr.mr_n63021360)
print v(xbgr.mr_n63021696)
print v(xbgr.mr_n63022352)
print v(xbgr.mr_n63022736)
print v(xbgr.mr_n63023248)
print v(xbgr.mr_n63023360)
print v(xbgr.mr_n63023472)
print v(xbgr.mr_n63023584)
print v(xbgr.mr_n63023696)
print v(xbgr.mr_n63025680)
print v(xbgr.mr_n63025792)
print v(xbgr.mr_n63025904)
print v(xbgr.mr_n63026016)
print v(xbgr.mr_n63028000)
print v(xbgr.mr_n63028112)
print v(xbgr.mr_n63028224)
print v(xbgr.mr_n63028336)
print v(xbgr.mr_n63030320)
print v(xbgr.mr_n63030432)
print v(xbgr.mr_n63030544)
print v(xbgr.mr_n63030656)
print v(xbgr.mr_n63032640)
print v(xbgr.mr_n63032752)
print v(xbgr.mr_n63032864)
print v(xbgr.mr_n63032976)
print v(xbgr.mr_n63034960)
print v(xbgr.mr_n63035072)
print v(xbgr.mr_n63035184)
print v(xbgr.mr_n63035296)
print v(xbgr.mr_n63037280)
print v(xbgr.mr_n63037392)
print v(xbgr.mr_n63037504)
print v(xbgr.mr_n63037616)
print v(xbgr.mr_n63039600)
print v(xbgr.mr_n63039712)
print v(xbgr.mr_n63039824)
print v(xbgr.mr_n63039936)
print v(xbgr.mr_n63041920)
print v(xbgr.mr_n63042032)
print v(xbgr.mr_n63042144)
print v(xbgr.mr_n63042256)
print v(xbgr.mr_n63044240)
print v(xbgr.mr_n63044352)
print v(xbgr.mr_n63044464)
print v(xbgr.mr_n63044576)
print v(xbgr.mr_n63046560)
print v(xbgr.mr_n63046672)
print v(xbgr.mr_n63046784)
print v(xbgr.mr_n63046896)
print v(xbgr.mr_n63048880)
print v(xbgr.mr_n63048992)
print v(xbgr.mr_n63049104)
print v(xbgr.mr_n63049216)
print v(xbgr.mr_n63051200)
print v(xbgr.mr_n63051312)
print v(xbgr.mr_n63051424)
print v(xbgr.mr_n63051536)
print v(xbgr.mr_n63053520)
print v(xbgr.mr_n63053632)
print v(xbgr.mr_n63054128)
print v(xbgr.mr_n63054240)
print v(xbgr.mr_n63057888)
print v(xbgr.mr_n63058000)
print v(xbgr.mr_n63058240)
print v(xbgr.mr_n63058560)
print v(xbgr.mr_n63058672)
print v(xbgr.mr_n63062320)
print v(xbgr.mr_n63062432)
print v(xbgr.mr_n63062992)
print v(xbgr.mr_n63063104)
print v(xbgr.mr_n63066752)
print v(xbgr.mr_n63066864)
print v(xbgr.mr_n63067424)
print v(xbgr.mr_n63067536)
print v(xbgr.mr_n63069840)
print v(xbgr.mr_n63070208)
print v(xbgr.mr_n63071712)
print v(xbgr.mr_n63072496)
print v(xbgr.mr_n63072672)
print v(xbgr.mr_n63074240)
print v(xbgr.mr_n63075056)
print v(xbgr.mr_n63075232)
print v(xbgr.mr_n63075744)
print v(xbgr.mr_n63076800)
print v(xbgr.mr_n63077504)
print v(xbgr.mr_n63077616)
print v(xbgr.mr_n63077792)
print v(xbgr.mr_n63078608)
print v(xbgr.mr_n63078720)
print v(xbgr.mr_n63078832)
print v(xbgr.mr_n63080656)
print v(xbgr.mr_n63081152)
print v(xbgr.mr_n63081264)
print v(xbgr.mr_n63082768)
print v(xbgr.mr_n63084704)
print v(xbgr.mr_n63084880)
print v(xbgr.mr_n63086448)
print v(xbgr.mr_n63087296)
print v(xbgr.mr_n63087472)
print v(xbgr.mr_n63089040)
print v(xbgr.mr_n63089856)
print v(xbgr.mr_n63090032)
print v(xbgr.mr_n63091600)
print v(xbgr.mr_n63092416)
print v(xbgr.mr_n63092592)
print v(xbgr.mr_n63094160)
print v(xbgr.mr_n63094976)
print v(xbgr.mr_n63095152)
print v(xbgr.mr_n63096720)
print v(xbgr.mr_n63097536)
print v(xbgr.mr_n63097712)
print v(xbgr.mr_n63099280)
print v(xbgr.mr_n63100096)
print v(xbgr.mr_n63100272)
print v(xbgr.mr_n63101840)
print v(xbgr.mr_n63102656)
print v(xbgr.mr_n63102832)
print v(xbgr.mr_n63104400)
print v(xbgr.mr_n63105216)
print v(xbgr.mr_n63105392)
print v(xbgr.mr_n63106960)
print v(xbgr.mr_n63107776)
print v(xbgr.mr_n63107952)
print v(xbgr.mr_n63109520)
print v(xbgr.mr_n63110336)
print v(xbgr.mr_n63110512)
print v(xbgr.mr_n63112080)
print v(xbgr.mr_n63112896)
print v(xbgr.mr_n63113072)
print v(xbgr.mr_n63113504)
print v(xbgr.mr_n63114640)
print v(xbgr.mr_n63115456)
print v(xbgr.mr_n63115632)
print v(xbgr.mr_n63117200)
print v(xbgr.mr_n63118016)
print v(xbgr.mr_n63118192)
print v(xbgr.mr_n63119760)
print v(xbgr.mr_n63120576)
print v(xbgr.mr_n63120752)
print v(xbgr.mr_n63122320)
print v(xbgr.mr_n63122704)
print v(xbgr.mr_n63123136)
print v(xbgr.mr_n63123312)
print v(xbgr.mr_n63124880)
print v(xbgr.mr_n63125696)
print v(xbgr.mr_n63125872)
print v(xbgr.mr_n63127440)
print v(xbgr.mr_n63128256)
print v(xbgr.mr_n63128432)
print v(xbgr.mr_n63130000)
print v(xbgr.mr_n63130816)
print v(xbgr.mr_n63130992)
print v(xbgr.mr_n63132560)
print v(xbgr.mr_n63133232)
print v(xbgr.mr_n63133376)
print v(xbgr.mr_n63133552)
print v(xbgr.mr_n63135120)
print v(xbgr.mr_n63135936)
print v(xbgr.mr_n63136112)
print v(xbgr.mr_n63137680)
print v(xbgr.mr_n63138496)
print v(xbgr.mr_n63138672)
print v(xbgr.mr_n63140240)
print v(xbgr.mr_n63163760)
print v(xbgr.mr_n63173152)
print v(xbgr.mr_n63180384)
print v(xbgr.mr_n63183264)
print v(xbgr.mr_n63191616)
print v(xbgr.mr_n63192096)
print v(xbgr.mr_n63198512)
print v(xbgr.mr_n63205280)
print v(xbgr.mr_n63207392)
print v(xbgr.mr_n63209520)
print v(xbgr.mr_n63308000)
print v(xbgr.mr_n63308112)
print v(xbgr.mr_n63308944)
print v(xbgr.mr_n63309056)
print v(xbgr.mr_n63309888)
print v(xbgr.mr_n63310000)
print v(xbgr.mr_n63310832)
print v(xbgr.mr_n63310944)
print v(xbgr.mr_n63311776)
print v(xbgr.mr_n63311888)
print v(xbgr.mr_n63312720)
print v(xbgr.mr_n63312832)
print v(xbgr.mr_n63313664)
print v(xbgr.mr_n63313776)
print v(xbgr.mr_n63314608)
print v(xbgr.mr_n63314720)
print v(xbgr.mr_n63315552)
print v(xbgr.mr_n63315664)
print v(xbgr.mr_n63316496)
print v(xbgr.mr_n63316608)
print v(xbgr.mr_n63317440)
print v(xbgr.mr_n63317552)
print v(xbgr.mr_n63318384)
print v(xbgr.mr_n63318496)
print v(xbgr.mr_n63319328)
print v(xbgr.mr_n63319440)
print v(xbgr.mr_n63320272)
print v(xbgr.mr_n63320384)
print v(xbgr.mr_n63321216)
print v(xbgr.mr_n63321328)
print v(xbgr.mr_n63322160)
print v(xbgr.mr_n63322272)
print v(xbgr.mr_n63323104)
print v(xbgr.mr_n63323216)
print v(xbgr.mr_n63323488)
print v(xbgr.mr_n63323872)
print v(xbgr.mr_n63325232)
print v(xbgr.mr_n63351136)
print v(xbgr.mr_n63357904)
print v(xbgr.mr_n63362864)
print v(xbgr.mr_n63363712)
print v(xbgr.mr_n63368960)
print v(xbgr.mr_n63369296)
print v(xbgr.mr_n63371472)
print v(xbgr.mr_n63371808)
print v(xbgr.mr_n63373984)
print v(xbgr.mr_n63374320)
print v(xbgr.mr_n63376496)
print v(xbgr.mr_n63376832)
print v(xbgr.mr_n63379008)
print v(xbgr.mr_n63379344)
print v(xbgr.mr_n63381520)
print v(xbgr.mr_n63381856)
print v(xbgr.mr_n63384032)
print v(xbgr.mr_n63384368)
print v(xbgr.mr_n63386544)
print v(xbgr.mr_n63386880)
print v(xbgr.mr_n63388736)
print v(xbgr.mr_n63389360)
print v(xbgr.mr_n63390048)
print v(xbgr.mr_n63390800)
print v(xbgr.mr_n63391744)
print v(xbgr.mr_n63392688)
print v(xbgr.mr_n63393632)
print v(xbgr.mr_n63394576)
print v(xbgr.mr_n63395520)
print v(xbgr.mr_n63396464)
print v(xbgr.mr_n63397408)
print v(xbgr.mr_n63398352)
print v(xbgr.mr_n63399296)
print v(xbgr.mr_n63400240)
print v(xbgr.mr_n63401184)
print v(xbgr.mr_n63402128)
print v(xbgr.mr_n63403072)
print v(xbgr.mr_n63404016)
print v(xbgr.mr_n63404960)
print v(xbgr.mr_n63405904)
print v(xbgr.mr_n63406848)
print v(xbgr.mr_n63407792)
print v(xbgr.mr_n63408736)
print v(xbgr.mr_n63409680)
print v(xbgr.mr_n63410624)
print v(xbgr.mr_n63411568)
print v(xbgr.mr_n63412512)
print v(xbgr.mr_n63413456)
print v(xbgr.mr_n63414400)
print v(xbgr.mr_n63415344)
print v(xbgr.mr_n63416288)
print v(xbgr.mr_n63417232)
print v(xbgr.mr_n63418176)
print v(xbgr.mr_n63419120)
print v(xbgr.mr_n63420064)
print v(xbgr.mr_n63421008)
print v(xbgr.mr_n63422624)
print v(xbgr.mr_n63422800)
print v(xbgr.mr_n63422912)
print v(xbgr.mr_n63423584)
print v(xbgr.mr_n63423696)
print v(xbgr.mr_n63424784)
print v(xbgr.mr_n63424896)
print v(xbgr.mr_n63426048)
print v(xbgr.mr_n63426160)
print v(xbgr.mr_n63427312)
print v(xbgr.mr_n63427424)
print v(xbgr.mr_n63428576)
print v(xbgr.mr_n63428688)
print v(xbgr.mr_n63429776)
print v(xbgr.mr_n63429888)
print v(xbgr.mr_n63431104)
print v(xbgr.mr_n63431216)
print v(xbgr.mr_n63432368)
print v(xbgr.mr_n63432480)
print v(xbgr.mr_n63433632)
print v(xbgr.mr_n63433744)
print v(xbgr.mr_n63434896)
print v(xbgr.mr_n63435008)
print v(xbgr.mr_n63436160)
print v(xbgr.mr_n63436272)
print v(xbgr.mr_n63437360)
print v(xbgr.mr_n63437472)
print v(xbgr.mr_n63438688)
print v(xbgr.mr_n63438800)
print v(xbgr.mr_n63439952)
print v(xbgr.mr_n63440064)
print v(xbgr.mr_n63441216)
print v(xbgr.mr_n63441328)
print v(xbgr.mr_n63442480)
print v(xbgr.mr_n63442592)
print v(xbgr.mr_n63443488)
print v(xbgr.mr_n63447712)
print v(xbgr.mr_n63447824)
print v(xbgr.mr_n63448912)
print v(xbgr.mr_n63449024)
print v(xbgr.mr_n63450240)
print v(xbgr.mr_n63450352)
print v(xbgr.mr_n63451504)
print v(xbgr.mr_n63451616)
print v(xbgr.mr_n63452768)
print v(xbgr.mr_n63452880)
print v(xbgr.mr_n63454032)
print v(xbgr.mr_n63454144)
print v(xbgr.mr_n63455296)
print v(xbgr.mr_n63455408)
print v(xbgr.mr_n63456496)
print v(xbgr.mr_n63456608)
print v(xbgr.mr_n63457824)
print v(xbgr.mr_n63457936)
print v(xbgr.mr_n63459088)
print v(xbgr.mr_n63459200)
print v(xbgr.mr_n63460352)
print v(xbgr.mr_n63460464)
print v(xbgr.mr_n63461616)
print v(xbgr.mr_n63461728)
print v(xbgr.mr_n63462880)
print v(xbgr.mr_n63462992)
print v(xbgr.mr_n63464080)
print v(xbgr.mr_n63464192)
print v(xbgr.mr_n63465408)
print v(xbgr.mr_n63465520)
print v(xbgr.mr_n63466672)
print v(xbgr.mr_n63466784)
print v(xbgr.mr_n63467936)
print v(xbgr.mr_n63468048)
print v(xbgr.mr_n63469760)
print v(xbgr.mr_n63471696)
print v(xbgr.mr_n63475776)
print v(xbgr.mr_n63487824)
print v(xbgr.mr_n63488512)
print v(xbgr.mr_n63488624)
print v(xbgr.mr_n63488816)
print v(xbgr.mr_n63489792)
print v(xbgr.mr_n63493856)
print v(xbgr.mr_n63495248)
print v(xbgr.mr_n63495520)
print v(xbgr.mr_n63495712)
print v(xbgr.mr_n63497072)
print v(xbgr.mr_n63498688)
print v(xbgr.mr_n63501568)
print v(xbgr.mr_n63503104)
print v(xbgr.mr_n63503296)
print v(xbgr.mr_n63504400)
print v(xbgr.mr_n63506272)
print v(xbgr.mr_n63510288)
print v(xbgr.mr_n63510560)
print v(xbgr.mr_n63510752)
print v(xbgr.mr_n63513728)
print v(xbgr.mr_n63517808)
print v(xbgr.mr_n63518080)
print v(xbgr.mr_n63518272)
print v(xbgr.mr_n63522800)
print v(xbgr.mr_n63525920)
print v(xbgr.mr_n63526032)
print v(xbgr.mr_n63526224)
print v(xbgr.mr_n63527200)
print v(xbgr.mr_n63531232)
print v(xbgr.mr_n63532208)
print v(xbgr.mr_n63536336)
print v(xbgr.mr_n63540112)
print v(xbgr.mr_n63544224)
print v(xbgr.mr_n63544336)
print v(xbgr.mr_n63545168)
print v(xbgr.mr_n63545280)
print v(xbgr.mr_n63546112)
print v(xbgr.mr_n63546224)
print v(xbgr.mr_n63547056)
print v(xbgr.mr_n63547168)
print v(xbgr.mr_n63548256)
print v(xbgr.mr_n63548368)
print v(xbgr.mr_n63549520)
print v(xbgr.mr_n63549632)
print v(xbgr.mr_n63550784)
print v(xbgr.mr_n63550896)
print v(xbgr.mr_n63552048)
print v(xbgr.mr_n63552160)
print v(xbgr.mr_n63553312)
print v(xbgr.mr_n63553424)
print v(xbgr.mr_n63554576)
print v(xbgr.mr_n63554688)
print v(xbgr.mr_n63555840)
print v(xbgr.mr_n63555952)
print v(xbgr.mr_n63557104)
print v(xbgr.mr_n63557216)
print v(xbgr.mr_n63558368)
print v(xbgr.mr_n63558480)
print v(xbgr.mr_n63559632)
print v(xbgr.mr_n63559744)
print v(xbgr.mr_n63560896)
print v(xbgr.mr_n63561008)
print v(xbgr.mr_n63562160)
print v(xbgr.mr_n63562272)
print v(xbgr.mr_n63565776)
print v(xbgr.mr_n63569680)
print v(xbgr.mr_n63570368)
print v(xbgr.mr_n63571056)
print v(xbgr.mr_n63571776)
print v(xbgr.mr_n63573392)
print v(xbgr.mr_n63574672)
print v(xbgr.mr_n63574784)
print v(xbgr.mr_n63575728)
print v(xbgr.mr_n63576880)
print v(xbgr.mr_n63576992)
print v(xbgr.mr_n63577616)
print v(xbgr.mr_n63579152)
print v(xbgr.mr_n63579696)
print v(xbgr.mr_n63581040)
print v(xbgr.mr_n63581584)
print v(xbgr.mr_n63582928)
print v(xbgr.mr_n63583472)
print v(xbgr.mr_n63584816)
print v(xbgr.mr_n63585360)
print v(xbgr.mr_n63586704)
print v(xbgr.mr_n63587248)
print v(xbgr.mr_n63588528)
print v(xbgr.mr_n63589072)
print v(xbgr.mr_n63590480)
print v(xbgr.mr_n63591024)
print v(xbgr.mr_n63592304)
print v(xbgr.mr_n63592848)
print v(xbgr.mr_n63594256)
print v(xbgr.mr_n63594800)
print v(xbgr.mr_n63596144)
print v(xbgr.mr_n63596688)
print v(xbgr.mr_n63598032)
print v(xbgr.mr_n63598576)
print v(xbgr.mr_n63599920)
print v(xbgr.mr_n63600784)
print v(xbgr.mr_n63601744)
print v(xbgr.mr_n63601856)
print v(xbgr.mr_n63602800)
print v(xbgr.mr_n63603952)
print v(xbgr.mr_n63604064)
print v(xbgr.mr_n63605008)
print v(xbgr.mr_n63606160)
print v(xbgr.mr_n63606272)
print v(xbgr.mr_n63624336)
print v(xbgr.mr_n63625024)
print v(xbgr.mr_n63625712)
print v(xbgr.mr_n63627392)
print v(xbgr.mr_n63628336)
print v(xbgr.mr_n63628528)
print v(xbgr.mr_n63628720)
print v(xbgr.mr_n63628912)
print v(xbgr.mr_n63629104)
print v(xbgr.mr_n63630976)
print v(xbgr.mr_n63632864)
print v(xbgr.mr_n63634736)
print v(xbgr.mr_n63639632)
print v(xbgr.mr_n63640576)
print v(xbgr.mr_n63641520)
print v(xbgr.mr_n63647264)
print v(xbgr.mr_n63648624)
print v(xbgr.mr_n63654096)
print v(xbgr.mr_n63655040)
print v(xbgr.mr_n63655984)
print v(xbgr.mr_n63656928)
print v(xbgr.mr_n63659088)
print v(xbgr.mr_n63663440)
print v(xbgr.mr_n63663632)
print v(xbgr.mr_n63664464)
print v(xbgr.mr_n63665792)
print v(xbgr.mr_n63665984)
print v(xbgr.mr_n63666672)
print v(xbgr.mr_n63668000)
print v(xbgr.mr_n63668192)
print v(xbgr.mr_n63668880)
print v(xbgr.mr_n63668992)
print v(xbgr.mr_n63669104)
print v(xbgr.mr_n63669216)
print v(xbgr.mr_n63670608)
print v(xbgr.mr_n63670880)
print v(xbgr.mr_n63671072)
print v(xbgr.mr_n63671424)
print v(xbgr.mr_n63671536)
print v(xbgr.mr_n63675200)
print v(xbgr.mr_n63675472)
print v(xbgr.mr_n63675664)
print v(xbgr.mr_n63676016)
print v(xbgr.mr_n63676128)
print v(xbgr.mr_n63678592)
print v(xbgr.mr_n63680128)
print v(xbgr.mr_n63680320)
print v(xbgr.mr_n63680672)
print v(xbgr.mr_n63680784)
print v(xbgr.mr_n63684384)
print v(xbgr.mr_n63684656)
print v(xbgr.mr_n63684848)
print v(xbgr.mr_n63685200)
print v(xbgr.mr_n63685312)
print v(xbgr.mr_n63688976)
print v(xbgr.mr_n63689248)
print v(xbgr.mr_n63689440)
print v(xbgr.mr_n63689792)
print v(xbgr.mr_n63689904)
print v(xbgr.mr_n63693568)
print v(xbgr.mr_n63693840)
print v(xbgr.mr_n63694032)
print v(xbgr.mr_n63694384)
print v(xbgr.mr_n63694496)
print v(xbgr.mr_n63698160)
print v(xbgr.mr_n63698432)
print v(xbgr.mr_n63698624)
print v(xbgr.mr_n63698976)
print v(xbgr.mr_n63699088)
print v(xbgr.mr_n63702752)
print v(xbgr.mr_n63703024)
print v(xbgr.mr_n63703216)
print v(xbgr.mr_n63703568)
print v(xbgr.mr_n63703680)
print v(xbgr.mr_n63707344)
print v(xbgr.mr_n63707616)
print v(xbgr.mr_n63707808)
print v(xbgr.mr_n63708160)
print v(xbgr.mr_n63708272)
print v(xbgr.mr_n63711936)
print v(xbgr.mr_n63712208)
print v(xbgr.mr_n63712400)
print v(xbgr.mr_n63712752)
print v(xbgr.mr_n63712864)
print v(xbgr.mr_n63716528)
print v(xbgr.mr_n63716800)
print v(xbgr.mr_n63716992)
print v(xbgr.mr_n63717344)
print v(xbgr.mr_n63717456)
print v(xbgr.mr_n63721120)
print v(xbgr.mr_n63721392)
print v(xbgr.mr_n63721584)
print v(xbgr.mr_n63721936)
print v(xbgr.mr_n63722048)
print v(xbgr.mr_n63724512)
print v(xbgr.mr_n63726048)
print v(xbgr.mr_n63726240)
print v(xbgr.mr_n63726592)
print v(xbgr.mr_n63726704)
print v(xbgr.mr_n63730304)
print v(xbgr.mr_n63730576)
print v(xbgr.mr_n63730768)
print v(xbgr.mr_n63731120)
print v(xbgr.mr_n63731232)
print v(xbgr.mr_n63734896)
print v(xbgr.mr_n63735168)
print v(xbgr.mr_n63735360)
print v(xbgr.mr_n63735712)
print v(xbgr.mr_n63735824)
print v(xbgr.mr_n63739200)
print v(xbgr.mr_n63739776)
print v(xbgr.mr_n63739888)
print v(xbgr.mr_n63740720)
print v(xbgr.mr_n63740832)
print v(xbgr.mr_n63741664)
print v(xbgr.mr_n63741776)
print v(xbgr.mr_n63742608)
print v(xbgr.mr_n63742720)
print v(xbgr.mr_n63743552)
print v(xbgr.mr_n63743664)
print v(xbgr.mr_n63744496)
print v(xbgr.mr_n63744608)
print v(xbgr.mr_n63745440)
print v(xbgr.mr_n63745552)
print v(xbgr.mr_n63746384)
print v(xbgr.mr_n63746496)
print v(xbgr.mr_n63747328)
print v(xbgr.mr_n63747440)
print v(xbgr.mr_n63748272)
print v(xbgr.mr_n63748384)
print v(xbgr.mr_n63749280)
print v(xbgr.mr_n63749392)
print v(xbgr.mr_n63750544)
print v(xbgr.mr_n63750656)
print v(xbgr.mr_n63751744)
print v(xbgr.mr_n63751856)
print v(xbgr.mr_n63753072)
print v(xbgr.mr_n63753184)
print v(xbgr.mr_n63754480)
print v(xbgr.mr_n63755696)
print v(xbgr.mr_n63755808)
print v(xbgr.mr_n63756640)
print v(xbgr.mr_n63756752)
print v(xbgr.mr_n63759472)
print v(xbgr.mr_n63759584)
print v(xbgr.mr_n63760736)
print v(xbgr.mr_n63760848)
print v(xbgr.mr_n63762000)
print v(xbgr.mr_n63762112)
print v(xbgr.mr_n63763264)
print v(xbgr.mr_n63763376)
print v(xbgr.mr_n63764528)
print v(xbgr.mr_n63764640)
print v(xbgr.mr_n63765792)
print v(xbgr.mr_n63765904)
print v(xbgr.mr_n63767056)
print v(xbgr.mr_n63767168)
print v(xbgr.mr_n63768320)
print v(xbgr.mr_n63768432)
print v(xbgr.mr_n63769584)
print v(xbgr.mr_n63769696)
print v(xbgr.mr_n63770848)
print v(xbgr.mr_n63770960)
print v(xbgr.mr_n63772112)
print v(xbgr.mr_n63772224)
print v(xbgr.mr_n63773376)
print v(xbgr.mr_n63773488)
print v(xbgr.mr_n63774640)
print v(xbgr.mr_n63774752)
print v(xbgr.mr_n63775904)
print v(xbgr.mr_n63776016)
print v(xbgr.mr_n63777168)
print v(xbgr.mr_n63777280)
print v(xbgr.mr_n63784784)
print v(xbgr.mr_n63785120)
print v(xbgr.mr_n63796832)
print v(xbgr.mr_n63799984)
print v(xbgr.mr_n63800672)
print v(xbgr.mr_n63801360)
print v(xbgr.mr_n63802112)
print v(xbgr.mr_n63803056)
print v(xbgr.mr_n63804000)
print v(xbgr.mr_n63804928)
print v(xbgr.mr_n63815104)
print v(xbgr.mr_n63815408)
print v(xbgr.mr_n63816528)
print v(xbgr.mr_n63817600)
print v(xbgr.mr_n63818416)
print v(xbgr.mr_n63818528)
print v(xbgr.mr_n63818800)
print v(xbgr.mr_n63819568)
print v(xbgr.mr_n63819760)
print v(xbgr.mr_n63819952)
print v(xbgr.mr_n63821936)
print v(xbgr.mr_n63822208)
print v(xbgr.mr_n63822400)
print v(xbgr.mr_n63822752)
print v(xbgr.mr_n63822864)
print v(xbgr.mr_n63823552)
print v(xbgr.mr_n63823856)
print v(xbgr.mr_n63825984)
print v(xbgr.mr_n63829408)
print v(xbgr.mr_n63829520)
print v(xbgr.mr_n63829632)
print v(xbgr.mr_n63831024)
print v(xbgr.mr_n63831296)
print v(xbgr.mr_n63831488)
print v(xbgr.mr_n63831840)
print v(xbgr.mr_n63831952)
print v(xbgr.mr_n63833520)
print v(xbgr.mr_n63833632)
print v(xbgr.mr_n63836896)
print v(xbgr.mr_n63838288)
print v(xbgr.mr_n63838560)
print v(xbgr.mr_n63838752)
print v(xbgr.mr_n63839104)
print v(xbgr.mr_n63839216)
print v(xbgr.mr_n63842848)
print v(xbgr.mr_n63842960)
print v(xbgr.mr_n63843072)
print v(xbgr.mr_n63844464)
print v(xbgr.mr_n63844736)
print v(xbgr.mr_n63844928)
print v(xbgr.mr_n63845280)
print v(xbgr.mr_n63845392)
print v(xbgr.mr_n63849024)
print v(xbgr.mr_n63849136)
print v(xbgr.mr_n63849248)
print v(xbgr.mr_n63850640)
print v(xbgr.mr_n63850912)
print v(xbgr.mr_n63851104)
print v(xbgr.mr_n63851456)
print v(xbgr.mr_n63851568)
print v(xbgr.mr_n63853136)
print v(xbgr.mr_n63853248)
print v(xbgr.mr_n63856672)
print v(xbgr.mr_n63856864)
print v(xbgr.mr_n63857056)
print v(xbgr.mr_n63857248)
print v(xbgr.mr_n63859040)
print v(xbgr.mr_n63859152)
print v(xbgr.mr_n63862464)
print v(xbgr.mr_n63862576)
print v(xbgr.mr_n63862688)
print v(xbgr.mr_n63864080)
print v(xbgr.mr_n63864352)
print v(xbgr.mr_n63864544)
print v(xbgr.mr_n63864896)
print v(xbgr.mr_n63865008)
print v(xbgr.mr_n63868640)
print v(xbgr.mr_n63868752)
print v(xbgr.mr_n63868864)
print v(xbgr.mr_n63870256)
print v(xbgr.mr_n63870528)
print v(xbgr.mr_n63870720)
print v(xbgr.mr_n63871072)
print v(xbgr.mr_n63871184)
print v(xbgr.mr_n63872752)
print v(xbgr.mr_n63872864)
print v(xbgr.mr_n63875104)
print v(xbgr.mr_n63876128)
print v(xbgr.mr_n63876320)
print v(xbgr.mr_n63877856)
print v(xbgr.mr_n63878048)
print v(xbgr.mr_n63878400)
print v(xbgr.mr_n63878512)
print v(xbgr.mr_n63882080)
print v(xbgr.mr_n63882192)
print v(xbgr.mr_n63882304)
print v(xbgr.mr_n63883696)
print v(xbgr.mr_n63883968)
print v(xbgr.mr_n63884160)
print v(xbgr.mr_n63884512)
print v(xbgr.mr_n63884624)
print v(xbgr.mr_n63888256)
print v(xbgr.mr_n63888368)
print v(xbgr.mr_n63888480)
print v(xbgr.mr_n63890160)
print v(xbgr.mr_n63890656)
print v(xbgr.mr_n63892000)
print v(xbgr.mr_n63892112)
print v(xbgr.mr_n63895616)
print v(xbgr.mr_n63896304)
print v(xbgr.mr_n63896416)
print v(xbgr.mr_n63896528)
print v(xbgr.mr_n63896640)
print v(xbgr.mr_n63898032)
print v(xbgr.mr_n63898304)
print v(xbgr.mr_n63898496)
print v(xbgr.mr_n63898848)
print v(xbgr.mr_n63898960)
print v(xbgr.mr_n63908832)
print v(xbgr.mr_n63908944)
print v(xbgr.mr_n63910096)
print v(xbgr.mr_n63910208)
print v(xbgr.mr_n63911360)
print v(xbgr.mr_n63911472)
print v(xbgr.mr_n63912624)
print v(xbgr.mr_n63912736)
print v(xbgr.mr_n63913888)
print v(xbgr.mr_n63914000)
print v(xbgr.mr_n63915152)
print v(xbgr.mr_n63915264)
print v(xbgr.mr_n63916416)
print v(xbgr.mr_n63916528)
print v(xbgr.mr_n63917680)
print v(xbgr.mr_n63917792)
print v(xbgr.mr_n63918944)
print v(xbgr.mr_n63919056)
print v(xbgr.mr_n63920208)
print v(xbgr.mr_n63920320)
print v(xbgr.mr_n63921472)
print v(xbgr.mr_n63921584)
print v(xbgr.mr_n63922736)
print v(xbgr.mr_n63922848)
print v(xbgr.mr_n63924000)
print v(xbgr.mr_n63924112)
print v(xbgr.mr_n63925264)
print v(xbgr.mr_n63925376)
print v(xbgr.mr_n63926528)
print v(xbgr.mr_n63926640)
print v(xbgr.mr_n63931232)
print v(xbgr.mr_n63939264)
print v(xbgr.mr_n63939552)
print v(xbgr.mr_n63940128)
print v(xbgr.mr_n63943648)
print v(xbgr.mr_n63947296)
print v(xbgr.mr_n63947536)
print v(xbgr.mr_n63947888)
print v(xbgr.mr_n63948240)
print v(xbgr.mr_n63949824)
print v(xbgr.mr_n63950992)
print v(xbgr.mr_n63953344)
print v(xbgr.mr_n63953984)
print v(xbgr.mr_n63954336)
print v(xbgr.mr_n63955104)
print v(xbgr.mr_n63955568)
print v(xbgr.mr_n63956864)
print v(xbgr.mr_n63958208)
print v(xbgr.mr_n63959328)
print v(xbgr.mr_n63961616)
print v(xbgr.mr_n63964016)
print v(xbgr.mr_n63964128)
print v(xbgr.mr_n63965248)
print v(xbgr.mr_n63966928)
print v(xbgr.mr_n63968480)
print v(xbgr.mr_n63968624)
print v(xbgr.mr_n63970512)
print v(xbgr.mr_n63973296)
print v(xbgr.mr_n63973984)
print v(xbgr.mr_n63974672)
print v(xbgr.mr_n63979584)
print v(xbgr.mr_n63980816)
print v(xbgr.mr_n63981008)
print v(xbgr.mr_n63981696)
print v(xbgr.mr_n63981808)
print v(xbgr.mr_n63981920)
print v(xbgr.mr_n63982032)
print v(xbgr.mr_n63983424)
print v(xbgr.mr_n63983696)
print v(xbgr.mr_n63983888)
print v(xbgr.mr_n63984240)
print v(xbgr.mr_n63984352)
print v(xbgr.mr_n63988016)
print v(xbgr.mr_n63988208)
print v(xbgr.mr_n63988400)
print v(xbgr.mr_n63988832)
print v(xbgr.mr_n63988944)
print v(xbgr.mr_n63992608)
print v(xbgr.mr_n63992880)
print v(xbgr.mr_n63993072)
print v(xbgr.mr_n63993424)
print v(xbgr.mr_n63993536)
print v(xbgr.mr_n63997200)
print v(xbgr.mr_n63997472)
print v(xbgr.mr_n63997664)
print v(xbgr.mr_n63998016)
print v(xbgr.mr_n63998128)
print v(xbgr.mr_n64001792)
print v(xbgr.mr_n64002064)
print v(xbgr.mr_n64002256)
print v(xbgr.mr_n64002608)
print v(xbgr.mr_n64002720)
print v(xbgr.mr_n64006384)
print v(xbgr.mr_n64006656)
print v(xbgr.mr_n64006848)
print v(xbgr.mr_n64007200)
print v(xbgr.mr_n64007312)
print v(xbgr.mr_n64010976)
print v(xbgr.mr_n64011248)
print v(xbgr.mr_n64011440)
print v(xbgr.mr_n64011792)
print v(xbgr.mr_n64011904)
print v(xbgr.mr_n64014368)
print v(xbgr.mr_n64015904)
print v(xbgr.mr_n64016096)
print v(xbgr.mr_n64016448)
print v(xbgr.mr_n64016560)
print v(xbgr.mr_n64020160)
print v(xbgr.mr_n64020432)
print v(xbgr.mr_n64020624)
print v(xbgr.mr_n64020976)
print v(xbgr.mr_n64021088)
print v(xbgr.mr_n64025024)
print v(xbgr.mr_n64025216)
print v(xbgr.mr_n64027616)
print v(xbgr.mr_n64027728)
print v(xbgr.mr_n64027840)
print v(xbgr.mr_n64029312)
print v(xbgr.mr_n64029504)
print v(xbgr.mr_n64029696)
print v(xbgr.mr_n64030128)
print v(xbgr.mr_n64030240)
print v(xbgr.mr_n64035216)
print v(xbgr.mr_n64035488)
print v(xbgr.mr_n64035680)
print v(xbgr.mr_n64036032)
print v(xbgr.mr_n64036144)
print v(xbgr.mr_n64038608)
print v(xbgr.mr_n64040144)
print v(xbgr.mr_n64040336)
print v(xbgr.mr_n64040688)
print v(xbgr.mr_n64040800)
print v(xbgr.mr_n64044400)
print v(xbgr.mr_n64044672)
print v(xbgr.mr_n64044864)
print v(xbgr.mr_n64045216)
print v(xbgr.mr_n64045328)
print v(xbgr.mr_n64048992)
print v(xbgr.mr_n64049264)
print v(xbgr.mr_n64049456)
print v(xbgr.mr_n64049808)
print v(xbgr.mr_n64049920)
print v(xbgr.mr_n64053584)
print v(xbgr.mr_n64053856)
print v(xbgr.mr_n64054048)
print v(xbgr.mr_n64054400)
print v(xbgr.mr_n64054512)
print v(xbgr.mr_n64057792)
print v(xbgr.mr_n64058576)
print v(xbgr.mr_n64060224)
print v(xbgr.mr_n64060560)
print v(xbgr.mr_n64060736)
print v(xbgr.mr_n64062768)
print v(xbgr.mr_n64064432)
print v(xbgr.mr_n64064864)
print v(xbgr.mr_n64065296)
print v(xbgr.mr_n64066720)
print v(xbgr.mr_n64067296)
print v(xbgr.mr_n64067408)
print v(xbgr.mr_n64068352)
print v(xbgr.mr_n64069184)
print v(xbgr.mr_n64069296)
print v(xbgr.mr_n64070240)
print v(xbgr.mr_n64071392)
print v(xbgr.mr_n64071504)
print v(xbgr.mr_n64072448)
print v(xbgr.mr_n64073600)
print v(xbgr.mr_n64073712)
print v(xbgr.mr_n64074656)
print v(xbgr.mr_n64075808)
print v(xbgr.mr_n64075920)
print v(xbgr.mr_n64076864)
print v(xbgr.mr_n64078016)
print v(xbgr.mr_n64078128)
print v(xbgr.mr_n64079072)
print v(xbgr.mr_n64080224)
print v(xbgr.mr_n64080336)
print v(xbgr.mr_n64081280)
print v(xbgr.mr_n64082432)
print v(xbgr.mr_n64082544)
print v(xbgr.mr_n64083488)
print v(xbgr.mr_n64084640)
print v(xbgr.mr_n64084752)
print v(xbgr.mr_n64085696)
print v(xbgr.mr_n64086848)
print v(xbgr.mr_n64086960)
print v(xbgr.mr_n64087904)
print v(xbgr.mr_n64089056)
print v(xbgr.mr_n64089168)
print v(xbgr.mr_n64090112)
print v(xbgr.mr_n64091264)
print v(xbgr.mr_n64091376)
print v(xbgr.mr_n64092320)
print v(xbgr.mr_n64093472)
print v(xbgr.mr_n64093584)
print v(xbgr.mr_n64094528)
print v(xbgr.mr_n64095680)
print v(xbgr.mr_n64095792)
print v(xbgr.mr_n64096736)
print v(xbgr.mr_n64097888)
print v(xbgr.mr_n64098000)
print v(xbgr.mr_n64099152)
print v(xbgr.mr_n64099264)
print v(xbgr.mr_n64100416)
print v(xbgr.mr_n64100528)
print v(xbgr.mr_n64105520)
print v(xbgr.mr_n64105632)
print v(xbgr.mr_n64106784)
print v(xbgr.mr_n64106896)
print v(xbgr.mr_n64108048)
print v(xbgr.mr_n64108160)
print v(xbgr.mr_n64109312)
print v(xbgr.mr_n64109424)
print v(xbgr.mr_n64110576)
print v(xbgr.mr_n64110688)
print v(xbgr.mr_n64111840)
print v(xbgr.mr_n64111952)
print v(xbgr.mr_n64113104)
print v(xbgr.mr_n64113216)
print v(xbgr.mr_n64114368)
print v(xbgr.mr_n64114480)
print v(xbgr.mr_n64115632)
print v(xbgr.mr_n64115744)
print v(xbgr.mr_n64116896)
print v(xbgr.mr_n64117008)
print v(xbgr.mr_n64118160)
print v(xbgr.mr_n64118272)
print v(xbgr.mr_n64119424)
print v(xbgr.mr_n64119536)
print v(xbgr.mr_n64120688)
print v(xbgr.mr_n64120800)
print v(xbgr.mr_n64121952)
print v(xbgr.mr_n64122064)
print v(xbgr.mr_n64123216)
print v(xbgr.mr_n64123328)
print v(xbgr.mr_n64124480)
print v(xbgr.mr_n64124592)
print v(xbgr.mr_n64125744)
print v(xbgr.mr_n64125856)
print v(xbgr.mr_n64130896)
print v(xbgr.mr_n64148768)
print v(xbgr.mr_n64151504)
print v(xbgr.mr_n64154304)
print v(xbgr.mr_n64154416)
print v(xbgr.mr_n64155200)
print v(xbgr.mr_n64155392)
print v(xbgr.mr_n64155584)
print v(xbgr.mr_n64157568)
print v(xbgr.mr_n64158032)
print v(xbgr.mr_n64158496)
print v(xbgr.mr_n64159840)
print v(xbgr.mr_n64162240)
print v(xbgr.mr_n64163072)
print v(xbgr.mr_n64163184)
print v(xbgr.mr_n64163296)
print v(xbgr.mr_n64163408)
print v(xbgr.mr_n64164800)
print v(xbgr.mr_n64165072)
print v(xbgr.mr_n64165264)
print v(xbgr.mr_n64165616)
print v(xbgr.mr_n64165728)
print v(xbgr.mr_n64169408)
print v(xbgr.mr_n64170800)
print v(xbgr.mr_n64170992)
print v(xbgr.mr_n64171184)
print v(xbgr.mr_n64171616)
print v(xbgr.mr_n64171728)
print v(xbgr.mr_n64174320)
print v(xbgr.mr_n64175712)
print v(xbgr.mr_n64175904)
print v(xbgr.mr_n64176096)
print v(xbgr.mr_n64176528)
print v(xbgr.mr_n64176640)
print v(xbgr.mr_n64179232)
print v(xbgr.mr_n64180624)
print v(xbgr.mr_n64180896)
print v(xbgr.mr_n64181088)
print v(xbgr.mr_n64181440)
print v(xbgr.mr_n64181552)
print v(xbgr.mr_n64184144)
print v(xbgr.mr_n64185536)
print v(xbgr.mr_n64185808)
print v(xbgr.mr_n64186000)
print v(xbgr.mr_n64186352)
print v(xbgr.mr_n64186464)
print v(xbgr.mr_n64189056)
print v(xbgr.mr_n64190448)
print v(xbgr.mr_n64190720)
print v(xbgr.mr_n64190912)
print v(xbgr.mr_n64191264)
print v(xbgr.mr_n64191376)
print v(xbgr.mr_n64193968)
print v(xbgr.mr_n64195360)
print v(xbgr.mr_n64195632)
print v(xbgr.mr_n64195824)
print v(xbgr.mr_n64196176)
print v(xbgr.mr_n64196288)
print v(xbgr.mr_n64198880)
print v(xbgr.mr_n64200272)
print v(xbgr.mr_n64200544)
print v(xbgr.mr_n64200736)
print v(xbgr.mr_n64201088)
print v(xbgr.mr_n64201200)
print v(xbgr.mr_n64203792)
print v(xbgr.mr_n64203984)
print v(xbgr.mr_n64205520)
print v(xbgr.mr_n64205712)
print v(xbgr.mr_n64206064)
print v(xbgr.mr_n64206176)
print v(xbgr.mr_n64208704)
print v(xbgr.mr_n64210096)
print v(xbgr.mr_n64210368)
print v(xbgr.mr_n64210560)
print v(xbgr.mr_n64210912)
print v(xbgr.mr_n64211024)
print v(xbgr.mr_n64213616)
print v(xbgr.mr_n64215008)
print v(xbgr.mr_n64215280)
print v(xbgr.mr_n64215472)
print v(xbgr.mr_n64215824)
print v(xbgr.mr_n64215936)
print v(xbgr.mr_n64218528)
print v(xbgr.mr_n64219920)
print v(xbgr.mr_n64220192)
print v(xbgr.mr_n64220384)
print v(xbgr.mr_n64220736)
print v(xbgr.mr_n64220848)
print v(xbgr.mr_n64223440)
print v(xbgr.mr_n64224832)
print v(xbgr.mr_n64225104)
print v(xbgr.mr_n64225296)
print v(xbgr.mr_n64225648)
print v(xbgr.mr_n64225760)
print v(xbgr.mr_n64228352)
print v(xbgr.mr_n64229744)
print v(xbgr.mr_n64229936)
print v(xbgr.mr_n64230128)
print v(xbgr.mr_n64230560)
print v(xbgr.mr_n64230672)
print v(xbgr.mr_n64233264)
print v(xbgr.mr_n64234656)
print v(xbgr.mr_n64234848)
print v(xbgr.mr_n64235040)
print v(xbgr.mr_n64235472)
print v(xbgr.mr_n64235584)
print v(xbgr.mr_n64238176)
print v(xbgr.mr_n64239568)
print v(xbgr.mr_n64239840)
print v(xbgr.mr_n64240032)
print v(xbgr.mr_n64240384)
print v(xbgr.mr_n64240496)
print v(xbgr.mr_n64241312)
print v(xbgr.mr_n64242416)
print v(xbgr.mr_n64245408)
print v(xbgr.mr_n64250784)
print v(xbgr.mr_n64252448)
print v(xbgr.mr_n64256608)
print v(xbgr.mr_n64262336)
print v(xbgr.mr_n64263120)
print v(xbgr.mr_n64264064)
print v(xbgr.mr_n64265008)
print v(xbgr.mr_n64265952)
print v(xbgr.mr_n64266896)
print v(xbgr.mr_n64267840)
print v(xbgr.mr_n64268784)
print v(xbgr.mr_n64269728)
print v(xbgr.mr_n64270672)
print v(xbgr.mr_n64271616)
print v(xbgr.mr_n64272560)
print v(xbgr.mr_n64273504)
print v(xbgr.mr_n64274448)
print v(xbgr.mr_n64275392)
print v(xbgr.mr_n64276336)
print v(xbgr.mr_n64277280)
print v(xbgr.mr_n64278224)
print v(xbgr.mr_n64279168)
print v(xbgr.mr_n64280112)
print v(xbgr.mr_n64281056)
print v(xbgr.mr_n64282000)
print v(xbgr.mr_n64282944)
print v(xbgr.mr_n64283888)
print v(xbgr.mr_n64285536)
print v(xbgr.mr_n64285872)
print v(xbgr.mr_n64288432)
print v(xbgr.mr_n64288768)
print v(xbgr.mr_n64290944)
print v(xbgr.mr_n64291280)
print v(xbgr.mr_n64293456)
print v(xbgr.mr_n64293792)
print v(xbgr.mr_n64294896)
print v(xbgr.mr_n64297104)
print v(xbgr.mr_n64297376)
print v(xbgr.mr_n64300608)
print v(xbgr.mr_n64301424)
print v(xbgr.mr_n64302368)
print v(xbgr.mr_n64303312)
print v(xbgr.mr_n64304256)
print v(xbgr.mr_n64305872)
print v(xbgr.mr_n64306448)
print v(xbgr.mr_n64306560)
print v(xbgr.mr_n64307392)
print v(xbgr.mr_n64307504)
print v(xbgr.mr_n64308336)
print v(xbgr.mr_n64308448)
print v(xbgr.mr_n64309280)
print v(xbgr.mr_n64309392)
print v(xbgr.mr_n64310224)
print v(xbgr.mr_n64310336)
print v(xbgr.mr_n64311424)
print v(xbgr.mr_n64311536)
print v(xbgr.mr_n64312688)
print v(xbgr.mr_n64312800)
print v(xbgr.mr_n64313952)
print v(xbgr.mr_n64314064)
print v(xbgr.mr_n64315216)
print v(xbgr.mr_n64315328)
print v(xbgr.mr_n64316480)
print v(xbgr.mr_n64316592)
print v(xbgr.mr_n64317744)
print v(xbgr.mr_n64317856)
print v(xbgr.mr_n64319008)
print v(xbgr.mr_n64319120)
print v(xbgr.mr_n64320272)
print v(xbgr.mr_n64320384)
print v(xbgr.mr_n64321536)
print v(xbgr.mr_n64321648)
print v(xbgr.mr_n64322736)
print v(xbgr.mr_n64322848)
print v(xbgr.mr_n64324064)
print v(xbgr.mr_n64324176)
print v(xbgr.mr_n64325328)
print v(xbgr.mr_n64325440)
print v(xbgr.mr_n64333248)
print v(xbgr.mr_n64336448)
print v(xbgr.mr_n64345344)
print v(xbgr.mr_n64346768)
print v(xbgr.mr_n64347728)
print v(xbgr.mr_n64347920)
print v(xbgr.mr_n64348112)
print v(xbgr.mr_n64350160)
print v(xbgr.mr_n64350432)
print v(xbgr.mr_n64350624)
print v(xbgr.mr_n64350976)
print v(xbgr.mr_n64351088)
print v(xbgr.mr_n64351584)
print v(xbgr.mr_n64353664)
print v(xbgr.mr_n64354976)
print v(xbgr.mr_n64357024)
print v(xbgr.mr_n64357216)
print v(xbgr.mr_n64357568)
print v(xbgr.mr_n64357680)
print v(xbgr.mr_n64360272)
print v(xbgr.mr_n64361664)
print v(xbgr.mr_n64361936)
print v(xbgr.mr_n64362128)
print v(xbgr.mr_n64362480)
print v(xbgr.mr_n64362592)
print v(xbgr.mr_n64364160)
print v(xbgr.mr_n64364272)
print v(xbgr.mr_n64368032)
print v(xbgr.mr_n64368224)
print v(xbgr.mr_n64368576)
print v(xbgr.mr_n64368688)
print v(xbgr.mr_n64371216)
print v(xbgr.mr_n64371408)
print v(xbgr.mr_n64372944)
print v(xbgr.mr_n64373136)
print v(xbgr.mr_n64373488)
print v(xbgr.mr_n64373600)
print v(xbgr.mr_n64375104)
print v(xbgr.mr_n64375216)
print v(xbgr.mr_n64378912)
print v(xbgr.mr_n64379104)
print v(xbgr.mr_n64379456)
print v(xbgr.mr_n64379568)
print v(xbgr.mr_n64382160)
print v(xbgr.mr_n64383552)
print v(xbgr.mr_n64383824)
print v(xbgr.mr_n64384016)
print v(xbgr.mr_n64384368)
print v(xbgr.mr_n64384480)
print v(xbgr.mr_n64386368)
print v(xbgr.mr_n64386480)
print v(xbgr.mr_n64389856)
print v(xbgr.mr_n64390048)
print v(xbgr.mr_n64390400)
print v(xbgr.mr_n64390512)
print v(xbgr.mr_n64393104)
print v(xbgr.mr_n64394496)
print v(xbgr.mr_n64394688)
print v(xbgr.mr_n64394880)
print v(xbgr.mr_n64395312)
print v(xbgr.mr_n64395424)
print v(xbgr.mr_n64397056)
print v(xbgr.mr_n64397168)
print v(xbgr.mr_n64400800)
print v(xbgr.mr_n64400992)
print v(xbgr.mr_n64401344)
print v(xbgr.mr_n64401456)
print v(xbgr.mr_n64404048)
print v(xbgr.mr_n64405440)
print v(xbgr.mr_n64405712)
print v(xbgr.mr_n64405904)
print v(xbgr.mr_n64406256)
print v(xbgr.mr_n64406368)
print v(xbgr.mr_n64407936)
print v(xbgr.mr_n64408048)
print v(xbgr.mr_n64411744)
print v(xbgr.mr_n64411936)
print v(xbgr.mr_n64412288)
print v(xbgr.mr_n64412400)
print v(xbgr.mr_n64417792)
print v(xbgr.mr_n64417904)
print v(xbgr.mr_n64418736)
print v(xbgr.mr_n64418848)
print v(xbgr.mr_n64419680)
print v(xbgr.mr_n64419792)
print v(xbgr.mr_n64420816)
print v(xbgr.mr_n64420928)
print v(xbgr.mr_n64422144)
print v(xbgr.mr_n64422256)
print v(xbgr.mr_n64423408)
print v(xbgr.mr_n64423520)
print v(xbgr.mr_n64423792)
print v(xbgr.mr_n64424672)
print v(xbgr.mr_n64424784)
print v(xbgr.mr_n64425936)
print v(xbgr.mr_n64426048)
print v(xbgr.mr_n64427200)
print v(xbgr.mr_n64427312)
print v(xbgr.mr_n64428464)
print v(xbgr.mr_n64428576)
print v(xbgr.mr_n64428720)
print v(xbgr.mr_n64428880)
print v(xbgr.mr_n64429728)
print v(xbgr.mr_n64429840)
print v(xbgr.mr_n64430176)
print v(xbgr.mr_n64431328)
print v(xbgr.mr_n64431440)
print v(xbgr.mr_n64432272)
print v(xbgr.mr_n64432384)
print v(xbgr.mr_n64435360)
print v(xbgr.mr_n64435472)
print v(xbgr.mr_n64437104)
print v(xbgr.mr_n64437216)
print v(xbgr.mr_n64438368)
print v(xbgr.mr_n64438480)
print v(xbgr.mr_n64439632)
print v(xbgr.mr_n64439744)
print v(xbgr.mr_n64440896)
print v(xbgr.mr_n64441008)
print v(xbgr.mr_n64442160)
print v(xbgr.mr_n64442272)
print v(xbgr.mr_n64443424)
print v(xbgr.mr_n64443536)
print v(xbgr.mr_n64444688)
print v(xbgr.mr_n64444800)
print v(xbgr.mr_n64445952)
print v(xbgr.mr_n64446064)
print v(xbgr.mr_n64447216)
print v(xbgr.mr_n64447328)
print v(xbgr.mr_n64448480)
print v(xbgr.mr_n64448592)
print v(xbgr.mr_n64449744)
print v(xbgr.mr_n64449856)
print v(xbgr.mr_n64451008)
print v(xbgr.mr_n64451120)
print v(xbgr.mr_n64452272)
print v(xbgr.mr_n64452384)
print v(xbgr.mr_n64453536)
print v(xbgr.mr_n64453648)
print v(xbgr.mr_n64463872)
print v(xbgr.mr_n64466480)
print v(xbgr.mr_n64471040)
print v(xbgr.mr_n64487344)
print v(xbgr.mr_n64488288)
print v(xbgr.mr_n64491264)
print v(xbgr.mr_n64491952)
print v(xbgr.mr_n64492640)
print v(xbgr.mr_n64493360)
print v(xbgr.mr_n64494304)
print v(xbgr.mr_n64495248)
print v(xbgr.mr_n64496192)
print v(xbgr.mr_n64497136)
print v(xbgr.mr_n64498080)
print v(xbgr.mr_n64499024)
print v(xbgr.mr_n64499968)
print v(xbgr.mr_n64500912)
print v(xbgr.mr_n64501856)
print v(xbgr.mr_n64502800)
print v(xbgr.mr_n64503744)
print v(xbgr.mr_n64504688)
print v(xbgr.mr_n64505632)
print v(xbgr.mr_n64506576)
print v(xbgr.mr_n64507520)
print v(xbgr.mr_n64510320)
print v(xbgr.mr_n64513584)
print v(xbgr.mr_n64515152)
print v(xbgr.mr_n64517408)
print v(xbgr.mr_n64517632)
print v(xbgr.mr_n64520608)
print v(xbgr.mr_n64521888)
print v(xbgr.mr_n64522336)
print v(xbgr.mr_n64522528)
print v(xbgr.mr_n64523216)
print v(xbgr.mr_n64523328)
print v(xbgr.mr_n64523440)
print v(xbgr.mr_n64523552)
print v(xbgr.mr_n64524944)
print v(xbgr.mr_n64525216)
print v(xbgr.mr_n64525408)
print v(xbgr.mr_n64525760)
print v(xbgr.mr_n64525872)
print v(xbgr.mr_n64528448)
print v(xbgr.mr_n64528720)
print v(xbgr.mr_n64528912)
print v(xbgr.mr_n64529264)
print v(xbgr.mr_n64529376)
print v(xbgr.mr_n64533120)
print v(xbgr.mr_n64533312)
print v(xbgr.mr_n64533664)
print v(xbgr.mr_n64533776)
print v(xbgr.mr_n64537568)
print v(xbgr.mr_n64537840)
print v(xbgr.mr_n64538032)
print v(xbgr.mr_n64538384)
print v(xbgr.mr_n64538496)
print v(xbgr.mr_n64542240)
print v(xbgr.mr_n64542432)
print v(xbgr.mr_n64542784)
print v(xbgr.mr_n64542896)
print v(xbgr.mr_n64546688)
print v(xbgr.mr_n64546960)
print v(xbgr.mr_n64547152)
print v(xbgr.mr_n64547504)
print v(xbgr.mr_n64547616)
print v(xbgr.mr_n64551360)
print v(xbgr.mr_n64551552)
print v(xbgr.mr_n64551904)
print v(xbgr.mr_n64552016)
print v(xbgr.mr_n64555808)
print v(xbgr.mr_n64556080)
print v(xbgr.mr_n64556272)
print v(xbgr.mr_n64556624)
print v(xbgr.mr_n64556736)
print v(xbgr.mr_n64560480)
print v(xbgr.mr_n64560672)
print v(xbgr.mr_n64561024)
print v(xbgr.mr_n64561136)
print v(xbgr.mr_n64563216)
print v(xbgr.mr_n64564928)
print v(xbgr.mr_n64565536)
print v(xbgr.mr_n64565728)
print v(xbgr.mr_n64565920)
print v(xbgr.mr_n64567520)
print v(xbgr.mr_n64567792)
print v(xbgr.mr_n64567984)
print v(xbgr.mr_n64568336)
print v(xbgr.mr_n64568448)
print v(xbgr.mr_n64572976)
print v(xbgr.mr_n64574400)
print v(xbgr.mr_n64574592)
print v(xbgr.mr_n64574944)
print v(xbgr.mr_n64575056)
print v(xbgr.mr_n64577184)
print v(xbgr.mr_n64577728)
print v(xbgr.mr_n64579760)
print v(xbgr.mr_n64581152)
print v(xbgr.mr_n64581424)
print v(xbgr.mr_n64581616)
print v(xbgr.mr_n64581968)
print v(xbgr.mr_n64582080)
print v(xbgr.mr_n64584672)
print v(xbgr.mr_n64586064)
print v(xbgr.mr_n64586256)
print v(xbgr.mr_n64586448)
print v(xbgr.mr_n64586880)
print v(xbgr.mr_n64586992)
print v(xbgr.mr_n64589584)
print v(xbgr.mr_n64589776)
print v(xbgr.mr_n64590048)
print v(xbgr.mr_n64591312)
print v(xbgr.mr_n64591504)
print v(xbgr.mr_n64591856)
print v(xbgr.mr_n64591968)
print v(xbgr.mr_n64594496)
print v(xbgr.mr_n64595888)
print v(xbgr.mr_n64596160)
print v(xbgr.mr_n64596352)
print v(xbgr.mr_n64596704)
print v(xbgr.mr_n64596816)
print v(xbgr.mr_n64602432)
print v(xbgr.mr_n64603664)
print v(xbgr.mr_n64604624)
print v(xbgr.mr_n64606192)
print v(xbgr.mr_n64607136)
print v(xbgr.mr_n64609328)
print v(xbgr.mr_n64610896)
print v(xbgr.mr_n64611840)
print v(xbgr.mr_n64614032)
print v(xbgr.mr_n64615648)
print v(xbgr.mr_n64616224)
print v(xbgr.mr_n64616336)
print v(xbgr.mr_n64617168)
print v(xbgr.mr_n64617280)
print v(xbgr.mr_n64618112)
print v(xbgr.mr_n64618224)
print v(xbgr.mr_n64619056)
print v(xbgr.mr_n64619168)
print v(xbgr.mr_n64620000)
print v(xbgr.mr_n64620112)
print v(xbgr.mr_n64620944)
print v(xbgr.mr_n64621056)
print v(xbgr.mr_n64621888)
print v(xbgr.mr_n64622000)
print v(xbgr.mr_n64622832)
print v(xbgr.mr_n64622944)
print v(xbgr.mr_n64623776)
print v(xbgr.mr_n64623888)
print v(xbgr.mr_n64624848)
print v(xbgr.mr_n64624960)
print v(xbgr.mr_n64636208)
print v(xbgr.mr_n64653440)
print v(xbgr.mr_n64655792)
print v(xbgr.mr_n64656480)
print v(xbgr.mr_n64657168)
print v(xbgr.mr_n64657888)
print v(xbgr.mr_n64658832)
print v(xbgr.mr_n64659776)
print v(xbgr.mr_n64660720)
print v(xbgr.mr_n64661664)
print v(xbgr.mr_n64662608)
print v(xbgr.mr_n64663552)
print v(xbgr.mr_n64664496)
print v(xbgr.mr_n64665440)
print v(xbgr.mr_n64666384)
print v(xbgr.mr_n64667328)
print v(xbgr.mr_n64670160)
print v(xbgr.mr_n64671104)
print v(xbgr.mr_n64672048)
print v(xbgr.mr_n64672240)
print v(xbgr.mr_n64672432)
print v(xbgr.mr_n64672624)
print v(xbgr.mr_n64672816)
print v(xbgr.mr_n64674688)
print v(xbgr.mr_n64688224)
print v(xbgr.mr_n64694032)
print v(xbgr.mr_n64702928)
print v(xbgr.mr_n64703760)
print v(xbgr.mr_n64704608)
print v(xbgr.mr_n64704720)
print v(xbgr.mr_n64704832)
print v(xbgr.mr_n64705024)
print v(xbgr.mr_n64706560)
print v(xbgr.mr_n64706752)
print v(xbgr.mr_n64707104)
print v(xbgr.mr_n64707216)
print v(xbgr.mr_n64711904)
print v(xbgr.mr_n64712176)
print v(xbgr.mr_n64712368)
print v(xbgr.mr_n64712720)
print v(xbgr.mr_n64712832)
print v(xbgr.mr_n64716448)
print v(xbgr.mr_n64716640)
print v(xbgr.mr_n64716992)
print v(xbgr.mr_n64717104)
print v(xbgr.mr_n64720768)
print v(xbgr.mr_n64721040)
print v(xbgr.mr_n64721232)
print v(xbgr.mr_n64721584)
print v(xbgr.mr_n64721696)
print v(xbgr.mr_n64725312)
print v(xbgr.mr_n64725504)
print v(xbgr.mr_n64725856)
print v(xbgr.mr_n64725968)
print v(xbgr.mr_n64729632)
print v(xbgr.mr_n64729904)
print v(xbgr.mr_n64730096)
print v(xbgr.mr_n64730448)
print v(xbgr.mr_n64730560)
print v(xbgr.mr_n64734176)
print v(xbgr.mr_n64734368)
print v(xbgr.mr_n64734720)
print v(xbgr.mr_n64734832)
print v(xbgr.mr_n64738496)
print v(xbgr.mr_n64738768)
print v(xbgr.mr_n64738960)
print v(xbgr.mr_n64739312)
print v(xbgr.mr_n64739424)
print v(xbgr.mr_n64747536)
print v(xbgr.mr_n64749104)
print v(xbgr.mr_n64750672)
print v(xbgr.mr_n64752240)
print v(xbgr.mr_n64753808)
print v(xbgr.mr_n64755376)
print v(xbgr.mr_n64756944)
print v(xbgr.mr_n64759424)
print v(xbgr.mr_n64759760)
print v(xbgr.mr_n64759872)
print v(xbgr.mr_n64760704)
print v(xbgr.mr_n64760816)
print v(xbgr.mr_n64761648)
print v(xbgr.mr_n64761760)
print v(xbgr.mr_n64762592)
print v(xbgr.mr_n64762704)
print v(xbgr.mr_n64763536)
print v(xbgr.mr_n64763648)
print v(xbgr.mr_n64764480)
print v(xbgr.mr_n64764592)
print v(xbgr.mr_n64765424)
print v(xbgr.mr_n64765536)
print v(xbgr.mr_n64766368)
print v(xbgr.mr_n64766480)
print v(xbgr.mr_n64767312)
print v(xbgr.mr_n64767424)
print v(xbgr.mr_n64768256)
print v(xbgr.mr_n64768368)
print v(xbgr.mr_n64769200)
print v(xbgr.mr_n64769312)
print v(xbgr.mr_n64770144)
print v(xbgr.mr_n64770256)
print v(xbgr.mr_n64771280)
print v(xbgr.mr_n64771392)
print v(xbgr.mr_n64772544)
print v(xbgr.mr_n64772656)
print v(xbgr.mr_n64773808)
print v(xbgr.mr_n64773920)
print v(xbgr.mr_n64775072)
print v(xbgr.mr_n64775184)
print v(xbgr.mr_n64776336)
print v(xbgr.mr_n64776448)
print v(xbgr.mr_n64777584)
print v(xbgr.mr_n64778944)
print v(xbgr.mr_n64780272)
print v(xbgr.mr_n64782192)
print v(xbgr.mr_n64782880)
print v(xbgr.mr_n64783568)
print v(xbgr.mr_n64784288)
print v(xbgr.mr_n64785232)
print v(xbgr.mr_n64786176)
print v(xbgr.mr_n64787120)
print v(xbgr.mr_n64788064)
print v(xbgr.mr_n64789008)
print v(xbgr.mr_n64789952)
print v(xbgr.mr_n64790896)
print v(xbgr.mr_n64791840)
print v(xbgr.mr_n64792784)
print v(xbgr.mr_n64793728)
print v(xbgr.mr_n64794672)
print v(xbgr.mr_n64795616)
print v(xbgr.mr_n64796560)
print v(xbgr.mr_n64797504)
print v(xbgr.mr_n64798448)
print v(xbgr.mr_n64811040)
print v(xbgr.mr_n64813216)
print v(xbgr.mr_n64814784)
print v(xbgr.mr_n64815824)
print v(xbgr.mr_n64816016)
print v(xbgr.mr_n64817344)
print v(xbgr.mr_n64819488)
print v(xbgr.mr_n64820304)
print v(xbgr.mr_n64821248)
print v(xbgr.mr_n64823904)
print v(xbgr.mr_n64825024)
print v(xbgr.mr_n64826496)
print v(xbgr.mr_n64828064)
print v(xbgr.mr_n64829632)
print v(xbgr.mr_n64831200)
print v(xbgr.mr_n64835504)
print v(xbgr.mr_n64835616)
print v(xbgr.mr_n64837136)
print v(xbgr.mr_n64837328)
print v(xbgr.mr_n64837872)
print v(xbgr.mr_n64838704)
print v(xbgr.mr_n64838816)
print v(xbgr.mr_n64840976)
print v(xbgr.mr_n64842528)
print v(xbgr.mr_n64843648)
print v(xbgr.mr_n64844336)
print v(xbgr.mr_n64846336)
print v(xbgr.mr_n64848544)
print v(xbgr.mr_n64849488)
print v(xbgr.mr_n64854768)
print v(xbgr.mr_n64856640)
print v(xbgr.mr_n64857088)
print v(xbgr.mr_n64858256)
print v(xbgr.mr_n64858368)
print v(xbgr.mr_n64859520)
print v(xbgr.mr_n64859632)
print v(xbgr.mr_n64860784)
print v(xbgr.mr_n64860896)
print v(xbgr.mr_n64862048)
print v(xbgr.mr_n64862160)
print v(xbgr.mr_n64863312)
print v(xbgr.mr_n64863424)
print v(xbgr.mr_n64864576)
print v(xbgr.mr_n64864688)
print v(xbgr.mr_n64865840)
print v(xbgr.mr_n64865952)
print v(xbgr.mr_n64867104)
print v(xbgr.mr_n64867216)
print v(xbgr.mr_n64868368)
print v(xbgr.mr_n64868480)
print v(xbgr.mr_n64869632)
print v(xbgr.mr_n64869744)
print v(xbgr.mr_n64882992)
print v(xbgr.mr_n64883680)
print v(xbgr.mr_n64887136)
print v(xbgr.mr_n64892896)
print v(xbgr.mr_n64893008)
print v(xbgr.mr_n64893200)
print v(xbgr.mr_n64893392)
print v(xbgr.mr_n64893584)
print v(xbgr.mr_n64896000)
print v(xbgr.mr_n64901008)
print v(xbgr.mr_n64906528)
print v(xbgr.mr_n64907472)
print v(xbgr.mr_n64908416)
print v(xbgr.mr_n64909360)
print v(xbgr.mr_n64910304)
print v(xbgr.mr_n64911248)
print v(xbgr.mr_n64912192)
print v(xbgr.mr_n64913136)
print v(xbgr.mr_n64914080)
print v(xbgr.mr_n64915024)
print v(xbgr.mr_n64915968)
print v(xbgr.mr_n64916912)
print v(xbgr.mr_n64917856)
print v(xbgr.mr_n64918800)
print v(xbgr.mr_n64919744)
print v(xbgr.mr_n64920688)
print v(xbgr.mr_n64921632)
print v(xbgr.mr_n64922576)
print v(xbgr.mr_n64923520)
print v(xbgr.mr_n64924464)
print v(xbgr.mr_n64925408)
print v(xbgr.mr_n64926352)
print v(xbgr.mr_n64927296)
print v(xbgr.mr_n64928240)
print v(xbgr.mr_n64929184)
print v(xbgr.mr_n64930128)
print v(xbgr.mr_n64931072)
print v(xbgr.mr_n64932016)
print v(xbgr.mr_n64932960)
print v(xbgr.mr_n64933904)
print v(xbgr.mr_n64936064)
print v(xbgr.mr_n64937024)
print v(xbgr.mr_n64937968)
print v(xbgr.mr_n64938912)
print v(xbgr.mr_n64940528)
print v(xbgr.mr_n64941808)
print v(xbgr.mr_n64941920)
print v(xbgr.mr_n64943072)
print v(xbgr.mr_n64943184)
print v(xbgr.mr_n64946176)
print v(xbgr.mr_n64946864)
print v(xbgr.mr_n64946976)
print v(xbgr.mr_n64947088)
print v(xbgr.mr_n64947200)
print v(xbgr.mr_n64948592)
print v(xbgr.mr_n64948864)
print v(xbgr.mr_n64949056)
print v(xbgr.mr_n64949408)
print v(xbgr.mr_n64949520)
print v(xbgr.mr_n64952112)
print v(xbgr.mr_n64953504)
print v(xbgr.mr_n64953776)
print v(xbgr.mr_n64953968)
print v(xbgr.mr_n64954320)
print v(xbgr.mr_n64954432)
print v(xbgr.mr_n64957024)
print v(xbgr.mr_n64958416)
print v(xbgr.mr_n64958688)
print v(xbgr.mr_n64958880)
print v(xbgr.mr_n64959232)
print v(xbgr.mr_n64959344)
print v(xbgr.mr_n64961936)
print v(xbgr.mr_n64963328)
print v(xbgr.mr_n64963600)
print v(xbgr.mr_n64963792)
print v(xbgr.mr_n64964144)
print v(xbgr.mr_n64964256)
print v(xbgr.mr_n64966848)
print v(xbgr.mr_n64968240)
print v(xbgr.mr_n64968512)
print v(xbgr.mr_n64968704)
print v(xbgr.mr_n64969056)
print v(xbgr.mr_n64969168)
print v(xbgr.mr_n64970960)
print v(xbgr.mr_n64971840)
print v(xbgr.mr_n64972032)
print v(xbgr.mr_n64972224)
print v(xbgr.mr_n64973696)
print v(xbgr.mr_n64973968)
print v(xbgr.mr_n64974160)
print v(xbgr.mr_n64974512)
print v(xbgr.mr_n64974624)
print v(xbgr.mr_n64978912)
print v(xbgr.mr_n64980304)
print v(xbgr.mr_n64980576)
print v(xbgr.mr_n64980768)
print v(xbgr.mr_n64981120)
print v(xbgr.mr_n64981232)
print v(xbgr.mr_n64984080)
print v(xbgr.mr_n64984928)
print v(xbgr.mr_n64985872)
print v(xbgr.mr_n64986816)
print v(xbgr.mr_n64987760)
print v(xbgr.mr_n64988704)
print v(xbgr.mr_n64989648)
print v(xbgr.mr_n64990592)
print v(xbgr.mr_n64991536)
print v(xbgr.mr_n64992480)
print v(xbgr.mr_n64993424)
print v(xbgr.mr_n64994368)
print v(xbgr.mr_n64998320)
print v(xbgr.mr_n65000144)
print v(xbgr.mr_n65000976)
print v(xbgr.mr_n65001248)
print v(xbgr.mr_n65002384)
print v(xbgr.mr_n65003472)
print v(xbgr.mr_n65003808)
print v(xbgr.mr_n65004000)
print v(xbgr.mr_n65005104)
print v(xbgr.mr_n65005216)
print v(xbgr.mr_n65011616)
print v(xbgr.mr_n65012304)
print v(xbgr.mr_n65012992)
print v(xbgr.mr_n65013680)
print v(xbgr.mr_n65014368)
print v(xbgr.mr_n65015056)
print v(xbgr.mr_n65015744)
print v(xbgr.mr_n65016432)
print v(xbgr.mr_n65017120)
print v(xbgr.mr_n65017808)
print v(xbgr.mr_n65018496)
print v(xbgr.mr_n65020400)
print v(xbgr.mr_n65021360)
print v(xbgr.mr_n65031616)
print v(xbgr.mr_n65033472)
print v(xbgr.mr_n65033584)
print v(xbgr.mr_n65034736)
print v(xbgr.mr_n65034848)
print v(xbgr.mr_n65036000)
print v(xbgr.mr_n65036112)
print v(xbgr.mr_n65037200)
print v(xbgr.mr_n65037312)
print v(xbgr.mr_n65038528)
print v(xbgr.mr_n65038640)
print v(xbgr.mr_n65039792)
print v(xbgr.mr_n65039904)
print v(xbgr.mr_n65041056)
print v(xbgr.mr_n65041168)
print v(xbgr.mr_n65042320)
print v(xbgr.mr_n65042432)
print v(xbgr.mr_n65043584)
print v(xbgr.mr_n65043696)
print v(xbgr.mr_n65044784)
print v(xbgr.mr_n65044896)
print v(xbgr.mr_n65046112)
print v(xbgr.mr_n65046224)
print v(xbgr.mr_n65047376)
print v(xbgr.mr_n65047488)
print v(xbgr.mr_n65048640)
print v(xbgr.mr_n65048752)
print v(xbgr.mr_n65049904)
print v(xbgr.mr_n65050016)
print v(xbgr.mr_n65051168)
print v(xbgr.mr_n65051280)
print v(xbgr.mr_n65052368)
print v(xbgr.mr_n65052480)
print v(xbgr.mr_n65053696)
print v(xbgr.mr_n65053808)
print v(xbgr.mr_n65057552)
print v(xbgr.mr_n65058672)
print v(xbgr.mr_n65060144)
print v(xbgr.mr_n65061712)
print v(xbgr.mr_n65063280)
print v(xbgr.mr_n65064848)
print v(xbgr.mr_n65066416)
print v(xbgr.mr_n65067984)
print v(xbgr.mr_n65069552)
print v(xbgr.mr_n65071120)
print v(xbgr.mr_n65072688)
print v(xbgr.mr_n65074256)
print v(xbgr.mr_n65076448)
print v(xbgr.mr_n65078016)
print v(xbgr.mr_n65079584)
print v(xbgr.mr_n65084688)
print v(xbgr.mr_n65088464)
print v(xbgr.mr_n65094320)
print v(xbgr.mr_n65095392)
print v(xbgr.mr_n65095584)
print v(xbgr.mr_n65095776)
print v(xbgr.mr_n65097824)
print v(xbgr.mr_n65098096)
print v(xbgr.mr_n65098288)
print v(xbgr.mr_n65098640)
print v(xbgr.mr_n65098752)
print v(xbgr.mr_n65102896)
print v(xbgr.mr_n65103088)
print v(xbgr.mr_n65103552)
print v(xbgr.mr_n65105888)
print v(xbgr.mr_n65106000)
print v(xbgr.mr_n65106112)
print v(xbgr.mr_n65106224)
print v(xbgr.mr_n65106544)
print v(xbgr.mr_n65106816)
print v(xbgr.mr_n65107008)
print v(xbgr.mr_n65107360)
print v(xbgr.mr_n65107472)
print v(xbgr.mr_n65110080)
print v(xbgr.mr_n65110192)
print v(xbgr.mr_n65110304)
print v(xbgr.mr_n65114624)
print v(xbgr.mr_n65114816)
print v(xbgr.mr_n65115168)
print v(xbgr.mr_n65115280)
print v(xbgr.mr_n65117744)
print v(xbgr.mr_n65117856)
print v(xbgr.mr_n65120256)
print v(xbgr.mr_n65120368)
print v(xbgr.mr_n65122704)
print v(xbgr.mr_n65122816)
print v(xbgr.mr_n65125216)
print v(xbgr.mr_n65125328)
print v(xbgr.mr_n65127728)
print v(xbgr.mr_n65127840)
print v(xbgr.mr_n65130240)
print v(xbgr.mr_n65130352)
print v(xbgr.mr_n65132752)
print v(xbgr.mr_n65132864)
print v(xbgr.mr_n65135264)
print v(xbgr.mr_n65135376)
print v(xbgr.mr_n65137776)
print v(xbgr.mr_n65137888)
print v(xbgr.mr_n65140288)
print v(xbgr.mr_n65140400)
print v(xbgr.mr_n65142864)
print v(xbgr.mr_n65142976)
print v(xbgr.mr_n65148160)
print v(xbgr.mr_n65151696)
print v(xbgr.mr_n65151808)
print v(xbgr.mr_n65152960)
print v(xbgr.mr_n65153072)
print v(xbgr.mr_n65154224)
print v(xbgr.mr_n65154336)
print v(xbgr.mr_n65155488)
print v(xbgr.mr_n65155600)
print v(xbgr.mr_n65156752)
print v(xbgr.mr_n65156864)
print v(xbgr.mr_n65158016)
print v(xbgr.mr_n65158128)
print v(xbgr.mr_n65159280)
print v(xbgr.mr_n65159392)
print v(xbgr.mr_n65160544)
print v(xbgr.mr_n65160656)
print v(xbgr.mr_n65161808)
print v(xbgr.mr_n65161920)
print v(xbgr.mr_n65163072)
print v(xbgr.mr_n65163184)
print v(xbgr.mr_n65164336)
print v(xbgr.mr_n65164448)
print v(xbgr.mr_n65165600)
print v(xbgr.mr_n65165712)
print v(xbgr.mr_n65166864)
print v(xbgr.mr_n65166976)
print v(xbgr.mr_n65168128)
print v(xbgr.mr_n65168240)
print v(xbgr.mr_n65177568)
print v(xbgr.mr_n65178352)
print v(xbgr.mr_n65183264)
print v(xbgr.mr_n65184928)
print v(xbgr.mr_n65186720)
print v(xbgr.mr_n65187408)
print v(xbgr.mr_n65188096)
print v(xbgr.mr_n65188816)
print v(xbgr.mr_n65189760)
print v(xbgr.mr_n65190704)
print v(xbgr.mr_n65191648)
print v(xbgr.mr_n65192592)
print v(xbgr.mr_n65193536)
print v(xbgr.mr_n65194480)
print v(xbgr.mr_n65195424)
print v(xbgr.mr_n65196368)
print v(xbgr.mr_n65197312)
print v(xbgr.mr_n65198256)
print v(xbgr.mr_n65199200)
print v(xbgr.mr_n65200144)
print v(xbgr.mr_n65201088)
print v(xbgr.mr_n65202032)
print v(xbgr.mr_n65202976)
print v(xbgr.mr_n65208032)
print v(xbgr.mr_n65209296)
print v(xbgr.mr_n65210864)
print v(xbgr.mr_n65213440)
print v(xbgr.mr_n65214672)
print v(xbgr.mr_n65214784)
print v(xbgr.mr_n65215728)
print v(xbgr.mr_n65216880)
print v(xbgr.mr_n65216992)
print v(xbgr.mr_n65218768)
print v(xbgr.mr_n65218880)
print v(xbgr.mr_n65219824)
print v(xbgr.mr_n65220976)
print v(xbgr.mr_n65221088)
print v(xbgr.mr_n65222864)
print v(xbgr.mr_n65222976)
print v(xbgr.mr_n65223920)
print v(xbgr.mr_n65225072)
print v(xbgr.mr_n65225184)
print v(xbgr.mr_n65226960)
print v(xbgr.mr_n65227072)
print v(xbgr.mr_n65228016)
print v(xbgr.mr_n65229168)
print v(xbgr.mr_n65229280)
print v(xbgr.mr_n65230448)
print v(xbgr.mr_n65231056)
print v(xbgr.mr_n65231168)
print v(xbgr.mr_n65232112)
print v(xbgr.mr_n65233264)
print v(xbgr.mr_n65233376)
print v(xbgr.mr_n65234544)
print v(xbgr.mr_n65235152)
print v(xbgr.mr_n65235264)
print v(xbgr.mr_n65236208)
print v(xbgr.mr_n65237360)
print v(xbgr.mr_n65237472)
print v(xbgr.mr_n65239248)
print v(xbgr.mr_n65239360)
print v(xbgr.mr_n65239872)
print v(xbgr.mr_n65240304)
print v(xbgr.mr_n65243072)
print v(xbgr.mr_n65246080)
print v(xbgr.mr_n65248272)
print v(xbgr.mr_n65249840)
print v(xbgr.mr_n65251408)
print v(xbgr.mr_n65252976)
print v(xbgr.mr_n65254544)
print v(xbgr.mr_n65256112)
print v(xbgr.mr_n65257680)
print v(xbgr.mr_n65278624)
print v(xbgr.mr_n65279152)
print v(xbgr.mr_n65279344)
print v(xbgr.mr_n65280032)
print v(xbgr.mr_n65280464)
print v(xbgr.mr_n65281296)
print v(xbgr.mr_n65282000)
print v(xbgr.mr_n65282560)
print v(xbgr.mr_n65282992)
print v(xbgr.mr_n65283824)
print v(xbgr.mr_n65284256)
print v(xbgr.mr_n65285088)
print v(xbgr.mr_n65285664)
print v(xbgr.mr_n65286352)
print v(xbgr.mr_n65286928)
print v(xbgr.mr_n65287616)
print v(xbgr.mr_n65288048)
print v(xbgr.mr_n65288880)
print v(xbgr.mr_n65289312)
print v(xbgr.mr_n65290144)
print v(xbgr.mr_n65290720)
print v(xbgr.mr_n65291408)
print v(xbgr.mr_n65291840)
print v(xbgr.mr_n65292672)
print v(xbgr.mr_n65293376)
print v(xbgr.mr_n65293936)
print v(xbgr.mr_n65294512)
print v(xbgr.mr_n65295200)
print v(xbgr.mr_n65295776)
print v(xbgr.mr_n65296464)
print v(xbgr.mr_n65297040)
print v(xbgr.mr_n65297728)
print v(xbgr.mr_n65298304)
print v(xbgr.mr_n65298992)
print v(xbgr.mr_n65299424)
print v(xbgr.mr_n65300256)
print v(xbgr.mr_n65301024)
print v(xbgr.mr_n65303760)
print v(xbgr.mr_n65303872)
print v(xbgr.mr_n65303984)
print v(xbgr.mr_n65305952)
print v(xbgr.mr_n65306144)
print v(xbgr.mr_n65306336)
print v(xbgr.mr_n65306768)
print v(xbgr.mr_n65306880)
print v(xbgr.mr_n65308448)
print v(xbgr.mr_n65308560)
print v(xbgr.mr_n65308992)
print v(xbgr.mr_n65310448)
print v(xbgr.mr_n65310560)
print v(xbgr.mr_n65312832)
print v(xbgr.mr_n65312944)
print v(xbgr.mr_n65315216)
print v(xbgr.mr_n65315328)
print v(xbgr.mr_n65317600)
print v(xbgr.mr_n65317712)
print v(xbgr.mr_n65319984)
print v(xbgr.mr_n65320096)
print v(xbgr.mr_n65320912)
print v(xbgr.mr_n65322368)
print v(xbgr.mr_n65322480)
print v(xbgr.mr_n65324816)
print v(xbgr.mr_n65324928)
print v(xbgr.mr_n65327136)
print v(xbgr.mr_n65327248)
print v(xbgr.mr_n65329520)
print v(xbgr.mr_n65329632)
print v(xbgr.mr_n65331904)
print v(xbgr.mr_n65332016)
print v(xbgr.mr_n65334288)
print v(xbgr.mr_n65334400)
print v(xbgr.mr_n65336672)
print v(xbgr.mr_n65336784)
print v(xbgr.mr_n65337600)
print v(xbgr.mr_n65339056)
print v(xbgr.mr_n65339168)
print v(xbgr.mr_n65341440)
print v(xbgr.mr_n65341552)
print v(xbgr.mr_n65343824)
print v(xbgr.mr_n65343936)
print v(xbgr.mr_n65349488)
print v(xbgr.mr_n65353360)
print v(xbgr.mr_n65353472)
print v(xbgr.mr_n65354688)
print v(xbgr.mr_n65354800)
print v(xbgr.mr_n65355952)
print v(xbgr.mr_n65356064)
print v(xbgr.mr_n65357216)
print v(xbgr.mr_n65357328)
print v(xbgr.mr_n65358480)
print v(xbgr.mr_n65358592)
print v(xbgr.mr_n65359744)
print v(xbgr.mr_n65359856)
print v(xbgr.mr_n65361008)
print v(xbgr.mr_n65361120)
print v(xbgr.mr_n65362272)
print v(xbgr.mr_n65362384)
print v(xbgr.mr_n65363536)
print v(xbgr.mr_n65363648)
print v(xbgr.mr_n65364800)
print v(xbgr.mr_n65364912)
print v(xbgr.mr_n65366000)
print v(xbgr.mr_n65366112)
print v(xbgr.mr_n65367328)
print v(xbgr.mr_n65367440)
print v(xbgr.mr_n65368528)
print v(xbgr.mr_n65368640)
print v(xbgr.mr_n65369856)
print v(xbgr.mr_n65369968)
print v(xbgr.mr_n65373872)
print v(xbgr.mr_n65375120)
print v(xbgr.mr_n65376640)
print v(xbgr.mr_n65376752)
print v(xbgr.mr_n65376864)
print v(xbgr.mr_n65377056)
print v(xbgr.mr_n65377664)
print v(xbgr.mr_n65378352)
print v(xbgr.mr_n65379456)
print v(xbgr.mr_n65381392)
print v(xbgr.mr_n65382336)
print v(xbgr.mr_n65383280)
print v(xbgr.mr_n65384224)
print v(xbgr.mr_n65385168)
print v(xbgr.mr_n65386112)
print v(xbgr.mr_n65387056)
print v(xbgr.mr_n65388000)
print v(xbgr.mr_n65388944)
print v(xbgr.mr_n65389888)
print v(xbgr.mr_n65390832)
print v(xbgr.mr_n65391776)
print v(xbgr.mr_n65401552)
print v(xbgr.mr_n65402448)
print v(xbgr.mr_n65404016)
print v(xbgr.mr_n65405584)
print v(xbgr.mr_n65407152)
print v(xbgr.mr_n65408720)
print v(xbgr.mr_n65410288)
print v(xbgr.mr_n65411856)
print v(xbgr.mr_n65413424)
print v(xbgr.mr_n65414992)
print v(xbgr.mr_n65416560)
print v(xbgr.mr_n65418128)
print v(xbgr.mr_n65419696)
print v(xbgr.mr_n65421264)
print v(xbgr.mr_n65422576)
print v(xbgr.mr_n65423456)
print v(xbgr.mr_n65425024)
print v(xbgr.mr_n65426592)
print v(xbgr.mr_n65428160)
print v(xbgr.mr_n65429728)
print v(xbgr.mr_n65431296)
print v(xbgr.mr_n65432864)
print v(xbgr.mr_n65435440)
print v(xbgr.mr_n65437296)
print v(xbgr.mr_n65437408)
print v(xbgr.mr_n65438560)
print v(xbgr.mr_n65438672)
print v(xbgr.mr_n65439760)
print v(xbgr.mr_n65439872)
print v(xbgr.mr_n65441088)
print v(xbgr.mr_n65441200)
print v(xbgr.mr_n65442352)
print v(xbgr.mr_n65442464)
print v(xbgr.mr_n65443616)
print v(xbgr.mr_n65443728)
print v(xbgr.mr_n65444880)
print v(xbgr.mr_n65444992)
print v(xbgr.mr_n65446144)
print v(xbgr.mr_n65446256)
print v(xbgr.mr_n65447408)
print v(xbgr.mr_n65447520)
print v(xbgr.mr_n65448672)
print v(xbgr.mr_n65448784)
print v(xbgr.mr_n65449936)
print v(xbgr.mr_n65450048)
print v(xbgr.mr_n65451200)
print v(xbgr.mr_n65451312)
print v(xbgr.mr_n65452464)
print v(xbgr.mr_n65452576)
print v(xbgr.mr_n65453728)
print v(xbgr.mr_n65453840)
print v(xbgr.mr_n65454992)
print v(xbgr.mr_n65455104)
print v(xbgr.mr_n65456256)
print v(xbgr.mr_n65456368)
print v(xbgr.mr_n65457520)
print v(xbgr.mr_n65457632)
print v(xbgr.mr_n65457888)
print v(xbgr.mr_n65468944)
print v(xbgr.mr_n65470800)
print v(xbgr.mr_n65479424)
print v(xbgr.mr_n65480256)
print v(xbgr.mr_n65480832)
print v(xbgr.mr_n65481520)
print v(xbgr.mr_n65482096)
print v(xbgr.mr_n65482784)
print v(xbgr.mr_n65483216)
print v(xbgr.mr_n65484048)
print v(xbgr.mr_n65484624)
print v(xbgr.mr_n65485312)
print v(xbgr.mr_n65485888)
print v(xbgr.mr_n65486576)
print v(xbgr.mr_n65487152)
print v(xbgr.mr_n65487840)
print v(xbgr.mr_n65488416)
print v(xbgr.mr_n65489104)
print v(xbgr.mr_n65489536)
print v(xbgr.mr_n65490368)
print v(xbgr.mr_n65490944)
print v(xbgr.mr_n65491632)
print v(xbgr.mr_n65492064)
print v(xbgr.mr_n65492896)
print v(xbgr.mr_n65493328)
print v(xbgr.mr_n65494160)
print v(xbgr.mr_n65494592)
print v(xbgr.mr_n65495424)
print v(xbgr.mr_n65496000)
print v(xbgr.mr_n65496688)
print v(xbgr.mr_n65497120)
print v(xbgr.mr_n65497952)
print v(xbgr.mr_n65498528)
print v(xbgr.mr_n65499216)
print v(xbgr.mr_n65499648)
print v(xbgr.mr_n65500480)
print v(xbgr.mr_n65503104)
print v(xbgr.mr_n65504128)
print v(xbgr.mr_n65506176)
print v(xbgr.mr_n65506448)
print v(xbgr.mr_n65506640)
print v(xbgr.mr_n65506992)
print v(xbgr.mr_n65507104)
print v(xbgr.mr_n65507216)
print v(xbgr.mr_n65508672)
print v(xbgr.mr_n65508784)
print v(xbgr.mr_n65509360)
print v(xbgr.mr_n65510672)
print v(xbgr.mr_n65510784)
print v(xbgr.mr_n65511568)
print v(xbgr.mr_n65511760)
print v(xbgr.mr_n65512112)
print v(xbgr.mr_n65512224)
print v(xbgr.mr_n65512336)
print v(xbgr.mr_n65514768)
print v(xbgr.mr_n65515120)
print v(xbgr.mr_n65515232)
print v(xbgr.mr_n65517504)
print v(xbgr.mr_n65517616)
print v(xbgr.mr_n65521232)
print v(xbgr.mr_n65521344)
print v(xbgr.mr_n65523616)
print v(xbgr.mr_n65523728)
print v(xbgr.mr_n65526000)
print v(xbgr.mr_n65526112)
print v(xbgr.mr_n65528384)
print v(xbgr.mr_n65528496)
print v(xbgr.mr_n65530768)
print v(xbgr.mr_n65530880)
print v(xbgr.mr_n65533152)
print v(xbgr.mr_n65533264)
print v(xbgr.mr_n65535536)
print v(xbgr.mr_n65535648)
print v(xbgr.mr_n65537920)
print v(xbgr.mr_n65538032)
print v(xbgr.mr_n65540304)
print v(xbgr.mr_n65540416)
print v(xbgr.mr_n65542688)
print v(xbgr.mr_n65542800)
print v(xbgr.mr_n65543440)
print v(xbgr.mr_n65551104)
print v(xbgr.mr_n65552320)
print v(xbgr.mr_n65552432)
print v(xbgr.mr_n65553584)
print v(xbgr.mr_n65553696)
print v(xbgr.mr_n65554848)
print v(xbgr.mr_n65554960)
print v(xbgr.mr_n65556112)
print v(xbgr.mr_n65556224)
print v(xbgr.mr_n65557376)
print v(xbgr.mr_n65557488)
print v(xbgr.mr_n65558640)
print v(xbgr.mr_n65558752)
print v(xbgr.mr_n65559904)
print v(xbgr.mr_n65560016)
print v(xbgr.mr_n65561168)
print v(xbgr.mr_n65561280)
print v(xbgr.mr_n65562432)
print v(xbgr.mr_n65562544)
print v(xbgr.mr_n65563696)
print v(xbgr.mr_n65563808)
print v(xbgr.mr_n65564960)
print v(xbgr.mr_n65565072)
print v(xbgr.mr_n65566160)
print v(xbgr.mr_n65566272)
print v(xbgr.mr_n65567488)
print v(xbgr.mr_n65567600)
print v(xbgr.mr_n65568752)
print v(xbgr.mr_n65568864)
print v(xbgr.mr_n65570016)
print v(xbgr.mr_n65570128)
print v(xbgr.mr_n65571008)
print v(xbgr.mr_n65571696)
print v(xbgr.mr_n65572384)
print v(xbgr.mr_n65573104)
print v(xbgr.mr_n65574048)
print v(xbgr.mr_n65574992)
print v(xbgr.mr_n65575936)
print v(xbgr.mr_n65576880)
print v(xbgr.mr_n65577824)
print v(xbgr.mr_n65578768)
print v(xbgr.mr_n65579712)
print v(xbgr.mr_n65580656)
print v(xbgr.mr_n65581600)
print v(xbgr.mr_n65582544)
print v(xbgr.mr_n65583488)
print v(xbgr.mr_n65584432)
print v(xbgr.mr_n65592688)
print v(xbgr.mr_n65605088)
print v(xbgr.mr_n65606656)
print v(xbgr.mr_n65609136)
print v(xbgr.mr_n65610176)
print v(xbgr.mr_n65610288)
print v(xbgr.mr_n65611232)
print v(xbgr.mr_n65612384)
print v(xbgr.mr_n65612496)
print v(xbgr.mr_n65613664)
print v(xbgr.mr_n65614272)
print v(xbgr.mr_n65614384)
print v(xbgr.mr_n65615328)
print v(xbgr.mr_n65616480)
print v(xbgr.mr_n65616592)
print v(xbgr.mr_n65617760)
print v(xbgr.mr_n65618368)
print v(xbgr.mr_n65618480)
print v(xbgr.mr_n65619424)
print v(xbgr.mr_n65620576)
print v(xbgr.mr_n65620688)
print v(xbgr.mr_n65622464)
print v(xbgr.mr_n65622576)
print v(xbgr.mr_n65623520)
print v(xbgr.mr_n65624672)
print v(xbgr.mr_n65624784)
print v(xbgr.mr_n65625952)
print v(xbgr.mr_n65626560)
print v(xbgr.mr_n65626672)
print v(xbgr.mr_n65627616)
print v(xbgr.mr_n65628768)
print v(xbgr.mr_n65628880)
print v(xbgr.mr_n65630048)
print v(xbgr.mr_n65630656)
print v(xbgr.mr_n65630768)
print v(xbgr.mr_n65631712)
print v(xbgr.mr_n65632864)
print v(xbgr.mr_n65632976)
print v(xbgr.mr_n65634752)
print v(xbgr.mr_n65634864)
print v(xbgr.mr_n65635808)
print v(xbgr.mr_n65636960)
print v(xbgr.mr_n65637072)
print v(xbgr.mr_n65638848)
print v(xbgr.mr_n65638960)
print v(xbgr.mr_n65639904)
print v(xbgr.mr_n65641056)
print v(xbgr.mr_n65641168)
print v(xbgr.mr_n65642416)
print v(xbgr.mr_n65642944)
print v(xbgr.mr_n65643056)
print v(xbgr.mr_n65644368)
print v(xbgr.mr_n65644480)
print v(xbgr.mr_n65645488)
print v(xbgr.mr_n65646624)
print v(xbgr.mr_n65648688)
print v(xbgr.mr_n65650864)
print v(xbgr.mr_n65651696)
print v(xbgr.mr_n65652784)
print v(xbgr.mr_n65660384)
print v(xbgr.mr_n65667616)
print v(xbgr.mr_n65669312)
print v(xbgr.mr_n65671040)
print v(xbgr.mr_n65671904)
print v(xbgr.mr_n65674144)
print v(xbgr.mr_n65675408)
print v(xbgr.mr_n65675600)
print v(xbgr.mr_n65675792)
print v(xbgr.mr_n65677840)
print v(xbgr.mr_n65678112)
print v(xbgr.mr_n65678304)
print v(xbgr.mr_n65678656)
print v(xbgr.mr_n65678768)
print v(xbgr.mr_n65681344)
print v(xbgr.mr_n65684624)
print v(xbgr.mr_n65684816)
print v(xbgr.mr_n65685248)
print v(xbgr.mr_n65685360)
print v(xbgr.mr_n65688352)
print v(xbgr.mr_n65688544)
print v(xbgr.mr_n65688896)
print v(xbgr.mr_n65689008)
print v(xbgr.mr_n65691600)
print v(xbgr.mr_n65692992)
print v(xbgr.mr_n65693264)
print v(xbgr.mr_n65693456)
print v(xbgr.mr_n65693808)
print v(xbgr.mr_n65693920)
print v(xbgr.mr_n65695488)
print v(xbgr.mr_n65695600)
print v(xbgr.mr_n65699296)
print v(xbgr.mr_n65699488)
print v(xbgr.mr_n65699840)
print v(xbgr.mr_n65699952)
print v(xbgr.mr_n65702544)
print v(xbgr.mr_n65703936)
print v(xbgr.mr_n65704208)
print v(xbgr.mr_n65704400)
print v(xbgr.mr_n65704752)
print v(xbgr.mr_n65704864)
print v(xbgr.mr_n65706432)
print v(xbgr.mr_n65706544)
print v(xbgr.mr_n65710240)
print v(xbgr.mr_n65710432)
print v(xbgr.mr_n65710784)
print v(xbgr.mr_n65710896)
print v(xbgr.mr_n65713488)
print v(xbgr.mr_n65714880)
print v(xbgr.mr_n65715152)
print v(xbgr.mr_n65715344)
print v(xbgr.mr_n65715696)
print v(xbgr.mr_n65715808)
print v(xbgr.mr_n65717440)
print v(xbgr.mr_n65717552)
print v(xbgr.mr_n65721184)
print v(xbgr.mr_n65721376)
print v(xbgr.mr_n65721728)
print v(xbgr.mr_n65721840)
print v(xbgr.mr_n65724432)
print v(xbgr.mr_n65725824)
print v(xbgr.mr_n65726096)
print v(xbgr.mr_n65726288)
print v(xbgr.mr_n65726640)
print v(xbgr.mr_n65726752)
print v(xbgr.mr_n65728320)
print v(xbgr.mr_n65728432)
print v(xbgr.mr_n65732128)
print v(xbgr.mr_n65732320)
print v(xbgr.mr_n65732672)
print v(xbgr.mr_n65732784)
print v(xbgr.mr_n65735376)
print v(xbgr.mr_n65735568)
print v(xbgr.mr_n65737104)
print v(xbgr.mr_n65737296)
print v(xbgr.mr_n65737648)
print v(xbgr.mr_n65737760)
print v(xbgr.mr_n65739264)
print v(xbgr.mr_n65739376)
print v(xbgr.mr_n65742592)
print v(xbgr.mr_n65742704)
print v(xbgr.mr_n65743216)
print v(xbgr.mr_n65743328)
print v(xbgr.mr_n65743840)
print v(xbgr.mr_n65743952)
print v(xbgr.mr_n65744720)
print v(xbgr.mr_n65744832)
print v(xbgr.mr_n65745664)
print v(xbgr.mr_n65745776)
print v(xbgr.mr_n65746608)
print v(xbgr.mr_n65746720)
print v(xbgr.mr_n65747552)
print v(xbgr.mr_n65747664)
print v(xbgr.mr_n65748624)
print v(xbgr.mr_n65748736)
print v(xbgr.mr_n65749888)
print v(xbgr.mr_n65750000)
print v(xbgr.mr_n65751152)
print v(xbgr.mr_n65751264)
print v(xbgr.mr_n65752416)
print v(xbgr.mr_n65752528)
print v(xbgr.mr_n65753680)
print v(xbgr.mr_n65753792)
print v(xbgr.mr_n65754944)
print v(xbgr.mr_n65755056)
print v(xbgr.mr_n65756208)
print v(xbgr.mr_n65756320)
print v(xbgr.mr_n65757472)
print v(xbgr.mr_n65757584)
print v(xbgr.mr_n65758592)
print v(xbgr.mr_n65761792)
print v(xbgr.mr_n65762816)
print v(xbgr.mr_n65766400)
print v(xbgr.mr_n65769440)
print v(xbgr.mr_n65771536)
print v(xbgr.mr_n65772336)
print v(xbgr.mr_n65773424)
print v(xbgr.mr_n65777664)
print v(xbgr.mr_n65778208)
print v(xbgr.mr_n65778320)
print v(xbgr.mr_n65779168)
print v(xbgr.mr_n65784768)
print v(xbgr.mr_n65785024)
print v(xbgr.mr_n65790512)
print v(xbgr.mr_n65790624)
print v(xbgr.mr_n65793280)
print v(xbgr.mr_n65793392)
print v(xbgr.mr_n65794544)
print v(xbgr.mr_n65794656)
print v(xbgr.mr_n65795808)
print v(xbgr.mr_n65795920)
print v(xbgr.mr_n65797072)
print v(xbgr.mr_n65797184)
print v(xbgr.mr_n65798336)
print v(xbgr.mr_n65798448)
print v(xbgr.mr_n65799536)
print v(xbgr.mr_n65799648)
print v(xbgr.mr_n65800864)
print v(xbgr.mr_n65800976)
print v(xbgr.mr_n65802128)
print v(xbgr.mr_n65802240)
print v(xbgr.mr_n65803392)
print v(xbgr.mr_n65803504)
print v(xbgr.mr_n65804656)
print v(xbgr.mr_n65804768)
print v(xbgr.mr_n65805920)
print v(xbgr.mr_n65806032)
print v(xbgr.mr_n65807120)
print v(xbgr.mr_n65807232)
print v(xbgr.mr_n65808448)
print v(xbgr.mr_n65808560)
print v(xbgr.mr_n65809712)
print v(xbgr.mr_n65809824)
print v(xbgr.mr_n65810976)
print v(xbgr.mr_n65811088)
print v(xbgr.mr_n65812240)
print v(xbgr.mr_n65812352)
print v(xbgr.mr_n65820336)
print v(xbgr.mr_n65821024)
print v(xbgr.mr_n65821712)
print v(xbgr.mr_n65822432)
print v(xbgr.mr_n65823376)
print v(xbgr.mr_n65824320)
print v(xbgr.mr_n65825264)
print v(xbgr.mr_n65826208)
print v(xbgr.mr_n65827152)
print v(xbgr.mr_n65828096)
print v(xbgr.mr_n65829040)
print v(xbgr.mr_n65829984)
print v(xbgr.mr_n65830928)
print v(xbgr.mr_n65831872)
print v(xbgr.mr_n65832816)
print v(xbgr.mr_n65833760)
print v(xbgr.mr_n65834704)
print v(xbgr.mr_n65835648)
print v(xbgr.mr_n65836592)
print v(xbgr.mr_n65837536)
print v(xbgr.mr_n65838480)
print v(xbgr.mr_n65839424)
print v(xbgr.mr_n65840368)
print v(xbgr.mr_n65841312)
print v(xbgr.mr_n65842256)
print v(xbgr.mr_n65843200)
print v(xbgr.mr_n65844144)
print v(xbgr.mr_n65845088)
print v(xbgr.mr_n65846032)
print v(xbgr.mr_n65846976)
print v(xbgr.mr_n65847920)
print v(xbgr.mr_n65848864)
print v(xbgr.mr_n65853616)
print v(xbgr.mr_n65862416)
print v(xbgr.mr_n65862592)
print v(xbgr.mr_n65862960)
print v(xbgr.mr_n65863552)
print v(xbgr.mr_n65863904)
print v(xbgr.mr_n65864688)
print v(xbgr.mr_n65865760)
print v(xbgr.mr_n65866784)
print v(xbgr.mr_n65867072)
print v(xbgr.mr_n65870656)
print v(xbgr.mr_n65871184)
print v(xbgr.mr_n65872176)
print v(xbgr.mr_n65873120)
print v(xbgr.mr_n65873584)
print v(xbgr.mr_n65873936)
print v(xbgr.mr_n65874992)
print v(xbgr.mr_n65875520)
print v(xbgr.mr_n65876288)
print v(xbgr.mr_n65877456)
print v(xbgr.mr_n65877984)
print v(xbgr.mr_n65878160)
print v(xbgr.mr_n65879984)
print v(xbgr.mr_n65881920)
print v(xbgr.mr_n65883792)
print v(xbgr.mr_n65884560)
print v(xbgr.mr_n65884736)
print v(xbgr.mr_n65886144)
print v(xbgr.mr_n65887552)
print v(xbgr.mr_n65888608)
print v(xbgr.mr_n65888784)
print v(xbgr.mr_n65889664)
print v(xbgr.mr_n65890624)
print v(xbgr.mr_n65891024)
print v(xbgr.mr_n65891280)
print v(xbgr.mr_n65892432)
print v(xbgr.mr_n65893376)
print v(xbgr.mr_n65894320)
print v(xbgr.mr_n65895264)
print v(xbgr.mr_n65896208)
print v(xbgr.mr_n65897152)
print v(xbgr.mr_n65898096)
print v(xbgr.mr_n65899040)
print v(xbgr.mr_n65899984)
print v(xbgr.mr_n65900928)
print v(xbgr.mr_n65901872)
print v(xbgr.mr_n65902816)
print v(xbgr.mr_n65903760)
print v(xbgr.mr_n65904704)
print v(xbgr.mr_n65905648)
print v(xbgr.mr_n65906592)
print v(xbgr.mr_n65907536)
print v(xbgr.mr_n65908480)
print v(xbgr.mr_n65909424)
print v(xbgr.mr_n65910368)
print v(xbgr.mr_n65911312)
print v(xbgr.mr_n65912256)
print v(xbgr.mr_n65913200)
print v(xbgr.mr_n65914144)
print v(xbgr.mr_n65915088)
print v(xbgr.mr_n65916032)
print v(xbgr.mr_n65916976)
print v(xbgr.mr_n65918368)
print v(xbgr.mr_n65919472)
print v(xbgr.mr_n65920896)
print v(xbgr.mr_n65921840)
print v(xbgr.mr_n65922784)
print v(xbgr.mr_n65923728)
print v(xbgr.mr_n65924672)
print v(xbgr.mr_n65925616)
print v(xbgr.mr_n65926560)
print v(xbgr.mr_n65927504)
print v(xbgr.mr_n65928448)
print v(xbgr.mr_n65929392)
print v(xbgr.mr_n65930336)
print v(xbgr.mr_n65931280)
print v(xbgr.mr_n65932224)
print v(xbgr.mr_n65933168)
print v(xbgr.mr_n65934112)
print v(xbgr.mr_n65935056)
print v(xbgr.mr_n65936000)
print v(xbgr.mr_n65936944)
print v(xbgr.mr_n65937888)
print v(xbgr.mr_n65938832)
print v(xbgr.mr_n65939776)
print v(xbgr.mr_n65940720)
print v(xbgr.mr_n65941664)
print v(xbgr.mr_n65942608)
print v(xbgr.mr_n65943552)
print v(xbgr.mr_n65944496)
print v(xbgr.mr_n65945440)
print v(xbgr.mr_n65946384)
print v(xbgr.mr_n65947328)
print v(xbgr.mr_n65948272)
print v(xbgr.mr_n65949216)
print v(xbgr.mr_n65950160)
print v(xbgr.mr_n65951104)
print v(xbgr.mr_n65952048)
print v(xbgr.mr_n65952992)
print v(xbgr.mr_n65953936)
print v(xbgr.mr_n65954880)
print v(xbgr.mr_n65955824)
print v(xbgr.mr_n65956768)
print v(xbgr.mr_n65957712)
print v(xbgr.mr_n65958656)
print v(xbgr.mr_n65959600)
print v(xbgr.mr_n65960544)
print v(xbgr.mr_n65961488)
print v(xbgr.mr_n65962432)
print v(xbgr.mr_n65963376)
print v(xbgr.mr_n65964320)
print v(xbgr.mr_n65965264)
print v(xbgr.mr_n65966208)
print v(xbgr.mr_n65967152)
print v(xbgr.mr_n65968096)
print v(xbgr.mr_n65969040)
print v(xbgr.mr_n65969984)
print v(xbgr.mr_n65970928)
print v(xbgr.mr_n65971872)
print v(xbgr.mr_n65972816)
print v(xbgr.mr_n65973760)
print v(xbgr.mr_n65974704)
print v(xbgr.mr_n65975648)
print v(xbgr.mr_n65976592)
print v(xbgr.mr_n65977536)
print v(xbgr.mr_n65978480)
print v(xbgr.mr_n65979424)
print v(xbgr.mr_n65980368)
print v(xbgr.mr_n65981312)
print v(xbgr.mr_n65982608)
print v(xbgr.mr_n65983696)
print v(xbgr.mr_n65984272)
print v(xbgr.mr_n65984384)
print v(xbgr.mr_n65984496)
print v(xbgr.mr_n65985328)
print v(xbgr.mr_n65985520)
print v(xbgr.mr_n65985712)
print v(xbgr.mr_n65986544)
print v(xbgr.mr_n65986816)
print v(xbgr.mr_n65987008)
print v(xbgr.mr_n65987360)
print v(xbgr.mr_n65987472)
print v(xbgr.mr_n65991472)
print v(xbgr.mr_n65992224)
print v(xbgr.mr_n65992496)
print v(xbgr.mr_n65992688)
print v(xbgr.mr_n65993040)
print v(xbgr.mr_n65993152)
print v(xbgr.mr_n65996144)
print v(xbgr.mr_n65996256)
print v(xbgr.mr_n65996368)
print v(xbgr.mr_n65997760)
print v(xbgr.mr_n65998032)
print v(xbgr.mr_n65998224)
print v(xbgr.mr_n65998576)
print v(xbgr.mr_n65998688)
print v(xbgr.mr_n66000256)
print v(xbgr.mr_n66000368)
print v(xbgr.mr_n66003824)
print v(xbgr.mr_n66004016)
print v(xbgr.mr_n66004208)
print v(xbgr.mr_n66004400)
print v(xbgr.mr_n66006192)
print v(xbgr.mr_n66006304)
print v(xbgr.mr_n66009616)
print v(xbgr.mr_n66009728)
print v(xbgr.mr_n66009840)
print v(xbgr.mr_n66011232)
print v(xbgr.mr_n66011424)
print v(xbgr.mr_n66011616)
print v(xbgr.mr_n66012048)
print v(xbgr.mr_n66012160)
print v(xbgr.mr_n66015792)
print v(xbgr.mr_n66015984)
print v(xbgr.mr_n66016176)
print v(xbgr.mr_n66016368)
print v(xbgr.mr_n66016560)
print v(xbgr.mr_n66016752)
print v(xbgr.mr_n66018544)
print v(xbgr.mr_n66018656)
print v(xbgr.mr_n66019968)
print v(xbgr.mr_n66020080)
print v(xbgr.mr_n66023312)
print v(xbgr.mr_n66024704)
print v(xbgr.mr_n66024896)
print v(xbgr.mr_n66025088)
print v(xbgr.mr_n66025520)
print v(xbgr.mr_n66025632)
print v(xbgr.mr_n66029264)
print v(xbgr.mr_n66029376)
print v(xbgr.mr_n66029488)
print v(xbgr.mr_n66030880)
print v(xbgr.mr_n66031152)
print v(xbgr.mr_n66031344)
print v(xbgr.mr_n66031696)
print v(xbgr.mr_n66031808)
print v(xbgr.mr_n66035440)
print v(xbgr.mr_n66035552)
print v(xbgr.mr_n66035664)
print v(xbgr.mr_n66037056)
print v(xbgr.mr_n66037328)
print v(xbgr.mr_n66037520)
print v(xbgr.mr_n66037872)
print v(xbgr.mr_n66037984)
print v(xbgr.mr_n66039552)
print v(xbgr.mr_n66039664)
print v(xbgr.mr_n66042960)
print v(xbgr.mr_n66044352)
print v(xbgr.mr_n66044624)
print v(xbgr.mr_n66044816)
print v(xbgr.mr_n66045168)
print v(xbgr.mr_n66045280)
print v(xbgr.mr_n66048912)
print v(xbgr.mr_n66049024)
print v(xbgr.mr_n66049136)
print v(xbgr.mr_n66050528)
print v(xbgr.mr_n66050800)
print v(xbgr.mr_n66050992)
print v(xbgr.mr_n66051344)
print v(xbgr.mr_n66051456)
print v(xbgr.mr_n66053200)
print v(xbgr.mr_n66053392)
print v(xbgr.mr_n66054864)
print v(xbgr.mr_n66055136)
print v(xbgr.mr_n66055328)
print v(xbgr.mr_n66055680)
print v(xbgr.mr_n66055792)
print v(xbgr.mr_n66059424)
print v(xbgr.mr_n66059536)
print v(xbgr.mr_n66060368)
print v(xbgr.mr_n66060480)
print v(xbgr.mr_n66061312)
print v(xbgr.mr_n66061424)
print v(xbgr.mr_n66062256)
print v(xbgr.mr_n66062368)
print v(xbgr.mr_n66063200)
print v(xbgr.mr_n66063312)
print v(xbgr.mr_n66064400)
print v(xbgr.mr_n66064512)
print v(xbgr.mr_n66065664)
print v(xbgr.mr_n66065776)
print v(xbgr.mr_n66066928)
print v(xbgr.mr_n66067040)
print v(xbgr.mr_n66068192)
print v(xbgr.mr_n66068304)
print v(xbgr.mr_n66069456)
print v(xbgr.mr_n66069568)
print v(xbgr.mr_n66070720)
print v(xbgr.mr_n66070832)
print v(xbgr.mr_n66071984)
print v(xbgr.mr_n66072096)
print v(xbgr.mr_n66073184)
print v(xbgr.mr_n66073296)
print v(xbgr.mr_n66074512)
print v(xbgr.mr_n66074624)
print v(xbgr.mr_n66075776)
print v(xbgr.mr_n66075888)
print v(xbgr.mr_n66077040)
print v(xbgr.mr_n66077152)
print v(xbgr.mr_n66080544)
print v(xbgr.mr_n66087440)
print v(xbgr.mr_n66100304)
print v(xbgr.mr_n66108496)
print v(xbgr.mr_n66108752)
print v(xbgr.mr_n66109008)
print v(xbgr.mr_n66111392)
print v(xbgr.mr_n66114288)
print v(xbgr.mr_n66115728)
print v(xbgr.mr_n66119584)
print v(xbgr.mr_n66140640)
print v(xbgr.mr_n66140896)
print v(xbgr.mr_n66145936)
print v(xbgr.mr_n66146880)
print v(xbgr.mr_n66147824)
print v(xbgr.mr_n66148768)
print v(xbgr.mr_n66149712)
print v(xbgr.mr_n66150656)
print v(xbgr.mr_n66151600)
print v(xbgr.mr_n66152544)
print v(xbgr.mr_n66153488)
print v(xbgr.mr_n66154432)
print v(xbgr.mr_n66155376)
print v(xbgr.mr_n66156320)
print v(xbgr.mr_n66157264)
print v(xbgr.mr_n66158208)
print v(xbgr.mr_n66159152)
print v(xbgr.mr_n66160096)
print v(xbgr.mr_n66161040)
print v(xbgr.mr_n66161984)
print v(xbgr.mr_n66162928)
print v(xbgr.mr_n66163872)
print v(xbgr.mr_n66164816)
print v(xbgr.mr_n66165760)
print v(xbgr.mr_n66166704)
print v(xbgr.mr_n66167648)
print v(xbgr.mr_n66168592)
print v(xbgr.mr_n66170240)
print v(xbgr.mr_n66174528)
print v(xbgr.mr_n66175472)
print v(xbgr.mr_n66176416)
print v(xbgr.mr_n66181280)
print v(xbgr.mr_n66181840)
print v(xbgr.mr_n66181952)
print v(xbgr.mr_n66182064)
print v(xbgr.mr_n66182176)
print v(xbgr.mr_n66183568)
print v(xbgr.mr_n66183840)
print v(xbgr.mr_n66184032)
print v(xbgr.mr_n66184384)
print v(xbgr.mr_n66184496)
print v(xbgr.mr_n66188240)
print v(xbgr.mr_n66188432)
print v(xbgr.mr_n66189120)
print v(xbgr.mr_n66189616)
print v(xbgr.mr_n66189728)
print v(xbgr.mr_n66189840)
print v(xbgr.mr_n66191232)
print v(xbgr.mr_n66191504)
print v(xbgr.mr_n66191696)
print v(xbgr.mr_n66192048)
print v(xbgr.mr_n66192160)
print v(xbgr.mr_n66196912)
print v(xbgr.mr_n66197184)
print v(xbgr.mr_n66197376)
print v(xbgr.mr_n66197728)
print v(xbgr.mr_n66197840)
print v(xbgr.mr_n66201504)
print v(xbgr.mr_n66201776)
print v(xbgr.mr_n66201968)
print v(xbgr.mr_n66202320)
print v(xbgr.mr_n66202432)
print v(xbgr.mr_n66206096)
print v(xbgr.mr_n66206368)
print v(xbgr.mr_n66206560)
print v(xbgr.mr_n66206912)
print v(xbgr.mr_n66207024)
print v(xbgr.mr_n66210688)
print v(xbgr.mr_n66210960)
print v(xbgr.mr_n66211152)
print v(xbgr.mr_n66211504)
print v(xbgr.mr_n66211616)
print v(xbgr.mr_n66214080)
print v(xbgr.mr_n66214272)
print v(xbgr.mr_n66215616)
print v(xbgr.mr_n66215808)
print v(xbgr.mr_n66216160)
print v(xbgr.mr_n66216272)
print v(xbgr.mr_n66219872)
print v(xbgr.mr_n66220144)
print v(xbgr.mr_n66220336)
print v(xbgr.mr_n66220688)
print v(xbgr.mr_n66220800)
print v(xbgr.mr_n66224464)
print v(xbgr.mr_n66224736)
print v(xbgr.mr_n66224928)
print v(xbgr.mr_n66225280)
print v(xbgr.mr_n66225392)
print v(xbgr.mr_n66229056)
print v(xbgr.mr_n66229328)
print v(xbgr.mr_n66229520)
print v(xbgr.mr_n66229872)
print v(xbgr.mr_n66229984)
print v(xbgr.mr_n66233648)
print v(xbgr.mr_n66233920)
print v(xbgr.mr_n66234112)
print v(xbgr.mr_n66234464)
print v(xbgr.mr_n66234576)
print v(xbgr.mr_n66238240)
print v(xbgr.mr_n66238512)
print v(xbgr.mr_n66238704)
print v(xbgr.mr_n66239056)
print v(xbgr.mr_n66239168)
print v(xbgr.mr_n66242832)
print v(xbgr.mr_n66243104)
print v(xbgr.mr_n66243296)
print v(xbgr.mr_n66243648)
print v(xbgr.mr_n66243760)
print v(xbgr.mr_n66247424)
print v(xbgr.mr_n66247696)
print v(xbgr.mr_n66247888)
print v(xbgr.mr_n66248240)
print v(xbgr.mr_n66248352)
print v(xbgr.mr_n66248752)
print v(xbgr.mr_n66251040)
print v(xbgr.mr_n66253008)
print v(xbgr.mr_n66253936)
print v(xbgr.mr_n66254320)
print v(xbgr.mr_n66254512)
print v(xbgr.mr_n66256400)
print v(xbgr.mr_n66258080)
print v(xbgr.mr_n66258848)
print v(xbgr.mr_n66260464)
print v(xbgr.mr_n66261536)
print v(xbgr.mr_n66262112)
print v(xbgr.mr_n66263488)
print v(xbgr.mr_n66263840)
print v(xbgr.mr_n66268448)
print v(xbgr.mr_n66269024)
print v(xbgr.mr_n66269440)
print v(xbgr.mr_n66270496)
print v(xbgr.mr_n66270912)
print v(xbgr.mr_n66273504)
print v(xbgr.mr_n66273696)
print v(xbgr.mr_n66276672)
print v(xbgr.mr_n66278528)
print v(xbgr.mr_n66280480)
print v(xbgr.mr_n66283984)
print v(xbgr.mr_n66284336)
print v(xbgr.mr_n66285280)
print v(xbgr.mr_n66286416)
print v(xbgr.mr_n66287440)
print v(xbgr.mr_n66287664)
print v(xbgr.mr_n66288176)
print v(xbgr.mr_n66288688)
print v(xbgr.mr_n66290160)
print v(xbgr.mr_n66290272)
print v(xbgr.mr_n66290416)
print v(xbgr.mr_n66291696)
print v(xbgr.mr_n66292208)
print v(xbgr.mr_n66296176)
print v(xbgr.mr_n66296288)
print v(xbgr.mr_n66297200)
print v(xbgr.mr_n66297488)
print v(xbgr.mr_n66297792)
print v(xbgr.mr_n66299696)
print v(xbgr.mr_n66300720)
print v(xbgr.mr_n66303296)
print v(xbgr.mr_n66303728)
print v(xbgr.mr_n66306224)
print v(xbgr.mr_n66306416)
print v(xbgr.mr_n66308800)
print v(xbgr.mr_n66309744)
print v(xbgr.mr_n66310288)
print v(xbgr.mr_n66312016)
print v(xbgr.mr_n66312240)
print v(xbgr.mr_n66313152)
print v(xbgr.mr_n66314480)
print v(xbgr.mr_n66314736)
print v(xbgr.mr_n66315248)
print v(xbgr.mr_n66315840)
print v(xbgr.mr_n66316992)
print v(xbgr.mr_n66317504)
print v(xbgr.mr_n66317616)
print v(xbgr.mr_n66318048)
print v(xbgr.mr_n66318560)
print v(xbgr.mr_n66318672)
print v(xbgr.mr_n66319104)
print v(xbgr.mr_n66319616)
print v(xbgr.mr_n66319728)
print v(xbgr.mr_n66320816)
print v(xbgr.mr_n66321488)
print v(xbgr.mr_n66322688)
print v(xbgr.mr_n66323296)
print v(xbgr.mr_n66323616)
print v(xbgr.mr_n66323872)
print v(xbgr.mr_n66324288)
print v(xbgr.mr_n66326080)
print v(xbgr.mr_n66326416)
print v(xbgr.mr_n66326880)
print v(xbgr.mr_n66329040)
print v(xbgr.mr_n66329328)
print v(xbgr.mr_n66329520)
print v(xbgr.mr_n66331984)
print v(xbgr.mr_n66333744)
print v(xbgr.mr_n66334304)
print v(xbgr.mr_n66334768)
print v(xbgr.mr_n66335760)
print v(xbgr.mr_n66337392)
print v(xbgr.mr_n66337648)
print v(xbgr.mr_n66338640)
print v(xbgr.mr_n66339072)
print v(xbgr.mr_n66339424)
print v(xbgr.mr_n66339744)
print v(xbgr.mr_n66340224)
print v(xbgr.mr_n66340736)
print v(xbgr.mr_n66341280)
print v(xbgr.mr_n66341776)
print v(xbgr.mr_n66342272)
print v(xbgr.mr_n66342480)
print v(xbgr.mr_n66342672)
print v(xbgr.mr_n66343136)
print v(xbgr.mr_n66343328)
print v(xbgr.mr_n66346192)
print v(xbgr.mr_n66346384)
print v(xbgr.mr_n66346576)
print v(xbgr.mr_n66346768)
print v(xbgr.mr_n66347120)
print v(xbgr.mr_n66347232)
print v(xbgr.mr_n66347632)
print v(xbgr.mr_n66347824)
print v(xbgr.mr_n66349040)
print v(xbgr.mr_n66349504)
print v(xbgr.mr_n66349696)
print v(xbgr.mr_n66354048)
print v(xbgr.mr_n66354656)
print v(xbgr.mr_n66355792)
print v(xbgr.mr_n66356192)
print v(xbgr.mr_n66356592)
print v(xbgr.mr_n66357696)
print v(xbgr.mr_n66357968)
print v(xbgr.mr_n66358432)
print v(xbgr.mr_n66360288)
print v(xbgr.mr_n66360672)
print v(xbgr.mr_n66364096)
print v(xbgr.mr_n66365456)
print v(xbgr.mr_n66365968)
print v(xbgr.mr_n66366080)
print v(xbgr.mr_n66366896)
print v(xbgr.mr_n66367584)
print v(xbgr.mr_n66368272)
print v(xbgr.mr_n66368960)
print v(xbgr.mr_n66369648)
print v(xbgr.mr_n66370336)
print v(xbgr.mr_n66371024)
print v(xbgr.mr_n66371712)
print v(xbgr.mr_n66372400)
print v(xbgr.mr_n66373088)
print v(xbgr.mr_n66373776)
print v(xbgr.mr_n66374464)
print v(xbgr.mr_n66375152)
print v(xbgr.mr_n66375840)
print v(xbgr.mr_n66376528)
print v(xbgr.mr_n66377216)
print v(xbgr.mr_n66377904)
print v(xbgr.mr_n66378592)
print v(xbgr.mr_n66379280)
print v(xbgr.mr_n66379968)
print v(xbgr.mr_n66380656)
print v(xbgr.mr_n66381344)
print v(xbgr.mr_n66382032)
print v(xbgr.mr_n66382720)
print v(xbgr.mr_n66383408)
print v(xbgr.mr_n66384096)
print v(xbgr.mr_n66384784)
print v(xbgr.mr_n66385472)
print v(xbgr.mr_n66386160)
print v(xbgr.mr_n66386848)
print v(xbgr.mr_n66387536)
print v(xbgr.mr_n66388224)
print v(xbgr.mr_n66388912)
print v(xbgr.mr_n66389600)
print v(xbgr.mr_n66390288)
print v(xbgr.mr_n66390976)
print v(xbgr.mr_n66392080)
print v(xbgr.mr_n66394832)
print v(xbgr.mr_n66402464)
print v(xbgr.mr_n66402656)
print v(xbgr.mr_n66403600)
print v(xbgr.mr_n66406976)
print v(xbgr.mr_n66411152)
print v(xbgr.mr_n66416848)
print v(xbgr.mr_n66420544)
print v(xbgr.mr_n66420928)
print v(xbgr.mr_n66423248)
print v(xbgr.mr_n66423440)
print v(xbgr.mr_n66423952)
print v(xbgr.mr_n66424064)
print v(xbgr.mr_n66424176)
print v(xbgr.mr_n66424368)
print v(xbgr.mr_n66424560)
print v(xbgr.mr_n66424752)
print v(xbgr.mr_n66424944)
print v(xbgr.mr_n66425136)
print v(xbgr.mr_n66428768)
print v(xbgr.mr_n66440192)
print v(xbgr.mr_n66457552)
print v(xbgr.mr_n66457920)
print v(xbgr.mr_n66458176)
print v(xbgr.mr_n66459248)
print v(xbgr.mr_n66459440)
print v(xbgr.mr_n66460128)
print v(xbgr.mr_n66460512)
print v(xbgr.mr_n66461072)
print v(xbgr.mr_n66461328)
print v(xbgr.mr_n66462016)
print v(xbgr.mr_n66462272)
print v(xbgr.mr_n66462960)
print v(xbgr.mr_n66463216)
print v(xbgr.mr_n66463904)
print v(xbgr.mr_n66464288)
print v(xbgr.mr_n66464848)
print v(xbgr.mr_n66464960)
print v(xbgr.mr_n66465792)
print v(xbgr.mr_n66465904)
print v(xbgr.mr_n66466736)
print v(xbgr.mr_n66466992)
print v(xbgr.mr_n66467680)
print v(xbgr.mr_n66476832)
print v(xbgr.mr_n66477280)
print v(xbgr.mr_n66479184)
print v(xbgr.mr_n66484128)
print v(xbgr.mr_n66485184)
print v(xbgr.mr_n66485552)
print v(xbgr.mr_n66486832)
print v(xbgr.mr_n66488112)
print v(xbgr.mr_n66488624)
print v(xbgr.mr_n66488880)
print v(xbgr.mr_n66489136)
print v(xbgr.mr_n66490688)
print v(xbgr.mr_n66492784)
print v(xbgr.mr_n66493392)
print v(xbgr.mr_n66497200)
print v(xbgr.mr_n66497520)
print v(xbgr.mr_n66497824)
print v(xbgr.mr_n66500208)
print v(xbgr.mr_n66500528)
print v(xbgr.mr_n66500944)
print v(xbgr.mr_n66502416)
print v(xbgr.mr_n66503952)
print v(xbgr.mr_n66505168)
print v(xbgr.mr_n66513136)
print v(xbgr.mr_n66513328)
print v(xbgr.mr_n66513440)
print v(xbgr.mr_n66513952)
print v(xbgr.mr_n66514064)
print v(xbgr.mr_n66514576)
print v(xbgr.mr_n66514688)
print v(xbgr.mr_n66515024)
print v(xbgr.mr_n66515424)
print v(xbgr.mr_n66515616)
print v(xbgr.mr_n66518000)
print v(xbgr.mr_n66518272)
print v(xbgr.mr_n66518608)
print v(xbgr.mr_n66519008)
print v(xbgr.mr_n66519408)
print v(xbgr.mr_n66520224)
print v(xbgr.mr_n66522544)
print v(xbgr.mr_n66523056)
print v(xbgr.mr_n66523168)
print v(xbgr.mr_n66523680)
print v(xbgr.mr_n66523792)
print v(xbgr.mr_n66524304)
print v(xbgr.mr_n66524416)
print v(xbgr.mr_n66524928)
print v(xbgr.mr_n66525040)
print v(xbgr.mr_n66525552)
print v(xbgr.mr_n66525664)
print v(xbgr.mr_n66526176)
print v(xbgr.mr_n66526288)
print v(xbgr.mr_n66526800)
print v(xbgr.mr_n66526912)
print v(xbgr.mr_n66529840)
print v(xbgr.mr_n66540272)
print v(xbgr.mr_n66540960)
print v(xbgr.mr_n66541648)
print v(xbgr.mr_n66542336)
print v(xbgr.mr_n66543024)
print v(xbgr.mr_n66543712)
print v(xbgr.mr_n66544400)
print v(xbgr.mr_n66545088)
print v(xbgr.mr_n66547056)
print v(xbgr.mr_n66548128)
print v(xbgr.mr_n66549072)
print v(xbgr.mr_n66550016)
print v(xbgr.mr_n66550960)
print v(xbgr.mr_n66551904)
print v(xbgr.mr_n66552848)
print v(xbgr.mr_n66553792)
print v(xbgr.mr_n66554736)
print v(xbgr.mr_n66555072)
print v(xbgr.mr_n66555680)
print v(xbgr.mr_n66562992)
print v(xbgr.mr_n66563376)
print v(xbgr.mr_n66563760)
print v(xbgr.mr_n66564992)
print v(xbgr.mr_n66565680)
print v(xbgr.mr_n66566064)
print v(xbgr.mr_n66566832)
print v(xbgr.mr_n66567216)
print v(xbgr.mr_n66568368)
print v(xbgr.mr_n66569136)
print v(xbgr.mr_n66569520)
print v(xbgr.mr_n66571056)
print v(xbgr.mr_n66571440)
print v(xbgr.mr_n66571824)
print v(xbgr.mr_n66573056)
print v(xbgr.mr_n66573360)
print v(xbgr.mr_n66573744)
print v(xbgr.mr_n66574128)
print v(xbgr.mr_n66577376)
print v(xbgr.mr_n66578832)
print v(xbgr.mr_n66581520)
print v(xbgr.mr_n66589888)
print v(xbgr.mr_n66590112)
print v(xbgr.mr_n66590336)
print v(xbgr.mr_n66590560)
print v(xbgr.mr_n66590784)
print v(xbgr.mr_n66591008)
print v(xbgr.mr_n66592208)
print v(xbgr.mr_n66593184)
print v(xbgr.mr_n66593888)
print v(xbgr.mr_n66600624)
print v(xbgr.mr_n66601824)
print v(xbgr.mr_n66602304)
print v(xbgr.mr_n66602960)
print v(xbgr.mr_n66603696)
print v(xbgr.mr_n66605312)
print v(xbgr.mr_n66608208)
print v(xbgr.mr_n66608976)
print v(xbgr.mr_n66609712)
print v(xbgr.mr_n66612576)
print v(xbgr.mr_n66613088)
print v(xbgr.mr_n66613200)
print v(xbgr.mr_n66613632)
print v(xbgr.mr_n66614144)
print v(xbgr.mr_n66614256)
print v(xbgr.mr_n66614688)
print v(xbgr.mr_n66615200)
print v(xbgr.mr_n66615312)
print v(xbgr.mr_n66615744)
print v(xbgr.mr_n66616896)
print v(xbgr.mr_n66617952)
print v(xbgr.mr_n66619456)
print v(xbgr.mr_n66621184)
print v(xbgr.mr_n66624896)
print v(xbgr.mr_n66625120)
print v(xbgr.mr_n66626176)
print v(xbgr.mr_n66627072)
print v(xbgr.mr_n66631136)
print v(xbgr.mr_n66631392)
print v(xbgr.mr_n66636144)
print v(xbgr.mr_n66638192)
print v(xbgr.mr_n66646464)
print v(xbgr.mr_n66649248)
print v(xbgr.mr_n66656992)
print v(xbgr.mr_n66660000)
print v(xbgr.mr_n66660656)
print v(xbgr.mr_n66662304)
print v(xbgr.mr_n66664528)
print v(xbgr.mr_n66665472)
print v(xbgr.mr_n66665808)
print v(xbgr.mr_n66666272)
print v(xbgr.mr_n66667216)
print v(xbgr.mr_n66667440)
print v(xbgr.mr_n66670640)
print v(xbgr.mr_n66671104)
print v(xbgr.mr_n66671296)
print v(xbgr.mr_n66671760)
print v(xbgr.mr_n66671952)
print v(xbgr.mr_n66672896)
print v(xbgr.mr_n66673088)
print v(xbgr.mr_n66673280)
print v(xbgr.mr_n66674160)
print v(xbgr.mr_n66674496)
print v(xbgr.mr_n66674688)
print v(xbgr.mr_n66675152)
print v(xbgr.mr_n66675344)
print v(xbgr.mr_n66676288)
print v(xbgr.mr_n66676624)
print v(xbgr.mr_n66677088)
print v(xbgr.mr_n66677552)
print v(xbgr.mr_n66678016)
print v(xbgr.mr_n66678480)
print v(xbgr.mr_n66678944)
print v(xbgr.mr_n66679136)
print v(xbgr.mr_n66679600)
print v(xbgr.mr_n66680688)
print v(xbgr.mr_n66681088)
print v(xbgr.mr_n66681552)
print v(xbgr.mr_n66682016)
print v(xbgr.mr_n66682784)
print v(xbgr.mr_n66685792)
print v(xbgr.mr_n66686704)
print v(xbgr.mr_n66689088)
print v(xbgr.mr_n66689424)
print v(xbgr.mr_n66689920)
print v(xbgr.mr_n66690256)
print v(xbgr.mr_n66698608)
print v(xbgr.mr_n66698720)
print v(xbgr.mr_n66699152)
print v(xbgr.mr_n66699664)
print v(xbgr.mr_n66699776)
print v(xbgr.mr_n66700208)
print v(xbgr.mr_n66700720)
print v(xbgr.mr_n66700832)
print v(xbgr.mr_n66701264)
print v(xbgr.mr_n66701776)
print v(xbgr.mr_n66701888)
print v(xbgr.mr_n66702320)
print v(xbgr.mr_n66702832)
print v(xbgr.mr_n66702944)
print v(xbgr.mr_n66703376)
print v(xbgr.mr_n66703888)
print v(xbgr.mr_n66704000)
print v(xbgr.mr_n66704432)
print v(xbgr.mr_n66704944)
print v(xbgr.mr_n66705056)
print v(xbgr.mr_n66705488)
print v(xbgr.mr_n66706000)
print v(xbgr.mr_n66706112)
print v(xbgr.mr_n66706544)
print v(xbgr.mr_n66707056)
print v(xbgr.mr_n66707168)
print v(xbgr.mr_n66707600)
print v(xbgr.mr_n66708688)
print v(xbgr.mr_n66708800)
print v(xbgr.mr_n66709680)
print v(xbgr.mr_n66710368)
print v(xbgr.mr_n66711056)
print v(xbgr.mr_n66711744)
print v(xbgr.mr_n66712432)
print v(xbgr.mr_n66713120)
print v(xbgr.mr_n66713808)
print v(xbgr.mr_n66714496)
print v(xbgr.mr_n66715184)
print v(xbgr.mr_n66715872)
print v(xbgr.mr_n66716560)
print v(xbgr.mr_n66717248)
print v(xbgr.mr_n66717936)
print v(xbgr.mr_n66718624)
print v(xbgr.mr_n66719312)
print v(xbgr.mr_n66720000)
print v(xbgr.mr_n66720688)
print v(xbgr.mr_n66721376)
print v(xbgr.mr_n66722064)
print v(xbgr.mr_n66723008)
print v(xbgr.mr_n66724272)
print v(xbgr.mr_n66725216)
print v(xbgr.mr_n66726160)
print v(xbgr.mr_n66727104)
print v(xbgr.mr_n66728160)
print v(xbgr.mr_n66728272)
print v(xbgr.mr_n66729664)
print v(xbgr.mr_n66729856)
print v(xbgr.mr_n66731664)
print v(xbgr.mr_n66733776)
print v(xbgr.mr_n66733968)
print v(xbgr.mr_n66740352)
print v(xbgr.mr_n66740624)
print v(xbgr.mr_n66740816)
print v(xbgr.mr_n66744432)
print v(xbgr.mr_n66745840)
print v(xbgr.mr_n66745952)
print v(xbgr.mr_n66746352)
print v(xbgr.mr_n66747360)
print v(xbgr.mr_n66747472)
print v(xbgr.mr_n66748880)
print v(xbgr.mr_n66748992)
print v(xbgr.mr_n66750400)
print v(xbgr.mr_n66750512)
print v(xbgr.mr_n66751920)
print v(xbgr.mr_n66752032)
print v(xbgr.mr_n66753440)
print v(xbgr.mr_n66753552)
print v(xbgr.mr_n66754960)
print v(xbgr.mr_n66755072)
print v(xbgr.mr_n66756480)
print v(xbgr.mr_n66756592)
print v(xbgr.mr_n66758112)
print v(xbgr.mr_n66759520)
print v(xbgr.mr_n66759632)
print v(xbgr.mr_n66776256)
print v(xbgr.mr_n66777040)
print v(xbgr.mr_n66777440)
print v(xbgr.mr_n66778304)
print v(xbgr.mr_n66778704)
print v(xbgr.mr_n66778880)
print v(xbgr.mr_n66779072)
print v(xbgr.mr_n67054256)
print v(xbgr.mr_n67054448)
print v(xbgr.mr_n67106640)
print v(xbgr.mr_n67120000)
print v(xbgr.mr_n67163168)
print v(xbgr.mr_n67214944)
print v(xbgr.mr_n67215392)
print v(xbgr.mr_n67233072)
print v(xbgr.mr_n67261088)
print v(xbgr.mr_n67277600)
print v(xbgr.mr_n67278032)
print v(xbgr.mr_n67278144)
print v(xbgr.mr_n67381456)
print v(xbgr.mr_n67400816)
print v(xbgr.mr_n67401280)
print v(xbgr.mr_n67401648)
print v(xbgr.mr_n67435184)
print v(xbgr.mr_n67450400)
print v(xbgr.mr_n67450864)
print v(xbgr.mr_n67451216)
print v(xbgr.mr_n67483936)
print v(xbgr.mr_n67513392)
print v(xbgr.mr_n67514048)
print v(xbgr.mr_n67562160)
print v(xbgr.mr_n67571712)
print v(xbgr.mr_n67571856)
print v(xbgr.mr_n67597328)
print v(xbgr.mr_n67597520)
print v(xbgr.mr_n67597712)
print v(xbgr.mr_n67611424)
print v(xbgr.mr_n67611664)
print v(xbgr.mr_n67611856)
print v(xbgr.mr_n67672752)
print v(xbgr.mr_n67672944)
print v(xbgr.mr_n67673136)
print v(xbgr.mr_n67673520)
print v(xbgr.mr_n67673712)
print v(xbgr.mr_n67673904)
print v(xbgr.mr_n67674096)
print v(xbgr.mr_n67674752)
print v(xbgr.mr_n67702880)
print v(xbgr.mr_n67703168)
print v(xbgr.mr_n67706128)
print v(xbgr.mr_n67708784)
print v(xbgr.mr_n67714848)
print v(xbgr.mr_n67716384)
print v(xbgr.mr_n67723616)
print v(xbgr.mr_n67724448)
print v(xbgr.mr_n67724800)
print v(xbgr.mr_n67725152)
print v(xbgr.mr_n67725984)
print v(xbgr.mr_n67757856)
print v(xbgr.mr_n67760608)
print v(xbgr.mr_n67760928)
print v(xbgr.mr_n67761440)
print v(xbgr.mr_n67762560)
print v(xbgr.mr_n67762704)
print v(xbgr.mr_n67784752)
print v(xbgr.mr_n67837232)
print v(xbgr.mr_n67840464)
print v(xbgr.mr_n67841376)
print v(xbgr.mr_n67851504)
print v(xbgr.mr_n67869936)
print v(xbgr.mr_n67890768)
print v(xbgr.mr_n67895072)
print v(xbgr.mr_n67896544)
print v(xbgr.mr_n67897056)
print v(xbgr.mr_n67897312)
print v(xbgr.mr_n67913024)
print v(xbgr.mr_n67932816)
print v(xbgr.mr_n67933456)
print v(xbgr.n1)
print v(xbgr.n_10)
print v(xbgr.n_11)
print v(xbgr.n_12)
print v(xbgr.n_13)
print v(xbgr.n_14)
print v(xbgr.n_15)
print v(xbgr.n_16)
print v(xbgr.n_17)
print v(xbgr.n_18)
print v(xbgr.n_19)
print v(xbgr.n_2)
print v(xbgr.n_21)
print v(xbgr.n_22)
print v(xbgr.n_23)
print v(xbgr.n_24)
print v(xbgr.n_25)
print v(xbgr.n_26)
print v(xbgr.n_27)
print v(xbgr.n_3)
print v(xbgr.n_30)
print v(xbgr.n_31)
print v(xbgr.n_33)
print v(xbgr.n_34)
print v(xbgr.n_36)
print v(xbgr.n_37)
print v(xbgr.n_4)
print v(xbgr.n_5)
print v(xbgr.n_6)
print v(xbgr.n_7)
print v(xbgr.n_8)
print v(xbgr.n_9)
print v(pbias)
print v(pcasc)
print v(r4)
print v(xbgr.r4n)
print v(xbgr.vb2)
print v(vbe)
print v(xbgr.vbe3)
print v(xbgr.vd1)
print v(xbgr.vd2)
print v(vdd)
print v(vref)
print v(vdd)-v(vdd)
echo METALLIC_ALL_NODE_VOLTAGES_END
quit
.endc
.end
