* G1_BGR standalone capacitance-PEX qualification
.lib /foss/pdks/ihp-sg13g2/libs.tech/ngspice/models/cornerHBT.lib hbt_typ
.lib /foss/pdks/ihp-sg13g2/libs.tech/ngspice/models/cornerMOShv.lib mos_tt
.lib /foss/pdks/ihp-sg13g2/libs.tech/ngspice/models/cornerRES.lib res_typ
.include conditional_metal.spice
.option seed=44001 gmin=1e-15 abstol=1e-14 reltol=1e-5 vntol=1e-7
.global sub!
Vsub sub! 0 0
Vdd vdd 0 3.3
Vr4 r4 0 0
Xbgr vdd 0 r4 vref iptat pbias pcasc vbe dvbe g1_bgr
Vload iptat 0 1
Cload vref 0 1e-12
.control
set num_threads=1
set numdgt=15
set wr_singlescale
set wr_vecnames
op
echo RAW_CURRENT_LEDGER_BEGIN
print @n.xbgr.xr1.nr1[ibody]
print @n.xbgr.xr2.nr1[ibody]
print @n.xbgr.xr3.nr1[ibody]
print @n.xbgr.xr4.nr1[ibody]
print @n.xbgr.xr5.nr1[ibody]
print @n.xbgr.xr6.nr1[ibody]
print @n.xbgr.xr7.nr1[ibody]
print @n.xbgr.xr8.nr1[ibody]
print @n.xbgr.xr9.nr1[ibody]
print @n.xbgr.xr10.nr1[ibody]
print @n.xbgr.xr11.nr1[ibody]
print @n.xbgr.xr12.nr1[ibody]
print @n.xbgr.xr13.nr1[ibody]
print @n.xbgr.xr14.nr1[ibody]
print @n.xbgr.xr15.nr1[ibody]
print @n.xbgr.xr16.nr1[ibody]
print @n.xbgr.xr17.nr1[ibody]
print @n.xbgr.xr18.nr1[ibody]
print @n.xbgr.xr19.nr1[ibody]
print @n.xbgr.xr20.nr1[ibody]
print @n.xbgr.xr21.nr1[ibody]
print @n.xbgr.xr22.nr1[ibody]
print @n.xbgr.xr23.nr1[ibody]
print @n.xbgr.xr24.nr1[ibody]
print @n.xbgr.xr25.nr1[ibody]
print @n.xbgr.xr26.nr1[ibody]
print @n.xbgr.xm27.nsg13_hv_pmos[ide]
print @n.xbgr.xm27.nsg13_hv_pmos[ige]
print @n.xbgr.xm27.nsg13_hv_pmos[ise]
print @n.xbgr.xm27.nsg13_hv_pmos[ibe]
print @n.xbgr.xm27.nsg13_hv_pmos[ctype]
print @n.xbgr.xm28.nsg13_hv_pmos[ide]
print @n.xbgr.xm28.nsg13_hv_pmos[ige]
print @n.xbgr.xm28.nsg13_hv_pmos[ise]
print @n.xbgr.xm28.nsg13_hv_pmos[ibe]
print @n.xbgr.xm28.nsg13_hv_pmos[ctype]
print @n.xbgr.xm29.nsg13_hv_nmos[ide]
print @n.xbgr.xm29.nsg13_hv_nmos[ige]
print @n.xbgr.xm29.nsg13_hv_nmos[ise]
print @n.xbgr.xm29.nsg13_hv_nmos[ibe]
print @n.xbgr.xm29.nsg13_hv_nmos[ctype]
print @n.xbgr.xm30.nsg13_hv_nmos[ide]
print @n.xbgr.xm30.nsg13_hv_nmos[ige]
print @n.xbgr.xm30.nsg13_hv_nmos[ise]
print @n.xbgr.xm30.nsg13_hv_nmos[ibe]
print @n.xbgr.xm30.nsg13_hv_nmos[ctype]
print @n.xbgr.xm31.nsg13_hv_nmos[ide]
print @n.xbgr.xm31.nsg13_hv_nmos[ige]
print @n.xbgr.xm31.nsg13_hv_nmos[ise]
print @n.xbgr.xm31.nsg13_hv_nmos[ibe]
print @n.xbgr.xm31.nsg13_hv_nmos[ctype]
print @n.xbgr.xm32.nsg13_hv_nmos[ide]
print @n.xbgr.xm32.nsg13_hv_nmos[ige]
print @n.xbgr.xm32.nsg13_hv_nmos[ise]
print @n.xbgr.xm32.nsg13_hv_nmos[ibe]
print @n.xbgr.xm32.nsg13_hv_nmos[ctype]
print @n.xbgr.xm33.nsg13_hv_nmos[ide]
print @n.xbgr.xm33.nsg13_hv_nmos[ige]
print @n.xbgr.xm33.nsg13_hv_nmos[ise]
print @n.xbgr.xm33.nsg13_hv_nmos[ibe]
print @n.xbgr.xm33.nsg13_hv_nmos[ctype]
print @n.xbgr.xm34.nsg13_hv_nmos[ide]
print @n.xbgr.xm34.nsg13_hv_nmos[ige]
print @n.xbgr.xm34.nsg13_hv_nmos[ise]
print @n.xbgr.xm34.nsg13_hv_nmos[ibe]
print @n.xbgr.xm34.nsg13_hv_nmos[ctype]
print @n.xbgr.xm35.nsg13_hv_nmos[ide]
print @n.xbgr.xm35.nsg13_hv_nmos[ige]
print @n.xbgr.xm35.nsg13_hv_nmos[ise]
print @n.xbgr.xm35.nsg13_hv_nmos[ibe]
print @n.xbgr.xm35.nsg13_hv_nmos[ctype]
print @n.xbgr.xm36.nsg13_hv_nmos[ide]
print @n.xbgr.xm36.nsg13_hv_nmos[ige]
print @n.xbgr.xm36.nsg13_hv_nmos[ise]
print @n.xbgr.xm36.nsg13_hv_nmos[ibe]
print @n.xbgr.xm36.nsg13_hv_nmos[ctype]
print @n.xbgr.xm37.nsg13_hv_nmos[ide]
print @n.xbgr.xm37.nsg13_hv_nmos[ige]
print @n.xbgr.xm37.nsg13_hv_nmos[ise]
print @n.xbgr.xm37.nsg13_hv_nmos[ibe]
print @n.xbgr.xm37.nsg13_hv_nmos[ctype]
print @n.xbgr.xm38.nsg13_hv_pmos[ide]
print @n.xbgr.xm38.nsg13_hv_pmos[ige]
print @n.xbgr.xm38.nsg13_hv_pmos[ise]
print @n.xbgr.xm38.nsg13_hv_pmos[ibe]
print @n.xbgr.xm38.nsg13_hv_pmos[ctype]
print @n.xbgr.xm39.nsg13_hv_pmos[ide]
print @n.xbgr.xm39.nsg13_hv_pmos[ige]
print @n.xbgr.xm39.nsg13_hv_pmos[ise]
print @n.xbgr.xm39.nsg13_hv_pmos[ibe]
print @n.xbgr.xm39.nsg13_hv_pmos[ctype]
print @n.xbgr.xm40.nsg13_hv_pmos[ide]
print @n.xbgr.xm40.nsg13_hv_pmos[ige]
print @n.xbgr.xm40.nsg13_hv_pmos[ise]
print @n.xbgr.xm40.nsg13_hv_pmos[ibe]
print @n.xbgr.xm40.nsg13_hv_pmos[ctype]
print @n.xbgr.xm41.nsg13_hv_pmos[ide]
print @n.xbgr.xm41.nsg13_hv_pmos[ige]
print @n.xbgr.xm41.nsg13_hv_pmos[ise]
print @n.xbgr.xm41.nsg13_hv_pmos[ibe]
print @n.xbgr.xm41.nsg13_hv_pmos[ctype]
print @n.xbgr.xm42.nsg13_hv_pmos[ide]
print @n.xbgr.xm42.nsg13_hv_pmos[ige]
print @n.xbgr.xm42.nsg13_hv_pmos[ise]
print @n.xbgr.xm42.nsg13_hv_pmos[ibe]
print @n.xbgr.xm42.nsg13_hv_pmos[ctype]
print @n.xbgr.xm43.nsg13_hv_pmos[ide]
print @n.xbgr.xm43.nsg13_hv_pmos[ige]
print @n.xbgr.xm43.nsg13_hv_pmos[ise]
print @n.xbgr.xm43.nsg13_hv_pmos[ibe]
print @n.xbgr.xm43.nsg13_hv_pmos[ctype]
print @n.xbgr.xm44.nsg13_hv_pmos[ide]
print @n.xbgr.xm44.nsg13_hv_pmos[ige]
print @n.xbgr.xm44.nsg13_hv_pmos[ise]
print @n.xbgr.xm44.nsg13_hv_pmos[ibe]
print @n.xbgr.xm44.nsg13_hv_pmos[ctype]
print @n.xbgr.xm45.nsg13_hv_pmos[ide]
print @n.xbgr.xm45.nsg13_hv_pmos[ige]
print @n.xbgr.xm45.nsg13_hv_pmos[ise]
print @n.xbgr.xm45.nsg13_hv_pmos[ibe]
print @n.xbgr.xm45.nsg13_hv_pmos[ctype]
print @n.xbgr.xm46.nsg13_hv_pmos[ide]
print @n.xbgr.xm46.nsg13_hv_pmos[ige]
print @n.xbgr.xm46.nsg13_hv_pmos[ise]
print @n.xbgr.xm46.nsg13_hv_pmos[ibe]
print @n.xbgr.xm46.nsg13_hv_pmos[ctype]
print @n.xbgr.xm47.nsg13_hv_pmos[ide]
print @n.xbgr.xm47.nsg13_hv_pmos[ige]
print @n.xbgr.xm47.nsg13_hv_pmos[ise]
print @n.xbgr.xm47.nsg13_hv_pmos[ibe]
print @n.xbgr.xm47.nsg13_hv_pmos[ctype]
print @n.xbgr.xm48.nsg13_hv_pmos[ide]
print @n.xbgr.xm48.nsg13_hv_pmos[ige]
print @n.xbgr.xm48.nsg13_hv_pmos[ise]
print @n.xbgr.xm48.nsg13_hv_pmos[ibe]
print @n.xbgr.xm48.nsg13_hv_pmos[ctype]
print @n.xbgr.xm49.nsg13_hv_pmos[ide]
print @n.xbgr.xm49.nsg13_hv_pmos[ige]
print @n.xbgr.xm49.nsg13_hv_pmos[ise]
print @n.xbgr.xm49.nsg13_hv_pmos[ibe]
print @n.xbgr.xm49.nsg13_hv_pmos[ctype]
print @n.xbgr.xm50.nsg13_hv_pmos[ide]
print @n.xbgr.xm50.nsg13_hv_pmos[ige]
print @n.xbgr.xm50.nsg13_hv_pmos[ise]
print @n.xbgr.xm50.nsg13_hv_pmos[ibe]
print @n.xbgr.xm50.nsg13_hv_pmos[ctype]
print @n.xbgr.xm51.nsg13_hv_pmos[ide]
print @n.xbgr.xm51.nsg13_hv_pmos[ige]
print @n.xbgr.xm51.nsg13_hv_pmos[ise]
print @n.xbgr.xm51.nsg13_hv_pmos[ibe]
print @n.xbgr.xm51.nsg13_hv_pmos[ctype]
print @n.xbgr.xm52.nsg13_hv_pmos[ide]
print @n.xbgr.xm52.nsg13_hv_pmos[ige]
print @n.xbgr.xm52.nsg13_hv_pmos[ise]
print @n.xbgr.xm52.nsg13_hv_pmos[ibe]
print @n.xbgr.xm52.nsg13_hv_pmos[ctype]
print @n.xbgr.xm53.nsg13_hv_pmos[ide]
print @n.xbgr.xm53.nsg13_hv_pmos[ige]
print @n.xbgr.xm53.nsg13_hv_pmos[ise]
print @n.xbgr.xm53.nsg13_hv_pmos[ibe]
print @n.xbgr.xm53.nsg13_hv_pmos[ctype]
print @n.xbgr.xm54.nsg13_hv_pmos[ide]
print @n.xbgr.xm54.nsg13_hv_pmos[ige]
print @n.xbgr.xm54.nsg13_hv_pmos[ise]
print @n.xbgr.xm54.nsg13_hv_pmos[ibe]
print @n.xbgr.xm54.nsg13_hv_pmos[ctype]
print @q.xbgr.xq55.qnpn13g2[ic]
print @q.xbgr.xq55.qnpn13g2[ib]
print @q.xbgr.xq55.qnpn13g2[ie]
print @q.xbgr.xq55.qnpn13g2[is]
print @r.xbgr.xq55.rsub[i]
print @c.xbgr.xq55.csub[i]
print @q.xbgr.xq56.qnpn13g2[ic]
print @q.xbgr.xq56.qnpn13g2[ib]
print @q.xbgr.xq56.qnpn13g2[ie]
print @q.xbgr.xq56.qnpn13g2[is]
print @r.xbgr.xq56.rsub[i]
print @c.xbgr.xq56.csub[i]
print @q.xbgr.xq57.qnpn13g2[ic]
print @q.xbgr.xq57.qnpn13g2[ib]
print @q.xbgr.xq57.qnpn13g2[ie]
print @q.xbgr.xq57.qnpn13g2[is]
print @r.xbgr.xq57.rsub[i]
print @c.xbgr.xq57.csub[i]
print @q.xbgr.xq58.qnpn13g2[ic]
print @q.xbgr.xq58.qnpn13g2[ib]
print @q.xbgr.xq58.qnpn13g2[ie]
print @q.xbgr.xq58.qnpn13g2[is]
print @r.xbgr.xq58.rsub[i]
print @c.xbgr.xq58.csub[i]
print @q.xbgr.xq59.qnpn13g2[ic]
print @q.xbgr.xq59.qnpn13g2[ib]
print @q.xbgr.xq59.qnpn13g2[ie]
print @q.xbgr.xq59.qnpn13g2[is]
print @r.xbgr.xq59.rsub[i]
print @c.xbgr.xq59.csub[i]
print @q.xbgr.xq60.qnpn13g2[ic]
print @q.xbgr.xq60.qnpn13g2[ib]
print @q.xbgr.xq60.qnpn13g2[ie]
print @q.xbgr.xq60.qnpn13g2[is]
print @r.xbgr.xq60.rsub[i]
print @c.xbgr.xq60.csub[i]
print @q.xbgr.xq61.qnpn13g2[ic]
print @q.xbgr.xq61.qnpn13g2[ib]
print @q.xbgr.xq61.qnpn13g2[ie]
print @q.xbgr.xq61.qnpn13g2[is]
print @r.xbgr.xq61.rsub[i]
print @c.xbgr.xq61.csub[i]
print @q.xbgr.xq62.qnpn13g2[ic]
print @q.xbgr.xq62.qnpn13g2[ib]
print @q.xbgr.xq62.qnpn13g2[ie]
print @q.xbgr.xq62.qnpn13g2[is]
print @r.xbgr.xq62.rsub[i]
print @c.xbgr.xq62.csub[i]
print @q.xbgr.xq63.qnpn13g2[ic]
print @q.xbgr.xq63.qnpn13g2[ib]
print @q.xbgr.xq63.qnpn13g2[ie]
print @q.xbgr.xq63.qnpn13g2[is]
print @r.xbgr.xq63.rsub[i]
print @c.xbgr.xq63.csub[i]
print @q.xbgr.xq64.qnpn13g2[ic]
print @q.xbgr.xq64.qnpn13g2[ib]
print @q.xbgr.xq64.qnpn13g2[ie]
print @q.xbgr.xq64.qnpn13g2[is]
print @r.xbgr.xq64.rsub[i]
print @c.xbgr.xq64.csub[i]
print @q.xbgr.xq65.qnpn13g2[ic]
print @q.xbgr.xq65.qnpn13g2[ib]
print @q.xbgr.xq65.qnpn13g2[ie]
print @q.xbgr.xq65.qnpn13g2[is]
print @r.xbgr.xq65.rsub[i]
print @c.xbgr.xq65.csub[i]
print @q.xbgr.xq66.qnpn13g2[ic]
print @q.xbgr.xq66.qnpn13g2[ib]
print @q.xbgr.xq66.qnpn13g2[ie]
print @q.xbgr.xq66.qnpn13g2[is]
print @r.xbgr.xq66.rsub[i]
print @c.xbgr.xq66.csub[i]
print @q.xbgr.xq67.qnpn13g2[ic]
print @q.xbgr.xq67.qnpn13g2[ib]
print @q.xbgr.xq67.qnpn13g2[ie]
print @q.xbgr.xq67.qnpn13g2[is]
print @r.xbgr.xq67.rsub[i]
print @c.xbgr.xq67.csub[i]
print @q.xbgr.xq68.qnpn13g2[ic]
print @q.xbgr.xq68.qnpn13g2[ib]
print @q.xbgr.xq68.qnpn13g2[ie]
print @q.xbgr.xq68.qnpn13g2[is]
print @r.xbgr.xq68.rsub[i]
print @c.xbgr.xq68.csub[i]
print @q.xbgr.xq69.qnpn13g2[ic]
print @q.xbgr.xq69.qnpn13g2[ib]
print @q.xbgr.xq69.qnpn13g2[ie]
print @q.xbgr.xq69.qnpn13g2[is]
print @r.xbgr.xq69.rsub[i]
print @c.xbgr.xq69.csub[i]
print @q.xbgr.xq70.qnpn13g2[ic]
print @q.xbgr.xq70.qnpn13g2[ib]
print @q.xbgr.xq70.qnpn13g2[ie]
print @q.xbgr.xq70.qnpn13g2[is]
print @r.xbgr.xq70.rsub[i]
print @c.xbgr.xq70.csub[i]
print @q.xbgr.xq71.qnpn13g2[ic]
print @q.xbgr.xq71.qnpn13g2[ib]
print @q.xbgr.xq71.qnpn13g2[ie]
print @q.xbgr.xq71.qnpn13g2[is]
print @r.xbgr.xq71.rsub[i]
print @c.xbgr.xq71.csub[i]
print @q.xbgr.xq72.qnpn13g2[ic]
print @q.xbgr.xq72.qnpn13g2[ib]
print @q.xbgr.xq72.qnpn13g2[ie]
print @q.xbgr.xq72.qnpn13g2[is]
print @r.xbgr.xq72.rsub[i]
print @c.xbgr.xq72.csub[i]
print @q.xbgr.xq73.qnpn13g2[ic]
print @q.xbgr.xq73.qnpn13g2[ib]
print @q.xbgr.xq73.qnpn13g2[ie]
print @q.xbgr.xq73.qnpn13g2[is]
print @r.xbgr.xq73.rsub[i]
print @c.xbgr.xq73.csub[i]
print @q.xbgr.xq74.qnpn13g2[ic]
print @q.xbgr.xq74.qnpn13g2[ib]
print @q.xbgr.xq74.qnpn13g2[ie]
print @q.xbgr.xq74.qnpn13g2[is]
print @r.xbgr.xq74.rsub[i]
print @c.xbgr.xq74.csub[i]
print @q.xbgr.xq75.qnpn13g2[ic]
print @q.xbgr.xq75.qnpn13g2[ib]
print @q.xbgr.xq75.qnpn13g2[ie]
print @q.xbgr.xq75.qnpn13g2[is]
print @r.xbgr.xq75.rsub[i]
print @c.xbgr.xq75.csub[i]
print @q.xbgr.xq76.qnpn13g2[ic]
print @q.xbgr.xq76.qnpn13g2[ib]
print @q.xbgr.xq76.qnpn13g2[ie]
print @q.xbgr.xq76.qnpn13g2[is]
print @r.xbgr.xq76.rsub[i]
print @c.xbgr.xq76.csub[i]
print @n.xbgr.xr77.nr1[ibody]
print @n.xbgr.xr78.nr1[ibody]
print @n.xbgr.xr79.nr1[ibody]
print @n.xbgr.xr80.nr1[ibody]
print @n.xbgr.xr81.nr1[ibody]
print @n.xbgr.xr82.nr1[ibody]
print @n.xbgr.xr83.nr1[ibody]
print @n.xbgr.xr84.nr1[ibody]
print @n.xbgr.xr85.nr1[ibody]
print @n.xbgr.xr86.nr1[ibody]
print @n.xbgr.xr16_u2.nr1[ibody]
print @n.xbgr.xr16_u3.nr1[ibody]
print @n.xbgr.xr16_u4.nr1[ibody]
print @n.xbgr.xr16_u5.nr1[ibody]
print @n.xbgr.xr16_u6.nr1[ibody]
print @n.xbgr.xr16_u7.nr1[ibody]
print @n.xbgr.xr16_u8.nr1[ibody]
print @n.xbgr.xr16_u9.nr1[ibody]
print @n.xbgr.xr16_u10.nr1[ibody]
print @n.xbgr.xr16_u11.nr1[ibody]
print @n.xbgr.xr16_u12.nr1[ibody]
print @n.xbgr.xr16_u13.nr1[ibody]
print @n.xbgr.xr16_u14.nr1[ibody]
print @n.xbgr.xr16_u15.nr1[ibody]
print @n.xbgr.xr16_u16.nr1[ibody]
print @n.xbgr.xr16_u17.nr1[ibody]
print @n.xbgr.xr16_u18.nr1[ibody]
print @n.xbgr.xr16_u19.nr1[ibody]
print @n.xbgr.xr16_u20.nr1[ibody]
print @n.xbgr.xr16_u21.nr1[ibody]
print @n.xbgr.xr16_u22.nr1[ibody]
print @n.xbgr.xr16_u23.nr1[ibody]
print @n.xbgr.xr16_u24.nr1[ibody]
print @n.xbgr.xr17_u2.nr1[ibody]
print @n.xbgr.xr17_u3.nr1[ibody]
print @n.xbgr.xr17_u4.nr1[ibody]
print @n.xbgr.xr18_u2.nr1[ibody]
print @n.xbgr.xr18_u3.nr1[ibody]
print @n.xbgr.xr18_u4.nr1[ibody]
print @n.xbgr.xr19_u2.nr1[ibody]
print @n.xbgr.xr19_u3.nr1[ibody]
print @n.xbgr.xr19_u4.nr1[ibody]
print @n.xbgr.xr20_u2.nr1[ibody]
print @n.xbgr.xr20_u3.nr1[ibody]
print @n.xbgr.xr20_u4.nr1[ibody]
print @n.xbgr.xr21_u2.nr1[ibody]
print @n.xbgr.xr21_u3.nr1[ibody]
print @n.xbgr.xr21_u4.nr1[ibody]
print @n.xbgr.xr22_u2.nr1[ibody]
print @n.xbgr.xr22_u3.nr1[ibody]
print @n.xbgr.xr22_u4.nr1[ibody]
print @n.xbgr.xr23_u2.nr1[ibody]
print @n.xbgr.xr23_u3.nr1[ibody]
print @n.xbgr.xr23_u4.nr1[ibody]
print @n.xbgr.xr23_u5.nr1[ibody]
print @n.xbgr.xr23_u6.nr1[ibody]
print @n.xbgr.xr23_u7.nr1[ibody]
print @n.xbgr.xr23_u8.nr1[ibody]
print @n.xbgr.xr23_u9.nr1[ibody]
print @n.xbgr.xr23_u10.nr1[ibody]
print @n.xbgr.xr23_u11.nr1[ibody]
print @n.xbgr.xr23_u12.nr1[ibody]
print @n.xbgr.xr23_u13.nr1[ibody]
print @n.xbgr.xr23_u14.nr1[ibody]
print @n.xbgr.xr23_u15.nr1[ibody]
print @n.xbgr.xr23_u16.nr1[ibody]
print @n.xbgr.xr23_u17.nr1[ibody]
print @n.xbgr.xr23_u18.nr1[ibody]
print @n.xbgr.xr23_u19.nr1[ibody]
print @n.xbgr.xr23_u20.nr1[ibody]
print @n.xbgr.xr23_u21.nr1[ibody]
print @n.xbgr.xr23_u22.nr1[ibody]
print @n.xbgr.xr23_u23.nr1[ibody]
print @n.xbgr.xr23_u24.nr1[ibody]
print @n.xbgr.xr24_u2.nr1[ibody]
print @n.xbgr.xr24_u3.nr1[ibody]
print @n.xbgr.xr24_u4.nr1[ibody]
print @n.xbgr.xr24_u5.nr1[ibody]
print @n.xbgr.xr24_u6.nr1[ibody]
print @n.xbgr.xr24_u7.nr1[ibody]
print @n.xbgr.xr24_u8.nr1[ibody]
print @n.xbgr.xr24_u9.nr1[ibody]
print @n.xbgr.xr24_u10.nr1[ibody]
print @n.xbgr.xr24_u11.nr1[ibody]
print @n.xbgr.xr24_u12.nr1[ibody]
print @n.xbgr.xr24_u13.nr1[ibody]
print @n.xbgr.xr24_u14.nr1[ibody]
print @n.xbgr.xr24_u15.nr1[ibody]
print @n.xbgr.xr24_u16.nr1[ibody]
print @n.xbgr.xr24_u17.nr1[ibody]
print @n.xbgr.xr24_u18.nr1[ibody]
print @n.xbgr.xr24_u19.nr1[ibody]
print @n.xbgr.xr24_u20.nr1[ibody]
print @n.xbgr.xr24_u21.nr1[ibody]
print @n.xbgr.xr24_u22.nr1[ibody]
print @n.xbgr.xr24_u23.nr1[ibody]
print @n.xbgr.xr24_u24.nr1[ibody]
print @n.xbgr.xr25_u2.nr1[ibody]
print @n.xbgr.xr25_u3.nr1[ibody]
print @n.xbgr.xr25_u4.nr1[ibody]
print @n.xbgr.xr25_u5.nr1[ibody]
print @n.xbgr.xr25_u6.nr1[ibody]
print @n.xbgr.xr25_u7.nr1[ibody]
print @n.xbgr.xr25_u8.nr1[ibody]
print @n.xbgr.xr25_u9.nr1[ibody]
print @n.xbgr.xr25_u10.nr1[ibody]
print @n.xbgr.xr25_u11.nr1[ibody]
print @n.xbgr.xr25_u12.nr1[ibody]
print @n.xbgr.xr25_u13.nr1[ibody]
print @n.xbgr.xr25_u14.nr1[ibody]
print @n.xbgr.xr25_u15.nr1[ibody]
print @n.xbgr.xr25_u16.nr1[ibody]
print @n.xbgr.xr25_u17.nr1[ibody]
print @n.xbgr.xr25_u18.nr1[ibody]
print @n.xbgr.xr25_u19.nr1[ibody]
print @n.xbgr.xr25_u20.nr1[ibody]
print @n.xbgr.xr25_u21.nr1[ibody]
print @n.xbgr.xr25_u22.nr1[ibody]
print @n.xbgr.xr25_u23.nr1[ibody]
print @n.xbgr.xr25_u24.nr1[ibody]
print @n.xbgr.xr26_u2.nr1[ibody]
print @n.xbgr.xr26_u3.nr1[ibody]
print @n.xbgr.xr26_u4.nr1[ibody]
print @n.xbgr.xr26_u5.nr1[ibody]
print @n.xbgr.xr26_u6.nr1[ibody]
print @n.xbgr.xr26_u7.nr1[ibody]
print @n.xbgr.xr26_u8.nr1[ibody]
print @n.xbgr.xr26_u9.nr1[ibody]
print @n.xbgr.xr26_u10.nr1[ibody]
print @n.xbgr.xr26_u11.nr1[ibody]
print @n.xbgr.xr26_u12.nr1[ibody]
print @n.xbgr.xr26_u13.nr1[ibody]
print @n.xbgr.xr26_u14.nr1[ibody]
print @n.xbgr.xr26_u15.nr1[ibody]
print @n.xbgr.xr26_u16.nr1[ibody]
print @n.xbgr.xr26_u17.nr1[ibody]
print @n.xbgr.xr26_u18.nr1[ibody]
print @n.xbgr.xr26_u19.nr1[ibody]
print @n.xbgr.xr26_u20.nr1[ibody]
print @n.xbgr.xr26_u21.nr1[ibody]
print @n.xbgr.xr26_u22.nr1[ibody]
print @n.xbgr.xr26_u23.nr1[ibody]
print @n.xbgr.xr26_u24.nr1[ibody]
print @n.xbgr.xm34_u2.nsg13_hv_nmos[ide]
print @n.xbgr.xm34_u2.nsg13_hv_nmos[ige]
print @n.xbgr.xm34_u2.nsg13_hv_nmos[ise]
print @n.xbgr.xm34_u2.nsg13_hv_nmos[ibe]
print @n.xbgr.xm34_u2.nsg13_hv_nmos[ctype]
print @n.xbgr.xm34_u3.nsg13_hv_nmos[ide]
print @n.xbgr.xm34_u3.nsg13_hv_nmos[ige]
print @n.xbgr.xm34_u3.nsg13_hv_nmos[ise]
print @n.xbgr.xm34_u3.nsg13_hv_nmos[ibe]
print @n.xbgr.xm34_u3.nsg13_hv_nmos[ctype]
print @n.xbgr.xm34_u4.nsg13_hv_nmos[ide]
print @n.xbgr.xm34_u4.nsg13_hv_nmos[ige]
print @n.xbgr.xm34_u4.nsg13_hv_nmos[ise]
print @n.xbgr.xm34_u4.nsg13_hv_nmos[ibe]
print @n.xbgr.xm34_u4.nsg13_hv_nmos[ctype]
print @n.xbgr.xm34_u5.nsg13_hv_nmos[ide]
print @n.xbgr.xm34_u5.nsg13_hv_nmos[ige]
print @n.xbgr.xm34_u5.nsg13_hv_nmos[ise]
print @n.xbgr.xm34_u5.nsg13_hv_nmos[ibe]
print @n.xbgr.xm34_u5.nsg13_hv_nmos[ctype]
print @n.xbgr.xm34_u6.nsg13_hv_nmos[ide]
print @n.xbgr.xm34_u6.nsg13_hv_nmos[ige]
print @n.xbgr.xm34_u6.nsg13_hv_nmos[ise]
print @n.xbgr.xm34_u6.nsg13_hv_nmos[ibe]
print @n.xbgr.xm34_u6.nsg13_hv_nmos[ctype]
print @n.xbgr.xm34_u7.nsg13_hv_nmos[ide]
print @n.xbgr.xm34_u7.nsg13_hv_nmos[ige]
print @n.xbgr.xm34_u7.nsg13_hv_nmos[ise]
print @n.xbgr.xm34_u7.nsg13_hv_nmos[ibe]
print @n.xbgr.xm34_u7.nsg13_hv_nmos[ctype]
print @n.xbgr.xm34_u8.nsg13_hv_nmos[ide]
print @n.xbgr.xm34_u8.nsg13_hv_nmos[ige]
print @n.xbgr.xm34_u8.nsg13_hv_nmos[ise]
print @n.xbgr.xm34_u8.nsg13_hv_nmos[ibe]
print @n.xbgr.xm34_u8.nsg13_hv_nmos[ctype]
print @n.xbgr.xm34_u9.nsg13_hv_nmos[ide]
print @n.xbgr.xm34_u9.nsg13_hv_nmos[ige]
print @n.xbgr.xm34_u9.nsg13_hv_nmos[ise]
print @n.xbgr.xm34_u9.nsg13_hv_nmos[ibe]
print @n.xbgr.xm34_u9.nsg13_hv_nmos[ctype]
print @n.xbgr.xm34_u10.nsg13_hv_nmos[ide]
print @n.xbgr.xm34_u10.nsg13_hv_nmos[ige]
print @n.xbgr.xm34_u10.nsg13_hv_nmos[ise]
print @n.xbgr.xm34_u10.nsg13_hv_nmos[ibe]
print @n.xbgr.xm34_u10.nsg13_hv_nmos[ctype]
print @n.xbgr.xm34_u11.nsg13_hv_nmos[ide]
print @n.xbgr.xm34_u11.nsg13_hv_nmos[ige]
print @n.xbgr.xm34_u11.nsg13_hv_nmos[ise]
print @n.xbgr.xm34_u11.nsg13_hv_nmos[ibe]
print @n.xbgr.xm34_u11.nsg13_hv_nmos[ctype]
print @n.xbgr.xm34_u12.nsg13_hv_nmos[ide]
print @n.xbgr.xm34_u12.nsg13_hv_nmos[ige]
print @n.xbgr.xm34_u12.nsg13_hv_nmos[ise]
print @n.xbgr.xm34_u12.nsg13_hv_nmos[ibe]
print @n.xbgr.xm34_u12.nsg13_hv_nmos[ctype]
print @n.xbgr.xm34_u13.nsg13_hv_nmos[ide]
print @n.xbgr.xm34_u13.nsg13_hv_nmos[ige]
print @n.xbgr.xm34_u13.nsg13_hv_nmos[ise]
print @n.xbgr.xm34_u13.nsg13_hv_nmos[ibe]
print @n.xbgr.xm34_u13.nsg13_hv_nmos[ctype]
print @n.xbgr.xm34_u14.nsg13_hv_nmos[ide]
print @n.xbgr.xm34_u14.nsg13_hv_nmos[ige]
print @n.xbgr.xm34_u14.nsg13_hv_nmos[ise]
print @n.xbgr.xm34_u14.nsg13_hv_nmos[ibe]
print @n.xbgr.xm34_u14.nsg13_hv_nmos[ctype]
print @n.xbgr.xm34_u15.nsg13_hv_nmos[ide]
print @n.xbgr.xm34_u15.nsg13_hv_nmos[ige]
print @n.xbgr.xm34_u15.nsg13_hv_nmos[ise]
print @n.xbgr.xm34_u15.nsg13_hv_nmos[ibe]
print @n.xbgr.xm34_u15.nsg13_hv_nmos[ctype]
print @n.xbgr.xm34_u16.nsg13_hv_nmos[ide]
print @n.xbgr.xm34_u16.nsg13_hv_nmos[ige]
print @n.xbgr.xm34_u16.nsg13_hv_nmos[ise]
print @n.xbgr.xm34_u16.nsg13_hv_nmos[ibe]
print @n.xbgr.xm34_u16.nsg13_hv_nmos[ctype]
print @n.xbgr.xm34_u17.nsg13_hv_nmos[ide]
print @n.xbgr.xm34_u17.nsg13_hv_nmos[ige]
print @n.xbgr.xm34_u17.nsg13_hv_nmos[ise]
print @n.xbgr.xm34_u17.nsg13_hv_nmos[ibe]
print @n.xbgr.xm34_u17.nsg13_hv_nmos[ctype]
print @n.xbgr.xm34_u18.nsg13_hv_nmos[ide]
print @n.xbgr.xm34_u18.nsg13_hv_nmos[ige]
print @n.xbgr.xm34_u18.nsg13_hv_nmos[ise]
print @n.xbgr.xm34_u18.nsg13_hv_nmos[ibe]
print @n.xbgr.xm34_u18.nsg13_hv_nmos[ctype]
print @n.xbgr.xm34_u19.nsg13_hv_nmos[ide]
print @n.xbgr.xm34_u19.nsg13_hv_nmos[ige]
print @n.xbgr.xm34_u19.nsg13_hv_nmos[ise]
print @n.xbgr.xm34_u19.nsg13_hv_nmos[ibe]
print @n.xbgr.xm34_u19.nsg13_hv_nmos[ctype]
print @n.xbgr.xm34_u20.nsg13_hv_nmos[ide]
print @n.xbgr.xm34_u20.nsg13_hv_nmos[ige]
print @n.xbgr.xm34_u20.nsg13_hv_nmos[ise]
print @n.xbgr.xm34_u20.nsg13_hv_nmos[ibe]
print @n.xbgr.xm34_u20.nsg13_hv_nmos[ctype]
print @n.xbgr.xm34_u21.nsg13_hv_nmos[ide]
print @n.xbgr.xm34_u21.nsg13_hv_nmos[ige]
print @n.xbgr.xm34_u21.nsg13_hv_nmos[ise]
print @n.xbgr.xm34_u21.nsg13_hv_nmos[ibe]
print @n.xbgr.xm34_u21.nsg13_hv_nmos[ctype]
print @n.xbgr.xm34_u22.nsg13_hv_nmos[ide]
print @n.xbgr.xm34_u22.nsg13_hv_nmos[ige]
print @n.xbgr.xm34_u22.nsg13_hv_nmos[ise]
print @n.xbgr.xm34_u22.nsg13_hv_nmos[ibe]
print @n.xbgr.xm34_u22.nsg13_hv_nmos[ctype]
print @n.xbgr.xm34_u23.nsg13_hv_nmos[ide]
print @n.xbgr.xm34_u23.nsg13_hv_nmos[ige]
print @n.xbgr.xm34_u23.nsg13_hv_nmos[ise]
print @n.xbgr.xm34_u23.nsg13_hv_nmos[ibe]
print @n.xbgr.xm34_u23.nsg13_hv_nmos[ctype]
print @n.xbgr.xm34_u24.nsg13_hv_nmos[ide]
print @n.xbgr.xm34_u24.nsg13_hv_nmos[ige]
print @n.xbgr.xm34_u24.nsg13_hv_nmos[ise]
print @n.xbgr.xm34_u24.nsg13_hv_nmos[ibe]
print @n.xbgr.xm34_u24.nsg13_hv_nmos[ctype]
print @n.xbgr.xm35_u2.nsg13_hv_nmos[ide]
print @n.xbgr.xm35_u2.nsg13_hv_nmos[ige]
print @n.xbgr.xm35_u2.nsg13_hv_nmos[ise]
print @n.xbgr.xm35_u2.nsg13_hv_nmos[ibe]
print @n.xbgr.xm35_u2.nsg13_hv_nmos[ctype]
print @n.xbgr.xm35_u3.nsg13_hv_nmos[ide]
print @n.xbgr.xm35_u3.nsg13_hv_nmos[ige]
print @n.xbgr.xm35_u3.nsg13_hv_nmos[ise]
print @n.xbgr.xm35_u3.nsg13_hv_nmos[ibe]
print @n.xbgr.xm35_u3.nsg13_hv_nmos[ctype]
print @n.xbgr.xm35_u4.nsg13_hv_nmos[ide]
print @n.xbgr.xm35_u4.nsg13_hv_nmos[ige]
print @n.xbgr.xm35_u4.nsg13_hv_nmos[ise]
print @n.xbgr.xm35_u4.nsg13_hv_nmos[ibe]
print @n.xbgr.xm35_u4.nsg13_hv_nmos[ctype]
print @n.xbgr.xm35_u5.nsg13_hv_nmos[ide]
print @n.xbgr.xm35_u5.nsg13_hv_nmos[ige]
print @n.xbgr.xm35_u5.nsg13_hv_nmos[ise]
print @n.xbgr.xm35_u5.nsg13_hv_nmos[ibe]
print @n.xbgr.xm35_u5.nsg13_hv_nmos[ctype]
print @n.xbgr.xm35_u6.nsg13_hv_nmos[ide]
print @n.xbgr.xm35_u6.nsg13_hv_nmos[ige]
print @n.xbgr.xm35_u6.nsg13_hv_nmos[ise]
print @n.xbgr.xm35_u6.nsg13_hv_nmos[ibe]
print @n.xbgr.xm35_u6.nsg13_hv_nmos[ctype]
print @n.xbgr.xm35_u7.nsg13_hv_nmos[ide]
print @n.xbgr.xm35_u7.nsg13_hv_nmos[ige]
print @n.xbgr.xm35_u7.nsg13_hv_nmos[ise]
print @n.xbgr.xm35_u7.nsg13_hv_nmos[ibe]
print @n.xbgr.xm35_u7.nsg13_hv_nmos[ctype]
print @n.xbgr.xm35_u8.nsg13_hv_nmos[ide]
print @n.xbgr.xm35_u8.nsg13_hv_nmos[ige]
print @n.xbgr.xm35_u8.nsg13_hv_nmos[ise]
print @n.xbgr.xm35_u8.nsg13_hv_nmos[ibe]
print @n.xbgr.xm35_u8.nsg13_hv_nmos[ctype]
print @n.xbgr.xm35_u9.nsg13_hv_nmos[ide]
print @n.xbgr.xm35_u9.nsg13_hv_nmos[ige]
print @n.xbgr.xm35_u9.nsg13_hv_nmos[ise]
print @n.xbgr.xm35_u9.nsg13_hv_nmos[ibe]
print @n.xbgr.xm35_u9.nsg13_hv_nmos[ctype]
print @n.xbgr.xm35_u10.nsg13_hv_nmos[ide]
print @n.xbgr.xm35_u10.nsg13_hv_nmos[ige]
print @n.xbgr.xm35_u10.nsg13_hv_nmos[ise]
print @n.xbgr.xm35_u10.nsg13_hv_nmos[ibe]
print @n.xbgr.xm35_u10.nsg13_hv_nmos[ctype]
print @n.xbgr.xm35_u11.nsg13_hv_nmos[ide]
print @n.xbgr.xm35_u11.nsg13_hv_nmos[ige]
print @n.xbgr.xm35_u11.nsg13_hv_nmos[ise]
print @n.xbgr.xm35_u11.nsg13_hv_nmos[ibe]
print @n.xbgr.xm35_u11.nsg13_hv_nmos[ctype]
print @n.xbgr.xm35_u12.nsg13_hv_nmos[ide]
print @n.xbgr.xm35_u12.nsg13_hv_nmos[ige]
print @n.xbgr.xm35_u12.nsg13_hv_nmos[ise]
print @n.xbgr.xm35_u12.nsg13_hv_nmos[ibe]
print @n.xbgr.xm35_u12.nsg13_hv_nmos[ctype]
print @n.xbgr.xm35_u13.nsg13_hv_nmos[ide]
print @n.xbgr.xm35_u13.nsg13_hv_nmos[ige]
print @n.xbgr.xm35_u13.nsg13_hv_nmos[ise]
print @n.xbgr.xm35_u13.nsg13_hv_nmos[ibe]
print @n.xbgr.xm35_u13.nsg13_hv_nmos[ctype]
print @n.xbgr.xm35_u14.nsg13_hv_nmos[ide]
print @n.xbgr.xm35_u14.nsg13_hv_nmos[ige]
print @n.xbgr.xm35_u14.nsg13_hv_nmos[ise]
print @n.xbgr.xm35_u14.nsg13_hv_nmos[ibe]
print @n.xbgr.xm35_u14.nsg13_hv_nmos[ctype]
print @n.xbgr.xm35_u15.nsg13_hv_nmos[ide]
print @n.xbgr.xm35_u15.nsg13_hv_nmos[ige]
print @n.xbgr.xm35_u15.nsg13_hv_nmos[ise]
print @n.xbgr.xm35_u15.nsg13_hv_nmos[ibe]
print @n.xbgr.xm35_u15.nsg13_hv_nmos[ctype]
print @n.xbgr.xm35_u16.nsg13_hv_nmos[ide]
print @n.xbgr.xm35_u16.nsg13_hv_nmos[ige]
print @n.xbgr.xm35_u16.nsg13_hv_nmos[ise]
print @n.xbgr.xm35_u16.nsg13_hv_nmos[ibe]
print @n.xbgr.xm35_u16.nsg13_hv_nmos[ctype]
print @n.xbgr.xm35_u17.nsg13_hv_nmos[ide]
print @n.xbgr.xm35_u17.nsg13_hv_nmos[ige]
print @n.xbgr.xm35_u17.nsg13_hv_nmos[ise]
print @n.xbgr.xm35_u17.nsg13_hv_nmos[ibe]
print @n.xbgr.xm35_u17.nsg13_hv_nmos[ctype]
print @n.xbgr.xm35_u18.nsg13_hv_nmos[ide]
print @n.xbgr.xm35_u18.nsg13_hv_nmos[ige]
print @n.xbgr.xm35_u18.nsg13_hv_nmos[ise]
print @n.xbgr.xm35_u18.nsg13_hv_nmos[ibe]
print @n.xbgr.xm35_u18.nsg13_hv_nmos[ctype]
print @n.xbgr.xm35_u19.nsg13_hv_nmos[ide]
print @n.xbgr.xm35_u19.nsg13_hv_nmos[ige]
print @n.xbgr.xm35_u19.nsg13_hv_nmos[ise]
print @n.xbgr.xm35_u19.nsg13_hv_nmos[ibe]
print @n.xbgr.xm35_u19.nsg13_hv_nmos[ctype]
print @n.xbgr.xm35_u20.nsg13_hv_nmos[ide]
print @n.xbgr.xm35_u20.nsg13_hv_nmos[ige]
print @n.xbgr.xm35_u20.nsg13_hv_nmos[ise]
print @n.xbgr.xm35_u20.nsg13_hv_nmos[ibe]
print @n.xbgr.xm35_u20.nsg13_hv_nmos[ctype]
print @n.xbgr.xm35_u21.nsg13_hv_nmos[ide]
print @n.xbgr.xm35_u21.nsg13_hv_nmos[ige]
print @n.xbgr.xm35_u21.nsg13_hv_nmos[ise]
print @n.xbgr.xm35_u21.nsg13_hv_nmos[ibe]
print @n.xbgr.xm35_u21.nsg13_hv_nmos[ctype]
print @n.xbgr.xm35_u22.nsg13_hv_nmos[ide]
print @n.xbgr.xm35_u22.nsg13_hv_nmos[ige]
print @n.xbgr.xm35_u22.nsg13_hv_nmos[ise]
print @n.xbgr.xm35_u22.nsg13_hv_nmos[ibe]
print @n.xbgr.xm35_u22.nsg13_hv_nmos[ctype]
print @n.xbgr.xm35_u23.nsg13_hv_nmos[ide]
print @n.xbgr.xm35_u23.nsg13_hv_nmos[ige]
print @n.xbgr.xm35_u23.nsg13_hv_nmos[ise]
print @n.xbgr.xm35_u23.nsg13_hv_nmos[ibe]
print @n.xbgr.xm35_u23.nsg13_hv_nmos[ctype]
print @n.xbgr.xm35_u24.nsg13_hv_nmos[ide]
print @n.xbgr.xm35_u24.nsg13_hv_nmos[ige]
print @n.xbgr.xm35_u24.nsg13_hv_nmos[ise]
print @n.xbgr.xm35_u24.nsg13_hv_nmos[ibe]
print @n.xbgr.xm35_u24.nsg13_hv_nmos[ctype]
print @n.xbgr.xm36_u2.nsg13_hv_nmos[ide]
print @n.xbgr.xm36_u2.nsg13_hv_nmos[ige]
print @n.xbgr.xm36_u2.nsg13_hv_nmos[ise]
print @n.xbgr.xm36_u2.nsg13_hv_nmos[ibe]
print @n.xbgr.xm36_u2.nsg13_hv_nmos[ctype]
print @n.xbgr.xm36_u3.nsg13_hv_nmos[ide]
print @n.xbgr.xm36_u3.nsg13_hv_nmos[ige]
print @n.xbgr.xm36_u3.nsg13_hv_nmos[ise]
print @n.xbgr.xm36_u3.nsg13_hv_nmos[ibe]
print @n.xbgr.xm36_u3.nsg13_hv_nmos[ctype]
print @n.xbgr.xm36_u4.nsg13_hv_nmos[ide]
print @n.xbgr.xm36_u4.nsg13_hv_nmos[ige]
print @n.xbgr.xm36_u4.nsg13_hv_nmos[ise]
print @n.xbgr.xm36_u4.nsg13_hv_nmos[ibe]
print @n.xbgr.xm36_u4.nsg13_hv_nmos[ctype]
print @n.xbgr.xm36_u5.nsg13_hv_nmos[ide]
print @n.xbgr.xm36_u5.nsg13_hv_nmos[ige]
print @n.xbgr.xm36_u5.nsg13_hv_nmos[ise]
print @n.xbgr.xm36_u5.nsg13_hv_nmos[ibe]
print @n.xbgr.xm36_u5.nsg13_hv_nmos[ctype]
print @n.xbgr.xm36_u6.nsg13_hv_nmos[ide]
print @n.xbgr.xm36_u6.nsg13_hv_nmos[ige]
print @n.xbgr.xm36_u6.nsg13_hv_nmos[ise]
print @n.xbgr.xm36_u6.nsg13_hv_nmos[ibe]
print @n.xbgr.xm36_u6.nsg13_hv_nmos[ctype]
print @n.xbgr.xm36_u7.nsg13_hv_nmos[ide]
print @n.xbgr.xm36_u7.nsg13_hv_nmos[ige]
print @n.xbgr.xm36_u7.nsg13_hv_nmos[ise]
print @n.xbgr.xm36_u7.nsg13_hv_nmos[ibe]
print @n.xbgr.xm36_u7.nsg13_hv_nmos[ctype]
print @n.xbgr.xm36_u8.nsg13_hv_nmos[ide]
print @n.xbgr.xm36_u8.nsg13_hv_nmos[ige]
print @n.xbgr.xm36_u8.nsg13_hv_nmos[ise]
print @n.xbgr.xm36_u8.nsg13_hv_nmos[ibe]
print @n.xbgr.xm36_u8.nsg13_hv_nmos[ctype]
print @n.xbgr.xm36_u9.nsg13_hv_nmos[ide]
print @n.xbgr.xm36_u9.nsg13_hv_nmos[ige]
print @n.xbgr.xm36_u9.nsg13_hv_nmos[ise]
print @n.xbgr.xm36_u9.nsg13_hv_nmos[ibe]
print @n.xbgr.xm36_u9.nsg13_hv_nmos[ctype]
print @n.xbgr.xm36_u10.nsg13_hv_nmos[ide]
print @n.xbgr.xm36_u10.nsg13_hv_nmos[ige]
print @n.xbgr.xm36_u10.nsg13_hv_nmos[ise]
print @n.xbgr.xm36_u10.nsg13_hv_nmos[ibe]
print @n.xbgr.xm36_u10.nsg13_hv_nmos[ctype]
print @n.xbgr.xm36_u11.nsg13_hv_nmos[ide]
print @n.xbgr.xm36_u11.nsg13_hv_nmos[ige]
print @n.xbgr.xm36_u11.nsg13_hv_nmos[ise]
print @n.xbgr.xm36_u11.nsg13_hv_nmos[ibe]
print @n.xbgr.xm36_u11.nsg13_hv_nmos[ctype]
print @n.xbgr.xm36_u12.nsg13_hv_nmos[ide]
print @n.xbgr.xm36_u12.nsg13_hv_nmos[ige]
print @n.xbgr.xm36_u12.nsg13_hv_nmos[ise]
print @n.xbgr.xm36_u12.nsg13_hv_nmos[ibe]
print @n.xbgr.xm36_u12.nsg13_hv_nmos[ctype]
print @n.xbgr.xm36_u13.nsg13_hv_nmos[ide]
print @n.xbgr.xm36_u13.nsg13_hv_nmos[ige]
print @n.xbgr.xm36_u13.nsg13_hv_nmos[ise]
print @n.xbgr.xm36_u13.nsg13_hv_nmos[ibe]
print @n.xbgr.xm36_u13.nsg13_hv_nmos[ctype]
print @n.xbgr.xm36_u14.nsg13_hv_nmos[ide]
print @n.xbgr.xm36_u14.nsg13_hv_nmos[ige]
print @n.xbgr.xm36_u14.nsg13_hv_nmos[ise]
print @n.xbgr.xm36_u14.nsg13_hv_nmos[ibe]
print @n.xbgr.xm36_u14.nsg13_hv_nmos[ctype]
print @n.xbgr.xm36_u15.nsg13_hv_nmos[ide]
print @n.xbgr.xm36_u15.nsg13_hv_nmos[ige]
print @n.xbgr.xm36_u15.nsg13_hv_nmos[ise]
print @n.xbgr.xm36_u15.nsg13_hv_nmos[ibe]
print @n.xbgr.xm36_u15.nsg13_hv_nmos[ctype]
print @n.xbgr.xm36_u16.nsg13_hv_nmos[ide]
print @n.xbgr.xm36_u16.nsg13_hv_nmos[ige]
print @n.xbgr.xm36_u16.nsg13_hv_nmos[ise]
print @n.xbgr.xm36_u16.nsg13_hv_nmos[ibe]
print @n.xbgr.xm36_u16.nsg13_hv_nmos[ctype]
print @n.xbgr.xm36_u17.nsg13_hv_nmos[ide]
print @n.xbgr.xm36_u17.nsg13_hv_nmos[ige]
print @n.xbgr.xm36_u17.nsg13_hv_nmos[ise]
print @n.xbgr.xm36_u17.nsg13_hv_nmos[ibe]
print @n.xbgr.xm36_u17.nsg13_hv_nmos[ctype]
print @n.xbgr.xm36_u18.nsg13_hv_nmos[ide]
print @n.xbgr.xm36_u18.nsg13_hv_nmos[ige]
print @n.xbgr.xm36_u18.nsg13_hv_nmos[ise]
print @n.xbgr.xm36_u18.nsg13_hv_nmos[ibe]
print @n.xbgr.xm36_u18.nsg13_hv_nmos[ctype]
print @n.xbgr.xm36_u19.nsg13_hv_nmos[ide]
print @n.xbgr.xm36_u19.nsg13_hv_nmos[ige]
print @n.xbgr.xm36_u19.nsg13_hv_nmos[ise]
print @n.xbgr.xm36_u19.nsg13_hv_nmos[ibe]
print @n.xbgr.xm36_u19.nsg13_hv_nmos[ctype]
print @n.xbgr.xm36_u20.nsg13_hv_nmos[ide]
print @n.xbgr.xm36_u20.nsg13_hv_nmos[ige]
print @n.xbgr.xm36_u20.nsg13_hv_nmos[ise]
print @n.xbgr.xm36_u20.nsg13_hv_nmos[ibe]
print @n.xbgr.xm36_u20.nsg13_hv_nmos[ctype]
print @n.xbgr.xm36_u21.nsg13_hv_nmos[ide]
print @n.xbgr.xm36_u21.nsg13_hv_nmos[ige]
print @n.xbgr.xm36_u21.nsg13_hv_nmos[ise]
print @n.xbgr.xm36_u21.nsg13_hv_nmos[ibe]
print @n.xbgr.xm36_u21.nsg13_hv_nmos[ctype]
print @n.xbgr.xm36_u22.nsg13_hv_nmos[ide]
print @n.xbgr.xm36_u22.nsg13_hv_nmos[ige]
print @n.xbgr.xm36_u22.nsg13_hv_nmos[ise]
print @n.xbgr.xm36_u22.nsg13_hv_nmos[ibe]
print @n.xbgr.xm36_u22.nsg13_hv_nmos[ctype]
print @n.xbgr.xm36_u23.nsg13_hv_nmos[ide]
print @n.xbgr.xm36_u23.nsg13_hv_nmos[ige]
print @n.xbgr.xm36_u23.nsg13_hv_nmos[ise]
print @n.xbgr.xm36_u23.nsg13_hv_nmos[ibe]
print @n.xbgr.xm36_u23.nsg13_hv_nmos[ctype]
print @n.xbgr.xm36_u24.nsg13_hv_nmos[ide]
print @n.xbgr.xm36_u24.nsg13_hv_nmos[ige]
print @n.xbgr.xm36_u24.nsg13_hv_nmos[ise]
print @n.xbgr.xm36_u24.nsg13_hv_nmos[ibe]
print @n.xbgr.xm36_u24.nsg13_hv_nmos[ctype]
print @n.xbgr.xm37_u2.nsg13_hv_nmos[ide]
print @n.xbgr.xm37_u2.nsg13_hv_nmos[ige]
print @n.xbgr.xm37_u2.nsg13_hv_nmos[ise]
print @n.xbgr.xm37_u2.nsg13_hv_nmos[ibe]
print @n.xbgr.xm37_u2.nsg13_hv_nmos[ctype]
print @n.xbgr.xm37_u3.nsg13_hv_nmos[ide]
print @n.xbgr.xm37_u3.nsg13_hv_nmos[ige]
print @n.xbgr.xm37_u3.nsg13_hv_nmos[ise]
print @n.xbgr.xm37_u3.nsg13_hv_nmos[ibe]
print @n.xbgr.xm37_u3.nsg13_hv_nmos[ctype]
print @n.xbgr.xm37_u4.nsg13_hv_nmos[ide]
print @n.xbgr.xm37_u4.nsg13_hv_nmos[ige]
print @n.xbgr.xm37_u4.nsg13_hv_nmos[ise]
print @n.xbgr.xm37_u4.nsg13_hv_nmos[ibe]
print @n.xbgr.xm37_u4.nsg13_hv_nmos[ctype]
print @n.xbgr.xm37_u5.nsg13_hv_nmos[ide]
print @n.xbgr.xm37_u5.nsg13_hv_nmos[ige]
print @n.xbgr.xm37_u5.nsg13_hv_nmos[ise]
print @n.xbgr.xm37_u5.nsg13_hv_nmos[ibe]
print @n.xbgr.xm37_u5.nsg13_hv_nmos[ctype]
print @n.xbgr.xm37_u6.nsg13_hv_nmos[ide]
print @n.xbgr.xm37_u6.nsg13_hv_nmos[ige]
print @n.xbgr.xm37_u6.nsg13_hv_nmos[ise]
print @n.xbgr.xm37_u6.nsg13_hv_nmos[ibe]
print @n.xbgr.xm37_u6.nsg13_hv_nmos[ctype]
print @n.xbgr.xm37_u7.nsg13_hv_nmos[ide]
print @n.xbgr.xm37_u7.nsg13_hv_nmos[ige]
print @n.xbgr.xm37_u7.nsg13_hv_nmos[ise]
print @n.xbgr.xm37_u7.nsg13_hv_nmos[ibe]
print @n.xbgr.xm37_u7.nsg13_hv_nmos[ctype]
print @n.xbgr.xm37_u8.nsg13_hv_nmos[ide]
print @n.xbgr.xm37_u8.nsg13_hv_nmos[ige]
print @n.xbgr.xm37_u8.nsg13_hv_nmos[ise]
print @n.xbgr.xm37_u8.nsg13_hv_nmos[ibe]
print @n.xbgr.xm37_u8.nsg13_hv_nmos[ctype]
print @n.xbgr.xm37_u9.nsg13_hv_nmos[ide]
print @n.xbgr.xm37_u9.nsg13_hv_nmos[ige]
print @n.xbgr.xm37_u9.nsg13_hv_nmos[ise]
print @n.xbgr.xm37_u9.nsg13_hv_nmos[ibe]
print @n.xbgr.xm37_u9.nsg13_hv_nmos[ctype]
print @n.xbgr.xm37_u10.nsg13_hv_nmos[ide]
print @n.xbgr.xm37_u10.nsg13_hv_nmos[ige]
print @n.xbgr.xm37_u10.nsg13_hv_nmos[ise]
print @n.xbgr.xm37_u10.nsg13_hv_nmos[ibe]
print @n.xbgr.xm37_u10.nsg13_hv_nmos[ctype]
print @n.xbgr.xm37_u11.nsg13_hv_nmos[ide]
print @n.xbgr.xm37_u11.nsg13_hv_nmos[ige]
print @n.xbgr.xm37_u11.nsg13_hv_nmos[ise]
print @n.xbgr.xm37_u11.nsg13_hv_nmos[ibe]
print @n.xbgr.xm37_u11.nsg13_hv_nmos[ctype]
print @n.xbgr.xm37_u12.nsg13_hv_nmos[ide]
print @n.xbgr.xm37_u12.nsg13_hv_nmos[ige]
print @n.xbgr.xm37_u12.nsg13_hv_nmos[ise]
print @n.xbgr.xm37_u12.nsg13_hv_nmos[ibe]
print @n.xbgr.xm37_u12.nsg13_hv_nmos[ctype]
print @n.xbgr.xm37_u13.nsg13_hv_nmos[ide]
print @n.xbgr.xm37_u13.nsg13_hv_nmos[ige]
print @n.xbgr.xm37_u13.nsg13_hv_nmos[ise]
print @n.xbgr.xm37_u13.nsg13_hv_nmos[ibe]
print @n.xbgr.xm37_u13.nsg13_hv_nmos[ctype]
print @n.xbgr.xm37_u14.nsg13_hv_nmos[ide]
print @n.xbgr.xm37_u14.nsg13_hv_nmos[ige]
print @n.xbgr.xm37_u14.nsg13_hv_nmos[ise]
print @n.xbgr.xm37_u14.nsg13_hv_nmos[ibe]
print @n.xbgr.xm37_u14.nsg13_hv_nmos[ctype]
print @n.xbgr.xm37_u15.nsg13_hv_nmos[ide]
print @n.xbgr.xm37_u15.nsg13_hv_nmos[ige]
print @n.xbgr.xm37_u15.nsg13_hv_nmos[ise]
print @n.xbgr.xm37_u15.nsg13_hv_nmos[ibe]
print @n.xbgr.xm37_u15.nsg13_hv_nmos[ctype]
print @n.xbgr.xm37_u16.nsg13_hv_nmos[ide]
print @n.xbgr.xm37_u16.nsg13_hv_nmos[ige]
print @n.xbgr.xm37_u16.nsg13_hv_nmos[ise]
print @n.xbgr.xm37_u16.nsg13_hv_nmos[ibe]
print @n.xbgr.xm37_u16.nsg13_hv_nmos[ctype]
print @n.xbgr.xm37_u17.nsg13_hv_nmos[ide]
print @n.xbgr.xm37_u17.nsg13_hv_nmos[ige]
print @n.xbgr.xm37_u17.nsg13_hv_nmos[ise]
print @n.xbgr.xm37_u17.nsg13_hv_nmos[ibe]
print @n.xbgr.xm37_u17.nsg13_hv_nmos[ctype]
print @n.xbgr.xm37_u18.nsg13_hv_nmos[ide]
print @n.xbgr.xm37_u18.nsg13_hv_nmos[ige]
print @n.xbgr.xm37_u18.nsg13_hv_nmos[ise]
print @n.xbgr.xm37_u18.nsg13_hv_nmos[ibe]
print @n.xbgr.xm37_u18.nsg13_hv_nmos[ctype]
print @n.xbgr.xm37_u19.nsg13_hv_nmos[ide]
print @n.xbgr.xm37_u19.nsg13_hv_nmos[ige]
print @n.xbgr.xm37_u19.nsg13_hv_nmos[ise]
print @n.xbgr.xm37_u19.nsg13_hv_nmos[ibe]
print @n.xbgr.xm37_u19.nsg13_hv_nmos[ctype]
print @n.xbgr.xm37_u20.nsg13_hv_nmos[ide]
print @n.xbgr.xm37_u20.nsg13_hv_nmos[ige]
print @n.xbgr.xm37_u20.nsg13_hv_nmos[ise]
print @n.xbgr.xm37_u20.nsg13_hv_nmos[ibe]
print @n.xbgr.xm37_u20.nsg13_hv_nmos[ctype]
print @n.xbgr.xm37_u21.nsg13_hv_nmos[ide]
print @n.xbgr.xm37_u21.nsg13_hv_nmos[ige]
print @n.xbgr.xm37_u21.nsg13_hv_nmos[ise]
print @n.xbgr.xm37_u21.nsg13_hv_nmos[ibe]
print @n.xbgr.xm37_u21.nsg13_hv_nmos[ctype]
print @n.xbgr.xm37_u22.nsg13_hv_nmos[ide]
print @n.xbgr.xm37_u22.nsg13_hv_nmos[ige]
print @n.xbgr.xm37_u22.nsg13_hv_nmos[ise]
print @n.xbgr.xm37_u22.nsg13_hv_nmos[ibe]
print @n.xbgr.xm37_u22.nsg13_hv_nmos[ctype]
print @n.xbgr.xm37_u23.nsg13_hv_nmos[ide]
print @n.xbgr.xm37_u23.nsg13_hv_nmos[ige]
print @n.xbgr.xm37_u23.nsg13_hv_nmos[ise]
print @n.xbgr.xm37_u23.nsg13_hv_nmos[ibe]
print @n.xbgr.xm37_u23.nsg13_hv_nmos[ctype]
print @n.xbgr.xm37_u24.nsg13_hv_nmos[ide]
print @n.xbgr.xm37_u24.nsg13_hv_nmos[ige]
print @n.xbgr.xm37_u24.nsg13_hv_nmos[ise]
print @n.xbgr.xm37_u24.nsg13_hv_nmos[ibe]
print @n.xbgr.xm37_u24.nsg13_hv_nmos[ctype]
print @n.xbgr.xm38_u2.nsg13_hv_pmos[ide]
print @n.xbgr.xm38_u2.nsg13_hv_pmos[ige]
print @n.xbgr.xm38_u2.nsg13_hv_pmos[ise]
print @n.xbgr.xm38_u2.nsg13_hv_pmos[ibe]
print @n.xbgr.xm38_u2.nsg13_hv_pmos[ctype]
print @n.xbgr.xm38_u3.nsg13_hv_pmos[ide]
print @n.xbgr.xm38_u3.nsg13_hv_pmos[ige]
print @n.xbgr.xm38_u3.nsg13_hv_pmos[ise]
print @n.xbgr.xm38_u3.nsg13_hv_pmos[ibe]
print @n.xbgr.xm38_u3.nsg13_hv_pmos[ctype]
print @n.xbgr.xm38_u4.nsg13_hv_pmos[ide]
print @n.xbgr.xm38_u4.nsg13_hv_pmos[ige]
print @n.xbgr.xm38_u4.nsg13_hv_pmos[ise]
print @n.xbgr.xm38_u4.nsg13_hv_pmos[ibe]
print @n.xbgr.xm38_u4.nsg13_hv_pmos[ctype]
print @n.xbgr.xm38_u5.nsg13_hv_pmos[ide]
print @n.xbgr.xm38_u5.nsg13_hv_pmos[ige]
print @n.xbgr.xm38_u5.nsg13_hv_pmos[ise]
print @n.xbgr.xm38_u5.nsg13_hv_pmos[ibe]
print @n.xbgr.xm38_u5.nsg13_hv_pmos[ctype]
print @n.xbgr.xm38_u6.nsg13_hv_pmos[ide]
print @n.xbgr.xm38_u6.nsg13_hv_pmos[ige]
print @n.xbgr.xm38_u6.nsg13_hv_pmos[ise]
print @n.xbgr.xm38_u6.nsg13_hv_pmos[ibe]
print @n.xbgr.xm38_u6.nsg13_hv_pmos[ctype]
print @n.xbgr.xm38_u7.nsg13_hv_pmos[ide]
print @n.xbgr.xm38_u7.nsg13_hv_pmos[ige]
print @n.xbgr.xm38_u7.nsg13_hv_pmos[ise]
print @n.xbgr.xm38_u7.nsg13_hv_pmos[ibe]
print @n.xbgr.xm38_u7.nsg13_hv_pmos[ctype]
print @n.xbgr.xm38_u8.nsg13_hv_pmos[ide]
print @n.xbgr.xm38_u8.nsg13_hv_pmos[ige]
print @n.xbgr.xm38_u8.nsg13_hv_pmos[ise]
print @n.xbgr.xm38_u8.nsg13_hv_pmos[ibe]
print @n.xbgr.xm38_u8.nsg13_hv_pmos[ctype]
print @n.xbgr.xm38_u9.nsg13_hv_pmos[ide]
print @n.xbgr.xm38_u9.nsg13_hv_pmos[ige]
print @n.xbgr.xm38_u9.nsg13_hv_pmos[ise]
print @n.xbgr.xm38_u9.nsg13_hv_pmos[ibe]
print @n.xbgr.xm38_u9.nsg13_hv_pmos[ctype]
print @n.xbgr.xm38_u10.nsg13_hv_pmos[ide]
print @n.xbgr.xm38_u10.nsg13_hv_pmos[ige]
print @n.xbgr.xm38_u10.nsg13_hv_pmos[ise]
print @n.xbgr.xm38_u10.nsg13_hv_pmos[ibe]
print @n.xbgr.xm38_u10.nsg13_hv_pmos[ctype]
print @n.xbgr.xm38_u11.nsg13_hv_pmos[ide]
print @n.xbgr.xm38_u11.nsg13_hv_pmos[ige]
print @n.xbgr.xm38_u11.nsg13_hv_pmos[ise]
print @n.xbgr.xm38_u11.nsg13_hv_pmos[ibe]
print @n.xbgr.xm38_u11.nsg13_hv_pmos[ctype]
print @n.xbgr.xm38_u12.nsg13_hv_pmos[ide]
print @n.xbgr.xm38_u12.nsg13_hv_pmos[ige]
print @n.xbgr.xm38_u12.nsg13_hv_pmos[ise]
print @n.xbgr.xm38_u12.nsg13_hv_pmos[ibe]
print @n.xbgr.xm38_u12.nsg13_hv_pmos[ctype]
print @n.xbgr.xm38_u13.nsg13_hv_pmos[ide]
print @n.xbgr.xm38_u13.nsg13_hv_pmos[ige]
print @n.xbgr.xm38_u13.nsg13_hv_pmos[ise]
print @n.xbgr.xm38_u13.nsg13_hv_pmos[ibe]
print @n.xbgr.xm38_u13.nsg13_hv_pmos[ctype]
print @n.xbgr.xm38_u14.nsg13_hv_pmos[ide]
print @n.xbgr.xm38_u14.nsg13_hv_pmos[ige]
print @n.xbgr.xm38_u14.nsg13_hv_pmos[ise]
print @n.xbgr.xm38_u14.nsg13_hv_pmos[ibe]
print @n.xbgr.xm38_u14.nsg13_hv_pmos[ctype]
print @n.xbgr.xm38_u15.nsg13_hv_pmos[ide]
print @n.xbgr.xm38_u15.nsg13_hv_pmos[ige]
print @n.xbgr.xm38_u15.nsg13_hv_pmos[ise]
print @n.xbgr.xm38_u15.nsg13_hv_pmos[ibe]
print @n.xbgr.xm38_u15.nsg13_hv_pmos[ctype]
print @n.xbgr.xm38_u16.nsg13_hv_pmos[ide]
print @n.xbgr.xm38_u16.nsg13_hv_pmos[ige]
print @n.xbgr.xm38_u16.nsg13_hv_pmos[ise]
print @n.xbgr.xm38_u16.nsg13_hv_pmos[ibe]
print @n.xbgr.xm38_u16.nsg13_hv_pmos[ctype]
print @n.xbgr.xm38_u17.nsg13_hv_pmos[ide]
print @n.xbgr.xm38_u17.nsg13_hv_pmos[ige]
print @n.xbgr.xm38_u17.nsg13_hv_pmos[ise]
print @n.xbgr.xm38_u17.nsg13_hv_pmos[ibe]
print @n.xbgr.xm38_u17.nsg13_hv_pmos[ctype]
print @n.xbgr.xm38_u18.nsg13_hv_pmos[ide]
print @n.xbgr.xm38_u18.nsg13_hv_pmos[ige]
print @n.xbgr.xm38_u18.nsg13_hv_pmos[ise]
print @n.xbgr.xm38_u18.nsg13_hv_pmos[ibe]
print @n.xbgr.xm38_u18.nsg13_hv_pmos[ctype]
print @n.xbgr.xm38_u19.nsg13_hv_pmos[ide]
print @n.xbgr.xm38_u19.nsg13_hv_pmos[ige]
print @n.xbgr.xm38_u19.nsg13_hv_pmos[ise]
print @n.xbgr.xm38_u19.nsg13_hv_pmos[ibe]
print @n.xbgr.xm38_u19.nsg13_hv_pmos[ctype]
print @n.xbgr.xm38_u20.nsg13_hv_pmos[ide]
print @n.xbgr.xm38_u20.nsg13_hv_pmos[ige]
print @n.xbgr.xm38_u20.nsg13_hv_pmos[ise]
print @n.xbgr.xm38_u20.nsg13_hv_pmos[ibe]
print @n.xbgr.xm38_u20.nsg13_hv_pmos[ctype]
print @n.xbgr.xm38_u21.nsg13_hv_pmos[ide]
print @n.xbgr.xm38_u21.nsg13_hv_pmos[ige]
print @n.xbgr.xm38_u21.nsg13_hv_pmos[ise]
print @n.xbgr.xm38_u21.nsg13_hv_pmos[ibe]
print @n.xbgr.xm38_u21.nsg13_hv_pmos[ctype]
print @n.xbgr.xm38_u22.nsg13_hv_pmos[ide]
print @n.xbgr.xm38_u22.nsg13_hv_pmos[ige]
print @n.xbgr.xm38_u22.nsg13_hv_pmos[ise]
print @n.xbgr.xm38_u22.nsg13_hv_pmos[ibe]
print @n.xbgr.xm38_u22.nsg13_hv_pmos[ctype]
print @n.xbgr.xm38_u23.nsg13_hv_pmos[ide]
print @n.xbgr.xm38_u23.nsg13_hv_pmos[ige]
print @n.xbgr.xm38_u23.nsg13_hv_pmos[ise]
print @n.xbgr.xm38_u23.nsg13_hv_pmos[ibe]
print @n.xbgr.xm38_u23.nsg13_hv_pmos[ctype]
print @n.xbgr.xm38_u24.nsg13_hv_pmos[ide]
print @n.xbgr.xm38_u24.nsg13_hv_pmos[ige]
print @n.xbgr.xm38_u24.nsg13_hv_pmos[ise]
print @n.xbgr.xm38_u24.nsg13_hv_pmos[ibe]
print @n.xbgr.xm38_u24.nsg13_hv_pmos[ctype]
print @n.xbgr.xm39_u2.nsg13_hv_pmos[ide]
print @n.xbgr.xm39_u2.nsg13_hv_pmos[ige]
print @n.xbgr.xm39_u2.nsg13_hv_pmos[ise]
print @n.xbgr.xm39_u2.nsg13_hv_pmos[ibe]
print @n.xbgr.xm39_u2.nsg13_hv_pmos[ctype]
print @n.xbgr.xm39_u3.nsg13_hv_pmos[ide]
print @n.xbgr.xm39_u3.nsg13_hv_pmos[ige]
print @n.xbgr.xm39_u3.nsg13_hv_pmos[ise]
print @n.xbgr.xm39_u3.nsg13_hv_pmos[ibe]
print @n.xbgr.xm39_u3.nsg13_hv_pmos[ctype]
print @n.xbgr.xm39_u4.nsg13_hv_pmos[ide]
print @n.xbgr.xm39_u4.nsg13_hv_pmos[ige]
print @n.xbgr.xm39_u4.nsg13_hv_pmos[ise]
print @n.xbgr.xm39_u4.nsg13_hv_pmos[ibe]
print @n.xbgr.xm39_u4.nsg13_hv_pmos[ctype]
print @n.xbgr.xm39_u5.nsg13_hv_pmos[ide]
print @n.xbgr.xm39_u5.nsg13_hv_pmos[ige]
print @n.xbgr.xm39_u5.nsg13_hv_pmos[ise]
print @n.xbgr.xm39_u5.nsg13_hv_pmos[ibe]
print @n.xbgr.xm39_u5.nsg13_hv_pmos[ctype]
print @n.xbgr.xm39_u6.nsg13_hv_pmos[ide]
print @n.xbgr.xm39_u6.nsg13_hv_pmos[ige]
print @n.xbgr.xm39_u6.nsg13_hv_pmos[ise]
print @n.xbgr.xm39_u6.nsg13_hv_pmos[ibe]
print @n.xbgr.xm39_u6.nsg13_hv_pmos[ctype]
print @n.xbgr.xm39_u7.nsg13_hv_pmos[ide]
print @n.xbgr.xm39_u7.nsg13_hv_pmos[ige]
print @n.xbgr.xm39_u7.nsg13_hv_pmos[ise]
print @n.xbgr.xm39_u7.nsg13_hv_pmos[ibe]
print @n.xbgr.xm39_u7.nsg13_hv_pmos[ctype]
print @n.xbgr.xm39_u8.nsg13_hv_pmos[ide]
print @n.xbgr.xm39_u8.nsg13_hv_pmos[ige]
print @n.xbgr.xm39_u8.nsg13_hv_pmos[ise]
print @n.xbgr.xm39_u8.nsg13_hv_pmos[ibe]
print @n.xbgr.xm39_u8.nsg13_hv_pmos[ctype]
print @n.xbgr.xm39_u9.nsg13_hv_pmos[ide]
print @n.xbgr.xm39_u9.nsg13_hv_pmos[ige]
print @n.xbgr.xm39_u9.nsg13_hv_pmos[ise]
print @n.xbgr.xm39_u9.nsg13_hv_pmos[ibe]
print @n.xbgr.xm39_u9.nsg13_hv_pmos[ctype]
print @n.xbgr.xm39_u10.nsg13_hv_pmos[ide]
print @n.xbgr.xm39_u10.nsg13_hv_pmos[ige]
print @n.xbgr.xm39_u10.nsg13_hv_pmos[ise]
print @n.xbgr.xm39_u10.nsg13_hv_pmos[ibe]
print @n.xbgr.xm39_u10.nsg13_hv_pmos[ctype]
print @n.xbgr.xm39_u11.nsg13_hv_pmos[ide]
print @n.xbgr.xm39_u11.nsg13_hv_pmos[ige]
print @n.xbgr.xm39_u11.nsg13_hv_pmos[ise]
print @n.xbgr.xm39_u11.nsg13_hv_pmos[ibe]
print @n.xbgr.xm39_u11.nsg13_hv_pmos[ctype]
print @n.xbgr.xm39_u12.nsg13_hv_pmos[ide]
print @n.xbgr.xm39_u12.nsg13_hv_pmos[ige]
print @n.xbgr.xm39_u12.nsg13_hv_pmos[ise]
print @n.xbgr.xm39_u12.nsg13_hv_pmos[ibe]
print @n.xbgr.xm39_u12.nsg13_hv_pmos[ctype]
print @n.xbgr.xm39_u13.nsg13_hv_pmos[ide]
print @n.xbgr.xm39_u13.nsg13_hv_pmos[ige]
print @n.xbgr.xm39_u13.nsg13_hv_pmos[ise]
print @n.xbgr.xm39_u13.nsg13_hv_pmos[ibe]
print @n.xbgr.xm39_u13.nsg13_hv_pmos[ctype]
print @n.xbgr.xm39_u14.nsg13_hv_pmos[ide]
print @n.xbgr.xm39_u14.nsg13_hv_pmos[ige]
print @n.xbgr.xm39_u14.nsg13_hv_pmos[ise]
print @n.xbgr.xm39_u14.nsg13_hv_pmos[ibe]
print @n.xbgr.xm39_u14.nsg13_hv_pmos[ctype]
print @n.xbgr.xm39_u15.nsg13_hv_pmos[ide]
print @n.xbgr.xm39_u15.nsg13_hv_pmos[ige]
print @n.xbgr.xm39_u15.nsg13_hv_pmos[ise]
print @n.xbgr.xm39_u15.nsg13_hv_pmos[ibe]
print @n.xbgr.xm39_u15.nsg13_hv_pmos[ctype]
print @n.xbgr.xm39_u16.nsg13_hv_pmos[ide]
print @n.xbgr.xm39_u16.nsg13_hv_pmos[ige]
print @n.xbgr.xm39_u16.nsg13_hv_pmos[ise]
print @n.xbgr.xm39_u16.nsg13_hv_pmos[ibe]
print @n.xbgr.xm39_u16.nsg13_hv_pmos[ctype]
print @n.xbgr.xm39_u17.nsg13_hv_pmos[ide]
print @n.xbgr.xm39_u17.nsg13_hv_pmos[ige]
print @n.xbgr.xm39_u17.nsg13_hv_pmos[ise]
print @n.xbgr.xm39_u17.nsg13_hv_pmos[ibe]
print @n.xbgr.xm39_u17.nsg13_hv_pmos[ctype]
print @n.xbgr.xm39_u18.nsg13_hv_pmos[ide]
print @n.xbgr.xm39_u18.nsg13_hv_pmos[ige]
print @n.xbgr.xm39_u18.nsg13_hv_pmos[ise]
print @n.xbgr.xm39_u18.nsg13_hv_pmos[ibe]
print @n.xbgr.xm39_u18.nsg13_hv_pmos[ctype]
print @n.xbgr.xm39_u19.nsg13_hv_pmos[ide]
print @n.xbgr.xm39_u19.nsg13_hv_pmos[ige]
print @n.xbgr.xm39_u19.nsg13_hv_pmos[ise]
print @n.xbgr.xm39_u19.nsg13_hv_pmos[ibe]
print @n.xbgr.xm39_u19.nsg13_hv_pmos[ctype]
print @n.xbgr.xm39_u20.nsg13_hv_pmos[ide]
print @n.xbgr.xm39_u20.nsg13_hv_pmos[ige]
print @n.xbgr.xm39_u20.nsg13_hv_pmos[ise]
print @n.xbgr.xm39_u20.nsg13_hv_pmos[ibe]
print @n.xbgr.xm39_u20.nsg13_hv_pmos[ctype]
print @n.xbgr.xm39_u21.nsg13_hv_pmos[ide]
print @n.xbgr.xm39_u21.nsg13_hv_pmos[ige]
print @n.xbgr.xm39_u21.nsg13_hv_pmos[ise]
print @n.xbgr.xm39_u21.nsg13_hv_pmos[ibe]
print @n.xbgr.xm39_u21.nsg13_hv_pmos[ctype]
print @n.xbgr.xm39_u22.nsg13_hv_pmos[ide]
print @n.xbgr.xm39_u22.nsg13_hv_pmos[ige]
print @n.xbgr.xm39_u22.nsg13_hv_pmos[ise]
print @n.xbgr.xm39_u22.nsg13_hv_pmos[ibe]
print @n.xbgr.xm39_u22.nsg13_hv_pmos[ctype]
print @n.xbgr.xm39_u23.nsg13_hv_pmos[ide]
print @n.xbgr.xm39_u23.nsg13_hv_pmos[ige]
print @n.xbgr.xm39_u23.nsg13_hv_pmos[ise]
print @n.xbgr.xm39_u23.nsg13_hv_pmos[ibe]
print @n.xbgr.xm39_u23.nsg13_hv_pmos[ctype]
print @n.xbgr.xm39_u24.nsg13_hv_pmos[ide]
print @n.xbgr.xm39_u24.nsg13_hv_pmos[ige]
print @n.xbgr.xm39_u24.nsg13_hv_pmos[ise]
print @n.xbgr.xm39_u24.nsg13_hv_pmos[ibe]
print @n.xbgr.xm39_u24.nsg13_hv_pmos[ctype]
print @n.xbgr.xm41_u2.nsg13_hv_pmos[ide]
print @n.xbgr.xm41_u2.nsg13_hv_pmos[ige]
print @n.xbgr.xm41_u2.nsg13_hv_pmos[ise]
print @n.xbgr.xm41_u2.nsg13_hv_pmos[ibe]
print @n.xbgr.xm41_u2.nsg13_hv_pmos[ctype]
print @n.xbgr.xm41_u3.nsg13_hv_pmos[ide]
print @n.xbgr.xm41_u3.nsg13_hv_pmos[ige]
print @n.xbgr.xm41_u3.nsg13_hv_pmos[ise]
print @n.xbgr.xm41_u3.nsg13_hv_pmos[ibe]
print @n.xbgr.xm41_u3.nsg13_hv_pmos[ctype]
print @n.xbgr.xm41_u4.nsg13_hv_pmos[ide]
print @n.xbgr.xm41_u4.nsg13_hv_pmos[ige]
print @n.xbgr.xm41_u4.nsg13_hv_pmos[ise]
print @n.xbgr.xm41_u4.nsg13_hv_pmos[ibe]
print @n.xbgr.xm41_u4.nsg13_hv_pmos[ctype]
print @n.xbgr.xm41_u5.nsg13_hv_pmos[ide]
print @n.xbgr.xm41_u5.nsg13_hv_pmos[ige]
print @n.xbgr.xm41_u5.nsg13_hv_pmos[ise]
print @n.xbgr.xm41_u5.nsg13_hv_pmos[ibe]
print @n.xbgr.xm41_u5.nsg13_hv_pmos[ctype]
print @n.xbgr.xm41_u6.nsg13_hv_pmos[ide]
print @n.xbgr.xm41_u6.nsg13_hv_pmos[ige]
print @n.xbgr.xm41_u6.nsg13_hv_pmos[ise]
print @n.xbgr.xm41_u6.nsg13_hv_pmos[ibe]
print @n.xbgr.xm41_u6.nsg13_hv_pmos[ctype]
print @n.xbgr.xm41_u7.nsg13_hv_pmos[ide]
print @n.xbgr.xm41_u7.nsg13_hv_pmos[ige]
print @n.xbgr.xm41_u7.nsg13_hv_pmos[ise]
print @n.xbgr.xm41_u7.nsg13_hv_pmos[ibe]
print @n.xbgr.xm41_u7.nsg13_hv_pmos[ctype]
print @n.xbgr.xm41_u8.nsg13_hv_pmos[ide]
print @n.xbgr.xm41_u8.nsg13_hv_pmos[ige]
print @n.xbgr.xm41_u8.nsg13_hv_pmos[ise]
print @n.xbgr.xm41_u8.nsg13_hv_pmos[ibe]
print @n.xbgr.xm41_u8.nsg13_hv_pmos[ctype]
print @n.xbgr.xm41_u9.nsg13_hv_pmos[ide]
print @n.xbgr.xm41_u9.nsg13_hv_pmos[ige]
print @n.xbgr.xm41_u9.nsg13_hv_pmos[ise]
print @n.xbgr.xm41_u9.nsg13_hv_pmos[ibe]
print @n.xbgr.xm41_u9.nsg13_hv_pmos[ctype]
print @n.xbgr.xm41_u10.nsg13_hv_pmos[ide]
print @n.xbgr.xm41_u10.nsg13_hv_pmos[ige]
print @n.xbgr.xm41_u10.nsg13_hv_pmos[ise]
print @n.xbgr.xm41_u10.nsg13_hv_pmos[ibe]
print @n.xbgr.xm41_u10.nsg13_hv_pmos[ctype]
print @n.xbgr.xm41_u11.nsg13_hv_pmos[ide]
print @n.xbgr.xm41_u11.nsg13_hv_pmos[ige]
print @n.xbgr.xm41_u11.nsg13_hv_pmos[ise]
print @n.xbgr.xm41_u11.nsg13_hv_pmos[ibe]
print @n.xbgr.xm41_u11.nsg13_hv_pmos[ctype]
print @n.xbgr.xm41_u12.nsg13_hv_pmos[ide]
print @n.xbgr.xm41_u12.nsg13_hv_pmos[ige]
print @n.xbgr.xm41_u12.nsg13_hv_pmos[ise]
print @n.xbgr.xm41_u12.nsg13_hv_pmos[ibe]
print @n.xbgr.xm41_u12.nsg13_hv_pmos[ctype]
print @n.xbgr.xm41_u13.nsg13_hv_pmos[ide]
print @n.xbgr.xm41_u13.nsg13_hv_pmos[ige]
print @n.xbgr.xm41_u13.nsg13_hv_pmos[ise]
print @n.xbgr.xm41_u13.nsg13_hv_pmos[ibe]
print @n.xbgr.xm41_u13.nsg13_hv_pmos[ctype]
print @n.xbgr.xm41_u14.nsg13_hv_pmos[ide]
print @n.xbgr.xm41_u14.nsg13_hv_pmos[ige]
print @n.xbgr.xm41_u14.nsg13_hv_pmos[ise]
print @n.xbgr.xm41_u14.nsg13_hv_pmos[ibe]
print @n.xbgr.xm41_u14.nsg13_hv_pmos[ctype]
print @n.xbgr.xm41_u15.nsg13_hv_pmos[ide]
print @n.xbgr.xm41_u15.nsg13_hv_pmos[ige]
print @n.xbgr.xm41_u15.nsg13_hv_pmos[ise]
print @n.xbgr.xm41_u15.nsg13_hv_pmos[ibe]
print @n.xbgr.xm41_u15.nsg13_hv_pmos[ctype]
print @n.xbgr.xm41_u16.nsg13_hv_pmos[ide]
print @n.xbgr.xm41_u16.nsg13_hv_pmos[ige]
print @n.xbgr.xm41_u16.nsg13_hv_pmos[ise]
print @n.xbgr.xm41_u16.nsg13_hv_pmos[ibe]
print @n.xbgr.xm41_u16.nsg13_hv_pmos[ctype]
print @n.xbgr.xm41_u17.nsg13_hv_pmos[ide]
print @n.xbgr.xm41_u17.nsg13_hv_pmos[ige]
print @n.xbgr.xm41_u17.nsg13_hv_pmos[ise]
print @n.xbgr.xm41_u17.nsg13_hv_pmos[ibe]
print @n.xbgr.xm41_u17.nsg13_hv_pmos[ctype]
print @n.xbgr.xm41_u18.nsg13_hv_pmos[ide]
print @n.xbgr.xm41_u18.nsg13_hv_pmos[ige]
print @n.xbgr.xm41_u18.nsg13_hv_pmos[ise]
print @n.xbgr.xm41_u18.nsg13_hv_pmos[ibe]
print @n.xbgr.xm41_u18.nsg13_hv_pmos[ctype]
print @n.xbgr.xm41_u19.nsg13_hv_pmos[ide]
print @n.xbgr.xm41_u19.nsg13_hv_pmos[ige]
print @n.xbgr.xm41_u19.nsg13_hv_pmos[ise]
print @n.xbgr.xm41_u19.nsg13_hv_pmos[ibe]
print @n.xbgr.xm41_u19.nsg13_hv_pmos[ctype]
print @n.xbgr.xm41_u20.nsg13_hv_pmos[ide]
print @n.xbgr.xm41_u20.nsg13_hv_pmos[ige]
print @n.xbgr.xm41_u20.nsg13_hv_pmos[ise]
print @n.xbgr.xm41_u20.nsg13_hv_pmos[ibe]
print @n.xbgr.xm41_u20.nsg13_hv_pmos[ctype]
print @n.xbgr.xm41_u21.nsg13_hv_pmos[ide]
print @n.xbgr.xm41_u21.nsg13_hv_pmos[ige]
print @n.xbgr.xm41_u21.nsg13_hv_pmos[ise]
print @n.xbgr.xm41_u21.nsg13_hv_pmos[ibe]
print @n.xbgr.xm41_u21.nsg13_hv_pmos[ctype]
print @n.xbgr.xm41_u22.nsg13_hv_pmos[ide]
print @n.xbgr.xm41_u22.nsg13_hv_pmos[ige]
print @n.xbgr.xm41_u22.nsg13_hv_pmos[ise]
print @n.xbgr.xm41_u22.nsg13_hv_pmos[ibe]
print @n.xbgr.xm41_u22.nsg13_hv_pmos[ctype]
print @n.xbgr.xm41_u23.nsg13_hv_pmos[ide]
print @n.xbgr.xm41_u23.nsg13_hv_pmos[ige]
print @n.xbgr.xm41_u23.nsg13_hv_pmos[ise]
print @n.xbgr.xm41_u23.nsg13_hv_pmos[ibe]
print @n.xbgr.xm41_u23.nsg13_hv_pmos[ctype]
print @n.xbgr.xm41_u24.nsg13_hv_pmos[ide]
print @n.xbgr.xm41_u24.nsg13_hv_pmos[ige]
print @n.xbgr.xm41_u24.nsg13_hv_pmos[ise]
print @n.xbgr.xm41_u24.nsg13_hv_pmos[ibe]
print @n.xbgr.xm41_u24.nsg13_hv_pmos[ctype]
print @n.xbgr.xm43_u2.nsg13_hv_pmos[ide]
print @n.xbgr.xm43_u2.nsg13_hv_pmos[ige]
print @n.xbgr.xm43_u2.nsg13_hv_pmos[ise]
print @n.xbgr.xm43_u2.nsg13_hv_pmos[ibe]
print @n.xbgr.xm43_u2.nsg13_hv_pmos[ctype]
print @n.xbgr.xm43_u3.nsg13_hv_pmos[ide]
print @n.xbgr.xm43_u3.nsg13_hv_pmos[ige]
print @n.xbgr.xm43_u3.nsg13_hv_pmos[ise]
print @n.xbgr.xm43_u3.nsg13_hv_pmos[ibe]
print @n.xbgr.xm43_u3.nsg13_hv_pmos[ctype]
print @n.xbgr.xm43_u4.nsg13_hv_pmos[ide]
print @n.xbgr.xm43_u4.nsg13_hv_pmos[ige]
print @n.xbgr.xm43_u4.nsg13_hv_pmos[ise]
print @n.xbgr.xm43_u4.nsg13_hv_pmos[ibe]
print @n.xbgr.xm43_u4.nsg13_hv_pmos[ctype]
print @n.xbgr.xm44_u2.nsg13_hv_pmos[ide]
print @n.xbgr.xm44_u2.nsg13_hv_pmos[ige]
print @n.xbgr.xm44_u2.nsg13_hv_pmos[ise]
print @n.xbgr.xm44_u2.nsg13_hv_pmos[ibe]
print @n.xbgr.xm44_u2.nsg13_hv_pmos[ctype]
print @n.xbgr.xm44_u3.nsg13_hv_pmos[ide]
print @n.xbgr.xm44_u3.nsg13_hv_pmos[ige]
print @n.xbgr.xm44_u3.nsg13_hv_pmos[ise]
print @n.xbgr.xm44_u3.nsg13_hv_pmos[ibe]
print @n.xbgr.xm44_u3.nsg13_hv_pmos[ctype]
print @n.xbgr.xm44_u4.nsg13_hv_pmos[ide]
print @n.xbgr.xm44_u4.nsg13_hv_pmos[ige]
print @n.xbgr.xm44_u4.nsg13_hv_pmos[ise]
print @n.xbgr.xm44_u4.nsg13_hv_pmos[ibe]
print @n.xbgr.xm44_u4.nsg13_hv_pmos[ctype]
print @n.xbgr.xm45_u2.nsg13_hv_pmos[ide]
print @n.xbgr.xm45_u2.nsg13_hv_pmos[ige]
print @n.xbgr.xm45_u2.nsg13_hv_pmos[ise]
print @n.xbgr.xm45_u2.nsg13_hv_pmos[ibe]
print @n.xbgr.xm45_u2.nsg13_hv_pmos[ctype]
print @n.xbgr.xm45_u3.nsg13_hv_pmos[ide]
print @n.xbgr.xm45_u3.nsg13_hv_pmos[ige]
print @n.xbgr.xm45_u3.nsg13_hv_pmos[ise]
print @n.xbgr.xm45_u3.nsg13_hv_pmos[ibe]
print @n.xbgr.xm45_u3.nsg13_hv_pmos[ctype]
print @n.xbgr.xm45_u4.nsg13_hv_pmos[ide]
print @n.xbgr.xm45_u4.nsg13_hv_pmos[ige]
print @n.xbgr.xm45_u4.nsg13_hv_pmos[ise]
print @n.xbgr.xm45_u4.nsg13_hv_pmos[ibe]
print @n.xbgr.xm45_u4.nsg13_hv_pmos[ctype]
print @n.xbgr.xm45_u5.nsg13_hv_pmos[ide]
print @n.xbgr.xm45_u5.nsg13_hv_pmos[ige]
print @n.xbgr.xm45_u5.nsg13_hv_pmos[ise]
print @n.xbgr.xm45_u5.nsg13_hv_pmos[ibe]
print @n.xbgr.xm45_u5.nsg13_hv_pmos[ctype]
print @n.xbgr.xm45_u6.nsg13_hv_pmos[ide]
print @n.xbgr.xm45_u6.nsg13_hv_pmos[ige]
print @n.xbgr.xm45_u6.nsg13_hv_pmos[ise]
print @n.xbgr.xm45_u6.nsg13_hv_pmos[ibe]
print @n.xbgr.xm45_u6.nsg13_hv_pmos[ctype]
print @n.xbgr.xm45_u7.nsg13_hv_pmos[ide]
print @n.xbgr.xm45_u7.nsg13_hv_pmos[ige]
print @n.xbgr.xm45_u7.nsg13_hv_pmos[ise]
print @n.xbgr.xm45_u7.nsg13_hv_pmos[ibe]
print @n.xbgr.xm45_u7.nsg13_hv_pmos[ctype]
print @n.xbgr.xm45_u8.nsg13_hv_pmos[ide]
print @n.xbgr.xm45_u8.nsg13_hv_pmos[ige]
print @n.xbgr.xm45_u8.nsg13_hv_pmos[ise]
print @n.xbgr.xm45_u8.nsg13_hv_pmos[ibe]
print @n.xbgr.xm45_u8.nsg13_hv_pmos[ctype]
print @n.xbgr.xm45_u9.nsg13_hv_pmos[ide]
print @n.xbgr.xm45_u9.nsg13_hv_pmos[ige]
print @n.xbgr.xm45_u9.nsg13_hv_pmos[ise]
print @n.xbgr.xm45_u9.nsg13_hv_pmos[ibe]
print @n.xbgr.xm45_u9.nsg13_hv_pmos[ctype]
print @n.xbgr.xm45_u10.nsg13_hv_pmos[ide]
print @n.xbgr.xm45_u10.nsg13_hv_pmos[ige]
print @n.xbgr.xm45_u10.nsg13_hv_pmos[ise]
print @n.xbgr.xm45_u10.nsg13_hv_pmos[ibe]
print @n.xbgr.xm45_u10.nsg13_hv_pmos[ctype]
print @n.xbgr.xm45_u11.nsg13_hv_pmos[ide]
print @n.xbgr.xm45_u11.nsg13_hv_pmos[ige]
print @n.xbgr.xm45_u11.nsg13_hv_pmos[ise]
print @n.xbgr.xm45_u11.nsg13_hv_pmos[ibe]
print @n.xbgr.xm45_u11.nsg13_hv_pmos[ctype]
print @n.xbgr.xm45_u12.nsg13_hv_pmos[ide]
print @n.xbgr.xm45_u12.nsg13_hv_pmos[ige]
print @n.xbgr.xm45_u12.nsg13_hv_pmos[ise]
print @n.xbgr.xm45_u12.nsg13_hv_pmos[ibe]
print @n.xbgr.xm45_u12.nsg13_hv_pmos[ctype]
print @n.xbgr.xm45_u13.nsg13_hv_pmos[ide]
print @n.xbgr.xm45_u13.nsg13_hv_pmos[ige]
print @n.xbgr.xm45_u13.nsg13_hv_pmos[ise]
print @n.xbgr.xm45_u13.nsg13_hv_pmos[ibe]
print @n.xbgr.xm45_u13.nsg13_hv_pmos[ctype]
print @n.xbgr.xm45_u14.nsg13_hv_pmos[ide]
print @n.xbgr.xm45_u14.nsg13_hv_pmos[ige]
print @n.xbgr.xm45_u14.nsg13_hv_pmos[ise]
print @n.xbgr.xm45_u14.nsg13_hv_pmos[ibe]
print @n.xbgr.xm45_u14.nsg13_hv_pmos[ctype]
print @n.xbgr.xm45_u15.nsg13_hv_pmos[ide]
print @n.xbgr.xm45_u15.nsg13_hv_pmos[ige]
print @n.xbgr.xm45_u15.nsg13_hv_pmos[ise]
print @n.xbgr.xm45_u15.nsg13_hv_pmos[ibe]
print @n.xbgr.xm45_u15.nsg13_hv_pmos[ctype]
print @n.xbgr.xm45_u16.nsg13_hv_pmos[ide]
print @n.xbgr.xm45_u16.nsg13_hv_pmos[ige]
print @n.xbgr.xm45_u16.nsg13_hv_pmos[ise]
print @n.xbgr.xm45_u16.nsg13_hv_pmos[ibe]
print @n.xbgr.xm45_u16.nsg13_hv_pmos[ctype]
print @n.xbgr.xm45_u17.nsg13_hv_pmos[ide]
print @n.xbgr.xm45_u17.nsg13_hv_pmos[ige]
print @n.xbgr.xm45_u17.nsg13_hv_pmos[ise]
print @n.xbgr.xm45_u17.nsg13_hv_pmos[ibe]
print @n.xbgr.xm45_u17.nsg13_hv_pmos[ctype]
print @n.xbgr.xm45_u18.nsg13_hv_pmos[ide]
print @n.xbgr.xm45_u18.nsg13_hv_pmos[ige]
print @n.xbgr.xm45_u18.nsg13_hv_pmos[ise]
print @n.xbgr.xm45_u18.nsg13_hv_pmos[ibe]
print @n.xbgr.xm45_u18.nsg13_hv_pmos[ctype]
print @n.xbgr.xm45_u19.nsg13_hv_pmos[ide]
print @n.xbgr.xm45_u19.nsg13_hv_pmos[ige]
print @n.xbgr.xm45_u19.nsg13_hv_pmos[ise]
print @n.xbgr.xm45_u19.nsg13_hv_pmos[ibe]
print @n.xbgr.xm45_u19.nsg13_hv_pmos[ctype]
print @n.xbgr.xm45_u20.nsg13_hv_pmos[ide]
print @n.xbgr.xm45_u20.nsg13_hv_pmos[ige]
print @n.xbgr.xm45_u20.nsg13_hv_pmos[ise]
print @n.xbgr.xm45_u20.nsg13_hv_pmos[ibe]
print @n.xbgr.xm45_u20.nsg13_hv_pmos[ctype]
print @n.xbgr.xm45_u21.nsg13_hv_pmos[ide]
print @n.xbgr.xm45_u21.nsg13_hv_pmos[ige]
print @n.xbgr.xm45_u21.nsg13_hv_pmos[ise]
print @n.xbgr.xm45_u21.nsg13_hv_pmos[ibe]
print @n.xbgr.xm45_u21.nsg13_hv_pmos[ctype]
print @n.xbgr.xm45_u22.nsg13_hv_pmos[ide]
print @n.xbgr.xm45_u22.nsg13_hv_pmos[ige]
print @n.xbgr.xm45_u22.nsg13_hv_pmos[ise]
print @n.xbgr.xm45_u22.nsg13_hv_pmos[ibe]
print @n.xbgr.xm45_u22.nsg13_hv_pmos[ctype]
print @n.xbgr.xm45_u23.nsg13_hv_pmos[ide]
print @n.xbgr.xm45_u23.nsg13_hv_pmos[ige]
print @n.xbgr.xm45_u23.nsg13_hv_pmos[ise]
print @n.xbgr.xm45_u23.nsg13_hv_pmos[ibe]
print @n.xbgr.xm45_u23.nsg13_hv_pmos[ctype]
print @n.xbgr.xm45_u24.nsg13_hv_pmos[ide]
print @n.xbgr.xm45_u24.nsg13_hv_pmos[ige]
print @n.xbgr.xm45_u24.nsg13_hv_pmos[ise]
print @n.xbgr.xm45_u24.nsg13_hv_pmos[ibe]
print @n.xbgr.xm45_u24.nsg13_hv_pmos[ctype]
print @n.xbgr.xm47_u2.nsg13_hv_pmos[ide]
print @n.xbgr.xm47_u2.nsg13_hv_pmos[ige]
print @n.xbgr.xm47_u2.nsg13_hv_pmos[ise]
print @n.xbgr.xm47_u2.nsg13_hv_pmos[ibe]
print @n.xbgr.xm47_u2.nsg13_hv_pmos[ctype]
print @n.xbgr.xm47_u3.nsg13_hv_pmos[ide]
print @n.xbgr.xm47_u3.nsg13_hv_pmos[ige]
print @n.xbgr.xm47_u3.nsg13_hv_pmos[ise]
print @n.xbgr.xm47_u3.nsg13_hv_pmos[ibe]
print @n.xbgr.xm47_u3.nsg13_hv_pmos[ctype]
print @n.xbgr.xm47_u4.nsg13_hv_pmos[ide]
print @n.xbgr.xm47_u4.nsg13_hv_pmos[ige]
print @n.xbgr.xm47_u4.nsg13_hv_pmos[ise]
print @n.xbgr.xm47_u4.nsg13_hv_pmos[ibe]
print @n.xbgr.xm47_u4.nsg13_hv_pmos[ctype]
print @n.xbgr.xm47_u5.nsg13_hv_pmos[ide]
print @n.xbgr.xm47_u5.nsg13_hv_pmos[ige]
print @n.xbgr.xm47_u5.nsg13_hv_pmos[ise]
print @n.xbgr.xm47_u5.nsg13_hv_pmos[ibe]
print @n.xbgr.xm47_u5.nsg13_hv_pmos[ctype]
print @n.xbgr.xm47_u6.nsg13_hv_pmos[ide]
print @n.xbgr.xm47_u6.nsg13_hv_pmos[ige]
print @n.xbgr.xm47_u6.nsg13_hv_pmos[ise]
print @n.xbgr.xm47_u6.nsg13_hv_pmos[ibe]
print @n.xbgr.xm47_u6.nsg13_hv_pmos[ctype]
print @n.xbgr.xm47_u7.nsg13_hv_pmos[ide]
print @n.xbgr.xm47_u7.nsg13_hv_pmos[ige]
print @n.xbgr.xm47_u7.nsg13_hv_pmos[ise]
print @n.xbgr.xm47_u7.nsg13_hv_pmos[ibe]
print @n.xbgr.xm47_u7.nsg13_hv_pmos[ctype]
print @n.xbgr.xm47_u8.nsg13_hv_pmos[ide]
print @n.xbgr.xm47_u8.nsg13_hv_pmos[ige]
print @n.xbgr.xm47_u8.nsg13_hv_pmos[ise]
print @n.xbgr.xm47_u8.nsg13_hv_pmos[ibe]
print @n.xbgr.xm47_u8.nsg13_hv_pmos[ctype]
print @n.xbgr.xm47_u9.nsg13_hv_pmos[ide]
print @n.xbgr.xm47_u9.nsg13_hv_pmos[ige]
print @n.xbgr.xm47_u9.nsg13_hv_pmos[ise]
print @n.xbgr.xm47_u9.nsg13_hv_pmos[ibe]
print @n.xbgr.xm47_u9.nsg13_hv_pmos[ctype]
print @n.xbgr.xm47_u10.nsg13_hv_pmos[ide]
print @n.xbgr.xm47_u10.nsg13_hv_pmos[ige]
print @n.xbgr.xm47_u10.nsg13_hv_pmos[ise]
print @n.xbgr.xm47_u10.nsg13_hv_pmos[ibe]
print @n.xbgr.xm47_u10.nsg13_hv_pmos[ctype]
print @n.xbgr.xm47_u11.nsg13_hv_pmos[ide]
print @n.xbgr.xm47_u11.nsg13_hv_pmos[ige]
print @n.xbgr.xm47_u11.nsg13_hv_pmos[ise]
print @n.xbgr.xm47_u11.nsg13_hv_pmos[ibe]
print @n.xbgr.xm47_u11.nsg13_hv_pmos[ctype]
print @n.xbgr.xm47_u12.nsg13_hv_pmos[ide]
print @n.xbgr.xm47_u12.nsg13_hv_pmos[ige]
print @n.xbgr.xm47_u12.nsg13_hv_pmos[ise]
print @n.xbgr.xm47_u12.nsg13_hv_pmos[ibe]
print @n.xbgr.xm47_u12.nsg13_hv_pmos[ctype]
print @n.xbgr.xm47_u13.nsg13_hv_pmos[ide]
print @n.xbgr.xm47_u13.nsg13_hv_pmos[ige]
print @n.xbgr.xm47_u13.nsg13_hv_pmos[ise]
print @n.xbgr.xm47_u13.nsg13_hv_pmos[ibe]
print @n.xbgr.xm47_u13.nsg13_hv_pmos[ctype]
print @n.xbgr.xm47_u14.nsg13_hv_pmos[ide]
print @n.xbgr.xm47_u14.nsg13_hv_pmos[ige]
print @n.xbgr.xm47_u14.nsg13_hv_pmos[ise]
print @n.xbgr.xm47_u14.nsg13_hv_pmos[ibe]
print @n.xbgr.xm47_u14.nsg13_hv_pmos[ctype]
print @n.xbgr.xm47_u15.nsg13_hv_pmos[ide]
print @n.xbgr.xm47_u15.nsg13_hv_pmos[ige]
print @n.xbgr.xm47_u15.nsg13_hv_pmos[ise]
print @n.xbgr.xm47_u15.nsg13_hv_pmos[ibe]
print @n.xbgr.xm47_u15.nsg13_hv_pmos[ctype]
print @n.xbgr.xm47_u16.nsg13_hv_pmos[ide]
print @n.xbgr.xm47_u16.nsg13_hv_pmos[ige]
print @n.xbgr.xm47_u16.nsg13_hv_pmos[ise]
print @n.xbgr.xm47_u16.nsg13_hv_pmos[ibe]
print @n.xbgr.xm47_u16.nsg13_hv_pmos[ctype]
print @n.xbgr.xm47_u17.nsg13_hv_pmos[ide]
print @n.xbgr.xm47_u17.nsg13_hv_pmos[ige]
print @n.xbgr.xm47_u17.nsg13_hv_pmos[ise]
print @n.xbgr.xm47_u17.nsg13_hv_pmos[ibe]
print @n.xbgr.xm47_u17.nsg13_hv_pmos[ctype]
print @n.xbgr.xm47_u18.nsg13_hv_pmos[ide]
print @n.xbgr.xm47_u18.nsg13_hv_pmos[ige]
print @n.xbgr.xm47_u18.nsg13_hv_pmos[ise]
print @n.xbgr.xm47_u18.nsg13_hv_pmos[ibe]
print @n.xbgr.xm47_u18.nsg13_hv_pmos[ctype]
print @n.xbgr.xm47_u19.nsg13_hv_pmos[ide]
print @n.xbgr.xm47_u19.nsg13_hv_pmos[ige]
print @n.xbgr.xm47_u19.nsg13_hv_pmos[ise]
print @n.xbgr.xm47_u19.nsg13_hv_pmos[ibe]
print @n.xbgr.xm47_u19.nsg13_hv_pmos[ctype]
print @n.xbgr.xm47_u20.nsg13_hv_pmos[ide]
print @n.xbgr.xm47_u20.nsg13_hv_pmos[ige]
print @n.xbgr.xm47_u20.nsg13_hv_pmos[ise]
print @n.xbgr.xm47_u20.nsg13_hv_pmos[ibe]
print @n.xbgr.xm47_u20.nsg13_hv_pmos[ctype]
print @n.xbgr.xm47_u21.nsg13_hv_pmos[ide]
print @n.xbgr.xm47_u21.nsg13_hv_pmos[ige]
print @n.xbgr.xm47_u21.nsg13_hv_pmos[ise]
print @n.xbgr.xm47_u21.nsg13_hv_pmos[ibe]
print @n.xbgr.xm47_u21.nsg13_hv_pmos[ctype]
print @n.xbgr.xm47_u22.nsg13_hv_pmos[ide]
print @n.xbgr.xm47_u22.nsg13_hv_pmos[ige]
print @n.xbgr.xm47_u22.nsg13_hv_pmos[ise]
print @n.xbgr.xm47_u22.nsg13_hv_pmos[ibe]
print @n.xbgr.xm47_u22.nsg13_hv_pmos[ctype]
print @n.xbgr.xm47_u23.nsg13_hv_pmos[ide]
print @n.xbgr.xm47_u23.nsg13_hv_pmos[ige]
print @n.xbgr.xm47_u23.nsg13_hv_pmos[ise]
print @n.xbgr.xm47_u23.nsg13_hv_pmos[ibe]
print @n.xbgr.xm47_u23.nsg13_hv_pmos[ctype]
print @n.xbgr.xm47_u24.nsg13_hv_pmos[ide]
print @n.xbgr.xm47_u24.nsg13_hv_pmos[ige]
print @n.xbgr.xm47_u24.nsg13_hv_pmos[ise]
print @n.xbgr.xm47_u24.nsg13_hv_pmos[ibe]
print @n.xbgr.xm47_u24.nsg13_hv_pmos[ctype]
print @n.xbgr.xm48_u2.nsg13_hv_pmos[ide]
print @n.xbgr.xm48_u2.nsg13_hv_pmos[ige]
print @n.xbgr.xm48_u2.nsg13_hv_pmos[ise]
print @n.xbgr.xm48_u2.nsg13_hv_pmos[ibe]
print @n.xbgr.xm48_u2.nsg13_hv_pmos[ctype]
print @n.xbgr.xm48_u3.nsg13_hv_pmos[ide]
print @n.xbgr.xm48_u3.nsg13_hv_pmos[ige]
print @n.xbgr.xm48_u3.nsg13_hv_pmos[ise]
print @n.xbgr.xm48_u3.nsg13_hv_pmos[ibe]
print @n.xbgr.xm48_u3.nsg13_hv_pmos[ctype]
print @n.xbgr.xm48_u4.nsg13_hv_pmos[ide]
print @n.xbgr.xm48_u4.nsg13_hv_pmos[ige]
print @n.xbgr.xm48_u4.nsg13_hv_pmos[ise]
print @n.xbgr.xm48_u4.nsg13_hv_pmos[ibe]
print @n.xbgr.xm48_u4.nsg13_hv_pmos[ctype]
print @n.xbgr.xm48_u5.nsg13_hv_pmos[ide]
print @n.xbgr.xm48_u5.nsg13_hv_pmos[ige]
print @n.xbgr.xm48_u5.nsg13_hv_pmos[ise]
print @n.xbgr.xm48_u5.nsg13_hv_pmos[ibe]
print @n.xbgr.xm48_u5.nsg13_hv_pmos[ctype]
print @n.xbgr.xm48_u6.nsg13_hv_pmos[ide]
print @n.xbgr.xm48_u6.nsg13_hv_pmos[ige]
print @n.xbgr.xm48_u6.nsg13_hv_pmos[ise]
print @n.xbgr.xm48_u6.nsg13_hv_pmos[ibe]
print @n.xbgr.xm48_u6.nsg13_hv_pmos[ctype]
print @n.xbgr.xm48_u7.nsg13_hv_pmos[ide]
print @n.xbgr.xm48_u7.nsg13_hv_pmos[ige]
print @n.xbgr.xm48_u7.nsg13_hv_pmos[ise]
print @n.xbgr.xm48_u7.nsg13_hv_pmos[ibe]
print @n.xbgr.xm48_u7.nsg13_hv_pmos[ctype]
print @n.xbgr.xm48_u8.nsg13_hv_pmos[ide]
print @n.xbgr.xm48_u8.nsg13_hv_pmos[ige]
print @n.xbgr.xm48_u8.nsg13_hv_pmos[ise]
print @n.xbgr.xm48_u8.nsg13_hv_pmos[ibe]
print @n.xbgr.xm48_u8.nsg13_hv_pmos[ctype]
print @n.xbgr.xm48_u9.nsg13_hv_pmos[ide]
print @n.xbgr.xm48_u9.nsg13_hv_pmos[ige]
print @n.xbgr.xm48_u9.nsg13_hv_pmos[ise]
print @n.xbgr.xm48_u9.nsg13_hv_pmos[ibe]
print @n.xbgr.xm48_u9.nsg13_hv_pmos[ctype]
print @n.xbgr.xm48_u10.nsg13_hv_pmos[ide]
print @n.xbgr.xm48_u10.nsg13_hv_pmos[ige]
print @n.xbgr.xm48_u10.nsg13_hv_pmos[ise]
print @n.xbgr.xm48_u10.nsg13_hv_pmos[ibe]
print @n.xbgr.xm48_u10.nsg13_hv_pmos[ctype]
print @n.xbgr.xm48_u11.nsg13_hv_pmos[ide]
print @n.xbgr.xm48_u11.nsg13_hv_pmos[ige]
print @n.xbgr.xm48_u11.nsg13_hv_pmos[ise]
print @n.xbgr.xm48_u11.nsg13_hv_pmos[ibe]
print @n.xbgr.xm48_u11.nsg13_hv_pmos[ctype]
print @n.xbgr.xm48_u12.nsg13_hv_pmos[ide]
print @n.xbgr.xm48_u12.nsg13_hv_pmos[ige]
print @n.xbgr.xm48_u12.nsg13_hv_pmos[ise]
print @n.xbgr.xm48_u12.nsg13_hv_pmos[ibe]
print @n.xbgr.xm48_u12.nsg13_hv_pmos[ctype]
print @n.xbgr.xm48_u13.nsg13_hv_pmos[ide]
print @n.xbgr.xm48_u13.nsg13_hv_pmos[ige]
print @n.xbgr.xm48_u13.nsg13_hv_pmos[ise]
print @n.xbgr.xm48_u13.nsg13_hv_pmos[ibe]
print @n.xbgr.xm48_u13.nsg13_hv_pmos[ctype]
print @n.xbgr.xm48_u14.nsg13_hv_pmos[ide]
print @n.xbgr.xm48_u14.nsg13_hv_pmos[ige]
print @n.xbgr.xm48_u14.nsg13_hv_pmos[ise]
print @n.xbgr.xm48_u14.nsg13_hv_pmos[ibe]
print @n.xbgr.xm48_u14.nsg13_hv_pmos[ctype]
print @n.xbgr.xm48_u15.nsg13_hv_pmos[ide]
print @n.xbgr.xm48_u15.nsg13_hv_pmos[ige]
print @n.xbgr.xm48_u15.nsg13_hv_pmos[ise]
print @n.xbgr.xm48_u15.nsg13_hv_pmos[ibe]
print @n.xbgr.xm48_u15.nsg13_hv_pmos[ctype]
print @n.xbgr.xm48_u16.nsg13_hv_pmos[ide]
print @n.xbgr.xm48_u16.nsg13_hv_pmos[ige]
print @n.xbgr.xm48_u16.nsg13_hv_pmos[ise]
print @n.xbgr.xm48_u16.nsg13_hv_pmos[ibe]
print @n.xbgr.xm48_u16.nsg13_hv_pmos[ctype]
print @n.xbgr.xm48_u17.nsg13_hv_pmos[ide]
print @n.xbgr.xm48_u17.nsg13_hv_pmos[ige]
print @n.xbgr.xm48_u17.nsg13_hv_pmos[ise]
print @n.xbgr.xm48_u17.nsg13_hv_pmos[ibe]
print @n.xbgr.xm48_u17.nsg13_hv_pmos[ctype]
print @n.xbgr.xm48_u18.nsg13_hv_pmos[ide]
print @n.xbgr.xm48_u18.nsg13_hv_pmos[ige]
print @n.xbgr.xm48_u18.nsg13_hv_pmos[ise]
print @n.xbgr.xm48_u18.nsg13_hv_pmos[ibe]
print @n.xbgr.xm48_u18.nsg13_hv_pmos[ctype]
print @n.xbgr.xm48_u19.nsg13_hv_pmos[ide]
print @n.xbgr.xm48_u19.nsg13_hv_pmos[ige]
print @n.xbgr.xm48_u19.nsg13_hv_pmos[ise]
print @n.xbgr.xm48_u19.nsg13_hv_pmos[ibe]
print @n.xbgr.xm48_u19.nsg13_hv_pmos[ctype]
print @n.xbgr.xm48_u20.nsg13_hv_pmos[ide]
print @n.xbgr.xm48_u20.nsg13_hv_pmos[ige]
print @n.xbgr.xm48_u20.nsg13_hv_pmos[ise]
print @n.xbgr.xm48_u20.nsg13_hv_pmos[ibe]
print @n.xbgr.xm48_u20.nsg13_hv_pmos[ctype]
print @n.xbgr.xm48_u21.nsg13_hv_pmos[ide]
print @n.xbgr.xm48_u21.nsg13_hv_pmos[ige]
print @n.xbgr.xm48_u21.nsg13_hv_pmos[ise]
print @n.xbgr.xm48_u21.nsg13_hv_pmos[ibe]
print @n.xbgr.xm48_u21.nsg13_hv_pmos[ctype]
print @n.xbgr.xm48_u22.nsg13_hv_pmos[ide]
print @n.xbgr.xm48_u22.nsg13_hv_pmos[ige]
print @n.xbgr.xm48_u22.nsg13_hv_pmos[ise]
print @n.xbgr.xm48_u22.nsg13_hv_pmos[ibe]
print @n.xbgr.xm48_u22.nsg13_hv_pmos[ctype]
print @n.xbgr.xm48_u23.nsg13_hv_pmos[ide]
print @n.xbgr.xm48_u23.nsg13_hv_pmos[ige]
print @n.xbgr.xm48_u23.nsg13_hv_pmos[ise]
print @n.xbgr.xm48_u23.nsg13_hv_pmos[ibe]
print @n.xbgr.xm48_u23.nsg13_hv_pmos[ctype]
print @n.xbgr.xm48_u24.nsg13_hv_pmos[ide]
print @n.xbgr.xm48_u24.nsg13_hv_pmos[ige]
print @n.xbgr.xm48_u24.nsg13_hv_pmos[ise]
print @n.xbgr.xm48_u24.nsg13_hv_pmos[ibe]
print @n.xbgr.xm48_u24.nsg13_hv_pmos[ctype]
print @n.xbgr.xm50_u2.nsg13_hv_pmos[ide]
print @n.xbgr.xm50_u2.nsg13_hv_pmos[ige]
print @n.xbgr.xm50_u2.nsg13_hv_pmos[ise]
print @n.xbgr.xm50_u2.nsg13_hv_pmos[ibe]
print @n.xbgr.xm50_u2.nsg13_hv_pmos[ctype]
print @n.xbgr.xm50_u3.nsg13_hv_pmos[ide]
print @n.xbgr.xm50_u3.nsg13_hv_pmos[ige]
print @n.xbgr.xm50_u3.nsg13_hv_pmos[ise]
print @n.xbgr.xm50_u3.nsg13_hv_pmos[ibe]
print @n.xbgr.xm50_u3.nsg13_hv_pmos[ctype]
print @n.xbgr.xm50_u4.nsg13_hv_pmos[ide]
print @n.xbgr.xm50_u4.nsg13_hv_pmos[ige]
print @n.xbgr.xm50_u4.nsg13_hv_pmos[ise]
print @n.xbgr.xm50_u4.nsg13_hv_pmos[ibe]
print @n.xbgr.xm50_u4.nsg13_hv_pmos[ctype]
print @n.xbgr.xm50_u5.nsg13_hv_pmos[ide]
print @n.xbgr.xm50_u5.nsg13_hv_pmos[ige]
print @n.xbgr.xm50_u5.nsg13_hv_pmos[ise]
print @n.xbgr.xm50_u5.nsg13_hv_pmos[ibe]
print @n.xbgr.xm50_u5.nsg13_hv_pmos[ctype]
print @n.xbgr.xm50_u6.nsg13_hv_pmos[ide]
print @n.xbgr.xm50_u6.nsg13_hv_pmos[ige]
print @n.xbgr.xm50_u6.nsg13_hv_pmos[ise]
print @n.xbgr.xm50_u6.nsg13_hv_pmos[ibe]
print @n.xbgr.xm50_u6.nsg13_hv_pmos[ctype]
print @n.xbgr.xm50_u7.nsg13_hv_pmos[ide]
print @n.xbgr.xm50_u7.nsg13_hv_pmos[ige]
print @n.xbgr.xm50_u7.nsg13_hv_pmos[ise]
print @n.xbgr.xm50_u7.nsg13_hv_pmos[ibe]
print @n.xbgr.xm50_u7.nsg13_hv_pmos[ctype]
print @n.xbgr.xm50_u8.nsg13_hv_pmos[ide]
print @n.xbgr.xm50_u8.nsg13_hv_pmos[ige]
print @n.xbgr.xm50_u8.nsg13_hv_pmos[ise]
print @n.xbgr.xm50_u8.nsg13_hv_pmos[ibe]
print @n.xbgr.xm50_u8.nsg13_hv_pmos[ctype]
print @n.xbgr.xm50_u9.nsg13_hv_pmos[ide]
print @n.xbgr.xm50_u9.nsg13_hv_pmos[ige]
print @n.xbgr.xm50_u9.nsg13_hv_pmos[ise]
print @n.xbgr.xm50_u9.nsg13_hv_pmos[ibe]
print @n.xbgr.xm50_u9.nsg13_hv_pmos[ctype]
print @n.xbgr.xm50_u10.nsg13_hv_pmos[ide]
print @n.xbgr.xm50_u10.nsg13_hv_pmos[ige]
print @n.xbgr.xm50_u10.nsg13_hv_pmos[ise]
print @n.xbgr.xm50_u10.nsg13_hv_pmos[ibe]
print @n.xbgr.xm50_u10.nsg13_hv_pmos[ctype]
print @n.xbgr.xm50_u11.nsg13_hv_pmos[ide]
print @n.xbgr.xm50_u11.nsg13_hv_pmos[ige]
print @n.xbgr.xm50_u11.nsg13_hv_pmos[ise]
print @n.xbgr.xm50_u11.nsg13_hv_pmos[ibe]
print @n.xbgr.xm50_u11.nsg13_hv_pmos[ctype]
print @n.xbgr.xm50_u12.nsg13_hv_pmos[ide]
print @n.xbgr.xm50_u12.nsg13_hv_pmos[ige]
print @n.xbgr.xm50_u12.nsg13_hv_pmos[ise]
print @n.xbgr.xm50_u12.nsg13_hv_pmos[ibe]
print @n.xbgr.xm50_u12.nsg13_hv_pmos[ctype]
print @n.xbgr.xm50_u13.nsg13_hv_pmos[ide]
print @n.xbgr.xm50_u13.nsg13_hv_pmos[ige]
print @n.xbgr.xm50_u13.nsg13_hv_pmos[ise]
print @n.xbgr.xm50_u13.nsg13_hv_pmos[ibe]
print @n.xbgr.xm50_u13.nsg13_hv_pmos[ctype]
print @n.xbgr.xm50_u14.nsg13_hv_pmos[ide]
print @n.xbgr.xm50_u14.nsg13_hv_pmos[ige]
print @n.xbgr.xm50_u14.nsg13_hv_pmos[ise]
print @n.xbgr.xm50_u14.nsg13_hv_pmos[ibe]
print @n.xbgr.xm50_u14.nsg13_hv_pmos[ctype]
print @n.xbgr.xm50_u15.nsg13_hv_pmos[ide]
print @n.xbgr.xm50_u15.nsg13_hv_pmos[ige]
print @n.xbgr.xm50_u15.nsg13_hv_pmos[ise]
print @n.xbgr.xm50_u15.nsg13_hv_pmos[ibe]
print @n.xbgr.xm50_u15.nsg13_hv_pmos[ctype]
print @n.xbgr.xm50_u16.nsg13_hv_pmos[ide]
print @n.xbgr.xm50_u16.nsg13_hv_pmos[ige]
print @n.xbgr.xm50_u16.nsg13_hv_pmos[ise]
print @n.xbgr.xm50_u16.nsg13_hv_pmos[ibe]
print @n.xbgr.xm50_u16.nsg13_hv_pmos[ctype]
print @n.xbgr.xm50_u17.nsg13_hv_pmos[ide]
print @n.xbgr.xm50_u17.nsg13_hv_pmos[ige]
print @n.xbgr.xm50_u17.nsg13_hv_pmos[ise]
print @n.xbgr.xm50_u17.nsg13_hv_pmos[ibe]
print @n.xbgr.xm50_u17.nsg13_hv_pmos[ctype]
print @n.xbgr.xm50_u18.nsg13_hv_pmos[ide]
print @n.xbgr.xm50_u18.nsg13_hv_pmos[ige]
print @n.xbgr.xm50_u18.nsg13_hv_pmos[ise]
print @n.xbgr.xm50_u18.nsg13_hv_pmos[ibe]
print @n.xbgr.xm50_u18.nsg13_hv_pmos[ctype]
print @n.xbgr.xm50_u19.nsg13_hv_pmos[ide]
print @n.xbgr.xm50_u19.nsg13_hv_pmos[ige]
print @n.xbgr.xm50_u19.nsg13_hv_pmos[ise]
print @n.xbgr.xm50_u19.nsg13_hv_pmos[ibe]
print @n.xbgr.xm50_u19.nsg13_hv_pmos[ctype]
print @n.xbgr.xm50_u20.nsg13_hv_pmos[ide]
print @n.xbgr.xm50_u20.nsg13_hv_pmos[ige]
print @n.xbgr.xm50_u20.nsg13_hv_pmos[ise]
print @n.xbgr.xm50_u20.nsg13_hv_pmos[ibe]
print @n.xbgr.xm50_u20.nsg13_hv_pmos[ctype]
print @n.xbgr.xm50_u21.nsg13_hv_pmos[ide]
print @n.xbgr.xm50_u21.nsg13_hv_pmos[ige]
print @n.xbgr.xm50_u21.nsg13_hv_pmos[ise]
print @n.xbgr.xm50_u21.nsg13_hv_pmos[ibe]
print @n.xbgr.xm50_u21.nsg13_hv_pmos[ctype]
print @n.xbgr.xm50_u22.nsg13_hv_pmos[ide]
print @n.xbgr.xm50_u22.nsg13_hv_pmos[ige]
print @n.xbgr.xm50_u22.nsg13_hv_pmos[ise]
print @n.xbgr.xm50_u22.nsg13_hv_pmos[ibe]
print @n.xbgr.xm50_u22.nsg13_hv_pmos[ctype]
print @n.xbgr.xm50_u23.nsg13_hv_pmos[ide]
print @n.xbgr.xm50_u23.nsg13_hv_pmos[ige]
print @n.xbgr.xm50_u23.nsg13_hv_pmos[ise]
print @n.xbgr.xm50_u23.nsg13_hv_pmos[ibe]
print @n.xbgr.xm50_u23.nsg13_hv_pmos[ctype]
print @n.xbgr.xm50_u24.nsg13_hv_pmos[ide]
print @n.xbgr.xm50_u24.nsg13_hv_pmos[ige]
print @n.xbgr.xm50_u24.nsg13_hv_pmos[ise]
print @n.xbgr.xm50_u24.nsg13_hv_pmos[ibe]
print @n.xbgr.xm50_u24.nsg13_hv_pmos[ctype]
print @n.xbgr.xm51_u2.nsg13_hv_pmos[ide]
print @n.xbgr.xm51_u2.nsg13_hv_pmos[ige]
print @n.xbgr.xm51_u2.nsg13_hv_pmos[ise]
print @n.xbgr.xm51_u2.nsg13_hv_pmos[ibe]
print @n.xbgr.xm51_u2.nsg13_hv_pmos[ctype]
print @n.xbgr.xm51_u3.nsg13_hv_pmos[ide]
print @n.xbgr.xm51_u3.nsg13_hv_pmos[ige]
print @n.xbgr.xm51_u3.nsg13_hv_pmos[ise]
print @n.xbgr.xm51_u3.nsg13_hv_pmos[ibe]
print @n.xbgr.xm51_u3.nsg13_hv_pmos[ctype]
print @n.xbgr.xm51_u4.nsg13_hv_pmos[ide]
print @n.xbgr.xm51_u4.nsg13_hv_pmos[ige]
print @n.xbgr.xm51_u4.nsg13_hv_pmos[ise]
print @n.xbgr.xm51_u4.nsg13_hv_pmos[ibe]
print @n.xbgr.xm51_u4.nsg13_hv_pmos[ctype]
print @n.xbgr.xm52_u2.nsg13_hv_pmos[ide]
print @n.xbgr.xm52_u2.nsg13_hv_pmos[ige]
print @n.xbgr.xm52_u2.nsg13_hv_pmos[ise]
print @n.xbgr.xm52_u2.nsg13_hv_pmos[ibe]
print @n.xbgr.xm52_u2.nsg13_hv_pmos[ctype]
print @n.xbgr.xm52_u3.nsg13_hv_pmos[ide]
print @n.xbgr.xm52_u3.nsg13_hv_pmos[ige]
print @n.xbgr.xm52_u3.nsg13_hv_pmos[ise]
print @n.xbgr.xm52_u3.nsg13_hv_pmos[ibe]
print @n.xbgr.xm52_u3.nsg13_hv_pmos[ctype]
print @n.xbgr.xm52_u4.nsg13_hv_pmos[ide]
print @n.xbgr.xm52_u4.nsg13_hv_pmos[ige]
print @n.xbgr.xm52_u4.nsg13_hv_pmos[ise]
print @n.xbgr.xm52_u4.nsg13_hv_pmos[ibe]
print @n.xbgr.xm52_u4.nsg13_hv_pmos[ctype]
print @n.xbgr.xm52_u5.nsg13_hv_pmos[ide]
print @n.xbgr.xm52_u5.nsg13_hv_pmos[ige]
print @n.xbgr.xm52_u5.nsg13_hv_pmos[ise]
print @n.xbgr.xm52_u5.nsg13_hv_pmos[ibe]
print @n.xbgr.xm52_u5.nsg13_hv_pmos[ctype]
print @n.xbgr.xm52_u6.nsg13_hv_pmos[ide]
print @n.xbgr.xm52_u6.nsg13_hv_pmos[ige]
print @n.xbgr.xm52_u6.nsg13_hv_pmos[ise]
print @n.xbgr.xm52_u6.nsg13_hv_pmos[ibe]
print @n.xbgr.xm52_u6.nsg13_hv_pmos[ctype]
print @n.xbgr.xm52_u7.nsg13_hv_pmos[ide]
print @n.xbgr.xm52_u7.nsg13_hv_pmos[ige]
print @n.xbgr.xm52_u7.nsg13_hv_pmos[ise]
print @n.xbgr.xm52_u7.nsg13_hv_pmos[ibe]
print @n.xbgr.xm52_u7.nsg13_hv_pmos[ctype]
print @n.xbgr.xm52_u8.nsg13_hv_pmos[ide]
print @n.xbgr.xm52_u8.nsg13_hv_pmos[ige]
print @n.xbgr.xm52_u8.nsg13_hv_pmos[ise]
print @n.xbgr.xm52_u8.nsg13_hv_pmos[ibe]
print @n.xbgr.xm52_u8.nsg13_hv_pmos[ctype]
print @n.xbgr.xm52_u9.nsg13_hv_pmos[ide]
print @n.xbgr.xm52_u9.nsg13_hv_pmos[ige]
print @n.xbgr.xm52_u9.nsg13_hv_pmos[ise]
print @n.xbgr.xm52_u9.nsg13_hv_pmos[ibe]
print @n.xbgr.xm52_u9.nsg13_hv_pmos[ctype]
print @n.xbgr.xm52_u10.nsg13_hv_pmos[ide]
print @n.xbgr.xm52_u10.nsg13_hv_pmos[ige]
print @n.xbgr.xm52_u10.nsg13_hv_pmos[ise]
print @n.xbgr.xm52_u10.nsg13_hv_pmos[ibe]
print @n.xbgr.xm52_u10.nsg13_hv_pmos[ctype]
print @n.xbgr.xm52_u11.nsg13_hv_pmos[ide]
print @n.xbgr.xm52_u11.nsg13_hv_pmos[ige]
print @n.xbgr.xm52_u11.nsg13_hv_pmos[ise]
print @n.xbgr.xm52_u11.nsg13_hv_pmos[ibe]
print @n.xbgr.xm52_u11.nsg13_hv_pmos[ctype]
print @n.xbgr.xm52_u12.nsg13_hv_pmos[ide]
print @n.xbgr.xm52_u12.nsg13_hv_pmos[ige]
print @n.xbgr.xm52_u12.nsg13_hv_pmos[ise]
print @n.xbgr.xm52_u12.nsg13_hv_pmos[ibe]
print @n.xbgr.xm52_u12.nsg13_hv_pmos[ctype]
print @n.xbgr.xm52_u13.nsg13_hv_pmos[ide]
print @n.xbgr.xm52_u13.nsg13_hv_pmos[ige]
print @n.xbgr.xm52_u13.nsg13_hv_pmos[ise]
print @n.xbgr.xm52_u13.nsg13_hv_pmos[ibe]
print @n.xbgr.xm52_u13.nsg13_hv_pmos[ctype]
print @n.xbgr.xm52_u14.nsg13_hv_pmos[ide]
print @n.xbgr.xm52_u14.nsg13_hv_pmos[ige]
print @n.xbgr.xm52_u14.nsg13_hv_pmos[ise]
print @n.xbgr.xm52_u14.nsg13_hv_pmos[ibe]
print @n.xbgr.xm52_u14.nsg13_hv_pmos[ctype]
print @n.xbgr.xm52_u15.nsg13_hv_pmos[ide]
print @n.xbgr.xm52_u15.nsg13_hv_pmos[ige]
print @n.xbgr.xm52_u15.nsg13_hv_pmos[ise]
print @n.xbgr.xm52_u15.nsg13_hv_pmos[ibe]
print @n.xbgr.xm52_u15.nsg13_hv_pmos[ctype]
print @n.xbgr.xm52_u16.nsg13_hv_pmos[ide]
print @n.xbgr.xm52_u16.nsg13_hv_pmos[ige]
print @n.xbgr.xm52_u16.nsg13_hv_pmos[ise]
print @n.xbgr.xm52_u16.nsg13_hv_pmos[ibe]
print @n.xbgr.xm52_u16.nsg13_hv_pmos[ctype]
print @n.xbgr.xm52_u17.nsg13_hv_pmos[ide]
print @n.xbgr.xm52_u17.nsg13_hv_pmos[ige]
print @n.xbgr.xm52_u17.nsg13_hv_pmos[ise]
print @n.xbgr.xm52_u17.nsg13_hv_pmos[ibe]
print @n.xbgr.xm52_u17.nsg13_hv_pmos[ctype]
print @n.xbgr.xm52_u18.nsg13_hv_pmos[ide]
print @n.xbgr.xm52_u18.nsg13_hv_pmos[ige]
print @n.xbgr.xm52_u18.nsg13_hv_pmos[ise]
print @n.xbgr.xm52_u18.nsg13_hv_pmos[ibe]
print @n.xbgr.xm52_u18.nsg13_hv_pmos[ctype]
print @n.xbgr.xm52_u19.nsg13_hv_pmos[ide]
print @n.xbgr.xm52_u19.nsg13_hv_pmos[ige]
print @n.xbgr.xm52_u19.nsg13_hv_pmos[ise]
print @n.xbgr.xm52_u19.nsg13_hv_pmos[ibe]
print @n.xbgr.xm52_u19.nsg13_hv_pmos[ctype]
print @n.xbgr.xm52_u20.nsg13_hv_pmos[ide]
print @n.xbgr.xm52_u20.nsg13_hv_pmos[ige]
print @n.xbgr.xm52_u20.nsg13_hv_pmos[ise]
print @n.xbgr.xm52_u20.nsg13_hv_pmos[ibe]
print @n.xbgr.xm52_u20.nsg13_hv_pmos[ctype]
print @n.xbgr.xm52_u21.nsg13_hv_pmos[ide]
print @n.xbgr.xm52_u21.nsg13_hv_pmos[ige]
print @n.xbgr.xm52_u21.nsg13_hv_pmos[ise]
print @n.xbgr.xm52_u21.nsg13_hv_pmos[ibe]
print @n.xbgr.xm52_u21.nsg13_hv_pmos[ctype]
print @n.xbgr.xm52_u22.nsg13_hv_pmos[ide]
print @n.xbgr.xm52_u22.nsg13_hv_pmos[ige]
print @n.xbgr.xm52_u22.nsg13_hv_pmos[ise]
print @n.xbgr.xm52_u22.nsg13_hv_pmos[ibe]
print @n.xbgr.xm52_u22.nsg13_hv_pmos[ctype]
print @n.xbgr.xm52_u23.nsg13_hv_pmos[ide]
print @n.xbgr.xm52_u23.nsg13_hv_pmos[ige]
print @n.xbgr.xm52_u23.nsg13_hv_pmos[ise]
print @n.xbgr.xm52_u23.nsg13_hv_pmos[ibe]
print @n.xbgr.xm52_u23.nsg13_hv_pmos[ctype]
print @n.xbgr.xm52_u24.nsg13_hv_pmos[ide]
print @n.xbgr.xm52_u24.nsg13_hv_pmos[ige]
print @n.xbgr.xm52_u24.nsg13_hv_pmos[ise]
print @n.xbgr.xm52_u24.nsg13_hv_pmos[ibe]
print @n.xbgr.xm52_u24.nsg13_hv_pmos[ctype]
print @n.xbgr.xm54_u2.nsg13_hv_pmos[ide]
print @n.xbgr.xm54_u2.nsg13_hv_pmos[ige]
print @n.xbgr.xm54_u2.nsg13_hv_pmos[ise]
print @n.xbgr.xm54_u2.nsg13_hv_pmos[ibe]
print @n.xbgr.xm54_u2.nsg13_hv_pmos[ctype]
print @n.xbgr.xm54_u3.nsg13_hv_pmos[ide]
print @n.xbgr.xm54_u3.nsg13_hv_pmos[ige]
print @n.xbgr.xm54_u3.nsg13_hv_pmos[ise]
print @n.xbgr.xm54_u3.nsg13_hv_pmos[ibe]
print @n.xbgr.xm54_u3.nsg13_hv_pmos[ctype]
print @n.xbgr.xm54_u4.nsg13_hv_pmos[ide]
print @n.xbgr.xm54_u4.nsg13_hv_pmos[ige]
print @n.xbgr.xm54_u4.nsg13_hv_pmos[ise]
print @n.xbgr.xm54_u4.nsg13_hv_pmos[ibe]
print @n.xbgr.xm54_u4.nsg13_hv_pmos[ctype]
print @n.xbgr.xm54_u5.nsg13_hv_pmos[ide]
print @n.xbgr.xm54_u5.nsg13_hv_pmos[ige]
print @n.xbgr.xm54_u5.nsg13_hv_pmos[ise]
print @n.xbgr.xm54_u5.nsg13_hv_pmos[ibe]
print @n.xbgr.xm54_u5.nsg13_hv_pmos[ctype]
print @n.xbgr.xm54_u6.nsg13_hv_pmos[ide]
print @n.xbgr.xm54_u6.nsg13_hv_pmos[ige]
print @n.xbgr.xm54_u6.nsg13_hv_pmos[ise]
print @n.xbgr.xm54_u6.nsg13_hv_pmos[ibe]
print @n.xbgr.xm54_u6.nsg13_hv_pmos[ctype]
print @n.xbgr.xm54_u7.nsg13_hv_pmos[ide]
print @n.xbgr.xm54_u7.nsg13_hv_pmos[ige]
print @n.xbgr.xm54_u7.nsg13_hv_pmos[ise]
print @n.xbgr.xm54_u7.nsg13_hv_pmos[ibe]
print @n.xbgr.xm54_u7.nsg13_hv_pmos[ctype]
print @n.xbgr.xm54_u8.nsg13_hv_pmos[ide]
print @n.xbgr.xm54_u8.nsg13_hv_pmos[ige]
print @n.xbgr.xm54_u8.nsg13_hv_pmos[ise]
print @n.xbgr.xm54_u8.nsg13_hv_pmos[ibe]
print @n.xbgr.xm54_u8.nsg13_hv_pmos[ctype]
print @n.xbgr.xm54_u9.nsg13_hv_pmos[ide]
print @n.xbgr.xm54_u9.nsg13_hv_pmos[ige]
print @n.xbgr.xm54_u9.nsg13_hv_pmos[ise]
print @n.xbgr.xm54_u9.nsg13_hv_pmos[ibe]
print @n.xbgr.xm54_u9.nsg13_hv_pmos[ctype]
print @n.xbgr.xm54_u10.nsg13_hv_pmos[ide]
print @n.xbgr.xm54_u10.nsg13_hv_pmos[ige]
print @n.xbgr.xm54_u10.nsg13_hv_pmos[ise]
print @n.xbgr.xm54_u10.nsg13_hv_pmos[ibe]
print @n.xbgr.xm54_u10.nsg13_hv_pmos[ctype]
print @n.xbgr.xm54_u11.nsg13_hv_pmos[ide]
print @n.xbgr.xm54_u11.nsg13_hv_pmos[ige]
print @n.xbgr.xm54_u11.nsg13_hv_pmos[ise]
print @n.xbgr.xm54_u11.nsg13_hv_pmos[ibe]
print @n.xbgr.xm54_u11.nsg13_hv_pmos[ctype]
print @n.xbgr.xm54_u12.nsg13_hv_pmos[ide]
print @n.xbgr.xm54_u12.nsg13_hv_pmos[ige]
print @n.xbgr.xm54_u12.nsg13_hv_pmos[ise]
print @n.xbgr.xm54_u12.nsg13_hv_pmos[ibe]
print @n.xbgr.xm54_u12.nsg13_hv_pmos[ctype]
print @n.xbgr.xm54_u13.nsg13_hv_pmos[ide]
print @n.xbgr.xm54_u13.nsg13_hv_pmos[ige]
print @n.xbgr.xm54_u13.nsg13_hv_pmos[ise]
print @n.xbgr.xm54_u13.nsg13_hv_pmos[ibe]
print @n.xbgr.xm54_u13.nsg13_hv_pmos[ctype]
print @n.xbgr.xm54_u14.nsg13_hv_pmos[ide]
print @n.xbgr.xm54_u14.nsg13_hv_pmos[ige]
print @n.xbgr.xm54_u14.nsg13_hv_pmos[ise]
print @n.xbgr.xm54_u14.nsg13_hv_pmos[ibe]
print @n.xbgr.xm54_u14.nsg13_hv_pmos[ctype]
print @n.xbgr.xm54_u15.nsg13_hv_pmos[ide]
print @n.xbgr.xm54_u15.nsg13_hv_pmos[ige]
print @n.xbgr.xm54_u15.nsg13_hv_pmos[ise]
print @n.xbgr.xm54_u15.nsg13_hv_pmos[ibe]
print @n.xbgr.xm54_u15.nsg13_hv_pmos[ctype]
print @n.xbgr.xm54_u16.nsg13_hv_pmos[ide]
print @n.xbgr.xm54_u16.nsg13_hv_pmos[ige]
print @n.xbgr.xm54_u16.nsg13_hv_pmos[ise]
print @n.xbgr.xm54_u16.nsg13_hv_pmos[ibe]
print @n.xbgr.xm54_u16.nsg13_hv_pmos[ctype]
print @n.xbgr.xm54_u17.nsg13_hv_pmos[ide]
print @n.xbgr.xm54_u17.nsg13_hv_pmos[ige]
print @n.xbgr.xm54_u17.nsg13_hv_pmos[ise]
print @n.xbgr.xm54_u17.nsg13_hv_pmos[ibe]
print @n.xbgr.xm54_u17.nsg13_hv_pmos[ctype]
print @n.xbgr.xm54_u18.nsg13_hv_pmos[ide]
print @n.xbgr.xm54_u18.nsg13_hv_pmos[ige]
print @n.xbgr.xm54_u18.nsg13_hv_pmos[ise]
print @n.xbgr.xm54_u18.nsg13_hv_pmos[ibe]
print @n.xbgr.xm54_u18.nsg13_hv_pmos[ctype]
print @n.xbgr.xm54_u19.nsg13_hv_pmos[ide]
print @n.xbgr.xm54_u19.nsg13_hv_pmos[ige]
print @n.xbgr.xm54_u19.nsg13_hv_pmos[ise]
print @n.xbgr.xm54_u19.nsg13_hv_pmos[ibe]
print @n.xbgr.xm54_u19.nsg13_hv_pmos[ctype]
print @n.xbgr.xm54_u20.nsg13_hv_pmos[ide]
print @n.xbgr.xm54_u20.nsg13_hv_pmos[ige]
print @n.xbgr.xm54_u20.nsg13_hv_pmos[ise]
print @n.xbgr.xm54_u20.nsg13_hv_pmos[ibe]
print @n.xbgr.xm54_u20.nsg13_hv_pmos[ctype]
print @n.xbgr.xm54_u21.nsg13_hv_pmos[ide]
print @n.xbgr.xm54_u21.nsg13_hv_pmos[ige]
print @n.xbgr.xm54_u21.nsg13_hv_pmos[ise]
print @n.xbgr.xm54_u21.nsg13_hv_pmos[ibe]
print @n.xbgr.xm54_u21.nsg13_hv_pmos[ctype]
print @n.xbgr.xm54_u22.nsg13_hv_pmos[ide]
print @n.xbgr.xm54_u22.nsg13_hv_pmos[ige]
print @n.xbgr.xm54_u22.nsg13_hv_pmos[ise]
print @n.xbgr.xm54_u22.nsg13_hv_pmos[ibe]
print @n.xbgr.xm54_u22.nsg13_hv_pmos[ctype]
print @n.xbgr.xm54_u23.nsg13_hv_pmos[ide]
print @n.xbgr.xm54_u23.nsg13_hv_pmos[ige]
print @n.xbgr.xm54_u23.nsg13_hv_pmos[ise]
print @n.xbgr.xm54_u23.nsg13_hv_pmos[ibe]
print @n.xbgr.xm54_u23.nsg13_hv_pmos[ctype]
print @n.xbgr.xm54_u24.nsg13_hv_pmos[ide]
print @n.xbgr.xm54_u24.nsg13_hv_pmos[ige]
print @n.xbgr.xm54_u24.nsg13_hv_pmos[ise]
print @n.xbgr.xm54_u24.nsg13_hv_pmos[ibe]
print @n.xbgr.xm54_u24.nsg13_hv_pmos[ctype]
print @q.xbgr.xq56_u2.qnpn13g2[ic]
print @q.xbgr.xq56_u2.qnpn13g2[ib]
print @q.xbgr.xq56_u2.qnpn13g2[ie]
print @q.xbgr.xq56_u2.qnpn13g2[is]
print @r.xbgr.xq56_u2.rsub[i]
print @c.xbgr.xq56_u2.csub[i]
print @q.xbgr.xq56_u3.qnpn13g2[ic]
print @q.xbgr.xq56_u3.qnpn13g2[ib]
print @q.xbgr.xq56_u3.qnpn13g2[ie]
print @q.xbgr.xq56_u3.qnpn13g2[is]
print @r.xbgr.xq56_u3.rsub[i]
print @c.xbgr.xq56_u3.csub[i]
print @q.xbgr.xq56_u4.qnpn13g2[ic]
print @q.xbgr.xq56_u4.qnpn13g2[ib]
print @q.xbgr.xq56_u4.qnpn13g2[ie]
print @q.xbgr.xq56_u4.qnpn13g2[is]
print @r.xbgr.xq56_u4.rsub[i]
print @c.xbgr.xq56_u4.csub[i]
print @q.xbgr.xq56_u5.qnpn13g2[ic]
print @q.xbgr.xq56_u5.qnpn13g2[ib]
print @q.xbgr.xq56_u5.qnpn13g2[ie]
print @q.xbgr.xq56_u5.qnpn13g2[is]
print @r.xbgr.xq56_u5.rsub[i]
print @c.xbgr.xq56_u5.csub[i]
print @q.xbgr.xq56_u6.qnpn13g2[ic]
print @q.xbgr.xq56_u6.qnpn13g2[ib]
print @q.xbgr.xq56_u6.qnpn13g2[ie]
print @q.xbgr.xq56_u6.qnpn13g2[is]
print @r.xbgr.xq56_u6.rsub[i]
print @c.xbgr.xq56_u6.csub[i]
print @q.xbgr.xq56_u7.qnpn13g2[ic]
print @q.xbgr.xq56_u7.qnpn13g2[ib]
print @q.xbgr.xq56_u7.qnpn13g2[ie]
print @q.xbgr.xq56_u7.qnpn13g2[is]
print @r.xbgr.xq56_u7.rsub[i]
print @c.xbgr.xq56_u7.csub[i]
print @q.xbgr.xq56_u8.qnpn13g2[ic]
print @q.xbgr.xq56_u8.qnpn13g2[ib]
print @q.xbgr.xq56_u8.qnpn13g2[ie]
print @q.xbgr.xq56_u8.qnpn13g2[is]
print @r.xbgr.xq56_u8.rsub[i]
print @c.xbgr.xq56_u8.csub[i]
print @q.xbgr.xq56_u9.qnpn13g2[ic]
print @q.xbgr.xq56_u9.qnpn13g2[ib]
print @q.xbgr.xq56_u9.qnpn13g2[ie]
print @q.xbgr.xq56_u9.qnpn13g2[is]
print @r.xbgr.xq56_u9.rsub[i]
print @c.xbgr.xq56_u9.csub[i]
print @q.xbgr.xq56_u10.qnpn13g2[ic]
print @q.xbgr.xq56_u10.qnpn13g2[ib]
print @q.xbgr.xq56_u10.qnpn13g2[ie]
print @q.xbgr.xq56_u10.qnpn13g2[is]
print @r.xbgr.xq56_u10.rsub[i]
print @c.xbgr.xq56_u10.csub[i]
print @q.xbgr.xq56_u11.qnpn13g2[ic]
print @q.xbgr.xq56_u11.qnpn13g2[ib]
print @q.xbgr.xq56_u11.qnpn13g2[ie]
print @q.xbgr.xq56_u11.qnpn13g2[is]
print @r.xbgr.xq56_u11.rsub[i]
print @c.xbgr.xq56_u11.csub[i]
print @q.xbgr.xq56_u12.qnpn13g2[ic]
print @q.xbgr.xq56_u12.qnpn13g2[ib]
print @q.xbgr.xq56_u12.qnpn13g2[ie]
print @q.xbgr.xq56_u12.qnpn13g2[is]
print @r.xbgr.xq56_u12.rsub[i]
print @c.xbgr.xq56_u12.csub[i]
print @q.xbgr.xq56_u13.qnpn13g2[ic]
print @q.xbgr.xq56_u13.qnpn13g2[ib]
print @q.xbgr.xq56_u13.qnpn13g2[ie]
print @q.xbgr.xq56_u13.qnpn13g2[is]
print @r.xbgr.xq56_u13.rsub[i]
print @c.xbgr.xq56_u13.csub[i]
print @q.xbgr.xq56_u14.qnpn13g2[ic]
print @q.xbgr.xq56_u14.qnpn13g2[ib]
print @q.xbgr.xq56_u14.qnpn13g2[ie]
print @q.xbgr.xq56_u14.qnpn13g2[is]
print @r.xbgr.xq56_u14.rsub[i]
print @c.xbgr.xq56_u14.csub[i]
print @q.xbgr.xq56_u15.qnpn13g2[ic]
print @q.xbgr.xq56_u15.qnpn13g2[ib]
print @q.xbgr.xq56_u15.qnpn13g2[ie]
print @q.xbgr.xq56_u15.qnpn13g2[is]
print @r.xbgr.xq56_u15.rsub[i]
print @c.xbgr.xq56_u15.csub[i]
print @q.xbgr.xq56_u16.qnpn13g2[ic]
print @q.xbgr.xq56_u16.qnpn13g2[ib]
print @q.xbgr.xq56_u16.qnpn13g2[ie]
print @q.xbgr.xq56_u16.qnpn13g2[is]
print @r.xbgr.xq56_u16.rsub[i]
print @c.xbgr.xq56_u16.csub[i]
print @q.xbgr.xq56_u17.qnpn13g2[ic]
print @q.xbgr.xq56_u17.qnpn13g2[ib]
print @q.xbgr.xq56_u17.qnpn13g2[ie]
print @q.xbgr.xq56_u17.qnpn13g2[is]
print @r.xbgr.xq56_u17.rsub[i]
print @c.xbgr.xq56_u17.csub[i]
print @q.xbgr.xq56_u18.qnpn13g2[ic]
print @q.xbgr.xq56_u18.qnpn13g2[ib]
print @q.xbgr.xq56_u18.qnpn13g2[ie]
print @q.xbgr.xq56_u18.qnpn13g2[is]
print @r.xbgr.xq56_u18.rsub[i]
print @c.xbgr.xq56_u18.csub[i]
print @q.xbgr.xq56_u19.qnpn13g2[ic]
print @q.xbgr.xq56_u19.qnpn13g2[ib]
print @q.xbgr.xq56_u19.qnpn13g2[ie]
print @q.xbgr.xq56_u19.qnpn13g2[is]
print @r.xbgr.xq56_u19.rsub[i]
print @c.xbgr.xq56_u19.csub[i]
print @q.xbgr.xq56_u20.qnpn13g2[ic]
print @q.xbgr.xq56_u20.qnpn13g2[ib]
print @q.xbgr.xq56_u20.qnpn13g2[ie]
print @q.xbgr.xq56_u20.qnpn13g2[is]
print @r.xbgr.xq56_u20.rsub[i]
print @c.xbgr.xq56_u20.csub[i]
print @q.xbgr.xq56_u21.qnpn13g2[ic]
print @q.xbgr.xq56_u21.qnpn13g2[ib]
print @q.xbgr.xq56_u21.qnpn13g2[ie]
print @q.xbgr.xq56_u21.qnpn13g2[is]
print @r.xbgr.xq56_u21.rsub[i]
print @c.xbgr.xq56_u21.csub[i]
print @q.xbgr.xq56_u22.qnpn13g2[ic]
print @q.xbgr.xq56_u22.qnpn13g2[ib]
print @q.xbgr.xq56_u22.qnpn13g2[ie]
print @q.xbgr.xq56_u22.qnpn13g2[is]
print @r.xbgr.xq56_u22.rsub[i]
print @c.xbgr.xq56_u22.csub[i]
print @q.xbgr.xq56_u23.qnpn13g2[ic]
print @q.xbgr.xq56_u23.qnpn13g2[ib]
print @q.xbgr.xq56_u23.qnpn13g2[ie]
print @q.xbgr.xq56_u23.qnpn13g2[is]
print @r.xbgr.xq56_u23.rsub[i]
print @c.xbgr.xq56_u23.csub[i]
print @q.xbgr.xq56_u24.qnpn13g2[ic]
print @q.xbgr.xq56_u24.qnpn13g2[ib]
print @q.xbgr.xq56_u24.qnpn13g2[ie]
print @q.xbgr.xq56_u24.qnpn13g2[is]
print @r.xbgr.xq56_u24.rsub[i]
print @c.xbgr.xq56_u24.csub[i]
print @q.xbgr.xq60_u2.qnpn13g2[ic]
print @q.xbgr.xq60_u2.qnpn13g2[ib]
print @q.xbgr.xq60_u2.qnpn13g2[ie]
print @q.xbgr.xq60_u2.qnpn13g2[is]
print @r.xbgr.xq60_u2.rsub[i]
print @c.xbgr.xq60_u2.csub[i]
print @q.xbgr.xq60_u3.qnpn13g2[ic]
print @q.xbgr.xq60_u3.qnpn13g2[ib]
print @q.xbgr.xq60_u3.qnpn13g2[ie]
print @q.xbgr.xq60_u3.qnpn13g2[is]
print @r.xbgr.xq60_u3.rsub[i]
print @c.xbgr.xq60_u3.csub[i]
print @q.xbgr.xq60_u4.qnpn13g2[ic]
print @q.xbgr.xq60_u4.qnpn13g2[ib]
print @q.xbgr.xq60_u4.qnpn13g2[ie]
print @q.xbgr.xq60_u4.qnpn13g2[is]
print @r.xbgr.xq60_u4.rsub[i]
print @c.xbgr.xq60_u4.csub[i]
print @q.xbgr.xq62_u2.qnpn13g2[ic]
print @q.xbgr.xq62_u2.qnpn13g2[ib]
print @q.xbgr.xq62_u2.qnpn13g2[ie]
print @q.xbgr.xq62_u2.qnpn13g2[is]
print @r.xbgr.xq62_u2.rsub[i]
print @c.xbgr.xq62_u2.csub[i]
print @q.xbgr.xq62_u3.qnpn13g2[ic]
print @q.xbgr.xq62_u3.qnpn13g2[ib]
print @q.xbgr.xq62_u3.qnpn13g2[ie]
print @q.xbgr.xq62_u3.qnpn13g2[is]
print @r.xbgr.xq62_u3.rsub[i]
print @c.xbgr.xq62_u3.csub[i]
print @q.xbgr.xq62_u4.qnpn13g2[ic]
print @q.xbgr.xq62_u4.qnpn13g2[ib]
print @q.xbgr.xq62_u4.qnpn13g2[ie]
print @q.xbgr.xq62_u4.qnpn13g2[is]
print @r.xbgr.xq62_u4.rsub[i]
print @c.xbgr.xq62_u4.csub[i]
print @q.xbgr.xq62_u5.qnpn13g2[ic]
print @q.xbgr.xq62_u5.qnpn13g2[ib]
print @q.xbgr.xq62_u5.qnpn13g2[ie]
print @q.xbgr.xq62_u5.qnpn13g2[is]
print @r.xbgr.xq62_u5.rsub[i]
print @c.xbgr.xq62_u5.csub[i]
print @q.xbgr.xq62_u6.qnpn13g2[ic]
print @q.xbgr.xq62_u6.qnpn13g2[ib]
print @q.xbgr.xq62_u6.qnpn13g2[ie]
print @q.xbgr.xq62_u6.qnpn13g2[is]
print @r.xbgr.xq62_u6.rsub[i]
print @c.xbgr.xq62_u6.csub[i]
print @q.xbgr.xq62_u7.qnpn13g2[ic]
print @q.xbgr.xq62_u7.qnpn13g2[ib]
print @q.xbgr.xq62_u7.qnpn13g2[ie]
print @q.xbgr.xq62_u7.qnpn13g2[is]
print @r.xbgr.xq62_u7.rsub[i]
print @c.xbgr.xq62_u7.csub[i]
print @q.xbgr.xq62_u8.qnpn13g2[ic]
print @q.xbgr.xq62_u8.qnpn13g2[ib]
print @q.xbgr.xq62_u8.qnpn13g2[ie]
print @q.xbgr.xq62_u8.qnpn13g2[is]
print @r.xbgr.xq62_u8.rsub[i]
print @c.xbgr.xq62_u8.csub[i]
print @q.xbgr.xq62_u9.qnpn13g2[ic]
print @q.xbgr.xq62_u9.qnpn13g2[ib]
print @q.xbgr.xq62_u9.qnpn13g2[ie]
print @q.xbgr.xq62_u9.qnpn13g2[is]
print @r.xbgr.xq62_u9.rsub[i]
print @c.xbgr.xq62_u9.csub[i]
print @q.xbgr.xq62_u10.qnpn13g2[ic]
print @q.xbgr.xq62_u10.qnpn13g2[ib]
print @q.xbgr.xq62_u10.qnpn13g2[ie]
print @q.xbgr.xq62_u10.qnpn13g2[is]
print @r.xbgr.xq62_u10.rsub[i]
print @c.xbgr.xq62_u10.csub[i]
print @q.xbgr.xq62_u11.qnpn13g2[ic]
print @q.xbgr.xq62_u11.qnpn13g2[ib]
print @q.xbgr.xq62_u11.qnpn13g2[ie]
print @q.xbgr.xq62_u11.qnpn13g2[is]
print @r.xbgr.xq62_u11.rsub[i]
print @c.xbgr.xq62_u11.csub[i]
print @q.xbgr.xq62_u12.qnpn13g2[ic]
print @q.xbgr.xq62_u12.qnpn13g2[ib]
print @q.xbgr.xq62_u12.qnpn13g2[ie]
print @q.xbgr.xq62_u12.qnpn13g2[is]
print @r.xbgr.xq62_u12.rsub[i]
print @c.xbgr.xq62_u12.csub[i]
print @q.xbgr.xq62_u13.qnpn13g2[ic]
print @q.xbgr.xq62_u13.qnpn13g2[ib]
print @q.xbgr.xq62_u13.qnpn13g2[ie]
print @q.xbgr.xq62_u13.qnpn13g2[is]
print @r.xbgr.xq62_u13.rsub[i]
print @c.xbgr.xq62_u13.csub[i]
print @q.xbgr.xq62_u14.qnpn13g2[ic]
print @q.xbgr.xq62_u14.qnpn13g2[ib]
print @q.xbgr.xq62_u14.qnpn13g2[ie]
print @q.xbgr.xq62_u14.qnpn13g2[is]
print @r.xbgr.xq62_u14.rsub[i]
print @c.xbgr.xq62_u14.csub[i]
print @q.xbgr.xq62_u15.qnpn13g2[ic]
print @q.xbgr.xq62_u15.qnpn13g2[ib]
print @q.xbgr.xq62_u15.qnpn13g2[ie]
print @q.xbgr.xq62_u15.qnpn13g2[is]
print @r.xbgr.xq62_u15.rsub[i]
print @c.xbgr.xq62_u15.csub[i]
print @q.xbgr.xq62_u16.qnpn13g2[ic]
print @q.xbgr.xq62_u16.qnpn13g2[ib]
print @q.xbgr.xq62_u16.qnpn13g2[ie]
print @q.xbgr.xq62_u16.qnpn13g2[is]
print @r.xbgr.xq62_u16.rsub[i]
print @c.xbgr.xq62_u16.csub[i]
print @q.xbgr.xq62_u17.qnpn13g2[ic]
print @q.xbgr.xq62_u17.qnpn13g2[ib]
print @q.xbgr.xq62_u17.qnpn13g2[ie]
print @q.xbgr.xq62_u17.qnpn13g2[is]
print @r.xbgr.xq62_u17.rsub[i]
print @c.xbgr.xq62_u17.csub[i]
print @q.xbgr.xq62_u18.qnpn13g2[ic]
print @q.xbgr.xq62_u18.qnpn13g2[ib]
print @q.xbgr.xq62_u18.qnpn13g2[ie]
print @q.xbgr.xq62_u18.qnpn13g2[is]
print @r.xbgr.xq62_u18.rsub[i]
print @c.xbgr.xq62_u18.csub[i]
print @q.xbgr.xq62_u19.qnpn13g2[ic]
print @q.xbgr.xq62_u19.qnpn13g2[ib]
print @q.xbgr.xq62_u19.qnpn13g2[ie]
print @q.xbgr.xq62_u19.qnpn13g2[is]
print @r.xbgr.xq62_u19.rsub[i]
print @c.xbgr.xq62_u19.csub[i]
print @q.xbgr.xq62_u20.qnpn13g2[ic]
print @q.xbgr.xq62_u20.qnpn13g2[ib]
print @q.xbgr.xq62_u20.qnpn13g2[ie]
print @q.xbgr.xq62_u20.qnpn13g2[is]
print @r.xbgr.xq62_u20.rsub[i]
print @c.xbgr.xq62_u20.csub[i]
print @q.xbgr.xq62_u21.qnpn13g2[ic]
print @q.xbgr.xq62_u21.qnpn13g2[ib]
print @q.xbgr.xq62_u21.qnpn13g2[ie]
print @q.xbgr.xq62_u21.qnpn13g2[is]
print @r.xbgr.xq62_u21.rsub[i]
print @c.xbgr.xq62_u21.csub[i]
print @q.xbgr.xq62_u22.qnpn13g2[ic]
print @q.xbgr.xq62_u22.qnpn13g2[ib]
print @q.xbgr.xq62_u22.qnpn13g2[ie]
print @q.xbgr.xq62_u22.qnpn13g2[is]
print @r.xbgr.xq62_u22.rsub[i]
print @c.xbgr.xq62_u22.csub[i]
print @q.xbgr.xq62_u23.qnpn13g2[ic]
print @q.xbgr.xq62_u23.qnpn13g2[ib]
print @q.xbgr.xq62_u23.qnpn13g2[ie]
print @q.xbgr.xq62_u23.qnpn13g2[is]
print @r.xbgr.xq62_u23.rsub[i]
print @c.xbgr.xq62_u23.csub[i]
print @q.xbgr.xq62_u24.qnpn13g2[ic]
print @q.xbgr.xq62_u24.qnpn13g2[ib]
print @q.xbgr.xq62_u24.qnpn13g2[ie]
print @q.xbgr.xq62_u24.qnpn13g2[is]
print @r.xbgr.xq62_u24.rsub[i]
print @c.xbgr.xq62_u24.csub[i]
print @q.xbgr.xq67_u2.qnpn13g2[ic]
print @q.xbgr.xq67_u2.qnpn13g2[ib]
print @q.xbgr.xq67_u2.qnpn13g2[ie]
print @q.xbgr.xq67_u2.qnpn13g2[is]
print @r.xbgr.xq67_u2.rsub[i]
print @c.xbgr.xq67_u2.csub[i]
print @q.xbgr.xq67_u3.qnpn13g2[ic]
print @q.xbgr.xq67_u3.qnpn13g2[ib]
print @q.xbgr.xq67_u3.qnpn13g2[ie]
print @q.xbgr.xq67_u3.qnpn13g2[is]
print @r.xbgr.xq67_u3.rsub[i]
print @c.xbgr.xq67_u3.csub[i]
print @q.xbgr.xq67_u4.qnpn13g2[ic]
print @q.xbgr.xq67_u4.qnpn13g2[ib]
print @q.xbgr.xq67_u4.qnpn13g2[ie]
print @q.xbgr.xq67_u4.qnpn13g2[is]
print @r.xbgr.xq67_u4.rsub[i]
print @c.xbgr.xq67_u4.csub[i]
print @q.xbgr.xq67_u5.qnpn13g2[ic]
print @q.xbgr.xq67_u5.qnpn13g2[ib]
print @q.xbgr.xq67_u5.qnpn13g2[ie]
print @q.xbgr.xq67_u5.qnpn13g2[is]
print @r.xbgr.xq67_u5.rsub[i]
print @c.xbgr.xq67_u5.csub[i]
print @q.xbgr.xq67_u6.qnpn13g2[ic]
print @q.xbgr.xq67_u6.qnpn13g2[ib]
print @q.xbgr.xq67_u6.qnpn13g2[ie]
print @q.xbgr.xq67_u6.qnpn13g2[is]
print @r.xbgr.xq67_u6.rsub[i]
print @c.xbgr.xq67_u6.csub[i]
print @q.xbgr.xq67_u7.qnpn13g2[ic]
print @q.xbgr.xq67_u7.qnpn13g2[ib]
print @q.xbgr.xq67_u7.qnpn13g2[ie]
print @q.xbgr.xq67_u7.qnpn13g2[is]
print @r.xbgr.xq67_u7.rsub[i]
print @c.xbgr.xq67_u7.csub[i]
print @q.xbgr.xq67_u8.qnpn13g2[ic]
print @q.xbgr.xq67_u8.qnpn13g2[ib]
print @q.xbgr.xq67_u8.qnpn13g2[ie]
print @q.xbgr.xq67_u8.qnpn13g2[is]
print @r.xbgr.xq67_u8.rsub[i]
print @c.xbgr.xq67_u8.csub[i]
print @q.xbgr.xq67_u9.qnpn13g2[ic]
print @q.xbgr.xq67_u9.qnpn13g2[ib]
print @q.xbgr.xq67_u9.qnpn13g2[ie]
print @q.xbgr.xq67_u9.qnpn13g2[is]
print @r.xbgr.xq67_u9.rsub[i]
print @c.xbgr.xq67_u9.csub[i]
print @q.xbgr.xq67_u10.qnpn13g2[ic]
print @q.xbgr.xq67_u10.qnpn13g2[ib]
print @q.xbgr.xq67_u10.qnpn13g2[ie]
print @q.xbgr.xq67_u10.qnpn13g2[is]
print @r.xbgr.xq67_u10.rsub[i]
print @c.xbgr.xq67_u10.csub[i]
print @q.xbgr.xq67_u11.qnpn13g2[ic]
print @q.xbgr.xq67_u11.qnpn13g2[ib]
print @q.xbgr.xq67_u11.qnpn13g2[ie]
print @q.xbgr.xq67_u11.qnpn13g2[is]
print @r.xbgr.xq67_u11.rsub[i]
print @c.xbgr.xq67_u11.csub[i]
print @q.xbgr.xq67_u12.qnpn13g2[ic]
print @q.xbgr.xq67_u12.qnpn13g2[ib]
print @q.xbgr.xq67_u12.qnpn13g2[ie]
print @q.xbgr.xq67_u12.qnpn13g2[is]
print @r.xbgr.xq67_u12.rsub[i]
print @c.xbgr.xq67_u12.csub[i]
print @q.xbgr.xq67_u13.qnpn13g2[ic]
print @q.xbgr.xq67_u13.qnpn13g2[ib]
print @q.xbgr.xq67_u13.qnpn13g2[ie]
print @q.xbgr.xq67_u13.qnpn13g2[is]
print @r.xbgr.xq67_u13.rsub[i]
print @c.xbgr.xq67_u13.csub[i]
print @q.xbgr.xq67_u14.qnpn13g2[ic]
print @q.xbgr.xq67_u14.qnpn13g2[ib]
print @q.xbgr.xq67_u14.qnpn13g2[ie]
print @q.xbgr.xq67_u14.qnpn13g2[is]
print @r.xbgr.xq67_u14.rsub[i]
print @c.xbgr.xq67_u14.csub[i]
print @q.xbgr.xq67_u15.qnpn13g2[ic]
print @q.xbgr.xq67_u15.qnpn13g2[ib]
print @q.xbgr.xq67_u15.qnpn13g2[ie]
print @q.xbgr.xq67_u15.qnpn13g2[is]
print @r.xbgr.xq67_u15.rsub[i]
print @c.xbgr.xq67_u15.csub[i]
print @q.xbgr.xq67_u16.qnpn13g2[ic]
print @q.xbgr.xq67_u16.qnpn13g2[ib]
print @q.xbgr.xq67_u16.qnpn13g2[ie]
print @q.xbgr.xq67_u16.qnpn13g2[is]
print @r.xbgr.xq67_u16.rsub[i]
print @c.xbgr.xq67_u16.csub[i]
print @q.xbgr.xq67_u17.qnpn13g2[ic]
print @q.xbgr.xq67_u17.qnpn13g2[ib]
print @q.xbgr.xq67_u17.qnpn13g2[ie]
print @q.xbgr.xq67_u17.qnpn13g2[is]
print @r.xbgr.xq67_u17.rsub[i]
print @c.xbgr.xq67_u17.csub[i]
print @q.xbgr.xq67_u18.qnpn13g2[ic]
print @q.xbgr.xq67_u18.qnpn13g2[ib]
print @q.xbgr.xq67_u18.qnpn13g2[ie]
print @q.xbgr.xq67_u18.qnpn13g2[is]
print @r.xbgr.xq67_u18.rsub[i]
print @c.xbgr.xq67_u18.csub[i]
print @q.xbgr.xq67_u19.qnpn13g2[ic]
print @q.xbgr.xq67_u19.qnpn13g2[ib]
print @q.xbgr.xq67_u19.qnpn13g2[ie]
print @q.xbgr.xq67_u19.qnpn13g2[is]
print @r.xbgr.xq67_u19.rsub[i]
print @c.xbgr.xq67_u19.csub[i]
print @q.xbgr.xq67_u20.qnpn13g2[ic]
print @q.xbgr.xq67_u20.qnpn13g2[ib]
print @q.xbgr.xq67_u20.qnpn13g2[ie]
print @q.xbgr.xq67_u20.qnpn13g2[is]
print @r.xbgr.xq67_u20.rsub[i]
print @c.xbgr.xq67_u20.csub[i]
print @q.xbgr.xq67_u21.qnpn13g2[ic]
print @q.xbgr.xq67_u21.qnpn13g2[ib]
print @q.xbgr.xq67_u21.qnpn13g2[ie]
print @q.xbgr.xq67_u21.qnpn13g2[is]
print @r.xbgr.xq67_u21.rsub[i]
print @c.xbgr.xq67_u21.csub[i]
print @q.xbgr.xq67_u22.qnpn13g2[ic]
print @q.xbgr.xq67_u22.qnpn13g2[ib]
print @q.xbgr.xq67_u22.qnpn13g2[ie]
print @q.xbgr.xq67_u22.qnpn13g2[is]
print @r.xbgr.xq67_u22.rsub[i]
print @c.xbgr.xq67_u22.csub[i]
print @q.xbgr.xq67_u23.qnpn13g2[ic]
print @q.xbgr.xq67_u23.qnpn13g2[ib]
print @q.xbgr.xq67_u23.qnpn13g2[ie]
print @q.xbgr.xq67_u23.qnpn13g2[is]
print @r.xbgr.xq67_u23.rsub[i]
print @c.xbgr.xq67_u23.csub[i]
print @q.xbgr.xq67_u24.qnpn13g2[ic]
print @q.xbgr.xq67_u24.qnpn13g2[ib]
print @q.xbgr.xq67_u24.qnpn13g2[ie]
print @q.xbgr.xq67_u24.qnpn13g2[is]
print @r.xbgr.xq67_u24.rsub[i]
print @c.xbgr.xq67_u24.csub[i]
print @q.xbgr.xq68_u2.qnpn13g2[ic]
print @q.xbgr.xq68_u2.qnpn13g2[ib]
print @q.xbgr.xq68_u2.qnpn13g2[ie]
print @q.xbgr.xq68_u2.qnpn13g2[is]
print @r.xbgr.xq68_u2.rsub[i]
print @c.xbgr.xq68_u2.csub[i]
print @q.xbgr.xq68_u3.qnpn13g2[ic]
print @q.xbgr.xq68_u3.qnpn13g2[ib]
print @q.xbgr.xq68_u3.qnpn13g2[ie]
print @q.xbgr.xq68_u3.qnpn13g2[is]
print @r.xbgr.xq68_u3.rsub[i]
print @c.xbgr.xq68_u3.csub[i]
print @q.xbgr.xq68_u4.qnpn13g2[ic]
print @q.xbgr.xq68_u4.qnpn13g2[ib]
print @q.xbgr.xq68_u4.qnpn13g2[ie]
print @q.xbgr.xq68_u4.qnpn13g2[is]
print @r.xbgr.xq68_u4.rsub[i]
print @c.xbgr.xq68_u4.csub[i]
print @q.xbgr.xq68_u5.qnpn13g2[ic]
print @q.xbgr.xq68_u5.qnpn13g2[ib]
print @q.xbgr.xq68_u5.qnpn13g2[ie]
print @q.xbgr.xq68_u5.qnpn13g2[is]
print @r.xbgr.xq68_u5.rsub[i]
print @c.xbgr.xq68_u5.csub[i]
print @q.xbgr.xq68_u6.qnpn13g2[ic]
print @q.xbgr.xq68_u6.qnpn13g2[ib]
print @q.xbgr.xq68_u6.qnpn13g2[ie]
print @q.xbgr.xq68_u6.qnpn13g2[is]
print @r.xbgr.xq68_u6.rsub[i]
print @c.xbgr.xq68_u6.csub[i]
print @q.xbgr.xq68_u7.qnpn13g2[ic]
print @q.xbgr.xq68_u7.qnpn13g2[ib]
print @q.xbgr.xq68_u7.qnpn13g2[ie]
print @q.xbgr.xq68_u7.qnpn13g2[is]
print @r.xbgr.xq68_u7.rsub[i]
print @c.xbgr.xq68_u7.csub[i]
print @q.xbgr.xq68_u8.qnpn13g2[ic]
print @q.xbgr.xq68_u8.qnpn13g2[ib]
print @q.xbgr.xq68_u8.qnpn13g2[ie]
print @q.xbgr.xq68_u8.qnpn13g2[is]
print @r.xbgr.xq68_u8.rsub[i]
print @c.xbgr.xq68_u8.csub[i]
print @q.xbgr.xq68_u9.qnpn13g2[ic]
print @q.xbgr.xq68_u9.qnpn13g2[ib]
print @q.xbgr.xq68_u9.qnpn13g2[ie]
print @q.xbgr.xq68_u9.qnpn13g2[is]
print @r.xbgr.xq68_u9.rsub[i]
print @c.xbgr.xq68_u9.csub[i]
print @q.xbgr.xq68_u10.qnpn13g2[ic]
print @q.xbgr.xq68_u10.qnpn13g2[ib]
print @q.xbgr.xq68_u10.qnpn13g2[ie]
print @q.xbgr.xq68_u10.qnpn13g2[is]
print @r.xbgr.xq68_u10.rsub[i]
print @c.xbgr.xq68_u10.csub[i]
print @q.xbgr.xq68_u11.qnpn13g2[ic]
print @q.xbgr.xq68_u11.qnpn13g2[ib]
print @q.xbgr.xq68_u11.qnpn13g2[ie]
print @q.xbgr.xq68_u11.qnpn13g2[is]
print @r.xbgr.xq68_u11.rsub[i]
print @c.xbgr.xq68_u11.csub[i]
print @q.xbgr.xq68_u12.qnpn13g2[ic]
print @q.xbgr.xq68_u12.qnpn13g2[ib]
print @q.xbgr.xq68_u12.qnpn13g2[ie]
print @q.xbgr.xq68_u12.qnpn13g2[is]
print @r.xbgr.xq68_u12.rsub[i]
print @c.xbgr.xq68_u12.csub[i]
print @q.xbgr.xq68_u13.qnpn13g2[ic]
print @q.xbgr.xq68_u13.qnpn13g2[ib]
print @q.xbgr.xq68_u13.qnpn13g2[ie]
print @q.xbgr.xq68_u13.qnpn13g2[is]
print @r.xbgr.xq68_u13.rsub[i]
print @c.xbgr.xq68_u13.csub[i]
print @q.xbgr.xq68_u14.qnpn13g2[ic]
print @q.xbgr.xq68_u14.qnpn13g2[ib]
print @q.xbgr.xq68_u14.qnpn13g2[ie]
print @q.xbgr.xq68_u14.qnpn13g2[is]
print @r.xbgr.xq68_u14.rsub[i]
print @c.xbgr.xq68_u14.csub[i]
print @q.xbgr.xq68_u15.qnpn13g2[ic]
print @q.xbgr.xq68_u15.qnpn13g2[ib]
print @q.xbgr.xq68_u15.qnpn13g2[ie]
print @q.xbgr.xq68_u15.qnpn13g2[is]
print @r.xbgr.xq68_u15.rsub[i]
print @c.xbgr.xq68_u15.csub[i]
print @q.xbgr.xq68_u16.qnpn13g2[ic]
print @q.xbgr.xq68_u16.qnpn13g2[ib]
print @q.xbgr.xq68_u16.qnpn13g2[ie]
print @q.xbgr.xq68_u16.qnpn13g2[is]
print @r.xbgr.xq68_u16.rsub[i]
print @c.xbgr.xq68_u16.csub[i]
print @q.xbgr.xq68_u17.qnpn13g2[ic]
print @q.xbgr.xq68_u17.qnpn13g2[ib]
print @q.xbgr.xq68_u17.qnpn13g2[ie]
print @q.xbgr.xq68_u17.qnpn13g2[is]
print @r.xbgr.xq68_u17.rsub[i]
print @c.xbgr.xq68_u17.csub[i]
print @q.xbgr.xq68_u18.qnpn13g2[ic]
print @q.xbgr.xq68_u18.qnpn13g2[ib]
print @q.xbgr.xq68_u18.qnpn13g2[ie]
print @q.xbgr.xq68_u18.qnpn13g2[is]
print @r.xbgr.xq68_u18.rsub[i]
print @c.xbgr.xq68_u18.csub[i]
print @q.xbgr.xq68_u19.qnpn13g2[ic]
print @q.xbgr.xq68_u19.qnpn13g2[ib]
print @q.xbgr.xq68_u19.qnpn13g2[ie]
print @q.xbgr.xq68_u19.qnpn13g2[is]
print @r.xbgr.xq68_u19.rsub[i]
print @c.xbgr.xq68_u19.csub[i]
print @q.xbgr.xq68_u20.qnpn13g2[ic]
print @q.xbgr.xq68_u20.qnpn13g2[ib]
print @q.xbgr.xq68_u20.qnpn13g2[ie]
print @q.xbgr.xq68_u20.qnpn13g2[is]
print @r.xbgr.xq68_u20.rsub[i]
print @c.xbgr.xq68_u20.csub[i]
print @q.xbgr.xq68_u21.qnpn13g2[ic]
print @q.xbgr.xq68_u21.qnpn13g2[ib]
print @q.xbgr.xq68_u21.qnpn13g2[ie]
print @q.xbgr.xq68_u21.qnpn13g2[is]
print @r.xbgr.xq68_u21.rsub[i]
print @c.xbgr.xq68_u21.csub[i]
print @q.xbgr.xq68_u22.qnpn13g2[ic]
print @q.xbgr.xq68_u22.qnpn13g2[ib]
print @q.xbgr.xq68_u22.qnpn13g2[ie]
print @q.xbgr.xq68_u22.qnpn13g2[is]
print @r.xbgr.xq68_u22.rsub[i]
print @c.xbgr.xq68_u22.csub[i]
print @q.xbgr.xq68_u23.qnpn13g2[ic]
print @q.xbgr.xq68_u23.qnpn13g2[ib]
print @q.xbgr.xq68_u23.qnpn13g2[ie]
print @q.xbgr.xq68_u23.qnpn13g2[is]
print @r.xbgr.xq68_u23.rsub[i]
print @c.xbgr.xq68_u23.csub[i]
print @q.xbgr.xq68_u24.qnpn13g2[ic]
print @q.xbgr.xq68_u24.qnpn13g2[ib]
print @q.xbgr.xq68_u24.qnpn13g2[ie]
print @q.xbgr.xq68_u24.qnpn13g2[is]
print @r.xbgr.xq68_u24.rsub[i]
print @c.xbgr.xq68_u24.csub[i]
print @q.xbgr.xq69_u2.qnpn13g2[ic]
print @q.xbgr.xq69_u2.qnpn13g2[ib]
print @q.xbgr.xq69_u2.qnpn13g2[ie]
print @q.xbgr.xq69_u2.qnpn13g2[is]
print @r.xbgr.xq69_u2.rsub[i]
print @c.xbgr.xq69_u2.csub[i]
print @q.xbgr.xq69_u3.qnpn13g2[ic]
print @q.xbgr.xq69_u3.qnpn13g2[ib]
print @q.xbgr.xq69_u3.qnpn13g2[ie]
print @q.xbgr.xq69_u3.qnpn13g2[is]
print @r.xbgr.xq69_u3.rsub[i]
print @c.xbgr.xq69_u3.csub[i]
print @q.xbgr.xq69_u4.qnpn13g2[ic]
print @q.xbgr.xq69_u4.qnpn13g2[ib]
print @q.xbgr.xq69_u4.qnpn13g2[ie]
print @q.xbgr.xq69_u4.qnpn13g2[is]
print @r.xbgr.xq69_u4.rsub[i]
print @c.xbgr.xq69_u4.csub[i]
print @q.xbgr.xq69_u5.qnpn13g2[ic]
print @q.xbgr.xq69_u5.qnpn13g2[ib]
print @q.xbgr.xq69_u5.qnpn13g2[ie]
print @q.xbgr.xq69_u5.qnpn13g2[is]
print @r.xbgr.xq69_u5.rsub[i]
print @c.xbgr.xq69_u5.csub[i]
print @q.xbgr.xq69_u6.qnpn13g2[ic]
print @q.xbgr.xq69_u6.qnpn13g2[ib]
print @q.xbgr.xq69_u6.qnpn13g2[ie]
print @q.xbgr.xq69_u6.qnpn13g2[is]
print @r.xbgr.xq69_u6.rsub[i]
print @c.xbgr.xq69_u6.csub[i]
print @q.xbgr.xq69_u7.qnpn13g2[ic]
print @q.xbgr.xq69_u7.qnpn13g2[ib]
print @q.xbgr.xq69_u7.qnpn13g2[ie]
print @q.xbgr.xq69_u7.qnpn13g2[is]
print @r.xbgr.xq69_u7.rsub[i]
print @c.xbgr.xq69_u7.csub[i]
print @q.xbgr.xq69_u8.qnpn13g2[ic]
print @q.xbgr.xq69_u8.qnpn13g2[ib]
print @q.xbgr.xq69_u8.qnpn13g2[ie]
print @q.xbgr.xq69_u8.qnpn13g2[is]
print @r.xbgr.xq69_u8.rsub[i]
print @c.xbgr.xq69_u8.csub[i]
print @q.xbgr.xq69_u9.qnpn13g2[ic]
print @q.xbgr.xq69_u9.qnpn13g2[ib]
print @q.xbgr.xq69_u9.qnpn13g2[ie]
print @q.xbgr.xq69_u9.qnpn13g2[is]
print @r.xbgr.xq69_u9.rsub[i]
print @c.xbgr.xq69_u9.csub[i]
print @q.xbgr.xq69_u10.qnpn13g2[ic]
print @q.xbgr.xq69_u10.qnpn13g2[ib]
print @q.xbgr.xq69_u10.qnpn13g2[ie]
print @q.xbgr.xq69_u10.qnpn13g2[is]
print @r.xbgr.xq69_u10.rsub[i]
print @c.xbgr.xq69_u10.csub[i]
print @q.xbgr.xq69_u11.qnpn13g2[ic]
print @q.xbgr.xq69_u11.qnpn13g2[ib]
print @q.xbgr.xq69_u11.qnpn13g2[ie]
print @q.xbgr.xq69_u11.qnpn13g2[is]
print @r.xbgr.xq69_u11.rsub[i]
print @c.xbgr.xq69_u11.csub[i]
print @q.xbgr.xq69_u12.qnpn13g2[ic]
print @q.xbgr.xq69_u12.qnpn13g2[ib]
print @q.xbgr.xq69_u12.qnpn13g2[ie]
print @q.xbgr.xq69_u12.qnpn13g2[is]
print @r.xbgr.xq69_u12.rsub[i]
print @c.xbgr.xq69_u12.csub[i]
print @q.xbgr.xq69_u13.qnpn13g2[ic]
print @q.xbgr.xq69_u13.qnpn13g2[ib]
print @q.xbgr.xq69_u13.qnpn13g2[ie]
print @q.xbgr.xq69_u13.qnpn13g2[is]
print @r.xbgr.xq69_u13.rsub[i]
print @c.xbgr.xq69_u13.csub[i]
print @q.xbgr.xq69_u14.qnpn13g2[ic]
print @q.xbgr.xq69_u14.qnpn13g2[ib]
print @q.xbgr.xq69_u14.qnpn13g2[ie]
print @q.xbgr.xq69_u14.qnpn13g2[is]
print @r.xbgr.xq69_u14.rsub[i]
print @c.xbgr.xq69_u14.csub[i]
print @q.xbgr.xq69_u15.qnpn13g2[ic]
print @q.xbgr.xq69_u15.qnpn13g2[ib]
print @q.xbgr.xq69_u15.qnpn13g2[ie]
print @q.xbgr.xq69_u15.qnpn13g2[is]
print @r.xbgr.xq69_u15.rsub[i]
print @c.xbgr.xq69_u15.csub[i]
print @q.xbgr.xq69_u16.qnpn13g2[ic]
print @q.xbgr.xq69_u16.qnpn13g2[ib]
print @q.xbgr.xq69_u16.qnpn13g2[ie]
print @q.xbgr.xq69_u16.qnpn13g2[is]
print @r.xbgr.xq69_u16.rsub[i]
print @c.xbgr.xq69_u16.csub[i]
print @q.xbgr.xq69_u17.qnpn13g2[ic]
print @q.xbgr.xq69_u17.qnpn13g2[ib]
print @q.xbgr.xq69_u17.qnpn13g2[ie]
print @q.xbgr.xq69_u17.qnpn13g2[is]
print @r.xbgr.xq69_u17.rsub[i]
print @c.xbgr.xq69_u17.csub[i]
print @q.xbgr.xq69_u18.qnpn13g2[ic]
print @q.xbgr.xq69_u18.qnpn13g2[ib]
print @q.xbgr.xq69_u18.qnpn13g2[ie]
print @q.xbgr.xq69_u18.qnpn13g2[is]
print @r.xbgr.xq69_u18.rsub[i]
print @c.xbgr.xq69_u18.csub[i]
print @q.xbgr.xq69_u19.qnpn13g2[ic]
print @q.xbgr.xq69_u19.qnpn13g2[ib]
print @q.xbgr.xq69_u19.qnpn13g2[ie]
print @q.xbgr.xq69_u19.qnpn13g2[is]
print @r.xbgr.xq69_u19.rsub[i]
print @c.xbgr.xq69_u19.csub[i]
print @q.xbgr.xq69_u20.qnpn13g2[ic]
print @q.xbgr.xq69_u20.qnpn13g2[ib]
print @q.xbgr.xq69_u20.qnpn13g2[ie]
print @q.xbgr.xq69_u20.qnpn13g2[is]
print @r.xbgr.xq69_u20.rsub[i]
print @c.xbgr.xq69_u20.csub[i]
print @q.xbgr.xq69_u21.qnpn13g2[ic]
print @q.xbgr.xq69_u21.qnpn13g2[ib]
print @q.xbgr.xq69_u21.qnpn13g2[ie]
print @q.xbgr.xq69_u21.qnpn13g2[is]
print @r.xbgr.xq69_u21.rsub[i]
print @c.xbgr.xq69_u21.csub[i]
print @q.xbgr.xq69_u22.qnpn13g2[ic]
print @q.xbgr.xq69_u22.qnpn13g2[ib]
print @q.xbgr.xq69_u22.qnpn13g2[ie]
print @q.xbgr.xq69_u22.qnpn13g2[is]
print @r.xbgr.xq69_u22.rsub[i]
print @c.xbgr.xq69_u22.csub[i]
print @q.xbgr.xq69_u23.qnpn13g2[ic]
print @q.xbgr.xq69_u23.qnpn13g2[ib]
print @q.xbgr.xq69_u23.qnpn13g2[ie]
print @q.xbgr.xq69_u23.qnpn13g2[is]
print @r.xbgr.xq69_u23.rsub[i]
print @c.xbgr.xq69_u23.csub[i]
print @q.xbgr.xq69_u24.qnpn13g2[ic]
print @q.xbgr.xq69_u24.qnpn13g2[ib]
print @q.xbgr.xq69_u24.qnpn13g2[ie]
print @q.xbgr.xq69_u24.qnpn13g2[is]
print @r.xbgr.xq69_u24.rsub[i]
print @c.xbgr.xq69_u24.csub[i]
print @q.xbgr.xq70_u2.qnpn13g2[ic]
print @q.xbgr.xq70_u2.qnpn13g2[ib]
print @q.xbgr.xq70_u2.qnpn13g2[ie]
print @q.xbgr.xq70_u2.qnpn13g2[is]
print @r.xbgr.xq70_u2.rsub[i]
print @c.xbgr.xq70_u2.csub[i]
print @q.xbgr.xq70_u3.qnpn13g2[ic]
print @q.xbgr.xq70_u3.qnpn13g2[ib]
print @q.xbgr.xq70_u3.qnpn13g2[ie]
print @q.xbgr.xq70_u3.qnpn13g2[is]
print @r.xbgr.xq70_u3.rsub[i]
print @c.xbgr.xq70_u3.csub[i]
print @q.xbgr.xq70_u4.qnpn13g2[ic]
print @q.xbgr.xq70_u4.qnpn13g2[ib]
print @q.xbgr.xq70_u4.qnpn13g2[ie]
print @q.xbgr.xq70_u4.qnpn13g2[is]
print @r.xbgr.xq70_u4.rsub[i]
print @c.xbgr.xq70_u4.csub[i]
print @q.xbgr.xq70_u5.qnpn13g2[ic]
print @q.xbgr.xq70_u5.qnpn13g2[ib]
print @q.xbgr.xq70_u5.qnpn13g2[ie]
print @q.xbgr.xq70_u5.qnpn13g2[is]
print @r.xbgr.xq70_u5.rsub[i]
print @c.xbgr.xq70_u5.csub[i]
print @q.xbgr.xq70_u6.qnpn13g2[ic]
print @q.xbgr.xq70_u6.qnpn13g2[ib]
print @q.xbgr.xq70_u6.qnpn13g2[ie]
print @q.xbgr.xq70_u6.qnpn13g2[is]
print @r.xbgr.xq70_u6.rsub[i]
print @c.xbgr.xq70_u6.csub[i]
print @q.xbgr.xq70_u7.qnpn13g2[ic]
print @q.xbgr.xq70_u7.qnpn13g2[ib]
print @q.xbgr.xq70_u7.qnpn13g2[ie]
print @q.xbgr.xq70_u7.qnpn13g2[is]
print @r.xbgr.xq70_u7.rsub[i]
print @c.xbgr.xq70_u7.csub[i]
print @q.xbgr.xq70_u8.qnpn13g2[ic]
print @q.xbgr.xq70_u8.qnpn13g2[ib]
print @q.xbgr.xq70_u8.qnpn13g2[ie]
print @q.xbgr.xq70_u8.qnpn13g2[is]
print @r.xbgr.xq70_u8.rsub[i]
print @c.xbgr.xq70_u8.csub[i]
print @q.xbgr.xq70_u9.qnpn13g2[ic]
print @q.xbgr.xq70_u9.qnpn13g2[ib]
print @q.xbgr.xq70_u9.qnpn13g2[ie]
print @q.xbgr.xq70_u9.qnpn13g2[is]
print @r.xbgr.xq70_u9.rsub[i]
print @c.xbgr.xq70_u9.csub[i]
print @q.xbgr.xq70_u10.qnpn13g2[ic]
print @q.xbgr.xq70_u10.qnpn13g2[ib]
print @q.xbgr.xq70_u10.qnpn13g2[ie]
print @q.xbgr.xq70_u10.qnpn13g2[is]
print @r.xbgr.xq70_u10.rsub[i]
print @c.xbgr.xq70_u10.csub[i]
print @q.xbgr.xq70_u11.qnpn13g2[ic]
print @q.xbgr.xq70_u11.qnpn13g2[ib]
print @q.xbgr.xq70_u11.qnpn13g2[ie]
print @q.xbgr.xq70_u11.qnpn13g2[is]
print @r.xbgr.xq70_u11.rsub[i]
print @c.xbgr.xq70_u11.csub[i]
print @q.xbgr.xq70_u12.qnpn13g2[ic]
print @q.xbgr.xq70_u12.qnpn13g2[ib]
print @q.xbgr.xq70_u12.qnpn13g2[ie]
print @q.xbgr.xq70_u12.qnpn13g2[is]
print @r.xbgr.xq70_u12.rsub[i]
print @c.xbgr.xq70_u12.csub[i]
print @q.xbgr.xq70_u13.qnpn13g2[ic]
print @q.xbgr.xq70_u13.qnpn13g2[ib]
print @q.xbgr.xq70_u13.qnpn13g2[ie]
print @q.xbgr.xq70_u13.qnpn13g2[is]
print @r.xbgr.xq70_u13.rsub[i]
print @c.xbgr.xq70_u13.csub[i]
print @q.xbgr.xq70_u14.qnpn13g2[ic]
print @q.xbgr.xq70_u14.qnpn13g2[ib]
print @q.xbgr.xq70_u14.qnpn13g2[ie]
print @q.xbgr.xq70_u14.qnpn13g2[is]
print @r.xbgr.xq70_u14.rsub[i]
print @c.xbgr.xq70_u14.csub[i]
print @q.xbgr.xq70_u15.qnpn13g2[ic]
print @q.xbgr.xq70_u15.qnpn13g2[ib]
print @q.xbgr.xq70_u15.qnpn13g2[ie]
print @q.xbgr.xq70_u15.qnpn13g2[is]
print @r.xbgr.xq70_u15.rsub[i]
print @c.xbgr.xq70_u15.csub[i]
print @q.xbgr.xq70_u16.qnpn13g2[ic]
print @q.xbgr.xq70_u16.qnpn13g2[ib]
print @q.xbgr.xq70_u16.qnpn13g2[ie]
print @q.xbgr.xq70_u16.qnpn13g2[is]
print @r.xbgr.xq70_u16.rsub[i]
print @c.xbgr.xq70_u16.csub[i]
print @q.xbgr.xq70_u17.qnpn13g2[ic]
print @q.xbgr.xq70_u17.qnpn13g2[ib]
print @q.xbgr.xq70_u17.qnpn13g2[ie]
print @q.xbgr.xq70_u17.qnpn13g2[is]
print @r.xbgr.xq70_u17.rsub[i]
print @c.xbgr.xq70_u17.csub[i]
print @q.xbgr.xq70_u18.qnpn13g2[ic]
print @q.xbgr.xq70_u18.qnpn13g2[ib]
print @q.xbgr.xq70_u18.qnpn13g2[ie]
print @q.xbgr.xq70_u18.qnpn13g2[is]
print @r.xbgr.xq70_u18.rsub[i]
print @c.xbgr.xq70_u18.csub[i]
print @q.xbgr.xq70_u19.qnpn13g2[ic]
print @q.xbgr.xq70_u19.qnpn13g2[ib]
print @q.xbgr.xq70_u19.qnpn13g2[ie]
print @q.xbgr.xq70_u19.qnpn13g2[is]
print @r.xbgr.xq70_u19.rsub[i]
print @c.xbgr.xq70_u19.csub[i]
print @q.xbgr.xq70_u20.qnpn13g2[ic]
print @q.xbgr.xq70_u20.qnpn13g2[ib]
print @q.xbgr.xq70_u20.qnpn13g2[ie]
print @q.xbgr.xq70_u20.qnpn13g2[is]
print @r.xbgr.xq70_u20.rsub[i]
print @c.xbgr.xq70_u20.csub[i]
print @q.xbgr.xq70_u21.qnpn13g2[ic]
print @q.xbgr.xq70_u21.qnpn13g2[ib]
print @q.xbgr.xq70_u21.qnpn13g2[ie]
print @q.xbgr.xq70_u21.qnpn13g2[is]
print @r.xbgr.xq70_u21.rsub[i]
print @c.xbgr.xq70_u21.csub[i]
print @q.xbgr.xq70_u22.qnpn13g2[ic]
print @q.xbgr.xq70_u22.qnpn13g2[ib]
print @q.xbgr.xq70_u22.qnpn13g2[ie]
print @q.xbgr.xq70_u22.qnpn13g2[is]
print @r.xbgr.xq70_u22.rsub[i]
print @c.xbgr.xq70_u22.csub[i]
print @q.xbgr.xq70_u23.qnpn13g2[ic]
print @q.xbgr.xq70_u23.qnpn13g2[ib]
print @q.xbgr.xq70_u23.qnpn13g2[ie]
print @q.xbgr.xq70_u23.qnpn13g2[is]
print @r.xbgr.xq70_u23.rsub[i]
print @c.xbgr.xq70_u23.csub[i]
print @q.xbgr.xq70_u24.qnpn13g2[ic]
print @q.xbgr.xq70_u24.qnpn13g2[ib]
print @q.xbgr.xq70_u24.qnpn13g2[ie]
print @q.xbgr.xq70_u24.qnpn13g2[is]
print @r.xbgr.xq70_u24.rsub[i]
print @c.xbgr.xq70_u24.csub[i]
print @q.xbgr.xq71_u2.qnpn13g2[ic]
print @q.xbgr.xq71_u2.qnpn13g2[ib]
print @q.xbgr.xq71_u2.qnpn13g2[ie]
print @q.xbgr.xq71_u2.qnpn13g2[is]
print @r.xbgr.xq71_u2.rsub[i]
print @c.xbgr.xq71_u2.csub[i]
print @q.xbgr.xq71_u3.qnpn13g2[ic]
print @q.xbgr.xq71_u3.qnpn13g2[ib]
print @q.xbgr.xq71_u3.qnpn13g2[ie]
print @q.xbgr.xq71_u3.qnpn13g2[is]
print @r.xbgr.xq71_u3.rsub[i]
print @c.xbgr.xq71_u3.csub[i]
print @q.xbgr.xq71_u4.qnpn13g2[ic]
print @q.xbgr.xq71_u4.qnpn13g2[ib]
print @q.xbgr.xq71_u4.qnpn13g2[ie]
print @q.xbgr.xq71_u4.qnpn13g2[is]
print @r.xbgr.xq71_u4.rsub[i]
print @c.xbgr.xq71_u4.csub[i]
print @q.xbgr.xq71_u5.qnpn13g2[ic]
print @q.xbgr.xq71_u5.qnpn13g2[ib]
print @q.xbgr.xq71_u5.qnpn13g2[ie]
print @q.xbgr.xq71_u5.qnpn13g2[is]
print @r.xbgr.xq71_u5.rsub[i]
print @c.xbgr.xq71_u5.csub[i]
print @q.xbgr.xq71_u6.qnpn13g2[ic]
print @q.xbgr.xq71_u6.qnpn13g2[ib]
print @q.xbgr.xq71_u6.qnpn13g2[ie]
print @q.xbgr.xq71_u6.qnpn13g2[is]
print @r.xbgr.xq71_u6.rsub[i]
print @c.xbgr.xq71_u6.csub[i]
print @q.xbgr.xq71_u7.qnpn13g2[ic]
print @q.xbgr.xq71_u7.qnpn13g2[ib]
print @q.xbgr.xq71_u7.qnpn13g2[ie]
print @q.xbgr.xq71_u7.qnpn13g2[is]
print @r.xbgr.xq71_u7.rsub[i]
print @c.xbgr.xq71_u7.csub[i]
print @q.xbgr.xq71_u8.qnpn13g2[ic]
print @q.xbgr.xq71_u8.qnpn13g2[ib]
print @q.xbgr.xq71_u8.qnpn13g2[ie]
print @q.xbgr.xq71_u8.qnpn13g2[is]
print @r.xbgr.xq71_u8.rsub[i]
print @c.xbgr.xq71_u8.csub[i]
print @q.xbgr.xq71_u9.qnpn13g2[ic]
print @q.xbgr.xq71_u9.qnpn13g2[ib]
print @q.xbgr.xq71_u9.qnpn13g2[ie]
print @q.xbgr.xq71_u9.qnpn13g2[is]
print @r.xbgr.xq71_u9.rsub[i]
print @c.xbgr.xq71_u9.csub[i]
print @q.xbgr.xq71_u10.qnpn13g2[ic]
print @q.xbgr.xq71_u10.qnpn13g2[ib]
print @q.xbgr.xq71_u10.qnpn13g2[ie]
print @q.xbgr.xq71_u10.qnpn13g2[is]
print @r.xbgr.xq71_u10.rsub[i]
print @c.xbgr.xq71_u10.csub[i]
print @q.xbgr.xq71_u11.qnpn13g2[ic]
print @q.xbgr.xq71_u11.qnpn13g2[ib]
print @q.xbgr.xq71_u11.qnpn13g2[ie]
print @q.xbgr.xq71_u11.qnpn13g2[is]
print @r.xbgr.xq71_u11.rsub[i]
print @c.xbgr.xq71_u11.csub[i]
print @q.xbgr.xq71_u12.qnpn13g2[ic]
print @q.xbgr.xq71_u12.qnpn13g2[ib]
print @q.xbgr.xq71_u12.qnpn13g2[ie]
print @q.xbgr.xq71_u12.qnpn13g2[is]
print @r.xbgr.xq71_u12.rsub[i]
print @c.xbgr.xq71_u12.csub[i]
print @q.xbgr.xq71_u13.qnpn13g2[ic]
print @q.xbgr.xq71_u13.qnpn13g2[ib]
print @q.xbgr.xq71_u13.qnpn13g2[ie]
print @q.xbgr.xq71_u13.qnpn13g2[is]
print @r.xbgr.xq71_u13.rsub[i]
print @c.xbgr.xq71_u13.csub[i]
print @q.xbgr.xq71_u14.qnpn13g2[ic]
print @q.xbgr.xq71_u14.qnpn13g2[ib]
print @q.xbgr.xq71_u14.qnpn13g2[ie]
print @q.xbgr.xq71_u14.qnpn13g2[is]
print @r.xbgr.xq71_u14.rsub[i]
print @c.xbgr.xq71_u14.csub[i]
print @q.xbgr.xq71_u15.qnpn13g2[ic]
print @q.xbgr.xq71_u15.qnpn13g2[ib]
print @q.xbgr.xq71_u15.qnpn13g2[ie]
print @q.xbgr.xq71_u15.qnpn13g2[is]
print @r.xbgr.xq71_u15.rsub[i]
print @c.xbgr.xq71_u15.csub[i]
print @q.xbgr.xq71_u16.qnpn13g2[ic]
print @q.xbgr.xq71_u16.qnpn13g2[ib]
print @q.xbgr.xq71_u16.qnpn13g2[ie]
print @q.xbgr.xq71_u16.qnpn13g2[is]
print @r.xbgr.xq71_u16.rsub[i]
print @c.xbgr.xq71_u16.csub[i]
print @q.xbgr.xq71_u17.qnpn13g2[ic]
print @q.xbgr.xq71_u17.qnpn13g2[ib]
print @q.xbgr.xq71_u17.qnpn13g2[ie]
print @q.xbgr.xq71_u17.qnpn13g2[is]
print @r.xbgr.xq71_u17.rsub[i]
print @c.xbgr.xq71_u17.csub[i]
print @q.xbgr.xq71_u18.qnpn13g2[ic]
print @q.xbgr.xq71_u18.qnpn13g2[ib]
print @q.xbgr.xq71_u18.qnpn13g2[ie]
print @q.xbgr.xq71_u18.qnpn13g2[is]
print @r.xbgr.xq71_u18.rsub[i]
print @c.xbgr.xq71_u18.csub[i]
print @q.xbgr.xq71_u19.qnpn13g2[ic]
print @q.xbgr.xq71_u19.qnpn13g2[ib]
print @q.xbgr.xq71_u19.qnpn13g2[ie]
print @q.xbgr.xq71_u19.qnpn13g2[is]
print @r.xbgr.xq71_u19.rsub[i]
print @c.xbgr.xq71_u19.csub[i]
print @q.xbgr.xq71_u20.qnpn13g2[ic]
print @q.xbgr.xq71_u20.qnpn13g2[ib]
print @q.xbgr.xq71_u20.qnpn13g2[ie]
print @q.xbgr.xq71_u20.qnpn13g2[is]
print @r.xbgr.xq71_u20.rsub[i]
print @c.xbgr.xq71_u20.csub[i]
print @q.xbgr.xq71_u21.qnpn13g2[ic]
print @q.xbgr.xq71_u21.qnpn13g2[ib]
print @q.xbgr.xq71_u21.qnpn13g2[ie]
print @q.xbgr.xq71_u21.qnpn13g2[is]
print @r.xbgr.xq71_u21.rsub[i]
print @c.xbgr.xq71_u21.csub[i]
print @q.xbgr.xq71_u22.qnpn13g2[ic]
print @q.xbgr.xq71_u22.qnpn13g2[ib]
print @q.xbgr.xq71_u22.qnpn13g2[ie]
print @q.xbgr.xq71_u22.qnpn13g2[is]
print @r.xbgr.xq71_u22.rsub[i]
print @c.xbgr.xq71_u22.csub[i]
print @q.xbgr.xq71_u23.qnpn13g2[ic]
print @q.xbgr.xq71_u23.qnpn13g2[ib]
print @q.xbgr.xq71_u23.qnpn13g2[ie]
print @q.xbgr.xq71_u23.qnpn13g2[is]
print @r.xbgr.xq71_u23.rsub[i]
print @c.xbgr.xq71_u23.csub[i]
print @q.xbgr.xq71_u24.qnpn13g2[ic]
print @q.xbgr.xq71_u24.qnpn13g2[ib]
print @q.xbgr.xq71_u24.qnpn13g2[ie]
print @q.xbgr.xq71_u24.qnpn13g2[is]
print @r.xbgr.xq71_u24.rsub[i]
print @c.xbgr.xq71_u24.csub[i]
print @q.xbgr.xq72_u2.qnpn13g2[ic]
print @q.xbgr.xq72_u2.qnpn13g2[ib]
print @q.xbgr.xq72_u2.qnpn13g2[ie]
print @q.xbgr.xq72_u2.qnpn13g2[is]
print @r.xbgr.xq72_u2.rsub[i]
print @c.xbgr.xq72_u2.csub[i]
print @q.xbgr.xq72_u3.qnpn13g2[ic]
print @q.xbgr.xq72_u3.qnpn13g2[ib]
print @q.xbgr.xq72_u3.qnpn13g2[ie]
print @q.xbgr.xq72_u3.qnpn13g2[is]
print @r.xbgr.xq72_u3.rsub[i]
print @c.xbgr.xq72_u3.csub[i]
print @q.xbgr.xq72_u4.qnpn13g2[ic]
print @q.xbgr.xq72_u4.qnpn13g2[ib]
print @q.xbgr.xq72_u4.qnpn13g2[ie]
print @q.xbgr.xq72_u4.qnpn13g2[is]
print @r.xbgr.xq72_u4.rsub[i]
print @c.xbgr.xq72_u4.csub[i]
print @q.xbgr.xq72_u5.qnpn13g2[ic]
print @q.xbgr.xq72_u5.qnpn13g2[ib]
print @q.xbgr.xq72_u5.qnpn13g2[ie]
print @q.xbgr.xq72_u5.qnpn13g2[is]
print @r.xbgr.xq72_u5.rsub[i]
print @c.xbgr.xq72_u5.csub[i]
print @q.xbgr.xq72_u6.qnpn13g2[ic]
print @q.xbgr.xq72_u6.qnpn13g2[ib]
print @q.xbgr.xq72_u6.qnpn13g2[ie]
print @q.xbgr.xq72_u6.qnpn13g2[is]
print @r.xbgr.xq72_u6.rsub[i]
print @c.xbgr.xq72_u6.csub[i]
print @q.xbgr.xq72_u7.qnpn13g2[ic]
print @q.xbgr.xq72_u7.qnpn13g2[ib]
print @q.xbgr.xq72_u7.qnpn13g2[ie]
print @q.xbgr.xq72_u7.qnpn13g2[is]
print @r.xbgr.xq72_u7.rsub[i]
print @c.xbgr.xq72_u7.csub[i]
print @q.xbgr.xq72_u8.qnpn13g2[ic]
print @q.xbgr.xq72_u8.qnpn13g2[ib]
print @q.xbgr.xq72_u8.qnpn13g2[ie]
print @q.xbgr.xq72_u8.qnpn13g2[is]
print @r.xbgr.xq72_u8.rsub[i]
print @c.xbgr.xq72_u8.csub[i]
print @q.xbgr.xq72_u9.qnpn13g2[ic]
print @q.xbgr.xq72_u9.qnpn13g2[ib]
print @q.xbgr.xq72_u9.qnpn13g2[ie]
print @q.xbgr.xq72_u9.qnpn13g2[is]
print @r.xbgr.xq72_u9.rsub[i]
print @c.xbgr.xq72_u9.csub[i]
print @q.xbgr.xq72_u10.qnpn13g2[ic]
print @q.xbgr.xq72_u10.qnpn13g2[ib]
print @q.xbgr.xq72_u10.qnpn13g2[ie]
print @q.xbgr.xq72_u10.qnpn13g2[is]
print @r.xbgr.xq72_u10.rsub[i]
print @c.xbgr.xq72_u10.csub[i]
print @q.xbgr.xq72_u11.qnpn13g2[ic]
print @q.xbgr.xq72_u11.qnpn13g2[ib]
print @q.xbgr.xq72_u11.qnpn13g2[ie]
print @q.xbgr.xq72_u11.qnpn13g2[is]
print @r.xbgr.xq72_u11.rsub[i]
print @c.xbgr.xq72_u11.csub[i]
print @q.xbgr.xq72_u12.qnpn13g2[ic]
print @q.xbgr.xq72_u12.qnpn13g2[ib]
print @q.xbgr.xq72_u12.qnpn13g2[ie]
print @q.xbgr.xq72_u12.qnpn13g2[is]
print @r.xbgr.xq72_u12.rsub[i]
print @c.xbgr.xq72_u12.csub[i]
print @q.xbgr.xq72_u13.qnpn13g2[ic]
print @q.xbgr.xq72_u13.qnpn13g2[ib]
print @q.xbgr.xq72_u13.qnpn13g2[ie]
print @q.xbgr.xq72_u13.qnpn13g2[is]
print @r.xbgr.xq72_u13.rsub[i]
print @c.xbgr.xq72_u13.csub[i]
print @q.xbgr.xq72_u14.qnpn13g2[ic]
print @q.xbgr.xq72_u14.qnpn13g2[ib]
print @q.xbgr.xq72_u14.qnpn13g2[ie]
print @q.xbgr.xq72_u14.qnpn13g2[is]
print @r.xbgr.xq72_u14.rsub[i]
print @c.xbgr.xq72_u14.csub[i]
print @q.xbgr.xq72_u15.qnpn13g2[ic]
print @q.xbgr.xq72_u15.qnpn13g2[ib]
print @q.xbgr.xq72_u15.qnpn13g2[ie]
print @q.xbgr.xq72_u15.qnpn13g2[is]
print @r.xbgr.xq72_u15.rsub[i]
print @c.xbgr.xq72_u15.csub[i]
print @q.xbgr.xq72_u16.qnpn13g2[ic]
print @q.xbgr.xq72_u16.qnpn13g2[ib]
print @q.xbgr.xq72_u16.qnpn13g2[ie]
print @q.xbgr.xq72_u16.qnpn13g2[is]
print @r.xbgr.xq72_u16.rsub[i]
print @c.xbgr.xq72_u16.csub[i]
print @q.xbgr.xq72_u17.qnpn13g2[ic]
print @q.xbgr.xq72_u17.qnpn13g2[ib]
print @q.xbgr.xq72_u17.qnpn13g2[ie]
print @q.xbgr.xq72_u17.qnpn13g2[is]
print @r.xbgr.xq72_u17.rsub[i]
print @c.xbgr.xq72_u17.csub[i]
print @q.xbgr.xq72_u18.qnpn13g2[ic]
print @q.xbgr.xq72_u18.qnpn13g2[ib]
print @q.xbgr.xq72_u18.qnpn13g2[ie]
print @q.xbgr.xq72_u18.qnpn13g2[is]
print @r.xbgr.xq72_u18.rsub[i]
print @c.xbgr.xq72_u18.csub[i]
print @q.xbgr.xq72_u19.qnpn13g2[ic]
print @q.xbgr.xq72_u19.qnpn13g2[ib]
print @q.xbgr.xq72_u19.qnpn13g2[ie]
print @q.xbgr.xq72_u19.qnpn13g2[is]
print @r.xbgr.xq72_u19.rsub[i]
print @c.xbgr.xq72_u19.csub[i]
print @q.xbgr.xq72_u20.qnpn13g2[ic]
print @q.xbgr.xq72_u20.qnpn13g2[ib]
print @q.xbgr.xq72_u20.qnpn13g2[ie]
print @q.xbgr.xq72_u20.qnpn13g2[is]
print @r.xbgr.xq72_u20.rsub[i]
print @c.xbgr.xq72_u20.csub[i]
print @q.xbgr.xq72_u21.qnpn13g2[ic]
print @q.xbgr.xq72_u21.qnpn13g2[ib]
print @q.xbgr.xq72_u21.qnpn13g2[ie]
print @q.xbgr.xq72_u21.qnpn13g2[is]
print @r.xbgr.xq72_u21.rsub[i]
print @c.xbgr.xq72_u21.csub[i]
print @q.xbgr.xq72_u22.qnpn13g2[ic]
print @q.xbgr.xq72_u22.qnpn13g2[ib]
print @q.xbgr.xq72_u22.qnpn13g2[ie]
print @q.xbgr.xq72_u22.qnpn13g2[is]
print @r.xbgr.xq72_u22.rsub[i]
print @c.xbgr.xq72_u22.csub[i]
print @q.xbgr.xq72_u23.qnpn13g2[ic]
print @q.xbgr.xq72_u23.qnpn13g2[ib]
print @q.xbgr.xq72_u23.qnpn13g2[ie]
print @q.xbgr.xq72_u23.qnpn13g2[is]
print @r.xbgr.xq72_u23.rsub[i]
print @c.xbgr.xq72_u23.csub[i]
print @q.xbgr.xq72_u24.qnpn13g2[ic]
print @q.xbgr.xq72_u24.qnpn13g2[ib]
print @q.xbgr.xq72_u24.qnpn13g2[ie]
print @q.xbgr.xq72_u24.qnpn13g2[is]
print @r.xbgr.xq72_u24.rsub[i]
print @c.xbgr.xq72_u24.csub[i]
print @q.xbgr.xq73_u2.qnpn13g2[ic]
print @q.xbgr.xq73_u2.qnpn13g2[ib]
print @q.xbgr.xq73_u2.qnpn13g2[ie]
print @q.xbgr.xq73_u2.qnpn13g2[is]
print @r.xbgr.xq73_u2.rsub[i]
print @c.xbgr.xq73_u2.csub[i]
print @q.xbgr.xq73_u3.qnpn13g2[ic]
print @q.xbgr.xq73_u3.qnpn13g2[ib]
print @q.xbgr.xq73_u3.qnpn13g2[ie]
print @q.xbgr.xq73_u3.qnpn13g2[is]
print @r.xbgr.xq73_u3.rsub[i]
print @c.xbgr.xq73_u3.csub[i]
print @q.xbgr.xq73_u4.qnpn13g2[ic]
print @q.xbgr.xq73_u4.qnpn13g2[ib]
print @q.xbgr.xq73_u4.qnpn13g2[ie]
print @q.xbgr.xq73_u4.qnpn13g2[is]
print @r.xbgr.xq73_u4.rsub[i]
print @c.xbgr.xq73_u4.csub[i]
print @q.xbgr.xq73_u5.qnpn13g2[ic]
print @q.xbgr.xq73_u5.qnpn13g2[ib]
print @q.xbgr.xq73_u5.qnpn13g2[ie]
print @q.xbgr.xq73_u5.qnpn13g2[is]
print @r.xbgr.xq73_u5.rsub[i]
print @c.xbgr.xq73_u5.csub[i]
print @q.xbgr.xq73_u6.qnpn13g2[ic]
print @q.xbgr.xq73_u6.qnpn13g2[ib]
print @q.xbgr.xq73_u6.qnpn13g2[ie]
print @q.xbgr.xq73_u6.qnpn13g2[is]
print @r.xbgr.xq73_u6.rsub[i]
print @c.xbgr.xq73_u6.csub[i]
print @q.xbgr.xq73_u7.qnpn13g2[ic]
print @q.xbgr.xq73_u7.qnpn13g2[ib]
print @q.xbgr.xq73_u7.qnpn13g2[ie]
print @q.xbgr.xq73_u7.qnpn13g2[is]
print @r.xbgr.xq73_u7.rsub[i]
print @c.xbgr.xq73_u7.csub[i]
print @q.xbgr.xq73_u8.qnpn13g2[ic]
print @q.xbgr.xq73_u8.qnpn13g2[ib]
print @q.xbgr.xq73_u8.qnpn13g2[ie]
print @q.xbgr.xq73_u8.qnpn13g2[is]
print @r.xbgr.xq73_u8.rsub[i]
print @c.xbgr.xq73_u8.csub[i]
print @q.xbgr.xq73_u9.qnpn13g2[ic]
print @q.xbgr.xq73_u9.qnpn13g2[ib]
print @q.xbgr.xq73_u9.qnpn13g2[ie]
print @q.xbgr.xq73_u9.qnpn13g2[is]
print @r.xbgr.xq73_u9.rsub[i]
print @c.xbgr.xq73_u9.csub[i]
print @q.xbgr.xq73_u10.qnpn13g2[ic]
print @q.xbgr.xq73_u10.qnpn13g2[ib]
print @q.xbgr.xq73_u10.qnpn13g2[ie]
print @q.xbgr.xq73_u10.qnpn13g2[is]
print @r.xbgr.xq73_u10.rsub[i]
print @c.xbgr.xq73_u10.csub[i]
print @q.xbgr.xq73_u11.qnpn13g2[ic]
print @q.xbgr.xq73_u11.qnpn13g2[ib]
print @q.xbgr.xq73_u11.qnpn13g2[ie]
print @q.xbgr.xq73_u11.qnpn13g2[is]
print @r.xbgr.xq73_u11.rsub[i]
print @c.xbgr.xq73_u11.csub[i]
print @q.xbgr.xq73_u12.qnpn13g2[ic]
print @q.xbgr.xq73_u12.qnpn13g2[ib]
print @q.xbgr.xq73_u12.qnpn13g2[ie]
print @q.xbgr.xq73_u12.qnpn13g2[is]
print @r.xbgr.xq73_u12.rsub[i]
print @c.xbgr.xq73_u12.csub[i]
print @q.xbgr.xq73_u13.qnpn13g2[ic]
print @q.xbgr.xq73_u13.qnpn13g2[ib]
print @q.xbgr.xq73_u13.qnpn13g2[ie]
print @q.xbgr.xq73_u13.qnpn13g2[is]
print @r.xbgr.xq73_u13.rsub[i]
print @c.xbgr.xq73_u13.csub[i]
print @q.xbgr.xq73_u14.qnpn13g2[ic]
print @q.xbgr.xq73_u14.qnpn13g2[ib]
print @q.xbgr.xq73_u14.qnpn13g2[ie]
print @q.xbgr.xq73_u14.qnpn13g2[is]
print @r.xbgr.xq73_u14.rsub[i]
print @c.xbgr.xq73_u14.csub[i]
print @q.xbgr.xq73_u15.qnpn13g2[ic]
print @q.xbgr.xq73_u15.qnpn13g2[ib]
print @q.xbgr.xq73_u15.qnpn13g2[ie]
print @q.xbgr.xq73_u15.qnpn13g2[is]
print @r.xbgr.xq73_u15.rsub[i]
print @c.xbgr.xq73_u15.csub[i]
print @q.xbgr.xq73_u16.qnpn13g2[ic]
print @q.xbgr.xq73_u16.qnpn13g2[ib]
print @q.xbgr.xq73_u16.qnpn13g2[ie]
print @q.xbgr.xq73_u16.qnpn13g2[is]
print @r.xbgr.xq73_u16.rsub[i]
print @c.xbgr.xq73_u16.csub[i]
print @q.xbgr.xq73_u17.qnpn13g2[ic]
print @q.xbgr.xq73_u17.qnpn13g2[ib]
print @q.xbgr.xq73_u17.qnpn13g2[ie]
print @q.xbgr.xq73_u17.qnpn13g2[is]
print @r.xbgr.xq73_u17.rsub[i]
print @c.xbgr.xq73_u17.csub[i]
print @q.xbgr.xq73_u18.qnpn13g2[ic]
print @q.xbgr.xq73_u18.qnpn13g2[ib]
print @q.xbgr.xq73_u18.qnpn13g2[ie]
print @q.xbgr.xq73_u18.qnpn13g2[is]
print @r.xbgr.xq73_u18.rsub[i]
print @c.xbgr.xq73_u18.csub[i]
print @q.xbgr.xq73_u19.qnpn13g2[ic]
print @q.xbgr.xq73_u19.qnpn13g2[ib]
print @q.xbgr.xq73_u19.qnpn13g2[ie]
print @q.xbgr.xq73_u19.qnpn13g2[is]
print @r.xbgr.xq73_u19.rsub[i]
print @c.xbgr.xq73_u19.csub[i]
print @q.xbgr.xq73_u20.qnpn13g2[ic]
print @q.xbgr.xq73_u20.qnpn13g2[ib]
print @q.xbgr.xq73_u20.qnpn13g2[ie]
print @q.xbgr.xq73_u20.qnpn13g2[is]
print @r.xbgr.xq73_u20.rsub[i]
print @c.xbgr.xq73_u20.csub[i]
print @q.xbgr.xq73_u21.qnpn13g2[ic]
print @q.xbgr.xq73_u21.qnpn13g2[ib]
print @q.xbgr.xq73_u21.qnpn13g2[ie]
print @q.xbgr.xq73_u21.qnpn13g2[is]
print @r.xbgr.xq73_u21.rsub[i]
print @c.xbgr.xq73_u21.csub[i]
print @q.xbgr.xq73_u22.qnpn13g2[ic]
print @q.xbgr.xq73_u22.qnpn13g2[ib]
print @q.xbgr.xq73_u22.qnpn13g2[ie]
print @q.xbgr.xq73_u22.qnpn13g2[is]
print @r.xbgr.xq73_u22.rsub[i]
print @c.xbgr.xq73_u22.csub[i]
print @q.xbgr.xq73_u23.qnpn13g2[ic]
print @q.xbgr.xq73_u23.qnpn13g2[ib]
print @q.xbgr.xq73_u23.qnpn13g2[ie]
print @q.xbgr.xq73_u23.qnpn13g2[is]
print @r.xbgr.xq73_u23.rsub[i]
print @c.xbgr.xq73_u23.csub[i]
print @q.xbgr.xq73_u24.qnpn13g2[ic]
print @q.xbgr.xq73_u24.qnpn13g2[ib]
print @q.xbgr.xq73_u24.qnpn13g2[ie]
print @q.xbgr.xq73_u24.qnpn13g2[is]
print @r.xbgr.xq73_u24.rsub[i]
print @c.xbgr.xq73_u24.csub[i]
print @q.xbgr.xq74_u2.qnpn13g2[ic]
print @q.xbgr.xq74_u2.qnpn13g2[ib]
print @q.xbgr.xq74_u2.qnpn13g2[ie]
print @q.xbgr.xq74_u2.qnpn13g2[is]
print @r.xbgr.xq74_u2.rsub[i]
print @c.xbgr.xq74_u2.csub[i]
print @q.xbgr.xq74_u3.qnpn13g2[ic]
print @q.xbgr.xq74_u3.qnpn13g2[ib]
print @q.xbgr.xq74_u3.qnpn13g2[ie]
print @q.xbgr.xq74_u3.qnpn13g2[is]
print @r.xbgr.xq74_u3.rsub[i]
print @c.xbgr.xq74_u3.csub[i]
print @q.xbgr.xq74_u4.qnpn13g2[ic]
print @q.xbgr.xq74_u4.qnpn13g2[ib]
print @q.xbgr.xq74_u4.qnpn13g2[ie]
print @q.xbgr.xq74_u4.qnpn13g2[is]
print @r.xbgr.xq74_u4.rsub[i]
print @c.xbgr.xq74_u4.csub[i]
print @q.xbgr.xq74_u5.qnpn13g2[ic]
print @q.xbgr.xq74_u5.qnpn13g2[ib]
print @q.xbgr.xq74_u5.qnpn13g2[ie]
print @q.xbgr.xq74_u5.qnpn13g2[is]
print @r.xbgr.xq74_u5.rsub[i]
print @c.xbgr.xq74_u5.csub[i]
print @q.xbgr.xq74_u6.qnpn13g2[ic]
print @q.xbgr.xq74_u6.qnpn13g2[ib]
print @q.xbgr.xq74_u6.qnpn13g2[ie]
print @q.xbgr.xq74_u6.qnpn13g2[is]
print @r.xbgr.xq74_u6.rsub[i]
print @c.xbgr.xq74_u6.csub[i]
print @q.xbgr.xq74_u7.qnpn13g2[ic]
print @q.xbgr.xq74_u7.qnpn13g2[ib]
print @q.xbgr.xq74_u7.qnpn13g2[ie]
print @q.xbgr.xq74_u7.qnpn13g2[is]
print @r.xbgr.xq74_u7.rsub[i]
print @c.xbgr.xq74_u7.csub[i]
print @q.xbgr.xq74_u8.qnpn13g2[ic]
print @q.xbgr.xq74_u8.qnpn13g2[ib]
print @q.xbgr.xq74_u8.qnpn13g2[ie]
print @q.xbgr.xq74_u8.qnpn13g2[is]
print @r.xbgr.xq74_u8.rsub[i]
print @c.xbgr.xq74_u8.csub[i]
print @q.xbgr.xq74_u9.qnpn13g2[ic]
print @q.xbgr.xq74_u9.qnpn13g2[ib]
print @q.xbgr.xq74_u9.qnpn13g2[ie]
print @q.xbgr.xq74_u9.qnpn13g2[is]
print @r.xbgr.xq74_u9.rsub[i]
print @c.xbgr.xq74_u9.csub[i]
print @q.xbgr.xq74_u10.qnpn13g2[ic]
print @q.xbgr.xq74_u10.qnpn13g2[ib]
print @q.xbgr.xq74_u10.qnpn13g2[ie]
print @q.xbgr.xq74_u10.qnpn13g2[is]
print @r.xbgr.xq74_u10.rsub[i]
print @c.xbgr.xq74_u10.csub[i]
print @q.xbgr.xq74_u11.qnpn13g2[ic]
print @q.xbgr.xq74_u11.qnpn13g2[ib]
print @q.xbgr.xq74_u11.qnpn13g2[ie]
print @q.xbgr.xq74_u11.qnpn13g2[is]
print @r.xbgr.xq74_u11.rsub[i]
print @c.xbgr.xq74_u11.csub[i]
print @q.xbgr.xq74_u12.qnpn13g2[ic]
print @q.xbgr.xq74_u12.qnpn13g2[ib]
print @q.xbgr.xq74_u12.qnpn13g2[ie]
print @q.xbgr.xq74_u12.qnpn13g2[is]
print @r.xbgr.xq74_u12.rsub[i]
print @c.xbgr.xq74_u12.csub[i]
print @q.xbgr.xq74_u13.qnpn13g2[ic]
print @q.xbgr.xq74_u13.qnpn13g2[ib]
print @q.xbgr.xq74_u13.qnpn13g2[ie]
print @q.xbgr.xq74_u13.qnpn13g2[is]
print @r.xbgr.xq74_u13.rsub[i]
print @c.xbgr.xq74_u13.csub[i]
print @q.xbgr.xq74_u14.qnpn13g2[ic]
print @q.xbgr.xq74_u14.qnpn13g2[ib]
print @q.xbgr.xq74_u14.qnpn13g2[ie]
print @q.xbgr.xq74_u14.qnpn13g2[is]
print @r.xbgr.xq74_u14.rsub[i]
print @c.xbgr.xq74_u14.csub[i]
print @q.xbgr.xq74_u15.qnpn13g2[ic]
print @q.xbgr.xq74_u15.qnpn13g2[ib]
print @q.xbgr.xq74_u15.qnpn13g2[ie]
print @q.xbgr.xq74_u15.qnpn13g2[is]
print @r.xbgr.xq74_u15.rsub[i]
print @c.xbgr.xq74_u15.csub[i]
print @q.xbgr.xq74_u16.qnpn13g2[ic]
print @q.xbgr.xq74_u16.qnpn13g2[ib]
print @q.xbgr.xq74_u16.qnpn13g2[ie]
print @q.xbgr.xq74_u16.qnpn13g2[is]
print @r.xbgr.xq74_u16.rsub[i]
print @c.xbgr.xq74_u16.csub[i]
print @q.xbgr.xq74_u17.qnpn13g2[ic]
print @q.xbgr.xq74_u17.qnpn13g2[ib]
print @q.xbgr.xq74_u17.qnpn13g2[ie]
print @q.xbgr.xq74_u17.qnpn13g2[is]
print @r.xbgr.xq74_u17.rsub[i]
print @c.xbgr.xq74_u17.csub[i]
print @q.xbgr.xq74_u18.qnpn13g2[ic]
print @q.xbgr.xq74_u18.qnpn13g2[ib]
print @q.xbgr.xq74_u18.qnpn13g2[ie]
print @q.xbgr.xq74_u18.qnpn13g2[is]
print @r.xbgr.xq74_u18.rsub[i]
print @c.xbgr.xq74_u18.csub[i]
print @q.xbgr.xq74_u19.qnpn13g2[ic]
print @q.xbgr.xq74_u19.qnpn13g2[ib]
print @q.xbgr.xq74_u19.qnpn13g2[ie]
print @q.xbgr.xq74_u19.qnpn13g2[is]
print @r.xbgr.xq74_u19.rsub[i]
print @c.xbgr.xq74_u19.csub[i]
print @q.xbgr.xq74_u20.qnpn13g2[ic]
print @q.xbgr.xq74_u20.qnpn13g2[ib]
print @q.xbgr.xq74_u20.qnpn13g2[ie]
print @q.xbgr.xq74_u20.qnpn13g2[is]
print @r.xbgr.xq74_u20.rsub[i]
print @c.xbgr.xq74_u20.csub[i]
print @q.xbgr.xq74_u21.qnpn13g2[ic]
print @q.xbgr.xq74_u21.qnpn13g2[ib]
print @q.xbgr.xq74_u21.qnpn13g2[ie]
print @q.xbgr.xq74_u21.qnpn13g2[is]
print @r.xbgr.xq74_u21.rsub[i]
print @c.xbgr.xq74_u21.csub[i]
print @q.xbgr.xq74_u22.qnpn13g2[ic]
print @q.xbgr.xq74_u22.qnpn13g2[ib]
print @q.xbgr.xq74_u22.qnpn13g2[ie]
print @q.xbgr.xq74_u22.qnpn13g2[is]
print @r.xbgr.xq74_u22.rsub[i]
print @c.xbgr.xq74_u22.csub[i]
print @q.xbgr.xq74_u23.qnpn13g2[ic]
print @q.xbgr.xq74_u23.qnpn13g2[ib]
print @q.xbgr.xq74_u23.qnpn13g2[ie]
print @q.xbgr.xq74_u23.qnpn13g2[is]
print @r.xbgr.xq74_u23.rsub[i]
print @c.xbgr.xq74_u23.csub[i]
print @q.xbgr.xq74_u24.qnpn13g2[ic]
print @q.xbgr.xq74_u24.qnpn13g2[ib]
print @q.xbgr.xq74_u24.qnpn13g2[ie]
print @q.xbgr.xq74_u24.qnpn13g2[is]
print @r.xbgr.xq74_u24.rsub[i]
print @c.xbgr.xq74_u24.csub[i]
print @q.xbgr.xq75_u2.qnpn13g2[ic]
print @q.xbgr.xq75_u2.qnpn13g2[ib]
print @q.xbgr.xq75_u2.qnpn13g2[ie]
print @q.xbgr.xq75_u2.qnpn13g2[is]
print @r.xbgr.xq75_u2.rsub[i]
print @c.xbgr.xq75_u2.csub[i]
print @q.xbgr.xq75_u3.qnpn13g2[ic]
print @q.xbgr.xq75_u3.qnpn13g2[ib]
print @q.xbgr.xq75_u3.qnpn13g2[ie]
print @q.xbgr.xq75_u3.qnpn13g2[is]
print @r.xbgr.xq75_u3.rsub[i]
print @c.xbgr.xq75_u3.csub[i]
print @q.xbgr.xq75_u4.qnpn13g2[ic]
print @q.xbgr.xq75_u4.qnpn13g2[ib]
print @q.xbgr.xq75_u4.qnpn13g2[ie]
print @q.xbgr.xq75_u4.qnpn13g2[is]
print @r.xbgr.xq75_u4.rsub[i]
print @c.xbgr.xq75_u4.csub[i]
print @q.xbgr.xq75_u5.qnpn13g2[ic]
print @q.xbgr.xq75_u5.qnpn13g2[ib]
print @q.xbgr.xq75_u5.qnpn13g2[ie]
print @q.xbgr.xq75_u5.qnpn13g2[is]
print @r.xbgr.xq75_u5.rsub[i]
print @c.xbgr.xq75_u5.csub[i]
print @q.xbgr.xq75_u6.qnpn13g2[ic]
print @q.xbgr.xq75_u6.qnpn13g2[ib]
print @q.xbgr.xq75_u6.qnpn13g2[ie]
print @q.xbgr.xq75_u6.qnpn13g2[is]
print @r.xbgr.xq75_u6.rsub[i]
print @c.xbgr.xq75_u6.csub[i]
print @q.xbgr.xq75_u7.qnpn13g2[ic]
print @q.xbgr.xq75_u7.qnpn13g2[ib]
print @q.xbgr.xq75_u7.qnpn13g2[ie]
print @q.xbgr.xq75_u7.qnpn13g2[is]
print @r.xbgr.xq75_u7.rsub[i]
print @c.xbgr.xq75_u7.csub[i]
print @q.xbgr.xq75_u8.qnpn13g2[ic]
print @q.xbgr.xq75_u8.qnpn13g2[ib]
print @q.xbgr.xq75_u8.qnpn13g2[ie]
print @q.xbgr.xq75_u8.qnpn13g2[is]
print @r.xbgr.xq75_u8.rsub[i]
print @c.xbgr.xq75_u8.csub[i]
print @q.xbgr.xq75_u9.qnpn13g2[ic]
print @q.xbgr.xq75_u9.qnpn13g2[ib]
print @q.xbgr.xq75_u9.qnpn13g2[ie]
print @q.xbgr.xq75_u9.qnpn13g2[is]
print @r.xbgr.xq75_u9.rsub[i]
print @c.xbgr.xq75_u9.csub[i]
print @q.xbgr.xq75_u10.qnpn13g2[ic]
print @q.xbgr.xq75_u10.qnpn13g2[ib]
print @q.xbgr.xq75_u10.qnpn13g2[ie]
print @q.xbgr.xq75_u10.qnpn13g2[is]
print @r.xbgr.xq75_u10.rsub[i]
print @c.xbgr.xq75_u10.csub[i]
print @q.xbgr.xq75_u11.qnpn13g2[ic]
print @q.xbgr.xq75_u11.qnpn13g2[ib]
print @q.xbgr.xq75_u11.qnpn13g2[ie]
print @q.xbgr.xq75_u11.qnpn13g2[is]
print @r.xbgr.xq75_u11.rsub[i]
print @c.xbgr.xq75_u11.csub[i]
print @q.xbgr.xq75_u12.qnpn13g2[ic]
print @q.xbgr.xq75_u12.qnpn13g2[ib]
print @q.xbgr.xq75_u12.qnpn13g2[ie]
print @q.xbgr.xq75_u12.qnpn13g2[is]
print @r.xbgr.xq75_u12.rsub[i]
print @c.xbgr.xq75_u12.csub[i]
print @q.xbgr.xq75_u13.qnpn13g2[ic]
print @q.xbgr.xq75_u13.qnpn13g2[ib]
print @q.xbgr.xq75_u13.qnpn13g2[ie]
print @q.xbgr.xq75_u13.qnpn13g2[is]
print @r.xbgr.xq75_u13.rsub[i]
print @c.xbgr.xq75_u13.csub[i]
print @q.xbgr.xq75_u14.qnpn13g2[ic]
print @q.xbgr.xq75_u14.qnpn13g2[ib]
print @q.xbgr.xq75_u14.qnpn13g2[ie]
print @q.xbgr.xq75_u14.qnpn13g2[is]
print @r.xbgr.xq75_u14.rsub[i]
print @c.xbgr.xq75_u14.csub[i]
print @q.xbgr.xq75_u15.qnpn13g2[ic]
print @q.xbgr.xq75_u15.qnpn13g2[ib]
print @q.xbgr.xq75_u15.qnpn13g2[ie]
print @q.xbgr.xq75_u15.qnpn13g2[is]
print @r.xbgr.xq75_u15.rsub[i]
print @c.xbgr.xq75_u15.csub[i]
print @q.xbgr.xq75_u16.qnpn13g2[ic]
print @q.xbgr.xq75_u16.qnpn13g2[ib]
print @q.xbgr.xq75_u16.qnpn13g2[ie]
print @q.xbgr.xq75_u16.qnpn13g2[is]
print @r.xbgr.xq75_u16.rsub[i]
print @c.xbgr.xq75_u16.csub[i]
print @q.xbgr.xq75_u17.qnpn13g2[ic]
print @q.xbgr.xq75_u17.qnpn13g2[ib]
print @q.xbgr.xq75_u17.qnpn13g2[ie]
print @q.xbgr.xq75_u17.qnpn13g2[is]
print @r.xbgr.xq75_u17.rsub[i]
print @c.xbgr.xq75_u17.csub[i]
print @q.xbgr.xq75_u18.qnpn13g2[ic]
print @q.xbgr.xq75_u18.qnpn13g2[ib]
print @q.xbgr.xq75_u18.qnpn13g2[ie]
print @q.xbgr.xq75_u18.qnpn13g2[is]
print @r.xbgr.xq75_u18.rsub[i]
print @c.xbgr.xq75_u18.csub[i]
print @q.xbgr.xq75_u19.qnpn13g2[ic]
print @q.xbgr.xq75_u19.qnpn13g2[ib]
print @q.xbgr.xq75_u19.qnpn13g2[ie]
print @q.xbgr.xq75_u19.qnpn13g2[is]
print @r.xbgr.xq75_u19.rsub[i]
print @c.xbgr.xq75_u19.csub[i]
print @q.xbgr.xq75_u20.qnpn13g2[ic]
print @q.xbgr.xq75_u20.qnpn13g2[ib]
print @q.xbgr.xq75_u20.qnpn13g2[ie]
print @q.xbgr.xq75_u20.qnpn13g2[is]
print @r.xbgr.xq75_u20.rsub[i]
print @c.xbgr.xq75_u20.csub[i]
print @q.xbgr.xq75_u21.qnpn13g2[ic]
print @q.xbgr.xq75_u21.qnpn13g2[ib]
print @q.xbgr.xq75_u21.qnpn13g2[ie]
print @q.xbgr.xq75_u21.qnpn13g2[is]
print @r.xbgr.xq75_u21.rsub[i]
print @c.xbgr.xq75_u21.csub[i]
print @q.xbgr.xq75_u22.qnpn13g2[ic]
print @q.xbgr.xq75_u22.qnpn13g2[ib]
print @q.xbgr.xq75_u22.qnpn13g2[ie]
print @q.xbgr.xq75_u22.qnpn13g2[is]
print @r.xbgr.xq75_u22.rsub[i]
print @c.xbgr.xq75_u22.csub[i]
print @q.xbgr.xq75_u23.qnpn13g2[ic]
print @q.xbgr.xq75_u23.qnpn13g2[ib]
print @q.xbgr.xq75_u23.qnpn13g2[ie]
print @q.xbgr.xq75_u23.qnpn13g2[is]
print @r.xbgr.xq75_u23.rsub[i]
print @c.xbgr.xq75_u23.csub[i]
print @q.xbgr.xq75_u24.qnpn13g2[ic]
print @q.xbgr.xq75_u24.qnpn13g2[ib]
print @q.xbgr.xq75_u24.qnpn13g2[ie]
print @q.xbgr.xq75_u24.qnpn13g2[is]
print @r.xbgr.xq75_u24.rsub[i]
print @c.xbgr.xq75_u24.csub[i]
print @q.xbgr.xq76_u2.qnpn13g2[ic]
print @q.xbgr.xq76_u2.qnpn13g2[ib]
print @q.xbgr.xq76_u2.qnpn13g2[ie]
print @q.xbgr.xq76_u2.qnpn13g2[is]
print @r.xbgr.xq76_u2.rsub[i]
print @c.xbgr.xq76_u2.csub[i]
print @q.xbgr.xq76_u3.qnpn13g2[ic]
print @q.xbgr.xq76_u3.qnpn13g2[ib]
print @q.xbgr.xq76_u3.qnpn13g2[ie]
print @q.xbgr.xq76_u3.qnpn13g2[is]
print @r.xbgr.xq76_u3.rsub[i]
print @c.xbgr.xq76_u3.csub[i]
print @q.xbgr.xq76_u4.qnpn13g2[ic]
print @q.xbgr.xq76_u4.qnpn13g2[ib]
print @q.xbgr.xq76_u4.qnpn13g2[ie]
print @q.xbgr.xq76_u4.qnpn13g2[is]
print @r.xbgr.xq76_u4.rsub[i]
print @c.xbgr.xq76_u4.csub[i]
print @q.xbgr.xq76_u5.qnpn13g2[ic]
print @q.xbgr.xq76_u5.qnpn13g2[ib]
print @q.xbgr.xq76_u5.qnpn13g2[ie]
print @q.xbgr.xq76_u5.qnpn13g2[is]
print @r.xbgr.xq76_u5.rsub[i]
print @c.xbgr.xq76_u5.csub[i]
print @q.xbgr.xq76_u6.qnpn13g2[ic]
print @q.xbgr.xq76_u6.qnpn13g2[ib]
print @q.xbgr.xq76_u6.qnpn13g2[ie]
print @q.xbgr.xq76_u6.qnpn13g2[is]
print @r.xbgr.xq76_u6.rsub[i]
print @c.xbgr.xq76_u6.csub[i]
print @q.xbgr.xq76_u7.qnpn13g2[ic]
print @q.xbgr.xq76_u7.qnpn13g2[ib]
print @q.xbgr.xq76_u7.qnpn13g2[ie]
print @q.xbgr.xq76_u7.qnpn13g2[is]
print @r.xbgr.xq76_u7.rsub[i]
print @c.xbgr.xq76_u7.csub[i]
print @q.xbgr.xq76_u8.qnpn13g2[ic]
print @q.xbgr.xq76_u8.qnpn13g2[ib]
print @q.xbgr.xq76_u8.qnpn13g2[ie]
print @q.xbgr.xq76_u8.qnpn13g2[is]
print @r.xbgr.xq76_u8.rsub[i]
print @c.xbgr.xq76_u8.csub[i]
print @q.xbgr.xq76_u9.qnpn13g2[ic]
print @q.xbgr.xq76_u9.qnpn13g2[ib]
print @q.xbgr.xq76_u9.qnpn13g2[ie]
print @q.xbgr.xq76_u9.qnpn13g2[is]
print @r.xbgr.xq76_u9.rsub[i]
print @c.xbgr.xq76_u9.csub[i]
print @q.xbgr.xq76_u10.qnpn13g2[ic]
print @q.xbgr.xq76_u10.qnpn13g2[ib]
print @q.xbgr.xq76_u10.qnpn13g2[ie]
print @q.xbgr.xq76_u10.qnpn13g2[is]
print @r.xbgr.xq76_u10.rsub[i]
print @c.xbgr.xq76_u10.csub[i]
print @q.xbgr.xq76_u11.qnpn13g2[ic]
print @q.xbgr.xq76_u11.qnpn13g2[ib]
print @q.xbgr.xq76_u11.qnpn13g2[ie]
print @q.xbgr.xq76_u11.qnpn13g2[is]
print @r.xbgr.xq76_u11.rsub[i]
print @c.xbgr.xq76_u11.csub[i]
print @q.xbgr.xq76_u12.qnpn13g2[ic]
print @q.xbgr.xq76_u12.qnpn13g2[ib]
print @q.xbgr.xq76_u12.qnpn13g2[ie]
print @q.xbgr.xq76_u12.qnpn13g2[is]
print @r.xbgr.xq76_u12.rsub[i]
print @c.xbgr.xq76_u12.csub[i]
print @q.xbgr.xq76_u13.qnpn13g2[ic]
print @q.xbgr.xq76_u13.qnpn13g2[ib]
print @q.xbgr.xq76_u13.qnpn13g2[ie]
print @q.xbgr.xq76_u13.qnpn13g2[is]
print @r.xbgr.xq76_u13.rsub[i]
print @c.xbgr.xq76_u13.csub[i]
print @q.xbgr.xq76_u14.qnpn13g2[ic]
print @q.xbgr.xq76_u14.qnpn13g2[ib]
print @q.xbgr.xq76_u14.qnpn13g2[ie]
print @q.xbgr.xq76_u14.qnpn13g2[is]
print @r.xbgr.xq76_u14.rsub[i]
print @c.xbgr.xq76_u14.csub[i]
print @q.xbgr.xq76_u15.qnpn13g2[ic]
print @q.xbgr.xq76_u15.qnpn13g2[ib]
print @q.xbgr.xq76_u15.qnpn13g2[ie]
print @q.xbgr.xq76_u15.qnpn13g2[is]
print @r.xbgr.xq76_u15.rsub[i]
print @c.xbgr.xq76_u15.csub[i]
print @q.xbgr.xq76_u16.qnpn13g2[ic]
print @q.xbgr.xq76_u16.qnpn13g2[ib]
print @q.xbgr.xq76_u16.qnpn13g2[ie]
print @q.xbgr.xq76_u16.qnpn13g2[is]
print @r.xbgr.xq76_u16.rsub[i]
print @c.xbgr.xq76_u16.csub[i]
print @q.xbgr.xq76_u17.qnpn13g2[ic]
print @q.xbgr.xq76_u17.qnpn13g2[ib]
print @q.xbgr.xq76_u17.qnpn13g2[ie]
print @q.xbgr.xq76_u17.qnpn13g2[is]
print @r.xbgr.xq76_u17.rsub[i]
print @c.xbgr.xq76_u17.csub[i]
print @q.xbgr.xq76_u18.qnpn13g2[ic]
print @q.xbgr.xq76_u18.qnpn13g2[ib]
print @q.xbgr.xq76_u18.qnpn13g2[ie]
print @q.xbgr.xq76_u18.qnpn13g2[is]
print @r.xbgr.xq76_u18.rsub[i]
print @c.xbgr.xq76_u18.csub[i]
print @q.xbgr.xq76_u19.qnpn13g2[ic]
print @q.xbgr.xq76_u19.qnpn13g2[ib]
print @q.xbgr.xq76_u19.qnpn13g2[ie]
print @q.xbgr.xq76_u19.qnpn13g2[is]
print @r.xbgr.xq76_u19.rsub[i]
print @c.xbgr.xq76_u19.csub[i]
print @q.xbgr.xq76_u20.qnpn13g2[ic]
print @q.xbgr.xq76_u20.qnpn13g2[ib]
print @q.xbgr.xq76_u20.qnpn13g2[ie]
print @q.xbgr.xq76_u20.qnpn13g2[is]
print @r.xbgr.xq76_u20.rsub[i]
print @c.xbgr.xq76_u20.csub[i]
print @q.xbgr.xq76_u21.qnpn13g2[ic]
print @q.xbgr.xq76_u21.qnpn13g2[ib]
print @q.xbgr.xq76_u21.qnpn13g2[ie]
print @q.xbgr.xq76_u21.qnpn13g2[is]
print @r.xbgr.xq76_u21.rsub[i]
print @c.xbgr.xq76_u21.csub[i]
print @q.xbgr.xq76_u22.qnpn13g2[ic]
print @q.xbgr.xq76_u22.qnpn13g2[ib]
print @q.xbgr.xq76_u22.qnpn13g2[ie]
print @q.xbgr.xq76_u22.qnpn13g2[is]
print @r.xbgr.xq76_u22.rsub[i]
print @c.xbgr.xq76_u22.csub[i]
print @q.xbgr.xq76_u23.qnpn13g2[ic]
print @q.xbgr.xq76_u23.qnpn13g2[ib]
print @q.xbgr.xq76_u23.qnpn13g2[ie]
print @q.xbgr.xq76_u23.qnpn13g2[is]
print @r.xbgr.xq76_u23.rsub[i]
print @c.xbgr.xq76_u23.csub[i]
print @q.xbgr.xq76_u24.qnpn13g2[ic]
print @q.xbgr.xq76_u24.qnpn13g2[ib]
print @q.xbgr.xq76_u24.qnpn13g2[ie]
print @q.xbgr.xq76_u24.qnpn13g2[is]
print @r.xbgr.xq76_u24.rsub[i]
print @c.xbgr.xq76_u24.csub[i]
print @n.xbgr.xr77_u2.nr1[ibody]
print @n.xbgr.xr77_u3.nr1[ibody]
print @n.xbgr.xr77_u4.nr1[ibody]
print @n.xbgr.xr77_u5.nr1[ibody]
print @n.xbgr.xr77_u6.nr1[ibody]
print @n.xbgr.xr77_u7.nr1[ibody]
print @n.xbgr.xr77_u8.nr1[ibody]
print @n.xbgr.xr77_u9.nr1[ibody]
print @n.xbgr.xr77_u10.nr1[ibody]
print @n.xbgr.xr77_u11.nr1[ibody]
print @n.xbgr.xr77_u12.nr1[ibody]
print @n.xbgr.xr77_u13.nr1[ibody]
print @n.xbgr.xr77_u14.nr1[ibody]
print @n.xbgr.xr77_u15.nr1[ibody]
print @n.xbgr.xr77_u16.nr1[ibody]
print @n.xbgr.xr77_u17.nr1[ibody]
print @n.xbgr.xr77_u18.nr1[ibody]
print @n.xbgr.xr77_u19.nr1[ibody]
print @n.xbgr.xr77_u20.nr1[ibody]
print @n.xbgr.xr77_u21.nr1[ibody]
print @n.xbgr.xr77_u22.nr1[ibody]
print @n.xbgr.xr77_u23.nr1[ibody]
print @n.xbgr.xr77_u24.nr1[ibody]
print @n.xbgr.xr78_u2.nr1[ibody]
print @n.xbgr.xr78_u3.nr1[ibody]
print @n.xbgr.xr78_u4.nr1[ibody]
print @n.xbgr.xr78_u5.nr1[ibody]
print @n.xbgr.xr78_u6.nr1[ibody]
print @n.xbgr.xr78_u7.nr1[ibody]
print @n.xbgr.xr78_u8.nr1[ibody]
print @n.xbgr.xr78_u9.nr1[ibody]
print @n.xbgr.xr78_u10.nr1[ibody]
print @n.xbgr.xr78_u11.nr1[ibody]
print @n.xbgr.xr78_u12.nr1[ibody]
print @n.xbgr.xr78_u13.nr1[ibody]
print @n.xbgr.xr78_u14.nr1[ibody]
print @n.xbgr.xr78_u15.nr1[ibody]
print @n.xbgr.xr78_u16.nr1[ibody]
print @n.xbgr.xr78_u17.nr1[ibody]
print @n.xbgr.xr78_u18.nr1[ibody]
print @n.xbgr.xr78_u19.nr1[ibody]
print @n.xbgr.xr78_u20.nr1[ibody]
print @n.xbgr.xr78_u21.nr1[ibody]
print @n.xbgr.xr78_u22.nr1[ibody]
print @n.xbgr.xr78_u23.nr1[ibody]
print @n.xbgr.xr78_u24.nr1[ibody]
print @n.xbgr.xr79_u2.nr1[ibody]
print @n.xbgr.xr79_u3.nr1[ibody]
print @n.xbgr.xr79_u4.nr1[ibody]
print @n.xbgr.xr79_u5.nr1[ibody]
print @n.xbgr.xr79_u6.nr1[ibody]
print @n.xbgr.xr79_u7.nr1[ibody]
print @n.xbgr.xr79_u8.nr1[ibody]
print @n.xbgr.xr79_u9.nr1[ibody]
print @n.xbgr.xr79_u10.nr1[ibody]
print @n.xbgr.xr79_u11.nr1[ibody]
print @n.xbgr.xr79_u12.nr1[ibody]
print @n.xbgr.xr79_u13.nr1[ibody]
print @n.xbgr.xr79_u14.nr1[ibody]
print @n.xbgr.xr79_u15.nr1[ibody]
print @n.xbgr.xr79_u16.nr1[ibody]
print @n.xbgr.xr79_u17.nr1[ibody]
print @n.xbgr.xr79_u18.nr1[ibody]
print @n.xbgr.xr79_u19.nr1[ibody]
print @n.xbgr.xr79_u20.nr1[ibody]
print @n.xbgr.xr79_u21.nr1[ibody]
print @n.xbgr.xr79_u22.nr1[ibody]
print @n.xbgr.xr79_u23.nr1[ibody]
print @n.xbgr.xr79_u24.nr1[ibody]
print @n.xbgr.xr80_u2.nr1[ibody]
print @n.xbgr.xr80_u3.nr1[ibody]
print @n.xbgr.xr80_u4.nr1[ibody]
print @n.xbgr.xr80_u5.nr1[ibody]
print @n.xbgr.xr80_u6.nr1[ibody]
print @n.xbgr.xr80_u7.nr1[ibody]
print @n.xbgr.xr80_u8.nr1[ibody]
print @n.xbgr.xr80_u9.nr1[ibody]
print @n.xbgr.xr80_u10.nr1[ibody]
print @n.xbgr.xr80_u11.nr1[ibody]
print @n.xbgr.xr80_u12.nr1[ibody]
print @n.xbgr.xr80_u13.nr1[ibody]
print @n.xbgr.xr80_u14.nr1[ibody]
print @n.xbgr.xr80_u15.nr1[ibody]
print @n.xbgr.xr80_u16.nr1[ibody]
print @n.xbgr.xr80_u17.nr1[ibody]
print @n.xbgr.xr80_u18.nr1[ibody]
print @n.xbgr.xr80_u19.nr1[ibody]
print @n.xbgr.xr80_u20.nr1[ibody]
print @n.xbgr.xr80_u21.nr1[ibody]
print @n.xbgr.xr80_u22.nr1[ibody]
print @n.xbgr.xr80_u23.nr1[ibody]
print @n.xbgr.xr80_u24.nr1[ibody]
print @n.xbgr.xr81_u2.nr1[ibody]
print @n.xbgr.xr81_u3.nr1[ibody]
print @n.xbgr.xr81_u4.nr1[ibody]
print @n.xbgr.xr81_u5.nr1[ibody]
print @n.xbgr.xr81_u6.nr1[ibody]
print @n.xbgr.xr81_u7.nr1[ibody]
print @n.xbgr.xr81_u8.nr1[ibody]
print @n.xbgr.xr81_u9.nr1[ibody]
print @n.xbgr.xr81_u10.nr1[ibody]
print @n.xbgr.xr81_u11.nr1[ibody]
print @n.xbgr.xr81_u12.nr1[ibody]
print @n.xbgr.xr81_u13.nr1[ibody]
print @n.xbgr.xr81_u14.nr1[ibody]
print @n.xbgr.xr81_u15.nr1[ibody]
print @n.xbgr.xr81_u16.nr1[ibody]
print @n.xbgr.xr81_u17.nr1[ibody]
print @n.xbgr.xr81_u18.nr1[ibody]
print @n.xbgr.xr81_u19.nr1[ibody]
print @n.xbgr.xr81_u20.nr1[ibody]
print @n.xbgr.xr81_u21.nr1[ibody]
print @n.xbgr.xr81_u22.nr1[ibody]
print @n.xbgr.xr81_u23.nr1[ibody]
print @n.xbgr.xr81_u24.nr1[ibody]
print @n.xbgr.xr82_u2.nr1[ibody]
print @n.xbgr.xr82_u3.nr1[ibody]
print @n.xbgr.xr82_u4.nr1[ibody]
print @n.xbgr.xr82_u5.nr1[ibody]
print @n.xbgr.xr82_u6.nr1[ibody]
print @n.xbgr.xr82_u7.nr1[ibody]
print @n.xbgr.xr82_u8.nr1[ibody]
print @n.xbgr.xr82_u9.nr1[ibody]
print @n.xbgr.xr82_u10.nr1[ibody]
print @n.xbgr.xr82_u11.nr1[ibody]
print @n.xbgr.xr82_u12.nr1[ibody]
print @n.xbgr.xr82_u13.nr1[ibody]
print @n.xbgr.xr82_u14.nr1[ibody]
print @n.xbgr.xr82_u15.nr1[ibody]
print @n.xbgr.xr82_u16.nr1[ibody]
print @n.xbgr.xr82_u17.nr1[ibody]
print @n.xbgr.xr82_u18.nr1[ibody]
print @n.xbgr.xr82_u19.nr1[ibody]
print @n.xbgr.xr82_u20.nr1[ibody]
print @n.xbgr.xr82_u21.nr1[ibody]
print @n.xbgr.xr82_u22.nr1[ibody]
print @n.xbgr.xr82_u23.nr1[ibody]
print @n.xbgr.xr82_u24.nr1[ibody]
print @n.xbgr.xr83_u2.nr1[ibody]
print @n.xbgr.xr83_u3.nr1[ibody]
print @n.xbgr.xr83_u4.nr1[ibody]
print @n.xbgr.xr83_u5.nr1[ibody]
print @n.xbgr.xr83_u6.nr1[ibody]
print @n.xbgr.xr83_u7.nr1[ibody]
print @n.xbgr.xr83_u8.nr1[ibody]
print @n.xbgr.xr83_u9.nr1[ibody]
print @n.xbgr.xr83_u10.nr1[ibody]
print @n.xbgr.xr83_u11.nr1[ibody]
print @n.xbgr.xr83_u12.nr1[ibody]
print @n.xbgr.xr83_u13.nr1[ibody]
print @n.xbgr.xr83_u14.nr1[ibody]
print @n.xbgr.xr83_u15.nr1[ibody]
print @n.xbgr.xr83_u16.nr1[ibody]
print @n.xbgr.xr83_u17.nr1[ibody]
print @n.xbgr.xr83_u18.nr1[ibody]
print @n.xbgr.xr83_u19.nr1[ibody]
print @n.xbgr.xr83_u20.nr1[ibody]
print @n.xbgr.xr83_u21.nr1[ibody]
print @n.xbgr.xr83_u22.nr1[ibody]
print @n.xbgr.xr83_u23.nr1[ibody]
print @n.xbgr.xr83_u24.nr1[ibody]
print @n.xbgr.xr84_u2.nr1[ibody]
print @n.xbgr.xr84_u3.nr1[ibody]
print @n.xbgr.xr84_u4.nr1[ibody]
print @n.xbgr.xr84_u5.nr1[ibody]
print @n.xbgr.xr84_u6.nr1[ibody]
print @n.xbgr.xr84_u7.nr1[ibody]
print @n.xbgr.xr84_u8.nr1[ibody]
print @n.xbgr.xr84_u9.nr1[ibody]
print @n.xbgr.xr84_u10.nr1[ibody]
print @n.xbgr.xr84_u11.nr1[ibody]
print @n.xbgr.xr84_u12.nr1[ibody]
print @n.xbgr.xr84_u13.nr1[ibody]
print @n.xbgr.xr84_u14.nr1[ibody]
print @n.xbgr.xr84_u15.nr1[ibody]
print @n.xbgr.xr84_u16.nr1[ibody]
print @n.xbgr.xr84_u17.nr1[ibody]
print @n.xbgr.xr84_u18.nr1[ibody]
print @n.xbgr.xr84_u19.nr1[ibody]
print @n.xbgr.xr84_u20.nr1[ibody]
print @n.xbgr.xr84_u21.nr1[ibody]
print @n.xbgr.xr84_u22.nr1[ibody]
print @n.xbgr.xr84_u23.nr1[ibody]
print @n.xbgr.xr84_u24.nr1[ibody]
print @n.xbgr.xr85_u2.nr1[ibody]
print @n.xbgr.xr85_u3.nr1[ibody]
print @n.xbgr.xr85_u4.nr1[ibody]
print @n.xbgr.xr85_u5.nr1[ibody]
print @n.xbgr.xr85_u6.nr1[ibody]
print @n.xbgr.xr85_u7.nr1[ibody]
print @n.xbgr.xr85_u8.nr1[ibody]
print @n.xbgr.xr85_u9.nr1[ibody]
print @n.xbgr.xr85_u10.nr1[ibody]
print @n.xbgr.xr85_u11.nr1[ibody]
print @n.xbgr.xr85_u12.nr1[ibody]
print @n.xbgr.xr85_u13.nr1[ibody]
print @n.xbgr.xr85_u14.nr1[ibody]
print @n.xbgr.xr85_u15.nr1[ibody]
print @n.xbgr.xr85_u16.nr1[ibody]
print @n.xbgr.xr85_u17.nr1[ibody]
print @n.xbgr.xr85_u18.nr1[ibody]
print @n.xbgr.xr85_u19.nr1[ibody]
print @n.xbgr.xr85_u20.nr1[ibody]
print @n.xbgr.xr85_u21.nr1[ibody]
print @n.xbgr.xr85_u22.nr1[ibody]
print @n.xbgr.xr85_u23.nr1[ibody]
print @n.xbgr.xr85_u24.nr1[ibody]
print @n.xbgr.xr86_u2.nr1[ibody]
print @n.xbgr.xr86_u3.nr1[ibody]
print @n.xbgr.xr86_u4.nr1[ibody]
print @n.xbgr.xr86_u5.nr1[ibody]
print @n.xbgr.xr86_u6.nr1[ibody]
print @n.xbgr.xr86_u7.nr1[ibody]
print @n.xbgr.xr86_u8.nr1[ibody]
print @n.xbgr.xr86_u9.nr1[ibody]
print @n.xbgr.xr86_u10.nr1[ibody]
print @n.xbgr.xr86_u11.nr1[ibody]
print @n.xbgr.xr86_u12.nr1[ibody]
print @n.xbgr.xr86_u13.nr1[ibody]
print @n.xbgr.xr86_u14.nr1[ibody]
print @n.xbgr.xr86_u15.nr1[ibody]
print @n.xbgr.xr86_u16.nr1[ibody]
print @n.xbgr.xr86_u17.nr1[ibody]
print @n.xbgr.xr86_u18.nr1[ibody]
print @n.xbgr.xr86_u19.nr1[ibody]
print @n.xbgr.xr86_u20.nr1[ibody]
print @n.xbgr.xr86_u21.nr1[ibody]
print @n.xbgr.xr86_u22.nr1[ibody]
print @n.xbgr.xr86_u23.nr1[ibody]
print @n.xbgr.xr86_u24.nr1[ibody]
echo RAW_CURRENT_LEDGER_END
wrdata op_nodes.dat v(xbgr.b1b) v(xbgr.c2) v(xbgr.d1) v(xbgr.d2) v(xbgr.d3) v(xbgr.d4) v(xbgr.d5) v(xbgr.det) v(dvbe) v(iptat) v(xbgr.kick) v(xbgr.n1) v(xbgr.n_10) v(xbgr.n_11) v(xbgr.n_12) v(xbgr.n_13) v(xbgr.n_14) v(xbgr.n_15) v(xbgr.n_16) v(xbgr.n_17) v(xbgr.n_18) v(xbgr.n_19) v(xbgr.n_2) v(xbgr.n_21) v(xbgr.n_22) v(xbgr.n_23) v(xbgr.n_24) v(xbgr.n_25) v(xbgr.n_26) v(xbgr.n_27) v(xbgr.n_3) v(xbgr.n_30) v(xbgr.n_31) v(xbgr.n_33) v(xbgr.n_34) v(xbgr.n_36) v(xbgr.n_37) v(xbgr.n_4) v(xbgr.n_5) v(xbgr.n_6) v(xbgr.n_7) v(xbgr.n_8) v(xbgr.n_9) v(pbias) v(pcasc) v(r4) v(xbgr.r4n) v(xbgr.vb2) v(vbe) v(xbgr.vbe3) v(xbgr.vd1) v(xbgr.vd2) v(vdd) v(vref) v(vdd)-v(vdd) i(vdd) i(vload) i(vr4) i(vsub)
print @n.xbgr.xr1.nr1[nsmm_rsh]
print @n.xbgr.xr1.nr1[nsmm_w]
print @n.xbgr.xr1.nr1[nsmm_l]
print @n.xbgr.xr2.nr1[nsmm_rsh]
print @n.xbgr.xr2.nr1[nsmm_w]
print @n.xbgr.xr2.nr1[nsmm_l]
print @n.xbgr.xr3.nr1[nsmm_rsh]
print @n.xbgr.xr3.nr1[nsmm_w]
print @n.xbgr.xr3.nr1[nsmm_l]
print @n.xbgr.xr4.nr1[nsmm_rsh]
print @n.xbgr.xr4.nr1[nsmm_w]
print @n.xbgr.xr4.nr1[nsmm_l]
print @n.xbgr.xr5.nr1[nsmm_rsh]
print @n.xbgr.xr5.nr1[nsmm_w]
print @n.xbgr.xr5.nr1[nsmm_l]
print @n.xbgr.xr6.nr1[nsmm_rsh]
print @n.xbgr.xr6.nr1[nsmm_w]
print @n.xbgr.xr6.nr1[nsmm_l]
print @n.xbgr.xr7.nr1[nsmm_rsh]
print @n.xbgr.xr7.nr1[nsmm_w]
print @n.xbgr.xr7.nr1[nsmm_l]
print @n.xbgr.xr8.nr1[nsmm_rsh]
print @n.xbgr.xr8.nr1[nsmm_w]
print @n.xbgr.xr8.nr1[nsmm_l]
print @n.xbgr.xr9.nr1[nsmm_rsh]
print @n.xbgr.xr9.nr1[nsmm_w]
print @n.xbgr.xr9.nr1[nsmm_l]
print @n.xbgr.xr10.nr1[nsmm_rsh]
print @n.xbgr.xr10.nr1[nsmm_w]
print @n.xbgr.xr10.nr1[nsmm_l]
print @n.xbgr.xr11.nr1[nsmm_rsh]
print @n.xbgr.xr11.nr1[nsmm_w]
print @n.xbgr.xr11.nr1[nsmm_l]
print @n.xbgr.xr12.nr1[nsmm_rsh]
print @n.xbgr.xr12.nr1[nsmm_w]
print @n.xbgr.xr12.nr1[nsmm_l]
print @n.xbgr.xr13.nr1[nsmm_rsh]
print @n.xbgr.xr13.nr1[nsmm_w]
print @n.xbgr.xr13.nr1[nsmm_l]
print @n.xbgr.xr14.nr1[nsmm_rsh]
print @n.xbgr.xr14.nr1[nsmm_w]
print @n.xbgr.xr14.nr1[nsmm_l]
print @n.xbgr.xr15.nr1[nsmm_rsh]
print @n.xbgr.xr15.nr1[nsmm_w]
print @n.xbgr.xr15.nr1[nsmm_l]
print @n.xbgr.xr16.nr1[nsmm_rsh]
print @n.xbgr.xr16.nr1[nsmm_w]
print @n.xbgr.xr16.nr1[nsmm_l]
print @n.xbgr.xr17.nr1[nsmm_rsh]
print @n.xbgr.xr17.nr1[nsmm_w]
print @n.xbgr.xr17.nr1[nsmm_l]
print @n.xbgr.xr18.nr1[nsmm_rsh]
print @n.xbgr.xr18.nr1[nsmm_w]
print @n.xbgr.xr18.nr1[nsmm_l]
print @n.xbgr.xr19.nr1[nsmm_rsh]
print @n.xbgr.xr19.nr1[nsmm_w]
print @n.xbgr.xr19.nr1[nsmm_l]
print @n.xbgr.xr20.nr1[nsmm_rsh]
print @n.xbgr.xr20.nr1[nsmm_w]
print @n.xbgr.xr20.nr1[nsmm_l]
print @n.xbgr.xr21.nr1[nsmm_rsh]
print @n.xbgr.xr21.nr1[nsmm_w]
print @n.xbgr.xr21.nr1[nsmm_l]
print @n.xbgr.xr22.nr1[nsmm_rsh]
print @n.xbgr.xr22.nr1[nsmm_w]
print @n.xbgr.xr22.nr1[nsmm_l]
print @n.xbgr.xr23.nr1[nsmm_rsh]
print @n.xbgr.xr23.nr1[nsmm_w]
print @n.xbgr.xr23.nr1[nsmm_l]
print @n.xbgr.xr24.nr1[nsmm_rsh]
print @n.xbgr.xr24.nr1[nsmm_w]
print @n.xbgr.xr24.nr1[nsmm_l]
print @n.xbgr.xr25.nr1[nsmm_rsh]
print @n.xbgr.xr25.nr1[nsmm_w]
print @n.xbgr.xr25.nr1[nsmm_l]
print @n.xbgr.xr26.nr1[nsmm_rsh]
print @n.xbgr.xr26.nr1[nsmm_w]
print @n.xbgr.xr26.nr1[nsmm_l]
print @n.xbgr.xm27.nsg13_hv_pmos[w]
print @n.xbgr.xm27.nsg13_hv_pmos[l]
print @n.xbgr.xm27.nsg13_hv_pmos[delvto]
print @n.xbgr.xm27.nsg13_hv_pmos[factuo]
print @n.xbgr.xm28.nsg13_hv_pmos[w]
print @n.xbgr.xm28.nsg13_hv_pmos[l]
print @n.xbgr.xm28.nsg13_hv_pmos[delvto]
print @n.xbgr.xm28.nsg13_hv_pmos[factuo]
print @n.xbgr.xm29.nsg13_hv_nmos[w]
print @n.xbgr.xm29.nsg13_hv_nmos[l]
print @n.xbgr.xm29.nsg13_hv_nmos[delvto]
print @n.xbgr.xm29.nsg13_hv_nmos[factuo]
print @n.xbgr.xm30.nsg13_hv_nmos[w]
print @n.xbgr.xm30.nsg13_hv_nmos[l]
print @n.xbgr.xm30.nsg13_hv_nmos[delvto]
print @n.xbgr.xm30.nsg13_hv_nmos[factuo]
print @n.xbgr.xm31.nsg13_hv_nmos[w]
print @n.xbgr.xm31.nsg13_hv_nmos[l]
print @n.xbgr.xm31.nsg13_hv_nmos[delvto]
print @n.xbgr.xm31.nsg13_hv_nmos[factuo]
print @n.xbgr.xm32.nsg13_hv_nmos[w]
print @n.xbgr.xm32.nsg13_hv_nmos[l]
print @n.xbgr.xm32.nsg13_hv_nmos[delvto]
print @n.xbgr.xm32.nsg13_hv_nmos[factuo]
print @n.xbgr.xm33.nsg13_hv_nmos[w]
print @n.xbgr.xm33.nsg13_hv_nmos[l]
print @n.xbgr.xm33.nsg13_hv_nmos[delvto]
print @n.xbgr.xm33.nsg13_hv_nmos[factuo]
print @n.xbgr.xm34.nsg13_hv_nmos[w]
print @n.xbgr.xm34.nsg13_hv_nmos[l]
print @n.xbgr.xm34.nsg13_hv_nmos[delvto]
print @n.xbgr.xm34.nsg13_hv_nmos[factuo]
print @n.xbgr.xm35.nsg13_hv_nmos[w]
print @n.xbgr.xm35.nsg13_hv_nmos[l]
print @n.xbgr.xm35.nsg13_hv_nmos[delvto]
print @n.xbgr.xm35.nsg13_hv_nmos[factuo]
print @n.xbgr.xm36.nsg13_hv_nmos[w]
print @n.xbgr.xm36.nsg13_hv_nmos[l]
print @n.xbgr.xm36.nsg13_hv_nmos[delvto]
print @n.xbgr.xm36.nsg13_hv_nmos[factuo]
print @n.xbgr.xm37.nsg13_hv_nmos[w]
print @n.xbgr.xm37.nsg13_hv_nmos[l]
print @n.xbgr.xm37.nsg13_hv_nmos[delvto]
print @n.xbgr.xm37.nsg13_hv_nmos[factuo]
print @n.xbgr.xm38.nsg13_hv_pmos[w]
print @n.xbgr.xm38.nsg13_hv_pmos[l]
print @n.xbgr.xm38.nsg13_hv_pmos[delvto]
print @n.xbgr.xm38.nsg13_hv_pmos[factuo]
print @n.xbgr.xm39.nsg13_hv_pmos[w]
print @n.xbgr.xm39.nsg13_hv_pmos[l]
print @n.xbgr.xm39.nsg13_hv_pmos[delvto]
print @n.xbgr.xm39.nsg13_hv_pmos[factuo]
print @n.xbgr.xm40.nsg13_hv_pmos[w]
print @n.xbgr.xm40.nsg13_hv_pmos[l]
print @n.xbgr.xm40.nsg13_hv_pmos[delvto]
print @n.xbgr.xm40.nsg13_hv_pmos[factuo]
print @n.xbgr.xm41.nsg13_hv_pmos[w]
print @n.xbgr.xm41.nsg13_hv_pmos[l]
print @n.xbgr.xm41.nsg13_hv_pmos[delvto]
print @n.xbgr.xm41.nsg13_hv_pmos[factuo]
print @n.xbgr.xm42.nsg13_hv_pmos[w]
print @n.xbgr.xm42.nsg13_hv_pmos[l]
print @n.xbgr.xm42.nsg13_hv_pmos[delvto]
print @n.xbgr.xm42.nsg13_hv_pmos[factuo]
print @n.xbgr.xm43.nsg13_hv_pmos[w]
print @n.xbgr.xm43.nsg13_hv_pmos[l]
print @n.xbgr.xm43.nsg13_hv_pmos[delvto]
print @n.xbgr.xm43.nsg13_hv_pmos[factuo]
print @n.xbgr.xm44.nsg13_hv_pmos[w]
print @n.xbgr.xm44.nsg13_hv_pmos[l]
print @n.xbgr.xm44.nsg13_hv_pmos[delvto]
print @n.xbgr.xm44.nsg13_hv_pmos[factuo]
print @n.xbgr.xm45.nsg13_hv_pmos[w]
print @n.xbgr.xm45.nsg13_hv_pmos[l]
print @n.xbgr.xm45.nsg13_hv_pmos[delvto]
print @n.xbgr.xm45.nsg13_hv_pmos[factuo]
print @n.xbgr.xm46.nsg13_hv_pmos[w]
print @n.xbgr.xm46.nsg13_hv_pmos[l]
print @n.xbgr.xm46.nsg13_hv_pmos[delvto]
print @n.xbgr.xm46.nsg13_hv_pmos[factuo]
print @n.xbgr.xm47.nsg13_hv_pmos[w]
print @n.xbgr.xm47.nsg13_hv_pmos[l]
print @n.xbgr.xm47.nsg13_hv_pmos[delvto]
print @n.xbgr.xm47.nsg13_hv_pmos[factuo]
print @n.xbgr.xm48.nsg13_hv_pmos[w]
print @n.xbgr.xm48.nsg13_hv_pmos[l]
print @n.xbgr.xm48.nsg13_hv_pmos[delvto]
print @n.xbgr.xm48.nsg13_hv_pmos[factuo]
print @n.xbgr.xm49.nsg13_hv_pmos[w]
print @n.xbgr.xm49.nsg13_hv_pmos[l]
print @n.xbgr.xm49.nsg13_hv_pmos[delvto]
print @n.xbgr.xm49.nsg13_hv_pmos[factuo]
print @n.xbgr.xm50.nsg13_hv_pmos[w]
print @n.xbgr.xm50.nsg13_hv_pmos[l]
print @n.xbgr.xm50.nsg13_hv_pmos[delvto]
print @n.xbgr.xm50.nsg13_hv_pmos[factuo]
print @n.xbgr.xm51.nsg13_hv_pmos[w]
print @n.xbgr.xm51.nsg13_hv_pmos[l]
print @n.xbgr.xm51.nsg13_hv_pmos[delvto]
print @n.xbgr.xm51.nsg13_hv_pmos[factuo]
print @n.xbgr.xm52.nsg13_hv_pmos[w]
print @n.xbgr.xm52.nsg13_hv_pmos[l]
print @n.xbgr.xm52.nsg13_hv_pmos[delvto]
print @n.xbgr.xm52.nsg13_hv_pmos[factuo]
print @n.xbgr.xm53.nsg13_hv_pmos[w]
print @n.xbgr.xm53.nsg13_hv_pmos[l]
print @n.xbgr.xm53.nsg13_hv_pmos[delvto]
print @n.xbgr.xm53.nsg13_hv_pmos[factuo]
print @n.xbgr.xm54.nsg13_hv_pmos[w]
print @n.xbgr.xm54.nsg13_hv_pmos[l]
print @n.xbgr.xm54.nsg13_hv_pmos[delvto]
print @n.xbgr.xm54.nsg13_hv_pmos[factuo]
print @q.xbgr.xq55.qnpn13g2[area]
print @q.xbgr.xq56.qnpn13g2[area]
print @q.xbgr.xq57.qnpn13g2[area]
print @q.xbgr.xq58.qnpn13g2[area]
print @q.xbgr.xq59.qnpn13g2[area]
print @q.xbgr.xq60.qnpn13g2[area]
print @q.xbgr.xq61.qnpn13g2[area]
print @q.xbgr.xq62.qnpn13g2[area]
print @q.xbgr.xq63.qnpn13g2[area]
print @q.xbgr.xq64.qnpn13g2[area]
print @q.xbgr.xq65.qnpn13g2[area]
print @q.xbgr.xq66.qnpn13g2[area]
print @q.xbgr.xq67.qnpn13g2[area]
print @q.xbgr.xq68.qnpn13g2[area]
print @q.xbgr.xq69.qnpn13g2[area]
print @q.xbgr.xq70.qnpn13g2[area]
print @q.xbgr.xq71.qnpn13g2[area]
print @q.xbgr.xq72.qnpn13g2[area]
print @q.xbgr.xq73.qnpn13g2[area]
print @q.xbgr.xq74.qnpn13g2[area]
print @q.xbgr.xq75.qnpn13g2[area]
print @q.xbgr.xq76.qnpn13g2[area]
print @n.xbgr.xr77.nr1[nsmm_rsh]
print @n.xbgr.xr77.nr1[nsmm_w]
print @n.xbgr.xr77.nr1[nsmm_l]
print @n.xbgr.xr78.nr1[nsmm_rsh]
print @n.xbgr.xr78.nr1[nsmm_w]
print @n.xbgr.xr78.nr1[nsmm_l]
print @n.xbgr.xr79.nr1[nsmm_rsh]
print @n.xbgr.xr79.nr1[nsmm_w]
print @n.xbgr.xr79.nr1[nsmm_l]
print @n.xbgr.xr80.nr1[nsmm_rsh]
print @n.xbgr.xr80.nr1[nsmm_w]
print @n.xbgr.xr80.nr1[nsmm_l]
print @n.xbgr.xr81.nr1[nsmm_rsh]
print @n.xbgr.xr81.nr1[nsmm_w]
print @n.xbgr.xr81.nr1[nsmm_l]
print @n.xbgr.xr82.nr1[nsmm_rsh]
print @n.xbgr.xr82.nr1[nsmm_w]
print @n.xbgr.xr82.nr1[nsmm_l]
print @n.xbgr.xr83.nr1[nsmm_rsh]
print @n.xbgr.xr83.nr1[nsmm_w]
print @n.xbgr.xr83.nr1[nsmm_l]
print @n.xbgr.xr84.nr1[nsmm_rsh]
print @n.xbgr.xr84.nr1[nsmm_w]
print @n.xbgr.xr84.nr1[nsmm_l]
print @n.xbgr.xr85.nr1[nsmm_rsh]
print @n.xbgr.xr85.nr1[nsmm_w]
print @n.xbgr.xr85.nr1[nsmm_l]
print @n.xbgr.xr86.nr1[nsmm_rsh]
print @n.xbgr.xr86.nr1[nsmm_w]
print @n.xbgr.xr86.nr1[nsmm_l]
print @n.xbgr.xr16_u2.nr1[nsmm_rsh]
print @n.xbgr.xr16_u2.nr1[nsmm_w]
print @n.xbgr.xr16_u2.nr1[nsmm_l]
print @n.xbgr.xr16_u3.nr1[nsmm_rsh]
print @n.xbgr.xr16_u3.nr1[nsmm_w]
print @n.xbgr.xr16_u3.nr1[nsmm_l]
print @n.xbgr.xr16_u4.nr1[nsmm_rsh]
print @n.xbgr.xr16_u4.nr1[nsmm_w]
print @n.xbgr.xr16_u4.nr1[nsmm_l]
print @n.xbgr.xr16_u5.nr1[nsmm_rsh]
print @n.xbgr.xr16_u5.nr1[nsmm_w]
print @n.xbgr.xr16_u5.nr1[nsmm_l]
print @n.xbgr.xr16_u6.nr1[nsmm_rsh]
print @n.xbgr.xr16_u6.nr1[nsmm_w]
print @n.xbgr.xr16_u6.nr1[nsmm_l]
print @n.xbgr.xr16_u7.nr1[nsmm_rsh]
print @n.xbgr.xr16_u7.nr1[nsmm_w]
print @n.xbgr.xr16_u7.nr1[nsmm_l]
print @n.xbgr.xr16_u8.nr1[nsmm_rsh]
print @n.xbgr.xr16_u8.nr1[nsmm_w]
print @n.xbgr.xr16_u8.nr1[nsmm_l]
print @n.xbgr.xr16_u9.nr1[nsmm_rsh]
print @n.xbgr.xr16_u9.nr1[nsmm_w]
print @n.xbgr.xr16_u9.nr1[nsmm_l]
print @n.xbgr.xr16_u10.nr1[nsmm_rsh]
print @n.xbgr.xr16_u10.nr1[nsmm_w]
print @n.xbgr.xr16_u10.nr1[nsmm_l]
print @n.xbgr.xr16_u11.nr1[nsmm_rsh]
print @n.xbgr.xr16_u11.nr1[nsmm_w]
print @n.xbgr.xr16_u11.nr1[nsmm_l]
print @n.xbgr.xr16_u12.nr1[nsmm_rsh]
print @n.xbgr.xr16_u12.nr1[nsmm_w]
print @n.xbgr.xr16_u12.nr1[nsmm_l]
print @n.xbgr.xr16_u13.nr1[nsmm_rsh]
print @n.xbgr.xr16_u13.nr1[nsmm_w]
print @n.xbgr.xr16_u13.nr1[nsmm_l]
print @n.xbgr.xr16_u14.nr1[nsmm_rsh]
print @n.xbgr.xr16_u14.nr1[nsmm_w]
print @n.xbgr.xr16_u14.nr1[nsmm_l]
print @n.xbgr.xr16_u15.nr1[nsmm_rsh]
print @n.xbgr.xr16_u15.nr1[nsmm_w]
print @n.xbgr.xr16_u15.nr1[nsmm_l]
print @n.xbgr.xr16_u16.nr1[nsmm_rsh]
print @n.xbgr.xr16_u16.nr1[nsmm_w]
print @n.xbgr.xr16_u16.nr1[nsmm_l]
print @n.xbgr.xr16_u17.nr1[nsmm_rsh]
print @n.xbgr.xr16_u17.nr1[nsmm_w]
print @n.xbgr.xr16_u17.nr1[nsmm_l]
print @n.xbgr.xr16_u18.nr1[nsmm_rsh]
print @n.xbgr.xr16_u18.nr1[nsmm_w]
print @n.xbgr.xr16_u18.nr1[nsmm_l]
print @n.xbgr.xr16_u19.nr1[nsmm_rsh]
print @n.xbgr.xr16_u19.nr1[nsmm_w]
print @n.xbgr.xr16_u19.nr1[nsmm_l]
print @n.xbgr.xr16_u20.nr1[nsmm_rsh]
print @n.xbgr.xr16_u20.nr1[nsmm_w]
print @n.xbgr.xr16_u20.nr1[nsmm_l]
print @n.xbgr.xr16_u21.nr1[nsmm_rsh]
print @n.xbgr.xr16_u21.nr1[nsmm_w]
print @n.xbgr.xr16_u21.nr1[nsmm_l]
print @n.xbgr.xr16_u22.nr1[nsmm_rsh]
print @n.xbgr.xr16_u22.nr1[nsmm_w]
print @n.xbgr.xr16_u22.nr1[nsmm_l]
print @n.xbgr.xr16_u23.nr1[nsmm_rsh]
print @n.xbgr.xr16_u23.nr1[nsmm_w]
print @n.xbgr.xr16_u23.nr1[nsmm_l]
print @n.xbgr.xr16_u24.nr1[nsmm_rsh]
print @n.xbgr.xr16_u24.nr1[nsmm_w]
print @n.xbgr.xr16_u24.nr1[nsmm_l]
print @n.xbgr.xr17_u2.nr1[nsmm_rsh]
print @n.xbgr.xr17_u2.nr1[nsmm_w]
print @n.xbgr.xr17_u2.nr1[nsmm_l]
print @n.xbgr.xr17_u3.nr1[nsmm_rsh]
print @n.xbgr.xr17_u3.nr1[nsmm_w]
print @n.xbgr.xr17_u3.nr1[nsmm_l]
print @n.xbgr.xr17_u4.nr1[nsmm_rsh]
print @n.xbgr.xr17_u4.nr1[nsmm_w]
print @n.xbgr.xr17_u4.nr1[nsmm_l]
print @n.xbgr.xr18_u2.nr1[nsmm_rsh]
print @n.xbgr.xr18_u2.nr1[nsmm_w]
print @n.xbgr.xr18_u2.nr1[nsmm_l]
print @n.xbgr.xr18_u3.nr1[nsmm_rsh]
print @n.xbgr.xr18_u3.nr1[nsmm_w]
print @n.xbgr.xr18_u3.nr1[nsmm_l]
print @n.xbgr.xr18_u4.nr1[nsmm_rsh]
print @n.xbgr.xr18_u4.nr1[nsmm_w]
print @n.xbgr.xr18_u4.nr1[nsmm_l]
print @n.xbgr.xr19_u2.nr1[nsmm_rsh]
print @n.xbgr.xr19_u2.nr1[nsmm_w]
print @n.xbgr.xr19_u2.nr1[nsmm_l]
print @n.xbgr.xr19_u3.nr1[nsmm_rsh]
print @n.xbgr.xr19_u3.nr1[nsmm_w]
print @n.xbgr.xr19_u3.nr1[nsmm_l]
print @n.xbgr.xr19_u4.nr1[nsmm_rsh]
print @n.xbgr.xr19_u4.nr1[nsmm_w]
print @n.xbgr.xr19_u4.nr1[nsmm_l]
print @n.xbgr.xr20_u2.nr1[nsmm_rsh]
print @n.xbgr.xr20_u2.nr1[nsmm_w]
print @n.xbgr.xr20_u2.nr1[nsmm_l]
print @n.xbgr.xr20_u3.nr1[nsmm_rsh]
print @n.xbgr.xr20_u3.nr1[nsmm_w]
print @n.xbgr.xr20_u3.nr1[nsmm_l]
print @n.xbgr.xr20_u4.nr1[nsmm_rsh]
print @n.xbgr.xr20_u4.nr1[nsmm_w]
print @n.xbgr.xr20_u4.nr1[nsmm_l]
print @n.xbgr.xr21_u2.nr1[nsmm_rsh]
print @n.xbgr.xr21_u2.nr1[nsmm_w]
print @n.xbgr.xr21_u2.nr1[nsmm_l]
print @n.xbgr.xr21_u3.nr1[nsmm_rsh]
print @n.xbgr.xr21_u3.nr1[nsmm_w]
print @n.xbgr.xr21_u3.nr1[nsmm_l]
print @n.xbgr.xr21_u4.nr1[nsmm_rsh]
print @n.xbgr.xr21_u4.nr1[nsmm_w]
print @n.xbgr.xr21_u4.nr1[nsmm_l]
print @n.xbgr.xr22_u2.nr1[nsmm_rsh]
print @n.xbgr.xr22_u2.nr1[nsmm_w]
print @n.xbgr.xr22_u2.nr1[nsmm_l]
print @n.xbgr.xr22_u3.nr1[nsmm_rsh]
print @n.xbgr.xr22_u3.nr1[nsmm_w]
print @n.xbgr.xr22_u3.nr1[nsmm_l]
print @n.xbgr.xr22_u4.nr1[nsmm_rsh]
print @n.xbgr.xr22_u4.nr1[nsmm_w]
print @n.xbgr.xr22_u4.nr1[nsmm_l]
print @n.xbgr.xr23_u2.nr1[nsmm_rsh]
print @n.xbgr.xr23_u2.nr1[nsmm_w]
print @n.xbgr.xr23_u2.nr1[nsmm_l]
print @n.xbgr.xr23_u3.nr1[nsmm_rsh]
print @n.xbgr.xr23_u3.nr1[nsmm_w]
print @n.xbgr.xr23_u3.nr1[nsmm_l]
print @n.xbgr.xr23_u4.nr1[nsmm_rsh]
print @n.xbgr.xr23_u4.nr1[nsmm_w]
print @n.xbgr.xr23_u4.nr1[nsmm_l]
print @n.xbgr.xr23_u5.nr1[nsmm_rsh]
print @n.xbgr.xr23_u5.nr1[nsmm_w]
print @n.xbgr.xr23_u5.nr1[nsmm_l]
print @n.xbgr.xr23_u6.nr1[nsmm_rsh]
print @n.xbgr.xr23_u6.nr1[nsmm_w]
print @n.xbgr.xr23_u6.nr1[nsmm_l]
print @n.xbgr.xr23_u7.nr1[nsmm_rsh]
print @n.xbgr.xr23_u7.nr1[nsmm_w]
print @n.xbgr.xr23_u7.nr1[nsmm_l]
print @n.xbgr.xr23_u8.nr1[nsmm_rsh]
print @n.xbgr.xr23_u8.nr1[nsmm_w]
print @n.xbgr.xr23_u8.nr1[nsmm_l]
print @n.xbgr.xr23_u9.nr1[nsmm_rsh]
print @n.xbgr.xr23_u9.nr1[nsmm_w]
print @n.xbgr.xr23_u9.nr1[nsmm_l]
print @n.xbgr.xr23_u10.nr1[nsmm_rsh]
print @n.xbgr.xr23_u10.nr1[nsmm_w]
print @n.xbgr.xr23_u10.nr1[nsmm_l]
print @n.xbgr.xr23_u11.nr1[nsmm_rsh]
print @n.xbgr.xr23_u11.nr1[nsmm_w]
print @n.xbgr.xr23_u11.nr1[nsmm_l]
print @n.xbgr.xr23_u12.nr1[nsmm_rsh]
print @n.xbgr.xr23_u12.nr1[nsmm_w]
print @n.xbgr.xr23_u12.nr1[nsmm_l]
print @n.xbgr.xr23_u13.nr1[nsmm_rsh]
print @n.xbgr.xr23_u13.nr1[nsmm_w]
print @n.xbgr.xr23_u13.nr1[nsmm_l]
print @n.xbgr.xr23_u14.nr1[nsmm_rsh]
print @n.xbgr.xr23_u14.nr1[nsmm_w]
print @n.xbgr.xr23_u14.nr1[nsmm_l]
print @n.xbgr.xr23_u15.nr1[nsmm_rsh]
print @n.xbgr.xr23_u15.nr1[nsmm_w]
print @n.xbgr.xr23_u15.nr1[nsmm_l]
print @n.xbgr.xr23_u16.nr1[nsmm_rsh]
print @n.xbgr.xr23_u16.nr1[nsmm_w]
print @n.xbgr.xr23_u16.nr1[nsmm_l]
print @n.xbgr.xr23_u17.nr1[nsmm_rsh]
print @n.xbgr.xr23_u17.nr1[nsmm_w]
print @n.xbgr.xr23_u17.nr1[nsmm_l]
print @n.xbgr.xr23_u18.nr1[nsmm_rsh]
print @n.xbgr.xr23_u18.nr1[nsmm_w]
print @n.xbgr.xr23_u18.nr1[nsmm_l]
print @n.xbgr.xr23_u19.nr1[nsmm_rsh]
print @n.xbgr.xr23_u19.nr1[nsmm_w]
print @n.xbgr.xr23_u19.nr1[nsmm_l]
print @n.xbgr.xr23_u20.nr1[nsmm_rsh]
print @n.xbgr.xr23_u20.nr1[nsmm_w]
print @n.xbgr.xr23_u20.nr1[nsmm_l]
print @n.xbgr.xr23_u21.nr1[nsmm_rsh]
print @n.xbgr.xr23_u21.nr1[nsmm_w]
print @n.xbgr.xr23_u21.nr1[nsmm_l]
print @n.xbgr.xr23_u22.nr1[nsmm_rsh]
print @n.xbgr.xr23_u22.nr1[nsmm_w]
print @n.xbgr.xr23_u22.nr1[nsmm_l]
print @n.xbgr.xr23_u23.nr1[nsmm_rsh]
print @n.xbgr.xr23_u23.nr1[nsmm_w]
print @n.xbgr.xr23_u23.nr1[nsmm_l]
print @n.xbgr.xr23_u24.nr1[nsmm_rsh]
print @n.xbgr.xr23_u24.nr1[nsmm_w]
print @n.xbgr.xr23_u24.nr1[nsmm_l]
print @n.xbgr.xr24_u2.nr1[nsmm_rsh]
print @n.xbgr.xr24_u2.nr1[nsmm_w]
print @n.xbgr.xr24_u2.nr1[nsmm_l]
print @n.xbgr.xr24_u3.nr1[nsmm_rsh]
print @n.xbgr.xr24_u3.nr1[nsmm_w]
print @n.xbgr.xr24_u3.nr1[nsmm_l]
print @n.xbgr.xr24_u4.nr1[nsmm_rsh]
print @n.xbgr.xr24_u4.nr1[nsmm_w]
print @n.xbgr.xr24_u4.nr1[nsmm_l]
print @n.xbgr.xr24_u5.nr1[nsmm_rsh]
print @n.xbgr.xr24_u5.nr1[nsmm_w]
print @n.xbgr.xr24_u5.nr1[nsmm_l]
print @n.xbgr.xr24_u6.nr1[nsmm_rsh]
print @n.xbgr.xr24_u6.nr1[nsmm_w]
print @n.xbgr.xr24_u6.nr1[nsmm_l]
print @n.xbgr.xr24_u7.nr1[nsmm_rsh]
print @n.xbgr.xr24_u7.nr1[nsmm_w]
print @n.xbgr.xr24_u7.nr1[nsmm_l]
print @n.xbgr.xr24_u8.nr1[nsmm_rsh]
print @n.xbgr.xr24_u8.nr1[nsmm_w]
print @n.xbgr.xr24_u8.nr1[nsmm_l]
print @n.xbgr.xr24_u9.nr1[nsmm_rsh]
print @n.xbgr.xr24_u9.nr1[nsmm_w]
print @n.xbgr.xr24_u9.nr1[nsmm_l]
print @n.xbgr.xr24_u10.nr1[nsmm_rsh]
print @n.xbgr.xr24_u10.nr1[nsmm_w]
print @n.xbgr.xr24_u10.nr1[nsmm_l]
print @n.xbgr.xr24_u11.nr1[nsmm_rsh]
print @n.xbgr.xr24_u11.nr1[nsmm_w]
print @n.xbgr.xr24_u11.nr1[nsmm_l]
print @n.xbgr.xr24_u12.nr1[nsmm_rsh]
print @n.xbgr.xr24_u12.nr1[nsmm_w]
print @n.xbgr.xr24_u12.nr1[nsmm_l]
print @n.xbgr.xr24_u13.nr1[nsmm_rsh]
print @n.xbgr.xr24_u13.nr1[nsmm_w]
print @n.xbgr.xr24_u13.nr1[nsmm_l]
print @n.xbgr.xr24_u14.nr1[nsmm_rsh]
print @n.xbgr.xr24_u14.nr1[nsmm_w]
print @n.xbgr.xr24_u14.nr1[nsmm_l]
print @n.xbgr.xr24_u15.nr1[nsmm_rsh]
print @n.xbgr.xr24_u15.nr1[nsmm_w]
print @n.xbgr.xr24_u15.nr1[nsmm_l]
print @n.xbgr.xr24_u16.nr1[nsmm_rsh]
print @n.xbgr.xr24_u16.nr1[nsmm_w]
print @n.xbgr.xr24_u16.nr1[nsmm_l]
print @n.xbgr.xr24_u17.nr1[nsmm_rsh]
print @n.xbgr.xr24_u17.nr1[nsmm_w]
print @n.xbgr.xr24_u17.nr1[nsmm_l]
print @n.xbgr.xr24_u18.nr1[nsmm_rsh]
print @n.xbgr.xr24_u18.nr1[nsmm_w]
print @n.xbgr.xr24_u18.nr1[nsmm_l]
print @n.xbgr.xr24_u19.nr1[nsmm_rsh]
print @n.xbgr.xr24_u19.nr1[nsmm_w]
print @n.xbgr.xr24_u19.nr1[nsmm_l]
print @n.xbgr.xr24_u20.nr1[nsmm_rsh]
print @n.xbgr.xr24_u20.nr1[nsmm_w]
print @n.xbgr.xr24_u20.nr1[nsmm_l]
print @n.xbgr.xr24_u21.nr1[nsmm_rsh]
print @n.xbgr.xr24_u21.nr1[nsmm_w]
print @n.xbgr.xr24_u21.nr1[nsmm_l]
print @n.xbgr.xr24_u22.nr1[nsmm_rsh]
print @n.xbgr.xr24_u22.nr1[nsmm_w]
print @n.xbgr.xr24_u22.nr1[nsmm_l]
print @n.xbgr.xr24_u23.nr1[nsmm_rsh]
print @n.xbgr.xr24_u23.nr1[nsmm_w]
print @n.xbgr.xr24_u23.nr1[nsmm_l]
print @n.xbgr.xr24_u24.nr1[nsmm_rsh]
print @n.xbgr.xr24_u24.nr1[nsmm_w]
print @n.xbgr.xr24_u24.nr1[nsmm_l]
print @n.xbgr.xr25_u2.nr1[nsmm_rsh]
print @n.xbgr.xr25_u2.nr1[nsmm_w]
print @n.xbgr.xr25_u2.nr1[nsmm_l]
print @n.xbgr.xr25_u3.nr1[nsmm_rsh]
print @n.xbgr.xr25_u3.nr1[nsmm_w]
print @n.xbgr.xr25_u3.nr1[nsmm_l]
print @n.xbgr.xr25_u4.nr1[nsmm_rsh]
print @n.xbgr.xr25_u4.nr1[nsmm_w]
print @n.xbgr.xr25_u4.nr1[nsmm_l]
print @n.xbgr.xr25_u5.nr1[nsmm_rsh]
print @n.xbgr.xr25_u5.nr1[nsmm_w]
print @n.xbgr.xr25_u5.nr1[nsmm_l]
print @n.xbgr.xr25_u6.nr1[nsmm_rsh]
print @n.xbgr.xr25_u6.nr1[nsmm_w]
print @n.xbgr.xr25_u6.nr1[nsmm_l]
print @n.xbgr.xr25_u7.nr1[nsmm_rsh]
print @n.xbgr.xr25_u7.nr1[nsmm_w]
print @n.xbgr.xr25_u7.nr1[nsmm_l]
print @n.xbgr.xr25_u8.nr1[nsmm_rsh]
print @n.xbgr.xr25_u8.nr1[nsmm_w]
print @n.xbgr.xr25_u8.nr1[nsmm_l]
print @n.xbgr.xr25_u9.nr1[nsmm_rsh]
print @n.xbgr.xr25_u9.nr1[nsmm_w]
print @n.xbgr.xr25_u9.nr1[nsmm_l]
print @n.xbgr.xr25_u10.nr1[nsmm_rsh]
print @n.xbgr.xr25_u10.nr1[nsmm_w]
print @n.xbgr.xr25_u10.nr1[nsmm_l]
print @n.xbgr.xr25_u11.nr1[nsmm_rsh]
print @n.xbgr.xr25_u11.nr1[nsmm_w]
print @n.xbgr.xr25_u11.nr1[nsmm_l]
print @n.xbgr.xr25_u12.nr1[nsmm_rsh]
print @n.xbgr.xr25_u12.nr1[nsmm_w]
print @n.xbgr.xr25_u12.nr1[nsmm_l]
print @n.xbgr.xr25_u13.nr1[nsmm_rsh]
print @n.xbgr.xr25_u13.nr1[nsmm_w]
print @n.xbgr.xr25_u13.nr1[nsmm_l]
print @n.xbgr.xr25_u14.nr1[nsmm_rsh]
print @n.xbgr.xr25_u14.nr1[nsmm_w]
print @n.xbgr.xr25_u14.nr1[nsmm_l]
print @n.xbgr.xr25_u15.nr1[nsmm_rsh]
print @n.xbgr.xr25_u15.nr1[nsmm_w]
print @n.xbgr.xr25_u15.nr1[nsmm_l]
print @n.xbgr.xr25_u16.nr1[nsmm_rsh]
print @n.xbgr.xr25_u16.nr1[nsmm_w]
print @n.xbgr.xr25_u16.nr1[nsmm_l]
print @n.xbgr.xr25_u17.nr1[nsmm_rsh]
print @n.xbgr.xr25_u17.nr1[nsmm_w]
print @n.xbgr.xr25_u17.nr1[nsmm_l]
print @n.xbgr.xr25_u18.nr1[nsmm_rsh]
print @n.xbgr.xr25_u18.nr1[nsmm_w]
print @n.xbgr.xr25_u18.nr1[nsmm_l]
print @n.xbgr.xr25_u19.nr1[nsmm_rsh]
print @n.xbgr.xr25_u19.nr1[nsmm_w]
print @n.xbgr.xr25_u19.nr1[nsmm_l]
print @n.xbgr.xr25_u20.nr1[nsmm_rsh]
print @n.xbgr.xr25_u20.nr1[nsmm_w]
print @n.xbgr.xr25_u20.nr1[nsmm_l]
print @n.xbgr.xr25_u21.nr1[nsmm_rsh]
print @n.xbgr.xr25_u21.nr1[nsmm_w]
print @n.xbgr.xr25_u21.nr1[nsmm_l]
print @n.xbgr.xr25_u22.nr1[nsmm_rsh]
print @n.xbgr.xr25_u22.nr1[nsmm_w]
print @n.xbgr.xr25_u22.nr1[nsmm_l]
print @n.xbgr.xr25_u23.nr1[nsmm_rsh]
print @n.xbgr.xr25_u23.nr1[nsmm_w]
print @n.xbgr.xr25_u23.nr1[nsmm_l]
print @n.xbgr.xr25_u24.nr1[nsmm_rsh]
print @n.xbgr.xr25_u24.nr1[nsmm_w]
print @n.xbgr.xr25_u24.nr1[nsmm_l]
print @n.xbgr.xr26_u2.nr1[nsmm_rsh]
print @n.xbgr.xr26_u2.nr1[nsmm_w]
print @n.xbgr.xr26_u2.nr1[nsmm_l]
print @n.xbgr.xr26_u3.nr1[nsmm_rsh]
print @n.xbgr.xr26_u3.nr1[nsmm_w]
print @n.xbgr.xr26_u3.nr1[nsmm_l]
print @n.xbgr.xr26_u4.nr1[nsmm_rsh]
print @n.xbgr.xr26_u4.nr1[nsmm_w]
print @n.xbgr.xr26_u4.nr1[nsmm_l]
print @n.xbgr.xr26_u5.nr1[nsmm_rsh]
print @n.xbgr.xr26_u5.nr1[nsmm_w]
print @n.xbgr.xr26_u5.nr1[nsmm_l]
print @n.xbgr.xr26_u6.nr1[nsmm_rsh]
print @n.xbgr.xr26_u6.nr1[nsmm_w]
print @n.xbgr.xr26_u6.nr1[nsmm_l]
print @n.xbgr.xr26_u7.nr1[nsmm_rsh]
print @n.xbgr.xr26_u7.nr1[nsmm_w]
print @n.xbgr.xr26_u7.nr1[nsmm_l]
print @n.xbgr.xr26_u8.nr1[nsmm_rsh]
print @n.xbgr.xr26_u8.nr1[nsmm_w]
print @n.xbgr.xr26_u8.nr1[nsmm_l]
print @n.xbgr.xr26_u9.nr1[nsmm_rsh]
print @n.xbgr.xr26_u9.nr1[nsmm_w]
print @n.xbgr.xr26_u9.nr1[nsmm_l]
print @n.xbgr.xr26_u10.nr1[nsmm_rsh]
print @n.xbgr.xr26_u10.nr1[nsmm_w]
print @n.xbgr.xr26_u10.nr1[nsmm_l]
print @n.xbgr.xr26_u11.nr1[nsmm_rsh]
print @n.xbgr.xr26_u11.nr1[nsmm_w]
print @n.xbgr.xr26_u11.nr1[nsmm_l]
print @n.xbgr.xr26_u12.nr1[nsmm_rsh]
print @n.xbgr.xr26_u12.nr1[nsmm_w]
print @n.xbgr.xr26_u12.nr1[nsmm_l]
print @n.xbgr.xr26_u13.nr1[nsmm_rsh]
print @n.xbgr.xr26_u13.nr1[nsmm_w]
print @n.xbgr.xr26_u13.nr1[nsmm_l]
print @n.xbgr.xr26_u14.nr1[nsmm_rsh]
print @n.xbgr.xr26_u14.nr1[nsmm_w]
print @n.xbgr.xr26_u14.nr1[nsmm_l]
print @n.xbgr.xr26_u15.nr1[nsmm_rsh]
print @n.xbgr.xr26_u15.nr1[nsmm_w]
print @n.xbgr.xr26_u15.nr1[nsmm_l]
print @n.xbgr.xr26_u16.nr1[nsmm_rsh]
print @n.xbgr.xr26_u16.nr1[nsmm_w]
print @n.xbgr.xr26_u16.nr1[nsmm_l]
print @n.xbgr.xr26_u17.nr1[nsmm_rsh]
print @n.xbgr.xr26_u17.nr1[nsmm_w]
print @n.xbgr.xr26_u17.nr1[nsmm_l]
print @n.xbgr.xr26_u18.nr1[nsmm_rsh]
print @n.xbgr.xr26_u18.nr1[nsmm_w]
print @n.xbgr.xr26_u18.nr1[nsmm_l]
print @n.xbgr.xr26_u19.nr1[nsmm_rsh]
print @n.xbgr.xr26_u19.nr1[nsmm_w]
print @n.xbgr.xr26_u19.nr1[nsmm_l]
print @n.xbgr.xr26_u20.nr1[nsmm_rsh]
print @n.xbgr.xr26_u20.nr1[nsmm_w]
print @n.xbgr.xr26_u20.nr1[nsmm_l]
print @n.xbgr.xr26_u21.nr1[nsmm_rsh]
print @n.xbgr.xr26_u21.nr1[nsmm_w]
print @n.xbgr.xr26_u21.nr1[nsmm_l]
print @n.xbgr.xr26_u22.nr1[nsmm_rsh]
print @n.xbgr.xr26_u22.nr1[nsmm_w]
print @n.xbgr.xr26_u22.nr1[nsmm_l]
print @n.xbgr.xr26_u23.nr1[nsmm_rsh]
print @n.xbgr.xr26_u23.nr1[nsmm_w]
print @n.xbgr.xr26_u23.nr1[nsmm_l]
print @n.xbgr.xr26_u24.nr1[nsmm_rsh]
print @n.xbgr.xr26_u24.nr1[nsmm_w]
print @n.xbgr.xr26_u24.nr1[nsmm_l]
print @n.xbgr.xm34_u2.nsg13_hv_nmos[w]
print @n.xbgr.xm34_u2.nsg13_hv_nmos[l]
print @n.xbgr.xm34_u2.nsg13_hv_nmos[delvto]
print @n.xbgr.xm34_u2.nsg13_hv_nmos[factuo]
print @n.xbgr.xm34_u3.nsg13_hv_nmos[w]
print @n.xbgr.xm34_u3.nsg13_hv_nmos[l]
print @n.xbgr.xm34_u3.nsg13_hv_nmos[delvto]
print @n.xbgr.xm34_u3.nsg13_hv_nmos[factuo]
print @n.xbgr.xm34_u4.nsg13_hv_nmos[w]
print @n.xbgr.xm34_u4.nsg13_hv_nmos[l]
print @n.xbgr.xm34_u4.nsg13_hv_nmos[delvto]
print @n.xbgr.xm34_u4.nsg13_hv_nmos[factuo]
print @n.xbgr.xm34_u5.nsg13_hv_nmos[w]
print @n.xbgr.xm34_u5.nsg13_hv_nmos[l]
print @n.xbgr.xm34_u5.nsg13_hv_nmos[delvto]
print @n.xbgr.xm34_u5.nsg13_hv_nmos[factuo]
print @n.xbgr.xm34_u6.nsg13_hv_nmos[w]
print @n.xbgr.xm34_u6.nsg13_hv_nmos[l]
print @n.xbgr.xm34_u6.nsg13_hv_nmos[delvto]
print @n.xbgr.xm34_u6.nsg13_hv_nmos[factuo]
print @n.xbgr.xm34_u7.nsg13_hv_nmos[w]
print @n.xbgr.xm34_u7.nsg13_hv_nmos[l]
print @n.xbgr.xm34_u7.nsg13_hv_nmos[delvto]
print @n.xbgr.xm34_u7.nsg13_hv_nmos[factuo]
print @n.xbgr.xm34_u8.nsg13_hv_nmos[w]
print @n.xbgr.xm34_u8.nsg13_hv_nmos[l]
print @n.xbgr.xm34_u8.nsg13_hv_nmos[delvto]
print @n.xbgr.xm34_u8.nsg13_hv_nmos[factuo]
print @n.xbgr.xm34_u9.nsg13_hv_nmos[w]
print @n.xbgr.xm34_u9.nsg13_hv_nmos[l]
print @n.xbgr.xm34_u9.nsg13_hv_nmos[delvto]
print @n.xbgr.xm34_u9.nsg13_hv_nmos[factuo]
print @n.xbgr.xm34_u10.nsg13_hv_nmos[w]
print @n.xbgr.xm34_u10.nsg13_hv_nmos[l]
print @n.xbgr.xm34_u10.nsg13_hv_nmos[delvto]
print @n.xbgr.xm34_u10.nsg13_hv_nmos[factuo]
print @n.xbgr.xm34_u11.nsg13_hv_nmos[w]
print @n.xbgr.xm34_u11.nsg13_hv_nmos[l]
print @n.xbgr.xm34_u11.nsg13_hv_nmos[delvto]
print @n.xbgr.xm34_u11.nsg13_hv_nmos[factuo]
print @n.xbgr.xm34_u12.nsg13_hv_nmos[w]
print @n.xbgr.xm34_u12.nsg13_hv_nmos[l]
print @n.xbgr.xm34_u12.nsg13_hv_nmos[delvto]
print @n.xbgr.xm34_u12.nsg13_hv_nmos[factuo]
print @n.xbgr.xm34_u13.nsg13_hv_nmos[w]
print @n.xbgr.xm34_u13.nsg13_hv_nmos[l]
print @n.xbgr.xm34_u13.nsg13_hv_nmos[delvto]
print @n.xbgr.xm34_u13.nsg13_hv_nmos[factuo]
print @n.xbgr.xm34_u14.nsg13_hv_nmos[w]
print @n.xbgr.xm34_u14.nsg13_hv_nmos[l]
print @n.xbgr.xm34_u14.nsg13_hv_nmos[delvto]
print @n.xbgr.xm34_u14.nsg13_hv_nmos[factuo]
print @n.xbgr.xm34_u15.nsg13_hv_nmos[w]
print @n.xbgr.xm34_u15.nsg13_hv_nmos[l]
print @n.xbgr.xm34_u15.nsg13_hv_nmos[delvto]
print @n.xbgr.xm34_u15.nsg13_hv_nmos[factuo]
print @n.xbgr.xm34_u16.nsg13_hv_nmos[w]
print @n.xbgr.xm34_u16.nsg13_hv_nmos[l]
print @n.xbgr.xm34_u16.nsg13_hv_nmos[delvto]
print @n.xbgr.xm34_u16.nsg13_hv_nmos[factuo]
print @n.xbgr.xm34_u17.nsg13_hv_nmos[w]
print @n.xbgr.xm34_u17.nsg13_hv_nmos[l]
print @n.xbgr.xm34_u17.nsg13_hv_nmos[delvto]
print @n.xbgr.xm34_u17.nsg13_hv_nmos[factuo]
print @n.xbgr.xm34_u18.nsg13_hv_nmos[w]
print @n.xbgr.xm34_u18.nsg13_hv_nmos[l]
print @n.xbgr.xm34_u18.nsg13_hv_nmos[delvto]
print @n.xbgr.xm34_u18.nsg13_hv_nmos[factuo]
print @n.xbgr.xm34_u19.nsg13_hv_nmos[w]
print @n.xbgr.xm34_u19.nsg13_hv_nmos[l]
print @n.xbgr.xm34_u19.nsg13_hv_nmos[delvto]
print @n.xbgr.xm34_u19.nsg13_hv_nmos[factuo]
print @n.xbgr.xm34_u20.nsg13_hv_nmos[w]
print @n.xbgr.xm34_u20.nsg13_hv_nmos[l]
print @n.xbgr.xm34_u20.nsg13_hv_nmos[delvto]
print @n.xbgr.xm34_u20.nsg13_hv_nmos[factuo]
print @n.xbgr.xm34_u21.nsg13_hv_nmos[w]
print @n.xbgr.xm34_u21.nsg13_hv_nmos[l]
print @n.xbgr.xm34_u21.nsg13_hv_nmos[delvto]
print @n.xbgr.xm34_u21.nsg13_hv_nmos[factuo]
print @n.xbgr.xm34_u22.nsg13_hv_nmos[w]
print @n.xbgr.xm34_u22.nsg13_hv_nmos[l]
print @n.xbgr.xm34_u22.nsg13_hv_nmos[delvto]
print @n.xbgr.xm34_u22.nsg13_hv_nmos[factuo]
print @n.xbgr.xm34_u23.nsg13_hv_nmos[w]
print @n.xbgr.xm34_u23.nsg13_hv_nmos[l]
print @n.xbgr.xm34_u23.nsg13_hv_nmos[delvto]
print @n.xbgr.xm34_u23.nsg13_hv_nmos[factuo]
print @n.xbgr.xm34_u24.nsg13_hv_nmos[w]
print @n.xbgr.xm34_u24.nsg13_hv_nmos[l]
print @n.xbgr.xm34_u24.nsg13_hv_nmos[delvto]
print @n.xbgr.xm34_u24.nsg13_hv_nmos[factuo]
print @n.xbgr.xm35_u2.nsg13_hv_nmos[w]
print @n.xbgr.xm35_u2.nsg13_hv_nmos[l]
print @n.xbgr.xm35_u2.nsg13_hv_nmos[delvto]
print @n.xbgr.xm35_u2.nsg13_hv_nmos[factuo]
print @n.xbgr.xm35_u3.nsg13_hv_nmos[w]
print @n.xbgr.xm35_u3.nsg13_hv_nmos[l]
print @n.xbgr.xm35_u3.nsg13_hv_nmos[delvto]
print @n.xbgr.xm35_u3.nsg13_hv_nmos[factuo]
print @n.xbgr.xm35_u4.nsg13_hv_nmos[w]
print @n.xbgr.xm35_u4.nsg13_hv_nmos[l]
print @n.xbgr.xm35_u4.nsg13_hv_nmos[delvto]
print @n.xbgr.xm35_u4.nsg13_hv_nmos[factuo]
print @n.xbgr.xm35_u5.nsg13_hv_nmos[w]
print @n.xbgr.xm35_u5.nsg13_hv_nmos[l]
print @n.xbgr.xm35_u5.nsg13_hv_nmos[delvto]
print @n.xbgr.xm35_u5.nsg13_hv_nmos[factuo]
print @n.xbgr.xm35_u6.nsg13_hv_nmos[w]
print @n.xbgr.xm35_u6.nsg13_hv_nmos[l]
print @n.xbgr.xm35_u6.nsg13_hv_nmos[delvto]
print @n.xbgr.xm35_u6.nsg13_hv_nmos[factuo]
print @n.xbgr.xm35_u7.nsg13_hv_nmos[w]
print @n.xbgr.xm35_u7.nsg13_hv_nmos[l]
print @n.xbgr.xm35_u7.nsg13_hv_nmos[delvto]
print @n.xbgr.xm35_u7.nsg13_hv_nmos[factuo]
print @n.xbgr.xm35_u8.nsg13_hv_nmos[w]
print @n.xbgr.xm35_u8.nsg13_hv_nmos[l]
print @n.xbgr.xm35_u8.nsg13_hv_nmos[delvto]
print @n.xbgr.xm35_u8.nsg13_hv_nmos[factuo]
print @n.xbgr.xm35_u9.nsg13_hv_nmos[w]
print @n.xbgr.xm35_u9.nsg13_hv_nmos[l]
print @n.xbgr.xm35_u9.nsg13_hv_nmos[delvto]
print @n.xbgr.xm35_u9.nsg13_hv_nmos[factuo]
print @n.xbgr.xm35_u10.nsg13_hv_nmos[w]
print @n.xbgr.xm35_u10.nsg13_hv_nmos[l]
print @n.xbgr.xm35_u10.nsg13_hv_nmos[delvto]
print @n.xbgr.xm35_u10.nsg13_hv_nmos[factuo]
print @n.xbgr.xm35_u11.nsg13_hv_nmos[w]
print @n.xbgr.xm35_u11.nsg13_hv_nmos[l]
print @n.xbgr.xm35_u11.nsg13_hv_nmos[delvto]
print @n.xbgr.xm35_u11.nsg13_hv_nmos[factuo]
print @n.xbgr.xm35_u12.nsg13_hv_nmos[w]
print @n.xbgr.xm35_u12.nsg13_hv_nmos[l]
print @n.xbgr.xm35_u12.nsg13_hv_nmos[delvto]
print @n.xbgr.xm35_u12.nsg13_hv_nmos[factuo]
print @n.xbgr.xm35_u13.nsg13_hv_nmos[w]
print @n.xbgr.xm35_u13.nsg13_hv_nmos[l]
print @n.xbgr.xm35_u13.nsg13_hv_nmos[delvto]
print @n.xbgr.xm35_u13.nsg13_hv_nmos[factuo]
print @n.xbgr.xm35_u14.nsg13_hv_nmos[w]
print @n.xbgr.xm35_u14.nsg13_hv_nmos[l]
print @n.xbgr.xm35_u14.nsg13_hv_nmos[delvto]
print @n.xbgr.xm35_u14.nsg13_hv_nmos[factuo]
print @n.xbgr.xm35_u15.nsg13_hv_nmos[w]
print @n.xbgr.xm35_u15.nsg13_hv_nmos[l]
print @n.xbgr.xm35_u15.nsg13_hv_nmos[delvto]
print @n.xbgr.xm35_u15.nsg13_hv_nmos[factuo]
print @n.xbgr.xm35_u16.nsg13_hv_nmos[w]
print @n.xbgr.xm35_u16.nsg13_hv_nmos[l]
print @n.xbgr.xm35_u16.nsg13_hv_nmos[delvto]
print @n.xbgr.xm35_u16.nsg13_hv_nmos[factuo]
print @n.xbgr.xm35_u17.nsg13_hv_nmos[w]
print @n.xbgr.xm35_u17.nsg13_hv_nmos[l]
print @n.xbgr.xm35_u17.nsg13_hv_nmos[delvto]
print @n.xbgr.xm35_u17.nsg13_hv_nmos[factuo]
print @n.xbgr.xm35_u18.nsg13_hv_nmos[w]
print @n.xbgr.xm35_u18.nsg13_hv_nmos[l]
print @n.xbgr.xm35_u18.nsg13_hv_nmos[delvto]
print @n.xbgr.xm35_u18.nsg13_hv_nmos[factuo]
print @n.xbgr.xm35_u19.nsg13_hv_nmos[w]
print @n.xbgr.xm35_u19.nsg13_hv_nmos[l]
print @n.xbgr.xm35_u19.nsg13_hv_nmos[delvto]
print @n.xbgr.xm35_u19.nsg13_hv_nmos[factuo]
print @n.xbgr.xm35_u20.nsg13_hv_nmos[w]
print @n.xbgr.xm35_u20.nsg13_hv_nmos[l]
print @n.xbgr.xm35_u20.nsg13_hv_nmos[delvto]
print @n.xbgr.xm35_u20.nsg13_hv_nmos[factuo]
print @n.xbgr.xm35_u21.nsg13_hv_nmos[w]
print @n.xbgr.xm35_u21.nsg13_hv_nmos[l]
print @n.xbgr.xm35_u21.nsg13_hv_nmos[delvto]
print @n.xbgr.xm35_u21.nsg13_hv_nmos[factuo]
print @n.xbgr.xm35_u22.nsg13_hv_nmos[w]
print @n.xbgr.xm35_u22.nsg13_hv_nmos[l]
print @n.xbgr.xm35_u22.nsg13_hv_nmos[delvto]
print @n.xbgr.xm35_u22.nsg13_hv_nmos[factuo]
print @n.xbgr.xm35_u23.nsg13_hv_nmos[w]
print @n.xbgr.xm35_u23.nsg13_hv_nmos[l]
print @n.xbgr.xm35_u23.nsg13_hv_nmos[delvto]
print @n.xbgr.xm35_u23.nsg13_hv_nmos[factuo]
print @n.xbgr.xm35_u24.nsg13_hv_nmos[w]
print @n.xbgr.xm35_u24.nsg13_hv_nmos[l]
print @n.xbgr.xm35_u24.nsg13_hv_nmos[delvto]
print @n.xbgr.xm35_u24.nsg13_hv_nmos[factuo]
print @n.xbgr.xm36_u2.nsg13_hv_nmos[w]
print @n.xbgr.xm36_u2.nsg13_hv_nmos[l]
print @n.xbgr.xm36_u2.nsg13_hv_nmos[delvto]
print @n.xbgr.xm36_u2.nsg13_hv_nmos[factuo]
print @n.xbgr.xm36_u3.nsg13_hv_nmos[w]
print @n.xbgr.xm36_u3.nsg13_hv_nmos[l]
print @n.xbgr.xm36_u3.nsg13_hv_nmos[delvto]
print @n.xbgr.xm36_u3.nsg13_hv_nmos[factuo]
print @n.xbgr.xm36_u4.nsg13_hv_nmos[w]
print @n.xbgr.xm36_u4.nsg13_hv_nmos[l]
print @n.xbgr.xm36_u4.nsg13_hv_nmos[delvto]
print @n.xbgr.xm36_u4.nsg13_hv_nmos[factuo]
print @n.xbgr.xm36_u5.nsg13_hv_nmos[w]
print @n.xbgr.xm36_u5.nsg13_hv_nmos[l]
print @n.xbgr.xm36_u5.nsg13_hv_nmos[delvto]
print @n.xbgr.xm36_u5.nsg13_hv_nmos[factuo]
print @n.xbgr.xm36_u6.nsg13_hv_nmos[w]
print @n.xbgr.xm36_u6.nsg13_hv_nmos[l]
print @n.xbgr.xm36_u6.nsg13_hv_nmos[delvto]
print @n.xbgr.xm36_u6.nsg13_hv_nmos[factuo]
print @n.xbgr.xm36_u7.nsg13_hv_nmos[w]
print @n.xbgr.xm36_u7.nsg13_hv_nmos[l]
print @n.xbgr.xm36_u7.nsg13_hv_nmos[delvto]
print @n.xbgr.xm36_u7.nsg13_hv_nmos[factuo]
print @n.xbgr.xm36_u8.nsg13_hv_nmos[w]
print @n.xbgr.xm36_u8.nsg13_hv_nmos[l]
print @n.xbgr.xm36_u8.nsg13_hv_nmos[delvto]
print @n.xbgr.xm36_u8.nsg13_hv_nmos[factuo]
print @n.xbgr.xm36_u9.nsg13_hv_nmos[w]
print @n.xbgr.xm36_u9.nsg13_hv_nmos[l]
print @n.xbgr.xm36_u9.nsg13_hv_nmos[delvto]
print @n.xbgr.xm36_u9.nsg13_hv_nmos[factuo]
print @n.xbgr.xm36_u10.nsg13_hv_nmos[w]
print @n.xbgr.xm36_u10.nsg13_hv_nmos[l]
print @n.xbgr.xm36_u10.nsg13_hv_nmos[delvto]
print @n.xbgr.xm36_u10.nsg13_hv_nmos[factuo]
print @n.xbgr.xm36_u11.nsg13_hv_nmos[w]
print @n.xbgr.xm36_u11.nsg13_hv_nmos[l]
print @n.xbgr.xm36_u11.nsg13_hv_nmos[delvto]
print @n.xbgr.xm36_u11.nsg13_hv_nmos[factuo]
print @n.xbgr.xm36_u12.nsg13_hv_nmos[w]
print @n.xbgr.xm36_u12.nsg13_hv_nmos[l]
print @n.xbgr.xm36_u12.nsg13_hv_nmos[delvto]
print @n.xbgr.xm36_u12.nsg13_hv_nmos[factuo]
print @n.xbgr.xm36_u13.nsg13_hv_nmos[w]
print @n.xbgr.xm36_u13.nsg13_hv_nmos[l]
print @n.xbgr.xm36_u13.nsg13_hv_nmos[delvto]
print @n.xbgr.xm36_u13.nsg13_hv_nmos[factuo]
print @n.xbgr.xm36_u14.nsg13_hv_nmos[w]
print @n.xbgr.xm36_u14.nsg13_hv_nmos[l]
print @n.xbgr.xm36_u14.nsg13_hv_nmos[delvto]
print @n.xbgr.xm36_u14.nsg13_hv_nmos[factuo]
print @n.xbgr.xm36_u15.nsg13_hv_nmos[w]
print @n.xbgr.xm36_u15.nsg13_hv_nmos[l]
print @n.xbgr.xm36_u15.nsg13_hv_nmos[delvto]
print @n.xbgr.xm36_u15.nsg13_hv_nmos[factuo]
print @n.xbgr.xm36_u16.nsg13_hv_nmos[w]
print @n.xbgr.xm36_u16.nsg13_hv_nmos[l]
print @n.xbgr.xm36_u16.nsg13_hv_nmos[delvto]
print @n.xbgr.xm36_u16.nsg13_hv_nmos[factuo]
print @n.xbgr.xm36_u17.nsg13_hv_nmos[w]
print @n.xbgr.xm36_u17.nsg13_hv_nmos[l]
print @n.xbgr.xm36_u17.nsg13_hv_nmos[delvto]
print @n.xbgr.xm36_u17.nsg13_hv_nmos[factuo]
print @n.xbgr.xm36_u18.nsg13_hv_nmos[w]
print @n.xbgr.xm36_u18.nsg13_hv_nmos[l]
print @n.xbgr.xm36_u18.nsg13_hv_nmos[delvto]
print @n.xbgr.xm36_u18.nsg13_hv_nmos[factuo]
print @n.xbgr.xm36_u19.nsg13_hv_nmos[w]
print @n.xbgr.xm36_u19.nsg13_hv_nmos[l]
print @n.xbgr.xm36_u19.nsg13_hv_nmos[delvto]
print @n.xbgr.xm36_u19.nsg13_hv_nmos[factuo]
print @n.xbgr.xm36_u20.nsg13_hv_nmos[w]
print @n.xbgr.xm36_u20.nsg13_hv_nmos[l]
print @n.xbgr.xm36_u20.nsg13_hv_nmos[delvto]
print @n.xbgr.xm36_u20.nsg13_hv_nmos[factuo]
print @n.xbgr.xm36_u21.nsg13_hv_nmos[w]
print @n.xbgr.xm36_u21.nsg13_hv_nmos[l]
print @n.xbgr.xm36_u21.nsg13_hv_nmos[delvto]
print @n.xbgr.xm36_u21.nsg13_hv_nmos[factuo]
print @n.xbgr.xm36_u22.nsg13_hv_nmos[w]
print @n.xbgr.xm36_u22.nsg13_hv_nmos[l]
print @n.xbgr.xm36_u22.nsg13_hv_nmos[delvto]
print @n.xbgr.xm36_u22.nsg13_hv_nmos[factuo]
print @n.xbgr.xm36_u23.nsg13_hv_nmos[w]
print @n.xbgr.xm36_u23.nsg13_hv_nmos[l]
print @n.xbgr.xm36_u23.nsg13_hv_nmos[delvto]
print @n.xbgr.xm36_u23.nsg13_hv_nmos[factuo]
print @n.xbgr.xm36_u24.nsg13_hv_nmos[w]
print @n.xbgr.xm36_u24.nsg13_hv_nmos[l]
print @n.xbgr.xm36_u24.nsg13_hv_nmos[delvto]
print @n.xbgr.xm36_u24.nsg13_hv_nmos[factuo]
print @n.xbgr.xm37_u2.nsg13_hv_nmos[w]
print @n.xbgr.xm37_u2.nsg13_hv_nmos[l]
print @n.xbgr.xm37_u2.nsg13_hv_nmos[delvto]
print @n.xbgr.xm37_u2.nsg13_hv_nmos[factuo]
print @n.xbgr.xm37_u3.nsg13_hv_nmos[w]
print @n.xbgr.xm37_u3.nsg13_hv_nmos[l]
print @n.xbgr.xm37_u3.nsg13_hv_nmos[delvto]
print @n.xbgr.xm37_u3.nsg13_hv_nmos[factuo]
print @n.xbgr.xm37_u4.nsg13_hv_nmos[w]
print @n.xbgr.xm37_u4.nsg13_hv_nmos[l]
print @n.xbgr.xm37_u4.nsg13_hv_nmos[delvto]
print @n.xbgr.xm37_u4.nsg13_hv_nmos[factuo]
print @n.xbgr.xm37_u5.nsg13_hv_nmos[w]
print @n.xbgr.xm37_u5.nsg13_hv_nmos[l]
print @n.xbgr.xm37_u5.nsg13_hv_nmos[delvto]
print @n.xbgr.xm37_u5.nsg13_hv_nmos[factuo]
print @n.xbgr.xm37_u6.nsg13_hv_nmos[w]
print @n.xbgr.xm37_u6.nsg13_hv_nmos[l]
print @n.xbgr.xm37_u6.nsg13_hv_nmos[delvto]
print @n.xbgr.xm37_u6.nsg13_hv_nmos[factuo]
print @n.xbgr.xm37_u7.nsg13_hv_nmos[w]
print @n.xbgr.xm37_u7.nsg13_hv_nmos[l]
print @n.xbgr.xm37_u7.nsg13_hv_nmos[delvto]
print @n.xbgr.xm37_u7.nsg13_hv_nmos[factuo]
print @n.xbgr.xm37_u8.nsg13_hv_nmos[w]
print @n.xbgr.xm37_u8.nsg13_hv_nmos[l]
print @n.xbgr.xm37_u8.nsg13_hv_nmos[delvto]
print @n.xbgr.xm37_u8.nsg13_hv_nmos[factuo]
print @n.xbgr.xm37_u9.nsg13_hv_nmos[w]
print @n.xbgr.xm37_u9.nsg13_hv_nmos[l]
print @n.xbgr.xm37_u9.nsg13_hv_nmos[delvto]
print @n.xbgr.xm37_u9.nsg13_hv_nmos[factuo]
print @n.xbgr.xm37_u10.nsg13_hv_nmos[w]
print @n.xbgr.xm37_u10.nsg13_hv_nmos[l]
print @n.xbgr.xm37_u10.nsg13_hv_nmos[delvto]
print @n.xbgr.xm37_u10.nsg13_hv_nmos[factuo]
print @n.xbgr.xm37_u11.nsg13_hv_nmos[w]
print @n.xbgr.xm37_u11.nsg13_hv_nmos[l]
print @n.xbgr.xm37_u11.nsg13_hv_nmos[delvto]
print @n.xbgr.xm37_u11.nsg13_hv_nmos[factuo]
print @n.xbgr.xm37_u12.nsg13_hv_nmos[w]
print @n.xbgr.xm37_u12.nsg13_hv_nmos[l]
print @n.xbgr.xm37_u12.nsg13_hv_nmos[delvto]
print @n.xbgr.xm37_u12.nsg13_hv_nmos[factuo]
print @n.xbgr.xm37_u13.nsg13_hv_nmos[w]
print @n.xbgr.xm37_u13.nsg13_hv_nmos[l]
print @n.xbgr.xm37_u13.nsg13_hv_nmos[delvto]
print @n.xbgr.xm37_u13.nsg13_hv_nmos[factuo]
print @n.xbgr.xm37_u14.nsg13_hv_nmos[w]
print @n.xbgr.xm37_u14.nsg13_hv_nmos[l]
print @n.xbgr.xm37_u14.nsg13_hv_nmos[delvto]
print @n.xbgr.xm37_u14.nsg13_hv_nmos[factuo]
print @n.xbgr.xm37_u15.nsg13_hv_nmos[w]
print @n.xbgr.xm37_u15.nsg13_hv_nmos[l]
print @n.xbgr.xm37_u15.nsg13_hv_nmos[delvto]
print @n.xbgr.xm37_u15.nsg13_hv_nmos[factuo]
print @n.xbgr.xm37_u16.nsg13_hv_nmos[w]
print @n.xbgr.xm37_u16.nsg13_hv_nmos[l]
print @n.xbgr.xm37_u16.nsg13_hv_nmos[delvto]
print @n.xbgr.xm37_u16.nsg13_hv_nmos[factuo]
print @n.xbgr.xm37_u17.nsg13_hv_nmos[w]
print @n.xbgr.xm37_u17.nsg13_hv_nmos[l]
print @n.xbgr.xm37_u17.nsg13_hv_nmos[delvto]
print @n.xbgr.xm37_u17.nsg13_hv_nmos[factuo]
print @n.xbgr.xm37_u18.nsg13_hv_nmos[w]
print @n.xbgr.xm37_u18.nsg13_hv_nmos[l]
print @n.xbgr.xm37_u18.nsg13_hv_nmos[delvto]
print @n.xbgr.xm37_u18.nsg13_hv_nmos[factuo]
print @n.xbgr.xm37_u19.nsg13_hv_nmos[w]
print @n.xbgr.xm37_u19.nsg13_hv_nmos[l]
print @n.xbgr.xm37_u19.nsg13_hv_nmos[delvto]
print @n.xbgr.xm37_u19.nsg13_hv_nmos[factuo]
print @n.xbgr.xm37_u20.nsg13_hv_nmos[w]
print @n.xbgr.xm37_u20.nsg13_hv_nmos[l]
print @n.xbgr.xm37_u20.nsg13_hv_nmos[delvto]
print @n.xbgr.xm37_u20.nsg13_hv_nmos[factuo]
print @n.xbgr.xm37_u21.nsg13_hv_nmos[w]
print @n.xbgr.xm37_u21.nsg13_hv_nmos[l]
print @n.xbgr.xm37_u21.nsg13_hv_nmos[delvto]
print @n.xbgr.xm37_u21.nsg13_hv_nmos[factuo]
print @n.xbgr.xm37_u22.nsg13_hv_nmos[w]
print @n.xbgr.xm37_u22.nsg13_hv_nmos[l]
print @n.xbgr.xm37_u22.nsg13_hv_nmos[delvto]
print @n.xbgr.xm37_u22.nsg13_hv_nmos[factuo]
print @n.xbgr.xm37_u23.nsg13_hv_nmos[w]
print @n.xbgr.xm37_u23.nsg13_hv_nmos[l]
print @n.xbgr.xm37_u23.nsg13_hv_nmos[delvto]
print @n.xbgr.xm37_u23.nsg13_hv_nmos[factuo]
print @n.xbgr.xm37_u24.nsg13_hv_nmos[w]
print @n.xbgr.xm37_u24.nsg13_hv_nmos[l]
print @n.xbgr.xm37_u24.nsg13_hv_nmos[delvto]
print @n.xbgr.xm37_u24.nsg13_hv_nmos[factuo]
print @n.xbgr.xm38_u2.nsg13_hv_pmos[w]
print @n.xbgr.xm38_u2.nsg13_hv_pmos[l]
print @n.xbgr.xm38_u2.nsg13_hv_pmos[delvto]
print @n.xbgr.xm38_u2.nsg13_hv_pmos[factuo]
print @n.xbgr.xm38_u3.nsg13_hv_pmos[w]
print @n.xbgr.xm38_u3.nsg13_hv_pmos[l]
print @n.xbgr.xm38_u3.nsg13_hv_pmos[delvto]
print @n.xbgr.xm38_u3.nsg13_hv_pmos[factuo]
print @n.xbgr.xm38_u4.nsg13_hv_pmos[w]
print @n.xbgr.xm38_u4.nsg13_hv_pmos[l]
print @n.xbgr.xm38_u4.nsg13_hv_pmos[delvto]
print @n.xbgr.xm38_u4.nsg13_hv_pmos[factuo]
print @n.xbgr.xm38_u5.nsg13_hv_pmos[w]
print @n.xbgr.xm38_u5.nsg13_hv_pmos[l]
print @n.xbgr.xm38_u5.nsg13_hv_pmos[delvto]
print @n.xbgr.xm38_u5.nsg13_hv_pmos[factuo]
print @n.xbgr.xm38_u6.nsg13_hv_pmos[w]
print @n.xbgr.xm38_u6.nsg13_hv_pmos[l]
print @n.xbgr.xm38_u6.nsg13_hv_pmos[delvto]
print @n.xbgr.xm38_u6.nsg13_hv_pmos[factuo]
print @n.xbgr.xm38_u7.nsg13_hv_pmos[w]
print @n.xbgr.xm38_u7.nsg13_hv_pmos[l]
print @n.xbgr.xm38_u7.nsg13_hv_pmos[delvto]
print @n.xbgr.xm38_u7.nsg13_hv_pmos[factuo]
print @n.xbgr.xm38_u8.nsg13_hv_pmos[w]
print @n.xbgr.xm38_u8.nsg13_hv_pmos[l]
print @n.xbgr.xm38_u8.nsg13_hv_pmos[delvto]
print @n.xbgr.xm38_u8.nsg13_hv_pmos[factuo]
print @n.xbgr.xm38_u9.nsg13_hv_pmos[w]
print @n.xbgr.xm38_u9.nsg13_hv_pmos[l]
print @n.xbgr.xm38_u9.nsg13_hv_pmos[delvto]
print @n.xbgr.xm38_u9.nsg13_hv_pmos[factuo]
print @n.xbgr.xm38_u10.nsg13_hv_pmos[w]
print @n.xbgr.xm38_u10.nsg13_hv_pmos[l]
print @n.xbgr.xm38_u10.nsg13_hv_pmos[delvto]
print @n.xbgr.xm38_u10.nsg13_hv_pmos[factuo]
print @n.xbgr.xm38_u11.nsg13_hv_pmos[w]
print @n.xbgr.xm38_u11.nsg13_hv_pmos[l]
print @n.xbgr.xm38_u11.nsg13_hv_pmos[delvto]
print @n.xbgr.xm38_u11.nsg13_hv_pmos[factuo]
print @n.xbgr.xm38_u12.nsg13_hv_pmos[w]
print @n.xbgr.xm38_u12.nsg13_hv_pmos[l]
print @n.xbgr.xm38_u12.nsg13_hv_pmos[delvto]
print @n.xbgr.xm38_u12.nsg13_hv_pmos[factuo]
print @n.xbgr.xm38_u13.nsg13_hv_pmos[w]
print @n.xbgr.xm38_u13.nsg13_hv_pmos[l]
print @n.xbgr.xm38_u13.nsg13_hv_pmos[delvto]
print @n.xbgr.xm38_u13.nsg13_hv_pmos[factuo]
print @n.xbgr.xm38_u14.nsg13_hv_pmos[w]
print @n.xbgr.xm38_u14.nsg13_hv_pmos[l]
print @n.xbgr.xm38_u14.nsg13_hv_pmos[delvto]
print @n.xbgr.xm38_u14.nsg13_hv_pmos[factuo]
print @n.xbgr.xm38_u15.nsg13_hv_pmos[w]
print @n.xbgr.xm38_u15.nsg13_hv_pmos[l]
print @n.xbgr.xm38_u15.nsg13_hv_pmos[delvto]
print @n.xbgr.xm38_u15.nsg13_hv_pmos[factuo]
print @n.xbgr.xm38_u16.nsg13_hv_pmos[w]
print @n.xbgr.xm38_u16.nsg13_hv_pmos[l]
print @n.xbgr.xm38_u16.nsg13_hv_pmos[delvto]
print @n.xbgr.xm38_u16.nsg13_hv_pmos[factuo]
print @n.xbgr.xm38_u17.nsg13_hv_pmos[w]
print @n.xbgr.xm38_u17.nsg13_hv_pmos[l]
print @n.xbgr.xm38_u17.nsg13_hv_pmos[delvto]
print @n.xbgr.xm38_u17.nsg13_hv_pmos[factuo]
print @n.xbgr.xm38_u18.nsg13_hv_pmos[w]
print @n.xbgr.xm38_u18.nsg13_hv_pmos[l]
print @n.xbgr.xm38_u18.nsg13_hv_pmos[delvto]
print @n.xbgr.xm38_u18.nsg13_hv_pmos[factuo]
print @n.xbgr.xm38_u19.nsg13_hv_pmos[w]
print @n.xbgr.xm38_u19.nsg13_hv_pmos[l]
print @n.xbgr.xm38_u19.nsg13_hv_pmos[delvto]
print @n.xbgr.xm38_u19.nsg13_hv_pmos[factuo]
print @n.xbgr.xm38_u20.nsg13_hv_pmos[w]
print @n.xbgr.xm38_u20.nsg13_hv_pmos[l]
print @n.xbgr.xm38_u20.nsg13_hv_pmos[delvto]
print @n.xbgr.xm38_u20.nsg13_hv_pmos[factuo]
print @n.xbgr.xm38_u21.nsg13_hv_pmos[w]
print @n.xbgr.xm38_u21.nsg13_hv_pmos[l]
print @n.xbgr.xm38_u21.nsg13_hv_pmos[delvto]
print @n.xbgr.xm38_u21.nsg13_hv_pmos[factuo]
print @n.xbgr.xm38_u22.nsg13_hv_pmos[w]
print @n.xbgr.xm38_u22.nsg13_hv_pmos[l]
print @n.xbgr.xm38_u22.nsg13_hv_pmos[delvto]
print @n.xbgr.xm38_u22.nsg13_hv_pmos[factuo]
print @n.xbgr.xm38_u23.nsg13_hv_pmos[w]
print @n.xbgr.xm38_u23.nsg13_hv_pmos[l]
print @n.xbgr.xm38_u23.nsg13_hv_pmos[delvto]
print @n.xbgr.xm38_u23.nsg13_hv_pmos[factuo]
print @n.xbgr.xm38_u24.nsg13_hv_pmos[w]
print @n.xbgr.xm38_u24.nsg13_hv_pmos[l]
print @n.xbgr.xm38_u24.nsg13_hv_pmos[delvto]
print @n.xbgr.xm38_u24.nsg13_hv_pmos[factuo]
print @n.xbgr.xm39_u2.nsg13_hv_pmos[w]
print @n.xbgr.xm39_u2.nsg13_hv_pmos[l]
print @n.xbgr.xm39_u2.nsg13_hv_pmos[delvto]
print @n.xbgr.xm39_u2.nsg13_hv_pmos[factuo]
print @n.xbgr.xm39_u3.nsg13_hv_pmos[w]
print @n.xbgr.xm39_u3.nsg13_hv_pmos[l]
print @n.xbgr.xm39_u3.nsg13_hv_pmos[delvto]
print @n.xbgr.xm39_u3.nsg13_hv_pmos[factuo]
print @n.xbgr.xm39_u4.nsg13_hv_pmos[w]
print @n.xbgr.xm39_u4.nsg13_hv_pmos[l]
print @n.xbgr.xm39_u4.nsg13_hv_pmos[delvto]
print @n.xbgr.xm39_u4.nsg13_hv_pmos[factuo]
print @n.xbgr.xm39_u5.nsg13_hv_pmos[w]
print @n.xbgr.xm39_u5.nsg13_hv_pmos[l]
print @n.xbgr.xm39_u5.nsg13_hv_pmos[delvto]
print @n.xbgr.xm39_u5.nsg13_hv_pmos[factuo]
print @n.xbgr.xm39_u6.nsg13_hv_pmos[w]
print @n.xbgr.xm39_u6.nsg13_hv_pmos[l]
print @n.xbgr.xm39_u6.nsg13_hv_pmos[delvto]
print @n.xbgr.xm39_u6.nsg13_hv_pmos[factuo]
print @n.xbgr.xm39_u7.nsg13_hv_pmos[w]
print @n.xbgr.xm39_u7.nsg13_hv_pmos[l]
print @n.xbgr.xm39_u7.nsg13_hv_pmos[delvto]
print @n.xbgr.xm39_u7.nsg13_hv_pmos[factuo]
print @n.xbgr.xm39_u8.nsg13_hv_pmos[w]
print @n.xbgr.xm39_u8.nsg13_hv_pmos[l]
print @n.xbgr.xm39_u8.nsg13_hv_pmos[delvto]
print @n.xbgr.xm39_u8.nsg13_hv_pmos[factuo]
print @n.xbgr.xm39_u9.nsg13_hv_pmos[w]
print @n.xbgr.xm39_u9.nsg13_hv_pmos[l]
print @n.xbgr.xm39_u9.nsg13_hv_pmos[delvto]
print @n.xbgr.xm39_u9.nsg13_hv_pmos[factuo]
print @n.xbgr.xm39_u10.nsg13_hv_pmos[w]
print @n.xbgr.xm39_u10.nsg13_hv_pmos[l]
print @n.xbgr.xm39_u10.nsg13_hv_pmos[delvto]
print @n.xbgr.xm39_u10.nsg13_hv_pmos[factuo]
print @n.xbgr.xm39_u11.nsg13_hv_pmos[w]
print @n.xbgr.xm39_u11.nsg13_hv_pmos[l]
print @n.xbgr.xm39_u11.nsg13_hv_pmos[delvto]
print @n.xbgr.xm39_u11.nsg13_hv_pmos[factuo]
print @n.xbgr.xm39_u12.nsg13_hv_pmos[w]
print @n.xbgr.xm39_u12.nsg13_hv_pmos[l]
print @n.xbgr.xm39_u12.nsg13_hv_pmos[delvto]
print @n.xbgr.xm39_u12.nsg13_hv_pmos[factuo]
print @n.xbgr.xm39_u13.nsg13_hv_pmos[w]
print @n.xbgr.xm39_u13.nsg13_hv_pmos[l]
print @n.xbgr.xm39_u13.nsg13_hv_pmos[delvto]
print @n.xbgr.xm39_u13.nsg13_hv_pmos[factuo]
print @n.xbgr.xm39_u14.nsg13_hv_pmos[w]
print @n.xbgr.xm39_u14.nsg13_hv_pmos[l]
print @n.xbgr.xm39_u14.nsg13_hv_pmos[delvto]
print @n.xbgr.xm39_u14.nsg13_hv_pmos[factuo]
print @n.xbgr.xm39_u15.nsg13_hv_pmos[w]
print @n.xbgr.xm39_u15.nsg13_hv_pmos[l]
print @n.xbgr.xm39_u15.nsg13_hv_pmos[delvto]
print @n.xbgr.xm39_u15.nsg13_hv_pmos[factuo]
print @n.xbgr.xm39_u16.nsg13_hv_pmos[w]
print @n.xbgr.xm39_u16.nsg13_hv_pmos[l]
print @n.xbgr.xm39_u16.nsg13_hv_pmos[delvto]
print @n.xbgr.xm39_u16.nsg13_hv_pmos[factuo]
print @n.xbgr.xm39_u17.nsg13_hv_pmos[w]
print @n.xbgr.xm39_u17.nsg13_hv_pmos[l]
print @n.xbgr.xm39_u17.nsg13_hv_pmos[delvto]
print @n.xbgr.xm39_u17.nsg13_hv_pmos[factuo]
print @n.xbgr.xm39_u18.nsg13_hv_pmos[w]
print @n.xbgr.xm39_u18.nsg13_hv_pmos[l]
print @n.xbgr.xm39_u18.nsg13_hv_pmos[delvto]
print @n.xbgr.xm39_u18.nsg13_hv_pmos[factuo]
print @n.xbgr.xm39_u19.nsg13_hv_pmos[w]
print @n.xbgr.xm39_u19.nsg13_hv_pmos[l]
print @n.xbgr.xm39_u19.nsg13_hv_pmos[delvto]
print @n.xbgr.xm39_u19.nsg13_hv_pmos[factuo]
print @n.xbgr.xm39_u20.nsg13_hv_pmos[w]
print @n.xbgr.xm39_u20.nsg13_hv_pmos[l]
print @n.xbgr.xm39_u20.nsg13_hv_pmos[delvto]
print @n.xbgr.xm39_u20.nsg13_hv_pmos[factuo]
print @n.xbgr.xm39_u21.nsg13_hv_pmos[w]
print @n.xbgr.xm39_u21.nsg13_hv_pmos[l]
print @n.xbgr.xm39_u21.nsg13_hv_pmos[delvto]
print @n.xbgr.xm39_u21.nsg13_hv_pmos[factuo]
print @n.xbgr.xm39_u22.nsg13_hv_pmos[w]
print @n.xbgr.xm39_u22.nsg13_hv_pmos[l]
print @n.xbgr.xm39_u22.nsg13_hv_pmos[delvto]
print @n.xbgr.xm39_u22.nsg13_hv_pmos[factuo]
print @n.xbgr.xm39_u23.nsg13_hv_pmos[w]
print @n.xbgr.xm39_u23.nsg13_hv_pmos[l]
print @n.xbgr.xm39_u23.nsg13_hv_pmos[delvto]
print @n.xbgr.xm39_u23.nsg13_hv_pmos[factuo]
print @n.xbgr.xm39_u24.nsg13_hv_pmos[w]
print @n.xbgr.xm39_u24.nsg13_hv_pmos[l]
print @n.xbgr.xm39_u24.nsg13_hv_pmos[delvto]
print @n.xbgr.xm39_u24.nsg13_hv_pmos[factuo]
print @n.xbgr.xm41_u2.nsg13_hv_pmos[w]
print @n.xbgr.xm41_u2.nsg13_hv_pmos[l]
print @n.xbgr.xm41_u2.nsg13_hv_pmos[delvto]
print @n.xbgr.xm41_u2.nsg13_hv_pmos[factuo]
print @n.xbgr.xm41_u3.nsg13_hv_pmos[w]
print @n.xbgr.xm41_u3.nsg13_hv_pmos[l]
print @n.xbgr.xm41_u3.nsg13_hv_pmos[delvto]
print @n.xbgr.xm41_u3.nsg13_hv_pmos[factuo]
print @n.xbgr.xm41_u4.nsg13_hv_pmos[w]
print @n.xbgr.xm41_u4.nsg13_hv_pmos[l]
print @n.xbgr.xm41_u4.nsg13_hv_pmos[delvto]
print @n.xbgr.xm41_u4.nsg13_hv_pmos[factuo]
print @n.xbgr.xm41_u5.nsg13_hv_pmos[w]
print @n.xbgr.xm41_u5.nsg13_hv_pmos[l]
print @n.xbgr.xm41_u5.nsg13_hv_pmos[delvto]
print @n.xbgr.xm41_u5.nsg13_hv_pmos[factuo]
print @n.xbgr.xm41_u6.nsg13_hv_pmos[w]
print @n.xbgr.xm41_u6.nsg13_hv_pmos[l]
print @n.xbgr.xm41_u6.nsg13_hv_pmos[delvto]
print @n.xbgr.xm41_u6.nsg13_hv_pmos[factuo]
print @n.xbgr.xm41_u7.nsg13_hv_pmos[w]
print @n.xbgr.xm41_u7.nsg13_hv_pmos[l]
print @n.xbgr.xm41_u7.nsg13_hv_pmos[delvto]
print @n.xbgr.xm41_u7.nsg13_hv_pmos[factuo]
print @n.xbgr.xm41_u8.nsg13_hv_pmos[w]
print @n.xbgr.xm41_u8.nsg13_hv_pmos[l]
print @n.xbgr.xm41_u8.nsg13_hv_pmos[delvto]
print @n.xbgr.xm41_u8.nsg13_hv_pmos[factuo]
print @n.xbgr.xm41_u9.nsg13_hv_pmos[w]
print @n.xbgr.xm41_u9.nsg13_hv_pmos[l]
print @n.xbgr.xm41_u9.nsg13_hv_pmos[delvto]
print @n.xbgr.xm41_u9.nsg13_hv_pmos[factuo]
print @n.xbgr.xm41_u10.nsg13_hv_pmos[w]
print @n.xbgr.xm41_u10.nsg13_hv_pmos[l]
print @n.xbgr.xm41_u10.nsg13_hv_pmos[delvto]
print @n.xbgr.xm41_u10.nsg13_hv_pmos[factuo]
print @n.xbgr.xm41_u11.nsg13_hv_pmos[w]
print @n.xbgr.xm41_u11.nsg13_hv_pmos[l]
print @n.xbgr.xm41_u11.nsg13_hv_pmos[delvto]
print @n.xbgr.xm41_u11.nsg13_hv_pmos[factuo]
print @n.xbgr.xm41_u12.nsg13_hv_pmos[w]
print @n.xbgr.xm41_u12.nsg13_hv_pmos[l]
print @n.xbgr.xm41_u12.nsg13_hv_pmos[delvto]
print @n.xbgr.xm41_u12.nsg13_hv_pmos[factuo]
print @n.xbgr.xm41_u13.nsg13_hv_pmos[w]
print @n.xbgr.xm41_u13.nsg13_hv_pmos[l]
print @n.xbgr.xm41_u13.nsg13_hv_pmos[delvto]
print @n.xbgr.xm41_u13.nsg13_hv_pmos[factuo]
print @n.xbgr.xm41_u14.nsg13_hv_pmos[w]
print @n.xbgr.xm41_u14.nsg13_hv_pmos[l]
print @n.xbgr.xm41_u14.nsg13_hv_pmos[delvto]
print @n.xbgr.xm41_u14.nsg13_hv_pmos[factuo]
print @n.xbgr.xm41_u15.nsg13_hv_pmos[w]
print @n.xbgr.xm41_u15.nsg13_hv_pmos[l]
print @n.xbgr.xm41_u15.nsg13_hv_pmos[delvto]
print @n.xbgr.xm41_u15.nsg13_hv_pmos[factuo]
print @n.xbgr.xm41_u16.nsg13_hv_pmos[w]
print @n.xbgr.xm41_u16.nsg13_hv_pmos[l]
print @n.xbgr.xm41_u16.nsg13_hv_pmos[delvto]
print @n.xbgr.xm41_u16.nsg13_hv_pmos[factuo]
print @n.xbgr.xm41_u17.nsg13_hv_pmos[w]
print @n.xbgr.xm41_u17.nsg13_hv_pmos[l]
print @n.xbgr.xm41_u17.nsg13_hv_pmos[delvto]
print @n.xbgr.xm41_u17.nsg13_hv_pmos[factuo]
print @n.xbgr.xm41_u18.nsg13_hv_pmos[w]
print @n.xbgr.xm41_u18.nsg13_hv_pmos[l]
print @n.xbgr.xm41_u18.nsg13_hv_pmos[delvto]
print @n.xbgr.xm41_u18.nsg13_hv_pmos[factuo]
print @n.xbgr.xm41_u19.nsg13_hv_pmos[w]
print @n.xbgr.xm41_u19.nsg13_hv_pmos[l]
print @n.xbgr.xm41_u19.nsg13_hv_pmos[delvto]
print @n.xbgr.xm41_u19.nsg13_hv_pmos[factuo]
print @n.xbgr.xm41_u20.nsg13_hv_pmos[w]
print @n.xbgr.xm41_u20.nsg13_hv_pmos[l]
print @n.xbgr.xm41_u20.nsg13_hv_pmos[delvto]
print @n.xbgr.xm41_u20.nsg13_hv_pmos[factuo]
print @n.xbgr.xm41_u21.nsg13_hv_pmos[w]
print @n.xbgr.xm41_u21.nsg13_hv_pmos[l]
print @n.xbgr.xm41_u21.nsg13_hv_pmos[delvto]
print @n.xbgr.xm41_u21.nsg13_hv_pmos[factuo]
print @n.xbgr.xm41_u22.nsg13_hv_pmos[w]
print @n.xbgr.xm41_u22.nsg13_hv_pmos[l]
print @n.xbgr.xm41_u22.nsg13_hv_pmos[delvto]
print @n.xbgr.xm41_u22.nsg13_hv_pmos[factuo]
print @n.xbgr.xm41_u23.nsg13_hv_pmos[w]
print @n.xbgr.xm41_u23.nsg13_hv_pmos[l]
print @n.xbgr.xm41_u23.nsg13_hv_pmos[delvto]
print @n.xbgr.xm41_u23.nsg13_hv_pmos[factuo]
print @n.xbgr.xm41_u24.nsg13_hv_pmos[w]
print @n.xbgr.xm41_u24.nsg13_hv_pmos[l]
print @n.xbgr.xm41_u24.nsg13_hv_pmos[delvto]
print @n.xbgr.xm41_u24.nsg13_hv_pmos[factuo]
print @n.xbgr.xm43_u2.nsg13_hv_pmos[w]
print @n.xbgr.xm43_u2.nsg13_hv_pmos[l]
print @n.xbgr.xm43_u2.nsg13_hv_pmos[delvto]
print @n.xbgr.xm43_u2.nsg13_hv_pmos[factuo]
print @n.xbgr.xm43_u3.nsg13_hv_pmos[w]
print @n.xbgr.xm43_u3.nsg13_hv_pmos[l]
print @n.xbgr.xm43_u3.nsg13_hv_pmos[delvto]
print @n.xbgr.xm43_u3.nsg13_hv_pmos[factuo]
print @n.xbgr.xm43_u4.nsg13_hv_pmos[w]
print @n.xbgr.xm43_u4.nsg13_hv_pmos[l]
print @n.xbgr.xm43_u4.nsg13_hv_pmos[delvto]
print @n.xbgr.xm43_u4.nsg13_hv_pmos[factuo]
print @n.xbgr.xm44_u2.nsg13_hv_pmos[w]
print @n.xbgr.xm44_u2.nsg13_hv_pmos[l]
print @n.xbgr.xm44_u2.nsg13_hv_pmos[delvto]
print @n.xbgr.xm44_u2.nsg13_hv_pmos[factuo]
print @n.xbgr.xm44_u3.nsg13_hv_pmos[w]
print @n.xbgr.xm44_u3.nsg13_hv_pmos[l]
print @n.xbgr.xm44_u3.nsg13_hv_pmos[delvto]
print @n.xbgr.xm44_u3.nsg13_hv_pmos[factuo]
print @n.xbgr.xm44_u4.nsg13_hv_pmos[w]
print @n.xbgr.xm44_u4.nsg13_hv_pmos[l]
print @n.xbgr.xm44_u4.nsg13_hv_pmos[delvto]
print @n.xbgr.xm44_u4.nsg13_hv_pmos[factuo]
print @n.xbgr.xm45_u2.nsg13_hv_pmos[w]
print @n.xbgr.xm45_u2.nsg13_hv_pmos[l]
print @n.xbgr.xm45_u2.nsg13_hv_pmos[delvto]
print @n.xbgr.xm45_u2.nsg13_hv_pmos[factuo]
print @n.xbgr.xm45_u3.nsg13_hv_pmos[w]
print @n.xbgr.xm45_u3.nsg13_hv_pmos[l]
print @n.xbgr.xm45_u3.nsg13_hv_pmos[delvto]
print @n.xbgr.xm45_u3.nsg13_hv_pmos[factuo]
print @n.xbgr.xm45_u4.nsg13_hv_pmos[w]
print @n.xbgr.xm45_u4.nsg13_hv_pmos[l]
print @n.xbgr.xm45_u4.nsg13_hv_pmos[delvto]
print @n.xbgr.xm45_u4.nsg13_hv_pmos[factuo]
print @n.xbgr.xm45_u5.nsg13_hv_pmos[w]
print @n.xbgr.xm45_u5.nsg13_hv_pmos[l]
print @n.xbgr.xm45_u5.nsg13_hv_pmos[delvto]
print @n.xbgr.xm45_u5.nsg13_hv_pmos[factuo]
print @n.xbgr.xm45_u6.nsg13_hv_pmos[w]
print @n.xbgr.xm45_u6.nsg13_hv_pmos[l]
print @n.xbgr.xm45_u6.nsg13_hv_pmos[delvto]
print @n.xbgr.xm45_u6.nsg13_hv_pmos[factuo]
print @n.xbgr.xm45_u7.nsg13_hv_pmos[w]
print @n.xbgr.xm45_u7.nsg13_hv_pmos[l]
print @n.xbgr.xm45_u7.nsg13_hv_pmos[delvto]
print @n.xbgr.xm45_u7.nsg13_hv_pmos[factuo]
print @n.xbgr.xm45_u8.nsg13_hv_pmos[w]
print @n.xbgr.xm45_u8.nsg13_hv_pmos[l]
print @n.xbgr.xm45_u8.nsg13_hv_pmos[delvto]
print @n.xbgr.xm45_u8.nsg13_hv_pmos[factuo]
print @n.xbgr.xm45_u9.nsg13_hv_pmos[w]
print @n.xbgr.xm45_u9.nsg13_hv_pmos[l]
print @n.xbgr.xm45_u9.nsg13_hv_pmos[delvto]
print @n.xbgr.xm45_u9.nsg13_hv_pmos[factuo]
print @n.xbgr.xm45_u10.nsg13_hv_pmos[w]
print @n.xbgr.xm45_u10.nsg13_hv_pmos[l]
print @n.xbgr.xm45_u10.nsg13_hv_pmos[delvto]
print @n.xbgr.xm45_u10.nsg13_hv_pmos[factuo]
print @n.xbgr.xm45_u11.nsg13_hv_pmos[w]
print @n.xbgr.xm45_u11.nsg13_hv_pmos[l]
print @n.xbgr.xm45_u11.nsg13_hv_pmos[delvto]
print @n.xbgr.xm45_u11.nsg13_hv_pmos[factuo]
print @n.xbgr.xm45_u12.nsg13_hv_pmos[w]
print @n.xbgr.xm45_u12.nsg13_hv_pmos[l]
print @n.xbgr.xm45_u12.nsg13_hv_pmos[delvto]
print @n.xbgr.xm45_u12.nsg13_hv_pmos[factuo]
print @n.xbgr.xm45_u13.nsg13_hv_pmos[w]
print @n.xbgr.xm45_u13.nsg13_hv_pmos[l]
print @n.xbgr.xm45_u13.nsg13_hv_pmos[delvto]
print @n.xbgr.xm45_u13.nsg13_hv_pmos[factuo]
print @n.xbgr.xm45_u14.nsg13_hv_pmos[w]
print @n.xbgr.xm45_u14.nsg13_hv_pmos[l]
print @n.xbgr.xm45_u14.nsg13_hv_pmos[delvto]
print @n.xbgr.xm45_u14.nsg13_hv_pmos[factuo]
print @n.xbgr.xm45_u15.nsg13_hv_pmos[w]
print @n.xbgr.xm45_u15.nsg13_hv_pmos[l]
print @n.xbgr.xm45_u15.nsg13_hv_pmos[delvto]
print @n.xbgr.xm45_u15.nsg13_hv_pmos[factuo]
print @n.xbgr.xm45_u16.nsg13_hv_pmos[w]
print @n.xbgr.xm45_u16.nsg13_hv_pmos[l]
print @n.xbgr.xm45_u16.nsg13_hv_pmos[delvto]
print @n.xbgr.xm45_u16.nsg13_hv_pmos[factuo]
print @n.xbgr.xm45_u17.nsg13_hv_pmos[w]
print @n.xbgr.xm45_u17.nsg13_hv_pmos[l]
print @n.xbgr.xm45_u17.nsg13_hv_pmos[delvto]
print @n.xbgr.xm45_u17.nsg13_hv_pmos[factuo]
print @n.xbgr.xm45_u18.nsg13_hv_pmos[w]
print @n.xbgr.xm45_u18.nsg13_hv_pmos[l]
print @n.xbgr.xm45_u18.nsg13_hv_pmos[delvto]
print @n.xbgr.xm45_u18.nsg13_hv_pmos[factuo]
print @n.xbgr.xm45_u19.nsg13_hv_pmos[w]
print @n.xbgr.xm45_u19.nsg13_hv_pmos[l]
print @n.xbgr.xm45_u19.nsg13_hv_pmos[delvto]
print @n.xbgr.xm45_u19.nsg13_hv_pmos[factuo]
print @n.xbgr.xm45_u20.nsg13_hv_pmos[w]
print @n.xbgr.xm45_u20.nsg13_hv_pmos[l]
print @n.xbgr.xm45_u20.nsg13_hv_pmos[delvto]
print @n.xbgr.xm45_u20.nsg13_hv_pmos[factuo]
print @n.xbgr.xm45_u21.nsg13_hv_pmos[w]
print @n.xbgr.xm45_u21.nsg13_hv_pmos[l]
print @n.xbgr.xm45_u21.nsg13_hv_pmos[delvto]
print @n.xbgr.xm45_u21.nsg13_hv_pmos[factuo]
print @n.xbgr.xm45_u22.nsg13_hv_pmos[w]
print @n.xbgr.xm45_u22.nsg13_hv_pmos[l]
print @n.xbgr.xm45_u22.nsg13_hv_pmos[delvto]
print @n.xbgr.xm45_u22.nsg13_hv_pmos[factuo]
print @n.xbgr.xm45_u23.nsg13_hv_pmos[w]
print @n.xbgr.xm45_u23.nsg13_hv_pmos[l]
print @n.xbgr.xm45_u23.nsg13_hv_pmos[delvto]
print @n.xbgr.xm45_u23.nsg13_hv_pmos[factuo]
print @n.xbgr.xm45_u24.nsg13_hv_pmos[w]
print @n.xbgr.xm45_u24.nsg13_hv_pmos[l]
print @n.xbgr.xm45_u24.nsg13_hv_pmos[delvto]
print @n.xbgr.xm45_u24.nsg13_hv_pmos[factuo]
print @n.xbgr.xm47_u2.nsg13_hv_pmos[w]
print @n.xbgr.xm47_u2.nsg13_hv_pmos[l]
print @n.xbgr.xm47_u2.nsg13_hv_pmos[delvto]
print @n.xbgr.xm47_u2.nsg13_hv_pmos[factuo]
print @n.xbgr.xm47_u3.nsg13_hv_pmos[w]
print @n.xbgr.xm47_u3.nsg13_hv_pmos[l]
print @n.xbgr.xm47_u3.nsg13_hv_pmos[delvto]
print @n.xbgr.xm47_u3.nsg13_hv_pmos[factuo]
print @n.xbgr.xm47_u4.nsg13_hv_pmos[w]
print @n.xbgr.xm47_u4.nsg13_hv_pmos[l]
print @n.xbgr.xm47_u4.nsg13_hv_pmos[delvto]
print @n.xbgr.xm47_u4.nsg13_hv_pmos[factuo]
print @n.xbgr.xm47_u5.nsg13_hv_pmos[w]
print @n.xbgr.xm47_u5.nsg13_hv_pmos[l]
print @n.xbgr.xm47_u5.nsg13_hv_pmos[delvto]
print @n.xbgr.xm47_u5.nsg13_hv_pmos[factuo]
print @n.xbgr.xm47_u6.nsg13_hv_pmos[w]
print @n.xbgr.xm47_u6.nsg13_hv_pmos[l]
print @n.xbgr.xm47_u6.nsg13_hv_pmos[delvto]
print @n.xbgr.xm47_u6.nsg13_hv_pmos[factuo]
print @n.xbgr.xm47_u7.nsg13_hv_pmos[w]
print @n.xbgr.xm47_u7.nsg13_hv_pmos[l]
print @n.xbgr.xm47_u7.nsg13_hv_pmos[delvto]
print @n.xbgr.xm47_u7.nsg13_hv_pmos[factuo]
print @n.xbgr.xm47_u8.nsg13_hv_pmos[w]
print @n.xbgr.xm47_u8.nsg13_hv_pmos[l]
print @n.xbgr.xm47_u8.nsg13_hv_pmos[delvto]
print @n.xbgr.xm47_u8.nsg13_hv_pmos[factuo]
print @n.xbgr.xm47_u9.nsg13_hv_pmos[w]
print @n.xbgr.xm47_u9.nsg13_hv_pmos[l]
print @n.xbgr.xm47_u9.nsg13_hv_pmos[delvto]
print @n.xbgr.xm47_u9.nsg13_hv_pmos[factuo]
print @n.xbgr.xm47_u10.nsg13_hv_pmos[w]
print @n.xbgr.xm47_u10.nsg13_hv_pmos[l]
print @n.xbgr.xm47_u10.nsg13_hv_pmos[delvto]
print @n.xbgr.xm47_u10.nsg13_hv_pmos[factuo]
print @n.xbgr.xm47_u11.nsg13_hv_pmos[w]
print @n.xbgr.xm47_u11.nsg13_hv_pmos[l]
print @n.xbgr.xm47_u11.nsg13_hv_pmos[delvto]
print @n.xbgr.xm47_u11.nsg13_hv_pmos[factuo]
print @n.xbgr.xm47_u12.nsg13_hv_pmos[w]
print @n.xbgr.xm47_u12.nsg13_hv_pmos[l]
print @n.xbgr.xm47_u12.nsg13_hv_pmos[delvto]
print @n.xbgr.xm47_u12.nsg13_hv_pmos[factuo]
print @n.xbgr.xm47_u13.nsg13_hv_pmos[w]
print @n.xbgr.xm47_u13.nsg13_hv_pmos[l]
print @n.xbgr.xm47_u13.nsg13_hv_pmos[delvto]
print @n.xbgr.xm47_u13.nsg13_hv_pmos[factuo]
print @n.xbgr.xm47_u14.nsg13_hv_pmos[w]
print @n.xbgr.xm47_u14.nsg13_hv_pmos[l]
print @n.xbgr.xm47_u14.nsg13_hv_pmos[delvto]
print @n.xbgr.xm47_u14.nsg13_hv_pmos[factuo]
print @n.xbgr.xm47_u15.nsg13_hv_pmos[w]
print @n.xbgr.xm47_u15.nsg13_hv_pmos[l]
print @n.xbgr.xm47_u15.nsg13_hv_pmos[delvto]
print @n.xbgr.xm47_u15.nsg13_hv_pmos[factuo]
print @n.xbgr.xm47_u16.nsg13_hv_pmos[w]
print @n.xbgr.xm47_u16.nsg13_hv_pmos[l]
print @n.xbgr.xm47_u16.nsg13_hv_pmos[delvto]
print @n.xbgr.xm47_u16.nsg13_hv_pmos[factuo]
print @n.xbgr.xm47_u17.nsg13_hv_pmos[w]
print @n.xbgr.xm47_u17.nsg13_hv_pmos[l]
print @n.xbgr.xm47_u17.nsg13_hv_pmos[delvto]
print @n.xbgr.xm47_u17.nsg13_hv_pmos[factuo]
print @n.xbgr.xm47_u18.nsg13_hv_pmos[w]
print @n.xbgr.xm47_u18.nsg13_hv_pmos[l]
print @n.xbgr.xm47_u18.nsg13_hv_pmos[delvto]
print @n.xbgr.xm47_u18.nsg13_hv_pmos[factuo]
print @n.xbgr.xm47_u19.nsg13_hv_pmos[w]
print @n.xbgr.xm47_u19.nsg13_hv_pmos[l]
print @n.xbgr.xm47_u19.nsg13_hv_pmos[delvto]
print @n.xbgr.xm47_u19.nsg13_hv_pmos[factuo]
print @n.xbgr.xm47_u20.nsg13_hv_pmos[w]
print @n.xbgr.xm47_u20.nsg13_hv_pmos[l]
print @n.xbgr.xm47_u20.nsg13_hv_pmos[delvto]
print @n.xbgr.xm47_u20.nsg13_hv_pmos[factuo]
print @n.xbgr.xm47_u21.nsg13_hv_pmos[w]
print @n.xbgr.xm47_u21.nsg13_hv_pmos[l]
print @n.xbgr.xm47_u21.nsg13_hv_pmos[delvto]
print @n.xbgr.xm47_u21.nsg13_hv_pmos[factuo]
print @n.xbgr.xm47_u22.nsg13_hv_pmos[w]
print @n.xbgr.xm47_u22.nsg13_hv_pmos[l]
print @n.xbgr.xm47_u22.nsg13_hv_pmos[delvto]
print @n.xbgr.xm47_u22.nsg13_hv_pmos[factuo]
print @n.xbgr.xm47_u23.nsg13_hv_pmos[w]
print @n.xbgr.xm47_u23.nsg13_hv_pmos[l]
print @n.xbgr.xm47_u23.nsg13_hv_pmos[delvto]
print @n.xbgr.xm47_u23.nsg13_hv_pmos[factuo]
print @n.xbgr.xm47_u24.nsg13_hv_pmos[w]
print @n.xbgr.xm47_u24.nsg13_hv_pmos[l]
print @n.xbgr.xm47_u24.nsg13_hv_pmos[delvto]
print @n.xbgr.xm47_u24.nsg13_hv_pmos[factuo]
print @n.xbgr.xm48_u2.nsg13_hv_pmos[w]
print @n.xbgr.xm48_u2.nsg13_hv_pmos[l]
print @n.xbgr.xm48_u2.nsg13_hv_pmos[delvto]
print @n.xbgr.xm48_u2.nsg13_hv_pmos[factuo]
print @n.xbgr.xm48_u3.nsg13_hv_pmos[w]
print @n.xbgr.xm48_u3.nsg13_hv_pmos[l]
print @n.xbgr.xm48_u3.nsg13_hv_pmos[delvto]
print @n.xbgr.xm48_u3.nsg13_hv_pmos[factuo]
print @n.xbgr.xm48_u4.nsg13_hv_pmos[w]
print @n.xbgr.xm48_u4.nsg13_hv_pmos[l]
print @n.xbgr.xm48_u4.nsg13_hv_pmos[delvto]
print @n.xbgr.xm48_u4.nsg13_hv_pmos[factuo]
print @n.xbgr.xm48_u5.nsg13_hv_pmos[w]
print @n.xbgr.xm48_u5.nsg13_hv_pmos[l]
print @n.xbgr.xm48_u5.nsg13_hv_pmos[delvto]
print @n.xbgr.xm48_u5.nsg13_hv_pmos[factuo]
print @n.xbgr.xm48_u6.nsg13_hv_pmos[w]
print @n.xbgr.xm48_u6.nsg13_hv_pmos[l]
print @n.xbgr.xm48_u6.nsg13_hv_pmos[delvto]
print @n.xbgr.xm48_u6.nsg13_hv_pmos[factuo]
print @n.xbgr.xm48_u7.nsg13_hv_pmos[w]
print @n.xbgr.xm48_u7.nsg13_hv_pmos[l]
print @n.xbgr.xm48_u7.nsg13_hv_pmos[delvto]
print @n.xbgr.xm48_u7.nsg13_hv_pmos[factuo]
print @n.xbgr.xm48_u8.nsg13_hv_pmos[w]
print @n.xbgr.xm48_u8.nsg13_hv_pmos[l]
print @n.xbgr.xm48_u8.nsg13_hv_pmos[delvto]
print @n.xbgr.xm48_u8.nsg13_hv_pmos[factuo]
print @n.xbgr.xm48_u9.nsg13_hv_pmos[w]
print @n.xbgr.xm48_u9.nsg13_hv_pmos[l]
print @n.xbgr.xm48_u9.nsg13_hv_pmos[delvto]
print @n.xbgr.xm48_u9.nsg13_hv_pmos[factuo]
print @n.xbgr.xm48_u10.nsg13_hv_pmos[w]
print @n.xbgr.xm48_u10.nsg13_hv_pmos[l]
print @n.xbgr.xm48_u10.nsg13_hv_pmos[delvto]
print @n.xbgr.xm48_u10.nsg13_hv_pmos[factuo]
print @n.xbgr.xm48_u11.nsg13_hv_pmos[w]
print @n.xbgr.xm48_u11.nsg13_hv_pmos[l]
print @n.xbgr.xm48_u11.nsg13_hv_pmos[delvto]
print @n.xbgr.xm48_u11.nsg13_hv_pmos[factuo]
print @n.xbgr.xm48_u12.nsg13_hv_pmos[w]
print @n.xbgr.xm48_u12.nsg13_hv_pmos[l]
print @n.xbgr.xm48_u12.nsg13_hv_pmos[delvto]
print @n.xbgr.xm48_u12.nsg13_hv_pmos[factuo]
print @n.xbgr.xm48_u13.nsg13_hv_pmos[w]
print @n.xbgr.xm48_u13.nsg13_hv_pmos[l]
print @n.xbgr.xm48_u13.nsg13_hv_pmos[delvto]
print @n.xbgr.xm48_u13.nsg13_hv_pmos[factuo]
print @n.xbgr.xm48_u14.nsg13_hv_pmos[w]
print @n.xbgr.xm48_u14.nsg13_hv_pmos[l]
print @n.xbgr.xm48_u14.nsg13_hv_pmos[delvto]
print @n.xbgr.xm48_u14.nsg13_hv_pmos[factuo]
print @n.xbgr.xm48_u15.nsg13_hv_pmos[w]
print @n.xbgr.xm48_u15.nsg13_hv_pmos[l]
print @n.xbgr.xm48_u15.nsg13_hv_pmos[delvto]
print @n.xbgr.xm48_u15.nsg13_hv_pmos[factuo]
print @n.xbgr.xm48_u16.nsg13_hv_pmos[w]
print @n.xbgr.xm48_u16.nsg13_hv_pmos[l]
print @n.xbgr.xm48_u16.nsg13_hv_pmos[delvto]
print @n.xbgr.xm48_u16.nsg13_hv_pmos[factuo]
print @n.xbgr.xm48_u17.nsg13_hv_pmos[w]
print @n.xbgr.xm48_u17.nsg13_hv_pmos[l]
print @n.xbgr.xm48_u17.nsg13_hv_pmos[delvto]
print @n.xbgr.xm48_u17.nsg13_hv_pmos[factuo]
print @n.xbgr.xm48_u18.nsg13_hv_pmos[w]
print @n.xbgr.xm48_u18.nsg13_hv_pmos[l]
print @n.xbgr.xm48_u18.nsg13_hv_pmos[delvto]
print @n.xbgr.xm48_u18.nsg13_hv_pmos[factuo]
print @n.xbgr.xm48_u19.nsg13_hv_pmos[w]
print @n.xbgr.xm48_u19.nsg13_hv_pmos[l]
print @n.xbgr.xm48_u19.nsg13_hv_pmos[delvto]
print @n.xbgr.xm48_u19.nsg13_hv_pmos[factuo]
print @n.xbgr.xm48_u20.nsg13_hv_pmos[w]
print @n.xbgr.xm48_u20.nsg13_hv_pmos[l]
print @n.xbgr.xm48_u20.nsg13_hv_pmos[delvto]
print @n.xbgr.xm48_u20.nsg13_hv_pmos[factuo]
print @n.xbgr.xm48_u21.nsg13_hv_pmos[w]
print @n.xbgr.xm48_u21.nsg13_hv_pmos[l]
print @n.xbgr.xm48_u21.nsg13_hv_pmos[delvto]
print @n.xbgr.xm48_u21.nsg13_hv_pmos[factuo]
print @n.xbgr.xm48_u22.nsg13_hv_pmos[w]
print @n.xbgr.xm48_u22.nsg13_hv_pmos[l]
print @n.xbgr.xm48_u22.nsg13_hv_pmos[delvto]
print @n.xbgr.xm48_u22.nsg13_hv_pmos[factuo]
print @n.xbgr.xm48_u23.nsg13_hv_pmos[w]
print @n.xbgr.xm48_u23.nsg13_hv_pmos[l]
print @n.xbgr.xm48_u23.nsg13_hv_pmos[delvto]
print @n.xbgr.xm48_u23.nsg13_hv_pmos[factuo]
print @n.xbgr.xm48_u24.nsg13_hv_pmos[w]
print @n.xbgr.xm48_u24.nsg13_hv_pmos[l]
print @n.xbgr.xm48_u24.nsg13_hv_pmos[delvto]
print @n.xbgr.xm48_u24.nsg13_hv_pmos[factuo]
print @n.xbgr.xm50_u2.nsg13_hv_pmos[w]
print @n.xbgr.xm50_u2.nsg13_hv_pmos[l]
print @n.xbgr.xm50_u2.nsg13_hv_pmos[delvto]
print @n.xbgr.xm50_u2.nsg13_hv_pmos[factuo]
print @n.xbgr.xm50_u3.nsg13_hv_pmos[w]
print @n.xbgr.xm50_u3.nsg13_hv_pmos[l]
print @n.xbgr.xm50_u3.nsg13_hv_pmos[delvto]
print @n.xbgr.xm50_u3.nsg13_hv_pmos[factuo]
print @n.xbgr.xm50_u4.nsg13_hv_pmos[w]
print @n.xbgr.xm50_u4.nsg13_hv_pmos[l]
print @n.xbgr.xm50_u4.nsg13_hv_pmos[delvto]
print @n.xbgr.xm50_u4.nsg13_hv_pmos[factuo]
print @n.xbgr.xm50_u5.nsg13_hv_pmos[w]
print @n.xbgr.xm50_u5.nsg13_hv_pmos[l]
print @n.xbgr.xm50_u5.nsg13_hv_pmos[delvto]
print @n.xbgr.xm50_u5.nsg13_hv_pmos[factuo]
print @n.xbgr.xm50_u6.nsg13_hv_pmos[w]
print @n.xbgr.xm50_u6.nsg13_hv_pmos[l]
print @n.xbgr.xm50_u6.nsg13_hv_pmos[delvto]
print @n.xbgr.xm50_u6.nsg13_hv_pmos[factuo]
print @n.xbgr.xm50_u7.nsg13_hv_pmos[w]
print @n.xbgr.xm50_u7.nsg13_hv_pmos[l]
print @n.xbgr.xm50_u7.nsg13_hv_pmos[delvto]
print @n.xbgr.xm50_u7.nsg13_hv_pmos[factuo]
print @n.xbgr.xm50_u8.nsg13_hv_pmos[w]
print @n.xbgr.xm50_u8.nsg13_hv_pmos[l]
print @n.xbgr.xm50_u8.nsg13_hv_pmos[delvto]
print @n.xbgr.xm50_u8.nsg13_hv_pmos[factuo]
print @n.xbgr.xm50_u9.nsg13_hv_pmos[w]
print @n.xbgr.xm50_u9.nsg13_hv_pmos[l]
print @n.xbgr.xm50_u9.nsg13_hv_pmos[delvto]
print @n.xbgr.xm50_u9.nsg13_hv_pmos[factuo]
print @n.xbgr.xm50_u10.nsg13_hv_pmos[w]
print @n.xbgr.xm50_u10.nsg13_hv_pmos[l]
print @n.xbgr.xm50_u10.nsg13_hv_pmos[delvto]
print @n.xbgr.xm50_u10.nsg13_hv_pmos[factuo]
print @n.xbgr.xm50_u11.nsg13_hv_pmos[w]
print @n.xbgr.xm50_u11.nsg13_hv_pmos[l]
print @n.xbgr.xm50_u11.nsg13_hv_pmos[delvto]
print @n.xbgr.xm50_u11.nsg13_hv_pmos[factuo]
print @n.xbgr.xm50_u12.nsg13_hv_pmos[w]
print @n.xbgr.xm50_u12.nsg13_hv_pmos[l]
print @n.xbgr.xm50_u12.nsg13_hv_pmos[delvto]
print @n.xbgr.xm50_u12.nsg13_hv_pmos[factuo]
print @n.xbgr.xm50_u13.nsg13_hv_pmos[w]
print @n.xbgr.xm50_u13.nsg13_hv_pmos[l]
print @n.xbgr.xm50_u13.nsg13_hv_pmos[delvto]
print @n.xbgr.xm50_u13.nsg13_hv_pmos[factuo]
print @n.xbgr.xm50_u14.nsg13_hv_pmos[w]
print @n.xbgr.xm50_u14.nsg13_hv_pmos[l]
print @n.xbgr.xm50_u14.nsg13_hv_pmos[delvto]
print @n.xbgr.xm50_u14.nsg13_hv_pmos[factuo]
print @n.xbgr.xm50_u15.nsg13_hv_pmos[w]
print @n.xbgr.xm50_u15.nsg13_hv_pmos[l]
print @n.xbgr.xm50_u15.nsg13_hv_pmos[delvto]
print @n.xbgr.xm50_u15.nsg13_hv_pmos[factuo]
print @n.xbgr.xm50_u16.nsg13_hv_pmos[w]
print @n.xbgr.xm50_u16.nsg13_hv_pmos[l]
print @n.xbgr.xm50_u16.nsg13_hv_pmos[delvto]
print @n.xbgr.xm50_u16.nsg13_hv_pmos[factuo]
print @n.xbgr.xm50_u17.nsg13_hv_pmos[w]
print @n.xbgr.xm50_u17.nsg13_hv_pmos[l]
print @n.xbgr.xm50_u17.nsg13_hv_pmos[delvto]
print @n.xbgr.xm50_u17.nsg13_hv_pmos[factuo]
print @n.xbgr.xm50_u18.nsg13_hv_pmos[w]
print @n.xbgr.xm50_u18.nsg13_hv_pmos[l]
print @n.xbgr.xm50_u18.nsg13_hv_pmos[delvto]
print @n.xbgr.xm50_u18.nsg13_hv_pmos[factuo]
print @n.xbgr.xm50_u19.nsg13_hv_pmos[w]
print @n.xbgr.xm50_u19.nsg13_hv_pmos[l]
print @n.xbgr.xm50_u19.nsg13_hv_pmos[delvto]
print @n.xbgr.xm50_u19.nsg13_hv_pmos[factuo]
print @n.xbgr.xm50_u20.nsg13_hv_pmos[w]
print @n.xbgr.xm50_u20.nsg13_hv_pmos[l]
print @n.xbgr.xm50_u20.nsg13_hv_pmos[delvto]
print @n.xbgr.xm50_u20.nsg13_hv_pmos[factuo]
print @n.xbgr.xm50_u21.nsg13_hv_pmos[w]
print @n.xbgr.xm50_u21.nsg13_hv_pmos[l]
print @n.xbgr.xm50_u21.nsg13_hv_pmos[delvto]
print @n.xbgr.xm50_u21.nsg13_hv_pmos[factuo]
print @n.xbgr.xm50_u22.nsg13_hv_pmos[w]
print @n.xbgr.xm50_u22.nsg13_hv_pmos[l]
print @n.xbgr.xm50_u22.nsg13_hv_pmos[delvto]
print @n.xbgr.xm50_u22.nsg13_hv_pmos[factuo]
print @n.xbgr.xm50_u23.nsg13_hv_pmos[w]
print @n.xbgr.xm50_u23.nsg13_hv_pmos[l]
print @n.xbgr.xm50_u23.nsg13_hv_pmos[delvto]
print @n.xbgr.xm50_u23.nsg13_hv_pmos[factuo]
print @n.xbgr.xm50_u24.nsg13_hv_pmos[w]
print @n.xbgr.xm50_u24.nsg13_hv_pmos[l]
print @n.xbgr.xm50_u24.nsg13_hv_pmos[delvto]
print @n.xbgr.xm50_u24.nsg13_hv_pmos[factuo]
print @n.xbgr.xm51_u2.nsg13_hv_pmos[w]
print @n.xbgr.xm51_u2.nsg13_hv_pmos[l]
print @n.xbgr.xm51_u2.nsg13_hv_pmos[delvto]
print @n.xbgr.xm51_u2.nsg13_hv_pmos[factuo]
print @n.xbgr.xm51_u3.nsg13_hv_pmos[w]
print @n.xbgr.xm51_u3.nsg13_hv_pmos[l]
print @n.xbgr.xm51_u3.nsg13_hv_pmos[delvto]
print @n.xbgr.xm51_u3.nsg13_hv_pmos[factuo]
print @n.xbgr.xm51_u4.nsg13_hv_pmos[w]
print @n.xbgr.xm51_u4.nsg13_hv_pmos[l]
print @n.xbgr.xm51_u4.nsg13_hv_pmos[delvto]
print @n.xbgr.xm51_u4.nsg13_hv_pmos[factuo]
print @n.xbgr.xm52_u2.nsg13_hv_pmos[w]
print @n.xbgr.xm52_u2.nsg13_hv_pmos[l]
print @n.xbgr.xm52_u2.nsg13_hv_pmos[delvto]
print @n.xbgr.xm52_u2.nsg13_hv_pmos[factuo]
print @n.xbgr.xm52_u3.nsg13_hv_pmos[w]
print @n.xbgr.xm52_u3.nsg13_hv_pmos[l]
print @n.xbgr.xm52_u3.nsg13_hv_pmos[delvto]
print @n.xbgr.xm52_u3.nsg13_hv_pmos[factuo]
print @n.xbgr.xm52_u4.nsg13_hv_pmos[w]
print @n.xbgr.xm52_u4.nsg13_hv_pmos[l]
print @n.xbgr.xm52_u4.nsg13_hv_pmos[delvto]
print @n.xbgr.xm52_u4.nsg13_hv_pmos[factuo]
print @n.xbgr.xm52_u5.nsg13_hv_pmos[w]
print @n.xbgr.xm52_u5.nsg13_hv_pmos[l]
print @n.xbgr.xm52_u5.nsg13_hv_pmos[delvto]
print @n.xbgr.xm52_u5.nsg13_hv_pmos[factuo]
print @n.xbgr.xm52_u6.nsg13_hv_pmos[w]
print @n.xbgr.xm52_u6.nsg13_hv_pmos[l]
print @n.xbgr.xm52_u6.nsg13_hv_pmos[delvto]
print @n.xbgr.xm52_u6.nsg13_hv_pmos[factuo]
print @n.xbgr.xm52_u7.nsg13_hv_pmos[w]
print @n.xbgr.xm52_u7.nsg13_hv_pmos[l]
print @n.xbgr.xm52_u7.nsg13_hv_pmos[delvto]
print @n.xbgr.xm52_u7.nsg13_hv_pmos[factuo]
print @n.xbgr.xm52_u8.nsg13_hv_pmos[w]
print @n.xbgr.xm52_u8.nsg13_hv_pmos[l]
print @n.xbgr.xm52_u8.nsg13_hv_pmos[delvto]
print @n.xbgr.xm52_u8.nsg13_hv_pmos[factuo]
print @n.xbgr.xm52_u9.nsg13_hv_pmos[w]
print @n.xbgr.xm52_u9.nsg13_hv_pmos[l]
print @n.xbgr.xm52_u9.nsg13_hv_pmos[delvto]
print @n.xbgr.xm52_u9.nsg13_hv_pmos[factuo]
print @n.xbgr.xm52_u10.nsg13_hv_pmos[w]
print @n.xbgr.xm52_u10.nsg13_hv_pmos[l]
print @n.xbgr.xm52_u10.nsg13_hv_pmos[delvto]
print @n.xbgr.xm52_u10.nsg13_hv_pmos[factuo]
print @n.xbgr.xm52_u11.nsg13_hv_pmos[w]
print @n.xbgr.xm52_u11.nsg13_hv_pmos[l]
print @n.xbgr.xm52_u11.nsg13_hv_pmos[delvto]
print @n.xbgr.xm52_u11.nsg13_hv_pmos[factuo]
print @n.xbgr.xm52_u12.nsg13_hv_pmos[w]
print @n.xbgr.xm52_u12.nsg13_hv_pmos[l]
print @n.xbgr.xm52_u12.nsg13_hv_pmos[delvto]
print @n.xbgr.xm52_u12.nsg13_hv_pmos[factuo]
print @n.xbgr.xm52_u13.nsg13_hv_pmos[w]
print @n.xbgr.xm52_u13.nsg13_hv_pmos[l]
print @n.xbgr.xm52_u13.nsg13_hv_pmos[delvto]
print @n.xbgr.xm52_u13.nsg13_hv_pmos[factuo]
print @n.xbgr.xm52_u14.nsg13_hv_pmos[w]
print @n.xbgr.xm52_u14.nsg13_hv_pmos[l]
print @n.xbgr.xm52_u14.nsg13_hv_pmos[delvto]
print @n.xbgr.xm52_u14.nsg13_hv_pmos[factuo]
print @n.xbgr.xm52_u15.nsg13_hv_pmos[w]
print @n.xbgr.xm52_u15.nsg13_hv_pmos[l]
print @n.xbgr.xm52_u15.nsg13_hv_pmos[delvto]
print @n.xbgr.xm52_u15.nsg13_hv_pmos[factuo]
print @n.xbgr.xm52_u16.nsg13_hv_pmos[w]
print @n.xbgr.xm52_u16.nsg13_hv_pmos[l]
print @n.xbgr.xm52_u16.nsg13_hv_pmos[delvto]
print @n.xbgr.xm52_u16.nsg13_hv_pmos[factuo]
print @n.xbgr.xm52_u17.nsg13_hv_pmos[w]
print @n.xbgr.xm52_u17.nsg13_hv_pmos[l]
print @n.xbgr.xm52_u17.nsg13_hv_pmos[delvto]
print @n.xbgr.xm52_u17.nsg13_hv_pmos[factuo]
print @n.xbgr.xm52_u18.nsg13_hv_pmos[w]
print @n.xbgr.xm52_u18.nsg13_hv_pmos[l]
print @n.xbgr.xm52_u18.nsg13_hv_pmos[delvto]
print @n.xbgr.xm52_u18.nsg13_hv_pmos[factuo]
print @n.xbgr.xm52_u19.nsg13_hv_pmos[w]
print @n.xbgr.xm52_u19.nsg13_hv_pmos[l]
print @n.xbgr.xm52_u19.nsg13_hv_pmos[delvto]
print @n.xbgr.xm52_u19.nsg13_hv_pmos[factuo]
print @n.xbgr.xm52_u20.nsg13_hv_pmos[w]
print @n.xbgr.xm52_u20.nsg13_hv_pmos[l]
print @n.xbgr.xm52_u20.nsg13_hv_pmos[delvto]
print @n.xbgr.xm52_u20.nsg13_hv_pmos[factuo]
print @n.xbgr.xm52_u21.nsg13_hv_pmos[w]
print @n.xbgr.xm52_u21.nsg13_hv_pmos[l]
print @n.xbgr.xm52_u21.nsg13_hv_pmos[delvto]
print @n.xbgr.xm52_u21.nsg13_hv_pmos[factuo]
print @n.xbgr.xm52_u22.nsg13_hv_pmos[w]
print @n.xbgr.xm52_u22.nsg13_hv_pmos[l]
print @n.xbgr.xm52_u22.nsg13_hv_pmos[delvto]
print @n.xbgr.xm52_u22.nsg13_hv_pmos[factuo]
print @n.xbgr.xm52_u23.nsg13_hv_pmos[w]
print @n.xbgr.xm52_u23.nsg13_hv_pmos[l]
print @n.xbgr.xm52_u23.nsg13_hv_pmos[delvto]
print @n.xbgr.xm52_u23.nsg13_hv_pmos[factuo]
print @n.xbgr.xm52_u24.nsg13_hv_pmos[w]
print @n.xbgr.xm52_u24.nsg13_hv_pmos[l]
print @n.xbgr.xm52_u24.nsg13_hv_pmos[delvto]
print @n.xbgr.xm52_u24.nsg13_hv_pmos[factuo]
print @n.xbgr.xm54_u2.nsg13_hv_pmos[w]
print @n.xbgr.xm54_u2.nsg13_hv_pmos[l]
print @n.xbgr.xm54_u2.nsg13_hv_pmos[delvto]
print @n.xbgr.xm54_u2.nsg13_hv_pmos[factuo]
print @n.xbgr.xm54_u3.nsg13_hv_pmos[w]
print @n.xbgr.xm54_u3.nsg13_hv_pmos[l]
print @n.xbgr.xm54_u3.nsg13_hv_pmos[delvto]
print @n.xbgr.xm54_u3.nsg13_hv_pmos[factuo]
print @n.xbgr.xm54_u4.nsg13_hv_pmos[w]
print @n.xbgr.xm54_u4.nsg13_hv_pmos[l]
print @n.xbgr.xm54_u4.nsg13_hv_pmos[delvto]
print @n.xbgr.xm54_u4.nsg13_hv_pmos[factuo]
print @n.xbgr.xm54_u5.nsg13_hv_pmos[w]
print @n.xbgr.xm54_u5.nsg13_hv_pmos[l]
print @n.xbgr.xm54_u5.nsg13_hv_pmos[delvto]
print @n.xbgr.xm54_u5.nsg13_hv_pmos[factuo]
print @n.xbgr.xm54_u6.nsg13_hv_pmos[w]
print @n.xbgr.xm54_u6.nsg13_hv_pmos[l]
print @n.xbgr.xm54_u6.nsg13_hv_pmos[delvto]
print @n.xbgr.xm54_u6.nsg13_hv_pmos[factuo]
print @n.xbgr.xm54_u7.nsg13_hv_pmos[w]
print @n.xbgr.xm54_u7.nsg13_hv_pmos[l]
print @n.xbgr.xm54_u7.nsg13_hv_pmos[delvto]
print @n.xbgr.xm54_u7.nsg13_hv_pmos[factuo]
print @n.xbgr.xm54_u8.nsg13_hv_pmos[w]
print @n.xbgr.xm54_u8.nsg13_hv_pmos[l]
print @n.xbgr.xm54_u8.nsg13_hv_pmos[delvto]
print @n.xbgr.xm54_u8.nsg13_hv_pmos[factuo]
print @n.xbgr.xm54_u9.nsg13_hv_pmos[w]
print @n.xbgr.xm54_u9.nsg13_hv_pmos[l]
print @n.xbgr.xm54_u9.nsg13_hv_pmos[delvto]
print @n.xbgr.xm54_u9.nsg13_hv_pmos[factuo]
print @n.xbgr.xm54_u10.nsg13_hv_pmos[w]
print @n.xbgr.xm54_u10.nsg13_hv_pmos[l]
print @n.xbgr.xm54_u10.nsg13_hv_pmos[delvto]
print @n.xbgr.xm54_u10.nsg13_hv_pmos[factuo]
print @n.xbgr.xm54_u11.nsg13_hv_pmos[w]
print @n.xbgr.xm54_u11.nsg13_hv_pmos[l]
print @n.xbgr.xm54_u11.nsg13_hv_pmos[delvto]
print @n.xbgr.xm54_u11.nsg13_hv_pmos[factuo]
print @n.xbgr.xm54_u12.nsg13_hv_pmos[w]
print @n.xbgr.xm54_u12.nsg13_hv_pmos[l]
print @n.xbgr.xm54_u12.nsg13_hv_pmos[delvto]
print @n.xbgr.xm54_u12.nsg13_hv_pmos[factuo]
print @n.xbgr.xm54_u13.nsg13_hv_pmos[w]
print @n.xbgr.xm54_u13.nsg13_hv_pmos[l]
print @n.xbgr.xm54_u13.nsg13_hv_pmos[delvto]
print @n.xbgr.xm54_u13.nsg13_hv_pmos[factuo]
print @n.xbgr.xm54_u14.nsg13_hv_pmos[w]
print @n.xbgr.xm54_u14.nsg13_hv_pmos[l]
print @n.xbgr.xm54_u14.nsg13_hv_pmos[delvto]
print @n.xbgr.xm54_u14.nsg13_hv_pmos[factuo]
print @n.xbgr.xm54_u15.nsg13_hv_pmos[w]
print @n.xbgr.xm54_u15.nsg13_hv_pmos[l]
print @n.xbgr.xm54_u15.nsg13_hv_pmos[delvto]
print @n.xbgr.xm54_u15.nsg13_hv_pmos[factuo]
print @n.xbgr.xm54_u16.nsg13_hv_pmos[w]
print @n.xbgr.xm54_u16.nsg13_hv_pmos[l]
print @n.xbgr.xm54_u16.nsg13_hv_pmos[delvto]
print @n.xbgr.xm54_u16.nsg13_hv_pmos[factuo]
print @n.xbgr.xm54_u17.nsg13_hv_pmos[w]
print @n.xbgr.xm54_u17.nsg13_hv_pmos[l]
print @n.xbgr.xm54_u17.nsg13_hv_pmos[delvto]
print @n.xbgr.xm54_u17.nsg13_hv_pmos[factuo]
print @n.xbgr.xm54_u18.nsg13_hv_pmos[w]
print @n.xbgr.xm54_u18.nsg13_hv_pmos[l]
print @n.xbgr.xm54_u18.nsg13_hv_pmos[delvto]
print @n.xbgr.xm54_u18.nsg13_hv_pmos[factuo]
print @n.xbgr.xm54_u19.nsg13_hv_pmos[w]
print @n.xbgr.xm54_u19.nsg13_hv_pmos[l]
print @n.xbgr.xm54_u19.nsg13_hv_pmos[delvto]
print @n.xbgr.xm54_u19.nsg13_hv_pmos[factuo]
print @n.xbgr.xm54_u20.nsg13_hv_pmos[w]
print @n.xbgr.xm54_u20.nsg13_hv_pmos[l]
print @n.xbgr.xm54_u20.nsg13_hv_pmos[delvto]
print @n.xbgr.xm54_u20.nsg13_hv_pmos[factuo]
print @n.xbgr.xm54_u21.nsg13_hv_pmos[w]
print @n.xbgr.xm54_u21.nsg13_hv_pmos[l]
print @n.xbgr.xm54_u21.nsg13_hv_pmos[delvto]
print @n.xbgr.xm54_u21.nsg13_hv_pmos[factuo]
print @n.xbgr.xm54_u22.nsg13_hv_pmos[w]
print @n.xbgr.xm54_u22.nsg13_hv_pmos[l]
print @n.xbgr.xm54_u22.nsg13_hv_pmos[delvto]
print @n.xbgr.xm54_u22.nsg13_hv_pmos[factuo]
print @n.xbgr.xm54_u23.nsg13_hv_pmos[w]
print @n.xbgr.xm54_u23.nsg13_hv_pmos[l]
print @n.xbgr.xm54_u23.nsg13_hv_pmos[delvto]
print @n.xbgr.xm54_u23.nsg13_hv_pmos[factuo]
print @n.xbgr.xm54_u24.nsg13_hv_pmos[w]
print @n.xbgr.xm54_u24.nsg13_hv_pmos[l]
print @n.xbgr.xm54_u24.nsg13_hv_pmos[delvto]
print @n.xbgr.xm54_u24.nsg13_hv_pmos[factuo]
print @q.xbgr.xq56_u2.qnpn13g2[area]
print @q.xbgr.xq56_u3.qnpn13g2[area]
print @q.xbgr.xq56_u4.qnpn13g2[area]
print @q.xbgr.xq56_u5.qnpn13g2[area]
print @q.xbgr.xq56_u6.qnpn13g2[area]
print @q.xbgr.xq56_u7.qnpn13g2[area]
print @q.xbgr.xq56_u8.qnpn13g2[area]
print @q.xbgr.xq56_u9.qnpn13g2[area]
print @q.xbgr.xq56_u10.qnpn13g2[area]
print @q.xbgr.xq56_u11.qnpn13g2[area]
print @q.xbgr.xq56_u12.qnpn13g2[area]
print @q.xbgr.xq56_u13.qnpn13g2[area]
print @q.xbgr.xq56_u14.qnpn13g2[area]
print @q.xbgr.xq56_u15.qnpn13g2[area]
print @q.xbgr.xq56_u16.qnpn13g2[area]
print @q.xbgr.xq56_u17.qnpn13g2[area]
print @q.xbgr.xq56_u18.qnpn13g2[area]
print @q.xbgr.xq56_u19.qnpn13g2[area]
print @q.xbgr.xq56_u20.qnpn13g2[area]
print @q.xbgr.xq56_u21.qnpn13g2[area]
print @q.xbgr.xq56_u22.qnpn13g2[area]
print @q.xbgr.xq56_u23.qnpn13g2[area]
print @q.xbgr.xq56_u24.qnpn13g2[area]
print @q.xbgr.xq60_u2.qnpn13g2[area]
print @q.xbgr.xq60_u3.qnpn13g2[area]
print @q.xbgr.xq60_u4.qnpn13g2[area]
print @q.xbgr.xq62_u2.qnpn13g2[area]
print @q.xbgr.xq62_u3.qnpn13g2[area]
print @q.xbgr.xq62_u4.qnpn13g2[area]
print @q.xbgr.xq62_u5.qnpn13g2[area]
print @q.xbgr.xq62_u6.qnpn13g2[area]
print @q.xbgr.xq62_u7.qnpn13g2[area]
print @q.xbgr.xq62_u8.qnpn13g2[area]
print @q.xbgr.xq62_u9.qnpn13g2[area]
print @q.xbgr.xq62_u10.qnpn13g2[area]
print @q.xbgr.xq62_u11.qnpn13g2[area]
print @q.xbgr.xq62_u12.qnpn13g2[area]
print @q.xbgr.xq62_u13.qnpn13g2[area]
print @q.xbgr.xq62_u14.qnpn13g2[area]
print @q.xbgr.xq62_u15.qnpn13g2[area]
print @q.xbgr.xq62_u16.qnpn13g2[area]
print @q.xbgr.xq62_u17.qnpn13g2[area]
print @q.xbgr.xq62_u18.qnpn13g2[area]
print @q.xbgr.xq62_u19.qnpn13g2[area]
print @q.xbgr.xq62_u20.qnpn13g2[area]
print @q.xbgr.xq62_u21.qnpn13g2[area]
print @q.xbgr.xq62_u22.qnpn13g2[area]
print @q.xbgr.xq62_u23.qnpn13g2[area]
print @q.xbgr.xq62_u24.qnpn13g2[area]
print @q.xbgr.xq67_u2.qnpn13g2[area]
print @q.xbgr.xq67_u3.qnpn13g2[area]
print @q.xbgr.xq67_u4.qnpn13g2[area]
print @q.xbgr.xq67_u5.qnpn13g2[area]
print @q.xbgr.xq67_u6.qnpn13g2[area]
print @q.xbgr.xq67_u7.qnpn13g2[area]
print @q.xbgr.xq67_u8.qnpn13g2[area]
print @q.xbgr.xq67_u9.qnpn13g2[area]
print @q.xbgr.xq67_u10.qnpn13g2[area]
print @q.xbgr.xq67_u11.qnpn13g2[area]
print @q.xbgr.xq67_u12.qnpn13g2[area]
print @q.xbgr.xq67_u13.qnpn13g2[area]
print @q.xbgr.xq67_u14.qnpn13g2[area]
print @q.xbgr.xq67_u15.qnpn13g2[area]
print @q.xbgr.xq67_u16.qnpn13g2[area]
print @q.xbgr.xq67_u17.qnpn13g2[area]
print @q.xbgr.xq67_u18.qnpn13g2[area]
print @q.xbgr.xq67_u19.qnpn13g2[area]
print @q.xbgr.xq67_u20.qnpn13g2[area]
print @q.xbgr.xq67_u21.qnpn13g2[area]
print @q.xbgr.xq67_u22.qnpn13g2[area]
print @q.xbgr.xq67_u23.qnpn13g2[area]
print @q.xbgr.xq67_u24.qnpn13g2[area]
print @q.xbgr.xq68_u2.qnpn13g2[area]
print @q.xbgr.xq68_u3.qnpn13g2[area]
print @q.xbgr.xq68_u4.qnpn13g2[area]
print @q.xbgr.xq68_u5.qnpn13g2[area]
print @q.xbgr.xq68_u6.qnpn13g2[area]
print @q.xbgr.xq68_u7.qnpn13g2[area]
print @q.xbgr.xq68_u8.qnpn13g2[area]
print @q.xbgr.xq68_u9.qnpn13g2[area]
print @q.xbgr.xq68_u10.qnpn13g2[area]
print @q.xbgr.xq68_u11.qnpn13g2[area]
print @q.xbgr.xq68_u12.qnpn13g2[area]
print @q.xbgr.xq68_u13.qnpn13g2[area]
print @q.xbgr.xq68_u14.qnpn13g2[area]
print @q.xbgr.xq68_u15.qnpn13g2[area]
print @q.xbgr.xq68_u16.qnpn13g2[area]
print @q.xbgr.xq68_u17.qnpn13g2[area]
print @q.xbgr.xq68_u18.qnpn13g2[area]
print @q.xbgr.xq68_u19.qnpn13g2[area]
print @q.xbgr.xq68_u20.qnpn13g2[area]
print @q.xbgr.xq68_u21.qnpn13g2[area]
print @q.xbgr.xq68_u22.qnpn13g2[area]
print @q.xbgr.xq68_u23.qnpn13g2[area]
print @q.xbgr.xq68_u24.qnpn13g2[area]
print @q.xbgr.xq69_u2.qnpn13g2[area]
print @q.xbgr.xq69_u3.qnpn13g2[area]
print @q.xbgr.xq69_u4.qnpn13g2[area]
print @q.xbgr.xq69_u5.qnpn13g2[area]
print @q.xbgr.xq69_u6.qnpn13g2[area]
print @q.xbgr.xq69_u7.qnpn13g2[area]
print @q.xbgr.xq69_u8.qnpn13g2[area]
print @q.xbgr.xq69_u9.qnpn13g2[area]
print @q.xbgr.xq69_u10.qnpn13g2[area]
print @q.xbgr.xq69_u11.qnpn13g2[area]
print @q.xbgr.xq69_u12.qnpn13g2[area]
print @q.xbgr.xq69_u13.qnpn13g2[area]
print @q.xbgr.xq69_u14.qnpn13g2[area]
print @q.xbgr.xq69_u15.qnpn13g2[area]
print @q.xbgr.xq69_u16.qnpn13g2[area]
print @q.xbgr.xq69_u17.qnpn13g2[area]
print @q.xbgr.xq69_u18.qnpn13g2[area]
print @q.xbgr.xq69_u19.qnpn13g2[area]
print @q.xbgr.xq69_u20.qnpn13g2[area]
print @q.xbgr.xq69_u21.qnpn13g2[area]
print @q.xbgr.xq69_u22.qnpn13g2[area]
print @q.xbgr.xq69_u23.qnpn13g2[area]
print @q.xbgr.xq69_u24.qnpn13g2[area]
print @q.xbgr.xq70_u2.qnpn13g2[area]
print @q.xbgr.xq70_u3.qnpn13g2[area]
print @q.xbgr.xq70_u4.qnpn13g2[area]
print @q.xbgr.xq70_u5.qnpn13g2[area]
print @q.xbgr.xq70_u6.qnpn13g2[area]
print @q.xbgr.xq70_u7.qnpn13g2[area]
print @q.xbgr.xq70_u8.qnpn13g2[area]
print @q.xbgr.xq70_u9.qnpn13g2[area]
print @q.xbgr.xq70_u10.qnpn13g2[area]
print @q.xbgr.xq70_u11.qnpn13g2[area]
print @q.xbgr.xq70_u12.qnpn13g2[area]
print @q.xbgr.xq70_u13.qnpn13g2[area]
print @q.xbgr.xq70_u14.qnpn13g2[area]
print @q.xbgr.xq70_u15.qnpn13g2[area]
print @q.xbgr.xq70_u16.qnpn13g2[area]
print @q.xbgr.xq70_u17.qnpn13g2[area]
print @q.xbgr.xq70_u18.qnpn13g2[area]
print @q.xbgr.xq70_u19.qnpn13g2[area]
print @q.xbgr.xq70_u20.qnpn13g2[area]
print @q.xbgr.xq70_u21.qnpn13g2[area]
print @q.xbgr.xq70_u22.qnpn13g2[area]
print @q.xbgr.xq70_u23.qnpn13g2[area]
print @q.xbgr.xq70_u24.qnpn13g2[area]
print @q.xbgr.xq71_u2.qnpn13g2[area]
print @q.xbgr.xq71_u3.qnpn13g2[area]
print @q.xbgr.xq71_u4.qnpn13g2[area]
print @q.xbgr.xq71_u5.qnpn13g2[area]
print @q.xbgr.xq71_u6.qnpn13g2[area]
print @q.xbgr.xq71_u7.qnpn13g2[area]
print @q.xbgr.xq71_u8.qnpn13g2[area]
print @q.xbgr.xq71_u9.qnpn13g2[area]
print @q.xbgr.xq71_u10.qnpn13g2[area]
print @q.xbgr.xq71_u11.qnpn13g2[area]
print @q.xbgr.xq71_u12.qnpn13g2[area]
print @q.xbgr.xq71_u13.qnpn13g2[area]
print @q.xbgr.xq71_u14.qnpn13g2[area]
print @q.xbgr.xq71_u15.qnpn13g2[area]
print @q.xbgr.xq71_u16.qnpn13g2[area]
print @q.xbgr.xq71_u17.qnpn13g2[area]
print @q.xbgr.xq71_u18.qnpn13g2[area]
print @q.xbgr.xq71_u19.qnpn13g2[area]
print @q.xbgr.xq71_u20.qnpn13g2[area]
print @q.xbgr.xq71_u21.qnpn13g2[area]
print @q.xbgr.xq71_u22.qnpn13g2[area]
print @q.xbgr.xq71_u23.qnpn13g2[area]
print @q.xbgr.xq71_u24.qnpn13g2[area]
print @q.xbgr.xq72_u2.qnpn13g2[area]
print @q.xbgr.xq72_u3.qnpn13g2[area]
print @q.xbgr.xq72_u4.qnpn13g2[area]
print @q.xbgr.xq72_u5.qnpn13g2[area]
print @q.xbgr.xq72_u6.qnpn13g2[area]
print @q.xbgr.xq72_u7.qnpn13g2[area]
print @q.xbgr.xq72_u8.qnpn13g2[area]
print @q.xbgr.xq72_u9.qnpn13g2[area]
print @q.xbgr.xq72_u10.qnpn13g2[area]
print @q.xbgr.xq72_u11.qnpn13g2[area]
print @q.xbgr.xq72_u12.qnpn13g2[area]
print @q.xbgr.xq72_u13.qnpn13g2[area]
print @q.xbgr.xq72_u14.qnpn13g2[area]
print @q.xbgr.xq72_u15.qnpn13g2[area]
print @q.xbgr.xq72_u16.qnpn13g2[area]
print @q.xbgr.xq72_u17.qnpn13g2[area]
print @q.xbgr.xq72_u18.qnpn13g2[area]
print @q.xbgr.xq72_u19.qnpn13g2[area]
print @q.xbgr.xq72_u20.qnpn13g2[area]
print @q.xbgr.xq72_u21.qnpn13g2[area]
print @q.xbgr.xq72_u22.qnpn13g2[area]
print @q.xbgr.xq72_u23.qnpn13g2[area]
print @q.xbgr.xq72_u24.qnpn13g2[area]
print @q.xbgr.xq73_u2.qnpn13g2[area]
print @q.xbgr.xq73_u3.qnpn13g2[area]
print @q.xbgr.xq73_u4.qnpn13g2[area]
print @q.xbgr.xq73_u5.qnpn13g2[area]
print @q.xbgr.xq73_u6.qnpn13g2[area]
print @q.xbgr.xq73_u7.qnpn13g2[area]
print @q.xbgr.xq73_u8.qnpn13g2[area]
print @q.xbgr.xq73_u9.qnpn13g2[area]
print @q.xbgr.xq73_u10.qnpn13g2[area]
print @q.xbgr.xq73_u11.qnpn13g2[area]
print @q.xbgr.xq73_u12.qnpn13g2[area]
print @q.xbgr.xq73_u13.qnpn13g2[area]
print @q.xbgr.xq73_u14.qnpn13g2[area]
print @q.xbgr.xq73_u15.qnpn13g2[area]
print @q.xbgr.xq73_u16.qnpn13g2[area]
print @q.xbgr.xq73_u17.qnpn13g2[area]
print @q.xbgr.xq73_u18.qnpn13g2[area]
print @q.xbgr.xq73_u19.qnpn13g2[area]
print @q.xbgr.xq73_u20.qnpn13g2[area]
print @q.xbgr.xq73_u21.qnpn13g2[area]
print @q.xbgr.xq73_u22.qnpn13g2[area]
print @q.xbgr.xq73_u23.qnpn13g2[area]
print @q.xbgr.xq73_u24.qnpn13g2[area]
print @q.xbgr.xq74_u2.qnpn13g2[area]
print @q.xbgr.xq74_u3.qnpn13g2[area]
print @q.xbgr.xq74_u4.qnpn13g2[area]
print @q.xbgr.xq74_u5.qnpn13g2[area]
print @q.xbgr.xq74_u6.qnpn13g2[area]
print @q.xbgr.xq74_u7.qnpn13g2[area]
print @q.xbgr.xq74_u8.qnpn13g2[area]
print @q.xbgr.xq74_u9.qnpn13g2[area]
print @q.xbgr.xq74_u10.qnpn13g2[area]
print @q.xbgr.xq74_u11.qnpn13g2[area]
print @q.xbgr.xq74_u12.qnpn13g2[area]
print @q.xbgr.xq74_u13.qnpn13g2[area]
print @q.xbgr.xq74_u14.qnpn13g2[area]
print @q.xbgr.xq74_u15.qnpn13g2[area]
print @q.xbgr.xq74_u16.qnpn13g2[area]
print @q.xbgr.xq74_u17.qnpn13g2[area]
print @q.xbgr.xq74_u18.qnpn13g2[area]
print @q.xbgr.xq74_u19.qnpn13g2[area]
print @q.xbgr.xq74_u20.qnpn13g2[area]
print @q.xbgr.xq74_u21.qnpn13g2[area]
print @q.xbgr.xq74_u22.qnpn13g2[area]
print @q.xbgr.xq74_u23.qnpn13g2[area]
print @q.xbgr.xq74_u24.qnpn13g2[area]
print @q.xbgr.xq75_u2.qnpn13g2[area]
print @q.xbgr.xq75_u3.qnpn13g2[area]
print @q.xbgr.xq75_u4.qnpn13g2[area]
print @q.xbgr.xq75_u5.qnpn13g2[area]
print @q.xbgr.xq75_u6.qnpn13g2[area]
print @q.xbgr.xq75_u7.qnpn13g2[area]
print @q.xbgr.xq75_u8.qnpn13g2[area]
print @q.xbgr.xq75_u9.qnpn13g2[area]
print @q.xbgr.xq75_u10.qnpn13g2[area]
print @q.xbgr.xq75_u11.qnpn13g2[area]
print @q.xbgr.xq75_u12.qnpn13g2[area]
print @q.xbgr.xq75_u13.qnpn13g2[area]
print @q.xbgr.xq75_u14.qnpn13g2[area]
print @q.xbgr.xq75_u15.qnpn13g2[area]
print @q.xbgr.xq75_u16.qnpn13g2[area]
print @q.xbgr.xq75_u17.qnpn13g2[area]
print @q.xbgr.xq75_u18.qnpn13g2[area]
print @q.xbgr.xq75_u19.qnpn13g2[area]
print @q.xbgr.xq75_u20.qnpn13g2[area]
print @q.xbgr.xq75_u21.qnpn13g2[area]
print @q.xbgr.xq75_u22.qnpn13g2[area]
print @q.xbgr.xq75_u23.qnpn13g2[area]
print @q.xbgr.xq75_u24.qnpn13g2[area]
print @q.xbgr.xq76_u2.qnpn13g2[area]
print @q.xbgr.xq76_u3.qnpn13g2[area]
print @q.xbgr.xq76_u4.qnpn13g2[area]
print @q.xbgr.xq76_u5.qnpn13g2[area]
print @q.xbgr.xq76_u6.qnpn13g2[area]
print @q.xbgr.xq76_u7.qnpn13g2[area]
print @q.xbgr.xq76_u8.qnpn13g2[area]
print @q.xbgr.xq76_u9.qnpn13g2[area]
print @q.xbgr.xq76_u10.qnpn13g2[area]
print @q.xbgr.xq76_u11.qnpn13g2[area]
print @q.xbgr.xq76_u12.qnpn13g2[area]
print @q.xbgr.xq76_u13.qnpn13g2[area]
print @q.xbgr.xq76_u14.qnpn13g2[area]
print @q.xbgr.xq76_u15.qnpn13g2[area]
print @q.xbgr.xq76_u16.qnpn13g2[area]
print @q.xbgr.xq76_u17.qnpn13g2[area]
print @q.xbgr.xq76_u18.qnpn13g2[area]
print @q.xbgr.xq76_u19.qnpn13g2[area]
print @q.xbgr.xq76_u20.qnpn13g2[area]
print @q.xbgr.xq76_u21.qnpn13g2[area]
print @q.xbgr.xq76_u22.qnpn13g2[area]
print @q.xbgr.xq76_u23.qnpn13g2[area]
print @q.xbgr.xq76_u24.qnpn13g2[area]
print @n.xbgr.xr77_u2.nr1[nsmm_rsh]
print @n.xbgr.xr77_u2.nr1[nsmm_w]
print @n.xbgr.xr77_u2.nr1[nsmm_l]
print @n.xbgr.xr77_u3.nr1[nsmm_rsh]
print @n.xbgr.xr77_u3.nr1[nsmm_w]
print @n.xbgr.xr77_u3.nr1[nsmm_l]
print @n.xbgr.xr77_u4.nr1[nsmm_rsh]
print @n.xbgr.xr77_u4.nr1[nsmm_w]
print @n.xbgr.xr77_u4.nr1[nsmm_l]
print @n.xbgr.xr77_u5.nr1[nsmm_rsh]
print @n.xbgr.xr77_u5.nr1[nsmm_w]
print @n.xbgr.xr77_u5.nr1[nsmm_l]
print @n.xbgr.xr77_u6.nr1[nsmm_rsh]
print @n.xbgr.xr77_u6.nr1[nsmm_w]
print @n.xbgr.xr77_u6.nr1[nsmm_l]
print @n.xbgr.xr77_u7.nr1[nsmm_rsh]
print @n.xbgr.xr77_u7.nr1[nsmm_w]
print @n.xbgr.xr77_u7.nr1[nsmm_l]
print @n.xbgr.xr77_u8.nr1[nsmm_rsh]
print @n.xbgr.xr77_u8.nr1[nsmm_w]
print @n.xbgr.xr77_u8.nr1[nsmm_l]
print @n.xbgr.xr77_u9.nr1[nsmm_rsh]
print @n.xbgr.xr77_u9.nr1[nsmm_w]
print @n.xbgr.xr77_u9.nr1[nsmm_l]
print @n.xbgr.xr77_u10.nr1[nsmm_rsh]
print @n.xbgr.xr77_u10.nr1[nsmm_w]
print @n.xbgr.xr77_u10.nr1[nsmm_l]
print @n.xbgr.xr77_u11.nr1[nsmm_rsh]
print @n.xbgr.xr77_u11.nr1[nsmm_w]
print @n.xbgr.xr77_u11.nr1[nsmm_l]
print @n.xbgr.xr77_u12.nr1[nsmm_rsh]
print @n.xbgr.xr77_u12.nr1[nsmm_w]
print @n.xbgr.xr77_u12.nr1[nsmm_l]
print @n.xbgr.xr77_u13.nr1[nsmm_rsh]
print @n.xbgr.xr77_u13.nr1[nsmm_w]
print @n.xbgr.xr77_u13.nr1[nsmm_l]
print @n.xbgr.xr77_u14.nr1[nsmm_rsh]
print @n.xbgr.xr77_u14.nr1[nsmm_w]
print @n.xbgr.xr77_u14.nr1[nsmm_l]
print @n.xbgr.xr77_u15.nr1[nsmm_rsh]
print @n.xbgr.xr77_u15.nr1[nsmm_w]
print @n.xbgr.xr77_u15.nr1[nsmm_l]
print @n.xbgr.xr77_u16.nr1[nsmm_rsh]
print @n.xbgr.xr77_u16.nr1[nsmm_w]
print @n.xbgr.xr77_u16.nr1[nsmm_l]
print @n.xbgr.xr77_u17.nr1[nsmm_rsh]
print @n.xbgr.xr77_u17.nr1[nsmm_w]
print @n.xbgr.xr77_u17.nr1[nsmm_l]
print @n.xbgr.xr77_u18.nr1[nsmm_rsh]
print @n.xbgr.xr77_u18.nr1[nsmm_w]
print @n.xbgr.xr77_u18.nr1[nsmm_l]
print @n.xbgr.xr77_u19.nr1[nsmm_rsh]
print @n.xbgr.xr77_u19.nr1[nsmm_w]
print @n.xbgr.xr77_u19.nr1[nsmm_l]
print @n.xbgr.xr77_u20.nr1[nsmm_rsh]
print @n.xbgr.xr77_u20.nr1[nsmm_w]
print @n.xbgr.xr77_u20.nr1[nsmm_l]
print @n.xbgr.xr77_u21.nr1[nsmm_rsh]
print @n.xbgr.xr77_u21.nr1[nsmm_w]
print @n.xbgr.xr77_u21.nr1[nsmm_l]
print @n.xbgr.xr77_u22.nr1[nsmm_rsh]
print @n.xbgr.xr77_u22.nr1[nsmm_w]
print @n.xbgr.xr77_u22.nr1[nsmm_l]
print @n.xbgr.xr77_u23.nr1[nsmm_rsh]
print @n.xbgr.xr77_u23.nr1[nsmm_w]
print @n.xbgr.xr77_u23.nr1[nsmm_l]
print @n.xbgr.xr77_u24.nr1[nsmm_rsh]
print @n.xbgr.xr77_u24.nr1[nsmm_w]
print @n.xbgr.xr77_u24.nr1[nsmm_l]
print @n.xbgr.xr78_u2.nr1[nsmm_rsh]
print @n.xbgr.xr78_u2.nr1[nsmm_w]
print @n.xbgr.xr78_u2.nr1[nsmm_l]
print @n.xbgr.xr78_u3.nr1[nsmm_rsh]
print @n.xbgr.xr78_u3.nr1[nsmm_w]
print @n.xbgr.xr78_u3.nr1[nsmm_l]
print @n.xbgr.xr78_u4.nr1[nsmm_rsh]
print @n.xbgr.xr78_u4.nr1[nsmm_w]
print @n.xbgr.xr78_u4.nr1[nsmm_l]
print @n.xbgr.xr78_u5.nr1[nsmm_rsh]
print @n.xbgr.xr78_u5.nr1[nsmm_w]
print @n.xbgr.xr78_u5.nr1[nsmm_l]
print @n.xbgr.xr78_u6.nr1[nsmm_rsh]
print @n.xbgr.xr78_u6.nr1[nsmm_w]
print @n.xbgr.xr78_u6.nr1[nsmm_l]
print @n.xbgr.xr78_u7.nr1[nsmm_rsh]
print @n.xbgr.xr78_u7.nr1[nsmm_w]
print @n.xbgr.xr78_u7.nr1[nsmm_l]
print @n.xbgr.xr78_u8.nr1[nsmm_rsh]
print @n.xbgr.xr78_u8.nr1[nsmm_w]
print @n.xbgr.xr78_u8.nr1[nsmm_l]
print @n.xbgr.xr78_u9.nr1[nsmm_rsh]
print @n.xbgr.xr78_u9.nr1[nsmm_w]
print @n.xbgr.xr78_u9.nr1[nsmm_l]
print @n.xbgr.xr78_u10.nr1[nsmm_rsh]
print @n.xbgr.xr78_u10.nr1[nsmm_w]
print @n.xbgr.xr78_u10.nr1[nsmm_l]
print @n.xbgr.xr78_u11.nr1[nsmm_rsh]
print @n.xbgr.xr78_u11.nr1[nsmm_w]
print @n.xbgr.xr78_u11.nr1[nsmm_l]
print @n.xbgr.xr78_u12.nr1[nsmm_rsh]
print @n.xbgr.xr78_u12.nr1[nsmm_w]
print @n.xbgr.xr78_u12.nr1[nsmm_l]
print @n.xbgr.xr78_u13.nr1[nsmm_rsh]
print @n.xbgr.xr78_u13.nr1[nsmm_w]
print @n.xbgr.xr78_u13.nr1[nsmm_l]
print @n.xbgr.xr78_u14.nr1[nsmm_rsh]
print @n.xbgr.xr78_u14.nr1[nsmm_w]
print @n.xbgr.xr78_u14.nr1[nsmm_l]
print @n.xbgr.xr78_u15.nr1[nsmm_rsh]
print @n.xbgr.xr78_u15.nr1[nsmm_w]
print @n.xbgr.xr78_u15.nr1[nsmm_l]
print @n.xbgr.xr78_u16.nr1[nsmm_rsh]
print @n.xbgr.xr78_u16.nr1[nsmm_w]
print @n.xbgr.xr78_u16.nr1[nsmm_l]
print @n.xbgr.xr78_u17.nr1[nsmm_rsh]
print @n.xbgr.xr78_u17.nr1[nsmm_w]
print @n.xbgr.xr78_u17.nr1[nsmm_l]
print @n.xbgr.xr78_u18.nr1[nsmm_rsh]
print @n.xbgr.xr78_u18.nr1[nsmm_w]
print @n.xbgr.xr78_u18.nr1[nsmm_l]
print @n.xbgr.xr78_u19.nr1[nsmm_rsh]
print @n.xbgr.xr78_u19.nr1[nsmm_w]
print @n.xbgr.xr78_u19.nr1[nsmm_l]
print @n.xbgr.xr78_u20.nr1[nsmm_rsh]
print @n.xbgr.xr78_u20.nr1[nsmm_w]
print @n.xbgr.xr78_u20.nr1[nsmm_l]
print @n.xbgr.xr78_u21.nr1[nsmm_rsh]
print @n.xbgr.xr78_u21.nr1[nsmm_w]
print @n.xbgr.xr78_u21.nr1[nsmm_l]
print @n.xbgr.xr78_u22.nr1[nsmm_rsh]
print @n.xbgr.xr78_u22.nr1[nsmm_w]
print @n.xbgr.xr78_u22.nr1[nsmm_l]
print @n.xbgr.xr78_u23.nr1[nsmm_rsh]
print @n.xbgr.xr78_u23.nr1[nsmm_w]
print @n.xbgr.xr78_u23.nr1[nsmm_l]
print @n.xbgr.xr78_u24.nr1[nsmm_rsh]
print @n.xbgr.xr78_u24.nr1[nsmm_w]
print @n.xbgr.xr78_u24.nr1[nsmm_l]
print @n.xbgr.xr79_u2.nr1[nsmm_rsh]
print @n.xbgr.xr79_u2.nr1[nsmm_w]
print @n.xbgr.xr79_u2.nr1[nsmm_l]
print @n.xbgr.xr79_u3.nr1[nsmm_rsh]
print @n.xbgr.xr79_u3.nr1[nsmm_w]
print @n.xbgr.xr79_u3.nr1[nsmm_l]
print @n.xbgr.xr79_u4.nr1[nsmm_rsh]
print @n.xbgr.xr79_u4.nr1[nsmm_w]
print @n.xbgr.xr79_u4.nr1[nsmm_l]
print @n.xbgr.xr79_u5.nr1[nsmm_rsh]
print @n.xbgr.xr79_u5.nr1[nsmm_w]
print @n.xbgr.xr79_u5.nr1[nsmm_l]
print @n.xbgr.xr79_u6.nr1[nsmm_rsh]
print @n.xbgr.xr79_u6.nr1[nsmm_w]
print @n.xbgr.xr79_u6.nr1[nsmm_l]
print @n.xbgr.xr79_u7.nr1[nsmm_rsh]
print @n.xbgr.xr79_u7.nr1[nsmm_w]
print @n.xbgr.xr79_u7.nr1[nsmm_l]
print @n.xbgr.xr79_u8.nr1[nsmm_rsh]
print @n.xbgr.xr79_u8.nr1[nsmm_w]
print @n.xbgr.xr79_u8.nr1[nsmm_l]
print @n.xbgr.xr79_u9.nr1[nsmm_rsh]
print @n.xbgr.xr79_u9.nr1[nsmm_w]
print @n.xbgr.xr79_u9.nr1[nsmm_l]
print @n.xbgr.xr79_u10.nr1[nsmm_rsh]
print @n.xbgr.xr79_u10.nr1[nsmm_w]
print @n.xbgr.xr79_u10.nr1[nsmm_l]
print @n.xbgr.xr79_u11.nr1[nsmm_rsh]
print @n.xbgr.xr79_u11.nr1[nsmm_w]
print @n.xbgr.xr79_u11.nr1[nsmm_l]
print @n.xbgr.xr79_u12.nr1[nsmm_rsh]
print @n.xbgr.xr79_u12.nr1[nsmm_w]
print @n.xbgr.xr79_u12.nr1[nsmm_l]
print @n.xbgr.xr79_u13.nr1[nsmm_rsh]
print @n.xbgr.xr79_u13.nr1[nsmm_w]
print @n.xbgr.xr79_u13.nr1[nsmm_l]
print @n.xbgr.xr79_u14.nr1[nsmm_rsh]
print @n.xbgr.xr79_u14.nr1[nsmm_w]
print @n.xbgr.xr79_u14.nr1[nsmm_l]
print @n.xbgr.xr79_u15.nr1[nsmm_rsh]
print @n.xbgr.xr79_u15.nr1[nsmm_w]
print @n.xbgr.xr79_u15.nr1[nsmm_l]
print @n.xbgr.xr79_u16.nr1[nsmm_rsh]
print @n.xbgr.xr79_u16.nr1[nsmm_w]
print @n.xbgr.xr79_u16.nr1[nsmm_l]
print @n.xbgr.xr79_u17.nr1[nsmm_rsh]
print @n.xbgr.xr79_u17.nr1[nsmm_w]
print @n.xbgr.xr79_u17.nr1[nsmm_l]
print @n.xbgr.xr79_u18.nr1[nsmm_rsh]
print @n.xbgr.xr79_u18.nr1[nsmm_w]
print @n.xbgr.xr79_u18.nr1[nsmm_l]
print @n.xbgr.xr79_u19.nr1[nsmm_rsh]
print @n.xbgr.xr79_u19.nr1[nsmm_w]
print @n.xbgr.xr79_u19.nr1[nsmm_l]
print @n.xbgr.xr79_u20.nr1[nsmm_rsh]
print @n.xbgr.xr79_u20.nr1[nsmm_w]
print @n.xbgr.xr79_u20.nr1[nsmm_l]
print @n.xbgr.xr79_u21.nr1[nsmm_rsh]
print @n.xbgr.xr79_u21.nr1[nsmm_w]
print @n.xbgr.xr79_u21.nr1[nsmm_l]
print @n.xbgr.xr79_u22.nr1[nsmm_rsh]
print @n.xbgr.xr79_u22.nr1[nsmm_w]
print @n.xbgr.xr79_u22.nr1[nsmm_l]
print @n.xbgr.xr79_u23.nr1[nsmm_rsh]
print @n.xbgr.xr79_u23.nr1[nsmm_w]
print @n.xbgr.xr79_u23.nr1[nsmm_l]
print @n.xbgr.xr79_u24.nr1[nsmm_rsh]
print @n.xbgr.xr79_u24.nr1[nsmm_w]
print @n.xbgr.xr79_u24.nr1[nsmm_l]
print @n.xbgr.xr80_u2.nr1[nsmm_rsh]
print @n.xbgr.xr80_u2.nr1[nsmm_w]
print @n.xbgr.xr80_u2.nr1[nsmm_l]
print @n.xbgr.xr80_u3.nr1[nsmm_rsh]
print @n.xbgr.xr80_u3.nr1[nsmm_w]
print @n.xbgr.xr80_u3.nr1[nsmm_l]
print @n.xbgr.xr80_u4.nr1[nsmm_rsh]
print @n.xbgr.xr80_u4.nr1[nsmm_w]
print @n.xbgr.xr80_u4.nr1[nsmm_l]
print @n.xbgr.xr80_u5.nr1[nsmm_rsh]
print @n.xbgr.xr80_u5.nr1[nsmm_w]
print @n.xbgr.xr80_u5.nr1[nsmm_l]
print @n.xbgr.xr80_u6.nr1[nsmm_rsh]
print @n.xbgr.xr80_u6.nr1[nsmm_w]
print @n.xbgr.xr80_u6.nr1[nsmm_l]
print @n.xbgr.xr80_u7.nr1[nsmm_rsh]
print @n.xbgr.xr80_u7.nr1[nsmm_w]
print @n.xbgr.xr80_u7.nr1[nsmm_l]
print @n.xbgr.xr80_u8.nr1[nsmm_rsh]
print @n.xbgr.xr80_u8.nr1[nsmm_w]
print @n.xbgr.xr80_u8.nr1[nsmm_l]
print @n.xbgr.xr80_u9.nr1[nsmm_rsh]
print @n.xbgr.xr80_u9.nr1[nsmm_w]
print @n.xbgr.xr80_u9.nr1[nsmm_l]
print @n.xbgr.xr80_u10.nr1[nsmm_rsh]
print @n.xbgr.xr80_u10.nr1[nsmm_w]
print @n.xbgr.xr80_u10.nr1[nsmm_l]
print @n.xbgr.xr80_u11.nr1[nsmm_rsh]
print @n.xbgr.xr80_u11.nr1[nsmm_w]
print @n.xbgr.xr80_u11.nr1[nsmm_l]
print @n.xbgr.xr80_u12.nr1[nsmm_rsh]
print @n.xbgr.xr80_u12.nr1[nsmm_w]
print @n.xbgr.xr80_u12.nr1[nsmm_l]
print @n.xbgr.xr80_u13.nr1[nsmm_rsh]
print @n.xbgr.xr80_u13.nr1[nsmm_w]
print @n.xbgr.xr80_u13.nr1[nsmm_l]
print @n.xbgr.xr80_u14.nr1[nsmm_rsh]
print @n.xbgr.xr80_u14.nr1[nsmm_w]
print @n.xbgr.xr80_u14.nr1[nsmm_l]
print @n.xbgr.xr80_u15.nr1[nsmm_rsh]
print @n.xbgr.xr80_u15.nr1[nsmm_w]
print @n.xbgr.xr80_u15.nr1[nsmm_l]
print @n.xbgr.xr80_u16.nr1[nsmm_rsh]
print @n.xbgr.xr80_u16.nr1[nsmm_w]
print @n.xbgr.xr80_u16.nr1[nsmm_l]
print @n.xbgr.xr80_u17.nr1[nsmm_rsh]
print @n.xbgr.xr80_u17.nr1[nsmm_w]
print @n.xbgr.xr80_u17.nr1[nsmm_l]
print @n.xbgr.xr80_u18.nr1[nsmm_rsh]
print @n.xbgr.xr80_u18.nr1[nsmm_w]
print @n.xbgr.xr80_u18.nr1[nsmm_l]
print @n.xbgr.xr80_u19.nr1[nsmm_rsh]
print @n.xbgr.xr80_u19.nr1[nsmm_w]
print @n.xbgr.xr80_u19.nr1[nsmm_l]
print @n.xbgr.xr80_u20.nr1[nsmm_rsh]
print @n.xbgr.xr80_u20.nr1[nsmm_w]
print @n.xbgr.xr80_u20.nr1[nsmm_l]
print @n.xbgr.xr80_u21.nr1[nsmm_rsh]
print @n.xbgr.xr80_u21.nr1[nsmm_w]
print @n.xbgr.xr80_u21.nr1[nsmm_l]
print @n.xbgr.xr80_u22.nr1[nsmm_rsh]
print @n.xbgr.xr80_u22.nr1[nsmm_w]
print @n.xbgr.xr80_u22.nr1[nsmm_l]
print @n.xbgr.xr80_u23.nr1[nsmm_rsh]
print @n.xbgr.xr80_u23.nr1[nsmm_w]
print @n.xbgr.xr80_u23.nr1[nsmm_l]
print @n.xbgr.xr80_u24.nr1[nsmm_rsh]
print @n.xbgr.xr80_u24.nr1[nsmm_w]
print @n.xbgr.xr80_u24.nr1[nsmm_l]
print @n.xbgr.xr81_u2.nr1[nsmm_rsh]
print @n.xbgr.xr81_u2.nr1[nsmm_w]
print @n.xbgr.xr81_u2.nr1[nsmm_l]
print @n.xbgr.xr81_u3.nr1[nsmm_rsh]
print @n.xbgr.xr81_u3.nr1[nsmm_w]
print @n.xbgr.xr81_u3.nr1[nsmm_l]
print @n.xbgr.xr81_u4.nr1[nsmm_rsh]
print @n.xbgr.xr81_u4.nr1[nsmm_w]
print @n.xbgr.xr81_u4.nr1[nsmm_l]
print @n.xbgr.xr81_u5.nr1[nsmm_rsh]
print @n.xbgr.xr81_u5.nr1[nsmm_w]
print @n.xbgr.xr81_u5.nr1[nsmm_l]
print @n.xbgr.xr81_u6.nr1[nsmm_rsh]
print @n.xbgr.xr81_u6.nr1[nsmm_w]
print @n.xbgr.xr81_u6.nr1[nsmm_l]
print @n.xbgr.xr81_u7.nr1[nsmm_rsh]
print @n.xbgr.xr81_u7.nr1[nsmm_w]
print @n.xbgr.xr81_u7.nr1[nsmm_l]
print @n.xbgr.xr81_u8.nr1[nsmm_rsh]
print @n.xbgr.xr81_u8.nr1[nsmm_w]
print @n.xbgr.xr81_u8.nr1[nsmm_l]
print @n.xbgr.xr81_u9.nr1[nsmm_rsh]
print @n.xbgr.xr81_u9.nr1[nsmm_w]
print @n.xbgr.xr81_u9.nr1[nsmm_l]
print @n.xbgr.xr81_u10.nr1[nsmm_rsh]
print @n.xbgr.xr81_u10.nr1[nsmm_w]
print @n.xbgr.xr81_u10.nr1[nsmm_l]
print @n.xbgr.xr81_u11.nr1[nsmm_rsh]
print @n.xbgr.xr81_u11.nr1[nsmm_w]
print @n.xbgr.xr81_u11.nr1[nsmm_l]
print @n.xbgr.xr81_u12.nr1[nsmm_rsh]
print @n.xbgr.xr81_u12.nr1[nsmm_w]
print @n.xbgr.xr81_u12.nr1[nsmm_l]
print @n.xbgr.xr81_u13.nr1[nsmm_rsh]
print @n.xbgr.xr81_u13.nr1[nsmm_w]
print @n.xbgr.xr81_u13.nr1[nsmm_l]
print @n.xbgr.xr81_u14.nr1[nsmm_rsh]
print @n.xbgr.xr81_u14.nr1[nsmm_w]
print @n.xbgr.xr81_u14.nr1[nsmm_l]
print @n.xbgr.xr81_u15.nr1[nsmm_rsh]
print @n.xbgr.xr81_u15.nr1[nsmm_w]
print @n.xbgr.xr81_u15.nr1[nsmm_l]
print @n.xbgr.xr81_u16.nr1[nsmm_rsh]
print @n.xbgr.xr81_u16.nr1[nsmm_w]
print @n.xbgr.xr81_u16.nr1[nsmm_l]
print @n.xbgr.xr81_u17.nr1[nsmm_rsh]
print @n.xbgr.xr81_u17.nr1[nsmm_w]
print @n.xbgr.xr81_u17.nr1[nsmm_l]
print @n.xbgr.xr81_u18.nr1[nsmm_rsh]
print @n.xbgr.xr81_u18.nr1[nsmm_w]
print @n.xbgr.xr81_u18.nr1[nsmm_l]
print @n.xbgr.xr81_u19.nr1[nsmm_rsh]
print @n.xbgr.xr81_u19.nr1[nsmm_w]
print @n.xbgr.xr81_u19.nr1[nsmm_l]
print @n.xbgr.xr81_u20.nr1[nsmm_rsh]
print @n.xbgr.xr81_u20.nr1[nsmm_w]
print @n.xbgr.xr81_u20.nr1[nsmm_l]
print @n.xbgr.xr81_u21.nr1[nsmm_rsh]
print @n.xbgr.xr81_u21.nr1[nsmm_w]
print @n.xbgr.xr81_u21.nr1[nsmm_l]
print @n.xbgr.xr81_u22.nr1[nsmm_rsh]
print @n.xbgr.xr81_u22.nr1[nsmm_w]
print @n.xbgr.xr81_u22.nr1[nsmm_l]
print @n.xbgr.xr81_u23.nr1[nsmm_rsh]
print @n.xbgr.xr81_u23.nr1[nsmm_w]
print @n.xbgr.xr81_u23.nr1[nsmm_l]
print @n.xbgr.xr81_u24.nr1[nsmm_rsh]
print @n.xbgr.xr81_u24.nr1[nsmm_w]
print @n.xbgr.xr81_u24.nr1[nsmm_l]
print @n.xbgr.xr82_u2.nr1[nsmm_rsh]
print @n.xbgr.xr82_u2.nr1[nsmm_w]
print @n.xbgr.xr82_u2.nr1[nsmm_l]
print @n.xbgr.xr82_u3.nr1[nsmm_rsh]
print @n.xbgr.xr82_u3.nr1[nsmm_w]
print @n.xbgr.xr82_u3.nr1[nsmm_l]
print @n.xbgr.xr82_u4.nr1[nsmm_rsh]
print @n.xbgr.xr82_u4.nr1[nsmm_w]
print @n.xbgr.xr82_u4.nr1[nsmm_l]
print @n.xbgr.xr82_u5.nr1[nsmm_rsh]
print @n.xbgr.xr82_u5.nr1[nsmm_w]
print @n.xbgr.xr82_u5.nr1[nsmm_l]
print @n.xbgr.xr82_u6.nr1[nsmm_rsh]
print @n.xbgr.xr82_u6.nr1[nsmm_w]
print @n.xbgr.xr82_u6.nr1[nsmm_l]
print @n.xbgr.xr82_u7.nr1[nsmm_rsh]
print @n.xbgr.xr82_u7.nr1[nsmm_w]
print @n.xbgr.xr82_u7.nr1[nsmm_l]
print @n.xbgr.xr82_u8.nr1[nsmm_rsh]
print @n.xbgr.xr82_u8.nr1[nsmm_w]
print @n.xbgr.xr82_u8.nr1[nsmm_l]
print @n.xbgr.xr82_u9.nr1[nsmm_rsh]
print @n.xbgr.xr82_u9.nr1[nsmm_w]
print @n.xbgr.xr82_u9.nr1[nsmm_l]
print @n.xbgr.xr82_u10.nr1[nsmm_rsh]
print @n.xbgr.xr82_u10.nr1[nsmm_w]
print @n.xbgr.xr82_u10.nr1[nsmm_l]
print @n.xbgr.xr82_u11.nr1[nsmm_rsh]
print @n.xbgr.xr82_u11.nr1[nsmm_w]
print @n.xbgr.xr82_u11.nr1[nsmm_l]
print @n.xbgr.xr82_u12.nr1[nsmm_rsh]
print @n.xbgr.xr82_u12.nr1[nsmm_w]
print @n.xbgr.xr82_u12.nr1[nsmm_l]
print @n.xbgr.xr82_u13.nr1[nsmm_rsh]
print @n.xbgr.xr82_u13.nr1[nsmm_w]
print @n.xbgr.xr82_u13.nr1[nsmm_l]
print @n.xbgr.xr82_u14.nr1[nsmm_rsh]
print @n.xbgr.xr82_u14.nr1[nsmm_w]
print @n.xbgr.xr82_u14.nr1[nsmm_l]
print @n.xbgr.xr82_u15.nr1[nsmm_rsh]
print @n.xbgr.xr82_u15.nr1[nsmm_w]
print @n.xbgr.xr82_u15.nr1[nsmm_l]
print @n.xbgr.xr82_u16.nr1[nsmm_rsh]
print @n.xbgr.xr82_u16.nr1[nsmm_w]
print @n.xbgr.xr82_u16.nr1[nsmm_l]
print @n.xbgr.xr82_u17.nr1[nsmm_rsh]
print @n.xbgr.xr82_u17.nr1[nsmm_w]
print @n.xbgr.xr82_u17.nr1[nsmm_l]
print @n.xbgr.xr82_u18.nr1[nsmm_rsh]
print @n.xbgr.xr82_u18.nr1[nsmm_w]
print @n.xbgr.xr82_u18.nr1[nsmm_l]
print @n.xbgr.xr82_u19.nr1[nsmm_rsh]
print @n.xbgr.xr82_u19.nr1[nsmm_w]
print @n.xbgr.xr82_u19.nr1[nsmm_l]
print @n.xbgr.xr82_u20.nr1[nsmm_rsh]
print @n.xbgr.xr82_u20.nr1[nsmm_w]
print @n.xbgr.xr82_u20.nr1[nsmm_l]
print @n.xbgr.xr82_u21.nr1[nsmm_rsh]
print @n.xbgr.xr82_u21.nr1[nsmm_w]
print @n.xbgr.xr82_u21.nr1[nsmm_l]
print @n.xbgr.xr82_u22.nr1[nsmm_rsh]
print @n.xbgr.xr82_u22.nr1[nsmm_w]
print @n.xbgr.xr82_u22.nr1[nsmm_l]
print @n.xbgr.xr82_u23.nr1[nsmm_rsh]
print @n.xbgr.xr82_u23.nr1[nsmm_w]
print @n.xbgr.xr82_u23.nr1[nsmm_l]
print @n.xbgr.xr82_u24.nr1[nsmm_rsh]
print @n.xbgr.xr82_u24.nr1[nsmm_w]
print @n.xbgr.xr82_u24.nr1[nsmm_l]
print @n.xbgr.xr83_u2.nr1[nsmm_rsh]
print @n.xbgr.xr83_u2.nr1[nsmm_w]
print @n.xbgr.xr83_u2.nr1[nsmm_l]
print @n.xbgr.xr83_u3.nr1[nsmm_rsh]
print @n.xbgr.xr83_u3.nr1[nsmm_w]
print @n.xbgr.xr83_u3.nr1[nsmm_l]
print @n.xbgr.xr83_u4.nr1[nsmm_rsh]
print @n.xbgr.xr83_u4.nr1[nsmm_w]
print @n.xbgr.xr83_u4.nr1[nsmm_l]
print @n.xbgr.xr83_u5.nr1[nsmm_rsh]
print @n.xbgr.xr83_u5.nr1[nsmm_w]
print @n.xbgr.xr83_u5.nr1[nsmm_l]
print @n.xbgr.xr83_u6.nr1[nsmm_rsh]
print @n.xbgr.xr83_u6.nr1[nsmm_w]
print @n.xbgr.xr83_u6.nr1[nsmm_l]
print @n.xbgr.xr83_u7.nr1[nsmm_rsh]
print @n.xbgr.xr83_u7.nr1[nsmm_w]
print @n.xbgr.xr83_u7.nr1[nsmm_l]
print @n.xbgr.xr83_u8.nr1[nsmm_rsh]
print @n.xbgr.xr83_u8.nr1[nsmm_w]
print @n.xbgr.xr83_u8.nr1[nsmm_l]
print @n.xbgr.xr83_u9.nr1[nsmm_rsh]
print @n.xbgr.xr83_u9.nr1[nsmm_w]
print @n.xbgr.xr83_u9.nr1[nsmm_l]
print @n.xbgr.xr83_u10.nr1[nsmm_rsh]
print @n.xbgr.xr83_u10.nr1[nsmm_w]
print @n.xbgr.xr83_u10.nr1[nsmm_l]
print @n.xbgr.xr83_u11.nr1[nsmm_rsh]
print @n.xbgr.xr83_u11.nr1[nsmm_w]
print @n.xbgr.xr83_u11.nr1[nsmm_l]
print @n.xbgr.xr83_u12.nr1[nsmm_rsh]
print @n.xbgr.xr83_u12.nr1[nsmm_w]
print @n.xbgr.xr83_u12.nr1[nsmm_l]
print @n.xbgr.xr83_u13.nr1[nsmm_rsh]
print @n.xbgr.xr83_u13.nr1[nsmm_w]
print @n.xbgr.xr83_u13.nr1[nsmm_l]
print @n.xbgr.xr83_u14.nr1[nsmm_rsh]
print @n.xbgr.xr83_u14.nr1[nsmm_w]
print @n.xbgr.xr83_u14.nr1[nsmm_l]
print @n.xbgr.xr83_u15.nr1[nsmm_rsh]
print @n.xbgr.xr83_u15.nr1[nsmm_w]
print @n.xbgr.xr83_u15.nr1[nsmm_l]
print @n.xbgr.xr83_u16.nr1[nsmm_rsh]
print @n.xbgr.xr83_u16.nr1[nsmm_w]
print @n.xbgr.xr83_u16.nr1[nsmm_l]
print @n.xbgr.xr83_u17.nr1[nsmm_rsh]
print @n.xbgr.xr83_u17.nr1[nsmm_w]
print @n.xbgr.xr83_u17.nr1[nsmm_l]
print @n.xbgr.xr83_u18.nr1[nsmm_rsh]
print @n.xbgr.xr83_u18.nr1[nsmm_w]
print @n.xbgr.xr83_u18.nr1[nsmm_l]
print @n.xbgr.xr83_u19.nr1[nsmm_rsh]
print @n.xbgr.xr83_u19.nr1[nsmm_w]
print @n.xbgr.xr83_u19.nr1[nsmm_l]
print @n.xbgr.xr83_u20.nr1[nsmm_rsh]
print @n.xbgr.xr83_u20.nr1[nsmm_w]
print @n.xbgr.xr83_u20.nr1[nsmm_l]
print @n.xbgr.xr83_u21.nr1[nsmm_rsh]
print @n.xbgr.xr83_u21.nr1[nsmm_w]
print @n.xbgr.xr83_u21.nr1[nsmm_l]
print @n.xbgr.xr83_u22.nr1[nsmm_rsh]
print @n.xbgr.xr83_u22.nr1[nsmm_w]
print @n.xbgr.xr83_u22.nr1[nsmm_l]
print @n.xbgr.xr83_u23.nr1[nsmm_rsh]
print @n.xbgr.xr83_u23.nr1[nsmm_w]
print @n.xbgr.xr83_u23.nr1[nsmm_l]
print @n.xbgr.xr83_u24.nr1[nsmm_rsh]
print @n.xbgr.xr83_u24.nr1[nsmm_w]
print @n.xbgr.xr83_u24.nr1[nsmm_l]
print @n.xbgr.xr84_u2.nr1[nsmm_rsh]
print @n.xbgr.xr84_u2.nr1[nsmm_w]
print @n.xbgr.xr84_u2.nr1[nsmm_l]
print @n.xbgr.xr84_u3.nr1[nsmm_rsh]
print @n.xbgr.xr84_u3.nr1[nsmm_w]
print @n.xbgr.xr84_u3.nr1[nsmm_l]
print @n.xbgr.xr84_u4.nr1[nsmm_rsh]
print @n.xbgr.xr84_u4.nr1[nsmm_w]
print @n.xbgr.xr84_u4.nr1[nsmm_l]
print @n.xbgr.xr84_u5.nr1[nsmm_rsh]
print @n.xbgr.xr84_u5.nr1[nsmm_w]
print @n.xbgr.xr84_u5.nr1[nsmm_l]
print @n.xbgr.xr84_u6.nr1[nsmm_rsh]
print @n.xbgr.xr84_u6.nr1[nsmm_w]
print @n.xbgr.xr84_u6.nr1[nsmm_l]
print @n.xbgr.xr84_u7.nr1[nsmm_rsh]
print @n.xbgr.xr84_u7.nr1[nsmm_w]
print @n.xbgr.xr84_u7.nr1[nsmm_l]
print @n.xbgr.xr84_u8.nr1[nsmm_rsh]
print @n.xbgr.xr84_u8.nr1[nsmm_w]
print @n.xbgr.xr84_u8.nr1[nsmm_l]
print @n.xbgr.xr84_u9.nr1[nsmm_rsh]
print @n.xbgr.xr84_u9.nr1[nsmm_w]
print @n.xbgr.xr84_u9.nr1[nsmm_l]
print @n.xbgr.xr84_u10.nr1[nsmm_rsh]
print @n.xbgr.xr84_u10.nr1[nsmm_w]
print @n.xbgr.xr84_u10.nr1[nsmm_l]
print @n.xbgr.xr84_u11.nr1[nsmm_rsh]
print @n.xbgr.xr84_u11.nr1[nsmm_w]
print @n.xbgr.xr84_u11.nr1[nsmm_l]
print @n.xbgr.xr84_u12.nr1[nsmm_rsh]
print @n.xbgr.xr84_u12.nr1[nsmm_w]
print @n.xbgr.xr84_u12.nr1[nsmm_l]
print @n.xbgr.xr84_u13.nr1[nsmm_rsh]
print @n.xbgr.xr84_u13.nr1[nsmm_w]
print @n.xbgr.xr84_u13.nr1[nsmm_l]
print @n.xbgr.xr84_u14.nr1[nsmm_rsh]
print @n.xbgr.xr84_u14.nr1[nsmm_w]
print @n.xbgr.xr84_u14.nr1[nsmm_l]
print @n.xbgr.xr84_u15.nr1[nsmm_rsh]
print @n.xbgr.xr84_u15.nr1[nsmm_w]
print @n.xbgr.xr84_u15.nr1[nsmm_l]
print @n.xbgr.xr84_u16.nr1[nsmm_rsh]
print @n.xbgr.xr84_u16.nr1[nsmm_w]
print @n.xbgr.xr84_u16.nr1[nsmm_l]
print @n.xbgr.xr84_u17.nr1[nsmm_rsh]
print @n.xbgr.xr84_u17.nr1[nsmm_w]
print @n.xbgr.xr84_u17.nr1[nsmm_l]
print @n.xbgr.xr84_u18.nr1[nsmm_rsh]
print @n.xbgr.xr84_u18.nr1[nsmm_w]
print @n.xbgr.xr84_u18.nr1[nsmm_l]
print @n.xbgr.xr84_u19.nr1[nsmm_rsh]
print @n.xbgr.xr84_u19.nr1[nsmm_w]
print @n.xbgr.xr84_u19.nr1[nsmm_l]
print @n.xbgr.xr84_u20.nr1[nsmm_rsh]
print @n.xbgr.xr84_u20.nr1[nsmm_w]
print @n.xbgr.xr84_u20.nr1[nsmm_l]
print @n.xbgr.xr84_u21.nr1[nsmm_rsh]
print @n.xbgr.xr84_u21.nr1[nsmm_w]
print @n.xbgr.xr84_u21.nr1[nsmm_l]
print @n.xbgr.xr84_u22.nr1[nsmm_rsh]
print @n.xbgr.xr84_u22.nr1[nsmm_w]
print @n.xbgr.xr84_u22.nr1[nsmm_l]
print @n.xbgr.xr84_u23.nr1[nsmm_rsh]
print @n.xbgr.xr84_u23.nr1[nsmm_w]
print @n.xbgr.xr84_u23.nr1[nsmm_l]
print @n.xbgr.xr84_u24.nr1[nsmm_rsh]
print @n.xbgr.xr84_u24.nr1[nsmm_w]
print @n.xbgr.xr84_u24.nr1[nsmm_l]
print @n.xbgr.xr85_u2.nr1[nsmm_rsh]
print @n.xbgr.xr85_u2.nr1[nsmm_w]
print @n.xbgr.xr85_u2.nr1[nsmm_l]
print @n.xbgr.xr85_u3.nr1[nsmm_rsh]
print @n.xbgr.xr85_u3.nr1[nsmm_w]
print @n.xbgr.xr85_u3.nr1[nsmm_l]
print @n.xbgr.xr85_u4.nr1[nsmm_rsh]
print @n.xbgr.xr85_u4.nr1[nsmm_w]
print @n.xbgr.xr85_u4.nr1[nsmm_l]
print @n.xbgr.xr85_u5.nr1[nsmm_rsh]
print @n.xbgr.xr85_u5.nr1[nsmm_w]
print @n.xbgr.xr85_u5.nr1[nsmm_l]
print @n.xbgr.xr85_u6.nr1[nsmm_rsh]
print @n.xbgr.xr85_u6.nr1[nsmm_w]
print @n.xbgr.xr85_u6.nr1[nsmm_l]
print @n.xbgr.xr85_u7.nr1[nsmm_rsh]
print @n.xbgr.xr85_u7.nr1[nsmm_w]
print @n.xbgr.xr85_u7.nr1[nsmm_l]
print @n.xbgr.xr85_u8.nr1[nsmm_rsh]
print @n.xbgr.xr85_u8.nr1[nsmm_w]
print @n.xbgr.xr85_u8.nr1[nsmm_l]
print @n.xbgr.xr85_u9.nr1[nsmm_rsh]
print @n.xbgr.xr85_u9.nr1[nsmm_w]
print @n.xbgr.xr85_u9.nr1[nsmm_l]
print @n.xbgr.xr85_u10.nr1[nsmm_rsh]
print @n.xbgr.xr85_u10.nr1[nsmm_w]
print @n.xbgr.xr85_u10.nr1[nsmm_l]
print @n.xbgr.xr85_u11.nr1[nsmm_rsh]
print @n.xbgr.xr85_u11.nr1[nsmm_w]
print @n.xbgr.xr85_u11.nr1[nsmm_l]
print @n.xbgr.xr85_u12.nr1[nsmm_rsh]
print @n.xbgr.xr85_u12.nr1[nsmm_w]
print @n.xbgr.xr85_u12.nr1[nsmm_l]
print @n.xbgr.xr85_u13.nr1[nsmm_rsh]
print @n.xbgr.xr85_u13.nr1[nsmm_w]
print @n.xbgr.xr85_u13.nr1[nsmm_l]
print @n.xbgr.xr85_u14.nr1[nsmm_rsh]
print @n.xbgr.xr85_u14.nr1[nsmm_w]
print @n.xbgr.xr85_u14.nr1[nsmm_l]
print @n.xbgr.xr85_u15.nr1[nsmm_rsh]
print @n.xbgr.xr85_u15.nr1[nsmm_w]
print @n.xbgr.xr85_u15.nr1[nsmm_l]
print @n.xbgr.xr85_u16.nr1[nsmm_rsh]
print @n.xbgr.xr85_u16.nr1[nsmm_w]
print @n.xbgr.xr85_u16.nr1[nsmm_l]
print @n.xbgr.xr85_u17.nr1[nsmm_rsh]
print @n.xbgr.xr85_u17.nr1[nsmm_w]
print @n.xbgr.xr85_u17.nr1[nsmm_l]
print @n.xbgr.xr85_u18.nr1[nsmm_rsh]
print @n.xbgr.xr85_u18.nr1[nsmm_w]
print @n.xbgr.xr85_u18.nr1[nsmm_l]
print @n.xbgr.xr85_u19.nr1[nsmm_rsh]
print @n.xbgr.xr85_u19.nr1[nsmm_w]
print @n.xbgr.xr85_u19.nr1[nsmm_l]
print @n.xbgr.xr85_u20.nr1[nsmm_rsh]
print @n.xbgr.xr85_u20.nr1[nsmm_w]
print @n.xbgr.xr85_u20.nr1[nsmm_l]
print @n.xbgr.xr85_u21.nr1[nsmm_rsh]
print @n.xbgr.xr85_u21.nr1[nsmm_w]
print @n.xbgr.xr85_u21.nr1[nsmm_l]
print @n.xbgr.xr85_u22.nr1[nsmm_rsh]
print @n.xbgr.xr85_u22.nr1[nsmm_w]
print @n.xbgr.xr85_u22.nr1[nsmm_l]
print @n.xbgr.xr85_u23.nr1[nsmm_rsh]
print @n.xbgr.xr85_u23.nr1[nsmm_w]
print @n.xbgr.xr85_u23.nr1[nsmm_l]
print @n.xbgr.xr85_u24.nr1[nsmm_rsh]
print @n.xbgr.xr85_u24.nr1[nsmm_w]
print @n.xbgr.xr85_u24.nr1[nsmm_l]
print @n.xbgr.xr86_u2.nr1[nsmm_rsh]
print @n.xbgr.xr86_u2.nr1[nsmm_w]
print @n.xbgr.xr86_u2.nr1[nsmm_l]
print @n.xbgr.xr86_u3.nr1[nsmm_rsh]
print @n.xbgr.xr86_u3.nr1[nsmm_w]
print @n.xbgr.xr86_u3.nr1[nsmm_l]
print @n.xbgr.xr86_u4.nr1[nsmm_rsh]
print @n.xbgr.xr86_u4.nr1[nsmm_w]
print @n.xbgr.xr86_u4.nr1[nsmm_l]
print @n.xbgr.xr86_u5.nr1[nsmm_rsh]
print @n.xbgr.xr86_u5.nr1[nsmm_w]
print @n.xbgr.xr86_u5.nr1[nsmm_l]
print @n.xbgr.xr86_u6.nr1[nsmm_rsh]
print @n.xbgr.xr86_u6.nr1[nsmm_w]
print @n.xbgr.xr86_u6.nr1[nsmm_l]
print @n.xbgr.xr86_u7.nr1[nsmm_rsh]
print @n.xbgr.xr86_u7.nr1[nsmm_w]
print @n.xbgr.xr86_u7.nr1[nsmm_l]
print @n.xbgr.xr86_u8.nr1[nsmm_rsh]
print @n.xbgr.xr86_u8.nr1[nsmm_w]
print @n.xbgr.xr86_u8.nr1[nsmm_l]
print @n.xbgr.xr86_u9.nr1[nsmm_rsh]
print @n.xbgr.xr86_u9.nr1[nsmm_w]
print @n.xbgr.xr86_u9.nr1[nsmm_l]
print @n.xbgr.xr86_u10.nr1[nsmm_rsh]
print @n.xbgr.xr86_u10.nr1[nsmm_w]
print @n.xbgr.xr86_u10.nr1[nsmm_l]
print @n.xbgr.xr86_u11.nr1[nsmm_rsh]
print @n.xbgr.xr86_u11.nr1[nsmm_w]
print @n.xbgr.xr86_u11.nr1[nsmm_l]
print @n.xbgr.xr86_u12.nr1[nsmm_rsh]
print @n.xbgr.xr86_u12.nr1[nsmm_w]
print @n.xbgr.xr86_u12.nr1[nsmm_l]
print @n.xbgr.xr86_u13.nr1[nsmm_rsh]
print @n.xbgr.xr86_u13.nr1[nsmm_w]
print @n.xbgr.xr86_u13.nr1[nsmm_l]
print @n.xbgr.xr86_u14.nr1[nsmm_rsh]
print @n.xbgr.xr86_u14.nr1[nsmm_w]
print @n.xbgr.xr86_u14.nr1[nsmm_l]
print @n.xbgr.xr86_u15.nr1[nsmm_rsh]
print @n.xbgr.xr86_u15.nr1[nsmm_w]
print @n.xbgr.xr86_u15.nr1[nsmm_l]
print @n.xbgr.xr86_u16.nr1[nsmm_rsh]
print @n.xbgr.xr86_u16.nr1[nsmm_w]
print @n.xbgr.xr86_u16.nr1[nsmm_l]
print @n.xbgr.xr86_u17.nr1[nsmm_rsh]
print @n.xbgr.xr86_u17.nr1[nsmm_w]
print @n.xbgr.xr86_u17.nr1[nsmm_l]
print @n.xbgr.xr86_u18.nr1[nsmm_rsh]
print @n.xbgr.xr86_u18.nr1[nsmm_w]
print @n.xbgr.xr86_u18.nr1[nsmm_l]
print @n.xbgr.xr86_u19.nr1[nsmm_rsh]
print @n.xbgr.xr86_u19.nr1[nsmm_w]
print @n.xbgr.xr86_u19.nr1[nsmm_l]
print @n.xbgr.xr86_u20.nr1[nsmm_rsh]
print @n.xbgr.xr86_u20.nr1[nsmm_w]
print @n.xbgr.xr86_u20.nr1[nsmm_l]
print @n.xbgr.xr86_u21.nr1[nsmm_rsh]
print @n.xbgr.xr86_u21.nr1[nsmm_w]
print @n.xbgr.xr86_u21.nr1[nsmm_l]
print @n.xbgr.xr86_u22.nr1[nsmm_rsh]
print @n.xbgr.xr86_u22.nr1[nsmm_w]
print @n.xbgr.xr86_u22.nr1[nsmm_l]
print @n.xbgr.xr86_u23.nr1[nsmm_rsh]
print @n.xbgr.xr86_u23.nr1[nsmm_w]
print @n.xbgr.xr86_u23.nr1[nsmm_l]
print @n.xbgr.xr86_u24.nr1[nsmm_rsh]
print @n.xbgr.xr86_u24.nr1[nsmm_w]
print @n.xbgr.xr86_u24.nr1[nsmm_l]
echo METALLIC_POINT_VOLTAGES_BEGIN
print v(xbgr.mr_n60826720)
print v(xbgr.vd2)
print v(xbgr.mr_n60968624)
print v(xbgr.c2)
print v(xbgr.mr_n61152304)
print v(xbgr.mr_n61258160)
print v(xbgr.mr_n61393376)
print v(xbgr.mr_n61502576)
print v(xbgr.mr_n61628640)
print v(xbgr.mr_n61769856)
print v(xbgr.mr_n61955648)
print v(xbgr.mr_n62082928)
print v(xbgr.mr_n62232608)
print v(xbgr.mr_n62408320)
print v(xbgr.mr_n62536112)
print v(xbgr.mr_n62718240)
print v(xbgr.mr_n62817744)
print v(xbgr.mr_n62888352)
print v(xbgr.mr_n60833216)
print v(xbgr.mr_n60896336)
print v(xbgr.mr_n60932096)
print v(xbgr.mr_n61038256)
print v(xbgr.mr_n61155440)
print v(xbgr.mr_n61259120)
print v(xbgr.mr_n61365728)
print v(xbgr.mr_n61510352)
print v(xbgr.mr_n61626384)
print v(xbgr.mr_n61781776)
print v(xbgr.mr_n61769184)
print v(xbgr.mr_n61958784)
print v(xbgr.mr_n62086320)
print v(xbgr.mr_n62233504)
print v(xbgr.mr_n62363248)
print v(xbgr.mr_n62508400)
print v(xbgr.mr_n62721472)
print v(xbgr.mr_n62843056)
print v(xbgr.mr_n63023584)
print v(xbgr.mr_n60827008)
print v(xbgr.mr_n60030416)
print v(xbgr.b1b)
print v(xbgr.mr_n60995968)
print v(xbgr.mr_n61112240)
print v(xbgr.mr_n61206864)
print v(xbgr.mr_n61241504)
print v(xbgr.mr_n61449280)
print v(xbgr.mr_n61576528)
print v(xbgr.mr_n61918720)
print v(xbgr.mr_n62043312)
print v(xbgr.mr_n62177984)
print v(xbgr.mr_n62289968)
print v(xbgr.mr_n62472336)
print v(xbgr.mr_n62643888)
print v(xbgr.mr_n62752544)
print v(xbgr.mr_n63020688)
print v(xbgr.mr_n60859696)
print v(xbgr.mr_n59984192)
print v(xbgr.mr_n60934032)
print v(xbgr.mr_n60136096)
print v(xbgr.mr_n61198592)
print v(xbgr.mr_n61323536)
print v(xbgr.mr_n61306832)
print v(xbgr.mr_n61554000)
print v(xbgr.mr_n61626272)
print v(xbgr.mr_n61674640)
print v(xbgr.mr_n61887216)
print v(xbgr.mr_n62020640)
print v(xbgr.mr_n62236400)
print v(xbgr.mr_n62274992)
print v(xbgr.mr_n62588336)
print v(xbgr.mr_n62639856)
print v(xbgr.mr_n62842320)
print v(xbgr.mr_n63022736)
print v(xbgr.mr_n60003664)
print v(xbgr.mr_n60074912)
print v(xbgr.n_13)
print v(xbgr.n_24)
print v(xbgr.mr_n60091872)
print v(xbgr.mr_n60079136)
print v(xbgr.n_14)
print v(xbgr.mr_n60701008)
print v(xbgr.mr_n60828976)
print v(xbgr.mr_n60892528)
print v(xbgr.mr_n60963104)
print v(xbgr.mr_n61067328)
print v(xbgr.mr_n61155552)
print v(xbgr.mr_n61236960)
print v(xbgr.mr_n61418752)
print v(xbgr.vd1)
print v(xbgr.mr_n61639152)
print v(xbgr.mr_n61645600)
print v(xbgr.mr_n61956608)
print v(xbgr.mr_n62083888)
print v(xbgr.mr_n62240192)
print v(xbgr.mr_n62395680)
print v(xbgr.mr_n62589120)
print v(xbgr.mr_n62720608)
print v(xbgr.mr_n62841328)
print v(xbgr.mr_n63021360)
print v(xbgr.mr_n60835792)
print v(xbgr.mr_n60895120)
print v(xbgr.mr_n60935120)
print v(xbgr.mr_n61064032)
print v(xbgr.mr_n61159328)
print v(xbgr.mr_n61262736)
print v(xbgr.mr_n61369344)
print v(xbgr.mr_n61516928)
print v(xbgr.mr_n61626496)
print v(xbgr.mr_n61773024)
print v(xbgr.mr_n61770528)
print v(xbgr.mr_n61968512)
print v(xbgr.mr_n62094512)
print v(xbgr.mr_n62237296)
print v(xbgr.mr_n62367360)
print v(xbgr.mr_n62505456)
print v(xbgr.mr_n62723536)
print v(xbgr.mr_n62845120)
print v(xbgr.mr_n63025904)
print v(xbgr.mr_n60819360)
print v(xbgr.mr_n60914816)
print v(xbgr.mr_n60023904)
print v(xbgr.mr_n61024368)
print v(xbgr.mr_n61113632)
print v(xbgr.mr_n61207136)
print v(xbgr.mr_n61307904)
print v(xbgr.mr_n61505824)
print v(xbgr.mr_n61578032)
print v(xbgr.mr_n61920112)
print v(xbgr.mr_n62044704)
print v(xbgr.mr_n62179376)
print v(xbgr.mr_n62343088)
print v(xbgr.mr_n62473792)
print v(xbgr.mr_n62644624)
print v(xbgr.mr_n62754384)
print v(xbgr.mr_n63021024)
print v(xbgr.mr_n60094672)
print v(xbgr.mr_n60360288)
print v(xbgr.mr_n60589264)
print v(xbgr.n_26)
print v(xbgr.mr_n60094208)
print v(xbgr.mr_n60360944)
print v(xbgr.n_15)
print v(xbgr.mr_n60702448)
print v(xbgr.mr_n60866976)
print v(xbgr.mr_n59996320)
print v(xbgr.mr_n60977712)
print v(xbgr.mr_n61093648)
print v(xbgr.mr_n61199392)
print v(xbgr.mr_n61324176)
print v(xbgr.mr_n61419984)
print v(xbgr.mr_n61554640)
print v(xbgr.mr_n61654304)
print v(xbgr.mr_n61770192)
print v(xbgr.mr_n61958896)
print v(xbgr.mr_n62083120)
print v(xbgr.mr_n62282944)
print v(xbgr.mr_n62388320)
print v(xbgr.mr_n62590272)
print v(xbgr.mr_n62717568)
print v(xbgr.mr_n62842944)
print v(xbgr.mr_n63023472)
print v(xbgr.mr_n60095600)
print v(xbgr.mr_n60357120)
print v(xbgr.mr_n60590192)
print v(xbgr.n_27)
print v(xbgr.mr_n60003776)
print v(xbgr.mr_n60362128)
print v(xbgr.n_16)
print v(xbgr.mr_n60703888)
print v(xbgr.mr_n60096528)
print v(xbgr.mr_n60362720)
print v(xbgr.mr_n60590656)
print v(xbgr.n_21)
print v(xbgr.mr_n60827392)
print v(xbgr.mr_n60028592)
print v(xbgr.mr_n60977280)
print v(xbgr.mr_n61067440)
print v(xbgr.mr_n61098928)
print v(xbgr.mr_n61285184)
print v(xbgr.mr_n61421168)
print v(xbgr.mr_n61433936)
print v(xbgr.mr_n61637696)
print v(xbgr.mr_n61956096)
print v(xbgr.mr_n62086432)
print v(xbgr.mr_n61727216)
print v(xbgr.mr_n62395904)
print v(xbgr.mr_n62591360)
print v(xbgr.mr_n62721248)
print v(xbgr.mr_n62843168)
print v(xbgr.mr_n63023696)
print v(xbgr.mr_n60096064)
print v(xbgr.mr_n60304976)
print v(xbgr.mr_n60838976)
print v(xbgr.mr_n60897952)
print v(xbgr.mr_n60938144)
print v(xbgr.mr_n61067552)
print v(xbgr.mr_n61152752)
print v(xbgr.mr_n61266784)
print v(xbgr.mr_n61373328)
print v(xbgr.mr_n61520880)
print v(xbgr.mr_n61632512)
print v(xbgr.mr_n61970576)
print v(xbgr.mr_n62096576)
print v(xbgr.mr_n62241088)
print v(xbgr.mr_n62370256)
print v(xbgr.mr_n62512192)
print v(xbgr.mr_n62725600)
print v(xbgr.mr_n62847184)
print v(xbgr.mr_n63028224)
print v(xbgr.mr_n60832384)
print v(xbgr.mr_n60894928)
print v(xbgr.mr_n60666448)
print v(xbgr.mr_n61025440)
print v(xbgr.mr_n61115024)
print v(xbgr.mr_n61207744)
print v(xbgr.mr_n61358192)
print v(xbgr.mr_n61503536)
print v(xbgr.mr_n61581968)
print v(xbgr.mr_n61919648)
print v(xbgr.mr_n62046096)
print v(xbgr.mr_n62180768)
print v(xbgr.mr_n62344864)
print v(xbgr.mr_n62475568)
print v(xbgr.mr_n62645200)
print v(xbgr.mr_n62786592)
print v(xbgr.mr_n63023248)
print v(xbgr.mr_n60097456)
print v(xbgr.mr_n60305888)
print v(xbgr.n_8)
print v(xbgr.vbe3)
print v(xbgr.mr_n60867856)
print v(xbgr.mr_n60342384)
print v(xbgr.mr_n60976848)
print v(xbgr.mr_n61094368)
print v(xbgr.mr_n61200192)
print v(xbgr.mr_n61324448)
print v(xbgr.mr_n61421840)
print v(xbgr.mr_n61555456)
print v(xbgr.mr_n61655184)
print v(xbgr.mr_n61920576)
print v(xbgr.mr_n62083376)
print v(xbgr.mr_n62283744)
print v(xbgr.mr_n62413104)
print v(xbgr.mr_n62591872)
print v(xbgr.mr_n62721360)
print v(xbgr.mr_n62845008)
print v(xbgr.mr_n63025792)
print v(xbgr.mr_n60096992)
print v(xbgr.mr_n60036896)
print v(xbgr.mr_n60432624)
print v(xbgr.mr_n60750048)
print v(xbgr.mr_n60098384)
print v(xbgr.mr_n60366864)
print v(xbgr.mr_n60441648)
print v(xbgr.n_37)
print v(xbgr.mr_n60097920)
print v(xbgr.mr_n60368640)
print v(xbgr.mr_n60442048)
print v(xbgr.mr_n60751232)
print v(xbgr.n_6)
print v(xbgr.vb2)
print v(xbgr.n_2)
print v(xbgr.mr_n60751824)
print v(xbgr.mr_n60833328)
print v(xbgr.mr_n60316080)
print v(xbgr.mr_n60950352)
print v(xbgr.mr_n61058016)
print v(xbgr.mr_n61163200)
print v(xbgr.mr_n61283344)
print v(xbgr.mr_n61422352)
print v(xbgr.mr_n61502768)
print v(xbgr.mr_n61655008)
print v(xbgr.mr_n61889232)
print v(xbgr.mr_n62094624)
print v(xbgr.mr_n62270656)
print v(xbgr.mr_n62406800)
print v(xbgr.mr_n62593200)
print v(xbgr.mr_n62641936)
print v(xbgr.mr_n62845232)
print v(xbgr.mr_n63026016)
print v(xbgr.mr_n60841552)
print v(xbgr.mr_n60900912)
print v(xbgr.mr_n60941168)
print v(xbgr.mr_n61070096)
print v(xbgr.mr_n61166624)
print v(xbgr.mr_n61272304)
print v(xbgr.mr_n61378656)
print v(xbgr.mr_n61523712)
print v(xbgr.mr_n61636368)
print v(xbgr.mr_n61972640)
print v(xbgr.mr_n62098640)
print v(xbgr.mr_n62244880)
print v(xbgr.mr_n62374048)
print v(xbgr.mr_n62517712)
print v(xbgr.mr_n62727664)
print v(xbgr.mr_n62849248)
print v(xbgr.mr_n63030544)
print v(xbgr.mr_n60200896)
print v(xbgr.mr_n60235792)
print v(xbgr.mr_n60442848)
print v(xbgr.mr_n60752416)
print v(xbgr.mr_n60836656)
print v(xbgr.mr_n60889904)
print v(xbgr.mr_n60697440)
print v(xbgr.mr_n61026832)
print v(xbgr.mr_n61116416)
print v(xbgr.mr_n61221872)
print v(xbgr.mr_n61359344)
print v(xbgr.mr_n61510464)
print v(xbgr.mr_n61583360)
print v(xbgr.mr_n61919184)
print v(xbgr.mr_n62047808)
print v(xbgr.mr_n62182480)
print v(xbgr.mr_n62346640)
print v(xbgr.mr_n62477344)
print v(xbgr.mr_n62646016)
print v(xbgr.mr_n62787984)
print v(xbgr.mr_n63023360)
print v(xbgr.mr_n60201632)
print v(xbgr.mr_n60236384)
print v(xbgr.n_7)
print v(xbgr.n_36)
print v(xbgr.mr_n60868816)
print v(xbgr.mr_n60671088)
print v(xbgr.mr_n60980048)
print v(xbgr.mr_n61095328)
print v(xbgr.mr_n61200992)
print v(xbgr.mr_n61324720)
print v(xbgr.mr_n61423696)
print v(xbgr.mr_n61556912)
print v(xbgr.mr_n61655984)
print v(xbgr.mr_n61956352)
print v(xbgr.mr_n62096464)
print v(xbgr.mr_n62284544)
print v(xbgr.mr_n62413904)
print v(xbgr.mr_n62593696)
print v(xbgr.mr_n62725488)
print v(xbgr.mr_n62847072)
print v(xbgr.mr_n63028112)
print v(xbgr.mr_n60202368)
print v(xbgr.mr_n60236976)
print v(xbgr.mr_n60441248)
print v(xbgr.mr_n60753600)
print v(xbgr.mr_n60203104)
print v(xbgr.mr_n60237568)
print v(xbgr.mr_n60436176)
print v(xbgr.mr_n60605200)
print v(xbgr.mr_n60203840)
print v(xbgr.mr_n60238160)
print v(xbgr.mr_n60427888)
print v(xbgr.mr_n60754720)
print v(xbgr.mr_n60204576)
print v(xbgr.mr_n60238752)
print v(xbgr.mr_n60440320)
print v(xbgr.mr_n60755376)
print v(xbgr.mr_n60835904)
print v(xbgr.mr_n60317296)
print v(xbgr.mr_n60980816)
print v(xbgr.mr_n61092912)
print v(xbgr.mr_n61159440)
print v(xbgr.mr_n61292272)
print v(xbgr.mr_n61424208)
print v(xbgr.mr_n61520992)
print v(xbgr.mr_n61640992)
print v(xbgr.mr_n61968624)
print v(xbgr.mr_n62096688)
print v(xbgr.mr_n62262720)
print v(xbgr.mr_n62372928)
print v(xbgr.mr_n62594208)
print v(xbgr.mr_n62723648)
print v(xbgr.mr_n62818336)
print v(xbgr.mr_n63028336)
print v(xbgr.mr_n60844736)
print v(xbgr.mr_n60904704)
print v(xbgr.mr_n60944192)
print v(xbgr.mr_n61074080)
print v(xbgr.mr_n61161872)
print v(xbgr.mr_n61277824)
print v(xbgr.mr_n61384176)
print v(xbgr.mr_n61527792)
print v(xbgr.mr_n61635040)
print v(xbgr.mr_n61974704)
print v(xbgr.mr_n62100704)
print v(xbgr.mr_n62248672)
print v(xbgr.mr_n62377840)
print v(xbgr.mr_n62523232)
print v(xbgr.mr_n62729728)
print v(xbgr.mr_n62851312)
print v(xbgr.mr_n63032864)
print v(xbgr.mr_n60838144)
print v(xbgr.mr_n60336752)
print v(xbgr.mr_n60916016)
print v(xbgr.mr_n61028224)
print v(xbgr.mr_n61117808)
print v(xbgr.mr_n61224240)
print v(xbgr.mr_n61360736)
print v(xbgr.mr_n61503280)
print v(xbgr.mr_n61584752)
print v(xbgr.mr_n61968400)
print v(xbgr.mr_n62049584)
print v(xbgr.mr_n62184256)
print v(xbgr.mr_n62348416)
print v(xbgr.mr_n62479120)
print v(xbgr.mr_n62646832)
print v(xbgr.mr_n62789568)
print v(xbgr.mr_n63025680)
print v(xbgr.mr_n60205088)
print v(xbgr.mr_n60239344)
print v(xbgr.mr_n60426032)
print v(xbgr.mr_n60756560)
print v(xbgr.mr_n60205632)
print v(xbgr.mr_n60058016)
print v(xbgr.n_11)
print v(xbgr.mr_n60755968)
print v(xbgr.mr_n60869616)
print v(xbgr.mr_n60654672)
print v(xbgr.mr_n60981424)
print v(xbgr.mr_n61096528)
print v(xbgr.mr_n61201792)
print v(xbgr.mr_n61324992)
print v(xbgr.mr_n61425552)
print v(xbgr.mr_n61557792)
print v(xbgr.mr_n61656784)
print v(xbgr.mr_n61976320)
print v(xbgr.mr_n62011296)
print v(xbgr.mr_n62285344)
print v(xbgr.mr_n62414704)
print v(xbgr.mr_n62595440)
print v(xbgr.mr_n62727552)
print v(xbgr.mr_n62819520)
print v(xbgr.mr_n63028000)
print v(xbgr.mr_n60206128)
print v(xbgr.mr_n60069280)
print v(xbgr.mr_n60521984)
print v(xbgr.mr_n60757152)
print v(xbgr.mr_n60207184)
print v(xbgr.mr_n60080544)
print v(xbgr.mr_n60476432)
print v(xbgr.mr_n60704496)
print v(xbgr.mr_n60207456)
print v(xbgr.mr_n59989616)
print v(xbgr.mr_n60523168)
print v(xbgr.mr_n60758256)
print v(xbgr.mr_n60842416)
print v(xbgr.mr_n60056880)
print v(xbgr.mr_n60982272)
print v(xbgr.mr_n61059456)
print v(xbgr.mr_n61170496)
print v(xbgr.mr_n61293072)
print v(xbgr.mr_n61391536)
print v(xbgr.mr_n61503024)
print v(xbgr.mr_n61653792)
print v(xbgr.mr_n61972528)
print v(xbgr.mr_n62083632)
print v(xbgr.mr_n62268528)
print v(xbgr.mr_n62414528)
print v(xbgr.mr_n62596176)
print v(xbgr.mr_n62723424)
print v(xbgr.mr_n62818928)
print v(xbgr.mr_n62892704)
print v(xbgr.n_9)
print v(xbgr.mr_n60067872)
print v(xbgr.mr_n60523760)
print v(xbgr.mr_n60758928)
print v(xbgr.mr_n60847312)
print v(xbgr.mr_n60908496)
print v(xbgr.mr_n60947216)
print v(xbgr.mr_n61078064)
print v(xbgr.mr_n61173920)
print v(xbgr.mr_n61281504)
print v(xbgr.mr_n61387856)
print v(xbgr.mr_n61530624)
print v(xbgr.mr_n61633712)
print v(xbgr.mr_n61977024)
print v(xbgr.mr_n62102768)
print v(xbgr.mr_n62252464)
print v(xbgr.mr_n62381632)
print v(xbgr.mr_n62528752)
print v(xbgr.mr_n62731792)
print v(xbgr.mr_n62853376)
print v(xbgr.mr_n63035184)
print v(xbgr.mr_n60834736)
print v(xbgr.mr_n60103744)
print v(xbgr.mr_n60917808)
print v(xbgr.mr_n61029616)
print v(xbgr.mr_n61119200)
print v(xbgr.mr_n61226960)
print v(xbgr.mr_n61362128)
print v(xbgr.mr_n61520048)
print v(xbgr.mr_n61586144)
print v(xbgr.mr_n61970464)
print v(xbgr.mr_n62051360)
print v(xbgr.mr_n62186032)
print v(xbgr.mr_n62350192)
print v(xbgr.mr_n62480896)
print v(xbgr.mr_n62647648)
print v(xbgr.mr_n62791344)
print v(xbgr.mr_n63030320)
print v(xbgr.mr_n60208544)
print v(xbgr.mr_n59991024)
print v(xbgr.mr_n60524352)
print v(xbgr.mr_n60759520)
print v(xbgr.mr_n60870176)
print v(xbgr.mr_n60344336)
print v(xbgr.mr_n60982880)
print v(xbgr.mr_n61097648)
print v(xbgr.mr_n61202592)
print v(xbgr.mr_n61325264)
print v(xbgr.mr_n61427408)
print v(xbgr.mr_n61558768)
print v(xbgr.mr_n61657584)
print v(xbgr.mr_n61890112)
print v(xbgr.mr_n62016912)
print v(xbgr.mr_n62286144)
print v(xbgr.mr_n62415504)
print v(xbgr.mr_n62597504)
print v(xbgr.mr_n62729616)
print v(xbgr.mr_n62851200)
print v(xbgr.mr_n63021696)
print v(xbgr.mr_n60209088)
print v(xbgr.mr_n60061536)
print v(xbgr.mr_n60524944)
print v(xbgr.mr_n60760112)
print v(xbgr.mr_n60209632)
print v(xbgr.mr_n59988912)
print v(xbgr.mr_n60525536)
print v(xbgr.mr_n60760704)
print v(xbgr.mr_n60210176)
print v(xbgr.mr_n60204352)
print v(xbgr.mr_n60526128)
print v(xbgr.mr_n60761296)
print v(xbgr.mr_n60210720)
print v(xbgr.mr_n60066464)
print v(xbgr.mr_n60526720)
print v(xbgr.mr_n60761888)
print v(xbgr.mr_n60841664)
print v(xbgr.mr_n60061040)
print v(xbgr.mr_n60978496)
print v(xbgr.mr_n61094192)
print v(xbgr.mr_n61166736)
print v(xbgr.mr_n61293872)
print v(xbgr.mr_n61427920)
print v(xbgr.mr_n61527904)
print v(xbgr.mr_n61642832)
print v(xbgr.mr_n61976912)
print v(xbgr.mr_n62102656)
print v(xbgr.mr_n62266736)
print v(xbgr.mr_n62415328)
print v(xbgr.mr_n62594768)
print v(xbgr.mr_n62680112)
print v(xbgr.mr_n62841664)
print v(xbgr.mr_n62891616)
print v(xbgr.mr_n60850496)
print v(xbgr.mr_n60909760)
print v(xbgr.mr_n60950240)
print v(xbgr.mr_n61082528)
print v(xbgr.mr_n61169168)
print v(xbgr.mr_n61279664)
print v(xbgr.mr_n61386016)
print v(xbgr.mr_n61534704)
print v(xbgr.mr_n61627440)
print v(xbgr.mr_n61979344)
print v(xbgr.mr_n62104832)
print v(xbgr.mr_n62256256)
print v(xbgr.mr_n62385424)
print v(xbgr.mr_n62530592)
print v(xbgr.mr_n62733856)
print v(xbgr.mr_n62855440)
print v(xbgr.mr_n63037504)
print v(xbgr.mr_n60211264)
print v(xbgr.mr_n60062944)
print v(xbgr.mr_n60527312)
print v(xbgr.mr_n60747232)
print v(xbgr.mr_n60843904)
print v(xbgr.mr_n60034992)
print v(xbgr.mr_n60917344)
print v(xbgr.mr_n61031008)
print v(xbgr.mr_n61118736)
print v(xbgr.mr_n61229504)
print v(xbgr.mr_n61361664)
print v(xbgr.mr_n61517040)
print v(xbgr.mr_n61587536)
print v(xbgr.mr_n61970688)
print v(xbgr.mr_n62050768)
print v(xbgr.mr_n62185440)
print v(xbgr.mr_n62351968)
print v(xbgr.mr_n62480304)
print v(xbgr.mr_n62647376)
print v(xbgr.mr_n62793120)
print v(xbgr.mr_n63032976)
print v(xbgr.mr_n60212080)
print v(xbgr.mr_n59990320)
print v(xbgr.mr_n60527904)
print v(xbgr.mr_n60762992)
print v(xbgr.mr_n60870816)
print v(xbgr.mr_n60023056)
print v(xbgr.mr_n60984416)
print v(xbgr.mr_n61097392)
print v(xbgr.mr_n61203392)
print v(xbgr.mr_n61325536)
print v(xbgr.mr_n61429264)
print v(xbgr.mr_n61559408)
print v(xbgr.mr_n61658384)
print v(xbgr.mr_n61981040)
print v(xbgr.mr_n62098528)
print v(xbgr.mr_n62286944)
print v(xbgr.mr_n62416304)
print v(xbgr.mr_n62598704)
print v(xbgr.mr_n62731680)
print v(xbgr.mr_n62853264)
print v(xbgr.mr_n63035072)
print v(xbgr.mr_n60212352)
print v(xbgr.mr_n60081984)
print v(xbgr.n_3)
print v(xbgr.n_33)
print v(xbgr.mr_n60212896)
print v(xbgr.mr_n60057312)
print v(xbgr.mr_n60529088)
print v(xbgr.mr_n60764256)
print v(xbgr.mr_n60213504)
print v(xbgr.mr_n60001648)
print v(xbgr.mr_n60444848)
print v(xbgr.mr_n60310608)
print v(xbgr.mr_n60214896)
print v(xbgr.mr_n60143584)
print v(xbgr.mr_n60530272)
print v(xbgr.mr_n60765440)
print v(xbgr.mr_n60848176)
print v(xbgr.mr_n60648592)
print v(xbgr.mr_n60981168)
print v(xbgr.mr_n61099616)
print v(xbgr.mr_n61177792)
print v(xbgr.mr_n61294992)
print v(xbgr.mr_n61428032)
print v(xbgr.mr_n61516096)
print v(xbgr.mr_n61623760)
print v(xbgr.mr_n61815584)
print v(xbgr.mr_n61979456)
print v(xbgr.mr_n62104720)
print v(xbgr.mr_n62285968)
print v(xbgr.mr_n62413728)
print v(xbgr.mr_n62597168)
print v(xbgr.mr_n62721584)
print v(xbgr.mr_n62842832)
print v(xbgr.mr_n63035296)
print v(xbgr.mr_n60853072)
print v(xbgr.mr_n60907232)
print v(xbgr.mr_n60953264)
print v(xbgr.mr_n61086240)
print v(xbgr.mr_n61181216)
print v(xbgr.mr_n61275984)
print v(xbgr.mr_n61382336)
print v(xbgr.mr_n61537536)
print v(xbgr.mr_n61631568)
print v(xbgr.mr_n61853152)
print v(xbgr.mr_n61981664)
print v(xbgr.mr_n62106896)
print v(xbgr.mr_n62260048)
print v(xbgr.mr_n62389216)
print v(xbgr.mr_n62526912)
print v(xbgr.mr_n62735920)
print v(xbgr.mr_n62857504)
print v(xbgr.mr_n63039824)
print v(xbgr.mr_n60840496)
print v(xbgr.mr_n60894272)
print v(xbgr.mr_n60916880)
print v(xbgr.mr_n61031472)
print v(xbgr.mr_n61118272)
print v(xbgr.mr_n61231872)
print v(xbgr.mr_n61361200)
print v(xbgr.mr_n61526960)
print v(xbgr.mr_n61588928)
print v(xbgr.mr_n61850016)
print v(xbgr.mr_n61974816)
print v(xbgr.mr_n62050176)
print v(xbgr.mr_n62184848)
print v(xbgr.mr_n62353744)
print v(xbgr.mr_n62479712)
print v(xbgr.mr_n62647104)
print v(xbgr.mr_n62794896)
print v(xbgr.mr_n63030432)
print v(xbgr.mr_n60215360)
print v(xbgr.n_19)
print v(xbgr.mr_n60530864)
print v(xbgr.mr_n60766032)
print v(xbgr.mr_n60871616)
print v(xbgr.mr_n60103504)
print v(xbgr.mr_n60985792)
print v(xbgr.mr_n61099968)
print v(xbgr.mr_n60921760)
print v(xbgr.mr_n61326768)
print v(xbgr.mr_n61430640)
print v(xbgr.mr_n61560048)
print v(xbgr.mr_n61659184)
print v(xbgr.mr_n61856624)
print v(xbgr.mr_n61979232)
print v(xbgr.mr_n62104944)
print v(xbgr.mr_n62286768)
print v(xbgr.mr_n62417104)
print v(xbgr.mr_n62600528)
print v(xbgr.mr_n62733744)
print v(xbgr.mr_n62855328)
print v(xbgr.mr_n63037392)
print v(xbgr.mr_n60216288)
print v(xbgr.mr_n60141296)
print v(xbgr.mr_n60531456)
print v(xbgr.mr_n60766624)
print v(xbgr.mr_n60217216)
print v(xbgr.mr_n60203728)
print v(xbgr.mr_n60532048)
print v(xbgr.mr_n60767216)
print v(xbgr.mr_n60218608)
print v(xbgr.mr_n60000128)
print v(xbgr.mr_n60532640)
print v(xbgr.mr_n60767808)
print v(xbgr.mr_n60218144)
print v(xbgr.mr_n60205904)
print v(xbgr.mr_n60533232)
print v(xbgr.mr_n60768400)
print v(xbgr.mr_n60847424)
print v(xbgr.mr_n60672976)
print v(xbgr.mr_n60985184)
print v(xbgr.mr_n61058656)
print v(xbgr.mr_n61174032)
print v(xbgr.mr_n61296176)
print v(xbgr.mr_n61426176)
print v(xbgr.mr_n61523824)
print v(xbgr.mr_n61590320)
print v(xbgr.mr_n61853264)
print v(xbgr.mr_n61981552)
print v(xbgr.mr_n62100816)
print v(xbgr.mr_n62284368)
print v(xbgr.mr_n62391888)
print v(xbgr.mr_n62600032)
print v(xbgr.mr_n62733968)
print v(xbgr.mr_n62855552)
print v(xbgr.mr_n63032752)
print v(xbgr.mr_n60217680)
print v(xbgr.mr_n60100112)
print v(xbgr.mr_n60533824)
print v(xbgr.mr_n60768992)
print v(xbgr.mr_n60856256)
print v(xbgr.mr_n60905968)
print v(xbgr.mr_n60956288)
print v(xbgr.mr_n61084400)
print v(xbgr.mr_n61176464)
print v(xbgr.mr_n61274144)
print v(xbgr.mr_n61380496)
print v(xbgr.mr_n61541616)
print v(xbgr.mr_n61632400)
print v(xbgr.mr_n61857376)
print v(xbgr.mr_n61983984)
print v(xbgr.mr_n62108960)
print v(xbgr.mr_n62263840)
print v(xbgr.mr_n62393008)
print v(xbgr.mr_n62525072)
print v(xbgr.mr_n62737984)
print v(xbgr.mr_n62859568)
print v(xbgr.mr_n63042144)
print v(xbgr.mr_n60849664)
print v(xbgr.mr_n60894000)
print v(xbgr.mr_n60915696)
print v(xbgr.mr_n61030544)
print v(xbgr.mr_n61117344)
print v(xbgr.mr_n61234592)
print v(xbgr.mr_n61360272)
print v(xbgr.mr_n61530736)
print v(xbgr.mr_n61624096)
print v(xbgr.mr_n61799648)
print v(xbgr.mr_n61977136)
print v(xbgr.mr_n62048992)
print v(xbgr.mr_n62183664)
print v(xbgr.mr_n62355520)
print v(xbgr.mr_n62478528)
print v(xbgr.mr_n62646560)
print v(xbgr.mr_n62796672)
print v(xbgr.mr_n63039600)
print v(xbgr.mr_n60216752)
print v(xbgr.mr_n60136832)
print v(xbgr.mr_n60534416)
print v(xbgr.mr_n60769584)
print v(xbgr.mr_n60872736)
print v(xbgr.mr_n60618016)
print v(xbgr.mr_n60987248)
print v(xbgr.mr_n61101568)
print v(xbgr.mr_n61204592)
print v(xbgr.mr_n61327232)
print v(xbgr.mr_n61432496)
print v(xbgr.mr_n61561024)
print v(xbgr.mr_n61659984)
print v(xbgr.mr_n61859600)
print v(xbgr.mr_n61985680)
print v(xbgr.mr_n62094400)
print v(xbgr.mr_n62288544)
print v(xbgr.mr_n62416928)
print v(xbgr.mr_n62602592)
print v(xbgr.mr_n62735808)
print v(xbgr.mr_n62857392)
print v(xbgr.mr_n63039712)
print v(xbgr.mr_n60215824)
print v(xbgr.mr_n60206016)
print v(xbgr.mr_n60535008)
print v(xbgr.mr_n60770176)
print v(xbgr.mr_n60214432)
print v(xbgr.mr_n60068576)
print v(xbgr.n_4)
print v(xbgr.n_30)
print v(xbgr.mr_n60213968)
print v(xbgr.mr_n60032672)
print v(xbgr.mr_n60536192)
print v(xbgr.mr_n60762480)
print v(xbgr.mr_n60213168)
print v(xbgr.mr_n59991584)
print v(xbgr.mr_n60431440)
print v(xbgr.mr_n60703776)
print v(xbgr.mr_n60853936)
print v(xbgr.mr_n60914448)
print v(xbgr.mr_n60987952)
print v(xbgr.mr_n61102352)
print v(xbgr.mr_n61179616)
print v(xbgr.mr_n61297360)
print v(xbgr.mr_n61433088)
print v(xbgr.mr_n61538848)
print v(xbgr.mr_n61568960)
print v(xbgr.mr_n61796720)
print v(xbgr.mr_n61972752)
print v(xbgr.mr_n62107008)
print v(xbgr.mr_n62285168)
print v(xbgr.mr_n62402032)
print v(xbgr.mr_n62603680)
print v(xbgr.mr_n62725712)
print v(xbgr.mr_n62849136)
print v(xbgr.mr_n63039936)
print v(xbgr.mr_n60858832)
print v(xbgr.mr_n60903440)
print v(xbgr.mr_n60953376)
print v(xbgr.mr_n61080720)
print v(xbgr.mr_n60923824)
print v(xbgr.mr_n61270464)
print v(xbgr.mr_n61376816)
print v(xbgr.mr_n61544512)
print v(xbgr.mr_n61627328)
print v(xbgr.mr_n61860304)
print v(xbgr.mr_n61986304)
print v(xbgr.mr_n62111024)
print v(xbgr.mr_n62256960)
print v(xbgr.mr_n62396800)
print v(xbgr.mr_n62521392)
print v(xbgr.mr_n62740048)
print v(xbgr.mr_n62861632)
print v(xbgr.mr_n63044464)
print v(xbgr.mr_n60212624)
print v(xbgr.mr_n60090336)
print v(xbgr.mr_n60537376)
print v(xbgr.mr_n60772480)
print v(xbgr.mr_n60846256)
print v(xbgr.mr_n60893728)
print v(xbgr.mr_n60699792)
print v(xbgr.mr_n61030080)
print v(xbgr.mr_n61116880)
print v(xbgr.mr_n61241856)
print v(xbgr.mr_n61359808)
print v(xbgr.mr_n61534816)
print v(xbgr.mr_n61579088)
print v(xbgr.mr_n61815120)
print v(xbgr.mr_n61978480)
print v(xbgr.mr_n62048400)
print v(xbgr.mr_n62183072)
print v(xbgr.mr_n62357296)
print v(xbgr.mr_n62477936)
print v(xbgr.mr_n62646288)
print v(xbgr.mr_n62798448)
print v(xbgr.mr_n63037616)
print v(xbgr.mr_n60211808)
print v(xbgr.mr_n59991872)
print v(xbgr.mr_n60515312)
print v(xbgr.mr_n60754192)
print v(xbgr.mr_n60873376)
print v(xbgr.mr_n60615968)
print v(xbgr.mr_n60989440)
print v(xbgr.mr_n61102528)
print v(xbgr.mr_n61203792)
print v(xbgr.mr_n61327632)
print v(xbgr.mr_n61434432)
print v(xbgr.mr_n61561904)
print v(xbgr.mr_n61660544)
print v(xbgr.mr_n61857264)
print v(xbgr.mr_n61987920)
print v(xbgr.mr_n62098752)
print v(xbgr.mr_n62289344)
print v(xbgr.mr_n62418704)
print v(xbgr.mr_n62604272)
print v(xbgr.mr_n62737872)
print v(xbgr.mr_n62859456)
print v(xbgr.mr_n63042032)
print v(xbgr.mr_n60211536)
print v(xbgr.mr_n60142336)
print v(xbgr.mr_n60538560)
print v(xbgr.mr_n60773728)
print v(xbgr.mr_n60210992)
print v(xbgr.mr_n60092880)
print v(xbgr.mr_n60539152)
print v(xbgr.mr_n60774320)
print v(xbgr.mr_n60210448)
print v(xbgr.mr_n59991440)
print v(xbgr.mr_n60539744)
print v(xbgr.mr_n60774912)
print v(xbgr.mr_n60853184)
print v(xbgr.mr_n60673584)
print v(xbgr.mr_n60988064)
print v(xbgr.mr_n61098752)
print v(xbgr.mr_n61185088)
print v(xbgr.mr_n61298544)
print v(xbgr.mr_n61433760)
print v(xbgr.mr_n61537648)
print v(xbgr.mr_n61659808)
print v(xbgr.mr_n61850208)
print v(xbgr.mr_n61955840)
print v(xbgr.mr_n62102880)
print v(xbgr.mr_n62288368)
print v(xbgr.mr_n62417904)
print v(xbgr.mr_n62603856)
print v(xbgr.mr_n62738096)
print v(xbgr.mr_n62849360)
print v(xbgr.mr_n63042256)
print v(xbgr.mr_n60209904)
print v(xbgr.mr_n59988208)
print v(xbgr.mr_n60540336)
print v(xbgr.mr_n60775504)
print v(xbgr.mr_n60862016)
print v(xbgr.mr_n60902176)
print v(xbgr.mr_n60959056)
print v(xbgr.mr_n61079392)
print v(xbgr.mr_n60921648)
print v(xbgr.mr_n61268624)
print v(xbgr.mr_n61374976)
print v(xbgr.mr_n61548336)
print v(xbgr.mr_n61659008)
print v(xbgr.mr_n61657408)
print v(xbgr.mr_n61783648)
print v(xbgr.mr_n61988624)
print v(xbgr.mr_n62113088)
print v(xbgr.mr_n61964544)
print v(xbgr.mr_n62400592)
print v(xbgr.mr_n62519552)
print v(xbgr.mr_n62742112)
print v(xbgr.mr_n62863808)
print v(xbgr.mr_n63046784)
print v(xbgr.mr_n60855424)
print v(xbgr.mr_n60893456)
print v(xbgr.mr_n60716176)
print v(xbgr.mr_n61029152)
print v(xbgr.mr_n61115952)
print v(xbgr.mr_n61242624)
print v(xbgr.mr_n61358880)
print v(xbgr.mr_n61540784)
print v(xbgr.mr_n61814656)
print v(xbgr.mr_n61983872)
print v(xbgr.mr_n62047216)
print v(xbgr.mr_n62181888)
print v(xbgr.mr_n62340464)
print v(xbgr.mr_n62476752)
print v(xbgr.mr_n62645744)
print v(xbgr.mr_n62851424)
print v(xbgr.mr_n63032640)
print v(xbgr.mr_n60209360)
print v(xbgr.mr_n60039712)
print v(xbgr.mr_n60540928)
print v(xbgr.mr_n60776096)
print v(xbgr.mr_n60874016)
print v(xbgr.mr_n60744192)
print v(xbgr.mr_n60990896)
print v(xbgr.mr_n61104048)
print v(xbgr.mr_n61202992)
print v(xbgr.mr_n61328032)
print v(xbgr.mr_n61436688)
print v(xbgr.mr_n61562880)
print v(xbgr.mr_n61655808)
print v(xbgr.mr_n61850464)
print v(xbgr.mr_n61990320)
print v(xbgr.mr_n62100592)
print v(xbgr.mr_n62290144)
print v(xbgr.mr_n62419504)
print v(xbgr.mr_n62605536)
print v(xbgr.mr_n62739936)
print v(xbgr.mr_n62861520)
print v(xbgr.mr_n63041920)
print v(xbgr.mr_n60208816)
print v(xbgr.mr_n60125328)
print v(xbgr.mr_n60541520)
print v(xbgr.mr_n60776672)
print v(xbgr.mr_n60208272)
print v(xbgr.mr_n60087856)
print v(xbgr.mr_n60542112)
print v(xbgr.mr_n60777264)
print v(xbgr.mr_n60207728)
print v(xbgr.mr_n60240048)
print v(xbgr.n_5)
print v(xbgr.mr_n60777840)
print v(xbgr.mr_n60206912)
print v(xbgr.mr_n60240672)
print v(xbgr.mr_n60543296)
print v(xbgr.mr_n60778432)
print v(xbgr.mr_n60852240)
print v(xbgr.mr_n60743152)
print v(xbgr.mr_n60990560)
print v(xbgr.mr_n61101392)
print v(xbgr.mr_n61157728)
print v(xbgr.mr_n61299728)
print v(xbgr.mr_n61438048)
print v(xbgr.mr_n61536704)
print v(xbgr.mr_n61687520)
print v(xbgr.mr_n61857488)
print v(xbgr.mr_n61988736)
print v(xbgr.mr_n62112976)
print v(xbgr.mr_n62289168)
print v(xbgr.mr_n62416128)
print v(xbgr.mr_n62605104)
print v(xbgr.mr_n62729840)
print v(xbgr.mr_n62861744)
print v(xbgr.mr_n63044576)
print v(xbgr.mr_n60857888)
print v(xbgr.mr_n60899648)
print v(xbgr.mr_n60961712)
print v(xbgr.mr_n61076736)
print v(xbgr.mr_n61187088)
print v(xbgr.mr_n61265392)
print v(xbgr.mr_n61372000)
print v(xbgr.mr_n61543568)
print v(xbgr.mr_n61686320)
print v(xbgr.mr_n61691056)
print v(xbgr.mr_n61752496)
print v(xbgr.mr_n61990944)
print v(xbgr.mr_n62115152)
print v(xbgr.mr_n62268416)
print v(xbgr.mr_n62397216)
print v(xbgr.mr_n62515872)
print v(xbgr.mr_n62744176)
print v(xbgr.mr_n62866128)
print v(xbgr.mr_n63049104)
print v(xbgr.mr_n60206640)
print v(xbgr.mr_n60241376)
print v(xbgr.mr_n60543888)
print v(xbgr.mr_n60747408)
print v(xbgr.mr_n60856368)
print v(xbgr.mr_n60893184)
print v(xbgr.mr_n60697808)
print v(xbgr.mr_n61028688)
print v(xbgr.mr_n61115488)
print v(xbgr.mr_n61243552)
print v(xbgr.mr_n61358496)
print v(xbgr.mr_n61541728)
print v(xbgr.mr_n61814192)
print v(xbgr.mr_n61986416)
print v(xbgr.mr_n62046624)
print v(xbgr.mr_n62181296)
print v(xbgr.mr_n62360384)
print v(xbgr.mr_n62476160)
print v(xbgr.mr_n62645472)
print v(xbgr.mr_n62859680)
print v(xbgr.mr_n63030656)
print v(xbgr.mr_n60205360)
print v(xbgr.mr_n60241840)
print v(xbgr.mr_n60544480)
print v(xbgr.mr_n60764848)
print v(xbgr.mr_n60874816)
print v(xbgr.mr_n60805968)
print v(xbgr.mr_n60991776)
print v(xbgr.mr_n61104928)
print v(xbgr.mr_n61202192)
print v(xbgr.mr_n61328432)
print v(xbgr.mr_n61438544)
print v(xbgr.mr_n61564336)
print v(xbgr.mr_n61686752)
print v(xbgr.mr_n61750032)
print v(xbgr.mr_n61992640)
print v(xbgr.mr_n62110912)
print v(xbgr.mr_n62290944)
print v(xbgr.mr_n62420304)
print v(xbgr.mr_n62607760)
print v(xbgr.mr_n62717904)
print v(xbgr.mr_n62863696)
print v(xbgr.mr_n63046672)
print v(xbgr.mr_n60166688)
print v(xbgr.mr_n60369232)
print v(xbgr.mr_n60545072)
print v(xbgr.mr_n60780128)
print v(xbgr.mr_n60167152)
print v(xbgr.mr_n60373968)
print v(xbgr.mr_n60545664)
print v(xbgr.mr_n60742896)
print v(xbgr.mr_n60167616)
print v(xbgr.mr_n60370416)
print v(xbgr.mr_n60546256)
print v(xbgr.mr_n60472592)
print v(xbgr.mr_n60168080)
print v(xbgr.mr_n60365680)
print v(xbgr.mr_n60546848)
print v(xbgr.mr_n60748688)
print v(xbgr.mr_n60846480)
print v(xbgr.mr_n60230272)
print v(xbgr.mr_n60988688)
print v(xbgr.mr_n61096352)
print v(xbgr.mr_n61153264)
print v(xbgr.mr_n61300912)
print v(xbgr.mr_n61439904)
print v(xbgr.mr_n61529792)
print v(xbgr.mr_n61656608)
print v(xbgr.mr_n61850720)
print v(xbgr.mr_n61990832)
print v(xbgr.mr_n62115040)
print v(xbgr.mr_n62287744)
print v(xbgr.mr_n62392112)
print v(xbgr.mr_n62605280)
print v(xbgr.mr_n62718576)
print v(xbgr.mr_n62817152)
print v(xbgr.mr_n63034960)
print v(xbgr.mr_n60852128)
print v(xbgr.mr_n60898704)
print v(xbgr.mr_n60960384)
print v(xbgr.mr_n61075408)
print v(xbgr.mr_n60923024)
print v(xbgr.mr_n61264064)
print v(xbgr.mr_n61370672)
print v(xbgr.mr_n61536592)
print v(xbgr.mr_n61686960)
print v(xbgr.mr_n61700240)
print v(xbgr.mr_n61759376)
print v(xbgr.mr_n61993264)
print v(xbgr.mr_n62117216)
print v(xbgr.mr_n62266512)
print v(xbgr.mr_n62400704)
print v(xbgr.mr_n62514032)
print v(xbgr.mr_n62746240)
print v(xbgr.mr_n62868448)
print v(xbgr.mr_n63051424)
print v(xbgr.mr_n60850608)
print v(xbgr.mr_n60892992)
print v(xbgr.mr_n60669680)
print v(xbgr.mr_n61027760)
print v(xbgr.mr_n61114560)
print v(xbgr.mr_n61243088)
print v(xbgr.mr_n61357888)
print v(xbgr.mr_n61531936)
print v(xbgr.mr_n61813728)
print v(xbgr.mr_n61986192)
print v(xbgr.mr_n62045632)
print v(xbgr.mr_n62180304)
print v(xbgr.mr_n62360992)
print v(xbgr.mr_n62474976)
print v(xbgr.mr_n62644928)
print v(xbgr.mr_n62865904)
print v(xbgr.mr_n63044352)
print v(xbgr.mr_n60168544)
print v(xbgr.mr_n60371600)
print v(xbgr.mr_n60529680)
print v(xbgr.mr_n60698256)
print v(xbgr.mr_n60169008)
print v(xbgr.mr_n60372192)
print v(xbgr.mr_n60548032)
print v(xbgr.mr_n60698624)
print v(xbgr.mr_n60875616)
print v(xbgr.mr_n60063920)
print v(xbgr.mr_n60993648)
print v(xbgr.mr_n61103088)
print v(xbgr.mr_n61201392)
print v(xbgr.mr_n61328832)
print v(xbgr.mr_n61440320)
print v(xbgr.mr_n61564976)
print v(xbgr.mr_n61685760)
print v(xbgr.mr_n61860416)
print v(xbgr.mr_n61994960)
print v(xbgr.mr_n62106784)
print v(xbgr.mr_n62291744)
print v(xbgr.mr_n62421104)
print v(xbgr.mr_n62609280)
print v(xbgr.mr_n62744064)
print v(xbgr.mr_n62866016)
print v(xbgr.mr_n63048992)
print v(xbgr.mr_n60169472)
print v(xbgr.mr_n60358400)
print v(xbgr.mr_n60548624)
print v(xbgr.mr_n60744480)
print v(xbgr.mr_n60169936)
print v(xbgr.mr_n60373376)
print v(xbgr.mr_n60549216)
print v(xbgr.mr_n60757744)
print v(xbgr.mr_n60170400)
print v(xbgr.mr_n60369824)
print v(xbgr.mr_n60549808)
print v(xbgr.n_31)
print v(xbgr.mr_n60840720)
print v(xbgr.mr_n60067440)
print v(xbgr.mr_n60986816)
print v(xbgr.mr_n61095152)
print v(xbgr.mr_n61103616)
print v(xbgr.mr_n61302096)
print v(xbgr.mr_n61441584)
print v(xbgr.mr_n61525024)
print v(xbgr.mr_n61693056)
print v(xbgr.mr_n61753808)
print v(xbgr.mr_n61993152)
print v(xbgr.mr_n62117104)
print v(xbgr.mr_n62259152)
print v(xbgr.mr_n62417728)
print v(xbgr.mr_n62606352)
print v(xbgr.mr_n62742224)
print v(xbgr.mr_n62863584)
print v(xbgr.mr_n63046560)
print v(xbgr.mr_n60095136)
print v(xbgr.mr_n60343952)
print v(xbgr.mr_n60550400)
print v(xbgr.mr_n60746368)
print v(xbgr.mr_n60846368)
print v(xbgr.mr_n60897200)
print v(xbgr.mr_n60957728)
print v(xbgr.mr_n61072752)
print v(xbgr.mr_n61183648)
print v(xbgr.mr_n61261408)
print v(xbgr.mr_n61368016)
print v(xbgr.mr_n61529680)
print v(xbgr.mr_n61705968)
print v(xbgr.mr_n61692944)
print v(xbgr.mr_n61733392)
print v(xbgr.mr_n61995584)
print v(xbgr.mr_n62119280)
print v(xbgr.mr_n62266624)
print v(xbgr.mr_n62399472)
print v(xbgr.mr_n62510352)
print v(xbgr.mr_n62748304)
print v(xbgr.mr_n62870768)
print v(xbgr.mr_n63054128)
print v(xbgr.mr_n60844848)
print v(xbgr.mr_n60892880)
print v(xbgr.mr_n60659344)
print v(xbgr.mr_n61027296)
print v(xbgr.mr_n61114096)
print v(xbgr.mr_n61242160)
print v(xbgr.mr_n61357584)
print v(xbgr.mr_n61451376)
print v(xbgr.mr_n61813264)
print v(xbgr.mr_n61988512)
print v(xbgr.mr_n62045168)
print v(xbgr.mr_n62179840)
print v(xbgr.mr_n62360656)
print v(xbgr.mr_n62474384)
print v(xbgr.mr_n62644736)
print v(xbgr.mr_n62816560)
print v(xbgr.mr_n63044240)
print v(xbgr.mr_n60171328)
print v(xbgr.mr_n60340288)
print v(xbgr.mr_n60550992)
print v(xbgr.mr_n60651696)
print v(xbgr.mr_n60876656)
print v(xbgr.mr_n60315840)
print v(xbgr.mr_n60994688)
print v(xbgr.mr_n61100688)
print v(xbgr.mr_n61200592)
print v(xbgr.mr_n61329232)
print v(xbgr.mr_n61442256)
print v(xbgr.mr_n61565616)
print v(xbgr.mr_n61658208)
print v(xbgr.mr_n61860192)
print v(xbgr.mr_n61995696)
print v(xbgr.mr_n62111136)
print v(xbgr.mr_n62292544)
print v(xbgr.mr_n62421904)
print v(xbgr.mr_n62611024)
print v(xbgr.mr_n62746128)
print v(xbgr.mr_n62868336)
print v(xbgr.mr_n63051312)
print v(xbgr.mr_n60171792)
print v(xbgr.mr_n60375136)
print v(xbgr.mr_n60551584)
print v(xbgr.mr_n60652912)
print v(xbgr.mr_n60172256)
print v(xbgr.n_34)
print v(xbgr.mr_n60552176)
print v(xbgr.mr_n60780528)
print v(xbgr.mr_n60172720)
print v(xbgr.mr_n60377568)
print v(xbgr.mr_n60552768)
print v(xbgr.mr_n60781072)
print v(xbgr.mr_n60173184)
print v(xbgr.mr_n60353536)
print v(xbgr.mr_n60553360)
print v(xbgr.mr_n60771872)
print v(xbgr.mr_n60834960)
print v(xbgr.mr_n60021840)
print v(xbgr.mr_n60995120)
print v(xbgr.mr_n61094016)
print v(xbgr.mr_n61119664)
print v(xbgr.mr_n61303280)
print v(xbgr.mr_n61440912)
print v(xbgr.mr_n61518112)
print v(xbgr.mr_n61687360)
print v(xbgr.mr_n61755664)
print v(xbgr.mr_n61981776)
print v(xbgr.mr_n62108848)
print v(xbgr.mr_n62283568)
print v(xbgr.mr_n62275280)
print v(xbgr.mr_n62606128)
print v(xbgr.mr_n62742000)
print v(xbgr.mr_n62870544)
print v(xbgr.mr_n63048880)
print v(xbgr.mr_n60840608)
print v(xbgr.mr_n60896448)
print v(xbgr.mr_n60956400)
print v(xbgr.mr_n61071424)
print v(xbgr.mr_n61176352)
print v(xbgr.mr_n61258608)
print v(xbgr.mr_n61365216)
print v(xbgr.mr_n61522768)
print v(xbgr.mr_n61699280)
print v(xbgr.mr_n61700960)
print v(xbgr.mr_n61763632)
print v(xbgr.mr_n61743952)
print v(xbgr.mr_n62121344)
print v(xbgr.mr_n62260432)
print v(xbgr.mr_n62276784)
print v(xbgr.mr_n62508512)
print v(xbgr.mr_n62750368)
print v(xbgr.mr_n62873088)
print v(xbgr.mr_n63058560)
print v(xbgr.mr_n60173648)
print v(xbgr.mr_n60378672)
print v(xbgr.mr_n60553952)
print v(xbgr.mr_n60783360)
print v(xbgr.mr_n60839088)
print v(xbgr.mr_n60891872)
print v(xbgr.mr_n60669072)
print v(xbgr.mr_n61026368)
print v(xbgr.mr_n61113168)
print v(xbgr.mr_n61241968)
print v(xbgr.mr_n61321296)
print v(xbgr.mr_n61451184)
print v(xbgr.mr_n61812800)
print v(xbgr.mr_n61993376)
print v(xbgr.mr_n62044240)
print v(xbgr.mr_n62178912)
print v(xbgr.mr_n62360112)
print v(xbgr.mr_n62473264)
print v(xbgr.mr_n62641024)
print v(xbgr.mr_n62863920)
print v(xbgr.mr_n63037280)
print v(xbgr.mr_n60174112)
print v(xbgr.mr_n60351456)
print v(xbgr.mr_n60536784)
print v(xbgr.mr_n60779552)
print v(xbgr.mr_n60877616)
print v(xbgr.mr_n60050544)
print v(xbgr.mr_n60996720)
print v(xbgr.mr_n61098288)
print v(xbgr.mr_n61199792)
print v(xbgr.mr_n61329632)
print v(xbgr.mr_n61443712)
print v(xbgr.mr_n61566592)
print v(xbgr.mr_n61686560)
print v(xbgr.mr_n61727600)
print v(xbgr.mr_n61493648)
print v(xbgr.mr_n62117328)
print v(xbgr.mr_n62293344)
print v(xbgr.mr_n62422704)
print v(xbgr.mr_n62612768)
print v(xbgr.mr_n62748192)
print v(xbgr.mr_n62870656)
print v(xbgr.mr_n63053632)
print v(xbgr.mr_n60174576)
print v(xbgr.mr_n60379872)
print v(xbgr.mr_n60555136)
print v(xbgr.mr_n60784528)
print v(xbgr.mr_n60175040)
print v(xbgr.mr_n60375024)
print v(xbgr.mr_n60555728)
print v(xbgr.mr_n60785200)
print v(xbgr.mr_n60175504)
print v(xbgr.mr_n60381120)
print v(xbgr.mr_n60556320)
print v(xbgr.mr_n60785792)
print v(xbgr.mr_n60175968)
print v(xbgr.mr_n60381712)
print v(xbgr.n_10)
print v(xbgr.mr_n60771360)
print v(xbgr.mr_n60827776)
print v(xbgr.mr_n60107088)
print v(xbgr.mr_n60992432)
print v(xbgr.mr_n61066544)
print v(xbgr.mr_n61152496)
print v(xbgr.mr_n61304464)
print v(xbgr.mr_n61444224)
print v(xbgr.mr_n61451072)
print v(xbgr.mr_n61699168)
print v(xbgr.mr_n61758448)
print v(xbgr.mr_n61895776)
print v(xbgr.mr_n62119392)
print v(xbgr.mr_n62292368)
print v(xbgr.mr_n62418528)
print v(xbgr.mr_n62611616)
print v(xbgr.mr_n62744288)
print v(xbgr.mr_n62853488)
print v(xbgr.mr_n63049216)
print v(xbgr.mr_n60834848)
print v(xbgr.mr_n60895504)
print v(xbgr.mr_n60955200)
print v(xbgr.mr_n61068896)
print v(xbgr.mr_n61169056)
print v(xbgr.mr_n61258864)
print v(xbgr.mr_n61365472)
print v(xbgr.mr_n61515984)
print v(xbgr.mr_n61712912)
print v(xbgr.mr_n61594832)
print v(xbgr.mr_n61858656)
print v(xbgr.mr_n61739728)
print v(xbgr.mr_n62123408)
print v(xbgr.mr_n61746160)
print v(xbgr.mr_n62399696)
print v(xbgr.mr_n62505968)
print v(xbgr.mr_n62752432)
print v(xbgr.mr_n62875408)
print v(xbgr.mr_n63062992)
print v(xbgr.mr_n60827584)
print v(xbgr.mr_n60891696)
print v(xbgr.mr_n60710800)
print v(xbgr.mr_n61025904)
print v(xbgr.mr_n61112704)
print v(xbgr.mr_n61240528)
print v(xbgr.mr_n61321568)
print v(xbgr.mr_n61450016)
print v(xbgr.mr_n61812336)
print v(xbgr.mr_n61996288)
print v(xbgr.mr_n62043776)
print v(xbgr.mr_n62178448)
print v(xbgr.mr_n62354688)
print v(xbgr.mr_n62472800)
print v(xbgr.mr_n62642544)
print v(xbgr.mr_n62868224)
print v(xbgr.mr_n63054240)
print v(xbgr.mr_n60176432)
print v(xbgr.mr_n60374560)
print v(xbgr.mr_n60557504)
print v(xbgr.mr_n60786896)
print v(xbgr.mr_n60176896)
print v(xbgr.mr_n60345968)
print v(xbgr.mr_n60558096)
print v(xbgr.mr_n60787568)
print v(xbgr.mr_n60878176)
print v(xbgr.mr_n60614944)
print v(xbgr.mr_n60998176)
print v(xbgr.mr_n61095888)
print v(xbgr.mr_n61198992)
print v(xbgr.mr_n61330032)
print v(xbgr.mr_n61445488)
print v(xbgr.mr_n61567472)
print v(xbgr.mr_n61695712)
print v(xbgr.mr_n61749760)
print v(xbgr.mr_n61997632)
print v(xbgr.mr_n62119168)
print v(xbgr.mr_n62262944)
print v(xbgr.mr_n62423504)
print v(xbgr.mr_n62612432)
print v(xbgr.mr_n62727776)
print v(xbgr.mr_n62872976)
print v(xbgr.mr_n63058000)
print v(xbgr.mr_n60177360)
print v(xbgr.mr_n60383408)
print v(xbgr.mr_n60558688)
print v(xbgr.mr_n60788160)
print v(xbgr.mr_n60177824)
print v(xbgr.mr_n60378160)
print v(xbgr.mr_n60559280)
print v(xbgr.mr_n60773136)
print v(xbgr.mr_n60178288)
print v(xbgr.mr_n60384592)
print v(xbgr.mr_n60559872)
print v(xbgr.mr_n60789344)
print v(xbgr.mr_n60827200)
print v(xbgr.mr_n60674192)
print v(xbgr.mr_n60994512)
print v(xbgr.mr_n61039328)
print v(xbgr.mr_n61097216)
print v(xbgr.mr_n61305648)
print v(xbgr.mr_n61445072)
print v(xbgr.mr_n61450384)
print v(xbgr.mr_n61706480)
print v(xbgr.mr_n61850976)
print v(xbgr.mr_n61997520)
print v(xbgr.mr_n62121456)
print v(xbgr.mr_n62287568)
print v(xbgr.mr_n62420928)
print v(xbgr.mr_n62608944)
print v(xbgr.mr_n62731904)
print v(xbgr.mr_n62868560)
print v(xbgr.mr_n63058672)
print v(xbgr.mr_n60178752)
print v(xbgr.mr_n60385264)
print v(xbgr.mr_n60560464)
print v(xbgr.mr_n60789936)
print v(xbgr.mr_n60828864)
print v(xbgr.mr_n60895312)
print v(xbgr.mr_n60926688)
print v(xbgr.mr_n61068144)
print v(xbgr.mr_n61161760)
print v(xbgr.mr_n61261296)
print v(xbgr.mr_n61367904)
print v(xbgr.mr_n61505712)
print v(xbgr.mr_n61719488)
print v(xbgr.mr_n61719296)
print v(xbgr.mr_n61736160)
print v(xbgr.mr_n61999216)
print v(xbgr.mr_n62125472)
print v(xbgr.mr_n62260752)
print v(xbgr.mr_n62399584)
print v(xbgr.mr_n62505712)
print v(xbgr.mr_n62754496)
print v(xbgr.mr_n62877728)
print v(xbgr.mr_n63067424)
print v(xbgr.mr_n60797040)
print v(xbgr.mr_n60892352)
print v(xbgr.mr_n60043680)
print v(xbgr.mr_n61024976)
print v(xbgr.mr_n61101216)
print v(xbgr.mr_n61232896)
print v(xbgr.mr_n61244016)
print v(xbgr.mr_n61448272)
print v(xbgr.mr_n61801200)
print v(xbgr.mr_n61888192)
print v(xbgr.mr_n62020016)
print v(xbgr.mr_n62148800)
print v(xbgr.mr_n62358240)
print v(xbgr.mr_n62421728)
print v(xbgr.mr_n62643280)
print v(xbgr.mr_n62875184)
print v(xbgr.mr_n63051200)
print v(xbgr.mr_n60179216)
print v(xbgr.mr_n60385856)
print v(xbgr.mr_n60561056)
print v(xbgr.mr_n60790528)
print v(xbgr.mr_n60879136)
print v(xbgr.mr_n60049840)
print v(xbgr.mr_n60999632)
print v(xbgr.mr_n61093088)
print v(xbgr.mr_n61195808)
print v(xbgr.mr_n61330432)
print v(xbgr.mr_n61447424)
print v(xbgr.mr_n61568448)
print v(xbgr.mr_n61699808)
print v(xbgr.mr_n61801760)
print v(xbgr.mr_n61974592)
print v(xbgr.mr_n62123296)
print v(xbgr.mr_n62294944)
print v(xbgr.mr_n62424304)
print v(xbgr.mr_n62616112)
print v(xbgr.mr_n62752320)
print v(xbgr.mr_n62875296)
print v(xbgr.mr_n63062432)
print v(xbgr.mr_n60179680)
print v(xbgr.mr_n60346976)
print v(xbgr.mr_n60561648)
print v(xbgr.mr_n60786384)
print v(xbgr.mr_n60180144)
print v(xbgr.mr_n60379344)
print v(xbgr.mr_n60562240)
print v(xbgr.mr_n60791776)
print v(xbgr.mr_n60180608)
print v(xbgr.mr_n60387568)
print v(xbgr.mr_n60562832)
print v(xbgr.mr_n60781776)
print v(xbgr.mr_n60181072)
print v(xbgr.mr_n60388224)
print v(xbgr.mr_n60563424)
print v(xbgr.mr_n60792896)
print v(xbgr.mr_n60181536)
print v(xbgr.mr_n60388816)
print v(xbgr.mr_n60564016)
print v(xbgr.mr_n60748928)
print v(xbgr.mr_n60154160)
print v(xbgr.mr_n60389408)
print v(xbgr.mr_n60564608)
print v(xbgr.mr_n60794080)
print v(xbgr.mr_n60182464)
print v(xbgr.mr_n60382304)
print v(xbgr.mr_n60565200)
print v(xbgr.mr_n60794672)
print v(xbgr.mr_n60182928)
print v(xbgr.mr_n60390656)
print v(xbgr.mr_n60565792)
print v(xbgr.mr_n60795264)
print v(xbgr.mr_n61065216)
print v(xbgr.mr_n62616704)
print v(xbgr.mr_n62875520)
print v(xbgr.mr_n63046896)
print v(xbgr.mr_n60183328)
print v(xbgr.mr_n60380528)
print v(xbgr.mr_n60566384)
print v(xbgr.mr_n60795856)
print v(xbgr.d5)
print v(xbgr.d1)
print v(xbgr.mr_n61063296)
print v(xbgr.mr_n61446752)
print v(xbgr.mr_n60890560)
print v(xbgr.mr_n60997840)
print v(xbgr.mr_n61441760)
print v(xbgr.mr_n62607344)
print v(xbgr.n1)
print v(xbgr.mr_n63066752)
print v(xbgr.mr_n60183792)
print v(xbgr.mr_n60391712)
print v(xbgr.mr_n60566976)
print v(xbgr.mr_n60796448)
print v(xbgr.mr_n62422528)
print v(xbgr.mr_n62647920)
print v(xbgr.mr_n62891072)
print v(xbgr.mr_n60825904)
print v(xbgr.mr_n60912288)
print v(xbgr.kick)
print v(xbgr.mr_n61258352)
print v(xbgr.mr_n62613360)
print v(xbgr.mr_n62808272)
print v(xbgr.mr_n63066864)
print v(xbgr.mr_n60184256)
print v(xbgr.mr_n60392368)
print v(xbgr.mr_n60567568)
print v(xbgr.mr_n60797632)
print v(xbgr.mr_n60184720)
print v(xbgr.mr_n60390000)
print v(xbgr.mr_n60568160)
print v(xbgr.mr_n60798224)
print v(xbgr.mr_n60878704)
print v(xbgr.mr_n60947328)
print v(xbgr.mr_n61040272)
print v(xbgr.mr_n61446928)
print v(xbgr.mr_n62615696)
print v(xbgr.mr_n62847296)
print v(xbgr.mr_n63067536)
print v(xbgr.mr_n61568096)
print v(xbgr.mr_n61712800)
print v(xbgr.mr_n61782000)
print v(xbgr.mr_n61740960)
print v(xbgr.mr_n62109072)
print v(xbgr.mr_n62251568)
print v(xbgr.mr_n62384304)
print v(xbgr.mr_n61566416)
print v(xbgr.mr_n61690208)
print v(xbgr.mr_n61784288)
print v(xbgr.mr_n61757520)
print v(xbgr.mr_n62115264)
print v(xbgr.mr_n62262832)
print v(xbgr.mr_n62395792)
print v(xbgr.mr_n60185168)
print v(xbgr.mr_n60356080)
print v(xbgr.mr_n60568752)
print v(xbgr.mr_n60798816)
print v(xbgr.mr_n62617280)
print v(xbgr.mr_n62807680)
print v(xbgr.mr_n63062320)
print v(xbgr.mr_n61465408)
print v(xbgr.mr_n61551552)
print v(xbgr.mr_n61666064)
print v(xbgr.mr_n61804384)
print v(xbgr.mr_n62017328)
print v(xbgr.mr_n62146112)
print v(xbgr.mr_n62290768)
print v(xbgr.mr_n62435760)
print v(xbgr.mr_n62679520)
print v(xbgr.mr_n62894240)
print v(xbgr.mr_n60185632)
print v(xbgr.mr_n60394064)
print v(xbgr.mr_n60569344)
print v(xbgr.mr_n60799408)
print v(xbgr.mr_n62614960)
print v(xbgr.mr_n62808160)
print v(xbgr.mr_n63053520)
print v(xbgr.mr_n61065104)
print v(xbgr.mr_n61568272)
print v(xbgr.d2)
print v(xbgr.mr_n61773824)
print v(xbgr.mr_n61758016)
print v(xbgr.mr_n62051952)
print v(xbgr.mr_n62222192)
print v(xbgr.mr_n62356464)
print v(xbgr.mr_n60889248)
print v(xbgr.mr_n60997232)
print v(xbgr.mr_n61448160)
print v(xbgr.mr_n60186096)
print v(xbgr.mr_n60394736)
print v(xbgr.mr_n60569936)
print v(xbgr.mr_n60800000)
print v(xbgr.mr_n60890384)
print v(xbgr.mr_n60993232)
print v(xbgr.mr_n61448656)
print v(xbgr.mr_n62617904)
print v(xbgr.mr_n62857616)
print v(xbgr.mr_n63057888)
print v(xbgr.mr_n61063920)
print v(xbgr.mr_n60186560)
print v(xbgr.mr_n60395328)
print v(xbgr.mr_n60570528)
print v(xbgr.mr_n60801184)
print v(xbgr.mr_n60826448)
print v(xbgr.mr_n60911024)
print v(xbgr.mr_n61308640)
print v(xbgr.det)
print v(xbgr.mr_n62617392)
print v(xbgr.mr_n62808384)
print v(xbgr.mr_n63051536)
print v(xbgr.mr_n61042720)
print v(xbgr.mr_n60187024)
print v(xbgr.mr_n60395920)
print v(xbgr.mr_n60571120)
print v(xbgr.mr_n60791120)
print v(xbgr.mr_n62437536)
print v(xbgr.mr_n62678928)
print v(xbgr.mr_n62895328)
print v(xbgr.mr_n60879648)
print v(xbgr.mr_n60229328)
print v(xbgr.mr_n61448928)
print v(xbgr.mr_n62618128)
print v(xbgr.mr_n62809088)
print v(xbgr.mr_n63070208)
print v(xbgr.mr_n61564000)
print v(xbgr.mr_n61714656)
print v(xbgr.mr_n61783392)
print v(xbgr.mr_n61733504)
print v(xbgr.mr_n62121232)
print v(xbgr.mr_n62258928)
print v(xbgr.mr_n62392000)
print v(xbgr.mr_n61569072)
print v(xbgr.mr_n61712688)
print v(xbgr.mr_n61781888)
print v(xbgr.mr_n61739248)
print v(xbgr.mr_n62127648)
print v(xbgr.mr_n62263952)
print v(xbgr.mr_n62396912)
print v(xbgr.mr_n60187488)
print v(xbgr.mr_n60396512)
print v(xbgr.mr_n60571712)
print v(xbgr.mr_n60788752)
print v(xbgr.mr_n61464944)
print v(xbgr.mr_n61550688)
print v(xbgr.mr_n61673104)
print v(xbgr.mr_n61805200)
print v(xbgr.mr_n62021360)
print v(xbgr.mr_n62150144)
print v(xbgr.mr_n62295488)
print v(xbgr.mr_n62615520)
print v(xbgr.mr_n62880192)
print v(xbgr.mr_n63063104)
print v(xbgr.mr_n60187952)
print v(xbgr.mr_n60386976)
print v(xbgr.mr_n60554544)
print v(xbgr.mr_n60806896)
print v(xbgr.mr_n62618016)
print v(xbgr.mr_n62811232)
print v(xbgr.mr_n63071712)
print v(xbgr.mr_n60188416)
print v(xbgr.mr_n60397696)
print v(xbgr.mr_n60572896)
print v(xbgr.mr_n60807008)
print v(xbgr.mr_n60999120)
print v(xbgr.mr_n61569408)
print v(xbgr.mr_n61718544)
print v(xbgr.mr_n61773328)
print v(xbgr.mr_n61770816)
print v(xbgr.mr_n62128144)
print v(xbgr.mr_n62218048)
print v(xbgr.mr_n62353568)
print v(xbgr.mr_n60888592)
print v(xbgr.mr_n60995344)
print v(xbgr.mr_n61447936)
print v(xbgr.mr_n62439392)
print v(xbgr.mr_n62678336)
print v(xbgr.mr_n62896736)
print v(xbgr.mr_n60891040)
print v(xbgr.mr_n60990384)
print v(xbgr.mr_n61449392)
print v(xbgr.mr_n62619600)
print v(xbgr.mr_n62811824)
print v(xbgr.mr_n63074240)
print v(xbgr.mr_n60188880)
print v(xbgr.mr_n60398288)
print v(xbgr.mr_n60537968)
print v(xbgr.mr_n60807232)
print v(xbgr.mr_n61058288)
print v(xbgr.mr_n60826176)
print v(xbgr.mr_n60913552)
print v(xbgr.mr_n60997664)
print v(xbgr.mr_n61308176)
print v(xbgr.r4n)
print v(xbgr.mr_n60189344)
print v(xbgr.mr_n60384080)
print v(xbgr.mr_n60574080)
print v(xbgr.mr_n60807344)
print v(xbgr.mr_n62616816)
print v(xbgr.mr_n62881824)
print v(xbgr.mr_n62892160)
print v(xbgr.mr_n60872304)
print v(xbgr.mr_n60944304)
print v(xbgr.mr_n61449664)
print v(xbgr.mr_n61570032)
print v(xbgr.mr_n61713456)
print v(xbgr.mr_n61773216)
print v(xbgr.mr_n61735472)
print v(xbgr.mr_n62128032)
print v(xbgr.mr_n62255360)
print v(xbgr.mr_n62369200)
print v(xbgr.mr_n61569184)
print v(xbgr.mr_n61710608)
print v(xbgr.mr_n61780896)
print v(xbgr.mr_n61753456)
print v(xbgr.mr_n62128608)
print v(xbgr.mr_n62259040)
print v(xbgr.mr_n62393120)
print v(xbgr.mr_n60189808)
print v(xbgr.mr_n60393472)
print v(xbgr.mr_n60574672)
print v(xbgr.mr_n60807536)
print v(xbgr.mr_n62618352)
print v(xbgr.mr_n62813008)
print v(xbgr.mr_n63072672)
print v(xbgr.mr_n62441248)
print v(xbgr.mr_n62677744)
print v(xbgr.mr_n62898592)
print v(xbgr.mr_n61464480)
print v(xbgr.mr_n61550976)
print v(xbgr.mr_n61668368)
print v(xbgr.mr_n61806016)
print v(xbgr.mr_n62022176)
print v(xbgr.mr_n62150960)
print v(xbgr.mr_n62295904)
print v(xbgr.mr_n60190272)
print v(xbgr.mr_n60392960)
print v(xbgr.mr_n60575264)
print v(xbgr.mr_n60807808)
print v(xbgr.mr_n62619168)
print v(xbgr.mr_n62813600)
print v(xbgr.mr_n63075232)
print v(xbgr.mr_n60190736)
print v(xbgr.mr_n60400592)
print v(xbgr.mr_n60522576)
print v(xbgr.mr_n60808080)
print v(xbgr.mr_n61039600)
print v(xbgr.mr_n61571344)
print v(xbgr.mr_n61695984)
print v(xbgr.mr_n61784400)
print v(xbgr.mr_n61738896)
print v(xbgr.mr_n62127760)
print v(xbgr.mr_n62219232)
print v(xbgr.mr_n62351136)
print v(xbgr.mr_n62616928)
print v(xbgr.mr_n62881280)
print v(xbgr.mr_n63000208)
print v(xbgr.mr_n60887936)
print v(xbgr.mr_n60989952)
print v(xbgr.mr_n61448048)
print v(xbgr.mr_n60885792)
print v(xbgr.mr_n60995232)
print v(xbgr.mr_n61448544)
print v(xbgr.mr_n60191200)
print v(xbgr.mr_n60401248)
print v(xbgr.mr_n60576448)
print v(xbgr.mr_n60808624)
print v(xbgr.mr_n62620512)
print v(xbgr.mr_n62814784)
print v(xbgr.mr_n63076800)
print v(xbgr.mr_n61039056)
print v(xbgr.mr_n60825632)
print v(xbgr.mr_n60118336)
print v(xbgr.mr_n61307712)
print v(xbgr.mr_n60996144)
print v(xbgr.mr_n62443104)
print v(xbgr.mr_n62677152)
print v(xbgr.mr_n62900448)
print v(xbgr.mr_n60191664)
print v(xbgr.mr_n60398880)
print v(xbgr.mr_n60577040)
print v(xbgr.mr_n60808896)
print v(xbgr.mr_n61031936)
print v(xbgr.mr_n62619776)
print v(xbgr.mr_n62815376)
print v(xbgr.mr_n63077792)
print v(xbgr.mr_n60858944)
print v(xbgr.mr_n60946128)
print v(xbgr.mr_n61450720)
print v(xbgr.mr_n60192128)
print v(xbgr.mr_n60402352)
print v(xbgr.mr_n60577632)
print v(xbgr.mr_n60809168)
print v(xbgr.mr_n61571168)
print v(xbgr.mr_n61719680)
print v(xbgr.mr_n61785984)
print v(xbgr.mr_n61861856)
print v(xbgr.mr_n62129424)
print v(xbgr.mr_n62255136)
print v(xbgr.mr_n62388096)
print v(xbgr.mr_n61572064)
print v(xbgr.mr_n61720064)
print v(xbgr.mr_n61770704)
print v(xbgr.mr_n61863232)
print v(xbgr.mr_n62127536)
print v(xbgr.mr_n62260160)
print v(xbgr.mr_n62388208)
print v(xbgr.mr_n62621120)
print v(xbgr.mr_n62884000)
print v(xbgr.mr_n63077616)
print v(xbgr.mr_n60192592)
print v(xbgr.mr_n60391184)
print v(xbgr.mr_n60578224)
print v(xbgr.mr_n60809440)
print v(xbgr.mr_n61464016)
print v(xbgr.mr_n61591248)
print v(xbgr.mr_n61663024)
print v(xbgr.mr_n61806752)
print v(xbgr.mr_n62022992)
print v(xbgr.mr_n62151776)
print v(xbgr.mr_n62296720)
print v(xbgr.mr_n62621856)
print v(xbgr.mr_n62815968)
print v(xbgr.mr_n62981776)
print v(xbgr.mr_n60193056)
print v(xbgr.mr_n60403552)
print v(xbgr.mr_n60578816)
print v(xbgr.mr_n60809712)
print v(xbgr.mr_n62444960)
print v(xbgr.mr_n62676176)
print v(xbgr.mr_n62902336)
print v(xbgr.mr_n61570688)
print v(xbgr.mr_n61716320)
print v(xbgr.mr_n61770960)
print v(xbgr.mr_n61861968)
print v(xbgr.mr_n62129856)
print v(xbgr.mr_n62218640)
print v(xbgr.mr_n62355344)
print v(xbgr.mr_n62623632)
print v(xbgr.mr_n62814192)
print v(xbgr.mr_n63075056)
print v(xbgr.mr_n60887280)
print v(xbgr.mr_n60992208)
print v(xbgr.d3)
print v(xbgr.mr_n61446080)
print v(xbgr.mr_n60889728)
print v(xbgr.mr_n60993056)
print v(xbgr.mr_n61241008)
print v(xbgr.mr_n61446576)
print v(xbgr.mr_n60193520)
print v(xbgr.mr_n60399984)
print v(xbgr.mr_n60579408)
print v(xbgr.mr_n60809984)
print v(xbgr.mr_n60825360)
print v(xbgr.mr_n60119552)
print v(xbgr.mr_n61108064)
print v(xbgr.mr_n61306528)
print v(xbgr.mr_n62622464)
print v(xbgr.mr_n62886720)
print v(xbgr.mr_n63011776)
print v(xbgr.mr_n60193984)
print v(xbgr.mr_n60404736)
print v(xbgr.mr_n60580000)
print v(xbgr.mr_n60810256)
print v(xbgr.mr_n62623200)
print v(xbgr.mr_n62812416)
print v(xbgr.mr_n63072496)
print v(xbgr.mr_n60194448)
print v(xbgr.mr_n60405392)
print v(xbgr.mr_n60580592)
print v(xbgr.mr_n60810960)
print v(xbgr.mr_n60877440)
print v(xbgr.mr_n60941280)
print v(xbgr.mr_n61205088)
print v(xbgr.mr_n61444720)
print v(xbgr.mr_n61572752)
print v(xbgr.mr_n61690320)
print v(xbgr.mr_n61773600)
print v(xbgr.mr_n61738288)
print v(xbgr.mr_n61998384)
print v(xbgr.mr_n62128496)
print v(xbgr.mr_n62256368)
print v(xbgr.mr_n62380736)
print v(xbgr.mr_n61570144)
print v(xbgr.mr_n61719024)
print v(xbgr.mr_n61785360)
print v(xbgr.mr_n61775856)
print v(xbgr.mr_n62000640)
print v(xbgr.mr_n61734944)
print v(xbgr.mr_n62255248)
print v(xbgr.mr_n62384528)
print v(xbgr.mr_n62446816)
print v(xbgr.mr_n62675552)
print v(xbgr.mr_n62904704)
print v(xbgr.mr_n62620944)
print v(xbgr.mr_n62809776)
print v(xbgr.mr_n62987824)
print v(xbgr.mr_n60194912)
print v(xbgr.mr_n60405984)
print v(xbgr.mr_n60581184)
print v(xbgr.mr_n60811360)
print v(xbgr.mr_n61463552)
print v(xbgr.mr_n61590784)
print v(xbgr.mr_n61621280)
print v(xbgr.mr_n61806288)
print v(xbgr.mr_n61888544)
print v(xbgr.mr_n62023808)
print v(xbgr.mr_n62152592)
print v(xbgr.mr_n62297536)
print v(xbgr.mr_n60195376)
print v(xbgr.mr_n60406576)
print v(xbgr.mr_n60581776)
print v(xbgr.mr_n60811760)
print v(xbgr.mr_n62623808)
print v(xbgr.mr_n62885632)
print v(xbgr.mr_n62990992)
print v(xbgr.mr_n61571696)
print v(xbgr.mr_n61719872)
print v(xbgr.mr_n61786448)
print v(xbgr.mr_n61865776)
print v(xbgr.mr_n62000976)
print v(xbgr.mr_n62127424)
print v(xbgr.mr_n62219824)
print v(xbgr.mr_n62352912)
print v(xbgr.mr_n60886624)
print v(xbgr.mr_n60991600)
print v(xbgr.mr_n61238960)
print v(xbgr.mr_n61443376)
print v(xbgr.mr_n60889072)
print v(xbgr.mr_n60992320)
print v(xbgr.mr_n61239680)
print v(xbgr.mr_n61443200)
print v(xbgr.mr_n60182000)
print v(xbgr.mr_n60407168)
print v(xbgr.mr_n60582368)
print v(xbgr.mr_n60812160)
print v(xbgr.mr_n62624544)
print v(xbgr.mr_n62707968)
print v(xbgr.mr_n63018800)
print v(xbgr.mr_n62447744)
print v(xbgr.mr_n62675088)
print v(xbgr.mr_n62905888)
print v(xbgr.mr_n60196304)
print v(xbgr.mr_n60401840)
print v(xbgr.mr_n60547440)
print v(xbgr.mr_n60812960)
print v(xbgr.mr_n60825088)
print v(xbgr.mr_n60341376)
print v(xbgr.mr_n61107792)
print v(xbgr.mr_n61305344)
print v(xbgr.mr_n62626320)
print v(xbgr.mr_n62808816)
print v(xbgr.mr_n63017072)
print v(xbgr.mr_n60196768)
print v(xbgr.mr_n60408272)
print v(xbgr.mr_n60583552)
print v(xbgr.mr_n60813360)
print v(xbgr.mr_n60866096)
print v(xbgr.mr_n60943104)
print v(xbgr.mr_n61206048)
print v(xbgr.mr_n61444896)
print v(xbgr.mr_n62614208)
print v(xbgr.mr_n62889984)
print v(xbgr.mr_n63009344)
print v(xbgr.mr_n61574336)
print v(xbgr.mr_n61722128)
print v(xbgr.mr_n61778400)
print v(xbgr.mr_n61863744)
print v(xbgr.mr_n62000752)
print v(xbgr.mr_n61676048)
print v(xbgr.mr_n62251344)
print v(xbgr.mr_n62384416)
print v(xbgr.mr_n61575232)
print v(xbgr.mr_n61716992)
print v(xbgr.mr_n61771632)
print v(xbgr.mr_n61867712)
print v(xbgr.mr_n62001936)
print v(xbgr.mr_n61736544)
print v(xbgr.mr_n62251456)
print v(xbgr.mr_n62389328)
print v(xbgr.mr_n60197232)
print v(xbgr.mr_n60408944)
print v(xbgr.mr_n60584144)
print v(xbgr.mr_n60813760)
print v(xbgr.mr_n62625152)
print v(xbgr.mr_n62808048)
print v(xbgr.mr_n63009232)
print v(xbgr.mr_n61463088)
print v(xbgr.mr_n61589856)
print v(xbgr.mr_n61661104)
print v(xbgr.mr_n61805744)
print v(xbgr.mr_n61891008)
print v(xbgr.mr_n62024624)
print v(xbgr.mr_n62153408)
print v(xbgr.mr_n62298352)
print v(xbgr.mr_n62447280)
print v(xbgr.mr_n62674624)
print v(xbgr.mr_n62905296)
print v(xbgr.mr_n60197696)
print v(xbgr.mr_n60409536)
print v(xbgr.mr_n60584736)
print v(xbgr.mr_n60814160)
print v(xbgr.mr_n62627664)
print v(xbgr.mr_n62708160)
print v(xbgr.mr_n62983216)
print v(xbgr.mr_n61573856)
print v(xbgr.mr_n61717808)
print v(xbgr.mr_n61772528)
print v(xbgr.mr_n61864096)
print v(xbgr.mr_n62002832)
print v(xbgr.mr_n61734640)
print v(xbgr.mr_n62217456)
print v(xbgr.mr_n62348240)
print v(xbgr.mr_n60198160)
print v(xbgr.mr_n60410128)
print v(xbgr.mr_n60585328)
print v(xbgr.mr_n60784016)
print v(xbgr.mr_n60885968)
print v(xbgr.mr_n60985536)
print v(xbgr.mr_n61235376)
print v(xbgr.mr_n61441024)
print v(xbgr.mr_n60888416)
print v(xbgr.mr_n60987840)
print v(xbgr.mr_n61238464)
print v(xbgr.mr_n61443024)
print v(xbgr.mr_n62626496)
print v(xbgr.mr_n62890528)
print v(xbgr.mr_n63022352)
print v(xbgr.mr_n60198624)
print v(xbgr.mr_n60403024)
print v(xbgr.mr_n60585920)
print v(xbgr.mr_n60815360)
print v(xbgr.mr_n60824816)
print v(xbgr.mr_n60337664)
print v(xbgr.mr_n61107520)
print v(xbgr.mr_n61304160)
print v(xbgr.mr_n62624976)
print v(xbgr.mr_n62711936)
print v(xbgr.mr_n63008224)
print v(xbgr.mr_n60199088)
print v(xbgr.mr_n60386448)
print v(xbgr.mr_n60586512)
print v(xbgr.mr_n60815760)
print v(xbgr.mr_n62446352)
print v(xbgr.mr_n62674160)
print v(xbgr.mr_n62904112)
print v(xbgr.mr_n60874640)
print v(xbgr.mr_n60938256)
print v(xbgr.mr_n61205776)
print v(xbgr.mr_n61436032)
print v(xbgr.mr_n61575920)
print v(xbgr.mr_n61717696)
print v(xbgr.mr_n61772416)
print v(xbgr.mr_n61868880)
print v(xbgr.mr_n62001824)
print v(xbgr.mr_n62130416)
print v(xbgr.mr_n62243984)
print v(xbgr.mr_n62376944)
print v(xbgr.mr_n62629008)
print v(xbgr.mr_n62712832)
print v(xbgr.mr_n63078608)
print v(xbgr.mr_n61572864)
print v(xbgr.mr_n61718272)
print v(xbgr.mr_n61788560)
print v(xbgr.mr_n61870416)
print v(xbgr.mr_n62002720)
print v(xbgr.mr_n61735936)
print v(xbgr.mr_n62247776)
print v(xbgr.mr_n62385536)
print v(xbgr.mr_n60199552)
print v(xbgr.mr_n60397104)
print v(xbgr.mr_n60587104)
print v(xbgr.mr_n60793488)
print v(xbgr.mr_n61462624)
print v(xbgr.mr_n61589392)
print v(xbgr.mr_n61621840)
print v(xbgr.mr_n61805472)
print v(xbgr.mr_n61891824)
print v(xbgr.mr_n62025440)
print v(xbgr.mr_n62154224)
print v(xbgr.mr_n62299168)
print v(xbgr.mr_n60166224)
print v(xbgr.mr_n60412432)
print v(xbgr.mr_n60587696)
print v(xbgr.mr_n60816480)
print v(xbgr.mr_n62627840)
print v(xbgr.mr_n62889440)
print v(xbgr.mr_n63078832)
print v(xbgr.mr_n62628576)
print v(xbgr.mr_n62706720)
print v(xbgr.mr_n63080656)
print v(xbgr.mr_n60165760)
print v(xbgr.mr_n60413088)
print v(xbgr.mr_n60520800)
print v(xbgr.mr_n60816960)
print v(xbgr.mr_n61577680)
print v(xbgr.mr_n61716768)
print v(xbgr.mr_n61772064)
print v(xbgr.mr_n61868400)
print v(xbgr.mr_n62003904)
print v(xbgr.mr_n62132304)
print v(xbgr.mr_n62216864)
print v(xbgr.mr_n62347584)
print v(xbgr.mr_n60886448)
print v(xbgr.mr_n60988864)
print v(xbgr.mr_n61236416)
print v(xbgr.mr_n61434944)
print v(xbgr.mr_n60887760)
print v(xbgr.mr_n60982624)
print v(xbgr.mr_n61237136)
print v(xbgr.mr_n61439728)
print v(xbgr.mr_n62445888)
print v(xbgr.mr_n62673376)
print v(xbgr.mr_n62903520)
print v(xbgr.mr_n62622288)
print v(xbgr.mr_n62715616)
print v(xbgr.mr_n63078720)
print v(xbgr.mr_n60165296)
print v(xbgr.mr_n60413680)
print v(xbgr.mr_n60520208)
print v(xbgr.mr_n60800592)
print v(xbgr.mr_n60824544)
print v(xbgr.mr_n60340464)
print v(xbgr.mr_n61107248)
print v(xbgr.mr_n61302976)
print v(xbgr.mr_n60164832)
print v(xbgr.mr_n60414272)
print v(xbgr.mr_n60519616)
print v(xbgr.mr_n60818080)
print v(xbgr.mr_n62625888)
print v(xbgr.mr_n62888896)
print v(xbgr.mr_n63081264)
print v(xbgr.mr_n60875440)
print v(xbgr.mr_n60801664)
print v(xbgr.mr_n61206320)
print v(xbgr.mr_n61439056)
print v(xbgr.mr_n61574864)
print v(xbgr.mr_n61723664)
print v(xbgr.mr_n61789248)
print v(xbgr.mr_n61871296)
print v(xbgr.mr_n62004784)
print v(xbgr.mr_n62130960)
print v(xbgr.mr_n62247552)
print v(xbgr.mr_n62380512)
print v(xbgr.mr_n60164368)
print v(xbgr.mr_n60414864)
print v(xbgr.mr_n60519024)
print v(xbgr.mr_n60818560)
print v(xbgr.mr_n61578400)
print v(xbgr.mr_n61716880)
print v(xbgr.mr_n61771520)
print v(xbgr.mr_n61867024)
print v(xbgr.mr_n61997296)
print v(xbgr.mr_n62132192)
print v(xbgr.mr_n62252576)
print v(xbgr.mr_n62380624)
print v(xbgr.mr_n62629920)
print v(xbgr.mr_n62805312)
print v(xbgr.mr_n63087296)
print v(xbgr.mr_n62445424)
print v(xbgr.mr_n62672976)
print v(xbgr.mr_n62902928)
print v(xbgr.mr_n60163904)
print v(xbgr.mr_n60407760)
print v(xbgr.mr_n60518432)
print v(xbgr.mr_n60818960)
print v(xbgr.mr_n61462160)
print v(xbgr.mr_n61588464)
print v(xbgr.mr_n61620640)
print v(xbgr.mr_n61804928)
print v(xbgr.mr_n61892640)
print v(xbgr.mr_n62025168)
print v(xbgr.mr_n62153952)
print v(xbgr.mr_n62298896)
print v(xbgr.mr_n62629184)
print v(xbgr.mr_n62806496)
print v(xbgr.mr_n63086448)
print v(xbgr.mr_n60163440)
print v(xbgr.mr_n60399408)
print v(xbgr.mr_n60517840)
print v(xbgr.mr_n60311824)
print v(xbgr.mr_n61576032)
print v(xbgr.mr_n61718160)
print v(xbgr.mr_n61789680)
print v(xbgr.mr_n61874016)
print v(xbgr.mr_n62007568)
print v(xbgr.mr_n62134816)
print v(xbgr.mr_n62214496)
print v(xbgr.mr_n62351792)
print v(xbgr.mr_n60884000)
print v(xbgr.mr_n60985360)
print v(xbgr.mr_n61234416)
print v(xbgr.mr_n61435168)
print v(xbgr.mr_n62630528)
print v(xbgr.mr_n62886176)
print v(xbgr.mr_n63084880)
print v(xbgr.mr_n60885312)
print v(xbgr.mr_n60986640)
print v(xbgr.mr_n61235920)
print v(xbgr.mr_n61439168)
print v(xbgr.mr_n60162976)
print v(xbgr.mr_n60416576)
print v(xbgr.mr_n60515568)
print v(xbgr.mr_n60820160)
print v(xbgr.mr_n62627232)
print v(xbgr.mr_n62807088)
print v(xbgr.mr_n63081152)
print v(xbgr.mr_n60824272)
print v(xbgr.mr_n60346176)
print v(xbgr.mr_n61106976)
print v(xbgr.mr_n61301792)
print v(xbgr.mr_n60162512)
print v(xbgr.mr_n60411376)
print v(xbgr.mr_n60592640)
print v(xbgr.mr_n60607728)
print v(xbgr.mr_n62444496)
print v(xbgr.mr_n62672864)
print v(xbgr.mr_n62901840)
print v(xbgr.mr_n62631264)
print v(xbgr.mr_n62804720)
print v(xbgr.mr_n63089040)
print v(xbgr.mr_n60858000)
print v(xbgr.mr_n60935232)
print v(xbgr.mr_n61153008)
print v(xbgr.mr_n61437200)
print v(xbgr.mr_n60162048)
print v(xbgr.mr_n60410720)
print v(xbgr.mr_n60594080)
print v(xbgr.mr_n60590544)
print v(xbgr.mr_n61574512)
print v(xbgr.mr_n61724096)
print v(xbgr.mr_n61789984)
print v(xbgr.mr_n61871728)
print v(xbgr.mr_n62003248)
print v(xbgr.mr_n62134448)
print v(xbgr.mr_n62248784)
print v(xbgr.mr_n62359072)
print v(xbgr.mr_n61577504)
print v(xbgr.mr_n61725376)
print v(xbgr.mr_n61772880)
print v(xbgr.mr_n61873584)
print v(xbgr.mr_n62008608)
print v(xbgr.mr_n62137392)
print v(xbgr.mr_n62247664)
print v(xbgr.mr_n62381744)
print v(xbgr.mr_n62630352)
print v(xbgr.mr_n62887264)
print v(xbgr.mr_n63087472)
print v(xbgr.mr_n60161584)
print v(xbgr.mr_n60418416)
print v(xbgr.mr_n60594480)
print v(xbgr.mr_n60049568)
print v(xbgr.mr_n61461696)
print v(xbgr.mr_n61588000)
print v(xbgr.mr_n61620368)
print v(xbgr.mr_n61804656)
print v(xbgr.mr_n61893456)
print v(xbgr.mr_n62024896)
print v(xbgr.mr_n62153680)
print v(xbgr.mr_n62298624)
print v(xbgr.mr_n62631872)
print v(xbgr.mr_n62804128)
print v(xbgr.mr_n63084704)
print v(xbgr.mr_n60161120)
print v(xbgr.mr_n60419008)
print v(xbgr.mr_n60592048)
print v(xbgr.mr_n60129776)
print v(xbgr.mr_n62444032)
print v(xbgr.mr_n62563088)
print v(xbgr.mr_n62901376)
print v(xbgr.mr_n61575568)
print v(xbgr.mr_n61726592)
print v(xbgr.mr_n61792176)
print v(xbgr.mr_n61873040)
print v(xbgr.mr_n62002368)
print v(xbgr.mr_n62134032)
print v(xbgr.mr_n62213904)
print v(xbgr.mr_n62349360)
print v(xbgr.mr_n60881856)
print v(xbgr.mr_n60979536)
print v(xbgr.mr_n61227744)
print v(xbgr.mr_n61437312)
print v(xbgr.mr_n62634304)
print v(xbgr.mr_n62803536)
print v(xbgr.mr_n63082768)
print v(xbgr.mr_n60884656)
print v(xbgr.mr_n60986992)
print v(xbgr.mr_n61233872)
print v(xbgr.mr_n61437872)
print v(xbgr.mr_n60160656)
print v(xbgr.mr_n60419600)
print v(xbgr.mr_n60596400)
print v(xbgr.mr_n60512272)
print v(xbgr.mr_n60824000)
print v(xbgr.mr_n60124416)
print v(xbgr.mr_n61106704)
print v(xbgr.mr_n61300608)
print v(xbgr.mr_n60160192)
print v(xbgr.mr_n60420192)
print v(xbgr.mr_n60596800)
print v(xbgr.mr_n60089840)
print v(xbgr.mr_n62633216)
print v(xbgr.mr_n63090032)
print v(xbgr.mr_n60159728)
print v(xbgr.mr_n60404208)
print v(xbgr.mr_n60598000)
print v(xbgr.mr_n60092688)
print v(xbgr.mr_n62633872)
print v(xbgr.mr_n63094976)
print v(xbgr.mr_n60872480)
print v(xbgr.mr_n60937056)
print v(xbgr.mr_n61205200)
print v(xbgr.mr_n61435056)
print v(xbgr.mr_n61573360)
print v(xbgr.mr_n61724960)
print v(xbgr.mr_n61792992)
print v(xbgr.mr_n61876000)
print v(xbgr.mr_n62005904)
print v(xbgr.mr_n62138272)
print v(xbgr.mr_n62221600)
print v(xbgr.mr_n62376720)
print v(xbgr.mr_n61569296)
print v(xbgr.mr_n61726160)
print v(xbgr.mr_n61791392)
print v(xbgr.mr_n61869728)
print v(xbgr.mr_n62010608)
print v(xbgr.mr_n62132416)
print v(xbgr.mr_n62243760)
print v(xbgr.mr_n62376832)
print v(xbgr.mr_n62443568)
print v(xbgr.mr_n62900912)
print v(xbgr.mr_n60159264)
print v(xbgr.mr_n60421312)
print v(xbgr.mr_n60598400)
print v(xbgr.mr_n60572304)
print v(xbgr.mr_n62631696)
print v(xbgr.mr_n63094160)
print v(xbgr.mr_n61461232)
print v(xbgr.mr_n61587072)
print v(xbgr.mr_n61621008)
print v(xbgr.mr_n61804112)
print v(xbgr.mr_n61894000)
print v(xbgr.mr_n62024352)
print v(xbgr.mr_n62153136)
print v(xbgr.mr_n62298080)
print v(xbgr.mr_n60158800)
print v(xbgr.mr_n60417744)
print v(xbgr.mr_n60599600)
print v(xbgr.mr_n60475248)
print v(xbgr.mr_n62633040)
print v(xbgr.mr_n63092592)
print v(xbgr.mr_n61572400)
print v(xbgr.mr_n60924896)
print v(xbgr.mr_n61795136)
print v(xbgr.mr_n61878720)
print v(xbgr.mr_n62012208)
print v(xbgr.mr_n62135232)
print v(xbgr.mr_n62215088)
print v(xbgr.mr_n62350016)
print v(xbgr.mr_n60883344)
print v(xbgr.mr_n60979712)
print v(xbgr.mr_n61230288)
print v(xbgr.mr_n61422464)
print v(xbgr.mr_n60158336)
print v(xbgr.mr_n60422560)
print v(xbgr.mr_n60600400)
print v(xbgr.mr_n60512752)
print v(xbgr.mr_n60881376)
print v(xbgr.mr_n60984080)
print v(xbgr.mr_n61233376)
print v(xbgr.mr_n61435856)
print v(xbgr.mr_n62634480)
print v(xbgr.mr_n63089856)
print v(xbgr.mr_n62442640)
print v(xbgr.mr_n62899984)
print v(xbgr.mr_n60157872)
print v(xbgr.mr_n60417232)
print v(xbgr.mr_n60600800)
print v(xbgr.mr_n60602800)
print v(xbgr.mr_n60823728)
print v(xbgr.mr_n59989120)
print v(xbgr.mr_n61106432)
print v(xbgr.mr_n61299424)
print v(xbgr.mr_n62636992)
print v(xbgr.mr_n63096720)
print v(xbgr.mr_n60157408)
print v(xbgr.mr_n60411840)
print v(xbgr.mr_n60601600)
print v(xbgr.mr_n60090592)
print v(xbgr.mr_n60868640)
print v(xbgr.mr_n60932208)
print v(xbgr.mr_n61205504)
print v(xbgr.mr_n61431232)
print v(xbgr.mr_n61570256)
print v(xbgr.mr_n61662448)
print v(xbgr.mr_n61793728)
print v(xbgr.mr_n61878288)
print v(xbgr.mr_n62011776)
print v(xbgr.mr_n62140560)
print v(xbgr.mr_n62244992)
print v(xbgr.mr_n62361840)
print v(xbgr.mr_n62632608)
print v(xbgr.mr_n63095152)
print v(xbgr.mr_n61569680)
print v(xbgr.mr_n61676368)
print v(xbgr.mr_n61791744)
print v(xbgr.mr_n61879824)
print v(xbgr.mr_n62013312)
print v(xbgr.mr_n62142096)
print v(xbgr.mr_n62243872)
print v(xbgr.mr_n62373152)
print v(xbgr.mr_n60156944)
print v(xbgr.mr_n60424272)
print v(xbgr.mr_n60602400)
print v(xbgr.mr_n60478320)
print v(xbgr.mr_n62635824)
print v(xbgr.mr_n63092416)
print v(xbgr.mr_n61460768)
print v(xbgr.mr_n61586608)
print v(xbgr.mr_n61647344)
print v(xbgr.mr_n61803840)
print v(xbgr.mr_n61893728)
print v(xbgr.mr_n62024080)
print v(xbgr.mr_n62152864)
print v(xbgr.mr_n62297808)
print v(xbgr.mr_n60156480)
print v(xbgr.mr_n60424928)
print v(xbgr.mr_n60603600)
print v(xbgr.mr_n59992864)
print v(xbgr.mr_n62442176)
print v(xbgr.mr_n62899520)
print v(xbgr.mr_n62636560)
print v(xbgr.mr_n63099280)
print v(xbgr.mr_n60156016)
print v(xbgr.mr_n60382832)
print v(xbgr.mr_n60604000)
print v(xbgr.mr_n60512432)
print v(xbgr.mr_n61565440)
print v(xbgr.mr_n61683024)
print v(xbgr.mr_n61795920)
print v(xbgr.mr_n61875120)
print v(xbgr.mr_n62009488)
print v(xbgr.mr_n61738032)
print v(xbgr.mr_n62216272)
print v(xbgr.mr_n62344032)
print v(xbgr.mr_n60882688)
print v(xbgr.mr_n60983728)
print v(xbgr.mr_n61231328)
print v(xbgr.mr_n61433584)
print v(xbgr.mr_n60885136)
print v(xbgr.mr_n60983904)
print v(xbgr.mr_n61232048)
print v(xbgr.mr_n61431904)
print v(xbgr.mr_n62635648)
print v(xbgr.mr_n62885088)
print v(xbgr.mr_n63097712)
print v(xbgr.mr_n60155552)
print v(xbgr.mr_n60423152)
print v(xbgr.mr_n60604800)
print v(xbgr.mr_n60297088)
print v(xbgr.mr_n60823456)
print v(xbgr.mr_n60021296)
print v(xbgr.mr_n61106160)
print v(xbgr.mr_n61298240)
print v(xbgr.mr_n62637168)
print v(xbgr.mr_n62802944)
print v(xbgr.mr_n63091600)
print v(xbgr.mr_n60155088)
print v(xbgr.mr_n60426624)
print v(xbgr.mr_n60606000)
print v(xbgr.mr_n60299840)
print v(xbgr.mr_n62441712)
print v(xbgr.mr_n62562896)
print v(xbgr.mr_n62899056)
print v(xbgr.mr_n60814560)
print v(xbgr.mr_n60930816)
print v(xbgr.mr_n61205312)
print v(xbgr.mr_n61432080)
print v(xbgr.mr_n61562528)
print v(xbgr.mr_n61645888)
print v(xbgr.mr_n61793424)
print v(xbgr.mr_n61880704)
print v(xbgr.mr_n62014192)
print v(xbgr.mr_n62142976)
print v(xbgr.mr_n62231056)
print v(xbgr.mr_n62373040)
print v(xbgr.mr_n62637904)
print v(xbgr.mr_n62802352)
print v(xbgr.mr_n63101840)
print v(xbgr.mr_n61563824)
print v(xbgr.mr_n61717344)
print v(xbgr.mr_n61797456)
print v(xbgr.mr_n61876432)
print v(xbgr.mr_n62009920)
print v(xbgr.mr_n62138704)
print v(xbgr.mr_n62239968)
print v(xbgr.mr_n62377952)
print v(xbgr.mr_n60154624)
print v(xbgr.mr_n60427296)
print v(xbgr.mr_n60606400)
print v(xbgr.mr_n60297440)
print v(xbgr.mr_n61460304)
print v(xbgr.mr_n61585680)
print v(xbgr.mr_n61622896)
print v(xbgr.mr_n61803568)
print v(xbgr.mr_n61893184)
print v(xbgr.mr_n62023536)
print v(xbgr.mr_n62152320)
print v(xbgr.mr_n62297264)
print v(xbgr.mr_n60004576)
print v(xbgr.mr_n60415984)
print v(xbgr.mr_n60595680)
print v(xbgr.mr_n60354224)
print v(xbgr.mr_n62638512)
print v(xbgr.mr_n62884544)
print v(xbgr.mr_n63100272)
print v(xbgr.mr_n60153696)
print v(xbgr.mr_n60420784)
print v(xbgr.mr_n60608320)
print v(xbgr.mr_n60088688)
print v(xbgr.mr_n62635216)
print v(xbgr.mr_n62801760)
print v(xbgr.mr_n63105216)
print v(xbgr.mr_n61522880)
print v(xbgr.mr_n61670032)
print v(xbgr.mr_n61797152)
print v(xbgr.mr_n61881136)
print v(xbgr.mr_n62012624)
print v(xbgr.mr_n62141408)
print v(xbgr.mr_n62215680)
print v(xbgr.mr_n62346464)
print v(xbgr.mr_n60882032)
print v(xbgr.mr_n60978672)
print v(xbgr.mr_n61229328)
print v(xbgr.mr_n61431728)
print v(xbgr.mr_n60884480)
print v(xbgr.mr_n60982448)
print v(xbgr.mr_n61230832)
print v(xbgr.mr_n61430384)
print v(xbgr.mr_n62440784)
print v(xbgr.mr_n62583856)
print v(xbgr.mr_n62898128)
print v(xbgr.mr_n60153232)
print v(xbgr.mr_n60429008)
print v(xbgr.mr_n60610096)
print v(xbgr.mr_n60297952)
print v(xbgr.mr_n62639248)
print v(xbgr.mr_n62801168)
print v(xbgr.mr_n63104400)
print v(xbgr.mr_n60823184)
print v(xbgr.mr_n60018864)
print v(xbgr.mr_n61105888)
print v(xbgr.mr_n61297056)
print v(xbgr.mr_n60152768)
print v(xbgr.mr_n60429664)
print v(xbgr.mr_n60611280)
print v(xbgr.mr_n60472448)
print v(xbgr.mr_n62638336)
print v(xbgr.mr_n62883456)
print v(xbgr.mr_n63102832)
print v(xbgr.mr_n60870640)
print v(xbgr.mr_n60930704)
print v(xbgr.mr_n61204864)
print v(xbgr.mr_n61430032)
print v(xbgr.mr_n60152304)
print v(xbgr.mr_n60430256)
print v(xbgr.mr_n60611872)
print v(xbgr.mr_n60644864)
print v(xbgr.mr_n61566240)
print v(xbgr.mr_n61683216)
print v(xbgr.mr_n61790544)
print v(xbgr.mr_n61881824)
print v(xbgr.mr_n62016480)
print v(xbgr.mr_n62146800)
print v(xbgr.mr_n62241200)
print v(xbgr.mr_n62366848)
print v(xbgr.mr_n61567296)
print v(xbgr.mr_n61665104)
print v(xbgr.mr_n61795488)
print v(xbgr.mr_n61879136)
print v(xbgr.mr_n62018016)
print v(xbgr.mr_n62145264)
print v(xbgr.mr_n62240080)
print v(xbgr.mr_n62369424)
print v(xbgr.mr_n62640592)
print v(xbgr.mr_n62800224)
print v(xbgr.mr_n63100096)
print v(xbgr.mr_n62440320)
print v(xbgr.mr_n62561840)
print v(xbgr.mr_n62897664)
print v(xbgr.mr_n60151840)
print v(xbgr.mr_n60430848)
print v(xbgr.mr_n60613056)
print v(xbgr.mr_n60644272)
print v(xbgr.mr_n61459840)
print v(xbgr.mr_n61585216)
print v(xbgr.mr_n61603760)
print v(xbgr.mr_n61803296)
print v(xbgr.mr_n61892912)
print v(xbgr.mr_n62023264)
print v(xbgr.mr_n62152048)
print v(xbgr.mr_n62296992)
print v(xbgr.mr_n62642368)
print v(xbgr.mr_n62799392)
print v(xbgr.mr_n63102656)
print v(xbgr.mr_n60151376)
print v(xbgr.mr_n60423664)
print v(xbgr.mr_n60613648)
print v(xbgr.mr_n60643680)
print v(xbgr.mr_n61563392)
print v(xbgr.mr_n61667376)
print v(xbgr.mr_n61798080)
print v(xbgr.mr_n61884528)
print v(xbgr.mr_n62015936)
print v(xbgr.mr_n62140016)
print v(xbgr.mr_n62211104)
print v(xbgr.mr_n62345808)
print v(xbgr.mr_n60882512)
print v(xbgr.mr_n60977456)
print v(xbgr.mr_n61225264)
print v(xbgr.mr_n61430208)
print v(xbgr.mr_n60883824)
print v(xbgr.mr_n60980992)
print v(xbgr.mr_n61228784)
print v(xbgr.mr_n61423200)
print v(xbgr.mr_n62639680)
print v(xbgr.mr_n62880736)
print v(xbgr.mr_n63105392)
print v(xbgr.mr_n60150912)
print v(xbgr.mr_n60432096)
print v(xbgr.mr_n60612464)
print v(xbgr.mr_n60643088)
print v(xbgr.mr_n62641200)
print v(xbgr.mr_n62748416)
print v(xbgr.mr_n63106960)
print v(xbgr.mr_n60822912)
print v(xbgr.mr_n60345168)
print v(xbgr.mr_n61105696)
print v(xbgr.mr_n61295872)
print v(xbgr.mr_n60150448)
print v(xbgr.mr_n60421968)
print v(xbgr.mr_n60610688)
print v(xbgr.mr_n60642496)
print v(xbgr.mr_n62439856)
print v(xbgr.mr_n62573968)
print v(xbgr.mr_n62897200)
print v(xbgr.mr_n62614032)
print v(xbgr.mr_n62750256)
print v(xbgr.mr_n63109520)
print v(xbgr.mr_n60149984)
print v(xbgr.mr_n60433152)
print v(xbgr.mr_n60609504)
print v(xbgr.mr_n60641904)
print v(xbgr.mr_n60867504)
print v(xbgr.mr_n60931008)
print v(xbgr.mr_n61186112)
print v(xbgr.mr_n61428768)
print v(xbgr.mr_n61557616)
print v(xbgr.mr_n61666352)
print v(xbgr.mr_n61800464)
print v(xbgr.mr_n61883488)
print v(xbgr.mr_n62018896)
print v(xbgr.mr_n62147680)
print v(xbgr.mr_n62223968)
print v(xbgr.mr_n62369312)
print v(xbgr.mr_n61561728)
print v(xbgr.mr_n61664816)
print v(xbgr.mr_n61798864)
print v(xbgr.mr_n61886528)
print v(xbgr.mr_n62014624)
print v(xbgr.mr_n62143408)
print v(xbgr.mr_n62236176)
print v(xbgr.mr_n62374160)
print v(xbgr.mr_n60149520)
print v(xbgr.mr_n60433808)
print v(xbgr.mr_n60608912)
print v(xbgr.mr_n60641312)
print v(xbgr.mr_n62613856)
print v(xbgr.mr_n62882912)
print v(xbgr.mr_n63097536)
print v(xbgr.mr_n61459376)
print v(xbgr.mr_n61584288)
print v(xbgr.mr_n61672688)
print v(xbgr.mr_n61803024)
print v(xbgr.mr_n61892368)
print v(xbgr.mr_n62022720)
print v(xbgr.mr_n62151504)
print v(xbgr.mr_n62296448)
print v(xbgr.mr_n62608768)
print v(xbgr.mr_n62792288)
print v(xbgr.mr_n63112896)
print v(xbgr.mr_n60149056)
print v(xbgr.mr_n60434400)
print v(xbgr.mr_n60607200)
print v(xbgr.mr_n60640720)
print v(xbgr.mr_n62438928)
print v(xbgr.mr_n62587360)
print v(xbgr.mr_n62896272)
print v(xbgr.mr_n61562704)
print v(xbgr.mr_n61669680)
print v(xbgr.mr_n61800048)
print v(xbgr.mr_n61885840)
print v(xbgr.mr_n62018544)
print v(xbgr.mr_n62147328)
print v(xbgr.mr_n62211440)
print v(xbgr.mr_n62344688)
print v(xbgr.mr_n60880448)
print v(xbgr.mr_n60979360)
print v(xbgr.mr_n61226784)
print v(xbgr.mr_n61428592)
print v(xbgr.mr_n60883168)
print v(xbgr.mr_n60964944)
print v(xbgr.mr_n61228288)
print v(xbgr.mr_n61426064)
print v(xbgr.mr_n62610432)
print v(xbgr.mr_n62800048)
print v(xbgr.mr_n63112080)
print v(xbgr.mr_n60148592)
print v(xbgr.mr_n60434992)
print v(xbgr.mr_n60606800)
print v(xbgr.mr_n60640128)
print v(xbgr.mr_n60822640)
print v(xbgr.mr_n60894544)
print v(xbgr.mr_n61105584)
print v(xbgr.mr_n61294688)
print v(xbgr.mr_n60148128)
print v(xbgr.mr_n60435584)
print v(xbgr.mr_n60605600)
print v(xbgr.mr_n60639536)
print v(xbgr.mr_n62610608)
print v(xbgr.mr_n62882368)
print v(xbgr.mr_n63107776)
print v(xbgr.mr_n60147664)
print v(xbgr.mr_n60415456)
print v(xbgr.mr_n60590080)
print v(xbgr.mr_n60638944)
print v(xbgr.mr_n62611728)
print v(xbgr.mr_n62797616)
print v(xbgr.mr_n63110512)
print v(xbgr.mr_n60857776)
print v(xbgr.mr_n60926512)
print v(xbgr.mr_n61204976)
print v(xbgr.mr_n61426912)
print v(xbgr.mr_n61560672)
print v(xbgr.mr_n61725744)
print v(xbgr.mr_n61794288)
print v(xbgr.mr_n61877664)
print v(xbgr.mr_n62015312)
print v(xbgr.mr_n62144096)
print v(xbgr.mr_n62237408)
print v(xbgr.mr_n62361648)
print v(xbgr.mr_n61555104)
print v(xbgr.mr_n61664304)
print v(xbgr.mr_n61798432)
print v(xbgr.mr_n61883840)
print v(xbgr.mr_n62013840)
print v(xbgr.mr_n62140992)
print v(xbgr.mr_n62236288)
print v(xbgr.mr_n62370368)
print v(xbgr.mr_n62438464)
print v(xbgr.mr_n62580032)
print v(xbgr.mr_n62895872)
print v(xbgr.mr_n60147200)
print v(xbgr.mr_n60436688)
print v(xbgr.mr_n60604400)
print v(xbgr.mr_n60638352)
print v(xbgr.mr_n62609872)
print v(xbgr.mr_n62798272)
print v(xbgr.mr_n63114640)
print v(xbgr.mr_n61458912)
print v(xbgr.mr_n61583824)
print v(xbgr.mr_n61666928)
print v(xbgr.mr_n61802752)
print v(xbgr.mr_n61892096)
print v(xbgr.mr_n62022448)
print v(xbgr.mr_n62151232)
print v(xbgr.mr_n62296176)
print v(xbgr.mr_n60146736)
print v(xbgr.mr_n60437360)
print v(xbgr.mr_n60603200)
print v(xbgr.mr_n60637760)
print v(xbgr.mr_n62608272)
print v(xbgr.mr_n62879104)
print v(xbgr.mr_n63113072)
print v(xbgr.mr_n61560848)
print v(xbgr.mr_n61668992)
print v(xbgr.mr_n61796304)
print v(xbgr.mr_n61885408)
print v(xbgr.mr_n62007920)
print v(xbgr.mr_n62142624)
print v(xbgr.mr_n62144720)
print v(xbgr.mr_n62293968)
print v(xbgr.mr_n60146272)
print v(xbgr.mr_n60437952)
print v(xbgr.mr_n60592304)
print v(xbgr.mr_n60637168)
print v(xbgr.mr_n60879984)
print v(xbgr.mr_n60966784)
print v(xbgr.mr_n61206592)
print v(xbgr.mr_n61420608)
print v(xbgr.mr_n60880912)
print v(xbgr.mr_n60940080)
print v(xbgr.mr_n61226240)
print v(xbgr.mr_n61426736)
print v(xbgr.mr_n62599856)
print v(xbgr.mr_n62795840)
print v(xbgr.mr_n63110336)
print v(xbgr.mr_n60145808)
print v(xbgr.mr_n60428416)
print v(xbgr.mr_n60602000)
print v(xbgr.mr_n60636576)
print v(xbgr.mr_n62438000)
print v(xbgr.mr_n62581024)
print v(xbgr.mr_n62895600)
print v(xbgr.mr_n60822368)
print v(xbgr.mr_n60894736)
print v(xbgr.mr_n61105472)
print v(xbgr.mr_n61293568)
print v(xbgr.mr_n62601152)
print v(xbgr.mr_n62796496)
print v(xbgr.mr_n63117200)
print v(xbgr.mr_n60145344)
print v(xbgr.mr_n60439136)
print v(xbgr.mr_n60601200)
print v(xbgr.mr_n60635984)
print v(xbgr.mr_n60869440)
print v(xbgr.mr_n60918272)
print v(xbgr.mr_n61186000)
print v(xbgr.mr_n61424880)
print v(xbgr.mr_n61558592)
print v(xbgr.mr_n61724400)
print v(xbgr.mr_n61792576)
print v(xbgr.mr_n61882448)
print v(xbgr.mr_n62005216)
print v(xbgr.mr_n62139392)
print v(xbgr.mr_n62232384)
print v(xbgr.mr_n62358896)
print v(xbgr.mr_n61556576)
print v(xbgr.mr_n61716432)
print v(xbgr.mr_n61794704)
print v(xbgr.mr_n61887696)
print v(xbgr.mr_n62006448)
print v(xbgr.mr_n62137920)
print v(xbgr.mr_n62232496)
print v(xbgr.mr_n62366624)
print v(xbgr.mr_n62602256)
print v(xbgr.mr_n62879648)
print v(xbgr.mr_n63115632)
print v(xbgr.mr_n60144880)
print v(xbgr.mr_n60439728)
print v(xbgr.mr_n60600000)
print v(xbgr.mr_n60635392)
print v(xbgr.mr_n62606240)
print v(xbgr.mr_n62794064)
print v(xbgr.mr_n63107952)
print v(xbgr.mr_n61458448)
print v(xbgr.mr_n61582896)
print v(xbgr.mr_n61673888)
print v(xbgr.mr_n61802480)
print v(xbgr.mr_n61891552)
print v(xbgr.mr_n62021904)
print v(xbgr.mr_n62150688)
print v(xbgr.mr_n62295712)
print v(xbgr.mr_n60142768)
print v(xbgr.mr_n60425520)
print v(xbgr.mr_n60599200)
print v(xbgr.mr_n60634800)
print v(xbgr.mr_n62437072)
print v(xbgr.mr_n62582064)
print v(xbgr.mr_n62895056)
print v(xbgr.mr_n62601040)
print v(xbgr.mr_n62794720)
print v(xbgr.mr_n63119760)
print v(xbgr.mr_n60011600)
print v(xbgr.mr_n60372784)
print v(xbgr.mr_n60598800)
print v(xbgr.mr_n60634208)
print v(xbgr.mr_n61558416)
print v(xbgr.mr_n61723312)
print v(xbgr.mr_n61771408)
print v(xbgr.mr_n61884992)
print v(xbgr.mr_n62009136)
print v(xbgr.mr_n62132528)
print v(xbgr.mr_n62213312)
print v(xbgr.mr_n62342912)
print v(xbgr.mr_n60880800)
print v(xbgr.mr_n60949152)
print v(xbgr.mr_n61222656)
print v(xbgr.mr_n61424320)
print v(xbgr.mr_n60880336)
print v(xbgr.mr_n60975712)
print v(xbgr.mr_n61225744)
print v(xbgr.mr_n61425056)
print v(xbgr.mr_n60011136)
print v(xbgr.mr_n60365088)
print v(xbgr.mr_n60597600)
print v(xbgr.mr_n60633616)
print v(xbgr.mr_n62603184)
print v(xbgr.mr_n62877504)
print v(xbgr.mr_n63118192)
print v(xbgr.mr_n60822096)
print v(xbgr.mr_n59995712)
print v(xbgr.mr_n61105360)
print v(xbgr.mr_n61292768)
print v(xbgr.mr_n60010672)
print v(xbgr.mr_n60367456)
print v(xbgr.mr_n60597200)
print v(xbgr.mr_n60633024)
print v(xbgr.mr_n62591184)
print v(xbgr.mr_n62754608)
print v(xbgr.mr_n63115456)
print v(xbgr.mr_n62436608)
print v(xbgr.mr_n62576320)
print v(xbgr.mr_n62894784)
print v(xbgr.mr_n60867680)
print v(xbgr.mr_n60927024)
print v(xbgr.mr_n61204192)
print v(xbgr.mr_n61423024)
print v(xbgr.mr_n61559872)
print v(xbgr.mr_n61721024)
print v(xbgr.mr_n61788896)
print v(xbgr.mr_n61874432)
print v(xbgr.mr_n62001712)
print v(xbgr.mr_n62133392)
print v(xbgr.mr_n62223376)
print v(xbgr.mr_n62362416)
print v(xbgr.mr_n60010208)
print v(xbgr.mr_n60363840)
print v(xbgr.mr_n60596000)
print v(xbgr.mr_n60632432)
print v(xbgr.mr_n61544624)
print v(xbgr.mr_n61716544)
print v(xbgr.mr_n61790960)
print v(xbgr.mr_n61882992)
print v(xbgr.mr_n62007072)
print v(xbgr.mr_n62133120)
print v(xbgr.mr_n62232032)
print v(xbgr.mr_n62366736)
print v(xbgr.mr_n62598528)
print v(xbgr.mr_n62792944)
print v(xbgr.mr_n63118016)
print v(xbgr.mr_n60009744)
print v(xbgr.mr_n60366208)
print v(xbgr.mr_n60595280)
print v(xbgr.mr_n60631840)
print v(xbgr.mr_n61457984)
print v(xbgr.mr_n61582432)
print v(xbgr.mr_n61668624)
print v(xbgr.mr_n61802288)
print v(xbgr.mr_n61891280)
print v(xbgr.mr_n62021632)
print v(xbgr.mr_n62150416)
print v(xbgr.mr_n62295600)
print v(xbgr.mr_n62598352)
print v(xbgr.mr_n62870880)
print v(xbgr.mr_n63120752)
print v(xbgr.mr_n60009280)
print v(xbgr.mr_n60361536)
print v(xbgr.mr_n60594880)
print v(xbgr.mr_n60631248)
print v(xbgr.mr_n62601264)
print v(xbgr.mr_n62790512)
print v(xbgr.mr_n63125696)
print v(xbgr.mr_n61556400)
print v(xbgr.mr_n61716656)
print v(xbgr.mr_n61771072)
print v(xbgr.d4)
print v(xbgr.mr_n62004368)
print v(xbgr.mr_n62132080)
print v(xbgr.mr_n62149424)
print v(xbgr.mr_n62340976)
print v(xbgr.mr_n60879872)
print v(xbgr.mr_n60952176)
print v(xbgr.mr_n61223696)
print v(xbgr.mr_n61389696)
print v(xbgr.mr_n60881264)
print v(xbgr.mr_n60930176)
print v(xbgr.mr_n61224416)
print v(xbgr.mr_n61421344)
print v(xbgr.mr_n62436144)
print v(xbgr.mr_n62574816)
print v(xbgr.mr_n62894512)
print v(xbgr.mr_n60008816)
print v(xbgr.mr_n60359760)
print v(xbgr.mr_n60593680)
print v(xbgr.mr_n60630736)
print v(xbgr.mr_n62599296)
print v(xbgr.mr_n62791168)
print v(xbgr.mr_n63124880)
print v(xbgr.mr_n60816160)
print v(xbgr.mr_n60891216)
print v(xbgr.mr_n61066816)
print v(xbgr.mr_n61291968)
print v(xbgr.mr_n60008352)
print v(xbgr.mr_n60368048)
print v(xbgr.mr_n60593280)
print v(xbgr.mr_n60629216)
print v(xbgr.mr_n62595952)
print v(xbgr.mr_n62877840)
print v(xbgr.mr_n63120576)
print v(xbgr.mr_n60852016)
print v(xbgr.mr_n60115968)
print v(xbgr.mr_n61165024)
print v(xbgr.mr_n61420496)
print v(xbgr.mr_n60007888)
print v(xbgr.mr_n60363312)
print v(xbgr.mr_n60478736)
print v(xbgr.mr_n60821760)
print v(xbgr.mr_n61555968)
print v(xbgr.mr_n61700752)
print v(xbgr.mr_n61786640)
print v(xbgr.mr_n61877120)
print v(xbgr.mr_n62001360)
print v(xbgr.mr_n61734752)
print v(xbgr.mr_n62221008)
print v(xbgr.mr_n62362032)
print v(xbgr.mr_n61555280)
print v(xbgr.mr_n61710848)
print v(xbgr.mr_n61771184)
print v(xbgr.mr_n61866592)
print v(xbgr.mr_n62001248)
print v(xbgr.mr_n61735248)
print v(xbgr.mr_n62233616)
print v(xbgr.mr_n62367472)
print v(xbgr.mr_n62596064)
print v(xbgr.mr_n62788800)
print v(xbgr.mr_n63123312)
print v(xbgr.mr_n60007424)
print v(xbgr.mr_n60357456)
print v(xbgr.mr_n60479392)
print v(xbgr.mr_n60821360)
print v(xbgr.mr_n62435456)
print v(xbgr.mr_n62584560)
print v(xbgr.mr_n62893968)
print v(xbgr.mr_n61457520)
print v(xbgr.mr_n61581504)
print v(xbgr.mr_n61670640)
print v(xbgr.mr_n61802176)
print v(xbgr.mr_n61890736)
print v(xbgr.mr_n62021168)
print v(xbgr.mr_n62149952)
print v(xbgr.mr_n62295376)
print v(xbgr.mr_n62591536)
print v(xbgr.mr_n62789392)
print v(xbgr.mr_n63127440)
print v(xbgr.mr_n60006960)
print v(xbgr.mr_n60356944)
print v(xbgr.mr_n60477552)
print v(xbgr.mr_n60820960)
print v(xbgr.mr_n61543680)
print v(xbgr.mr_n61705376)
print v(xbgr.mr_n61771296)
print v(xbgr.mr_n61875584)
print v(xbgr.mr_n61999328)
print v(xbgr.mr_n61618512)
print v(xbgr.mr_n62210928)
print v(xbgr.mr_n62293168)
print v(xbgr.mr_n60873840)
print v(xbgr.mr_n61221696)
print v(xbgr.mr_n61418640)
print v(xbgr.mr_n60876304)
print v(xbgr.mr_n61223200)
print v(xbgr.mr_n61364768)
print v(xbgr.mr_n62594944)
print v(xbgr.mr_n62877616)
print v(xbgr.mr_n63123136)
print v(xbgr.mr_n60004848)
print v(xbgr.mr_n60364496)
print v(xbgr.mr_n60475776)
print v(xbgr.mr_n60820560)
print v(xbgr.mr_n60698064)
print v(xbgr.mr_n60677168)
print v(xbgr.mr_n62419328)
print v(xbgr.mr_n62787408)
print v(xbgr.mr_n63125872)
print v(xbgr.mr_n60792304)
print v(xbgr.mr_n60513168)
print v(xbgr.mr_n61103792)
print v(xbgr.mr_n61287024)
print v(xbgr.mr_n60202992)
print v(xbgr.n_23)
print v(xbgr.mr_n60443648)
print v(xbgr.mr_n60819680)
print v(xbgr.mr_n60683856)
print v(xbgr.mr_n62435152)
print v(xbgr.mr_n62402624)
print v(xbgr.mr_n62893776)
print v(xbgr.mr_n62593024)
print v(xbgr.mr_n62787872)
print v(xbgr.mr_n63130000)
print v(xbgr.n_12)
print v(xbgr.n_25)
print v(xbgr.mr_n60444048)
print v(xbgr.mr_n60817360)
print v(xbgr.mr_n60861184)
print v(xbgr.mr_n61181328)
print v(xbgr.mr_n61320960)
print v(xbgr.mr_n61545568)
print v(xbgr.mr_n61721296)
print v(xbgr.mr_n61787664)
print v(xbgr.mr_n61872416)
print v(xbgr.mr_n61995472)
print v(xbgr.mr_n62125584)
print v(xbgr.mr_n62231536)
print v(xbgr.mr_n62357120)
print v(xbgr.mr_n61547504)
print v(xbgr.mr_n61700640)
print v(xbgr.mr_n61773712)
print v(xbgr.mr_n61869312)
print v(xbgr.mr_n62000864)
print v(xbgr.mr_n62131584)
print v(xbgr.mr_n62220416)
print v(xbgr.mr_n62362224)
print v(xbgr.mr_n60003888)
print v(xbgr.mr_n60304176)
print v(xbgr.mr_n60443248)
print v(xbgr.mr_n60814880)
print v(xbgr.mr_n62592848)
print v(xbgr.mr_n62866240)
print v(xbgr.mr_n63128432)
print v(xbgr.mr_n61457056)
print v(xbgr.mr_n61581120)
print v(xbgr.mr_n61666544)
print v(xbgr.mr_n61799216)
print v(xbgr.mr_n61890544)
print v(xbgr.mr_n62021056)
print v(xbgr.mr_n62149840)
print v(xbgr.mr_n62291568)
print v(xbgr.n_17)
print v(xbgr.n_22)
print v(xbgr.mr_n60445248)
print v(xbgr.mr_n60812560)
print v(xbgr.mr_n62423328)
print v(xbgr.mr_n62736032)
print v(xbgr.mr_n63133376)
print v(xbgr.mr_n62434848)
print v(xbgr.mr_n62578592)
print v(xbgr.mr_n62893664)
print v(xbgr.mr_n61548448)
print v(xbgr.mr_n61709168)
print v(xbgr.mr_n61786256)
print v(xbgr.mr_n61870944)
print v(xbgr.mr_n61984096)
print v(xbgr.mr_n62129072)
print v(xbgr.mr_n62186624)
print v(xbgr.mr_n62340640)
print v(xbgr.mr_n60876480)
print v(xbgr.mr_n61208144)
print v(xbgr.mr_n61419488)
print v(xbgr.n_18)
print v(xbgr.mr_n60302352)
print v(xbgr.mr_n60474064)
print v(xbgr.mr_n60810560)
print v(xbgr.mr_n60878880)
print v(xbgr.mr_n61221152)
print v(xbgr.mr_n61419312)
print v(xbgr.mr_n62586160)
print v(xbgr.mr_n62786480)
print v(xbgr.mr_n63132560)
print v(xbgr.mr_n60801776)
print v(xbgr.mr_n60068784)
print v(xbgr.mr_n60200128)
print v(xbgr.mr_n60301440)
print v(xbgr.mr_n60474656)
print v(xbgr.mr_n60808352)
print v(xbgr.mr_n60817760)
print v(xbgr.mr_n60805824)
print v(xbgr.mr_n61099792)
print v(xbgr.mr_n61288864)
print v(xbgr.mr_n62589680)
print v(xbgr.mr_n62873200)
print v(xbgr.mr_n63130992)
print v(xbgr.mr_n60729936)
print v(xbgr.mr_n60093744)
print v(xbgr.mr_n60300496)
print v(xbgr.mr_n60473472)
print v(xbgr.mr_n60807120)
print v(xbgr.mr_n60865680)
print v(xbgr.mr_n61183760)
print v(xbgr.mr_n61320624)
print v(xbgr.mr_n62420128)
print v(xbgr.mr_n62750480)
print v(xbgr.mr_n63135936)
print v(xbgr.mr_n61553344)
print v(xbgr.mr_n61623504)
print v(xbgr.mr_n61784944)
print v(xbgr.mr_n61862800)
print v(xbgr.mr_n61991056)
print v(xbgr.mr_n62113200)
print v(xbgr.mr_n62222784)
print v(xbgr.mr_n62361456)
print v(xbgr.mr_n61533872)
print v(xbgr.mr_n61626160)
print v(xbgr.mr_n61731088)
print v(xbgr.mr_n61619824)
print v(xbgr.mr_n61983120)
print v(xbgr.mr_n62123520)
print v(xbgr.mr_n62229136)
print v(xbgr.mr_n62363360)
print v(xbgr.mr_n62412928)
print v(xbgr.mr_n62579808)
print v(xbgr.mr_n62887808)
print v(xbgr.mr_n60142576)
print v(xbgr.mr_n60170864)
print v(xbgr.mr_n60471568)
print v(xbgr.mr_n60649872)
print v(xbgr.mr_n62589856)
print v(xbgr.mr_n62746352)
print v(xbgr.mr_n63135120)
print v(xbgr.mr_n61456592)
print v(xbgr.mr_n61578736)
print v(xbgr.mr_n61625168)
print v(xbgr.mr_n61800896)
print v(xbgr.mr_n61889616)
print v(xbgr.mr_n62019328)
print v(xbgr.mr_n62148112)
print v(xbgr.mr_n62294768)
print v(xbgr.mr_n62481488)
print v(xbgr.mr_n62872864)
print v(xbgr.mr_n63133552)
print v(xbgr.mr_n60697184)
print v(xbgr.mr_n61543456)
print v(xbgr.mr_n61577024)
print v(xbgr.mr_n61782112)
print v(xbgr.mr_n61866176)
print v(xbgr.mr_n61997408)
print v(xbgr.mr_n62125360)
print v(xbgr.mr_n62145696)
print v(xbgr.mr_n62294144)
print v(xbgr.mr_n60879760)
print v(xbgr.mr_n61219424)
print v(xbgr.mr_n61362592)
print v(xbgr.mr_n60871440)
print v(xbgr.mr_n61207408)
print v(xbgr.mr_n61395216)
print v(xbgr.mr_n62505200)
print v(xbgr.mr_n62643712)
print v(xbgr.mr_n63130816)
print v(xbgr.mr_n60029744)
print v(xbgr.mr_n62424128)
print v(xbgr.mr_n62579520)
print v(xbgr.mr_n62893248)
print v(xbgr.mr_n60805280)
print v(xbgr.mr_n60509040)
print v(xbgr.mr_n61104752)
print v(xbgr.mr_n61239504)
print v(xbgr.mr_n60289696)
print v(xbgr.mr_n62505008)
print v(xbgr.mr_n62740160)
print v(xbgr.mr_n63122320)
print v(xbgr.mr_n60862128)
print v(xbgr.mr_n61187200)
print v(xbgr.mr_n61364960)
print v(dvbe)
print v(iptat)
print v(pbias)
print v(pcasc)
print v(r4)
print v(vbe)
print v(vdd)
print v(vref)
print v(vdd)-v(vdd)
echo METALLIC_POINT_VOLTAGES_END
quit
.endc
.end
