* G1_BGR standalone capacitance-PEX qualification
.lib /foss/pdks/ihp-sg13g2/libs.tech/ngspice/models/cornerHBT.lib hbt_typ
.lib /foss/pdks/ihp-sg13g2/libs.tech/ngspice/models/cornerMOShv.lib mos_tt
.lib /foss/pdks/ihp-sg13g2/libs.tech/ngspice/models/cornerRES.lib res_typ
.include conditional_metal.spice
.option seed=44001 gmin=1e-15 abstol=1e-14 reltol=1e-5 vntol=1e-7
.global sub!
Vsub sub! 0 0
Vdd vdd 0 3.3
Vr4 r4 0 0
Xbgr vdd 0 r4 vref iptat pbias pcasc vbe dvbe g1_bgr
Vload iptat 0 1
Cload vref 0 1e-12
.control
set num_threads=1
set numdgt=15
set wr_singlescale
set wr_vecnames
op
echo RAW_CURRENT_LEDGER_BEGIN
print @n.xbgr.xr1.nr1[ibody]
print @n.xbgr.xr2.nr1[ibody]
print @n.xbgr.xr3.nr1[ibody]
print @n.xbgr.xr4.nr1[ibody]
print @n.xbgr.xr5.nr1[ibody]
print @n.xbgr.xr6.nr1[ibody]
print @n.xbgr.xr7.nr1[ibody]
print @n.xbgr.xr8.nr1[ibody]
print @n.xbgr.xr9.nr1[ibody]
print @n.xbgr.xr10.nr1[ibody]
print @n.xbgr.xr11.nr1[ibody]
print @n.xbgr.xr12.nr1[ibody]
print @n.xbgr.xr13.nr1[ibody]
print @n.xbgr.xr14.nr1[ibody]
print @n.xbgr.xr15.nr1[ibody]
print @n.xbgr.xr16.nr1[ibody]
print @n.xbgr.xr17.nr1[ibody]
print @n.xbgr.xr18.nr1[ibody]
print @n.xbgr.xr19.nr1[ibody]
print @n.xbgr.xr20.nr1[ibody]
print @n.xbgr.xr21.nr1[ibody]
print @n.xbgr.xr22.nr1[ibody]
print @n.xbgr.xr23.nr1[ibody]
print @n.xbgr.xr24.nr1[ibody]
print @n.xbgr.xr25.nr1[ibody]
print @n.xbgr.xr26.nr1[ibody]
print @n.xbgr.xm27.nsg13_hv_pmos[ide]
print @n.xbgr.xm27.nsg13_hv_pmos[ige]
print @n.xbgr.xm27.nsg13_hv_pmos[ise]
print @n.xbgr.xm27.nsg13_hv_pmos[ibe]
print @n.xbgr.xm27.nsg13_hv_pmos[ctype]
print @n.xbgr.xm28.nsg13_hv_pmos[ide]
print @n.xbgr.xm28.nsg13_hv_pmos[ige]
print @n.xbgr.xm28.nsg13_hv_pmos[ise]
print @n.xbgr.xm28.nsg13_hv_pmos[ibe]
print @n.xbgr.xm28.nsg13_hv_pmos[ctype]
print @n.xbgr.xm29.nsg13_hv_nmos[ide]
print @n.xbgr.xm29.nsg13_hv_nmos[ige]
print @n.xbgr.xm29.nsg13_hv_nmos[ise]
print @n.xbgr.xm29.nsg13_hv_nmos[ibe]
print @n.xbgr.xm29.nsg13_hv_nmos[ctype]
print @n.xbgr.xm30.nsg13_hv_nmos[ide]
print @n.xbgr.xm30.nsg13_hv_nmos[ige]
print @n.xbgr.xm30.nsg13_hv_nmos[ise]
print @n.xbgr.xm30.nsg13_hv_nmos[ibe]
print @n.xbgr.xm30.nsg13_hv_nmos[ctype]
print @n.xbgr.xm31.nsg13_hv_nmos[ide]
print @n.xbgr.xm31.nsg13_hv_nmos[ige]
print @n.xbgr.xm31.nsg13_hv_nmos[ise]
print @n.xbgr.xm31.nsg13_hv_nmos[ibe]
print @n.xbgr.xm31.nsg13_hv_nmos[ctype]
print @n.xbgr.xm32.nsg13_hv_nmos[ide]
print @n.xbgr.xm32.nsg13_hv_nmos[ige]
print @n.xbgr.xm32.nsg13_hv_nmos[ise]
print @n.xbgr.xm32.nsg13_hv_nmos[ibe]
print @n.xbgr.xm32.nsg13_hv_nmos[ctype]
print @n.xbgr.xm33.nsg13_hv_nmos[ide]
print @n.xbgr.xm33.nsg13_hv_nmos[ige]
print @n.xbgr.xm33.nsg13_hv_nmos[ise]
print @n.xbgr.xm33.nsg13_hv_nmos[ibe]
print @n.xbgr.xm33.nsg13_hv_nmos[ctype]
print @n.xbgr.xm34.nsg13_hv_nmos[ide]
print @n.xbgr.xm34.nsg13_hv_nmos[ige]
print @n.xbgr.xm34.nsg13_hv_nmos[ise]
print @n.xbgr.xm34.nsg13_hv_nmos[ibe]
print @n.xbgr.xm34.nsg13_hv_nmos[ctype]
print @n.xbgr.xm35.nsg13_hv_nmos[ide]
print @n.xbgr.xm35.nsg13_hv_nmos[ige]
print @n.xbgr.xm35.nsg13_hv_nmos[ise]
print @n.xbgr.xm35.nsg13_hv_nmos[ibe]
print @n.xbgr.xm35.nsg13_hv_nmos[ctype]
print @n.xbgr.xm36.nsg13_hv_nmos[ide]
print @n.xbgr.xm36.nsg13_hv_nmos[ige]
print @n.xbgr.xm36.nsg13_hv_nmos[ise]
print @n.xbgr.xm36.nsg13_hv_nmos[ibe]
print @n.xbgr.xm36.nsg13_hv_nmos[ctype]
print @n.xbgr.xm37.nsg13_hv_nmos[ide]
print @n.xbgr.xm37.nsg13_hv_nmos[ige]
print @n.xbgr.xm37.nsg13_hv_nmos[ise]
print @n.xbgr.xm37.nsg13_hv_nmos[ibe]
print @n.xbgr.xm37.nsg13_hv_nmos[ctype]
print @n.xbgr.xm38.nsg13_hv_pmos[ide]
print @n.xbgr.xm38.nsg13_hv_pmos[ige]
print @n.xbgr.xm38.nsg13_hv_pmos[ise]
print @n.xbgr.xm38.nsg13_hv_pmos[ibe]
print @n.xbgr.xm38.nsg13_hv_pmos[ctype]
print @n.xbgr.xm39.nsg13_hv_pmos[ide]
print @n.xbgr.xm39.nsg13_hv_pmos[ige]
print @n.xbgr.xm39.nsg13_hv_pmos[ise]
print @n.xbgr.xm39.nsg13_hv_pmos[ibe]
print @n.xbgr.xm39.nsg13_hv_pmos[ctype]
print @n.xbgr.xm40.nsg13_hv_pmos[ide]
print @n.xbgr.xm40.nsg13_hv_pmos[ige]
print @n.xbgr.xm40.nsg13_hv_pmos[ise]
print @n.xbgr.xm40.nsg13_hv_pmos[ibe]
print @n.xbgr.xm40.nsg13_hv_pmos[ctype]
print @n.xbgr.xm41.nsg13_hv_pmos[ide]
print @n.xbgr.xm41.nsg13_hv_pmos[ige]
print @n.xbgr.xm41.nsg13_hv_pmos[ise]
print @n.xbgr.xm41.nsg13_hv_pmos[ibe]
print @n.xbgr.xm41.nsg13_hv_pmos[ctype]
print @n.xbgr.xm42.nsg13_hv_pmos[ide]
print @n.xbgr.xm42.nsg13_hv_pmos[ige]
print @n.xbgr.xm42.nsg13_hv_pmos[ise]
print @n.xbgr.xm42.nsg13_hv_pmos[ibe]
print @n.xbgr.xm42.nsg13_hv_pmos[ctype]
print @n.xbgr.xm43.nsg13_hv_pmos[ide]
print @n.xbgr.xm43.nsg13_hv_pmos[ige]
print @n.xbgr.xm43.nsg13_hv_pmos[ise]
print @n.xbgr.xm43.nsg13_hv_pmos[ibe]
print @n.xbgr.xm43.nsg13_hv_pmos[ctype]
print @n.xbgr.xm44.nsg13_hv_pmos[ide]
print @n.xbgr.xm44.nsg13_hv_pmos[ige]
print @n.xbgr.xm44.nsg13_hv_pmos[ise]
print @n.xbgr.xm44.nsg13_hv_pmos[ibe]
print @n.xbgr.xm44.nsg13_hv_pmos[ctype]
print @n.xbgr.xm45.nsg13_hv_pmos[ide]
print @n.xbgr.xm45.nsg13_hv_pmos[ige]
print @n.xbgr.xm45.nsg13_hv_pmos[ise]
print @n.xbgr.xm45.nsg13_hv_pmos[ibe]
print @n.xbgr.xm45.nsg13_hv_pmos[ctype]
print @n.xbgr.xm46.nsg13_hv_pmos[ide]
print @n.xbgr.xm46.nsg13_hv_pmos[ige]
print @n.xbgr.xm46.nsg13_hv_pmos[ise]
print @n.xbgr.xm46.nsg13_hv_pmos[ibe]
print @n.xbgr.xm46.nsg13_hv_pmos[ctype]
print @n.xbgr.xm47.nsg13_hv_pmos[ide]
print @n.xbgr.xm47.nsg13_hv_pmos[ige]
print @n.xbgr.xm47.nsg13_hv_pmos[ise]
print @n.xbgr.xm47.nsg13_hv_pmos[ibe]
print @n.xbgr.xm47.nsg13_hv_pmos[ctype]
print @n.xbgr.xm48.nsg13_hv_pmos[ide]
print @n.xbgr.xm48.nsg13_hv_pmos[ige]
print @n.xbgr.xm48.nsg13_hv_pmos[ise]
print @n.xbgr.xm48.nsg13_hv_pmos[ibe]
print @n.xbgr.xm48.nsg13_hv_pmos[ctype]
print @n.xbgr.xm49.nsg13_hv_pmos[ide]
print @n.xbgr.xm49.nsg13_hv_pmos[ige]
print @n.xbgr.xm49.nsg13_hv_pmos[ise]
print @n.xbgr.xm49.nsg13_hv_pmos[ibe]
print @n.xbgr.xm49.nsg13_hv_pmos[ctype]
print @n.xbgr.xm50.nsg13_hv_pmos[ide]
print @n.xbgr.xm50.nsg13_hv_pmos[ige]
print @n.xbgr.xm50.nsg13_hv_pmos[ise]
print @n.xbgr.xm50.nsg13_hv_pmos[ibe]
print @n.xbgr.xm50.nsg13_hv_pmos[ctype]
print @n.xbgr.xm51.nsg13_hv_pmos[ide]
print @n.xbgr.xm51.nsg13_hv_pmos[ige]
print @n.xbgr.xm51.nsg13_hv_pmos[ise]
print @n.xbgr.xm51.nsg13_hv_pmos[ibe]
print @n.xbgr.xm51.nsg13_hv_pmos[ctype]
print @n.xbgr.xm52.nsg13_hv_pmos[ide]
print @n.xbgr.xm52.nsg13_hv_pmos[ige]
print @n.xbgr.xm52.nsg13_hv_pmos[ise]
print @n.xbgr.xm52.nsg13_hv_pmos[ibe]
print @n.xbgr.xm52.nsg13_hv_pmos[ctype]
print @n.xbgr.xm53.nsg13_hv_pmos[ide]
print @n.xbgr.xm53.nsg13_hv_pmos[ige]
print @n.xbgr.xm53.nsg13_hv_pmos[ise]
print @n.xbgr.xm53.nsg13_hv_pmos[ibe]
print @n.xbgr.xm53.nsg13_hv_pmos[ctype]
print @n.xbgr.xm54.nsg13_hv_pmos[ide]
print @n.xbgr.xm54.nsg13_hv_pmos[ige]
print @n.xbgr.xm54.nsg13_hv_pmos[ise]
print @n.xbgr.xm54.nsg13_hv_pmos[ibe]
print @n.xbgr.xm54.nsg13_hv_pmos[ctype]
print @q.xbgr.xq55.qnpn13g2[ic]
print @q.xbgr.xq55.qnpn13g2[ib]
print @q.xbgr.xq55.qnpn13g2[ie]
print @q.xbgr.xq55.qnpn13g2[is]
print @r.xbgr.xq55.rsub[i]
print @c.xbgr.xq55.csub[i]
print @q.xbgr.xq56.qnpn13g2[ic]
print @q.xbgr.xq56.qnpn13g2[ib]
print @q.xbgr.xq56.qnpn13g2[ie]
print @q.xbgr.xq56.qnpn13g2[is]
print @r.xbgr.xq56.rsub[i]
print @c.xbgr.xq56.csub[i]
print @q.xbgr.xq57.qnpn13g2[ic]
print @q.xbgr.xq57.qnpn13g2[ib]
print @q.xbgr.xq57.qnpn13g2[ie]
print @q.xbgr.xq57.qnpn13g2[is]
print @r.xbgr.xq57.rsub[i]
print @c.xbgr.xq57.csub[i]
print @q.xbgr.xq58.qnpn13g2[ic]
print @q.xbgr.xq58.qnpn13g2[ib]
print @q.xbgr.xq58.qnpn13g2[ie]
print @q.xbgr.xq58.qnpn13g2[is]
print @r.xbgr.xq58.rsub[i]
print @c.xbgr.xq58.csub[i]
print @q.xbgr.xq59.qnpn13g2[ic]
print @q.xbgr.xq59.qnpn13g2[ib]
print @q.xbgr.xq59.qnpn13g2[ie]
print @q.xbgr.xq59.qnpn13g2[is]
print @r.xbgr.xq59.rsub[i]
print @c.xbgr.xq59.csub[i]
print @q.xbgr.xq60.qnpn13g2[ic]
print @q.xbgr.xq60.qnpn13g2[ib]
print @q.xbgr.xq60.qnpn13g2[ie]
print @q.xbgr.xq60.qnpn13g2[is]
print @r.xbgr.xq60.rsub[i]
print @c.xbgr.xq60.csub[i]
print @q.xbgr.xq61.qnpn13g2[ic]
print @q.xbgr.xq61.qnpn13g2[ib]
print @q.xbgr.xq61.qnpn13g2[ie]
print @q.xbgr.xq61.qnpn13g2[is]
print @r.xbgr.xq61.rsub[i]
print @c.xbgr.xq61.csub[i]
print @q.xbgr.xq62.qnpn13g2[ic]
print @q.xbgr.xq62.qnpn13g2[ib]
print @q.xbgr.xq62.qnpn13g2[ie]
print @q.xbgr.xq62.qnpn13g2[is]
print @r.xbgr.xq62.rsub[i]
print @c.xbgr.xq62.csub[i]
print @q.xbgr.xq63.qnpn13g2[ic]
print @q.xbgr.xq63.qnpn13g2[ib]
print @q.xbgr.xq63.qnpn13g2[ie]
print @q.xbgr.xq63.qnpn13g2[is]
print @r.xbgr.xq63.rsub[i]
print @c.xbgr.xq63.csub[i]
print @q.xbgr.xq64.qnpn13g2[ic]
print @q.xbgr.xq64.qnpn13g2[ib]
print @q.xbgr.xq64.qnpn13g2[ie]
print @q.xbgr.xq64.qnpn13g2[is]
print @r.xbgr.xq64.rsub[i]
print @c.xbgr.xq64.csub[i]
print @q.xbgr.xq65.qnpn13g2[ic]
print @q.xbgr.xq65.qnpn13g2[ib]
print @q.xbgr.xq65.qnpn13g2[ie]
print @q.xbgr.xq65.qnpn13g2[is]
print @r.xbgr.xq65.rsub[i]
print @c.xbgr.xq65.csub[i]
print @q.xbgr.xq66.qnpn13g2[ic]
print @q.xbgr.xq66.qnpn13g2[ib]
print @q.xbgr.xq66.qnpn13g2[ie]
print @q.xbgr.xq66.qnpn13g2[is]
print @r.xbgr.xq66.rsub[i]
print @c.xbgr.xq66.csub[i]
print @q.xbgr.xq67.qnpn13g2[ic]
print @q.xbgr.xq67.qnpn13g2[ib]
print @q.xbgr.xq67.qnpn13g2[ie]
print @q.xbgr.xq67.qnpn13g2[is]
print @r.xbgr.xq67.rsub[i]
print @c.xbgr.xq67.csub[i]
print @q.xbgr.xq68.qnpn13g2[ic]
print @q.xbgr.xq68.qnpn13g2[ib]
print @q.xbgr.xq68.qnpn13g2[ie]
print @q.xbgr.xq68.qnpn13g2[is]
print @r.xbgr.xq68.rsub[i]
print @c.xbgr.xq68.csub[i]
print @q.xbgr.xq69.qnpn13g2[ic]
print @q.xbgr.xq69.qnpn13g2[ib]
print @q.xbgr.xq69.qnpn13g2[ie]
print @q.xbgr.xq69.qnpn13g2[is]
print @r.xbgr.xq69.rsub[i]
print @c.xbgr.xq69.csub[i]
print @q.xbgr.xq70.qnpn13g2[ic]
print @q.xbgr.xq70.qnpn13g2[ib]
print @q.xbgr.xq70.qnpn13g2[ie]
print @q.xbgr.xq70.qnpn13g2[is]
print @r.xbgr.xq70.rsub[i]
print @c.xbgr.xq70.csub[i]
print @q.xbgr.xq71.qnpn13g2[ic]
print @q.xbgr.xq71.qnpn13g2[ib]
print @q.xbgr.xq71.qnpn13g2[ie]
print @q.xbgr.xq71.qnpn13g2[is]
print @r.xbgr.xq71.rsub[i]
print @c.xbgr.xq71.csub[i]
print @q.xbgr.xq72.qnpn13g2[ic]
print @q.xbgr.xq72.qnpn13g2[ib]
print @q.xbgr.xq72.qnpn13g2[ie]
print @q.xbgr.xq72.qnpn13g2[is]
print @r.xbgr.xq72.rsub[i]
print @c.xbgr.xq72.csub[i]
print @q.xbgr.xq73.qnpn13g2[ic]
print @q.xbgr.xq73.qnpn13g2[ib]
print @q.xbgr.xq73.qnpn13g2[ie]
print @q.xbgr.xq73.qnpn13g2[is]
print @r.xbgr.xq73.rsub[i]
print @c.xbgr.xq73.csub[i]
print @q.xbgr.xq74.qnpn13g2[ic]
print @q.xbgr.xq74.qnpn13g2[ib]
print @q.xbgr.xq74.qnpn13g2[ie]
print @q.xbgr.xq74.qnpn13g2[is]
print @r.xbgr.xq74.rsub[i]
print @c.xbgr.xq74.csub[i]
print @q.xbgr.xq75.qnpn13g2[ic]
print @q.xbgr.xq75.qnpn13g2[ib]
print @q.xbgr.xq75.qnpn13g2[ie]
print @q.xbgr.xq75.qnpn13g2[is]
print @r.xbgr.xq75.rsub[i]
print @c.xbgr.xq75.csub[i]
print @q.xbgr.xq76.qnpn13g2[ic]
print @q.xbgr.xq76.qnpn13g2[ib]
print @q.xbgr.xq76.qnpn13g2[ie]
print @q.xbgr.xq76.qnpn13g2[is]
print @r.xbgr.xq76.rsub[i]
print @c.xbgr.xq76.csub[i]
print @n.xbgr.xr77.nr1[ibody]
print @n.xbgr.xr78.nr1[ibody]
print @n.xbgr.xr79.nr1[ibody]
print @n.xbgr.xr80.nr1[ibody]
print @n.xbgr.xr81.nr1[ibody]
print @n.xbgr.xr82.nr1[ibody]
print @n.xbgr.xr83.nr1[ibody]
print @n.xbgr.xr84.nr1[ibody]
print @n.xbgr.xr85.nr1[ibody]
print @n.xbgr.xr86.nr1[ibody]
print @n.xbgr.xr16_u2.nr1[ibody]
print @n.xbgr.xr16_u3.nr1[ibody]
print @n.xbgr.xr16_u4.nr1[ibody]
print @n.xbgr.xr16_u5.nr1[ibody]
print @n.xbgr.xr16_u6.nr1[ibody]
print @n.xbgr.xr16_u7.nr1[ibody]
print @n.xbgr.xr16_u8.nr1[ibody]
print @n.xbgr.xr16_u9.nr1[ibody]
print @n.xbgr.xr16_u10.nr1[ibody]
print @n.xbgr.xr16_u11.nr1[ibody]
print @n.xbgr.xr16_u12.nr1[ibody]
print @n.xbgr.xr16_u13.nr1[ibody]
print @n.xbgr.xr16_u14.nr1[ibody]
print @n.xbgr.xr16_u15.nr1[ibody]
print @n.xbgr.xr16_u16.nr1[ibody]
print @n.xbgr.xr16_u17.nr1[ibody]
print @n.xbgr.xr16_u18.nr1[ibody]
print @n.xbgr.xr16_u19.nr1[ibody]
print @n.xbgr.xr16_u20.nr1[ibody]
print @n.xbgr.xr16_u21.nr1[ibody]
print @n.xbgr.xr16_u22.nr1[ibody]
print @n.xbgr.xr16_u23.nr1[ibody]
print @n.xbgr.xr16_u24.nr1[ibody]
print @n.xbgr.xr17_u2.nr1[ibody]
print @n.xbgr.xr17_u3.nr1[ibody]
print @n.xbgr.xr17_u4.nr1[ibody]
print @n.xbgr.xr18_u2.nr1[ibody]
print @n.xbgr.xr18_u3.nr1[ibody]
print @n.xbgr.xr18_u4.nr1[ibody]
print @n.xbgr.xr19_u2.nr1[ibody]
print @n.xbgr.xr19_u3.nr1[ibody]
print @n.xbgr.xr19_u4.nr1[ibody]
print @n.xbgr.xr20_u2.nr1[ibody]
print @n.xbgr.xr20_u3.nr1[ibody]
print @n.xbgr.xr20_u4.nr1[ibody]
print @n.xbgr.xr21_u2.nr1[ibody]
print @n.xbgr.xr21_u3.nr1[ibody]
print @n.xbgr.xr21_u4.nr1[ibody]
print @n.xbgr.xr22_u2.nr1[ibody]
print @n.xbgr.xr22_u3.nr1[ibody]
print @n.xbgr.xr22_u4.nr1[ibody]
print @n.xbgr.xr23_u2.nr1[ibody]
print @n.xbgr.xr23_u3.nr1[ibody]
print @n.xbgr.xr23_u4.nr1[ibody]
print @n.xbgr.xr23_u5.nr1[ibody]
print @n.xbgr.xr23_u6.nr1[ibody]
print @n.xbgr.xr23_u7.nr1[ibody]
print @n.xbgr.xr23_u8.nr1[ibody]
print @n.xbgr.xr23_u9.nr1[ibody]
print @n.xbgr.xr23_u10.nr1[ibody]
print @n.xbgr.xr23_u11.nr1[ibody]
print @n.xbgr.xr23_u12.nr1[ibody]
print @n.xbgr.xr23_u13.nr1[ibody]
print @n.xbgr.xr23_u14.nr1[ibody]
print @n.xbgr.xr23_u15.nr1[ibody]
print @n.xbgr.xr23_u16.nr1[ibody]
print @n.xbgr.xr23_u17.nr1[ibody]
print @n.xbgr.xr23_u18.nr1[ibody]
print @n.xbgr.xr23_u19.nr1[ibody]
print @n.xbgr.xr23_u20.nr1[ibody]
print @n.xbgr.xr23_u21.nr1[ibody]
print @n.xbgr.xr23_u22.nr1[ibody]
print @n.xbgr.xr23_u23.nr1[ibody]
print @n.xbgr.xr23_u24.nr1[ibody]
print @n.xbgr.xr24_u2.nr1[ibody]
print @n.xbgr.xr24_u3.nr1[ibody]
print @n.xbgr.xr24_u4.nr1[ibody]
print @n.xbgr.xr24_u5.nr1[ibody]
print @n.xbgr.xr24_u6.nr1[ibody]
print @n.xbgr.xr24_u7.nr1[ibody]
print @n.xbgr.xr24_u8.nr1[ibody]
print @n.xbgr.xr24_u9.nr1[ibody]
print @n.xbgr.xr24_u10.nr1[ibody]
print @n.xbgr.xr24_u11.nr1[ibody]
print @n.xbgr.xr24_u12.nr1[ibody]
print @n.xbgr.xr24_u13.nr1[ibody]
print @n.xbgr.xr24_u14.nr1[ibody]
print @n.xbgr.xr24_u15.nr1[ibody]
print @n.xbgr.xr24_u16.nr1[ibody]
print @n.xbgr.xr24_u17.nr1[ibody]
print @n.xbgr.xr24_u18.nr1[ibody]
print @n.xbgr.xr24_u19.nr1[ibody]
print @n.xbgr.xr24_u20.nr1[ibody]
print @n.xbgr.xr24_u21.nr1[ibody]
print @n.xbgr.xr24_u22.nr1[ibody]
print @n.xbgr.xr24_u23.nr1[ibody]
print @n.xbgr.xr24_u24.nr1[ibody]
print @n.xbgr.xr25_u2.nr1[ibody]
print @n.xbgr.xr25_u3.nr1[ibody]
print @n.xbgr.xr25_u4.nr1[ibody]
print @n.xbgr.xr25_u5.nr1[ibody]
print @n.xbgr.xr25_u6.nr1[ibody]
print @n.xbgr.xr25_u7.nr1[ibody]
print @n.xbgr.xr25_u8.nr1[ibody]
print @n.xbgr.xr25_u9.nr1[ibody]
print @n.xbgr.xr25_u10.nr1[ibody]
print @n.xbgr.xr25_u11.nr1[ibody]
print @n.xbgr.xr25_u12.nr1[ibody]
print @n.xbgr.xr25_u13.nr1[ibody]
print @n.xbgr.xr25_u14.nr1[ibody]
print @n.xbgr.xr25_u15.nr1[ibody]
print @n.xbgr.xr25_u16.nr1[ibody]
print @n.xbgr.xr25_u17.nr1[ibody]
print @n.xbgr.xr25_u18.nr1[ibody]
print @n.xbgr.xr25_u19.nr1[ibody]
print @n.xbgr.xr25_u20.nr1[ibody]
print @n.xbgr.xr25_u21.nr1[ibody]
print @n.xbgr.xr25_u22.nr1[ibody]
print @n.xbgr.xr25_u23.nr1[ibody]
print @n.xbgr.xr25_u24.nr1[ibody]
print @n.xbgr.xr26_u2.nr1[ibody]
print @n.xbgr.xr26_u3.nr1[ibody]
print @n.xbgr.xr26_u4.nr1[ibody]
print @n.xbgr.xr26_u5.nr1[ibody]
print @n.xbgr.xr26_u6.nr1[ibody]
print @n.xbgr.xr26_u7.nr1[ibody]
print @n.xbgr.xr26_u8.nr1[ibody]
print @n.xbgr.xr26_u9.nr1[ibody]
print @n.xbgr.xr26_u10.nr1[ibody]
print @n.xbgr.xr26_u11.nr1[ibody]
print @n.xbgr.xr26_u12.nr1[ibody]
print @n.xbgr.xr26_u13.nr1[ibody]
print @n.xbgr.xr26_u14.nr1[ibody]
print @n.xbgr.xr26_u15.nr1[ibody]
print @n.xbgr.xr26_u16.nr1[ibody]
print @n.xbgr.xr26_u17.nr1[ibody]
print @n.xbgr.xr26_u18.nr1[ibody]
print @n.xbgr.xr26_u19.nr1[ibody]
print @n.xbgr.xr26_u20.nr1[ibody]
print @n.xbgr.xr26_u21.nr1[ibody]
print @n.xbgr.xr26_u22.nr1[ibody]
print @n.xbgr.xr26_u23.nr1[ibody]
print @n.xbgr.xr26_u24.nr1[ibody]
print @n.xbgr.xm34_u2.nsg13_hv_nmos[ide]
print @n.xbgr.xm34_u2.nsg13_hv_nmos[ige]
print @n.xbgr.xm34_u2.nsg13_hv_nmos[ise]
print @n.xbgr.xm34_u2.nsg13_hv_nmos[ibe]
print @n.xbgr.xm34_u2.nsg13_hv_nmos[ctype]
print @n.xbgr.xm34_u3.nsg13_hv_nmos[ide]
print @n.xbgr.xm34_u3.nsg13_hv_nmos[ige]
print @n.xbgr.xm34_u3.nsg13_hv_nmos[ise]
print @n.xbgr.xm34_u3.nsg13_hv_nmos[ibe]
print @n.xbgr.xm34_u3.nsg13_hv_nmos[ctype]
print @n.xbgr.xm34_u4.nsg13_hv_nmos[ide]
print @n.xbgr.xm34_u4.nsg13_hv_nmos[ige]
print @n.xbgr.xm34_u4.nsg13_hv_nmos[ise]
print @n.xbgr.xm34_u4.nsg13_hv_nmos[ibe]
print @n.xbgr.xm34_u4.nsg13_hv_nmos[ctype]
print @n.xbgr.xm34_u5.nsg13_hv_nmos[ide]
print @n.xbgr.xm34_u5.nsg13_hv_nmos[ige]
print @n.xbgr.xm34_u5.nsg13_hv_nmos[ise]
print @n.xbgr.xm34_u5.nsg13_hv_nmos[ibe]
print @n.xbgr.xm34_u5.nsg13_hv_nmos[ctype]
print @n.xbgr.xm34_u6.nsg13_hv_nmos[ide]
print @n.xbgr.xm34_u6.nsg13_hv_nmos[ige]
print @n.xbgr.xm34_u6.nsg13_hv_nmos[ise]
print @n.xbgr.xm34_u6.nsg13_hv_nmos[ibe]
print @n.xbgr.xm34_u6.nsg13_hv_nmos[ctype]
print @n.xbgr.xm34_u7.nsg13_hv_nmos[ide]
print @n.xbgr.xm34_u7.nsg13_hv_nmos[ige]
print @n.xbgr.xm34_u7.nsg13_hv_nmos[ise]
print @n.xbgr.xm34_u7.nsg13_hv_nmos[ibe]
print @n.xbgr.xm34_u7.nsg13_hv_nmos[ctype]
print @n.xbgr.xm34_u8.nsg13_hv_nmos[ide]
print @n.xbgr.xm34_u8.nsg13_hv_nmos[ige]
print @n.xbgr.xm34_u8.nsg13_hv_nmos[ise]
print @n.xbgr.xm34_u8.nsg13_hv_nmos[ibe]
print @n.xbgr.xm34_u8.nsg13_hv_nmos[ctype]
print @n.xbgr.xm34_u9.nsg13_hv_nmos[ide]
print @n.xbgr.xm34_u9.nsg13_hv_nmos[ige]
print @n.xbgr.xm34_u9.nsg13_hv_nmos[ise]
print @n.xbgr.xm34_u9.nsg13_hv_nmos[ibe]
print @n.xbgr.xm34_u9.nsg13_hv_nmos[ctype]
print @n.xbgr.xm34_u10.nsg13_hv_nmos[ide]
print @n.xbgr.xm34_u10.nsg13_hv_nmos[ige]
print @n.xbgr.xm34_u10.nsg13_hv_nmos[ise]
print @n.xbgr.xm34_u10.nsg13_hv_nmos[ibe]
print @n.xbgr.xm34_u10.nsg13_hv_nmos[ctype]
print @n.xbgr.xm34_u11.nsg13_hv_nmos[ide]
print @n.xbgr.xm34_u11.nsg13_hv_nmos[ige]
print @n.xbgr.xm34_u11.nsg13_hv_nmos[ise]
print @n.xbgr.xm34_u11.nsg13_hv_nmos[ibe]
print @n.xbgr.xm34_u11.nsg13_hv_nmos[ctype]
print @n.xbgr.xm34_u12.nsg13_hv_nmos[ide]
print @n.xbgr.xm34_u12.nsg13_hv_nmos[ige]
print @n.xbgr.xm34_u12.nsg13_hv_nmos[ise]
print @n.xbgr.xm34_u12.nsg13_hv_nmos[ibe]
print @n.xbgr.xm34_u12.nsg13_hv_nmos[ctype]
print @n.xbgr.xm34_u13.nsg13_hv_nmos[ide]
print @n.xbgr.xm34_u13.nsg13_hv_nmos[ige]
print @n.xbgr.xm34_u13.nsg13_hv_nmos[ise]
print @n.xbgr.xm34_u13.nsg13_hv_nmos[ibe]
print @n.xbgr.xm34_u13.nsg13_hv_nmos[ctype]
print @n.xbgr.xm34_u14.nsg13_hv_nmos[ide]
print @n.xbgr.xm34_u14.nsg13_hv_nmos[ige]
print @n.xbgr.xm34_u14.nsg13_hv_nmos[ise]
print @n.xbgr.xm34_u14.nsg13_hv_nmos[ibe]
print @n.xbgr.xm34_u14.nsg13_hv_nmos[ctype]
print @n.xbgr.xm34_u15.nsg13_hv_nmos[ide]
print @n.xbgr.xm34_u15.nsg13_hv_nmos[ige]
print @n.xbgr.xm34_u15.nsg13_hv_nmos[ise]
print @n.xbgr.xm34_u15.nsg13_hv_nmos[ibe]
print @n.xbgr.xm34_u15.nsg13_hv_nmos[ctype]
print @n.xbgr.xm34_u16.nsg13_hv_nmos[ide]
print @n.xbgr.xm34_u16.nsg13_hv_nmos[ige]
print @n.xbgr.xm34_u16.nsg13_hv_nmos[ise]
print @n.xbgr.xm34_u16.nsg13_hv_nmos[ibe]
print @n.xbgr.xm34_u16.nsg13_hv_nmos[ctype]
print @n.xbgr.xm34_u17.nsg13_hv_nmos[ide]
print @n.xbgr.xm34_u17.nsg13_hv_nmos[ige]
print @n.xbgr.xm34_u17.nsg13_hv_nmos[ise]
print @n.xbgr.xm34_u17.nsg13_hv_nmos[ibe]
print @n.xbgr.xm34_u17.nsg13_hv_nmos[ctype]
print @n.xbgr.xm34_u18.nsg13_hv_nmos[ide]
print @n.xbgr.xm34_u18.nsg13_hv_nmos[ige]
print @n.xbgr.xm34_u18.nsg13_hv_nmos[ise]
print @n.xbgr.xm34_u18.nsg13_hv_nmos[ibe]
print @n.xbgr.xm34_u18.nsg13_hv_nmos[ctype]
print @n.xbgr.xm34_u19.nsg13_hv_nmos[ide]
print @n.xbgr.xm34_u19.nsg13_hv_nmos[ige]
print @n.xbgr.xm34_u19.nsg13_hv_nmos[ise]
print @n.xbgr.xm34_u19.nsg13_hv_nmos[ibe]
print @n.xbgr.xm34_u19.nsg13_hv_nmos[ctype]
print @n.xbgr.xm34_u20.nsg13_hv_nmos[ide]
print @n.xbgr.xm34_u20.nsg13_hv_nmos[ige]
print @n.xbgr.xm34_u20.nsg13_hv_nmos[ise]
print @n.xbgr.xm34_u20.nsg13_hv_nmos[ibe]
print @n.xbgr.xm34_u20.nsg13_hv_nmos[ctype]
print @n.xbgr.xm34_u21.nsg13_hv_nmos[ide]
print @n.xbgr.xm34_u21.nsg13_hv_nmos[ige]
print @n.xbgr.xm34_u21.nsg13_hv_nmos[ise]
print @n.xbgr.xm34_u21.nsg13_hv_nmos[ibe]
print @n.xbgr.xm34_u21.nsg13_hv_nmos[ctype]
print @n.xbgr.xm34_u22.nsg13_hv_nmos[ide]
print @n.xbgr.xm34_u22.nsg13_hv_nmos[ige]
print @n.xbgr.xm34_u22.nsg13_hv_nmos[ise]
print @n.xbgr.xm34_u22.nsg13_hv_nmos[ibe]
print @n.xbgr.xm34_u22.nsg13_hv_nmos[ctype]
print @n.xbgr.xm34_u23.nsg13_hv_nmos[ide]
print @n.xbgr.xm34_u23.nsg13_hv_nmos[ige]
print @n.xbgr.xm34_u23.nsg13_hv_nmos[ise]
print @n.xbgr.xm34_u23.nsg13_hv_nmos[ibe]
print @n.xbgr.xm34_u23.nsg13_hv_nmos[ctype]
print @n.xbgr.xm34_u24.nsg13_hv_nmos[ide]
print @n.xbgr.xm34_u24.nsg13_hv_nmos[ige]
print @n.xbgr.xm34_u24.nsg13_hv_nmos[ise]
print @n.xbgr.xm34_u24.nsg13_hv_nmos[ibe]
print @n.xbgr.xm34_u24.nsg13_hv_nmos[ctype]
print @n.xbgr.xm35_u2.nsg13_hv_nmos[ide]
print @n.xbgr.xm35_u2.nsg13_hv_nmos[ige]
print @n.xbgr.xm35_u2.nsg13_hv_nmos[ise]
print @n.xbgr.xm35_u2.nsg13_hv_nmos[ibe]
print @n.xbgr.xm35_u2.nsg13_hv_nmos[ctype]
print @n.xbgr.xm35_u3.nsg13_hv_nmos[ide]
print @n.xbgr.xm35_u3.nsg13_hv_nmos[ige]
print @n.xbgr.xm35_u3.nsg13_hv_nmos[ise]
print @n.xbgr.xm35_u3.nsg13_hv_nmos[ibe]
print @n.xbgr.xm35_u3.nsg13_hv_nmos[ctype]
print @n.xbgr.xm35_u4.nsg13_hv_nmos[ide]
print @n.xbgr.xm35_u4.nsg13_hv_nmos[ige]
print @n.xbgr.xm35_u4.nsg13_hv_nmos[ise]
print @n.xbgr.xm35_u4.nsg13_hv_nmos[ibe]
print @n.xbgr.xm35_u4.nsg13_hv_nmos[ctype]
print @n.xbgr.xm35_u5.nsg13_hv_nmos[ide]
print @n.xbgr.xm35_u5.nsg13_hv_nmos[ige]
print @n.xbgr.xm35_u5.nsg13_hv_nmos[ise]
print @n.xbgr.xm35_u5.nsg13_hv_nmos[ibe]
print @n.xbgr.xm35_u5.nsg13_hv_nmos[ctype]
print @n.xbgr.xm35_u6.nsg13_hv_nmos[ide]
print @n.xbgr.xm35_u6.nsg13_hv_nmos[ige]
print @n.xbgr.xm35_u6.nsg13_hv_nmos[ise]
print @n.xbgr.xm35_u6.nsg13_hv_nmos[ibe]
print @n.xbgr.xm35_u6.nsg13_hv_nmos[ctype]
print @n.xbgr.xm35_u7.nsg13_hv_nmos[ide]
print @n.xbgr.xm35_u7.nsg13_hv_nmos[ige]
print @n.xbgr.xm35_u7.nsg13_hv_nmos[ise]
print @n.xbgr.xm35_u7.nsg13_hv_nmos[ibe]
print @n.xbgr.xm35_u7.nsg13_hv_nmos[ctype]
print @n.xbgr.xm35_u8.nsg13_hv_nmos[ide]
print @n.xbgr.xm35_u8.nsg13_hv_nmos[ige]
print @n.xbgr.xm35_u8.nsg13_hv_nmos[ise]
print @n.xbgr.xm35_u8.nsg13_hv_nmos[ibe]
print @n.xbgr.xm35_u8.nsg13_hv_nmos[ctype]
print @n.xbgr.xm35_u9.nsg13_hv_nmos[ide]
print @n.xbgr.xm35_u9.nsg13_hv_nmos[ige]
print @n.xbgr.xm35_u9.nsg13_hv_nmos[ise]
print @n.xbgr.xm35_u9.nsg13_hv_nmos[ibe]
print @n.xbgr.xm35_u9.nsg13_hv_nmos[ctype]
print @n.xbgr.xm35_u10.nsg13_hv_nmos[ide]
print @n.xbgr.xm35_u10.nsg13_hv_nmos[ige]
print @n.xbgr.xm35_u10.nsg13_hv_nmos[ise]
print @n.xbgr.xm35_u10.nsg13_hv_nmos[ibe]
print @n.xbgr.xm35_u10.nsg13_hv_nmos[ctype]
print @n.xbgr.xm35_u11.nsg13_hv_nmos[ide]
print @n.xbgr.xm35_u11.nsg13_hv_nmos[ige]
print @n.xbgr.xm35_u11.nsg13_hv_nmos[ise]
print @n.xbgr.xm35_u11.nsg13_hv_nmos[ibe]
print @n.xbgr.xm35_u11.nsg13_hv_nmos[ctype]
print @n.xbgr.xm35_u12.nsg13_hv_nmos[ide]
print @n.xbgr.xm35_u12.nsg13_hv_nmos[ige]
print @n.xbgr.xm35_u12.nsg13_hv_nmos[ise]
print @n.xbgr.xm35_u12.nsg13_hv_nmos[ibe]
print @n.xbgr.xm35_u12.nsg13_hv_nmos[ctype]
print @n.xbgr.xm35_u13.nsg13_hv_nmos[ide]
print @n.xbgr.xm35_u13.nsg13_hv_nmos[ige]
print @n.xbgr.xm35_u13.nsg13_hv_nmos[ise]
print @n.xbgr.xm35_u13.nsg13_hv_nmos[ibe]
print @n.xbgr.xm35_u13.nsg13_hv_nmos[ctype]
print @n.xbgr.xm35_u14.nsg13_hv_nmos[ide]
print @n.xbgr.xm35_u14.nsg13_hv_nmos[ige]
print @n.xbgr.xm35_u14.nsg13_hv_nmos[ise]
print @n.xbgr.xm35_u14.nsg13_hv_nmos[ibe]
print @n.xbgr.xm35_u14.nsg13_hv_nmos[ctype]
print @n.xbgr.xm35_u15.nsg13_hv_nmos[ide]
print @n.xbgr.xm35_u15.nsg13_hv_nmos[ige]
print @n.xbgr.xm35_u15.nsg13_hv_nmos[ise]
print @n.xbgr.xm35_u15.nsg13_hv_nmos[ibe]
print @n.xbgr.xm35_u15.nsg13_hv_nmos[ctype]
print @n.xbgr.xm35_u16.nsg13_hv_nmos[ide]
print @n.xbgr.xm35_u16.nsg13_hv_nmos[ige]
print @n.xbgr.xm35_u16.nsg13_hv_nmos[ise]
print @n.xbgr.xm35_u16.nsg13_hv_nmos[ibe]
print @n.xbgr.xm35_u16.nsg13_hv_nmos[ctype]
print @n.xbgr.xm35_u17.nsg13_hv_nmos[ide]
print @n.xbgr.xm35_u17.nsg13_hv_nmos[ige]
print @n.xbgr.xm35_u17.nsg13_hv_nmos[ise]
print @n.xbgr.xm35_u17.nsg13_hv_nmos[ibe]
print @n.xbgr.xm35_u17.nsg13_hv_nmos[ctype]
print @n.xbgr.xm35_u18.nsg13_hv_nmos[ide]
print @n.xbgr.xm35_u18.nsg13_hv_nmos[ige]
print @n.xbgr.xm35_u18.nsg13_hv_nmos[ise]
print @n.xbgr.xm35_u18.nsg13_hv_nmos[ibe]
print @n.xbgr.xm35_u18.nsg13_hv_nmos[ctype]
print @n.xbgr.xm35_u19.nsg13_hv_nmos[ide]
print @n.xbgr.xm35_u19.nsg13_hv_nmos[ige]
print @n.xbgr.xm35_u19.nsg13_hv_nmos[ise]
print @n.xbgr.xm35_u19.nsg13_hv_nmos[ibe]
print @n.xbgr.xm35_u19.nsg13_hv_nmos[ctype]
print @n.xbgr.xm35_u20.nsg13_hv_nmos[ide]
print @n.xbgr.xm35_u20.nsg13_hv_nmos[ige]
print @n.xbgr.xm35_u20.nsg13_hv_nmos[ise]
print @n.xbgr.xm35_u20.nsg13_hv_nmos[ibe]
print @n.xbgr.xm35_u20.nsg13_hv_nmos[ctype]
print @n.xbgr.xm35_u21.nsg13_hv_nmos[ide]
print @n.xbgr.xm35_u21.nsg13_hv_nmos[ige]
print @n.xbgr.xm35_u21.nsg13_hv_nmos[ise]
print @n.xbgr.xm35_u21.nsg13_hv_nmos[ibe]
print @n.xbgr.xm35_u21.nsg13_hv_nmos[ctype]
print @n.xbgr.xm35_u22.nsg13_hv_nmos[ide]
print @n.xbgr.xm35_u22.nsg13_hv_nmos[ige]
print @n.xbgr.xm35_u22.nsg13_hv_nmos[ise]
print @n.xbgr.xm35_u22.nsg13_hv_nmos[ibe]
print @n.xbgr.xm35_u22.nsg13_hv_nmos[ctype]
print @n.xbgr.xm35_u23.nsg13_hv_nmos[ide]
print @n.xbgr.xm35_u23.nsg13_hv_nmos[ige]
print @n.xbgr.xm35_u23.nsg13_hv_nmos[ise]
print @n.xbgr.xm35_u23.nsg13_hv_nmos[ibe]
print @n.xbgr.xm35_u23.nsg13_hv_nmos[ctype]
print @n.xbgr.xm35_u24.nsg13_hv_nmos[ide]
print @n.xbgr.xm35_u24.nsg13_hv_nmos[ige]
print @n.xbgr.xm35_u24.nsg13_hv_nmos[ise]
print @n.xbgr.xm35_u24.nsg13_hv_nmos[ibe]
print @n.xbgr.xm35_u24.nsg13_hv_nmos[ctype]
print @n.xbgr.xm36_u2.nsg13_hv_nmos[ide]
print @n.xbgr.xm36_u2.nsg13_hv_nmos[ige]
print @n.xbgr.xm36_u2.nsg13_hv_nmos[ise]
print @n.xbgr.xm36_u2.nsg13_hv_nmos[ibe]
print @n.xbgr.xm36_u2.nsg13_hv_nmos[ctype]
print @n.xbgr.xm36_u3.nsg13_hv_nmos[ide]
print @n.xbgr.xm36_u3.nsg13_hv_nmos[ige]
print @n.xbgr.xm36_u3.nsg13_hv_nmos[ise]
print @n.xbgr.xm36_u3.nsg13_hv_nmos[ibe]
print @n.xbgr.xm36_u3.nsg13_hv_nmos[ctype]
print @n.xbgr.xm36_u4.nsg13_hv_nmos[ide]
print @n.xbgr.xm36_u4.nsg13_hv_nmos[ige]
print @n.xbgr.xm36_u4.nsg13_hv_nmos[ise]
print @n.xbgr.xm36_u4.nsg13_hv_nmos[ibe]
print @n.xbgr.xm36_u4.nsg13_hv_nmos[ctype]
print @n.xbgr.xm36_u5.nsg13_hv_nmos[ide]
print @n.xbgr.xm36_u5.nsg13_hv_nmos[ige]
print @n.xbgr.xm36_u5.nsg13_hv_nmos[ise]
print @n.xbgr.xm36_u5.nsg13_hv_nmos[ibe]
print @n.xbgr.xm36_u5.nsg13_hv_nmos[ctype]
print @n.xbgr.xm36_u6.nsg13_hv_nmos[ide]
print @n.xbgr.xm36_u6.nsg13_hv_nmos[ige]
print @n.xbgr.xm36_u6.nsg13_hv_nmos[ise]
print @n.xbgr.xm36_u6.nsg13_hv_nmos[ibe]
print @n.xbgr.xm36_u6.nsg13_hv_nmos[ctype]
print @n.xbgr.xm36_u7.nsg13_hv_nmos[ide]
print @n.xbgr.xm36_u7.nsg13_hv_nmos[ige]
print @n.xbgr.xm36_u7.nsg13_hv_nmos[ise]
print @n.xbgr.xm36_u7.nsg13_hv_nmos[ibe]
print @n.xbgr.xm36_u7.nsg13_hv_nmos[ctype]
print @n.xbgr.xm36_u8.nsg13_hv_nmos[ide]
print @n.xbgr.xm36_u8.nsg13_hv_nmos[ige]
print @n.xbgr.xm36_u8.nsg13_hv_nmos[ise]
print @n.xbgr.xm36_u8.nsg13_hv_nmos[ibe]
print @n.xbgr.xm36_u8.nsg13_hv_nmos[ctype]
print @n.xbgr.xm36_u9.nsg13_hv_nmos[ide]
print @n.xbgr.xm36_u9.nsg13_hv_nmos[ige]
print @n.xbgr.xm36_u9.nsg13_hv_nmos[ise]
print @n.xbgr.xm36_u9.nsg13_hv_nmos[ibe]
print @n.xbgr.xm36_u9.nsg13_hv_nmos[ctype]
print @n.xbgr.xm36_u10.nsg13_hv_nmos[ide]
print @n.xbgr.xm36_u10.nsg13_hv_nmos[ige]
print @n.xbgr.xm36_u10.nsg13_hv_nmos[ise]
print @n.xbgr.xm36_u10.nsg13_hv_nmos[ibe]
print @n.xbgr.xm36_u10.nsg13_hv_nmos[ctype]
print @n.xbgr.xm36_u11.nsg13_hv_nmos[ide]
print @n.xbgr.xm36_u11.nsg13_hv_nmos[ige]
print @n.xbgr.xm36_u11.nsg13_hv_nmos[ise]
print @n.xbgr.xm36_u11.nsg13_hv_nmos[ibe]
print @n.xbgr.xm36_u11.nsg13_hv_nmos[ctype]
print @n.xbgr.xm36_u12.nsg13_hv_nmos[ide]
print @n.xbgr.xm36_u12.nsg13_hv_nmos[ige]
print @n.xbgr.xm36_u12.nsg13_hv_nmos[ise]
print @n.xbgr.xm36_u12.nsg13_hv_nmos[ibe]
print @n.xbgr.xm36_u12.nsg13_hv_nmos[ctype]
print @n.xbgr.xm36_u13.nsg13_hv_nmos[ide]
print @n.xbgr.xm36_u13.nsg13_hv_nmos[ige]
print @n.xbgr.xm36_u13.nsg13_hv_nmos[ise]
print @n.xbgr.xm36_u13.nsg13_hv_nmos[ibe]
print @n.xbgr.xm36_u13.nsg13_hv_nmos[ctype]
print @n.xbgr.xm36_u14.nsg13_hv_nmos[ide]
print @n.xbgr.xm36_u14.nsg13_hv_nmos[ige]
print @n.xbgr.xm36_u14.nsg13_hv_nmos[ise]
print @n.xbgr.xm36_u14.nsg13_hv_nmos[ibe]
print @n.xbgr.xm36_u14.nsg13_hv_nmos[ctype]
print @n.xbgr.xm36_u15.nsg13_hv_nmos[ide]
print @n.xbgr.xm36_u15.nsg13_hv_nmos[ige]
print @n.xbgr.xm36_u15.nsg13_hv_nmos[ise]
print @n.xbgr.xm36_u15.nsg13_hv_nmos[ibe]
print @n.xbgr.xm36_u15.nsg13_hv_nmos[ctype]
print @n.xbgr.xm36_u16.nsg13_hv_nmos[ide]
print @n.xbgr.xm36_u16.nsg13_hv_nmos[ige]
print @n.xbgr.xm36_u16.nsg13_hv_nmos[ise]
print @n.xbgr.xm36_u16.nsg13_hv_nmos[ibe]
print @n.xbgr.xm36_u16.nsg13_hv_nmos[ctype]
print @n.xbgr.xm36_u17.nsg13_hv_nmos[ide]
print @n.xbgr.xm36_u17.nsg13_hv_nmos[ige]
print @n.xbgr.xm36_u17.nsg13_hv_nmos[ise]
print @n.xbgr.xm36_u17.nsg13_hv_nmos[ibe]
print @n.xbgr.xm36_u17.nsg13_hv_nmos[ctype]
print @n.xbgr.xm36_u18.nsg13_hv_nmos[ide]
print @n.xbgr.xm36_u18.nsg13_hv_nmos[ige]
print @n.xbgr.xm36_u18.nsg13_hv_nmos[ise]
print @n.xbgr.xm36_u18.nsg13_hv_nmos[ibe]
print @n.xbgr.xm36_u18.nsg13_hv_nmos[ctype]
print @n.xbgr.xm36_u19.nsg13_hv_nmos[ide]
print @n.xbgr.xm36_u19.nsg13_hv_nmos[ige]
print @n.xbgr.xm36_u19.nsg13_hv_nmos[ise]
print @n.xbgr.xm36_u19.nsg13_hv_nmos[ibe]
print @n.xbgr.xm36_u19.nsg13_hv_nmos[ctype]
print @n.xbgr.xm36_u20.nsg13_hv_nmos[ide]
print @n.xbgr.xm36_u20.nsg13_hv_nmos[ige]
print @n.xbgr.xm36_u20.nsg13_hv_nmos[ise]
print @n.xbgr.xm36_u20.nsg13_hv_nmos[ibe]
print @n.xbgr.xm36_u20.nsg13_hv_nmos[ctype]
print @n.xbgr.xm36_u21.nsg13_hv_nmos[ide]
print @n.xbgr.xm36_u21.nsg13_hv_nmos[ige]
print @n.xbgr.xm36_u21.nsg13_hv_nmos[ise]
print @n.xbgr.xm36_u21.nsg13_hv_nmos[ibe]
print @n.xbgr.xm36_u21.nsg13_hv_nmos[ctype]
print @n.xbgr.xm36_u22.nsg13_hv_nmos[ide]
print @n.xbgr.xm36_u22.nsg13_hv_nmos[ige]
print @n.xbgr.xm36_u22.nsg13_hv_nmos[ise]
print @n.xbgr.xm36_u22.nsg13_hv_nmos[ibe]
print @n.xbgr.xm36_u22.nsg13_hv_nmos[ctype]
print @n.xbgr.xm36_u23.nsg13_hv_nmos[ide]
print @n.xbgr.xm36_u23.nsg13_hv_nmos[ige]
print @n.xbgr.xm36_u23.nsg13_hv_nmos[ise]
print @n.xbgr.xm36_u23.nsg13_hv_nmos[ibe]
print @n.xbgr.xm36_u23.nsg13_hv_nmos[ctype]
print @n.xbgr.xm36_u24.nsg13_hv_nmos[ide]
print @n.xbgr.xm36_u24.nsg13_hv_nmos[ige]
print @n.xbgr.xm36_u24.nsg13_hv_nmos[ise]
print @n.xbgr.xm36_u24.nsg13_hv_nmos[ibe]
print @n.xbgr.xm36_u24.nsg13_hv_nmos[ctype]
print @n.xbgr.xm37_u2.nsg13_hv_nmos[ide]
print @n.xbgr.xm37_u2.nsg13_hv_nmos[ige]
print @n.xbgr.xm37_u2.nsg13_hv_nmos[ise]
print @n.xbgr.xm37_u2.nsg13_hv_nmos[ibe]
print @n.xbgr.xm37_u2.nsg13_hv_nmos[ctype]
print @n.xbgr.xm37_u3.nsg13_hv_nmos[ide]
print @n.xbgr.xm37_u3.nsg13_hv_nmos[ige]
print @n.xbgr.xm37_u3.nsg13_hv_nmos[ise]
print @n.xbgr.xm37_u3.nsg13_hv_nmos[ibe]
print @n.xbgr.xm37_u3.nsg13_hv_nmos[ctype]
print @n.xbgr.xm37_u4.nsg13_hv_nmos[ide]
print @n.xbgr.xm37_u4.nsg13_hv_nmos[ige]
print @n.xbgr.xm37_u4.nsg13_hv_nmos[ise]
print @n.xbgr.xm37_u4.nsg13_hv_nmos[ibe]
print @n.xbgr.xm37_u4.nsg13_hv_nmos[ctype]
print @n.xbgr.xm37_u5.nsg13_hv_nmos[ide]
print @n.xbgr.xm37_u5.nsg13_hv_nmos[ige]
print @n.xbgr.xm37_u5.nsg13_hv_nmos[ise]
print @n.xbgr.xm37_u5.nsg13_hv_nmos[ibe]
print @n.xbgr.xm37_u5.nsg13_hv_nmos[ctype]
print @n.xbgr.xm37_u6.nsg13_hv_nmos[ide]
print @n.xbgr.xm37_u6.nsg13_hv_nmos[ige]
print @n.xbgr.xm37_u6.nsg13_hv_nmos[ise]
print @n.xbgr.xm37_u6.nsg13_hv_nmos[ibe]
print @n.xbgr.xm37_u6.nsg13_hv_nmos[ctype]
print @n.xbgr.xm37_u7.nsg13_hv_nmos[ide]
print @n.xbgr.xm37_u7.nsg13_hv_nmos[ige]
print @n.xbgr.xm37_u7.nsg13_hv_nmos[ise]
print @n.xbgr.xm37_u7.nsg13_hv_nmos[ibe]
print @n.xbgr.xm37_u7.nsg13_hv_nmos[ctype]
print @n.xbgr.xm37_u8.nsg13_hv_nmos[ide]
print @n.xbgr.xm37_u8.nsg13_hv_nmos[ige]
print @n.xbgr.xm37_u8.nsg13_hv_nmos[ise]
print @n.xbgr.xm37_u8.nsg13_hv_nmos[ibe]
print @n.xbgr.xm37_u8.nsg13_hv_nmos[ctype]
print @n.xbgr.xm37_u9.nsg13_hv_nmos[ide]
print @n.xbgr.xm37_u9.nsg13_hv_nmos[ige]
print @n.xbgr.xm37_u9.nsg13_hv_nmos[ise]
print @n.xbgr.xm37_u9.nsg13_hv_nmos[ibe]
print @n.xbgr.xm37_u9.nsg13_hv_nmos[ctype]
print @n.xbgr.xm37_u10.nsg13_hv_nmos[ide]
print @n.xbgr.xm37_u10.nsg13_hv_nmos[ige]
print @n.xbgr.xm37_u10.nsg13_hv_nmos[ise]
print @n.xbgr.xm37_u10.nsg13_hv_nmos[ibe]
print @n.xbgr.xm37_u10.nsg13_hv_nmos[ctype]
print @n.xbgr.xm37_u11.nsg13_hv_nmos[ide]
print @n.xbgr.xm37_u11.nsg13_hv_nmos[ige]
print @n.xbgr.xm37_u11.nsg13_hv_nmos[ise]
print @n.xbgr.xm37_u11.nsg13_hv_nmos[ibe]
print @n.xbgr.xm37_u11.nsg13_hv_nmos[ctype]
print @n.xbgr.xm37_u12.nsg13_hv_nmos[ide]
print @n.xbgr.xm37_u12.nsg13_hv_nmos[ige]
print @n.xbgr.xm37_u12.nsg13_hv_nmos[ise]
print @n.xbgr.xm37_u12.nsg13_hv_nmos[ibe]
print @n.xbgr.xm37_u12.nsg13_hv_nmos[ctype]
print @n.xbgr.xm37_u13.nsg13_hv_nmos[ide]
print @n.xbgr.xm37_u13.nsg13_hv_nmos[ige]
print @n.xbgr.xm37_u13.nsg13_hv_nmos[ise]
print @n.xbgr.xm37_u13.nsg13_hv_nmos[ibe]
print @n.xbgr.xm37_u13.nsg13_hv_nmos[ctype]
print @n.xbgr.xm37_u14.nsg13_hv_nmos[ide]
print @n.xbgr.xm37_u14.nsg13_hv_nmos[ige]
print @n.xbgr.xm37_u14.nsg13_hv_nmos[ise]
print @n.xbgr.xm37_u14.nsg13_hv_nmos[ibe]
print @n.xbgr.xm37_u14.nsg13_hv_nmos[ctype]
print @n.xbgr.xm37_u15.nsg13_hv_nmos[ide]
print @n.xbgr.xm37_u15.nsg13_hv_nmos[ige]
print @n.xbgr.xm37_u15.nsg13_hv_nmos[ise]
print @n.xbgr.xm37_u15.nsg13_hv_nmos[ibe]
print @n.xbgr.xm37_u15.nsg13_hv_nmos[ctype]
print @n.xbgr.xm37_u16.nsg13_hv_nmos[ide]
print @n.xbgr.xm37_u16.nsg13_hv_nmos[ige]
print @n.xbgr.xm37_u16.nsg13_hv_nmos[ise]
print @n.xbgr.xm37_u16.nsg13_hv_nmos[ibe]
print @n.xbgr.xm37_u16.nsg13_hv_nmos[ctype]
print @n.xbgr.xm37_u17.nsg13_hv_nmos[ide]
print @n.xbgr.xm37_u17.nsg13_hv_nmos[ige]
print @n.xbgr.xm37_u17.nsg13_hv_nmos[ise]
print @n.xbgr.xm37_u17.nsg13_hv_nmos[ibe]
print @n.xbgr.xm37_u17.nsg13_hv_nmos[ctype]
print @n.xbgr.xm37_u18.nsg13_hv_nmos[ide]
print @n.xbgr.xm37_u18.nsg13_hv_nmos[ige]
print @n.xbgr.xm37_u18.nsg13_hv_nmos[ise]
print @n.xbgr.xm37_u18.nsg13_hv_nmos[ibe]
print @n.xbgr.xm37_u18.nsg13_hv_nmos[ctype]
print @n.xbgr.xm37_u19.nsg13_hv_nmos[ide]
print @n.xbgr.xm37_u19.nsg13_hv_nmos[ige]
print @n.xbgr.xm37_u19.nsg13_hv_nmos[ise]
print @n.xbgr.xm37_u19.nsg13_hv_nmos[ibe]
print @n.xbgr.xm37_u19.nsg13_hv_nmos[ctype]
print @n.xbgr.xm37_u20.nsg13_hv_nmos[ide]
print @n.xbgr.xm37_u20.nsg13_hv_nmos[ige]
print @n.xbgr.xm37_u20.nsg13_hv_nmos[ise]
print @n.xbgr.xm37_u20.nsg13_hv_nmos[ibe]
print @n.xbgr.xm37_u20.nsg13_hv_nmos[ctype]
print @n.xbgr.xm37_u21.nsg13_hv_nmos[ide]
print @n.xbgr.xm37_u21.nsg13_hv_nmos[ige]
print @n.xbgr.xm37_u21.nsg13_hv_nmos[ise]
print @n.xbgr.xm37_u21.nsg13_hv_nmos[ibe]
print @n.xbgr.xm37_u21.nsg13_hv_nmos[ctype]
print @n.xbgr.xm37_u22.nsg13_hv_nmos[ide]
print @n.xbgr.xm37_u22.nsg13_hv_nmos[ige]
print @n.xbgr.xm37_u22.nsg13_hv_nmos[ise]
print @n.xbgr.xm37_u22.nsg13_hv_nmos[ibe]
print @n.xbgr.xm37_u22.nsg13_hv_nmos[ctype]
print @n.xbgr.xm37_u23.nsg13_hv_nmos[ide]
print @n.xbgr.xm37_u23.nsg13_hv_nmos[ige]
print @n.xbgr.xm37_u23.nsg13_hv_nmos[ise]
print @n.xbgr.xm37_u23.nsg13_hv_nmos[ibe]
print @n.xbgr.xm37_u23.nsg13_hv_nmos[ctype]
print @n.xbgr.xm37_u24.nsg13_hv_nmos[ide]
print @n.xbgr.xm37_u24.nsg13_hv_nmos[ige]
print @n.xbgr.xm37_u24.nsg13_hv_nmos[ise]
print @n.xbgr.xm37_u24.nsg13_hv_nmos[ibe]
print @n.xbgr.xm37_u24.nsg13_hv_nmos[ctype]
print @n.xbgr.xm38_u2.nsg13_hv_pmos[ide]
print @n.xbgr.xm38_u2.nsg13_hv_pmos[ige]
print @n.xbgr.xm38_u2.nsg13_hv_pmos[ise]
print @n.xbgr.xm38_u2.nsg13_hv_pmos[ibe]
print @n.xbgr.xm38_u2.nsg13_hv_pmos[ctype]
print @n.xbgr.xm38_u3.nsg13_hv_pmos[ide]
print @n.xbgr.xm38_u3.nsg13_hv_pmos[ige]
print @n.xbgr.xm38_u3.nsg13_hv_pmos[ise]
print @n.xbgr.xm38_u3.nsg13_hv_pmos[ibe]
print @n.xbgr.xm38_u3.nsg13_hv_pmos[ctype]
print @n.xbgr.xm38_u4.nsg13_hv_pmos[ide]
print @n.xbgr.xm38_u4.nsg13_hv_pmos[ige]
print @n.xbgr.xm38_u4.nsg13_hv_pmos[ise]
print @n.xbgr.xm38_u4.nsg13_hv_pmos[ibe]
print @n.xbgr.xm38_u4.nsg13_hv_pmos[ctype]
print @n.xbgr.xm38_u5.nsg13_hv_pmos[ide]
print @n.xbgr.xm38_u5.nsg13_hv_pmos[ige]
print @n.xbgr.xm38_u5.nsg13_hv_pmos[ise]
print @n.xbgr.xm38_u5.nsg13_hv_pmos[ibe]
print @n.xbgr.xm38_u5.nsg13_hv_pmos[ctype]
print @n.xbgr.xm38_u6.nsg13_hv_pmos[ide]
print @n.xbgr.xm38_u6.nsg13_hv_pmos[ige]
print @n.xbgr.xm38_u6.nsg13_hv_pmos[ise]
print @n.xbgr.xm38_u6.nsg13_hv_pmos[ibe]
print @n.xbgr.xm38_u6.nsg13_hv_pmos[ctype]
print @n.xbgr.xm38_u7.nsg13_hv_pmos[ide]
print @n.xbgr.xm38_u7.nsg13_hv_pmos[ige]
print @n.xbgr.xm38_u7.nsg13_hv_pmos[ise]
print @n.xbgr.xm38_u7.nsg13_hv_pmos[ibe]
print @n.xbgr.xm38_u7.nsg13_hv_pmos[ctype]
print @n.xbgr.xm38_u8.nsg13_hv_pmos[ide]
print @n.xbgr.xm38_u8.nsg13_hv_pmos[ige]
print @n.xbgr.xm38_u8.nsg13_hv_pmos[ise]
print @n.xbgr.xm38_u8.nsg13_hv_pmos[ibe]
print @n.xbgr.xm38_u8.nsg13_hv_pmos[ctype]
print @n.xbgr.xm38_u9.nsg13_hv_pmos[ide]
print @n.xbgr.xm38_u9.nsg13_hv_pmos[ige]
print @n.xbgr.xm38_u9.nsg13_hv_pmos[ise]
print @n.xbgr.xm38_u9.nsg13_hv_pmos[ibe]
print @n.xbgr.xm38_u9.nsg13_hv_pmos[ctype]
print @n.xbgr.xm38_u10.nsg13_hv_pmos[ide]
print @n.xbgr.xm38_u10.nsg13_hv_pmos[ige]
print @n.xbgr.xm38_u10.nsg13_hv_pmos[ise]
print @n.xbgr.xm38_u10.nsg13_hv_pmos[ibe]
print @n.xbgr.xm38_u10.nsg13_hv_pmos[ctype]
print @n.xbgr.xm38_u11.nsg13_hv_pmos[ide]
print @n.xbgr.xm38_u11.nsg13_hv_pmos[ige]
print @n.xbgr.xm38_u11.nsg13_hv_pmos[ise]
print @n.xbgr.xm38_u11.nsg13_hv_pmos[ibe]
print @n.xbgr.xm38_u11.nsg13_hv_pmos[ctype]
print @n.xbgr.xm38_u12.nsg13_hv_pmos[ide]
print @n.xbgr.xm38_u12.nsg13_hv_pmos[ige]
print @n.xbgr.xm38_u12.nsg13_hv_pmos[ise]
print @n.xbgr.xm38_u12.nsg13_hv_pmos[ibe]
print @n.xbgr.xm38_u12.nsg13_hv_pmos[ctype]
print @n.xbgr.xm38_u13.nsg13_hv_pmos[ide]
print @n.xbgr.xm38_u13.nsg13_hv_pmos[ige]
print @n.xbgr.xm38_u13.nsg13_hv_pmos[ise]
print @n.xbgr.xm38_u13.nsg13_hv_pmos[ibe]
print @n.xbgr.xm38_u13.nsg13_hv_pmos[ctype]
print @n.xbgr.xm38_u14.nsg13_hv_pmos[ide]
print @n.xbgr.xm38_u14.nsg13_hv_pmos[ige]
print @n.xbgr.xm38_u14.nsg13_hv_pmos[ise]
print @n.xbgr.xm38_u14.nsg13_hv_pmos[ibe]
print @n.xbgr.xm38_u14.nsg13_hv_pmos[ctype]
print @n.xbgr.xm38_u15.nsg13_hv_pmos[ide]
print @n.xbgr.xm38_u15.nsg13_hv_pmos[ige]
print @n.xbgr.xm38_u15.nsg13_hv_pmos[ise]
print @n.xbgr.xm38_u15.nsg13_hv_pmos[ibe]
print @n.xbgr.xm38_u15.nsg13_hv_pmos[ctype]
print @n.xbgr.xm38_u16.nsg13_hv_pmos[ide]
print @n.xbgr.xm38_u16.nsg13_hv_pmos[ige]
print @n.xbgr.xm38_u16.nsg13_hv_pmos[ise]
print @n.xbgr.xm38_u16.nsg13_hv_pmos[ibe]
print @n.xbgr.xm38_u16.nsg13_hv_pmos[ctype]
print @n.xbgr.xm38_u17.nsg13_hv_pmos[ide]
print @n.xbgr.xm38_u17.nsg13_hv_pmos[ige]
print @n.xbgr.xm38_u17.nsg13_hv_pmos[ise]
print @n.xbgr.xm38_u17.nsg13_hv_pmos[ibe]
print @n.xbgr.xm38_u17.nsg13_hv_pmos[ctype]
print @n.xbgr.xm38_u18.nsg13_hv_pmos[ide]
print @n.xbgr.xm38_u18.nsg13_hv_pmos[ige]
print @n.xbgr.xm38_u18.nsg13_hv_pmos[ise]
print @n.xbgr.xm38_u18.nsg13_hv_pmos[ibe]
print @n.xbgr.xm38_u18.nsg13_hv_pmos[ctype]
print @n.xbgr.xm38_u19.nsg13_hv_pmos[ide]
print @n.xbgr.xm38_u19.nsg13_hv_pmos[ige]
print @n.xbgr.xm38_u19.nsg13_hv_pmos[ise]
print @n.xbgr.xm38_u19.nsg13_hv_pmos[ibe]
print @n.xbgr.xm38_u19.nsg13_hv_pmos[ctype]
print @n.xbgr.xm38_u20.nsg13_hv_pmos[ide]
print @n.xbgr.xm38_u20.nsg13_hv_pmos[ige]
print @n.xbgr.xm38_u20.nsg13_hv_pmos[ise]
print @n.xbgr.xm38_u20.nsg13_hv_pmos[ibe]
print @n.xbgr.xm38_u20.nsg13_hv_pmos[ctype]
print @n.xbgr.xm38_u21.nsg13_hv_pmos[ide]
print @n.xbgr.xm38_u21.nsg13_hv_pmos[ige]
print @n.xbgr.xm38_u21.nsg13_hv_pmos[ise]
print @n.xbgr.xm38_u21.nsg13_hv_pmos[ibe]
print @n.xbgr.xm38_u21.nsg13_hv_pmos[ctype]
print @n.xbgr.xm38_u22.nsg13_hv_pmos[ide]
print @n.xbgr.xm38_u22.nsg13_hv_pmos[ige]
print @n.xbgr.xm38_u22.nsg13_hv_pmos[ise]
print @n.xbgr.xm38_u22.nsg13_hv_pmos[ibe]
print @n.xbgr.xm38_u22.nsg13_hv_pmos[ctype]
print @n.xbgr.xm38_u23.nsg13_hv_pmos[ide]
print @n.xbgr.xm38_u23.nsg13_hv_pmos[ige]
print @n.xbgr.xm38_u23.nsg13_hv_pmos[ise]
print @n.xbgr.xm38_u23.nsg13_hv_pmos[ibe]
print @n.xbgr.xm38_u23.nsg13_hv_pmos[ctype]
print @n.xbgr.xm38_u24.nsg13_hv_pmos[ide]
print @n.xbgr.xm38_u24.nsg13_hv_pmos[ige]
print @n.xbgr.xm38_u24.nsg13_hv_pmos[ise]
print @n.xbgr.xm38_u24.nsg13_hv_pmos[ibe]
print @n.xbgr.xm38_u24.nsg13_hv_pmos[ctype]
print @n.xbgr.xm39_u2.nsg13_hv_pmos[ide]
print @n.xbgr.xm39_u2.nsg13_hv_pmos[ige]
print @n.xbgr.xm39_u2.nsg13_hv_pmos[ise]
print @n.xbgr.xm39_u2.nsg13_hv_pmos[ibe]
print @n.xbgr.xm39_u2.nsg13_hv_pmos[ctype]
print @n.xbgr.xm39_u3.nsg13_hv_pmos[ide]
print @n.xbgr.xm39_u3.nsg13_hv_pmos[ige]
print @n.xbgr.xm39_u3.nsg13_hv_pmos[ise]
print @n.xbgr.xm39_u3.nsg13_hv_pmos[ibe]
print @n.xbgr.xm39_u3.nsg13_hv_pmos[ctype]
print @n.xbgr.xm39_u4.nsg13_hv_pmos[ide]
print @n.xbgr.xm39_u4.nsg13_hv_pmos[ige]
print @n.xbgr.xm39_u4.nsg13_hv_pmos[ise]
print @n.xbgr.xm39_u4.nsg13_hv_pmos[ibe]
print @n.xbgr.xm39_u4.nsg13_hv_pmos[ctype]
print @n.xbgr.xm39_u5.nsg13_hv_pmos[ide]
print @n.xbgr.xm39_u5.nsg13_hv_pmos[ige]
print @n.xbgr.xm39_u5.nsg13_hv_pmos[ise]
print @n.xbgr.xm39_u5.nsg13_hv_pmos[ibe]
print @n.xbgr.xm39_u5.nsg13_hv_pmos[ctype]
print @n.xbgr.xm39_u6.nsg13_hv_pmos[ide]
print @n.xbgr.xm39_u6.nsg13_hv_pmos[ige]
print @n.xbgr.xm39_u6.nsg13_hv_pmos[ise]
print @n.xbgr.xm39_u6.nsg13_hv_pmos[ibe]
print @n.xbgr.xm39_u6.nsg13_hv_pmos[ctype]
print @n.xbgr.xm39_u7.nsg13_hv_pmos[ide]
print @n.xbgr.xm39_u7.nsg13_hv_pmos[ige]
print @n.xbgr.xm39_u7.nsg13_hv_pmos[ise]
print @n.xbgr.xm39_u7.nsg13_hv_pmos[ibe]
print @n.xbgr.xm39_u7.nsg13_hv_pmos[ctype]
print @n.xbgr.xm39_u8.nsg13_hv_pmos[ide]
print @n.xbgr.xm39_u8.nsg13_hv_pmos[ige]
print @n.xbgr.xm39_u8.nsg13_hv_pmos[ise]
print @n.xbgr.xm39_u8.nsg13_hv_pmos[ibe]
print @n.xbgr.xm39_u8.nsg13_hv_pmos[ctype]
print @n.xbgr.xm39_u9.nsg13_hv_pmos[ide]
print @n.xbgr.xm39_u9.nsg13_hv_pmos[ige]
print @n.xbgr.xm39_u9.nsg13_hv_pmos[ise]
print @n.xbgr.xm39_u9.nsg13_hv_pmos[ibe]
print @n.xbgr.xm39_u9.nsg13_hv_pmos[ctype]
print @n.xbgr.xm39_u10.nsg13_hv_pmos[ide]
print @n.xbgr.xm39_u10.nsg13_hv_pmos[ige]
print @n.xbgr.xm39_u10.nsg13_hv_pmos[ise]
print @n.xbgr.xm39_u10.nsg13_hv_pmos[ibe]
print @n.xbgr.xm39_u10.nsg13_hv_pmos[ctype]
print @n.xbgr.xm39_u11.nsg13_hv_pmos[ide]
print @n.xbgr.xm39_u11.nsg13_hv_pmos[ige]
print @n.xbgr.xm39_u11.nsg13_hv_pmos[ise]
print @n.xbgr.xm39_u11.nsg13_hv_pmos[ibe]
print @n.xbgr.xm39_u11.nsg13_hv_pmos[ctype]
print @n.xbgr.xm39_u12.nsg13_hv_pmos[ide]
print @n.xbgr.xm39_u12.nsg13_hv_pmos[ige]
print @n.xbgr.xm39_u12.nsg13_hv_pmos[ise]
print @n.xbgr.xm39_u12.nsg13_hv_pmos[ibe]
print @n.xbgr.xm39_u12.nsg13_hv_pmos[ctype]
print @n.xbgr.xm39_u13.nsg13_hv_pmos[ide]
print @n.xbgr.xm39_u13.nsg13_hv_pmos[ige]
print @n.xbgr.xm39_u13.nsg13_hv_pmos[ise]
print @n.xbgr.xm39_u13.nsg13_hv_pmos[ibe]
print @n.xbgr.xm39_u13.nsg13_hv_pmos[ctype]
print @n.xbgr.xm39_u14.nsg13_hv_pmos[ide]
print @n.xbgr.xm39_u14.nsg13_hv_pmos[ige]
print @n.xbgr.xm39_u14.nsg13_hv_pmos[ise]
print @n.xbgr.xm39_u14.nsg13_hv_pmos[ibe]
print @n.xbgr.xm39_u14.nsg13_hv_pmos[ctype]
print @n.xbgr.xm39_u15.nsg13_hv_pmos[ide]
print @n.xbgr.xm39_u15.nsg13_hv_pmos[ige]
print @n.xbgr.xm39_u15.nsg13_hv_pmos[ise]
print @n.xbgr.xm39_u15.nsg13_hv_pmos[ibe]
print @n.xbgr.xm39_u15.nsg13_hv_pmos[ctype]
print @n.xbgr.xm39_u16.nsg13_hv_pmos[ide]
print @n.xbgr.xm39_u16.nsg13_hv_pmos[ige]
print @n.xbgr.xm39_u16.nsg13_hv_pmos[ise]
print @n.xbgr.xm39_u16.nsg13_hv_pmos[ibe]
print @n.xbgr.xm39_u16.nsg13_hv_pmos[ctype]
print @n.xbgr.xm39_u17.nsg13_hv_pmos[ide]
print @n.xbgr.xm39_u17.nsg13_hv_pmos[ige]
print @n.xbgr.xm39_u17.nsg13_hv_pmos[ise]
print @n.xbgr.xm39_u17.nsg13_hv_pmos[ibe]
print @n.xbgr.xm39_u17.nsg13_hv_pmos[ctype]
print @n.xbgr.xm39_u18.nsg13_hv_pmos[ide]
print @n.xbgr.xm39_u18.nsg13_hv_pmos[ige]
print @n.xbgr.xm39_u18.nsg13_hv_pmos[ise]
print @n.xbgr.xm39_u18.nsg13_hv_pmos[ibe]
print @n.xbgr.xm39_u18.nsg13_hv_pmos[ctype]
print @n.xbgr.xm39_u19.nsg13_hv_pmos[ide]
print @n.xbgr.xm39_u19.nsg13_hv_pmos[ige]
print @n.xbgr.xm39_u19.nsg13_hv_pmos[ise]
print @n.xbgr.xm39_u19.nsg13_hv_pmos[ibe]
print @n.xbgr.xm39_u19.nsg13_hv_pmos[ctype]
print @n.xbgr.xm39_u20.nsg13_hv_pmos[ide]
print @n.xbgr.xm39_u20.nsg13_hv_pmos[ige]
print @n.xbgr.xm39_u20.nsg13_hv_pmos[ise]
print @n.xbgr.xm39_u20.nsg13_hv_pmos[ibe]
print @n.xbgr.xm39_u20.nsg13_hv_pmos[ctype]
print @n.xbgr.xm39_u21.nsg13_hv_pmos[ide]
print @n.xbgr.xm39_u21.nsg13_hv_pmos[ige]
print @n.xbgr.xm39_u21.nsg13_hv_pmos[ise]
print @n.xbgr.xm39_u21.nsg13_hv_pmos[ibe]
print @n.xbgr.xm39_u21.nsg13_hv_pmos[ctype]
print @n.xbgr.xm39_u22.nsg13_hv_pmos[ide]
print @n.xbgr.xm39_u22.nsg13_hv_pmos[ige]
print @n.xbgr.xm39_u22.nsg13_hv_pmos[ise]
print @n.xbgr.xm39_u22.nsg13_hv_pmos[ibe]
print @n.xbgr.xm39_u22.nsg13_hv_pmos[ctype]
print @n.xbgr.xm39_u23.nsg13_hv_pmos[ide]
print @n.xbgr.xm39_u23.nsg13_hv_pmos[ige]
print @n.xbgr.xm39_u23.nsg13_hv_pmos[ise]
print @n.xbgr.xm39_u23.nsg13_hv_pmos[ibe]
print @n.xbgr.xm39_u23.nsg13_hv_pmos[ctype]
print @n.xbgr.xm39_u24.nsg13_hv_pmos[ide]
print @n.xbgr.xm39_u24.nsg13_hv_pmos[ige]
print @n.xbgr.xm39_u24.nsg13_hv_pmos[ise]
print @n.xbgr.xm39_u24.nsg13_hv_pmos[ibe]
print @n.xbgr.xm39_u24.nsg13_hv_pmos[ctype]
print @n.xbgr.xm41_u2.nsg13_hv_pmos[ide]
print @n.xbgr.xm41_u2.nsg13_hv_pmos[ige]
print @n.xbgr.xm41_u2.nsg13_hv_pmos[ise]
print @n.xbgr.xm41_u2.nsg13_hv_pmos[ibe]
print @n.xbgr.xm41_u2.nsg13_hv_pmos[ctype]
print @n.xbgr.xm41_u3.nsg13_hv_pmos[ide]
print @n.xbgr.xm41_u3.nsg13_hv_pmos[ige]
print @n.xbgr.xm41_u3.nsg13_hv_pmos[ise]
print @n.xbgr.xm41_u3.nsg13_hv_pmos[ibe]
print @n.xbgr.xm41_u3.nsg13_hv_pmos[ctype]
print @n.xbgr.xm41_u4.nsg13_hv_pmos[ide]
print @n.xbgr.xm41_u4.nsg13_hv_pmos[ige]
print @n.xbgr.xm41_u4.nsg13_hv_pmos[ise]
print @n.xbgr.xm41_u4.nsg13_hv_pmos[ibe]
print @n.xbgr.xm41_u4.nsg13_hv_pmos[ctype]
print @n.xbgr.xm41_u5.nsg13_hv_pmos[ide]
print @n.xbgr.xm41_u5.nsg13_hv_pmos[ige]
print @n.xbgr.xm41_u5.nsg13_hv_pmos[ise]
print @n.xbgr.xm41_u5.nsg13_hv_pmos[ibe]
print @n.xbgr.xm41_u5.nsg13_hv_pmos[ctype]
print @n.xbgr.xm41_u6.nsg13_hv_pmos[ide]
print @n.xbgr.xm41_u6.nsg13_hv_pmos[ige]
print @n.xbgr.xm41_u6.nsg13_hv_pmos[ise]
print @n.xbgr.xm41_u6.nsg13_hv_pmos[ibe]
print @n.xbgr.xm41_u6.nsg13_hv_pmos[ctype]
print @n.xbgr.xm41_u7.nsg13_hv_pmos[ide]
print @n.xbgr.xm41_u7.nsg13_hv_pmos[ige]
print @n.xbgr.xm41_u7.nsg13_hv_pmos[ise]
print @n.xbgr.xm41_u7.nsg13_hv_pmos[ibe]
print @n.xbgr.xm41_u7.nsg13_hv_pmos[ctype]
print @n.xbgr.xm41_u8.nsg13_hv_pmos[ide]
print @n.xbgr.xm41_u8.nsg13_hv_pmos[ige]
print @n.xbgr.xm41_u8.nsg13_hv_pmos[ise]
print @n.xbgr.xm41_u8.nsg13_hv_pmos[ibe]
print @n.xbgr.xm41_u8.nsg13_hv_pmos[ctype]
print @n.xbgr.xm41_u9.nsg13_hv_pmos[ide]
print @n.xbgr.xm41_u9.nsg13_hv_pmos[ige]
print @n.xbgr.xm41_u9.nsg13_hv_pmos[ise]
print @n.xbgr.xm41_u9.nsg13_hv_pmos[ibe]
print @n.xbgr.xm41_u9.nsg13_hv_pmos[ctype]
print @n.xbgr.xm41_u10.nsg13_hv_pmos[ide]
print @n.xbgr.xm41_u10.nsg13_hv_pmos[ige]
print @n.xbgr.xm41_u10.nsg13_hv_pmos[ise]
print @n.xbgr.xm41_u10.nsg13_hv_pmos[ibe]
print @n.xbgr.xm41_u10.nsg13_hv_pmos[ctype]
print @n.xbgr.xm41_u11.nsg13_hv_pmos[ide]
print @n.xbgr.xm41_u11.nsg13_hv_pmos[ige]
print @n.xbgr.xm41_u11.nsg13_hv_pmos[ise]
print @n.xbgr.xm41_u11.nsg13_hv_pmos[ibe]
print @n.xbgr.xm41_u11.nsg13_hv_pmos[ctype]
print @n.xbgr.xm41_u12.nsg13_hv_pmos[ide]
print @n.xbgr.xm41_u12.nsg13_hv_pmos[ige]
print @n.xbgr.xm41_u12.nsg13_hv_pmos[ise]
print @n.xbgr.xm41_u12.nsg13_hv_pmos[ibe]
print @n.xbgr.xm41_u12.nsg13_hv_pmos[ctype]
print @n.xbgr.xm41_u13.nsg13_hv_pmos[ide]
print @n.xbgr.xm41_u13.nsg13_hv_pmos[ige]
print @n.xbgr.xm41_u13.nsg13_hv_pmos[ise]
print @n.xbgr.xm41_u13.nsg13_hv_pmos[ibe]
print @n.xbgr.xm41_u13.nsg13_hv_pmos[ctype]
print @n.xbgr.xm41_u14.nsg13_hv_pmos[ide]
print @n.xbgr.xm41_u14.nsg13_hv_pmos[ige]
print @n.xbgr.xm41_u14.nsg13_hv_pmos[ise]
print @n.xbgr.xm41_u14.nsg13_hv_pmos[ibe]
print @n.xbgr.xm41_u14.nsg13_hv_pmos[ctype]
print @n.xbgr.xm41_u15.nsg13_hv_pmos[ide]
print @n.xbgr.xm41_u15.nsg13_hv_pmos[ige]
print @n.xbgr.xm41_u15.nsg13_hv_pmos[ise]
print @n.xbgr.xm41_u15.nsg13_hv_pmos[ibe]
print @n.xbgr.xm41_u15.nsg13_hv_pmos[ctype]
print @n.xbgr.xm41_u16.nsg13_hv_pmos[ide]
print @n.xbgr.xm41_u16.nsg13_hv_pmos[ige]
print @n.xbgr.xm41_u16.nsg13_hv_pmos[ise]
print @n.xbgr.xm41_u16.nsg13_hv_pmos[ibe]
print @n.xbgr.xm41_u16.nsg13_hv_pmos[ctype]
print @n.xbgr.xm41_u17.nsg13_hv_pmos[ide]
print @n.xbgr.xm41_u17.nsg13_hv_pmos[ige]
print @n.xbgr.xm41_u17.nsg13_hv_pmos[ise]
print @n.xbgr.xm41_u17.nsg13_hv_pmos[ibe]
print @n.xbgr.xm41_u17.nsg13_hv_pmos[ctype]
print @n.xbgr.xm41_u18.nsg13_hv_pmos[ide]
print @n.xbgr.xm41_u18.nsg13_hv_pmos[ige]
print @n.xbgr.xm41_u18.nsg13_hv_pmos[ise]
print @n.xbgr.xm41_u18.nsg13_hv_pmos[ibe]
print @n.xbgr.xm41_u18.nsg13_hv_pmos[ctype]
print @n.xbgr.xm41_u19.nsg13_hv_pmos[ide]
print @n.xbgr.xm41_u19.nsg13_hv_pmos[ige]
print @n.xbgr.xm41_u19.nsg13_hv_pmos[ise]
print @n.xbgr.xm41_u19.nsg13_hv_pmos[ibe]
print @n.xbgr.xm41_u19.nsg13_hv_pmos[ctype]
print @n.xbgr.xm41_u20.nsg13_hv_pmos[ide]
print @n.xbgr.xm41_u20.nsg13_hv_pmos[ige]
print @n.xbgr.xm41_u20.nsg13_hv_pmos[ise]
print @n.xbgr.xm41_u20.nsg13_hv_pmos[ibe]
print @n.xbgr.xm41_u20.nsg13_hv_pmos[ctype]
print @n.xbgr.xm41_u21.nsg13_hv_pmos[ide]
print @n.xbgr.xm41_u21.nsg13_hv_pmos[ige]
print @n.xbgr.xm41_u21.nsg13_hv_pmos[ise]
print @n.xbgr.xm41_u21.nsg13_hv_pmos[ibe]
print @n.xbgr.xm41_u21.nsg13_hv_pmos[ctype]
print @n.xbgr.xm41_u22.nsg13_hv_pmos[ide]
print @n.xbgr.xm41_u22.nsg13_hv_pmos[ige]
print @n.xbgr.xm41_u22.nsg13_hv_pmos[ise]
print @n.xbgr.xm41_u22.nsg13_hv_pmos[ibe]
print @n.xbgr.xm41_u22.nsg13_hv_pmos[ctype]
print @n.xbgr.xm41_u23.nsg13_hv_pmos[ide]
print @n.xbgr.xm41_u23.nsg13_hv_pmos[ige]
print @n.xbgr.xm41_u23.nsg13_hv_pmos[ise]
print @n.xbgr.xm41_u23.nsg13_hv_pmos[ibe]
print @n.xbgr.xm41_u23.nsg13_hv_pmos[ctype]
print @n.xbgr.xm41_u24.nsg13_hv_pmos[ide]
print @n.xbgr.xm41_u24.nsg13_hv_pmos[ige]
print @n.xbgr.xm41_u24.nsg13_hv_pmos[ise]
print @n.xbgr.xm41_u24.nsg13_hv_pmos[ibe]
print @n.xbgr.xm41_u24.nsg13_hv_pmos[ctype]
print @n.xbgr.xm43_u2.nsg13_hv_pmos[ide]
print @n.xbgr.xm43_u2.nsg13_hv_pmos[ige]
print @n.xbgr.xm43_u2.nsg13_hv_pmos[ise]
print @n.xbgr.xm43_u2.nsg13_hv_pmos[ibe]
print @n.xbgr.xm43_u2.nsg13_hv_pmos[ctype]
print @n.xbgr.xm43_u3.nsg13_hv_pmos[ide]
print @n.xbgr.xm43_u3.nsg13_hv_pmos[ige]
print @n.xbgr.xm43_u3.nsg13_hv_pmos[ise]
print @n.xbgr.xm43_u3.nsg13_hv_pmos[ibe]
print @n.xbgr.xm43_u3.nsg13_hv_pmos[ctype]
print @n.xbgr.xm43_u4.nsg13_hv_pmos[ide]
print @n.xbgr.xm43_u4.nsg13_hv_pmos[ige]
print @n.xbgr.xm43_u4.nsg13_hv_pmos[ise]
print @n.xbgr.xm43_u4.nsg13_hv_pmos[ibe]
print @n.xbgr.xm43_u4.nsg13_hv_pmos[ctype]
print @n.xbgr.xm44_u2.nsg13_hv_pmos[ide]
print @n.xbgr.xm44_u2.nsg13_hv_pmos[ige]
print @n.xbgr.xm44_u2.nsg13_hv_pmos[ise]
print @n.xbgr.xm44_u2.nsg13_hv_pmos[ibe]
print @n.xbgr.xm44_u2.nsg13_hv_pmos[ctype]
print @n.xbgr.xm44_u3.nsg13_hv_pmos[ide]
print @n.xbgr.xm44_u3.nsg13_hv_pmos[ige]
print @n.xbgr.xm44_u3.nsg13_hv_pmos[ise]
print @n.xbgr.xm44_u3.nsg13_hv_pmos[ibe]
print @n.xbgr.xm44_u3.nsg13_hv_pmos[ctype]
print @n.xbgr.xm44_u4.nsg13_hv_pmos[ide]
print @n.xbgr.xm44_u4.nsg13_hv_pmos[ige]
print @n.xbgr.xm44_u4.nsg13_hv_pmos[ise]
print @n.xbgr.xm44_u4.nsg13_hv_pmos[ibe]
print @n.xbgr.xm44_u4.nsg13_hv_pmos[ctype]
print @n.xbgr.xm45_u2.nsg13_hv_pmos[ide]
print @n.xbgr.xm45_u2.nsg13_hv_pmos[ige]
print @n.xbgr.xm45_u2.nsg13_hv_pmos[ise]
print @n.xbgr.xm45_u2.nsg13_hv_pmos[ibe]
print @n.xbgr.xm45_u2.nsg13_hv_pmos[ctype]
print @n.xbgr.xm45_u3.nsg13_hv_pmos[ide]
print @n.xbgr.xm45_u3.nsg13_hv_pmos[ige]
print @n.xbgr.xm45_u3.nsg13_hv_pmos[ise]
print @n.xbgr.xm45_u3.nsg13_hv_pmos[ibe]
print @n.xbgr.xm45_u3.nsg13_hv_pmos[ctype]
print @n.xbgr.xm45_u4.nsg13_hv_pmos[ide]
print @n.xbgr.xm45_u4.nsg13_hv_pmos[ige]
print @n.xbgr.xm45_u4.nsg13_hv_pmos[ise]
print @n.xbgr.xm45_u4.nsg13_hv_pmos[ibe]
print @n.xbgr.xm45_u4.nsg13_hv_pmos[ctype]
print @n.xbgr.xm45_u5.nsg13_hv_pmos[ide]
print @n.xbgr.xm45_u5.nsg13_hv_pmos[ige]
print @n.xbgr.xm45_u5.nsg13_hv_pmos[ise]
print @n.xbgr.xm45_u5.nsg13_hv_pmos[ibe]
print @n.xbgr.xm45_u5.nsg13_hv_pmos[ctype]
print @n.xbgr.xm45_u6.nsg13_hv_pmos[ide]
print @n.xbgr.xm45_u6.nsg13_hv_pmos[ige]
print @n.xbgr.xm45_u6.nsg13_hv_pmos[ise]
print @n.xbgr.xm45_u6.nsg13_hv_pmos[ibe]
print @n.xbgr.xm45_u6.nsg13_hv_pmos[ctype]
print @n.xbgr.xm45_u7.nsg13_hv_pmos[ide]
print @n.xbgr.xm45_u7.nsg13_hv_pmos[ige]
print @n.xbgr.xm45_u7.nsg13_hv_pmos[ise]
print @n.xbgr.xm45_u7.nsg13_hv_pmos[ibe]
print @n.xbgr.xm45_u7.nsg13_hv_pmos[ctype]
print @n.xbgr.xm45_u8.nsg13_hv_pmos[ide]
print @n.xbgr.xm45_u8.nsg13_hv_pmos[ige]
print @n.xbgr.xm45_u8.nsg13_hv_pmos[ise]
print @n.xbgr.xm45_u8.nsg13_hv_pmos[ibe]
print @n.xbgr.xm45_u8.nsg13_hv_pmos[ctype]
print @n.xbgr.xm45_u9.nsg13_hv_pmos[ide]
print @n.xbgr.xm45_u9.nsg13_hv_pmos[ige]
print @n.xbgr.xm45_u9.nsg13_hv_pmos[ise]
print @n.xbgr.xm45_u9.nsg13_hv_pmos[ibe]
print @n.xbgr.xm45_u9.nsg13_hv_pmos[ctype]
print @n.xbgr.xm45_u10.nsg13_hv_pmos[ide]
print @n.xbgr.xm45_u10.nsg13_hv_pmos[ige]
print @n.xbgr.xm45_u10.nsg13_hv_pmos[ise]
print @n.xbgr.xm45_u10.nsg13_hv_pmos[ibe]
print @n.xbgr.xm45_u10.nsg13_hv_pmos[ctype]
print @n.xbgr.xm45_u11.nsg13_hv_pmos[ide]
print @n.xbgr.xm45_u11.nsg13_hv_pmos[ige]
print @n.xbgr.xm45_u11.nsg13_hv_pmos[ise]
print @n.xbgr.xm45_u11.nsg13_hv_pmos[ibe]
print @n.xbgr.xm45_u11.nsg13_hv_pmos[ctype]
print @n.xbgr.xm45_u12.nsg13_hv_pmos[ide]
print @n.xbgr.xm45_u12.nsg13_hv_pmos[ige]
print @n.xbgr.xm45_u12.nsg13_hv_pmos[ise]
print @n.xbgr.xm45_u12.nsg13_hv_pmos[ibe]
print @n.xbgr.xm45_u12.nsg13_hv_pmos[ctype]
print @n.xbgr.xm45_u13.nsg13_hv_pmos[ide]
print @n.xbgr.xm45_u13.nsg13_hv_pmos[ige]
print @n.xbgr.xm45_u13.nsg13_hv_pmos[ise]
print @n.xbgr.xm45_u13.nsg13_hv_pmos[ibe]
print @n.xbgr.xm45_u13.nsg13_hv_pmos[ctype]
print @n.xbgr.xm45_u14.nsg13_hv_pmos[ide]
print @n.xbgr.xm45_u14.nsg13_hv_pmos[ige]
print @n.xbgr.xm45_u14.nsg13_hv_pmos[ise]
print @n.xbgr.xm45_u14.nsg13_hv_pmos[ibe]
print @n.xbgr.xm45_u14.nsg13_hv_pmos[ctype]
print @n.xbgr.xm45_u15.nsg13_hv_pmos[ide]
print @n.xbgr.xm45_u15.nsg13_hv_pmos[ige]
print @n.xbgr.xm45_u15.nsg13_hv_pmos[ise]
print @n.xbgr.xm45_u15.nsg13_hv_pmos[ibe]
print @n.xbgr.xm45_u15.nsg13_hv_pmos[ctype]
print @n.xbgr.xm45_u16.nsg13_hv_pmos[ide]
print @n.xbgr.xm45_u16.nsg13_hv_pmos[ige]
print @n.xbgr.xm45_u16.nsg13_hv_pmos[ise]
print @n.xbgr.xm45_u16.nsg13_hv_pmos[ibe]
print @n.xbgr.xm45_u16.nsg13_hv_pmos[ctype]
print @n.xbgr.xm45_u17.nsg13_hv_pmos[ide]
print @n.xbgr.xm45_u17.nsg13_hv_pmos[ige]
print @n.xbgr.xm45_u17.nsg13_hv_pmos[ise]
print @n.xbgr.xm45_u17.nsg13_hv_pmos[ibe]
print @n.xbgr.xm45_u17.nsg13_hv_pmos[ctype]
print @n.xbgr.xm45_u18.nsg13_hv_pmos[ide]
print @n.xbgr.xm45_u18.nsg13_hv_pmos[ige]
print @n.xbgr.xm45_u18.nsg13_hv_pmos[ise]
print @n.xbgr.xm45_u18.nsg13_hv_pmos[ibe]
print @n.xbgr.xm45_u18.nsg13_hv_pmos[ctype]
print @n.xbgr.xm45_u19.nsg13_hv_pmos[ide]
print @n.xbgr.xm45_u19.nsg13_hv_pmos[ige]
print @n.xbgr.xm45_u19.nsg13_hv_pmos[ise]
print @n.xbgr.xm45_u19.nsg13_hv_pmos[ibe]
print @n.xbgr.xm45_u19.nsg13_hv_pmos[ctype]
print @n.xbgr.xm45_u20.nsg13_hv_pmos[ide]
print @n.xbgr.xm45_u20.nsg13_hv_pmos[ige]
print @n.xbgr.xm45_u20.nsg13_hv_pmos[ise]
print @n.xbgr.xm45_u20.nsg13_hv_pmos[ibe]
print @n.xbgr.xm45_u20.nsg13_hv_pmos[ctype]
print @n.xbgr.xm45_u21.nsg13_hv_pmos[ide]
print @n.xbgr.xm45_u21.nsg13_hv_pmos[ige]
print @n.xbgr.xm45_u21.nsg13_hv_pmos[ise]
print @n.xbgr.xm45_u21.nsg13_hv_pmos[ibe]
print @n.xbgr.xm45_u21.nsg13_hv_pmos[ctype]
print @n.xbgr.xm45_u22.nsg13_hv_pmos[ide]
print @n.xbgr.xm45_u22.nsg13_hv_pmos[ige]
print @n.xbgr.xm45_u22.nsg13_hv_pmos[ise]
print @n.xbgr.xm45_u22.nsg13_hv_pmos[ibe]
print @n.xbgr.xm45_u22.nsg13_hv_pmos[ctype]
print @n.xbgr.xm45_u23.nsg13_hv_pmos[ide]
print @n.xbgr.xm45_u23.nsg13_hv_pmos[ige]
print @n.xbgr.xm45_u23.nsg13_hv_pmos[ise]
print @n.xbgr.xm45_u23.nsg13_hv_pmos[ibe]
print @n.xbgr.xm45_u23.nsg13_hv_pmos[ctype]
print @n.xbgr.xm45_u24.nsg13_hv_pmos[ide]
print @n.xbgr.xm45_u24.nsg13_hv_pmos[ige]
print @n.xbgr.xm45_u24.nsg13_hv_pmos[ise]
print @n.xbgr.xm45_u24.nsg13_hv_pmos[ibe]
print @n.xbgr.xm45_u24.nsg13_hv_pmos[ctype]
print @n.xbgr.xm47_u2.nsg13_hv_pmos[ide]
print @n.xbgr.xm47_u2.nsg13_hv_pmos[ige]
print @n.xbgr.xm47_u2.nsg13_hv_pmos[ise]
print @n.xbgr.xm47_u2.nsg13_hv_pmos[ibe]
print @n.xbgr.xm47_u2.nsg13_hv_pmos[ctype]
print @n.xbgr.xm47_u3.nsg13_hv_pmos[ide]
print @n.xbgr.xm47_u3.nsg13_hv_pmos[ige]
print @n.xbgr.xm47_u3.nsg13_hv_pmos[ise]
print @n.xbgr.xm47_u3.nsg13_hv_pmos[ibe]
print @n.xbgr.xm47_u3.nsg13_hv_pmos[ctype]
print @n.xbgr.xm47_u4.nsg13_hv_pmos[ide]
print @n.xbgr.xm47_u4.nsg13_hv_pmos[ige]
print @n.xbgr.xm47_u4.nsg13_hv_pmos[ise]
print @n.xbgr.xm47_u4.nsg13_hv_pmos[ibe]
print @n.xbgr.xm47_u4.nsg13_hv_pmos[ctype]
print @n.xbgr.xm47_u5.nsg13_hv_pmos[ide]
print @n.xbgr.xm47_u5.nsg13_hv_pmos[ige]
print @n.xbgr.xm47_u5.nsg13_hv_pmos[ise]
print @n.xbgr.xm47_u5.nsg13_hv_pmos[ibe]
print @n.xbgr.xm47_u5.nsg13_hv_pmos[ctype]
print @n.xbgr.xm47_u6.nsg13_hv_pmos[ide]
print @n.xbgr.xm47_u6.nsg13_hv_pmos[ige]
print @n.xbgr.xm47_u6.nsg13_hv_pmos[ise]
print @n.xbgr.xm47_u6.nsg13_hv_pmos[ibe]
print @n.xbgr.xm47_u6.nsg13_hv_pmos[ctype]
print @n.xbgr.xm47_u7.nsg13_hv_pmos[ide]
print @n.xbgr.xm47_u7.nsg13_hv_pmos[ige]
print @n.xbgr.xm47_u7.nsg13_hv_pmos[ise]
print @n.xbgr.xm47_u7.nsg13_hv_pmos[ibe]
print @n.xbgr.xm47_u7.nsg13_hv_pmos[ctype]
print @n.xbgr.xm47_u8.nsg13_hv_pmos[ide]
print @n.xbgr.xm47_u8.nsg13_hv_pmos[ige]
print @n.xbgr.xm47_u8.nsg13_hv_pmos[ise]
print @n.xbgr.xm47_u8.nsg13_hv_pmos[ibe]
print @n.xbgr.xm47_u8.nsg13_hv_pmos[ctype]
print @n.xbgr.xm47_u9.nsg13_hv_pmos[ide]
print @n.xbgr.xm47_u9.nsg13_hv_pmos[ige]
print @n.xbgr.xm47_u9.nsg13_hv_pmos[ise]
print @n.xbgr.xm47_u9.nsg13_hv_pmos[ibe]
print @n.xbgr.xm47_u9.nsg13_hv_pmos[ctype]
print @n.xbgr.xm47_u10.nsg13_hv_pmos[ide]
print @n.xbgr.xm47_u10.nsg13_hv_pmos[ige]
print @n.xbgr.xm47_u10.nsg13_hv_pmos[ise]
print @n.xbgr.xm47_u10.nsg13_hv_pmos[ibe]
print @n.xbgr.xm47_u10.nsg13_hv_pmos[ctype]
print @n.xbgr.xm47_u11.nsg13_hv_pmos[ide]
print @n.xbgr.xm47_u11.nsg13_hv_pmos[ige]
print @n.xbgr.xm47_u11.nsg13_hv_pmos[ise]
print @n.xbgr.xm47_u11.nsg13_hv_pmos[ibe]
print @n.xbgr.xm47_u11.nsg13_hv_pmos[ctype]
print @n.xbgr.xm47_u12.nsg13_hv_pmos[ide]
print @n.xbgr.xm47_u12.nsg13_hv_pmos[ige]
print @n.xbgr.xm47_u12.nsg13_hv_pmos[ise]
print @n.xbgr.xm47_u12.nsg13_hv_pmos[ibe]
print @n.xbgr.xm47_u12.nsg13_hv_pmos[ctype]
print @n.xbgr.xm47_u13.nsg13_hv_pmos[ide]
print @n.xbgr.xm47_u13.nsg13_hv_pmos[ige]
print @n.xbgr.xm47_u13.nsg13_hv_pmos[ise]
print @n.xbgr.xm47_u13.nsg13_hv_pmos[ibe]
print @n.xbgr.xm47_u13.nsg13_hv_pmos[ctype]
print @n.xbgr.xm47_u14.nsg13_hv_pmos[ide]
print @n.xbgr.xm47_u14.nsg13_hv_pmos[ige]
print @n.xbgr.xm47_u14.nsg13_hv_pmos[ise]
print @n.xbgr.xm47_u14.nsg13_hv_pmos[ibe]
print @n.xbgr.xm47_u14.nsg13_hv_pmos[ctype]
print @n.xbgr.xm47_u15.nsg13_hv_pmos[ide]
print @n.xbgr.xm47_u15.nsg13_hv_pmos[ige]
print @n.xbgr.xm47_u15.nsg13_hv_pmos[ise]
print @n.xbgr.xm47_u15.nsg13_hv_pmos[ibe]
print @n.xbgr.xm47_u15.nsg13_hv_pmos[ctype]
print @n.xbgr.xm47_u16.nsg13_hv_pmos[ide]
print @n.xbgr.xm47_u16.nsg13_hv_pmos[ige]
print @n.xbgr.xm47_u16.nsg13_hv_pmos[ise]
print @n.xbgr.xm47_u16.nsg13_hv_pmos[ibe]
print @n.xbgr.xm47_u16.nsg13_hv_pmos[ctype]
print @n.xbgr.xm47_u17.nsg13_hv_pmos[ide]
print @n.xbgr.xm47_u17.nsg13_hv_pmos[ige]
print @n.xbgr.xm47_u17.nsg13_hv_pmos[ise]
print @n.xbgr.xm47_u17.nsg13_hv_pmos[ibe]
print @n.xbgr.xm47_u17.nsg13_hv_pmos[ctype]
print @n.xbgr.xm47_u18.nsg13_hv_pmos[ide]
print @n.xbgr.xm47_u18.nsg13_hv_pmos[ige]
print @n.xbgr.xm47_u18.nsg13_hv_pmos[ise]
print @n.xbgr.xm47_u18.nsg13_hv_pmos[ibe]
print @n.xbgr.xm47_u18.nsg13_hv_pmos[ctype]
print @n.xbgr.xm47_u19.nsg13_hv_pmos[ide]
print @n.xbgr.xm47_u19.nsg13_hv_pmos[ige]
print @n.xbgr.xm47_u19.nsg13_hv_pmos[ise]
print @n.xbgr.xm47_u19.nsg13_hv_pmos[ibe]
print @n.xbgr.xm47_u19.nsg13_hv_pmos[ctype]
print @n.xbgr.xm47_u20.nsg13_hv_pmos[ide]
print @n.xbgr.xm47_u20.nsg13_hv_pmos[ige]
print @n.xbgr.xm47_u20.nsg13_hv_pmos[ise]
print @n.xbgr.xm47_u20.nsg13_hv_pmos[ibe]
print @n.xbgr.xm47_u20.nsg13_hv_pmos[ctype]
print @n.xbgr.xm47_u21.nsg13_hv_pmos[ide]
print @n.xbgr.xm47_u21.nsg13_hv_pmos[ige]
print @n.xbgr.xm47_u21.nsg13_hv_pmos[ise]
print @n.xbgr.xm47_u21.nsg13_hv_pmos[ibe]
print @n.xbgr.xm47_u21.nsg13_hv_pmos[ctype]
print @n.xbgr.xm47_u22.nsg13_hv_pmos[ide]
print @n.xbgr.xm47_u22.nsg13_hv_pmos[ige]
print @n.xbgr.xm47_u22.nsg13_hv_pmos[ise]
print @n.xbgr.xm47_u22.nsg13_hv_pmos[ibe]
print @n.xbgr.xm47_u22.nsg13_hv_pmos[ctype]
print @n.xbgr.xm47_u23.nsg13_hv_pmos[ide]
print @n.xbgr.xm47_u23.nsg13_hv_pmos[ige]
print @n.xbgr.xm47_u23.nsg13_hv_pmos[ise]
print @n.xbgr.xm47_u23.nsg13_hv_pmos[ibe]
print @n.xbgr.xm47_u23.nsg13_hv_pmos[ctype]
print @n.xbgr.xm47_u24.nsg13_hv_pmos[ide]
print @n.xbgr.xm47_u24.nsg13_hv_pmos[ige]
print @n.xbgr.xm47_u24.nsg13_hv_pmos[ise]
print @n.xbgr.xm47_u24.nsg13_hv_pmos[ibe]
print @n.xbgr.xm47_u24.nsg13_hv_pmos[ctype]
print @n.xbgr.xm48_u2.nsg13_hv_pmos[ide]
print @n.xbgr.xm48_u2.nsg13_hv_pmos[ige]
print @n.xbgr.xm48_u2.nsg13_hv_pmos[ise]
print @n.xbgr.xm48_u2.nsg13_hv_pmos[ibe]
print @n.xbgr.xm48_u2.nsg13_hv_pmos[ctype]
print @n.xbgr.xm48_u3.nsg13_hv_pmos[ide]
print @n.xbgr.xm48_u3.nsg13_hv_pmos[ige]
print @n.xbgr.xm48_u3.nsg13_hv_pmos[ise]
print @n.xbgr.xm48_u3.nsg13_hv_pmos[ibe]
print @n.xbgr.xm48_u3.nsg13_hv_pmos[ctype]
print @n.xbgr.xm48_u4.nsg13_hv_pmos[ide]
print @n.xbgr.xm48_u4.nsg13_hv_pmos[ige]
print @n.xbgr.xm48_u4.nsg13_hv_pmos[ise]
print @n.xbgr.xm48_u4.nsg13_hv_pmos[ibe]
print @n.xbgr.xm48_u4.nsg13_hv_pmos[ctype]
print @n.xbgr.xm48_u5.nsg13_hv_pmos[ide]
print @n.xbgr.xm48_u5.nsg13_hv_pmos[ige]
print @n.xbgr.xm48_u5.nsg13_hv_pmos[ise]
print @n.xbgr.xm48_u5.nsg13_hv_pmos[ibe]
print @n.xbgr.xm48_u5.nsg13_hv_pmos[ctype]
print @n.xbgr.xm48_u6.nsg13_hv_pmos[ide]
print @n.xbgr.xm48_u6.nsg13_hv_pmos[ige]
print @n.xbgr.xm48_u6.nsg13_hv_pmos[ise]
print @n.xbgr.xm48_u6.nsg13_hv_pmos[ibe]
print @n.xbgr.xm48_u6.nsg13_hv_pmos[ctype]
print @n.xbgr.xm48_u7.nsg13_hv_pmos[ide]
print @n.xbgr.xm48_u7.nsg13_hv_pmos[ige]
print @n.xbgr.xm48_u7.nsg13_hv_pmos[ise]
print @n.xbgr.xm48_u7.nsg13_hv_pmos[ibe]
print @n.xbgr.xm48_u7.nsg13_hv_pmos[ctype]
print @n.xbgr.xm48_u8.nsg13_hv_pmos[ide]
print @n.xbgr.xm48_u8.nsg13_hv_pmos[ige]
print @n.xbgr.xm48_u8.nsg13_hv_pmos[ise]
print @n.xbgr.xm48_u8.nsg13_hv_pmos[ibe]
print @n.xbgr.xm48_u8.nsg13_hv_pmos[ctype]
print @n.xbgr.xm48_u9.nsg13_hv_pmos[ide]
print @n.xbgr.xm48_u9.nsg13_hv_pmos[ige]
print @n.xbgr.xm48_u9.nsg13_hv_pmos[ise]
print @n.xbgr.xm48_u9.nsg13_hv_pmos[ibe]
print @n.xbgr.xm48_u9.nsg13_hv_pmos[ctype]
print @n.xbgr.xm48_u10.nsg13_hv_pmos[ide]
print @n.xbgr.xm48_u10.nsg13_hv_pmos[ige]
print @n.xbgr.xm48_u10.nsg13_hv_pmos[ise]
print @n.xbgr.xm48_u10.nsg13_hv_pmos[ibe]
print @n.xbgr.xm48_u10.nsg13_hv_pmos[ctype]
print @n.xbgr.xm48_u11.nsg13_hv_pmos[ide]
print @n.xbgr.xm48_u11.nsg13_hv_pmos[ige]
print @n.xbgr.xm48_u11.nsg13_hv_pmos[ise]
print @n.xbgr.xm48_u11.nsg13_hv_pmos[ibe]
print @n.xbgr.xm48_u11.nsg13_hv_pmos[ctype]
print @n.xbgr.xm48_u12.nsg13_hv_pmos[ide]
print @n.xbgr.xm48_u12.nsg13_hv_pmos[ige]
print @n.xbgr.xm48_u12.nsg13_hv_pmos[ise]
print @n.xbgr.xm48_u12.nsg13_hv_pmos[ibe]
print @n.xbgr.xm48_u12.nsg13_hv_pmos[ctype]
print @n.xbgr.xm48_u13.nsg13_hv_pmos[ide]
print @n.xbgr.xm48_u13.nsg13_hv_pmos[ige]
print @n.xbgr.xm48_u13.nsg13_hv_pmos[ise]
print @n.xbgr.xm48_u13.nsg13_hv_pmos[ibe]
print @n.xbgr.xm48_u13.nsg13_hv_pmos[ctype]
print @n.xbgr.xm48_u14.nsg13_hv_pmos[ide]
print @n.xbgr.xm48_u14.nsg13_hv_pmos[ige]
print @n.xbgr.xm48_u14.nsg13_hv_pmos[ise]
print @n.xbgr.xm48_u14.nsg13_hv_pmos[ibe]
print @n.xbgr.xm48_u14.nsg13_hv_pmos[ctype]
print @n.xbgr.xm48_u15.nsg13_hv_pmos[ide]
print @n.xbgr.xm48_u15.nsg13_hv_pmos[ige]
print @n.xbgr.xm48_u15.nsg13_hv_pmos[ise]
print @n.xbgr.xm48_u15.nsg13_hv_pmos[ibe]
print @n.xbgr.xm48_u15.nsg13_hv_pmos[ctype]
print @n.xbgr.xm48_u16.nsg13_hv_pmos[ide]
print @n.xbgr.xm48_u16.nsg13_hv_pmos[ige]
print @n.xbgr.xm48_u16.nsg13_hv_pmos[ise]
print @n.xbgr.xm48_u16.nsg13_hv_pmos[ibe]
print @n.xbgr.xm48_u16.nsg13_hv_pmos[ctype]
print @n.xbgr.xm48_u17.nsg13_hv_pmos[ide]
print @n.xbgr.xm48_u17.nsg13_hv_pmos[ige]
print @n.xbgr.xm48_u17.nsg13_hv_pmos[ise]
print @n.xbgr.xm48_u17.nsg13_hv_pmos[ibe]
print @n.xbgr.xm48_u17.nsg13_hv_pmos[ctype]
print @n.xbgr.xm48_u18.nsg13_hv_pmos[ide]
print @n.xbgr.xm48_u18.nsg13_hv_pmos[ige]
print @n.xbgr.xm48_u18.nsg13_hv_pmos[ise]
print @n.xbgr.xm48_u18.nsg13_hv_pmos[ibe]
print @n.xbgr.xm48_u18.nsg13_hv_pmos[ctype]
print @n.xbgr.xm48_u19.nsg13_hv_pmos[ide]
print @n.xbgr.xm48_u19.nsg13_hv_pmos[ige]
print @n.xbgr.xm48_u19.nsg13_hv_pmos[ise]
print @n.xbgr.xm48_u19.nsg13_hv_pmos[ibe]
print @n.xbgr.xm48_u19.nsg13_hv_pmos[ctype]
print @n.xbgr.xm48_u20.nsg13_hv_pmos[ide]
print @n.xbgr.xm48_u20.nsg13_hv_pmos[ige]
print @n.xbgr.xm48_u20.nsg13_hv_pmos[ise]
print @n.xbgr.xm48_u20.nsg13_hv_pmos[ibe]
print @n.xbgr.xm48_u20.nsg13_hv_pmos[ctype]
print @n.xbgr.xm48_u21.nsg13_hv_pmos[ide]
print @n.xbgr.xm48_u21.nsg13_hv_pmos[ige]
print @n.xbgr.xm48_u21.nsg13_hv_pmos[ise]
print @n.xbgr.xm48_u21.nsg13_hv_pmos[ibe]
print @n.xbgr.xm48_u21.nsg13_hv_pmos[ctype]
print @n.xbgr.xm48_u22.nsg13_hv_pmos[ide]
print @n.xbgr.xm48_u22.nsg13_hv_pmos[ige]
print @n.xbgr.xm48_u22.nsg13_hv_pmos[ise]
print @n.xbgr.xm48_u22.nsg13_hv_pmos[ibe]
print @n.xbgr.xm48_u22.nsg13_hv_pmos[ctype]
print @n.xbgr.xm48_u23.nsg13_hv_pmos[ide]
print @n.xbgr.xm48_u23.nsg13_hv_pmos[ige]
print @n.xbgr.xm48_u23.nsg13_hv_pmos[ise]
print @n.xbgr.xm48_u23.nsg13_hv_pmos[ibe]
print @n.xbgr.xm48_u23.nsg13_hv_pmos[ctype]
print @n.xbgr.xm48_u24.nsg13_hv_pmos[ide]
print @n.xbgr.xm48_u24.nsg13_hv_pmos[ige]
print @n.xbgr.xm48_u24.nsg13_hv_pmos[ise]
print @n.xbgr.xm48_u24.nsg13_hv_pmos[ibe]
print @n.xbgr.xm48_u24.nsg13_hv_pmos[ctype]
print @n.xbgr.xm50_u2.nsg13_hv_pmos[ide]
print @n.xbgr.xm50_u2.nsg13_hv_pmos[ige]
print @n.xbgr.xm50_u2.nsg13_hv_pmos[ise]
print @n.xbgr.xm50_u2.nsg13_hv_pmos[ibe]
print @n.xbgr.xm50_u2.nsg13_hv_pmos[ctype]
print @n.xbgr.xm50_u3.nsg13_hv_pmos[ide]
print @n.xbgr.xm50_u3.nsg13_hv_pmos[ige]
print @n.xbgr.xm50_u3.nsg13_hv_pmos[ise]
print @n.xbgr.xm50_u3.nsg13_hv_pmos[ibe]
print @n.xbgr.xm50_u3.nsg13_hv_pmos[ctype]
print @n.xbgr.xm50_u4.nsg13_hv_pmos[ide]
print @n.xbgr.xm50_u4.nsg13_hv_pmos[ige]
print @n.xbgr.xm50_u4.nsg13_hv_pmos[ise]
print @n.xbgr.xm50_u4.nsg13_hv_pmos[ibe]
print @n.xbgr.xm50_u4.nsg13_hv_pmos[ctype]
print @n.xbgr.xm50_u5.nsg13_hv_pmos[ide]
print @n.xbgr.xm50_u5.nsg13_hv_pmos[ige]
print @n.xbgr.xm50_u5.nsg13_hv_pmos[ise]
print @n.xbgr.xm50_u5.nsg13_hv_pmos[ibe]
print @n.xbgr.xm50_u5.nsg13_hv_pmos[ctype]
print @n.xbgr.xm50_u6.nsg13_hv_pmos[ide]
print @n.xbgr.xm50_u6.nsg13_hv_pmos[ige]
print @n.xbgr.xm50_u6.nsg13_hv_pmos[ise]
print @n.xbgr.xm50_u6.nsg13_hv_pmos[ibe]
print @n.xbgr.xm50_u6.nsg13_hv_pmos[ctype]
print @n.xbgr.xm50_u7.nsg13_hv_pmos[ide]
print @n.xbgr.xm50_u7.nsg13_hv_pmos[ige]
print @n.xbgr.xm50_u7.nsg13_hv_pmos[ise]
print @n.xbgr.xm50_u7.nsg13_hv_pmos[ibe]
print @n.xbgr.xm50_u7.nsg13_hv_pmos[ctype]
print @n.xbgr.xm50_u8.nsg13_hv_pmos[ide]
print @n.xbgr.xm50_u8.nsg13_hv_pmos[ige]
print @n.xbgr.xm50_u8.nsg13_hv_pmos[ise]
print @n.xbgr.xm50_u8.nsg13_hv_pmos[ibe]
print @n.xbgr.xm50_u8.nsg13_hv_pmos[ctype]
print @n.xbgr.xm50_u9.nsg13_hv_pmos[ide]
print @n.xbgr.xm50_u9.nsg13_hv_pmos[ige]
print @n.xbgr.xm50_u9.nsg13_hv_pmos[ise]
print @n.xbgr.xm50_u9.nsg13_hv_pmos[ibe]
print @n.xbgr.xm50_u9.nsg13_hv_pmos[ctype]
print @n.xbgr.xm50_u10.nsg13_hv_pmos[ide]
print @n.xbgr.xm50_u10.nsg13_hv_pmos[ige]
print @n.xbgr.xm50_u10.nsg13_hv_pmos[ise]
print @n.xbgr.xm50_u10.nsg13_hv_pmos[ibe]
print @n.xbgr.xm50_u10.nsg13_hv_pmos[ctype]
print @n.xbgr.xm50_u11.nsg13_hv_pmos[ide]
print @n.xbgr.xm50_u11.nsg13_hv_pmos[ige]
print @n.xbgr.xm50_u11.nsg13_hv_pmos[ise]
print @n.xbgr.xm50_u11.nsg13_hv_pmos[ibe]
print @n.xbgr.xm50_u11.nsg13_hv_pmos[ctype]
print @n.xbgr.xm50_u12.nsg13_hv_pmos[ide]
print @n.xbgr.xm50_u12.nsg13_hv_pmos[ige]
print @n.xbgr.xm50_u12.nsg13_hv_pmos[ise]
print @n.xbgr.xm50_u12.nsg13_hv_pmos[ibe]
print @n.xbgr.xm50_u12.nsg13_hv_pmos[ctype]
print @n.xbgr.xm50_u13.nsg13_hv_pmos[ide]
print @n.xbgr.xm50_u13.nsg13_hv_pmos[ige]
print @n.xbgr.xm50_u13.nsg13_hv_pmos[ise]
print @n.xbgr.xm50_u13.nsg13_hv_pmos[ibe]
print @n.xbgr.xm50_u13.nsg13_hv_pmos[ctype]
print @n.xbgr.xm50_u14.nsg13_hv_pmos[ide]
print @n.xbgr.xm50_u14.nsg13_hv_pmos[ige]
print @n.xbgr.xm50_u14.nsg13_hv_pmos[ise]
print @n.xbgr.xm50_u14.nsg13_hv_pmos[ibe]
print @n.xbgr.xm50_u14.nsg13_hv_pmos[ctype]
print @n.xbgr.xm50_u15.nsg13_hv_pmos[ide]
print @n.xbgr.xm50_u15.nsg13_hv_pmos[ige]
print @n.xbgr.xm50_u15.nsg13_hv_pmos[ise]
print @n.xbgr.xm50_u15.nsg13_hv_pmos[ibe]
print @n.xbgr.xm50_u15.nsg13_hv_pmos[ctype]
print @n.xbgr.xm50_u16.nsg13_hv_pmos[ide]
print @n.xbgr.xm50_u16.nsg13_hv_pmos[ige]
print @n.xbgr.xm50_u16.nsg13_hv_pmos[ise]
print @n.xbgr.xm50_u16.nsg13_hv_pmos[ibe]
print @n.xbgr.xm50_u16.nsg13_hv_pmos[ctype]
print @n.xbgr.xm50_u17.nsg13_hv_pmos[ide]
print @n.xbgr.xm50_u17.nsg13_hv_pmos[ige]
print @n.xbgr.xm50_u17.nsg13_hv_pmos[ise]
print @n.xbgr.xm50_u17.nsg13_hv_pmos[ibe]
print @n.xbgr.xm50_u17.nsg13_hv_pmos[ctype]
print @n.xbgr.xm50_u18.nsg13_hv_pmos[ide]
print @n.xbgr.xm50_u18.nsg13_hv_pmos[ige]
print @n.xbgr.xm50_u18.nsg13_hv_pmos[ise]
print @n.xbgr.xm50_u18.nsg13_hv_pmos[ibe]
print @n.xbgr.xm50_u18.nsg13_hv_pmos[ctype]
print @n.xbgr.xm50_u19.nsg13_hv_pmos[ide]
print @n.xbgr.xm50_u19.nsg13_hv_pmos[ige]
print @n.xbgr.xm50_u19.nsg13_hv_pmos[ise]
print @n.xbgr.xm50_u19.nsg13_hv_pmos[ibe]
print @n.xbgr.xm50_u19.nsg13_hv_pmos[ctype]
print @n.xbgr.xm50_u20.nsg13_hv_pmos[ide]
print @n.xbgr.xm50_u20.nsg13_hv_pmos[ige]
print @n.xbgr.xm50_u20.nsg13_hv_pmos[ise]
print @n.xbgr.xm50_u20.nsg13_hv_pmos[ibe]
print @n.xbgr.xm50_u20.nsg13_hv_pmos[ctype]
print @n.xbgr.xm50_u21.nsg13_hv_pmos[ide]
print @n.xbgr.xm50_u21.nsg13_hv_pmos[ige]
print @n.xbgr.xm50_u21.nsg13_hv_pmos[ise]
print @n.xbgr.xm50_u21.nsg13_hv_pmos[ibe]
print @n.xbgr.xm50_u21.nsg13_hv_pmos[ctype]
print @n.xbgr.xm50_u22.nsg13_hv_pmos[ide]
print @n.xbgr.xm50_u22.nsg13_hv_pmos[ige]
print @n.xbgr.xm50_u22.nsg13_hv_pmos[ise]
print @n.xbgr.xm50_u22.nsg13_hv_pmos[ibe]
print @n.xbgr.xm50_u22.nsg13_hv_pmos[ctype]
print @n.xbgr.xm50_u23.nsg13_hv_pmos[ide]
print @n.xbgr.xm50_u23.nsg13_hv_pmos[ige]
print @n.xbgr.xm50_u23.nsg13_hv_pmos[ise]
print @n.xbgr.xm50_u23.nsg13_hv_pmos[ibe]
print @n.xbgr.xm50_u23.nsg13_hv_pmos[ctype]
print @n.xbgr.xm50_u24.nsg13_hv_pmos[ide]
print @n.xbgr.xm50_u24.nsg13_hv_pmos[ige]
print @n.xbgr.xm50_u24.nsg13_hv_pmos[ise]
print @n.xbgr.xm50_u24.nsg13_hv_pmos[ibe]
print @n.xbgr.xm50_u24.nsg13_hv_pmos[ctype]
print @n.xbgr.xm51_u2.nsg13_hv_pmos[ide]
print @n.xbgr.xm51_u2.nsg13_hv_pmos[ige]
print @n.xbgr.xm51_u2.nsg13_hv_pmos[ise]
print @n.xbgr.xm51_u2.nsg13_hv_pmos[ibe]
print @n.xbgr.xm51_u2.nsg13_hv_pmos[ctype]
print @n.xbgr.xm51_u3.nsg13_hv_pmos[ide]
print @n.xbgr.xm51_u3.nsg13_hv_pmos[ige]
print @n.xbgr.xm51_u3.nsg13_hv_pmos[ise]
print @n.xbgr.xm51_u3.nsg13_hv_pmos[ibe]
print @n.xbgr.xm51_u3.nsg13_hv_pmos[ctype]
print @n.xbgr.xm51_u4.nsg13_hv_pmos[ide]
print @n.xbgr.xm51_u4.nsg13_hv_pmos[ige]
print @n.xbgr.xm51_u4.nsg13_hv_pmos[ise]
print @n.xbgr.xm51_u4.nsg13_hv_pmos[ibe]
print @n.xbgr.xm51_u4.nsg13_hv_pmos[ctype]
print @n.xbgr.xm52_u2.nsg13_hv_pmos[ide]
print @n.xbgr.xm52_u2.nsg13_hv_pmos[ige]
print @n.xbgr.xm52_u2.nsg13_hv_pmos[ise]
print @n.xbgr.xm52_u2.nsg13_hv_pmos[ibe]
print @n.xbgr.xm52_u2.nsg13_hv_pmos[ctype]
print @n.xbgr.xm52_u3.nsg13_hv_pmos[ide]
print @n.xbgr.xm52_u3.nsg13_hv_pmos[ige]
print @n.xbgr.xm52_u3.nsg13_hv_pmos[ise]
print @n.xbgr.xm52_u3.nsg13_hv_pmos[ibe]
print @n.xbgr.xm52_u3.nsg13_hv_pmos[ctype]
print @n.xbgr.xm52_u4.nsg13_hv_pmos[ide]
print @n.xbgr.xm52_u4.nsg13_hv_pmos[ige]
print @n.xbgr.xm52_u4.nsg13_hv_pmos[ise]
print @n.xbgr.xm52_u4.nsg13_hv_pmos[ibe]
print @n.xbgr.xm52_u4.nsg13_hv_pmos[ctype]
print @n.xbgr.xm52_u5.nsg13_hv_pmos[ide]
print @n.xbgr.xm52_u5.nsg13_hv_pmos[ige]
print @n.xbgr.xm52_u5.nsg13_hv_pmos[ise]
print @n.xbgr.xm52_u5.nsg13_hv_pmos[ibe]
print @n.xbgr.xm52_u5.nsg13_hv_pmos[ctype]
print @n.xbgr.xm52_u6.nsg13_hv_pmos[ide]
print @n.xbgr.xm52_u6.nsg13_hv_pmos[ige]
print @n.xbgr.xm52_u6.nsg13_hv_pmos[ise]
print @n.xbgr.xm52_u6.nsg13_hv_pmos[ibe]
print @n.xbgr.xm52_u6.nsg13_hv_pmos[ctype]
print @n.xbgr.xm52_u7.nsg13_hv_pmos[ide]
print @n.xbgr.xm52_u7.nsg13_hv_pmos[ige]
print @n.xbgr.xm52_u7.nsg13_hv_pmos[ise]
print @n.xbgr.xm52_u7.nsg13_hv_pmos[ibe]
print @n.xbgr.xm52_u7.nsg13_hv_pmos[ctype]
print @n.xbgr.xm52_u8.nsg13_hv_pmos[ide]
print @n.xbgr.xm52_u8.nsg13_hv_pmos[ige]
print @n.xbgr.xm52_u8.nsg13_hv_pmos[ise]
print @n.xbgr.xm52_u8.nsg13_hv_pmos[ibe]
print @n.xbgr.xm52_u8.nsg13_hv_pmos[ctype]
print @n.xbgr.xm52_u9.nsg13_hv_pmos[ide]
print @n.xbgr.xm52_u9.nsg13_hv_pmos[ige]
print @n.xbgr.xm52_u9.nsg13_hv_pmos[ise]
print @n.xbgr.xm52_u9.nsg13_hv_pmos[ibe]
print @n.xbgr.xm52_u9.nsg13_hv_pmos[ctype]
print @n.xbgr.xm52_u10.nsg13_hv_pmos[ide]
print @n.xbgr.xm52_u10.nsg13_hv_pmos[ige]
print @n.xbgr.xm52_u10.nsg13_hv_pmos[ise]
print @n.xbgr.xm52_u10.nsg13_hv_pmos[ibe]
print @n.xbgr.xm52_u10.nsg13_hv_pmos[ctype]
print @n.xbgr.xm52_u11.nsg13_hv_pmos[ide]
print @n.xbgr.xm52_u11.nsg13_hv_pmos[ige]
print @n.xbgr.xm52_u11.nsg13_hv_pmos[ise]
print @n.xbgr.xm52_u11.nsg13_hv_pmos[ibe]
print @n.xbgr.xm52_u11.nsg13_hv_pmos[ctype]
print @n.xbgr.xm52_u12.nsg13_hv_pmos[ide]
print @n.xbgr.xm52_u12.nsg13_hv_pmos[ige]
print @n.xbgr.xm52_u12.nsg13_hv_pmos[ise]
print @n.xbgr.xm52_u12.nsg13_hv_pmos[ibe]
print @n.xbgr.xm52_u12.nsg13_hv_pmos[ctype]
print @n.xbgr.xm52_u13.nsg13_hv_pmos[ide]
print @n.xbgr.xm52_u13.nsg13_hv_pmos[ige]
print @n.xbgr.xm52_u13.nsg13_hv_pmos[ise]
print @n.xbgr.xm52_u13.nsg13_hv_pmos[ibe]
print @n.xbgr.xm52_u13.nsg13_hv_pmos[ctype]
print @n.xbgr.xm52_u14.nsg13_hv_pmos[ide]
print @n.xbgr.xm52_u14.nsg13_hv_pmos[ige]
print @n.xbgr.xm52_u14.nsg13_hv_pmos[ise]
print @n.xbgr.xm52_u14.nsg13_hv_pmos[ibe]
print @n.xbgr.xm52_u14.nsg13_hv_pmos[ctype]
print @n.xbgr.xm52_u15.nsg13_hv_pmos[ide]
print @n.xbgr.xm52_u15.nsg13_hv_pmos[ige]
print @n.xbgr.xm52_u15.nsg13_hv_pmos[ise]
print @n.xbgr.xm52_u15.nsg13_hv_pmos[ibe]
print @n.xbgr.xm52_u15.nsg13_hv_pmos[ctype]
print @n.xbgr.xm52_u16.nsg13_hv_pmos[ide]
print @n.xbgr.xm52_u16.nsg13_hv_pmos[ige]
print @n.xbgr.xm52_u16.nsg13_hv_pmos[ise]
print @n.xbgr.xm52_u16.nsg13_hv_pmos[ibe]
print @n.xbgr.xm52_u16.nsg13_hv_pmos[ctype]
print @n.xbgr.xm52_u17.nsg13_hv_pmos[ide]
print @n.xbgr.xm52_u17.nsg13_hv_pmos[ige]
print @n.xbgr.xm52_u17.nsg13_hv_pmos[ise]
print @n.xbgr.xm52_u17.nsg13_hv_pmos[ibe]
print @n.xbgr.xm52_u17.nsg13_hv_pmos[ctype]
print @n.xbgr.xm52_u18.nsg13_hv_pmos[ide]
print @n.xbgr.xm52_u18.nsg13_hv_pmos[ige]
print @n.xbgr.xm52_u18.nsg13_hv_pmos[ise]
print @n.xbgr.xm52_u18.nsg13_hv_pmos[ibe]
print @n.xbgr.xm52_u18.nsg13_hv_pmos[ctype]
print @n.xbgr.xm52_u19.nsg13_hv_pmos[ide]
print @n.xbgr.xm52_u19.nsg13_hv_pmos[ige]
print @n.xbgr.xm52_u19.nsg13_hv_pmos[ise]
print @n.xbgr.xm52_u19.nsg13_hv_pmos[ibe]
print @n.xbgr.xm52_u19.nsg13_hv_pmos[ctype]
print @n.xbgr.xm52_u20.nsg13_hv_pmos[ide]
print @n.xbgr.xm52_u20.nsg13_hv_pmos[ige]
print @n.xbgr.xm52_u20.nsg13_hv_pmos[ise]
print @n.xbgr.xm52_u20.nsg13_hv_pmos[ibe]
print @n.xbgr.xm52_u20.nsg13_hv_pmos[ctype]
print @n.xbgr.xm52_u21.nsg13_hv_pmos[ide]
print @n.xbgr.xm52_u21.nsg13_hv_pmos[ige]
print @n.xbgr.xm52_u21.nsg13_hv_pmos[ise]
print @n.xbgr.xm52_u21.nsg13_hv_pmos[ibe]
print @n.xbgr.xm52_u21.nsg13_hv_pmos[ctype]
print @n.xbgr.xm52_u22.nsg13_hv_pmos[ide]
print @n.xbgr.xm52_u22.nsg13_hv_pmos[ige]
print @n.xbgr.xm52_u22.nsg13_hv_pmos[ise]
print @n.xbgr.xm52_u22.nsg13_hv_pmos[ibe]
print @n.xbgr.xm52_u22.nsg13_hv_pmos[ctype]
print @n.xbgr.xm52_u23.nsg13_hv_pmos[ide]
print @n.xbgr.xm52_u23.nsg13_hv_pmos[ige]
print @n.xbgr.xm52_u23.nsg13_hv_pmos[ise]
print @n.xbgr.xm52_u23.nsg13_hv_pmos[ibe]
print @n.xbgr.xm52_u23.nsg13_hv_pmos[ctype]
print @n.xbgr.xm52_u24.nsg13_hv_pmos[ide]
print @n.xbgr.xm52_u24.nsg13_hv_pmos[ige]
print @n.xbgr.xm52_u24.nsg13_hv_pmos[ise]
print @n.xbgr.xm52_u24.nsg13_hv_pmos[ibe]
print @n.xbgr.xm52_u24.nsg13_hv_pmos[ctype]
print @n.xbgr.xm54_u2.nsg13_hv_pmos[ide]
print @n.xbgr.xm54_u2.nsg13_hv_pmos[ige]
print @n.xbgr.xm54_u2.nsg13_hv_pmos[ise]
print @n.xbgr.xm54_u2.nsg13_hv_pmos[ibe]
print @n.xbgr.xm54_u2.nsg13_hv_pmos[ctype]
print @n.xbgr.xm54_u3.nsg13_hv_pmos[ide]
print @n.xbgr.xm54_u3.nsg13_hv_pmos[ige]
print @n.xbgr.xm54_u3.nsg13_hv_pmos[ise]
print @n.xbgr.xm54_u3.nsg13_hv_pmos[ibe]
print @n.xbgr.xm54_u3.nsg13_hv_pmos[ctype]
print @n.xbgr.xm54_u4.nsg13_hv_pmos[ide]
print @n.xbgr.xm54_u4.nsg13_hv_pmos[ige]
print @n.xbgr.xm54_u4.nsg13_hv_pmos[ise]
print @n.xbgr.xm54_u4.nsg13_hv_pmos[ibe]
print @n.xbgr.xm54_u4.nsg13_hv_pmos[ctype]
print @n.xbgr.xm54_u5.nsg13_hv_pmos[ide]
print @n.xbgr.xm54_u5.nsg13_hv_pmos[ige]
print @n.xbgr.xm54_u5.nsg13_hv_pmos[ise]
print @n.xbgr.xm54_u5.nsg13_hv_pmos[ibe]
print @n.xbgr.xm54_u5.nsg13_hv_pmos[ctype]
print @n.xbgr.xm54_u6.nsg13_hv_pmos[ide]
print @n.xbgr.xm54_u6.nsg13_hv_pmos[ige]
print @n.xbgr.xm54_u6.nsg13_hv_pmos[ise]
print @n.xbgr.xm54_u6.nsg13_hv_pmos[ibe]
print @n.xbgr.xm54_u6.nsg13_hv_pmos[ctype]
print @n.xbgr.xm54_u7.nsg13_hv_pmos[ide]
print @n.xbgr.xm54_u7.nsg13_hv_pmos[ige]
print @n.xbgr.xm54_u7.nsg13_hv_pmos[ise]
print @n.xbgr.xm54_u7.nsg13_hv_pmos[ibe]
print @n.xbgr.xm54_u7.nsg13_hv_pmos[ctype]
print @n.xbgr.xm54_u8.nsg13_hv_pmos[ide]
print @n.xbgr.xm54_u8.nsg13_hv_pmos[ige]
print @n.xbgr.xm54_u8.nsg13_hv_pmos[ise]
print @n.xbgr.xm54_u8.nsg13_hv_pmos[ibe]
print @n.xbgr.xm54_u8.nsg13_hv_pmos[ctype]
print @n.xbgr.xm54_u9.nsg13_hv_pmos[ide]
print @n.xbgr.xm54_u9.nsg13_hv_pmos[ige]
print @n.xbgr.xm54_u9.nsg13_hv_pmos[ise]
print @n.xbgr.xm54_u9.nsg13_hv_pmos[ibe]
print @n.xbgr.xm54_u9.nsg13_hv_pmos[ctype]
print @n.xbgr.xm54_u10.nsg13_hv_pmos[ide]
print @n.xbgr.xm54_u10.nsg13_hv_pmos[ige]
print @n.xbgr.xm54_u10.nsg13_hv_pmos[ise]
print @n.xbgr.xm54_u10.nsg13_hv_pmos[ibe]
print @n.xbgr.xm54_u10.nsg13_hv_pmos[ctype]
print @n.xbgr.xm54_u11.nsg13_hv_pmos[ide]
print @n.xbgr.xm54_u11.nsg13_hv_pmos[ige]
print @n.xbgr.xm54_u11.nsg13_hv_pmos[ise]
print @n.xbgr.xm54_u11.nsg13_hv_pmos[ibe]
print @n.xbgr.xm54_u11.nsg13_hv_pmos[ctype]
print @n.xbgr.xm54_u12.nsg13_hv_pmos[ide]
print @n.xbgr.xm54_u12.nsg13_hv_pmos[ige]
print @n.xbgr.xm54_u12.nsg13_hv_pmos[ise]
print @n.xbgr.xm54_u12.nsg13_hv_pmos[ibe]
print @n.xbgr.xm54_u12.nsg13_hv_pmos[ctype]
print @n.xbgr.xm54_u13.nsg13_hv_pmos[ide]
print @n.xbgr.xm54_u13.nsg13_hv_pmos[ige]
print @n.xbgr.xm54_u13.nsg13_hv_pmos[ise]
print @n.xbgr.xm54_u13.nsg13_hv_pmos[ibe]
print @n.xbgr.xm54_u13.nsg13_hv_pmos[ctype]
print @n.xbgr.xm54_u14.nsg13_hv_pmos[ide]
print @n.xbgr.xm54_u14.nsg13_hv_pmos[ige]
print @n.xbgr.xm54_u14.nsg13_hv_pmos[ise]
print @n.xbgr.xm54_u14.nsg13_hv_pmos[ibe]
print @n.xbgr.xm54_u14.nsg13_hv_pmos[ctype]
print @n.xbgr.xm54_u15.nsg13_hv_pmos[ide]
print @n.xbgr.xm54_u15.nsg13_hv_pmos[ige]
print @n.xbgr.xm54_u15.nsg13_hv_pmos[ise]
print @n.xbgr.xm54_u15.nsg13_hv_pmos[ibe]
print @n.xbgr.xm54_u15.nsg13_hv_pmos[ctype]
print @n.xbgr.xm54_u16.nsg13_hv_pmos[ide]
print @n.xbgr.xm54_u16.nsg13_hv_pmos[ige]
print @n.xbgr.xm54_u16.nsg13_hv_pmos[ise]
print @n.xbgr.xm54_u16.nsg13_hv_pmos[ibe]
print @n.xbgr.xm54_u16.nsg13_hv_pmos[ctype]
print @n.xbgr.xm54_u17.nsg13_hv_pmos[ide]
print @n.xbgr.xm54_u17.nsg13_hv_pmos[ige]
print @n.xbgr.xm54_u17.nsg13_hv_pmos[ise]
print @n.xbgr.xm54_u17.nsg13_hv_pmos[ibe]
print @n.xbgr.xm54_u17.nsg13_hv_pmos[ctype]
print @n.xbgr.xm54_u18.nsg13_hv_pmos[ide]
print @n.xbgr.xm54_u18.nsg13_hv_pmos[ige]
print @n.xbgr.xm54_u18.nsg13_hv_pmos[ise]
print @n.xbgr.xm54_u18.nsg13_hv_pmos[ibe]
print @n.xbgr.xm54_u18.nsg13_hv_pmos[ctype]
print @n.xbgr.xm54_u19.nsg13_hv_pmos[ide]
print @n.xbgr.xm54_u19.nsg13_hv_pmos[ige]
print @n.xbgr.xm54_u19.nsg13_hv_pmos[ise]
print @n.xbgr.xm54_u19.nsg13_hv_pmos[ibe]
print @n.xbgr.xm54_u19.nsg13_hv_pmos[ctype]
print @n.xbgr.xm54_u20.nsg13_hv_pmos[ide]
print @n.xbgr.xm54_u20.nsg13_hv_pmos[ige]
print @n.xbgr.xm54_u20.nsg13_hv_pmos[ise]
print @n.xbgr.xm54_u20.nsg13_hv_pmos[ibe]
print @n.xbgr.xm54_u20.nsg13_hv_pmos[ctype]
print @n.xbgr.xm54_u21.nsg13_hv_pmos[ide]
print @n.xbgr.xm54_u21.nsg13_hv_pmos[ige]
print @n.xbgr.xm54_u21.nsg13_hv_pmos[ise]
print @n.xbgr.xm54_u21.nsg13_hv_pmos[ibe]
print @n.xbgr.xm54_u21.nsg13_hv_pmos[ctype]
print @n.xbgr.xm54_u22.nsg13_hv_pmos[ide]
print @n.xbgr.xm54_u22.nsg13_hv_pmos[ige]
print @n.xbgr.xm54_u22.nsg13_hv_pmos[ise]
print @n.xbgr.xm54_u22.nsg13_hv_pmos[ibe]
print @n.xbgr.xm54_u22.nsg13_hv_pmos[ctype]
print @n.xbgr.xm54_u23.nsg13_hv_pmos[ide]
print @n.xbgr.xm54_u23.nsg13_hv_pmos[ige]
print @n.xbgr.xm54_u23.nsg13_hv_pmos[ise]
print @n.xbgr.xm54_u23.nsg13_hv_pmos[ibe]
print @n.xbgr.xm54_u23.nsg13_hv_pmos[ctype]
print @n.xbgr.xm54_u24.nsg13_hv_pmos[ide]
print @n.xbgr.xm54_u24.nsg13_hv_pmos[ige]
print @n.xbgr.xm54_u24.nsg13_hv_pmos[ise]
print @n.xbgr.xm54_u24.nsg13_hv_pmos[ibe]
print @n.xbgr.xm54_u24.nsg13_hv_pmos[ctype]
print @q.xbgr.xq56_u2.qnpn13g2[ic]
print @q.xbgr.xq56_u2.qnpn13g2[ib]
print @q.xbgr.xq56_u2.qnpn13g2[ie]
print @q.xbgr.xq56_u2.qnpn13g2[is]
print @r.xbgr.xq56_u2.rsub[i]
print @c.xbgr.xq56_u2.csub[i]
print @q.xbgr.xq56_u3.qnpn13g2[ic]
print @q.xbgr.xq56_u3.qnpn13g2[ib]
print @q.xbgr.xq56_u3.qnpn13g2[ie]
print @q.xbgr.xq56_u3.qnpn13g2[is]
print @r.xbgr.xq56_u3.rsub[i]
print @c.xbgr.xq56_u3.csub[i]
print @q.xbgr.xq56_u4.qnpn13g2[ic]
print @q.xbgr.xq56_u4.qnpn13g2[ib]
print @q.xbgr.xq56_u4.qnpn13g2[ie]
print @q.xbgr.xq56_u4.qnpn13g2[is]
print @r.xbgr.xq56_u4.rsub[i]
print @c.xbgr.xq56_u4.csub[i]
print @q.xbgr.xq56_u5.qnpn13g2[ic]
print @q.xbgr.xq56_u5.qnpn13g2[ib]
print @q.xbgr.xq56_u5.qnpn13g2[ie]
print @q.xbgr.xq56_u5.qnpn13g2[is]
print @r.xbgr.xq56_u5.rsub[i]
print @c.xbgr.xq56_u5.csub[i]
print @q.xbgr.xq56_u6.qnpn13g2[ic]
print @q.xbgr.xq56_u6.qnpn13g2[ib]
print @q.xbgr.xq56_u6.qnpn13g2[ie]
print @q.xbgr.xq56_u6.qnpn13g2[is]
print @r.xbgr.xq56_u6.rsub[i]
print @c.xbgr.xq56_u6.csub[i]
print @q.xbgr.xq56_u7.qnpn13g2[ic]
print @q.xbgr.xq56_u7.qnpn13g2[ib]
print @q.xbgr.xq56_u7.qnpn13g2[ie]
print @q.xbgr.xq56_u7.qnpn13g2[is]
print @r.xbgr.xq56_u7.rsub[i]
print @c.xbgr.xq56_u7.csub[i]
print @q.xbgr.xq56_u8.qnpn13g2[ic]
print @q.xbgr.xq56_u8.qnpn13g2[ib]
print @q.xbgr.xq56_u8.qnpn13g2[ie]
print @q.xbgr.xq56_u8.qnpn13g2[is]
print @r.xbgr.xq56_u8.rsub[i]
print @c.xbgr.xq56_u8.csub[i]
print @q.xbgr.xq56_u9.qnpn13g2[ic]
print @q.xbgr.xq56_u9.qnpn13g2[ib]
print @q.xbgr.xq56_u9.qnpn13g2[ie]
print @q.xbgr.xq56_u9.qnpn13g2[is]
print @r.xbgr.xq56_u9.rsub[i]
print @c.xbgr.xq56_u9.csub[i]
print @q.xbgr.xq56_u10.qnpn13g2[ic]
print @q.xbgr.xq56_u10.qnpn13g2[ib]
print @q.xbgr.xq56_u10.qnpn13g2[ie]
print @q.xbgr.xq56_u10.qnpn13g2[is]
print @r.xbgr.xq56_u10.rsub[i]
print @c.xbgr.xq56_u10.csub[i]
print @q.xbgr.xq56_u11.qnpn13g2[ic]
print @q.xbgr.xq56_u11.qnpn13g2[ib]
print @q.xbgr.xq56_u11.qnpn13g2[ie]
print @q.xbgr.xq56_u11.qnpn13g2[is]
print @r.xbgr.xq56_u11.rsub[i]
print @c.xbgr.xq56_u11.csub[i]
print @q.xbgr.xq56_u12.qnpn13g2[ic]
print @q.xbgr.xq56_u12.qnpn13g2[ib]
print @q.xbgr.xq56_u12.qnpn13g2[ie]
print @q.xbgr.xq56_u12.qnpn13g2[is]
print @r.xbgr.xq56_u12.rsub[i]
print @c.xbgr.xq56_u12.csub[i]
print @q.xbgr.xq56_u13.qnpn13g2[ic]
print @q.xbgr.xq56_u13.qnpn13g2[ib]
print @q.xbgr.xq56_u13.qnpn13g2[ie]
print @q.xbgr.xq56_u13.qnpn13g2[is]
print @r.xbgr.xq56_u13.rsub[i]
print @c.xbgr.xq56_u13.csub[i]
print @q.xbgr.xq56_u14.qnpn13g2[ic]
print @q.xbgr.xq56_u14.qnpn13g2[ib]
print @q.xbgr.xq56_u14.qnpn13g2[ie]
print @q.xbgr.xq56_u14.qnpn13g2[is]
print @r.xbgr.xq56_u14.rsub[i]
print @c.xbgr.xq56_u14.csub[i]
print @q.xbgr.xq56_u15.qnpn13g2[ic]
print @q.xbgr.xq56_u15.qnpn13g2[ib]
print @q.xbgr.xq56_u15.qnpn13g2[ie]
print @q.xbgr.xq56_u15.qnpn13g2[is]
print @r.xbgr.xq56_u15.rsub[i]
print @c.xbgr.xq56_u15.csub[i]
print @q.xbgr.xq56_u16.qnpn13g2[ic]
print @q.xbgr.xq56_u16.qnpn13g2[ib]
print @q.xbgr.xq56_u16.qnpn13g2[ie]
print @q.xbgr.xq56_u16.qnpn13g2[is]
print @r.xbgr.xq56_u16.rsub[i]
print @c.xbgr.xq56_u16.csub[i]
print @q.xbgr.xq56_u17.qnpn13g2[ic]
print @q.xbgr.xq56_u17.qnpn13g2[ib]
print @q.xbgr.xq56_u17.qnpn13g2[ie]
print @q.xbgr.xq56_u17.qnpn13g2[is]
print @r.xbgr.xq56_u17.rsub[i]
print @c.xbgr.xq56_u17.csub[i]
print @q.xbgr.xq56_u18.qnpn13g2[ic]
print @q.xbgr.xq56_u18.qnpn13g2[ib]
print @q.xbgr.xq56_u18.qnpn13g2[ie]
print @q.xbgr.xq56_u18.qnpn13g2[is]
print @r.xbgr.xq56_u18.rsub[i]
print @c.xbgr.xq56_u18.csub[i]
print @q.xbgr.xq56_u19.qnpn13g2[ic]
print @q.xbgr.xq56_u19.qnpn13g2[ib]
print @q.xbgr.xq56_u19.qnpn13g2[ie]
print @q.xbgr.xq56_u19.qnpn13g2[is]
print @r.xbgr.xq56_u19.rsub[i]
print @c.xbgr.xq56_u19.csub[i]
print @q.xbgr.xq56_u20.qnpn13g2[ic]
print @q.xbgr.xq56_u20.qnpn13g2[ib]
print @q.xbgr.xq56_u20.qnpn13g2[ie]
print @q.xbgr.xq56_u20.qnpn13g2[is]
print @r.xbgr.xq56_u20.rsub[i]
print @c.xbgr.xq56_u20.csub[i]
print @q.xbgr.xq56_u21.qnpn13g2[ic]
print @q.xbgr.xq56_u21.qnpn13g2[ib]
print @q.xbgr.xq56_u21.qnpn13g2[ie]
print @q.xbgr.xq56_u21.qnpn13g2[is]
print @r.xbgr.xq56_u21.rsub[i]
print @c.xbgr.xq56_u21.csub[i]
print @q.xbgr.xq56_u22.qnpn13g2[ic]
print @q.xbgr.xq56_u22.qnpn13g2[ib]
print @q.xbgr.xq56_u22.qnpn13g2[ie]
print @q.xbgr.xq56_u22.qnpn13g2[is]
print @r.xbgr.xq56_u22.rsub[i]
print @c.xbgr.xq56_u22.csub[i]
print @q.xbgr.xq56_u23.qnpn13g2[ic]
print @q.xbgr.xq56_u23.qnpn13g2[ib]
print @q.xbgr.xq56_u23.qnpn13g2[ie]
print @q.xbgr.xq56_u23.qnpn13g2[is]
print @r.xbgr.xq56_u23.rsub[i]
print @c.xbgr.xq56_u23.csub[i]
print @q.xbgr.xq56_u24.qnpn13g2[ic]
print @q.xbgr.xq56_u24.qnpn13g2[ib]
print @q.xbgr.xq56_u24.qnpn13g2[ie]
print @q.xbgr.xq56_u24.qnpn13g2[is]
print @r.xbgr.xq56_u24.rsub[i]
print @c.xbgr.xq56_u24.csub[i]
print @q.xbgr.xq60_u2.qnpn13g2[ic]
print @q.xbgr.xq60_u2.qnpn13g2[ib]
print @q.xbgr.xq60_u2.qnpn13g2[ie]
print @q.xbgr.xq60_u2.qnpn13g2[is]
print @r.xbgr.xq60_u2.rsub[i]
print @c.xbgr.xq60_u2.csub[i]
print @q.xbgr.xq60_u3.qnpn13g2[ic]
print @q.xbgr.xq60_u3.qnpn13g2[ib]
print @q.xbgr.xq60_u3.qnpn13g2[ie]
print @q.xbgr.xq60_u3.qnpn13g2[is]
print @r.xbgr.xq60_u3.rsub[i]
print @c.xbgr.xq60_u3.csub[i]
print @q.xbgr.xq60_u4.qnpn13g2[ic]
print @q.xbgr.xq60_u4.qnpn13g2[ib]
print @q.xbgr.xq60_u4.qnpn13g2[ie]
print @q.xbgr.xq60_u4.qnpn13g2[is]
print @r.xbgr.xq60_u4.rsub[i]
print @c.xbgr.xq60_u4.csub[i]
print @q.xbgr.xq62_u2.qnpn13g2[ic]
print @q.xbgr.xq62_u2.qnpn13g2[ib]
print @q.xbgr.xq62_u2.qnpn13g2[ie]
print @q.xbgr.xq62_u2.qnpn13g2[is]
print @r.xbgr.xq62_u2.rsub[i]
print @c.xbgr.xq62_u2.csub[i]
print @q.xbgr.xq62_u3.qnpn13g2[ic]
print @q.xbgr.xq62_u3.qnpn13g2[ib]
print @q.xbgr.xq62_u3.qnpn13g2[ie]
print @q.xbgr.xq62_u3.qnpn13g2[is]
print @r.xbgr.xq62_u3.rsub[i]
print @c.xbgr.xq62_u3.csub[i]
print @q.xbgr.xq62_u4.qnpn13g2[ic]
print @q.xbgr.xq62_u4.qnpn13g2[ib]
print @q.xbgr.xq62_u4.qnpn13g2[ie]
print @q.xbgr.xq62_u4.qnpn13g2[is]
print @r.xbgr.xq62_u4.rsub[i]
print @c.xbgr.xq62_u4.csub[i]
print @q.xbgr.xq62_u5.qnpn13g2[ic]
print @q.xbgr.xq62_u5.qnpn13g2[ib]
print @q.xbgr.xq62_u5.qnpn13g2[ie]
print @q.xbgr.xq62_u5.qnpn13g2[is]
print @r.xbgr.xq62_u5.rsub[i]
print @c.xbgr.xq62_u5.csub[i]
print @q.xbgr.xq62_u6.qnpn13g2[ic]
print @q.xbgr.xq62_u6.qnpn13g2[ib]
print @q.xbgr.xq62_u6.qnpn13g2[ie]
print @q.xbgr.xq62_u6.qnpn13g2[is]
print @r.xbgr.xq62_u6.rsub[i]
print @c.xbgr.xq62_u6.csub[i]
print @q.xbgr.xq62_u7.qnpn13g2[ic]
print @q.xbgr.xq62_u7.qnpn13g2[ib]
print @q.xbgr.xq62_u7.qnpn13g2[ie]
print @q.xbgr.xq62_u7.qnpn13g2[is]
print @r.xbgr.xq62_u7.rsub[i]
print @c.xbgr.xq62_u7.csub[i]
print @q.xbgr.xq62_u8.qnpn13g2[ic]
print @q.xbgr.xq62_u8.qnpn13g2[ib]
print @q.xbgr.xq62_u8.qnpn13g2[ie]
print @q.xbgr.xq62_u8.qnpn13g2[is]
print @r.xbgr.xq62_u8.rsub[i]
print @c.xbgr.xq62_u8.csub[i]
print @q.xbgr.xq62_u9.qnpn13g2[ic]
print @q.xbgr.xq62_u9.qnpn13g2[ib]
print @q.xbgr.xq62_u9.qnpn13g2[ie]
print @q.xbgr.xq62_u9.qnpn13g2[is]
print @r.xbgr.xq62_u9.rsub[i]
print @c.xbgr.xq62_u9.csub[i]
print @q.xbgr.xq62_u10.qnpn13g2[ic]
print @q.xbgr.xq62_u10.qnpn13g2[ib]
print @q.xbgr.xq62_u10.qnpn13g2[ie]
print @q.xbgr.xq62_u10.qnpn13g2[is]
print @r.xbgr.xq62_u10.rsub[i]
print @c.xbgr.xq62_u10.csub[i]
print @q.xbgr.xq62_u11.qnpn13g2[ic]
print @q.xbgr.xq62_u11.qnpn13g2[ib]
print @q.xbgr.xq62_u11.qnpn13g2[ie]
print @q.xbgr.xq62_u11.qnpn13g2[is]
print @r.xbgr.xq62_u11.rsub[i]
print @c.xbgr.xq62_u11.csub[i]
print @q.xbgr.xq62_u12.qnpn13g2[ic]
print @q.xbgr.xq62_u12.qnpn13g2[ib]
print @q.xbgr.xq62_u12.qnpn13g2[ie]
print @q.xbgr.xq62_u12.qnpn13g2[is]
print @r.xbgr.xq62_u12.rsub[i]
print @c.xbgr.xq62_u12.csub[i]
print @q.xbgr.xq62_u13.qnpn13g2[ic]
print @q.xbgr.xq62_u13.qnpn13g2[ib]
print @q.xbgr.xq62_u13.qnpn13g2[ie]
print @q.xbgr.xq62_u13.qnpn13g2[is]
print @r.xbgr.xq62_u13.rsub[i]
print @c.xbgr.xq62_u13.csub[i]
print @q.xbgr.xq62_u14.qnpn13g2[ic]
print @q.xbgr.xq62_u14.qnpn13g2[ib]
print @q.xbgr.xq62_u14.qnpn13g2[ie]
print @q.xbgr.xq62_u14.qnpn13g2[is]
print @r.xbgr.xq62_u14.rsub[i]
print @c.xbgr.xq62_u14.csub[i]
print @q.xbgr.xq62_u15.qnpn13g2[ic]
print @q.xbgr.xq62_u15.qnpn13g2[ib]
print @q.xbgr.xq62_u15.qnpn13g2[ie]
print @q.xbgr.xq62_u15.qnpn13g2[is]
print @r.xbgr.xq62_u15.rsub[i]
print @c.xbgr.xq62_u15.csub[i]
print @q.xbgr.xq62_u16.qnpn13g2[ic]
print @q.xbgr.xq62_u16.qnpn13g2[ib]
print @q.xbgr.xq62_u16.qnpn13g2[ie]
print @q.xbgr.xq62_u16.qnpn13g2[is]
print @r.xbgr.xq62_u16.rsub[i]
print @c.xbgr.xq62_u16.csub[i]
print @q.xbgr.xq62_u17.qnpn13g2[ic]
print @q.xbgr.xq62_u17.qnpn13g2[ib]
print @q.xbgr.xq62_u17.qnpn13g2[ie]
print @q.xbgr.xq62_u17.qnpn13g2[is]
print @r.xbgr.xq62_u17.rsub[i]
print @c.xbgr.xq62_u17.csub[i]
print @q.xbgr.xq62_u18.qnpn13g2[ic]
print @q.xbgr.xq62_u18.qnpn13g2[ib]
print @q.xbgr.xq62_u18.qnpn13g2[ie]
print @q.xbgr.xq62_u18.qnpn13g2[is]
print @r.xbgr.xq62_u18.rsub[i]
print @c.xbgr.xq62_u18.csub[i]
print @q.xbgr.xq62_u19.qnpn13g2[ic]
print @q.xbgr.xq62_u19.qnpn13g2[ib]
print @q.xbgr.xq62_u19.qnpn13g2[ie]
print @q.xbgr.xq62_u19.qnpn13g2[is]
print @r.xbgr.xq62_u19.rsub[i]
print @c.xbgr.xq62_u19.csub[i]
print @q.xbgr.xq62_u20.qnpn13g2[ic]
print @q.xbgr.xq62_u20.qnpn13g2[ib]
print @q.xbgr.xq62_u20.qnpn13g2[ie]
print @q.xbgr.xq62_u20.qnpn13g2[is]
print @r.xbgr.xq62_u20.rsub[i]
print @c.xbgr.xq62_u20.csub[i]
print @q.xbgr.xq62_u21.qnpn13g2[ic]
print @q.xbgr.xq62_u21.qnpn13g2[ib]
print @q.xbgr.xq62_u21.qnpn13g2[ie]
print @q.xbgr.xq62_u21.qnpn13g2[is]
print @r.xbgr.xq62_u21.rsub[i]
print @c.xbgr.xq62_u21.csub[i]
print @q.xbgr.xq62_u22.qnpn13g2[ic]
print @q.xbgr.xq62_u22.qnpn13g2[ib]
print @q.xbgr.xq62_u22.qnpn13g2[ie]
print @q.xbgr.xq62_u22.qnpn13g2[is]
print @r.xbgr.xq62_u22.rsub[i]
print @c.xbgr.xq62_u22.csub[i]
print @q.xbgr.xq62_u23.qnpn13g2[ic]
print @q.xbgr.xq62_u23.qnpn13g2[ib]
print @q.xbgr.xq62_u23.qnpn13g2[ie]
print @q.xbgr.xq62_u23.qnpn13g2[is]
print @r.xbgr.xq62_u23.rsub[i]
print @c.xbgr.xq62_u23.csub[i]
print @q.xbgr.xq62_u24.qnpn13g2[ic]
print @q.xbgr.xq62_u24.qnpn13g2[ib]
print @q.xbgr.xq62_u24.qnpn13g2[ie]
print @q.xbgr.xq62_u24.qnpn13g2[is]
print @r.xbgr.xq62_u24.rsub[i]
print @c.xbgr.xq62_u24.csub[i]
print @q.xbgr.xq67_u2.qnpn13g2[ic]
print @q.xbgr.xq67_u2.qnpn13g2[ib]
print @q.xbgr.xq67_u2.qnpn13g2[ie]
print @q.xbgr.xq67_u2.qnpn13g2[is]
print @r.xbgr.xq67_u2.rsub[i]
print @c.xbgr.xq67_u2.csub[i]
print @q.xbgr.xq67_u3.qnpn13g2[ic]
print @q.xbgr.xq67_u3.qnpn13g2[ib]
print @q.xbgr.xq67_u3.qnpn13g2[ie]
print @q.xbgr.xq67_u3.qnpn13g2[is]
print @r.xbgr.xq67_u3.rsub[i]
print @c.xbgr.xq67_u3.csub[i]
print @q.xbgr.xq67_u4.qnpn13g2[ic]
print @q.xbgr.xq67_u4.qnpn13g2[ib]
print @q.xbgr.xq67_u4.qnpn13g2[ie]
print @q.xbgr.xq67_u4.qnpn13g2[is]
print @r.xbgr.xq67_u4.rsub[i]
print @c.xbgr.xq67_u4.csub[i]
print @q.xbgr.xq67_u5.qnpn13g2[ic]
print @q.xbgr.xq67_u5.qnpn13g2[ib]
print @q.xbgr.xq67_u5.qnpn13g2[ie]
print @q.xbgr.xq67_u5.qnpn13g2[is]
print @r.xbgr.xq67_u5.rsub[i]
print @c.xbgr.xq67_u5.csub[i]
print @q.xbgr.xq67_u6.qnpn13g2[ic]
print @q.xbgr.xq67_u6.qnpn13g2[ib]
print @q.xbgr.xq67_u6.qnpn13g2[ie]
print @q.xbgr.xq67_u6.qnpn13g2[is]
print @r.xbgr.xq67_u6.rsub[i]
print @c.xbgr.xq67_u6.csub[i]
print @q.xbgr.xq67_u7.qnpn13g2[ic]
print @q.xbgr.xq67_u7.qnpn13g2[ib]
print @q.xbgr.xq67_u7.qnpn13g2[ie]
print @q.xbgr.xq67_u7.qnpn13g2[is]
print @r.xbgr.xq67_u7.rsub[i]
print @c.xbgr.xq67_u7.csub[i]
print @q.xbgr.xq67_u8.qnpn13g2[ic]
print @q.xbgr.xq67_u8.qnpn13g2[ib]
print @q.xbgr.xq67_u8.qnpn13g2[ie]
print @q.xbgr.xq67_u8.qnpn13g2[is]
print @r.xbgr.xq67_u8.rsub[i]
print @c.xbgr.xq67_u8.csub[i]
print @q.xbgr.xq67_u9.qnpn13g2[ic]
print @q.xbgr.xq67_u9.qnpn13g2[ib]
print @q.xbgr.xq67_u9.qnpn13g2[ie]
print @q.xbgr.xq67_u9.qnpn13g2[is]
print @r.xbgr.xq67_u9.rsub[i]
print @c.xbgr.xq67_u9.csub[i]
print @q.xbgr.xq67_u10.qnpn13g2[ic]
print @q.xbgr.xq67_u10.qnpn13g2[ib]
print @q.xbgr.xq67_u10.qnpn13g2[ie]
print @q.xbgr.xq67_u10.qnpn13g2[is]
print @r.xbgr.xq67_u10.rsub[i]
print @c.xbgr.xq67_u10.csub[i]
print @q.xbgr.xq67_u11.qnpn13g2[ic]
print @q.xbgr.xq67_u11.qnpn13g2[ib]
print @q.xbgr.xq67_u11.qnpn13g2[ie]
print @q.xbgr.xq67_u11.qnpn13g2[is]
print @r.xbgr.xq67_u11.rsub[i]
print @c.xbgr.xq67_u11.csub[i]
print @q.xbgr.xq67_u12.qnpn13g2[ic]
print @q.xbgr.xq67_u12.qnpn13g2[ib]
print @q.xbgr.xq67_u12.qnpn13g2[ie]
print @q.xbgr.xq67_u12.qnpn13g2[is]
print @r.xbgr.xq67_u12.rsub[i]
print @c.xbgr.xq67_u12.csub[i]
print @q.xbgr.xq67_u13.qnpn13g2[ic]
print @q.xbgr.xq67_u13.qnpn13g2[ib]
print @q.xbgr.xq67_u13.qnpn13g2[ie]
print @q.xbgr.xq67_u13.qnpn13g2[is]
print @r.xbgr.xq67_u13.rsub[i]
print @c.xbgr.xq67_u13.csub[i]
print @q.xbgr.xq67_u14.qnpn13g2[ic]
print @q.xbgr.xq67_u14.qnpn13g2[ib]
print @q.xbgr.xq67_u14.qnpn13g2[ie]
print @q.xbgr.xq67_u14.qnpn13g2[is]
print @r.xbgr.xq67_u14.rsub[i]
print @c.xbgr.xq67_u14.csub[i]
print @q.xbgr.xq67_u15.qnpn13g2[ic]
print @q.xbgr.xq67_u15.qnpn13g2[ib]
print @q.xbgr.xq67_u15.qnpn13g2[ie]
print @q.xbgr.xq67_u15.qnpn13g2[is]
print @r.xbgr.xq67_u15.rsub[i]
print @c.xbgr.xq67_u15.csub[i]
print @q.xbgr.xq67_u16.qnpn13g2[ic]
print @q.xbgr.xq67_u16.qnpn13g2[ib]
print @q.xbgr.xq67_u16.qnpn13g2[ie]
print @q.xbgr.xq67_u16.qnpn13g2[is]
print @r.xbgr.xq67_u16.rsub[i]
print @c.xbgr.xq67_u16.csub[i]
print @q.xbgr.xq67_u17.qnpn13g2[ic]
print @q.xbgr.xq67_u17.qnpn13g2[ib]
print @q.xbgr.xq67_u17.qnpn13g2[ie]
print @q.xbgr.xq67_u17.qnpn13g2[is]
print @r.xbgr.xq67_u17.rsub[i]
print @c.xbgr.xq67_u17.csub[i]
print @q.xbgr.xq67_u18.qnpn13g2[ic]
print @q.xbgr.xq67_u18.qnpn13g2[ib]
print @q.xbgr.xq67_u18.qnpn13g2[ie]
print @q.xbgr.xq67_u18.qnpn13g2[is]
print @r.xbgr.xq67_u18.rsub[i]
print @c.xbgr.xq67_u18.csub[i]
print @q.xbgr.xq67_u19.qnpn13g2[ic]
print @q.xbgr.xq67_u19.qnpn13g2[ib]
print @q.xbgr.xq67_u19.qnpn13g2[ie]
print @q.xbgr.xq67_u19.qnpn13g2[is]
print @r.xbgr.xq67_u19.rsub[i]
print @c.xbgr.xq67_u19.csub[i]
print @q.xbgr.xq67_u20.qnpn13g2[ic]
print @q.xbgr.xq67_u20.qnpn13g2[ib]
print @q.xbgr.xq67_u20.qnpn13g2[ie]
print @q.xbgr.xq67_u20.qnpn13g2[is]
print @r.xbgr.xq67_u20.rsub[i]
print @c.xbgr.xq67_u20.csub[i]
print @q.xbgr.xq67_u21.qnpn13g2[ic]
print @q.xbgr.xq67_u21.qnpn13g2[ib]
print @q.xbgr.xq67_u21.qnpn13g2[ie]
print @q.xbgr.xq67_u21.qnpn13g2[is]
print @r.xbgr.xq67_u21.rsub[i]
print @c.xbgr.xq67_u21.csub[i]
print @q.xbgr.xq67_u22.qnpn13g2[ic]
print @q.xbgr.xq67_u22.qnpn13g2[ib]
print @q.xbgr.xq67_u22.qnpn13g2[ie]
print @q.xbgr.xq67_u22.qnpn13g2[is]
print @r.xbgr.xq67_u22.rsub[i]
print @c.xbgr.xq67_u22.csub[i]
print @q.xbgr.xq67_u23.qnpn13g2[ic]
print @q.xbgr.xq67_u23.qnpn13g2[ib]
print @q.xbgr.xq67_u23.qnpn13g2[ie]
print @q.xbgr.xq67_u23.qnpn13g2[is]
print @r.xbgr.xq67_u23.rsub[i]
print @c.xbgr.xq67_u23.csub[i]
print @q.xbgr.xq67_u24.qnpn13g2[ic]
print @q.xbgr.xq67_u24.qnpn13g2[ib]
print @q.xbgr.xq67_u24.qnpn13g2[ie]
print @q.xbgr.xq67_u24.qnpn13g2[is]
print @r.xbgr.xq67_u24.rsub[i]
print @c.xbgr.xq67_u24.csub[i]
print @q.xbgr.xq68_u2.qnpn13g2[ic]
print @q.xbgr.xq68_u2.qnpn13g2[ib]
print @q.xbgr.xq68_u2.qnpn13g2[ie]
print @q.xbgr.xq68_u2.qnpn13g2[is]
print @r.xbgr.xq68_u2.rsub[i]
print @c.xbgr.xq68_u2.csub[i]
print @q.xbgr.xq68_u3.qnpn13g2[ic]
print @q.xbgr.xq68_u3.qnpn13g2[ib]
print @q.xbgr.xq68_u3.qnpn13g2[ie]
print @q.xbgr.xq68_u3.qnpn13g2[is]
print @r.xbgr.xq68_u3.rsub[i]
print @c.xbgr.xq68_u3.csub[i]
print @q.xbgr.xq68_u4.qnpn13g2[ic]
print @q.xbgr.xq68_u4.qnpn13g2[ib]
print @q.xbgr.xq68_u4.qnpn13g2[ie]
print @q.xbgr.xq68_u4.qnpn13g2[is]
print @r.xbgr.xq68_u4.rsub[i]
print @c.xbgr.xq68_u4.csub[i]
print @q.xbgr.xq68_u5.qnpn13g2[ic]
print @q.xbgr.xq68_u5.qnpn13g2[ib]
print @q.xbgr.xq68_u5.qnpn13g2[ie]
print @q.xbgr.xq68_u5.qnpn13g2[is]
print @r.xbgr.xq68_u5.rsub[i]
print @c.xbgr.xq68_u5.csub[i]
print @q.xbgr.xq68_u6.qnpn13g2[ic]
print @q.xbgr.xq68_u6.qnpn13g2[ib]
print @q.xbgr.xq68_u6.qnpn13g2[ie]
print @q.xbgr.xq68_u6.qnpn13g2[is]
print @r.xbgr.xq68_u6.rsub[i]
print @c.xbgr.xq68_u6.csub[i]
print @q.xbgr.xq68_u7.qnpn13g2[ic]
print @q.xbgr.xq68_u7.qnpn13g2[ib]
print @q.xbgr.xq68_u7.qnpn13g2[ie]
print @q.xbgr.xq68_u7.qnpn13g2[is]
print @r.xbgr.xq68_u7.rsub[i]
print @c.xbgr.xq68_u7.csub[i]
print @q.xbgr.xq68_u8.qnpn13g2[ic]
print @q.xbgr.xq68_u8.qnpn13g2[ib]
print @q.xbgr.xq68_u8.qnpn13g2[ie]
print @q.xbgr.xq68_u8.qnpn13g2[is]
print @r.xbgr.xq68_u8.rsub[i]
print @c.xbgr.xq68_u8.csub[i]
print @q.xbgr.xq68_u9.qnpn13g2[ic]
print @q.xbgr.xq68_u9.qnpn13g2[ib]
print @q.xbgr.xq68_u9.qnpn13g2[ie]
print @q.xbgr.xq68_u9.qnpn13g2[is]
print @r.xbgr.xq68_u9.rsub[i]
print @c.xbgr.xq68_u9.csub[i]
print @q.xbgr.xq68_u10.qnpn13g2[ic]
print @q.xbgr.xq68_u10.qnpn13g2[ib]
print @q.xbgr.xq68_u10.qnpn13g2[ie]
print @q.xbgr.xq68_u10.qnpn13g2[is]
print @r.xbgr.xq68_u10.rsub[i]
print @c.xbgr.xq68_u10.csub[i]
print @q.xbgr.xq68_u11.qnpn13g2[ic]
print @q.xbgr.xq68_u11.qnpn13g2[ib]
print @q.xbgr.xq68_u11.qnpn13g2[ie]
print @q.xbgr.xq68_u11.qnpn13g2[is]
print @r.xbgr.xq68_u11.rsub[i]
print @c.xbgr.xq68_u11.csub[i]
print @q.xbgr.xq68_u12.qnpn13g2[ic]
print @q.xbgr.xq68_u12.qnpn13g2[ib]
print @q.xbgr.xq68_u12.qnpn13g2[ie]
print @q.xbgr.xq68_u12.qnpn13g2[is]
print @r.xbgr.xq68_u12.rsub[i]
print @c.xbgr.xq68_u12.csub[i]
print @q.xbgr.xq68_u13.qnpn13g2[ic]
print @q.xbgr.xq68_u13.qnpn13g2[ib]
print @q.xbgr.xq68_u13.qnpn13g2[ie]
print @q.xbgr.xq68_u13.qnpn13g2[is]
print @r.xbgr.xq68_u13.rsub[i]
print @c.xbgr.xq68_u13.csub[i]
print @q.xbgr.xq68_u14.qnpn13g2[ic]
print @q.xbgr.xq68_u14.qnpn13g2[ib]
print @q.xbgr.xq68_u14.qnpn13g2[ie]
print @q.xbgr.xq68_u14.qnpn13g2[is]
print @r.xbgr.xq68_u14.rsub[i]
print @c.xbgr.xq68_u14.csub[i]
print @q.xbgr.xq68_u15.qnpn13g2[ic]
print @q.xbgr.xq68_u15.qnpn13g2[ib]
print @q.xbgr.xq68_u15.qnpn13g2[ie]
print @q.xbgr.xq68_u15.qnpn13g2[is]
print @r.xbgr.xq68_u15.rsub[i]
print @c.xbgr.xq68_u15.csub[i]
print @q.xbgr.xq68_u16.qnpn13g2[ic]
print @q.xbgr.xq68_u16.qnpn13g2[ib]
print @q.xbgr.xq68_u16.qnpn13g2[ie]
print @q.xbgr.xq68_u16.qnpn13g2[is]
print @r.xbgr.xq68_u16.rsub[i]
print @c.xbgr.xq68_u16.csub[i]
print @q.xbgr.xq68_u17.qnpn13g2[ic]
print @q.xbgr.xq68_u17.qnpn13g2[ib]
print @q.xbgr.xq68_u17.qnpn13g2[ie]
print @q.xbgr.xq68_u17.qnpn13g2[is]
print @r.xbgr.xq68_u17.rsub[i]
print @c.xbgr.xq68_u17.csub[i]
print @q.xbgr.xq68_u18.qnpn13g2[ic]
print @q.xbgr.xq68_u18.qnpn13g2[ib]
print @q.xbgr.xq68_u18.qnpn13g2[ie]
print @q.xbgr.xq68_u18.qnpn13g2[is]
print @r.xbgr.xq68_u18.rsub[i]
print @c.xbgr.xq68_u18.csub[i]
print @q.xbgr.xq68_u19.qnpn13g2[ic]
print @q.xbgr.xq68_u19.qnpn13g2[ib]
print @q.xbgr.xq68_u19.qnpn13g2[ie]
print @q.xbgr.xq68_u19.qnpn13g2[is]
print @r.xbgr.xq68_u19.rsub[i]
print @c.xbgr.xq68_u19.csub[i]
print @q.xbgr.xq68_u20.qnpn13g2[ic]
print @q.xbgr.xq68_u20.qnpn13g2[ib]
print @q.xbgr.xq68_u20.qnpn13g2[ie]
print @q.xbgr.xq68_u20.qnpn13g2[is]
print @r.xbgr.xq68_u20.rsub[i]
print @c.xbgr.xq68_u20.csub[i]
print @q.xbgr.xq68_u21.qnpn13g2[ic]
print @q.xbgr.xq68_u21.qnpn13g2[ib]
print @q.xbgr.xq68_u21.qnpn13g2[ie]
print @q.xbgr.xq68_u21.qnpn13g2[is]
print @r.xbgr.xq68_u21.rsub[i]
print @c.xbgr.xq68_u21.csub[i]
print @q.xbgr.xq68_u22.qnpn13g2[ic]
print @q.xbgr.xq68_u22.qnpn13g2[ib]
print @q.xbgr.xq68_u22.qnpn13g2[ie]
print @q.xbgr.xq68_u22.qnpn13g2[is]
print @r.xbgr.xq68_u22.rsub[i]
print @c.xbgr.xq68_u22.csub[i]
print @q.xbgr.xq68_u23.qnpn13g2[ic]
print @q.xbgr.xq68_u23.qnpn13g2[ib]
print @q.xbgr.xq68_u23.qnpn13g2[ie]
print @q.xbgr.xq68_u23.qnpn13g2[is]
print @r.xbgr.xq68_u23.rsub[i]
print @c.xbgr.xq68_u23.csub[i]
print @q.xbgr.xq68_u24.qnpn13g2[ic]
print @q.xbgr.xq68_u24.qnpn13g2[ib]
print @q.xbgr.xq68_u24.qnpn13g2[ie]
print @q.xbgr.xq68_u24.qnpn13g2[is]
print @r.xbgr.xq68_u24.rsub[i]
print @c.xbgr.xq68_u24.csub[i]
print @q.xbgr.xq69_u2.qnpn13g2[ic]
print @q.xbgr.xq69_u2.qnpn13g2[ib]
print @q.xbgr.xq69_u2.qnpn13g2[ie]
print @q.xbgr.xq69_u2.qnpn13g2[is]
print @r.xbgr.xq69_u2.rsub[i]
print @c.xbgr.xq69_u2.csub[i]
print @q.xbgr.xq69_u3.qnpn13g2[ic]
print @q.xbgr.xq69_u3.qnpn13g2[ib]
print @q.xbgr.xq69_u3.qnpn13g2[ie]
print @q.xbgr.xq69_u3.qnpn13g2[is]
print @r.xbgr.xq69_u3.rsub[i]
print @c.xbgr.xq69_u3.csub[i]
print @q.xbgr.xq69_u4.qnpn13g2[ic]
print @q.xbgr.xq69_u4.qnpn13g2[ib]
print @q.xbgr.xq69_u4.qnpn13g2[ie]
print @q.xbgr.xq69_u4.qnpn13g2[is]
print @r.xbgr.xq69_u4.rsub[i]
print @c.xbgr.xq69_u4.csub[i]
print @q.xbgr.xq69_u5.qnpn13g2[ic]
print @q.xbgr.xq69_u5.qnpn13g2[ib]
print @q.xbgr.xq69_u5.qnpn13g2[ie]
print @q.xbgr.xq69_u5.qnpn13g2[is]
print @r.xbgr.xq69_u5.rsub[i]
print @c.xbgr.xq69_u5.csub[i]
print @q.xbgr.xq69_u6.qnpn13g2[ic]
print @q.xbgr.xq69_u6.qnpn13g2[ib]
print @q.xbgr.xq69_u6.qnpn13g2[ie]
print @q.xbgr.xq69_u6.qnpn13g2[is]
print @r.xbgr.xq69_u6.rsub[i]
print @c.xbgr.xq69_u6.csub[i]
print @q.xbgr.xq69_u7.qnpn13g2[ic]
print @q.xbgr.xq69_u7.qnpn13g2[ib]
print @q.xbgr.xq69_u7.qnpn13g2[ie]
print @q.xbgr.xq69_u7.qnpn13g2[is]
print @r.xbgr.xq69_u7.rsub[i]
print @c.xbgr.xq69_u7.csub[i]
print @q.xbgr.xq69_u8.qnpn13g2[ic]
print @q.xbgr.xq69_u8.qnpn13g2[ib]
print @q.xbgr.xq69_u8.qnpn13g2[ie]
print @q.xbgr.xq69_u8.qnpn13g2[is]
print @r.xbgr.xq69_u8.rsub[i]
print @c.xbgr.xq69_u8.csub[i]
print @q.xbgr.xq69_u9.qnpn13g2[ic]
print @q.xbgr.xq69_u9.qnpn13g2[ib]
print @q.xbgr.xq69_u9.qnpn13g2[ie]
print @q.xbgr.xq69_u9.qnpn13g2[is]
print @r.xbgr.xq69_u9.rsub[i]
print @c.xbgr.xq69_u9.csub[i]
print @q.xbgr.xq69_u10.qnpn13g2[ic]
print @q.xbgr.xq69_u10.qnpn13g2[ib]
print @q.xbgr.xq69_u10.qnpn13g2[ie]
print @q.xbgr.xq69_u10.qnpn13g2[is]
print @r.xbgr.xq69_u10.rsub[i]
print @c.xbgr.xq69_u10.csub[i]
print @q.xbgr.xq69_u11.qnpn13g2[ic]
print @q.xbgr.xq69_u11.qnpn13g2[ib]
print @q.xbgr.xq69_u11.qnpn13g2[ie]
print @q.xbgr.xq69_u11.qnpn13g2[is]
print @r.xbgr.xq69_u11.rsub[i]
print @c.xbgr.xq69_u11.csub[i]
print @q.xbgr.xq69_u12.qnpn13g2[ic]
print @q.xbgr.xq69_u12.qnpn13g2[ib]
print @q.xbgr.xq69_u12.qnpn13g2[ie]
print @q.xbgr.xq69_u12.qnpn13g2[is]
print @r.xbgr.xq69_u12.rsub[i]
print @c.xbgr.xq69_u12.csub[i]
print @q.xbgr.xq69_u13.qnpn13g2[ic]
print @q.xbgr.xq69_u13.qnpn13g2[ib]
print @q.xbgr.xq69_u13.qnpn13g2[ie]
print @q.xbgr.xq69_u13.qnpn13g2[is]
print @r.xbgr.xq69_u13.rsub[i]
print @c.xbgr.xq69_u13.csub[i]
print @q.xbgr.xq69_u14.qnpn13g2[ic]
print @q.xbgr.xq69_u14.qnpn13g2[ib]
print @q.xbgr.xq69_u14.qnpn13g2[ie]
print @q.xbgr.xq69_u14.qnpn13g2[is]
print @r.xbgr.xq69_u14.rsub[i]
print @c.xbgr.xq69_u14.csub[i]
print @q.xbgr.xq69_u15.qnpn13g2[ic]
print @q.xbgr.xq69_u15.qnpn13g2[ib]
print @q.xbgr.xq69_u15.qnpn13g2[ie]
print @q.xbgr.xq69_u15.qnpn13g2[is]
print @r.xbgr.xq69_u15.rsub[i]
print @c.xbgr.xq69_u15.csub[i]
print @q.xbgr.xq69_u16.qnpn13g2[ic]
print @q.xbgr.xq69_u16.qnpn13g2[ib]
print @q.xbgr.xq69_u16.qnpn13g2[ie]
print @q.xbgr.xq69_u16.qnpn13g2[is]
print @r.xbgr.xq69_u16.rsub[i]
print @c.xbgr.xq69_u16.csub[i]
print @q.xbgr.xq69_u17.qnpn13g2[ic]
print @q.xbgr.xq69_u17.qnpn13g2[ib]
print @q.xbgr.xq69_u17.qnpn13g2[ie]
print @q.xbgr.xq69_u17.qnpn13g2[is]
print @r.xbgr.xq69_u17.rsub[i]
print @c.xbgr.xq69_u17.csub[i]
print @q.xbgr.xq69_u18.qnpn13g2[ic]
print @q.xbgr.xq69_u18.qnpn13g2[ib]
print @q.xbgr.xq69_u18.qnpn13g2[ie]
print @q.xbgr.xq69_u18.qnpn13g2[is]
print @r.xbgr.xq69_u18.rsub[i]
print @c.xbgr.xq69_u18.csub[i]
print @q.xbgr.xq69_u19.qnpn13g2[ic]
print @q.xbgr.xq69_u19.qnpn13g2[ib]
print @q.xbgr.xq69_u19.qnpn13g2[ie]
print @q.xbgr.xq69_u19.qnpn13g2[is]
print @r.xbgr.xq69_u19.rsub[i]
print @c.xbgr.xq69_u19.csub[i]
print @q.xbgr.xq69_u20.qnpn13g2[ic]
print @q.xbgr.xq69_u20.qnpn13g2[ib]
print @q.xbgr.xq69_u20.qnpn13g2[ie]
print @q.xbgr.xq69_u20.qnpn13g2[is]
print @r.xbgr.xq69_u20.rsub[i]
print @c.xbgr.xq69_u20.csub[i]
print @q.xbgr.xq69_u21.qnpn13g2[ic]
print @q.xbgr.xq69_u21.qnpn13g2[ib]
print @q.xbgr.xq69_u21.qnpn13g2[ie]
print @q.xbgr.xq69_u21.qnpn13g2[is]
print @r.xbgr.xq69_u21.rsub[i]
print @c.xbgr.xq69_u21.csub[i]
print @q.xbgr.xq69_u22.qnpn13g2[ic]
print @q.xbgr.xq69_u22.qnpn13g2[ib]
print @q.xbgr.xq69_u22.qnpn13g2[ie]
print @q.xbgr.xq69_u22.qnpn13g2[is]
print @r.xbgr.xq69_u22.rsub[i]
print @c.xbgr.xq69_u22.csub[i]
print @q.xbgr.xq69_u23.qnpn13g2[ic]
print @q.xbgr.xq69_u23.qnpn13g2[ib]
print @q.xbgr.xq69_u23.qnpn13g2[ie]
print @q.xbgr.xq69_u23.qnpn13g2[is]
print @r.xbgr.xq69_u23.rsub[i]
print @c.xbgr.xq69_u23.csub[i]
print @q.xbgr.xq69_u24.qnpn13g2[ic]
print @q.xbgr.xq69_u24.qnpn13g2[ib]
print @q.xbgr.xq69_u24.qnpn13g2[ie]
print @q.xbgr.xq69_u24.qnpn13g2[is]
print @r.xbgr.xq69_u24.rsub[i]
print @c.xbgr.xq69_u24.csub[i]
print @q.xbgr.xq70_u2.qnpn13g2[ic]
print @q.xbgr.xq70_u2.qnpn13g2[ib]
print @q.xbgr.xq70_u2.qnpn13g2[ie]
print @q.xbgr.xq70_u2.qnpn13g2[is]
print @r.xbgr.xq70_u2.rsub[i]
print @c.xbgr.xq70_u2.csub[i]
print @q.xbgr.xq70_u3.qnpn13g2[ic]
print @q.xbgr.xq70_u3.qnpn13g2[ib]
print @q.xbgr.xq70_u3.qnpn13g2[ie]
print @q.xbgr.xq70_u3.qnpn13g2[is]
print @r.xbgr.xq70_u3.rsub[i]
print @c.xbgr.xq70_u3.csub[i]
print @q.xbgr.xq70_u4.qnpn13g2[ic]
print @q.xbgr.xq70_u4.qnpn13g2[ib]
print @q.xbgr.xq70_u4.qnpn13g2[ie]
print @q.xbgr.xq70_u4.qnpn13g2[is]
print @r.xbgr.xq70_u4.rsub[i]
print @c.xbgr.xq70_u4.csub[i]
print @q.xbgr.xq70_u5.qnpn13g2[ic]
print @q.xbgr.xq70_u5.qnpn13g2[ib]
print @q.xbgr.xq70_u5.qnpn13g2[ie]
print @q.xbgr.xq70_u5.qnpn13g2[is]
print @r.xbgr.xq70_u5.rsub[i]
print @c.xbgr.xq70_u5.csub[i]
print @q.xbgr.xq70_u6.qnpn13g2[ic]
print @q.xbgr.xq70_u6.qnpn13g2[ib]
print @q.xbgr.xq70_u6.qnpn13g2[ie]
print @q.xbgr.xq70_u6.qnpn13g2[is]
print @r.xbgr.xq70_u6.rsub[i]
print @c.xbgr.xq70_u6.csub[i]
print @q.xbgr.xq70_u7.qnpn13g2[ic]
print @q.xbgr.xq70_u7.qnpn13g2[ib]
print @q.xbgr.xq70_u7.qnpn13g2[ie]
print @q.xbgr.xq70_u7.qnpn13g2[is]
print @r.xbgr.xq70_u7.rsub[i]
print @c.xbgr.xq70_u7.csub[i]
print @q.xbgr.xq70_u8.qnpn13g2[ic]
print @q.xbgr.xq70_u8.qnpn13g2[ib]
print @q.xbgr.xq70_u8.qnpn13g2[ie]
print @q.xbgr.xq70_u8.qnpn13g2[is]
print @r.xbgr.xq70_u8.rsub[i]
print @c.xbgr.xq70_u8.csub[i]
print @q.xbgr.xq70_u9.qnpn13g2[ic]
print @q.xbgr.xq70_u9.qnpn13g2[ib]
print @q.xbgr.xq70_u9.qnpn13g2[ie]
print @q.xbgr.xq70_u9.qnpn13g2[is]
print @r.xbgr.xq70_u9.rsub[i]
print @c.xbgr.xq70_u9.csub[i]
print @q.xbgr.xq70_u10.qnpn13g2[ic]
print @q.xbgr.xq70_u10.qnpn13g2[ib]
print @q.xbgr.xq70_u10.qnpn13g2[ie]
print @q.xbgr.xq70_u10.qnpn13g2[is]
print @r.xbgr.xq70_u10.rsub[i]
print @c.xbgr.xq70_u10.csub[i]
print @q.xbgr.xq70_u11.qnpn13g2[ic]
print @q.xbgr.xq70_u11.qnpn13g2[ib]
print @q.xbgr.xq70_u11.qnpn13g2[ie]
print @q.xbgr.xq70_u11.qnpn13g2[is]
print @r.xbgr.xq70_u11.rsub[i]
print @c.xbgr.xq70_u11.csub[i]
print @q.xbgr.xq70_u12.qnpn13g2[ic]
print @q.xbgr.xq70_u12.qnpn13g2[ib]
print @q.xbgr.xq70_u12.qnpn13g2[ie]
print @q.xbgr.xq70_u12.qnpn13g2[is]
print @r.xbgr.xq70_u12.rsub[i]
print @c.xbgr.xq70_u12.csub[i]
print @q.xbgr.xq70_u13.qnpn13g2[ic]
print @q.xbgr.xq70_u13.qnpn13g2[ib]
print @q.xbgr.xq70_u13.qnpn13g2[ie]
print @q.xbgr.xq70_u13.qnpn13g2[is]
print @r.xbgr.xq70_u13.rsub[i]
print @c.xbgr.xq70_u13.csub[i]
print @q.xbgr.xq70_u14.qnpn13g2[ic]
print @q.xbgr.xq70_u14.qnpn13g2[ib]
print @q.xbgr.xq70_u14.qnpn13g2[ie]
print @q.xbgr.xq70_u14.qnpn13g2[is]
print @r.xbgr.xq70_u14.rsub[i]
print @c.xbgr.xq70_u14.csub[i]
print @q.xbgr.xq70_u15.qnpn13g2[ic]
print @q.xbgr.xq70_u15.qnpn13g2[ib]
print @q.xbgr.xq70_u15.qnpn13g2[ie]
print @q.xbgr.xq70_u15.qnpn13g2[is]
print @r.xbgr.xq70_u15.rsub[i]
print @c.xbgr.xq70_u15.csub[i]
print @q.xbgr.xq70_u16.qnpn13g2[ic]
print @q.xbgr.xq70_u16.qnpn13g2[ib]
print @q.xbgr.xq70_u16.qnpn13g2[ie]
print @q.xbgr.xq70_u16.qnpn13g2[is]
print @r.xbgr.xq70_u16.rsub[i]
print @c.xbgr.xq70_u16.csub[i]
print @q.xbgr.xq70_u17.qnpn13g2[ic]
print @q.xbgr.xq70_u17.qnpn13g2[ib]
print @q.xbgr.xq70_u17.qnpn13g2[ie]
print @q.xbgr.xq70_u17.qnpn13g2[is]
print @r.xbgr.xq70_u17.rsub[i]
print @c.xbgr.xq70_u17.csub[i]
print @q.xbgr.xq70_u18.qnpn13g2[ic]
print @q.xbgr.xq70_u18.qnpn13g2[ib]
print @q.xbgr.xq70_u18.qnpn13g2[ie]
print @q.xbgr.xq70_u18.qnpn13g2[is]
print @r.xbgr.xq70_u18.rsub[i]
print @c.xbgr.xq70_u18.csub[i]
print @q.xbgr.xq70_u19.qnpn13g2[ic]
print @q.xbgr.xq70_u19.qnpn13g2[ib]
print @q.xbgr.xq70_u19.qnpn13g2[ie]
print @q.xbgr.xq70_u19.qnpn13g2[is]
print @r.xbgr.xq70_u19.rsub[i]
print @c.xbgr.xq70_u19.csub[i]
print @q.xbgr.xq70_u20.qnpn13g2[ic]
print @q.xbgr.xq70_u20.qnpn13g2[ib]
print @q.xbgr.xq70_u20.qnpn13g2[ie]
print @q.xbgr.xq70_u20.qnpn13g2[is]
print @r.xbgr.xq70_u20.rsub[i]
print @c.xbgr.xq70_u20.csub[i]
print @q.xbgr.xq70_u21.qnpn13g2[ic]
print @q.xbgr.xq70_u21.qnpn13g2[ib]
print @q.xbgr.xq70_u21.qnpn13g2[ie]
print @q.xbgr.xq70_u21.qnpn13g2[is]
print @r.xbgr.xq70_u21.rsub[i]
print @c.xbgr.xq70_u21.csub[i]
print @q.xbgr.xq70_u22.qnpn13g2[ic]
print @q.xbgr.xq70_u22.qnpn13g2[ib]
print @q.xbgr.xq70_u22.qnpn13g2[ie]
print @q.xbgr.xq70_u22.qnpn13g2[is]
print @r.xbgr.xq70_u22.rsub[i]
print @c.xbgr.xq70_u22.csub[i]
print @q.xbgr.xq70_u23.qnpn13g2[ic]
print @q.xbgr.xq70_u23.qnpn13g2[ib]
print @q.xbgr.xq70_u23.qnpn13g2[ie]
print @q.xbgr.xq70_u23.qnpn13g2[is]
print @r.xbgr.xq70_u23.rsub[i]
print @c.xbgr.xq70_u23.csub[i]
print @q.xbgr.xq70_u24.qnpn13g2[ic]
print @q.xbgr.xq70_u24.qnpn13g2[ib]
print @q.xbgr.xq70_u24.qnpn13g2[ie]
print @q.xbgr.xq70_u24.qnpn13g2[is]
print @r.xbgr.xq70_u24.rsub[i]
print @c.xbgr.xq70_u24.csub[i]
print @q.xbgr.xq71_u2.qnpn13g2[ic]
print @q.xbgr.xq71_u2.qnpn13g2[ib]
print @q.xbgr.xq71_u2.qnpn13g2[ie]
print @q.xbgr.xq71_u2.qnpn13g2[is]
print @r.xbgr.xq71_u2.rsub[i]
print @c.xbgr.xq71_u2.csub[i]
print @q.xbgr.xq71_u3.qnpn13g2[ic]
print @q.xbgr.xq71_u3.qnpn13g2[ib]
print @q.xbgr.xq71_u3.qnpn13g2[ie]
print @q.xbgr.xq71_u3.qnpn13g2[is]
print @r.xbgr.xq71_u3.rsub[i]
print @c.xbgr.xq71_u3.csub[i]
print @q.xbgr.xq71_u4.qnpn13g2[ic]
print @q.xbgr.xq71_u4.qnpn13g2[ib]
print @q.xbgr.xq71_u4.qnpn13g2[ie]
print @q.xbgr.xq71_u4.qnpn13g2[is]
print @r.xbgr.xq71_u4.rsub[i]
print @c.xbgr.xq71_u4.csub[i]
print @q.xbgr.xq71_u5.qnpn13g2[ic]
print @q.xbgr.xq71_u5.qnpn13g2[ib]
print @q.xbgr.xq71_u5.qnpn13g2[ie]
print @q.xbgr.xq71_u5.qnpn13g2[is]
print @r.xbgr.xq71_u5.rsub[i]
print @c.xbgr.xq71_u5.csub[i]
print @q.xbgr.xq71_u6.qnpn13g2[ic]
print @q.xbgr.xq71_u6.qnpn13g2[ib]
print @q.xbgr.xq71_u6.qnpn13g2[ie]
print @q.xbgr.xq71_u6.qnpn13g2[is]
print @r.xbgr.xq71_u6.rsub[i]
print @c.xbgr.xq71_u6.csub[i]
print @q.xbgr.xq71_u7.qnpn13g2[ic]
print @q.xbgr.xq71_u7.qnpn13g2[ib]
print @q.xbgr.xq71_u7.qnpn13g2[ie]
print @q.xbgr.xq71_u7.qnpn13g2[is]
print @r.xbgr.xq71_u7.rsub[i]
print @c.xbgr.xq71_u7.csub[i]
print @q.xbgr.xq71_u8.qnpn13g2[ic]
print @q.xbgr.xq71_u8.qnpn13g2[ib]
print @q.xbgr.xq71_u8.qnpn13g2[ie]
print @q.xbgr.xq71_u8.qnpn13g2[is]
print @r.xbgr.xq71_u8.rsub[i]
print @c.xbgr.xq71_u8.csub[i]
print @q.xbgr.xq71_u9.qnpn13g2[ic]
print @q.xbgr.xq71_u9.qnpn13g2[ib]
print @q.xbgr.xq71_u9.qnpn13g2[ie]
print @q.xbgr.xq71_u9.qnpn13g2[is]
print @r.xbgr.xq71_u9.rsub[i]
print @c.xbgr.xq71_u9.csub[i]
print @q.xbgr.xq71_u10.qnpn13g2[ic]
print @q.xbgr.xq71_u10.qnpn13g2[ib]
print @q.xbgr.xq71_u10.qnpn13g2[ie]
print @q.xbgr.xq71_u10.qnpn13g2[is]
print @r.xbgr.xq71_u10.rsub[i]
print @c.xbgr.xq71_u10.csub[i]
print @q.xbgr.xq71_u11.qnpn13g2[ic]
print @q.xbgr.xq71_u11.qnpn13g2[ib]
print @q.xbgr.xq71_u11.qnpn13g2[ie]
print @q.xbgr.xq71_u11.qnpn13g2[is]
print @r.xbgr.xq71_u11.rsub[i]
print @c.xbgr.xq71_u11.csub[i]
print @q.xbgr.xq71_u12.qnpn13g2[ic]
print @q.xbgr.xq71_u12.qnpn13g2[ib]
print @q.xbgr.xq71_u12.qnpn13g2[ie]
print @q.xbgr.xq71_u12.qnpn13g2[is]
print @r.xbgr.xq71_u12.rsub[i]
print @c.xbgr.xq71_u12.csub[i]
print @q.xbgr.xq71_u13.qnpn13g2[ic]
print @q.xbgr.xq71_u13.qnpn13g2[ib]
print @q.xbgr.xq71_u13.qnpn13g2[ie]
print @q.xbgr.xq71_u13.qnpn13g2[is]
print @r.xbgr.xq71_u13.rsub[i]
print @c.xbgr.xq71_u13.csub[i]
print @q.xbgr.xq71_u14.qnpn13g2[ic]
print @q.xbgr.xq71_u14.qnpn13g2[ib]
print @q.xbgr.xq71_u14.qnpn13g2[ie]
print @q.xbgr.xq71_u14.qnpn13g2[is]
print @r.xbgr.xq71_u14.rsub[i]
print @c.xbgr.xq71_u14.csub[i]
print @q.xbgr.xq71_u15.qnpn13g2[ic]
print @q.xbgr.xq71_u15.qnpn13g2[ib]
print @q.xbgr.xq71_u15.qnpn13g2[ie]
print @q.xbgr.xq71_u15.qnpn13g2[is]
print @r.xbgr.xq71_u15.rsub[i]
print @c.xbgr.xq71_u15.csub[i]
print @q.xbgr.xq71_u16.qnpn13g2[ic]
print @q.xbgr.xq71_u16.qnpn13g2[ib]
print @q.xbgr.xq71_u16.qnpn13g2[ie]
print @q.xbgr.xq71_u16.qnpn13g2[is]
print @r.xbgr.xq71_u16.rsub[i]
print @c.xbgr.xq71_u16.csub[i]
print @q.xbgr.xq71_u17.qnpn13g2[ic]
print @q.xbgr.xq71_u17.qnpn13g2[ib]
print @q.xbgr.xq71_u17.qnpn13g2[ie]
print @q.xbgr.xq71_u17.qnpn13g2[is]
print @r.xbgr.xq71_u17.rsub[i]
print @c.xbgr.xq71_u17.csub[i]
print @q.xbgr.xq71_u18.qnpn13g2[ic]
print @q.xbgr.xq71_u18.qnpn13g2[ib]
print @q.xbgr.xq71_u18.qnpn13g2[ie]
print @q.xbgr.xq71_u18.qnpn13g2[is]
print @r.xbgr.xq71_u18.rsub[i]
print @c.xbgr.xq71_u18.csub[i]
print @q.xbgr.xq71_u19.qnpn13g2[ic]
print @q.xbgr.xq71_u19.qnpn13g2[ib]
print @q.xbgr.xq71_u19.qnpn13g2[ie]
print @q.xbgr.xq71_u19.qnpn13g2[is]
print @r.xbgr.xq71_u19.rsub[i]
print @c.xbgr.xq71_u19.csub[i]
print @q.xbgr.xq71_u20.qnpn13g2[ic]
print @q.xbgr.xq71_u20.qnpn13g2[ib]
print @q.xbgr.xq71_u20.qnpn13g2[ie]
print @q.xbgr.xq71_u20.qnpn13g2[is]
print @r.xbgr.xq71_u20.rsub[i]
print @c.xbgr.xq71_u20.csub[i]
print @q.xbgr.xq71_u21.qnpn13g2[ic]
print @q.xbgr.xq71_u21.qnpn13g2[ib]
print @q.xbgr.xq71_u21.qnpn13g2[ie]
print @q.xbgr.xq71_u21.qnpn13g2[is]
print @r.xbgr.xq71_u21.rsub[i]
print @c.xbgr.xq71_u21.csub[i]
print @q.xbgr.xq71_u22.qnpn13g2[ic]
print @q.xbgr.xq71_u22.qnpn13g2[ib]
print @q.xbgr.xq71_u22.qnpn13g2[ie]
print @q.xbgr.xq71_u22.qnpn13g2[is]
print @r.xbgr.xq71_u22.rsub[i]
print @c.xbgr.xq71_u22.csub[i]
print @q.xbgr.xq71_u23.qnpn13g2[ic]
print @q.xbgr.xq71_u23.qnpn13g2[ib]
print @q.xbgr.xq71_u23.qnpn13g2[ie]
print @q.xbgr.xq71_u23.qnpn13g2[is]
print @r.xbgr.xq71_u23.rsub[i]
print @c.xbgr.xq71_u23.csub[i]
print @q.xbgr.xq71_u24.qnpn13g2[ic]
print @q.xbgr.xq71_u24.qnpn13g2[ib]
print @q.xbgr.xq71_u24.qnpn13g2[ie]
print @q.xbgr.xq71_u24.qnpn13g2[is]
print @r.xbgr.xq71_u24.rsub[i]
print @c.xbgr.xq71_u24.csub[i]
print @q.xbgr.xq72_u2.qnpn13g2[ic]
print @q.xbgr.xq72_u2.qnpn13g2[ib]
print @q.xbgr.xq72_u2.qnpn13g2[ie]
print @q.xbgr.xq72_u2.qnpn13g2[is]
print @r.xbgr.xq72_u2.rsub[i]
print @c.xbgr.xq72_u2.csub[i]
print @q.xbgr.xq72_u3.qnpn13g2[ic]
print @q.xbgr.xq72_u3.qnpn13g2[ib]
print @q.xbgr.xq72_u3.qnpn13g2[ie]
print @q.xbgr.xq72_u3.qnpn13g2[is]
print @r.xbgr.xq72_u3.rsub[i]
print @c.xbgr.xq72_u3.csub[i]
print @q.xbgr.xq72_u4.qnpn13g2[ic]
print @q.xbgr.xq72_u4.qnpn13g2[ib]
print @q.xbgr.xq72_u4.qnpn13g2[ie]
print @q.xbgr.xq72_u4.qnpn13g2[is]
print @r.xbgr.xq72_u4.rsub[i]
print @c.xbgr.xq72_u4.csub[i]
print @q.xbgr.xq72_u5.qnpn13g2[ic]
print @q.xbgr.xq72_u5.qnpn13g2[ib]
print @q.xbgr.xq72_u5.qnpn13g2[ie]
print @q.xbgr.xq72_u5.qnpn13g2[is]
print @r.xbgr.xq72_u5.rsub[i]
print @c.xbgr.xq72_u5.csub[i]
print @q.xbgr.xq72_u6.qnpn13g2[ic]
print @q.xbgr.xq72_u6.qnpn13g2[ib]
print @q.xbgr.xq72_u6.qnpn13g2[ie]
print @q.xbgr.xq72_u6.qnpn13g2[is]
print @r.xbgr.xq72_u6.rsub[i]
print @c.xbgr.xq72_u6.csub[i]
print @q.xbgr.xq72_u7.qnpn13g2[ic]
print @q.xbgr.xq72_u7.qnpn13g2[ib]
print @q.xbgr.xq72_u7.qnpn13g2[ie]
print @q.xbgr.xq72_u7.qnpn13g2[is]
print @r.xbgr.xq72_u7.rsub[i]
print @c.xbgr.xq72_u7.csub[i]
print @q.xbgr.xq72_u8.qnpn13g2[ic]
print @q.xbgr.xq72_u8.qnpn13g2[ib]
print @q.xbgr.xq72_u8.qnpn13g2[ie]
print @q.xbgr.xq72_u8.qnpn13g2[is]
print @r.xbgr.xq72_u8.rsub[i]
print @c.xbgr.xq72_u8.csub[i]
print @q.xbgr.xq72_u9.qnpn13g2[ic]
print @q.xbgr.xq72_u9.qnpn13g2[ib]
print @q.xbgr.xq72_u9.qnpn13g2[ie]
print @q.xbgr.xq72_u9.qnpn13g2[is]
print @r.xbgr.xq72_u9.rsub[i]
print @c.xbgr.xq72_u9.csub[i]
print @q.xbgr.xq72_u10.qnpn13g2[ic]
print @q.xbgr.xq72_u10.qnpn13g2[ib]
print @q.xbgr.xq72_u10.qnpn13g2[ie]
print @q.xbgr.xq72_u10.qnpn13g2[is]
print @r.xbgr.xq72_u10.rsub[i]
print @c.xbgr.xq72_u10.csub[i]
print @q.xbgr.xq72_u11.qnpn13g2[ic]
print @q.xbgr.xq72_u11.qnpn13g2[ib]
print @q.xbgr.xq72_u11.qnpn13g2[ie]
print @q.xbgr.xq72_u11.qnpn13g2[is]
print @r.xbgr.xq72_u11.rsub[i]
print @c.xbgr.xq72_u11.csub[i]
print @q.xbgr.xq72_u12.qnpn13g2[ic]
print @q.xbgr.xq72_u12.qnpn13g2[ib]
print @q.xbgr.xq72_u12.qnpn13g2[ie]
print @q.xbgr.xq72_u12.qnpn13g2[is]
print @r.xbgr.xq72_u12.rsub[i]
print @c.xbgr.xq72_u12.csub[i]
print @q.xbgr.xq72_u13.qnpn13g2[ic]
print @q.xbgr.xq72_u13.qnpn13g2[ib]
print @q.xbgr.xq72_u13.qnpn13g2[ie]
print @q.xbgr.xq72_u13.qnpn13g2[is]
print @r.xbgr.xq72_u13.rsub[i]
print @c.xbgr.xq72_u13.csub[i]
print @q.xbgr.xq72_u14.qnpn13g2[ic]
print @q.xbgr.xq72_u14.qnpn13g2[ib]
print @q.xbgr.xq72_u14.qnpn13g2[ie]
print @q.xbgr.xq72_u14.qnpn13g2[is]
print @r.xbgr.xq72_u14.rsub[i]
print @c.xbgr.xq72_u14.csub[i]
print @q.xbgr.xq72_u15.qnpn13g2[ic]
print @q.xbgr.xq72_u15.qnpn13g2[ib]
print @q.xbgr.xq72_u15.qnpn13g2[ie]
print @q.xbgr.xq72_u15.qnpn13g2[is]
print @r.xbgr.xq72_u15.rsub[i]
print @c.xbgr.xq72_u15.csub[i]
print @q.xbgr.xq72_u16.qnpn13g2[ic]
print @q.xbgr.xq72_u16.qnpn13g2[ib]
print @q.xbgr.xq72_u16.qnpn13g2[ie]
print @q.xbgr.xq72_u16.qnpn13g2[is]
print @r.xbgr.xq72_u16.rsub[i]
print @c.xbgr.xq72_u16.csub[i]
print @q.xbgr.xq72_u17.qnpn13g2[ic]
print @q.xbgr.xq72_u17.qnpn13g2[ib]
print @q.xbgr.xq72_u17.qnpn13g2[ie]
print @q.xbgr.xq72_u17.qnpn13g2[is]
print @r.xbgr.xq72_u17.rsub[i]
print @c.xbgr.xq72_u17.csub[i]
print @q.xbgr.xq72_u18.qnpn13g2[ic]
print @q.xbgr.xq72_u18.qnpn13g2[ib]
print @q.xbgr.xq72_u18.qnpn13g2[ie]
print @q.xbgr.xq72_u18.qnpn13g2[is]
print @r.xbgr.xq72_u18.rsub[i]
print @c.xbgr.xq72_u18.csub[i]
print @q.xbgr.xq72_u19.qnpn13g2[ic]
print @q.xbgr.xq72_u19.qnpn13g2[ib]
print @q.xbgr.xq72_u19.qnpn13g2[ie]
print @q.xbgr.xq72_u19.qnpn13g2[is]
print @r.xbgr.xq72_u19.rsub[i]
print @c.xbgr.xq72_u19.csub[i]
print @q.xbgr.xq72_u20.qnpn13g2[ic]
print @q.xbgr.xq72_u20.qnpn13g2[ib]
print @q.xbgr.xq72_u20.qnpn13g2[ie]
print @q.xbgr.xq72_u20.qnpn13g2[is]
print @r.xbgr.xq72_u20.rsub[i]
print @c.xbgr.xq72_u20.csub[i]
print @q.xbgr.xq72_u21.qnpn13g2[ic]
print @q.xbgr.xq72_u21.qnpn13g2[ib]
print @q.xbgr.xq72_u21.qnpn13g2[ie]
print @q.xbgr.xq72_u21.qnpn13g2[is]
print @r.xbgr.xq72_u21.rsub[i]
print @c.xbgr.xq72_u21.csub[i]
print @q.xbgr.xq72_u22.qnpn13g2[ic]
print @q.xbgr.xq72_u22.qnpn13g2[ib]
print @q.xbgr.xq72_u22.qnpn13g2[ie]
print @q.xbgr.xq72_u22.qnpn13g2[is]
print @r.xbgr.xq72_u22.rsub[i]
print @c.xbgr.xq72_u22.csub[i]
print @q.xbgr.xq72_u23.qnpn13g2[ic]
print @q.xbgr.xq72_u23.qnpn13g2[ib]
print @q.xbgr.xq72_u23.qnpn13g2[ie]
print @q.xbgr.xq72_u23.qnpn13g2[is]
print @r.xbgr.xq72_u23.rsub[i]
print @c.xbgr.xq72_u23.csub[i]
print @q.xbgr.xq72_u24.qnpn13g2[ic]
print @q.xbgr.xq72_u24.qnpn13g2[ib]
print @q.xbgr.xq72_u24.qnpn13g2[ie]
print @q.xbgr.xq72_u24.qnpn13g2[is]
print @r.xbgr.xq72_u24.rsub[i]
print @c.xbgr.xq72_u24.csub[i]
print @q.xbgr.xq73_u2.qnpn13g2[ic]
print @q.xbgr.xq73_u2.qnpn13g2[ib]
print @q.xbgr.xq73_u2.qnpn13g2[ie]
print @q.xbgr.xq73_u2.qnpn13g2[is]
print @r.xbgr.xq73_u2.rsub[i]
print @c.xbgr.xq73_u2.csub[i]
print @q.xbgr.xq73_u3.qnpn13g2[ic]
print @q.xbgr.xq73_u3.qnpn13g2[ib]
print @q.xbgr.xq73_u3.qnpn13g2[ie]
print @q.xbgr.xq73_u3.qnpn13g2[is]
print @r.xbgr.xq73_u3.rsub[i]
print @c.xbgr.xq73_u3.csub[i]
print @q.xbgr.xq73_u4.qnpn13g2[ic]
print @q.xbgr.xq73_u4.qnpn13g2[ib]
print @q.xbgr.xq73_u4.qnpn13g2[ie]
print @q.xbgr.xq73_u4.qnpn13g2[is]
print @r.xbgr.xq73_u4.rsub[i]
print @c.xbgr.xq73_u4.csub[i]
print @q.xbgr.xq73_u5.qnpn13g2[ic]
print @q.xbgr.xq73_u5.qnpn13g2[ib]
print @q.xbgr.xq73_u5.qnpn13g2[ie]
print @q.xbgr.xq73_u5.qnpn13g2[is]
print @r.xbgr.xq73_u5.rsub[i]
print @c.xbgr.xq73_u5.csub[i]
print @q.xbgr.xq73_u6.qnpn13g2[ic]
print @q.xbgr.xq73_u6.qnpn13g2[ib]
print @q.xbgr.xq73_u6.qnpn13g2[ie]
print @q.xbgr.xq73_u6.qnpn13g2[is]
print @r.xbgr.xq73_u6.rsub[i]
print @c.xbgr.xq73_u6.csub[i]
print @q.xbgr.xq73_u7.qnpn13g2[ic]
print @q.xbgr.xq73_u7.qnpn13g2[ib]
print @q.xbgr.xq73_u7.qnpn13g2[ie]
print @q.xbgr.xq73_u7.qnpn13g2[is]
print @r.xbgr.xq73_u7.rsub[i]
print @c.xbgr.xq73_u7.csub[i]
print @q.xbgr.xq73_u8.qnpn13g2[ic]
print @q.xbgr.xq73_u8.qnpn13g2[ib]
print @q.xbgr.xq73_u8.qnpn13g2[ie]
print @q.xbgr.xq73_u8.qnpn13g2[is]
print @r.xbgr.xq73_u8.rsub[i]
print @c.xbgr.xq73_u8.csub[i]
print @q.xbgr.xq73_u9.qnpn13g2[ic]
print @q.xbgr.xq73_u9.qnpn13g2[ib]
print @q.xbgr.xq73_u9.qnpn13g2[ie]
print @q.xbgr.xq73_u9.qnpn13g2[is]
print @r.xbgr.xq73_u9.rsub[i]
print @c.xbgr.xq73_u9.csub[i]
print @q.xbgr.xq73_u10.qnpn13g2[ic]
print @q.xbgr.xq73_u10.qnpn13g2[ib]
print @q.xbgr.xq73_u10.qnpn13g2[ie]
print @q.xbgr.xq73_u10.qnpn13g2[is]
print @r.xbgr.xq73_u10.rsub[i]
print @c.xbgr.xq73_u10.csub[i]
print @q.xbgr.xq73_u11.qnpn13g2[ic]
print @q.xbgr.xq73_u11.qnpn13g2[ib]
print @q.xbgr.xq73_u11.qnpn13g2[ie]
print @q.xbgr.xq73_u11.qnpn13g2[is]
print @r.xbgr.xq73_u11.rsub[i]
print @c.xbgr.xq73_u11.csub[i]
print @q.xbgr.xq73_u12.qnpn13g2[ic]
print @q.xbgr.xq73_u12.qnpn13g2[ib]
print @q.xbgr.xq73_u12.qnpn13g2[ie]
print @q.xbgr.xq73_u12.qnpn13g2[is]
print @r.xbgr.xq73_u12.rsub[i]
print @c.xbgr.xq73_u12.csub[i]
print @q.xbgr.xq73_u13.qnpn13g2[ic]
print @q.xbgr.xq73_u13.qnpn13g2[ib]
print @q.xbgr.xq73_u13.qnpn13g2[ie]
print @q.xbgr.xq73_u13.qnpn13g2[is]
print @r.xbgr.xq73_u13.rsub[i]
print @c.xbgr.xq73_u13.csub[i]
print @q.xbgr.xq73_u14.qnpn13g2[ic]
print @q.xbgr.xq73_u14.qnpn13g2[ib]
print @q.xbgr.xq73_u14.qnpn13g2[ie]
print @q.xbgr.xq73_u14.qnpn13g2[is]
print @r.xbgr.xq73_u14.rsub[i]
print @c.xbgr.xq73_u14.csub[i]
print @q.xbgr.xq73_u15.qnpn13g2[ic]
print @q.xbgr.xq73_u15.qnpn13g2[ib]
print @q.xbgr.xq73_u15.qnpn13g2[ie]
print @q.xbgr.xq73_u15.qnpn13g2[is]
print @r.xbgr.xq73_u15.rsub[i]
print @c.xbgr.xq73_u15.csub[i]
print @q.xbgr.xq73_u16.qnpn13g2[ic]
print @q.xbgr.xq73_u16.qnpn13g2[ib]
print @q.xbgr.xq73_u16.qnpn13g2[ie]
print @q.xbgr.xq73_u16.qnpn13g2[is]
print @r.xbgr.xq73_u16.rsub[i]
print @c.xbgr.xq73_u16.csub[i]
print @q.xbgr.xq73_u17.qnpn13g2[ic]
print @q.xbgr.xq73_u17.qnpn13g2[ib]
print @q.xbgr.xq73_u17.qnpn13g2[ie]
print @q.xbgr.xq73_u17.qnpn13g2[is]
print @r.xbgr.xq73_u17.rsub[i]
print @c.xbgr.xq73_u17.csub[i]
print @q.xbgr.xq73_u18.qnpn13g2[ic]
print @q.xbgr.xq73_u18.qnpn13g2[ib]
print @q.xbgr.xq73_u18.qnpn13g2[ie]
print @q.xbgr.xq73_u18.qnpn13g2[is]
print @r.xbgr.xq73_u18.rsub[i]
print @c.xbgr.xq73_u18.csub[i]
print @q.xbgr.xq73_u19.qnpn13g2[ic]
print @q.xbgr.xq73_u19.qnpn13g2[ib]
print @q.xbgr.xq73_u19.qnpn13g2[ie]
print @q.xbgr.xq73_u19.qnpn13g2[is]
print @r.xbgr.xq73_u19.rsub[i]
print @c.xbgr.xq73_u19.csub[i]
print @q.xbgr.xq73_u20.qnpn13g2[ic]
print @q.xbgr.xq73_u20.qnpn13g2[ib]
print @q.xbgr.xq73_u20.qnpn13g2[ie]
print @q.xbgr.xq73_u20.qnpn13g2[is]
print @r.xbgr.xq73_u20.rsub[i]
print @c.xbgr.xq73_u20.csub[i]
print @q.xbgr.xq73_u21.qnpn13g2[ic]
print @q.xbgr.xq73_u21.qnpn13g2[ib]
print @q.xbgr.xq73_u21.qnpn13g2[ie]
print @q.xbgr.xq73_u21.qnpn13g2[is]
print @r.xbgr.xq73_u21.rsub[i]
print @c.xbgr.xq73_u21.csub[i]
print @q.xbgr.xq73_u22.qnpn13g2[ic]
print @q.xbgr.xq73_u22.qnpn13g2[ib]
print @q.xbgr.xq73_u22.qnpn13g2[ie]
print @q.xbgr.xq73_u22.qnpn13g2[is]
print @r.xbgr.xq73_u22.rsub[i]
print @c.xbgr.xq73_u22.csub[i]
print @q.xbgr.xq73_u23.qnpn13g2[ic]
print @q.xbgr.xq73_u23.qnpn13g2[ib]
print @q.xbgr.xq73_u23.qnpn13g2[ie]
print @q.xbgr.xq73_u23.qnpn13g2[is]
print @r.xbgr.xq73_u23.rsub[i]
print @c.xbgr.xq73_u23.csub[i]
print @q.xbgr.xq73_u24.qnpn13g2[ic]
print @q.xbgr.xq73_u24.qnpn13g2[ib]
print @q.xbgr.xq73_u24.qnpn13g2[ie]
print @q.xbgr.xq73_u24.qnpn13g2[is]
print @r.xbgr.xq73_u24.rsub[i]
print @c.xbgr.xq73_u24.csub[i]
print @q.xbgr.xq74_u2.qnpn13g2[ic]
print @q.xbgr.xq74_u2.qnpn13g2[ib]
print @q.xbgr.xq74_u2.qnpn13g2[ie]
print @q.xbgr.xq74_u2.qnpn13g2[is]
print @r.xbgr.xq74_u2.rsub[i]
print @c.xbgr.xq74_u2.csub[i]
print @q.xbgr.xq74_u3.qnpn13g2[ic]
print @q.xbgr.xq74_u3.qnpn13g2[ib]
print @q.xbgr.xq74_u3.qnpn13g2[ie]
print @q.xbgr.xq74_u3.qnpn13g2[is]
print @r.xbgr.xq74_u3.rsub[i]
print @c.xbgr.xq74_u3.csub[i]
print @q.xbgr.xq74_u4.qnpn13g2[ic]
print @q.xbgr.xq74_u4.qnpn13g2[ib]
print @q.xbgr.xq74_u4.qnpn13g2[ie]
print @q.xbgr.xq74_u4.qnpn13g2[is]
print @r.xbgr.xq74_u4.rsub[i]
print @c.xbgr.xq74_u4.csub[i]
print @q.xbgr.xq74_u5.qnpn13g2[ic]
print @q.xbgr.xq74_u5.qnpn13g2[ib]
print @q.xbgr.xq74_u5.qnpn13g2[ie]
print @q.xbgr.xq74_u5.qnpn13g2[is]
print @r.xbgr.xq74_u5.rsub[i]
print @c.xbgr.xq74_u5.csub[i]
print @q.xbgr.xq74_u6.qnpn13g2[ic]
print @q.xbgr.xq74_u6.qnpn13g2[ib]
print @q.xbgr.xq74_u6.qnpn13g2[ie]
print @q.xbgr.xq74_u6.qnpn13g2[is]
print @r.xbgr.xq74_u6.rsub[i]
print @c.xbgr.xq74_u6.csub[i]
print @q.xbgr.xq74_u7.qnpn13g2[ic]
print @q.xbgr.xq74_u7.qnpn13g2[ib]
print @q.xbgr.xq74_u7.qnpn13g2[ie]
print @q.xbgr.xq74_u7.qnpn13g2[is]
print @r.xbgr.xq74_u7.rsub[i]
print @c.xbgr.xq74_u7.csub[i]
print @q.xbgr.xq74_u8.qnpn13g2[ic]
print @q.xbgr.xq74_u8.qnpn13g2[ib]
print @q.xbgr.xq74_u8.qnpn13g2[ie]
print @q.xbgr.xq74_u8.qnpn13g2[is]
print @r.xbgr.xq74_u8.rsub[i]
print @c.xbgr.xq74_u8.csub[i]
print @q.xbgr.xq74_u9.qnpn13g2[ic]
print @q.xbgr.xq74_u9.qnpn13g2[ib]
print @q.xbgr.xq74_u9.qnpn13g2[ie]
print @q.xbgr.xq74_u9.qnpn13g2[is]
print @r.xbgr.xq74_u9.rsub[i]
print @c.xbgr.xq74_u9.csub[i]
print @q.xbgr.xq74_u10.qnpn13g2[ic]
print @q.xbgr.xq74_u10.qnpn13g2[ib]
print @q.xbgr.xq74_u10.qnpn13g2[ie]
print @q.xbgr.xq74_u10.qnpn13g2[is]
print @r.xbgr.xq74_u10.rsub[i]
print @c.xbgr.xq74_u10.csub[i]
print @q.xbgr.xq74_u11.qnpn13g2[ic]
print @q.xbgr.xq74_u11.qnpn13g2[ib]
print @q.xbgr.xq74_u11.qnpn13g2[ie]
print @q.xbgr.xq74_u11.qnpn13g2[is]
print @r.xbgr.xq74_u11.rsub[i]
print @c.xbgr.xq74_u11.csub[i]
print @q.xbgr.xq74_u12.qnpn13g2[ic]
print @q.xbgr.xq74_u12.qnpn13g2[ib]
print @q.xbgr.xq74_u12.qnpn13g2[ie]
print @q.xbgr.xq74_u12.qnpn13g2[is]
print @r.xbgr.xq74_u12.rsub[i]
print @c.xbgr.xq74_u12.csub[i]
print @q.xbgr.xq74_u13.qnpn13g2[ic]
print @q.xbgr.xq74_u13.qnpn13g2[ib]
print @q.xbgr.xq74_u13.qnpn13g2[ie]
print @q.xbgr.xq74_u13.qnpn13g2[is]
print @r.xbgr.xq74_u13.rsub[i]
print @c.xbgr.xq74_u13.csub[i]
print @q.xbgr.xq74_u14.qnpn13g2[ic]
print @q.xbgr.xq74_u14.qnpn13g2[ib]
print @q.xbgr.xq74_u14.qnpn13g2[ie]
print @q.xbgr.xq74_u14.qnpn13g2[is]
print @r.xbgr.xq74_u14.rsub[i]
print @c.xbgr.xq74_u14.csub[i]
print @q.xbgr.xq74_u15.qnpn13g2[ic]
print @q.xbgr.xq74_u15.qnpn13g2[ib]
print @q.xbgr.xq74_u15.qnpn13g2[ie]
print @q.xbgr.xq74_u15.qnpn13g2[is]
print @r.xbgr.xq74_u15.rsub[i]
print @c.xbgr.xq74_u15.csub[i]
print @q.xbgr.xq74_u16.qnpn13g2[ic]
print @q.xbgr.xq74_u16.qnpn13g2[ib]
print @q.xbgr.xq74_u16.qnpn13g2[ie]
print @q.xbgr.xq74_u16.qnpn13g2[is]
print @r.xbgr.xq74_u16.rsub[i]
print @c.xbgr.xq74_u16.csub[i]
print @q.xbgr.xq74_u17.qnpn13g2[ic]
print @q.xbgr.xq74_u17.qnpn13g2[ib]
print @q.xbgr.xq74_u17.qnpn13g2[ie]
print @q.xbgr.xq74_u17.qnpn13g2[is]
print @r.xbgr.xq74_u17.rsub[i]
print @c.xbgr.xq74_u17.csub[i]
print @q.xbgr.xq74_u18.qnpn13g2[ic]
print @q.xbgr.xq74_u18.qnpn13g2[ib]
print @q.xbgr.xq74_u18.qnpn13g2[ie]
print @q.xbgr.xq74_u18.qnpn13g2[is]
print @r.xbgr.xq74_u18.rsub[i]
print @c.xbgr.xq74_u18.csub[i]
print @q.xbgr.xq74_u19.qnpn13g2[ic]
print @q.xbgr.xq74_u19.qnpn13g2[ib]
print @q.xbgr.xq74_u19.qnpn13g2[ie]
print @q.xbgr.xq74_u19.qnpn13g2[is]
print @r.xbgr.xq74_u19.rsub[i]
print @c.xbgr.xq74_u19.csub[i]
print @q.xbgr.xq74_u20.qnpn13g2[ic]
print @q.xbgr.xq74_u20.qnpn13g2[ib]
print @q.xbgr.xq74_u20.qnpn13g2[ie]
print @q.xbgr.xq74_u20.qnpn13g2[is]
print @r.xbgr.xq74_u20.rsub[i]
print @c.xbgr.xq74_u20.csub[i]
print @q.xbgr.xq74_u21.qnpn13g2[ic]
print @q.xbgr.xq74_u21.qnpn13g2[ib]
print @q.xbgr.xq74_u21.qnpn13g2[ie]
print @q.xbgr.xq74_u21.qnpn13g2[is]
print @r.xbgr.xq74_u21.rsub[i]
print @c.xbgr.xq74_u21.csub[i]
print @q.xbgr.xq74_u22.qnpn13g2[ic]
print @q.xbgr.xq74_u22.qnpn13g2[ib]
print @q.xbgr.xq74_u22.qnpn13g2[ie]
print @q.xbgr.xq74_u22.qnpn13g2[is]
print @r.xbgr.xq74_u22.rsub[i]
print @c.xbgr.xq74_u22.csub[i]
print @q.xbgr.xq74_u23.qnpn13g2[ic]
print @q.xbgr.xq74_u23.qnpn13g2[ib]
print @q.xbgr.xq74_u23.qnpn13g2[ie]
print @q.xbgr.xq74_u23.qnpn13g2[is]
print @r.xbgr.xq74_u23.rsub[i]
print @c.xbgr.xq74_u23.csub[i]
print @q.xbgr.xq74_u24.qnpn13g2[ic]
print @q.xbgr.xq74_u24.qnpn13g2[ib]
print @q.xbgr.xq74_u24.qnpn13g2[ie]
print @q.xbgr.xq74_u24.qnpn13g2[is]
print @r.xbgr.xq74_u24.rsub[i]
print @c.xbgr.xq74_u24.csub[i]
print @q.xbgr.xq75_u2.qnpn13g2[ic]
print @q.xbgr.xq75_u2.qnpn13g2[ib]
print @q.xbgr.xq75_u2.qnpn13g2[ie]
print @q.xbgr.xq75_u2.qnpn13g2[is]
print @r.xbgr.xq75_u2.rsub[i]
print @c.xbgr.xq75_u2.csub[i]
print @q.xbgr.xq75_u3.qnpn13g2[ic]
print @q.xbgr.xq75_u3.qnpn13g2[ib]
print @q.xbgr.xq75_u3.qnpn13g2[ie]
print @q.xbgr.xq75_u3.qnpn13g2[is]
print @r.xbgr.xq75_u3.rsub[i]
print @c.xbgr.xq75_u3.csub[i]
print @q.xbgr.xq75_u4.qnpn13g2[ic]
print @q.xbgr.xq75_u4.qnpn13g2[ib]
print @q.xbgr.xq75_u4.qnpn13g2[ie]
print @q.xbgr.xq75_u4.qnpn13g2[is]
print @r.xbgr.xq75_u4.rsub[i]
print @c.xbgr.xq75_u4.csub[i]
print @q.xbgr.xq75_u5.qnpn13g2[ic]
print @q.xbgr.xq75_u5.qnpn13g2[ib]
print @q.xbgr.xq75_u5.qnpn13g2[ie]
print @q.xbgr.xq75_u5.qnpn13g2[is]
print @r.xbgr.xq75_u5.rsub[i]
print @c.xbgr.xq75_u5.csub[i]
print @q.xbgr.xq75_u6.qnpn13g2[ic]
print @q.xbgr.xq75_u6.qnpn13g2[ib]
print @q.xbgr.xq75_u6.qnpn13g2[ie]
print @q.xbgr.xq75_u6.qnpn13g2[is]
print @r.xbgr.xq75_u6.rsub[i]
print @c.xbgr.xq75_u6.csub[i]
print @q.xbgr.xq75_u7.qnpn13g2[ic]
print @q.xbgr.xq75_u7.qnpn13g2[ib]
print @q.xbgr.xq75_u7.qnpn13g2[ie]
print @q.xbgr.xq75_u7.qnpn13g2[is]
print @r.xbgr.xq75_u7.rsub[i]
print @c.xbgr.xq75_u7.csub[i]
print @q.xbgr.xq75_u8.qnpn13g2[ic]
print @q.xbgr.xq75_u8.qnpn13g2[ib]
print @q.xbgr.xq75_u8.qnpn13g2[ie]
print @q.xbgr.xq75_u8.qnpn13g2[is]
print @r.xbgr.xq75_u8.rsub[i]
print @c.xbgr.xq75_u8.csub[i]
print @q.xbgr.xq75_u9.qnpn13g2[ic]
print @q.xbgr.xq75_u9.qnpn13g2[ib]
print @q.xbgr.xq75_u9.qnpn13g2[ie]
print @q.xbgr.xq75_u9.qnpn13g2[is]
print @r.xbgr.xq75_u9.rsub[i]
print @c.xbgr.xq75_u9.csub[i]
print @q.xbgr.xq75_u10.qnpn13g2[ic]
print @q.xbgr.xq75_u10.qnpn13g2[ib]
print @q.xbgr.xq75_u10.qnpn13g2[ie]
print @q.xbgr.xq75_u10.qnpn13g2[is]
print @r.xbgr.xq75_u10.rsub[i]
print @c.xbgr.xq75_u10.csub[i]
print @q.xbgr.xq75_u11.qnpn13g2[ic]
print @q.xbgr.xq75_u11.qnpn13g2[ib]
print @q.xbgr.xq75_u11.qnpn13g2[ie]
print @q.xbgr.xq75_u11.qnpn13g2[is]
print @r.xbgr.xq75_u11.rsub[i]
print @c.xbgr.xq75_u11.csub[i]
print @q.xbgr.xq75_u12.qnpn13g2[ic]
print @q.xbgr.xq75_u12.qnpn13g2[ib]
print @q.xbgr.xq75_u12.qnpn13g2[ie]
print @q.xbgr.xq75_u12.qnpn13g2[is]
print @r.xbgr.xq75_u12.rsub[i]
print @c.xbgr.xq75_u12.csub[i]
print @q.xbgr.xq75_u13.qnpn13g2[ic]
print @q.xbgr.xq75_u13.qnpn13g2[ib]
print @q.xbgr.xq75_u13.qnpn13g2[ie]
print @q.xbgr.xq75_u13.qnpn13g2[is]
print @r.xbgr.xq75_u13.rsub[i]
print @c.xbgr.xq75_u13.csub[i]
print @q.xbgr.xq75_u14.qnpn13g2[ic]
print @q.xbgr.xq75_u14.qnpn13g2[ib]
print @q.xbgr.xq75_u14.qnpn13g2[ie]
print @q.xbgr.xq75_u14.qnpn13g2[is]
print @r.xbgr.xq75_u14.rsub[i]
print @c.xbgr.xq75_u14.csub[i]
print @q.xbgr.xq75_u15.qnpn13g2[ic]
print @q.xbgr.xq75_u15.qnpn13g2[ib]
print @q.xbgr.xq75_u15.qnpn13g2[ie]
print @q.xbgr.xq75_u15.qnpn13g2[is]
print @r.xbgr.xq75_u15.rsub[i]
print @c.xbgr.xq75_u15.csub[i]
print @q.xbgr.xq75_u16.qnpn13g2[ic]
print @q.xbgr.xq75_u16.qnpn13g2[ib]
print @q.xbgr.xq75_u16.qnpn13g2[ie]
print @q.xbgr.xq75_u16.qnpn13g2[is]
print @r.xbgr.xq75_u16.rsub[i]
print @c.xbgr.xq75_u16.csub[i]
print @q.xbgr.xq75_u17.qnpn13g2[ic]
print @q.xbgr.xq75_u17.qnpn13g2[ib]
print @q.xbgr.xq75_u17.qnpn13g2[ie]
print @q.xbgr.xq75_u17.qnpn13g2[is]
print @r.xbgr.xq75_u17.rsub[i]
print @c.xbgr.xq75_u17.csub[i]
print @q.xbgr.xq75_u18.qnpn13g2[ic]
print @q.xbgr.xq75_u18.qnpn13g2[ib]
print @q.xbgr.xq75_u18.qnpn13g2[ie]
print @q.xbgr.xq75_u18.qnpn13g2[is]
print @r.xbgr.xq75_u18.rsub[i]
print @c.xbgr.xq75_u18.csub[i]
print @q.xbgr.xq75_u19.qnpn13g2[ic]
print @q.xbgr.xq75_u19.qnpn13g2[ib]
print @q.xbgr.xq75_u19.qnpn13g2[ie]
print @q.xbgr.xq75_u19.qnpn13g2[is]
print @r.xbgr.xq75_u19.rsub[i]
print @c.xbgr.xq75_u19.csub[i]
print @q.xbgr.xq75_u20.qnpn13g2[ic]
print @q.xbgr.xq75_u20.qnpn13g2[ib]
print @q.xbgr.xq75_u20.qnpn13g2[ie]
print @q.xbgr.xq75_u20.qnpn13g2[is]
print @r.xbgr.xq75_u20.rsub[i]
print @c.xbgr.xq75_u20.csub[i]
print @q.xbgr.xq75_u21.qnpn13g2[ic]
print @q.xbgr.xq75_u21.qnpn13g2[ib]
print @q.xbgr.xq75_u21.qnpn13g2[ie]
print @q.xbgr.xq75_u21.qnpn13g2[is]
print @r.xbgr.xq75_u21.rsub[i]
print @c.xbgr.xq75_u21.csub[i]
print @q.xbgr.xq75_u22.qnpn13g2[ic]
print @q.xbgr.xq75_u22.qnpn13g2[ib]
print @q.xbgr.xq75_u22.qnpn13g2[ie]
print @q.xbgr.xq75_u22.qnpn13g2[is]
print @r.xbgr.xq75_u22.rsub[i]
print @c.xbgr.xq75_u22.csub[i]
print @q.xbgr.xq75_u23.qnpn13g2[ic]
print @q.xbgr.xq75_u23.qnpn13g2[ib]
print @q.xbgr.xq75_u23.qnpn13g2[ie]
print @q.xbgr.xq75_u23.qnpn13g2[is]
print @r.xbgr.xq75_u23.rsub[i]
print @c.xbgr.xq75_u23.csub[i]
print @q.xbgr.xq75_u24.qnpn13g2[ic]
print @q.xbgr.xq75_u24.qnpn13g2[ib]
print @q.xbgr.xq75_u24.qnpn13g2[ie]
print @q.xbgr.xq75_u24.qnpn13g2[is]
print @r.xbgr.xq75_u24.rsub[i]
print @c.xbgr.xq75_u24.csub[i]
print @q.xbgr.xq76_u2.qnpn13g2[ic]
print @q.xbgr.xq76_u2.qnpn13g2[ib]
print @q.xbgr.xq76_u2.qnpn13g2[ie]
print @q.xbgr.xq76_u2.qnpn13g2[is]
print @r.xbgr.xq76_u2.rsub[i]
print @c.xbgr.xq76_u2.csub[i]
print @q.xbgr.xq76_u3.qnpn13g2[ic]
print @q.xbgr.xq76_u3.qnpn13g2[ib]
print @q.xbgr.xq76_u3.qnpn13g2[ie]
print @q.xbgr.xq76_u3.qnpn13g2[is]
print @r.xbgr.xq76_u3.rsub[i]
print @c.xbgr.xq76_u3.csub[i]
print @q.xbgr.xq76_u4.qnpn13g2[ic]
print @q.xbgr.xq76_u4.qnpn13g2[ib]
print @q.xbgr.xq76_u4.qnpn13g2[ie]
print @q.xbgr.xq76_u4.qnpn13g2[is]
print @r.xbgr.xq76_u4.rsub[i]
print @c.xbgr.xq76_u4.csub[i]
print @q.xbgr.xq76_u5.qnpn13g2[ic]
print @q.xbgr.xq76_u5.qnpn13g2[ib]
print @q.xbgr.xq76_u5.qnpn13g2[ie]
print @q.xbgr.xq76_u5.qnpn13g2[is]
print @r.xbgr.xq76_u5.rsub[i]
print @c.xbgr.xq76_u5.csub[i]
print @q.xbgr.xq76_u6.qnpn13g2[ic]
print @q.xbgr.xq76_u6.qnpn13g2[ib]
print @q.xbgr.xq76_u6.qnpn13g2[ie]
print @q.xbgr.xq76_u6.qnpn13g2[is]
print @r.xbgr.xq76_u6.rsub[i]
print @c.xbgr.xq76_u6.csub[i]
print @q.xbgr.xq76_u7.qnpn13g2[ic]
print @q.xbgr.xq76_u7.qnpn13g2[ib]
print @q.xbgr.xq76_u7.qnpn13g2[ie]
print @q.xbgr.xq76_u7.qnpn13g2[is]
print @r.xbgr.xq76_u7.rsub[i]
print @c.xbgr.xq76_u7.csub[i]
print @q.xbgr.xq76_u8.qnpn13g2[ic]
print @q.xbgr.xq76_u8.qnpn13g2[ib]
print @q.xbgr.xq76_u8.qnpn13g2[ie]
print @q.xbgr.xq76_u8.qnpn13g2[is]
print @r.xbgr.xq76_u8.rsub[i]
print @c.xbgr.xq76_u8.csub[i]
print @q.xbgr.xq76_u9.qnpn13g2[ic]
print @q.xbgr.xq76_u9.qnpn13g2[ib]
print @q.xbgr.xq76_u9.qnpn13g2[ie]
print @q.xbgr.xq76_u9.qnpn13g2[is]
print @r.xbgr.xq76_u9.rsub[i]
print @c.xbgr.xq76_u9.csub[i]
print @q.xbgr.xq76_u10.qnpn13g2[ic]
print @q.xbgr.xq76_u10.qnpn13g2[ib]
print @q.xbgr.xq76_u10.qnpn13g2[ie]
print @q.xbgr.xq76_u10.qnpn13g2[is]
print @r.xbgr.xq76_u10.rsub[i]
print @c.xbgr.xq76_u10.csub[i]
print @q.xbgr.xq76_u11.qnpn13g2[ic]
print @q.xbgr.xq76_u11.qnpn13g2[ib]
print @q.xbgr.xq76_u11.qnpn13g2[ie]
print @q.xbgr.xq76_u11.qnpn13g2[is]
print @r.xbgr.xq76_u11.rsub[i]
print @c.xbgr.xq76_u11.csub[i]
print @q.xbgr.xq76_u12.qnpn13g2[ic]
print @q.xbgr.xq76_u12.qnpn13g2[ib]
print @q.xbgr.xq76_u12.qnpn13g2[ie]
print @q.xbgr.xq76_u12.qnpn13g2[is]
print @r.xbgr.xq76_u12.rsub[i]
print @c.xbgr.xq76_u12.csub[i]
print @q.xbgr.xq76_u13.qnpn13g2[ic]
print @q.xbgr.xq76_u13.qnpn13g2[ib]
print @q.xbgr.xq76_u13.qnpn13g2[ie]
print @q.xbgr.xq76_u13.qnpn13g2[is]
print @r.xbgr.xq76_u13.rsub[i]
print @c.xbgr.xq76_u13.csub[i]
print @q.xbgr.xq76_u14.qnpn13g2[ic]
print @q.xbgr.xq76_u14.qnpn13g2[ib]
print @q.xbgr.xq76_u14.qnpn13g2[ie]
print @q.xbgr.xq76_u14.qnpn13g2[is]
print @r.xbgr.xq76_u14.rsub[i]
print @c.xbgr.xq76_u14.csub[i]
print @q.xbgr.xq76_u15.qnpn13g2[ic]
print @q.xbgr.xq76_u15.qnpn13g2[ib]
print @q.xbgr.xq76_u15.qnpn13g2[ie]
print @q.xbgr.xq76_u15.qnpn13g2[is]
print @r.xbgr.xq76_u15.rsub[i]
print @c.xbgr.xq76_u15.csub[i]
print @q.xbgr.xq76_u16.qnpn13g2[ic]
print @q.xbgr.xq76_u16.qnpn13g2[ib]
print @q.xbgr.xq76_u16.qnpn13g2[ie]
print @q.xbgr.xq76_u16.qnpn13g2[is]
print @r.xbgr.xq76_u16.rsub[i]
print @c.xbgr.xq76_u16.csub[i]
print @q.xbgr.xq76_u17.qnpn13g2[ic]
print @q.xbgr.xq76_u17.qnpn13g2[ib]
print @q.xbgr.xq76_u17.qnpn13g2[ie]
print @q.xbgr.xq76_u17.qnpn13g2[is]
print @r.xbgr.xq76_u17.rsub[i]
print @c.xbgr.xq76_u17.csub[i]
print @q.xbgr.xq76_u18.qnpn13g2[ic]
print @q.xbgr.xq76_u18.qnpn13g2[ib]
print @q.xbgr.xq76_u18.qnpn13g2[ie]
print @q.xbgr.xq76_u18.qnpn13g2[is]
print @r.xbgr.xq76_u18.rsub[i]
print @c.xbgr.xq76_u18.csub[i]
print @q.xbgr.xq76_u19.qnpn13g2[ic]
print @q.xbgr.xq76_u19.qnpn13g2[ib]
print @q.xbgr.xq76_u19.qnpn13g2[ie]
print @q.xbgr.xq76_u19.qnpn13g2[is]
print @r.xbgr.xq76_u19.rsub[i]
print @c.xbgr.xq76_u19.csub[i]
print @q.xbgr.xq76_u20.qnpn13g2[ic]
print @q.xbgr.xq76_u20.qnpn13g2[ib]
print @q.xbgr.xq76_u20.qnpn13g2[ie]
print @q.xbgr.xq76_u20.qnpn13g2[is]
print @r.xbgr.xq76_u20.rsub[i]
print @c.xbgr.xq76_u20.csub[i]
print @q.xbgr.xq76_u21.qnpn13g2[ic]
print @q.xbgr.xq76_u21.qnpn13g2[ib]
print @q.xbgr.xq76_u21.qnpn13g2[ie]
print @q.xbgr.xq76_u21.qnpn13g2[is]
print @r.xbgr.xq76_u21.rsub[i]
print @c.xbgr.xq76_u21.csub[i]
print @q.xbgr.xq76_u22.qnpn13g2[ic]
print @q.xbgr.xq76_u22.qnpn13g2[ib]
print @q.xbgr.xq76_u22.qnpn13g2[ie]
print @q.xbgr.xq76_u22.qnpn13g2[is]
print @r.xbgr.xq76_u22.rsub[i]
print @c.xbgr.xq76_u22.csub[i]
print @q.xbgr.xq76_u23.qnpn13g2[ic]
print @q.xbgr.xq76_u23.qnpn13g2[ib]
print @q.xbgr.xq76_u23.qnpn13g2[ie]
print @q.xbgr.xq76_u23.qnpn13g2[is]
print @r.xbgr.xq76_u23.rsub[i]
print @c.xbgr.xq76_u23.csub[i]
print @q.xbgr.xq76_u24.qnpn13g2[ic]
print @q.xbgr.xq76_u24.qnpn13g2[ib]
print @q.xbgr.xq76_u24.qnpn13g2[ie]
print @q.xbgr.xq76_u24.qnpn13g2[is]
print @r.xbgr.xq76_u24.rsub[i]
print @c.xbgr.xq76_u24.csub[i]
print @n.xbgr.xr77_u2.nr1[ibody]
print @n.xbgr.xr77_u3.nr1[ibody]
print @n.xbgr.xr77_u4.nr1[ibody]
print @n.xbgr.xr77_u5.nr1[ibody]
print @n.xbgr.xr77_u6.nr1[ibody]
print @n.xbgr.xr77_u7.nr1[ibody]
print @n.xbgr.xr77_u8.nr1[ibody]
print @n.xbgr.xr77_u9.nr1[ibody]
print @n.xbgr.xr77_u10.nr1[ibody]
print @n.xbgr.xr77_u11.nr1[ibody]
print @n.xbgr.xr77_u12.nr1[ibody]
print @n.xbgr.xr77_u13.nr1[ibody]
print @n.xbgr.xr77_u14.nr1[ibody]
print @n.xbgr.xr77_u15.nr1[ibody]
print @n.xbgr.xr77_u16.nr1[ibody]
print @n.xbgr.xr77_u17.nr1[ibody]
print @n.xbgr.xr77_u18.nr1[ibody]
print @n.xbgr.xr77_u19.nr1[ibody]
print @n.xbgr.xr77_u20.nr1[ibody]
print @n.xbgr.xr77_u21.nr1[ibody]
print @n.xbgr.xr77_u22.nr1[ibody]
print @n.xbgr.xr77_u23.nr1[ibody]
print @n.xbgr.xr77_u24.nr1[ibody]
print @n.xbgr.xr78_u2.nr1[ibody]
print @n.xbgr.xr78_u3.nr1[ibody]
print @n.xbgr.xr78_u4.nr1[ibody]
print @n.xbgr.xr78_u5.nr1[ibody]
print @n.xbgr.xr78_u6.nr1[ibody]
print @n.xbgr.xr78_u7.nr1[ibody]
print @n.xbgr.xr78_u8.nr1[ibody]
print @n.xbgr.xr78_u9.nr1[ibody]
print @n.xbgr.xr78_u10.nr1[ibody]
print @n.xbgr.xr78_u11.nr1[ibody]
print @n.xbgr.xr78_u12.nr1[ibody]
print @n.xbgr.xr78_u13.nr1[ibody]
print @n.xbgr.xr78_u14.nr1[ibody]
print @n.xbgr.xr78_u15.nr1[ibody]
print @n.xbgr.xr78_u16.nr1[ibody]
print @n.xbgr.xr78_u17.nr1[ibody]
print @n.xbgr.xr78_u18.nr1[ibody]
print @n.xbgr.xr78_u19.nr1[ibody]
print @n.xbgr.xr78_u20.nr1[ibody]
print @n.xbgr.xr78_u21.nr1[ibody]
print @n.xbgr.xr78_u22.nr1[ibody]
print @n.xbgr.xr78_u23.nr1[ibody]
print @n.xbgr.xr78_u24.nr1[ibody]
print @n.xbgr.xr79_u2.nr1[ibody]
print @n.xbgr.xr79_u3.nr1[ibody]
print @n.xbgr.xr79_u4.nr1[ibody]
print @n.xbgr.xr79_u5.nr1[ibody]
print @n.xbgr.xr79_u6.nr1[ibody]
print @n.xbgr.xr79_u7.nr1[ibody]
print @n.xbgr.xr79_u8.nr1[ibody]
print @n.xbgr.xr79_u9.nr1[ibody]
print @n.xbgr.xr79_u10.nr1[ibody]
print @n.xbgr.xr79_u11.nr1[ibody]
print @n.xbgr.xr79_u12.nr1[ibody]
print @n.xbgr.xr79_u13.nr1[ibody]
print @n.xbgr.xr79_u14.nr1[ibody]
print @n.xbgr.xr79_u15.nr1[ibody]
print @n.xbgr.xr79_u16.nr1[ibody]
print @n.xbgr.xr79_u17.nr1[ibody]
print @n.xbgr.xr79_u18.nr1[ibody]
print @n.xbgr.xr79_u19.nr1[ibody]
print @n.xbgr.xr79_u20.nr1[ibody]
print @n.xbgr.xr79_u21.nr1[ibody]
print @n.xbgr.xr79_u22.nr1[ibody]
print @n.xbgr.xr79_u23.nr1[ibody]
print @n.xbgr.xr79_u24.nr1[ibody]
print @n.xbgr.xr80_u2.nr1[ibody]
print @n.xbgr.xr80_u3.nr1[ibody]
print @n.xbgr.xr80_u4.nr1[ibody]
print @n.xbgr.xr80_u5.nr1[ibody]
print @n.xbgr.xr80_u6.nr1[ibody]
print @n.xbgr.xr80_u7.nr1[ibody]
print @n.xbgr.xr80_u8.nr1[ibody]
print @n.xbgr.xr80_u9.nr1[ibody]
print @n.xbgr.xr80_u10.nr1[ibody]
print @n.xbgr.xr80_u11.nr1[ibody]
print @n.xbgr.xr80_u12.nr1[ibody]
print @n.xbgr.xr80_u13.nr1[ibody]
print @n.xbgr.xr80_u14.nr1[ibody]
print @n.xbgr.xr80_u15.nr1[ibody]
print @n.xbgr.xr80_u16.nr1[ibody]
print @n.xbgr.xr80_u17.nr1[ibody]
print @n.xbgr.xr80_u18.nr1[ibody]
print @n.xbgr.xr80_u19.nr1[ibody]
print @n.xbgr.xr80_u20.nr1[ibody]
print @n.xbgr.xr80_u21.nr1[ibody]
print @n.xbgr.xr80_u22.nr1[ibody]
print @n.xbgr.xr80_u23.nr1[ibody]
print @n.xbgr.xr80_u24.nr1[ibody]
print @n.xbgr.xr81_u2.nr1[ibody]
print @n.xbgr.xr81_u3.nr1[ibody]
print @n.xbgr.xr81_u4.nr1[ibody]
print @n.xbgr.xr81_u5.nr1[ibody]
print @n.xbgr.xr81_u6.nr1[ibody]
print @n.xbgr.xr81_u7.nr1[ibody]
print @n.xbgr.xr81_u8.nr1[ibody]
print @n.xbgr.xr81_u9.nr1[ibody]
print @n.xbgr.xr81_u10.nr1[ibody]
print @n.xbgr.xr81_u11.nr1[ibody]
print @n.xbgr.xr81_u12.nr1[ibody]
print @n.xbgr.xr81_u13.nr1[ibody]
print @n.xbgr.xr81_u14.nr1[ibody]
print @n.xbgr.xr81_u15.nr1[ibody]
print @n.xbgr.xr81_u16.nr1[ibody]
print @n.xbgr.xr81_u17.nr1[ibody]
print @n.xbgr.xr81_u18.nr1[ibody]
print @n.xbgr.xr81_u19.nr1[ibody]
print @n.xbgr.xr81_u20.nr1[ibody]
print @n.xbgr.xr81_u21.nr1[ibody]
print @n.xbgr.xr81_u22.nr1[ibody]
print @n.xbgr.xr81_u23.nr1[ibody]
print @n.xbgr.xr81_u24.nr1[ibody]
print @n.xbgr.xr82_u2.nr1[ibody]
print @n.xbgr.xr82_u3.nr1[ibody]
print @n.xbgr.xr82_u4.nr1[ibody]
print @n.xbgr.xr82_u5.nr1[ibody]
print @n.xbgr.xr82_u6.nr1[ibody]
print @n.xbgr.xr82_u7.nr1[ibody]
print @n.xbgr.xr82_u8.nr1[ibody]
print @n.xbgr.xr82_u9.nr1[ibody]
print @n.xbgr.xr82_u10.nr1[ibody]
print @n.xbgr.xr82_u11.nr1[ibody]
print @n.xbgr.xr82_u12.nr1[ibody]
print @n.xbgr.xr82_u13.nr1[ibody]
print @n.xbgr.xr82_u14.nr1[ibody]
print @n.xbgr.xr82_u15.nr1[ibody]
print @n.xbgr.xr82_u16.nr1[ibody]
print @n.xbgr.xr82_u17.nr1[ibody]
print @n.xbgr.xr82_u18.nr1[ibody]
print @n.xbgr.xr82_u19.nr1[ibody]
print @n.xbgr.xr82_u20.nr1[ibody]
print @n.xbgr.xr82_u21.nr1[ibody]
print @n.xbgr.xr82_u22.nr1[ibody]
print @n.xbgr.xr82_u23.nr1[ibody]
print @n.xbgr.xr82_u24.nr1[ibody]
print @n.xbgr.xr83_u2.nr1[ibody]
print @n.xbgr.xr83_u3.nr1[ibody]
print @n.xbgr.xr83_u4.nr1[ibody]
print @n.xbgr.xr83_u5.nr1[ibody]
print @n.xbgr.xr83_u6.nr1[ibody]
print @n.xbgr.xr83_u7.nr1[ibody]
print @n.xbgr.xr83_u8.nr1[ibody]
print @n.xbgr.xr83_u9.nr1[ibody]
print @n.xbgr.xr83_u10.nr1[ibody]
print @n.xbgr.xr83_u11.nr1[ibody]
print @n.xbgr.xr83_u12.nr1[ibody]
print @n.xbgr.xr83_u13.nr1[ibody]
print @n.xbgr.xr83_u14.nr1[ibody]
print @n.xbgr.xr83_u15.nr1[ibody]
print @n.xbgr.xr83_u16.nr1[ibody]
print @n.xbgr.xr83_u17.nr1[ibody]
print @n.xbgr.xr83_u18.nr1[ibody]
print @n.xbgr.xr83_u19.nr1[ibody]
print @n.xbgr.xr83_u20.nr1[ibody]
print @n.xbgr.xr83_u21.nr1[ibody]
print @n.xbgr.xr83_u22.nr1[ibody]
print @n.xbgr.xr83_u23.nr1[ibody]
print @n.xbgr.xr83_u24.nr1[ibody]
print @n.xbgr.xr84_u2.nr1[ibody]
print @n.xbgr.xr84_u3.nr1[ibody]
print @n.xbgr.xr84_u4.nr1[ibody]
print @n.xbgr.xr84_u5.nr1[ibody]
print @n.xbgr.xr84_u6.nr1[ibody]
print @n.xbgr.xr84_u7.nr1[ibody]
print @n.xbgr.xr84_u8.nr1[ibody]
print @n.xbgr.xr84_u9.nr1[ibody]
print @n.xbgr.xr84_u10.nr1[ibody]
print @n.xbgr.xr84_u11.nr1[ibody]
print @n.xbgr.xr84_u12.nr1[ibody]
print @n.xbgr.xr84_u13.nr1[ibody]
print @n.xbgr.xr84_u14.nr1[ibody]
print @n.xbgr.xr84_u15.nr1[ibody]
print @n.xbgr.xr84_u16.nr1[ibody]
print @n.xbgr.xr84_u17.nr1[ibody]
print @n.xbgr.xr84_u18.nr1[ibody]
print @n.xbgr.xr84_u19.nr1[ibody]
print @n.xbgr.xr84_u20.nr1[ibody]
print @n.xbgr.xr84_u21.nr1[ibody]
print @n.xbgr.xr84_u22.nr1[ibody]
print @n.xbgr.xr84_u23.nr1[ibody]
print @n.xbgr.xr84_u24.nr1[ibody]
print @n.xbgr.xr85_u2.nr1[ibody]
print @n.xbgr.xr85_u3.nr1[ibody]
print @n.xbgr.xr85_u4.nr1[ibody]
print @n.xbgr.xr85_u5.nr1[ibody]
print @n.xbgr.xr85_u6.nr1[ibody]
print @n.xbgr.xr85_u7.nr1[ibody]
print @n.xbgr.xr85_u8.nr1[ibody]
print @n.xbgr.xr85_u9.nr1[ibody]
print @n.xbgr.xr85_u10.nr1[ibody]
print @n.xbgr.xr85_u11.nr1[ibody]
print @n.xbgr.xr85_u12.nr1[ibody]
print @n.xbgr.xr85_u13.nr1[ibody]
print @n.xbgr.xr85_u14.nr1[ibody]
print @n.xbgr.xr85_u15.nr1[ibody]
print @n.xbgr.xr85_u16.nr1[ibody]
print @n.xbgr.xr85_u17.nr1[ibody]
print @n.xbgr.xr85_u18.nr1[ibody]
print @n.xbgr.xr85_u19.nr1[ibody]
print @n.xbgr.xr85_u20.nr1[ibody]
print @n.xbgr.xr85_u21.nr1[ibody]
print @n.xbgr.xr85_u22.nr1[ibody]
print @n.xbgr.xr85_u23.nr1[ibody]
print @n.xbgr.xr85_u24.nr1[ibody]
print @n.xbgr.xr86_u2.nr1[ibody]
print @n.xbgr.xr86_u3.nr1[ibody]
print @n.xbgr.xr86_u4.nr1[ibody]
print @n.xbgr.xr86_u5.nr1[ibody]
print @n.xbgr.xr86_u6.nr1[ibody]
print @n.xbgr.xr86_u7.nr1[ibody]
print @n.xbgr.xr86_u8.nr1[ibody]
print @n.xbgr.xr86_u9.nr1[ibody]
print @n.xbgr.xr86_u10.nr1[ibody]
print @n.xbgr.xr86_u11.nr1[ibody]
print @n.xbgr.xr86_u12.nr1[ibody]
print @n.xbgr.xr86_u13.nr1[ibody]
print @n.xbgr.xr86_u14.nr1[ibody]
print @n.xbgr.xr86_u15.nr1[ibody]
print @n.xbgr.xr86_u16.nr1[ibody]
print @n.xbgr.xr86_u17.nr1[ibody]
print @n.xbgr.xr86_u18.nr1[ibody]
print @n.xbgr.xr86_u19.nr1[ibody]
print @n.xbgr.xr86_u20.nr1[ibody]
print @n.xbgr.xr86_u21.nr1[ibody]
print @n.xbgr.xr86_u22.nr1[ibody]
print @n.xbgr.xr86_u23.nr1[ibody]
print @n.xbgr.xr86_u24.nr1[ibody]
echo RAW_CURRENT_LEDGER_END
wrdata op_nodes.dat v(xbgr.b1b) v(xbgr.c2) v(xbgr.d1) v(xbgr.d2) v(xbgr.d3) v(xbgr.d4) v(xbgr.d5) v(xbgr.det) v(dvbe) v(iptat) v(xbgr.kick) v(xbgr.n1) v(xbgr.n_10) v(xbgr.n_11) v(xbgr.n_12) v(xbgr.n_13) v(xbgr.n_14) v(xbgr.n_15) v(xbgr.n_16) v(xbgr.n_17) v(xbgr.n_18) v(xbgr.n_19) v(xbgr.n_2) v(xbgr.n_21) v(xbgr.n_22) v(xbgr.n_23) v(xbgr.n_24) v(xbgr.n_25) v(xbgr.n_26) v(xbgr.n_27) v(xbgr.n_3) v(xbgr.n_30) v(xbgr.n_31) v(xbgr.n_33) v(xbgr.n_34) v(xbgr.n_36) v(xbgr.n_37) v(xbgr.n_4) v(xbgr.n_5) v(xbgr.n_6) v(xbgr.n_7) v(xbgr.n_8) v(xbgr.n_9) v(pbias) v(pcasc) v(r4) v(xbgr.r4n) v(xbgr.vb2) v(vbe) v(xbgr.vbe3) v(xbgr.vd1) v(xbgr.vd2) v(vdd) v(vref) v(vdd)-v(vdd) i(vdd) i(vload) i(vr4) i(vsub)
print @n.xbgr.xr1.nr1[nsmm_rsh]
print @n.xbgr.xr1.nr1[nsmm_w]
print @n.xbgr.xr1.nr1[nsmm_l]
print @n.xbgr.xr2.nr1[nsmm_rsh]
print @n.xbgr.xr2.nr1[nsmm_w]
print @n.xbgr.xr2.nr1[nsmm_l]
print @n.xbgr.xr3.nr1[nsmm_rsh]
print @n.xbgr.xr3.nr1[nsmm_w]
print @n.xbgr.xr3.nr1[nsmm_l]
print @n.xbgr.xr4.nr1[nsmm_rsh]
print @n.xbgr.xr4.nr1[nsmm_w]
print @n.xbgr.xr4.nr1[nsmm_l]
print @n.xbgr.xr5.nr1[nsmm_rsh]
print @n.xbgr.xr5.nr1[nsmm_w]
print @n.xbgr.xr5.nr1[nsmm_l]
print @n.xbgr.xr6.nr1[nsmm_rsh]
print @n.xbgr.xr6.nr1[nsmm_w]
print @n.xbgr.xr6.nr1[nsmm_l]
print @n.xbgr.xr7.nr1[nsmm_rsh]
print @n.xbgr.xr7.nr1[nsmm_w]
print @n.xbgr.xr7.nr1[nsmm_l]
print @n.xbgr.xr8.nr1[nsmm_rsh]
print @n.xbgr.xr8.nr1[nsmm_w]
print @n.xbgr.xr8.nr1[nsmm_l]
print @n.xbgr.xr9.nr1[nsmm_rsh]
print @n.xbgr.xr9.nr1[nsmm_w]
print @n.xbgr.xr9.nr1[nsmm_l]
print @n.xbgr.xr10.nr1[nsmm_rsh]
print @n.xbgr.xr10.nr1[nsmm_w]
print @n.xbgr.xr10.nr1[nsmm_l]
print @n.xbgr.xr11.nr1[nsmm_rsh]
print @n.xbgr.xr11.nr1[nsmm_w]
print @n.xbgr.xr11.nr1[nsmm_l]
print @n.xbgr.xr12.nr1[nsmm_rsh]
print @n.xbgr.xr12.nr1[nsmm_w]
print @n.xbgr.xr12.nr1[nsmm_l]
print @n.xbgr.xr13.nr1[nsmm_rsh]
print @n.xbgr.xr13.nr1[nsmm_w]
print @n.xbgr.xr13.nr1[nsmm_l]
print @n.xbgr.xr14.nr1[nsmm_rsh]
print @n.xbgr.xr14.nr1[nsmm_w]
print @n.xbgr.xr14.nr1[nsmm_l]
print @n.xbgr.xr15.nr1[nsmm_rsh]
print @n.xbgr.xr15.nr1[nsmm_w]
print @n.xbgr.xr15.nr1[nsmm_l]
print @n.xbgr.xr16.nr1[nsmm_rsh]
print @n.xbgr.xr16.nr1[nsmm_w]
print @n.xbgr.xr16.nr1[nsmm_l]
print @n.xbgr.xr17.nr1[nsmm_rsh]
print @n.xbgr.xr17.nr1[nsmm_w]
print @n.xbgr.xr17.nr1[nsmm_l]
print @n.xbgr.xr18.nr1[nsmm_rsh]
print @n.xbgr.xr18.nr1[nsmm_w]
print @n.xbgr.xr18.nr1[nsmm_l]
print @n.xbgr.xr19.nr1[nsmm_rsh]
print @n.xbgr.xr19.nr1[nsmm_w]
print @n.xbgr.xr19.nr1[nsmm_l]
print @n.xbgr.xr20.nr1[nsmm_rsh]
print @n.xbgr.xr20.nr1[nsmm_w]
print @n.xbgr.xr20.nr1[nsmm_l]
print @n.xbgr.xr21.nr1[nsmm_rsh]
print @n.xbgr.xr21.nr1[nsmm_w]
print @n.xbgr.xr21.nr1[nsmm_l]
print @n.xbgr.xr22.nr1[nsmm_rsh]
print @n.xbgr.xr22.nr1[nsmm_w]
print @n.xbgr.xr22.nr1[nsmm_l]
print @n.xbgr.xr23.nr1[nsmm_rsh]
print @n.xbgr.xr23.nr1[nsmm_w]
print @n.xbgr.xr23.nr1[nsmm_l]
print @n.xbgr.xr24.nr1[nsmm_rsh]
print @n.xbgr.xr24.nr1[nsmm_w]
print @n.xbgr.xr24.nr1[nsmm_l]
print @n.xbgr.xr25.nr1[nsmm_rsh]
print @n.xbgr.xr25.nr1[nsmm_w]
print @n.xbgr.xr25.nr1[nsmm_l]
print @n.xbgr.xr26.nr1[nsmm_rsh]
print @n.xbgr.xr26.nr1[nsmm_w]
print @n.xbgr.xr26.nr1[nsmm_l]
print @n.xbgr.xm27.nsg13_hv_pmos[w]
print @n.xbgr.xm27.nsg13_hv_pmos[l]
print @n.xbgr.xm27.nsg13_hv_pmos[delvto]
print @n.xbgr.xm27.nsg13_hv_pmos[factuo]
print @n.xbgr.xm28.nsg13_hv_pmos[w]
print @n.xbgr.xm28.nsg13_hv_pmos[l]
print @n.xbgr.xm28.nsg13_hv_pmos[delvto]
print @n.xbgr.xm28.nsg13_hv_pmos[factuo]
print @n.xbgr.xm29.nsg13_hv_nmos[w]
print @n.xbgr.xm29.nsg13_hv_nmos[l]
print @n.xbgr.xm29.nsg13_hv_nmos[delvto]
print @n.xbgr.xm29.nsg13_hv_nmos[factuo]
print @n.xbgr.xm30.nsg13_hv_nmos[w]
print @n.xbgr.xm30.nsg13_hv_nmos[l]
print @n.xbgr.xm30.nsg13_hv_nmos[delvto]
print @n.xbgr.xm30.nsg13_hv_nmos[factuo]
print @n.xbgr.xm31.nsg13_hv_nmos[w]
print @n.xbgr.xm31.nsg13_hv_nmos[l]
print @n.xbgr.xm31.nsg13_hv_nmos[delvto]
print @n.xbgr.xm31.nsg13_hv_nmos[factuo]
print @n.xbgr.xm32.nsg13_hv_nmos[w]
print @n.xbgr.xm32.nsg13_hv_nmos[l]
print @n.xbgr.xm32.nsg13_hv_nmos[delvto]
print @n.xbgr.xm32.nsg13_hv_nmos[factuo]
print @n.xbgr.xm33.nsg13_hv_nmos[w]
print @n.xbgr.xm33.nsg13_hv_nmos[l]
print @n.xbgr.xm33.nsg13_hv_nmos[delvto]
print @n.xbgr.xm33.nsg13_hv_nmos[factuo]
print @n.xbgr.xm34.nsg13_hv_nmos[w]
print @n.xbgr.xm34.nsg13_hv_nmos[l]
print @n.xbgr.xm34.nsg13_hv_nmos[delvto]
print @n.xbgr.xm34.nsg13_hv_nmos[factuo]
print @n.xbgr.xm35.nsg13_hv_nmos[w]
print @n.xbgr.xm35.nsg13_hv_nmos[l]
print @n.xbgr.xm35.nsg13_hv_nmos[delvto]
print @n.xbgr.xm35.nsg13_hv_nmos[factuo]
print @n.xbgr.xm36.nsg13_hv_nmos[w]
print @n.xbgr.xm36.nsg13_hv_nmos[l]
print @n.xbgr.xm36.nsg13_hv_nmos[delvto]
print @n.xbgr.xm36.nsg13_hv_nmos[factuo]
print @n.xbgr.xm37.nsg13_hv_nmos[w]
print @n.xbgr.xm37.nsg13_hv_nmos[l]
print @n.xbgr.xm37.nsg13_hv_nmos[delvto]
print @n.xbgr.xm37.nsg13_hv_nmos[factuo]
print @n.xbgr.xm38.nsg13_hv_pmos[w]
print @n.xbgr.xm38.nsg13_hv_pmos[l]
print @n.xbgr.xm38.nsg13_hv_pmos[delvto]
print @n.xbgr.xm38.nsg13_hv_pmos[factuo]
print @n.xbgr.xm39.nsg13_hv_pmos[w]
print @n.xbgr.xm39.nsg13_hv_pmos[l]
print @n.xbgr.xm39.nsg13_hv_pmos[delvto]
print @n.xbgr.xm39.nsg13_hv_pmos[factuo]
print @n.xbgr.xm40.nsg13_hv_pmos[w]
print @n.xbgr.xm40.nsg13_hv_pmos[l]
print @n.xbgr.xm40.nsg13_hv_pmos[delvto]
print @n.xbgr.xm40.nsg13_hv_pmos[factuo]
print @n.xbgr.xm41.nsg13_hv_pmos[w]
print @n.xbgr.xm41.nsg13_hv_pmos[l]
print @n.xbgr.xm41.nsg13_hv_pmos[delvto]
print @n.xbgr.xm41.nsg13_hv_pmos[factuo]
print @n.xbgr.xm42.nsg13_hv_pmos[w]
print @n.xbgr.xm42.nsg13_hv_pmos[l]
print @n.xbgr.xm42.nsg13_hv_pmos[delvto]
print @n.xbgr.xm42.nsg13_hv_pmos[factuo]
print @n.xbgr.xm43.nsg13_hv_pmos[w]
print @n.xbgr.xm43.nsg13_hv_pmos[l]
print @n.xbgr.xm43.nsg13_hv_pmos[delvto]
print @n.xbgr.xm43.nsg13_hv_pmos[factuo]
print @n.xbgr.xm44.nsg13_hv_pmos[w]
print @n.xbgr.xm44.nsg13_hv_pmos[l]
print @n.xbgr.xm44.nsg13_hv_pmos[delvto]
print @n.xbgr.xm44.nsg13_hv_pmos[factuo]
print @n.xbgr.xm45.nsg13_hv_pmos[w]
print @n.xbgr.xm45.nsg13_hv_pmos[l]
print @n.xbgr.xm45.nsg13_hv_pmos[delvto]
print @n.xbgr.xm45.nsg13_hv_pmos[factuo]
print @n.xbgr.xm46.nsg13_hv_pmos[w]
print @n.xbgr.xm46.nsg13_hv_pmos[l]
print @n.xbgr.xm46.nsg13_hv_pmos[delvto]
print @n.xbgr.xm46.nsg13_hv_pmos[factuo]
print @n.xbgr.xm47.nsg13_hv_pmos[w]
print @n.xbgr.xm47.nsg13_hv_pmos[l]
print @n.xbgr.xm47.nsg13_hv_pmos[delvto]
print @n.xbgr.xm47.nsg13_hv_pmos[factuo]
print @n.xbgr.xm48.nsg13_hv_pmos[w]
print @n.xbgr.xm48.nsg13_hv_pmos[l]
print @n.xbgr.xm48.nsg13_hv_pmos[delvto]
print @n.xbgr.xm48.nsg13_hv_pmos[factuo]
print @n.xbgr.xm49.nsg13_hv_pmos[w]
print @n.xbgr.xm49.nsg13_hv_pmos[l]
print @n.xbgr.xm49.nsg13_hv_pmos[delvto]
print @n.xbgr.xm49.nsg13_hv_pmos[factuo]
print @n.xbgr.xm50.nsg13_hv_pmos[w]
print @n.xbgr.xm50.nsg13_hv_pmos[l]
print @n.xbgr.xm50.nsg13_hv_pmos[delvto]
print @n.xbgr.xm50.nsg13_hv_pmos[factuo]
print @n.xbgr.xm51.nsg13_hv_pmos[w]
print @n.xbgr.xm51.nsg13_hv_pmos[l]
print @n.xbgr.xm51.nsg13_hv_pmos[delvto]
print @n.xbgr.xm51.nsg13_hv_pmos[factuo]
print @n.xbgr.xm52.nsg13_hv_pmos[w]
print @n.xbgr.xm52.nsg13_hv_pmos[l]
print @n.xbgr.xm52.nsg13_hv_pmos[delvto]
print @n.xbgr.xm52.nsg13_hv_pmos[factuo]
print @n.xbgr.xm53.nsg13_hv_pmos[w]
print @n.xbgr.xm53.nsg13_hv_pmos[l]
print @n.xbgr.xm53.nsg13_hv_pmos[delvto]
print @n.xbgr.xm53.nsg13_hv_pmos[factuo]
print @n.xbgr.xm54.nsg13_hv_pmos[w]
print @n.xbgr.xm54.nsg13_hv_pmos[l]
print @n.xbgr.xm54.nsg13_hv_pmos[delvto]
print @n.xbgr.xm54.nsg13_hv_pmos[factuo]
print @q.xbgr.xq55.qnpn13g2[area]
print @q.xbgr.xq56.qnpn13g2[area]
print @q.xbgr.xq57.qnpn13g2[area]
print @q.xbgr.xq58.qnpn13g2[area]
print @q.xbgr.xq59.qnpn13g2[area]
print @q.xbgr.xq60.qnpn13g2[area]
print @q.xbgr.xq61.qnpn13g2[area]
print @q.xbgr.xq62.qnpn13g2[area]
print @q.xbgr.xq63.qnpn13g2[area]
print @q.xbgr.xq64.qnpn13g2[area]
print @q.xbgr.xq65.qnpn13g2[area]
print @q.xbgr.xq66.qnpn13g2[area]
print @q.xbgr.xq67.qnpn13g2[area]
print @q.xbgr.xq68.qnpn13g2[area]
print @q.xbgr.xq69.qnpn13g2[area]
print @q.xbgr.xq70.qnpn13g2[area]
print @q.xbgr.xq71.qnpn13g2[area]
print @q.xbgr.xq72.qnpn13g2[area]
print @q.xbgr.xq73.qnpn13g2[area]
print @q.xbgr.xq74.qnpn13g2[area]
print @q.xbgr.xq75.qnpn13g2[area]
print @q.xbgr.xq76.qnpn13g2[area]
print @n.xbgr.xr77.nr1[nsmm_rsh]
print @n.xbgr.xr77.nr1[nsmm_w]
print @n.xbgr.xr77.nr1[nsmm_l]
print @n.xbgr.xr78.nr1[nsmm_rsh]
print @n.xbgr.xr78.nr1[nsmm_w]
print @n.xbgr.xr78.nr1[nsmm_l]
print @n.xbgr.xr79.nr1[nsmm_rsh]
print @n.xbgr.xr79.nr1[nsmm_w]
print @n.xbgr.xr79.nr1[nsmm_l]
print @n.xbgr.xr80.nr1[nsmm_rsh]
print @n.xbgr.xr80.nr1[nsmm_w]
print @n.xbgr.xr80.nr1[nsmm_l]
print @n.xbgr.xr81.nr1[nsmm_rsh]
print @n.xbgr.xr81.nr1[nsmm_w]
print @n.xbgr.xr81.nr1[nsmm_l]
print @n.xbgr.xr82.nr1[nsmm_rsh]
print @n.xbgr.xr82.nr1[nsmm_w]
print @n.xbgr.xr82.nr1[nsmm_l]
print @n.xbgr.xr83.nr1[nsmm_rsh]
print @n.xbgr.xr83.nr1[nsmm_w]
print @n.xbgr.xr83.nr1[nsmm_l]
print @n.xbgr.xr84.nr1[nsmm_rsh]
print @n.xbgr.xr84.nr1[nsmm_w]
print @n.xbgr.xr84.nr1[nsmm_l]
print @n.xbgr.xr85.nr1[nsmm_rsh]
print @n.xbgr.xr85.nr1[nsmm_w]
print @n.xbgr.xr85.nr1[nsmm_l]
print @n.xbgr.xr86.nr1[nsmm_rsh]
print @n.xbgr.xr86.nr1[nsmm_w]
print @n.xbgr.xr86.nr1[nsmm_l]
print @n.xbgr.xr16_u2.nr1[nsmm_rsh]
print @n.xbgr.xr16_u2.nr1[nsmm_w]
print @n.xbgr.xr16_u2.nr1[nsmm_l]
print @n.xbgr.xr16_u3.nr1[nsmm_rsh]
print @n.xbgr.xr16_u3.nr1[nsmm_w]
print @n.xbgr.xr16_u3.nr1[nsmm_l]
print @n.xbgr.xr16_u4.nr1[nsmm_rsh]
print @n.xbgr.xr16_u4.nr1[nsmm_w]
print @n.xbgr.xr16_u4.nr1[nsmm_l]
print @n.xbgr.xr16_u5.nr1[nsmm_rsh]
print @n.xbgr.xr16_u5.nr1[nsmm_w]
print @n.xbgr.xr16_u5.nr1[nsmm_l]
print @n.xbgr.xr16_u6.nr1[nsmm_rsh]
print @n.xbgr.xr16_u6.nr1[nsmm_w]
print @n.xbgr.xr16_u6.nr1[nsmm_l]
print @n.xbgr.xr16_u7.nr1[nsmm_rsh]
print @n.xbgr.xr16_u7.nr1[nsmm_w]
print @n.xbgr.xr16_u7.nr1[nsmm_l]
print @n.xbgr.xr16_u8.nr1[nsmm_rsh]
print @n.xbgr.xr16_u8.nr1[nsmm_w]
print @n.xbgr.xr16_u8.nr1[nsmm_l]
print @n.xbgr.xr16_u9.nr1[nsmm_rsh]
print @n.xbgr.xr16_u9.nr1[nsmm_w]
print @n.xbgr.xr16_u9.nr1[nsmm_l]
print @n.xbgr.xr16_u10.nr1[nsmm_rsh]
print @n.xbgr.xr16_u10.nr1[nsmm_w]
print @n.xbgr.xr16_u10.nr1[nsmm_l]
print @n.xbgr.xr16_u11.nr1[nsmm_rsh]
print @n.xbgr.xr16_u11.nr1[nsmm_w]
print @n.xbgr.xr16_u11.nr1[nsmm_l]
print @n.xbgr.xr16_u12.nr1[nsmm_rsh]
print @n.xbgr.xr16_u12.nr1[nsmm_w]
print @n.xbgr.xr16_u12.nr1[nsmm_l]
print @n.xbgr.xr16_u13.nr1[nsmm_rsh]
print @n.xbgr.xr16_u13.nr1[nsmm_w]
print @n.xbgr.xr16_u13.nr1[nsmm_l]
print @n.xbgr.xr16_u14.nr1[nsmm_rsh]
print @n.xbgr.xr16_u14.nr1[nsmm_w]
print @n.xbgr.xr16_u14.nr1[nsmm_l]
print @n.xbgr.xr16_u15.nr1[nsmm_rsh]
print @n.xbgr.xr16_u15.nr1[nsmm_w]
print @n.xbgr.xr16_u15.nr1[nsmm_l]
print @n.xbgr.xr16_u16.nr1[nsmm_rsh]
print @n.xbgr.xr16_u16.nr1[nsmm_w]
print @n.xbgr.xr16_u16.nr1[nsmm_l]
print @n.xbgr.xr16_u17.nr1[nsmm_rsh]
print @n.xbgr.xr16_u17.nr1[nsmm_w]
print @n.xbgr.xr16_u17.nr1[nsmm_l]
print @n.xbgr.xr16_u18.nr1[nsmm_rsh]
print @n.xbgr.xr16_u18.nr1[nsmm_w]
print @n.xbgr.xr16_u18.nr1[nsmm_l]
print @n.xbgr.xr16_u19.nr1[nsmm_rsh]
print @n.xbgr.xr16_u19.nr1[nsmm_w]
print @n.xbgr.xr16_u19.nr1[nsmm_l]
print @n.xbgr.xr16_u20.nr1[nsmm_rsh]
print @n.xbgr.xr16_u20.nr1[nsmm_w]
print @n.xbgr.xr16_u20.nr1[nsmm_l]
print @n.xbgr.xr16_u21.nr1[nsmm_rsh]
print @n.xbgr.xr16_u21.nr1[nsmm_w]
print @n.xbgr.xr16_u21.nr1[nsmm_l]
print @n.xbgr.xr16_u22.nr1[nsmm_rsh]
print @n.xbgr.xr16_u22.nr1[nsmm_w]
print @n.xbgr.xr16_u22.nr1[nsmm_l]
print @n.xbgr.xr16_u23.nr1[nsmm_rsh]
print @n.xbgr.xr16_u23.nr1[nsmm_w]
print @n.xbgr.xr16_u23.nr1[nsmm_l]
print @n.xbgr.xr16_u24.nr1[nsmm_rsh]
print @n.xbgr.xr16_u24.nr1[nsmm_w]
print @n.xbgr.xr16_u24.nr1[nsmm_l]
print @n.xbgr.xr17_u2.nr1[nsmm_rsh]
print @n.xbgr.xr17_u2.nr1[nsmm_w]
print @n.xbgr.xr17_u2.nr1[nsmm_l]
print @n.xbgr.xr17_u3.nr1[nsmm_rsh]
print @n.xbgr.xr17_u3.nr1[nsmm_w]
print @n.xbgr.xr17_u3.nr1[nsmm_l]
print @n.xbgr.xr17_u4.nr1[nsmm_rsh]
print @n.xbgr.xr17_u4.nr1[nsmm_w]
print @n.xbgr.xr17_u4.nr1[nsmm_l]
print @n.xbgr.xr18_u2.nr1[nsmm_rsh]
print @n.xbgr.xr18_u2.nr1[nsmm_w]
print @n.xbgr.xr18_u2.nr1[nsmm_l]
print @n.xbgr.xr18_u3.nr1[nsmm_rsh]
print @n.xbgr.xr18_u3.nr1[nsmm_w]
print @n.xbgr.xr18_u3.nr1[nsmm_l]
print @n.xbgr.xr18_u4.nr1[nsmm_rsh]
print @n.xbgr.xr18_u4.nr1[nsmm_w]
print @n.xbgr.xr18_u4.nr1[nsmm_l]
print @n.xbgr.xr19_u2.nr1[nsmm_rsh]
print @n.xbgr.xr19_u2.nr1[nsmm_w]
print @n.xbgr.xr19_u2.nr1[nsmm_l]
print @n.xbgr.xr19_u3.nr1[nsmm_rsh]
print @n.xbgr.xr19_u3.nr1[nsmm_w]
print @n.xbgr.xr19_u3.nr1[nsmm_l]
print @n.xbgr.xr19_u4.nr1[nsmm_rsh]
print @n.xbgr.xr19_u4.nr1[nsmm_w]
print @n.xbgr.xr19_u4.nr1[nsmm_l]
print @n.xbgr.xr20_u2.nr1[nsmm_rsh]
print @n.xbgr.xr20_u2.nr1[nsmm_w]
print @n.xbgr.xr20_u2.nr1[nsmm_l]
print @n.xbgr.xr20_u3.nr1[nsmm_rsh]
print @n.xbgr.xr20_u3.nr1[nsmm_w]
print @n.xbgr.xr20_u3.nr1[nsmm_l]
print @n.xbgr.xr20_u4.nr1[nsmm_rsh]
print @n.xbgr.xr20_u4.nr1[nsmm_w]
print @n.xbgr.xr20_u4.nr1[nsmm_l]
print @n.xbgr.xr21_u2.nr1[nsmm_rsh]
print @n.xbgr.xr21_u2.nr1[nsmm_w]
print @n.xbgr.xr21_u2.nr1[nsmm_l]
print @n.xbgr.xr21_u3.nr1[nsmm_rsh]
print @n.xbgr.xr21_u3.nr1[nsmm_w]
print @n.xbgr.xr21_u3.nr1[nsmm_l]
print @n.xbgr.xr21_u4.nr1[nsmm_rsh]
print @n.xbgr.xr21_u4.nr1[nsmm_w]
print @n.xbgr.xr21_u4.nr1[nsmm_l]
print @n.xbgr.xr22_u2.nr1[nsmm_rsh]
print @n.xbgr.xr22_u2.nr1[nsmm_w]
print @n.xbgr.xr22_u2.nr1[nsmm_l]
print @n.xbgr.xr22_u3.nr1[nsmm_rsh]
print @n.xbgr.xr22_u3.nr1[nsmm_w]
print @n.xbgr.xr22_u3.nr1[nsmm_l]
print @n.xbgr.xr22_u4.nr1[nsmm_rsh]
print @n.xbgr.xr22_u4.nr1[nsmm_w]
print @n.xbgr.xr22_u4.nr1[nsmm_l]
print @n.xbgr.xr23_u2.nr1[nsmm_rsh]
print @n.xbgr.xr23_u2.nr1[nsmm_w]
print @n.xbgr.xr23_u2.nr1[nsmm_l]
print @n.xbgr.xr23_u3.nr1[nsmm_rsh]
print @n.xbgr.xr23_u3.nr1[nsmm_w]
print @n.xbgr.xr23_u3.nr1[nsmm_l]
print @n.xbgr.xr23_u4.nr1[nsmm_rsh]
print @n.xbgr.xr23_u4.nr1[nsmm_w]
print @n.xbgr.xr23_u4.nr1[nsmm_l]
print @n.xbgr.xr23_u5.nr1[nsmm_rsh]
print @n.xbgr.xr23_u5.nr1[nsmm_w]
print @n.xbgr.xr23_u5.nr1[nsmm_l]
print @n.xbgr.xr23_u6.nr1[nsmm_rsh]
print @n.xbgr.xr23_u6.nr1[nsmm_w]
print @n.xbgr.xr23_u6.nr1[nsmm_l]
print @n.xbgr.xr23_u7.nr1[nsmm_rsh]
print @n.xbgr.xr23_u7.nr1[nsmm_w]
print @n.xbgr.xr23_u7.nr1[nsmm_l]
print @n.xbgr.xr23_u8.nr1[nsmm_rsh]
print @n.xbgr.xr23_u8.nr1[nsmm_w]
print @n.xbgr.xr23_u8.nr1[nsmm_l]
print @n.xbgr.xr23_u9.nr1[nsmm_rsh]
print @n.xbgr.xr23_u9.nr1[nsmm_w]
print @n.xbgr.xr23_u9.nr1[nsmm_l]
print @n.xbgr.xr23_u10.nr1[nsmm_rsh]
print @n.xbgr.xr23_u10.nr1[nsmm_w]
print @n.xbgr.xr23_u10.nr1[nsmm_l]
print @n.xbgr.xr23_u11.nr1[nsmm_rsh]
print @n.xbgr.xr23_u11.nr1[nsmm_w]
print @n.xbgr.xr23_u11.nr1[nsmm_l]
print @n.xbgr.xr23_u12.nr1[nsmm_rsh]
print @n.xbgr.xr23_u12.nr1[nsmm_w]
print @n.xbgr.xr23_u12.nr1[nsmm_l]
print @n.xbgr.xr23_u13.nr1[nsmm_rsh]
print @n.xbgr.xr23_u13.nr1[nsmm_w]
print @n.xbgr.xr23_u13.nr1[nsmm_l]
print @n.xbgr.xr23_u14.nr1[nsmm_rsh]
print @n.xbgr.xr23_u14.nr1[nsmm_w]
print @n.xbgr.xr23_u14.nr1[nsmm_l]
print @n.xbgr.xr23_u15.nr1[nsmm_rsh]
print @n.xbgr.xr23_u15.nr1[nsmm_w]
print @n.xbgr.xr23_u15.nr1[nsmm_l]
print @n.xbgr.xr23_u16.nr1[nsmm_rsh]
print @n.xbgr.xr23_u16.nr1[nsmm_w]
print @n.xbgr.xr23_u16.nr1[nsmm_l]
print @n.xbgr.xr23_u17.nr1[nsmm_rsh]
print @n.xbgr.xr23_u17.nr1[nsmm_w]
print @n.xbgr.xr23_u17.nr1[nsmm_l]
print @n.xbgr.xr23_u18.nr1[nsmm_rsh]
print @n.xbgr.xr23_u18.nr1[nsmm_w]
print @n.xbgr.xr23_u18.nr1[nsmm_l]
print @n.xbgr.xr23_u19.nr1[nsmm_rsh]
print @n.xbgr.xr23_u19.nr1[nsmm_w]
print @n.xbgr.xr23_u19.nr1[nsmm_l]
print @n.xbgr.xr23_u20.nr1[nsmm_rsh]
print @n.xbgr.xr23_u20.nr1[nsmm_w]
print @n.xbgr.xr23_u20.nr1[nsmm_l]
print @n.xbgr.xr23_u21.nr1[nsmm_rsh]
print @n.xbgr.xr23_u21.nr1[nsmm_w]
print @n.xbgr.xr23_u21.nr1[nsmm_l]
print @n.xbgr.xr23_u22.nr1[nsmm_rsh]
print @n.xbgr.xr23_u22.nr1[nsmm_w]
print @n.xbgr.xr23_u22.nr1[nsmm_l]
print @n.xbgr.xr23_u23.nr1[nsmm_rsh]
print @n.xbgr.xr23_u23.nr1[nsmm_w]
print @n.xbgr.xr23_u23.nr1[nsmm_l]
print @n.xbgr.xr23_u24.nr1[nsmm_rsh]
print @n.xbgr.xr23_u24.nr1[nsmm_w]
print @n.xbgr.xr23_u24.nr1[nsmm_l]
print @n.xbgr.xr24_u2.nr1[nsmm_rsh]
print @n.xbgr.xr24_u2.nr1[nsmm_w]
print @n.xbgr.xr24_u2.nr1[nsmm_l]
print @n.xbgr.xr24_u3.nr1[nsmm_rsh]
print @n.xbgr.xr24_u3.nr1[nsmm_w]
print @n.xbgr.xr24_u3.nr1[nsmm_l]
print @n.xbgr.xr24_u4.nr1[nsmm_rsh]
print @n.xbgr.xr24_u4.nr1[nsmm_w]
print @n.xbgr.xr24_u4.nr1[nsmm_l]
print @n.xbgr.xr24_u5.nr1[nsmm_rsh]
print @n.xbgr.xr24_u5.nr1[nsmm_w]
print @n.xbgr.xr24_u5.nr1[nsmm_l]
print @n.xbgr.xr24_u6.nr1[nsmm_rsh]
print @n.xbgr.xr24_u6.nr1[nsmm_w]
print @n.xbgr.xr24_u6.nr1[nsmm_l]
print @n.xbgr.xr24_u7.nr1[nsmm_rsh]
print @n.xbgr.xr24_u7.nr1[nsmm_w]
print @n.xbgr.xr24_u7.nr1[nsmm_l]
print @n.xbgr.xr24_u8.nr1[nsmm_rsh]
print @n.xbgr.xr24_u8.nr1[nsmm_w]
print @n.xbgr.xr24_u8.nr1[nsmm_l]
print @n.xbgr.xr24_u9.nr1[nsmm_rsh]
print @n.xbgr.xr24_u9.nr1[nsmm_w]
print @n.xbgr.xr24_u9.nr1[nsmm_l]
print @n.xbgr.xr24_u10.nr1[nsmm_rsh]
print @n.xbgr.xr24_u10.nr1[nsmm_w]
print @n.xbgr.xr24_u10.nr1[nsmm_l]
print @n.xbgr.xr24_u11.nr1[nsmm_rsh]
print @n.xbgr.xr24_u11.nr1[nsmm_w]
print @n.xbgr.xr24_u11.nr1[nsmm_l]
print @n.xbgr.xr24_u12.nr1[nsmm_rsh]
print @n.xbgr.xr24_u12.nr1[nsmm_w]
print @n.xbgr.xr24_u12.nr1[nsmm_l]
print @n.xbgr.xr24_u13.nr1[nsmm_rsh]
print @n.xbgr.xr24_u13.nr1[nsmm_w]
print @n.xbgr.xr24_u13.nr1[nsmm_l]
print @n.xbgr.xr24_u14.nr1[nsmm_rsh]
print @n.xbgr.xr24_u14.nr1[nsmm_w]
print @n.xbgr.xr24_u14.nr1[nsmm_l]
print @n.xbgr.xr24_u15.nr1[nsmm_rsh]
print @n.xbgr.xr24_u15.nr1[nsmm_w]
print @n.xbgr.xr24_u15.nr1[nsmm_l]
print @n.xbgr.xr24_u16.nr1[nsmm_rsh]
print @n.xbgr.xr24_u16.nr1[nsmm_w]
print @n.xbgr.xr24_u16.nr1[nsmm_l]
print @n.xbgr.xr24_u17.nr1[nsmm_rsh]
print @n.xbgr.xr24_u17.nr1[nsmm_w]
print @n.xbgr.xr24_u17.nr1[nsmm_l]
print @n.xbgr.xr24_u18.nr1[nsmm_rsh]
print @n.xbgr.xr24_u18.nr1[nsmm_w]
print @n.xbgr.xr24_u18.nr1[nsmm_l]
print @n.xbgr.xr24_u19.nr1[nsmm_rsh]
print @n.xbgr.xr24_u19.nr1[nsmm_w]
print @n.xbgr.xr24_u19.nr1[nsmm_l]
print @n.xbgr.xr24_u20.nr1[nsmm_rsh]
print @n.xbgr.xr24_u20.nr1[nsmm_w]
print @n.xbgr.xr24_u20.nr1[nsmm_l]
print @n.xbgr.xr24_u21.nr1[nsmm_rsh]
print @n.xbgr.xr24_u21.nr1[nsmm_w]
print @n.xbgr.xr24_u21.nr1[nsmm_l]
print @n.xbgr.xr24_u22.nr1[nsmm_rsh]
print @n.xbgr.xr24_u22.nr1[nsmm_w]
print @n.xbgr.xr24_u22.nr1[nsmm_l]
print @n.xbgr.xr24_u23.nr1[nsmm_rsh]
print @n.xbgr.xr24_u23.nr1[nsmm_w]
print @n.xbgr.xr24_u23.nr1[nsmm_l]
print @n.xbgr.xr24_u24.nr1[nsmm_rsh]
print @n.xbgr.xr24_u24.nr1[nsmm_w]
print @n.xbgr.xr24_u24.nr1[nsmm_l]
print @n.xbgr.xr25_u2.nr1[nsmm_rsh]
print @n.xbgr.xr25_u2.nr1[nsmm_w]
print @n.xbgr.xr25_u2.nr1[nsmm_l]
print @n.xbgr.xr25_u3.nr1[nsmm_rsh]
print @n.xbgr.xr25_u3.nr1[nsmm_w]
print @n.xbgr.xr25_u3.nr1[nsmm_l]
print @n.xbgr.xr25_u4.nr1[nsmm_rsh]
print @n.xbgr.xr25_u4.nr1[nsmm_w]
print @n.xbgr.xr25_u4.nr1[nsmm_l]
print @n.xbgr.xr25_u5.nr1[nsmm_rsh]
print @n.xbgr.xr25_u5.nr1[nsmm_w]
print @n.xbgr.xr25_u5.nr1[nsmm_l]
print @n.xbgr.xr25_u6.nr1[nsmm_rsh]
print @n.xbgr.xr25_u6.nr1[nsmm_w]
print @n.xbgr.xr25_u6.nr1[nsmm_l]
print @n.xbgr.xr25_u7.nr1[nsmm_rsh]
print @n.xbgr.xr25_u7.nr1[nsmm_w]
print @n.xbgr.xr25_u7.nr1[nsmm_l]
print @n.xbgr.xr25_u8.nr1[nsmm_rsh]
print @n.xbgr.xr25_u8.nr1[nsmm_w]
print @n.xbgr.xr25_u8.nr1[nsmm_l]
print @n.xbgr.xr25_u9.nr1[nsmm_rsh]
print @n.xbgr.xr25_u9.nr1[nsmm_w]
print @n.xbgr.xr25_u9.nr1[nsmm_l]
print @n.xbgr.xr25_u10.nr1[nsmm_rsh]
print @n.xbgr.xr25_u10.nr1[nsmm_w]
print @n.xbgr.xr25_u10.nr1[nsmm_l]
print @n.xbgr.xr25_u11.nr1[nsmm_rsh]
print @n.xbgr.xr25_u11.nr1[nsmm_w]
print @n.xbgr.xr25_u11.nr1[nsmm_l]
print @n.xbgr.xr25_u12.nr1[nsmm_rsh]
print @n.xbgr.xr25_u12.nr1[nsmm_w]
print @n.xbgr.xr25_u12.nr1[nsmm_l]
print @n.xbgr.xr25_u13.nr1[nsmm_rsh]
print @n.xbgr.xr25_u13.nr1[nsmm_w]
print @n.xbgr.xr25_u13.nr1[nsmm_l]
print @n.xbgr.xr25_u14.nr1[nsmm_rsh]
print @n.xbgr.xr25_u14.nr1[nsmm_w]
print @n.xbgr.xr25_u14.nr1[nsmm_l]
print @n.xbgr.xr25_u15.nr1[nsmm_rsh]
print @n.xbgr.xr25_u15.nr1[nsmm_w]
print @n.xbgr.xr25_u15.nr1[nsmm_l]
print @n.xbgr.xr25_u16.nr1[nsmm_rsh]
print @n.xbgr.xr25_u16.nr1[nsmm_w]
print @n.xbgr.xr25_u16.nr1[nsmm_l]
print @n.xbgr.xr25_u17.nr1[nsmm_rsh]
print @n.xbgr.xr25_u17.nr1[nsmm_w]
print @n.xbgr.xr25_u17.nr1[nsmm_l]
print @n.xbgr.xr25_u18.nr1[nsmm_rsh]
print @n.xbgr.xr25_u18.nr1[nsmm_w]
print @n.xbgr.xr25_u18.nr1[nsmm_l]
print @n.xbgr.xr25_u19.nr1[nsmm_rsh]
print @n.xbgr.xr25_u19.nr1[nsmm_w]
print @n.xbgr.xr25_u19.nr1[nsmm_l]
print @n.xbgr.xr25_u20.nr1[nsmm_rsh]
print @n.xbgr.xr25_u20.nr1[nsmm_w]
print @n.xbgr.xr25_u20.nr1[nsmm_l]
print @n.xbgr.xr25_u21.nr1[nsmm_rsh]
print @n.xbgr.xr25_u21.nr1[nsmm_w]
print @n.xbgr.xr25_u21.nr1[nsmm_l]
print @n.xbgr.xr25_u22.nr1[nsmm_rsh]
print @n.xbgr.xr25_u22.nr1[nsmm_w]
print @n.xbgr.xr25_u22.nr1[nsmm_l]
print @n.xbgr.xr25_u23.nr1[nsmm_rsh]
print @n.xbgr.xr25_u23.nr1[nsmm_w]
print @n.xbgr.xr25_u23.nr1[nsmm_l]
print @n.xbgr.xr25_u24.nr1[nsmm_rsh]
print @n.xbgr.xr25_u24.nr1[nsmm_w]
print @n.xbgr.xr25_u24.nr1[nsmm_l]
print @n.xbgr.xr26_u2.nr1[nsmm_rsh]
print @n.xbgr.xr26_u2.nr1[nsmm_w]
print @n.xbgr.xr26_u2.nr1[nsmm_l]
print @n.xbgr.xr26_u3.nr1[nsmm_rsh]
print @n.xbgr.xr26_u3.nr1[nsmm_w]
print @n.xbgr.xr26_u3.nr1[nsmm_l]
print @n.xbgr.xr26_u4.nr1[nsmm_rsh]
print @n.xbgr.xr26_u4.nr1[nsmm_w]
print @n.xbgr.xr26_u4.nr1[nsmm_l]
print @n.xbgr.xr26_u5.nr1[nsmm_rsh]
print @n.xbgr.xr26_u5.nr1[nsmm_w]
print @n.xbgr.xr26_u5.nr1[nsmm_l]
print @n.xbgr.xr26_u6.nr1[nsmm_rsh]
print @n.xbgr.xr26_u6.nr1[nsmm_w]
print @n.xbgr.xr26_u6.nr1[nsmm_l]
print @n.xbgr.xr26_u7.nr1[nsmm_rsh]
print @n.xbgr.xr26_u7.nr1[nsmm_w]
print @n.xbgr.xr26_u7.nr1[nsmm_l]
print @n.xbgr.xr26_u8.nr1[nsmm_rsh]
print @n.xbgr.xr26_u8.nr1[nsmm_w]
print @n.xbgr.xr26_u8.nr1[nsmm_l]
print @n.xbgr.xr26_u9.nr1[nsmm_rsh]
print @n.xbgr.xr26_u9.nr1[nsmm_w]
print @n.xbgr.xr26_u9.nr1[nsmm_l]
print @n.xbgr.xr26_u10.nr1[nsmm_rsh]
print @n.xbgr.xr26_u10.nr1[nsmm_w]
print @n.xbgr.xr26_u10.nr1[nsmm_l]
print @n.xbgr.xr26_u11.nr1[nsmm_rsh]
print @n.xbgr.xr26_u11.nr1[nsmm_w]
print @n.xbgr.xr26_u11.nr1[nsmm_l]
print @n.xbgr.xr26_u12.nr1[nsmm_rsh]
print @n.xbgr.xr26_u12.nr1[nsmm_w]
print @n.xbgr.xr26_u12.nr1[nsmm_l]
print @n.xbgr.xr26_u13.nr1[nsmm_rsh]
print @n.xbgr.xr26_u13.nr1[nsmm_w]
print @n.xbgr.xr26_u13.nr1[nsmm_l]
print @n.xbgr.xr26_u14.nr1[nsmm_rsh]
print @n.xbgr.xr26_u14.nr1[nsmm_w]
print @n.xbgr.xr26_u14.nr1[nsmm_l]
print @n.xbgr.xr26_u15.nr1[nsmm_rsh]
print @n.xbgr.xr26_u15.nr1[nsmm_w]
print @n.xbgr.xr26_u15.nr1[nsmm_l]
print @n.xbgr.xr26_u16.nr1[nsmm_rsh]
print @n.xbgr.xr26_u16.nr1[nsmm_w]
print @n.xbgr.xr26_u16.nr1[nsmm_l]
print @n.xbgr.xr26_u17.nr1[nsmm_rsh]
print @n.xbgr.xr26_u17.nr1[nsmm_w]
print @n.xbgr.xr26_u17.nr1[nsmm_l]
print @n.xbgr.xr26_u18.nr1[nsmm_rsh]
print @n.xbgr.xr26_u18.nr1[nsmm_w]
print @n.xbgr.xr26_u18.nr1[nsmm_l]
print @n.xbgr.xr26_u19.nr1[nsmm_rsh]
print @n.xbgr.xr26_u19.nr1[nsmm_w]
print @n.xbgr.xr26_u19.nr1[nsmm_l]
print @n.xbgr.xr26_u20.nr1[nsmm_rsh]
print @n.xbgr.xr26_u20.nr1[nsmm_w]
print @n.xbgr.xr26_u20.nr1[nsmm_l]
print @n.xbgr.xr26_u21.nr1[nsmm_rsh]
print @n.xbgr.xr26_u21.nr1[nsmm_w]
print @n.xbgr.xr26_u21.nr1[nsmm_l]
print @n.xbgr.xr26_u22.nr1[nsmm_rsh]
print @n.xbgr.xr26_u22.nr1[nsmm_w]
print @n.xbgr.xr26_u22.nr1[nsmm_l]
print @n.xbgr.xr26_u23.nr1[nsmm_rsh]
print @n.xbgr.xr26_u23.nr1[nsmm_w]
print @n.xbgr.xr26_u23.nr1[nsmm_l]
print @n.xbgr.xr26_u24.nr1[nsmm_rsh]
print @n.xbgr.xr26_u24.nr1[nsmm_w]
print @n.xbgr.xr26_u24.nr1[nsmm_l]
print @n.xbgr.xm34_u2.nsg13_hv_nmos[w]
print @n.xbgr.xm34_u2.nsg13_hv_nmos[l]
print @n.xbgr.xm34_u2.nsg13_hv_nmos[delvto]
print @n.xbgr.xm34_u2.nsg13_hv_nmos[factuo]
print @n.xbgr.xm34_u3.nsg13_hv_nmos[w]
print @n.xbgr.xm34_u3.nsg13_hv_nmos[l]
print @n.xbgr.xm34_u3.nsg13_hv_nmos[delvto]
print @n.xbgr.xm34_u3.nsg13_hv_nmos[factuo]
print @n.xbgr.xm34_u4.nsg13_hv_nmos[w]
print @n.xbgr.xm34_u4.nsg13_hv_nmos[l]
print @n.xbgr.xm34_u4.nsg13_hv_nmos[delvto]
print @n.xbgr.xm34_u4.nsg13_hv_nmos[factuo]
print @n.xbgr.xm34_u5.nsg13_hv_nmos[w]
print @n.xbgr.xm34_u5.nsg13_hv_nmos[l]
print @n.xbgr.xm34_u5.nsg13_hv_nmos[delvto]
print @n.xbgr.xm34_u5.nsg13_hv_nmos[factuo]
print @n.xbgr.xm34_u6.nsg13_hv_nmos[w]
print @n.xbgr.xm34_u6.nsg13_hv_nmos[l]
print @n.xbgr.xm34_u6.nsg13_hv_nmos[delvto]
print @n.xbgr.xm34_u6.nsg13_hv_nmos[factuo]
print @n.xbgr.xm34_u7.nsg13_hv_nmos[w]
print @n.xbgr.xm34_u7.nsg13_hv_nmos[l]
print @n.xbgr.xm34_u7.nsg13_hv_nmos[delvto]
print @n.xbgr.xm34_u7.nsg13_hv_nmos[factuo]
print @n.xbgr.xm34_u8.nsg13_hv_nmos[w]
print @n.xbgr.xm34_u8.nsg13_hv_nmos[l]
print @n.xbgr.xm34_u8.nsg13_hv_nmos[delvto]
print @n.xbgr.xm34_u8.nsg13_hv_nmos[factuo]
print @n.xbgr.xm34_u9.nsg13_hv_nmos[w]
print @n.xbgr.xm34_u9.nsg13_hv_nmos[l]
print @n.xbgr.xm34_u9.nsg13_hv_nmos[delvto]
print @n.xbgr.xm34_u9.nsg13_hv_nmos[factuo]
print @n.xbgr.xm34_u10.nsg13_hv_nmos[w]
print @n.xbgr.xm34_u10.nsg13_hv_nmos[l]
print @n.xbgr.xm34_u10.nsg13_hv_nmos[delvto]
print @n.xbgr.xm34_u10.nsg13_hv_nmos[factuo]
print @n.xbgr.xm34_u11.nsg13_hv_nmos[w]
print @n.xbgr.xm34_u11.nsg13_hv_nmos[l]
print @n.xbgr.xm34_u11.nsg13_hv_nmos[delvto]
print @n.xbgr.xm34_u11.nsg13_hv_nmos[factuo]
print @n.xbgr.xm34_u12.nsg13_hv_nmos[w]
print @n.xbgr.xm34_u12.nsg13_hv_nmos[l]
print @n.xbgr.xm34_u12.nsg13_hv_nmos[delvto]
print @n.xbgr.xm34_u12.nsg13_hv_nmos[factuo]
print @n.xbgr.xm34_u13.nsg13_hv_nmos[w]
print @n.xbgr.xm34_u13.nsg13_hv_nmos[l]
print @n.xbgr.xm34_u13.nsg13_hv_nmos[delvto]
print @n.xbgr.xm34_u13.nsg13_hv_nmos[factuo]
print @n.xbgr.xm34_u14.nsg13_hv_nmos[w]
print @n.xbgr.xm34_u14.nsg13_hv_nmos[l]
print @n.xbgr.xm34_u14.nsg13_hv_nmos[delvto]
print @n.xbgr.xm34_u14.nsg13_hv_nmos[factuo]
print @n.xbgr.xm34_u15.nsg13_hv_nmos[w]
print @n.xbgr.xm34_u15.nsg13_hv_nmos[l]
print @n.xbgr.xm34_u15.nsg13_hv_nmos[delvto]
print @n.xbgr.xm34_u15.nsg13_hv_nmos[factuo]
print @n.xbgr.xm34_u16.nsg13_hv_nmos[w]
print @n.xbgr.xm34_u16.nsg13_hv_nmos[l]
print @n.xbgr.xm34_u16.nsg13_hv_nmos[delvto]
print @n.xbgr.xm34_u16.nsg13_hv_nmos[factuo]
print @n.xbgr.xm34_u17.nsg13_hv_nmos[w]
print @n.xbgr.xm34_u17.nsg13_hv_nmos[l]
print @n.xbgr.xm34_u17.nsg13_hv_nmos[delvto]
print @n.xbgr.xm34_u17.nsg13_hv_nmos[factuo]
print @n.xbgr.xm34_u18.nsg13_hv_nmos[w]
print @n.xbgr.xm34_u18.nsg13_hv_nmos[l]
print @n.xbgr.xm34_u18.nsg13_hv_nmos[delvto]
print @n.xbgr.xm34_u18.nsg13_hv_nmos[factuo]
print @n.xbgr.xm34_u19.nsg13_hv_nmos[w]
print @n.xbgr.xm34_u19.nsg13_hv_nmos[l]
print @n.xbgr.xm34_u19.nsg13_hv_nmos[delvto]
print @n.xbgr.xm34_u19.nsg13_hv_nmos[factuo]
print @n.xbgr.xm34_u20.nsg13_hv_nmos[w]
print @n.xbgr.xm34_u20.nsg13_hv_nmos[l]
print @n.xbgr.xm34_u20.nsg13_hv_nmos[delvto]
print @n.xbgr.xm34_u20.nsg13_hv_nmos[factuo]
print @n.xbgr.xm34_u21.nsg13_hv_nmos[w]
print @n.xbgr.xm34_u21.nsg13_hv_nmos[l]
print @n.xbgr.xm34_u21.nsg13_hv_nmos[delvto]
print @n.xbgr.xm34_u21.nsg13_hv_nmos[factuo]
print @n.xbgr.xm34_u22.nsg13_hv_nmos[w]
print @n.xbgr.xm34_u22.nsg13_hv_nmos[l]
print @n.xbgr.xm34_u22.nsg13_hv_nmos[delvto]
print @n.xbgr.xm34_u22.nsg13_hv_nmos[factuo]
print @n.xbgr.xm34_u23.nsg13_hv_nmos[w]
print @n.xbgr.xm34_u23.nsg13_hv_nmos[l]
print @n.xbgr.xm34_u23.nsg13_hv_nmos[delvto]
print @n.xbgr.xm34_u23.nsg13_hv_nmos[factuo]
print @n.xbgr.xm34_u24.nsg13_hv_nmos[w]
print @n.xbgr.xm34_u24.nsg13_hv_nmos[l]
print @n.xbgr.xm34_u24.nsg13_hv_nmos[delvto]
print @n.xbgr.xm34_u24.nsg13_hv_nmos[factuo]
print @n.xbgr.xm35_u2.nsg13_hv_nmos[w]
print @n.xbgr.xm35_u2.nsg13_hv_nmos[l]
print @n.xbgr.xm35_u2.nsg13_hv_nmos[delvto]
print @n.xbgr.xm35_u2.nsg13_hv_nmos[factuo]
print @n.xbgr.xm35_u3.nsg13_hv_nmos[w]
print @n.xbgr.xm35_u3.nsg13_hv_nmos[l]
print @n.xbgr.xm35_u3.nsg13_hv_nmos[delvto]
print @n.xbgr.xm35_u3.nsg13_hv_nmos[factuo]
print @n.xbgr.xm35_u4.nsg13_hv_nmos[w]
print @n.xbgr.xm35_u4.nsg13_hv_nmos[l]
print @n.xbgr.xm35_u4.nsg13_hv_nmos[delvto]
print @n.xbgr.xm35_u4.nsg13_hv_nmos[factuo]
print @n.xbgr.xm35_u5.nsg13_hv_nmos[w]
print @n.xbgr.xm35_u5.nsg13_hv_nmos[l]
print @n.xbgr.xm35_u5.nsg13_hv_nmos[delvto]
print @n.xbgr.xm35_u5.nsg13_hv_nmos[factuo]
print @n.xbgr.xm35_u6.nsg13_hv_nmos[w]
print @n.xbgr.xm35_u6.nsg13_hv_nmos[l]
print @n.xbgr.xm35_u6.nsg13_hv_nmos[delvto]
print @n.xbgr.xm35_u6.nsg13_hv_nmos[factuo]
print @n.xbgr.xm35_u7.nsg13_hv_nmos[w]
print @n.xbgr.xm35_u7.nsg13_hv_nmos[l]
print @n.xbgr.xm35_u7.nsg13_hv_nmos[delvto]
print @n.xbgr.xm35_u7.nsg13_hv_nmos[factuo]
print @n.xbgr.xm35_u8.nsg13_hv_nmos[w]
print @n.xbgr.xm35_u8.nsg13_hv_nmos[l]
print @n.xbgr.xm35_u8.nsg13_hv_nmos[delvto]
print @n.xbgr.xm35_u8.nsg13_hv_nmos[factuo]
print @n.xbgr.xm35_u9.nsg13_hv_nmos[w]
print @n.xbgr.xm35_u9.nsg13_hv_nmos[l]
print @n.xbgr.xm35_u9.nsg13_hv_nmos[delvto]
print @n.xbgr.xm35_u9.nsg13_hv_nmos[factuo]
print @n.xbgr.xm35_u10.nsg13_hv_nmos[w]
print @n.xbgr.xm35_u10.nsg13_hv_nmos[l]
print @n.xbgr.xm35_u10.nsg13_hv_nmos[delvto]
print @n.xbgr.xm35_u10.nsg13_hv_nmos[factuo]
print @n.xbgr.xm35_u11.nsg13_hv_nmos[w]
print @n.xbgr.xm35_u11.nsg13_hv_nmos[l]
print @n.xbgr.xm35_u11.nsg13_hv_nmos[delvto]
print @n.xbgr.xm35_u11.nsg13_hv_nmos[factuo]
print @n.xbgr.xm35_u12.nsg13_hv_nmos[w]
print @n.xbgr.xm35_u12.nsg13_hv_nmos[l]
print @n.xbgr.xm35_u12.nsg13_hv_nmos[delvto]
print @n.xbgr.xm35_u12.nsg13_hv_nmos[factuo]
print @n.xbgr.xm35_u13.nsg13_hv_nmos[w]
print @n.xbgr.xm35_u13.nsg13_hv_nmos[l]
print @n.xbgr.xm35_u13.nsg13_hv_nmos[delvto]
print @n.xbgr.xm35_u13.nsg13_hv_nmos[factuo]
print @n.xbgr.xm35_u14.nsg13_hv_nmos[w]
print @n.xbgr.xm35_u14.nsg13_hv_nmos[l]
print @n.xbgr.xm35_u14.nsg13_hv_nmos[delvto]
print @n.xbgr.xm35_u14.nsg13_hv_nmos[factuo]
print @n.xbgr.xm35_u15.nsg13_hv_nmos[w]
print @n.xbgr.xm35_u15.nsg13_hv_nmos[l]
print @n.xbgr.xm35_u15.nsg13_hv_nmos[delvto]
print @n.xbgr.xm35_u15.nsg13_hv_nmos[factuo]
print @n.xbgr.xm35_u16.nsg13_hv_nmos[w]
print @n.xbgr.xm35_u16.nsg13_hv_nmos[l]
print @n.xbgr.xm35_u16.nsg13_hv_nmos[delvto]
print @n.xbgr.xm35_u16.nsg13_hv_nmos[factuo]
print @n.xbgr.xm35_u17.nsg13_hv_nmos[w]
print @n.xbgr.xm35_u17.nsg13_hv_nmos[l]
print @n.xbgr.xm35_u17.nsg13_hv_nmos[delvto]
print @n.xbgr.xm35_u17.nsg13_hv_nmos[factuo]
print @n.xbgr.xm35_u18.nsg13_hv_nmos[w]
print @n.xbgr.xm35_u18.nsg13_hv_nmos[l]
print @n.xbgr.xm35_u18.nsg13_hv_nmos[delvto]
print @n.xbgr.xm35_u18.nsg13_hv_nmos[factuo]
print @n.xbgr.xm35_u19.nsg13_hv_nmos[w]
print @n.xbgr.xm35_u19.nsg13_hv_nmos[l]
print @n.xbgr.xm35_u19.nsg13_hv_nmos[delvto]
print @n.xbgr.xm35_u19.nsg13_hv_nmos[factuo]
print @n.xbgr.xm35_u20.nsg13_hv_nmos[w]
print @n.xbgr.xm35_u20.nsg13_hv_nmos[l]
print @n.xbgr.xm35_u20.nsg13_hv_nmos[delvto]
print @n.xbgr.xm35_u20.nsg13_hv_nmos[factuo]
print @n.xbgr.xm35_u21.nsg13_hv_nmos[w]
print @n.xbgr.xm35_u21.nsg13_hv_nmos[l]
print @n.xbgr.xm35_u21.nsg13_hv_nmos[delvto]
print @n.xbgr.xm35_u21.nsg13_hv_nmos[factuo]
print @n.xbgr.xm35_u22.nsg13_hv_nmos[w]
print @n.xbgr.xm35_u22.nsg13_hv_nmos[l]
print @n.xbgr.xm35_u22.nsg13_hv_nmos[delvto]
print @n.xbgr.xm35_u22.nsg13_hv_nmos[factuo]
print @n.xbgr.xm35_u23.nsg13_hv_nmos[w]
print @n.xbgr.xm35_u23.nsg13_hv_nmos[l]
print @n.xbgr.xm35_u23.nsg13_hv_nmos[delvto]
print @n.xbgr.xm35_u23.nsg13_hv_nmos[factuo]
print @n.xbgr.xm35_u24.nsg13_hv_nmos[w]
print @n.xbgr.xm35_u24.nsg13_hv_nmos[l]
print @n.xbgr.xm35_u24.nsg13_hv_nmos[delvto]
print @n.xbgr.xm35_u24.nsg13_hv_nmos[factuo]
print @n.xbgr.xm36_u2.nsg13_hv_nmos[w]
print @n.xbgr.xm36_u2.nsg13_hv_nmos[l]
print @n.xbgr.xm36_u2.nsg13_hv_nmos[delvto]
print @n.xbgr.xm36_u2.nsg13_hv_nmos[factuo]
print @n.xbgr.xm36_u3.nsg13_hv_nmos[w]
print @n.xbgr.xm36_u3.nsg13_hv_nmos[l]
print @n.xbgr.xm36_u3.nsg13_hv_nmos[delvto]
print @n.xbgr.xm36_u3.nsg13_hv_nmos[factuo]
print @n.xbgr.xm36_u4.nsg13_hv_nmos[w]
print @n.xbgr.xm36_u4.nsg13_hv_nmos[l]
print @n.xbgr.xm36_u4.nsg13_hv_nmos[delvto]
print @n.xbgr.xm36_u4.nsg13_hv_nmos[factuo]
print @n.xbgr.xm36_u5.nsg13_hv_nmos[w]
print @n.xbgr.xm36_u5.nsg13_hv_nmos[l]
print @n.xbgr.xm36_u5.nsg13_hv_nmos[delvto]
print @n.xbgr.xm36_u5.nsg13_hv_nmos[factuo]
print @n.xbgr.xm36_u6.nsg13_hv_nmos[w]
print @n.xbgr.xm36_u6.nsg13_hv_nmos[l]
print @n.xbgr.xm36_u6.nsg13_hv_nmos[delvto]
print @n.xbgr.xm36_u6.nsg13_hv_nmos[factuo]
print @n.xbgr.xm36_u7.nsg13_hv_nmos[w]
print @n.xbgr.xm36_u7.nsg13_hv_nmos[l]
print @n.xbgr.xm36_u7.nsg13_hv_nmos[delvto]
print @n.xbgr.xm36_u7.nsg13_hv_nmos[factuo]
print @n.xbgr.xm36_u8.nsg13_hv_nmos[w]
print @n.xbgr.xm36_u8.nsg13_hv_nmos[l]
print @n.xbgr.xm36_u8.nsg13_hv_nmos[delvto]
print @n.xbgr.xm36_u8.nsg13_hv_nmos[factuo]
print @n.xbgr.xm36_u9.nsg13_hv_nmos[w]
print @n.xbgr.xm36_u9.nsg13_hv_nmos[l]
print @n.xbgr.xm36_u9.nsg13_hv_nmos[delvto]
print @n.xbgr.xm36_u9.nsg13_hv_nmos[factuo]
print @n.xbgr.xm36_u10.nsg13_hv_nmos[w]
print @n.xbgr.xm36_u10.nsg13_hv_nmos[l]
print @n.xbgr.xm36_u10.nsg13_hv_nmos[delvto]
print @n.xbgr.xm36_u10.nsg13_hv_nmos[factuo]
print @n.xbgr.xm36_u11.nsg13_hv_nmos[w]
print @n.xbgr.xm36_u11.nsg13_hv_nmos[l]
print @n.xbgr.xm36_u11.nsg13_hv_nmos[delvto]
print @n.xbgr.xm36_u11.nsg13_hv_nmos[factuo]
print @n.xbgr.xm36_u12.nsg13_hv_nmos[w]
print @n.xbgr.xm36_u12.nsg13_hv_nmos[l]
print @n.xbgr.xm36_u12.nsg13_hv_nmos[delvto]
print @n.xbgr.xm36_u12.nsg13_hv_nmos[factuo]
print @n.xbgr.xm36_u13.nsg13_hv_nmos[w]
print @n.xbgr.xm36_u13.nsg13_hv_nmos[l]
print @n.xbgr.xm36_u13.nsg13_hv_nmos[delvto]
print @n.xbgr.xm36_u13.nsg13_hv_nmos[factuo]
print @n.xbgr.xm36_u14.nsg13_hv_nmos[w]
print @n.xbgr.xm36_u14.nsg13_hv_nmos[l]
print @n.xbgr.xm36_u14.nsg13_hv_nmos[delvto]
print @n.xbgr.xm36_u14.nsg13_hv_nmos[factuo]
print @n.xbgr.xm36_u15.nsg13_hv_nmos[w]
print @n.xbgr.xm36_u15.nsg13_hv_nmos[l]
print @n.xbgr.xm36_u15.nsg13_hv_nmos[delvto]
print @n.xbgr.xm36_u15.nsg13_hv_nmos[factuo]
print @n.xbgr.xm36_u16.nsg13_hv_nmos[w]
print @n.xbgr.xm36_u16.nsg13_hv_nmos[l]
print @n.xbgr.xm36_u16.nsg13_hv_nmos[delvto]
print @n.xbgr.xm36_u16.nsg13_hv_nmos[factuo]
print @n.xbgr.xm36_u17.nsg13_hv_nmos[w]
print @n.xbgr.xm36_u17.nsg13_hv_nmos[l]
print @n.xbgr.xm36_u17.nsg13_hv_nmos[delvto]
print @n.xbgr.xm36_u17.nsg13_hv_nmos[factuo]
print @n.xbgr.xm36_u18.nsg13_hv_nmos[w]
print @n.xbgr.xm36_u18.nsg13_hv_nmos[l]
print @n.xbgr.xm36_u18.nsg13_hv_nmos[delvto]
print @n.xbgr.xm36_u18.nsg13_hv_nmos[factuo]
print @n.xbgr.xm36_u19.nsg13_hv_nmos[w]
print @n.xbgr.xm36_u19.nsg13_hv_nmos[l]
print @n.xbgr.xm36_u19.nsg13_hv_nmos[delvto]
print @n.xbgr.xm36_u19.nsg13_hv_nmos[factuo]
print @n.xbgr.xm36_u20.nsg13_hv_nmos[w]
print @n.xbgr.xm36_u20.nsg13_hv_nmos[l]
print @n.xbgr.xm36_u20.nsg13_hv_nmos[delvto]
print @n.xbgr.xm36_u20.nsg13_hv_nmos[factuo]
print @n.xbgr.xm36_u21.nsg13_hv_nmos[w]
print @n.xbgr.xm36_u21.nsg13_hv_nmos[l]
print @n.xbgr.xm36_u21.nsg13_hv_nmos[delvto]
print @n.xbgr.xm36_u21.nsg13_hv_nmos[factuo]
print @n.xbgr.xm36_u22.nsg13_hv_nmos[w]
print @n.xbgr.xm36_u22.nsg13_hv_nmos[l]
print @n.xbgr.xm36_u22.nsg13_hv_nmos[delvto]
print @n.xbgr.xm36_u22.nsg13_hv_nmos[factuo]
print @n.xbgr.xm36_u23.nsg13_hv_nmos[w]
print @n.xbgr.xm36_u23.nsg13_hv_nmos[l]
print @n.xbgr.xm36_u23.nsg13_hv_nmos[delvto]
print @n.xbgr.xm36_u23.nsg13_hv_nmos[factuo]
print @n.xbgr.xm36_u24.nsg13_hv_nmos[w]
print @n.xbgr.xm36_u24.nsg13_hv_nmos[l]
print @n.xbgr.xm36_u24.nsg13_hv_nmos[delvto]
print @n.xbgr.xm36_u24.nsg13_hv_nmos[factuo]
print @n.xbgr.xm37_u2.nsg13_hv_nmos[w]
print @n.xbgr.xm37_u2.nsg13_hv_nmos[l]
print @n.xbgr.xm37_u2.nsg13_hv_nmos[delvto]
print @n.xbgr.xm37_u2.nsg13_hv_nmos[factuo]
print @n.xbgr.xm37_u3.nsg13_hv_nmos[w]
print @n.xbgr.xm37_u3.nsg13_hv_nmos[l]
print @n.xbgr.xm37_u3.nsg13_hv_nmos[delvto]
print @n.xbgr.xm37_u3.nsg13_hv_nmos[factuo]
print @n.xbgr.xm37_u4.nsg13_hv_nmos[w]
print @n.xbgr.xm37_u4.nsg13_hv_nmos[l]
print @n.xbgr.xm37_u4.nsg13_hv_nmos[delvto]
print @n.xbgr.xm37_u4.nsg13_hv_nmos[factuo]
print @n.xbgr.xm37_u5.nsg13_hv_nmos[w]
print @n.xbgr.xm37_u5.nsg13_hv_nmos[l]
print @n.xbgr.xm37_u5.nsg13_hv_nmos[delvto]
print @n.xbgr.xm37_u5.nsg13_hv_nmos[factuo]
print @n.xbgr.xm37_u6.nsg13_hv_nmos[w]
print @n.xbgr.xm37_u6.nsg13_hv_nmos[l]
print @n.xbgr.xm37_u6.nsg13_hv_nmos[delvto]
print @n.xbgr.xm37_u6.nsg13_hv_nmos[factuo]
print @n.xbgr.xm37_u7.nsg13_hv_nmos[w]
print @n.xbgr.xm37_u7.nsg13_hv_nmos[l]
print @n.xbgr.xm37_u7.nsg13_hv_nmos[delvto]
print @n.xbgr.xm37_u7.nsg13_hv_nmos[factuo]
print @n.xbgr.xm37_u8.nsg13_hv_nmos[w]
print @n.xbgr.xm37_u8.nsg13_hv_nmos[l]
print @n.xbgr.xm37_u8.nsg13_hv_nmos[delvto]
print @n.xbgr.xm37_u8.nsg13_hv_nmos[factuo]
print @n.xbgr.xm37_u9.nsg13_hv_nmos[w]
print @n.xbgr.xm37_u9.nsg13_hv_nmos[l]
print @n.xbgr.xm37_u9.nsg13_hv_nmos[delvto]
print @n.xbgr.xm37_u9.nsg13_hv_nmos[factuo]
print @n.xbgr.xm37_u10.nsg13_hv_nmos[w]
print @n.xbgr.xm37_u10.nsg13_hv_nmos[l]
print @n.xbgr.xm37_u10.nsg13_hv_nmos[delvto]
print @n.xbgr.xm37_u10.nsg13_hv_nmos[factuo]
print @n.xbgr.xm37_u11.nsg13_hv_nmos[w]
print @n.xbgr.xm37_u11.nsg13_hv_nmos[l]
print @n.xbgr.xm37_u11.nsg13_hv_nmos[delvto]
print @n.xbgr.xm37_u11.nsg13_hv_nmos[factuo]
print @n.xbgr.xm37_u12.nsg13_hv_nmos[w]
print @n.xbgr.xm37_u12.nsg13_hv_nmos[l]
print @n.xbgr.xm37_u12.nsg13_hv_nmos[delvto]
print @n.xbgr.xm37_u12.nsg13_hv_nmos[factuo]
print @n.xbgr.xm37_u13.nsg13_hv_nmos[w]
print @n.xbgr.xm37_u13.nsg13_hv_nmos[l]
print @n.xbgr.xm37_u13.nsg13_hv_nmos[delvto]
print @n.xbgr.xm37_u13.nsg13_hv_nmos[factuo]
print @n.xbgr.xm37_u14.nsg13_hv_nmos[w]
print @n.xbgr.xm37_u14.nsg13_hv_nmos[l]
print @n.xbgr.xm37_u14.nsg13_hv_nmos[delvto]
print @n.xbgr.xm37_u14.nsg13_hv_nmos[factuo]
print @n.xbgr.xm37_u15.nsg13_hv_nmos[w]
print @n.xbgr.xm37_u15.nsg13_hv_nmos[l]
print @n.xbgr.xm37_u15.nsg13_hv_nmos[delvto]
print @n.xbgr.xm37_u15.nsg13_hv_nmos[factuo]
print @n.xbgr.xm37_u16.nsg13_hv_nmos[w]
print @n.xbgr.xm37_u16.nsg13_hv_nmos[l]
print @n.xbgr.xm37_u16.nsg13_hv_nmos[delvto]
print @n.xbgr.xm37_u16.nsg13_hv_nmos[factuo]
print @n.xbgr.xm37_u17.nsg13_hv_nmos[w]
print @n.xbgr.xm37_u17.nsg13_hv_nmos[l]
print @n.xbgr.xm37_u17.nsg13_hv_nmos[delvto]
print @n.xbgr.xm37_u17.nsg13_hv_nmos[factuo]
print @n.xbgr.xm37_u18.nsg13_hv_nmos[w]
print @n.xbgr.xm37_u18.nsg13_hv_nmos[l]
print @n.xbgr.xm37_u18.nsg13_hv_nmos[delvto]
print @n.xbgr.xm37_u18.nsg13_hv_nmos[factuo]
print @n.xbgr.xm37_u19.nsg13_hv_nmos[w]
print @n.xbgr.xm37_u19.nsg13_hv_nmos[l]
print @n.xbgr.xm37_u19.nsg13_hv_nmos[delvto]
print @n.xbgr.xm37_u19.nsg13_hv_nmos[factuo]
print @n.xbgr.xm37_u20.nsg13_hv_nmos[w]
print @n.xbgr.xm37_u20.nsg13_hv_nmos[l]
print @n.xbgr.xm37_u20.nsg13_hv_nmos[delvto]
print @n.xbgr.xm37_u20.nsg13_hv_nmos[factuo]
print @n.xbgr.xm37_u21.nsg13_hv_nmos[w]
print @n.xbgr.xm37_u21.nsg13_hv_nmos[l]
print @n.xbgr.xm37_u21.nsg13_hv_nmos[delvto]
print @n.xbgr.xm37_u21.nsg13_hv_nmos[factuo]
print @n.xbgr.xm37_u22.nsg13_hv_nmos[w]
print @n.xbgr.xm37_u22.nsg13_hv_nmos[l]
print @n.xbgr.xm37_u22.nsg13_hv_nmos[delvto]
print @n.xbgr.xm37_u22.nsg13_hv_nmos[factuo]
print @n.xbgr.xm37_u23.nsg13_hv_nmos[w]
print @n.xbgr.xm37_u23.nsg13_hv_nmos[l]
print @n.xbgr.xm37_u23.nsg13_hv_nmos[delvto]
print @n.xbgr.xm37_u23.nsg13_hv_nmos[factuo]
print @n.xbgr.xm37_u24.nsg13_hv_nmos[w]
print @n.xbgr.xm37_u24.nsg13_hv_nmos[l]
print @n.xbgr.xm37_u24.nsg13_hv_nmos[delvto]
print @n.xbgr.xm37_u24.nsg13_hv_nmos[factuo]
print @n.xbgr.xm38_u2.nsg13_hv_pmos[w]
print @n.xbgr.xm38_u2.nsg13_hv_pmos[l]
print @n.xbgr.xm38_u2.nsg13_hv_pmos[delvto]
print @n.xbgr.xm38_u2.nsg13_hv_pmos[factuo]
print @n.xbgr.xm38_u3.nsg13_hv_pmos[w]
print @n.xbgr.xm38_u3.nsg13_hv_pmos[l]
print @n.xbgr.xm38_u3.nsg13_hv_pmos[delvto]
print @n.xbgr.xm38_u3.nsg13_hv_pmos[factuo]
print @n.xbgr.xm38_u4.nsg13_hv_pmos[w]
print @n.xbgr.xm38_u4.nsg13_hv_pmos[l]
print @n.xbgr.xm38_u4.nsg13_hv_pmos[delvto]
print @n.xbgr.xm38_u4.nsg13_hv_pmos[factuo]
print @n.xbgr.xm38_u5.nsg13_hv_pmos[w]
print @n.xbgr.xm38_u5.nsg13_hv_pmos[l]
print @n.xbgr.xm38_u5.nsg13_hv_pmos[delvto]
print @n.xbgr.xm38_u5.nsg13_hv_pmos[factuo]
print @n.xbgr.xm38_u6.nsg13_hv_pmos[w]
print @n.xbgr.xm38_u6.nsg13_hv_pmos[l]
print @n.xbgr.xm38_u6.nsg13_hv_pmos[delvto]
print @n.xbgr.xm38_u6.nsg13_hv_pmos[factuo]
print @n.xbgr.xm38_u7.nsg13_hv_pmos[w]
print @n.xbgr.xm38_u7.nsg13_hv_pmos[l]
print @n.xbgr.xm38_u7.nsg13_hv_pmos[delvto]
print @n.xbgr.xm38_u7.nsg13_hv_pmos[factuo]
print @n.xbgr.xm38_u8.nsg13_hv_pmos[w]
print @n.xbgr.xm38_u8.nsg13_hv_pmos[l]
print @n.xbgr.xm38_u8.nsg13_hv_pmos[delvto]
print @n.xbgr.xm38_u8.nsg13_hv_pmos[factuo]
print @n.xbgr.xm38_u9.nsg13_hv_pmos[w]
print @n.xbgr.xm38_u9.nsg13_hv_pmos[l]
print @n.xbgr.xm38_u9.nsg13_hv_pmos[delvto]
print @n.xbgr.xm38_u9.nsg13_hv_pmos[factuo]
print @n.xbgr.xm38_u10.nsg13_hv_pmos[w]
print @n.xbgr.xm38_u10.nsg13_hv_pmos[l]
print @n.xbgr.xm38_u10.nsg13_hv_pmos[delvto]
print @n.xbgr.xm38_u10.nsg13_hv_pmos[factuo]
print @n.xbgr.xm38_u11.nsg13_hv_pmos[w]
print @n.xbgr.xm38_u11.nsg13_hv_pmos[l]
print @n.xbgr.xm38_u11.nsg13_hv_pmos[delvto]
print @n.xbgr.xm38_u11.nsg13_hv_pmos[factuo]
print @n.xbgr.xm38_u12.nsg13_hv_pmos[w]
print @n.xbgr.xm38_u12.nsg13_hv_pmos[l]
print @n.xbgr.xm38_u12.nsg13_hv_pmos[delvto]
print @n.xbgr.xm38_u12.nsg13_hv_pmos[factuo]
print @n.xbgr.xm38_u13.nsg13_hv_pmos[w]
print @n.xbgr.xm38_u13.nsg13_hv_pmos[l]
print @n.xbgr.xm38_u13.nsg13_hv_pmos[delvto]
print @n.xbgr.xm38_u13.nsg13_hv_pmos[factuo]
print @n.xbgr.xm38_u14.nsg13_hv_pmos[w]
print @n.xbgr.xm38_u14.nsg13_hv_pmos[l]
print @n.xbgr.xm38_u14.nsg13_hv_pmos[delvto]
print @n.xbgr.xm38_u14.nsg13_hv_pmos[factuo]
print @n.xbgr.xm38_u15.nsg13_hv_pmos[w]
print @n.xbgr.xm38_u15.nsg13_hv_pmos[l]
print @n.xbgr.xm38_u15.nsg13_hv_pmos[delvto]
print @n.xbgr.xm38_u15.nsg13_hv_pmos[factuo]
print @n.xbgr.xm38_u16.nsg13_hv_pmos[w]
print @n.xbgr.xm38_u16.nsg13_hv_pmos[l]
print @n.xbgr.xm38_u16.nsg13_hv_pmos[delvto]
print @n.xbgr.xm38_u16.nsg13_hv_pmos[factuo]
print @n.xbgr.xm38_u17.nsg13_hv_pmos[w]
print @n.xbgr.xm38_u17.nsg13_hv_pmos[l]
print @n.xbgr.xm38_u17.nsg13_hv_pmos[delvto]
print @n.xbgr.xm38_u17.nsg13_hv_pmos[factuo]
print @n.xbgr.xm38_u18.nsg13_hv_pmos[w]
print @n.xbgr.xm38_u18.nsg13_hv_pmos[l]
print @n.xbgr.xm38_u18.nsg13_hv_pmos[delvto]
print @n.xbgr.xm38_u18.nsg13_hv_pmos[factuo]
print @n.xbgr.xm38_u19.nsg13_hv_pmos[w]
print @n.xbgr.xm38_u19.nsg13_hv_pmos[l]
print @n.xbgr.xm38_u19.nsg13_hv_pmos[delvto]
print @n.xbgr.xm38_u19.nsg13_hv_pmos[factuo]
print @n.xbgr.xm38_u20.nsg13_hv_pmos[w]
print @n.xbgr.xm38_u20.nsg13_hv_pmos[l]
print @n.xbgr.xm38_u20.nsg13_hv_pmos[delvto]
print @n.xbgr.xm38_u20.nsg13_hv_pmos[factuo]
print @n.xbgr.xm38_u21.nsg13_hv_pmos[w]
print @n.xbgr.xm38_u21.nsg13_hv_pmos[l]
print @n.xbgr.xm38_u21.nsg13_hv_pmos[delvto]
print @n.xbgr.xm38_u21.nsg13_hv_pmos[factuo]
print @n.xbgr.xm38_u22.nsg13_hv_pmos[w]
print @n.xbgr.xm38_u22.nsg13_hv_pmos[l]
print @n.xbgr.xm38_u22.nsg13_hv_pmos[delvto]
print @n.xbgr.xm38_u22.nsg13_hv_pmos[factuo]
print @n.xbgr.xm38_u23.nsg13_hv_pmos[w]
print @n.xbgr.xm38_u23.nsg13_hv_pmos[l]
print @n.xbgr.xm38_u23.nsg13_hv_pmos[delvto]
print @n.xbgr.xm38_u23.nsg13_hv_pmos[factuo]
print @n.xbgr.xm38_u24.nsg13_hv_pmos[w]
print @n.xbgr.xm38_u24.nsg13_hv_pmos[l]
print @n.xbgr.xm38_u24.nsg13_hv_pmos[delvto]
print @n.xbgr.xm38_u24.nsg13_hv_pmos[factuo]
print @n.xbgr.xm39_u2.nsg13_hv_pmos[w]
print @n.xbgr.xm39_u2.nsg13_hv_pmos[l]
print @n.xbgr.xm39_u2.nsg13_hv_pmos[delvto]
print @n.xbgr.xm39_u2.nsg13_hv_pmos[factuo]
print @n.xbgr.xm39_u3.nsg13_hv_pmos[w]
print @n.xbgr.xm39_u3.nsg13_hv_pmos[l]
print @n.xbgr.xm39_u3.nsg13_hv_pmos[delvto]
print @n.xbgr.xm39_u3.nsg13_hv_pmos[factuo]
print @n.xbgr.xm39_u4.nsg13_hv_pmos[w]
print @n.xbgr.xm39_u4.nsg13_hv_pmos[l]
print @n.xbgr.xm39_u4.nsg13_hv_pmos[delvto]
print @n.xbgr.xm39_u4.nsg13_hv_pmos[factuo]
print @n.xbgr.xm39_u5.nsg13_hv_pmos[w]
print @n.xbgr.xm39_u5.nsg13_hv_pmos[l]
print @n.xbgr.xm39_u5.nsg13_hv_pmos[delvto]
print @n.xbgr.xm39_u5.nsg13_hv_pmos[factuo]
print @n.xbgr.xm39_u6.nsg13_hv_pmos[w]
print @n.xbgr.xm39_u6.nsg13_hv_pmos[l]
print @n.xbgr.xm39_u6.nsg13_hv_pmos[delvto]
print @n.xbgr.xm39_u6.nsg13_hv_pmos[factuo]
print @n.xbgr.xm39_u7.nsg13_hv_pmos[w]
print @n.xbgr.xm39_u7.nsg13_hv_pmos[l]
print @n.xbgr.xm39_u7.nsg13_hv_pmos[delvto]
print @n.xbgr.xm39_u7.nsg13_hv_pmos[factuo]
print @n.xbgr.xm39_u8.nsg13_hv_pmos[w]
print @n.xbgr.xm39_u8.nsg13_hv_pmos[l]
print @n.xbgr.xm39_u8.nsg13_hv_pmos[delvto]
print @n.xbgr.xm39_u8.nsg13_hv_pmos[factuo]
print @n.xbgr.xm39_u9.nsg13_hv_pmos[w]
print @n.xbgr.xm39_u9.nsg13_hv_pmos[l]
print @n.xbgr.xm39_u9.nsg13_hv_pmos[delvto]
print @n.xbgr.xm39_u9.nsg13_hv_pmos[factuo]
print @n.xbgr.xm39_u10.nsg13_hv_pmos[w]
print @n.xbgr.xm39_u10.nsg13_hv_pmos[l]
print @n.xbgr.xm39_u10.nsg13_hv_pmos[delvto]
print @n.xbgr.xm39_u10.nsg13_hv_pmos[factuo]
print @n.xbgr.xm39_u11.nsg13_hv_pmos[w]
print @n.xbgr.xm39_u11.nsg13_hv_pmos[l]
print @n.xbgr.xm39_u11.nsg13_hv_pmos[delvto]
print @n.xbgr.xm39_u11.nsg13_hv_pmos[factuo]
print @n.xbgr.xm39_u12.nsg13_hv_pmos[w]
print @n.xbgr.xm39_u12.nsg13_hv_pmos[l]
print @n.xbgr.xm39_u12.nsg13_hv_pmos[delvto]
print @n.xbgr.xm39_u12.nsg13_hv_pmos[factuo]
print @n.xbgr.xm39_u13.nsg13_hv_pmos[w]
print @n.xbgr.xm39_u13.nsg13_hv_pmos[l]
print @n.xbgr.xm39_u13.nsg13_hv_pmos[delvto]
print @n.xbgr.xm39_u13.nsg13_hv_pmos[factuo]
print @n.xbgr.xm39_u14.nsg13_hv_pmos[w]
print @n.xbgr.xm39_u14.nsg13_hv_pmos[l]
print @n.xbgr.xm39_u14.nsg13_hv_pmos[delvto]
print @n.xbgr.xm39_u14.nsg13_hv_pmos[factuo]
print @n.xbgr.xm39_u15.nsg13_hv_pmos[w]
print @n.xbgr.xm39_u15.nsg13_hv_pmos[l]
print @n.xbgr.xm39_u15.nsg13_hv_pmos[delvto]
print @n.xbgr.xm39_u15.nsg13_hv_pmos[factuo]
print @n.xbgr.xm39_u16.nsg13_hv_pmos[w]
print @n.xbgr.xm39_u16.nsg13_hv_pmos[l]
print @n.xbgr.xm39_u16.nsg13_hv_pmos[delvto]
print @n.xbgr.xm39_u16.nsg13_hv_pmos[factuo]
print @n.xbgr.xm39_u17.nsg13_hv_pmos[w]
print @n.xbgr.xm39_u17.nsg13_hv_pmos[l]
print @n.xbgr.xm39_u17.nsg13_hv_pmos[delvto]
print @n.xbgr.xm39_u17.nsg13_hv_pmos[factuo]
print @n.xbgr.xm39_u18.nsg13_hv_pmos[w]
print @n.xbgr.xm39_u18.nsg13_hv_pmos[l]
print @n.xbgr.xm39_u18.nsg13_hv_pmos[delvto]
print @n.xbgr.xm39_u18.nsg13_hv_pmos[factuo]
print @n.xbgr.xm39_u19.nsg13_hv_pmos[w]
print @n.xbgr.xm39_u19.nsg13_hv_pmos[l]
print @n.xbgr.xm39_u19.nsg13_hv_pmos[delvto]
print @n.xbgr.xm39_u19.nsg13_hv_pmos[factuo]
print @n.xbgr.xm39_u20.nsg13_hv_pmos[w]
print @n.xbgr.xm39_u20.nsg13_hv_pmos[l]
print @n.xbgr.xm39_u20.nsg13_hv_pmos[delvto]
print @n.xbgr.xm39_u20.nsg13_hv_pmos[factuo]
print @n.xbgr.xm39_u21.nsg13_hv_pmos[w]
print @n.xbgr.xm39_u21.nsg13_hv_pmos[l]
print @n.xbgr.xm39_u21.nsg13_hv_pmos[delvto]
print @n.xbgr.xm39_u21.nsg13_hv_pmos[factuo]
print @n.xbgr.xm39_u22.nsg13_hv_pmos[w]
print @n.xbgr.xm39_u22.nsg13_hv_pmos[l]
print @n.xbgr.xm39_u22.nsg13_hv_pmos[delvto]
print @n.xbgr.xm39_u22.nsg13_hv_pmos[factuo]
print @n.xbgr.xm39_u23.nsg13_hv_pmos[w]
print @n.xbgr.xm39_u23.nsg13_hv_pmos[l]
print @n.xbgr.xm39_u23.nsg13_hv_pmos[delvto]
print @n.xbgr.xm39_u23.nsg13_hv_pmos[factuo]
print @n.xbgr.xm39_u24.nsg13_hv_pmos[w]
print @n.xbgr.xm39_u24.nsg13_hv_pmos[l]
print @n.xbgr.xm39_u24.nsg13_hv_pmos[delvto]
print @n.xbgr.xm39_u24.nsg13_hv_pmos[factuo]
print @n.xbgr.xm41_u2.nsg13_hv_pmos[w]
print @n.xbgr.xm41_u2.nsg13_hv_pmos[l]
print @n.xbgr.xm41_u2.nsg13_hv_pmos[delvto]
print @n.xbgr.xm41_u2.nsg13_hv_pmos[factuo]
print @n.xbgr.xm41_u3.nsg13_hv_pmos[w]
print @n.xbgr.xm41_u3.nsg13_hv_pmos[l]
print @n.xbgr.xm41_u3.nsg13_hv_pmos[delvto]
print @n.xbgr.xm41_u3.nsg13_hv_pmos[factuo]
print @n.xbgr.xm41_u4.nsg13_hv_pmos[w]
print @n.xbgr.xm41_u4.nsg13_hv_pmos[l]
print @n.xbgr.xm41_u4.nsg13_hv_pmos[delvto]
print @n.xbgr.xm41_u4.nsg13_hv_pmos[factuo]
print @n.xbgr.xm41_u5.nsg13_hv_pmos[w]
print @n.xbgr.xm41_u5.nsg13_hv_pmos[l]
print @n.xbgr.xm41_u5.nsg13_hv_pmos[delvto]
print @n.xbgr.xm41_u5.nsg13_hv_pmos[factuo]
print @n.xbgr.xm41_u6.nsg13_hv_pmos[w]
print @n.xbgr.xm41_u6.nsg13_hv_pmos[l]
print @n.xbgr.xm41_u6.nsg13_hv_pmos[delvto]
print @n.xbgr.xm41_u6.nsg13_hv_pmos[factuo]
print @n.xbgr.xm41_u7.nsg13_hv_pmos[w]
print @n.xbgr.xm41_u7.nsg13_hv_pmos[l]
print @n.xbgr.xm41_u7.nsg13_hv_pmos[delvto]
print @n.xbgr.xm41_u7.nsg13_hv_pmos[factuo]
print @n.xbgr.xm41_u8.nsg13_hv_pmos[w]
print @n.xbgr.xm41_u8.nsg13_hv_pmos[l]
print @n.xbgr.xm41_u8.nsg13_hv_pmos[delvto]
print @n.xbgr.xm41_u8.nsg13_hv_pmos[factuo]
print @n.xbgr.xm41_u9.nsg13_hv_pmos[w]
print @n.xbgr.xm41_u9.nsg13_hv_pmos[l]
print @n.xbgr.xm41_u9.nsg13_hv_pmos[delvto]
print @n.xbgr.xm41_u9.nsg13_hv_pmos[factuo]
print @n.xbgr.xm41_u10.nsg13_hv_pmos[w]
print @n.xbgr.xm41_u10.nsg13_hv_pmos[l]
print @n.xbgr.xm41_u10.nsg13_hv_pmos[delvto]
print @n.xbgr.xm41_u10.nsg13_hv_pmos[factuo]
print @n.xbgr.xm41_u11.nsg13_hv_pmos[w]
print @n.xbgr.xm41_u11.nsg13_hv_pmos[l]
print @n.xbgr.xm41_u11.nsg13_hv_pmos[delvto]
print @n.xbgr.xm41_u11.nsg13_hv_pmos[factuo]
print @n.xbgr.xm41_u12.nsg13_hv_pmos[w]
print @n.xbgr.xm41_u12.nsg13_hv_pmos[l]
print @n.xbgr.xm41_u12.nsg13_hv_pmos[delvto]
print @n.xbgr.xm41_u12.nsg13_hv_pmos[factuo]
print @n.xbgr.xm41_u13.nsg13_hv_pmos[w]
print @n.xbgr.xm41_u13.nsg13_hv_pmos[l]
print @n.xbgr.xm41_u13.nsg13_hv_pmos[delvto]
print @n.xbgr.xm41_u13.nsg13_hv_pmos[factuo]
print @n.xbgr.xm41_u14.nsg13_hv_pmos[w]
print @n.xbgr.xm41_u14.nsg13_hv_pmos[l]
print @n.xbgr.xm41_u14.nsg13_hv_pmos[delvto]
print @n.xbgr.xm41_u14.nsg13_hv_pmos[factuo]
print @n.xbgr.xm41_u15.nsg13_hv_pmos[w]
print @n.xbgr.xm41_u15.nsg13_hv_pmos[l]
print @n.xbgr.xm41_u15.nsg13_hv_pmos[delvto]
print @n.xbgr.xm41_u15.nsg13_hv_pmos[factuo]
print @n.xbgr.xm41_u16.nsg13_hv_pmos[w]
print @n.xbgr.xm41_u16.nsg13_hv_pmos[l]
print @n.xbgr.xm41_u16.nsg13_hv_pmos[delvto]
print @n.xbgr.xm41_u16.nsg13_hv_pmos[factuo]
print @n.xbgr.xm41_u17.nsg13_hv_pmos[w]
print @n.xbgr.xm41_u17.nsg13_hv_pmos[l]
print @n.xbgr.xm41_u17.nsg13_hv_pmos[delvto]
print @n.xbgr.xm41_u17.nsg13_hv_pmos[factuo]
print @n.xbgr.xm41_u18.nsg13_hv_pmos[w]
print @n.xbgr.xm41_u18.nsg13_hv_pmos[l]
print @n.xbgr.xm41_u18.nsg13_hv_pmos[delvto]
print @n.xbgr.xm41_u18.nsg13_hv_pmos[factuo]
print @n.xbgr.xm41_u19.nsg13_hv_pmos[w]
print @n.xbgr.xm41_u19.nsg13_hv_pmos[l]
print @n.xbgr.xm41_u19.nsg13_hv_pmos[delvto]
print @n.xbgr.xm41_u19.nsg13_hv_pmos[factuo]
print @n.xbgr.xm41_u20.nsg13_hv_pmos[w]
print @n.xbgr.xm41_u20.nsg13_hv_pmos[l]
print @n.xbgr.xm41_u20.nsg13_hv_pmos[delvto]
print @n.xbgr.xm41_u20.nsg13_hv_pmos[factuo]
print @n.xbgr.xm41_u21.nsg13_hv_pmos[w]
print @n.xbgr.xm41_u21.nsg13_hv_pmos[l]
print @n.xbgr.xm41_u21.nsg13_hv_pmos[delvto]
print @n.xbgr.xm41_u21.nsg13_hv_pmos[factuo]
print @n.xbgr.xm41_u22.nsg13_hv_pmos[w]
print @n.xbgr.xm41_u22.nsg13_hv_pmos[l]
print @n.xbgr.xm41_u22.nsg13_hv_pmos[delvto]
print @n.xbgr.xm41_u22.nsg13_hv_pmos[factuo]
print @n.xbgr.xm41_u23.nsg13_hv_pmos[w]
print @n.xbgr.xm41_u23.nsg13_hv_pmos[l]
print @n.xbgr.xm41_u23.nsg13_hv_pmos[delvto]
print @n.xbgr.xm41_u23.nsg13_hv_pmos[factuo]
print @n.xbgr.xm41_u24.nsg13_hv_pmos[w]
print @n.xbgr.xm41_u24.nsg13_hv_pmos[l]
print @n.xbgr.xm41_u24.nsg13_hv_pmos[delvto]
print @n.xbgr.xm41_u24.nsg13_hv_pmos[factuo]
print @n.xbgr.xm43_u2.nsg13_hv_pmos[w]
print @n.xbgr.xm43_u2.nsg13_hv_pmos[l]
print @n.xbgr.xm43_u2.nsg13_hv_pmos[delvto]
print @n.xbgr.xm43_u2.nsg13_hv_pmos[factuo]
print @n.xbgr.xm43_u3.nsg13_hv_pmos[w]
print @n.xbgr.xm43_u3.nsg13_hv_pmos[l]
print @n.xbgr.xm43_u3.nsg13_hv_pmos[delvto]
print @n.xbgr.xm43_u3.nsg13_hv_pmos[factuo]
print @n.xbgr.xm43_u4.nsg13_hv_pmos[w]
print @n.xbgr.xm43_u4.nsg13_hv_pmos[l]
print @n.xbgr.xm43_u4.nsg13_hv_pmos[delvto]
print @n.xbgr.xm43_u4.nsg13_hv_pmos[factuo]
print @n.xbgr.xm44_u2.nsg13_hv_pmos[w]
print @n.xbgr.xm44_u2.nsg13_hv_pmos[l]
print @n.xbgr.xm44_u2.nsg13_hv_pmos[delvto]
print @n.xbgr.xm44_u2.nsg13_hv_pmos[factuo]
print @n.xbgr.xm44_u3.nsg13_hv_pmos[w]
print @n.xbgr.xm44_u3.nsg13_hv_pmos[l]
print @n.xbgr.xm44_u3.nsg13_hv_pmos[delvto]
print @n.xbgr.xm44_u3.nsg13_hv_pmos[factuo]
print @n.xbgr.xm44_u4.nsg13_hv_pmos[w]
print @n.xbgr.xm44_u4.nsg13_hv_pmos[l]
print @n.xbgr.xm44_u4.nsg13_hv_pmos[delvto]
print @n.xbgr.xm44_u4.nsg13_hv_pmos[factuo]
print @n.xbgr.xm45_u2.nsg13_hv_pmos[w]
print @n.xbgr.xm45_u2.nsg13_hv_pmos[l]
print @n.xbgr.xm45_u2.nsg13_hv_pmos[delvto]
print @n.xbgr.xm45_u2.nsg13_hv_pmos[factuo]
print @n.xbgr.xm45_u3.nsg13_hv_pmos[w]
print @n.xbgr.xm45_u3.nsg13_hv_pmos[l]
print @n.xbgr.xm45_u3.nsg13_hv_pmos[delvto]
print @n.xbgr.xm45_u3.nsg13_hv_pmos[factuo]
print @n.xbgr.xm45_u4.nsg13_hv_pmos[w]
print @n.xbgr.xm45_u4.nsg13_hv_pmos[l]
print @n.xbgr.xm45_u4.nsg13_hv_pmos[delvto]
print @n.xbgr.xm45_u4.nsg13_hv_pmos[factuo]
print @n.xbgr.xm45_u5.nsg13_hv_pmos[w]
print @n.xbgr.xm45_u5.nsg13_hv_pmos[l]
print @n.xbgr.xm45_u5.nsg13_hv_pmos[delvto]
print @n.xbgr.xm45_u5.nsg13_hv_pmos[factuo]
print @n.xbgr.xm45_u6.nsg13_hv_pmos[w]
print @n.xbgr.xm45_u6.nsg13_hv_pmos[l]
print @n.xbgr.xm45_u6.nsg13_hv_pmos[delvto]
print @n.xbgr.xm45_u6.nsg13_hv_pmos[factuo]
print @n.xbgr.xm45_u7.nsg13_hv_pmos[w]
print @n.xbgr.xm45_u7.nsg13_hv_pmos[l]
print @n.xbgr.xm45_u7.nsg13_hv_pmos[delvto]
print @n.xbgr.xm45_u7.nsg13_hv_pmos[factuo]
print @n.xbgr.xm45_u8.nsg13_hv_pmos[w]
print @n.xbgr.xm45_u8.nsg13_hv_pmos[l]
print @n.xbgr.xm45_u8.nsg13_hv_pmos[delvto]
print @n.xbgr.xm45_u8.nsg13_hv_pmos[factuo]
print @n.xbgr.xm45_u9.nsg13_hv_pmos[w]
print @n.xbgr.xm45_u9.nsg13_hv_pmos[l]
print @n.xbgr.xm45_u9.nsg13_hv_pmos[delvto]
print @n.xbgr.xm45_u9.nsg13_hv_pmos[factuo]
print @n.xbgr.xm45_u10.nsg13_hv_pmos[w]
print @n.xbgr.xm45_u10.nsg13_hv_pmos[l]
print @n.xbgr.xm45_u10.nsg13_hv_pmos[delvto]
print @n.xbgr.xm45_u10.nsg13_hv_pmos[factuo]
print @n.xbgr.xm45_u11.nsg13_hv_pmos[w]
print @n.xbgr.xm45_u11.nsg13_hv_pmos[l]
print @n.xbgr.xm45_u11.nsg13_hv_pmos[delvto]
print @n.xbgr.xm45_u11.nsg13_hv_pmos[factuo]
print @n.xbgr.xm45_u12.nsg13_hv_pmos[w]
print @n.xbgr.xm45_u12.nsg13_hv_pmos[l]
print @n.xbgr.xm45_u12.nsg13_hv_pmos[delvto]
print @n.xbgr.xm45_u12.nsg13_hv_pmos[factuo]
print @n.xbgr.xm45_u13.nsg13_hv_pmos[w]
print @n.xbgr.xm45_u13.nsg13_hv_pmos[l]
print @n.xbgr.xm45_u13.nsg13_hv_pmos[delvto]
print @n.xbgr.xm45_u13.nsg13_hv_pmos[factuo]
print @n.xbgr.xm45_u14.nsg13_hv_pmos[w]
print @n.xbgr.xm45_u14.nsg13_hv_pmos[l]
print @n.xbgr.xm45_u14.nsg13_hv_pmos[delvto]
print @n.xbgr.xm45_u14.nsg13_hv_pmos[factuo]
print @n.xbgr.xm45_u15.nsg13_hv_pmos[w]
print @n.xbgr.xm45_u15.nsg13_hv_pmos[l]
print @n.xbgr.xm45_u15.nsg13_hv_pmos[delvto]
print @n.xbgr.xm45_u15.nsg13_hv_pmos[factuo]
print @n.xbgr.xm45_u16.nsg13_hv_pmos[w]
print @n.xbgr.xm45_u16.nsg13_hv_pmos[l]
print @n.xbgr.xm45_u16.nsg13_hv_pmos[delvto]
print @n.xbgr.xm45_u16.nsg13_hv_pmos[factuo]
print @n.xbgr.xm45_u17.nsg13_hv_pmos[w]
print @n.xbgr.xm45_u17.nsg13_hv_pmos[l]
print @n.xbgr.xm45_u17.nsg13_hv_pmos[delvto]
print @n.xbgr.xm45_u17.nsg13_hv_pmos[factuo]
print @n.xbgr.xm45_u18.nsg13_hv_pmos[w]
print @n.xbgr.xm45_u18.nsg13_hv_pmos[l]
print @n.xbgr.xm45_u18.nsg13_hv_pmos[delvto]
print @n.xbgr.xm45_u18.nsg13_hv_pmos[factuo]
print @n.xbgr.xm45_u19.nsg13_hv_pmos[w]
print @n.xbgr.xm45_u19.nsg13_hv_pmos[l]
print @n.xbgr.xm45_u19.nsg13_hv_pmos[delvto]
print @n.xbgr.xm45_u19.nsg13_hv_pmos[factuo]
print @n.xbgr.xm45_u20.nsg13_hv_pmos[w]
print @n.xbgr.xm45_u20.nsg13_hv_pmos[l]
print @n.xbgr.xm45_u20.nsg13_hv_pmos[delvto]
print @n.xbgr.xm45_u20.nsg13_hv_pmos[factuo]
print @n.xbgr.xm45_u21.nsg13_hv_pmos[w]
print @n.xbgr.xm45_u21.nsg13_hv_pmos[l]
print @n.xbgr.xm45_u21.nsg13_hv_pmos[delvto]
print @n.xbgr.xm45_u21.nsg13_hv_pmos[factuo]
print @n.xbgr.xm45_u22.nsg13_hv_pmos[w]
print @n.xbgr.xm45_u22.nsg13_hv_pmos[l]
print @n.xbgr.xm45_u22.nsg13_hv_pmos[delvto]
print @n.xbgr.xm45_u22.nsg13_hv_pmos[factuo]
print @n.xbgr.xm45_u23.nsg13_hv_pmos[w]
print @n.xbgr.xm45_u23.nsg13_hv_pmos[l]
print @n.xbgr.xm45_u23.nsg13_hv_pmos[delvto]
print @n.xbgr.xm45_u23.nsg13_hv_pmos[factuo]
print @n.xbgr.xm45_u24.nsg13_hv_pmos[w]
print @n.xbgr.xm45_u24.nsg13_hv_pmos[l]
print @n.xbgr.xm45_u24.nsg13_hv_pmos[delvto]
print @n.xbgr.xm45_u24.nsg13_hv_pmos[factuo]
print @n.xbgr.xm47_u2.nsg13_hv_pmos[w]
print @n.xbgr.xm47_u2.nsg13_hv_pmos[l]
print @n.xbgr.xm47_u2.nsg13_hv_pmos[delvto]
print @n.xbgr.xm47_u2.nsg13_hv_pmos[factuo]
print @n.xbgr.xm47_u3.nsg13_hv_pmos[w]
print @n.xbgr.xm47_u3.nsg13_hv_pmos[l]
print @n.xbgr.xm47_u3.nsg13_hv_pmos[delvto]
print @n.xbgr.xm47_u3.nsg13_hv_pmos[factuo]
print @n.xbgr.xm47_u4.nsg13_hv_pmos[w]
print @n.xbgr.xm47_u4.nsg13_hv_pmos[l]
print @n.xbgr.xm47_u4.nsg13_hv_pmos[delvto]
print @n.xbgr.xm47_u4.nsg13_hv_pmos[factuo]
print @n.xbgr.xm47_u5.nsg13_hv_pmos[w]
print @n.xbgr.xm47_u5.nsg13_hv_pmos[l]
print @n.xbgr.xm47_u5.nsg13_hv_pmos[delvto]
print @n.xbgr.xm47_u5.nsg13_hv_pmos[factuo]
print @n.xbgr.xm47_u6.nsg13_hv_pmos[w]
print @n.xbgr.xm47_u6.nsg13_hv_pmos[l]
print @n.xbgr.xm47_u6.nsg13_hv_pmos[delvto]
print @n.xbgr.xm47_u6.nsg13_hv_pmos[factuo]
print @n.xbgr.xm47_u7.nsg13_hv_pmos[w]
print @n.xbgr.xm47_u7.nsg13_hv_pmos[l]
print @n.xbgr.xm47_u7.nsg13_hv_pmos[delvto]
print @n.xbgr.xm47_u7.nsg13_hv_pmos[factuo]
print @n.xbgr.xm47_u8.nsg13_hv_pmos[w]
print @n.xbgr.xm47_u8.nsg13_hv_pmos[l]
print @n.xbgr.xm47_u8.nsg13_hv_pmos[delvto]
print @n.xbgr.xm47_u8.nsg13_hv_pmos[factuo]
print @n.xbgr.xm47_u9.nsg13_hv_pmos[w]
print @n.xbgr.xm47_u9.nsg13_hv_pmos[l]
print @n.xbgr.xm47_u9.nsg13_hv_pmos[delvto]
print @n.xbgr.xm47_u9.nsg13_hv_pmos[factuo]
print @n.xbgr.xm47_u10.nsg13_hv_pmos[w]
print @n.xbgr.xm47_u10.nsg13_hv_pmos[l]
print @n.xbgr.xm47_u10.nsg13_hv_pmos[delvto]
print @n.xbgr.xm47_u10.nsg13_hv_pmos[factuo]
print @n.xbgr.xm47_u11.nsg13_hv_pmos[w]
print @n.xbgr.xm47_u11.nsg13_hv_pmos[l]
print @n.xbgr.xm47_u11.nsg13_hv_pmos[delvto]
print @n.xbgr.xm47_u11.nsg13_hv_pmos[factuo]
print @n.xbgr.xm47_u12.nsg13_hv_pmos[w]
print @n.xbgr.xm47_u12.nsg13_hv_pmos[l]
print @n.xbgr.xm47_u12.nsg13_hv_pmos[delvto]
print @n.xbgr.xm47_u12.nsg13_hv_pmos[factuo]
print @n.xbgr.xm47_u13.nsg13_hv_pmos[w]
print @n.xbgr.xm47_u13.nsg13_hv_pmos[l]
print @n.xbgr.xm47_u13.nsg13_hv_pmos[delvto]
print @n.xbgr.xm47_u13.nsg13_hv_pmos[factuo]
print @n.xbgr.xm47_u14.nsg13_hv_pmos[w]
print @n.xbgr.xm47_u14.nsg13_hv_pmos[l]
print @n.xbgr.xm47_u14.nsg13_hv_pmos[delvto]
print @n.xbgr.xm47_u14.nsg13_hv_pmos[factuo]
print @n.xbgr.xm47_u15.nsg13_hv_pmos[w]
print @n.xbgr.xm47_u15.nsg13_hv_pmos[l]
print @n.xbgr.xm47_u15.nsg13_hv_pmos[delvto]
print @n.xbgr.xm47_u15.nsg13_hv_pmos[factuo]
print @n.xbgr.xm47_u16.nsg13_hv_pmos[w]
print @n.xbgr.xm47_u16.nsg13_hv_pmos[l]
print @n.xbgr.xm47_u16.nsg13_hv_pmos[delvto]
print @n.xbgr.xm47_u16.nsg13_hv_pmos[factuo]
print @n.xbgr.xm47_u17.nsg13_hv_pmos[w]
print @n.xbgr.xm47_u17.nsg13_hv_pmos[l]
print @n.xbgr.xm47_u17.nsg13_hv_pmos[delvto]
print @n.xbgr.xm47_u17.nsg13_hv_pmos[factuo]
print @n.xbgr.xm47_u18.nsg13_hv_pmos[w]
print @n.xbgr.xm47_u18.nsg13_hv_pmos[l]
print @n.xbgr.xm47_u18.nsg13_hv_pmos[delvto]
print @n.xbgr.xm47_u18.nsg13_hv_pmos[factuo]
print @n.xbgr.xm47_u19.nsg13_hv_pmos[w]
print @n.xbgr.xm47_u19.nsg13_hv_pmos[l]
print @n.xbgr.xm47_u19.nsg13_hv_pmos[delvto]
print @n.xbgr.xm47_u19.nsg13_hv_pmos[factuo]
print @n.xbgr.xm47_u20.nsg13_hv_pmos[w]
print @n.xbgr.xm47_u20.nsg13_hv_pmos[l]
print @n.xbgr.xm47_u20.nsg13_hv_pmos[delvto]
print @n.xbgr.xm47_u20.nsg13_hv_pmos[factuo]
print @n.xbgr.xm47_u21.nsg13_hv_pmos[w]
print @n.xbgr.xm47_u21.nsg13_hv_pmos[l]
print @n.xbgr.xm47_u21.nsg13_hv_pmos[delvto]
print @n.xbgr.xm47_u21.nsg13_hv_pmos[factuo]
print @n.xbgr.xm47_u22.nsg13_hv_pmos[w]
print @n.xbgr.xm47_u22.nsg13_hv_pmos[l]
print @n.xbgr.xm47_u22.nsg13_hv_pmos[delvto]
print @n.xbgr.xm47_u22.nsg13_hv_pmos[factuo]
print @n.xbgr.xm47_u23.nsg13_hv_pmos[w]
print @n.xbgr.xm47_u23.nsg13_hv_pmos[l]
print @n.xbgr.xm47_u23.nsg13_hv_pmos[delvto]
print @n.xbgr.xm47_u23.nsg13_hv_pmos[factuo]
print @n.xbgr.xm47_u24.nsg13_hv_pmos[w]
print @n.xbgr.xm47_u24.nsg13_hv_pmos[l]
print @n.xbgr.xm47_u24.nsg13_hv_pmos[delvto]
print @n.xbgr.xm47_u24.nsg13_hv_pmos[factuo]
print @n.xbgr.xm48_u2.nsg13_hv_pmos[w]
print @n.xbgr.xm48_u2.nsg13_hv_pmos[l]
print @n.xbgr.xm48_u2.nsg13_hv_pmos[delvto]
print @n.xbgr.xm48_u2.nsg13_hv_pmos[factuo]
print @n.xbgr.xm48_u3.nsg13_hv_pmos[w]
print @n.xbgr.xm48_u3.nsg13_hv_pmos[l]
print @n.xbgr.xm48_u3.nsg13_hv_pmos[delvto]
print @n.xbgr.xm48_u3.nsg13_hv_pmos[factuo]
print @n.xbgr.xm48_u4.nsg13_hv_pmos[w]
print @n.xbgr.xm48_u4.nsg13_hv_pmos[l]
print @n.xbgr.xm48_u4.nsg13_hv_pmos[delvto]
print @n.xbgr.xm48_u4.nsg13_hv_pmos[factuo]
print @n.xbgr.xm48_u5.nsg13_hv_pmos[w]
print @n.xbgr.xm48_u5.nsg13_hv_pmos[l]
print @n.xbgr.xm48_u5.nsg13_hv_pmos[delvto]
print @n.xbgr.xm48_u5.nsg13_hv_pmos[factuo]
print @n.xbgr.xm48_u6.nsg13_hv_pmos[w]
print @n.xbgr.xm48_u6.nsg13_hv_pmos[l]
print @n.xbgr.xm48_u6.nsg13_hv_pmos[delvto]
print @n.xbgr.xm48_u6.nsg13_hv_pmos[factuo]
print @n.xbgr.xm48_u7.nsg13_hv_pmos[w]
print @n.xbgr.xm48_u7.nsg13_hv_pmos[l]
print @n.xbgr.xm48_u7.nsg13_hv_pmos[delvto]
print @n.xbgr.xm48_u7.nsg13_hv_pmos[factuo]
print @n.xbgr.xm48_u8.nsg13_hv_pmos[w]
print @n.xbgr.xm48_u8.nsg13_hv_pmos[l]
print @n.xbgr.xm48_u8.nsg13_hv_pmos[delvto]
print @n.xbgr.xm48_u8.nsg13_hv_pmos[factuo]
print @n.xbgr.xm48_u9.nsg13_hv_pmos[w]
print @n.xbgr.xm48_u9.nsg13_hv_pmos[l]
print @n.xbgr.xm48_u9.nsg13_hv_pmos[delvto]
print @n.xbgr.xm48_u9.nsg13_hv_pmos[factuo]
print @n.xbgr.xm48_u10.nsg13_hv_pmos[w]
print @n.xbgr.xm48_u10.nsg13_hv_pmos[l]
print @n.xbgr.xm48_u10.nsg13_hv_pmos[delvto]
print @n.xbgr.xm48_u10.nsg13_hv_pmos[factuo]
print @n.xbgr.xm48_u11.nsg13_hv_pmos[w]
print @n.xbgr.xm48_u11.nsg13_hv_pmos[l]
print @n.xbgr.xm48_u11.nsg13_hv_pmos[delvto]
print @n.xbgr.xm48_u11.nsg13_hv_pmos[factuo]
print @n.xbgr.xm48_u12.nsg13_hv_pmos[w]
print @n.xbgr.xm48_u12.nsg13_hv_pmos[l]
print @n.xbgr.xm48_u12.nsg13_hv_pmos[delvto]
print @n.xbgr.xm48_u12.nsg13_hv_pmos[factuo]
print @n.xbgr.xm48_u13.nsg13_hv_pmos[w]
print @n.xbgr.xm48_u13.nsg13_hv_pmos[l]
print @n.xbgr.xm48_u13.nsg13_hv_pmos[delvto]
print @n.xbgr.xm48_u13.nsg13_hv_pmos[factuo]
print @n.xbgr.xm48_u14.nsg13_hv_pmos[w]
print @n.xbgr.xm48_u14.nsg13_hv_pmos[l]
print @n.xbgr.xm48_u14.nsg13_hv_pmos[delvto]
print @n.xbgr.xm48_u14.nsg13_hv_pmos[factuo]
print @n.xbgr.xm48_u15.nsg13_hv_pmos[w]
print @n.xbgr.xm48_u15.nsg13_hv_pmos[l]
print @n.xbgr.xm48_u15.nsg13_hv_pmos[delvto]
print @n.xbgr.xm48_u15.nsg13_hv_pmos[factuo]
print @n.xbgr.xm48_u16.nsg13_hv_pmos[w]
print @n.xbgr.xm48_u16.nsg13_hv_pmos[l]
print @n.xbgr.xm48_u16.nsg13_hv_pmos[delvto]
print @n.xbgr.xm48_u16.nsg13_hv_pmos[factuo]
print @n.xbgr.xm48_u17.nsg13_hv_pmos[w]
print @n.xbgr.xm48_u17.nsg13_hv_pmos[l]
print @n.xbgr.xm48_u17.nsg13_hv_pmos[delvto]
print @n.xbgr.xm48_u17.nsg13_hv_pmos[factuo]
print @n.xbgr.xm48_u18.nsg13_hv_pmos[w]
print @n.xbgr.xm48_u18.nsg13_hv_pmos[l]
print @n.xbgr.xm48_u18.nsg13_hv_pmos[delvto]
print @n.xbgr.xm48_u18.nsg13_hv_pmos[factuo]
print @n.xbgr.xm48_u19.nsg13_hv_pmos[w]
print @n.xbgr.xm48_u19.nsg13_hv_pmos[l]
print @n.xbgr.xm48_u19.nsg13_hv_pmos[delvto]
print @n.xbgr.xm48_u19.nsg13_hv_pmos[factuo]
print @n.xbgr.xm48_u20.nsg13_hv_pmos[w]
print @n.xbgr.xm48_u20.nsg13_hv_pmos[l]
print @n.xbgr.xm48_u20.nsg13_hv_pmos[delvto]
print @n.xbgr.xm48_u20.nsg13_hv_pmos[factuo]
print @n.xbgr.xm48_u21.nsg13_hv_pmos[w]
print @n.xbgr.xm48_u21.nsg13_hv_pmos[l]
print @n.xbgr.xm48_u21.nsg13_hv_pmos[delvto]
print @n.xbgr.xm48_u21.nsg13_hv_pmos[factuo]
print @n.xbgr.xm48_u22.nsg13_hv_pmos[w]
print @n.xbgr.xm48_u22.nsg13_hv_pmos[l]
print @n.xbgr.xm48_u22.nsg13_hv_pmos[delvto]
print @n.xbgr.xm48_u22.nsg13_hv_pmos[factuo]
print @n.xbgr.xm48_u23.nsg13_hv_pmos[w]
print @n.xbgr.xm48_u23.nsg13_hv_pmos[l]
print @n.xbgr.xm48_u23.nsg13_hv_pmos[delvto]
print @n.xbgr.xm48_u23.nsg13_hv_pmos[factuo]
print @n.xbgr.xm48_u24.nsg13_hv_pmos[w]
print @n.xbgr.xm48_u24.nsg13_hv_pmos[l]
print @n.xbgr.xm48_u24.nsg13_hv_pmos[delvto]
print @n.xbgr.xm48_u24.nsg13_hv_pmos[factuo]
print @n.xbgr.xm50_u2.nsg13_hv_pmos[w]
print @n.xbgr.xm50_u2.nsg13_hv_pmos[l]
print @n.xbgr.xm50_u2.nsg13_hv_pmos[delvto]
print @n.xbgr.xm50_u2.nsg13_hv_pmos[factuo]
print @n.xbgr.xm50_u3.nsg13_hv_pmos[w]
print @n.xbgr.xm50_u3.nsg13_hv_pmos[l]
print @n.xbgr.xm50_u3.nsg13_hv_pmos[delvto]
print @n.xbgr.xm50_u3.nsg13_hv_pmos[factuo]
print @n.xbgr.xm50_u4.nsg13_hv_pmos[w]
print @n.xbgr.xm50_u4.nsg13_hv_pmos[l]
print @n.xbgr.xm50_u4.nsg13_hv_pmos[delvto]
print @n.xbgr.xm50_u4.nsg13_hv_pmos[factuo]
print @n.xbgr.xm50_u5.nsg13_hv_pmos[w]
print @n.xbgr.xm50_u5.nsg13_hv_pmos[l]
print @n.xbgr.xm50_u5.nsg13_hv_pmos[delvto]
print @n.xbgr.xm50_u5.nsg13_hv_pmos[factuo]
print @n.xbgr.xm50_u6.nsg13_hv_pmos[w]
print @n.xbgr.xm50_u6.nsg13_hv_pmos[l]
print @n.xbgr.xm50_u6.nsg13_hv_pmos[delvto]
print @n.xbgr.xm50_u6.nsg13_hv_pmos[factuo]
print @n.xbgr.xm50_u7.nsg13_hv_pmos[w]
print @n.xbgr.xm50_u7.nsg13_hv_pmos[l]
print @n.xbgr.xm50_u7.nsg13_hv_pmos[delvto]
print @n.xbgr.xm50_u7.nsg13_hv_pmos[factuo]
print @n.xbgr.xm50_u8.nsg13_hv_pmos[w]
print @n.xbgr.xm50_u8.nsg13_hv_pmos[l]
print @n.xbgr.xm50_u8.nsg13_hv_pmos[delvto]
print @n.xbgr.xm50_u8.nsg13_hv_pmos[factuo]
print @n.xbgr.xm50_u9.nsg13_hv_pmos[w]
print @n.xbgr.xm50_u9.nsg13_hv_pmos[l]
print @n.xbgr.xm50_u9.nsg13_hv_pmos[delvto]
print @n.xbgr.xm50_u9.nsg13_hv_pmos[factuo]
print @n.xbgr.xm50_u10.nsg13_hv_pmos[w]
print @n.xbgr.xm50_u10.nsg13_hv_pmos[l]
print @n.xbgr.xm50_u10.nsg13_hv_pmos[delvto]
print @n.xbgr.xm50_u10.nsg13_hv_pmos[factuo]
print @n.xbgr.xm50_u11.nsg13_hv_pmos[w]
print @n.xbgr.xm50_u11.nsg13_hv_pmos[l]
print @n.xbgr.xm50_u11.nsg13_hv_pmos[delvto]
print @n.xbgr.xm50_u11.nsg13_hv_pmos[factuo]
print @n.xbgr.xm50_u12.nsg13_hv_pmos[w]
print @n.xbgr.xm50_u12.nsg13_hv_pmos[l]
print @n.xbgr.xm50_u12.nsg13_hv_pmos[delvto]
print @n.xbgr.xm50_u12.nsg13_hv_pmos[factuo]
print @n.xbgr.xm50_u13.nsg13_hv_pmos[w]
print @n.xbgr.xm50_u13.nsg13_hv_pmos[l]
print @n.xbgr.xm50_u13.nsg13_hv_pmos[delvto]
print @n.xbgr.xm50_u13.nsg13_hv_pmos[factuo]
print @n.xbgr.xm50_u14.nsg13_hv_pmos[w]
print @n.xbgr.xm50_u14.nsg13_hv_pmos[l]
print @n.xbgr.xm50_u14.nsg13_hv_pmos[delvto]
print @n.xbgr.xm50_u14.nsg13_hv_pmos[factuo]
print @n.xbgr.xm50_u15.nsg13_hv_pmos[w]
print @n.xbgr.xm50_u15.nsg13_hv_pmos[l]
print @n.xbgr.xm50_u15.nsg13_hv_pmos[delvto]
print @n.xbgr.xm50_u15.nsg13_hv_pmos[factuo]
print @n.xbgr.xm50_u16.nsg13_hv_pmos[w]
print @n.xbgr.xm50_u16.nsg13_hv_pmos[l]
print @n.xbgr.xm50_u16.nsg13_hv_pmos[delvto]
print @n.xbgr.xm50_u16.nsg13_hv_pmos[factuo]
print @n.xbgr.xm50_u17.nsg13_hv_pmos[w]
print @n.xbgr.xm50_u17.nsg13_hv_pmos[l]
print @n.xbgr.xm50_u17.nsg13_hv_pmos[delvto]
print @n.xbgr.xm50_u17.nsg13_hv_pmos[factuo]
print @n.xbgr.xm50_u18.nsg13_hv_pmos[w]
print @n.xbgr.xm50_u18.nsg13_hv_pmos[l]
print @n.xbgr.xm50_u18.nsg13_hv_pmos[delvto]
print @n.xbgr.xm50_u18.nsg13_hv_pmos[factuo]
print @n.xbgr.xm50_u19.nsg13_hv_pmos[w]
print @n.xbgr.xm50_u19.nsg13_hv_pmos[l]
print @n.xbgr.xm50_u19.nsg13_hv_pmos[delvto]
print @n.xbgr.xm50_u19.nsg13_hv_pmos[factuo]
print @n.xbgr.xm50_u20.nsg13_hv_pmos[w]
print @n.xbgr.xm50_u20.nsg13_hv_pmos[l]
print @n.xbgr.xm50_u20.nsg13_hv_pmos[delvto]
print @n.xbgr.xm50_u20.nsg13_hv_pmos[factuo]
print @n.xbgr.xm50_u21.nsg13_hv_pmos[w]
print @n.xbgr.xm50_u21.nsg13_hv_pmos[l]
print @n.xbgr.xm50_u21.nsg13_hv_pmos[delvto]
print @n.xbgr.xm50_u21.nsg13_hv_pmos[factuo]
print @n.xbgr.xm50_u22.nsg13_hv_pmos[w]
print @n.xbgr.xm50_u22.nsg13_hv_pmos[l]
print @n.xbgr.xm50_u22.nsg13_hv_pmos[delvto]
print @n.xbgr.xm50_u22.nsg13_hv_pmos[factuo]
print @n.xbgr.xm50_u23.nsg13_hv_pmos[w]
print @n.xbgr.xm50_u23.nsg13_hv_pmos[l]
print @n.xbgr.xm50_u23.nsg13_hv_pmos[delvto]
print @n.xbgr.xm50_u23.nsg13_hv_pmos[factuo]
print @n.xbgr.xm50_u24.nsg13_hv_pmos[w]
print @n.xbgr.xm50_u24.nsg13_hv_pmos[l]
print @n.xbgr.xm50_u24.nsg13_hv_pmos[delvto]
print @n.xbgr.xm50_u24.nsg13_hv_pmos[factuo]
print @n.xbgr.xm51_u2.nsg13_hv_pmos[w]
print @n.xbgr.xm51_u2.nsg13_hv_pmos[l]
print @n.xbgr.xm51_u2.nsg13_hv_pmos[delvto]
print @n.xbgr.xm51_u2.nsg13_hv_pmos[factuo]
print @n.xbgr.xm51_u3.nsg13_hv_pmos[w]
print @n.xbgr.xm51_u3.nsg13_hv_pmos[l]
print @n.xbgr.xm51_u3.nsg13_hv_pmos[delvto]
print @n.xbgr.xm51_u3.nsg13_hv_pmos[factuo]
print @n.xbgr.xm51_u4.nsg13_hv_pmos[w]
print @n.xbgr.xm51_u4.nsg13_hv_pmos[l]
print @n.xbgr.xm51_u4.nsg13_hv_pmos[delvto]
print @n.xbgr.xm51_u4.nsg13_hv_pmos[factuo]
print @n.xbgr.xm52_u2.nsg13_hv_pmos[w]
print @n.xbgr.xm52_u2.nsg13_hv_pmos[l]
print @n.xbgr.xm52_u2.nsg13_hv_pmos[delvto]
print @n.xbgr.xm52_u2.nsg13_hv_pmos[factuo]
print @n.xbgr.xm52_u3.nsg13_hv_pmos[w]
print @n.xbgr.xm52_u3.nsg13_hv_pmos[l]
print @n.xbgr.xm52_u3.nsg13_hv_pmos[delvto]
print @n.xbgr.xm52_u3.nsg13_hv_pmos[factuo]
print @n.xbgr.xm52_u4.nsg13_hv_pmos[w]
print @n.xbgr.xm52_u4.nsg13_hv_pmos[l]
print @n.xbgr.xm52_u4.nsg13_hv_pmos[delvto]
print @n.xbgr.xm52_u4.nsg13_hv_pmos[factuo]
print @n.xbgr.xm52_u5.nsg13_hv_pmos[w]
print @n.xbgr.xm52_u5.nsg13_hv_pmos[l]
print @n.xbgr.xm52_u5.nsg13_hv_pmos[delvto]
print @n.xbgr.xm52_u5.nsg13_hv_pmos[factuo]
print @n.xbgr.xm52_u6.nsg13_hv_pmos[w]
print @n.xbgr.xm52_u6.nsg13_hv_pmos[l]
print @n.xbgr.xm52_u6.nsg13_hv_pmos[delvto]
print @n.xbgr.xm52_u6.nsg13_hv_pmos[factuo]
print @n.xbgr.xm52_u7.nsg13_hv_pmos[w]
print @n.xbgr.xm52_u7.nsg13_hv_pmos[l]
print @n.xbgr.xm52_u7.nsg13_hv_pmos[delvto]
print @n.xbgr.xm52_u7.nsg13_hv_pmos[factuo]
print @n.xbgr.xm52_u8.nsg13_hv_pmos[w]
print @n.xbgr.xm52_u8.nsg13_hv_pmos[l]
print @n.xbgr.xm52_u8.nsg13_hv_pmos[delvto]
print @n.xbgr.xm52_u8.nsg13_hv_pmos[factuo]
print @n.xbgr.xm52_u9.nsg13_hv_pmos[w]
print @n.xbgr.xm52_u9.nsg13_hv_pmos[l]
print @n.xbgr.xm52_u9.nsg13_hv_pmos[delvto]
print @n.xbgr.xm52_u9.nsg13_hv_pmos[factuo]
print @n.xbgr.xm52_u10.nsg13_hv_pmos[w]
print @n.xbgr.xm52_u10.nsg13_hv_pmos[l]
print @n.xbgr.xm52_u10.nsg13_hv_pmos[delvto]
print @n.xbgr.xm52_u10.nsg13_hv_pmos[factuo]
print @n.xbgr.xm52_u11.nsg13_hv_pmos[w]
print @n.xbgr.xm52_u11.nsg13_hv_pmos[l]
print @n.xbgr.xm52_u11.nsg13_hv_pmos[delvto]
print @n.xbgr.xm52_u11.nsg13_hv_pmos[factuo]
print @n.xbgr.xm52_u12.nsg13_hv_pmos[w]
print @n.xbgr.xm52_u12.nsg13_hv_pmos[l]
print @n.xbgr.xm52_u12.nsg13_hv_pmos[delvto]
print @n.xbgr.xm52_u12.nsg13_hv_pmos[factuo]
print @n.xbgr.xm52_u13.nsg13_hv_pmos[w]
print @n.xbgr.xm52_u13.nsg13_hv_pmos[l]
print @n.xbgr.xm52_u13.nsg13_hv_pmos[delvto]
print @n.xbgr.xm52_u13.nsg13_hv_pmos[factuo]
print @n.xbgr.xm52_u14.nsg13_hv_pmos[w]
print @n.xbgr.xm52_u14.nsg13_hv_pmos[l]
print @n.xbgr.xm52_u14.nsg13_hv_pmos[delvto]
print @n.xbgr.xm52_u14.nsg13_hv_pmos[factuo]
print @n.xbgr.xm52_u15.nsg13_hv_pmos[w]
print @n.xbgr.xm52_u15.nsg13_hv_pmos[l]
print @n.xbgr.xm52_u15.nsg13_hv_pmos[delvto]
print @n.xbgr.xm52_u15.nsg13_hv_pmos[factuo]
print @n.xbgr.xm52_u16.nsg13_hv_pmos[w]
print @n.xbgr.xm52_u16.nsg13_hv_pmos[l]
print @n.xbgr.xm52_u16.nsg13_hv_pmos[delvto]
print @n.xbgr.xm52_u16.nsg13_hv_pmos[factuo]
print @n.xbgr.xm52_u17.nsg13_hv_pmos[w]
print @n.xbgr.xm52_u17.nsg13_hv_pmos[l]
print @n.xbgr.xm52_u17.nsg13_hv_pmos[delvto]
print @n.xbgr.xm52_u17.nsg13_hv_pmos[factuo]
print @n.xbgr.xm52_u18.nsg13_hv_pmos[w]
print @n.xbgr.xm52_u18.nsg13_hv_pmos[l]
print @n.xbgr.xm52_u18.nsg13_hv_pmos[delvto]
print @n.xbgr.xm52_u18.nsg13_hv_pmos[factuo]
print @n.xbgr.xm52_u19.nsg13_hv_pmos[w]
print @n.xbgr.xm52_u19.nsg13_hv_pmos[l]
print @n.xbgr.xm52_u19.nsg13_hv_pmos[delvto]
print @n.xbgr.xm52_u19.nsg13_hv_pmos[factuo]
print @n.xbgr.xm52_u20.nsg13_hv_pmos[w]
print @n.xbgr.xm52_u20.nsg13_hv_pmos[l]
print @n.xbgr.xm52_u20.nsg13_hv_pmos[delvto]
print @n.xbgr.xm52_u20.nsg13_hv_pmos[factuo]
print @n.xbgr.xm52_u21.nsg13_hv_pmos[w]
print @n.xbgr.xm52_u21.nsg13_hv_pmos[l]
print @n.xbgr.xm52_u21.nsg13_hv_pmos[delvto]
print @n.xbgr.xm52_u21.nsg13_hv_pmos[factuo]
print @n.xbgr.xm52_u22.nsg13_hv_pmos[w]
print @n.xbgr.xm52_u22.nsg13_hv_pmos[l]
print @n.xbgr.xm52_u22.nsg13_hv_pmos[delvto]
print @n.xbgr.xm52_u22.nsg13_hv_pmos[factuo]
print @n.xbgr.xm52_u23.nsg13_hv_pmos[w]
print @n.xbgr.xm52_u23.nsg13_hv_pmos[l]
print @n.xbgr.xm52_u23.nsg13_hv_pmos[delvto]
print @n.xbgr.xm52_u23.nsg13_hv_pmos[factuo]
print @n.xbgr.xm52_u24.nsg13_hv_pmos[w]
print @n.xbgr.xm52_u24.nsg13_hv_pmos[l]
print @n.xbgr.xm52_u24.nsg13_hv_pmos[delvto]
print @n.xbgr.xm52_u24.nsg13_hv_pmos[factuo]
print @n.xbgr.xm54_u2.nsg13_hv_pmos[w]
print @n.xbgr.xm54_u2.nsg13_hv_pmos[l]
print @n.xbgr.xm54_u2.nsg13_hv_pmos[delvto]
print @n.xbgr.xm54_u2.nsg13_hv_pmos[factuo]
print @n.xbgr.xm54_u3.nsg13_hv_pmos[w]
print @n.xbgr.xm54_u3.nsg13_hv_pmos[l]
print @n.xbgr.xm54_u3.nsg13_hv_pmos[delvto]
print @n.xbgr.xm54_u3.nsg13_hv_pmos[factuo]
print @n.xbgr.xm54_u4.nsg13_hv_pmos[w]
print @n.xbgr.xm54_u4.nsg13_hv_pmos[l]
print @n.xbgr.xm54_u4.nsg13_hv_pmos[delvto]
print @n.xbgr.xm54_u4.nsg13_hv_pmos[factuo]
print @n.xbgr.xm54_u5.nsg13_hv_pmos[w]
print @n.xbgr.xm54_u5.nsg13_hv_pmos[l]
print @n.xbgr.xm54_u5.nsg13_hv_pmos[delvto]
print @n.xbgr.xm54_u5.nsg13_hv_pmos[factuo]
print @n.xbgr.xm54_u6.nsg13_hv_pmos[w]
print @n.xbgr.xm54_u6.nsg13_hv_pmos[l]
print @n.xbgr.xm54_u6.nsg13_hv_pmos[delvto]
print @n.xbgr.xm54_u6.nsg13_hv_pmos[factuo]
print @n.xbgr.xm54_u7.nsg13_hv_pmos[w]
print @n.xbgr.xm54_u7.nsg13_hv_pmos[l]
print @n.xbgr.xm54_u7.nsg13_hv_pmos[delvto]
print @n.xbgr.xm54_u7.nsg13_hv_pmos[factuo]
print @n.xbgr.xm54_u8.nsg13_hv_pmos[w]
print @n.xbgr.xm54_u8.nsg13_hv_pmos[l]
print @n.xbgr.xm54_u8.nsg13_hv_pmos[delvto]
print @n.xbgr.xm54_u8.nsg13_hv_pmos[factuo]
print @n.xbgr.xm54_u9.nsg13_hv_pmos[w]
print @n.xbgr.xm54_u9.nsg13_hv_pmos[l]
print @n.xbgr.xm54_u9.nsg13_hv_pmos[delvto]
print @n.xbgr.xm54_u9.nsg13_hv_pmos[factuo]
print @n.xbgr.xm54_u10.nsg13_hv_pmos[w]
print @n.xbgr.xm54_u10.nsg13_hv_pmos[l]
print @n.xbgr.xm54_u10.nsg13_hv_pmos[delvto]
print @n.xbgr.xm54_u10.nsg13_hv_pmos[factuo]
print @n.xbgr.xm54_u11.nsg13_hv_pmos[w]
print @n.xbgr.xm54_u11.nsg13_hv_pmos[l]
print @n.xbgr.xm54_u11.nsg13_hv_pmos[delvto]
print @n.xbgr.xm54_u11.nsg13_hv_pmos[factuo]
print @n.xbgr.xm54_u12.nsg13_hv_pmos[w]
print @n.xbgr.xm54_u12.nsg13_hv_pmos[l]
print @n.xbgr.xm54_u12.nsg13_hv_pmos[delvto]
print @n.xbgr.xm54_u12.nsg13_hv_pmos[factuo]
print @n.xbgr.xm54_u13.nsg13_hv_pmos[w]
print @n.xbgr.xm54_u13.nsg13_hv_pmos[l]
print @n.xbgr.xm54_u13.nsg13_hv_pmos[delvto]
print @n.xbgr.xm54_u13.nsg13_hv_pmos[factuo]
print @n.xbgr.xm54_u14.nsg13_hv_pmos[w]
print @n.xbgr.xm54_u14.nsg13_hv_pmos[l]
print @n.xbgr.xm54_u14.nsg13_hv_pmos[delvto]
print @n.xbgr.xm54_u14.nsg13_hv_pmos[factuo]
print @n.xbgr.xm54_u15.nsg13_hv_pmos[w]
print @n.xbgr.xm54_u15.nsg13_hv_pmos[l]
print @n.xbgr.xm54_u15.nsg13_hv_pmos[delvto]
print @n.xbgr.xm54_u15.nsg13_hv_pmos[factuo]
print @n.xbgr.xm54_u16.nsg13_hv_pmos[w]
print @n.xbgr.xm54_u16.nsg13_hv_pmos[l]
print @n.xbgr.xm54_u16.nsg13_hv_pmos[delvto]
print @n.xbgr.xm54_u16.nsg13_hv_pmos[factuo]
print @n.xbgr.xm54_u17.nsg13_hv_pmos[w]
print @n.xbgr.xm54_u17.nsg13_hv_pmos[l]
print @n.xbgr.xm54_u17.nsg13_hv_pmos[delvto]
print @n.xbgr.xm54_u17.nsg13_hv_pmos[factuo]
print @n.xbgr.xm54_u18.nsg13_hv_pmos[w]
print @n.xbgr.xm54_u18.nsg13_hv_pmos[l]
print @n.xbgr.xm54_u18.nsg13_hv_pmos[delvto]
print @n.xbgr.xm54_u18.nsg13_hv_pmos[factuo]
print @n.xbgr.xm54_u19.nsg13_hv_pmos[w]
print @n.xbgr.xm54_u19.nsg13_hv_pmos[l]
print @n.xbgr.xm54_u19.nsg13_hv_pmos[delvto]
print @n.xbgr.xm54_u19.nsg13_hv_pmos[factuo]
print @n.xbgr.xm54_u20.nsg13_hv_pmos[w]
print @n.xbgr.xm54_u20.nsg13_hv_pmos[l]
print @n.xbgr.xm54_u20.nsg13_hv_pmos[delvto]
print @n.xbgr.xm54_u20.nsg13_hv_pmos[factuo]
print @n.xbgr.xm54_u21.nsg13_hv_pmos[w]
print @n.xbgr.xm54_u21.nsg13_hv_pmos[l]
print @n.xbgr.xm54_u21.nsg13_hv_pmos[delvto]
print @n.xbgr.xm54_u21.nsg13_hv_pmos[factuo]
print @n.xbgr.xm54_u22.nsg13_hv_pmos[w]
print @n.xbgr.xm54_u22.nsg13_hv_pmos[l]
print @n.xbgr.xm54_u22.nsg13_hv_pmos[delvto]
print @n.xbgr.xm54_u22.nsg13_hv_pmos[factuo]
print @n.xbgr.xm54_u23.nsg13_hv_pmos[w]
print @n.xbgr.xm54_u23.nsg13_hv_pmos[l]
print @n.xbgr.xm54_u23.nsg13_hv_pmos[delvto]
print @n.xbgr.xm54_u23.nsg13_hv_pmos[factuo]
print @n.xbgr.xm54_u24.nsg13_hv_pmos[w]
print @n.xbgr.xm54_u24.nsg13_hv_pmos[l]
print @n.xbgr.xm54_u24.nsg13_hv_pmos[delvto]
print @n.xbgr.xm54_u24.nsg13_hv_pmos[factuo]
print @q.xbgr.xq56_u2.qnpn13g2[area]
print @q.xbgr.xq56_u3.qnpn13g2[area]
print @q.xbgr.xq56_u4.qnpn13g2[area]
print @q.xbgr.xq56_u5.qnpn13g2[area]
print @q.xbgr.xq56_u6.qnpn13g2[area]
print @q.xbgr.xq56_u7.qnpn13g2[area]
print @q.xbgr.xq56_u8.qnpn13g2[area]
print @q.xbgr.xq56_u9.qnpn13g2[area]
print @q.xbgr.xq56_u10.qnpn13g2[area]
print @q.xbgr.xq56_u11.qnpn13g2[area]
print @q.xbgr.xq56_u12.qnpn13g2[area]
print @q.xbgr.xq56_u13.qnpn13g2[area]
print @q.xbgr.xq56_u14.qnpn13g2[area]
print @q.xbgr.xq56_u15.qnpn13g2[area]
print @q.xbgr.xq56_u16.qnpn13g2[area]
print @q.xbgr.xq56_u17.qnpn13g2[area]
print @q.xbgr.xq56_u18.qnpn13g2[area]
print @q.xbgr.xq56_u19.qnpn13g2[area]
print @q.xbgr.xq56_u20.qnpn13g2[area]
print @q.xbgr.xq56_u21.qnpn13g2[area]
print @q.xbgr.xq56_u22.qnpn13g2[area]
print @q.xbgr.xq56_u23.qnpn13g2[area]
print @q.xbgr.xq56_u24.qnpn13g2[area]
print @q.xbgr.xq60_u2.qnpn13g2[area]
print @q.xbgr.xq60_u3.qnpn13g2[area]
print @q.xbgr.xq60_u4.qnpn13g2[area]
print @q.xbgr.xq62_u2.qnpn13g2[area]
print @q.xbgr.xq62_u3.qnpn13g2[area]
print @q.xbgr.xq62_u4.qnpn13g2[area]
print @q.xbgr.xq62_u5.qnpn13g2[area]
print @q.xbgr.xq62_u6.qnpn13g2[area]
print @q.xbgr.xq62_u7.qnpn13g2[area]
print @q.xbgr.xq62_u8.qnpn13g2[area]
print @q.xbgr.xq62_u9.qnpn13g2[area]
print @q.xbgr.xq62_u10.qnpn13g2[area]
print @q.xbgr.xq62_u11.qnpn13g2[area]
print @q.xbgr.xq62_u12.qnpn13g2[area]
print @q.xbgr.xq62_u13.qnpn13g2[area]
print @q.xbgr.xq62_u14.qnpn13g2[area]
print @q.xbgr.xq62_u15.qnpn13g2[area]
print @q.xbgr.xq62_u16.qnpn13g2[area]
print @q.xbgr.xq62_u17.qnpn13g2[area]
print @q.xbgr.xq62_u18.qnpn13g2[area]
print @q.xbgr.xq62_u19.qnpn13g2[area]
print @q.xbgr.xq62_u20.qnpn13g2[area]
print @q.xbgr.xq62_u21.qnpn13g2[area]
print @q.xbgr.xq62_u22.qnpn13g2[area]
print @q.xbgr.xq62_u23.qnpn13g2[area]
print @q.xbgr.xq62_u24.qnpn13g2[area]
print @q.xbgr.xq67_u2.qnpn13g2[area]
print @q.xbgr.xq67_u3.qnpn13g2[area]
print @q.xbgr.xq67_u4.qnpn13g2[area]
print @q.xbgr.xq67_u5.qnpn13g2[area]
print @q.xbgr.xq67_u6.qnpn13g2[area]
print @q.xbgr.xq67_u7.qnpn13g2[area]
print @q.xbgr.xq67_u8.qnpn13g2[area]
print @q.xbgr.xq67_u9.qnpn13g2[area]
print @q.xbgr.xq67_u10.qnpn13g2[area]
print @q.xbgr.xq67_u11.qnpn13g2[area]
print @q.xbgr.xq67_u12.qnpn13g2[area]
print @q.xbgr.xq67_u13.qnpn13g2[area]
print @q.xbgr.xq67_u14.qnpn13g2[area]
print @q.xbgr.xq67_u15.qnpn13g2[area]
print @q.xbgr.xq67_u16.qnpn13g2[area]
print @q.xbgr.xq67_u17.qnpn13g2[area]
print @q.xbgr.xq67_u18.qnpn13g2[area]
print @q.xbgr.xq67_u19.qnpn13g2[area]
print @q.xbgr.xq67_u20.qnpn13g2[area]
print @q.xbgr.xq67_u21.qnpn13g2[area]
print @q.xbgr.xq67_u22.qnpn13g2[area]
print @q.xbgr.xq67_u23.qnpn13g2[area]
print @q.xbgr.xq67_u24.qnpn13g2[area]
print @q.xbgr.xq68_u2.qnpn13g2[area]
print @q.xbgr.xq68_u3.qnpn13g2[area]
print @q.xbgr.xq68_u4.qnpn13g2[area]
print @q.xbgr.xq68_u5.qnpn13g2[area]
print @q.xbgr.xq68_u6.qnpn13g2[area]
print @q.xbgr.xq68_u7.qnpn13g2[area]
print @q.xbgr.xq68_u8.qnpn13g2[area]
print @q.xbgr.xq68_u9.qnpn13g2[area]
print @q.xbgr.xq68_u10.qnpn13g2[area]
print @q.xbgr.xq68_u11.qnpn13g2[area]
print @q.xbgr.xq68_u12.qnpn13g2[area]
print @q.xbgr.xq68_u13.qnpn13g2[area]
print @q.xbgr.xq68_u14.qnpn13g2[area]
print @q.xbgr.xq68_u15.qnpn13g2[area]
print @q.xbgr.xq68_u16.qnpn13g2[area]
print @q.xbgr.xq68_u17.qnpn13g2[area]
print @q.xbgr.xq68_u18.qnpn13g2[area]
print @q.xbgr.xq68_u19.qnpn13g2[area]
print @q.xbgr.xq68_u20.qnpn13g2[area]
print @q.xbgr.xq68_u21.qnpn13g2[area]
print @q.xbgr.xq68_u22.qnpn13g2[area]
print @q.xbgr.xq68_u23.qnpn13g2[area]
print @q.xbgr.xq68_u24.qnpn13g2[area]
print @q.xbgr.xq69_u2.qnpn13g2[area]
print @q.xbgr.xq69_u3.qnpn13g2[area]
print @q.xbgr.xq69_u4.qnpn13g2[area]
print @q.xbgr.xq69_u5.qnpn13g2[area]
print @q.xbgr.xq69_u6.qnpn13g2[area]
print @q.xbgr.xq69_u7.qnpn13g2[area]
print @q.xbgr.xq69_u8.qnpn13g2[area]
print @q.xbgr.xq69_u9.qnpn13g2[area]
print @q.xbgr.xq69_u10.qnpn13g2[area]
print @q.xbgr.xq69_u11.qnpn13g2[area]
print @q.xbgr.xq69_u12.qnpn13g2[area]
print @q.xbgr.xq69_u13.qnpn13g2[area]
print @q.xbgr.xq69_u14.qnpn13g2[area]
print @q.xbgr.xq69_u15.qnpn13g2[area]
print @q.xbgr.xq69_u16.qnpn13g2[area]
print @q.xbgr.xq69_u17.qnpn13g2[area]
print @q.xbgr.xq69_u18.qnpn13g2[area]
print @q.xbgr.xq69_u19.qnpn13g2[area]
print @q.xbgr.xq69_u20.qnpn13g2[area]
print @q.xbgr.xq69_u21.qnpn13g2[area]
print @q.xbgr.xq69_u22.qnpn13g2[area]
print @q.xbgr.xq69_u23.qnpn13g2[area]
print @q.xbgr.xq69_u24.qnpn13g2[area]
print @q.xbgr.xq70_u2.qnpn13g2[area]
print @q.xbgr.xq70_u3.qnpn13g2[area]
print @q.xbgr.xq70_u4.qnpn13g2[area]
print @q.xbgr.xq70_u5.qnpn13g2[area]
print @q.xbgr.xq70_u6.qnpn13g2[area]
print @q.xbgr.xq70_u7.qnpn13g2[area]
print @q.xbgr.xq70_u8.qnpn13g2[area]
print @q.xbgr.xq70_u9.qnpn13g2[area]
print @q.xbgr.xq70_u10.qnpn13g2[area]
print @q.xbgr.xq70_u11.qnpn13g2[area]
print @q.xbgr.xq70_u12.qnpn13g2[area]
print @q.xbgr.xq70_u13.qnpn13g2[area]
print @q.xbgr.xq70_u14.qnpn13g2[area]
print @q.xbgr.xq70_u15.qnpn13g2[area]
print @q.xbgr.xq70_u16.qnpn13g2[area]
print @q.xbgr.xq70_u17.qnpn13g2[area]
print @q.xbgr.xq70_u18.qnpn13g2[area]
print @q.xbgr.xq70_u19.qnpn13g2[area]
print @q.xbgr.xq70_u20.qnpn13g2[area]
print @q.xbgr.xq70_u21.qnpn13g2[area]
print @q.xbgr.xq70_u22.qnpn13g2[area]
print @q.xbgr.xq70_u23.qnpn13g2[area]
print @q.xbgr.xq70_u24.qnpn13g2[area]
print @q.xbgr.xq71_u2.qnpn13g2[area]
print @q.xbgr.xq71_u3.qnpn13g2[area]
print @q.xbgr.xq71_u4.qnpn13g2[area]
print @q.xbgr.xq71_u5.qnpn13g2[area]
print @q.xbgr.xq71_u6.qnpn13g2[area]
print @q.xbgr.xq71_u7.qnpn13g2[area]
print @q.xbgr.xq71_u8.qnpn13g2[area]
print @q.xbgr.xq71_u9.qnpn13g2[area]
print @q.xbgr.xq71_u10.qnpn13g2[area]
print @q.xbgr.xq71_u11.qnpn13g2[area]
print @q.xbgr.xq71_u12.qnpn13g2[area]
print @q.xbgr.xq71_u13.qnpn13g2[area]
print @q.xbgr.xq71_u14.qnpn13g2[area]
print @q.xbgr.xq71_u15.qnpn13g2[area]
print @q.xbgr.xq71_u16.qnpn13g2[area]
print @q.xbgr.xq71_u17.qnpn13g2[area]
print @q.xbgr.xq71_u18.qnpn13g2[area]
print @q.xbgr.xq71_u19.qnpn13g2[area]
print @q.xbgr.xq71_u20.qnpn13g2[area]
print @q.xbgr.xq71_u21.qnpn13g2[area]
print @q.xbgr.xq71_u22.qnpn13g2[area]
print @q.xbgr.xq71_u23.qnpn13g2[area]
print @q.xbgr.xq71_u24.qnpn13g2[area]
print @q.xbgr.xq72_u2.qnpn13g2[area]
print @q.xbgr.xq72_u3.qnpn13g2[area]
print @q.xbgr.xq72_u4.qnpn13g2[area]
print @q.xbgr.xq72_u5.qnpn13g2[area]
print @q.xbgr.xq72_u6.qnpn13g2[area]
print @q.xbgr.xq72_u7.qnpn13g2[area]
print @q.xbgr.xq72_u8.qnpn13g2[area]
print @q.xbgr.xq72_u9.qnpn13g2[area]
print @q.xbgr.xq72_u10.qnpn13g2[area]
print @q.xbgr.xq72_u11.qnpn13g2[area]
print @q.xbgr.xq72_u12.qnpn13g2[area]
print @q.xbgr.xq72_u13.qnpn13g2[area]
print @q.xbgr.xq72_u14.qnpn13g2[area]
print @q.xbgr.xq72_u15.qnpn13g2[area]
print @q.xbgr.xq72_u16.qnpn13g2[area]
print @q.xbgr.xq72_u17.qnpn13g2[area]
print @q.xbgr.xq72_u18.qnpn13g2[area]
print @q.xbgr.xq72_u19.qnpn13g2[area]
print @q.xbgr.xq72_u20.qnpn13g2[area]
print @q.xbgr.xq72_u21.qnpn13g2[area]
print @q.xbgr.xq72_u22.qnpn13g2[area]
print @q.xbgr.xq72_u23.qnpn13g2[area]
print @q.xbgr.xq72_u24.qnpn13g2[area]
print @q.xbgr.xq73_u2.qnpn13g2[area]
print @q.xbgr.xq73_u3.qnpn13g2[area]
print @q.xbgr.xq73_u4.qnpn13g2[area]
print @q.xbgr.xq73_u5.qnpn13g2[area]
print @q.xbgr.xq73_u6.qnpn13g2[area]
print @q.xbgr.xq73_u7.qnpn13g2[area]
print @q.xbgr.xq73_u8.qnpn13g2[area]
print @q.xbgr.xq73_u9.qnpn13g2[area]
print @q.xbgr.xq73_u10.qnpn13g2[area]
print @q.xbgr.xq73_u11.qnpn13g2[area]
print @q.xbgr.xq73_u12.qnpn13g2[area]
print @q.xbgr.xq73_u13.qnpn13g2[area]
print @q.xbgr.xq73_u14.qnpn13g2[area]
print @q.xbgr.xq73_u15.qnpn13g2[area]
print @q.xbgr.xq73_u16.qnpn13g2[area]
print @q.xbgr.xq73_u17.qnpn13g2[area]
print @q.xbgr.xq73_u18.qnpn13g2[area]
print @q.xbgr.xq73_u19.qnpn13g2[area]
print @q.xbgr.xq73_u20.qnpn13g2[area]
print @q.xbgr.xq73_u21.qnpn13g2[area]
print @q.xbgr.xq73_u22.qnpn13g2[area]
print @q.xbgr.xq73_u23.qnpn13g2[area]
print @q.xbgr.xq73_u24.qnpn13g2[area]
print @q.xbgr.xq74_u2.qnpn13g2[area]
print @q.xbgr.xq74_u3.qnpn13g2[area]
print @q.xbgr.xq74_u4.qnpn13g2[area]
print @q.xbgr.xq74_u5.qnpn13g2[area]
print @q.xbgr.xq74_u6.qnpn13g2[area]
print @q.xbgr.xq74_u7.qnpn13g2[area]
print @q.xbgr.xq74_u8.qnpn13g2[area]
print @q.xbgr.xq74_u9.qnpn13g2[area]
print @q.xbgr.xq74_u10.qnpn13g2[area]
print @q.xbgr.xq74_u11.qnpn13g2[area]
print @q.xbgr.xq74_u12.qnpn13g2[area]
print @q.xbgr.xq74_u13.qnpn13g2[area]
print @q.xbgr.xq74_u14.qnpn13g2[area]
print @q.xbgr.xq74_u15.qnpn13g2[area]
print @q.xbgr.xq74_u16.qnpn13g2[area]
print @q.xbgr.xq74_u17.qnpn13g2[area]
print @q.xbgr.xq74_u18.qnpn13g2[area]
print @q.xbgr.xq74_u19.qnpn13g2[area]
print @q.xbgr.xq74_u20.qnpn13g2[area]
print @q.xbgr.xq74_u21.qnpn13g2[area]
print @q.xbgr.xq74_u22.qnpn13g2[area]
print @q.xbgr.xq74_u23.qnpn13g2[area]
print @q.xbgr.xq74_u24.qnpn13g2[area]
print @q.xbgr.xq75_u2.qnpn13g2[area]
print @q.xbgr.xq75_u3.qnpn13g2[area]
print @q.xbgr.xq75_u4.qnpn13g2[area]
print @q.xbgr.xq75_u5.qnpn13g2[area]
print @q.xbgr.xq75_u6.qnpn13g2[area]
print @q.xbgr.xq75_u7.qnpn13g2[area]
print @q.xbgr.xq75_u8.qnpn13g2[area]
print @q.xbgr.xq75_u9.qnpn13g2[area]
print @q.xbgr.xq75_u10.qnpn13g2[area]
print @q.xbgr.xq75_u11.qnpn13g2[area]
print @q.xbgr.xq75_u12.qnpn13g2[area]
print @q.xbgr.xq75_u13.qnpn13g2[area]
print @q.xbgr.xq75_u14.qnpn13g2[area]
print @q.xbgr.xq75_u15.qnpn13g2[area]
print @q.xbgr.xq75_u16.qnpn13g2[area]
print @q.xbgr.xq75_u17.qnpn13g2[area]
print @q.xbgr.xq75_u18.qnpn13g2[area]
print @q.xbgr.xq75_u19.qnpn13g2[area]
print @q.xbgr.xq75_u20.qnpn13g2[area]
print @q.xbgr.xq75_u21.qnpn13g2[area]
print @q.xbgr.xq75_u22.qnpn13g2[area]
print @q.xbgr.xq75_u23.qnpn13g2[area]
print @q.xbgr.xq75_u24.qnpn13g2[area]
print @q.xbgr.xq76_u2.qnpn13g2[area]
print @q.xbgr.xq76_u3.qnpn13g2[area]
print @q.xbgr.xq76_u4.qnpn13g2[area]
print @q.xbgr.xq76_u5.qnpn13g2[area]
print @q.xbgr.xq76_u6.qnpn13g2[area]
print @q.xbgr.xq76_u7.qnpn13g2[area]
print @q.xbgr.xq76_u8.qnpn13g2[area]
print @q.xbgr.xq76_u9.qnpn13g2[area]
print @q.xbgr.xq76_u10.qnpn13g2[area]
print @q.xbgr.xq76_u11.qnpn13g2[area]
print @q.xbgr.xq76_u12.qnpn13g2[area]
print @q.xbgr.xq76_u13.qnpn13g2[area]
print @q.xbgr.xq76_u14.qnpn13g2[area]
print @q.xbgr.xq76_u15.qnpn13g2[area]
print @q.xbgr.xq76_u16.qnpn13g2[area]
print @q.xbgr.xq76_u17.qnpn13g2[area]
print @q.xbgr.xq76_u18.qnpn13g2[area]
print @q.xbgr.xq76_u19.qnpn13g2[area]
print @q.xbgr.xq76_u20.qnpn13g2[area]
print @q.xbgr.xq76_u21.qnpn13g2[area]
print @q.xbgr.xq76_u22.qnpn13g2[area]
print @q.xbgr.xq76_u23.qnpn13g2[area]
print @q.xbgr.xq76_u24.qnpn13g2[area]
print @n.xbgr.xr77_u2.nr1[nsmm_rsh]
print @n.xbgr.xr77_u2.nr1[nsmm_w]
print @n.xbgr.xr77_u2.nr1[nsmm_l]
print @n.xbgr.xr77_u3.nr1[nsmm_rsh]
print @n.xbgr.xr77_u3.nr1[nsmm_w]
print @n.xbgr.xr77_u3.nr1[nsmm_l]
print @n.xbgr.xr77_u4.nr1[nsmm_rsh]
print @n.xbgr.xr77_u4.nr1[nsmm_w]
print @n.xbgr.xr77_u4.nr1[nsmm_l]
print @n.xbgr.xr77_u5.nr1[nsmm_rsh]
print @n.xbgr.xr77_u5.nr1[nsmm_w]
print @n.xbgr.xr77_u5.nr1[nsmm_l]
print @n.xbgr.xr77_u6.nr1[nsmm_rsh]
print @n.xbgr.xr77_u6.nr1[nsmm_w]
print @n.xbgr.xr77_u6.nr1[nsmm_l]
print @n.xbgr.xr77_u7.nr1[nsmm_rsh]
print @n.xbgr.xr77_u7.nr1[nsmm_w]
print @n.xbgr.xr77_u7.nr1[nsmm_l]
print @n.xbgr.xr77_u8.nr1[nsmm_rsh]
print @n.xbgr.xr77_u8.nr1[nsmm_w]
print @n.xbgr.xr77_u8.nr1[nsmm_l]
print @n.xbgr.xr77_u9.nr1[nsmm_rsh]
print @n.xbgr.xr77_u9.nr1[nsmm_w]
print @n.xbgr.xr77_u9.nr1[nsmm_l]
print @n.xbgr.xr77_u10.nr1[nsmm_rsh]
print @n.xbgr.xr77_u10.nr1[nsmm_w]
print @n.xbgr.xr77_u10.nr1[nsmm_l]
print @n.xbgr.xr77_u11.nr1[nsmm_rsh]
print @n.xbgr.xr77_u11.nr1[nsmm_w]
print @n.xbgr.xr77_u11.nr1[nsmm_l]
print @n.xbgr.xr77_u12.nr1[nsmm_rsh]
print @n.xbgr.xr77_u12.nr1[nsmm_w]
print @n.xbgr.xr77_u12.nr1[nsmm_l]
print @n.xbgr.xr77_u13.nr1[nsmm_rsh]
print @n.xbgr.xr77_u13.nr1[nsmm_w]
print @n.xbgr.xr77_u13.nr1[nsmm_l]
print @n.xbgr.xr77_u14.nr1[nsmm_rsh]
print @n.xbgr.xr77_u14.nr1[nsmm_w]
print @n.xbgr.xr77_u14.nr1[nsmm_l]
print @n.xbgr.xr77_u15.nr1[nsmm_rsh]
print @n.xbgr.xr77_u15.nr1[nsmm_w]
print @n.xbgr.xr77_u15.nr1[nsmm_l]
print @n.xbgr.xr77_u16.nr1[nsmm_rsh]
print @n.xbgr.xr77_u16.nr1[nsmm_w]
print @n.xbgr.xr77_u16.nr1[nsmm_l]
print @n.xbgr.xr77_u17.nr1[nsmm_rsh]
print @n.xbgr.xr77_u17.nr1[nsmm_w]
print @n.xbgr.xr77_u17.nr1[nsmm_l]
print @n.xbgr.xr77_u18.nr1[nsmm_rsh]
print @n.xbgr.xr77_u18.nr1[nsmm_w]
print @n.xbgr.xr77_u18.nr1[nsmm_l]
print @n.xbgr.xr77_u19.nr1[nsmm_rsh]
print @n.xbgr.xr77_u19.nr1[nsmm_w]
print @n.xbgr.xr77_u19.nr1[nsmm_l]
print @n.xbgr.xr77_u20.nr1[nsmm_rsh]
print @n.xbgr.xr77_u20.nr1[nsmm_w]
print @n.xbgr.xr77_u20.nr1[nsmm_l]
print @n.xbgr.xr77_u21.nr1[nsmm_rsh]
print @n.xbgr.xr77_u21.nr1[nsmm_w]
print @n.xbgr.xr77_u21.nr1[nsmm_l]
print @n.xbgr.xr77_u22.nr1[nsmm_rsh]
print @n.xbgr.xr77_u22.nr1[nsmm_w]
print @n.xbgr.xr77_u22.nr1[nsmm_l]
print @n.xbgr.xr77_u23.nr1[nsmm_rsh]
print @n.xbgr.xr77_u23.nr1[nsmm_w]
print @n.xbgr.xr77_u23.nr1[nsmm_l]
print @n.xbgr.xr77_u24.nr1[nsmm_rsh]
print @n.xbgr.xr77_u24.nr1[nsmm_w]
print @n.xbgr.xr77_u24.nr1[nsmm_l]
print @n.xbgr.xr78_u2.nr1[nsmm_rsh]
print @n.xbgr.xr78_u2.nr1[nsmm_w]
print @n.xbgr.xr78_u2.nr1[nsmm_l]
print @n.xbgr.xr78_u3.nr1[nsmm_rsh]
print @n.xbgr.xr78_u3.nr1[nsmm_w]
print @n.xbgr.xr78_u3.nr1[nsmm_l]
print @n.xbgr.xr78_u4.nr1[nsmm_rsh]
print @n.xbgr.xr78_u4.nr1[nsmm_w]
print @n.xbgr.xr78_u4.nr1[nsmm_l]
print @n.xbgr.xr78_u5.nr1[nsmm_rsh]
print @n.xbgr.xr78_u5.nr1[nsmm_w]
print @n.xbgr.xr78_u5.nr1[nsmm_l]
print @n.xbgr.xr78_u6.nr1[nsmm_rsh]
print @n.xbgr.xr78_u6.nr1[nsmm_w]
print @n.xbgr.xr78_u6.nr1[nsmm_l]
print @n.xbgr.xr78_u7.nr1[nsmm_rsh]
print @n.xbgr.xr78_u7.nr1[nsmm_w]
print @n.xbgr.xr78_u7.nr1[nsmm_l]
print @n.xbgr.xr78_u8.nr1[nsmm_rsh]
print @n.xbgr.xr78_u8.nr1[nsmm_w]
print @n.xbgr.xr78_u8.nr1[nsmm_l]
print @n.xbgr.xr78_u9.nr1[nsmm_rsh]
print @n.xbgr.xr78_u9.nr1[nsmm_w]
print @n.xbgr.xr78_u9.nr1[nsmm_l]
print @n.xbgr.xr78_u10.nr1[nsmm_rsh]
print @n.xbgr.xr78_u10.nr1[nsmm_w]
print @n.xbgr.xr78_u10.nr1[nsmm_l]
print @n.xbgr.xr78_u11.nr1[nsmm_rsh]
print @n.xbgr.xr78_u11.nr1[nsmm_w]
print @n.xbgr.xr78_u11.nr1[nsmm_l]
print @n.xbgr.xr78_u12.nr1[nsmm_rsh]
print @n.xbgr.xr78_u12.nr1[nsmm_w]
print @n.xbgr.xr78_u12.nr1[nsmm_l]
print @n.xbgr.xr78_u13.nr1[nsmm_rsh]
print @n.xbgr.xr78_u13.nr1[nsmm_w]
print @n.xbgr.xr78_u13.nr1[nsmm_l]
print @n.xbgr.xr78_u14.nr1[nsmm_rsh]
print @n.xbgr.xr78_u14.nr1[nsmm_w]
print @n.xbgr.xr78_u14.nr1[nsmm_l]
print @n.xbgr.xr78_u15.nr1[nsmm_rsh]
print @n.xbgr.xr78_u15.nr1[nsmm_w]
print @n.xbgr.xr78_u15.nr1[nsmm_l]
print @n.xbgr.xr78_u16.nr1[nsmm_rsh]
print @n.xbgr.xr78_u16.nr1[nsmm_w]
print @n.xbgr.xr78_u16.nr1[nsmm_l]
print @n.xbgr.xr78_u17.nr1[nsmm_rsh]
print @n.xbgr.xr78_u17.nr1[nsmm_w]
print @n.xbgr.xr78_u17.nr1[nsmm_l]
print @n.xbgr.xr78_u18.nr1[nsmm_rsh]
print @n.xbgr.xr78_u18.nr1[nsmm_w]
print @n.xbgr.xr78_u18.nr1[nsmm_l]
print @n.xbgr.xr78_u19.nr1[nsmm_rsh]
print @n.xbgr.xr78_u19.nr1[nsmm_w]
print @n.xbgr.xr78_u19.nr1[nsmm_l]
print @n.xbgr.xr78_u20.nr1[nsmm_rsh]
print @n.xbgr.xr78_u20.nr1[nsmm_w]
print @n.xbgr.xr78_u20.nr1[nsmm_l]
print @n.xbgr.xr78_u21.nr1[nsmm_rsh]
print @n.xbgr.xr78_u21.nr1[nsmm_w]
print @n.xbgr.xr78_u21.nr1[nsmm_l]
print @n.xbgr.xr78_u22.nr1[nsmm_rsh]
print @n.xbgr.xr78_u22.nr1[nsmm_w]
print @n.xbgr.xr78_u22.nr1[nsmm_l]
print @n.xbgr.xr78_u23.nr1[nsmm_rsh]
print @n.xbgr.xr78_u23.nr1[nsmm_w]
print @n.xbgr.xr78_u23.nr1[nsmm_l]
print @n.xbgr.xr78_u24.nr1[nsmm_rsh]
print @n.xbgr.xr78_u24.nr1[nsmm_w]
print @n.xbgr.xr78_u24.nr1[nsmm_l]
print @n.xbgr.xr79_u2.nr1[nsmm_rsh]
print @n.xbgr.xr79_u2.nr1[nsmm_w]
print @n.xbgr.xr79_u2.nr1[nsmm_l]
print @n.xbgr.xr79_u3.nr1[nsmm_rsh]
print @n.xbgr.xr79_u3.nr1[nsmm_w]
print @n.xbgr.xr79_u3.nr1[nsmm_l]
print @n.xbgr.xr79_u4.nr1[nsmm_rsh]
print @n.xbgr.xr79_u4.nr1[nsmm_w]
print @n.xbgr.xr79_u4.nr1[nsmm_l]
print @n.xbgr.xr79_u5.nr1[nsmm_rsh]
print @n.xbgr.xr79_u5.nr1[nsmm_w]
print @n.xbgr.xr79_u5.nr1[nsmm_l]
print @n.xbgr.xr79_u6.nr1[nsmm_rsh]
print @n.xbgr.xr79_u6.nr1[nsmm_w]
print @n.xbgr.xr79_u6.nr1[nsmm_l]
print @n.xbgr.xr79_u7.nr1[nsmm_rsh]
print @n.xbgr.xr79_u7.nr1[nsmm_w]
print @n.xbgr.xr79_u7.nr1[nsmm_l]
print @n.xbgr.xr79_u8.nr1[nsmm_rsh]
print @n.xbgr.xr79_u8.nr1[nsmm_w]
print @n.xbgr.xr79_u8.nr1[nsmm_l]
print @n.xbgr.xr79_u9.nr1[nsmm_rsh]
print @n.xbgr.xr79_u9.nr1[nsmm_w]
print @n.xbgr.xr79_u9.nr1[nsmm_l]
print @n.xbgr.xr79_u10.nr1[nsmm_rsh]
print @n.xbgr.xr79_u10.nr1[nsmm_w]
print @n.xbgr.xr79_u10.nr1[nsmm_l]
print @n.xbgr.xr79_u11.nr1[nsmm_rsh]
print @n.xbgr.xr79_u11.nr1[nsmm_w]
print @n.xbgr.xr79_u11.nr1[nsmm_l]
print @n.xbgr.xr79_u12.nr1[nsmm_rsh]
print @n.xbgr.xr79_u12.nr1[nsmm_w]
print @n.xbgr.xr79_u12.nr1[nsmm_l]
print @n.xbgr.xr79_u13.nr1[nsmm_rsh]
print @n.xbgr.xr79_u13.nr1[nsmm_w]
print @n.xbgr.xr79_u13.nr1[nsmm_l]
print @n.xbgr.xr79_u14.nr1[nsmm_rsh]
print @n.xbgr.xr79_u14.nr1[nsmm_w]
print @n.xbgr.xr79_u14.nr1[nsmm_l]
print @n.xbgr.xr79_u15.nr1[nsmm_rsh]
print @n.xbgr.xr79_u15.nr1[nsmm_w]
print @n.xbgr.xr79_u15.nr1[nsmm_l]
print @n.xbgr.xr79_u16.nr1[nsmm_rsh]
print @n.xbgr.xr79_u16.nr1[nsmm_w]
print @n.xbgr.xr79_u16.nr1[nsmm_l]
print @n.xbgr.xr79_u17.nr1[nsmm_rsh]
print @n.xbgr.xr79_u17.nr1[nsmm_w]
print @n.xbgr.xr79_u17.nr1[nsmm_l]
print @n.xbgr.xr79_u18.nr1[nsmm_rsh]
print @n.xbgr.xr79_u18.nr1[nsmm_w]
print @n.xbgr.xr79_u18.nr1[nsmm_l]
print @n.xbgr.xr79_u19.nr1[nsmm_rsh]
print @n.xbgr.xr79_u19.nr1[nsmm_w]
print @n.xbgr.xr79_u19.nr1[nsmm_l]
print @n.xbgr.xr79_u20.nr1[nsmm_rsh]
print @n.xbgr.xr79_u20.nr1[nsmm_w]
print @n.xbgr.xr79_u20.nr1[nsmm_l]
print @n.xbgr.xr79_u21.nr1[nsmm_rsh]
print @n.xbgr.xr79_u21.nr1[nsmm_w]
print @n.xbgr.xr79_u21.nr1[nsmm_l]
print @n.xbgr.xr79_u22.nr1[nsmm_rsh]
print @n.xbgr.xr79_u22.nr1[nsmm_w]
print @n.xbgr.xr79_u22.nr1[nsmm_l]
print @n.xbgr.xr79_u23.nr1[nsmm_rsh]
print @n.xbgr.xr79_u23.nr1[nsmm_w]
print @n.xbgr.xr79_u23.nr1[nsmm_l]
print @n.xbgr.xr79_u24.nr1[nsmm_rsh]
print @n.xbgr.xr79_u24.nr1[nsmm_w]
print @n.xbgr.xr79_u24.nr1[nsmm_l]
print @n.xbgr.xr80_u2.nr1[nsmm_rsh]
print @n.xbgr.xr80_u2.nr1[nsmm_w]
print @n.xbgr.xr80_u2.nr1[nsmm_l]
print @n.xbgr.xr80_u3.nr1[nsmm_rsh]
print @n.xbgr.xr80_u3.nr1[nsmm_w]
print @n.xbgr.xr80_u3.nr1[nsmm_l]
print @n.xbgr.xr80_u4.nr1[nsmm_rsh]
print @n.xbgr.xr80_u4.nr1[nsmm_w]
print @n.xbgr.xr80_u4.nr1[nsmm_l]
print @n.xbgr.xr80_u5.nr1[nsmm_rsh]
print @n.xbgr.xr80_u5.nr1[nsmm_w]
print @n.xbgr.xr80_u5.nr1[nsmm_l]
print @n.xbgr.xr80_u6.nr1[nsmm_rsh]
print @n.xbgr.xr80_u6.nr1[nsmm_w]
print @n.xbgr.xr80_u6.nr1[nsmm_l]
print @n.xbgr.xr80_u7.nr1[nsmm_rsh]
print @n.xbgr.xr80_u7.nr1[nsmm_w]
print @n.xbgr.xr80_u7.nr1[nsmm_l]
print @n.xbgr.xr80_u8.nr1[nsmm_rsh]
print @n.xbgr.xr80_u8.nr1[nsmm_w]
print @n.xbgr.xr80_u8.nr1[nsmm_l]
print @n.xbgr.xr80_u9.nr1[nsmm_rsh]
print @n.xbgr.xr80_u9.nr1[nsmm_w]
print @n.xbgr.xr80_u9.nr1[nsmm_l]
print @n.xbgr.xr80_u10.nr1[nsmm_rsh]
print @n.xbgr.xr80_u10.nr1[nsmm_w]
print @n.xbgr.xr80_u10.nr1[nsmm_l]
print @n.xbgr.xr80_u11.nr1[nsmm_rsh]
print @n.xbgr.xr80_u11.nr1[nsmm_w]
print @n.xbgr.xr80_u11.nr1[nsmm_l]
print @n.xbgr.xr80_u12.nr1[nsmm_rsh]
print @n.xbgr.xr80_u12.nr1[nsmm_w]
print @n.xbgr.xr80_u12.nr1[nsmm_l]
print @n.xbgr.xr80_u13.nr1[nsmm_rsh]
print @n.xbgr.xr80_u13.nr1[nsmm_w]
print @n.xbgr.xr80_u13.nr1[nsmm_l]
print @n.xbgr.xr80_u14.nr1[nsmm_rsh]
print @n.xbgr.xr80_u14.nr1[nsmm_w]
print @n.xbgr.xr80_u14.nr1[nsmm_l]
print @n.xbgr.xr80_u15.nr1[nsmm_rsh]
print @n.xbgr.xr80_u15.nr1[nsmm_w]
print @n.xbgr.xr80_u15.nr1[nsmm_l]
print @n.xbgr.xr80_u16.nr1[nsmm_rsh]
print @n.xbgr.xr80_u16.nr1[nsmm_w]
print @n.xbgr.xr80_u16.nr1[nsmm_l]
print @n.xbgr.xr80_u17.nr1[nsmm_rsh]
print @n.xbgr.xr80_u17.nr1[nsmm_w]
print @n.xbgr.xr80_u17.nr1[nsmm_l]
print @n.xbgr.xr80_u18.nr1[nsmm_rsh]
print @n.xbgr.xr80_u18.nr1[nsmm_w]
print @n.xbgr.xr80_u18.nr1[nsmm_l]
print @n.xbgr.xr80_u19.nr1[nsmm_rsh]
print @n.xbgr.xr80_u19.nr1[nsmm_w]
print @n.xbgr.xr80_u19.nr1[nsmm_l]
print @n.xbgr.xr80_u20.nr1[nsmm_rsh]
print @n.xbgr.xr80_u20.nr1[nsmm_w]
print @n.xbgr.xr80_u20.nr1[nsmm_l]
print @n.xbgr.xr80_u21.nr1[nsmm_rsh]
print @n.xbgr.xr80_u21.nr1[nsmm_w]
print @n.xbgr.xr80_u21.nr1[nsmm_l]
print @n.xbgr.xr80_u22.nr1[nsmm_rsh]
print @n.xbgr.xr80_u22.nr1[nsmm_w]
print @n.xbgr.xr80_u22.nr1[nsmm_l]
print @n.xbgr.xr80_u23.nr1[nsmm_rsh]
print @n.xbgr.xr80_u23.nr1[nsmm_w]
print @n.xbgr.xr80_u23.nr1[nsmm_l]
print @n.xbgr.xr80_u24.nr1[nsmm_rsh]
print @n.xbgr.xr80_u24.nr1[nsmm_w]
print @n.xbgr.xr80_u24.nr1[nsmm_l]
print @n.xbgr.xr81_u2.nr1[nsmm_rsh]
print @n.xbgr.xr81_u2.nr1[nsmm_w]
print @n.xbgr.xr81_u2.nr1[nsmm_l]
print @n.xbgr.xr81_u3.nr1[nsmm_rsh]
print @n.xbgr.xr81_u3.nr1[nsmm_w]
print @n.xbgr.xr81_u3.nr1[nsmm_l]
print @n.xbgr.xr81_u4.nr1[nsmm_rsh]
print @n.xbgr.xr81_u4.nr1[nsmm_w]
print @n.xbgr.xr81_u4.nr1[nsmm_l]
print @n.xbgr.xr81_u5.nr1[nsmm_rsh]
print @n.xbgr.xr81_u5.nr1[nsmm_w]
print @n.xbgr.xr81_u5.nr1[nsmm_l]
print @n.xbgr.xr81_u6.nr1[nsmm_rsh]
print @n.xbgr.xr81_u6.nr1[nsmm_w]
print @n.xbgr.xr81_u6.nr1[nsmm_l]
print @n.xbgr.xr81_u7.nr1[nsmm_rsh]
print @n.xbgr.xr81_u7.nr1[nsmm_w]
print @n.xbgr.xr81_u7.nr1[nsmm_l]
print @n.xbgr.xr81_u8.nr1[nsmm_rsh]
print @n.xbgr.xr81_u8.nr1[nsmm_w]
print @n.xbgr.xr81_u8.nr1[nsmm_l]
print @n.xbgr.xr81_u9.nr1[nsmm_rsh]
print @n.xbgr.xr81_u9.nr1[nsmm_w]
print @n.xbgr.xr81_u9.nr1[nsmm_l]
print @n.xbgr.xr81_u10.nr1[nsmm_rsh]
print @n.xbgr.xr81_u10.nr1[nsmm_w]
print @n.xbgr.xr81_u10.nr1[nsmm_l]
print @n.xbgr.xr81_u11.nr1[nsmm_rsh]
print @n.xbgr.xr81_u11.nr1[nsmm_w]
print @n.xbgr.xr81_u11.nr1[nsmm_l]
print @n.xbgr.xr81_u12.nr1[nsmm_rsh]
print @n.xbgr.xr81_u12.nr1[nsmm_w]
print @n.xbgr.xr81_u12.nr1[nsmm_l]
print @n.xbgr.xr81_u13.nr1[nsmm_rsh]
print @n.xbgr.xr81_u13.nr1[nsmm_w]
print @n.xbgr.xr81_u13.nr1[nsmm_l]
print @n.xbgr.xr81_u14.nr1[nsmm_rsh]
print @n.xbgr.xr81_u14.nr1[nsmm_w]
print @n.xbgr.xr81_u14.nr1[nsmm_l]
print @n.xbgr.xr81_u15.nr1[nsmm_rsh]
print @n.xbgr.xr81_u15.nr1[nsmm_w]
print @n.xbgr.xr81_u15.nr1[nsmm_l]
print @n.xbgr.xr81_u16.nr1[nsmm_rsh]
print @n.xbgr.xr81_u16.nr1[nsmm_w]
print @n.xbgr.xr81_u16.nr1[nsmm_l]
print @n.xbgr.xr81_u17.nr1[nsmm_rsh]
print @n.xbgr.xr81_u17.nr1[nsmm_w]
print @n.xbgr.xr81_u17.nr1[nsmm_l]
print @n.xbgr.xr81_u18.nr1[nsmm_rsh]
print @n.xbgr.xr81_u18.nr1[nsmm_w]
print @n.xbgr.xr81_u18.nr1[nsmm_l]
print @n.xbgr.xr81_u19.nr1[nsmm_rsh]
print @n.xbgr.xr81_u19.nr1[nsmm_w]
print @n.xbgr.xr81_u19.nr1[nsmm_l]
print @n.xbgr.xr81_u20.nr1[nsmm_rsh]
print @n.xbgr.xr81_u20.nr1[nsmm_w]
print @n.xbgr.xr81_u20.nr1[nsmm_l]
print @n.xbgr.xr81_u21.nr1[nsmm_rsh]
print @n.xbgr.xr81_u21.nr1[nsmm_w]
print @n.xbgr.xr81_u21.nr1[nsmm_l]
print @n.xbgr.xr81_u22.nr1[nsmm_rsh]
print @n.xbgr.xr81_u22.nr1[nsmm_w]
print @n.xbgr.xr81_u22.nr1[nsmm_l]
print @n.xbgr.xr81_u23.nr1[nsmm_rsh]
print @n.xbgr.xr81_u23.nr1[nsmm_w]
print @n.xbgr.xr81_u23.nr1[nsmm_l]
print @n.xbgr.xr81_u24.nr1[nsmm_rsh]
print @n.xbgr.xr81_u24.nr1[nsmm_w]
print @n.xbgr.xr81_u24.nr1[nsmm_l]
print @n.xbgr.xr82_u2.nr1[nsmm_rsh]
print @n.xbgr.xr82_u2.nr1[nsmm_w]
print @n.xbgr.xr82_u2.nr1[nsmm_l]
print @n.xbgr.xr82_u3.nr1[nsmm_rsh]
print @n.xbgr.xr82_u3.nr1[nsmm_w]
print @n.xbgr.xr82_u3.nr1[nsmm_l]
print @n.xbgr.xr82_u4.nr1[nsmm_rsh]
print @n.xbgr.xr82_u4.nr1[nsmm_w]
print @n.xbgr.xr82_u4.nr1[nsmm_l]
print @n.xbgr.xr82_u5.nr1[nsmm_rsh]
print @n.xbgr.xr82_u5.nr1[nsmm_w]
print @n.xbgr.xr82_u5.nr1[nsmm_l]
print @n.xbgr.xr82_u6.nr1[nsmm_rsh]
print @n.xbgr.xr82_u6.nr1[nsmm_w]
print @n.xbgr.xr82_u6.nr1[nsmm_l]
print @n.xbgr.xr82_u7.nr1[nsmm_rsh]
print @n.xbgr.xr82_u7.nr1[nsmm_w]
print @n.xbgr.xr82_u7.nr1[nsmm_l]
print @n.xbgr.xr82_u8.nr1[nsmm_rsh]
print @n.xbgr.xr82_u8.nr1[nsmm_w]
print @n.xbgr.xr82_u8.nr1[nsmm_l]
print @n.xbgr.xr82_u9.nr1[nsmm_rsh]
print @n.xbgr.xr82_u9.nr1[nsmm_w]
print @n.xbgr.xr82_u9.nr1[nsmm_l]
print @n.xbgr.xr82_u10.nr1[nsmm_rsh]
print @n.xbgr.xr82_u10.nr1[nsmm_w]
print @n.xbgr.xr82_u10.nr1[nsmm_l]
print @n.xbgr.xr82_u11.nr1[nsmm_rsh]
print @n.xbgr.xr82_u11.nr1[nsmm_w]
print @n.xbgr.xr82_u11.nr1[nsmm_l]
print @n.xbgr.xr82_u12.nr1[nsmm_rsh]
print @n.xbgr.xr82_u12.nr1[nsmm_w]
print @n.xbgr.xr82_u12.nr1[nsmm_l]
print @n.xbgr.xr82_u13.nr1[nsmm_rsh]
print @n.xbgr.xr82_u13.nr1[nsmm_w]
print @n.xbgr.xr82_u13.nr1[nsmm_l]
print @n.xbgr.xr82_u14.nr1[nsmm_rsh]
print @n.xbgr.xr82_u14.nr1[nsmm_w]
print @n.xbgr.xr82_u14.nr1[nsmm_l]
print @n.xbgr.xr82_u15.nr1[nsmm_rsh]
print @n.xbgr.xr82_u15.nr1[nsmm_w]
print @n.xbgr.xr82_u15.nr1[nsmm_l]
print @n.xbgr.xr82_u16.nr1[nsmm_rsh]
print @n.xbgr.xr82_u16.nr1[nsmm_w]
print @n.xbgr.xr82_u16.nr1[nsmm_l]
print @n.xbgr.xr82_u17.nr1[nsmm_rsh]
print @n.xbgr.xr82_u17.nr1[nsmm_w]
print @n.xbgr.xr82_u17.nr1[nsmm_l]
print @n.xbgr.xr82_u18.nr1[nsmm_rsh]
print @n.xbgr.xr82_u18.nr1[nsmm_w]
print @n.xbgr.xr82_u18.nr1[nsmm_l]
print @n.xbgr.xr82_u19.nr1[nsmm_rsh]
print @n.xbgr.xr82_u19.nr1[nsmm_w]
print @n.xbgr.xr82_u19.nr1[nsmm_l]
print @n.xbgr.xr82_u20.nr1[nsmm_rsh]
print @n.xbgr.xr82_u20.nr1[nsmm_w]
print @n.xbgr.xr82_u20.nr1[nsmm_l]
print @n.xbgr.xr82_u21.nr1[nsmm_rsh]
print @n.xbgr.xr82_u21.nr1[nsmm_w]
print @n.xbgr.xr82_u21.nr1[nsmm_l]
print @n.xbgr.xr82_u22.nr1[nsmm_rsh]
print @n.xbgr.xr82_u22.nr1[nsmm_w]
print @n.xbgr.xr82_u22.nr1[nsmm_l]
print @n.xbgr.xr82_u23.nr1[nsmm_rsh]
print @n.xbgr.xr82_u23.nr1[nsmm_w]
print @n.xbgr.xr82_u23.nr1[nsmm_l]
print @n.xbgr.xr82_u24.nr1[nsmm_rsh]
print @n.xbgr.xr82_u24.nr1[nsmm_w]
print @n.xbgr.xr82_u24.nr1[nsmm_l]
print @n.xbgr.xr83_u2.nr1[nsmm_rsh]
print @n.xbgr.xr83_u2.nr1[nsmm_w]
print @n.xbgr.xr83_u2.nr1[nsmm_l]
print @n.xbgr.xr83_u3.nr1[nsmm_rsh]
print @n.xbgr.xr83_u3.nr1[nsmm_w]
print @n.xbgr.xr83_u3.nr1[nsmm_l]
print @n.xbgr.xr83_u4.nr1[nsmm_rsh]
print @n.xbgr.xr83_u4.nr1[nsmm_w]
print @n.xbgr.xr83_u4.nr1[nsmm_l]
print @n.xbgr.xr83_u5.nr1[nsmm_rsh]
print @n.xbgr.xr83_u5.nr1[nsmm_w]
print @n.xbgr.xr83_u5.nr1[nsmm_l]
print @n.xbgr.xr83_u6.nr1[nsmm_rsh]
print @n.xbgr.xr83_u6.nr1[nsmm_w]
print @n.xbgr.xr83_u6.nr1[nsmm_l]
print @n.xbgr.xr83_u7.nr1[nsmm_rsh]
print @n.xbgr.xr83_u7.nr1[nsmm_w]
print @n.xbgr.xr83_u7.nr1[nsmm_l]
print @n.xbgr.xr83_u8.nr1[nsmm_rsh]
print @n.xbgr.xr83_u8.nr1[nsmm_w]
print @n.xbgr.xr83_u8.nr1[nsmm_l]
print @n.xbgr.xr83_u9.nr1[nsmm_rsh]
print @n.xbgr.xr83_u9.nr1[nsmm_w]
print @n.xbgr.xr83_u9.nr1[nsmm_l]
print @n.xbgr.xr83_u10.nr1[nsmm_rsh]
print @n.xbgr.xr83_u10.nr1[nsmm_w]
print @n.xbgr.xr83_u10.nr1[nsmm_l]
print @n.xbgr.xr83_u11.nr1[nsmm_rsh]
print @n.xbgr.xr83_u11.nr1[nsmm_w]
print @n.xbgr.xr83_u11.nr1[nsmm_l]
print @n.xbgr.xr83_u12.nr1[nsmm_rsh]
print @n.xbgr.xr83_u12.nr1[nsmm_w]
print @n.xbgr.xr83_u12.nr1[nsmm_l]
print @n.xbgr.xr83_u13.nr1[nsmm_rsh]
print @n.xbgr.xr83_u13.nr1[nsmm_w]
print @n.xbgr.xr83_u13.nr1[nsmm_l]
print @n.xbgr.xr83_u14.nr1[nsmm_rsh]
print @n.xbgr.xr83_u14.nr1[nsmm_w]
print @n.xbgr.xr83_u14.nr1[nsmm_l]
print @n.xbgr.xr83_u15.nr1[nsmm_rsh]
print @n.xbgr.xr83_u15.nr1[nsmm_w]
print @n.xbgr.xr83_u15.nr1[nsmm_l]
print @n.xbgr.xr83_u16.nr1[nsmm_rsh]
print @n.xbgr.xr83_u16.nr1[nsmm_w]
print @n.xbgr.xr83_u16.nr1[nsmm_l]
print @n.xbgr.xr83_u17.nr1[nsmm_rsh]
print @n.xbgr.xr83_u17.nr1[nsmm_w]
print @n.xbgr.xr83_u17.nr1[nsmm_l]
print @n.xbgr.xr83_u18.nr1[nsmm_rsh]
print @n.xbgr.xr83_u18.nr1[nsmm_w]
print @n.xbgr.xr83_u18.nr1[nsmm_l]
print @n.xbgr.xr83_u19.nr1[nsmm_rsh]
print @n.xbgr.xr83_u19.nr1[nsmm_w]
print @n.xbgr.xr83_u19.nr1[nsmm_l]
print @n.xbgr.xr83_u20.nr1[nsmm_rsh]
print @n.xbgr.xr83_u20.nr1[nsmm_w]
print @n.xbgr.xr83_u20.nr1[nsmm_l]
print @n.xbgr.xr83_u21.nr1[nsmm_rsh]
print @n.xbgr.xr83_u21.nr1[nsmm_w]
print @n.xbgr.xr83_u21.nr1[nsmm_l]
print @n.xbgr.xr83_u22.nr1[nsmm_rsh]
print @n.xbgr.xr83_u22.nr1[nsmm_w]
print @n.xbgr.xr83_u22.nr1[nsmm_l]
print @n.xbgr.xr83_u23.nr1[nsmm_rsh]
print @n.xbgr.xr83_u23.nr1[nsmm_w]
print @n.xbgr.xr83_u23.nr1[nsmm_l]
print @n.xbgr.xr83_u24.nr1[nsmm_rsh]
print @n.xbgr.xr83_u24.nr1[nsmm_w]
print @n.xbgr.xr83_u24.nr1[nsmm_l]
print @n.xbgr.xr84_u2.nr1[nsmm_rsh]
print @n.xbgr.xr84_u2.nr1[nsmm_w]
print @n.xbgr.xr84_u2.nr1[nsmm_l]
print @n.xbgr.xr84_u3.nr1[nsmm_rsh]
print @n.xbgr.xr84_u3.nr1[nsmm_w]
print @n.xbgr.xr84_u3.nr1[nsmm_l]
print @n.xbgr.xr84_u4.nr1[nsmm_rsh]
print @n.xbgr.xr84_u4.nr1[nsmm_w]
print @n.xbgr.xr84_u4.nr1[nsmm_l]
print @n.xbgr.xr84_u5.nr1[nsmm_rsh]
print @n.xbgr.xr84_u5.nr1[nsmm_w]
print @n.xbgr.xr84_u5.nr1[nsmm_l]
print @n.xbgr.xr84_u6.nr1[nsmm_rsh]
print @n.xbgr.xr84_u6.nr1[nsmm_w]
print @n.xbgr.xr84_u6.nr1[nsmm_l]
print @n.xbgr.xr84_u7.nr1[nsmm_rsh]
print @n.xbgr.xr84_u7.nr1[nsmm_w]
print @n.xbgr.xr84_u7.nr1[nsmm_l]
print @n.xbgr.xr84_u8.nr1[nsmm_rsh]
print @n.xbgr.xr84_u8.nr1[nsmm_w]
print @n.xbgr.xr84_u8.nr1[nsmm_l]
print @n.xbgr.xr84_u9.nr1[nsmm_rsh]
print @n.xbgr.xr84_u9.nr1[nsmm_w]
print @n.xbgr.xr84_u9.nr1[nsmm_l]
print @n.xbgr.xr84_u10.nr1[nsmm_rsh]
print @n.xbgr.xr84_u10.nr1[nsmm_w]
print @n.xbgr.xr84_u10.nr1[nsmm_l]
print @n.xbgr.xr84_u11.nr1[nsmm_rsh]
print @n.xbgr.xr84_u11.nr1[nsmm_w]
print @n.xbgr.xr84_u11.nr1[nsmm_l]
print @n.xbgr.xr84_u12.nr1[nsmm_rsh]
print @n.xbgr.xr84_u12.nr1[nsmm_w]
print @n.xbgr.xr84_u12.nr1[nsmm_l]
print @n.xbgr.xr84_u13.nr1[nsmm_rsh]
print @n.xbgr.xr84_u13.nr1[nsmm_w]
print @n.xbgr.xr84_u13.nr1[nsmm_l]
print @n.xbgr.xr84_u14.nr1[nsmm_rsh]
print @n.xbgr.xr84_u14.nr1[nsmm_w]
print @n.xbgr.xr84_u14.nr1[nsmm_l]
print @n.xbgr.xr84_u15.nr1[nsmm_rsh]
print @n.xbgr.xr84_u15.nr1[nsmm_w]
print @n.xbgr.xr84_u15.nr1[nsmm_l]
print @n.xbgr.xr84_u16.nr1[nsmm_rsh]
print @n.xbgr.xr84_u16.nr1[nsmm_w]
print @n.xbgr.xr84_u16.nr1[nsmm_l]
print @n.xbgr.xr84_u17.nr1[nsmm_rsh]
print @n.xbgr.xr84_u17.nr1[nsmm_w]
print @n.xbgr.xr84_u17.nr1[nsmm_l]
print @n.xbgr.xr84_u18.nr1[nsmm_rsh]
print @n.xbgr.xr84_u18.nr1[nsmm_w]
print @n.xbgr.xr84_u18.nr1[nsmm_l]
print @n.xbgr.xr84_u19.nr1[nsmm_rsh]
print @n.xbgr.xr84_u19.nr1[nsmm_w]
print @n.xbgr.xr84_u19.nr1[nsmm_l]
print @n.xbgr.xr84_u20.nr1[nsmm_rsh]
print @n.xbgr.xr84_u20.nr1[nsmm_w]
print @n.xbgr.xr84_u20.nr1[nsmm_l]
print @n.xbgr.xr84_u21.nr1[nsmm_rsh]
print @n.xbgr.xr84_u21.nr1[nsmm_w]
print @n.xbgr.xr84_u21.nr1[nsmm_l]
print @n.xbgr.xr84_u22.nr1[nsmm_rsh]
print @n.xbgr.xr84_u22.nr1[nsmm_w]
print @n.xbgr.xr84_u22.nr1[nsmm_l]
print @n.xbgr.xr84_u23.nr1[nsmm_rsh]
print @n.xbgr.xr84_u23.nr1[nsmm_w]
print @n.xbgr.xr84_u23.nr1[nsmm_l]
print @n.xbgr.xr84_u24.nr1[nsmm_rsh]
print @n.xbgr.xr84_u24.nr1[nsmm_w]
print @n.xbgr.xr84_u24.nr1[nsmm_l]
print @n.xbgr.xr85_u2.nr1[nsmm_rsh]
print @n.xbgr.xr85_u2.nr1[nsmm_w]
print @n.xbgr.xr85_u2.nr1[nsmm_l]
print @n.xbgr.xr85_u3.nr1[nsmm_rsh]
print @n.xbgr.xr85_u3.nr1[nsmm_w]
print @n.xbgr.xr85_u3.nr1[nsmm_l]
print @n.xbgr.xr85_u4.nr1[nsmm_rsh]
print @n.xbgr.xr85_u4.nr1[nsmm_w]
print @n.xbgr.xr85_u4.nr1[nsmm_l]
print @n.xbgr.xr85_u5.nr1[nsmm_rsh]
print @n.xbgr.xr85_u5.nr1[nsmm_w]
print @n.xbgr.xr85_u5.nr1[nsmm_l]
print @n.xbgr.xr85_u6.nr1[nsmm_rsh]
print @n.xbgr.xr85_u6.nr1[nsmm_w]
print @n.xbgr.xr85_u6.nr1[nsmm_l]
print @n.xbgr.xr85_u7.nr1[nsmm_rsh]
print @n.xbgr.xr85_u7.nr1[nsmm_w]
print @n.xbgr.xr85_u7.nr1[nsmm_l]
print @n.xbgr.xr85_u8.nr1[nsmm_rsh]
print @n.xbgr.xr85_u8.nr1[nsmm_w]
print @n.xbgr.xr85_u8.nr1[nsmm_l]
print @n.xbgr.xr85_u9.nr1[nsmm_rsh]
print @n.xbgr.xr85_u9.nr1[nsmm_w]
print @n.xbgr.xr85_u9.nr1[nsmm_l]
print @n.xbgr.xr85_u10.nr1[nsmm_rsh]
print @n.xbgr.xr85_u10.nr1[nsmm_w]
print @n.xbgr.xr85_u10.nr1[nsmm_l]
print @n.xbgr.xr85_u11.nr1[nsmm_rsh]
print @n.xbgr.xr85_u11.nr1[nsmm_w]
print @n.xbgr.xr85_u11.nr1[nsmm_l]
print @n.xbgr.xr85_u12.nr1[nsmm_rsh]
print @n.xbgr.xr85_u12.nr1[nsmm_w]
print @n.xbgr.xr85_u12.nr1[nsmm_l]
print @n.xbgr.xr85_u13.nr1[nsmm_rsh]
print @n.xbgr.xr85_u13.nr1[nsmm_w]
print @n.xbgr.xr85_u13.nr1[nsmm_l]
print @n.xbgr.xr85_u14.nr1[nsmm_rsh]
print @n.xbgr.xr85_u14.nr1[nsmm_w]
print @n.xbgr.xr85_u14.nr1[nsmm_l]
print @n.xbgr.xr85_u15.nr1[nsmm_rsh]
print @n.xbgr.xr85_u15.nr1[nsmm_w]
print @n.xbgr.xr85_u15.nr1[nsmm_l]
print @n.xbgr.xr85_u16.nr1[nsmm_rsh]
print @n.xbgr.xr85_u16.nr1[nsmm_w]
print @n.xbgr.xr85_u16.nr1[nsmm_l]
print @n.xbgr.xr85_u17.nr1[nsmm_rsh]
print @n.xbgr.xr85_u17.nr1[nsmm_w]
print @n.xbgr.xr85_u17.nr1[nsmm_l]
print @n.xbgr.xr85_u18.nr1[nsmm_rsh]
print @n.xbgr.xr85_u18.nr1[nsmm_w]
print @n.xbgr.xr85_u18.nr1[nsmm_l]
print @n.xbgr.xr85_u19.nr1[nsmm_rsh]
print @n.xbgr.xr85_u19.nr1[nsmm_w]
print @n.xbgr.xr85_u19.nr1[nsmm_l]
print @n.xbgr.xr85_u20.nr1[nsmm_rsh]
print @n.xbgr.xr85_u20.nr1[nsmm_w]
print @n.xbgr.xr85_u20.nr1[nsmm_l]
print @n.xbgr.xr85_u21.nr1[nsmm_rsh]
print @n.xbgr.xr85_u21.nr1[nsmm_w]
print @n.xbgr.xr85_u21.nr1[nsmm_l]
print @n.xbgr.xr85_u22.nr1[nsmm_rsh]
print @n.xbgr.xr85_u22.nr1[nsmm_w]
print @n.xbgr.xr85_u22.nr1[nsmm_l]
print @n.xbgr.xr85_u23.nr1[nsmm_rsh]
print @n.xbgr.xr85_u23.nr1[nsmm_w]
print @n.xbgr.xr85_u23.nr1[nsmm_l]
print @n.xbgr.xr85_u24.nr1[nsmm_rsh]
print @n.xbgr.xr85_u24.nr1[nsmm_w]
print @n.xbgr.xr85_u24.nr1[nsmm_l]
print @n.xbgr.xr86_u2.nr1[nsmm_rsh]
print @n.xbgr.xr86_u2.nr1[nsmm_w]
print @n.xbgr.xr86_u2.nr1[nsmm_l]
print @n.xbgr.xr86_u3.nr1[nsmm_rsh]
print @n.xbgr.xr86_u3.nr1[nsmm_w]
print @n.xbgr.xr86_u3.nr1[nsmm_l]
print @n.xbgr.xr86_u4.nr1[nsmm_rsh]
print @n.xbgr.xr86_u4.nr1[nsmm_w]
print @n.xbgr.xr86_u4.nr1[nsmm_l]
print @n.xbgr.xr86_u5.nr1[nsmm_rsh]
print @n.xbgr.xr86_u5.nr1[nsmm_w]
print @n.xbgr.xr86_u5.nr1[nsmm_l]
print @n.xbgr.xr86_u6.nr1[nsmm_rsh]
print @n.xbgr.xr86_u6.nr1[nsmm_w]
print @n.xbgr.xr86_u6.nr1[nsmm_l]
print @n.xbgr.xr86_u7.nr1[nsmm_rsh]
print @n.xbgr.xr86_u7.nr1[nsmm_w]
print @n.xbgr.xr86_u7.nr1[nsmm_l]
print @n.xbgr.xr86_u8.nr1[nsmm_rsh]
print @n.xbgr.xr86_u8.nr1[nsmm_w]
print @n.xbgr.xr86_u8.nr1[nsmm_l]
print @n.xbgr.xr86_u9.nr1[nsmm_rsh]
print @n.xbgr.xr86_u9.nr1[nsmm_w]
print @n.xbgr.xr86_u9.nr1[nsmm_l]
print @n.xbgr.xr86_u10.nr1[nsmm_rsh]
print @n.xbgr.xr86_u10.nr1[nsmm_w]
print @n.xbgr.xr86_u10.nr1[nsmm_l]
print @n.xbgr.xr86_u11.nr1[nsmm_rsh]
print @n.xbgr.xr86_u11.nr1[nsmm_w]
print @n.xbgr.xr86_u11.nr1[nsmm_l]
print @n.xbgr.xr86_u12.nr1[nsmm_rsh]
print @n.xbgr.xr86_u12.nr1[nsmm_w]
print @n.xbgr.xr86_u12.nr1[nsmm_l]
print @n.xbgr.xr86_u13.nr1[nsmm_rsh]
print @n.xbgr.xr86_u13.nr1[nsmm_w]
print @n.xbgr.xr86_u13.nr1[nsmm_l]
print @n.xbgr.xr86_u14.nr1[nsmm_rsh]
print @n.xbgr.xr86_u14.nr1[nsmm_w]
print @n.xbgr.xr86_u14.nr1[nsmm_l]
print @n.xbgr.xr86_u15.nr1[nsmm_rsh]
print @n.xbgr.xr86_u15.nr1[nsmm_w]
print @n.xbgr.xr86_u15.nr1[nsmm_l]
print @n.xbgr.xr86_u16.nr1[nsmm_rsh]
print @n.xbgr.xr86_u16.nr1[nsmm_w]
print @n.xbgr.xr86_u16.nr1[nsmm_l]
print @n.xbgr.xr86_u17.nr1[nsmm_rsh]
print @n.xbgr.xr86_u17.nr1[nsmm_w]
print @n.xbgr.xr86_u17.nr1[nsmm_l]
print @n.xbgr.xr86_u18.nr1[nsmm_rsh]
print @n.xbgr.xr86_u18.nr1[nsmm_w]
print @n.xbgr.xr86_u18.nr1[nsmm_l]
print @n.xbgr.xr86_u19.nr1[nsmm_rsh]
print @n.xbgr.xr86_u19.nr1[nsmm_w]
print @n.xbgr.xr86_u19.nr1[nsmm_l]
print @n.xbgr.xr86_u20.nr1[nsmm_rsh]
print @n.xbgr.xr86_u20.nr1[nsmm_w]
print @n.xbgr.xr86_u20.nr1[nsmm_l]
print @n.xbgr.xr86_u21.nr1[nsmm_rsh]
print @n.xbgr.xr86_u21.nr1[nsmm_w]
print @n.xbgr.xr86_u21.nr1[nsmm_l]
print @n.xbgr.xr86_u22.nr1[nsmm_rsh]
print @n.xbgr.xr86_u22.nr1[nsmm_w]
print @n.xbgr.xr86_u22.nr1[nsmm_l]
print @n.xbgr.xr86_u23.nr1[nsmm_rsh]
print @n.xbgr.xr86_u23.nr1[nsmm_w]
print @n.xbgr.xr86_u23.nr1[nsmm_l]
print @n.xbgr.xr86_u24.nr1[nsmm_rsh]
print @n.xbgr.xr86_u24.nr1[nsmm_w]
print @n.xbgr.xr86_u24.nr1[nsmm_l]
set numdgt=17
echo METALLIC_POINT_VOLTAGES_BEGIN
print v(xbgr.mr_n90065344)
print v(xbgr.vd2)
print v(xbgr.mr_n90184544)
print v(xbgr.c2)
print v(xbgr.mr_n90391440)
print v(xbgr.mr_n90496720)
print v(xbgr.mr_n90631936)
print v(xbgr.mr_n90741472)
print v(xbgr.mr_n90862448)
print v(xbgr.mr_n90936944)
print v(xbgr.mr_n91193024)
print v(xbgr.mr_n91320864)
print v(xbgr.mr_n91486784)
print v(xbgr.mr_n91646048)
print v(xbgr.mr_n91774016)
print v(xbgr.mr_n91956800)
print v(xbgr.mr_n92055888)
print v(xbgr.mr_n92259504)
print v(xbgr.mr_n90071840)
print v(xbgr.mr_n90134960)
print v(xbgr.mr_n90170512)
print v(xbgr.mr_n90160912)
print v(xbgr.mr_n90394576)
print v(xbgr.mr_n90497680)
print v(xbgr.mr_n90604288)
print v(xbgr.mr_n90748800)
print v(xbgr.mr_n90865328)
print v(xbgr.mr_n91007456)
print v(xbgr.mr_n91012032)
print v(xbgr.mr_n91196160)
print v(xbgr.mr_n91324256)
print v(xbgr.mr_n91472512)
print v(xbgr.mr_n91601712)
print v(xbgr.mr_n91746304)
print v(xbgr.mr_n91960368)
print v(xbgr.mr_n92081584)
print v(xbgr.mr_n92262400)
print v(xbgr.mr_n90065632)
print v(xbgr.mr_n90130320)
print v(xbgr.b1b)
print v(xbgr.mr_n90236240)
print v(xbgr.mr_n90351376)
print v(xbgr.mr_n90457984)
print v(xbgr.mr_n90482576)
print v(xbgr.mr_n90689280)
print v(xbgr.mr_n90814944)
print v(xbgr.mr_n91155808)
print v(xbgr.mr_n91281248)
print v(xbgr.mr_n91416992)
print v(xbgr.mr_n91533232)
print v(xbgr.mr_n91710240)
print v(xbgr.mr_n91882752)
print v(xbgr.mr_n91981120)
print v(xbgr.mr_n92130688)
print v(xbgr.mr_n90104960)
print v(xbgr.mr_n89227632)
print v(xbgr.mr_n90214608)
print v(xbgr.mr_n90296528)
print v(xbgr.mr_n90418752)
print v(xbgr.mr_n90561392)
print v(xbgr.mr_n90559152)
print v(xbgr.mr_n90792416)
print v(xbgr.mr_n90865216)
print v(xbgr.mr_n91007792)
print v(xbgr.mr_n91124160)
print v(xbgr.mr_n91258640)
print v(xbgr.mr_n91505696)
print v(xbgr.mr_n91638160)
print v(xbgr.mr_n91662032)
print v(xbgr.mr_n91959504)
print v(xbgr.mr_n92080768)
print v(xbgr.mr_n92261552)
print v(xbgr.mr_n89332256)
print v(xbgr.mr_n89595568)
print v(xbgr.n_13)
print v(xbgr.n_24)
print v(xbgr.mr_n89330384)
print v(xbgr.mr_n89597872)
print v(xbgr.n_14)
print v(xbgr.mr_n89938608)
print v(xbgr.mr_n90054704)
print v(xbgr.mr_n89368496)
print v(xbgr.mr_n90201504)
print v(xbgr.mr_n90303488)
print v(xbgr.mr_n90394688)
print v(xbgr.mr_n90470608)
print v(xbgr.mr_n90657200)
print v(xbgr.vd1)
print v(xbgr.mr_n90877840)
print v(xbgr.mr_n91011216)
print v(xbgr.mr_n91193984)
print v(xbgr.mr_n91321824)
print v(xbgr.mr_n91507824)
print v(xbgr.mr_n91634368)
print v(xbgr.mr_n91828016)
print v(xbgr.mr_n91956464)
print v(xbgr.mr_n92054704)
print v(xbgr.mr_n92260176)
print v(xbgr.mr_n90074416)
print v(xbgr.mr_n90133744)
print v(xbgr.mr_n90173536)
print v(xbgr.mr_n90302384)
print v(xbgr.mr_n90398464)
print v(xbgr.mr_n90501296)
print v(xbgr.mr_n90607904)
print v(xbgr.mr_n90755248)
print v(xbgr.mr_n90865440)
print v(xbgr.mr_n91011488)
print v(xbgr.mr_n91023824)
print v(xbgr.mr_n91207392)
print v(xbgr.mr_n91333792)
print v(xbgr.mr_n91476304)
print v(xbgr.mr_n91605824)
print v(xbgr.mr_n91743360)
print v(xbgr.mr_n91962432)
print v(xbgr.mr_n92083648)
print v(xbgr.mr_n92264720)
print v(xbgr.mr_n90067600)
print v(xbgr.mr_n90131152)
print v(xbgr.mr_n89588528)
print v(xbgr.mr_n90262816)
print v(xbgr.mr_n90352768)
print v(xbgr.mr_n90461760)
print v(xbgr.mr_n90545392)
print v(xbgr.mr_n90690208)
print v(xbgr.mr_n90816448)
print v(xbgr.mr_n91157200)
print v(xbgr.mr_n91282640)
print v(xbgr.mr_n91418384)
print v(xbgr.mr_n91581552)
print v(xbgr.mr_n91711696)
print v(xbgr.mr_n91883488)
print v(xbgr.mr_n91993280)
print v(xbgr.mr_n92259840)
print v(xbgr.mr_n89333184)
print v(xbgr.mr_n89598464)
print v(xbgr.mr_n89827168)
print v(xbgr.n_26)
print v(xbgr.mr_n89332720)
print v(xbgr.mr_n89599056)
print v(xbgr.n_15)
print v(xbgr.mr_n89940048)
print v(xbgr.mr_n90105600)
print v(xbgr.mr_n89709312)
print v(xbgr.mr_n90216112)
print v(xbgr.mr_n90238464)
print v(xbgr.mr_n90437952)
print v(xbgr.mr_n90562032)
print v(xbgr.mr_n90658544)
print v(xbgr.mr_n90793056)
print v(xbgr.mr_n90892912)
print v(xbgr.mr_n90943088)
print v(xbgr.mr_n91196272)
print v(xbgr.mr_n91256832)
print v(xbgr.mr_n91521408)
print v(xbgr.mr_n91634144)
print v(xbgr.mr_n91829168)
print v(xbgr.mr_n91917760)
print v(xbgr.mr_n92081472)
print v(xbgr.mr_n92262288)
print v(xbgr.mr_n89334112)
print v(xbgr.mr_n89599648)
print v(xbgr.mr_n89828096)
print v(xbgr.n_27)
print v(xbgr.mr_n89333648)
print v(xbgr.mr_n89600240)
print v(xbgr.n_16)
print v(xbgr.mr_n89941488)
print v(xbgr.mr_n89335040)
print v(xbgr.mr_n89600832)
print v(xbgr.mr_n89828560)
print v(xbgr.n_21)
print v(xbgr.mr_n90066016)
print v(xbgr.mr_n89372528)
print v(xbgr.mr_n90216896)
print v(xbgr.mr_n89979408)
print v(xbgr.mr_n90303296)
print v(xbgr.mr_n90523744)
print v(xbgr.mr_n90659056)
print v(xbgr.mr_n90748912)
print v(xbgr.mr_n90867584)
print v(xbgr.mr_n91207280)
print v(xbgr.mr_n91324368)
print v(xbgr.mr_n91501840)
print v(xbgr.mr_n91634256)
print v(xbgr.mr_n91830256)
print v(xbgr.mr_n91960144)
print v(xbgr.mr_n92080192)
print v(xbgr.mr_n92262512)
print v(xbgr.mr_n89334576)
print v(xbgr.mr_n89601424)
print v(xbgr.mr_n90077600)
print v(xbgr.mr_n90136576)
print v(xbgr.mr_n90176560)
print v(xbgr.mr_n90306272)
print v(xbgr.mr_n90391888)
print v(xbgr.mr_n90505344)
print v(xbgr.mr_n90611888)
print v(xbgr.mr_n90759328)
print v(xbgr.mr_n90871200)
print v(xbgr.mr_n91209456)
print v(xbgr.mr_n91335856)
print v(xbgr.mr_n91480096)
print v(xbgr.mr_n91608720)
print v(xbgr.mr_n91750096)
print v(xbgr.mr_n91964496)
print v(xbgr.mr_n92085712)
print v(xbgr.mr_n92267040)
print v(xbgr.mr_n90071008)
print v(xbgr.mr_n89369504)
print v(xbgr.mr_n77003568)
print v(xbgr.mr_n90263808)
print v(xbgr.mr_n90354160)
print v(xbgr.mr_n90464304)
print v(xbgr.mr_n90596752)
print v(xbgr.mr_n90683456)
print v(xbgr.mr_n90820384)
print v(xbgr.mr_n91156736)
print v(xbgr.mr_n91284032)
print v(xbgr.mr_n91419776)
print v(xbgr.mr_n91583328)
print v(xbgr.mr_n91713472)
print v(xbgr.mr_n91884064)
print v(xbgr.mr_n92025488)
print v(xbgr.mr_n92131232)
print v(xbgr.mr_n89335968)
print v(xbgr.mr_n89602016)
print v(xbgr.n_8)
print v(xbgr.vbe3)
print v(xbgr.mr_n90106480)
print v(xbgr.mr_n89582368)
print v(xbgr.mr_n90217072)
print v(xbgr.mr_n90333616)
print v(xbgr.mr_n90438752)
print v(xbgr.mr_n90562304)
print v(xbgr.mr_n90660400)
print v(xbgr.mr_n90783040)
print v(xbgr.mr_n90893872)
print v(xbgr.mr_n91207504)
print v(xbgr.mr_n91289888)
print v(xbgr.mr_n91501728)
print v(xbgr.mr_n91651008)
print v(xbgr.mr_n91830768)
print v(xbgr.mr_n91960256)
print v(xbgr.mr_n92083536)
print v(xbgr.mr_n92264608)
print v(xbgr.mr_n89335504)
print v(xbgr.mr_n89603200)
print v(xbgr.mr_n89678928)
print v(xbgr.mr_n89828448)
print v(xbgr.mr_n89248720)
print v(xbgr.mr_n89604976)
print v(xbgr.mr_n89679328)
print v(xbgr.n_37)
print v(xbgr.mr_n89336432)
print v(xbgr.mr_n89606752)
print v(xbgr.mr_n89679728)
print v(xbgr.mr_n89989328)
print v(xbgr.n_6)
print v(xbgr.vb2)
print v(xbgr.n_2)
print v(xbgr.mr_n89989920)
print v(xbgr.mr_n90075280)
print v(xbgr.mr_n90149648)
print v(xbgr.mr_n90205184)
print v(xbgr.mr_n90306048)
print v(xbgr.mr_n90402336)
print v(xbgr.mr_n90521904)
print v(xbgr.mr_n90657312)
print v(xbgr.mr_n90741664)
print v(xbgr.mr_n90893696)
print v(xbgr.mr_n91193472)
print v(xbgr.mr_n91321312)
print v(xbgr.mr_n91509152)
print v(xbgr.mr_n91650832)
print v(xbgr.mr_n91832096)
print v(xbgr.mr_n91880800)
print v(xbgr.mr_n92083760)
print v(xbgr.mr_n92264832)
print v(xbgr.mr_n90080176)
print v(xbgr.mr_n90139536)
print v(xbgr.mr_n90179584)
print v(xbgr.mr_n90308752)
print v(xbgr.mr_n90405760)
print v(xbgr.mr_n90510864)
print v(xbgr.mr_n90617216)
print v(xbgr.mr_n90762160)
print v(xbgr.mr_n90875056)
print v(xbgr.mr_n91211520)
print v(xbgr.mr_n91337920)
print v(xbgr.mr_n91483888)
print v(xbgr.mr_n91612512)
print v(xbgr.mr_n91755616)
print v(xbgr.mr_n91966560)
print v(xbgr.mr_n92087776)
print v(xbgr.mr_n92269360)
print v(xbgr.mr_n89439344)
print v(xbgr.mr_n89474160)
print v(xbgr.mr_n89680528)
print v(xbgr.mr_n89990512)
print v(xbgr.mr_n90066400)
print v(xbgr.mr_n90152176)
print v(xbgr.mr_n90153712)
print v(xbgr.mr_n90265200)
print v(xbgr.mr_n90355552)
print v(xbgr.mr_n90466848)
print v(xbgr.mr_n90597904)
print v(xbgr.mr_n90742176)
print v(xbgr.mr_n90821776)
print v(xbgr.mr_n91156272)
print v(xbgr.mr_n91285744)
print v(xbgr.mr_n91421488)
print v(xbgr.mr_n91585104)
print v(xbgr.mr_n91715248)
print v(xbgr.mr_n91884880)
print v(xbgr.mr_n92026880)
print v(xbgr.mr_n92262064)
print v(xbgr.mr_n89440080)
print v(xbgr.mr_n89447536)
print v(xbgr.n_7)
print v(xbgr.n_36)
print v(xbgr.mr_n90107440)
print v(xbgr.mr_n89303248)
print v(xbgr.mr_n90218368)
print v(xbgr.mr_n90334576)
print v(xbgr.mr_n90439552)
print v(xbgr.mr_n90563536)
print v(xbgr.mr_n90662256)
print v(xbgr.mr_n90795248)
print v(xbgr.mr_n90894672)
print v(xbgr.mr_n91209344)
print v(xbgr.mr_n91321568)
print v(xbgr.mr_n91523008)
print v(xbgr.mr_n91651808)
print v(xbgr.mr_n91832592)
print v(xbgr.mr_n91964384)
print v(xbgr.mr_n92085600)
print v(xbgr.mr_n92266928)
print v(xbgr.mr_n89440816)
print v(xbgr.mr_n89475088)
print v(xbgr.mr_n89681328)
print v(xbgr.mr_n89991696)
print v(xbgr.mr_n89441552)
print v(xbgr.mr_n89475664)
print v(xbgr.mr_n89681728)
print v(xbgr.mr_n89992288)
print v(xbgr.mr_n89442288)
print v(xbgr.mr_n89472688)
print v(xbgr.mr_n89682128)
print v(xbgr.mr_n89992880)
print v(xbgr.mr_n89443024)
print v(xbgr.mr_n89476768)
print v(xbgr.mr_n89682528)
print v(xbgr.mr_n89993472)
print v(xbgr.mr_n90074528)
print v(xbgr.mr_n89317856)
print v(xbgr.mr_n90217936)
print v(xbgr.mr_n90333440)
print v(xbgr.mr_n90398576)
print v(xbgr.mr_n90530832)
print v(xbgr.mr_n90662768)
print v(xbgr.mr_n90759440)
print v(xbgr.mr_n90892480)
print v(xbgr.mr_n91157664)
print v(xbgr.mr_n91333680)
print v(xbgr.mr_n91522832)
print v(xbgr.mr_n91644704)
print v(xbgr.mr_n91743104)
print v(xbgr.mr_n91962544)
print v(xbgr.mr_n92085824)
print v(xbgr.mr_n92267152)
print v(xbgr.mr_n90083360)
print v(xbgr.mr_n90143328)
print v(xbgr.mr_n90182608)
print v(xbgr.mr_n90312736)
print v(xbgr.mr_n90401008)
print v(xbgr.mr_n90516384)
print v(xbgr.mr_n90622736)
print v(xbgr.mr_n90766240)
print v(xbgr.mr_n90873728)
print v(xbgr.mr_n91213584)
print v(xbgr.mr_n91339984)
print v(xbgr.mr_n91487680)
print v(xbgr.mr_n91616304)
print v(xbgr.mr_n91761136)
print v(xbgr.mr_n91968624)
print v(xbgr.mr_n92089840)
print v(xbgr.mr_n92271680)
print v(xbgr.mr_n90076768)
print v(xbgr.mr_n89343104)
print v(xbgr.mr_n90154752)
print v(xbgr.mr_n90266592)
print v(xbgr.mr_n90356944)
print v(xbgr.mr_n90445424)
print v(xbgr.mr_n90599296)
print v(xbgr.mr_n90742432)
print v(xbgr.mr_n90823168)
print v(xbgr.mr_n91209568)
print v(xbgr.mr_n91287520)
print v(xbgr.mr_n91423264)
print v(xbgr.mr_n91586880)
print v(xbgr.mr_n91717024)
print v(xbgr.mr_n91885696)
print v(xbgr.mr_n92028464)
print v(xbgr.mr_n92260512)
print v(xbgr.mr_n89443536)
print v(xbgr.mr_n89227424)
print v(xbgr.mr_n89682928)
print v(xbgr.mr_n89994656)
print v(xbgr.mr_n89444080)
print v(xbgr.mr_n89297936)
print v(xbgr.n_11)
print v(xbgr.mr_n89994064)
print v(xbgr.mr_n90108240)
print v(xbgr.mr_n89467696)
print v(xbgr.mr_n90219904)
print v(xbgr.mr_n90335776)
print v(xbgr.mr_n90440352)
print v(xbgr.mr_n90480000)
print v(xbgr.mr_n90664112)
print v(xbgr.mr_n90796208)
print v(xbgr.mr_n90895472)
print v(xbgr.mr_n91215200)
print v(xbgr.mr_n91333904)
print v(xbgr.mr_n91523808)
print v(xbgr.mr_n91652608)
print v(xbgr.mr_n91834336)
print v(xbgr.mr_n91966448)
print v(xbgr.mr_n92087664)
print v(xbgr.mr_n92269248)
print v(xbgr.mr_n89444576)
print v(xbgr.mr_n89304272)
print v(xbgr.mr_n89759888)
print v(xbgr.mr_n89995248)
print v(xbgr.mr_n89445632)
print v(xbgr.mr_n89310608)
print v(xbgr.mr_n89594976)
print v(xbgr.mr_n89995840)
print v(xbgr.mr_n89445904)
print v(xbgr.mr_n89321168)
print v(xbgr.mr_n89761072)
print v(xbgr.mr_n89941376)
print v(xbgr.mr_n90081040)
print v(xbgr.mr_n89222704)
print v(xbgr.mr_n90221024)
print v(xbgr.mr_n90335600)
print v(xbgr.mr_n90409632)
print v(xbgr.mr_n90531632)
print v(xbgr.mr_n90661024)
print v(xbgr.mr_n90741920)
print v(xbgr.mr_n90876384)
print v(xbgr.mr_n91213472)
print v(xbgr.mr_n91338032)
print v(xbgr.mr_n91501952)
print v(xbgr.mr_n91600304)
print v(xbgr.mr_n91719392)
print v(xbgr.mr_n91962320)
print v(xbgr.mr_n92087888)
print v(xbgr.mr_n92130144)
print v(xbgr.n_9)
print v(xbgr.mr_n89457056)
print v(xbgr.mr_n89761664)
print v(xbgr.mr_n89996960)
print v(xbgr.mr_n90085936)
print v(xbgr.mr_n90147120)
print v(xbgr.mr_n90185632)
print v(xbgr.mr_n90316720)
print v(xbgr.mr_n90413056)
print v(xbgr.mr_n90520064)
print v(xbgr.mr_n90626416)
print v(xbgr.mr_n90769072)
print v(xbgr.mr_n90872400)
print v(xbgr.mr_n91215904)
print v(xbgr.mr_n91342048)
print v(xbgr.mr_n91491472)
print v(xbgr.mr_n91620096)
print v(xbgr.mr_n91766656)
print v(xbgr.mr_n91970688)
print v(xbgr.mr_n92091904)
print v(xbgr.mr_n92274000)
print v(xbgr.mr_n90073360)
print v(xbgr.mr_n89584208)
print v(xbgr.mr_n90156144)
print v(xbgr.mr_n90267984)
print v(xbgr.mr_n90358336)
print v(xbgr.mr_n90445696)
print v(xbgr.mr_n90600688)
print v(xbgr.mr_n90763472)
print v(xbgr.mr_n90824560)
print v(xbgr.mr_n91193728)
print v(xbgr.mr_n91289296)
print v(xbgr.mr_n91425040)
print v(xbgr.mr_n91588656)
print v(xbgr.mr_n91718800)
print v(xbgr.mr_n91886512)
print v(xbgr.mr_n92030240)
print v(xbgr.mr_n92262176)
print v(xbgr.mr_n89446992)
print v(xbgr.mr_n89303568)
print v(xbgr.mr_n89762256)
print v(xbgr.mr_n89997616)
print v(xbgr.mr_n90108800)
print v(xbgr.mr_n89935840)
print v(xbgr.mr_n90221280)
print v(xbgr.mr_n90336656)
print v(xbgr.mr_n90441152)
print v(xbgr.mr_n90564592)
print v(xbgr.mr_n90663616)
print v(xbgr.mr_n90797184)
print v(xbgr.mr_n90896272)
print v(xbgr.mr_n91217600)
print v(xbgr.mr_n91339872)
print v(xbgr.mr_n91524608)
print v(xbgr.mr_n91653408)
print v(xbgr.mr_n91835072)
print v(xbgr.mr_n91968512)
print v(xbgr.mr_n92057072)
print v(xbgr.mr_n92271568)
print v(xbgr.mr_n89444464)
print v(xbgr.mr_n89315536)
print v(xbgr.mr_n89762848)
print v(xbgr.mr_n89591280)
print v(xbgr.mr_n89448080)
print v(xbgr.mr_n89293712)
print v(xbgr.mr_n89763440)
print v(xbgr.mr_n89998800)
print v(xbgr.mr_n89448624)
print v(xbgr.mr_n89325392)
print v(xbgr.mr_n89764032)
print v(xbgr.mr_n89999392)
print v(xbgr.mr_n89437536)
print v(xbgr.mr_n89304976)
print v(xbgr.mr_n89764624)
print v(xbgr.mr_n89999984)
print v(xbgr.mr_n90080288)
print v(xbgr.mr_n89263824)
print v(xbgr.mr_n90222304)
print v(xbgr.mr_n90332176)
print v(xbgr.mr_n90405872)
print v(xbgr.mr_n90532432)
print v(xbgr.mr_n90664736)
print v(xbgr.mr_n90755360)
print v(xbgr.mr_n90879680)
print v(xbgr.mr_n91215792)
print v(xbgr.mr_n91341936)
print v(xbgr.mr_n91494368)
print v(xbgr.mr_n91639168)
print v(xbgr.mr_n91837424)
print v(xbgr.mr_n91957472)
print v(xbgr.mr_n92081696)
print v(xbgr.mr_n92116032)
print v(xbgr.mr_n90089120)
print v(xbgr.mr_n90148384)
print v(xbgr.mr_n90188656)
print v(xbgr.mr_n90321728)
print v(xbgr.mr_n90408304)
print v(xbgr.mr_n90518224)
print v(xbgr.mr_n90624576)
print v(xbgr.mr_n90773120)
print v(xbgr.mr_n90866384)
print v(xbgr.mr_n91218224)
print v(xbgr.mr_n91344112)
print v(xbgr.mr_n91495264)
print v(xbgr.mr_n91623888)
print v(xbgr.mr_n91768496)
print v(xbgr.mr_n91972752)
print v(xbgr.mr_n92093968)
print v(xbgr.mr_n92276320)
print v(xbgr.mr_n89449712)
print v(xbgr.mr_n89449168)
print v(xbgr.mr_n89765216)
print v(xbgr.mr_n90000576)
print v(xbgr.mr_n90082528)
print v(xbgr.mr_n89371520)
print v(xbgr.mr_n90155680)
print v(xbgr.mr_n90269376)
print v(xbgr.mr_n90357872)
print v(xbgr.mr_n90468064)
print v(xbgr.mr_n90600224)
print v(xbgr.mr_n90762272)
print v(xbgr.mr_n90825952)
print v(xbgr.mr_n91193216)
print v(xbgr.mr_n91288704)
print v(xbgr.mr_n91424448)
print v(xbgr.mr_n91590432)
print v(xbgr.mr_n91718208)
print v(xbgr.mr_n91886240)
print v(xbgr.mr_n92032016)
print v(xbgr.mr_n92266816)
print v(xbgr.mr_n89450528)
print v(xbgr.mr_n89442176)
print v(xbgr.mr_n89765808)
print v(xbgr.mr_n90001168)
print v(xbgr.mr_n90109440)
print v(xbgr.mr_n89581984)
print v(xbgr.mr_n90222736)
print v(xbgr.mr_n90338016)
print v(xbgr.mr_n90441952)
print v(xbgr.mr_n90564992)
print v(xbgr.mr_n90667824)
print v(xbgr.mr_n90797824)
print v(xbgr.mr_n90897072)
print v(xbgr.mr_n91219760)
print v(xbgr.mr_n91337808)
print v(xbgr.mr_n91525408)
print v(xbgr.mr_n91654208)
print v(xbgr.mr_n91837600)
print v(xbgr.mr_n91970576)
print v(xbgr.mr_n92091792)
print v(xbgr.mr_n92273888)
print v(xbgr.mr_n89446720)
print v(xbgr.mr_n89326096)
print v(xbgr.n_3)
print v(xbgr.n_33)
print v(xbgr.mr_n89451344)
print v(xbgr.mr_n89242288)
print v(xbgr.mr_n89766992)
print v(xbgr.mr_n89985504)
print v(xbgr.mr_n89451952)
print v(xbgr.mr_n89378240)
print v(xbgr.mr_n89543456)
print v(xbgr.mr_n89810208)
print v(xbgr.mr_n89453344)
print v(xbgr.mr_n89239296)
print v(xbgr.mr_n89768176)
print v(xbgr.mr_n90001760)
print v(xbgr.mr_n90086800)
print v(xbgr.mr_n89356784)
print v(xbgr.mr_n90220848)
print v(xbgr.mr_n90337840)
print v(xbgr.mr_n90416928)
print v(xbgr.mr_n90533552)
print v(xbgr.mr_n90668592)
print v(xbgr.mr_n90758496)
print v(xbgr.mr_n90892048)
print v(xbgr.mr_n91053376)
print v(xbgr.mr_n91218336)
print v(xbgr.mr_n91342160)
print v(xbgr.mr_n91524432)
print v(xbgr.mr_n91653232)
print v(xbgr.mr_n91838192)
print v(xbgr.mr_n91882576)
print v(xbgr.mr_n92092016)
print v(xbgr.mr_n92264496)
print v(xbgr.mr_n90091696)
print v(xbgr.mr_n90145856)
print v(xbgr.mr_n90191680)
print v(xbgr.mr_n90325408)
print v(xbgr.mr_n90420352)
print v(xbgr.mr_n90514544)
print v(xbgr.mr_n90620896)
print v(xbgr.mr_n90775952)
print v(xbgr.mr_n90870256)
print v(xbgr.mr_n91090944)
print v(xbgr.mr_n91220544)
print v(xbgr.mr_n91346176)
print v(xbgr.mr_n91499056)
print v(xbgr.mr_n91627680)
print v(xbgr.mr_n91764816)
print v(xbgr.mr_n91974816)
print v(xbgr.mr_n92096032)
print v(xbgr.mr_n92278640)
print v(xbgr.mr_n90079120)
print v(xbgr.mr_n90132896)
print v(xbgr.mr_n90155216)
print v(xbgr.mr_n90269840)
print v(xbgr.mr_n90357408)
print v(xbgr.mr_n90477024)
print v(xbgr.mr_n90599760)
print v(xbgr.mr_n90766352)
print v(xbgr.mr_n90827344)
print v(xbgr.mr_n91087808)
print v(xbgr.mr_n91127200)
print v(xbgr.mr_n91288112)
print v(xbgr.mr_n91423856)
print v(xbgr.mr_n91592208)
print v(xbgr.mr_n91717616)
print v(xbgr.mr_n91885968)
print v(xbgr.mr_n92033792)
print v(xbgr.mr_n92269136)
print v(xbgr.mr_n89453808)
print v(xbgr.n_19)
print v(xbgr.mr_n89768768)
print v(xbgr.mr_n90004192)
print v(xbgr.mr_n90110240)
print v(xbgr.mr_n90040560)
print v(xbgr.mr_n90224272)
print v(xbgr.mr_n90339056)
print v(xbgr.mr_n90442752)
print v(xbgr.mr_n90565392)
print v(xbgr.mr_n90669200)
print v(xbgr.mr_n90798464)
print v(xbgr.mr_n90897872)
print v(xbgr.mr_n91095696)
print v(xbgr.mr_n91222160)
print v(xbgr.mr_n91321056)
print v(xbgr.mr_n91525232)
print v(xbgr.mr_n91652432)
print v(xbgr.mr_n91839424)
print v(xbgr.mr_n91960480)
print v(xbgr.mr_n92093856)
print v(xbgr.mr_n92276208)
print v(xbgr.mr_n89454736)
print v(xbgr.mr_n89238672)
print v(xbgr.mr_n89769360)
print v(xbgr.mr_n90004720)
print v(xbgr.mr_n89455664)
print v(xbgr.mr_n89297264)
print v(xbgr.mr_n89769952)
print v(xbgr.mr_n90005312)
print v(xbgr.mr_n89450800)
print v(xbgr.mr_n89338688)
print v(xbgr.mr_n89770544)
print v(xbgr.mr_n90005904)
print v(xbgr.mr_n89456592)
print v(xbgr.mr_n89476256)
print v(xbgr.mr_n89771136)
print v(xbgr.mr_n89988144)
print v(xbgr.mr_n90086048)
print v(xbgr.mr_n89936496)
print v(xbgr.mr_n90222480)
print v(xbgr.mr_n90334400)
print v(xbgr.mr_n90396864)
print v(xbgr.mr_n90534736)
print v(xbgr.mr_n90669792)
print v(xbgr.mr_n90773232)
print v(xbgr.mr_n90862144)
print v(xbgr.mr_n91088768)
print v(xbgr.mr_n91220656)
print v(xbgr.mr_n91344224)
print v(xbgr.mr_n91522032)
print v(xbgr.mr_n91655008)
print v(xbgr.mr_n91837248)
print v(xbgr.mr_n91972864)
print v(xbgr.mr_n92089952)
print v(xbgr.mr_n92271792)
print v(xbgr.mr_n89456128)
print v(xbgr.mr_n89379792)
print v(xbgr.mr_n89771728)
print v(xbgr.mr_n89996432)
print v(xbgr.mr_n90094880)
print v(xbgr.mr_n90144592)
print v(xbgr.mr_n90194704)
print v(xbgr.mr_n90323568)
print v(xbgr.mr_n90415600)
print v(xbgr.mr_n90512704)
print v(xbgr.mr_n90619056)
print v(xbgr.mr_n90780032)
print v(xbgr.mr_n90871088)
print v(xbgr.mr_n91096448)
print v(xbgr.mr_n91222864)
print v(xbgr.mr_n91348240)
print v(xbgr.mr_n91502848)
print v(xbgr.mr_n91631472)
print v(xbgr.mr_n91762976)
print v(xbgr.mr_n91976880)
print v(xbgr.mr_n92098096)
print v(xbgr.mr_n92280960)
print v(xbgr.mr_n90088288)
print v(xbgr.mr_n90132624)
print v(xbgr.mr_n90154288)
print v(xbgr.mr_n90268912)
print v(xbgr.mr_n90356480)
print v(xbgr.mr_n90479568)
print v(xbgr.mr_n90598832)
print v(xbgr.mr_n90765408)
print v(xbgr.mr_n90863040)
print v(xbgr.mr_n91038256)
print v(xbgr.mr_n91211408)
print v(xbgr.mr_n91286928)
print v(xbgr.mr_n91422672)
print v(xbgr.mr_n91593984)
print v(xbgr.mr_n91716432)
print v(xbgr.mr_n91885424)
print v(xbgr.mr_n92035568)
print v(xbgr.mr_n92276432)
print v(xbgr.mr_n89455200)
print v(xbgr.mr_n89377040)
print v(xbgr.mr_n89772320)
print v(xbgr.mr_n90007616)
print v(xbgr.mr_n90110064)
print v(xbgr.mr_n89343776)
print v(xbgr.mr_n90225648)
print v(xbgr.mr_n90340736)
print v(xbgr.mr_n90443152)
print v(xbgr.mr_n90565792)
print v(xbgr.mr_n90671056)
print v(xbgr.mr_n90799440)
print v(xbgr.mr_n90898672)
print v(xbgr.mr_n91098064)
print v(xbgr.mr_n91224560)
print v(xbgr.mr_n91344000)
print v(xbgr.mr_n91527008)
print v(xbgr.mr_n91655808)
print v(xbgr.mr_n91841488)
print v(xbgr.mr_n91974704)
print v(xbgr.mr_n92095920)
print v(xbgr.mr_n92278528)
print v(xbgr.mr_n89454272)
print v(xbgr.mr_n89338512)
print v(xbgr.mr_n89772912)
print v(xbgr.mr_n90008272)
print v(xbgr.mr_n89452880)
print v(xbgr.mr_n89277520)
print v(xbgr.n_4)
print v(xbgr.n_30)
print v(xbgr.mr_n89452416)
print v(xbgr.mr_n89274000)
print v(xbgr.mr_n89774096)
print v(xbgr.mr_n90006496)
print v(xbgr.mr_n89451616)
print v(xbgr.mr_n89237136)
print v(xbgr.mr_n89647152)
print v(xbgr.mr_n90009968)
print v(xbgr.mr_n90092560)
print v(xbgr.mr_n90044672)
print v(xbgr.mr_n90225392)
print v(xbgr.mr_n90332736)
print v(xbgr.mr_n90420464)
print v(xbgr.mr_n90535920)
print v(xbgr.mr_n90672144)
print v(xbgr.mr_n90777264)
print v(xbgr.mr_n90813648)
print v(xbgr.mr_n91088000)
print v(xbgr.mr_n91222752)
print v(xbgr.mr_n91346288)
print v(xbgr.mr_n91526832)
print v(xbgr.mr_n91654032)
print v(xbgr.mr_n91842752)
print v(xbgr.mr_n91972640)
print v(xbgr.mr_n92057664)
print v(xbgr.mr_n92278752)
print v(xbgr.mr_n90097456)
print v(xbgr.mr_n90142064)
print v(xbgr.mr_n90191792)
print v(xbgr.mr_n90319856)
print v(xbgr.mr_n90289952)
print v(xbgr.mr_n90509024)
print v(xbgr.mr_n90615376)
print v(xbgr.mr_n90782928)
print v(xbgr.mr_n90866272)
print v(xbgr.mr_n91098768)
print v(xbgr.mr_n91225184)
print v(xbgr.mr_n91350304)
print v(xbgr.mr_n91446512)
print v(xbgr.mr_n91635264)
print v(xbgr.mr_n91759296)
print v(xbgr.mr_n91978944)
print v(xbgr.mr_n92100160)
print v(xbgr.mr_n92283280)
print v(xbgr.mr_n89451072)
print v(xbgr.mr_n89377648)
print v(xbgr.mr_n89775280)
print v(xbgr.mr_n90010640)
print v(xbgr.mr_n90084880)
print v(xbgr.mr_n90132352)
print v(xbgr.mr_n90153824)
print v(xbgr.mr_n90268448)
print v(xbgr.mr_n90356016)
print v(xbgr.mr_n90480416)
print v(xbgr.mr_n90598368)
print v(xbgr.mr_n90772288)
print v(xbgr.mr_n90817504)
print v(xbgr.mr_n91052912)
print v(xbgr.mr_n91220432)
print v(xbgr.mr_n91286336)
print v(xbgr.mr_n91422080)
print v(xbgr.mr_n91595760)
print v(xbgr.mr_n91715840)
print v(xbgr.mr_n91885152)
print v(xbgr.mr_n92037344)
print v(xbgr.mr_n92273776)
print v(xbgr.mr_n89450256)
print v(xbgr.mr_n89352224)
print v(xbgr.mr_n89775872)
print v(xbgr.mr_n90011232)
print v(xbgr.mr_n90112000)
print v(xbgr.mr_n89261568)
print v(xbgr.mr_n90227840)
print v(xbgr.mr_n90336480)
print v(xbgr.mr_n90442352)
print v(xbgr.mr_n90566192)
print v(xbgr.mr_n90672992)
print v(xbgr.mr_n90800320)
print v(xbgr.mr_n90899232)
print v(xbgr.mr_n91088256)
print v(xbgr.mr_n91226880)
print v(xbgr.mr_n91346064)
print v(xbgr.mr_n91527808)
print v(xbgr.mr_n91656608)
print v(xbgr.mr_n91843088)
print v(xbgr.mr_n91976768)
print v(xbgr.mr_n92097984)
print v(xbgr.mr_n92280848)
print v(xbgr.mr_n89449984)
print v(xbgr.mr_n89326992)
print v(xbgr.mr_n89776464)
print v(xbgr.mr_n90011824)
print v(xbgr.mr_n89449440)
print v(xbgr.mr_n89294416)
print v(xbgr.mr_n89777056)
print v(xbgr.mr_n90012416)
print v(xbgr.mr_n89448896)
print v(xbgr.mr_n89377792)
print v(xbgr.mr_n89777648)
print v(xbgr.mr_n89998208)
print v(xbgr.mr_n90091808)
print v(xbgr.mr_n89287648)
print v(xbgr.mr_n90226240)
print v(xbgr.mr_n90342704)
print v(xbgr.mr_n90404160)
print v(xbgr.mr_n90537104)
print v(xbgr.mr_n90674592)
print v(xbgr.mr_n90776064)
print v(xbgr.mr_n90894496)
print v(xbgr.mr_n91088512)
print v(xbgr.mr_n91225296)
print v(xbgr.mr_n91348352)
print v(xbgr.mr_n91527632)
print v(xbgr.mr_n91656432)
print v(xbgr.mr_n91842576)
print v(xbgr.mr_n91976992)
print v(xbgr.mr_n92098208)
print v(xbgr.mr_n92281072)
print v(xbgr.mr_n89428256)
print v(xbgr.mr_n89474704)
print v(xbgr.mr_n89778240)
print v(xbgr.mr_n90013600)
print v(xbgr.mr_n90100640)
print v(xbgr.mr_n90140800)
print v(xbgr.mr_n90197472)
print v(xbgr.mr_n90318048)
print v(xbgr.mr_n90423280)
print v(xbgr.mr_n90507184)
print v(xbgr.mr_n90613536)
print v(xbgr.mr_n90786752)
print v(xbgr.mr_n90930928)
print v(xbgr.mr_n90895296)
print v(xbgr.mr_n90980112)
print v(xbgr.mr_n91227504)
print v(xbgr.mr_n91352368)
print v(xbgr.mr_n91000848)
print v(xbgr.mr_n91639056)
print v(xbgr.mr_n91757456)
print v(xbgr.mr_n91981008)
print v(xbgr.mr_n92102336)
print v(xbgr.mr_n92285600)
print v(xbgr.mr_n90094048)
print v(xbgr.mr_n90132080)
print v(xbgr.mr_n90152976)
print v(xbgr.mr_n90267520)
print v(xbgr.mr_n90355088)
print v(xbgr.mr_n90481184)
print v(xbgr.mr_n90597440)
print v(xbgr.mr_n90779200)
print v(xbgr.mr_n91052448)
print v(xbgr.mr_n91211632)
print v(xbgr.mr_n91285152)
print v(xbgr.mr_n91420896)
print v(xbgr.mr_n91594928)
print v(xbgr.mr_n91714656)
print v(xbgr.mr_n91884608)
print v(xbgr.mr_n92055296)
print v(xbgr.mr_n92278416)
print v(xbgr.mr_n89447808)
print v(xbgr.mr_n89314336)
print v(xbgr.mr_n89778832)
print v(xbgr.mr_n90014192)
print v(xbgr.mr_n90112640)
print v(xbgr.mr_n89224816)
print v(xbgr.mr_n90229296)
print v(xbgr.mr_n90343136)
print v(xbgr.mr_n90441552)
print v(xbgr.mr_n90566592)
print v(xbgr.mr_n90675248)
print v(xbgr.mr_n90793520)
print v(xbgr.mr_n90896896)
print v(xbgr.mr_n91096560)
print v(xbgr.mr_n91227392)
print v(xbgr.mr_n91350416)
print v(xbgr.mr_n91469392)
print v(xbgr.mr_n91657408)
print v(xbgr.mr_n91844432)
print v(xbgr.mr_n91978832)
print v(xbgr.mr_n92100048)
print v(xbgr.mr_n92283168)
print v(xbgr.mr_n89447264)
print v(xbgr.mr_n89354048)
print v(xbgr.mr_n89779424)
print v(xbgr.mr_n90014784)
print v(xbgr.mr_n89444352)
print v(xbgr.mr_n89359520)
print v(xbgr.mr_n89780016)
print v(xbgr.mr_n90015376)
print v(xbgr.mr_n89446176)
print v(xbgr.mr_n89477104)
print v(xbgr.n_5)
print v(xbgr.mr_n90015968)
print v(xbgr.mr_n89445360)
print v(xbgr.mr_n89477744)
print v(xbgr.mr_n89781200)
print v(xbgr.mr_n90016560)
print v(xbgr.mr_n90090864)
print v(xbgr.mr_n89306592)
print v(xbgr.mr_n90227088)
print v(xbgr.mr_n90338880)
print v(xbgr.mr_n90290064)
print v(xbgr.mr_n90538288)
print v(xbgr.mr_n90675760)
print v(xbgr.mr_n90775120)
print v(xbgr.mr_n90865104)
print v(xbgr.mr_n91098880)
print v(xbgr.mr_n91225072)
print v(xbgr.mr_n91348128)
print v(xbgr.mr_n91522208)
print v(xbgr.mr_n91655632)
print v(xbgr.mr_n91844000)
print v(xbgr.mr_n91979056)
print v(xbgr.mr_n92079856)
print v(xbgr.mr_n92269472)
print v(xbgr.mr_n90096512)
print v(xbgr.mr_n90138272)
print v(xbgr.mr_n90200112)
print v(xbgr.mr_n90315392)
print v(xbgr.mr_n90426688)
print v(xbgr.mr_n90503952)
print v(xbgr.mr_n90610560)
print v(xbgr.mr_n90781984)
print v(xbgr.mr_n90922896)
print v(xbgr.mr_n90922400)
print v(xbgr.mr_n90992496)
print v(xbgr.mr_n91229824)
print v(xbgr.mr_n91354432)
print v(xbgr.mr_n91448624)
print v(xbgr.mr_n91234912)
print v(xbgr.mr_n91753776)
print v(xbgr.mr_n91983072)
print v(xbgr.mr_n92104656)
print v(xbgr.mr_n92287920)
print v(xbgr.mr_n89445088)
print v(xbgr.mr_n89478208)
print v(xbgr.mr_n89781792)
print v(xbgr.mr_n90017152)
print v(xbgr.mr_n90094992)
print v(xbgr.mr_n90131808)
print v(xbgr.mr_n89468784)
print v(xbgr.mr_n90267056)
print v(xbgr.mr_n90354624)
print v(xbgr.mr_n90482112)
print v(xbgr.mr_n90597056)
print v(xbgr.mr_n90780144)
print v(xbgr.mr_n91051984)
print v(xbgr.mr_n91119600)
print v(xbgr.mr_n91284560)
print v(xbgr.mr_n91420304)
print v(xbgr.mr_n91598848)
print v(xbgr.mr_n91714064)
print v(xbgr.mr_n91884336)
print v(xbgr.mr_n92094080)
print v(xbgr.mr_n92283392)
print v(xbgr.mr_n89443808)
print v(xbgr.mr_n89363776)
print v(xbgr.mr_n89773504)
print v(xbgr.mr_n90007088)
print v(xbgr.mr_n90113440)
print v(xbgr.mr_n89254944)
print v(xbgr.mr_n90230176)
print v(xbgr.mr_n90338704)
print v(xbgr.mr_n90440752)
print v(xbgr.mr_n90566992)
print v(xbgr.mr_n90677104)
print v(xbgr.mr_n90802672)
print v(xbgr.mr_n90922160)
print v(xbgr.mr_n90994016)
print v(xbgr.mr_n91231520)
print v(xbgr.mr_n91350192)
print v(xbgr.mr_n91529408)
print v(xbgr.mr_n91658208)
print v(xbgr.mr_n91846656)
print v(xbgr.mr_n91964608)
print v(xbgr.mr_n92096144)
print v(xbgr.mr_n92285488)
print v(xbgr.mr_n89405136)
print v(xbgr.mr_n89611488)
print v(xbgr.mr_n89782976)
print v(xbgr.mr_n90009456)
print v(xbgr.mr_n89405600)
print v(xbgr.mr_n89603792)
print v(xbgr.mr_n89783568)
print v(xbgr.mr_n90002880)
print v(xbgr.mr_n89406064)
print v(xbgr.mr_n89591568)
print v(xbgr.mr_n89784160)
print v(xbgr.mr_n90016896)
print v(xbgr.mr_n89406528)
print v(xbgr.mr_n89588032)
print v(xbgr.mr_n89784752)
print v(xbgr.mr_n90002272)
print v(xbgr.mr_n90085104)
print v(xbgr.mr_n89347056)
print v(xbgr.mr_n90230608)
print v(xbgr.mr_n90332000)
print v(xbgr.mr_n90411456)
print v(xbgr.mr_n90539472)
print v(xbgr.mr_n90678288)
print v(xbgr.mr_n90768240)
print v(xbgr.mr_n90923472)
print v(xbgr.mr_n90990304)
print v(xbgr.mr_n91229712)
print v(xbgr.mr_n91354320)
print v(xbgr.mr_n91526208)
print v(xbgr.mr_n91651632)
print v(xbgr.mr_n91844176)
print v(xbgr.mr_n91974928)
print v(xbgr.mr_n92104432)
print v(xbgr.mr_n92271456)
print v(xbgr.mr_n90090752)
print v(xbgr.mr_n90137328)
print v(xbgr.mr_n90198784)
print v(xbgr.mr_n90314064)
print v(xbgr.mr_n90304752)
print v(xbgr.mr_n90502624)
print v(xbgr.mr_n90609232)
print v(xbgr.mr_n90775008)
print v(xbgr.mr_n90897696)
print v(xbgr.mr_n90939792)
print v(xbgr.mr_n90996720)
print v(xbgr.mr_n91232144)
print v(xbgr.mr_n91356496)
print v(xbgr.mr_n91475184)
print v(xbgr.mr_n91514416)
print v(xbgr.mr_n91751936)
print v(xbgr.mr_n91985136)
print v(xbgr.mr_n92106976)
print v(xbgr.mr_n92290240)
print v(xbgr.mr_n90089232)
print v(xbgr.mr_n90131616)
print v(xbgr.mr_n89263568)
print v(xbgr.mr_n90266128)
print v(xbgr.mr_n90353696)
print v(xbgr.mr_n90481648)
print v(xbgr.mr_n90596448)
print v(xbgr.mr_n90770384)
print v(xbgr.mr_n91051520)
print v(xbgr.mr_n91228960)
print v(xbgr.mr_n91283568)
print v(xbgr.mr_n91419312)
print v(xbgr.mr_n91599456)
print v(xbgr.mr_n91712880)
print v(xbgr.mr_n91883792)
print v(xbgr.mr_n92102448)
print v(xbgr.mr_n92276096)
print v(xbgr.mr_n89406992)
print v(xbgr.mr_n89535584)
print v(xbgr.mr_n89785344)
print v(xbgr.mr_n89751296)
print v(xbgr.mr_n89407456)
print v(xbgr.mr_n89536368)
print v(xbgr.mr_n89785936)
print v(xbgr.mr_n89979936)
print v(xbgr.mr_n90114240)
print v(xbgr.mr_n89513600)
print v(xbgr.mr_n90232208)
print v(xbgr.mr_n90342176)
print v(xbgr.mr_n90439952)
print v(xbgr.mr_n90567392)
print v(xbgr.mr_n90666480)
print v(xbgr.mr_n90803392)
print v(xbgr.mr_n90859680)
print v(xbgr.mr_n90993008)
print v(xbgr.mr_n91233840)
print v(xbgr.mr_n91340096)
print v(xbgr.mr_n91530208)
print v(xbgr.mr_n91659008)
print v(xbgr.mr_n91848176)
print v(xbgr.mr_n91982960)
print v(xbgr.mr_n92104544)
print v(xbgr.mr_n92287808)
print v(xbgr.mr_n89407920)
print v(xbgr.mr_n89582992)
print v(xbgr.mr_n89786528)
print v(xbgr.mr_n89985248)
print v(xbgr.mr_n89408384)
print v(xbgr.mr_n89591872)
print v(xbgr.mr_n89787120)
print v(xbgr.mr_n89984512)
print v(xbgr.mr_n89408848)
print v(xbgr.mr_n89612256)
print v(xbgr.mr_n89787712)
print v(xbgr.n_31)
print v(xbgr.mr_n90079344)
print v(xbgr.mr_n89967888)
print v(xbgr.mr_n90219216)
print v(xbgr.mr_n90336304)
print v(xbgr.mr_n90340480)
print v(xbgr.mr_n90540656)
print v(xbgr.mr_n90679472)
print v(xbgr.mr_n90756560)
print v(xbgr.mr_n90924032)
print v(xbgr.mr_n90997728)
print v(xbgr.mr_n91222976)
print v(xbgr.mr_n91354544)
print v(xbgr.mr_n91523632)
print v(xbgr.mr_n91658032)
print v(xbgr.mr_n91849328)
print v(xbgr.mr_n91983184)
print v(xbgr.mr_n92081360)
print v(xbgr.mr_n92274112)
print v(xbgr.mr_n89409312)
print v(xbgr.mr_n89612432)
print v(xbgr.mr_n89788304)
print v(xbgr.mr_n90017856)
print v(xbgr.mr_n90084992)
print v(xbgr.mr_n90135824)
print v(xbgr.mr_n90196144)
print v(xbgr.mr_n90311408)
print v(xbgr.mr_n90422784)
print v(xbgr.mr_n90499968)
print v(xbgr.mr_n90606576)
print v(xbgr.mr_n90768128)
print v(xbgr.mr_n90936752)
print v(xbgr.mr_n90940192)
print v(xbgr.mr_n90991120)
print v(xbgr.mr_n91164688)
print v(xbgr.mr_n91358560)
print v(xbgr.mr_n91503552)
print v(xbgr.mr_n91637936)
print v(xbgr.mr_n91748256)
print v(xbgr.mr_n91987200)
print v(xbgr.mr_n92109296)
print v(xbgr.mr_n92292944)
print v(xbgr.mr_n90083472)
print v(xbgr.mr_n90131504)
print v(xbgr.mr_n89882608)
print v(xbgr.mr_n90265664)
print v(xbgr.mr_n90353232)
print v(xbgr.mr_n90480720)
print v(xbgr.mr_n90596144)
print v(xbgr.mr_n90689936)
print v(xbgr.mr_n91051056)
print v(xbgr.mr_n91229936)
print v(xbgr.mr_n91283104)
print v(xbgr.mr_n91418848)
print v(xbgr.mr_n91599120)
print v(xbgr.mr_n91712288)
print v(xbgr.mr_n91883600)
print v(xbgr.mr_n92102224)
print v(xbgr.mr_n92280736)
print v(xbgr.mr_n89384720)
print v(xbgr.mr_n89613328)
print v(xbgr.mr_n89788896)
print v(xbgr.mr_n89288080)
print v(xbgr.mr_n90115360)
print v(xbgr.mr_n89279136)
print v(xbgr.mr_n90233088)
print v(xbgr.mr_n90339776)
print v(xbgr.mr_n90439152)
print v(xbgr.mr_n90567792)
print v(xbgr.mr_n90680736)
print v(xbgr.mr_n90804032)
print v(xbgr.mr_n90925456)
print v(xbgr.mr_n90992080)
print v(xbgr.mr_n91200256)
print v(xbgr.mr_n91352480)
print v(xbgr.mr_n91531008)
print v(xbgr.mr_n91659808)
print v(xbgr.mr_n91849920)
print v(xbgr.mr_n91985024)
print v(xbgr.mr_n92104768)
print v(xbgr.mr_n92290128)
print v(xbgr.mr_n89410240)
print v(xbgr.mr_n89614016)
print v(xbgr.mr_n89789488)
print v(xbgr.mr_n90019184)
print v(xbgr.mr_n89410704)
print v(xbgr.n_34)
print v(xbgr.mr_n89790080)
print v(xbgr.mr_n89285264)
print v(xbgr.mr_n89411168)
print v(xbgr.mr_n89615200)
print v(xbgr.mr_n89790672)
print v(xbgr.mr_n90020672)
print v(xbgr.mr_n89411632)
print v(xbgr.mr_n89615792)
print v(xbgr.mr_n89791264)
print v(xbgr.mr_n90021552)
print v(xbgr.mr_n90073584)
print v(xbgr.mr_n89262784)
print v(xbgr.mr_n90231456)
print v(xbgr.mr_n90333264)
print v(xbgr.mr_n90358800)
print v(xbgr.mr_n90541840)
print v(xbgr.mr_n90680320)
print v(xbgr.mr_n90754416)
print v(xbgr.mr_n90929264)
print v(xbgr.mr_n91000432)
print v(xbgr.mr_n91218112)
print v(xbgr.mr_n91356608)
print v(xbgr.mr_n91529232)
print v(xbgr.mr_n91619200)
print v(xbgr.mr_n91845136)
print v(xbgr.mr_n91985248)
print v(xbgr.mr_n92102112)
print v(xbgr.mr_n92287696)
print v(xbgr.mr_n90079232)
print v(xbgr.mr_n90135072)
print v(xbgr.mr_n90194816)
print v(xbgr.mr_n90310080)
print v(xbgr.mr_n90415488)
print v(xbgr.mr_n90497168)
print v(xbgr.mr_n90603776)
print v(xbgr.mr_n90761216)
print v(xbgr.mr_n90950080)
print v(xbgr.mr_n90935024)
print v(xbgr.mr_n90979584)
print v(xbgr.mr_n91223536)
print v(xbgr.mr_n91360624)
print v(xbgr.mr_n91001136)
print v(xbgr.mr_n91511024)
print v(xbgr.mr_n91746416)
print v(xbgr.mr_n91989264)
print v(xbgr.mr_n92111616)
print v(xbgr.mr_n92297376)
print v(xbgr.mr_n89412096)
print v(xbgr.mr_n89616384)
print v(xbgr.mr_n89791856)
print v(xbgr.mr_n90022144)
print v(xbgr.mr_n90077712)
print v(xbgr.mr_n90130496)
print v(xbgr.mr_n89254448)
print v(xbgr.mr_n90264736)
print v(xbgr.mr_n90352304)
print v(xbgr.mr_n90480528)
print v(xbgr.mr_n90564192)
print v(xbgr.mr_n90689744)
print v(xbgr.mr_n91050592)
print v(xbgr.mr_n91199008)
print v(xbgr.mr_n91282176)
print v(xbgr.mr_n91417920)
print v(xbgr.mr_n91598576)
print v(xbgr.mr_n91711168)
print v(xbgr.mr_n91878112)
print v(xbgr.mr_n92109072)
print v(xbgr.mr_n92283056)
print v(xbgr.mr_n89392608)
print v(xbgr.mr_n89616976)
print v(xbgr.mr_n89774688)
print v(xbgr.mr_n90022736)
print v(xbgr.mr_n90116240)
print v(xbgr.mr_n89234832)
print v(xbgr.mr_n90235120)
print v(xbgr.mr_n90337376)
print v(xbgr.mr_n90438352)
print v(xbgr.mr_n90568192)
print v(xbgr.mr_n90682192)
print v(xbgr.mr_n90805008)
print v(xbgr.mr_n90942160)
print v(xbgr.mr_n90981408)
print v(xbgr.mr_n91232896)
print v(xbgr.mr_n91335968)
print v(xbgr.mr_n91531808)
print v(xbgr.mr_n91657232)
print v(xbgr.mr_n91851664)
print v(xbgr.mr_n91987088)
print v(xbgr.mr_n92109184)
print v(xbgr.mr_n92292448)
print v(xbgr.mr_n89413024)
print v(xbgr.mr_n89617568)
print v(xbgr.mr_n89793040)
print v(xbgr.mr_n90023328)
print v(xbgr.mr_n89413488)
print v(xbgr.mr_n89618160)
print v(xbgr.mr_n89793632)
print v(xbgr.mr_n90003536)
print v(xbgr.mr_n89413952)
print v(xbgr.mr_n89618752)
print v(xbgr.mr_n89794224)
print v(xbgr.mr_n90024512)
print v(xbgr.mr_n89409776)
print v(xbgr.mr_n89619344)
print v(xbgr.n_10)
print v(xbgr.mr_n89936352)
print v(xbgr.mr_n90066208)
print v(xbgr.mr_n89519680)
print v(xbgr.mr_n90232912)
print v(xbgr.mr_n90306160)
print v(xbgr.mr_n90391632)
print v(xbgr.mr_n90543024)
print v(xbgr.mr_n90682784)
print v(xbgr.mr_n90689632)
print v(xbgr.mr_n90942272)
print v(xbgr.mr_n91025776)
print v(xbgr.mr_n91199648)
print v(xbgr.mr_n91358672)
print v(xbgr.mr_n91530032)
print v(xbgr.mr_n91660432)
print v(xbgr.mr_n91847840)
print v(xbgr.mr_n91881232)
print v(xbgr.mr_n92109408)
print v(xbgr.mr_n92288032)
print v(xbgr.mr_n90073472)
print v(xbgr.mr_n90134128)
print v(xbgr.mr_n90193616)
print v(xbgr.mr_n90307616)
print v(xbgr.mr_n90408192)
print v(xbgr.mr_n90497424)
print v(xbgr.mr_n90604032)
print v(xbgr.mr_n90754304)
print v(xbgr.mr_n90953376)
print v(xbgr.mr_n90942384)
print v(xbgr.mr_n90978976)
print v(xbgr.mr_n91202896)
print v(xbgr.mr_n91362688)
print v(xbgr.mr_n90966128)
print v(xbgr.mr_n91515376)
print v(xbgr.mr_n91743872)
print v(xbgr.mr_n91991328)
print v(xbgr.mr_n92113936)
print v(xbgr.mr_n92301808)
print v(xbgr.mr_n90071952)
print v(xbgr.mr_n90129184)
print v(xbgr.mr_n89283536)
print v(xbgr.mr_n90264272)
print v(xbgr.mr_n90351840)
print v(xbgr.mr_n90479024)
print v(xbgr.mr_n90558608)
print v(xbgr.mr_n90688576)
print v(xbgr.mr_n91050128)
print v(xbgr.mr_n91232784)
print v(xbgr.mr_n91281712)
print v(xbgr.mr_n91417456)
print v(xbgr.mr_n91593152)
print v(xbgr.mr_n91710704)
print v(xbgr.mr_n91881408)
print v(xbgr.mr_n92106864)
print v(xbgr.mr_n92293056)
print v(xbgr.mr_n89414880)
print v(xbgr.mr_n89619936)
print v(xbgr.mr_n89795408)
print v(xbgr.mr_n90025696)
print v(xbgr.mr_n89415344)
print v(xbgr.mr_n89620528)
print v(xbgr.mr_n89796000)
print v(xbgr.mr_n90026288)
print v(xbgr.mr_n90116800)
print v(xbgr.mr_n90040384)
print v(xbgr.mr_n90234544)
print v(xbgr.mr_n90335136)
print v(xbgr.mr_n90392144)
print v(xbgr.mr_n90568592)
print v(xbgr.mr_n90684128)
print v(xbgr.mr_n90805888)
print v(xbgr.mr_n90946384)
print v(xbgr.mr_n91091056)
print v(xbgr.mr_n91203136)
print v(xbgr.mr_n91360512)
print v(xbgr.mr_n91532608)
print v(xbgr.mr_n91661408)
print v(xbgr.mr_n91851328)
print v(xbgr.mr_n91970800)
print v(xbgr.mr_n92111504)
print v(xbgr.mr_n92296816)
print v(xbgr.mr_n89415808)
print v(xbgr.mr_n89621120)
print v(xbgr.mr_n89796592)
print v(xbgr.mr_n90026880)
print v(xbgr.mr_n89416272)
print v(xbgr.mr_n89621712)
print v(xbgr.mr_n89797184)
print v(xbgr.mr_n90018560)
print v(xbgr.mr_n89416736)
print v(xbgr.mr_n89622304)
print v(xbgr.mr_n89797776)
print v(xbgr.mr_n90028064)
print v(xbgr.mr_n90055904)
print v(xbgr.mr_n89290896)
print v(xbgr.mr_n90230832)
print v(xbgr.mr_n90161088)
print v(xbgr.mr_n90341440)
print v(xbgr.mr_n90544208)
print v(xbgr.mr_n90683632)
print v(xbgr.mr_n90687840)
print v(xbgr.mr_n90925648)
print v(xbgr.mr_n90979088)
print v(xbgr.mr_n91213696)
print v(xbgr.mr_n91360736)
print v(xbgr.mr_n91531632)
print v(xbgr.mr_n91511136)
print v(xbgr.mr_n91854592)
print v(xbgr.mr_n91966672)
print v(xbgr.mr_n92111728)
print v(xbgr.mr_n92285712)
print v(xbgr.mr_n89417200)
print v(xbgr.mr_n89622896)
print v(xbgr.mr_n89798368)
print v(xbgr.mr_n90028656)
print v(xbgr.mr_n90067488)
print v(xbgr.mr_n90133936)
print v(xbgr.mr_n90156608)
print v(xbgr.mr_n90306864)
print v(xbgr.mr_n90400896)
print v(xbgr.mr_n90499856)
print v(xbgr.mr_n90606464)
print v(xbgr.mr_n90744608)
print v(xbgr.mr_n90936256)
print v(xbgr.mr_n90944272)
print v(xbgr.mr_n90974256)
print v(xbgr.mr_n90993712)
print v(xbgr.mr_n91364752)
print v(xbgr.mr_n91199392)
print v(xbgr.mr_n91638048)
print v(xbgr.mr_n91743616)
print v(xbgr.mr_n91993392)
print v(xbgr.mr_n92116256)
print v(xbgr.mr_n92306240)
print v(xbgr.mr_n90065824)
print v(xbgr.mr_n90129840)
print v(xbgr.mr_n89909472)
print v(xbgr.mr_n90263424)
print v(xbgr.mr_n90340304)
print v(xbgr.mr_n90476544)
print v(xbgr.mr_n90558880)
print v(xbgr.mr_n90687488)
print v(xbgr.mr_n91034960)
print v(xbgr.mr_n91122928)
print v(xbgr.mr_n91256480)
print v(xbgr.mr_n91387616)
print v(xbgr.mr_n91596704)
print v(xbgr.mr_n91658832)
print v(xbgr.mr_n91882144)
print v(xbgr.mr_n92100272)
print v(xbgr.mr_n92290016)
print v(xbgr.mr_n89417664)
print v(xbgr.mr_n89623488)
print v(xbgr.mr_n89798960)
print v(xbgr.mr_n90029248)
print v(xbgr.mr_n90117680)
print v(xbgr.mr_n89268080)
print v(xbgr.mr_n90237872)
print v(xbgr.mr_n90276896)
print v(xbgr.mr_n90425088)
print v(xbgr.mr_n90568992)
print v(xbgr.mr_n90685984)
print v(xbgr.mr_n90806864)
print v(xbgr.mr_n90952912)
print v(xbgr.mr_n90975248)
print v(xbgr.mr_n91235504)
print v(xbgr.mr_n91335744)
print v(xbgr.mr_n91533408)
print v(xbgr.mr_n91659632)
print v(xbgr.mr_n91855088)
print v(xbgr.mr_n91991216)
print v(xbgr.mr_n92113824)
print v(xbgr.mr_n92301248)
print v(xbgr.mr_n89400496)
print v(xbgr.mr_n89624080)
print v(xbgr.mr_n89799552)
print v(xbgr.mr_n90029840)
print v(xbgr.mr_n89418592)
print v(xbgr.mr_n89595232)
print v(xbgr.mr_n89782384)
print v(xbgr.mr_n90030432)
print v(xbgr.mr_n89419056)
print v(xbgr.mr_n89625200)
print v(xbgr.mr_n89800736)
print v(xbgr.mr_n90017744)
print v(xbgr.mr_n89419520)
print v(xbgr.mr_n89625856)
print v(xbgr.mr_n89801328)
print v(xbgr.mr_n90031616)
print v(xbgr.mr_n89419920)
print v(xbgr.mr_n89626448)
print v(xbgr.mr_n89801920)
print v(xbgr.mr_n90032208)
print v(xbgr.mr_n89418128)
print v(xbgr.mr_n89627024)
print v(xbgr.mr_n89802512)
print v(xbgr.mr_n90032800)
print v(xbgr.mr_n89420848)
print v(xbgr.mr_n89627616)
print v(xbgr.mr_n89803104)
print v(xbgr.mr_n90033392)
print v(xbgr.mr_n89421312)
print v(xbgr.mr_n89628208)
print v(xbgr.mr_n89803696)
print v(xbgr.mr_n90033984)
print v(xbgr.mr_n90305264)
print v(xbgr.mr_n91855600)
print v(xbgr.mr_n92089728)
print v(xbgr.mr_n92285376)
print v(xbgr.mr_n89421760)
print v(xbgr.mr_n89628800)
print v(xbgr.mr_n89804288)
print v(xbgr.mr_n90025104)
print v(xbgr.d5)
print v(xbgr.d1)
print v(xbgr.mr_n90277632)
print v(xbgr.mr_n90685312)
print v(xbgr.mr_n90130976)
print v(xbgr.mr_n90236064)
print v(xbgr.mr_n90686720)
print v(xbgr.mr_n91849504)
print v(xbgr.n1)
print v(xbgr.mr_n92305568)
print v(xbgr.mr_n89422224)
print v(xbgr.mr_n89629392)
print v(xbgr.mr_n89804880)
print v(xbgr.mr_n90035168)
print v(xbgr.mr_n91654832)
print v(xbgr.mr_n91886784)
print v(xbgr.mr_n92128512)
print v(xbgr.mr_n90064528)
print v(xbgr.mr_n89263024)
print v(xbgr.kick)
print v(xbgr.mr_n90496912)
print v(xbgr.mr_n91852928)
print v(xbgr.mr_n92046512)
print v(xbgr.mr_n92305680)
print v(xbgr.mr_n89422688)
print v(xbgr.mr_n89629984)
print v(xbgr.mr_n89805472)
print v(xbgr.mr_n90036352)
print v(xbgr.mr_n89423152)
print v(xbgr.mr_n89442800)
print v(xbgr.mr_n89806064)
print v(xbgr.mr_n90036944)
print v(xbgr.mr_n90098320)
print v(xbgr.mr_n90185744)
print v(xbgr.mr_n90281552)
print v(xbgr.mr_n90686496)
print v(xbgr.mr_n91854416)
print v(xbgr.mr_n92113712)
print v(xbgr.mr_n92306352)
print v(xbgr.mr_n90806512)
print v(xbgr.mr_n90949792)
print v(xbgr.mr_n91019024)
print v(xbgr.mr_n90978368)
print v(xbgr.mr_n91352256)
print v(xbgr.mr_n91498160)
print v(xbgr.mr_n91630576)
print v(xbgr.mr_n90804832)
print v(xbgr.mr_n90952720)
print v(xbgr.mr_n90971520)
print v(xbgr.mr_n90979696)
print v(xbgr.mr_n91356384)
print v(xbgr.mr_n91502960)
print v(xbgr.mr_n91635376)
print v(xbgr.mr_n89400960)
print v(xbgr.mr_n89631168)
print v(xbgr.mr_n89806656)
print v(xbgr.mr_n90037536)
print v(xbgr.mr_n91856176)
print v(xbgr.mr_n92045584)
print v(xbgr.mr_n92292336)
print v(xbgr.mr_n90704352)
print v(xbgr.mr_n90290816)
print v(xbgr.mr_n90859824)
print v(xbgr.mr_n91042176)
print v(xbgr.mr_n91255264)
print v(xbgr.mr_n91384928)
print v(xbgr.mr_n91528608)
print v(xbgr.mr_n91673664)
print v(xbgr.mr_n91917168)
print v(xbgr.mr_n92132768)
print v(xbgr.mr_n89424080)
print v(xbgr.mr_n89631760)
print v(xbgr.mr_n89807248)
print v(xbgr.mr_n89981200)
print v(xbgr.mr_n91853856)
print v(xbgr.mr_n92047712)
print v(xbgr.mr_n92290352)
print v(xbgr.mr_n90303840)
print v(xbgr.mr_n90807600)
print v(xbgr.d2)
print v(xbgr.mr_n91018912)
print v(xbgr.mr_n90988240)
print v(xbgr.mr_n91364864)
print v(xbgr.mr_n91457648)
print v(xbgr.mr_n91587824)
print v(xbgr.mr_n90127216)
print v(xbgr.mr_n90235632)
print v(xbgr.mr_n90686608)
print v(xbgr.mr_n89424544)
print v(xbgr.mr_n89632352)
print v(xbgr.mr_n89807840)
print v(xbgr.mr_n90038720)
print v(xbgr.mr_n90128528)
print v(xbgr.mr_n90236416)
print v(xbgr.mr_n90687216)
print v(xbgr.mr_n91856800)
print v(xbgr.mr_n92111392)
print v(xbgr.mr_n92297488)
print v(xbgr.mr_n90302272)
print v(xbgr.mr_n89425008)
print v(xbgr.mr_n89632944)
print v(xbgr.mr_n89808432)
print v(xbgr.mr_n90039904)
print v(xbgr.mr_n90065072)
print v(xbgr.mr_n89460592)
print v(xbgr.mr_n90547200)
print v(xbgr.det)
print v(xbgr.mr_n91856288)
print v(xbgr.mr_n92049376)
print v(xbgr.mr_n92296704)
print v(xbgr.mr_n90280960)
print v(xbgr.mr_n89425472)
print v(xbgr.mr_n89633536)
print v(xbgr.mr_n89809024)
print v(xbgr.mr_n90039312)
print v(xbgr.mr_n91675440)
print v(xbgr.mr_n91916576)
print v(xbgr.mr_n92133856)
print v(xbgr.mr_n90118272)
print v(xbgr.mr_n89369232)
print v(xbgr.mr_n90686832)
print v(xbgr.mr_n91857024)
print v(xbgr.mr_n91950832)
print v(xbgr.mr_n92310528)
print v(xbgr.mr_n90807488)
print v(xbgr.mr_n90957280)
print v(xbgr.mr_n91018800)
print v(xbgr.mr_n90970592)
print v(xbgr.mr_n91366704)
print v(xbgr.mr_n91497936)
print v(xbgr.mr_n91615184)
print v(xbgr.mr_n90807824)
print v(xbgr.mr_n90951408)
print v(xbgr.mr_n91018688)
print v(xbgr.mr_n91039616)
print v(xbgr.mr_n91251248)
print v(xbgr.mr_n91498048)
print v(xbgr.mr_n91630352)
print v(xbgr.mr_n89425936)
print v(xbgr.mr_n89634128)
print v(xbgr.mr_n89809616)
print v(xbgr.mr_n90019728)
print v(xbgr.mr_n90703888)
print v(xbgr.mr_n90749728)
print v(xbgr.mr_n90859040)
print v(xbgr.mr_n91042992)
print v(xbgr.mr_n91259296)
print v(xbgr.mr_n91389024)
print v(xbgr.mr_n91533952)
print v(xbgr.mr_n91855712)
print v(xbgr.mr_n92118720)
print v(xbgr.mr_n92301920)
print v(xbgr.mr_n89404208)
print v(xbgr.mr_n89634720)
print v(xbgr.mr_n89792448)
print v(xbgr.mr_n89981344)
print v(xbgr.mr_n91856912)
print v(xbgr.mr_n92051152)
print v(xbgr.mr_n92309024)
print v(xbgr.mr_n89426864)
print v(xbgr.mr_n89635312)
print v(xbgr.mr_n89810800)
print v(xbgr.mr_n90045664)
print v(xbgr.mr_n90298848)
print v(xbgr.mr_n90805712)
print v(xbgr.mr_n90940944)
print v(xbgr.mr_n91024400)
print v(xbgr.mr_n90976288)
print v(xbgr.mr_n91367424)
print v(xbgr.mr_n91458832)
print v(xbgr.mr_n91595584)
print v(xbgr.mr_n90125248)
print v(xbgr.mr_n90233744)
print v(xbgr.mr_n90685488)
print v(xbgr.mr_n91677296)
print v(xbgr.mr_n91915984)
print v(xbgr.mr_n92135264)
print v(xbgr.mr_n90127872)
print v(xbgr.mr_n90234368)
print v(xbgr.mr_n90677616)
print v(xbgr.mr_n91853104)
print v(xbgr.mr_n92051744)
print v(xbgr.mr_n92311488)
print v(xbgr.mr_n89427328)
print v(xbgr.mr_n89635904)
print v(xbgr.mr_n89811392)
print v(xbgr.mr_n90045888)
print v(xbgr.mr_n90296256)
print v(xbgr.mr_n90064800)
print v(xbgr.mr_n89585504)
print v(xbgr.mr_n90233520)
print v(xbgr.mr_n90546736)
print v(xbgr.r4n)
print v(xbgr.mr_n89427792)
print v(xbgr.mr_n89636496)
print v(xbgr.mr_n89811984)
print v(xbgr.mr_n90046000)
print v(xbgr.mr_n91857248)
print v(xbgr.mr_n92120352)
print v(xbgr.mr_n92260928)
print v(xbgr.mr_n90115104)
print v(xbgr.mr_n90182720)
print v(xbgr.mr_n90687104)
print v(xbgr.mr_n90808448)
print v(xbgr.mr_n90957888)
print v(xbgr.mr_n91015248)
print v(xbgr.mr_n90977920)
print v(xbgr.mr_n91366928)
print v(xbgr.mr_n91490576)
print v(xbgr.mr_n91630464)
print v(xbgr.mr_n90801808)
print v(xbgr.mr_n90953264)
print v(xbgr.mr_n91023264)
print v(xbgr.mr_n90978656)
print v(xbgr.mr_n91358448)
print v(xbgr.mr_n91499168)
print v(xbgr.mr_n91631584)
print v(xbgr.mr_n89423616)
print v(xbgr.mr_n89637088)
print v(xbgr.mr_n89812576)
print v(xbgr.mr_n90046112)
print v(xbgr.mr_n91858064)
print v(xbgr.mr_n92046240)
print v(xbgr.mr_n92261168)
print v(xbgr.mr_n91679152)
print v(xbgr.mr_n91915008)
print v(xbgr.mr_n92137120)
print v(xbgr.mr_n90703424)
print v(xbgr.mr_n90429792)
print v(xbgr.mr_n90842176)
print v(xbgr.mr_n91043808)
print v(xbgr.mr_n91260112)
print v(xbgr.mr_n91389840)
print v(xbgr.mr_n91534368)
print v(xbgr.mr_n89428720)
print v(xbgr.mr_n89637680)
print v(xbgr.mr_n89813168)
print v(xbgr.mr_n90046384)
print v(xbgr.mr_n91852256)
print v(xbgr.mr_n92049968)
print v(xbgr.mr_n92313872)
print v(xbgr.mr_n89429184)
print v(xbgr.mr_n89638272)
print v(xbgr.mr_n89760480)
print v(xbgr.mr_n90046656)
print v(xbgr.mr_n90270304)
print v(xbgr.mr_n90809760)
print v(xbgr.mr_n90927376)
print v(xbgr.mr_n90970480)
print v(xbgr.mr_n90975440)
print v(xbgr.mr_n91367040)
print v(xbgr.mr_n91458240)
print v(xbgr.mr_n91586048)
print v(xbgr.mr_n91855824)
print v(xbgr.mr_n92120896)
print v(xbgr.mr_n92314048)
print v(xbgr.mr_n90126560)
print v(xbgr.mr_n90228960)
print v(xbgr.mr_n90687952)
print v(xbgr.mr_n90125904)
print v(xbgr.mr_n90233632)
print v(xbgr.mr_n90688944)
print v(xbgr.mr_n89429648)
print v(xbgr.mr_n89638864)
print v(xbgr.mr_n89814352)
print v(xbgr.mr_n90047200)
print v(xbgr.mr_n91858672)
print v(xbgr.mr_n92052928)
print v(xbgr.mr_n92312368)
print v(xbgr.mr_n90230000)
print v(xbgr.mr_n90064256)
print v(xbgr.mr_n89480992)
print v(xbgr.mr_n90546272)
print v(xbgr.mr_n90237696)
print v(xbgr.mr_n91681008)
print v(xbgr.mr_n91914384)
print v(xbgr.mr_n92138976)
print v(xbgr.mr_n89430112)
print v(xbgr.mr_n89639456)
print v(xbgr.mr_n89814944)
print v(xbgr.mr_n90047472)
print v(xbgr.mr_n90278640)
print v(xbgr.mr_n91861184)
print v(xbgr.mr_n92053520)
print v(xbgr.mr_n92301136)
print v(xbgr.mr_n90114064)
print v(xbgr.mr_n90169232)
print v(xbgr.mr_n90688224)
print v(xbgr.mr_n89430576)
print v(xbgr.mr_n89640048)
print v(xbgr.mr_n89815536)
print v(xbgr.mr_n90023920)
print v(xbgr.mr_n90809584)
print v(xbgr.mr_n90958640)
print v(xbgr.mr_n91008720)
print v(xbgr.mr_n91096336)
print v(xbgr.mr_n91366816)
print v(xbgr.mr_n91471616)
print v(xbgr.mr_n91597536)
print v(xbgr.mr_n90810480)
print v(xbgr.mr_n90928720)
print v(xbgr.mr_n91022720)
print v(xbgr.mr_n91099344)
print v(xbgr.mr_n91367776)
print v(xbgr.mr_n91494144)
print v(xbgr.mr_n91626560)
print v(xbgr.mr_n91860016)
print v(xbgr.mr_n92123616)
print v(xbgr.mr_n92311312)
print v(xbgr.mr_n89431040)
print v(xbgr.mr_n89640640)
print v(xbgr.mr_n89816128)
print v(xbgr.mr_n90048016)
print v(xbgr.mr_n90702960)
print v(xbgr.mr_n90429216)
print v(xbgr.mr_n90860944)
print v(xbgr.mr_n91044544)
print v(xbgr.mr_n91260928)
print v(xbgr.mr_n91390656)
print v(xbgr.mr_n91535184)
print v(xbgr.mr_n91860752)
print v(xbgr.mr_n92054112)
print v(xbgr.mr_n92231120)
print v(xbgr.mr_n89431504)
print v(xbgr.mr_n89624672)
print v(xbgr.mr_n89816720)
print v(xbgr.mr_n90048288)
print v(xbgr.mr_n91682864)
print v(xbgr.mr_n91913920)
print v(xbgr.mr_n92140864)
print v(xbgr.mr_n90809104)
print v(xbgr.mr_n90959728)
print v(xbgr.mr_n91022912)
print v(xbgr.mr_n91099456)
print v(xbgr.mr_n91327616)
print v(xbgr.mr_n91459424)
print v(xbgr.mr_n91592032)
print v(xbgr.mr_n91862528)
print v(xbgr.mr_n92048784)
print v(xbgr.mr_n92314928)
print v(xbgr.mr_n90127040)
print v(xbgr.mr_n90228784)
print v(xbgr.d3)
print v(xbgr.mr_n90684640)
print v(xbgr.mr_n90128352)
print v(xbgr.mr_n90231632)
print v(xbgr.mr_n90478064)
print v(xbgr.mr_n90685136)
print v(xbgr.mr_n89414416)
print v(xbgr.mr_n89641760)
print v(xbgr.mr_n89817312)
print v(xbgr.mr_n90048560)
print v(xbgr.mr_n90063984)
print v(xbgr.mr_n89286416)
print v(xbgr.mr_n90347072)
print v(xbgr.mr_n90545088)
print v(xbgr.mr_n91859840)
print v(xbgr.mr_n92124160)
print v(xbgr.mr_n92229680)
print v(xbgr.mr_n89432432)
print v(xbgr.mr_n89642416)
print v(xbgr.mr_n89800144)
print v(xbgr.mr_n90048832)
print v(xbgr.mr_n91862096)
print v(xbgr.mr_n92052336)
print v(xbgr.mr_n92248816)
print v(xbgr.mr_n89432896)
print v(xbgr.mr_n89643008)
print v(xbgr.mr_n89818496)
print v(xbgr.mr_n90049504)
print v(xbgr.mr_n90113264)
print v(xbgr.mr_n90179696)
print v(xbgr.mr_n90444880)
print v(xbgr.mr_n90675872)
print v(xbgr.mr_n90808560)
print v(xbgr.mr_n90959616)
print v(xbgr.mr_n91015136)
print v(xbgr.mr_n91099232)
print v(xbgr.mr_n91237360)
print v(xbgr.mr_n91327040)
print v(xbgr.mr_n91495376)
print v(xbgr.mr_n91622992)
print v(xbgr.mr_n90811776)
print v(xbgr.mr_n90959952)
print v(xbgr.mr_n91024208)
print v(xbgr.mr_n91101280)
print v(xbgr.mr_n91227616)
print v(xbgr.mr_n91369136)
print v(xbgr.mr_n91494256)
print v(xbgr.mr_n91626672)
print v(xbgr.mr_n91684720)
print v(xbgr.mr_n91913456)
print v(xbgr.mr_n92143232)
print v(xbgr.mr_n91861360)
print v(xbgr.mr_n92050560)
print v(xbgr.mr_n92221904)
print v(xbgr.mr_n89433360)
print v(xbgr.mr_n89643600)
print v(xbgr.mr_n89819088)
print v(xbgr.mr_n90044128)
print v(xbgr.mr_n90702496)
print v(xbgr.mr_n90789968)
print v(xbgr.mr_n90902256)
print v(xbgr.mr_n91044080)
print v(xbgr.mr_n91125632)
print v(xbgr.mr_n91261744)
print v(xbgr.mr_n91391472)
print v(xbgr.mr_n91536000)
print v(xbgr.mr_n89433824)
print v(xbgr.mr_n89644192)
print v(xbgr.mr_n89819680)
print v(xbgr.mr_n90050304)
print v(xbgr.mr_n91862704)
print v(xbgr.mr_n92125248)
print v(xbgr.mr_n92314352)
print v(xbgr.mr_n90812928)
print v(xbgr.mr_n90940832)
print v(xbgr.mr_n91007968)
print v(xbgr.mr_n90975856)
print v(xbgr.mr_n91235152)
print v(xbgr.mr_n90976816)
print v(xbgr.mr_n91457056)
print v(xbgr.mr_n91591376)
print v(xbgr.mr_n90123280)
print v(xbgr.mr_n90228352)
print v(xbgr.mr_n90468848)
print v(xbgr.mr_n90681936)
print v(xbgr.mr_n90127696)
print v(xbgr.mr_n90230720)
print v(xbgr.mr_n90477456)
print v(xbgr.mr_n90683280)
print v(xbgr.mr_n89431968)
print v(xbgr.mr_n89644784)
print v(xbgr.mr_n89820272)
print v(xbgr.mr_n90050704)
print v(xbgr.mr_n91863440)
print v(xbgr.mr_n92045472)
print v(xbgr.mr_n92248992)
print v(xbgr.mr_n91685648)
print v(xbgr.mr_n91912992)
print v(xbgr.mr_n92144416)
print v(xbgr.mr_n89434752)
print v(xbgr.mr_n89645376)
print v(xbgr.mr_n89820864)
print v(xbgr.mr_n90051504)
print v(xbgr.mr_n90063712)
print v(xbgr.mr_n89504704)
print v(xbgr.mr_n90346800)
print v(xbgr.mr_n90543904)
print v(xbgr.mr_n91865216)
print v(xbgr.mr_n92045248)
print v(xbgr.mr_n92316464)
print v(xbgr.mr_n89435216)
print v(xbgr.mr_n89645968)
print v(xbgr.mr_n89821456)
print v(xbgr.mr_n90051904)
print v(xbgr.mr_n90116064)
print v(xbgr.mr_n90181520)
print v(xbgr.mr_n90444608)
print v(xbgr.mr_n90680144)
print v(xbgr.mr_n91858496)
print v(xbgr.mr_n92126336)
print v(xbgr.mr_n92316576)
print v(xbgr.mr_n90811280)
print v(xbgr.mr_n90955952)
print v(xbgr.mr_n91009184)
print v(xbgr.mr_n90977296)
print v(xbgr.mr_n91235040)
print v(xbgr.mr_n90974384)
print v(xbgr.mr_n91482768)
print v(xbgr.mr_n91622768)
print v(xbgr.mr_n90812752)
print v(xbgr.mr_n90960400)
print v(xbgr.mr_n91021664)
print v(xbgr.mr_n91104800)
print v(xbgr.mr_n91239136)
print v(xbgr.mr_n91367888)
print v(xbgr.mr_n91490352)
print v(xbgr.mr_n91627792)
print v(xbgr.mr_n89435680)
print v(xbgr.mr_n89646560)
print v(xbgr.mr_n89822048)
print v(xbgr.mr_n90052304)
print v(xbgr.mr_n91864048)
print v(xbgr.mr_n92045360)
print v(xbgr.mr_n92317504)
print v(xbgr.mr_n90702032)
print v(xbgr.mr_n90828272)
print v(xbgr.mr_n90861760)
print v(xbgr.mr_n91043536)
print v(xbgr.mr_n91128096)
print v(xbgr.mr_n91262560)
print v(xbgr.mr_n91392288)
print v(xbgr.mr_n91536816)
print v(xbgr.mr_n91685184)
print v(xbgr.mr_n91912528)
print v(xbgr.mr_n92143824)
print v(xbgr.mr_n89436144)
print v(xbgr.mr_n89589488)
print v(xbgr.mr_n89822640)
print v(xbgr.mr_n90052704)
print v(xbgr.mr_n91864784)
print v(xbgr.mr_n91944624)
print v(xbgr.mr_n92313056)
print v(xbgr.mr_n90812272)
print v(xbgr.mr_n90960976)
print v(xbgr.mr_n91010224)
print v(xbgr.mr_n91106400)
print v(xbgr.mr_n91240800)
print v(xbgr.mr_n91329440)
print v(xbgr.mr_n91452912)
print v(xbgr.mr_n91584928)
print v(xbgr.mr_n89436608)
print v(xbgr.mr_n89647744)
print v(xbgr.mr_n89823232)
print v(xbgr.mr_n90053104)
print v(xbgr.mr_n90124592)
print v(xbgr.mr_n90223936)
print v(xbgr.mr_n90475520)
print v(xbgr.mr_n90678800)
print v(xbgr.mr_n90123936)
print v(xbgr.mr_n90222128)
print v(xbgr.mr_n90474000)
print v(xbgr.mr_n90681760)
print v(xbgr.mr_n91865392)
print v(xbgr.mr_n92129056)
print v(xbgr.mr_n92247584)
print v(xbgr.mr_n89437072)
print v(xbgr.mr_n89648336)
print v(xbgr.mr_n89823824)
print v(xbgr.mr_n90053904)
print v(xbgr.mr_n90063440)
print v(xbgr.mr_n89744448)
print v(xbgr.mr_n90346528)
print v(xbgr.mr_n90542720)
print v(xbgr.mr_n91863872)
print v(xbgr.mr_n91809664)
print v(xbgr.mr_n92316752)
print v(xbgr.mr_n89412560)
print v(xbgr.mr_n89648928)
print v(xbgr.mr_n89824416)
print v(xbgr.mr_n90054304)
print v(xbgr.mr_n91684256)
print v(xbgr.mr_n91912064)
print v(xbgr.mr_n92142640)
print v(xbgr.mr_n90106128)
print v(xbgr.mr_n90176672)
print v(xbgr.mr_n90445152)
print v(xbgr.mr_n90681584)
print v(xbgr.mr_n90814336)
print v(xbgr.mr_n90959840)
print v(xbgr.mr_n91010112)
print v(xbgr.mr_n91105968)
print v(xbgr.mr_n91241840)
print v(xbgr.mr_n91369440)
print v(xbgr.mr_n91491584)
print v(xbgr.mr_n91624000)
print v(xbgr.mr_n91867904)
print v(xbgr.mr_n91947056)
print v(xbgr.mr_n92251536)
print v(xbgr.mr_n90810112)
print v(xbgr.mr_n90961440)
print v(xbgr.mr_n91010688)
print v(xbgr.mr_n91107504)
print v(xbgr.mr_n91202784)
print v(xbgr.mr_n91369888)
print v(xbgr.mr_n91490464)
print v(xbgr.mr_n91622880)
print v(xbgr.mr_n89438000)
print v(xbgr.mr_n89641232)
print v(xbgr.mr_n89825008)
print v(xbgr.mr_n90046928)
print v(xbgr.mr_n90701568)
print v(xbgr.mr_n90827808)
print v(xbgr.mr_n90900016)
print v(xbgr.mr_n91043264)
print v(xbgr.mr_n91128912)
print v(xbgr.mr_n91263376)
print v(xbgr.mr_n91393104)
print v(xbgr.mr_n91537632)
print v(xbgr.mr_n89404672)
print v(xbgr.mr_n89650048)
print v(xbgr.mr_n89825600)
print v(xbgr.mr_n90055104)
print v(xbgr.mr_n91859408)
print v(xbgr.mr_n92127968)
print v(xbgr.mr_n92317616)
print v(xbgr.mr_n91867472)
print v(xbgr.mr_n92041840)
print v(xbgr.mr_n92319120)
print v(xbgr.mr_n89242816)
print v(xbgr.mr_n89650704)
print v(xbgr.mr_n89758704)
print v(xbgr.mr_n90055504)
print v(xbgr.mr_n90814448)
print v(xbgr.mr_n90960176)
print v(xbgr.mr_n91009760)
print v(xbgr.mr_n91103104)
print v(xbgr.mr_n91239824)
print v(xbgr.mr_n91369664)
print v(xbgr.mr_n91454096)
print v(xbgr.mr_n91589600)
print v(xbgr.mr_n90125072)
print v(xbgr.mr_n90226464)
print v(xbgr.mr_n90474976)
print v(xbgr.mr_n90677728)
print v(xbgr.mr_n90126384)
print v(xbgr.mr_n90227264)
print v(xbgr.mr_n90475696)
print v(xbgr.mr_n90679584)
print v(xbgr.mr_n91683792)
print v(xbgr.mr_n91911600)
print v(xbgr.mr_n92142048)
print v(xbgr.mr_n91866736)
print v(xbgr.mr_n91944736)
print v(xbgr.mr_n92319728)
print v(xbgr.mr_n89403744)
print v(xbgr.mr_n89651296)
print v(xbgr.mr_n89758112)
print v(xbgr.mr_n90056304)
print v(xbgr.mr_n90063168)
print v(xbgr.mr_n89495584)
print v(xbgr.mr_n90346256)
print v(xbgr.mr_n90541536)
print v(xbgr.mr_n89403280)
print v(xbgr.mr_n89651888)
print v(xbgr.mr_n89757520)
print v(xbgr.mr_n90056704)
print v(xbgr.mr_n91866128)
print v(xbgr.mr_n92127424)
print v(xbgr.mr_n92326096)
print v(xbgr.mr_n90106304)
print v(xbgr.mr_n90178496)
print v(xbgr.mr_n90444064)
print v(xbgr.mr_n90672496)
print v(xbgr.mr_n90813280)
print v(xbgr.mr_n90962192)
print v(xbgr.mr_n91027040)
print v(xbgr.mr_n91108384)
print v(xbgr.mr_n91242720)
print v(xbgr.mr_n90972592)
print v(xbgr.mr_n91470064)
print v(xbgr.mr_n91618976)
print v(xbgr.mr_n89402816)
print v(xbgr.mr_n89652480)
print v(xbgr.mr_n89756928)
print v(xbgr.mr_n90057104)
print v(xbgr.mr_n90816816)
print v(xbgr.mr_n90960064)
print v(xbgr.mr_n91009296)
print v(xbgr.mr_n91103664)
print v(xbgr.mr_n91236528)
print v(xbgr.mr_n91372320)
print v(xbgr.mr_n91486560)
print v(xbgr.mr_n91619088)
print v(xbgr.mr_n91866560)
print v(xbgr.mr_n91951728)
print v(xbgr.mr_n92323360)
print v(xbgr.mr_n91683328)
print v(xbgr.mr_n91911136)
print v(xbgr.mr_n92141456)
print v(xbgr.mr_n89402352)
print v(xbgr.mr_n89653072)
print v(xbgr.mr_n89756336)
print v(xbgr.mr_n90057504)
print v(xbgr.mr_n90701104)
print v(xbgr.mr_n90826880)
print v(xbgr.mr_n90921264)
print v(xbgr.mr_n91042720)
print v(xbgr.mr_n91129728)
print v(xbgr.mr_n91263104)
print v(xbgr.mr_n91392832)
print v(xbgr.mr_n91537360)
print v(xbgr.mr_n91869248)
print v(xbgr.mr_n92044800)
print v(xbgr.mr_n92319616)
print v(xbgr.mr_n89401888)
print v(xbgr.mr_n89653664)
print v(xbgr.mr_n89755744)
print v(xbgr.mr_n90057904)
print v(xbgr.mr_n90816096)
print v(xbgr.mr_n90961328)
print v(xbgr.mr_n91029120)
print v(xbgr.mr_n91108816)
print v(xbgr.mr_n91245504)
print v(xbgr.mr_n91373664)
print v(xbgr.mr_n91455280)
print v(xbgr.mr_n91590256)
print v(xbgr.mr_n90121312)
print v(xbgr.mr_n90225216)
print v(xbgr.mr_n90471392)
print v(xbgr.mr_n90673504)
print v(xbgr.mr_n91772176)
print v(xbgr.mr_n92126880)
print v(xbgr.mr_n92323536)
print v(xbgr.mr_n90125728)
print v(xbgr.mr_n90226352)
print v(xbgr.mr_n90474480)
print v(xbgr.mr_n90678464)
print v(xbgr.mr_n89401424)
print v(xbgr.mr_n89654256)
print v(xbgr.mr_n89753600)
print v(xbgr.mr_n90038128)
print v(xbgr.mr_n91869424)
print v(xbgr.mr_n92044208)
print v(xbgr.mr_n92325104)
print v(xbgr.mr_n90062896)
print v(xbgr.mr_n89584448)
print v(xbgr.mr_n90345984)
print v(xbgr.mr_n90540352)
print v(xbgr.mr_n89398640)
print v(xbgr.mr_n89654848)
print v(xbgr.mr_n89830544)
print v(xbgr.mr_n89884000)
print v(xbgr.mr_n91682400)
print v(xbgr.mr_n91910272)
print v(xbgr.mr_n92140368)
print v(xbgr.mr_n91871824)
print v(xbgr.mr_n92042432)
print v(xbgr.mr_n92322192)
print v(xbgr.mr_n90112464)
print v(xbgr.mr_n90173648)
print v(xbgr.mr_n90443872)
print v(xbgr.mr_n90676608)
print v(xbgr.mr_n89395856)
print v(xbgr.mr_n89655440)
print v(xbgr.mr_n89831984)
print v(xbgr.mr_n89882848)
print v(xbgr.mr_n90813984)
print v(xbgr.mr_n90962928)
print v(xbgr.mr_n91028752)
print v(xbgr.mr_n91106816)
print v(xbgr.mr_n91241152)
print v(xbgr.mr_n91372016)
print v(xbgr.mr_n91482992)
print v(xbgr.mr_n91611616)
print v(xbgr.mr_n90815920)
print v(xbgr.mr_n90960512)
print v(xbgr.mr_n91029968)
print v(xbgr.mr_n91112208)
print v(xbgr.mr_n91246544)
print v(xbgr.mr_n91373296)
print v(xbgr.mr_n91486672)
print v(xbgr.mr_n91615408)
print v(xbgr.mr_n91870656)
print v(xbgr.mr_n92125792)
print v(xbgr.mr_n92325920)
print v(xbgr.mr_n89400032)
print v(xbgr.mr_n89656032)
print v(xbgr.mr_n89832384)
print v(xbgr.mr_n89882736)
print v(xbgr.mr_n90700640)
print v(xbgr.mr_n90826416)
print v(xbgr.mr_n90853728)
print v(xbgr.mr_n91042448)
print v(xbgr.mr_n91130544)
print v(xbgr.mr_n91262832)
print v(xbgr.mr_n91392560)
print v(xbgr.mr_n91537088)
print v(xbgr.mr_n91868816)
print v(xbgr.mr_n91954512)
print v(xbgr.mr_n92327664)
print v(xbgr.mr_n89399568)
print v(xbgr.mr_n89656624)
print v(xbgr.mr_n89829952)
print v(xbgr.mr_n89749664)
print v(xbgr.mr_n91681936)
print v(xbgr.mr_n91801088)
print v(xbgr.mr_n92139904)
print v(xbgr.mr_n90811168)
print v(xbgr.mr_n90962624)
print v(xbgr.mr_n91028336)
print v(xbgr.mr_n91110128)
print v(xbgr.mr_n91244464)
print v(xbgr.mr_n91372944)
print v(xbgr.mr_n91456464)
print v(xbgr.mr_n91579440)
print v(xbgr.mr_n90122624)
print v(xbgr.mr_n90215680)
print v(xbgr.mr_n90472432)
print v(xbgr.mr_n90676432)
print v(xbgr.mr_n91871392)
print v(xbgr.mr_n91968736)
print v(xbgr.mr_n92328656)
print v(xbgr.mr_n90123760)
print v(xbgr.mr_n90225040)
print v(xbgr.mr_n90473152)
print v(xbgr.mr_n90672320)
print v(xbgr.mr_n89399104)
print v(xbgr.mr_n89657216)
print v(xbgr.mr_n89834384)
print v(xbgr.mr_n89751520)
print v(xbgr.mr_n90062624)
print v(xbgr.mr_n90133360)
print v(xbgr.mr_n90345712)
print v(xbgr.mr_n90539168)
print v(xbgr.mr_n89243088)
print v(xbgr.mr_n89657808)
print v(xbgr.mr_n89834784)
print v(xbgr.mr_n89327200)
print v(xbgr.mr_n91868080)
print v(xbgr.mr_n92249408)
print v(xbgr.mr_n89398176)
print v(xbgr.mr_n89658400)
print v(xbgr.mr_n89835904)
print v(xbgr.mr_n89752704)
print v(xbgr.mr_n91872000)
print v(xbgr.mr_n92330224)
print v(xbgr.mr_n90096624)
print v(xbgr.mr_n90172448)
print v(xbgr.mr_n90444336)
print v(xbgr.mr_n90673616)
print v(xbgr.mr_n90807712)
print v(xbgr.mr_n90900144)
print v(xbgr.mr_n91030784)
print v(xbgr.mr_n91113088)
print v(xbgr.mr_n91247424)
print v(xbgr.mr_n91377088)
print v(xbgr.mr_n91482880)
print v(xbgr.mr_n91615296)
print v(xbgr.mr_n90807376)
print v(xbgr.mr_n90884352)
print v(xbgr.mr_n91027472)
print v(xbgr.mr_n91109504)
print v(xbgr.mr_n91243840)
print v(xbgr.mr_n91369552)
print v(xbgr.mr_n91487792)
print v(xbgr.mr_n91620208)
print v(xbgr.mr_n91681472)
print v(xbgr.mr_n92139440)
print v(xbgr.mr_n89397712)
print v(xbgr.mr_n89658992)
print v(xbgr.mr_n89836304)
print v(xbgr.mr_n89553504)
print v(xbgr.mr_n91874512)
print v(xbgr.mr_n92331216)
print v(xbgr.mr_n90700176)
print v(xbgr.mr_n90825488)
print v(xbgr.mr_n90861488)
print v(xbgr.mr_n91041904)
print v(xbgr.mr_n91131088)
print v(xbgr.mr_n91262288)
print v(xbgr.mr_n91392016)
print v(xbgr.mr_n91536544)
print v(xbgr.mr_n89397248)
print v(xbgr.mr_n89659584)
print v(xbgr.mr_n89837504)
print v(xbgr.mr_n89327808)
print v(xbgr.mr_n91870160)
print v(xbgr.mr_n92328480)
print v(xbgr.mr_n90810816)
print v(xbgr.mr_n90900368)
print v(xbgr.mr_n91031216)
print v(xbgr.mr_n91115808)
print v(xbgr.mr_n91245856)
print v(xbgr.mr_n91379872)
print v(xbgr.mr_n91455872)
print v(xbgr.mr_n91588480)
print v(xbgr.mr_n90121968)
print v(xbgr.mr_n90223584)
print v(xbgr.mr_n90471936)
print v(xbgr.mr_n90673728)
print v(xbgr.mr_n89396784)
print v(xbgr.mr_n89660176)
print v(xbgr.mr_n89838304)
print v(xbgr.mr_n89754624)
print v(xbgr.mr_n90124416)
print v(xbgr.mr_n90223760)
print v(xbgr.mr_n90470432)
print v(xbgr.mr_n90674416)
print v(xbgr.mr_n91873344)
print v(xbgr.mr_n92332784)
print v(xbgr.mr_n91680544)
print v(xbgr.mr_n92138512)
print v(xbgr.mr_n89396320)
print v(xbgr.mr_n89660768)
print v(xbgr.mr_n89838704)
print v(xbgr.mr_n89352528)
print v(xbgr.mr_n90062352)
print v(xbgr.mr_n89266432)
print v(xbgr.mr_n90345440)
print v(xbgr.mr_n90537984)
print v(xbgr.mr_n91874080)
print v(xbgr.mr_n92331040)
print v(xbgr.mr_n89336896)
print v(xbgr.mr_n89661360)
print v(xbgr.mr_n89833584)
print v(xbgr.mr_n89329104)
print v(xbgr.mr_n90100752)
print v(xbgr.mr_n90170624)
print v(xbgr.mr_n90443648)
print v(xbgr.mr_n90670640)
print v(xbgr.mr_n90808672)
print v(xbgr.mr_n90913360)
print v(xbgr.mr_n91033712)
print v(xbgr.mr_n91116912)
print v(xbgr.mr_n91247856)
print v(xbgr.mr_n91378208)
print v(xbgr.mr_n91460016)
print v(xbgr.mr_n91607888)
print v(xbgr.mr_n91874688)
print v(xbgr.mr_n92333776)
print v(xbgr.mr_n90808096)
print v(xbgr.mr_n90916240)
print v(xbgr.mr_n91029536)
print v(xbgr.mr_n91115376)
print v(xbgr.mr_n91249712)
print v(xbgr.mr_n91374624)
print v(xbgr.mr_n91479200)
print v(xbgr.mr_n91616416)
print v(xbgr.mr_n89395392)
print v(xbgr.mr_n89661952)
print v(xbgr.mr_n89840304)
print v(xbgr.mr_n89751104)
print v(xbgr.mr_n91875424)
print v(xbgr.mr_n92338720)
print v(xbgr.mr_n90699712)
print v(xbgr.mr_n90825024)
print v(xbgr.mr_n90861216)
print v(xbgr.mr_n91041632)
print v(xbgr.mr_n91130816)
print v(xbgr.mr_n91262016)
print v(xbgr.mr_n91391744)
print v(xbgr.mr_n91536272)
print v(xbgr.mr_n89394928)
print v(xbgr.mr_n89662544)
print v(xbgr.mr_n89841504)
print v(xbgr.mr_n89284560)
print v(xbgr.mr_n91680080)
print v(xbgr.mr_n92138048)
print v(xbgr.mr_n91877200)
print v(xbgr.mr_n92336336)
print v(xbgr.mr_n89394464)
print v(xbgr.mr_n89663136)
print v(xbgr.mr_n89841904)
print v(xbgr.mr_n89374272)
print v(xbgr.mr_n90806688)
print v(xbgr.mr_n90917168)
print v(xbgr.mr_n91032080)
print v(xbgr.mr_n91105488)
print v(xbgr.mr_n91249168)
print v(xbgr.mr_n91378832)
print v(xbgr.mr_n91450448)
print v(xbgr.mr_n91582496)
print v(xbgr.mr_n90122448)
print v(xbgr.mr_n90218112)
print v(xbgr.mr_n90466304)
print v(xbgr.mr_n90670288)
print v(xbgr.mr_n90120656)
print v(xbgr.mr_n90168592)
print v(xbgr.mr_n90469888)
print v(xbgr.mr_n90671648)
print v(xbgr.mr_n91872736)
print v(xbgr.mr_n92124704)
print v(xbgr.mr_n92341456)
print v(xbgr.mr_n89394000)
print v(xbgr.mr_n89663728)
print v(xbgr.mr_n89842704)
print v(xbgr.mr_n89536624)
print v(xbgr.mr_n90062080)
print v(xbgr.mr_n90150912)
print v(xbgr.mr_n90345168)
print v(xbgr.mr_n90536800)
print v(xbgr.mr_n91876032)
print v(xbgr.mr_n92043616)
print v(xbgr.mr_n92338896)
print v(xbgr.mr_n89393536)
print v(xbgr.mr_n89664320)
print v(xbgr.mr_n89843904)
print v(xbgr.mr_n89839504)
print v(xbgr.mr_n91679616)
print v(xbgr.mr_n91800832)
print v(xbgr.mr_n92137584)
print v(xbgr.mr_n90111104)
print v(xbgr.mr_n90169424)
print v(xbgr.mr_n90423392)
print v(xbgr.mr_n90668768)
print v(xbgr.mr_n90797008)
print v(xbgr.mr_n90908752)
print v(xbgr.mr_n91034528)
print v(xbgr.mr_n91113520)
print v(xbgr.mr_n91252128)
print v(xbgr.mr_n91377520)
print v(xbgr.mr_n91478976)
print v(xbgr.mr_n91611392)
print v(xbgr.mr_n91876768)
print v(xbgr.mr_n92043024)
print v(xbgr.mr_n92336160)
print v(xbgr.mr_n90802416)
print v(xbgr.mr_n90886080)
print v(xbgr.mr_n91031520)
print v(xbgr.mr_n91118912)
print v(xbgr.mr_n91250144)
print v(xbgr.mr_n91382912)
print v(xbgr.mr_n91484000)
print v(xbgr.mr_n91611504)
print v(xbgr.mr_n89393072)
print v(xbgr.mr_n89664912)
print v(xbgr.mr_n89844304)
print v(xbgr.mr_n89593376)
print v(xbgr.mr_n90699248)
print v(xbgr.mr_n90824096)
print v(xbgr.mr_n90860672)
print v(xbgr.mr_n91041360)
print v(xbgr.mr_n91130272)
print v(xbgr.mr_n91261472)
print v(xbgr.mr_n91391200)
print v(xbgr.mr_n91535728)
print v(xbgr.mr_n89390288)
print v(xbgr.mr_n89665504)
print v(xbgr.mr_n89845632)
print v(xbgr.mr_n89830208)
print v(xbgr.mr_n91877376)
print v(xbgr.mr_n92121984)
print v(xbgr.mr_n92333600)
print v(xbgr.mr_n89392144)
print v(xbgr.mr_n89612080)
print v(xbgr.mr_n89846224)
print v(xbgr.mr_n89537728)
print v(xbgr.mr_n91875856)
print v(xbgr.mr_n92038288)
print v(xbgr.mr_n92340464)
print v(xbgr.mr_n90801120)
print v(xbgr.mr_n90864112)
print v(xbgr.mr_n91036736)
print v(xbgr.mr_n91116224)
print v(xbgr.mr_n91254912)
print v(xbgr.mr_n91384576)
print v(xbgr.mr_n91454688)
print v(xbgr.mr_n91586704)
print v(xbgr.mr_n90117328)
print v(xbgr.mr_n90220672)
print v(xbgr.mr_n90467888)
print v(xbgr.mr_n90668944)
print v(xbgr.mr_n90123104)
print v(xbgr.mr_n90219568)
print v(xbgr.mr_n90469392)
print v(xbgr.mr_n90670464)
print v(xbgr.mr_n91678688)
print v(xbgr.mr_n91799776)
print v(xbgr.mr_n92136656)
print v(xbgr.mr_n89391680)
print v(xbgr.mr_n89666624)
print v(xbgr.mr_n89848000)
print v(xbgr.mr_n89354656)
print v(xbgr.mr_n91879888)
print v(xbgr.mr_n92038944)
print v(xbgr.mr_n92337904)
print v(xbgr.mr_n90061808)
print v(xbgr.mr_n89273504)
print v(xbgr.mr_n90344896)
print v(xbgr.mr_n90535616)
print v(xbgr.mr_n89391216)
print v(xbgr.mr_n89667280)
print v(xbgr.mr_n89849184)
print v(xbgr.mr_n89709120)
print v(xbgr.mr_n91873168)
print v(xbgr.mr_n92123072)
print v(xbgr.mr_n92341280)
print v(xbgr.mr_n90107264)
print v(xbgr.mr_n90169120)
print v(xbgr.mr_n90443424)
print v(xbgr.mr_n90665728)
print v(xbgr.mr_n89390752)
print v(xbgr.mr_n89667872)
print v(xbgr.mr_n89849776)
print v(xbgr.mr_n89666096)
print v(xbgr.mr_n90804656)
print v(xbgr.mr_n90914576)
print v(xbgr.mr_n91033280)
print v(xbgr.mr_n91120080)
print v(xbgr.mr_n91250560)
print v(xbgr.mr_n91385616)
print v(xbgr.mr_n91475408)
print v(xbgr.mr_n91605312)
print v(xbgr.mr_n90799088)
print v(xbgr.mr_n90904752)
print v(xbgr.mr_n91037440)
print v(xbgr.mr_n91121616)
print v(xbgr.mr_n91255952)
print v(xbgr.mr_n91380224)
print v(xbgr.mr_n91479088)
print v(xbgr.mr_n91612624)
print v(xbgr.mr_n91879456)
print v(xbgr.mr_n92041248)
print v(xbgr.mr_n92343024)
print v(xbgr.mr_n91678224)
print v(xbgr.mr_n91822576)
print v(xbgr.mr_n92136192)
print v(xbgr.mr_n89242512)
print v(xbgr.mr_n89668464)
print v(xbgr.mr_n89850960)
print v(xbgr.mr_n89882208)
print v(xbgr.mr_n90698784)
print v(xbgr.mr_n90823632)
print v(xbgr.mr_n90842448)
print v(xbgr.mr_n91041088)
print v(xbgr.mr_n91130000)
print v(xbgr.mr_n91261200)
print v(xbgr.mr_n91390928)
print v(xbgr.mr_n91535456)
print v(xbgr.mr_n91878720)
print v(xbgr.mr_n92040656)
print v(xbgr.mr_n92344016)
print v(xbgr.mr_n89389824)
print v(xbgr.mr_n89669056)
print v(xbgr.mr_n89851552)
print v(xbgr.mr_n89881616)
print v(xbgr.mr_n90803856)
print v(xbgr.mr_n90911280)
print v(xbgr.mr_n91035824)
print v(xbgr.mr_n91117792)
print v(xbgr.mr_n91253872)
print v(xbgr.mr_n91383600)
print v(xbgr.mr_n91452320)
print v(xbgr.mr_n91584272)
print v(xbgr.mr_n90120000)
print v(xbgr.mr_n90207024)
print v(xbgr.mr_n90463760)
print v(xbgr.mr_n90667328)
print v(xbgr.mr_n90118608)
print v(xbgr.mr_n90219392)
print v(xbgr.mr_n90467280)
print v(xbgr.mr_n90666592)
print v(xbgr.mr_n91880064)
print v(xbgr.mr_n92122528)
print v(xbgr.mr_n92335344)
print v(xbgr.mr_n89389360)
print v(xbgr.mr_n89669648)
print v(xbgr.mr_n89850368)
print v(xbgr.mr_n89881024)
print v(xbgr.mr_n91878544)
print v(xbgr.mr_n92040064)
print v(xbgr.mr_n92345584)
print v(xbgr.mr_n90061536)
print v(xbgr.mr_n90133552)
print v(xbgr.mr_n90344784)
print v(xbgr.mr_n90534432)
print v(xbgr.mr_n89388896)
print v(xbgr.mr_n89670240)
print v(xbgr.mr_n89848592)
print v(xbgr.mr_n89880432)
print v(xbgr.mr_n91677760)
print v(xbgr.mr_n91812912)
print v(xbgr.mr_n92135728)
print v(xbgr.mr_n91848768)
print v(xbgr.mr_n92039120)
print v(xbgr.mr_n92346576)
print v(xbgr.mr_n89388432)
print v(xbgr.mr_n89670832)
print v(xbgr.mr_n89847408)
print v(xbgr.mr_n89879840)
print v(xbgr.mr_n90109264)
print v(xbgr.mr_n90153088)
print v(xbgr.mr_n90424704)
print v(xbgr.mr_n90662880)
print v(xbgr.mr_n90799264)
print v(xbgr.mr_n90906416)
print v(xbgr.mr_n91035264)
print v(xbgr.mr_n91122496)
print v(xbgr.mr_n91253248)
print v(xbgr.mr_n91381376)
print v(xbgr.mr_n91475296)
print v(xbgr.mr_n91600496)
print v(xbgr.mr_n90800144)
print v(xbgr.mr_n90907040)
print v(xbgr.mr_n91038992)
print v(xbgr.mr_n91118224)
print v(xbgr.mr_n91257952)
print v(xbgr.mr_n91386928)
print v(xbgr.mr_n91480208)
print v(xbgr.mr_n91607664)
print v(xbgr.mr_n89387968)
print v(xbgr.mr_n89671424)
print v(xbgr.mr_n89846816)
print v(xbgr.mr_n89879248)
print v(xbgr.mr_n91852752)
print v(xbgr.mr_n92121440)
print v(xbgr.mr_n92343840)
print v(xbgr.mr_n90698320)
print v(xbgr.mr_n90822704)
print v(xbgr.mr_n90859504)
print v(xbgr.mr_n91040816)
print v(xbgr.mr_n91129456)
print v(xbgr.mr_n91260656)
print v(xbgr.mr_n91390384)
print v(xbgr.mr_n91534912)
print v(xbgr.mr_n91850512)
print v(xbgr.mr_n91993504)
print v(xbgr.mr_n92348144)
print v(xbgr.mr_n89387504)
print v(xbgr.mr_n89630576)
print v(xbgr.mr_n89845104)
print v(xbgr.mr_n89878656)
print v(xbgr.mr_n91676832)
print v(xbgr.mr_n91826320)
print v(xbgr.mr_n92134800)
print v(xbgr.mr_n90802240)
print v(xbgr.mr_n90912208)
print v(xbgr.mr_n91037904)
print v(xbgr.mr_n91125216)
print v(xbgr.mr_n91252560)
print v(xbgr.mr_n91382224)
print v(xbgr.mr_n91453504)
print v(xbgr.mr_n91532432)
print v(xbgr.mr_n90119536)
print v(xbgr.mr_n90215856)
print v(xbgr.mr_n90465520)
print v(xbgr.mr_n90664624)
print v(xbgr.mr_n90121792)
print v(xbgr.mr_n90217760)
print v(xbgr.mr_n90465344)
print v(xbgr.mr_n90667152)
print v(xbgr.mr_n91845024)
print v(xbgr.mr_n92035392)
print v(xbgr.mr_n92346400)
print v(xbgr.mr_n89387040)
print v(xbgr.mr_n89672608)
print v(xbgr.mr_n89844704)
print v(xbgr.mr_n89878064)
print v(xbgr.mr_n90061264)
print v(xbgr.mr_n89556544)
print v(xbgr.mr_n90344672)
print v(xbgr.mr_n90533248)
print v(xbgr.mr_n89386576)
print v(xbgr.mr_n89673200)
print v(xbgr.mr_n89843504)
print v(xbgr.mr_n89877472)
print v(xbgr.mr_n91847664)
print v(xbgr.mr_n92119808)
print v(xbgr.mr_n92349136)
print v(xbgr.mr_n89386112)
print v(xbgr.mr_n89673792)
print v(xbgr.mr_n89827984)
print v(xbgr.mr_n89876880)
print v(xbgr.mr_n91850624)
print v(xbgr.mr_n92036512)
print v(xbgr.mr_n92350704)
print v(xbgr.mr_n90097568)
print v(xbgr.mr_n90165072)
print v(xbgr.mr_n90443536)
print v(xbgr.mr_n90603328)
print v(xbgr.mr_n90800944)
print v(xbgr.mr_n90907600)
print v(xbgr.mr_n91034176)
print v(xbgr.mr_n91124784)
print v(xbgr.mr_n91237888)
print v(xbgr.mr_n91380912)
print v(xbgr.mr_n91462976)
print v(xbgr.mr_n91608832)
print v(xbgr.mr_n90801296)
print v(xbgr.mr_n90906208)
print v(xbgr.mr_n91036240)
print v(xbgr.mr_n91126320)
print v(xbgr.mr_n91254416)
print v(xbgr.mr_n91384080)
print v(xbgr.mr_n91476416)
print v(xbgr.mr_n91607776)
print v(xbgr.mr_n91676368)
print v(xbgr.mr_n91818688)
print v(xbgr.mr_n92134400)
print v(xbgr.mr_n89385648)
print v(xbgr.mr_n89674384)
print v(xbgr.mr_n89842304)
print v(xbgr.mr_n89876288)
print v(xbgr.mr_n91846240)
print v(xbgr.mr_n92037168)
print v(xbgr.mr_n92351696)
print v(xbgr.mr_n90697856)
print v(xbgr.mr_n90822240)
print v(xbgr.mr_n90859232)
print v(xbgr.mr_n91040544)
print v(xbgr.mr_n91129184)
print v(xbgr.mr_n91260384)
print v(xbgr.mr_n91390112)
print v(xbgr.mr_n91534640)
print v(xbgr.mr_n89385184)
print v(xbgr.mr_n89674976)
print v(xbgr.mr_n89841104)
print v(xbgr.mr_n89875696)
print v(xbgr.mr_n91847168)
print v(xbgr.mr_n92117632)
print v(xbgr.mr_n92356816)
print v(xbgr.mr_n90782096)
print v(xbgr.mr_n90736624)
print v(xbgr.mr_n91032928)
print v(xbgr.mr_n91126848)
print v(xbgr.mr_n91251712)
print v(xbgr.mr_n91376208)
print v(xbgr.mr_n91386496)
print v(xbgr.mr_n91530832)
print v(xbgr.mr_n89242400)
print v(xbgr.mr_n89675568)
print v(xbgr.mr_n89840704)
print v(xbgr.mr_n89875104)
print v(xbgr.mr_n90119072)
print v(xbgr.mr_n90187568)
print v(xbgr.mr_n90461216)
print v(xbgr.mr_n90665472)
print v(xbgr.mr_n90121136)
print v(xbgr.mr_n90215248)
print v(xbgr.mr_n90464736)
print v(xbgr.mr_n90665296)
print v(xbgr.mr_n91839936)
print v(xbgr.mr_n92034736)
print v(xbgr.mr_n92348960)
print v(xbgr.mr_n89384256)
print v(xbgr.mr_n89676160)
print v(xbgr.mr_n89839904)
print v(xbgr.mr_n89874512)
print v(xbgr.mr_n91675904)
print v(xbgr.mr_n91812384)
print v(xbgr.mr_n92134128)
print v(xbgr.mr_n90060992)
print v(xbgr.mr_n89375552)
print v(xbgr.mr_n90344560)
print v(xbgr.mr_n90532128)
print v(xbgr.mr_n91833104)
print v(xbgr.mr_n92031840)
print v(xbgr.mr_n92351520)
print v(xbgr.mr_n89383792)
print v(xbgr.mr_n89676752)
print v(xbgr.mr_n89839104)
print v(xbgr.mr_n89873920)
print v(xbgr.mr_n90108064)
print v(xbgr.mr_n90165280)
print v(xbgr.mr_n90424896)
print v(xbgr.mr_n90663440)
print v(xbgr.mr_n90793696)
print v(xbgr.mr_n90960288)
print v(xbgr.mr_n91032496)
print v(xbgr.mr_n91123616)
print v(xbgr.mr_n91248544)
print v(xbgr.mr_n91379376)
print v(xbgr.mr_n91471392)
print v(xbgr.mr_n91605088)
print v(xbgr.mr_n90796032)
print v(xbgr.mr_n90963488)
print v(xbgr.mr_n91010576)
print v(xbgr.mr_n91122144)
print v(xbgr.mr_n91243152)
print v(xbgr.mr_n91376672)
print v(xbgr.mr_n91471504)
print v(xbgr.mr_n91605200)
print v(xbgr.mr_n91840048)
print v(xbgr.mr_n92119264)
print v(xbgr.mr_n92354256)
print v(xbgr.mr_n89383328)
print v(xbgr.mr_n89677344)
print v(xbgr.mr_n89837904)
print v(xbgr.mr_n89873328)
print v(xbgr.mr_n91845248)
print v(xbgr.mr_n92032960)
print v(xbgr.mr_n92355824)
print v(xbgr.mr_n90697392)
print v(xbgr.mr_n90821312)
print v(xbgr.mr_n90899664)
print v(xbgr.mr_n91040272)
print v(xbgr.mr_n91128640)
print v(xbgr.mr_n91259840)
print v(xbgr.mr_n91389568)
print v(xbgr.mr_n91534176)
print v(xbgr.mr_n89381216)
print v(xbgr.mr_n89677936)
print v(xbgr.mr_n89837104)
print v(xbgr.mr_n89872736)
print v(xbgr.mr_n91674976)
print v(xbgr.mr_n91642800)
print v(xbgr.mr_n92133584)
print v(xbgr.mr_n91842080)
print v(xbgr.mr_n92033616)
print v(xbgr.mr_n92353264)
print v(xbgr.mr_n89250112)
print v(xbgr.mr_n89610896)
print v(xbgr.mr_n89836704)
print v(xbgr.mr_n89872144)
print v(xbgr.mr_n90798288)
print v(xbgr.mr_n90961840)
print v(xbgr.mr_n91030432)
print v(xbgr.mr_n91120512)
print v(xbgr.mr_n91247072)
print v(xbgr.mr_n91371584)
print v(xbgr.mr_n91450112)
print v(xbgr.mr_n91583152)
print v(xbgr.mr_n90119424)
print v(xbgr.mr_n90203344)
print v(xbgr.mr_n90462976)
print v(xbgr.mr_n90659168)
print v(xbgr.mr_n90120480)
print v(xbgr.mr_n90188768)
print v(xbgr.mr_n90462800)
print v(xbgr.mr_n90659728)
print v(xbgr.mr_n89249648)
print v(xbgr.mr_n89610304)
print v(xbgr.mr_n89835584)
print v(xbgr.mr_n89871552)
print v(xbgr.mr_n91841152)
print v(xbgr.mr_n92118176)
print v(xbgr.mr_n92356640)
print v(xbgr.mr_n90060720)
print v(xbgr.mr_n90133168)
print v(xbgr.mr_n90344448)
print v(xbgr.mr_n90531328)
print v(xbgr.mr_n89249184)
print v(xbgr.mr_n89542544)
print v(xbgr.mr_n89835184)
print v(xbgr.mr_n89870960)
print v(xbgr.mr_n91838928)
print v(xbgr.mr_n92031184)
print v(xbgr.mr_n92361760)
print v(xbgr.mr_n91674512)
print v(xbgr.mr_n91817760)
print v(xbgr.mr_n92133312)
print v(xbgr.mr_n90096400)
print v(xbgr.mr_n90165536)
print v(xbgr.mr_n90422896)
print v(xbgr.mr_n90661760)
print v(xbgr.mr_n90796832)
print v(xbgr.mr_n90928336)
print v(xbgr.mr_n91027776)
print v(xbgr.mr_n91111520)
print v(xbgr.mr_n91238064)
print v(xbgr.mr_n91328896)
print v(xbgr.mr_n91462384)
print v(xbgr.mr_n91593808)
print v(xbgr.mr_n89242176)
print v(xbgr.mr_n89609120)
print v(xbgr.mr_n89833984)
print v(xbgr.mr_n89870368)
print v(xbgr.mr_n90794992)
print v(xbgr.mr_n90960864)
print v(xbgr.mr_n91024016)
print v(xbgr.mr_n91114832)
print v(xbgr.mr_n91245008)
print v(xbgr.mr_n91369776)
print v(xbgr.mr_n91470976)
print v(xbgr.mr_n91600880)
print v(xbgr.mr_n91836240)
print v(xbgr.mr_n92026768)
print v(xbgr.mr_n92354080)
print v(xbgr.mr_n89248256)
print v(xbgr.mr_n89608528)
print v(xbgr.mr_n89833184)
print v(xbgr.mr_n89869776)
print v(xbgr.mr_n90696928)
print v(xbgr.mr_n90820848)
print v(xbgr.mr_n90860096)
print v(xbgr.mr_n91040080)
print v(xbgr.mr_n91128368)
print v(xbgr.mr_n91259568)
print v(xbgr.mr_n91389296)
print v(xbgr.mr_n91534064)
print v(xbgr.mr_n91834960)
print v(xbgr.mr_n92106752)
print v(xbgr.mr_n92359376)
print v(xbgr.mr_n89247792)
print v(xbgr.mr_n89607936)
print v(xbgr.mr_n89832784)
print v(xbgr.mr_n89869184)
print v(xbgr.mr_n91840160)
print v(xbgr.mr_n92029408)
print v(xbgr.mr_n92360944)
print v(xbgr.mr_n90769184)
print v(xbgr.mr_n90942048)
print v(xbgr.mr_n91011024)
print v(xbgr.d4)
print v(xbgr.mr_n91242368)
print v(xbgr.mr_n91371232)
print v(xbgr.mr_n91387952)
print v(xbgr.mr_n91578928)
print v(xbgr.mr_n90110928)
print v(xbgr.mr_n90190592)
print v(xbgr.mr_n90443760)
print v(xbgr.mr_n90661584)
print v(xbgr.mr_n90119888)
print v(xbgr.mr_n90175472)
print v(xbgr.mr_n90462192)
print v(xbgr.mr_n90660912)
print v(xbgr.mr_n91674048)
print v(xbgr.mr_n91813632)
print v(xbgr.mr_n92133040)
print v(xbgr.mr_n89247328)
print v(xbgr.mr_n89607344)
print v(xbgr.mr_n89831584)
print v(xbgr.mr_n89868592)
print v(xbgr.mr_n91838752)
print v(xbgr.mr_n92030064)
print v(xbgr.mr_n92361936)
print v(xbgr.mr_n90058704)
print v(xbgr.mr_n89370512)
print v(xbgr.mr_n90344016)
print v(xbgr.mr_n90530528)
print v(xbgr.mr_n89246864)
print v(xbgr.mr_n89606160)
print v(xbgr.mr_n89831184)
print v(xbgr.mr_n89866992)
print v(xbgr.mr_n91836064)
print v(xbgr.mr_n92116144)
print v(xbgr.mr_n92359200)
print v(xbgr.mr_n90099808)
print v(xbgr.mr_n89376288)
print v(xbgr.mr_n90426800)
print v(xbgr.mr_n90659904)
print v(xbgr.mr_n89246400)
print v(xbgr.mr_n89605568)
print v(xbgr.mr_n89716704)
print v(xbgr.mr_n90060304)
print v(xbgr.mr_n90794384)
print v(xbgr.mr_n90947968)
print v(xbgr.mr_n91009408)
print v(xbgr.mr_n91114208)
print v(xbgr.mr_n91240304)
print v(xbgr.mr_n91368704)
print v(xbgr.mr_n91470544)
print v(xbgr.mr_n91600688)
print v(xbgr.mr_n90794816)
print v(xbgr.mr_n90957616)
print v(xbgr.mr_n91013536)
print v(xbgr.mr_n91112736)
print v(xbgr.mr_n91236912)
print v(xbgr.mr_n91369024)
print v(xbgr.mr_n91472624)
print v(xbgr.mr_n91605936)
print v(xbgr.mr_n91834848)
print v(xbgr.mr_n92027696)
print v(xbgr.mr_n92363504)
print v(xbgr.mr_n89245936)
print v(xbgr.mr_n89604320)
print v(xbgr.mr_n89717296)
print v(xbgr.mr_n90059904)
print v(xbgr.mr_n91673360)
print v(xbgr.mr_n91742032)
print v(xbgr.mr_n92132496)
print v(xbgr.mr_n90696464)
print v(xbgr.mr_n90819920)
print v(xbgr.mr_n90901136)
print v(xbgr.mr_n91039968)
print v(xbgr.mr_n91127824)
print v(xbgr.mr_n91259104)
print v(xbgr.mr_n91388832)
print v(xbgr.mr_n91533840)
print v(xbgr.mr_n91825056)
print v(xbgr.mr_n92028288)
print v(xbgr.mr_n92358384)
print v(xbgr.mr_n89245472)
print v(xbgr.mr_n89300752)
print v(xbgr.mr_n89715520)
print v(xbgr.mr_n90059504)
print v(xbgr.mr_n90793872)
print v(xbgr.mr_n90928528)
print v(xbgr.mr_n91009072)
print v(xbgr.mr_n91111168)
print v(xbgr.mr_n91237536)
print v(xbgr.mr_n90973504)
print v(xbgr.mr_n91449936)
print v(xbgr.mr_n91581376)
print v(xbgr.mr_n90117504)
print v(xbgr.mr_n90460432)
print v(xbgr.mr_n90628256)
print v(xbgr.mr_n90118496)
print v(xbgr.mr_n90460256)
print v(xbgr.mr_n90658048)
print v(xbgr.mr_n91833840)
print v(xbgr.mr_n92116368)
print v(xbgr.mr_n92364496)
print v(xbgr.mr_n89243360)
print v(xbgr.mr_n89602608)
print v(xbgr.mr_n89716112)
print v(xbgr.mr_n90059104)
print v(xbgr.mr_n89556000)
print v(xbgr.mr_n89564512)
print v(xbgr.mr_n91830080)
print v(xbgr.mr_n92026304)
print v(xbgr.mr_n92366064)
print v(xbgr.mr_n90031024)
print v(xbgr.mr_n89853888)
print v(xbgr.mr_n90343840)
print v(xbgr.mr_n90525584)
print v(xbgr.mr_n89441440)
print v(xbgr.n_23)
print v(xbgr.mr_n89714336)
print v(xbgr.mr_n90058304)
print v(xbgr.mr_n89586464)
print v(xbgr.mr_n91673056)
print v(xbgr.mr_n91814752)
print v(xbgr.mr_n92132304)
print v(xbgr.mr_n91833664)
print v(xbgr.mr_n92025376)
print v(xbgr.mr_n92367056)
print v(xbgr.n_12)
print v(xbgr.n_25)
print v(xbgr.mr_n89714928)
print v(xbgr.mr_n90034576)
print v(xbgr.mr_n90047744)
print v(xbgr.mr_n90437552)
print v(xbgr.mr_n90559424)
print v(xbgr.mr_n90791760)
print v(xbgr.mr_n90954704)
print v(xbgr.mr_n91025360)
print v(xbgr.mr_n91099808)
print v(xbgr.mr_n91216016)
print v(xbgr.mr_n91362576)
print v(xbgr.mr_n91460608)
print v(xbgr.mr_n91600112)
print v(xbgr.mr_n90786864)
print v(xbgr.mr_n90950400)
print v(xbgr.mr_n90971712)
print v(xbgr.mr_n91110672)
print v(xbgr.mr_n91236640)
print v(xbgr.mr_n90974112)
print v(xbgr.mr_n91461200)
print v(xbgr.mr_n91601824)
print v(xbgr.mr_n89420384)
print v(xbgr.mr_n89541744)
print v(xbgr.mr_n89713152)
print v(xbgr.mr_n90053504)
print v(xbgr.mr_n91831744)
print v(xbgr.mr_n92107088)
print v(xbgr.mr_n92372176)
print v(xbgr.mr_n90696000)
print v(xbgr.mr_n90819536)
print v(xbgr.mr_n90905616)
print v(xbgr.mr_n91037008)
print v(xbgr.mr_n91127632)
print v(xbgr.mr_n91258992)
print v(xbgr.mr_n91388720)
print v(xbgr.mr_n91528432)
print v(xbgr.n_17)
print v(xbgr.n_22)
print v(xbgr.mr_n89713744)
print v(xbgr.mr_n90051104)
print v(xbgr.mr_n91831920)
print v(xbgr.mr_n91987312)
print v(xbgr.mr_n92369616)
print v(xbgr.mr_n91672752)
print v(xbgr.mr_n91815360)
print v(xbgr.mr_n92132192)
print v(xbgr.mr_n90785920)
print v(xbgr.mr_n90952528)
print v(xbgr.mr_n91015760)
print v(xbgr.mr_n91108032)
print v(xbgr.mr_n91236176)
print v(xbgr.mr_n91368208)
print v(xbgr.mr_n91425632)
print v(xbgr.mr_n91579104)
print v(xbgr.mr_n90114928)
print v(xbgr.mr_n90446704)
print v(xbgr.mr_n90657872)
print v(xbgr.n_18)
print v(xbgr.mr_n89539920)
print v(xbgr.mr_n89711968)
print v(xbgr.mr_n90049104)
print v(xbgr.mr_n90118960)
print v(xbgr.mr_n90459648)
print v(xbgr.mr_n90601152)
print v(xbgr.mr_n91830432)
print v(xbgr.mr_n91980896)
print v(xbgr.mr_n92366880)
print v(xbgr.mr_n89735296)
print v(xbgr.mr_n89275792)
print v(xbgr.mr_n89438576)
print v(xbgr.mr_n89539072)
print v(xbgr.mr_n89712560)
print v(xbgr.mr_n90013008)
print v(xbgr.mr_n90027472)
print v(xbgr.mr_n89316448)
print v(xbgr.mr_n90342880)
print v(xbgr.mr_n90527424)
print v(xbgr.mr_n91828576)
print v(xbgr.mr_n92056480)
print v(xbgr.mr_n92364320)
print v(xbgr.mr_n89373536)
print v(xbgr.mr_n89426400)
print v(xbgr.mr_n89538352)
print v(xbgr.mr_n89711376)
print v(xbgr.mr_n90045776)
print v(xbgr.mr_n90104304)
print v(xbgr.mr_n90392400)
print v(xbgr.mr_n90546464)
print v(xbgr.mr_n91662208)
print v(xbgr.mr_n91991440)
print v(xbgr.mr_n92371184)
print v(xbgr.mr_n90761328)
print v(xbgr.mr_n90862704)
print v(xbgr.mr_n91018464)
print v(xbgr.mr_n91099120)
print v(xbgr.mr_n91202112)
print v(xbgr.mr_n91364640)
print v(xbgr.mr_n91468144)
print v(xbgr.mr_n91597360)
print v(xbgr.mr_n90783984)
print v(xbgr.mr_n90881520)
print v(xbgr.mr_n91019136)
print v(xbgr.mr_n90979888)
print v(xbgr.mr_n91232256)
print v(xbgr.mr_n91367312)
print v(xbgr.mr_n91461792)
print v(xbgr.mr_n91599920)
print v(xbgr.mr_n91660608)
print v(xbgr.mr_n91818464)
print v(xbgr.mr_n92129600)
print v(xbgr.mr_n89381024)
print v(xbgr.mr_n89378560)
print v(xbgr.mr_n89709472)
print v(xbgr.mr_n90035760)
print v(xbgr.mr_n91828752)
print v(xbgr.mr_n91989376)
print v(xbgr.mr_n92368624)
print v(xbgr.mr_n90695536)
print v(xbgr.mr_n90817152)
print v(xbgr.mr_n90884624)
print v(xbgr.mr_n91038688)
print v(xbgr.mr_n91120928)
print v(xbgr.mr_n91257264)
print v(xbgr.mr_n91386144)
print v(xbgr.mr_n91526032)
print v(xbgr.mr_n91742912)
print v(xbgr.mr_n92114048)
print v(xbgr.mr_n92372000)
print v(xbgr.mr_n89976512)
print v(xbgr.mr_n90781872)
print v(xbgr.mr_n90815440)
print v(xbgr.mr_n91011600)
print v(xbgr.mr_n91102048)
print v(xbgr.mr_n91232032)
print v(xbgr.mr_n91362800)
print v(xbgr.mr_n91381792)
print v(xbgr.mr_n90978032)
print v(xbgr.mr_n90118384)
print v(xbgr.mr_n90446304)
print v(xbgr.mr_n90633776)
print v(xbgr.mr_n90111280)
print v(xbgr.mr_n90445968)
print v(xbgr.mr_n90630096)
print v(xbgr.mr_n91826688)
print v(xbgr.mr_n91957136)
print v(xbgr.mr_n92373744)
print v(xbgr.mr_n89457392)
print v(xbgr.mr_n91661232)
print v(xbgr.mr_n91818176)
print v(xbgr.mr_n92131776)
print v(xbgr.mr_n90049904)
print v(xbgr.mr_n89345536)
print v(xbgr.mr_n90341616)
print v(xbgr.mr_n90472976)
print v(xbgr.mr_n89277728)
print v(xbgr.mr_n91626784)
print v(xbgr.mr_n91989152)
print v(xbgr.mr_n92374736)
print v(xbgr.mr_n90090640)
print v(xbgr.mr_n90413168)
print v(xbgr.mr_n90603520)
print v(dvbe)
print v(iptat)
print v(pbias)
print v(pcasc)
print v(r4)
print v(vbe)
print v(vdd)
print v(vref)
print v(vdd)-v(vdd)
echo METALLIC_POINT_VOLTAGES_END
echo METALLIC_ALL_NODE_VOLTAGES_BEGIN
print v(xbgr.b1b)
print v(xbgr.c2)
print v(xbgr.d1)
print v(xbgr.d2)
print v(xbgr.d3)
print v(xbgr.d4)
print v(xbgr.d5)
print v(xbgr.det)
print v(dvbe)
print v(iptat)
print v(xbgr.kick)
print v(xbgr.mr_n76109424)
print v(xbgr.mr_n76155040)
print v(xbgr.mr_n77003568)
print v(xbgr.mr_n78548224)
print v(xbgr.mr_n78636144)
print v(xbgr.mr_n78914816)
print v(xbgr.mr_n78914928)
print v(xbgr.mr_n78915248)
print v(xbgr.mr_n78915360)
print v(xbgr.mr_n78915776)
print v(xbgr.mr_n78915888)
print v(xbgr.mr_n78916208)
print v(xbgr.mr_n78916320)
print v(xbgr.mr_n78916752)
print v(xbgr.mr_n78916992)
print v(xbgr.mr_n78917104)
print v(xbgr.mr_n78917456)
print v(xbgr.mr_n78917776)
print v(xbgr.mr_n78917888)
print v(xbgr.mr_n78918320)
print v(xbgr.mr_n78918640)
print v(xbgr.mr_n78918752)
print v(xbgr.mr_n78919184)
print v(xbgr.mr_n78919504)
print v(xbgr.mr_n78919616)
print v(xbgr.mr_n78920048)
print v(xbgr.mr_n78920368)
print v(xbgr.mr_n78920480)
print v(xbgr.mr_n78920912)
print v(xbgr.mr_n78921232)
print v(xbgr.mr_n78921344)
print v(xbgr.mr_n78921776)
print v(xbgr.mr_n78922096)
print v(xbgr.mr_n78922208)
print v(xbgr.mr_n78922640)
print v(xbgr.mr_n78922960)
print v(xbgr.mr_n78923072)
print v(xbgr.mr_n78923504)
print v(xbgr.mr_n78923824)
print v(xbgr.mr_n78923936)
print v(xbgr.mr_n78924368)
print v(xbgr.mr_n78924688)
print v(xbgr.mr_n78924800)
print v(xbgr.mr_n78925232)
print v(xbgr.mr_n78925552)
print v(xbgr.mr_n78925664)
print v(xbgr.mr_n78926096)
print v(xbgr.mr_n78926416)
print v(xbgr.mr_n78926528)
print v(xbgr.mr_n78926960)
print v(xbgr.mr_n78927280)
print v(xbgr.mr_n78927392)
print v(xbgr.mr_n78927824)
print v(xbgr.mr_n78928144)
print v(xbgr.mr_n78928256)
print v(xbgr.mr_n78928688)
print v(xbgr.mr_n78929008)
print v(xbgr.mr_n78929120)
print v(xbgr.mr_n78929552)
print v(xbgr.mr_n78929872)
print v(xbgr.mr_n78929984)
print v(xbgr.mr_n78930416)
print v(xbgr.mr_n78930736)
print v(xbgr.mr_n78930848)
print v(xbgr.mr_n78931168)
print v(xbgr.mr_n78931280)
print v(xbgr.mr_n78931600)
print v(xbgr.mr_n78931712)
print v(xbgr.mr_n78932032)
print v(xbgr.mr_n78932144)
print v(xbgr.mr_n78932464)
print v(xbgr.mr_n78932576)
print v(xbgr.mr_n78932896)
print v(xbgr.mr_n78933008)
print v(xbgr.mr_n78933328)
print v(xbgr.mr_n78933440)
print v(xbgr.mr_n78933760)
print v(xbgr.mr_n78933872)
print v(xbgr.mr_n78934192)
print v(xbgr.mr_n78934304)
print v(xbgr.mr_n78934624)
print v(xbgr.mr_n78934736)
print v(xbgr.mr_n78935056)
print v(xbgr.mr_n78935168)
print v(xbgr.mr_n78935488)
print v(xbgr.mr_n78935600)
print v(xbgr.mr_n78935920)
print v(xbgr.mr_n78936032)
print v(xbgr.mr_n78936352)
print v(xbgr.mr_n78936464)
print v(xbgr.mr_n78936784)
print v(xbgr.mr_n78936896)
print v(xbgr.mr_n78937216)
print v(xbgr.mr_n78937328)
print v(xbgr.mr_n78937648)
print v(xbgr.mr_n78937760)
print v(xbgr.mr_n78938080)
print v(xbgr.mr_n78938192)
print v(xbgr.mr_n78938512)
print v(xbgr.mr_n78938624)
print v(xbgr.mr_n78938944)
print v(xbgr.mr_n78939056)
print v(xbgr.mr_n78939376)
print v(xbgr.mr_n78939488)
print v(xbgr.mr_n78939808)
print v(xbgr.mr_n79515152)
print v(xbgr.mr_n79515472)
print v(xbgr.mr_n79515584)
print v(xbgr.mr_n79515904)
print v(xbgr.mr_n79516016)
print v(xbgr.mr_n79516336)
print v(xbgr.mr_n79516448)
print v(xbgr.mr_n79516768)
print v(xbgr.mr_n79516880)
print v(xbgr.mr_n79517200)
print v(xbgr.mr_n79517312)
print v(xbgr.mr_n79517632)
print v(xbgr.mr_n79517744)
print v(xbgr.mr_n79518064)
print v(xbgr.mr_n79518176)
print v(xbgr.mr_n79518496)
print v(xbgr.mr_n79518608)
print v(xbgr.mr_n79518928)
print v(xbgr.mr_n79519040)
print v(xbgr.mr_n79519360)
print v(xbgr.mr_n79519472)
print v(xbgr.mr_n79519792)
print v(xbgr.mr_n79519904)
print v(xbgr.mr_n79520224)
print v(xbgr.mr_n79520336)
print v(xbgr.mr_n79520656)
print v(xbgr.mr_n79520768)
print v(xbgr.mr_n79521088)
print v(xbgr.mr_n79521200)
print v(xbgr.mr_n79521520)
print v(xbgr.mr_n79521632)
print v(xbgr.mr_n79521760)
print v(xbgr.mr_n79521872)
print v(xbgr.mr_n79522192)
print v(xbgr.mr_n79522304)
print v(xbgr.mr_n79522624)
print v(xbgr.mr_n79522736)
print v(xbgr.mr_n79523056)
print v(xbgr.mr_n79523168)
print v(xbgr.mr_n79523488)
print v(xbgr.mr_n79523600)
print v(xbgr.mr_n79523920)
print v(xbgr.mr_n79524032)
print v(xbgr.mr_n79524352)
print v(xbgr.mr_n79524464)
print v(xbgr.mr_n79524784)
print v(xbgr.mr_n79524896)
print v(xbgr.mr_n79525216)
print v(xbgr.mr_n79525328)
print v(xbgr.mr_n79525648)
print v(xbgr.mr_n79525760)
print v(xbgr.mr_n79526080)
print v(xbgr.mr_n79526192)
print v(xbgr.mr_n79526512)
print v(xbgr.mr_n79526624)
print v(xbgr.mr_n79526944)
print v(xbgr.mr_n79527056)
print v(xbgr.mr_n79527376)
print v(xbgr.mr_n79527488)
print v(xbgr.mr_n79527808)
print v(xbgr.mr_n79527920)
print v(xbgr.mr_n79528240)
print v(xbgr.mr_n79528352)
print v(xbgr.mr_n79528672)
print v(xbgr.mr_n79528784)
print v(xbgr.mr_n79529104)
print v(xbgr.mr_n79529216)
print v(xbgr.mr_n79529536)
print v(xbgr.mr_n79529648)
print v(xbgr.mr_n79529968)
print v(xbgr.mr_n79530080)
print v(xbgr.mr_n79530400)
print v(xbgr.mr_n79530512)
print v(xbgr.mr_n79530832)
print v(xbgr.mr_n79530944)
print v(xbgr.mr_n79531264)
print v(xbgr.mr_n79531376)
print v(xbgr.mr_n79531696)
print v(xbgr.mr_n79531808)
print v(xbgr.mr_n79532128)
print v(xbgr.mr_n79532240)
print v(xbgr.mr_n79532560)
print v(xbgr.mr_n79532672)
print v(xbgr.mr_n79532992)
print v(xbgr.mr_n79533104)
print v(xbgr.mr_n79533424)
print v(xbgr.mr_n79533536)
print v(xbgr.mr_n79533856)
print v(xbgr.mr_n79533968)
print v(xbgr.mr_n79534288)
print v(xbgr.mr_n79534400)
print v(xbgr.mr_n79534720)
print v(xbgr.mr_n79534832)
print v(xbgr.mr_n79535152)
print v(xbgr.mr_n79535264)
print v(xbgr.mr_n79535584)
print v(xbgr.mr_n79535696)
print v(xbgr.mr_n79536016)
print v(xbgr.mr_n79536128)
print v(xbgr.mr_n79536448)
print v(xbgr.mr_n79536560)
print v(xbgr.mr_n79536880)
print v(xbgr.mr_n79536992)
print v(xbgr.mr_n79537312)
print v(xbgr.mr_n79537424)
print v(xbgr.mr_n79537744)
print v(xbgr.mr_n79537856)
print v(xbgr.mr_n79538176)
print v(xbgr.mr_n79538288)
print v(xbgr.mr_n79538608)
print v(xbgr.mr_n79538720)
print v(xbgr.mr_n79539040)
print v(xbgr.mr_n79539152)
print v(xbgr.mr_n79539472)
print v(xbgr.mr_n79539584)
print v(xbgr.mr_n79539904)
print v(xbgr.mr_n79540016)
print v(xbgr.mr_n79540336)
print v(xbgr.mr_n79540448)
print v(xbgr.mr_n79540768)
print v(xbgr.mr_n79540880)
print v(xbgr.mr_n79541200)
print v(xbgr.mr_n79541312)
print v(xbgr.mr_n79541632)
print v(xbgr.mr_n79541744)
print v(xbgr.mr_n79542064)
print v(xbgr.mr_n79542176)
print v(xbgr.mr_n79542496)
print v(xbgr.mr_n79542608)
print v(xbgr.mr_n79542928)
print v(xbgr.mr_n79543040)
print v(xbgr.mr_n79543360)
print v(xbgr.mr_n79543472)
print v(xbgr.mr_n79543792)
print v(xbgr.mr_n79543904)
print v(xbgr.mr_n79544224)
print v(xbgr.mr_n79544336)
print v(xbgr.mr_n79544656)
print v(xbgr.mr_n79544768)
print v(xbgr.mr_n79545088)
print v(xbgr.mr_n79545200)
print v(xbgr.mr_n79545520)
print v(xbgr.mr_n79545632)
print v(xbgr.mr_n79545952)
print v(xbgr.mr_n79546064)
print v(xbgr.mr_n79546384)
print v(xbgr.mr_n79546496)
print v(xbgr.mr_n79546816)
print v(xbgr.mr_n79546928)
print v(xbgr.mr_n79547248)
print v(xbgr.mr_n79547360)
print v(xbgr.mr_n79547680)
print v(xbgr.mr_n79547792)
print v(xbgr.mr_n79548112)
print v(xbgr.mr_n79548224)
print v(xbgr.mr_n79548544)
print v(xbgr.mr_n79548656)
print v(xbgr.mr_n79548976)
print v(xbgr.mr_n79549088)
print v(xbgr.mr_n79549408)
print v(xbgr.mr_n79549520)
print v(xbgr.mr_n79549840)
print v(xbgr.mr_n79549952)
print v(xbgr.mr_n79550272)
print v(xbgr.mr_n79550384)
print v(xbgr.mr_n79550704)
print v(xbgr.mr_n79550816)
print v(xbgr.mr_n79551136)
print v(xbgr.mr_n79551248)
print v(xbgr.mr_n79551568)
print v(xbgr.mr_n79551680)
print v(xbgr.mr_n79552000)
print v(xbgr.mr_n79552112)
print v(xbgr.mr_n79552432)
print v(xbgr.mr_n79552544)
print v(xbgr.mr_n79552864)
print v(xbgr.mr_n79552976)
print v(xbgr.mr_n79553296)
print v(xbgr.mr_n79553408)
print v(xbgr.mr_n79553728)
print v(xbgr.mr_n79553840)
print v(xbgr.mr_n79554160)
print v(xbgr.mr_n79554272)
print v(xbgr.mr_n79554592)
print v(xbgr.mr_n79554704)
print v(xbgr.mr_n79555024)
print v(xbgr.mr_n79555136)
print v(xbgr.mr_n79555456)
print v(xbgr.mr_n79555568)
print v(xbgr.mr_n79555888)
print v(xbgr.mr_n79556000)
print v(xbgr.mr_n79556320)
print v(xbgr.mr_n79556432)
print v(xbgr.mr_n79556752)
print v(xbgr.mr_n79556864)
print v(xbgr.mr_n79557184)
print v(xbgr.mr_n79557296)
print v(xbgr.mr_n79557840)
print v(xbgr.mr_n79557952)
print v(xbgr.mr_n79558272)
print v(xbgr.mr_n79558384)
print v(xbgr.mr_n79558704)
print v(xbgr.mr_n79558816)
print v(xbgr.mr_n79559136)
print v(xbgr.mr_n79559248)
print v(xbgr.mr_n79559568)
print v(xbgr.mr_n79559680)
print v(xbgr.mr_n79560000)
print v(xbgr.mr_n79560112)
print v(xbgr.mr_n79560432)
print v(xbgr.mr_n79560544)
print v(xbgr.mr_n79560864)
print v(xbgr.mr_n79560976)
print v(xbgr.mr_n79561296)
print v(xbgr.mr_n79561408)
print v(xbgr.mr_n79561728)
print v(xbgr.mr_n79561840)
print v(xbgr.mr_n79562160)
print v(xbgr.mr_n79562272)
print v(xbgr.mr_n79562592)
print v(xbgr.mr_n79562704)
print v(xbgr.mr_n79563024)
print v(xbgr.mr_n79563136)
print v(xbgr.mr_n79563456)
print v(xbgr.mr_n79563568)
print v(xbgr.mr_n79563888)
print v(xbgr.mr_n79564000)
print v(xbgr.mr_n79591120)
print v(xbgr.mr_n79591232)
print v(xbgr.mr_n79591552)
print v(xbgr.mr_n79591664)
print v(xbgr.mr_n79591984)
print v(xbgr.mr_n79592096)
print v(xbgr.mr_n79592416)
print v(xbgr.mr_n79592528)
print v(xbgr.mr_n79592848)
print v(xbgr.mr_n79592960)
print v(xbgr.mr_n79593280)
print v(xbgr.mr_n79593392)
print v(xbgr.mr_n79593712)
print v(xbgr.mr_n79593824)
print v(xbgr.mr_n79594144)
print v(xbgr.mr_n79594256)
print v(xbgr.mr_n79594576)
print v(xbgr.mr_n79594688)
print v(xbgr.mr_n79595008)
print v(xbgr.mr_n79595120)
print v(xbgr.mr_n79595440)
print v(xbgr.mr_n79595552)
print v(xbgr.mr_n79595872)
print v(xbgr.mr_n79595984)
print v(xbgr.mr_n79596304)
print v(xbgr.mr_n79596416)
print v(xbgr.mr_n79596736)
print v(xbgr.mr_n79596848)
print v(xbgr.mr_n79597168)
print v(xbgr.mr_n79597280)
print v(xbgr.mr_n79597600)
print v(xbgr.mr_n79597712)
print v(xbgr.mr_n79598032)
print v(xbgr.mr_n79598144)
print v(xbgr.mr_n79598464)
print v(xbgr.mr_n79598576)
print v(xbgr.mr_n79598896)
print v(xbgr.mr_n79599008)
print v(xbgr.mr_n79599328)
print v(xbgr.mr_n79599440)
print v(xbgr.mr_n79599760)
print v(xbgr.mr_n79599872)
print v(xbgr.mr_n79600192)
print v(xbgr.mr_n79600304)
print v(xbgr.mr_n79600624)
print v(xbgr.mr_n79600736)
print v(xbgr.mr_n79601056)
print v(xbgr.mr_n79601168)
print v(xbgr.mr_n79601488)
print v(xbgr.mr_n79601600)
print v(xbgr.mr_n79601920)
print v(xbgr.mr_n79602032)
print v(xbgr.mr_n79602352)
print v(xbgr.mr_n79602464)
print v(xbgr.mr_n79602784)
print v(xbgr.mr_n79602896)
print v(xbgr.mr_n79603216)
print v(xbgr.mr_n79603328)
print v(xbgr.mr_n79603648)
print v(xbgr.mr_n79603760)
print v(xbgr.mr_n79604080)
print v(xbgr.mr_n79604192)
print v(xbgr.mr_n79604512)
print v(xbgr.mr_n79604624)
print v(xbgr.mr_n79604944)
print v(xbgr.mr_n79605056)
print v(xbgr.mr_n79605376)
print v(xbgr.mr_n79605488)
print v(xbgr.mr_n79605808)
print v(xbgr.mr_n79605920)
print v(xbgr.mr_n79606240)
print v(xbgr.mr_n79606352)
print v(xbgr.mr_n79606672)
print v(xbgr.mr_n79606784)
print v(xbgr.mr_n79607104)
print v(xbgr.mr_n79607216)
print v(xbgr.mr_n79607536)
print v(xbgr.mr_n79607648)
print v(xbgr.mr_n79607968)
print v(xbgr.mr_n79608080)
print v(xbgr.mr_n79608400)
print v(xbgr.mr_n79608512)
print v(xbgr.mr_n79608832)
print v(xbgr.mr_n79608944)
print v(xbgr.mr_n79609264)
print v(xbgr.mr_n79609376)
print v(xbgr.mr_n79609696)
print v(xbgr.mr_n79609808)
print v(xbgr.mr_n79610128)
print v(xbgr.mr_n79610240)
print v(xbgr.mr_n79610560)
print v(xbgr.mr_n79610672)
print v(xbgr.mr_n79610992)
print v(xbgr.mr_n79611104)
print v(xbgr.mr_n79611424)
print v(xbgr.mr_n79611536)
print v(xbgr.mr_n79611856)
print v(xbgr.mr_n79611968)
print v(xbgr.mr_n79612288)
print v(xbgr.mr_n79612400)
print v(xbgr.mr_n79612720)
print v(xbgr.mr_n79612832)
print v(xbgr.mr_n79613152)
print v(xbgr.mr_n79613264)
print v(xbgr.mr_n79613584)
print v(xbgr.mr_n79613696)
print v(xbgr.mr_n79614016)
print v(xbgr.mr_n79614128)
print v(xbgr.mr_n79614448)
print v(xbgr.mr_n79614560)
print v(xbgr.mr_n79614880)
print v(xbgr.mr_n79614992)
print v(xbgr.mr_n79615312)
print v(xbgr.mr_n79615424)
print v(xbgr.mr_n79615744)
print v(xbgr.mr_n79615856)
print v(xbgr.mr_n79616176)
print v(xbgr.mr_n79616288)
print v(xbgr.mr_n79616608)
print v(xbgr.mr_n79616720)
print v(xbgr.mr_n79617040)
print v(xbgr.mr_n79617152)
print v(xbgr.mr_n79617472)
print v(xbgr.mr_n79617584)
print v(xbgr.mr_n79617904)
print v(xbgr.mr_n79618016)
print v(xbgr.mr_n79618336)
print v(xbgr.mr_n79618448)
print v(xbgr.mr_n79618768)
print v(xbgr.mr_n79618880)
print v(xbgr.mr_n79619200)
print v(xbgr.mr_n79619312)
print v(xbgr.mr_n79619632)
print v(xbgr.mr_n79619744)
print v(xbgr.mr_n79620064)
print v(xbgr.mr_n79620176)
print v(xbgr.mr_n79620496)
print v(xbgr.mr_n79620608)
print v(xbgr.mr_n79620928)
print v(xbgr.mr_n79621040)
print v(xbgr.mr_n79621360)
print v(xbgr.mr_n79621472)
print v(xbgr.mr_n79621792)
print v(xbgr.mr_n79621904)
print v(xbgr.mr_n79622224)
print v(xbgr.mr_n79622336)
print v(xbgr.mr_n79622656)
print v(xbgr.mr_n79622768)
print v(xbgr.mr_n79623088)
print v(xbgr.mr_n79623200)
print v(xbgr.mr_n79623520)
print v(xbgr.mr_n79623632)
print v(xbgr.mr_n79623952)
print v(xbgr.mr_n79624064)
print v(xbgr.mr_n79624384)
print v(xbgr.mr_n79624496)
print v(xbgr.mr_n79624816)
print v(xbgr.mr_n79624928)
print v(xbgr.mr_n79625248)
print v(xbgr.mr_n79625360)
print v(xbgr.mr_n79625680)
print v(xbgr.mr_n79625792)
print v(xbgr.mr_n79626112)
print v(xbgr.mr_n79626224)
print v(xbgr.mr_n79626544)
print v(xbgr.mr_n79626656)
print v(xbgr.mr_n79626976)
print v(xbgr.mr_n79627088)
print v(xbgr.mr_n79627408)
print v(xbgr.mr_n79627520)
print v(xbgr.mr_n79627840)
print v(xbgr.mr_n79627952)
print v(xbgr.mr_n79628272)
print v(xbgr.mr_n79628384)
print v(xbgr.mr_n79628704)
print v(xbgr.mr_n79628816)
print v(xbgr.mr_n79629136)
print v(xbgr.mr_n79629248)
print v(xbgr.mr_n79629568)
print v(xbgr.mr_n79629680)
print v(xbgr.mr_n79630000)
print v(xbgr.mr_n79630112)
print v(xbgr.mr_n79630432)
print v(xbgr.mr_n79630544)
print v(xbgr.mr_n79630864)
print v(xbgr.mr_n79630976)
print v(xbgr.mr_n79631296)
print v(xbgr.mr_n79631408)
print v(xbgr.mr_n79631728)
print v(xbgr.mr_n79631840)
print v(xbgr.mr_n79632160)
print v(xbgr.mr_n79632272)
print v(xbgr.mr_n79632592)
print v(xbgr.mr_n79632704)
print v(xbgr.mr_n79633024)
print v(xbgr.mr_n79633136)
print v(xbgr.mr_n79633456)
print v(xbgr.mr_n79633568)
print v(xbgr.mr_n79633888)
print v(xbgr.mr_n79634000)
print v(xbgr.mr_n79634320)
print v(xbgr.mr_n79634432)
print v(xbgr.mr_n79634752)
print v(xbgr.mr_n79634864)
print v(xbgr.mr_n79635184)
print v(xbgr.mr_n79635296)
print v(xbgr.mr_n79635616)
print v(xbgr.mr_n79635728)
print v(xbgr.mr_n79636048)
print v(xbgr.mr_n79636160)
print v(xbgr.mr_n79636480)
print v(xbgr.mr_n79636592)
print v(xbgr.mr_n79636912)
print v(xbgr.mr_n79637024)
print v(xbgr.mr_n79637344)
print v(xbgr.mr_n79637456)
print v(xbgr.mr_n79637776)
print v(xbgr.mr_n79637888)
print v(xbgr.mr_n79638208)
print v(xbgr.mr_n79638320)
print v(xbgr.mr_n79638640)
print v(xbgr.mr_n79638752)
print v(xbgr.mr_n79639072)
print v(xbgr.mr_n79639184)
print v(xbgr.mr_n79639504)
print v(xbgr.mr_n79639616)
print v(xbgr.mr_n79639936)
print v(xbgr.mr_n79640048)
print v(xbgr.mr_n79640368)
print v(xbgr.mr_n79640480)
print v(xbgr.mr_n79640800)
print v(xbgr.mr_n79640912)
print v(xbgr.mr_n79641232)
print v(xbgr.mr_n79641344)
print v(xbgr.mr_n79641664)
print v(xbgr.mr_n79641776)
print v(xbgr.mr_n79642096)
print v(xbgr.mr_n79642208)
print v(xbgr.mr_n79642528)
print v(xbgr.mr_n79642640)
print v(xbgr.mr_n79642960)
print v(xbgr.mr_n79643072)
print v(xbgr.mr_n79643392)
print v(xbgr.mr_n79643504)
print v(xbgr.mr_n79643824)
print v(xbgr.mr_n79643936)
print v(xbgr.mr_n79644256)
print v(xbgr.mr_n79644368)
print v(xbgr.mr_n79644688)
print v(xbgr.mr_n79644800)
print v(xbgr.mr_n79645120)
print v(xbgr.mr_n79645232)
print v(xbgr.mr_n79645552)
print v(xbgr.mr_n79645664)
print v(xbgr.mr_n79645984)
print v(xbgr.mr_n79646096)
print v(xbgr.mr_n79646416)
print v(xbgr.mr_n79646528)
print v(xbgr.mr_n79646848)
print v(xbgr.mr_n79646960)
print v(xbgr.mr_n79647280)
print v(xbgr.mr_n79647392)
print v(xbgr.mr_n79647712)
print v(xbgr.mr_n79647824)
print v(xbgr.mr_n79648144)
print v(xbgr.mr_n79648256)
print v(xbgr.mr_n79648576)
print v(xbgr.mr_n79648688)
print v(xbgr.mr_n79649008)
print v(xbgr.mr_n79649120)
print v(xbgr.mr_n79649440)
print v(xbgr.mr_n79649552)
print v(xbgr.mr_n79649872)
print v(xbgr.mr_n79649984)
print v(xbgr.mr_n79650304)
print v(xbgr.mr_n79650416)
print v(xbgr.mr_n79650736)
print v(xbgr.mr_n79650848)
print v(xbgr.mr_n79651168)
print v(xbgr.mr_n79651280)
print v(xbgr.mr_n79651600)
print v(xbgr.mr_n79651712)
print v(xbgr.mr_n79652032)
print v(xbgr.mr_n79652144)
print v(xbgr.mr_n79652464)
print v(xbgr.mr_n79652576)
print v(xbgr.mr_n79652896)
print v(xbgr.mr_n79653008)
print v(xbgr.mr_n79653328)
print v(xbgr.mr_n79653440)
print v(xbgr.mr_n79653760)
print v(xbgr.mr_n79653872)
print v(xbgr.mr_n79654192)
print v(xbgr.mr_n79654304)
print v(xbgr.mr_n79654624)
print v(xbgr.mr_n79654736)
print v(xbgr.mr_n79655056)
print v(xbgr.mr_n79655168)
print v(xbgr.mr_n79655488)
print v(xbgr.mr_n79655600)
print v(xbgr.mr_n79655920)
print v(xbgr.mr_n79656032)
print v(xbgr.mr_n79656352)
print v(xbgr.mr_n79656464)
print v(xbgr.mr_n79656784)
print v(xbgr.mr_n79656896)
print v(xbgr.mr_n79657216)
print v(xbgr.mr_n79657328)
print v(xbgr.mr_n79657648)
print v(xbgr.mr_n79657760)
print v(xbgr.mr_n79658080)
print v(xbgr.mr_n79658192)
print v(xbgr.mr_n79658512)
print v(xbgr.mr_n79658624)
print v(xbgr.mr_n79658944)
print v(xbgr.mr_n79659056)
print v(xbgr.mr_n79659376)
print v(xbgr.mr_n79659488)
print v(xbgr.mr_n79659808)
print v(xbgr.mr_n79659920)
print v(xbgr.mr_n79660240)
print v(xbgr.mr_n79660352)
print v(xbgr.mr_n79660672)
print v(xbgr.mr_n79660784)
print v(xbgr.mr_n79661104)
print v(xbgr.mr_n79661216)
print v(xbgr.mr_n79661536)
print v(xbgr.mr_n79661648)
print v(xbgr.mr_n79661968)
print v(xbgr.mr_n79662080)
print v(xbgr.mr_n79662400)
print v(xbgr.mr_n79662512)
print v(xbgr.mr_n79662832)
print v(xbgr.mr_n79662944)
print v(xbgr.mr_n79663264)
print v(xbgr.mr_n79663376)
print v(xbgr.mr_n79663696)
print v(xbgr.mr_n79663808)
print v(xbgr.mr_n79664128)
print v(xbgr.mr_n79664240)
print v(xbgr.mr_n79664560)
print v(xbgr.mr_n79664672)
print v(xbgr.mr_n79664992)
print v(xbgr.mr_n79665104)
print v(xbgr.mr_n79665424)
print v(xbgr.mr_n79665536)
print v(xbgr.mr_n79665856)
print v(xbgr.mr_n79665968)
print v(xbgr.mr_n79666288)
print v(xbgr.mr_n79666400)
print v(xbgr.mr_n79666720)
print v(xbgr.mr_n79666832)
print v(xbgr.mr_n79667152)
print v(xbgr.mr_n79667264)
print v(xbgr.mr_n79667584)
print v(xbgr.mr_n79667696)
print v(xbgr.mr_n79668016)
print v(xbgr.mr_n79668128)
print v(xbgr.mr_n79668448)
print v(xbgr.mr_n79668560)
print v(xbgr.mr_n79668880)
print v(xbgr.mr_n79668992)
print v(xbgr.mr_n79669312)
print v(xbgr.mr_n79669424)
print v(xbgr.mr_n79669744)
print v(xbgr.mr_n79669856)
print v(xbgr.mr_n79670176)
print v(xbgr.mr_n79670288)
print v(xbgr.mr_n79670608)
print v(xbgr.mr_n79670720)
print v(xbgr.mr_n79671040)
print v(xbgr.mr_n79671152)
print v(xbgr.mr_n79671472)
print v(xbgr.mr_n79671584)
print v(xbgr.mr_n79671904)
print v(xbgr.mr_n79672016)
print v(xbgr.mr_n79672336)
print v(xbgr.mr_n79672448)
print v(xbgr.mr_n79672768)
print v(xbgr.mr_n79672880)
print v(xbgr.mr_n79673200)
print v(xbgr.mr_n79673312)
print v(xbgr.mr_n79673632)
print v(xbgr.mr_n79673744)
print v(xbgr.mr_n79674064)
print v(xbgr.mr_n79674176)
print v(xbgr.mr_n79674496)
print v(xbgr.mr_n79674608)
print v(xbgr.mr_n79674928)
print v(xbgr.mr_n79675040)
print v(xbgr.mr_n79675360)
print v(xbgr.mr_n79675472)
print v(xbgr.mr_n79675792)
print v(xbgr.mr_n79675904)
print v(xbgr.mr_n79676224)
print v(xbgr.mr_n79676336)
print v(xbgr.mr_n79676656)
print v(xbgr.mr_n79676768)
print v(xbgr.mr_n79677088)
print v(xbgr.mr_n79677200)
print v(xbgr.mr_n79677520)
print v(xbgr.mr_n79677632)
print v(xbgr.mr_n79677952)
print v(xbgr.mr_n79678064)
print v(xbgr.mr_n79678384)
print v(xbgr.mr_n79678496)
print v(xbgr.mr_n79678816)
print v(xbgr.mr_n79678928)
print v(xbgr.mr_n79679248)
print v(xbgr.mr_n79679360)
print v(xbgr.mr_n79679680)
print v(xbgr.mr_n79679792)
print v(xbgr.mr_n79680112)
print v(xbgr.mr_n79680224)
print v(xbgr.mr_n79680544)
print v(xbgr.mr_n79680656)
print v(xbgr.mr_n79680976)
print v(xbgr.mr_n79681088)
print v(xbgr.mr_n79681408)
print v(xbgr.mr_n79681520)
print v(xbgr.mr_n79681840)
print v(xbgr.mr_n79681952)
print v(xbgr.mr_n79682272)
print v(xbgr.mr_n79682384)
print v(xbgr.mr_n79682704)
print v(xbgr.mr_n79682816)
print v(xbgr.mr_n79683136)
print v(xbgr.mr_n79683248)
print v(xbgr.mr_n79683568)
print v(xbgr.mr_n79683680)
print v(xbgr.mr_n79684000)
print v(xbgr.mr_n79684112)
print v(xbgr.mr_n79684432)
print v(xbgr.mr_n79684544)
print v(xbgr.mr_n80689168)
print v(xbgr.mr_n80689280)
print v(xbgr.mr_n80689536)
print v(xbgr.mr_n80689648)
print v(xbgr.mr_n80689904)
print v(xbgr.mr_n80690016)
print v(xbgr.mr_n80690272)
print v(xbgr.mr_n80690384)
print v(xbgr.mr_n80690640)
print v(xbgr.mr_n80690752)
print v(xbgr.mr_n80691008)
print v(xbgr.mr_n80691120)
print v(xbgr.mr_n80691376)
print v(xbgr.mr_n80691488)
print v(xbgr.mr_n80691744)
print v(xbgr.mr_n80691856)
print v(xbgr.mr_n80692112)
print v(xbgr.mr_n80692224)
print v(xbgr.mr_n80692544)
print v(xbgr.mr_n80692656)
print v(xbgr.mr_n80692976)
print v(xbgr.mr_n80693088)
print v(xbgr.mr_n80693408)
print v(xbgr.mr_n80693520)
print v(xbgr.mr_n80693840)
print v(xbgr.mr_n80693952)
print v(xbgr.mr_n80694272)
print v(xbgr.mr_n80694384)
print v(xbgr.mr_n80694704)
print v(xbgr.mr_n80694816)
print v(xbgr.mr_n80695136)
print v(xbgr.mr_n80695248)
print v(xbgr.mr_n80695568)
print v(xbgr.mr_n80695680)
print v(xbgr.mr_n80696000)
print v(xbgr.mr_n80696112)
print v(xbgr.mr_n80696432)
print v(xbgr.mr_n80696544)
print v(xbgr.mr_n80696864)
print v(xbgr.mr_n80696976)
print v(xbgr.mr_n80697296)
print v(xbgr.mr_n80697408)
print v(xbgr.mr_n80697728)
print v(xbgr.mr_n80697840)
print v(xbgr.mr_n80698160)
print v(xbgr.mr_n80698272)
print v(xbgr.mr_n80698592)
print v(xbgr.mr_n80698704)
print v(xbgr.mr_n80699024)
print v(xbgr.mr_n80699136)
print v(xbgr.mr_n80699456)
print v(xbgr.mr_n80699568)
print v(xbgr.mr_n80699888)
print v(xbgr.mr_n80700000)
print v(xbgr.mr_n80700320)
print v(xbgr.mr_n80700432)
print v(xbgr.mr_n80700752)
print v(xbgr.mr_n80700864)
print v(xbgr.mr_n80701184)
print v(xbgr.mr_n80701296)
print v(xbgr.mr_n80701616)
print v(xbgr.mr_n80701728)
print v(xbgr.mr_n80702048)
print v(xbgr.mr_n80702160)
print v(xbgr.mr_n80702480)
print v(xbgr.mr_n80702592)
print v(xbgr.mr_n80702912)
print v(xbgr.mr_n80703024)
print v(xbgr.mr_n80703344)
print v(xbgr.mr_n80703456)
print v(xbgr.mr_n80703776)
print v(xbgr.mr_n80703888)
print v(xbgr.mr_n80704208)
print v(xbgr.mr_n80704320)
print v(xbgr.mr_n80704640)
print v(xbgr.mr_n80704752)
print v(xbgr.mr_n80705072)
print v(xbgr.mr_n80705184)
print v(xbgr.mr_n80705504)
print v(xbgr.mr_n80705616)
print v(xbgr.mr_n80705936)
print v(xbgr.mr_n80706048)
print v(xbgr.mr_n80706368)
print v(xbgr.mr_n80706480)
print v(xbgr.mr_n80706800)
print v(xbgr.mr_n80706912)
print v(xbgr.mr_n80707232)
print v(xbgr.mr_n80707344)
print v(xbgr.mr_n80707664)
print v(xbgr.mr_n80707776)
print v(xbgr.mr_n80708096)
print v(xbgr.mr_n80708208)
print v(xbgr.mr_n80708528)
print v(xbgr.mr_n80708640)
print v(xbgr.mr_n80708960)
print v(xbgr.mr_n80709072)
print v(xbgr.mr_n80709392)
print v(xbgr.mr_n80709504)
print v(xbgr.mr_n80709824)
print v(xbgr.mr_n80709936)
print v(xbgr.mr_n80710256)
print v(xbgr.mr_n80710368)
print v(xbgr.mr_n80710688)
print v(xbgr.mr_n80710800)
print v(xbgr.mr_n80711120)
print v(xbgr.mr_n80711232)
print v(xbgr.mr_n80711552)
print v(xbgr.mr_n80711664)
print v(xbgr.mr_n80711984)
print v(xbgr.mr_n80712096)
print v(xbgr.mr_n80712416)
print v(xbgr.mr_n80712528)
print v(xbgr.mr_n80712848)
print v(xbgr.mr_n80712960)
print v(xbgr.mr_n80713280)
print v(xbgr.mr_n80713392)
print v(xbgr.mr_n80713712)
print v(xbgr.mr_n80713824)
print v(xbgr.mr_n80714144)
print v(xbgr.mr_n80714256)
print v(xbgr.mr_n80714576)
print v(xbgr.mr_n80714688)
print v(xbgr.mr_n80715008)
print v(xbgr.mr_n80715120)
print v(xbgr.mr_n80715440)
print v(xbgr.mr_n80715552)
print v(xbgr.mr_n80715872)
print v(xbgr.mr_n80715984)
print v(xbgr.mr_n80716304)
print v(xbgr.mr_n80716416)
print v(xbgr.mr_n80716736)
print v(xbgr.mr_n80716848)
print v(xbgr.mr_n80717168)
print v(xbgr.mr_n80717280)
print v(xbgr.mr_n80717600)
print v(xbgr.mr_n80717712)
print v(xbgr.mr_n80718032)
print v(xbgr.mr_n80718144)
print v(xbgr.mr_n80718464)
print v(xbgr.mr_n80718576)
print v(xbgr.mr_n80718896)
print v(xbgr.mr_n80719008)
print v(xbgr.mr_n80719328)
print v(xbgr.mr_n80719440)
print v(xbgr.mr_n80719760)
print v(xbgr.mr_n80719872)
print v(xbgr.mr_n80720192)
print v(xbgr.mr_n80720304)
print v(xbgr.mr_n80720624)
print v(xbgr.mr_n80720736)
print v(xbgr.mr_n80721056)
print v(xbgr.mr_n80721168)
print v(xbgr.mr_n80721488)
print v(xbgr.mr_n80721600)
print v(xbgr.mr_n80721920)
print v(xbgr.mr_n80722032)
print v(xbgr.mr_n80722352)
print v(xbgr.mr_n80722464)
print v(xbgr.mr_n80722784)
print v(xbgr.mr_n80722896)
print v(xbgr.mr_n80723216)
print v(xbgr.mr_n80723328)
print v(xbgr.mr_n80723648)
print v(xbgr.mr_n80723760)
print v(xbgr.mr_n80724080)
print v(xbgr.mr_n80724192)
print v(xbgr.mr_n80724512)
print v(xbgr.mr_n80724624)
print v(xbgr.mr_n80724944)
print v(xbgr.mr_n80725056)
print v(xbgr.mr_n80725376)
print v(xbgr.mr_n80725488)
print v(xbgr.mr_n80725808)
print v(xbgr.mr_n80725920)
print v(xbgr.mr_n80726240)
print v(xbgr.mr_n80726352)
print v(xbgr.mr_n80726672)
print v(xbgr.mr_n80726784)
print v(xbgr.mr_n80727104)
print v(xbgr.mr_n80727216)
print v(xbgr.mr_n80727536)
print v(xbgr.mr_n80727648)
print v(xbgr.mr_n80727968)
print v(xbgr.mr_n80728080)
print v(xbgr.mr_n80728400)
print v(xbgr.mr_n80728512)
print v(xbgr.mr_n80728832)
print v(xbgr.mr_n80728944)
print v(xbgr.mr_n80729264)
print v(xbgr.mr_n80729376)
print v(xbgr.mr_n80729696)
print v(xbgr.mr_n80729808)
print v(xbgr.mr_n80730128)
print v(xbgr.mr_n80730240)
print v(xbgr.mr_n80730560)
print v(xbgr.mr_n80730672)
print v(xbgr.mr_n80730992)
print v(xbgr.mr_n80731104)
print v(xbgr.mr_n80731424)
print v(xbgr.mr_n80731536)
print v(xbgr.mr_n80731856)
print v(xbgr.mr_n80731968)
print v(xbgr.mr_n80732288)
print v(xbgr.mr_n80732400)
print v(xbgr.mr_n80732720)
print v(xbgr.mr_n80732832)
print v(xbgr.mr_n80733152)
print v(xbgr.mr_n80733264)
print v(xbgr.mr_n80733584)
print v(xbgr.mr_n80733696)
print v(xbgr.mr_n80734016)
print v(xbgr.mr_n80734128)
print v(xbgr.mr_n80734448)
print v(xbgr.mr_n80734560)
print v(xbgr.mr_n80734880)
print v(xbgr.mr_n80734992)
print v(xbgr.mr_n80735312)
print v(xbgr.mr_n80735424)
print v(xbgr.mr_n80735744)
print v(xbgr.mr_n80735856)
print v(xbgr.mr_n80736176)
print v(xbgr.mr_n80736288)
print v(xbgr.mr_n80736608)
print v(xbgr.mr_n80736720)
print v(xbgr.mr_n80737040)
print v(xbgr.mr_n80737152)
print v(xbgr.mr_n80737472)
print v(xbgr.mr_n80737584)
print v(xbgr.mr_n80737904)
print v(xbgr.mr_n80738016)
print v(xbgr.mr_n80738336)
print v(xbgr.mr_n80738448)
print v(xbgr.mr_n80738768)
print v(xbgr.mr_n80738880)
print v(xbgr.mr_n80739200)
print v(xbgr.mr_n80739312)
print v(xbgr.mr_n80739632)
print v(xbgr.mr_n80739744)
print v(xbgr.mr_n80740064)
print v(xbgr.mr_n80740176)
print v(xbgr.mr_n80740496)
print v(xbgr.mr_n80740608)
print v(xbgr.mr_n80740928)
print v(xbgr.mr_n80741040)
print v(xbgr.mr_n80741360)
print v(xbgr.mr_n80741472)
print v(xbgr.mr_n80741792)
print v(xbgr.mr_n80741904)
print v(xbgr.mr_n80742224)
print v(xbgr.mr_n80742336)
print v(xbgr.mr_n80742656)
print v(xbgr.mr_n80742768)
print v(xbgr.mr_n80743088)
print v(xbgr.mr_n80743200)
print v(xbgr.mr_n80743520)
print v(xbgr.mr_n80743632)
print v(xbgr.mr_n80743952)
print v(xbgr.mr_n80744064)
print v(xbgr.mr_n80744384)
print v(xbgr.mr_n80744496)
print v(xbgr.mr_n80744816)
print v(xbgr.mr_n80744928)
print v(xbgr.mr_n80745248)
print v(xbgr.mr_n80745360)
print v(xbgr.mr_n80745680)
print v(xbgr.mr_n80745792)
print v(xbgr.mr_n80746112)
print v(xbgr.mr_n80746224)
print v(xbgr.mr_n80746544)
print v(xbgr.mr_n80746656)
print v(xbgr.mr_n80746976)
print v(xbgr.mr_n80747088)
print v(xbgr.mr_n80747408)
print v(xbgr.mr_n80747520)
print v(xbgr.mr_n80747840)
print v(xbgr.mr_n80747952)
print v(xbgr.mr_n80748272)
print v(xbgr.mr_n80748384)
print v(xbgr.mr_n80748704)
print v(xbgr.mr_n80748816)
print v(xbgr.mr_n80749136)
print v(xbgr.mr_n80749248)
print v(xbgr.mr_n80749568)
print v(xbgr.mr_n80749680)
print v(xbgr.mr_n80750000)
print v(xbgr.mr_n80750112)
print v(xbgr.mr_n80750432)
print v(xbgr.mr_n80750544)
print v(xbgr.mr_n80750864)
print v(xbgr.mr_n80750976)
print v(xbgr.mr_n80751296)
print v(xbgr.mr_n80751408)
print v(xbgr.mr_n80751728)
print v(xbgr.mr_n80751840)
print v(xbgr.mr_n80752160)
print v(xbgr.mr_n80752272)
print v(xbgr.mr_n80752592)
print v(xbgr.mr_n80752704)
print v(xbgr.mr_n80753024)
print v(xbgr.mr_n80753136)
print v(xbgr.mr_n80753456)
print v(xbgr.mr_n80753568)
print v(xbgr.mr_n80753888)
print v(xbgr.mr_n80754000)
print v(xbgr.mr_n80754320)
print v(xbgr.mr_n80754432)
print v(xbgr.mr_n80754752)
print v(xbgr.mr_n80754864)
print v(xbgr.mr_n80755184)
print v(xbgr.mr_n80755296)
print v(xbgr.mr_n80755616)
print v(xbgr.mr_n80755728)
print v(xbgr.mr_n80756048)
print v(xbgr.mr_n80756160)
print v(xbgr.mr_n80756480)
print v(xbgr.mr_n80756592)
print v(xbgr.mr_n80756912)
print v(xbgr.mr_n80757024)
print v(xbgr.mr_n80757344)
print v(xbgr.mr_n80757456)
print v(xbgr.mr_n80757776)
print v(xbgr.mr_n80757888)
print v(xbgr.mr_n80758208)
print v(xbgr.mr_n80758320)
print v(xbgr.mr_n80758640)
print v(xbgr.mr_n80758752)
print v(xbgr.mr_n80759072)
print v(xbgr.mr_n80759184)
print v(xbgr.mr_n80759504)
print v(xbgr.mr_n80759616)
print v(xbgr.mr_n80759936)
print v(xbgr.mr_n80760048)
print v(xbgr.mr_n80760368)
print v(xbgr.mr_n80760480)
print v(xbgr.mr_n80760800)
print v(xbgr.mr_n80760912)
print v(xbgr.mr_n80761232)
print v(xbgr.mr_n80761344)
print v(xbgr.mr_n80761664)
print v(xbgr.mr_n80761776)
print v(xbgr.mr_n80762096)
print v(xbgr.mr_n80762208)
print v(xbgr.mr_n80762528)
print v(xbgr.mr_n80762640)
print v(xbgr.mr_n80762960)
print v(xbgr.mr_n80763072)
print v(xbgr.mr_n80763392)
print v(xbgr.mr_n80763504)
print v(xbgr.mr_n80763824)
print v(xbgr.mr_n80763936)
print v(xbgr.mr_n80764256)
print v(xbgr.mr_n80764368)
print v(xbgr.mr_n80764688)
print v(xbgr.mr_n80764800)
print v(xbgr.mr_n80765120)
print v(xbgr.mr_n80765232)
print v(xbgr.mr_n80765552)
print v(xbgr.mr_n80765664)
print v(xbgr.mr_n80765984)
print v(xbgr.mr_n80766096)
print v(xbgr.mr_n80766416)
print v(xbgr.mr_n80766528)
print v(xbgr.mr_n80766848)
print v(xbgr.mr_n80766960)
print v(xbgr.mr_n80767280)
print v(xbgr.mr_n80767392)
print v(xbgr.mr_n80767712)
print v(xbgr.mr_n80767824)
print v(xbgr.mr_n80768144)
print v(xbgr.mr_n80768256)
print v(xbgr.mr_n80768576)
print v(xbgr.mr_n80768688)
print v(xbgr.mr_n80769008)
print v(xbgr.mr_n80769120)
print v(xbgr.mr_n80769440)
print v(xbgr.mr_n80769552)
print v(xbgr.mr_n80769872)
print v(xbgr.mr_n80769984)
print v(xbgr.mr_n80770304)
print v(xbgr.mr_n80770416)
print v(xbgr.mr_n80770736)
print v(xbgr.mr_n80770848)
print v(xbgr.mr_n80771168)
print v(xbgr.mr_n80771280)
print v(xbgr.mr_n80771600)
print v(xbgr.mr_n80771712)
print v(xbgr.mr_n80772032)
print v(xbgr.mr_n80772144)
print v(xbgr.mr_n80772464)
print v(xbgr.mr_n80772576)
print v(xbgr.mr_n80772896)
print v(xbgr.mr_n80773008)
print v(xbgr.mr_n80773328)
print v(xbgr.mr_n80773440)
print v(xbgr.mr_n80773760)
print v(xbgr.mr_n80773872)
print v(xbgr.mr_n80774192)
print v(xbgr.mr_n80774304)
print v(xbgr.mr_n80774624)
print v(xbgr.mr_n80774736)
print v(xbgr.mr_n80775056)
print v(xbgr.mr_n80775168)
print v(xbgr.mr_n80775488)
print v(xbgr.mr_n80775600)
print v(xbgr.mr_n80775920)
print v(xbgr.mr_n80776032)
print v(xbgr.mr_n80776352)
print v(xbgr.mr_n80776464)
print v(xbgr.mr_n80776784)
print v(xbgr.mr_n80776896)
print v(xbgr.mr_n80777216)
print v(xbgr.mr_n80777328)
print v(xbgr.mr_n80777648)
print v(xbgr.mr_n80777760)
print v(xbgr.mr_n80778080)
print v(xbgr.mr_n80778192)
print v(xbgr.mr_n80778512)
print v(xbgr.mr_n80778624)
print v(xbgr.mr_n80778944)
print v(xbgr.mr_n80779056)
print v(xbgr.mr_n80779376)
print v(xbgr.mr_n80779488)
print v(xbgr.mr_n80779808)
print v(xbgr.mr_n80779920)
print v(xbgr.mr_n80780240)
print v(xbgr.mr_n80780352)
print v(xbgr.mr_n80780672)
print v(xbgr.mr_n80780784)
print v(xbgr.mr_n80781104)
print v(xbgr.mr_n80781216)
print v(xbgr.mr_n80781536)
print v(xbgr.mr_n80781648)
print v(xbgr.mr_n80781968)
print v(xbgr.mr_n80782080)
print v(xbgr.mr_n80782400)
print v(xbgr.mr_n80782512)
print v(xbgr.mr_n80782832)
print v(xbgr.mr_n80782944)
print v(xbgr.mr_n80783264)
print v(xbgr.mr_n80783376)
print v(xbgr.mr_n80783696)
print v(xbgr.mr_n80783808)
print v(xbgr.mr_n80784128)
print v(xbgr.mr_n80784240)
print v(xbgr.mr_n80784560)
print v(xbgr.mr_n80784672)
print v(xbgr.mr_n80784992)
print v(xbgr.mr_n80785104)
print v(xbgr.mr_n80785424)
print v(xbgr.mr_n80785536)
print v(xbgr.mr_n80785856)
print v(xbgr.mr_n80785968)
print v(xbgr.mr_n80786288)
print v(xbgr.mr_n80786400)
print v(xbgr.mr_n80786720)
print v(xbgr.mr_n80786832)
print v(xbgr.mr_n80787152)
print v(xbgr.mr_n80787264)
print v(xbgr.mr_n80787584)
print v(xbgr.mr_n80787696)
print v(xbgr.mr_n80788016)
print v(xbgr.mr_n80788128)
print v(xbgr.mr_n80788448)
print v(xbgr.mr_n80788560)
print v(xbgr.mr_n80788880)
print v(xbgr.mr_n80788992)
print v(xbgr.mr_n80789312)
print v(xbgr.mr_n80789424)
print v(xbgr.mr_n80789744)
print v(xbgr.mr_n80789856)
print v(xbgr.mr_n80790176)
print v(xbgr.mr_n80790288)
print v(xbgr.mr_n80790608)
print v(xbgr.mr_n80790720)
print v(xbgr.mr_n80791008)
print v(xbgr.mr_n80791120)
print v(xbgr.mr_n80791440)
print v(xbgr.mr_n80791552)
print v(xbgr.mr_n80791872)
print v(xbgr.mr_n80791984)
print v(xbgr.mr_n80792304)
print v(xbgr.mr_n80792416)
print v(xbgr.mr_n80792736)
print v(xbgr.mr_n80792848)
print v(xbgr.mr_n80793168)
print v(xbgr.mr_n80793280)
print v(xbgr.mr_n80793600)
print v(xbgr.mr_n80793712)
print v(xbgr.mr_n80794032)
print v(xbgr.mr_n80794144)
print v(xbgr.mr_n80794464)
print v(xbgr.mr_n80794576)
print v(xbgr.mr_n80794896)
print v(xbgr.mr_n80795008)
print v(xbgr.mr_n80795328)
print v(xbgr.mr_n80795440)
print v(xbgr.mr_n80795760)
print v(xbgr.mr_n80795872)
print v(xbgr.mr_n80796192)
print v(xbgr.mr_n80796304)
print v(xbgr.mr_n80796624)
print v(xbgr.mr_n80796736)
print v(xbgr.mr_n80797056)
print v(xbgr.mr_n80797168)
print v(xbgr.mr_n80797488)
print v(xbgr.mr_n80797600)
print v(xbgr.mr_n80797920)
print v(xbgr.mr_n80798032)
print v(xbgr.mr_n80798352)
print v(xbgr.mr_n80798464)
print v(xbgr.mr_n80798784)
print v(xbgr.mr_n80798896)
print v(xbgr.mr_n80799216)
print v(xbgr.mr_n80799328)
print v(xbgr.mr_n80799648)
print v(xbgr.mr_n80799760)
print v(xbgr.mr_n80800080)
print v(xbgr.mr_n80800192)
print v(xbgr.mr_n80800512)
print v(xbgr.mr_n80800624)
print v(xbgr.mr_n80800944)
print v(xbgr.mr_n80801056)
print v(xbgr.mr_n80801376)
print v(xbgr.mr_n80801488)
print v(xbgr.mr_n80801808)
print v(xbgr.mr_n80801920)
print v(xbgr.mr_n80802240)
print v(xbgr.mr_n80802352)
print v(xbgr.mr_n80802672)
print v(xbgr.mr_n80802784)
print v(xbgr.mr_n80803104)
print v(xbgr.mr_n80803216)
print v(xbgr.mr_n80803536)
print v(xbgr.mr_n80803648)
print v(xbgr.mr_n80803968)
print v(xbgr.mr_n80804080)
print v(xbgr.mr_n80804400)
print v(xbgr.mr_n80804512)
print v(xbgr.mr_n80804832)
print v(xbgr.mr_n80804944)
print v(xbgr.mr_n80805264)
print v(xbgr.mr_n80805376)
print v(xbgr.mr_n80805696)
print v(xbgr.mr_n80805808)
print v(xbgr.mr_n80806128)
print v(xbgr.mr_n80806240)
print v(xbgr.mr_n80806560)
print v(xbgr.mr_n80806672)
print v(xbgr.mr_n80806992)
print v(xbgr.mr_n80807104)
print v(xbgr.mr_n80807424)
print v(xbgr.mr_n80807536)
print v(xbgr.mr_n80807856)
print v(xbgr.mr_n80807968)
print v(xbgr.mr_n80808288)
print v(xbgr.mr_n80808400)
print v(xbgr.mr_n80808720)
print v(xbgr.mr_n80808832)
print v(xbgr.mr_n80809152)
print v(xbgr.mr_n80809264)
print v(xbgr.mr_n80809584)
print v(xbgr.mr_n80809696)
print v(xbgr.mr_n80810016)
print v(xbgr.mr_n80810128)
print v(xbgr.mr_n80810448)
print v(xbgr.mr_n80810560)
print v(xbgr.mr_n80810880)
print v(xbgr.mr_n80810992)
print v(xbgr.mr_n80811312)
print v(xbgr.mr_n80811424)
print v(xbgr.mr_n80811744)
print v(xbgr.mr_n80811856)
print v(xbgr.mr_n80812176)
print v(xbgr.mr_n80812288)
print v(xbgr.mr_n80812608)
print v(xbgr.mr_n80812720)
print v(xbgr.mr_n80813040)
print v(xbgr.mr_n80813152)
print v(xbgr.mr_n80813472)
print v(xbgr.mr_n80813584)
print v(xbgr.mr_n80813904)
print v(xbgr.mr_n80814016)
print v(xbgr.mr_n80814336)
print v(xbgr.mr_n80814448)
print v(xbgr.mr_n80814768)
print v(xbgr.mr_n80814880)
print v(xbgr.mr_n80815200)
print v(xbgr.mr_n80815312)
print v(xbgr.mr_n80815632)
print v(xbgr.mr_n80815744)
print v(xbgr.mr_n80816064)
print v(xbgr.mr_n80816176)
print v(xbgr.mr_n80816496)
print v(xbgr.mr_n80816608)
print v(xbgr.mr_n80816928)
print v(xbgr.mr_n80817040)
print v(xbgr.mr_n80817360)
print v(xbgr.mr_n80817472)
print v(xbgr.mr_n80817792)
print v(xbgr.mr_n80817904)
print v(xbgr.mr_n80818224)
print v(xbgr.mr_n80818336)
print v(xbgr.mr_n80818656)
print v(xbgr.mr_n80818768)
print v(xbgr.mr_n80819088)
print v(xbgr.mr_n80819200)
print v(xbgr.mr_n80819520)
print v(xbgr.mr_n80819632)
print v(xbgr.mr_n80819952)
print v(xbgr.mr_n80820064)
print v(xbgr.mr_n80820384)
print v(xbgr.mr_n80820496)
print v(xbgr.mr_n80820816)
print v(xbgr.mr_n80820928)
print v(xbgr.mr_n80821248)
print v(xbgr.mr_n80821360)
print v(xbgr.mr_n80821680)
print v(xbgr.mr_n80821792)
print v(xbgr.mr_n80822112)
print v(xbgr.mr_n80822224)
print v(xbgr.mr_n80822544)
print v(xbgr.mr_n80822656)
print v(xbgr.mr_n80822976)
print v(xbgr.mr_n80823088)
print v(xbgr.mr_n80823408)
print v(xbgr.mr_n80823520)
print v(xbgr.mr_n80823840)
print v(xbgr.mr_n80823952)
print v(xbgr.mr_n80824272)
print v(xbgr.mr_n80824384)
print v(xbgr.mr_n80824704)
print v(xbgr.mr_n80824816)
print v(xbgr.mr_n80825136)
print v(xbgr.mr_n80825248)
print v(xbgr.mr_n80825568)
print v(xbgr.mr_n80825680)
print v(xbgr.mr_n80826000)
print v(xbgr.mr_n80826112)
print v(xbgr.mr_n80826432)
print v(xbgr.mr_n80826544)
print v(xbgr.mr_n80826864)
print v(xbgr.mr_n80826976)
print v(xbgr.mr_n80827296)
print v(xbgr.mr_n80827408)
print v(xbgr.mr_n80827728)
print v(xbgr.mr_n80827840)
print v(xbgr.mr_n80828160)
print v(xbgr.mr_n80828272)
print v(xbgr.mr_n80828592)
print v(xbgr.mr_n80828704)
print v(xbgr.mr_n80829024)
print v(xbgr.mr_n80829136)
print v(xbgr.mr_n80829456)
print v(xbgr.mr_n80829568)
print v(xbgr.mr_n80829888)
print v(xbgr.mr_n80830000)
print v(xbgr.mr_n80830320)
print v(xbgr.mr_n80830432)
print v(xbgr.mr_n80830752)
print v(xbgr.mr_n80830864)
print v(xbgr.mr_n80831184)
print v(xbgr.mr_n80831296)
print v(xbgr.mr_n80831616)
print v(xbgr.mr_n80831728)
print v(xbgr.mr_n80832048)
print v(xbgr.mr_n80832160)
print v(xbgr.mr_n80832480)
print v(xbgr.mr_n80832592)
print v(xbgr.mr_n80832912)
print v(xbgr.mr_n80833024)
print v(xbgr.mr_n80833344)
print v(xbgr.mr_n80833456)
print v(xbgr.mr_n80833776)
print v(xbgr.mr_n80833888)
print v(xbgr.mr_n80834208)
print v(xbgr.mr_n80834320)
print v(xbgr.mr_n80834640)
print v(xbgr.mr_n80834752)
print v(xbgr.mr_n80835072)
print v(xbgr.mr_n80835184)
print v(xbgr.mr_n80835504)
print v(xbgr.mr_n80835616)
print v(xbgr.mr_n80835936)
print v(xbgr.mr_n80836048)
print v(xbgr.mr_n80836368)
print v(xbgr.mr_n80836480)
print v(xbgr.mr_n80836800)
print v(xbgr.mr_n80836912)
print v(xbgr.mr_n80837232)
print v(xbgr.mr_n80837344)
print v(xbgr.mr_n80837664)
print v(xbgr.mr_n80837776)
print v(xbgr.mr_n80838096)
print v(xbgr.mr_n80838208)
print v(xbgr.mr_n80838528)
print v(xbgr.mr_n80838640)
print v(xbgr.mr_n80838960)
print v(xbgr.mr_n80839072)
print v(xbgr.mr_n80839392)
print v(xbgr.mr_n80839504)
print v(xbgr.mr_n80839824)
print v(xbgr.mr_n80839936)
print v(xbgr.mr_n80840256)
print v(xbgr.mr_n80840368)
print v(xbgr.mr_n80840688)
print v(xbgr.mr_n80840800)
print v(xbgr.mr_n80841120)
print v(xbgr.mr_n80841232)
print v(xbgr.mr_n80841552)
print v(xbgr.mr_n80841664)
print v(xbgr.mr_n80841984)
print v(xbgr.mr_n80842096)
print v(xbgr.mr_n80842416)
print v(xbgr.mr_n80842528)
print v(xbgr.mr_n80842848)
print v(xbgr.mr_n80842960)
print v(xbgr.mr_n80843280)
print v(xbgr.mr_n80843392)
print v(xbgr.mr_n80843712)
print v(xbgr.mr_n80843824)
print v(xbgr.mr_n80844144)
print v(xbgr.mr_n80844256)
print v(xbgr.mr_n80844576)
print v(xbgr.mr_n80844688)
print v(xbgr.mr_n80845008)
print v(xbgr.mr_n80845120)
print v(xbgr.mr_n80845440)
print v(xbgr.mr_n80845552)
print v(xbgr.mr_n80845872)
print v(xbgr.mr_n80845984)
print v(xbgr.mr_n80846304)
print v(xbgr.mr_n80846416)
print v(xbgr.mr_n80846736)
print v(xbgr.mr_n80846848)
print v(xbgr.mr_n80847168)
print v(xbgr.mr_n80847280)
print v(xbgr.mr_n80847600)
print v(xbgr.mr_n80847712)
print v(xbgr.mr_n80848032)
print v(xbgr.mr_n80848144)
print v(xbgr.mr_n80848464)
print v(xbgr.mr_n80848576)
print v(xbgr.mr_n80848896)
print v(xbgr.mr_n80849008)
print v(xbgr.mr_n80849328)
print v(xbgr.mr_n80849440)
print v(xbgr.mr_n80849760)
print v(xbgr.mr_n80849872)
print v(xbgr.mr_n80850192)
print v(xbgr.mr_n80850304)
print v(xbgr.mr_n80850624)
print v(xbgr.mr_n80850736)
print v(xbgr.mr_n80851056)
print v(xbgr.mr_n80851168)
print v(xbgr.mr_n80851488)
print v(xbgr.mr_n80851600)
print v(xbgr.mr_n80851920)
print v(xbgr.mr_n80852032)
print v(xbgr.mr_n80852352)
print v(xbgr.mr_n80852464)
print v(xbgr.mr_n80852784)
print v(xbgr.mr_n80852896)
print v(xbgr.mr_n80853216)
print v(xbgr.mr_n80853328)
print v(xbgr.mr_n80853648)
print v(xbgr.mr_n80853760)
print v(xbgr.mr_n80854080)
print v(xbgr.mr_n80854192)
print v(xbgr.mr_n80854512)
print v(xbgr.mr_n80854624)
print v(xbgr.mr_n80854944)
print v(xbgr.mr_n80855056)
print v(xbgr.mr_n80855376)
print v(xbgr.mr_n80855488)
print v(xbgr.mr_n80855808)
print v(xbgr.mr_n80855920)
print v(xbgr.mr_n80856240)
print v(xbgr.mr_n80856352)
print v(xbgr.mr_n80856672)
print v(xbgr.mr_n80856784)
print v(xbgr.mr_n80857104)
print v(xbgr.mr_n80857216)
print v(xbgr.mr_n80857536)
print v(xbgr.mr_n80857648)
print v(xbgr.mr_n80857968)
print v(xbgr.mr_n80858080)
print v(xbgr.mr_n80858400)
print v(xbgr.mr_n80858512)
print v(xbgr.mr_n80858832)
print v(xbgr.mr_n80858944)
print v(xbgr.mr_n80859264)
print v(xbgr.mr_n80859376)
print v(xbgr.mr_n80859696)
print v(xbgr.mr_n80859808)
print v(xbgr.mr_n80860128)
print v(xbgr.mr_n80860240)
print v(xbgr.mr_n80860560)
print v(xbgr.mr_n80860672)
print v(xbgr.mr_n80860992)
print v(xbgr.mr_n80861104)
print v(xbgr.mr_n80861424)
print v(xbgr.mr_n80861536)
print v(xbgr.mr_n80861856)
print v(xbgr.mr_n80861968)
print v(xbgr.mr_n80862288)
print v(xbgr.mr_n80862400)
print v(xbgr.mr_n80862720)
print v(xbgr.mr_n80862832)
print v(xbgr.mr_n80863152)
print v(xbgr.mr_n80863264)
print v(xbgr.mr_n80863584)
print v(xbgr.mr_n80863696)
print v(xbgr.mr_n80864016)
print v(xbgr.mr_n80864128)
print v(xbgr.mr_n80864448)
print v(xbgr.mr_n80864560)
print v(xbgr.mr_n80864880)
print v(xbgr.mr_n80864992)
print v(xbgr.mr_n80865312)
print v(xbgr.mr_n80865424)
print v(xbgr.mr_n80865744)
print v(xbgr.mr_n80865856)
print v(xbgr.mr_n80866176)
print v(xbgr.mr_n80866288)
print v(xbgr.mr_n80866608)
print v(xbgr.mr_n80866720)
print v(xbgr.mr_n80867040)
print v(xbgr.mr_n80867152)
print v(xbgr.mr_n80867472)
print v(xbgr.mr_n80867584)
print v(xbgr.mr_n80867904)
print v(xbgr.mr_n80868016)
print v(xbgr.mr_n80868336)
print v(xbgr.mr_n80868448)
print v(xbgr.mr_n80868768)
print v(xbgr.mr_n80868880)
print v(xbgr.mr_n80869200)
print v(xbgr.mr_n80869312)
print v(xbgr.mr_n80869632)
print v(xbgr.mr_n80869744)
print v(xbgr.mr_n80870064)
print v(xbgr.mr_n80870176)
print v(xbgr.mr_n80870496)
print v(xbgr.mr_n80870608)
print v(xbgr.mr_n80870928)
print v(xbgr.mr_n80871040)
print v(xbgr.mr_n80871360)
print v(xbgr.mr_n80871472)
print v(xbgr.mr_n80871792)
print v(xbgr.mr_n80871904)
print v(xbgr.mr_n80872224)
print v(xbgr.mr_n80872336)
print v(xbgr.mr_n80872656)
print v(xbgr.mr_n80872768)
print v(xbgr.mr_n80873088)
print v(xbgr.mr_n80873200)
print v(xbgr.mr_n80873520)
print v(xbgr.mr_n80873632)
print v(xbgr.mr_n80873952)
print v(xbgr.mr_n80874064)
print v(xbgr.mr_n80874384)
print v(xbgr.mr_n80874496)
print v(xbgr.mr_n80874816)
print v(xbgr.mr_n80874928)
print v(xbgr.mr_n80875248)
print v(xbgr.mr_n80875360)
print v(xbgr.mr_n80875680)
print v(xbgr.mr_n80875792)
print v(xbgr.mr_n80876112)
print v(xbgr.mr_n80876224)
print v(xbgr.mr_n80876544)
print v(xbgr.mr_n80876656)
print v(xbgr.mr_n80876976)
print v(xbgr.mr_n80877088)
print v(xbgr.mr_n80877408)
print v(xbgr.mr_n80877520)
print v(xbgr.mr_n80877840)
print v(xbgr.mr_n80877952)
print v(xbgr.mr_n80878272)
print v(xbgr.mr_n80878384)
print v(xbgr.mr_n80878704)
print v(xbgr.mr_n80878816)
print v(xbgr.mr_n80879136)
print v(xbgr.mr_n80879248)
print v(xbgr.mr_n80879568)
print v(xbgr.mr_n80879680)
print v(xbgr.mr_n80880000)
print v(xbgr.mr_n80880112)
print v(xbgr.mr_n80880432)
print v(xbgr.mr_n80880544)
print v(xbgr.mr_n80880864)
print v(xbgr.mr_n80880976)
print v(xbgr.mr_n80881296)
print v(xbgr.mr_n80881408)
print v(xbgr.mr_n80881728)
print v(xbgr.mr_n80881840)
print v(xbgr.mr_n80882160)
print v(xbgr.mr_n80882272)
print v(xbgr.mr_n80882592)
print v(xbgr.mr_n80882704)
print v(xbgr.mr_n80883024)
print v(xbgr.mr_n80883136)
print v(xbgr.mr_n80883456)
print v(xbgr.mr_n80883568)
print v(xbgr.mr_n80883888)
print v(xbgr.mr_n80884000)
print v(xbgr.mr_n80884320)
print v(xbgr.mr_n80884432)
print v(xbgr.mr_n80884752)
print v(xbgr.mr_n80884864)
print v(xbgr.mr_n80885184)
print v(xbgr.mr_n80885296)
print v(xbgr.mr_n80885616)
print v(xbgr.mr_n80885728)
print v(xbgr.mr_n80886048)
print v(xbgr.mr_n80886160)
print v(xbgr.mr_n80886480)
print v(xbgr.mr_n80886592)
print v(xbgr.mr_n80886912)
print v(xbgr.mr_n80887024)
print v(xbgr.mr_n80887344)
print v(xbgr.mr_n80887456)
print v(xbgr.mr_n80887776)
print v(xbgr.mr_n80887888)
print v(xbgr.mr_n80888208)
print v(xbgr.mr_n80888320)
print v(xbgr.mr_n80888640)
print v(xbgr.mr_n80888752)
print v(xbgr.mr_n80889072)
print v(xbgr.mr_n80889184)
print v(xbgr.mr_n80889504)
print v(xbgr.mr_n80889616)
print v(xbgr.mr_n80889936)
print v(xbgr.mr_n80890048)
print v(xbgr.mr_n80890368)
print v(xbgr.mr_n80890480)
print v(xbgr.mr_n80890800)
print v(xbgr.mr_n80890912)
print v(xbgr.mr_n80891232)
print v(xbgr.mr_n80891344)
print v(xbgr.mr_n80891664)
print v(xbgr.mr_n80891776)
print v(xbgr.mr_n80892096)
print v(xbgr.mr_n80892208)
print v(xbgr.mr_n80892528)
print v(xbgr.mr_n80892640)
print v(xbgr.mr_n80892960)
print v(xbgr.mr_n80893072)
print v(xbgr.mr_n80893392)
print v(xbgr.mr_n80893504)
print v(xbgr.mr_n80893824)
print v(xbgr.mr_n80893936)
print v(xbgr.mr_n80894256)
print v(xbgr.mr_n80894368)
print v(xbgr.mr_n80894688)
print v(xbgr.mr_n80894800)
print v(xbgr.mr_n80895120)
print v(xbgr.mr_n80895232)
print v(xbgr.mr_n80895552)
print v(xbgr.mr_n80895664)
print v(xbgr.mr_n80895984)
print v(xbgr.mr_n80896096)
print v(xbgr.mr_n80896416)
print v(xbgr.mr_n80896528)
print v(xbgr.mr_n80896848)
print v(xbgr.mr_n80896960)
print v(xbgr.mr_n80897280)
print v(xbgr.mr_n80897392)
print v(xbgr.mr_n80897712)
print v(xbgr.mr_n80897824)
print v(xbgr.mr_n80898144)
print v(xbgr.mr_n80898256)
print v(xbgr.mr_n80898576)
print v(xbgr.mr_n80898688)
print v(xbgr.mr_n80899008)
print v(xbgr.mr_n80899120)
print v(xbgr.mr_n80899440)
print v(xbgr.mr_n80899552)
print v(xbgr.mr_n80899872)
print v(xbgr.mr_n80899984)
print v(xbgr.mr_n80900304)
print v(xbgr.mr_n80900416)
print v(xbgr.mr_n80900736)
print v(xbgr.mr_n80900848)
print v(xbgr.mr_n80901168)
print v(xbgr.mr_n80901280)
print v(xbgr.mr_n80901600)
print v(xbgr.mr_n80901712)
print v(xbgr.mr_n80902032)
print v(xbgr.mr_n80902144)
print v(xbgr.mr_n80902464)
print v(xbgr.mr_n80902576)
print v(xbgr.mr_n80902896)
print v(xbgr.mr_n80903008)
print v(xbgr.mr_n80903328)
print v(xbgr.mr_n80903440)
print v(xbgr.mr_n80903760)
print v(xbgr.mr_n80903872)
print v(xbgr.mr_n80904192)
print v(xbgr.mr_n80904304)
print v(xbgr.mr_n80904624)
print v(xbgr.mr_n80904736)
print v(xbgr.mr_n80905056)
print v(xbgr.mr_n80905168)
print v(xbgr.mr_n80905488)
print v(xbgr.mr_n80905600)
print v(xbgr.mr_n80905920)
print v(xbgr.mr_n80906032)
print v(xbgr.mr_n80906352)
print v(xbgr.mr_n80906464)
print v(xbgr.mr_n80906784)
print v(xbgr.mr_n80906896)
print v(xbgr.mr_n80907216)
print v(xbgr.mr_n80907328)
print v(xbgr.mr_n80907648)
print v(xbgr.mr_n80907760)
print v(xbgr.mr_n80908080)
print v(xbgr.mr_n80908192)
print v(xbgr.mr_n80908512)
print v(xbgr.mr_n80908624)
print v(xbgr.mr_n80908944)
print v(xbgr.mr_n80909056)
print v(xbgr.mr_n80909376)
print v(xbgr.mr_n80909488)
print v(xbgr.mr_n80909808)
print v(xbgr.mr_n80909920)
print v(xbgr.mr_n80910240)
print v(xbgr.mr_n80910352)
print v(xbgr.mr_n80910672)
print v(xbgr.mr_n80910784)
print v(xbgr.mr_n80911104)
print v(xbgr.mr_n80911216)
print v(xbgr.mr_n80911536)
print v(xbgr.mr_n80911648)
print v(xbgr.mr_n80911968)
print v(xbgr.mr_n80912080)
print v(xbgr.mr_n80912400)
print v(xbgr.mr_n80912512)
print v(xbgr.mr_n80912832)
print v(xbgr.mr_n80912944)
print v(xbgr.mr_n80913264)
print v(xbgr.mr_n80913376)
print v(xbgr.mr_n80913696)
print v(xbgr.mr_n80913808)
print v(xbgr.mr_n80914128)
print v(xbgr.mr_n80914240)
print v(xbgr.mr_n80914560)
print v(xbgr.mr_n80914672)
print v(xbgr.mr_n80914992)
print v(xbgr.mr_n80915104)
print v(xbgr.mr_n80915424)
print v(xbgr.mr_n80915536)
print v(xbgr.mr_n80915856)
print v(xbgr.mr_n80915968)
print v(xbgr.mr_n80916288)
print v(xbgr.mr_n80916400)
print v(xbgr.mr_n80916720)
print v(xbgr.mr_n80916832)
print v(xbgr.mr_n80917152)
print v(xbgr.mr_n80917264)
print v(xbgr.mr_n80917584)
print v(xbgr.mr_n80917696)
print v(xbgr.mr_n80918016)
print v(xbgr.mr_n80918128)
print v(xbgr.mr_n80918448)
print v(xbgr.mr_n80918560)
print v(xbgr.mr_n80918880)
print v(xbgr.mr_n80918992)
print v(xbgr.mr_n80919312)
print v(xbgr.mr_n80919424)
print v(xbgr.mr_n80919744)
print v(xbgr.mr_n80919856)
print v(xbgr.mr_n80920176)
print v(xbgr.mr_n80920288)
print v(xbgr.mr_n80920608)
print v(xbgr.mr_n80920720)
print v(xbgr.mr_n80921040)
print v(xbgr.mr_n80921152)
print v(xbgr.mr_n80921472)
print v(xbgr.mr_n80921584)
print v(xbgr.mr_n80921904)
print v(xbgr.mr_n80922016)
print v(xbgr.mr_n80922336)
print v(xbgr.mr_n80922448)
print v(xbgr.mr_n80922768)
print v(xbgr.mr_n80922880)
print v(xbgr.mr_n80923200)
print v(xbgr.mr_n80923312)
print v(xbgr.mr_n80923632)
print v(xbgr.mr_n80923744)
print v(xbgr.mr_n80924064)
print v(xbgr.mr_n80924176)
print v(xbgr.mr_n80924496)
print v(xbgr.mr_n80924608)
print v(xbgr.mr_n80924928)
print v(xbgr.mr_n80925040)
print v(xbgr.mr_n80925360)
print v(xbgr.mr_n80925472)
print v(xbgr.mr_n80925792)
print v(xbgr.mr_n80925904)
print v(xbgr.mr_n80926224)
print v(xbgr.mr_n80926336)
print v(xbgr.mr_n80926656)
print v(xbgr.mr_n80926768)
print v(xbgr.mr_n80927088)
print v(xbgr.mr_n80927200)
print v(xbgr.mr_n80927520)
print v(xbgr.mr_n80927632)
print v(xbgr.mr_n80927952)
print v(xbgr.mr_n80928064)
print v(xbgr.mr_n80928384)
print v(xbgr.mr_n80928496)
print v(xbgr.mr_n80928816)
print v(xbgr.mr_n80928928)
print v(xbgr.mr_n80929248)
print v(xbgr.mr_n80929360)
print v(xbgr.mr_n80929680)
print v(xbgr.mr_n80929792)
print v(xbgr.mr_n80930112)
print v(xbgr.mr_n80930224)
print v(xbgr.mr_n80930544)
print v(xbgr.mr_n80930656)
print v(xbgr.mr_n80930976)
print v(xbgr.mr_n80931088)
print v(xbgr.mr_n80931408)
print v(xbgr.mr_n80931520)
print v(xbgr.mr_n80931840)
print v(xbgr.mr_n80931952)
print v(xbgr.mr_n80932272)
print v(xbgr.mr_n80932384)
print v(xbgr.mr_n80932704)
print v(xbgr.mr_n80932816)
print v(xbgr.mr_n80933136)
print v(xbgr.mr_n80933248)
print v(xbgr.mr_n80933568)
print v(xbgr.mr_n80933680)
print v(xbgr.mr_n80934000)
print v(xbgr.mr_n80934112)
print v(xbgr.mr_n80934432)
print v(xbgr.mr_n80934544)
print v(xbgr.mr_n80934864)
print v(xbgr.mr_n80934976)
print v(xbgr.mr_n80935296)
print v(xbgr.mr_n80935408)
print v(xbgr.mr_n80935728)
print v(xbgr.mr_n80935840)
print v(xbgr.mr_n80936160)
print v(xbgr.mr_n80936272)
print v(xbgr.mr_n80936592)
print v(xbgr.mr_n80936704)
print v(xbgr.mr_n80937024)
print v(xbgr.mr_n80937136)
print v(xbgr.mr_n80937456)
print v(xbgr.mr_n80937568)
print v(xbgr.mr_n80937888)
print v(xbgr.mr_n80938000)
print v(xbgr.mr_n80938320)
print v(xbgr.mr_n80938432)
print v(xbgr.mr_n80938752)
print v(xbgr.mr_n80938864)
print v(xbgr.mr_n80939184)
print v(xbgr.mr_n80939296)
print v(xbgr.mr_n80939616)
print v(xbgr.mr_n80939728)
print v(xbgr.mr_n80940048)
print v(xbgr.mr_n80940160)
print v(xbgr.mr_n80940480)
print v(xbgr.mr_n80940592)
print v(xbgr.mr_n80940912)
print v(xbgr.mr_n80941024)
print v(xbgr.mr_n80941344)
print v(xbgr.mr_n80941456)
print v(xbgr.mr_n80941776)
print v(xbgr.mr_n80941888)
print v(xbgr.mr_n80942208)
print v(xbgr.mr_n80942320)
print v(xbgr.mr_n80942640)
print v(xbgr.mr_n80942752)
print v(xbgr.mr_n80943072)
print v(xbgr.mr_n80943184)
print v(xbgr.mr_n80943504)
print v(xbgr.mr_n80943616)
print v(xbgr.mr_n80943936)
print v(xbgr.mr_n80944048)
print v(xbgr.mr_n80944368)
print v(xbgr.mr_n80944480)
print v(xbgr.mr_n80944800)
print v(xbgr.mr_n80944912)
print v(xbgr.mr_n80945232)
print v(xbgr.mr_n80945344)
print v(xbgr.mr_n80945664)
print v(xbgr.mr_n80945776)
print v(xbgr.mr_n80946096)
print v(xbgr.mr_n80946208)
print v(xbgr.mr_n80946528)
print v(xbgr.mr_n80946640)
print v(xbgr.mr_n80946960)
print v(xbgr.mr_n80947072)
print v(xbgr.mr_n80947392)
print v(xbgr.mr_n80947504)
print v(xbgr.mr_n80947824)
print v(xbgr.mr_n80947936)
print v(xbgr.mr_n80948256)
print v(xbgr.mr_n80948368)
print v(xbgr.mr_n80948688)
print v(xbgr.mr_n80948800)
print v(xbgr.mr_n80949120)
print v(xbgr.mr_n80949232)
print v(xbgr.mr_n80949552)
print v(xbgr.mr_n80949664)
print v(xbgr.mr_n80949984)
print v(xbgr.mr_n80950096)
print v(xbgr.mr_n80950416)
print v(xbgr.mr_n80950528)
print v(xbgr.mr_n80950848)
print v(xbgr.mr_n80950960)
print v(xbgr.mr_n80951280)
print v(xbgr.mr_n80951392)
print v(xbgr.mr_n80951712)
print v(xbgr.mr_n80951824)
print v(xbgr.mr_n80952144)
print v(xbgr.mr_n80952256)
print v(xbgr.mr_n80952576)
print v(xbgr.mr_n80952688)
print v(xbgr.mr_n80953008)
print v(xbgr.mr_n80953120)
print v(xbgr.mr_n80953440)
print v(xbgr.mr_n80953552)
print v(xbgr.mr_n80953872)
print v(xbgr.mr_n80953984)
print v(xbgr.mr_n80954304)
print v(xbgr.mr_n80954416)
print v(xbgr.mr_n80954736)
print v(xbgr.mr_n80954848)
print v(xbgr.mr_n80955168)
print v(xbgr.mr_n80955280)
print v(xbgr.mr_n80955600)
print v(xbgr.mr_n80955712)
print v(xbgr.mr_n80956032)
print v(xbgr.mr_n80956144)
print v(xbgr.mr_n80956464)
print v(xbgr.mr_n80956576)
print v(xbgr.mr_n80956896)
print v(xbgr.mr_n80957008)
print v(xbgr.mr_n80957328)
print v(xbgr.mr_n80957440)
print v(xbgr.mr_n80957760)
print v(xbgr.mr_n80957872)
print v(xbgr.mr_n80958192)
print v(xbgr.mr_n80958304)
print v(xbgr.mr_n80958624)
print v(xbgr.mr_n80958736)
print v(xbgr.mr_n80959056)
print v(xbgr.mr_n80959168)
print v(xbgr.mr_n80959488)
print v(xbgr.mr_n80959600)
print v(xbgr.mr_n80959920)
print v(xbgr.mr_n80960032)
print v(xbgr.mr_n80960352)
print v(xbgr.mr_n80960464)
print v(xbgr.mr_n80960784)
print v(xbgr.mr_n80960896)
print v(xbgr.mr_n80961216)
print v(xbgr.mr_n80961328)
print v(xbgr.mr_n80961648)
print v(xbgr.mr_n80961760)
print v(xbgr.mr_n80962080)
print v(xbgr.mr_n80962192)
print v(xbgr.mr_n80962512)
print v(xbgr.mr_n80962624)
print v(xbgr.mr_n80962944)
print v(xbgr.mr_n80963056)
print v(xbgr.mr_n80963376)
print v(xbgr.mr_n80963488)
print v(xbgr.mr_n80963808)
print v(xbgr.mr_n80963920)
print v(xbgr.mr_n80964240)
print v(xbgr.mr_n80964352)
print v(xbgr.mr_n80964672)
print v(xbgr.mr_n80964784)
print v(xbgr.mr_n80965104)
print v(xbgr.mr_n80965216)
print v(xbgr.mr_n80965536)
print v(xbgr.mr_n80965648)
print v(xbgr.mr_n80965968)
print v(xbgr.mr_n80966080)
print v(xbgr.mr_n80966400)
print v(xbgr.mr_n80966512)
print v(xbgr.mr_n80966832)
print v(xbgr.mr_n80966944)
print v(xbgr.mr_n80967264)
print v(xbgr.mr_n80967376)
print v(xbgr.mr_n80967696)
print v(xbgr.mr_n80967808)
print v(xbgr.mr_n80968128)
print v(xbgr.mr_n80968240)
print v(xbgr.mr_n80968560)
print v(xbgr.mr_n80968672)
print v(xbgr.mr_n80968992)
print v(xbgr.mr_n80969104)
print v(xbgr.mr_n80969424)
print v(xbgr.mr_n80969536)
print v(xbgr.mr_n80969856)
print v(xbgr.mr_n80969968)
print v(xbgr.mr_n80970288)
print v(xbgr.mr_n80970400)
print v(xbgr.mr_n80970720)
print v(xbgr.mr_n80970832)
print v(xbgr.mr_n80971152)
print v(xbgr.mr_n80971264)
print v(xbgr.mr_n80971584)
print v(xbgr.mr_n80971696)
print v(xbgr.mr_n80972016)
print v(xbgr.mr_n80972128)
print v(xbgr.mr_n80972448)
print v(xbgr.mr_n80972560)
print v(xbgr.mr_n80972880)
print v(xbgr.mr_n80972992)
print v(xbgr.mr_n80973312)
print v(xbgr.mr_n80973424)
print v(xbgr.mr_n80973744)
print v(xbgr.mr_n80973856)
print v(xbgr.mr_n80974176)
print v(xbgr.mr_n80974288)
print v(xbgr.mr_n80974608)
print v(xbgr.mr_n80974720)
print v(xbgr.mr_n80975040)
print v(xbgr.mr_n80975152)
print v(xbgr.mr_n80975472)
print v(xbgr.mr_n80975584)
print v(xbgr.mr_n80975904)
print v(xbgr.mr_n80976016)
print v(xbgr.mr_n80976336)
print v(xbgr.mr_n80976448)
print v(xbgr.mr_n80976768)
print v(xbgr.mr_n80976880)
print v(xbgr.mr_n80977200)
print v(xbgr.mr_n80977312)
print v(xbgr.mr_n80977632)
print v(xbgr.mr_n80977744)
print v(xbgr.mr_n80978064)
print v(xbgr.mr_n80978176)
print v(xbgr.mr_n80978496)
print v(xbgr.mr_n80978608)
print v(xbgr.mr_n80978928)
print v(xbgr.mr_n80979040)
print v(xbgr.mr_n80979360)
print v(xbgr.mr_n80979472)
print v(xbgr.mr_n80979792)
print v(xbgr.mr_n80979904)
print v(xbgr.mr_n80980224)
print v(xbgr.mr_n80980336)
print v(xbgr.mr_n80980656)
print v(xbgr.mr_n80980768)
print v(xbgr.mr_n80981088)
print v(xbgr.mr_n80981200)
print v(xbgr.mr_n80981520)
print v(xbgr.mr_n80981632)
print v(xbgr.mr_n80981952)
print v(xbgr.mr_n80982064)
print v(xbgr.mr_n80982384)
print v(xbgr.mr_n80982496)
print v(xbgr.mr_n80982816)
print v(xbgr.mr_n80982928)
print v(xbgr.mr_n80983248)
print v(xbgr.mr_n80983360)
print v(xbgr.mr_n80983680)
print v(xbgr.mr_n80983792)
print v(xbgr.mr_n80984112)
print v(xbgr.mr_n80984224)
print v(xbgr.mr_n80984544)
print v(xbgr.mr_n80984656)
print v(xbgr.mr_n80984976)
print v(xbgr.mr_n80985088)
print v(xbgr.mr_n80985408)
print v(xbgr.mr_n80985520)
print v(xbgr.mr_n80985840)
print v(xbgr.mr_n80985952)
print v(xbgr.mr_n80986272)
print v(xbgr.mr_n80986384)
print v(xbgr.mr_n80986704)
print v(xbgr.mr_n80986816)
print v(xbgr.mr_n80987136)
print v(xbgr.mr_n80987248)
print v(xbgr.mr_n80987568)
print v(xbgr.mr_n80987680)
print v(xbgr.mr_n80988000)
print v(xbgr.mr_n80988112)
print v(xbgr.mr_n80988432)
print v(xbgr.mr_n80988544)
print v(xbgr.mr_n80988864)
print v(xbgr.mr_n80988976)
print v(xbgr.mr_n80989296)
print v(xbgr.mr_n80989408)
print v(xbgr.mr_n80989728)
print v(xbgr.mr_n80989840)
print v(xbgr.mr_n80990160)
print v(xbgr.mr_n80990272)
print v(xbgr.mr_n80990592)
print v(xbgr.mr_n80990704)
print v(xbgr.mr_n80991024)
print v(xbgr.mr_n80991136)
print v(xbgr.mr_n80991456)
print v(xbgr.mr_n80991568)
print v(xbgr.mr_n80991888)
print v(xbgr.mr_n80992000)
print v(xbgr.mr_n80992320)
print v(xbgr.mr_n80992432)
print v(xbgr.mr_n80992752)
print v(xbgr.mr_n80992864)
print v(xbgr.mr_n80993184)
print v(xbgr.mr_n80993296)
print v(xbgr.mr_n80993616)
print v(xbgr.mr_n80993728)
print v(xbgr.mr_n80994048)
print v(xbgr.mr_n80994160)
print v(xbgr.mr_n80994480)
print v(xbgr.mr_n80994592)
print v(xbgr.mr_n80994912)
print v(xbgr.mr_n80995024)
print v(xbgr.mr_n80995344)
print v(xbgr.mr_n80995456)
print v(xbgr.mr_n80995776)
print v(xbgr.mr_n80995888)
print v(xbgr.mr_n80996320)
print v(xbgr.mr_n80996640)
print v(xbgr.mr_n80996752)
print v(xbgr.mr_n80997184)
print v(xbgr.mr_n80997504)
print v(xbgr.mr_n80997616)
print v(xbgr.mr_n80998048)
print v(xbgr.mr_n80998368)
print v(xbgr.mr_n80999232)
print v(xbgr.mr_n81000096)
print v(xbgr.mr_n81000960)
print v(xbgr.mr_n81001824)
print v(xbgr.mr_n81002688)
print v(xbgr.mr_n81003552)
print v(xbgr.mr_n81003664)
print v(xbgr.mr_n81003984)
print v(xbgr.mr_n81004096)
print v(xbgr.mr_n81004416)
print v(xbgr.mr_n81004528)
print v(xbgr.mr_n81004848)
print v(xbgr.mr_n81004960)
print v(xbgr.mr_n81005280)
print v(xbgr.mr_n81006144)
print v(xbgr.mr_n81007008)
print v(xbgr.mr_n81007872)
print v(xbgr.mr_n81007984)
print v(xbgr.mr_n81008304)
print v(xbgr.mr_n81008416)
print v(xbgr.mr_n81008736)
print v(xbgr.mr_n81008848)
print v(xbgr.mr_n81009280)
print v(xbgr.mr_n81009712)
print v(xbgr.mr_n81010144)
print v(xbgr.mr_n81010464)
print v(xbgr.mr_n81010576)
print v(xbgr.mr_n81010896)
print v(xbgr.mr_n81011008)
print v(xbgr.mr_n81011328)
print v(xbgr.mr_n81011440)
print v(xbgr.mr_n81011760)
print v(xbgr.mr_n81011872)
print v(xbgr.mr_n81012192)
print v(xbgr.mr_n81012304)
print v(xbgr.mr_n81012624)
print v(xbgr.mr_n81012736)
print v(xbgr.mr_n81013056)
print v(xbgr.mr_n81013168)
print v(xbgr.mr_n81013488)
print v(xbgr.mr_n81013600)
print v(xbgr.mr_n81013920)
print v(xbgr.mr_n81014032)
print v(xbgr.mr_n81014352)
print v(xbgr.mr_n81014464)
print v(xbgr.mr_n81014784)
print v(xbgr.mr_n81014896)
print v(xbgr.mr_n81015216)
print v(xbgr.mr_n81015328)
print v(xbgr.mr_n81015648)
print v(xbgr.mr_n81015760)
print v(xbgr.mr_n81016080)
print v(xbgr.mr_n81016192)
print v(xbgr.mr_n81016512)
print v(xbgr.mr_n81016624)
print v(xbgr.mr_n81016944)
print v(xbgr.mr_n81017056)
print v(xbgr.mr_n81017376)
print v(xbgr.mr_n81017488)
print v(xbgr.mr_n81017808)
print v(xbgr.mr_n81017920)
print v(xbgr.mr_n81018240)
print v(xbgr.mr_n81018352)
print v(xbgr.mr_n81018672)
print v(xbgr.mr_n81018784)
print v(xbgr.mr_n81019104)
print v(xbgr.mr_n81019216)
print v(xbgr.mr_n81019536)
print v(xbgr.mr_n81019648)
print v(xbgr.mr_n81019968)
print v(xbgr.mr_n81020080)
print v(xbgr.mr_n81020400)
print v(xbgr.mr_n81020512)
print v(xbgr.mr_n81020832)
print v(xbgr.mr_n81020944)
print v(xbgr.mr_n81021264)
print v(xbgr.mr_n81021376)
print v(xbgr.mr_n81021696)
print v(xbgr.mr_n81021808)
print v(xbgr.mr_n81022128)
print v(xbgr.mr_n81022240)
print v(xbgr.mr_n81022560)
print v(xbgr.mr_n81022672)
print v(xbgr.mr_n81022992)
print v(xbgr.mr_n81023104)
print v(xbgr.mr_n81023424)
print v(xbgr.mr_n81023536)
print v(xbgr.mr_n81023968)
print v(xbgr.mr_n81024288)
print v(xbgr.mr_n81024400)
print v(xbgr.mr_n81024832)
print v(xbgr.mr_n81025152)
print v(xbgr.mr_n81026016)
print v(xbgr.mr_n81026880)
print v(xbgr.mr_n81027744)
print v(xbgr.mr_n81028608)
print v(xbgr.mr_n81028720)
print v(xbgr.mr_n81029040)
print v(xbgr.mr_n81029152)
print v(xbgr.mr_n81029472)
print v(xbgr.mr_n81029584)
print v(xbgr.mr_n81029904)
print v(xbgr.mr_n81030016)
print v(xbgr.mr_n81030336)
print v(xbgr.mr_n81031200)
print v(xbgr.mr_n81032064)
print v(xbgr.mr_n81032176)
print v(xbgr.mr_n81032496)
print v(xbgr.mr_n81032608)
print v(xbgr.mr_n81032928)
print v(xbgr.mr_n81033040)
print v(xbgr.mr_n81033360)
print v(xbgr.mr_n81033472)
print v(xbgr.mr_n81033792)
print v(xbgr.mr_n81033904)
print v(xbgr.mr_n81034336)
print v(xbgr.mr_n81034656)
print v(xbgr.mr_n81034768)
print v(xbgr.mr_n81035200)
print v(xbgr.mr_n81035520)
print v(xbgr.mr_n81036384)
print v(xbgr.mr_n81037248)
print v(xbgr.mr_n81038112)
print v(xbgr.mr_n81038976)
print v(xbgr.mr_n81039088)
print v(xbgr.mr_n81039408)
print v(xbgr.mr_n81039520)
print v(xbgr.mr_n81039840)
print v(xbgr.mr_n81039952)
print v(xbgr.mr_n81040272)
print v(xbgr.mr_n81040384)
print v(xbgr.mr_n81040704)
print v(xbgr.mr_n81041568)
print v(xbgr.mr_n81042432)
print v(xbgr.mr_n81042544)
print v(xbgr.mr_n81042976)
print v(xbgr.mr_n81043296)
print v(xbgr.mr_n81043408)
print v(xbgr.mr_n81043728)
print v(xbgr.mr_n81043840)
print v(xbgr.mr_n81044160)
print v(xbgr.mr_n81044272)
print v(xbgr.mr_n81044592)
print v(xbgr.mr_n81044704)
print v(xbgr.mr_n81045024)
print v(xbgr.mr_n81045136)
print v(xbgr.mr_n81045568)
print v(xbgr.mr_n81045888)
print v(xbgr.mr_n81046752)
print v(xbgr.mr_n81046864)
print v(xbgr.mr_n81047296)
print v(xbgr.mr_n81047616)
print v(xbgr.mr_n81047728)
print v(xbgr.mr_n81048160)
print v(xbgr.mr_n81048480)
print v(xbgr.mr_n81048592)
print v(xbgr.mr_n81048912)
print v(xbgr.mr_n81049024)
print v(xbgr.mr_n81049344)
print v(xbgr.mr_n81049456)
print v(xbgr.mr_n81049776)
print v(xbgr.mr_n81049888)
print v(xbgr.mr_n81050208)
print v(xbgr.mr_n81051072)
print v(xbgr.mr_n81051936)
print v(xbgr.mr_n81052048)
print v(xbgr.mr_n81052368)
print v(xbgr.mr_n81052480)
print v(xbgr.mr_n81052800)
print v(xbgr.mr_n81052912)
print v(xbgr.mr_n81053232)
print v(xbgr.mr_n81053344)
print v(xbgr.mr_n81053664)
print v(xbgr.mr_n81054528)
print v(xbgr.mr_n81055392)
print v(xbgr.mr_n81055504)
print v(xbgr.mr_n81055824)
print v(xbgr.mr_n81055936)
print v(xbgr.mr_n81056256)
print v(xbgr.mr_n81057120)
print v(xbgr.mr_n81057232)
print v(xbgr.mr_n81057552)
print v(xbgr.mr_n81057664)
print v(xbgr.mr_n81057984)
print v(xbgr.mr_n81058096)
print v(xbgr.mr_n81058416)
print v(xbgr.mr_n81058528)
print v(xbgr.mr_n81058848)
print v(xbgr.mr_n81058960)
print v(xbgr.mr_n81059280)
print v(xbgr.mr_n81059392)
print v(xbgr.mr_n81059712)
print v(xbgr.mr_n81060576)
print v(xbgr.mr_n81061376)
print v(xbgr.mr_n81061488)
print v(xbgr.mr_n81061808)
print v(xbgr.mr_n81061920)
print v(xbgr.mr_n81062240)
print v(xbgr.mr_n81062352)
print v(xbgr.mr_n81062672)
print v(xbgr.mr_n81062784)
print v(xbgr.mr_n81063104)
print v(xbgr.mr_n81063216)
print v(xbgr.mr_n81063536)
print v(xbgr.mr_n81063648)
print v(xbgr.mr_n81063968)
print v(xbgr.mr_n81064080)
print v(xbgr.mr_n81064400)
print v(xbgr.mr_n81064512)
print v(xbgr.mr_n81064832)
print v(xbgr.mr_n81064944)
print v(xbgr.mr_n81065264)
print v(xbgr.mr_n81065376)
print v(xbgr.mr_n81065696)
print v(xbgr.mr_n81065808)
print v(xbgr.mr_n81066128)
print v(xbgr.mr_n81066240)
print v(xbgr.mr_n81066560)
print v(xbgr.mr_n81066672)
print v(xbgr.mr_n81066992)
print v(xbgr.mr_n81067104)
print v(xbgr.mr_n81067424)
print v(xbgr.mr_n81067536)
print v(xbgr.mr_n81067856)
print v(xbgr.mr_n81067968)
print v(xbgr.mr_n81068288)
print v(xbgr.mr_n81068400)
print v(xbgr.mr_n81068720)
print v(xbgr.mr_n81068832)
print v(xbgr.mr_n81069152)
print v(xbgr.mr_n81069264)
print v(xbgr.mr_n81069584)
print v(xbgr.mr_n81069696)
print v(xbgr.mr_n81070016)
print v(xbgr.mr_n81070128)
print v(xbgr.mr_n81070448)
print v(xbgr.mr_n81070560)
print v(xbgr.mr_n81070880)
print v(xbgr.mr_n81070992)
print v(xbgr.mr_n81071312)
print v(xbgr.mr_n81071424)
print v(xbgr.mr_n81071744)
print v(xbgr.mr_n81071856)
print v(xbgr.mr_n81072176)
print v(xbgr.mr_n81072288)
print v(xbgr.mr_n81072608)
print v(xbgr.mr_n81072720)
print v(xbgr.mr_n81073040)
print v(xbgr.mr_n81073152)
print v(xbgr.mr_n81073472)
print v(xbgr.mr_n81073584)
print v(xbgr.mr_n81073904)
print v(xbgr.mr_n81074016)
print v(xbgr.mr_n81074336)
print v(xbgr.mr_n81074448)
print v(xbgr.mr_n81074768)
print v(xbgr.mr_n81074880)
print v(xbgr.mr_n81075200)
print v(xbgr.mr_n81075312)
print v(xbgr.mr_n81075632)
print v(xbgr.mr_n81075744)
print v(xbgr.mr_n81076064)
print v(xbgr.mr_n81076176)
print v(xbgr.mr_n81076496)
print v(xbgr.mr_n81076608)
print v(xbgr.mr_n81076928)
print v(xbgr.mr_n81077040)
print v(xbgr.mr_n81077360)
print v(xbgr.mr_n81077472)
print v(xbgr.mr_n81077792)
print v(xbgr.mr_n81077904)
print v(xbgr.mr_n81078224)
print v(xbgr.mr_n81078336)
print v(xbgr.mr_n81078656)
print v(xbgr.mr_n81078768)
print v(xbgr.mr_n81079088)
print v(xbgr.mr_n81079200)
print v(xbgr.mr_n81079520)
print v(xbgr.mr_n81079632)
print v(xbgr.mr_n81079952)
print v(xbgr.mr_n81080064)
print v(xbgr.mr_n81080384)
print v(xbgr.mr_n81080496)
print v(xbgr.mr_n81080816)
print v(xbgr.mr_n81080928)
print v(xbgr.mr_n81081248)
print v(xbgr.mr_n81081360)
print v(xbgr.mr_n81081680)
print v(xbgr.mr_n81081792)
print v(xbgr.mr_n81082112)
print v(xbgr.mr_n81082224)
print v(xbgr.mr_n81082544)
print v(xbgr.mr_n81082656)
print v(xbgr.mr_n81082976)
print v(xbgr.mr_n81083088)
print v(xbgr.mr_n81083408)
print v(xbgr.mr_n81083520)
print v(xbgr.mr_n81083840)
print v(xbgr.mr_n81083952)
print v(xbgr.mr_n81084272)
print v(xbgr.mr_n81084384)
print v(xbgr.mr_n81084704)
print v(xbgr.mr_n81084816)
print v(xbgr.mr_n81085136)
print v(xbgr.mr_n81085248)
print v(xbgr.mr_n81085568)
print v(xbgr.mr_n81085680)
print v(xbgr.mr_n81086000)
print v(xbgr.mr_n81086112)
print v(xbgr.mr_n81086432)
print v(xbgr.mr_n81086544)
print v(xbgr.mr_n81086864)
print v(xbgr.mr_n81086976)
print v(xbgr.mr_n81087296)
print v(xbgr.mr_n81087408)
print v(xbgr.mr_n81087728)
print v(xbgr.mr_n81087840)
print v(xbgr.mr_n81088160)
print v(xbgr.mr_n81088272)
print v(xbgr.mr_n81088592)
print v(xbgr.mr_n81088704)
print v(xbgr.mr_n81089024)
print v(xbgr.mr_n81089136)
print v(xbgr.mr_n81089456)
print v(xbgr.mr_n81089568)
print v(xbgr.mr_n81089888)
print v(xbgr.mr_n81090000)
print v(xbgr.mr_n81090320)
print v(xbgr.mr_n81090432)
print v(xbgr.mr_n81090752)
print v(xbgr.mr_n81090864)
print v(xbgr.mr_n81091184)
print v(xbgr.mr_n81091296)
print v(xbgr.mr_n81091616)
print v(xbgr.mr_n81091728)
print v(xbgr.mr_n81092048)
print v(xbgr.mr_n81092160)
print v(xbgr.mr_n81092480)
print v(xbgr.mr_n81092592)
print v(xbgr.mr_n81092912)
print v(xbgr.mr_n81093024)
print v(xbgr.mr_n81093344)
print v(xbgr.mr_n81093456)
print v(xbgr.mr_n81093776)
print v(xbgr.mr_n81093888)
print v(xbgr.mr_n81094208)
print v(xbgr.mr_n81094320)
print v(xbgr.mr_n81094640)
print v(xbgr.mr_n81094752)
print v(xbgr.mr_n81095072)
print v(xbgr.mr_n81095184)
print v(xbgr.mr_n81095504)
print v(xbgr.mr_n81095616)
print v(xbgr.mr_n81095936)
print v(xbgr.mr_n81096048)
print v(xbgr.mr_n81096368)
print v(xbgr.mr_n81096480)
print v(xbgr.mr_n81096800)
print v(xbgr.mr_n81096912)
print v(xbgr.mr_n81097232)
print v(xbgr.mr_n81097344)
print v(xbgr.mr_n81097664)
print v(xbgr.mr_n81097776)
print v(xbgr.mr_n81098096)
print v(xbgr.mr_n81098208)
print v(xbgr.mr_n81098528)
print v(xbgr.mr_n81098640)
print v(xbgr.mr_n81098960)
print v(xbgr.mr_n81099072)
print v(xbgr.mr_n81099392)
print v(xbgr.mr_n81099504)
print v(xbgr.mr_n81099824)
print v(xbgr.mr_n81099936)
print v(xbgr.mr_n81100256)
print v(xbgr.mr_n81100368)
print v(xbgr.mr_n81100688)
print v(xbgr.mr_n81100800)
print v(xbgr.mr_n81101120)
print v(xbgr.mr_n81101232)
print v(xbgr.mr_n81101552)
print v(xbgr.mr_n81101664)
print v(xbgr.mr_n81101984)
print v(xbgr.mr_n81102096)
print v(xbgr.mr_n81102416)
print v(xbgr.mr_n81102528)
print v(xbgr.mr_n81102848)
print v(xbgr.mr_n81102960)
print v(xbgr.mr_n81103280)
print v(xbgr.mr_n81103392)
print v(xbgr.mr_n81103712)
print v(xbgr.mr_n81103824)
print v(xbgr.mr_n81104144)
print v(xbgr.mr_n81104256)
print v(xbgr.mr_n81104576)
print v(xbgr.mr_n81104688)
print v(xbgr.mr_n81105008)
print v(xbgr.mr_n81105120)
print v(xbgr.mr_n81105440)
print v(xbgr.mr_n81105552)
print v(xbgr.mr_n81105872)
print v(xbgr.mr_n81105984)
print v(xbgr.mr_n81106304)
print v(xbgr.mr_n81106416)
print v(xbgr.mr_n81106736)
print v(xbgr.mr_n81106848)
print v(xbgr.mr_n81107168)
print v(xbgr.mr_n81107280)
print v(xbgr.mr_n81107600)
print v(xbgr.mr_n81107712)
print v(xbgr.mr_n81108032)
print v(xbgr.mr_n81108144)
print v(xbgr.mr_n81108464)
print v(xbgr.mr_n81108576)
print v(xbgr.mr_n81108896)
print v(xbgr.mr_n81109008)
print v(xbgr.mr_n81109328)
print v(xbgr.mr_n81109440)
print v(xbgr.mr_n81109760)
print v(xbgr.mr_n81109872)
print v(xbgr.mr_n81110192)
print v(xbgr.mr_n81110304)
print v(xbgr.mr_n81110624)
print v(xbgr.mr_n81110736)
print v(xbgr.mr_n81111056)
print v(xbgr.mr_n81111168)
print v(xbgr.mr_n81111488)
print v(xbgr.mr_n81111600)
print v(xbgr.mr_n81111920)
print v(xbgr.mr_n81112032)
print v(xbgr.mr_n81112352)
print v(xbgr.mr_n81112464)
print v(xbgr.mr_n81112784)
print v(xbgr.mr_n81112896)
print v(xbgr.mr_n81113216)
print v(xbgr.mr_n81113328)
print v(xbgr.mr_n81113648)
print v(xbgr.mr_n81113760)
print v(xbgr.mr_n81114080)
print v(xbgr.mr_n81114192)
print v(xbgr.mr_n81114512)
print v(xbgr.mr_n81114624)
print v(xbgr.mr_n81114944)
print v(xbgr.mr_n81115056)
print v(xbgr.mr_n81115376)
print v(xbgr.mr_n81115488)
print v(xbgr.mr_n81115808)
print v(xbgr.mr_n81115920)
print v(xbgr.mr_n81116240)
print v(xbgr.mr_n81116352)
print v(xbgr.mr_n81116672)
print v(xbgr.mr_n81116784)
print v(xbgr.mr_n81117104)
print v(xbgr.mr_n81117216)
print v(xbgr.mr_n81117536)
print v(xbgr.mr_n81117648)
print v(xbgr.mr_n81117968)
print v(xbgr.mr_n81118080)
print v(xbgr.mr_n81118400)
print v(xbgr.mr_n81118512)
print v(xbgr.mr_n81118832)
print v(xbgr.mr_n81118944)
print v(xbgr.mr_n81119264)
print v(xbgr.mr_n81119376)
print v(xbgr.mr_n81119696)
print v(xbgr.mr_n81119808)
print v(xbgr.mr_n81120128)
print v(xbgr.mr_n81120240)
print v(xbgr.mr_n81120560)
print v(xbgr.mr_n81120672)
print v(xbgr.mr_n81120992)
print v(xbgr.mr_n81121104)
print v(xbgr.mr_n81121424)
print v(xbgr.mr_n81121536)
print v(xbgr.mr_n81121856)
print v(xbgr.mr_n81121968)
print v(xbgr.mr_n81122288)
print v(xbgr.mr_n81122400)
print v(xbgr.mr_n81122720)
print v(xbgr.mr_n81122832)
print v(xbgr.mr_n81123152)
print v(xbgr.mr_n81123264)
print v(xbgr.mr_n81123584)
print v(xbgr.mr_n81123696)
print v(xbgr.mr_n81124016)
print v(xbgr.mr_n81124128)
print v(xbgr.mr_n81124448)
print v(xbgr.mr_n81124560)
print v(xbgr.mr_n81124880)
print v(xbgr.mr_n81124992)
print v(xbgr.mr_n81125312)
print v(xbgr.mr_n81125424)
print v(xbgr.mr_n81125744)
print v(xbgr.mr_n81125856)
print v(xbgr.mr_n81126176)
print v(xbgr.mr_n81126288)
print v(xbgr.mr_n81126608)
print v(xbgr.mr_n81126720)
print v(xbgr.mr_n81127040)
print v(xbgr.mr_n81127152)
print v(xbgr.mr_n81127472)
print v(xbgr.mr_n81127584)
print v(xbgr.mr_n81127904)
print v(xbgr.mr_n81128016)
print v(xbgr.mr_n81128336)
print v(xbgr.mr_n81128448)
print v(xbgr.mr_n81128768)
print v(xbgr.mr_n81128880)
print v(xbgr.mr_n81129200)
print v(xbgr.mr_n81129312)
print v(xbgr.mr_n81129632)
print v(xbgr.mr_n81129744)
print v(xbgr.mr_n81130064)
print v(xbgr.mr_n81130176)
print v(xbgr.mr_n81130496)
print v(xbgr.mr_n81130608)
print v(xbgr.mr_n81130928)
print v(xbgr.mr_n81131040)
print v(xbgr.mr_n81131360)
print v(xbgr.mr_n81131472)
print v(xbgr.mr_n81131792)
print v(xbgr.mr_n81131904)
print v(xbgr.mr_n81132224)
print v(xbgr.mr_n81132336)
print v(xbgr.mr_n81132656)
print v(xbgr.mr_n81132768)
print v(xbgr.mr_n81133088)
print v(xbgr.mr_n81133200)
print v(xbgr.mr_n81133520)
print v(xbgr.mr_n81133632)
print v(xbgr.mr_n81133952)
print v(xbgr.mr_n81134064)
print v(xbgr.mr_n81134384)
print v(xbgr.mr_n81134496)
print v(xbgr.mr_n81134816)
print v(xbgr.mr_n81134928)
print v(xbgr.mr_n81135248)
print v(xbgr.mr_n81135360)
print v(xbgr.mr_n81135680)
print v(xbgr.mr_n81135792)
print v(xbgr.mr_n81136112)
print v(xbgr.mr_n81136224)
print v(xbgr.mr_n81136544)
print v(xbgr.mr_n81136656)
print v(xbgr.mr_n81136976)
print v(xbgr.mr_n81137088)
print v(xbgr.mr_n81137408)
print v(xbgr.mr_n81137520)
print v(xbgr.mr_n81137840)
print v(xbgr.mr_n81137952)
print v(xbgr.mr_n81138272)
print v(xbgr.mr_n81138384)
print v(xbgr.mr_n81138704)
print v(xbgr.mr_n81138816)
print v(xbgr.mr_n81139136)
print v(xbgr.mr_n81139248)
print v(xbgr.mr_n81139568)
print v(xbgr.mr_n81139680)
print v(xbgr.mr_n81140000)
print v(xbgr.mr_n81140112)
print v(xbgr.mr_n81140432)
print v(xbgr.mr_n81140544)
print v(xbgr.mr_n81140864)
print v(xbgr.mr_n81140976)
print v(xbgr.mr_n81141296)
print v(xbgr.mr_n81141408)
print v(xbgr.mr_n81141728)
print v(xbgr.mr_n81141840)
print v(xbgr.mr_n81142160)
print v(xbgr.mr_n81142272)
print v(xbgr.mr_n81142592)
print v(xbgr.mr_n81142704)
print v(xbgr.mr_n81143024)
print v(xbgr.mr_n81143136)
print v(xbgr.mr_n81143456)
print v(xbgr.mr_n81143568)
print v(xbgr.mr_n81143888)
print v(xbgr.mr_n81144000)
print v(xbgr.mr_n81144320)
print v(xbgr.mr_n81144432)
print v(xbgr.mr_n81144752)
print v(xbgr.mr_n81144864)
print v(xbgr.mr_n81145184)
print v(xbgr.mr_n81145296)
print v(xbgr.mr_n81145616)
print v(xbgr.mr_n81145728)
print v(xbgr.mr_n81146048)
print v(xbgr.mr_n81146160)
print v(xbgr.mr_n81146480)
print v(xbgr.mr_n81146592)
print v(xbgr.mr_n81146912)
print v(xbgr.mr_n81147024)
print v(xbgr.mr_n81147344)
print v(xbgr.mr_n81147456)
print v(xbgr.mr_n81147776)
print v(xbgr.mr_n81147888)
print v(xbgr.mr_n81148208)
print v(xbgr.mr_n81148320)
print v(xbgr.mr_n81148640)
print v(xbgr.mr_n81148752)
print v(xbgr.mr_n81149072)
print v(xbgr.mr_n81149184)
print v(xbgr.mr_n81149504)
print v(xbgr.mr_n81149616)
print v(xbgr.mr_n81149936)
print v(xbgr.mr_n81150048)
print v(xbgr.mr_n81150368)
print v(xbgr.mr_n81150480)
print v(xbgr.mr_n81150800)
print v(xbgr.mr_n81150912)
print v(xbgr.mr_n81151232)
print v(xbgr.mr_n81151344)
print v(xbgr.mr_n81151664)
print v(xbgr.mr_n81151776)
print v(xbgr.mr_n81152096)
print v(xbgr.mr_n81152208)
print v(xbgr.mr_n81152528)
print v(xbgr.mr_n81152640)
print v(xbgr.mr_n81152960)
print v(xbgr.mr_n81153072)
print v(xbgr.mr_n81153392)
print v(xbgr.mr_n81153504)
print v(xbgr.mr_n81153824)
print v(xbgr.mr_n81153936)
print v(xbgr.mr_n81154256)
print v(xbgr.mr_n81154368)
print v(xbgr.mr_n81154688)
print v(xbgr.mr_n81154800)
print v(xbgr.mr_n81155120)
print v(xbgr.mr_n81155232)
print v(xbgr.mr_n81155552)
print v(xbgr.mr_n81155664)
print v(xbgr.mr_n81155984)
print v(xbgr.mr_n81156096)
print v(xbgr.mr_n81156416)
print v(xbgr.mr_n81156528)
print v(xbgr.mr_n81156848)
print v(xbgr.mr_n81156960)
print v(xbgr.mr_n81157280)
print v(xbgr.mr_n81157392)
print v(xbgr.mr_n81157712)
print v(xbgr.mr_n81157824)
print v(xbgr.mr_n81158144)
print v(xbgr.mr_n81158256)
print v(xbgr.mr_n81158576)
print v(xbgr.mr_n81158688)
print v(xbgr.mr_n81159008)
print v(xbgr.mr_n81159120)
print v(xbgr.mr_n81159440)
print v(xbgr.mr_n81159552)
print v(xbgr.mr_n81159872)
print v(xbgr.mr_n81159984)
print v(xbgr.mr_n81160304)
print v(xbgr.mr_n81160416)
print v(xbgr.mr_n81160736)
print v(xbgr.mr_n81160848)
print v(xbgr.mr_n81161168)
print v(xbgr.mr_n81161280)
print v(xbgr.mr_n81161600)
print v(xbgr.mr_n81161712)
print v(xbgr.mr_n81162032)
print v(xbgr.mr_n81162144)
print v(xbgr.mr_n81162464)
print v(xbgr.mr_n81162576)
print v(xbgr.mr_n81162896)
print v(xbgr.mr_n81163008)
print v(xbgr.mr_n81163328)
print v(xbgr.mr_n81163440)
print v(xbgr.mr_n81163760)
print v(xbgr.mr_n81163872)
print v(xbgr.mr_n81164192)
print v(xbgr.mr_n81164304)
print v(xbgr.mr_n81164624)
print v(xbgr.mr_n81164736)
print v(xbgr.mr_n81165056)
print v(xbgr.mr_n81165168)
print v(xbgr.mr_n81165488)
print v(xbgr.mr_n81165600)
print v(xbgr.mr_n81165920)
print v(xbgr.mr_n81166032)
print v(xbgr.mr_n81166352)
print v(xbgr.mr_n81166464)
print v(xbgr.mr_n81166784)
print v(xbgr.mr_n81166896)
print v(xbgr.mr_n81167216)
print v(xbgr.mr_n81167328)
print v(xbgr.mr_n81167648)
print v(xbgr.mr_n81167760)
print v(xbgr.mr_n81168080)
print v(xbgr.mr_n81168192)
print v(xbgr.mr_n81168512)
print v(xbgr.mr_n81168624)
print v(xbgr.mr_n81168944)
print v(xbgr.mr_n81169056)
print v(xbgr.mr_n81169376)
print v(xbgr.mr_n81169488)
print v(xbgr.mr_n81169808)
print v(xbgr.mr_n81169920)
print v(xbgr.mr_n81170240)
print v(xbgr.mr_n81170352)
print v(xbgr.mr_n81170672)
print v(xbgr.mr_n81170784)
print v(xbgr.mr_n81171104)
print v(xbgr.mr_n81171216)
print v(xbgr.mr_n81171536)
print v(xbgr.mr_n81171648)
print v(xbgr.mr_n81171968)
print v(xbgr.mr_n81172080)
print v(xbgr.mr_n81172400)
print v(xbgr.mr_n81172512)
print v(xbgr.mr_n81172832)
print v(xbgr.mr_n81172944)
print v(xbgr.mr_n81173264)
print v(xbgr.mr_n81173376)
print v(xbgr.mr_n81173696)
print v(xbgr.mr_n81173808)
print v(xbgr.mr_n81174128)
print v(xbgr.mr_n81174240)
print v(xbgr.mr_n81174560)
print v(xbgr.mr_n81174672)
print v(xbgr.mr_n81174992)
print v(xbgr.mr_n81175104)
print v(xbgr.mr_n81175424)
print v(xbgr.mr_n81175536)
print v(xbgr.mr_n81175856)
print v(xbgr.mr_n81175968)
print v(xbgr.mr_n81176288)
print v(xbgr.mr_n81176400)
print v(xbgr.mr_n81176720)
print v(xbgr.mr_n81176832)
print v(xbgr.mr_n81177152)
print v(xbgr.mr_n81177264)
print v(xbgr.mr_n81177584)
print v(xbgr.mr_n81177696)
print v(xbgr.mr_n81178016)
print v(xbgr.mr_n81178128)
print v(xbgr.mr_n81178448)
print v(xbgr.mr_n81178560)
print v(xbgr.mr_n81178880)
print v(xbgr.mr_n81178992)
print v(xbgr.mr_n81179312)
print v(xbgr.mr_n81179424)
print v(xbgr.mr_n81179744)
print v(xbgr.mr_n81179856)
print v(xbgr.mr_n81180176)
print v(xbgr.mr_n81180288)
print v(xbgr.mr_n81180608)
print v(xbgr.mr_n81180720)
print v(xbgr.mr_n81181040)
print v(xbgr.mr_n81181152)
print v(xbgr.mr_n81181472)
print v(xbgr.mr_n81181584)
print v(xbgr.mr_n81181904)
print v(xbgr.mr_n81182016)
print v(xbgr.mr_n81182336)
print v(xbgr.mr_n81182448)
print v(xbgr.mr_n81182768)
print v(xbgr.mr_n81182880)
print v(xbgr.mr_n81183200)
print v(xbgr.mr_n81183312)
print v(xbgr.mr_n81183632)
print v(xbgr.mr_n81183744)
print v(xbgr.mr_n81184064)
print v(xbgr.mr_n81184176)
print v(xbgr.mr_n81184496)
print v(xbgr.mr_n81184608)
print v(xbgr.mr_n81184928)
print v(xbgr.mr_n81185040)
print v(xbgr.mr_n81185360)
print v(xbgr.mr_n81185472)
print v(xbgr.mr_n81185792)
print v(xbgr.mr_n81185904)
print v(xbgr.mr_n81186224)
print v(xbgr.mr_n81186336)
print v(xbgr.mr_n81186656)
print v(xbgr.mr_n81186768)
print v(xbgr.mr_n81187088)
print v(xbgr.mr_n81187200)
print v(xbgr.mr_n81187520)
print v(xbgr.mr_n81187632)
print v(xbgr.mr_n81187952)
print v(xbgr.mr_n81188064)
print v(xbgr.mr_n81188384)
print v(xbgr.mr_n81188496)
print v(xbgr.mr_n81188816)
print v(xbgr.mr_n81188928)
print v(xbgr.mr_n81189248)
print v(xbgr.mr_n81189360)
print v(xbgr.mr_n81189680)
print v(xbgr.mr_n81189792)
print v(xbgr.mr_n81190112)
print v(xbgr.mr_n81190224)
print v(xbgr.mr_n81190544)
print v(xbgr.mr_n81190656)
print v(xbgr.mr_n81190976)
print v(xbgr.mr_n81191088)
print v(xbgr.mr_n81191408)
print v(xbgr.mr_n81191520)
print v(xbgr.mr_n81191840)
print v(xbgr.mr_n81191952)
print v(xbgr.mr_n81192272)
print v(xbgr.mr_n81192384)
print v(xbgr.mr_n81192704)
print v(xbgr.mr_n81192816)
print v(xbgr.mr_n81193136)
print v(xbgr.mr_n81193248)
print v(xbgr.mr_n81193568)
print v(xbgr.mr_n81193680)
print v(xbgr.mr_n81194000)
print v(xbgr.mr_n81194112)
print v(xbgr.mr_n81194432)
print v(xbgr.mr_n81194544)
print v(xbgr.mr_n81194864)
print v(xbgr.mr_n81194976)
print v(xbgr.mr_n81195296)
print v(xbgr.mr_n81195408)
print v(xbgr.mr_n81195728)
print v(xbgr.mr_n81195840)
print v(xbgr.mr_n81196160)
print v(xbgr.mr_n81196272)
print v(xbgr.mr_n81196592)
print v(xbgr.mr_n81196704)
print v(xbgr.mr_n81197024)
print v(xbgr.mr_n81197136)
print v(xbgr.mr_n81197456)
print v(xbgr.mr_n81197568)
print v(xbgr.mr_n81197888)
print v(xbgr.mr_n81198000)
print v(xbgr.mr_n81198320)
print v(xbgr.mr_n81198432)
print v(xbgr.mr_n81198752)
print v(xbgr.mr_n81198864)
print v(xbgr.mr_n81199184)
print v(xbgr.mr_n81199296)
print v(xbgr.mr_n81199616)
print v(xbgr.mr_n81199728)
print v(xbgr.mr_n81200048)
print v(xbgr.mr_n81200160)
print v(xbgr.mr_n81200480)
print v(xbgr.mr_n81200592)
print v(xbgr.mr_n81200912)
print v(xbgr.mr_n81201024)
print v(xbgr.mr_n81201344)
print v(xbgr.mr_n81201456)
print v(xbgr.mr_n81201776)
print v(xbgr.mr_n81201888)
print v(xbgr.mr_n81202208)
print v(xbgr.mr_n81202320)
print v(xbgr.mr_n81202640)
print v(xbgr.mr_n81202752)
print v(xbgr.mr_n81203072)
print v(xbgr.mr_n81203184)
print v(xbgr.mr_n81203504)
print v(xbgr.mr_n81203616)
print v(xbgr.mr_n81203936)
print v(xbgr.mr_n81204048)
print v(xbgr.mr_n81204368)
print v(xbgr.mr_n81204480)
print v(xbgr.mr_n81204800)
print v(xbgr.mr_n81204912)
print v(xbgr.mr_n81205232)
print v(xbgr.mr_n81205344)
print v(xbgr.mr_n81205664)
print v(xbgr.mr_n81205776)
print v(xbgr.mr_n81206096)
print v(xbgr.mr_n81206208)
print v(xbgr.mr_n81206528)
print v(xbgr.mr_n81206640)
print v(xbgr.mr_n81206960)
print v(xbgr.mr_n81207072)
print v(xbgr.mr_n81207392)
print v(xbgr.mr_n81207504)
print v(xbgr.mr_n81207824)
print v(xbgr.mr_n81207936)
print v(xbgr.mr_n81208256)
print v(xbgr.mr_n81208368)
print v(xbgr.mr_n81208688)
print v(xbgr.mr_n81208800)
print v(xbgr.mr_n81209120)
print v(xbgr.mr_n81209232)
print v(xbgr.mr_n81209552)
print v(xbgr.mr_n81209664)
print v(xbgr.mr_n81209984)
print v(xbgr.mr_n81210096)
print v(xbgr.mr_n81210416)
print v(xbgr.mr_n81210528)
print v(xbgr.mr_n81210848)
print v(xbgr.mr_n81210960)
print v(xbgr.mr_n81211280)
print v(xbgr.mr_n81211392)
print v(xbgr.mr_n81211712)
print v(xbgr.mr_n81211824)
print v(xbgr.mr_n81212144)
print v(xbgr.mr_n81212256)
print v(xbgr.mr_n81212576)
print v(xbgr.mr_n81212688)
print v(xbgr.mr_n81213008)
print v(xbgr.mr_n81213120)
print v(xbgr.mr_n81213440)
print v(xbgr.mr_n81213552)
print v(xbgr.mr_n81213872)
print v(xbgr.mr_n81213984)
print v(xbgr.mr_n81214304)
print v(xbgr.mr_n81214416)
print v(xbgr.mr_n81214736)
print v(xbgr.mr_n81214848)
print v(xbgr.mr_n81215168)
print v(xbgr.mr_n81215280)
print v(xbgr.mr_n81215600)
print v(xbgr.mr_n81215712)
print v(xbgr.mr_n81216032)
print v(xbgr.mr_n81216144)
print v(xbgr.mr_n81216464)
print v(xbgr.mr_n81216576)
print v(xbgr.mr_n81216896)
print v(xbgr.mr_n81217008)
print v(xbgr.mr_n81217328)
print v(xbgr.mr_n81217440)
print v(xbgr.mr_n81217760)
print v(xbgr.mr_n81217872)
print v(xbgr.mr_n81218192)
print v(xbgr.mr_n81218304)
print v(xbgr.mr_n81218624)
print v(xbgr.mr_n81218736)
print v(xbgr.mr_n81219056)
print v(xbgr.mr_n81219168)
print v(xbgr.mr_n81219488)
print v(xbgr.mr_n81219600)
print v(xbgr.mr_n81219920)
print v(xbgr.mr_n81220032)
print v(xbgr.mr_n81220352)
print v(xbgr.mr_n81220464)
print v(xbgr.mr_n81220784)
print v(xbgr.mr_n81220896)
print v(xbgr.mr_n81221216)
print v(xbgr.mr_n81221328)
print v(xbgr.mr_n81221648)
print v(xbgr.mr_n81221760)
print v(xbgr.mr_n81222080)
print v(xbgr.mr_n81222192)
print v(xbgr.mr_n81222512)
print v(xbgr.mr_n81222944)
print v(xbgr.mr_n81223056)
print v(xbgr.mr_n81223376)
print v(xbgr.mr_n81223808)
print v(xbgr.mr_n81223920)
print v(xbgr.mr_n81224240)
print v(xbgr.mr_n81224352)
print v(xbgr.mr_n81224672)
print v(xbgr.mr_n81224784)
print v(xbgr.mr_n81225104)
print v(xbgr.mr_n81225216)
print v(xbgr.mr_n81225536)
print v(xbgr.mr_n81225648)
print v(xbgr.mr_n81225968)
print v(xbgr.mr_n81226080)
print v(xbgr.mr_n81226400)
print v(xbgr.mr_n81226512)
print v(xbgr.mr_n81226832)
print v(xbgr.mr_n81226944)
print v(xbgr.mr_n81227264)
print v(xbgr.mr_n81227376)
print v(xbgr.mr_n81227696)
print v(xbgr.mr_n81227808)
print v(xbgr.mr_n81228128)
print v(xbgr.mr_n81228240)
print v(xbgr.mr_n81228560)
print v(xbgr.mr_n81228672)
print v(xbgr.mr_n81228992)
print v(xbgr.mr_n81229104)
print v(xbgr.mr_n81229424)
print v(xbgr.mr_n81229536)
print v(xbgr.mr_n81229856)
print v(xbgr.mr_n81229968)
print v(xbgr.mr_n81230288)
print v(xbgr.mr_n81230400)
print v(xbgr.mr_n81230720)
print v(xbgr.mr_n81230832)
print v(xbgr.mr_n81231152)
print v(xbgr.mr_n81231264)
print v(xbgr.mr_n81231584)
print v(xbgr.mr_n81231696)
print v(xbgr.mr_n81232016)
print v(xbgr.mr_n81232128)
print v(xbgr.mr_n81232448)
print v(xbgr.mr_n81232560)
print v(xbgr.mr_n81232880)
print v(xbgr.mr_n81232992)
print v(xbgr.mr_n81233312)
print v(xbgr.mr_n81233744)
print v(xbgr.mr_n81233856)
print v(xbgr.mr_n81234176)
print v(xbgr.mr_n81234608)
print v(xbgr.mr_n81234720)
print v(xbgr.mr_n81235040)
print v(xbgr.mr_n81235472)
print v(xbgr.mr_n81235584)
print v(xbgr.mr_n81235904)
print v(xbgr.mr_n81236336)
print v(xbgr.mr_n81236448)
print v(xbgr.mr_n81236768)
print v(xbgr.mr_n81237200)
print v(xbgr.mr_n81237312)
print v(xbgr.mr_n81237632)
print v(xbgr.mr_n81237744)
print v(xbgr.mr_n81238064)
print v(xbgr.mr_n81238176)
print v(xbgr.mr_n81238496)
print v(xbgr.mr_n81238608)
print v(xbgr.mr_n81238928)
print v(xbgr.mr_n81239040)
print v(xbgr.mr_n81239360)
print v(xbgr.mr_n81239472)
print v(xbgr.mr_n81239792)
print v(xbgr.mr_n81239904)
print v(xbgr.mr_n81240224)
print v(xbgr.mr_n81240336)
print v(xbgr.mr_n81240656)
print v(xbgr.mr_n81240768)
print v(xbgr.mr_n81241088)
print v(xbgr.mr_n81241200)
print v(xbgr.mr_n81241520)
print v(xbgr.mr_n81241632)
print v(xbgr.mr_n81241952)
print v(xbgr.mr_n81242064)
print v(xbgr.mr_n81242384)
print v(xbgr.mr_n81242496)
print v(xbgr.mr_n81242816)
print v(xbgr.mr_n81242928)
print v(xbgr.mr_n81243248)
print v(xbgr.mr_n81243360)
print v(xbgr.mr_n81243680)
print v(xbgr.mr_n81243792)
print v(xbgr.mr_n81244112)
print v(xbgr.mr_n81244224)
print v(xbgr.mr_n81244544)
print v(xbgr.mr_n81244656)
print v(xbgr.mr_n81244976)
print v(xbgr.mr_n81245088)
print v(xbgr.mr_n81245408)
print v(xbgr.mr_n81245520)
print v(xbgr.mr_n81245840)
print v(xbgr.mr_n81245952)
print v(xbgr.mr_n81246272)
print v(xbgr.mr_n81246384)
print v(xbgr.mr_n81246704)
print v(xbgr.mr_n81246816)
print v(xbgr.mr_n81247136)
print v(xbgr.mr_n81247248)
print v(xbgr.mr_n81247568)
print v(xbgr.mr_n81247680)
print v(xbgr.mr_n81248000)
print v(xbgr.mr_n81248112)
print v(xbgr.mr_n81248432)
print v(xbgr.mr_n81248544)
print v(xbgr.mr_n81248864)
print v(xbgr.mr_n81248976)
print v(xbgr.mr_n81249296)
print v(xbgr.mr_n81249408)
print v(xbgr.mr_n81249728)
print v(xbgr.mr_n81249840)
print v(xbgr.mr_n81250160)
print v(xbgr.mr_n81250272)
print v(xbgr.mr_n81250592)
print v(xbgr.mr_n81250704)
print v(xbgr.mr_n81251024)
print v(xbgr.mr_n81251136)
print v(xbgr.mr_n81251456)
print v(xbgr.mr_n81251568)
print v(xbgr.mr_n81251888)
print v(xbgr.mr_n81252000)
print v(xbgr.mr_n81252320)
print v(xbgr.mr_n81252432)
print v(xbgr.mr_n81252752)
print v(xbgr.mr_n81252864)
print v(xbgr.mr_n81253184)
print v(xbgr.mr_n81253296)
print v(xbgr.mr_n81253616)
print v(xbgr.mr_n81253728)
print v(xbgr.mr_n81254048)
print v(xbgr.mr_n81254160)
print v(xbgr.mr_n81254480)
print v(xbgr.mr_n81254592)
print v(xbgr.mr_n81254912)
print v(xbgr.mr_n81255024)
print v(xbgr.mr_n81255344)
print v(xbgr.mr_n81255456)
print v(xbgr.mr_n81255776)
print v(xbgr.mr_n81255888)
print v(xbgr.mr_n81256208)
print v(xbgr.mr_n81256320)
print v(xbgr.mr_n81256640)
print v(xbgr.mr_n81256752)
print v(xbgr.mr_n81257072)
print v(xbgr.mr_n81257504)
print v(xbgr.mr_n81257616)
print v(xbgr.mr_n81257936)
print v(xbgr.mr_n81258368)
print v(xbgr.mr_n81258480)
print v(xbgr.mr_n81258800)
print v(xbgr.mr_n81259232)
print v(xbgr.mr_n81259344)
print v(xbgr.mr_n81259664)
print v(xbgr.mr_n81259776)
print v(xbgr.mr_n81260096)
print v(xbgr.mr_n81260208)
print v(xbgr.mr_n81260528)
print v(xbgr.mr_n81260640)
print v(xbgr.mr_n81260960)
print v(xbgr.mr_n81261072)
print v(xbgr.mr_n81261392)
print v(xbgr.mr_n81261504)
print v(xbgr.mr_n81261824)
print v(xbgr.mr_n81261936)
print v(xbgr.mr_n81262256)
print v(xbgr.mr_n81262368)
print v(xbgr.mr_n81262688)
print v(xbgr.mr_n81262800)
print v(xbgr.mr_n81263120)
print v(xbgr.mr_n81263232)
print v(xbgr.mr_n81263552)
print v(xbgr.mr_n81263664)
print v(xbgr.mr_n81263984)
print v(xbgr.mr_n81264096)
print v(xbgr.mr_n81264416)
print v(xbgr.mr_n81264528)
print v(xbgr.mr_n81264848)
print v(xbgr.mr_n81264960)
print v(xbgr.mr_n81265280)
print v(xbgr.mr_n81265392)
print v(xbgr.mr_n81265712)
print v(xbgr.mr_n81265824)
print v(xbgr.mr_n81266144)
print v(xbgr.mr_n81266256)
print v(xbgr.mr_n81266576)
print v(xbgr.mr_n81266688)
print v(xbgr.mr_n81267008)
print v(xbgr.mr_n81267120)
print v(xbgr.mr_n81267440)
print v(xbgr.mr_n81267552)
print v(xbgr.mr_n81267872)
print v(xbgr.mr_n81267984)
print v(xbgr.mr_n81268304)
print v(xbgr.mr_n81268416)
print v(xbgr.mr_n81268736)
print v(xbgr.mr_n81268848)
print v(xbgr.mr_n81269168)
print v(xbgr.mr_n81269280)
print v(xbgr.mr_n81269600)
print v(xbgr.mr_n81269712)
print v(xbgr.mr_n81270032)
print v(xbgr.mr_n81270144)
print v(xbgr.mr_n81270464)
print v(xbgr.mr_n81270576)
print v(xbgr.mr_n81270896)
print v(xbgr.mr_n81271008)
print v(xbgr.mr_n81271328)
print v(xbgr.mr_n81271440)
print v(xbgr.mr_n81271760)
print v(xbgr.mr_n81271872)
print v(xbgr.mr_n81272192)
print v(xbgr.mr_n81272304)
print v(xbgr.mr_n81272624)
print v(xbgr.mr_n81272736)
print v(xbgr.mr_n81273056)
print v(xbgr.mr_n81273168)
print v(xbgr.mr_n81273488)
print v(xbgr.mr_n81273600)
print v(xbgr.mr_n81273920)
print v(xbgr.mr_n81274032)
print v(xbgr.mr_n81274352)
print v(xbgr.mr_n81274464)
print v(xbgr.mr_n81274784)
print v(xbgr.mr_n81274896)
print v(xbgr.mr_n81275216)
print v(xbgr.mr_n81275328)
print v(xbgr.mr_n81275648)
print v(xbgr.mr_n81275760)
print v(xbgr.mr_n81276080)
print v(xbgr.mr_n81276192)
print v(xbgr.mr_n81276512)
print v(xbgr.mr_n81276624)
print v(xbgr.mr_n81276944)
print v(xbgr.mr_n81277056)
print v(xbgr.mr_n81277376)
print v(xbgr.mr_n81277488)
print v(xbgr.mr_n81277808)
print v(xbgr.mr_n81277920)
print v(xbgr.mr_n81278240)
print v(xbgr.mr_n81278352)
print v(xbgr.mr_n81278672)
print v(xbgr.mr_n81278784)
print v(xbgr.mr_n81279104)
print v(xbgr.mr_n81279216)
print v(xbgr.mr_n81279536)
print v(xbgr.mr_n81279648)
print v(xbgr.mr_n81279968)
print v(xbgr.mr_n81280080)
print v(xbgr.mr_n81280400)
print v(xbgr.mr_n81280512)
print v(xbgr.mr_n81280832)
print v(xbgr.mr_n81280944)
print v(xbgr.mr_n81281264)
print v(xbgr.mr_n81281376)
print v(xbgr.mr_n81281696)
print v(xbgr.mr_n81281808)
print v(xbgr.mr_n81282128)
print v(xbgr.mr_n81282240)
print v(xbgr.mr_n81282560)
print v(xbgr.mr_n81282672)
print v(xbgr.mr_n81282992)
print v(xbgr.mr_n81283104)
print v(xbgr.mr_n81283424)
print v(xbgr.mr_n81283536)
print v(xbgr.mr_n81283856)
print v(xbgr.mr_n81283968)
print v(xbgr.mr_n81284288)
print v(xbgr.mr_n81284400)
print v(xbgr.mr_n81284720)
print v(xbgr.mr_n81284832)
print v(xbgr.mr_n81285152)
print v(xbgr.mr_n81285264)
print v(xbgr.mr_n81285584)
print v(xbgr.mr_n81285696)
print v(xbgr.mr_n81286016)
print v(xbgr.mr_n81286128)
print v(xbgr.mr_n81286448)
print v(xbgr.mr_n81286560)
print v(xbgr.mr_n81286880)
print v(xbgr.mr_n81286992)
print v(xbgr.mr_n81287312)
print v(xbgr.mr_n81287424)
print v(xbgr.mr_n81287744)
print v(xbgr.mr_n81287856)
print v(xbgr.mr_n81288176)
print v(xbgr.mr_n81288288)
print v(xbgr.mr_n81288608)
print v(xbgr.mr_n81288720)
print v(xbgr.mr_n81289040)
print v(xbgr.mr_n81289152)
print v(xbgr.mr_n81289472)
print v(xbgr.mr_n81289584)
print v(xbgr.mr_n81289904)
print v(xbgr.mr_n81290016)
print v(xbgr.mr_n81290336)
print v(xbgr.mr_n81290448)
print v(xbgr.mr_n81290768)
print v(xbgr.mr_n81290880)
print v(xbgr.mr_n81291200)
print v(xbgr.mr_n81291312)
print v(xbgr.mr_n81291632)
print v(xbgr.mr_n81291744)
print v(xbgr.mr_n81292064)
print v(xbgr.mr_n81292176)
print v(xbgr.mr_n81292496)
print v(xbgr.mr_n81292608)
print v(xbgr.mr_n81292928)
print v(xbgr.mr_n81293040)
print v(xbgr.mr_n81293360)
print v(xbgr.mr_n81293472)
print v(xbgr.mr_n81293792)
print v(xbgr.mr_n81293904)
print v(xbgr.mr_n81294224)
print v(xbgr.mr_n81294336)
print v(xbgr.mr_n81294656)
print v(xbgr.mr_n81294768)
print v(xbgr.mr_n81295088)
print v(xbgr.mr_n81295200)
print v(xbgr.mr_n81295520)
print v(xbgr.mr_n81295632)
print v(xbgr.mr_n81295952)
print v(xbgr.mr_n81296064)
print v(xbgr.mr_n81296384)
print v(xbgr.mr_n81296496)
print v(xbgr.mr_n81296816)
print v(xbgr.mr_n81296928)
print v(xbgr.mr_n81297248)
print v(xbgr.mr_n81297360)
print v(xbgr.mr_n81297680)
print v(xbgr.mr_n81297792)
print v(xbgr.mr_n81298112)
print v(xbgr.mr_n81298224)
print v(xbgr.mr_n81298544)
print v(xbgr.mr_n81298656)
print v(xbgr.mr_n81298976)
print v(xbgr.mr_n81299088)
print v(xbgr.mr_n81299408)
print v(xbgr.mr_n81299520)
print v(xbgr.mr_n81299840)
print v(xbgr.mr_n81299952)
print v(xbgr.mr_n81300272)
print v(xbgr.mr_n81300384)
print v(xbgr.mr_n81300704)
print v(xbgr.mr_n81300816)
print v(xbgr.mr_n81301136)
print v(xbgr.mr_n81301248)
print v(xbgr.mr_n81301568)
print v(xbgr.mr_n81301680)
print v(xbgr.mr_n81302000)
print v(xbgr.mr_n81302112)
print v(xbgr.mr_n81302432)
print v(xbgr.mr_n81302544)
print v(xbgr.mr_n81302864)
print v(xbgr.mr_n81302976)
print v(xbgr.mr_n81303296)
print v(xbgr.mr_n81303408)
print v(xbgr.mr_n81303728)
print v(xbgr.mr_n81303840)
print v(xbgr.mr_n81304160)
print v(xbgr.mr_n81304272)
print v(xbgr.mr_n81304592)
print v(xbgr.mr_n81304704)
print v(xbgr.mr_n81305024)
print v(xbgr.mr_n81305136)
print v(xbgr.mr_n81305456)
print v(xbgr.mr_n81305568)
print v(xbgr.mr_n81305888)
print v(xbgr.mr_n81306000)
print v(xbgr.mr_n81306320)
print v(xbgr.mr_n81306432)
print v(xbgr.mr_n81306752)
print v(xbgr.mr_n81306864)
print v(xbgr.mr_n81307184)
print v(xbgr.mr_n81307296)
print v(xbgr.mr_n81307616)
print v(xbgr.mr_n81307728)
print v(xbgr.mr_n81308048)
print v(xbgr.mr_n81308160)
print v(xbgr.mr_n81308480)
print v(xbgr.mr_n81308592)
print v(xbgr.mr_n81308912)
print v(xbgr.mr_n81309024)
print v(xbgr.mr_n81309344)
print v(xbgr.mr_n81309456)
print v(xbgr.mr_n81309776)
print v(xbgr.mr_n81309888)
print v(xbgr.mr_n81310208)
print v(xbgr.mr_n81310320)
print v(xbgr.mr_n81310640)
print v(xbgr.mr_n81310752)
print v(xbgr.mr_n81311072)
print v(xbgr.mr_n81311184)
print v(xbgr.mr_n81311504)
print v(xbgr.mr_n81311616)
print v(xbgr.mr_n81311936)
print v(xbgr.mr_n81312048)
print v(xbgr.mr_n81312368)
print v(xbgr.mr_n81312480)
print v(xbgr.mr_n81312800)
print v(xbgr.mr_n81312912)
print v(xbgr.mr_n81313232)
print v(xbgr.mr_n81313344)
print v(xbgr.mr_n81313664)
print v(xbgr.mr_n81313776)
print v(xbgr.mr_n81314096)
print v(xbgr.mr_n81314208)
print v(xbgr.mr_n81314528)
print v(xbgr.mr_n81314640)
print v(xbgr.mr_n81314960)
print v(xbgr.mr_n81315072)
print v(xbgr.mr_n81315392)
print v(xbgr.mr_n81315504)
print v(xbgr.mr_n81315824)
print v(xbgr.mr_n81315936)
print v(xbgr.mr_n81316256)
print v(xbgr.mr_n81316368)
print v(xbgr.mr_n81316688)
print v(xbgr.mr_n81316800)
print v(xbgr.mr_n81317120)
print v(xbgr.mr_n81317232)
print v(xbgr.mr_n81317552)
print v(xbgr.mr_n81317664)
print v(xbgr.mr_n81317984)
print v(xbgr.mr_n81318096)
print v(xbgr.mr_n81318416)
print v(xbgr.mr_n81318528)
print v(xbgr.mr_n81318848)
print v(xbgr.mr_n81318960)
print v(xbgr.mr_n81319280)
print v(xbgr.mr_n81319392)
print v(xbgr.mr_n81319712)
print v(xbgr.mr_n81319824)
print v(xbgr.mr_n81320144)
print v(xbgr.mr_n81320256)
print v(xbgr.mr_n81320576)
print v(xbgr.mr_n81320688)
print v(xbgr.mr_n81321008)
print v(xbgr.mr_n81321120)
print v(xbgr.mr_n81321440)
print v(xbgr.mr_n81321552)
print v(xbgr.mr_n81321872)
print v(xbgr.mr_n81321984)
print v(xbgr.mr_n81322304)
print v(xbgr.mr_n81322416)
print v(xbgr.mr_n81322736)
print v(xbgr.mr_n81322848)
print v(xbgr.mr_n81323168)
print v(xbgr.mr_n81323280)
print v(xbgr.mr_n81323600)
print v(xbgr.mr_n81323712)
print v(xbgr.mr_n81324032)
print v(xbgr.mr_n81324144)
print v(xbgr.mr_n81324464)
print v(xbgr.mr_n81324576)
print v(xbgr.mr_n81324896)
print v(xbgr.mr_n81325008)
print v(xbgr.mr_n81325328)
print v(xbgr.mr_n81325440)
print v(xbgr.mr_n81325760)
print v(xbgr.mr_n81325872)
print v(xbgr.mr_n81326192)
print v(xbgr.mr_n81326304)
print v(xbgr.mr_n81326624)
print v(xbgr.mr_n81326736)
print v(xbgr.mr_n81327056)
print v(xbgr.mr_n81327168)
print v(xbgr.mr_n81327488)
print v(xbgr.mr_n81327600)
print v(xbgr.mr_n81327920)
print v(xbgr.mr_n81328032)
print v(xbgr.mr_n81328352)
print v(xbgr.mr_n81328464)
print v(xbgr.mr_n81328784)
print v(xbgr.mr_n81328896)
print v(xbgr.mr_n81329216)
print v(xbgr.mr_n81329328)
print v(xbgr.mr_n81329648)
print v(xbgr.mr_n81329760)
print v(xbgr.mr_n81330080)
print v(xbgr.mr_n81330192)
print v(xbgr.mr_n81330512)
print v(xbgr.mr_n81330624)
print v(xbgr.mr_n81330944)
print v(xbgr.mr_n81331056)
print v(xbgr.mr_n81331376)
print v(xbgr.mr_n81331488)
print v(xbgr.mr_n81331808)
print v(xbgr.mr_n81331920)
print v(xbgr.mr_n81332240)
print v(xbgr.mr_n81332352)
print v(xbgr.mr_n81332672)
print v(xbgr.mr_n81332784)
print v(xbgr.mr_n81333104)
print v(xbgr.mr_n81333216)
print v(xbgr.mr_n81333536)
print v(xbgr.mr_n81333648)
print v(xbgr.mr_n81333968)
print v(xbgr.mr_n81334080)
print v(xbgr.mr_n81334400)
print v(xbgr.mr_n81334512)
print v(xbgr.mr_n81334832)
print v(xbgr.mr_n81334944)
print v(xbgr.mr_n81335264)
print v(xbgr.mr_n81335376)
print v(xbgr.mr_n81335696)
print v(xbgr.mr_n81335808)
print v(xbgr.mr_n81336128)
print v(xbgr.mr_n81336240)
print v(xbgr.mr_n81336560)
print v(xbgr.mr_n81336672)
print v(xbgr.mr_n81336992)
print v(xbgr.mr_n81337104)
print v(xbgr.mr_n81337424)
print v(xbgr.mr_n81337536)
print v(xbgr.mr_n81337856)
print v(xbgr.mr_n81337968)
print v(xbgr.mr_n81338288)
print v(xbgr.mr_n81338400)
print v(xbgr.mr_n81338720)
print v(xbgr.mr_n81338832)
print v(xbgr.mr_n81339152)
print v(xbgr.mr_n81339264)
print v(xbgr.mr_n81339584)
print v(xbgr.mr_n81339696)
print v(xbgr.mr_n81340016)
print v(xbgr.mr_n81340128)
print v(xbgr.mr_n81340448)
print v(xbgr.mr_n81340560)
print v(xbgr.mr_n81340880)
print v(xbgr.mr_n81340992)
print v(xbgr.mr_n81341312)
print v(xbgr.mr_n81341424)
print v(xbgr.mr_n81341744)
print v(xbgr.mr_n81341856)
print v(xbgr.mr_n81342176)
print v(xbgr.mr_n81342288)
print v(xbgr.mr_n81342608)
print v(xbgr.mr_n81342720)
print v(xbgr.mr_n81343040)
print v(xbgr.mr_n81343152)
print v(xbgr.mr_n81343472)
print v(xbgr.mr_n81343584)
print v(xbgr.mr_n81343904)
print v(xbgr.mr_n81344016)
print v(xbgr.mr_n81344336)
print v(xbgr.mr_n81344448)
print v(xbgr.mr_n81344768)
print v(xbgr.mr_n81344880)
print v(xbgr.mr_n81345200)
print v(xbgr.mr_n81345312)
print v(xbgr.mr_n81345632)
print v(xbgr.mr_n81345744)
print v(xbgr.mr_n81346064)
print v(xbgr.mr_n81346176)
print v(xbgr.mr_n81346496)
print v(xbgr.mr_n81346608)
print v(xbgr.mr_n81346928)
print v(xbgr.mr_n81347040)
print v(xbgr.mr_n81347360)
print v(xbgr.mr_n81347472)
print v(xbgr.mr_n81347792)
print v(xbgr.mr_n81347904)
print v(xbgr.mr_n81348224)
print v(xbgr.mr_n81348336)
print v(xbgr.mr_n81348656)
print v(xbgr.mr_n81348768)
print v(xbgr.mr_n81349088)
print v(xbgr.mr_n81349200)
print v(xbgr.mr_n81349520)
print v(xbgr.mr_n81349632)
print v(xbgr.mr_n81349952)
print v(xbgr.mr_n81350064)
print v(xbgr.mr_n81350384)
print v(xbgr.mr_n81350496)
print v(xbgr.mr_n81350816)
print v(xbgr.mr_n81350928)
print v(xbgr.mr_n81351248)
print v(xbgr.mr_n81351360)
print v(xbgr.mr_n81351680)
print v(xbgr.mr_n81351792)
print v(xbgr.mr_n81352112)
print v(xbgr.mr_n81352224)
print v(xbgr.mr_n81352544)
print v(xbgr.mr_n81352656)
print v(xbgr.mr_n81352976)
print v(xbgr.mr_n81353088)
print v(xbgr.mr_n81353408)
print v(xbgr.mr_n81353520)
print v(xbgr.mr_n81353840)
print v(xbgr.mr_n81353952)
print v(xbgr.mr_n81354272)
print v(xbgr.mr_n81354384)
print v(xbgr.mr_n81354704)
print v(xbgr.mr_n81354816)
print v(xbgr.mr_n81355136)
print v(xbgr.mr_n81355248)
print v(xbgr.mr_n81355568)
print v(xbgr.mr_n81355680)
print v(xbgr.mr_n81356000)
print v(xbgr.mr_n81356112)
print v(xbgr.mr_n81356432)
print v(xbgr.mr_n81356544)
print v(xbgr.mr_n81356864)
print v(xbgr.mr_n81356976)
print v(xbgr.mr_n81357296)
print v(xbgr.mr_n81357408)
print v(xbgr.mr_n81357728)
print v(xbgr.mr_n81357840)
print v(xbgr.mr_n81358160)
print v(xbgr.mr_n81358272)
print v(xbgr.mr_n81358592)
print v(xbgr.mr_n81358704)
print v(xbgr.mr_n81359024)
print v(xbgr.mr_n81359136)
print v(xbgr.mr_n81359456)
print v(xbgr.mr_n81359568)
print v(xbgr.mr_n81359888)
print v(xbgr.mr_n81360000)
print v(xbgr.mr_n81360320)
print v(xbgr.mr_n81360432)
print v(xbgr.mr_n81360752)
print v(xbgr.mr_n81360864)
print v(xbgr.mr_n81361184)
print v(xbgr.mr_n81361296)
print v(xbgr.mr_n81361616)
print v(xbgr.mr_n81361728)
print v(xbgr.mr_n81362048)
print v(xbgr.mr_n81362160)
print v(xbgr.mr_n81362480)
print v(xbgr.mr_n81362592)
print v(xbgr.mr_n81362912)
print v(xbgr.mr_n81363024)
print v(xbgr.mr_n81363344)
print v(xbgr.mr_n81363456)
print v(xbgr.mr_n81363776)
print v(xbgr.mr_n81363888)
print v(xbgr.mr_n81364208)
print v(xbgr.mr_n81364320)
print v(xbgr.mr_n81364640)
print v(xbgr.mr_n81364752)
print v(xbgr.mr_n81365072)
print v(xbgr.mr_n81365184)
print v(xbgr.mr_n81365504)
print v(xbgr.mr_n81365616)
print v(xbgr.mr_n81365936)
print v(xbgr.mr_n81366048)
print v(xbgr.mr_n81366368)
print v(xbgr.mr_n81366480)
print v(xbgr.mr_n81366800)
print v(xbgr.mr_n81366912)
print v(xbgr.mr_n81367232)
print v(xbgr.mr_n81367344)
print v(xbgr.mr_n81367664)
print v(xbgr.mr_n81367776)
print v(xbgr.mr_n81368096)
print v(xbgr.mr_n81368208)
print v(xbgr.mr_n81368528)
print v(xbgr.mr_n81368640)
print v(xbgr.mr_n81368960)
print v(xbgr.mr_n81369072)
print v(xbgr.mr_n81369392)
print v(xbgr.mr_n81369504)
print v(xbgr.mr_n81369824)
print v(xbgr.mr_n81369936)
print v(xbgr.mr_n81370256)
print v(xbgr.mr_n81370368)
print v(xbgr.mr_n81370688)
print v(xbgr.mr_n81370800)
print v(xbgr.mr_n81371120)
print v(xbgr.mr_n81371232)
print v(xbgr.mr_n81371552)
print v(xbgr.mr_n81371664)
print v(xbgr.mr_n81371984)
print v(xbgr.mr_n81372096)
print v(xbgr.mr_n81372416)
print v(xbgr.mr_n81372528)
print v(xbgr.mr_n81372848)
print v(xbgr.mr_n81372960)
print v(xbgr.mr_n81373280)
print v(xbgr.mr_n81373392)
print v(xbgr.mr_n81373712)
print v(xbgr.mr_n81373824)
print v(xbgr.mr_n81374144)
print v(xbgr.mr_n81374256)
print v(xbgr.mr_n81374576)
print v(xbgr.mr_n81374688)
print v(xbgr.mr_n81375008)
print v(xbgr.mr_n81375120)
print v(xbgr.mr_n81375440)
print v(xbgr.mr_n81375552)
print v(xbgr.mr_n81375872)
print v(xbgr.mr_n81375984)
print v(xbgr.mr_n81376304)
print v(xbgr.mr_n81376416)
print v(xbgr.mr_n81376736)
print v(xbgr.mr_n81376848)
print v(xbgr.mr_n81377168)
print v(xbgr.mr_n81377280)
print v(xbgr.mr_n81377600)
print v(xbgr.mr_n81377712)
print v(xbgr.mr_n81378032)
print v(xbgr.mr_n81378144)
print v(xbgr.mr_n81378464)
print v(xbgr.mr_n81378576)
print v(xbgr.mr_n81378896)
print v(xbgr.mr_n81379008)
print v(xbgr.mr_n81379328)
print v(xbgr.mr_n81379440)
print v(xbgr.mr_n81379760)
print v(xbgr.mr_n81379872)
print v(xbgr.mr_n81380192)
print v(xbgr.mr_n81380304)
print v(xbgr.mr_n81380624)
print v(xbgr.mr_n81380736)
print v(xbgr.mr_n81381056)
print v(xbgr.mr_n81381168)
print v(xbgr.mr_n81381488)
print v(xbgr.mr_n81381600)
print v(xbgr.mr_n81381920)
print v(xbgr.mr_n81382032)
print v(xbgr.mr_n81382352)
print v(xbgr.mr_n81382464)
print v(xbgr.mr_n81382784)
print v(xbgr.mr_n81382896)
print v(xbgr.mr_n81383216)
print v(xbgr.mr_n81383328)
print v(xbgr.mr_n81383648)
print v(xbgr.mr_n81383760)
print v(xbgr.mr_n81384080)
print v(xbgr.mr_n81384192)
print v(xbgr.mr_n81384512)
print v(xbgr.mr_n81384624)
print v(xbgr.mr_n81384944)
print v(xbgr.mr_n81385056)
print v(xbgr.mr_n81385376)
print v(xbgr.mr_n81385488)
print v(xbgr.mr_n81385808)
print v(xbgr.mr_n81385920)
print v(xbgr.mr_n81386240)
print v(xbgr.mr_n81386352)
print v(xbgr.mr_n81386672)
print v(xbgr.mr_n81386784)
print v(xbgr.mr_n81387104)
print v(xbgr.mr_n81387216)
print v(xbgr.mr_n81387536)
print v(xbgr.mr_n81387648)
print v(xbgr.mr_n81387968)
print v(xbgr.mr_n81388080)
print v(xbgr.mr_n81388400)
print v(xbgr.mr_n81388512)
print v(xbgr.mr_n81388832)
print v(xbgr.mr_n81388944)
print v(xbgr.mr_n81389264)
print v(xbgr.mr_n81389376)
print v(xbgr.mr_n81389696)
print v(xbgr.mr_n81389808)
print v(xbgr.mr_n81390128)
print v(xbgr.mr_n81390240)
print v(xbgr.mr_n81390560)
print v(xbgr.mr_n81390672)
print v(xbgr.mr_n81390992)
print v(xbgr.mr_n81391104)
print v(xbgr.mr_n81391424)
print v(xbgr.mr_n81391536)
print v(xbgr.mr_n81391856)
print v(xbgr.mr_n81391968)
print v(xbgr.mr_n81392288)
print v(xbgr.mr_n81392400)
print v(xbgr.mr_n81392720)
print v(xbgr.mr_n81392832)
print v(xbgr.mr_n81393152)
print v(xbgr.mr_n81393264)
print v(xbgr.mr_n81393584)
print v(xbgr.mr_n81393696)
print v(xbgr.mr_n81394016)
print v(xbgr.mr_n81394128)
print v(xbgr.mr_n81394448)
print v(xbgr.mr_n81394560)
print v(xbgr.mr_n81394880)
print v(xbgr.mr_n81394992)
print v(xbgr.mr_n81395312)
print v(xbgr.mr_n81395424)
print v(xbgr.mr_n81395744)
print v(xbgr.mr_n81395856)
print v(xbgr.mr_n81396176)
print v(xbgr.mr_n81396288)
print v(xbgr.mr_n81396608)
print v(xbgr.mr_n81396720)
print v(xbgr.mr_n81397040)
print v(xbgr.mr_n81397152)
print v(xbgr.mr_n81397472)
print v(xbgr.mr_n81397584)
print v(xbgr.mr_n81397904)
print v(xbgr.mr_n81398016)
print v(xbgr.mr_n81398336)
print v(xbgr.mr_n81398448)
print v(xbgr.mr_n81398768)
print v(xbgr.mr_n81398880)
print v(xbgr.mr_n81399200)
print v(xbgr.mr_n81399312)
print v(xbgr.mr_n81399632)
print v(xbgr.mr_n81399744)
print v(xbgr.mr_n81400064)
print v(xbgr.mr_n81400176)
print v(xbgr.mr_n81400496)
print v(xbgr.mr_n81400608)
print v(xbgr.mr_n81400928)
print v(xbgr.mr_n81401040)
print v(xbgr.mr_n81401360)
print v(xbgr.mr_n81401472)
print v(xbgr.mr_n81401792)
print v(xbgr.mr_n81401904)
print v(xbgr.mr_n81402224)
print v(xbgr.mr_n81402336)
print v(xbgr.mr_n81402656)
print v(xbgr.mr_n81402768)
print v(xbgr.mr_n81403088)
print v(xbgr.mr_n81403200)
print v(xbgr.mr_n81403520)
print v(xbgr.mr_n81403632)
print v(xbgr.mr_n81403952)
print v(xbgr.mr_n81404064)
print v(xbgr.mr_n81404384)
print v(xbgr.mr_n81404496)
print v(xbgr.mr_n81404816)
print v(xbgr.mr_n81404928)
print v(xbgr.mr_n81405248)
print v(xbgr.mr_n81405360)
print v(xbgr.mr_n81405680)
print v(xbgr.mr_n81405792)
print v(xbgr.mr_n81406112)
print v(xbgr.mr_n81406224)
print v(xbgr.mr_n81406544)
print v(xbgr.mr_n81406656)
print v(xbgr.mr_n81406976)
print v(xbgr.mr_n81407088)
print v(xbgr.mr_n81407408)
print v(xbgr.mr_n81407520)
print v(xbgr.mr_n81407840)
print v(xbgr.mr_n81407952)
print v(xbgr.mr_n81408272)
print v(xbgr.mr_n81408384)
print v(xbgr.mr_n81408704)
print v(xbgr.mr_n81408816)
print v(xbgr.mr_n81409136)
print v(xbgr.mr_n81409248)
print v(xbgr.mr_n81409568)
print v(xbgr.mr_n81409680)
print v(xbgr.mr_n81410000)
print v(xbgr.mr_n81410112)
print v(xbgr.mr_n81410432)
print v(xbgr.mr_n81410544)
print v(xbgr.mr_n81410864)
print v(xbgr.mr_n81410976)
print v(xbgr.mr_n81411296)
print v(xbgr.mr_n81411408)
print v(xbgr.mr_n81411728)
print v(xbgr.mr_n81411840)
print v(xbgr.mr_n81412160)
print v(xbgr.mr_n81412272)
print v(xbgr.mr_n81412592)
print v(xbgr.mr_n81412704)
print v(xbgr.mr_n81413024)
print v(xbgr.mr_n81413136)
print v(xbgr.mr_n81413456)
print v(xbgr.mr_n81413568)
print v(xbgr.mr_n81413888)
print v(xbgr.mr_n81414000)
print v(xbgr.mr_n81414320)
print v(xbgr.mr_n81414432)
print v(xbgr.mr_n81414752)
print v(xbgr.mr_n81414864)
print v(xbgr.mr_n81415184)
print v(xbgr.mr_n81415296)
print v(xbgr.mr_n81415616)
print v(xbgr.mr_n81415728)
print v(xbgr.mr_n81416048)
print v(xbgr.mr_n81416160)
print v(xbgr.mr_n81416480)
print v(xbgr.mr_n81416592)
print v(xbgr.mr_n81416912)
print v(xbgr.mr_n81417024)
print v(xbgr.mr_n81417344)
print v(xbgr.mr_n81417456)
print v(xbgr.mr_n81417776)
print v(xbgr.mr_n81417888)
print v(xbgr.mr_n81418208)
print v(xbgr.mr_n81418320)
print v(xbgr.mr_n81418640)
print v(xbgr.mr_n81418752)
print v(xbgr.mr_n81419072)
print v(xbgr.mr_n81419184)
print v(xbgr.mr_n81419504)
print v(xbgr.mr_n81419616)
print v(xbgr.mr_n81419936)
print v(xbgr.mr_n81420048)
print v(xbgr.mr_n81420368)
print v(xbgr.mr_n81420480)
print v(xbgr.mr_n81420800)
print v(xbgr.mr_n81420912)
print v(xbgr.mr_n81421232)
print v(xbgr.mr_n81421344)
print v(xbgr.mr_n81421664)
print v(xbgr.mr_n81421776)
print v(xbgr.mr_n81422096)
print v(xbgr.mr_n81422208)
print v(xbgr.mr_n81422528)
print v(xbgr.mr_n81422640)
print v(xbgr.mr_n81422960)
print v(xbgr.mr_n81423072)
print v(xbgr.mr_n81423392)
print v(xbgr.mr_n81423504)
print v(xbgr.mr_n81423824)
print v(xbgr.mr_n81423936)
print v(xbgr.mr_n81424256)
print v(xbgr.mr_n81424368)
print v(xbgr.mr_n81424800)
print v(xbgr.mr_n81425120)
print v(xbgr.mr_n81425232)
print v(xbgr.mr_n81425664)
print v(xbgr.mr_n81425984)
print v(xbgr.mr_n81426096)
print v(xbgr.mr_n81426528)
print v(xbgr.mr_n81426848)
print v(xbgr.mr_n81427712)
print v(xbgr.mr_n81428576)
print v(xbgr.mr_n81428688)
print v(xbgr.mr_n81429008)
print v(xbgr.mr_n81429120)
print v(xbgr.mr_n81429440)
print v(xbgr.mr_n81429552)
print v(xbgr.mr_n81429872)
print v(xbgr.mr_n81429984)
print v(xbgr.mr_n81430304)
print v(xbgr.mr_n81430416)
print v(xbgr.mr_n81430736)
print v(xbgr.mr_n81430848)
print v(xbgr.mr_n81431168)
print v(xbgr.mr_n81432032)
print v(xbgr.mr_n81432896)
print v(xbgr.mr_n81433760)
print v(xbgr.mr_n81433872)
print v(xbgr.mr_n81434192)
print v(xbgr.mr_n81434304)
print v(xbgr.mr_n81434624)
print v(xbgr.mr_n81434736)
print v(xbgr.mr_n81435056)
print v(xbgr.mr_n81435168)
print v(xbgr.mr_n81435488)
print v(xbgr.mr_n81436352)
print v(xbgr.mr_n81437216)
print v(xbgr.mr_n81437328)
print v(xbgr.mr_n81437648)
print v(xbgr.mr_n81437760)
print v(xbgr.mr_n81438080)
print v(xbgr.mr_n81438192)
print v(xbgr.mr_n81438512)
print v(xbgr.mr_n81438624)
print v(xbgr.mr_n81438944)
print v(xbgr.mr_n81439056)
print v(xbgr.mr_n81439376)
print v(xbgr.mr_n81439488)
print v(xbgr.mr_n81439808)
print v(xbgr.mr_n81440672)
print v(xbgr.mr_n81440784)
print v(xbgr.mr_n81441216)
print v(xbgr.mr_n81441536)
print v(xbgr.mr_n81441648)
print v(xbgr.mr_n81442080)
print v(xbgr.mr_n81442400)
print v(xbgr.mr_n81442512)
print v(xbgr.mr_n81442944)
print v(xbgr.mr_n81443264)
print v(xbgr.mr_n81444128)
print v(xbgr.mr_n81444992)
print v(xbgr.mr_n81445856)
print v(xbgr.mr_n81446720)
print v(xbgr.mr_n81447584)
print v(xbgr.mr_n81448448)
print v(xbgr.mr_n81448560)
print v(xbgr.mr_n81448880)
print v(xbgr.mr_n81448992)
print v(xbgr.mr_n81449312)
print v(xbgr.mr_n81449424)
print v(xbgr.mr_n81449744)
print v(xbgr.mr_n81449856)
print v(xbgr.mr_n81450176)
print v(xbgr.mr_n81451040)
print v(xbgr.mr_n81451904)
print v(xbgr.mr_n81452768)
print v(xbgr.mr_n81453632)
print v(xbgr.mr_n81453744)
print v(xbgr.mr_n81454176)
print v(xbgr.mr_n81454496)
print v(xbgr.mr_n81454608)
print v(xbgr.mr_n81455040)
print v(xbgr.mr_n81455360)
print v(xbgr.mr_n81455472)
print v(xbgr.mr_n81455904)
print v(xbgr.mr_n81456224)
print v(xbgr.mr_n81457088)
print v(xbgr.mr_n81457952)
print v(xbgr.mr_n81458816)
print v(xbgr.mr_n81459680)
print v(xbgr.mr_n81460544)
print v(xbgr.mr_n81461408)
print v(xbgr.mr_n81461520)
print v(xbgr.mr_n81461840)
print v(xbgr.mr_n81461952)
print v(xbgr.mr_n81462272)
print v(xbgr.mr_n81462384)
print v(xbgr.mr_n81462704)
print v(xbgr.mr_n81462816)
print v(xbgr.mr_n81463136)
print v(xbgr.mr_n81464000)
print v(xbgr.mr_n81464864)
print v(xbgr.mr_n81465728)
print v(xbgr.mr_n81465840)
print v(xbgr.mr_n81466160)
print v(xbgr.mr_n81466272)
print v(xbgr.mr_n81466592)
print v(xbgr.mr_n81466704)
print v(xbgr.mr_n81467136)
print v(xbgr.mr_n81467568)
print v(xbgr.mr_n81468000)
print v(xbgr.mr_n81468320)
print v(xbgr.mr_n81468432)
print v(xbgr.mr_n81468752)
print v(xbgr.mr_n81468864)
print v(xbgr.mr_n81469184)
print v(xbgr.mr_n81469296)
print v(xbgr.mr_n81469616)
print v(xbgr.mr_n81469728)
print v(xbgr.mr_n81470048)
print v(xbgr.mr_n81470160)
print v(xbgr.mr_n81470480)
print v(xbgr.mr_n81470592)
print v(xbgr.mr_n81470912)
print v(xbgr.mr_n81471024)
print v(xbgr.mr_n81471456)
print v(xbgr.mr_n81471776)
print v(xbgr.mr_n81472208)
print v(xbgr.mr_n81472320)
print v(xbgr.mr_n81472640)
print v(xbgr.mr_n81472752)
print v(xbgr.mr_n81473072)
print v(xbgr.mr_n81473184)
print v(xbgr.mr_n81473504)
print v(xbgr.mr_n81473616)
print v(xbgr.mr_n81473936)
print v(xbgr.mr_n81474048)
print v(xbgr.mr_n81474368)
print v(xbgr.mr_n81474480)
print v(xbgr.mr_n81474800)
print v(xbgr.mr_n81474912)
print v(xbgr.mr_n81475344)
print v(xbgr.mr_n81475664)
print v(xbgr.mr_n81475776)
print v(xbgr.mr_n81476208)
print v(xbgr.mr_n81476528)
print v(xbgr.mr_n81476640)
print v(xbgr.mr_n81476960)
print v(xbgr.mr_n81477072)
print v(xbgr.mr_n81477392)
print v(xbgr.mr_n81477504)
print v(xbgr.mr_n81477936)
print v(xbgr.mr_n81478368)
print v(xbgr.mr_n81478688)
print v(xbgr.mr_n81478800)
print v(xbgr.mr_n81479120)
print v(xbgr.mr_n81479232)
print v(xbgr.mr_n81479552)
print v(xbgr.mr_n81479664)
print v(xbgr.mr_n81479984)
print v(xbgr.mr_n81480096)
print v(xbgr.mr_n81480416)
print v(xbgr.mr_n81480528)
print v(xbgr.mr_n81480848)
print v(xbgr.mr_n81480960)
print v(xbgr.mr_n81481280)
print v(xbgr.mr_n81481392)
print v(xbgr.mr_n81481712)
print v(xbgr.mr_n81481824)
print v(xbgr.mr_n81482144)
print v(xbgr.mr_n81482256)
print v(xbgr.mr_n81482576)
print v(xbgr.mr_n81482688)
print v(xbgr.mr_n81483008)
print v(xbgr.mr_n81483120)
print v(xbgr.mr_n81483440)
print v(xbgr.mr_n81484304)
print v(xbgr.mr_n81485168)
print v(xbgr.mr_n81485280)
print v(xbgr.mr_n81485712)
print v(xbgr.mr_n81486032)
print v(xbgr.mr_n81486144)
print v(xbgr.mr_n81486896)
print v(xbgr.mr_n81487328)
print v(xbgr.mr_n81487440)
print v(xbgr.mr_n81487760)
print v(xbgr.mr_n81487872)
print v(xbgr.mr_n81488192)
print v(xbgr.mr_n81488304)
print v(xbgr.mr_n81488624)
print v(xbgr.mr_n81488736)
print v(xbgr.mr_n81489056)
print v(xbgr.mr_n81489920)
print v(xbgr.mr_n81490352)
print v(xbgr.mr_n81490464)
print v(xbgr.mr_n81490784)
print v(xbgr.mr_n81490896)
print v(xbgr.mr_n81491216)
print v(xbgr.mr_n81492080)
print v(xbgr.mr_n81493376)
print v(xbgr.mr_n81494240)
print v(xbgr.mr_n81495104)
print v(xbgr.mr_n81495216)
print v(xbgr.mr_n81495968)
print v(xbgr.mr_n81496080)
print v(xbgr.mr_n81496512)
print v(xbgr.mr_n81496944)
print v(xbgr.mr_n81497696)
print v(xbgr.mr_n81498560)
print v(xbgr.mr_n81499424)
print v(xbgr.mr_n81499536)
print v(xbgr.mr_n81499856)
print v(xbgr.mr_n81499968)
print v(xbgr.mr_n81500400)
print v(xbgr.mr_n81500720)
print v(xbgr.mr_n81500832)
print v(xbgr.mr_n81501264)
print v(xbgr.mr_n81501584)
print v(xbgr.mr_n81501696)
print v(xbgr.mr_n81502016)
print v(xbgr.mr_n81502128)
print v(xbgr.mr_n81502448)
print v(xbgr.mr_n81503312)
print v(xbgr.mr_n81503424)
print v(xbgr.mr_n81503856)
print v(xbgr.mr_n81504176)
print v(xbgr.mr_n81505152)
print v(xbgr.mr_n81505472)
print v(xbgr.mr_n81505584)
print v(xbgr.mr_n81506016)
print v(xbgr.mr_n81506336)
print v(xbgr.mr_n81506768)
print v(xbgr.mr_n81506880)
print v(xbgr.mr_n81507200)
print v(xbgr.mr_n81507312)
print v(xbgr.mr_n81507632)
print v(xbgr.mr_n81508064)
print v(xbgr.mr_n81508176)
print v(xbgr.mr_n81508496)
print v(xbgr.mr_n81508608)
print v(xbgr.mr_n81508928)
print v(xbgr.mr_n81509040)
print v(xbgr.mr_n81509360)
print v(xbgr.mr_n81509472)
print v(xbgr.mr_n81509792)
print v(xbgr.mr_n81509904)
print v(xbgr.mr_n81510336)
print v(xbgr.mr_n81510656)
print v(xbgr.mr_n81510768)
print v(xbgr.mr_n81511088)
print v(xbgr.mr_n81511200)
print v(xbgr.mr_n81511520)
print v(xbgr.mr_n81512064)
print v(xbgr.mr_n81512816)
print v(xbgr.mr_n81514112)
print v(xbgr.mr_n81514224)
print v(xbgr.mr_n81514544)
print v(xbgr.mr_n81514656)
print v(xbgr.mr_n81514976)
print v(xbgr.mr_n81515840)
print v(xbgr.mr_n81516704)
print v(xbgr.mr_n81517568)
print v(xbgr.mr_n81517680)
print v(xbgr.mr_n81518000)
print v(xbgr.mr_n81518112)
print v(xbgr.mr_n81518432)
print v(xbgr.mr_n81518544)
print v(xbgr.mr_n81518864)
print v(xbgr.mr_n81518976)
print v(xbgr.mr_n81519296)
print v(xbgr.mr_n81519408)
print v(xbgr.mr_n81519728)
print v(xbgr.mr_n81520592)
print v(xbgr.mr_n81521456)
print v(xbgr.mr_n81522320)
print v(xbgr.mr_n81522432)
print v(xbgr.mr_n81522752)
print v(xbgr.mr_n81522864)
print v(xbgr.mr_n81523184)
print v(xbgr.mr_n81523296)
print v(xbgr.mr_n81523616)
print v(xbgr.mr_n81523728)
print v(xbgr.mr_n81524160)
print v(xbgr.mr_n81524480)
print v(xbgr.mr_n81524592)
print v(xbgr.mr_n81524912)
print v(xbgr.mr_n81525024)
print v(xbgr.mr_n81525344)
print v(xbgr.mr_n81525456)
print v(xbgr.mr_n81525776)
print v(xbgr.mr_n81525888)
print v(xbgr.mr_n81526640)
print v(xbgr.mr_n81527184)
print v(xbgr.mr_n81527616)
print v(xbgr.mr_n81528048)
print v(xbgr.mr_n81528480)
print v(xbgr.mr_n81528800)
print v(xbgr.mr_n81528912)
print v(xbgr.mr_n81529664)
print v(xbgr.mr_n81530528)
print v(xbgr.mr_n81531392)
print v(xbgr.mr_n81532256)
print v(xbgr.mr_n81533120)
print v(xbgr.mr_n81533984)
print v(xbgr.mr_n81534848)
print v(xbgr.mr_n81534960)
print v(xbgr.mr_n81535280)
print v(xbgr.mr_n81535392)
print v(xbgr.mr_n81535824)
print v(xbgr.mr_n81536144)
print v(xbgr.mr_n81536256)
print v(xbgr.mr_n81536688)
print v(xbgr.mr_n81537008)
print v(xbgr.mr_n81537120)
print v(xbgr.mr_n81537440)
print v(xbgr.mr_n81537552)
print v(xbgr.mr_n81537872)
print v(xbgr.mr_n81537984)
print v(xbgr.mr_n81538304)
print v(xbgr.mr_n81538416)
print v(xbgr.mr_n81538736)
print v(xbgr.mr_n81538848)
print v(xbgr.mr_n81539168)
print v(xbgr.mr_n81539280)
print v(xbgr.mr_n81539600)
print v(xbgr.mr_n81540464)
print v(xbgr.mr_n81540896)
print v(xbgr.mr_n81541872)
print v(xbgr.mr_n81542304)
print v(xbgr.mr_n81542736)
print v(xbgr.mr_n81543168)
print v(xbgr.mr_n81543488)
print v(xbgr.mr_n81544352)
print v(xbgr.mr_n81545216)
print v(xbgr.mr_n81546080)
print v(xbgr.mr_n81546944)
print v(xbgr.mr_n81547808)
print v(xbgr.mr_n81548672)
print v(xbgr.mr_n81549968)
print v(xbgr.mr_n81550400)
print v(xbgr.mr_n81551696)
print v(xbgr.mr_n81551808)
print v(xbgr.mr_n81552128)
print v(xbgr.mr_n81552240)
print v(xbgr.mr_n81552560)
print v(xbgr.mr_n81552672)
print v(xbgr.mr_n81553104)
print v(xbgr.mr_n81553536)
print v(xbgr.mr_n81553856)
print v(xbgr.mr_n81553968)
print v(xbgr.mr_n81554288)
print v(xbgr.mr_n81554400)
print v(xbgr.mr_n81554720)
print v(xbgr.mr_n81554832)
print v(xbgr.mr_n81555152)
print v(xbgr.mr_n81555264)
print v(xbgr.mr_n81555696)
print v(xbgr.mr_n81556016)
print v(xbgr.mr_n81556880)
print v(xbgr.mr_n81556992)
print v(xbgr.mr_n81557312)
print v(xbgr.mr_n81557424)
print v(xbgr.mr_n81557744)
print v(xbgr.mr_n81557856)
print v(xbgr.mr_n81558176)
print v(xbgr.mr_n81558288)
print v(xbgr.mr_n81558608)
print v(xbgr.mr_n81559472)
print v(xbgr.mr_n81559904)
print v(xbgr.mr_n81561200)
print v(xbgr.mr_n81561312)
print v(xbgr.mr_n81561632)
print v(xbgr.mr_n81561744)
print v(xbgr.mr_n81562064)
print v(xbgr.mr_n81562176)
print v(xbgr.mr_n81562496)
print v(xbgr.mr_n81563360)
print v(xbgr.mr_n81563472)
print v(xbgr.mr_n81563904)
print v(xbgr.mr_n81564224)
print v(xbgr.mr_n81564336)
print v(xbgr.mr_n81564656)
print v(xbgr.mr_n81564768)
print v(xbgr.mr_n81565088)
print v(xbgr.mr_n81565200)
print v(xbgr.mr_n81565520)
print v(xbgr.mr_n81565632)
print v(xbgr.mr_n81566064)
print v(xbgr.mr_n81566384)
print v(xbgr.mr_n81567248)
print v(xbgr.mr_n81567360)
print v(xbgr.mr_n81567680)
print v(xbgr.mr_n81568544)
print v(xbgr.mr_n81568656)
print v(xbgr.mr_n81568976)
print v(xbgr.mr_n81569088)
print v(xbgr.mr_n81569408)
print v(xbgr.mr_n81569952)
print v(xbgr.mr_n81570384)
print v(xbgr.mr_n81570704)
print v(xbgr.mr_n81571136)
print v(xbgr.mr_n81571248)
print v(xbgr.mr_n81571568)
print v(xbgr.mr_n81571680)
print v(xbgr.mr_n81572000)
print v(xbgr.mr_n81572112)
print v(xbgr.mr_n81572432)
print v(xbgr.mr_n81572544)
print v(xbgr.mr_n81572864)
print v(xbgr.mr_n81572976)
print v(xbgr.mr_n81573728)
print v(xbgr.mr_n81573840)
print v(xbgr.mr_n81574160)
print v(xbgr.mr_n81574272)
print v(xbgr.mr_n81574592)
print v(xbgr.mr_n81575888)
print v(xbgr.mr_n81576000)
print v(xbgr.mr_n81576320)
print v(xbgr.mr_n81576432)
print v(xbgr.mr_n81576752)
print v(xbgr.mr_n81577728)
print v(xbgr.mr_n81578048)
print v(xbgr.mr_n81578912)
print v(xbgr.mr_n81579344)
print v(xbgr.mr_n81579456)
print v(xbgr.mr_n81579776)
print v(xbgr.mr_n81579888)
print v(xbgr.mr_n81580208)
print v(xbgr.mr_n81580320)
print v(xbgr.mr_n81580640)
print v(xbgr.mr_n81581504)
print v(xbgr.mr_n81582800)
print v(xbgr.mr_n81583664)
print v(xbgr.mr_n81584640)
print v(xbgr.mr_n81584960)
print v(xbgr.mr_n81585072)
print v(xbgr.mr_n81585504)
print v(xbgr.mr_n81585824)
print v(xbgr.mr_n81585936)
print v(xbgr.mr_n81586256)
print v(xbgr.mr_n81586368)
print v(xbgr.mr_n81586688)
print v(xbgr.mr_n81586800)
print v(xbgr.mr_n81587120)
print v(xbgr.mr_n81587232)
print v(xbgr.mr_n81587552)
print v(xbgr.mr_n81587664)
print v(xbgr.mr_n81587984)
print v(xbgr.mr_n81588096)
print v(xbgr.mr_n81588416)
print v(xbgr.mr_n81588528)
print v(xbgr.mr_n81588848)
print v(xbgr.mr_n81588960)
print v(xbgr.mr_n81589392)
print v(xbgr.mr_n81589712)
print v(xbgr.mr_n81589824)
print v(xbgr.mr_n81590256)
print v(xbgr.mr_n81590576)
print v(xbgr.mr_n81591440)
print v(xbgr.mr_n81592304)
print v(xbgr.mr_n81593168)
print v(xbgr.mr_n81593280)
print v(xbgr.mr_n81593600)
print v(xbgr.mr_n81593712)
print v(xbgr.mr_n81594032)
print v(xbgr.mr_n81594144)
print v(xbgr.mr_n81594464)
print v(xbgr.mr_n81594576)
print v(xbgr.mr_n81595008)
print v(xbgr.mr_n81595440)
print v(xbgr.mr_n81595872)
print v(xbgr.mr_n81596304)
print v(xbgr.mr_n81596624)
print v(xbgr.mr_n81596736)
print v(xbgr.mr_n81597056)
print v(xbgr.mr_n81597168)
print v(xbgr.mr_n81597488)
print v(xbgr.mr_n81597600)
print v(xbgr.mr_n81597920)
print v(xbgr.mr_n81598032)
print v(xbgr.mr_n81598352)
print v(xbgr.mr_n81598464)
print v(xbgr.mr_n81598784)
print v(xbgr.mr_n81598896)
print v(xbgr.mr_n81599216)
print v(xbgr.mr_n81599328)
print v(xbgr.mr_n81599760)
print v(xbgr.mr_n81600080)
print v(xbgr.mr_n81600192)
print v(xbgr.mr_n81600512)
print v(xbgr.mr_n81601376)
print v(xbgr.mr_n81602112)
print v(xbgr.mr_n81602976)
print v(xbgr.mr_n81603840)
print v(xbgr.mr_n81604704)
print v(xbgr.mr_n81605568)
print v(xbgr.mr_n81605680)
print v(xbgr.mr_n81606112)
print v(xbgr.mr_n81606432)
print v(xbgr.mr_n81606544)
print v(xbgr.mr_n81606976)
print v(xbgr.mr_n81607296)
print v(xbgr.mr_n81607408)
print v(xbgr.mr_n81607728)
print v(xbgr.mr_n81607840)
print v(xbgr.mr_n81608160)
print v(xbgr.mr_n81608272)
print v(xbgr.mr_n81608704)
print v(xbgr.mr_n81609024)
print v(xbgr.mr_n81609888)
print v(xbgr.mr_n81610000)
print v(xbgr.mr_n81610320)
print v(xbgr.mr_n81610432)
print v(xbgr.mr_n81610752)
print v(xbgr.mr_n81610864)
print v(xbgr.mr_n81611184)
print v(xbgr.mr_n81611296)
print v(xbgr.mr_n81611616)
print v(xbgr.mr_n81611728)
print v(xbgr.mr_n81612048)
print v(xbgr.mr_n81612160)
print v(xbgr.mr_n81612480)
print v(xbgr.mr_n81612592)
print v(xbgr.mr_n81612912)
print v(xbgr.mr_n81613344)
print v(xbgr.mr_n81613456)
print v(xbgr.mr_n81613776)
print v(xbgr.mr_n81613888)
print v(xbgr.mr_n81614208)
print v(xbgr.mr_n81614320)
print v(xbgr.mr_n81614640)
print v(xbgr.mr_n81614752)
print v(xbgr.mr_n81615072)
print v(xbgr.mr_n81616368)
print v(xbgr.mr_n81617232)
print v(xbgr.mr_n81617776)
print v(xbgr.mr_n81618208)
print v(xbgr.mr_n81618528)
print v(xbgr.mr_n81618640)
print v(xbgr.mr_n81618960)
print v(xbgr.mr_n81619072)
print v(xbgr.mr_n81619392)
print v(xbgr.mr_n81619504)
print v(xbgr.mr_n81619824)
print v(xbgr.mr_n81619936)
print v(xbgr.mr_n81620256)
print v(xbgr.mr_n81620368)
print v(xbgr.mr_n81620688)
print v(xbgr.mr_n81620800)
print v(xbgr.mr_n81621120)
print v(xbgr.mr_n81621232)
print v(xbgr.mr_n81621552)
print v(xbgr.mr_n81621664)
print v(xbgr.mr_n81621984)
print v(xbgr.mr_n81622096)
print v(xbgr.mr_n81622416)
print v(xbgr.mr_n81623280)
print v(xbgr.mr_n81624144)
print v(xbgr.mr_n81624256)
print v(xbgr.mr_n81624688)
print v(xbgr.mr_n81625440)
print v(xbgr.mr_n81626304)
print v(xbgr.mr_n81627168)
print v(xbgr.mr_n81628144)
print v(xbgr.mr_n81628576)
print v(xbgr.mr_n81628896)
print v(xbgr.mr_n81629008)
print v(xbgr.mr_n81629328)
print v(xbgr.mr_n81629440)
print v(xbgr.mr_n81629760)
print v(xbgr.mr_n81630624)
print v(xbgr.mr_n81631488)
print v(xbgr.mr_n81631600)
print v(xbgr.mr_n81631920)
print v(xbgr.mr_n81632032)
print v(xbgr.mr_n81632352)
print v(xbgr.mr_n81632464)
print v(xbgr.mr_n81632784)
print v(xbgr.mr_n81632896)
print v(xbgr.mr_n81633216)
print v(xbgr.mr_n81633328)
print v(xbgr.mr_n81633648)
print v(xbgr.mr_n81633760)
print v(xbgr.mr_n81634080)
print v(xbgr.mr_n81634192)
print v(xbgr.mr_n81634512)
print v(xbgr.mr_n81634624)
print v(xbgr.mr_n81634944)
print v(xbgr.mr_n81635056)
print v(xbgr.mr_n81635488)
print v(xbgr.mr_n81635808)
print v(xbgr.mr_n81636240)
print v(xbgr.mr_n81636352)
print v(xbgr.mr_n81637104)
print v(xbgr.mr_n81637216)
print v(xbgr.mr_n81637648)
print v(xbgr.mr_n81638400)
print v(xbgr.mr_n81638512)
print v(xbgr.mr_n81638832)
print v(xbgr.mr_n81638944)
print v(xbgr.mr_n81639376)
print v(xbgr.mr_n81639808)
print v(xbgr.mr_n81640240)
print v(xbgr.mr_n81640560)
print v(xbgr.mr_n81640672)
print v(xbgr.mr_n81640992)
print v(xbgr.mr_n81641104)
print v(xbgr.mr_n81641536)
print v(xbgr.mr_n81641856)
print v(xbgr.mr_n81642720)
print v(xbgr.mr_n81642832)
print v(xbgr.mr_n81643152)
print v(xbgr.mr_n81643264)
print v(xbgr.mr_n81643584)
print v(xbgr.mr_n81643696)
print v(xbgr.mr_n81644016)
print v(xbgr.mr_n81644128)
print v(xbgr.mr_n81644448)
print v(xbgr.mr_n81644560)
print v(xbgr.mr_n81644880)
print v(xbgr.mr_n81644992)
print v(xbgr.mr_n81645312)
print v(xbgr.mr_n81646176)
print v(xbgr.mr_n81647040)
print v(xbgr.mr_n81647152)
print v(xbgr.mr_n81647472)
print v(xbgr.mr_n81647584)
print v(xbgr.mr_n81647904)
print v(xbgr.mr_n81648016)
print v(xbgr.mr_n81648336)
print v(xbgr.mr_n81648448)
print v(xbgr.mr_n81648768)
print v(xbgr.mr_n81649632)
print v(xbgr.mr_n81650496)
print v(xbgr.mr_n81651360)
print v(xbgr.mr_n81652224)
print v(xbgr.mr_n81653632)
print v(xbgr.mr_n81653952)
print v(xbgr.mr_n81654816)
print v(xbgr.mr_n81655680)
print v(xbgr.mr_n81655792)
print v(xbgr.mr_n81656224)
print v(xbgr.mr_n81656544)
print v(xbgr.mr_n81656656)
print v(xbgr.mr_n81657088)
print v(xbgr.mr_n81657408)
print v(xbgr.mr_n81658272)
print v(xbgr.mr_n81659136)
print v(xbgr.mr_n81660000)
print v(xbgr.mr_n81660864)
print v(xbgr.mr_n81660976)
print v(xbgr.mr_n81661296)
print v(xbgr.mr_n81661408)
print v(xbgr.mr_n81661728)
print v(xbgr.mr_n81661840)
print v(xbgr.mr_n81662160)
print v(xbgr.mr_n81662272)
print v(xbgr.mr_n81662592)
print v(xbgr.mr_n81663456)
print v(xbgr.mr_n81664320)
print v(xbgr.mr_n81664432)
print v(xbgr.mr_n81664752)
print v(xbgr.mr_n81664864)
print v(xbgr.mr_n81665296)
print v(xbgr.mr_n81665728)
print v(xbgr.mr_n81666048)
print v(xbgr.mr_n81666160)
print v(xbgr.mr_n81666480)
print v(xbgr.mr_n81666592)
print v(xbgr.mr_n81666912)
print v(xbgr.mr_n81667024)
print v(xbgr.mr_n81667344)
print v(xbgr.mr_n81667456)
print v(xbgr.mr_n81667776)
print v(xbgr.mr_n81667888)
print v(xbgr.mr_n81668320)
print v(xbgr.mr_n81668640)
print v(xbgr.mr_n81668752)
print v(xbgr.mr_n81669184)
print v(xbgr.mr_n81669504)
print v(xbgr.mr_n81670368)
print v(xbgr.mr_n81671232)
print v(xbgr.mr_n81672096)
print v(xbgr.mr_n81672960)
print v(xbgr.mr_n81673072)
print v(xbgr.mr_n81673392)
print v(xbgr.mr_n81673504)
print v(xbgr.mr_n81673824)
print v(xbgr.mr_n81673936)
print v(xbgr.mr_n81674256)
print v(xbgr.mr_n81674368)
print v(xbgr.mr_n81674688)
print v(xbgr.mr_n81675552)
print v(xbgr.mr_n81676416)
print v(xbgr.mr_n81676528)
print v(xbgr.mr_n81676848)
print v(xbgr.mr_n81676960)
print v(xbgr.mr_n81677392)
print v(xbgr.mr_n81677824)
print v(xbgr.mr_n81678144)
print v(xbgr.mr_n81678256)
print v(xbgr.mr_n81678576)
print v(xbgr.mr_n81678688)
print v(xbgr.mr_n81679008)
print v(xbgr.mr_n81679120)
print v(xbgr.mr_n81679440)
print v(xbgr.mr_n81679552)
print v(xbgr.mr_n81679872)
print v(xbgr.mr_n81679984)
print v(xbgr.mr_n81680416)
print v(xbgr.mr_n81680736)
print v(xbgr.mr_n81680848)
print v(xbgr.mr_n81681280)
print v(xbgr.mr_n81681600)
print v(xbgr.mr_n81681712)
print v(xbgr.mr_n81682144)
print v(xbgr.mr_n81682464)
print v(xbgr.mr_n81682576)
print v(xbgr.mr_n81683008)
print v(xbgr.mr_n81683328)
print v(xbgr.mr_n81684192)
print v(xbgr.mr_n81685056)
print v(xbgr.mr_n81685920)
print v(xbgr.mr_n81686784)
print v(xbgr.mr_n81687648)
print v(xbgr.mr_n81688512)
print v(xbgr.mr_n81688624)
print v(xbgr.mr_n81688944)
print v(xbgr.mr_n81689056)
print v(xbgr.mr_n81689376)
print v(xbgr.mr_n81689488)
print v(xbgr.mr_n81689808)
print v(xbgr.mr_n81689920)
print v(xbgr.mr_n81690240)
print v(xbgr.mr_n81690352)
print v(xbgr.mr_n81690672)
print v(xbgr.mr_n81690784)
print v(xbgr.mr_n81691104)
print v(xbgr.mr_n81691216)
print v(xbgr.mr_n81691536)
print v(xbgr.mr_n81691648)
print v(xbgr.mr_n81691968)
print v(xbgr.mr_n81692080)
print v(xbgr.mr_n81692400)
print v(xbgr.mr_n81692512)
print v(xbgr.mr_n81692944)
print v(xbgr.mr_n81693376)
print v(xbgr.mr_n81693696)
print v(xbgr.mr_n81694560)
print v(xbgr.mr_n81695424)
print v(xbgr.mr_n81695536)
print v(xbgr.mr_n81695856)
print v(xbgr.mr_n81695968)
print v(xbgr.mr_n81696288)
print v(xbgr.mr_n81696400)
print v(xbgr.mr_n81696720)
print v(xbgr.mr_n81696832)
print v(xbgr.mr_n81697152)
print v(xbgr.mr_n81697264)
print v(xbgr.mr_n81697584)
print v(xbgr.mr_n81697696)
print v(xbgr.mr_n81698016)
print v(xbgr.mr_n81698128)
print v(xbgr.mr_n81698448)
print v(xbgr.mr_n81698560)
print v(xbgr.mr_n81698992)
print v(xbgr.mr_n81699424)
print v(xbgr.mr_n81699744)
print v(xbgr.mr_n81699856)
print v(xbgr.mr_n81700176)
print v(xbgr.mr_n81700288)
print v(xbgr.mr_n81700608)
print v(xbgr.mr_n81700720)
print v(xbgr.mr_n81701040)
print v(xbgr.mr_n81701152)
print v(xbgr.mr_n81701472)
print v(xbgr.mr_n81701584)
print v(xbgr.mr_n81701904)
print v(xbgr.mr_n81702016)
print v(xbgr.mr_n81702336)
print v(xbgr.mr_n81703200)
print v(xbgr.mr_n81704064)
print v(xbgr.mr_n81704928)
print v(xbgr.mr_n81705792)
print v(xbgr.mr_n81705904)
print v(xbgr.mr_n81706336)
print v(xbgr.mr_n81706656)
print v(xbgr.mr_n81706768)
print v(xbgr.mr_n81707088)
print v(xbgr.mr_n81707200)
print v(xbgr.mr_n81707520)
print v(xbgr.mr_n81707632)
print v(xbgr.mr_n81707952)
print v(xbgr.mr_n81708064)
print v(xbgr.mr_n81708384)
print v(xbgr.mr_n81708496)
print v(xbgr.mr_n81708816)
print v(xbgr.mr_n81708928)
print v(xbgr.mr_n81709248)
print v(xbgr.mr_n81709360)
print v(xbgr.mr_n81709792)
print v(xbgr.mr_n81710112)
print v(xbgr.mr_n81710976)
print v(xbgr.mr_n81711088)
print v(xbgr.mr_n81711408)
print v(xbgr.mr_n81711520)
print v(xbgr.mr_n81711840)
print v(xbgr.mr_n81711952)
print v(xbgr.mr_n81712272)
print v(xbgr.mr_n81712384)
print v(xbgr.mr_n81712704)
print v(xbgr.mr_n81712816)
print v(xbgr.mr_n81713248)
print v(xbgr.mr_n81713568)
print v(xbgr.mr_n81713680)
print v(xbgr.mr_n81714112)
print v(xbgr.mr_n81714432)
print v(xbgr.mr_n81715296)
print v(xbgr.mr_n81716160)
print v(xbgr.mr_n81717024)
print v(xbgr.mr_n81717888)
print v(xbgr.mr_n81718000)
print v(xbgr.mr_n81718320)
print v(xbgr.mr_n81718432)
print v(xbgr.mr_n81718752)
print v(xbgr.mr_n81718864)
print v(xbgr.mr_n81719184)
print v(xbgr.mr_n81719296)
print v(xbgr.mr_n81719616)
print v(xbgr.mr_n81719728)
print v(xbgr.mr_n81720048)
print v(xbgr.mr_n81720160)
print v(xbgr.mr_n81720480)
print v(xbgr.mr_n81721344)
print v(xbgr.mr_n81722208)
print v(xbgr.mr_n81722320)
print v(xbgr.mr_n81722640)
print v(xbgr.mr_n81722752)
print v(xbgr.mr_n81723184)
print v(xbgr.mr_n81723616)
print v(xbgr.mr_n81723936)
print v(xbgr.mr_n81724048)
print v(xbgr.mr_n81724368)
print v(xbgr.mr_n81724480)
print v(xbgr.mr_n81724800)
print v(xbgr.mr_n81724912)
print v(xbgr.mr_n81725232)
print v(xbgr.mr_n81725344)
print v(xbgr.mr_n81725664)
print v(xbgr.mr_n81726528)
print v(xbgr.mr_n81727392)
print v(xbgr.mr_n81728256)
print v(xbgr.mr_n81729120)
print v(xbgr.mr_n81729984)
print v(xbgr.mr_n81730096)
print v(xbgr.mr_n81730416)
print v(xbgr.mr_n81730528)
print v(xbgr.mr_n81730848)
print v(xbgr.mr_n81730960)
print v(xbgr.mr_n81731280)
print v(xbgr.mr_n81731392)
print v(xbgr.mr_n81731712)
print v(xbgr.mr_n81731824)
print v(xbgr.mr_n81732256)
print v(xbgr.mr_n81732576)
print v(xbgr.mr_n81732688)
print v(xbgr.mr_n81733120)
print v(xbgr.mr_n81733440)
print v(xbgr.mr_n81733552)
print v(xbgr.mr_n81733984)
print v(xbgr.mr_n81734304)
print v(xbgr.mr_n81734416)
print v(xbgr.mr_n81734848)
print v(xbgr.mr_n81735168)
print v(xbgr.mr_n81736032)
print v(xbgr.mr_n81736144)
print v(xbgr.mr_n81736464)
print v(xbgr.mr_n81736576)
print v(xbgr.mr_n81736896)
print v(xbgr.mr_n81737008)
print v(xbgr.mr_n81737328)
print v(xbgr.mr_n81737440)
print v(xbgr.mr_n81737760)
print v(xbgr.mr_n81738624)
print v(xbgr.mr_n81739488)
print v(xbgr.mr_n81740352)
print v(xbgr.mr_n81741216)
print v(xbgr.mr_n81742080)
print v(xbgr.mr_n81742192)
print v(xbgr.mr_n81742512)
print v(xbgr.mr_n81742624)
print v(xbgr.mr_n81742944)
print v(xbgr.mr_n81743056)
print v(xbgr.mr_n81743376)
print v(xbgr.mr_n81743488)
print v(xbgr.mr_n81743920)
print v(xbgr.mr_n81744352)
print v(xbgr.mr_n81744672)
print v(xbgr.mr_n81744784)
print v(xbgr.mr_n81745104)
print v(xbgr.mr_n81745216)
print v(xbgr.mr_n81745536)
print v(xbgr.mr_n81746400)
print v(xbgr.mr_n81746512)
print v(xbgr.mr_n81746832)
print v(xbgr.mr_n81746944)
print v(xbgr.mr_n81747264)
print v(xbgr.mr_n81748128)
print v(xbgr.mr_n81748992)
print v(xbgr.mr_n81749104)
print v(xbgr.mr_n81749424)
print v(xbgr.mr_n81749536)
print v(xbgr.mr_n81749856)
print v(xbgr.mr_n81750720)
print v(xbgr.mr_n81751584)
print v(xbgr.mr_n81752448)
print v(xbgr.mr_n81752560)
print v(xbgr.mr_n81752880)
print v(xbgr.mr_n81752992)
print v(xbgr.mr_n81753312)
print v(xbgr.mr_n81753424)
print v(xbgr.mr_n81753744)
print v(xbgr.mr_n81753856)
print v(xbgr.mr_n81754176)
print v(xbgr.mr_n81754288)
print v(xbgr.mr_n81754608)
print v(xbgr.mr_n81754720)
print v(xbgr.mr_n81755040)
print v(xbgr.mr_n81755152)
print v(xbgr.mr_n81755472)
print v(xbgr.mr_n81755584)
print v(xbgr.mr_n81755904)
print v(xbgr.mr_n81756016)
print v(xbgr.mr_n81756336)
print v(xbgr.mr_n81756448)
print v(xbgr.mr_n81756768)
print v(xbgr.mr_n81756880)
print v(xbgr.mr_n81757200)
print v(xbgr.mr_n81757312)
print v(xbgr.mr_n81757744)
print v(xbgr.mr_n81758064)
print v(xbgr.mr_n81758176)
print v(xbgr.mr_n81758608)
print v(xbgr.mr_n81758928)
print v(xbgr.mr_n81759040)
print v(xbgr.mr_n81759472)
print v(xbgr.mr_n81759792)
print v(xbgr.mr_n81760656)
print v(xbgr.mr_n81761520)
print v(xbgr.mr_n81762384)
print v(xbgr.mr_n81762496)
print v(xbgr.mr_n81762816)
print v(xbgr.mr_n81762928)
print v(xbgr.mr_n81763248)
print v(xbgr.mr_n81764112)
print v(xbgr.mr_n81764976)
print v(xbgr.mr_n81765840)
print v(xbgr.mr_n81765952)
print v(xbgr.mr_n81766272)
print v(xbgr.mr_n81766384)
print v(xbgr.mr_n81766704)
print v(xbgr.mr_n81766816)
print v(xbgr.mr_n81767136)
print v(xbgr.mr_n81767248)
print v(xbgr.mr_n81767568)
print v(xbgr.mr_n81767680)
print v(xbgr.mr_n81768000)
print v(xbgr.mr_n81768112)
print v(xbgr.mr_n81768432)
print v(xbgr.mr_n81768544)
print v(xbgr.mr_n81768864)
print v(xbgr.mr_n81768976)
print v(xbgr.mr_n81769296)
print v(xbgr.mr_n81769408)
print v(xbgr.mr_n81769728)
print v(xbgr.mr_n81769840)
print v(xbgr.mr_n81770160)
print v(xbgr.mr_n81770272)
print v(xbgr.mr_n81770592)
print v(xbgr.mr_n81770704)
print v(xbgr.mr_n81771024)
print v(xbgr.mr_n81771136)
print v(xbgr.mr_n81771568)
print v(xbgr.mr_n81771888)
print v(xbgr.mr_n81772752)
print v(xbgr.mr_n81773616)
print v(xbgr.mr_n81774480)
print v(xbgr.mr_n81774592)
print v(xbgr.mr_n81775024)
print v(xbgr.mr_n81775344)
print v(xbgr.mr_n81775456)
print v(xbgr.mr_n81775888)
print v(xbgr.mr_n81776208)
print v(xbgr.mr_n81776320)
print v(xbgr.mr_n81776640)
print v(xbgr.mr_n81776752)
print v(xbgr.mr_n81777072)
print v(xbgr.mr_n81777184)
print v(xbgr.mr_n81777616)
print v(xbgr.mr_n81778048)
print v(xbgr.mr_n81778480)
print v(xbgr.mr_n81778800)
print v(xbgr.mr_n81779664)
print v(xbgr.mr_n81780528)
print v(xbgr.mr_n81781392)
print v(xbgr.mr_n81782256)
print v(xbgr.mr_n81783120)
print v(xbgr.mr_n81783984)
print v(xbgr.mr_n81784096)
print v(xbgr.mr_n81784416)
print v(xbgr.mr_n81784528)
print v(xbgr.mr_n81784848)
print v(xbgr.mr_n81784960)
print v(xbgr.mr_n81785280)
print v(xbgr.mr_n81785392)
print v(xbgr.mr_n81785712)
print v(xbgr.mr_n81785824)
print v(xbgr.mr_n81786144)
print v(xbgr.mr_n81786256)
print v(xbgr.mr_n81786576)
print v(xbgr.mr_n81787440)
print v(xbgr.mr_n81788304)
print v(xbgr.mr_n81789280)
print v(xbgr.mr_n81789712)
print v(xbgr.mr_n81790144)
print v(xbgr.mr_n81790464)
print v(xbgr.mr_n81790576)
print v(xbgr.mr_n81790896)
print v(xbgr.mr_n81791008)
print v(xbgr.mr_n81791328)
print v(xbgr.mr_n81791440)
print v(xbgr.mr_n81791872)
print v(xbgr.mr_n81792192)
print v(xbgr.mr_n81792304)
print v(xbgr.mr_n81792624)
print v(xbgr.mr_n81792736)
print v(xbgr.mr_n81793168)
print v(xbgr.mr_n81793488)
print v(xbgr.mr_n81793600)
print v(xbgr.mr_n81794032)
print v(xbgr.mr_n81794352)
print v(xbgr.mr_n81794464)
print v(xbgr.mr_n81794896)
print v(xbgr.mr_n81795216)
print v(xbgr.mr_n81796080)
print v(xbgr.mr_n81796944)
print v(xbgr.mr_n81797056)
print v(xbgr.mr_n81797376)
print v(xbgr.mr_n81797488)
print v(xbgr.mr_n81797808)
print v(xbgr.mr_n81797920)
print v(xbgr.mr_n81798240)
print v(xbgr.mr_n81798352)
print v(xbgr.mr_n81798784)
print v(xbgr.mr_n81799104)
print v(xbgr.mr_n81799968)
print v(xbgr.mr_n81800080)
print v(xbgr.mr_n81800400)
print v(xbgr.mr_n81800512)
print v(xbgr.mr_n81800832)
print v(xbgr.mr_n81800944)
print v(xbgr.mr_n81801264)
print v(xbgr.mr_n81802128)
print v(xbgr.mr_n81802560)
print v(xbgr.mr_n81803424)
print v(xbgr.mr_n81803536)
print v(xbgr.mr_n81803856)
print v(xbgr.mr_n81803968)
print v(xbgr.mr_n81804288)
print v(xbgr.mr_n81804400)
print v(xbgr.mr_n81804720)
print v(xbgr.mr_n81804832)
print v(xbgr.mr_n81805152)
print v(xbgr.mr_n81805264)
print v(xbgr.mr_n81805696)
print v(xbgr.mr_n81806448)
print v(xbgr.mr_n81807312)
print v(xbgr.mr_n81807744)
print v(xbgr.mr_n81807856)
print v(xbgr.mr_n81808176)
print v(xbgr.mr_n81808608)
print v(xbgr.mr_n81809472)
print v(xbgr.mr_n81810336)
print v(xbgr.mr_n81811200)
print v(xbgr.mr_n81812064)
print v(xbgr.mr_n81813360)
print v(xbgr.mr_n81814224)
print v(xbgr.mr_n81815200)
print v(xbgr.mr_n81815520)
print v(xbgr.mr_n81815632)
print v(xbgr.mr_n81816064)
print v(xbgr.mr_n81816384)
print v(xbgr.mr_n81817248)
print v(xbgr.mr_n81817360)
print v(xbgr.mr_n81817680)
print v(xbgr.mr_n81817792)
print v(xbgr.mr_n81818224)
print v(xbgr.mr_n81818544)
print v(xbgr.mr_n81818656)
print v(xbgr.mr_n81818976)
print v(xbgr.mr_n81819088)
print v(xbgr.mr_n81819408)
print v(xbgr.mr_n81819520)
print v(xbgr.mr_n81819840)
print v(xbgr.mr_n81819952)
print v(xbgr.mr_n81820384)
print v(xbgr.mr_n81820704)
print v(xbgr.mr_n81820816)
print v(xbgr.mr_n81821136)
print v(xbgr.mr_n81821248)
print v(xbgr.mr_n81821568)
print v(xbgr.mr_n81822432)
print v(xbgr.mr_n81822544)
print v(xbgr.mr_n81823296)
print v(xbgr.mr_n81823408)
print v(xbgr.mr_n81823728)
print v(xbgr.mr_n81823840)
print v(xbgr.mr_n81824160)
print v(xbgr.mr_n81824272)
print v(xbgr.mr_n81824592)
print v(xbgr.mr_n81824704)
print v(xbgr.mr_n81825024)
print v(xbgr.mr_n81825136)
print v(xbgr.mr_n81825456)
print v(xbgr.mr_n81825568)
print v(xbgr.mr_n81825888)
print v(xbgr.mr_n81826000)
print v(xbgr.mr_n81826320)
print v(xbgr.mr_n81826432)
print v(xbgr.mr_n81826752)
print v(xbgr.mr_n81826864)
print v(xbgr.mr_n81827184)
print v(xbgr.mr_n81827296)
print v(xbgr.mr_n81827616)
print v(xbgr.mr_n81827728)
print v(xbgr.mr_n81828048)
print v(xbgr.mr_n81828160)
print v(xbgr.mr_n81828480)
print v(xbgr.mr_n81828592)
print v(xbgr.mr_n81829024)
print v(xbgr.mr_n81829344)
print v(xbgr.mr_n81829456)
print v(xbgr.mr_n81829888)
print v(xbgr.mr_n81830208)
print v(xbgr.mr_n81830320)
print v(xbgr.mr_n81830752)
print v(xbgr.mr_n81831072)
print v(xbgr.mr_n81831936)
print v(xbgr.mr_n81832800)
print v(xbgr.mr_n81833664)
print v(xbgr.mr_n81834528)
print v(xbgr.mr_n81835392)
print v(xbgr.mr_n81836256)
print v(xbgr.mr_n81836368)
print v(xbgr.mr_n81836688)
print v(xbgr.mr_n81836800)
print v(xbgr.mr_n81837120)
print v(xbgr.mr_n81837232)
print v(xbgr.mr_n81837552)
print v(xbgr.mr_n81837664)
print v(xbgr.mr_n81837984)
print v(xbgr.mr_n81838848)
print v(xbgr.mr_n81839712)
print v(xbgr.mr_n81840576)
print v(xbgr.mr_n81840688)
print v(xbgr.mr_n81841008)
print v(xbgr.mr_n81841120)
print v(xbgr.mr_n81841440)
print v(xbgr.mr_n81841552)
print v(xbgr.mr_n81841984)
print v(xbgr.mr_n81842416)
print v(xbgr.mr_n81842848)
print v(xbgr.mr_n81843168)
print v(xbgr.mr_n81843280)
print v(xbgr.mr_n81843600)
print v(xbgr.mr_n81843712)
print v(xbgr.mr_n81844032)
print v(xbgr.mr_n81844144)
print v(xbgr.mr_n81844464)
print v(xbgr.mr_n81844576)
print v(xbgr.mr_n81844896)
print v(xbgr.mr_n81845008)
print v(xbgr.mr_n81845328)
print v(xbgr.mr_n81845440)
print v(xbgr.mr_n81845760)
print v(xbgr.mr_n81845872)
print v(xbgr.mr_n81846304)
print v(xbgr.mr_n81846624)
print v(xbgr.mr_n81846736)
print v(xbgr.mr_n81847168)
print v(xbgr.mr_n81847488)
print v(xbgr.mr_n81847600)
print v(xbgr.mr_n81848032)
print v(xbgr.mr_n81848352)
print v(xbgr.mr_n81849216)
print v(xbgr.mr_n81850080)
print v(xbgr.mr_n81850944)
print v(xbgr.mr_n81851808)
print v(xbgr.mr_n81852672)
print v(xbgr.mr_n81853536)
print v(xbgr.mr_n81853648)
print v(xbgr.mr_n81853968)
print v(xbgr.mr_n81854080)
print v(xbgr.mr_n81854400)
print v(xbgr.mr_n81854512)
print v(xbgr.mr_n81854832)
print v(xbgr.mr_n81854944)
print v(xbgr.mr_n81855264)
print v(xbgr.mr_n81856128)
print v(xbgr.mr_n81856992)
print v(xbgr.mr_n81857856)
print v(xbgr.mr_n81857968)
print v(xbgr.mr_n81858288)
print v(xbgr.mr_n81858400)
print v(xbgr.mr_n81858720)
print v(xbgr.mr_n81858832)
print v(xbgr.mr_n81859264)
print v(xbgr.mr_n81859584)
print v(xbgr.mr_n81859696)
print v(xbgr.mr_n81860128)
print v(xbgr.mr_n81860448)
print v(xbgr.mr_n81860560)
print v(xbgr.mr_n81860992)
print v(xbgr.mr_n81861312)
print v(xbgr.mr_n81861424)
print v(xbgr.mr_n81861744)
print v(xbgr.mr_n81861856)
print v(xbgr.mr_n81862176)
print v(xbgr.mr_n81862288)
print v(xbgr.mr_n81862720)
print v(xbgr.mr_n81863040)
print v(xbgr.mr_n81863904)
print v(xbgr.mr_n81864768)
print v(xbgr.mr_n81865632)
print v(xbgr.mr_n81865744)
print v(xbgr.mr_n81866064)
print v(xbgr.mr_n81866176)
print v(xbgr.mr_n81866496)
print v(xbgr.mr_n81867360)
print v(xbgr.mr_n81868224)
print v(xbgr.mr_n81869088)
print v(xbgr.mr_n81869952)
print v(xbgr.mr_n81870064)
print v(xbgr.mr_n81870384)
print v(xbgr.mr_n81870496)
print v(xbgr.mr_n81870816)
print v(xbgr.mr_n81871680)
print v(xbgr.mr_n81872224)
print v(xbgr.mr_n81872544)
print v(xbgr.mr_n81872656)
print v(xbgr.mr_n81872976)
print v(xbgr.mr_n81873088)
print v(xbgr.mr_n81873408)
print v(xbgr.mr_n81873520)
print v(xbgr.mr_n81873840)
print v(xbgr.mr_n81873952)
print v(xbgr.mr_n81874384)
print v(xbgr.mr_n81875136)
print v(xbgr.mr_n81876000)
print v(xbgr.mr_n81876864)
print v(xbgr.mr_n81877728)
print v(xbgr.mr_n81877840)
print v(xbgr.mr_n81878160)
print v(xbgr.mr_n81878272)
print v(xbgr.mr_n81878592)
print v(xbgr.mr_n81878704)
print v(xbgr.mr_n81879024)
print v(xbgr.mr_n81879136)
print v(xbgr.mr_n81879456)
print v(xbgr.mr_n81879568)
print v(xbgr.mr_n81879888)
print v(xbgr.mr_n81880000)
print v(xbgr.mr_n81880320)
print v(xbgr.mr_n81880432)
print v(xbgr.mr_n81880864)
print v(xbgr.mr_n81881184)
print v(xbgr.mr_n81881296)
print v(xbgr.mr_n81881616)
print v(xbgr.mr_n81881728)
print v(xbgr.mr_n81882048)
print v(xbgr.mr_n81882160)
print v(xbgr.mr_n81882480)
print v(xbgr.mr_n81882592)
print v(xbgr.mr_n81882912)
print v(xbgr.mr_n81883024)
print v(xbgr.mr_n81883456)
print v(xbgr.mr_n81883776)
print v(xbgr.mr_n81884640)
print v(xbgr.mr_n81884752)
print v(xbgr.mr_n81885072)
print v(xbgr.mr_n81885184)
print v(xbgr.mr_n81885616)
print v(xbgr.mr_n81886048)
print v(xbgr.mr_n81886368)
print v(xbgr.mr_n81886480)
print v(xbgr.mr_n81886800)
print v(xbgr.mr_n81886912)
print v(xbgr.mr_n81887232)
print v(xbgr.mr_n81887344)
print v(xbgr.mr_n81887664)
print v(xbgr.mr_n81887776)
print v(xbgr.mr_n81888096)
print v(xbgr.mr_n81888208)
print v(xbgr.mr_n81888640)
print v(xbgr.mr_n81888960)
print v(xbgr.mr_n81889072)
print v(xbgr.mr_n81889504)
print v(xbgr.mr_n81889824)
print v(xbgr.mr_n81890688)
print v(xbgr.mr_n81891552)
print v(xbgr.mr_n81892416)
print v(xbgr.mr_n81893280)
print v(xbgr.mr_n81893392)
print v(xbgr.mr_n81893712)
print v(xbgr.mr_n81893824)
print v(xbgr.mr_n81894144)
print v(xbgr.mr_n81894256)
print v(xbgr.mr_n81894576)
print v(xbgr.mr_n81894688)
print v(xbgr.mr_n81895008)
print v(xbgr.mr_n81895872)
print v(xbgr.mr_n81896736)
print v(xbgr.mr_n81896848)
print v(xbgr.mr_n81897168)
print v(xbgr.mr_n81897280)
print v(xbgr.mr_n81897712)
print v(xbgr.mr_n81898144)
print v(xbgr.mr_n81898464)
print v(xbgr.mr_n81898576)
print v(xbgr.mr_n81898896)
print v(xbgr.mr_n81899008)
print v(xbgr.mr_n81899328)
print v(xbgr.mr_n81899440)
print v(xbgr.mr_n81899760)
print v(xbgr.mr_n81899872)
print v(xbgr.mr_n81900192)
print v(xbgr.mr_n81901056)
print v(xbgr.mr_n81901920)
print v(xbgr.mr_n81902784)
print v(xbgr.mr_n81903648)
print v(xbgr.mr_n81904512)
print v(xbgr.mr_n81904624)
print v(xbgr.mr_n81905056)
print v(xbgr.mr_n81905376)
print v(xbgr.mr_n81905488)
print v(xbgr.mr_n81905920)
print v(xbgr.mr_n81906240)
print v(xbgr.mr_n81906352)
print v(xbgr.mr_n81906784)
print v(xbgr.mr_n81907104)
print v(xbgr.mr_n81907216)
print v(xbgr.mr_n81907536)
print v(xbgr.mr_n81907648)
print v(xbgr.mr_n81907968)
print v(xbgr.mr_n81908080)
print v(xbgr.mr_n81908400)
print v(xbgr.mr_n81908512)
print v(xbgr.mr_n81908832)
print v(xbgr.mr_n81908944)
print v(xbgr.mr_n81909264)
print v(xbgr.mr_n81909376)
print v(xbgr.mr_n81909696)
print v(xbgr.mr_n81909808)
print v(xbgr.mr_n81910128)
print v(xbgr.mr_n81910240)
print v(xbgr.mr_n81910560)
print v(xbgr.mr_n81910672)
print v(xbgr.mr_n81910992)
print v(xbgr.mr_n81911104)
print v(xbgr.mr_n81911424)
print v(xbgr.mr_n81911536)
print v(xbgr.mr_n81911856)
print v(xbgr.mr_n81911968)
print v(xbgr.mr_n81912288)
print v(xbgr.mr_n81913152)
print v(xbgr.mr_n81914016)
print v(xbgr.mr_n81914880)
print v(xbgr.mr_n81914992)
print v(xbgr.mr_n81915424)
print v(xbgr.mr_n81915744)
print v(xbgr.mr_n81915856)
print v(xbgr.mr_n81916176)
print v(xbgr.mr_n81916288)
print v(xbgr.mr_n81916608)
print v(xbgr.mr_n81916720)
print v(xbgr.mr_n81917040)
print v(xbgr.mr_n81917152)
print v(xbgr.mr_n81917584)
print v(xbgr.mr_n81918016)
print v(xbgr.mr_n81918448)
print v(xbgr.mr_n81918880)
print v(xbgr.mr_n81919200)
print v(xbgr.mr_n81919312)
print v(xbgr.mr_n81919744)
print v(xbgr.mr_n81920064)
print v(xbgr.mr_n81920928)
print v(xbgr.mr_n81921040)
print v(xbgr.mr_n81921360)
print v(xbgr.mr_n81921472)
print v(xbgr.mr_n81921792)
print v(xbgr.mr_n81921904)
print v(xbgr.mr_n81922224)
print v(xbgr.mr_n81923200)
print v(xbgr.mr_n81923632)
print v(xbgr.mr_n81924064)
print v(xbgr.mr_n81924384)
print v(xbgr.mr_n81925248)
print v(xbgr.mr_n81925360)
print v(xbgr.mr_n81925680)
print v(xbgr.mr_n81925792)
print v(xbgr.mr_n81926112)
print v(xbgr.mr_n81926224)
print v(xbgr.mr_n81926544)
print v(xbgr.mr_n81926656)
print v(xbgr.mr_n81926976)
print v(xbgr.mr_n81927088)
print v(xbgr.mr_n81927408)
print v(xbgr.mr_n81927520)
print v(xbgr.mr_n81927840)
print v(xbgr.mr_n81927952)
print v(xbgr.mr_n81928272)
print v(xbgr.mr_n81928384)
print v(xbgr.mr_n81928704)
print v(xbgr.mr_n81929568)
print v(xbgr.mr_n81930432)
print v(xbgr.mr_n81931296)
print v(xbgr.mr_n81932160)
print v(xbgr.mr_n81933024)
print v(xbgr.mr_n81933888)
print v(xbgr.mr_n81934752)
print v(xbgr.mr_n81935616)
print v(xbgr.mr_n81936480)
print v(xbgr.mr_n81937344)
print v(xbgr.mr_n81938208)
print v(xbgr.mr_n81939072)
print v(xbgr.mr_n81939184)
print v(xbgr.mr_n81939504)
print v(xbgr.mr_n81939616)
print v(xbgr.mr_n81939936)
print v(xbgr.mr_n81940048)
print v(xbgr.mr_n81940368)
print v(xbgr.mr_n81940480)
print v(xbgr.mr_n81940800)
print v(xbgr.mr_n81940912)
print v(xbgr.mr_n81941344)
print v(xbgr.mr_n81941664)
print v(xbgr.mr_n81941776)
print v(xbgr.mr_n81942208)
print v(xbgr.mr_n81942528)
print v(xbgr.mr_n81943392)
print v(xbgr.mr_n81944256)
print v(xbgr.mr_n81945120)
print v(xbgr.mr_n81945984)
print v(xbgr.mr_n81946096)
print v(xbgr.mr_n81946416)
print v(xbgr.mr_n81946528)
print v(xbgr.mr_n81946848)
print v(xbgr.mr_n81946960)
print v(xbgr.mr_n81947280)
print v(xbgr.mr_n81947392)
print v(xbgr.mr_n81947712)
print v(xbgr.mr_n81947824)
print v(xbgr.mr_n81948144)
print v(xbgr.mr_n81948256)
print v(xbgr.mr_n81948576)
print v(xbgr.mr_n81948688)
print v(xbgr.mr_n81949008)
print v(xbgr.mr_n81949872)
print v(xbgr.mr_n81950736)
print v(xbgr.mr_n81950848)
print v(xbgr.mr_n81951168)
print v(xbgr.mr_n81951280)
print v(xbgr.mr_n81951712)
print v(xbgr.mr_n81952144)
print v(xbgr.mr_n81952464)
print v(xbgr.mr_n81952576)
print v(xbgr.mr_n81952896)
print v(xbgr.mr_n81953008)
print v(xbgr.mr_n81953328)
print v(xbgr.mr_n81953440)
print v(xbgr.mr_n81953760)
print v(xbgr.mr_n81953872)
print v(xbgr.mr_n81954192)
print v(xbgr.mr_n81954304)
print v(xbgr.mr_n81954736)
print v(xbgr.mr_n81955056)
print v(xbgr.mr_n81955168)
print v(xbgr.mr_n81955600)
print v(xbgr.mr_n81955920)
print v(xbgr.mr_n81956032)
print v(xbgr.mr_n81956352)
print v(xbgr.mr_n81957216)
print v(xbgr.mr_n81958080)
print v(xbgr.mr_n81958944)
print v(xbgr.mr_n81959808)
print v(xbgr.mr_n81959920)
print v(xbgr.mr_n81960240)
print v(xbgr.mr_n81960352)
print v(xbgr.mr_n81960672)
print v(xbgr.mr_n81960784)
print v(xbgr.mr_n81961104)
print v(xbgr.mr_n81961216)
print v(xbgr.mr_n81961536)
print v(xbgr.mr_n81961648)
print v(xbgr.mr_n81961968)
print v(xbgr.mr_n81962080)
print v(xbgr.mr_n81962400)
print v(xbgr.mr_n81963264)
print v(xbgr.mr_n81964128)
print v(xbgr.mr_n81964240)
print v(xbgr.mr_n81964672)
print v(xbgr.mr_n81964992)
print v(xbgr.mr_n81965104)
print v(xbgr.mr_n81965424)
print v(xbgr.mr_n81965536)
print v(xbgr.mr_n81965856)
print v(xbgr.mr_n81965968)
print v(xbgr.mr_n81966288)
print v(xbgr.mr_n81966400)
print v(xbgr.mr_n81966720)
print v(xbgr.mr_n81966832)
print v(xbgr.mr_n81967152)
print v(xbgr.mr_n81967264)
print v(xbgr.mr_n81967696)
print v(xbgr.mr_n81968128)
print v(xbgr.mr_n81968560)
print v(xbgr.mr_n81968992)
print v(xbgr.mr_n81969312)
print v(xbgr.mr_n81969744)
print v(xbgr.mr_n81969856)
print v(xbgr.mr_n81970176)
print v(xbgr.mr_n81970288)
print v(xbgr.mr_n81970608)
print v(xbgr.mr_n81970720)
print v(xbgr.mr_n81971040)
print v(xbgr.mr_n81971152)
print v(xbgr.mr_n81971472)
print v(xbgr.mr_n81971584)
print v(xbgr.mr_n81971904)
print v(xbgr.mr_n81972016)
print v(xbgr.mr_n81972768)
print v(xbgr.mr_n81972880)
print v(xbgr.mr_n81973312)
print v(xbgr.mr_n81973632)
print v(xbgr.mr_n81974064)
print v(xbgr.mr_n81974176)
print v(xbgr.mr_n81974608)
print v(xbgr.mr_n81974928)
print v(xbgr.mr_n81975040)
print v(xbgr.mr_n81975472)
print v(xbgr.mr_n81975792)
print v(xbgr.mr_n81975904)
print v(xbgr.mr_n81976336)
print v(xbgr.mr_n81977088)
print v(xbgr.mr_n81977952)
print v(xbgr.mr_n81978816)
print v(xbgr.mr_n81979680)
print v(xbgr.mr_n81980544)
print v(xbgr.mr_n81981408)
print v(xbgr.mr_n81981520)
print v(xbgr.mr_n81981840)
print v(xbgr.mr_n81981952)
print v(xbgr.mr_n81982272)
print v(xbgr.mr_n81982384)
print v(xbgr.mr_n81982704)
print v(xbgr.mr_n81982816)
print v(xbgr.mr_n81983136)
print v(xbgr.mr_n81984000)
print v(xbgr.mr_n81984864)
print v(xbgr.mr_n81985728)
print v(xbgr.mr_n81985840)
print v(xbgr.mr_n81986160)
print v(xbgr.mr_n81986272)
print v(xbgr.mr_n81986592)
print v(xbgr.mr_n81986704)
print v(xbgr.mr_n81987024)
print v(xbgr.mr_n81987136)
print v(xbgr.mr_n81987456)
print v(xbgr.mr_n81987568)
print v(xbgr.mr_n81987888)
print v(xbgr.mr_n81988000)
print v(xbgr.mr_n81988320)
print v(xbgr.mr_n81988432)
print v(xbgr.mr_n81988752)
print v(xbgr.mr_n81988864)
print v(xbgr.mr_n81989184)
print v(xbgr.mr_n81990048)
print v(xbgr.mr_n81990480)
print v(xbgr.mr_n81991344)
print v(xbgr.mr_n81991776)
print v(xbgr.mr_n81992640)
print v(xbgr.mr_n81993504)
print v(xbgr.mr_n81994800)
print v(xbgr.mr_n81996096)
print v(xbgr.mr_n81996208)
print v(xbgr.mr_n81996528)
print v(xbgr.mr_n81996640)
print v(xbgr.mr_n81997072)
print v(xbgr.mr_n81997392)
print v(xbgr.mr_n81997504)
print v(xbgr.mr_n81997936)
print v(xbgr.mr_n81998256)
print v(xbgr.mr_n81998368)
print v(xbgr.mr_n81998688)
print v(xbgr.mr_n81998800)
print v(xbgr.mr_n81999120)
print v(xbgr.mr_n81999232)
print v(xbgr.mr_n81999664)
print v(xbgr.mr_n81999984)
print v(xbgr.mr_n82000096)
print v(xbgr.mr_n82000528)
print v(xbgr.mr_n82000848)
print v(xbgr.mr_n82000960)
print v(xbgr.mr_n82001392)
print v(xbgr.mr_n82001712)
print v(xbgr.mr_n82001824)
print v(xbgr.mr_n82002144)
print v(xbgr.mr_n82002576)
print v(xbgr.mr_n82002688)
print v(xbgr.mr_n82003008)
print v(xbgr.mr_n82003120)
print v(xbgr.mr_n82003440)
print v(xbgr.mr_n82003552)
print v(xbgr.mr_n82003872)
print v(xbgr.mr_n82003984)
print v(xbgr.mr_n82004736)
print v(xbgr.mr_n82005600)
print v(xbgr.mr_n82006464)
print v(xbgr.mr_n82006576)
print v(xbgr.mr_n82006896)
print v(xbgr.mr_n82007008)
print v(xbgr.mr_n82007328)
print v(xbgr.mr_n82007440)
print v(xbgr.mr_n82007760)
print v(xbgr.mr_n82007872)
print v(xbgr.mr_n82008624)
print v(xbgr.mr_n82009056)
print v(xbgr.mr_n82009920)
print v(xbgr.mr_n82011216)
print v(xbgr.mr_n82011648)
print v(xbgr.mr_n82012512)
print v(xbgr.mr_n82012624)
print v(xbgr.mr_n82012944)
print v(xbgr.mr_n82013056)
print v(xbgr.mr_n82013376)
print v(xbgr.mr_n82014240)
print v(xbgr.mr_n82014672)
print v(xbgr.mr_n82014784)
print v(xbgr.mr_n82015104)
print v(xbgr.mr_n82015968)
print v(xbgr.mr_n82016832)
print v(xbgr.mr_n82017696)
print v(xbgr.mr_n82018560)
print v(xbgr.mr_n82018672)
print v(xbgr.mr_n82018992)
print v(xbgr.mr_n82019104)
print v(xbgr.mr_n82019424)
print v(xbgr.mr_n82019536)
print v(xbgr.mr_n82019856)
print v(xbgr.mr_n82019968)
print v(xbgr.mr_n82020720)
print v(xbgr.mr_n82021584)
print v(xbgr.mr_n82022448)
print v(xbgr.mr_n82022560)
print v(xbgr.mr_n82022992)
print v(xbgr.mr_n82023424)
print v(xbgr.mr_n82023856)
print v(xbgr.mr_n82024176)
print v(xbgr.mr_n82024288)
print v(xbgr.mr_n82024608)
print v(xbgr.mr_n82024720)
print v(xbgr.mr_n82025040)
print v(xbgr.mr_n82025152)
print v(xbgr.mr_n82025472)
print v(xbgr.mr_n82025584)
print v(xbgr.mr_n82025904)
print v(xbgr.mr_n82026016)
print v(xbgr.mr_n82026336)
print v(xbgr.mr_n82026448)
print v(xbgr.mr_n82026768)
print v(xbgr.mr_n82026880)
print v(xbgr.mr_n82027200)
print v(xbgr.mr_n82027312)
print v(xbgr.mr_n82028496)
print v(xbgr.mr_n82029040)
print v(xbgr.mr_n82029472)
print v(xbgr.mr_n82029904)
print v(xbgr.mr_n82030656)
print v(xbgr.mr_n82030768)
print v(xbgr.mr_n82031088)
print v(xbgr.mr_n82031200)
print v(xbgr.mr_n82031520)
print v(xbgr.mr_n82031632)
print v(xbgr.mr_n82031952)
print v(xbgr.mr_n82032064)
print v(xbgr.mr_n82032384)
print v(xbgr.mr_n82032496)
print v(xbgr.mr_n82032816)
print v(xbgr.mr_n82032928)
print v(xbgr.mr_n82033360)
print v(xbgr.mr_n82033680)
print v(xbgr.mr_n82033792)
print v(xbgr.mr_n82034112)
print v(xbgr.mr_n82034224)
print v(xbgr.mr_n82034656)
print v(xbgr.mr_n82034976)
print v(xbgr.mr_n82035088)
print v(xbgr.mr_n82035408)
print v(xbgr.mr_n82035520)
print v(xbgr.mr_n82035840)
print v(xbgr.mr_n82035952)
print v(xbgr.mr_n82036272)
print v(xbgr.mr_n82036384)
print v(xbgr.mr_n82036704)
print v(xbgr.mr_n82036816)
print v(xbgr.mr_n82037136)
print v(xbgr.mr_n82037248)
print v(xbgr.mr_n82037568)
print v(xbgr.mr_n82038432)
print v(xbgr.mr_n82038976)
print v(xbgr.mr_n82039296)
print v(xbgr.mr_n82039408)
print v(xbgr.mr_n82039840)
print v(xbgr.mr_n82040160)
print v(xbgr.mr_n82040272)
print v(xbgr.mr_n82041024)
print v(xbgr.mr_n82041888)
print v(xbgr.mr_n82042000)
print v(xbgr.mr_n82042320)
print v(xbgr.mr_n82042432)
print v(xbgr.mr_n82042752)
print v(xbgr.mr_n82042864)
print v(xbgr.mr_n82043184)
print v(xbgr.mr_n82043616)
print v(xbgr.mr_n82044480)
print v(xbgr.mr_n82045776)
print v(xbgr.mr_n82046752)
print v(xbgr.mr_n82047072)
print v(xbgr.mr_n82047184)
print v(xbgr.mr_n82047504)
print v(xbgr.mr_n82047616)
print v(xbgr.mr_n82047936)
print v(xbgr.mr_n82048800)
print v(xbgr.mr_n82048912)
print v(xbgr.mr_n82049232)
print v(xbgr.mr_n82049344)
print v(xbgr.mr_n82049664)
print v(xbgr.mr_n82049776)
print v(xbgr.mr_n82050096)
print v(xbgr.mr_n82050208)
print v(xbgr.mr_n82050528)
print v(xbgr.mr_n82050640)
print v(xbgr.mr_n82050960)
print v(xbgr.mr_n82051504)
print v(xbgr.mr_n82051824)
print v(xbgr.mr_n82053120)
print v(xbgr.mr_n82053984)
print v(xbgr.mr_n82054528)
print v(xbgr.mr_n82054960)
print v(xbgr.mr_n82055712)
print v(xbgr.mr_n82055824)
print v(xbgr.mr_n82056144)
print v(xbgr.mr_n82056256)
print v(xbgr.mr_n82056576)
print v(xbgr.mr_n82056688)
print v(xbgr.mr_n82057008)
print v(xbgr.mr_n82057120)
print v(xbgr.mr_n82057440)
print v(xbgr.mr_n82057552)
print v(xbgr.mr_n82057872)
print v(xbgr.mr_n82057984)
print v(xbgr.mr_n82058416)
print v(xbgr.mr_n82058736)
print v(xbgr.mr_n82058848)
print v(xbgr.mr_n82059168)
print v(xbgr.mr_n82059280)
print v(xbgr.mr_n82059600)
print v(xbgr.mr_n82059712)
print v(xbgr.mr_n82060032)
print v(xbgr.mr_n82060144)
print v(xbgr.mr_n82060464)
print v(xbgr.mr_n82060576)
print v(xbgr.mr_n82060896)
print v(xbgr.mr_n82061008)
print v(xbgr.mr_n82061328)
print v(xbgr.mr_n82061440)
print v(xbgr.mr_n82061760)
print v(xbgr.mr_n82061872)
print v(xbgr.mr_n82062304)
print v(xbgr.mr_n82062736)
print v(xbgr.mr_n82063168)
print v(xbgr.mr_n82063488)
print v(xbgr.mr_n82063600)
print v(xbgr.mr_n82063920)
print v(xbgr.mr_n82064032)
print v(xbgr.mr_n82064352)
print v(xbgr.mr_n82064464)
print v(xbgr.mr_n82064784)
print v(xbgr.mr_n82064896)
print v(xbgr.mr_n82065216)
print v(xbgr.mr_n82065328)
print v(xbgr.mr_n82065760)
print v(xbgr.mr_n82066080)
print v(xbgr.mr_n82066944)
print v(xbgr.mr_n82067808)
print v(xbgr.mr_n82067920)
print v(xbgr.mr_n82068240)
print v(xbgr.mr_n82068352)
print v(xbgr.mr_n82068672)
print v(xbgr.mr_n82068784)
print v(xbgr.mr_n82069104)
print v(xbgr.mr_n82069216)
print v(xbgr.mr_n82069536)
print v(xbgr.mr_n82070512)
print v(xbgr.mr_n82070832)
print v(xbgr.mr_n82070944)
print v(xbgr.mr_n82071264)
print v(xbgr.mr_n82071376)
print v(xbgr.mr_n82071696)
print v(xbgr.mr_n82071808)
print v(xbgr.mr_n82072128)
print v(xbgr.mr_n82072240)
print v(xbgr.mr_n82072560)
print v(xbgr.mr_n82072672)
print v(xbgr.mr_n82072992)
print v(xbgr.mr_n82073856)
print v(xbgr.mr_n82074720)
print v(xbgr.mr_n82075584)
print v(xbgr.mr_n82076448)
print v(xbgr.mr_n82076560)
print v(xbgr.mr_n82076880)
print v(xbgr.mr_n82076992)
print v(xbgr.mr_n82077312)
print v(xbgr.mr_n82078288)
print v(xbgr.mr_n82078720)
print v(xbgr.mr_n82079040)
print v(xbgr.mr_n82079904)
print v(xbgr.mr_n82080768)
print v(xbgr.mr_n82081632)
print v(xbgr.mr_n82082496)
print v(xbgr.mr_n82082608)
print v(xbgr.mr_n82083040)
print v(xbgr.mr_n82083360)
print v(xbgr.mr_n82083472)
print v(xbgr.mr_n82083792)
print v(xbgr.mr_n82083904)
print v(xbgr.mr_n82084224)
print v(xbgr.mr_n82084336)
print v(xbgr.mr_n82084768)
print v(xbgr.mr_n82085088)
print v(xbgr.mr_n82085200)
print v(xbgr.mr_n82085632)
print v(xbgr.mr_n82085952)
print v(xbgr.mr_n82086064)
print v(xbgr.mr_n82086384)
print v(xbgr.mr_n82086496)
print v(xbgr.mr_n82086816)
print v(xbgr.mr_n82086928)
print v(xbgr.mr_n82087248)
print v(xbgr.mr_n82087360)
print v(xbgr.mr_n82087680)
print v(xbgr.mr_n82087792)
print v(xbgr.mr_n82088112)
print v(xbgr.mr_n82088224)
print v(xbgr.mr_n82088656)
print v(xbgr.mr_n82088976)
print v(xbgr.mr_n82089840)
print v(xbgr.mr_n82090384)
print v(xbgr.mr_n82090704)
print v(xbgr.mr_n82090816)
print v(xbgr.mr_n82091136)
print v(xbgr.mr_n82091248)
print v(xbgr.mr_n82091568)
print v(xbgr.mr_n82091680)
print v(xbgr.mr_n82092000)
print v(xbgr.mr_n82092112)
print v(xbgr.mr_n82092432)
print v(xbgr.mr_n82092544)
print v(xbgr.mr_n82092864)
print v(xbgr.mr_n82092976)
print v(xbgr.mr_n82093408)
print v(xbgr.mr_n82093728)
print v(xbgr.mr_n82094592)
print v(xbgr.mr_n82095024)
print v(xbgr.mr_n82095888)
print v(xbgr.mr_n82096752)
print v(xbgr.mr_n82098160)
print v(xbgr.mr_n82099024)
print v(xbgr.mr_n82099456)
print v(xbgr.mr_n82099776)
print v(xbgr.mr_n82100640)
print v(xbgr.mr_n82100752)
print v(xbgr.mr_n82101072)
print v(xbgr.mr_n82101184)
print v(xbgr.mr_n82101504)
print v(xbgr.mr_n82101616)
print v(xbgr.mr_n82101936)
print v(xbgr.mr_n82102048)
print v(xbgr.mr_n82102368)
print v(xbgr.mr_n82102480)
print v(xbgr.mr_n82102800)
print v(xbgr.mr_n82102912)
print v(xbgr.mr_n82103232)
print v(xbgr.mr_n82103344)
print v(xbgr.mr_n82103664)
print v(xbgr.mr_n82104528)
print v(xbgr.mr_n82105504)
print v(xbgr.mr_n82105936)
print v(xbgr.mr_n82106368)
print v(xbgr.mr_n82106688)
print v(xbgr.mr_n82106800)
print v(xbgr.mr_n82107120)
print v(xbgr.mr_n82107232)
print v(xbgr.mr_n82107552)
print v(xbgr.mr_n82108416)
print v(xbgr.mr_n82109280)
print v(xbgr.mr_n82110144)
print v(xbgr.mr_n82110256)
print v(xbgr.mr_n82110576)
print v(xbgr.mr_n82110688)
print v(xbgr.mr_n82111008)
print v(xbgr.mr_n82111872)
print v(xbgr.mr_n82112736)
print v(xbgr.mr_n82113600)
print v(xbgr.mr_n82113712)
print v(xbgr.mr_n82114032)
print v(xbgr.mr_n82114144)
print v(xbgr.mr_n82114464)
print v(xbgr.mr_n82114576)
print v(xbgr.mr_n82114896)
print v(xbgr.mr_n82115008)
print v(xbgr.mr_n82115328)
print v(xbgr.mr_n82116192)
print v(xbgr.mr_n82117056)
print v(xbgr.mr_n82117168)
print v(xbgr.mr_n82117488)
print v(xbgr.mr_n82117600)
print v(xbgr.mr_n82117920)
print v(xbgr.mr_n82118032)
print v(xbgr.mr_n82118352)
print v(xbgr.mr_n82118464)
print v(xbgr.mr_n82118784)
print v(xbgr.mr_n82118896)
print v(xbgr.mr_n82119328)
print v(xbgr.mr_n82119648)
print v(xbgr.mr_n82119760)
print v(xbgr.mr_n82120080)
print v(xbgr.mr_n82120192)
print v(xbgr.mr_n82120512)
print v(xbgr.mr_n82120624)
print v(xbgr.mr_n82120944)
print v(xbgr.mr_n82121056)
print v(xbgr.mr_n82121376)
print v(xbgr.mr_n82122240)
print v(xbgr.mr_n82122352)
print v(xbgr.mr_n82122784)
print v(xbgr.mr_n82123104)
print v(xbgr.mr_n82123216)
print v(xbgr.mr_n82123536)
print v(xbgr.mr_n82123648)
print v(xbgr.mr_n82123968)
print v(xbgr.mr_n82124080)
print v(xbgr.mr_n82124400)
print v(xbgr.mr_n82124512)
print v(xbgr.mr_n82124832)
print v(xbgr.mr_n82124944)
print v(xbgr.mr_n82125264)
print v(xbgr.mr_n82125376)
print v(xbgr.mr_n82125696)
print v(xbgr.mr_n82126128)
print v(xbgr.mr_n82126240)
print v(xbgr.mr_n82126560)
print v(xbgr.mr_n82127104)
print v(xbgr.mr_n82127424)
print v(xbgr.mr_n82127536)
print v(xbgr.mr_n82127968)
print v(xbgr.mr_n82128400)
print v(xbgr.mr_n82128832)
print v(xbgr.mr_n82129264)
print v(xbgr.mr_n82129696)
print v(xbgr.mr_n82130016)
print v(xbgr.mr_n82130128)
print v(xbgr.mr_n82130560)
print v(xbgr.mr_n82130880)
print v(xbgr.mr_n82130992)
print v(xbgr.mr_n82131424)
print v(xbgr.mr_n82131744)
print v(xbgr.mr_n82132608)
print v(xbgr.mr_n82133904)
print v(xbgr.mr_n82134448)
print v(xbgr.mr_n82134768)
print v(xbgr.mr_n82135312)
print v(xbgr.mr_n82135632)
print v(xbgr.mr_n82135744)
print v(xbgr.mr_n82136496)
print v(xbgr.mr_n82136928)
print v(xbgr.mr_n82137792)
print v(xbgr.mr_n82138656)
print v(xbgr.mr_n82139952)
print v(xbgr.mr_n82140816)
print v(xbgr.mr_n82141248)
print v(xbgr.mr_n82141360)
print v(xbgr.mr_n82142112)
print v(xbgr.mr_n82142224)
print v(xbgr.mr_n82142544)
print v(xbgr.mr_n82142656)
print v(xbgr.mr_n82142976)
print v(xbgr.mr_n82143088)
print v(xbgr.mr_n82143840)
print v(xbgr.mr_n82145136)
print v(xbgr.mr_n82146000)
print v(xbgr.mr_n82146864)
print v(xbgr.mr_n82147296)
print v(xbgr.mr_n82147408)
print v(xbgr.mr_n82147728)
print v(xbgr.mr_n82147840)
print v(xbgr.mr_n82148160)
print v(xbgr.mr_n82148272)
print v(xbgr.mr_n82148592)
print v(xbgr.mr_n82148704)
print v(xbgr.mr_n82149456)
print v(xbgr.mr_n82149568)
print v(xbgr.mr_n82149888)
print v(xbgr.mr_n82150000)
print v(xbgr.mr_n82150320)
print v(xbgr.mr_n82150432)
print v(xbgr.mr_n82150752)
print v(xbgr.mr_n82151616)
print v(xbgr.mr_n82151728)
print v(xbgr.mr_n82152048)
print v(xbgr.mr_n82152160)
print v(xbgr.mr_n82152592)
print v(xbgr.mr_n82152912)
print v(xbgr.mr_n82153024)
print v(xbgr.mr_n82153344)
print v(xbgr.mr_n82153456)
print v(xbgr.mr_n82153776)
print v(xbgr.mr_n82153888)
print v(xbgr.mr_n82154320)
print v(xbgr.mr_n82154752)
print v(xbgr.mr_n82155072)
print v(xbgr.mr_n82155184)
print v(xbgr.mr_n82155504)
print v(xbgr.mr_n82155616)
print v(xbgr.mr_n82155936)
print v(xbgr.mr_n82156048)
print v(xbgr.mr_n82156480)
print v(xbgr.mr_n82156800)
print v(xbgr.mr_n82156912)
print v(xbgr.mr_n82157344)
print v(xbgr.mr_n82157664)
print v(xbgr.mr_n82157776)
print v(xbgr.mr_n82158096)
print v(xbgr.mr_n82158208)
print v(xbgr.mr_n82158528)
print v(xbgr.mr_n82158640)
print v(xbgr.mr_n82158960)
print v(xbgr.mr_n82159072)
print v(xbgr.mr_n82159392)
print v(xbgr.mr_n82160256)
print v(xbgr.mr_n82161120)
print v(xbgr.mr_n82161232)
print v(xbgr.mr_n82161552)
print v(xbgr.mr_n82162096)
print v(xbgr.mr_n82162416)
print v(xbgr.mr_n82162848)
print v(xbgr.mr_n82164144)
print v(xbgr.mr_n82165440)
print v(xbgr.mr_n82165552)
print v(xbgr.mr_n82165872)
print v(xbgr.mr_n82165984)
print v(xbgr.mr_n82166304)
print v(xbgr.mr_n82166416)
print v(xbgr.mr_n82166736)
print v(xbgr.mr_n82166848)
print v(xbgr.mr_n82167168)
print v(xbgr.mr_n82167280)
print v(xbgr.mr_n82167600)
print v(xbgr.mr_n82167712)
print v(xbgr.mr_n82168032)
print v(xbgr.mr_n82168144)
print v(xbgr.mr_n82168576)
print v(xbgr.mr_n82168896)
print v(xbgr.mr_n82169760)
print v(xbgr.mr_n82169872)
print v(xbgr.mr_n82170192)
print v(xbgr.mr_n82170304)
print v(xbgr.mr_n82170624)
print v(xbgr.mr_n82170736)
print v(xbgr.mr_n82171056)
print v(xbgr.mr_n82171168)
print v(xbgr.mr_n82171488)
print v(xbgr.mr_n82172352)
print v(xbgr.mr_n82173216)
print v(xbgr.mr_n82174080)
print v(xbgr.mr_n82174944)
print v(xbgr.mr_n82175808)
print v(xbgr.mr_n82175920)
print v(xbgr.mr_n82176240)
print v(xbgr.mr_n82176352)
print v(xbgr.mr_n82176672)
print v(xbgr.mr_n82176784)
print v(xbgr.mr_n82177104)
print v(xbgr.mr_n82177216)
print v(xbgr.mr_n82177536)
print v(xbgr.mr_n82177648)
print v(xbgr.mr_n82177968)
print v(xbgr.mr_n82178080)
print v(xbgr.mr_n82178400)
print v(xbgr.mr_n82178512)
print v(xbgr.mr_n82178832)
print v(xbgr.mr_n82178944)
print v(xbgr.mr_n82179264)
print v(xbgr.mr_n82179376)
print v(xbgr.mr_n82179696)
print v(xbgr.mr_n82179808)
print v(xbgr.mr_n82180240)
print v(xbgr.mr_n82180560)
print v(xbgr.mr_n82180672)
print v(xbgr.mr_n82180992)
print v(xbgr.mr_n82181104)
print v(xbgr.mr_n82181536)
print v(xbgr.mr_n82181856)
print v(xbgr.mr_n82181968)
print v(xbgr.mr_n82182400)
print v(xbgr.mr_n82182720)
print v(xbgr.mr_n82182832)
print v(xbgr.mr_n82183264)
print v(xbgr.mr_n82183696)
print v(xbgr.mr_n82184016)
print v(xbgr.mr_n82184128)
print v(xbgr.mr_n82184560)
print v(xbgr.mr_n82184880)
print v(xbgr.mr_n82184992)
print v(xbgr.mr_n82185312)
print v(xbgr.mr_n82185424)
print v(xbgr.mr_n82185744)
print v(xbgr.mr_n82185856)
print v(xbgr.mr_n82186176)
print v(xbgr.mr_n82186288)
print v(xbgr.mr_n82186608)
print v(xbgr.mr_n82186720)
print v(xbgr.mr_n82187040)
print v(xbgr.mr_n82187152)
print v(xbgr.mr_n82187472)
print v(xbgr.mr_n82187584)
print v(xbgr.mr_n82187904)
print v(xbgr.mr_n82188016)
print v(xbgr.mr_n82188336)
print v(xbgr.mr_n82189200)
print v(xbgr.mr_n82189312)
print v(xbgr.mr_n82189632)
print v(xbgr.mr_n82189744)
print v(xbgr.mr_n82190064)
print v(xbgr.mr_n82190928)
print v(xbgr.mr_n82191792)
print v(xbgr.mr_n82192656)
print v(xbgr.mr_n82193520)
print v(xbgr.mr_n82194384)
print v(xbgr.mr_n82194496)
print v(xbgr.mr_n82194816)
print v(xbgr.mr_n82194928)
print v(xbgr.mr_n82195248)
print v(xbgr.mr_n82195360)
print v(xbgr.mr_n82195680)
print v(xbgr.mr_n82196544)
print v(xbgr.mr_n82197408)
print v(xbgr.mr_n82198272)
print v(xbgr.mr_n82199136)
print v(xbgr.mr_n82200000)
print v(xbgr.mr_n82200864)
print v(xbgr.mr_n82201728)
print v(xbgr.mr_n82201840)
print v(xbgr.mr_n82202160)
print v(xbgr.mr_n82202272)
print v(xbgr.mr_n82202704)
print v(xbgr.mr_n82203024)
print v(xbgr.mr_n82203888)
print v(xbgr.mr_n82204432)
print v(xbgr.mr_n82204864)
print v(xbgr.mr_n82205296)
print v(xbgr.mr_n82206048)
print v(xbgr.mr_n82206912)
print v(xbgr.mr_n82207776)
print v(xbgr.mr_n82207888)
print v(xbgr.mr_n82208208)
print v(xbgr.mr_n82208320)
print v(xbgr.mr_n82208752)
print v(xbgr.mr_n82209184)
print v(xbgr.mr_n82209504)
print v(xbgr.mr_n82210368)
print v(xbgr.mr_n82210480)
print v(xbgr.mr_n82210912)
print v(xbgr.mr_n82211232)
print v(xbgr.mr_n82211344)
print v(xbgr.mr_n82211776)
print v(xbgr.mr_n82212096)
print v(xbgr.mr_n82212960)
print v(xbgr.mr_n82213072)
print v(xbgr.mr_n82213392)
print v(xbgr.mr_n82214256)
print v(xbgr.mr_n82215120)
print v(xbgr.mr_n82215232)
print v(xbgr.mr_n82215552)
print v(xbgr.mr_n82215664)
print v(xbgr.mr_n82215984)
print v(xbgr.mr_n82216848)
print v(xbgr.mr_n82217280)
print v(xbgr.mr_n82217392)
print v(xbgr.mr_n82217824)
print v(xbgr.mr_n82218144)
print v(xbgr.mr_n82218256)
print v(xbgr.mr_n82218688)
print v(xbgr.mr_n82219440)
print v(xbgr.mr_n82219552)
print v(xbgr.mr_n82219872)
print v(xbgr.mr_n82219984)
print v(xbgr.mr_n82220304)
print v(xbgr.mr_n82220416)
print v(xbgr.mr_n82220736)
print v(xbgr.mr_n82221168)
print v(xbgr.mr_n82221280)
print v(xbgr.mr_n82222032)
print v(xbgr.mr_n82222464)
print v(xbgr.mr_n82222576)
print v(xbgr.mr_n82223440)
print v(xbgr.mr_n82223760)
print v(xbgr.mr_n82223872)
print v(xbgr.mr_n82224192)
print v(xbgr.mr_n82225056)
print v(xbgr.mr_n82225920)
print v(xbgr.mr_n82226784)
print v(xbgr.mr_n82227648)
print v(xbgr.mr_n82227760)
print v(xbgr.mr_n82228080)
print v(xbgr.mr_n82228192)
print v(xbgr.mr_n82228512)
print v(xbgr.mr_n82228624)
print v(xbgr.mr_n82228944)
print v(xbgr.mr_n82229056)
print v(xbgr.mr_n82229376)
print v(xbgr.mr_n82229488)
print v(xbgr.mr_n82229808)
print v(xbgr.mr_n82229920)
print v(xbgr.mr_n82230240)
print v(xbgr.mr_n82230352)
print v(xbgr.mr_n82230672)
print v(xbgr.mr_n82230784)
print v(xbgr.mr_n82231104)
print v(xbgr.mr_n82231216)
print v(xbgr.mr_n82231536)
print v(xbgr.mr_n82231648)
print v(xbgr.mr_n82232080)
print v(xbgr.mr_n82232512)
print v(xbgr.mr_n82232944)
print v(xbgr.mr_n82233264)
print v(xbgr.mr_n82233376)
print v(xbgr.mr_n82233696)
print v(xbgr.mr_n82234560)
print v(xbgr.mr_n82234672)
print v(xbgr.mr_n82234992)
print v(xbgr.mr_n82235104)
print v(xbgr.mr_n82235424)
print v(xbgr.mr_n82235536)
print v(xbgr.mr_n82235968)
print v(xbgr.mr_n82236288)
print v(xbgr.mr_n82236400)
print v(xbgr.mr_n82236720)
print v(xbgr.mr_n82236832)
print v(xbgr.mr_n82237264)
print v(xbgr.mr_n82237584)
print v(xbgr.mr_n82238016)
print v(xbgr.mr_n82238128)
print v(xbgr.mr_n82238448)
print v(xbgr.mr_n82238560)
print v(xbgr.mr_n82238880)
print v(xbgr.mr_n82238992)
print v(xbgr.mr_n82239312)
print v(xbgr.mr_n82239424)
print v(xbgr.mr_n82239856)
print v(xbgr.mr_n82240176)
print v(xbgr.mr_n82240288)
print v(xbgr.mr_n82240608)
print v(xbgr.mr_n82240720)
print v(xbgr.mr_n82241040)
print v(xbgr.mr_n82241152)
print v(xbgr.mr_n82241472)
print v(xbgr.mr_n82241584)
print v(xbgr.mr_n82241904)
print v(xbgr.mr_n82242016)
print v(xbgr.mr_n82242336)
print v(xbgr.mr_n82242448)
print v(xbgr.mr_n82242768)
print v(xbgr.mr_n82242880)
print v(xbgr.mr_n82243632)
print v(xbgr.mr_n82244064)
print v(xbgr.mr_n82244928)
print v(xbgr.mr_n82245040)
print v(xbgr.mr_n82245360)
print v(xbgr.mr_n82245904)
print v(xbgr.mr_n82246336)
print v(xbgr.mr_n82246768)
print v(xbgr.mr_n82247088)
print v(xbgr.mr_n82247520)
print v(xbgr.mr_n82248384)
print v(xbgr.mr_n82250544)
print v(xbgr.mr_n82251408)
print v(xbgr.mr_n82251520)
print v(xbgr.mr_n82251840)
print v(xbgr.mr_n82252704)
print v(xbgr.mr_n82253568)
print v(xbgr.mr_n82253680)
print v(xbgr.mr_n82254000)
print v(xbgr.mr_n82254112)
print v(xbgr.mr_n82254432)
print v(xbgr.mr_n82254544)
print v(xbgr.mr_n82254864)
print v(xbgr.mr_n82254976)
print v(xbgr.mr_n82255296)
print v(xbgr.mr_n82256160)
print v(xbgr.mr_n82257024)
print v(xbgr.mr_n82257136)
print v(xbgr.mr_n82257456)
print v(xbgr.mr_n82257568)
print v(xbgr.mr_n82257888)
print v(xbgr.mr_n82258000)
print v(xbgr.mr_n82258320)
print v(xbgr.mr_n82258432)
print v(xbgr.mr_n82258752)
print v(xbgr.mr_n82258864)
print v(xbgr.mr_n82259184)
print v(xbgr.mr_n82259296)
print v(xbgr.mr_n82259616)
print v(xbgr.mr_n82259728)
print v(xbgr.mr_n82260160)
print v(xbgr.mr_n82260480)
print v(xbgr.mr_n82260592)
print v(xbgr.mr_n82261024)
print v(xbgr.mr_n82261344)
print v(xbgr.mr_n82261888)
print v(xbgr.mr_n82262752)
print v(xbgr.mr_n82263072)
print v(xbgr.mr_n82263184)
print v(xbgr.mr_n82264368)
print v(xbgr.mr_n82264480)
print v(xbgr.mr_n82264800)
print v(xbgr.mr_n82264912)
print v(xbgr.mr_n82265232)
print v(xbgr.mr_n82265344)
print v(xbgr.mr_n82265664)
print v(xbgr.mr_n82265776)
print v(xbgr.mr_n82266096)
print v(xbgr.mr_n82266960)
print v(xbgr.mr_n82267824)
print v(xbgr.mr_n82267936)
print v(xbgr.mr_n82268368)
print v(xbgr.mr_n82268800)
print v(xbgr.mr_n82269232)
print v(xbgr.mr_n82269552)
print v(xbgr.mr_n82269664)
print v(xbgr.mr_n82269984)
print v(xbgr.mr_n82270096)
print v(xbgr.mr_n82270416)
print v(xbgr.mr_n82270528)
print v(xbgr.mr_n82270848)
print v(xbgr.mr_n82270960)
print v(xbgr.mr_n82271280)
print v(xbgr.mr_n82271392)
print v(xbgr.mr_n82271712)
print v(xbgr.mr_n82271824)
print v(xbgr.mr_n82272144)
print v(xbgr.mr_n82273008)
print v(xbgr.mr_n82273120)
print v(xbgr.mr_n82273440)
print v(xbgr.mr_n82273552)
print v(xbgr.mr_n82273872)
print v(xbgr.mr_n82273984)
print v(xbgr.mr_n82274304)
print v(xbgr.mr_n82274416)
print v(xbgr.mr_n82274736)
print v(xbgr.mr_n82275280)
print v(xbgr.mr_n82276032)
print v(xbgr.mr_n82276896)
print v(xbgr.mr_n82277760)
print v(xbgr.mr_n82278624)
print v(xbgr.mr_n82279488)
print v(xbgr.mr_n82280352)
print v(xbgr.mr_n82280464)
print v(xbgr.mr_n82280784)
print v(xbgr.mr_n82280896)
print v(xbgr.mr_n82281216)
print v(xbgr.mr_n82281328)
print v(xbgr.mr_n82281648)
print v(xbgr.mr_n82281760)
print v(xbgr.mr_n82282080)
print v(xbgr.mr_n82282192)
print v(xbgr.mr_n82282512)
print v(xbgr.mr_n82282624)
print v(xbgr.mr_n82282944)
print v(xbgr.mr_n82283808)
print v(xbgr.mr_n82284672)
print v(xbgr.mr_n82285536)
print v(xbgr.mr_n82286400)
print v(xbgr.mr_n82287264)
print v(xbgr.mr_n82288128)
print v(xbgr.mr_n82288992)
print v(xbgr.mr_n82289104)
print v(xbgr.mr_n82289424)
print v(xbgr.mr_n82289536)
print v(xbgr.mr_n82289856)
print v(xbgr.mr_n82289968)
print v(xbgr.mr_n82290288)
print v(xbgr.mr_n82290400)
print v(xbgr.mr_n82290720)
print v(xbgr.mr_n82290832)
print v(xbgr.mr_n82291152)
print v(xbgr.mr_n82291264)
print v(xbgr.mr_n82291584)
print v(xbgr.mr_n82291696)
print v(xbgr.mr_n82292128)
print v(xbgr.mr_n82292448)
print v(xbgr.mr_n82292560)
print v(xbgr.mr_n82292992)
print v(xbgr.mr_n82293312)
print v(xbgr.mr_n82293424)
print v(xbgr.mr_n82293856)
print v(xbgr.mr_n82294176)
print v(xbgr.mr_n82295040)
print v(xbgr.mr_n82295904)
print v(xbgr.mr_n82296768)
print v(xbgr.mr_n82297632)
print v(xbgr.mr_n82298496)
print v(xbgr.mr_n82299360)
print v(xbgr.mr_n82299472)
print v(xbgr.mr_n82299792)
print v(xbgr.mr_n82299904)
print v(xbgr.mr_n82300224)
print v(xbgr.mr_n82300336)
print v(xbgr.mr_n82300656)
print v(xbgr.mr_n82300768)
print v(xbgr.mr_n82301088)
print v(xbgr.mr_n82301952)
print v(xbgr.mr_n82302816)
print v(xbgr.mr_n82303680)
print v(xbgr.mr_n82303792)
print v(xbgr.mr_n82304224)
print v(xbgr.mr_n82304544)
print v(xbgr.mr_n82304656)
print v(xbgr.mr_n82304976)
print v(xbgr.mr_n82305088)
print v(xbgr.mr_n82305408)
print v(xbgr.mr_n82305520)
print v(xbgr.mr_n82305840)
print v(xbgr.mr_n82305952)
print v(xbgr.mr_n82306272)
print v(xbgr.mr_n82306384)
print v(xbgr.mr_n82306816)
print v(xbgr.mr_n82307136)
print v(xbgr.mr_n82307248)
print v(xbgr.mr_n82307680)
print v(xbgr.mr_n82308000)
print v(xbgr.mr_n82308112)
print v(xbgr.mr_n82308432)
print v(xbgr.mr_n82308544)
print v(xbgr.mr_n82308976)
print v(xbgr.mr_n82309408)
print v(xbgr.mr_n82309728)
print v(xbgr.mr_n82309840)
print v(xbgr.mr_n82310272)
print v(xbgr.mr_n82310592)
print v(xbgr.mr_n82310704)
print v(xbgr.mr_n82311136)
print v(xbgr.mr_n82311456)
print v(xbgr.mr_n82312320)
print v(xbgr.mr_n82313184)
print v(xbgr.mr_n82314048)
print v(xbgr.mr_n82314912)
print v(xbgr.mr_n82315024)
print v(xbgr.mr_n82315344)
print v(xbgr.mr_n82315456)
print v(xbgr.mr_n82315776)
print v(xbgr.mr_n82315888)
print v(xbgr.mr_n82316208)
print v(xbgr.mr_n82316320)
print v(xbgr.mr_n82316640)
print v(xbgr.mr_n82317504)
print v(xbgr.mr_n82318368)
print v(xbgr.mr_n82319232)
print v(xbgr.mr_n82320096)
print v(xbgr.mr_n82320960)
print v(xbgr.mr_n82321824)
print v(xbgr.mr_n82322688)
print v(xbgr.mr_n82323552)
print v(xbgr.mr_n82323664)
print v(xbgr.mr_n82323984)
print v(xbgr.mr_n82324096)
print v(xbgr.mr_n82324416)
print v(xbgr.mr_n82324528)
print v(xbgr.mr_n82324848)
print v(xbgr.mr_n82324960)
print v(xbgr.mr_n82325280)
print v(xbgr.mr_n82325392)
print v(xbgr.mr_n82325712)
print v(xbgr.mr_n82325824)
print v(xbgr.mr_n82326144)
print v(xbgr.mr_n82326256)
print v(xbgr.mr_n82326576)
print v(xbgr.mr_n82326688)
print v(xbgr.mr_n82327008)
print v(xbgr.mr_n82327120)
print v(xbgr.mr_n82327440)
print v(xbgr.mr_n82327552)
print v(xbgr.mr_n82327984)
print v(xbgr.mr_n82328304)
print v(xbgr.mr_n82328416)
print v(xbgr.mr_n82328736)
print v(xbgr.mr_n82328848)
print v(xbgr.mr_n82329168)
print v(xbgr.mr_n82329280)
print v(xbgr.mr_n82329600)
print v(xbgr.mr_n82329712)
print v(xbgr.mr_n82330032)
print v(xbgr.mr_n82330144)
print v(xbgr.mr_n82330576)
print v(xbgr.mr_n82330896)
print v(xbgr.mr_n82331008)
print v(xbgr.mr_n82331440)
print v(xbgr.mr_n82331760)
print v(xbgr.mr_n82331872)
print v(xbgr.mr_n82332192)
print v(xbgr.mr_n82333056)
print v(xbgr.mr_n82333920)
print v(xbgr.mr_n82334464)
print v(xbgr.mr_n82335216)
print v(xbgr.mr_n82335648)
print v(xbgr.mr_n82335760)
print v(xbgr.mr_n82336512)
print v(xbgr.mr_n82336624)
print v(xbgr.mr_n82337056)
print v(xbgr.mr_n82337488)
print v(xbgr.mr_n82337808)
print v(xbgr.mr_n82338672)
print v(xbgr.mr_n82339104)
print v(xbgr.mr_n82339968)
print v(xbgr.mr_n82340080)
print v(xbgr.mr_n82340832)
print v(xbgr.mr_n82342128)
print v(xbgr.mr_n82342992)
print v(xbgr.mr_n82343104)
print v(xbgr.mr_n82343424)
print v(xbgr.mr_n82343536)
print v(xbgr.mr_n82343856)
print v(xbgr.mr_n82343968)
print v(xbgr.mr_n82344288)
print v(xbgr.mr_n82344400)
print v(xbgr.mr_n82344720)
print v(xbgr.mr_n82345584)
print v(xbgr.mr_n82346448)
print v(xbgr.mr_n82347312)
print v(xbgr.mr_n82347424)
print v(xbgr.mr_n82347744)
print v(xbgr.mr_n82347856)
print v(xbgr.mr_n82348176)
print v(xbgr.mr_n82349040)
print v(xbgr.mr_n82349152)
print v(xbgr.mr_n82349472)
print v(xbgr.mr_n82349584)
print v(xbgr.mr_n82349904)
print v(xbgr.mr_n82350016)
print v(xbgr.mr_n82350336)
print v(xbgr.mr_n82350448)
print v(xbgr.mr_n82350768)
print v(xbgr.mr_n82351632)
print v(xbgr.mr_n82352496)
print v(xbgr.mr_n82352608)
print v(xbgr.mr_n82352928)
print v(xbgr.mr_n82353040)
print v(xbgr.mr_n82353360)
print v(xbgr.mr_n82353472)
print v(xbgr.mr_n82353792)
print v(xbgr.mr_n82353904)
print v(xbgr.mr_n82354224)
print v(xbgr.mr_n82354336)
print v(xbgr.mr_n82354656)
print v(xbgr.mr_n82354768)
print v(xbgr.mr_n82355520)
print v(xbgr.mr_n82356384)
print v(xbgr.mr_n82357248)
print v(xbgr.mr_n82357360)
print v(xbgr.mr_n82357680)
print v(xbgr.mr_n82357792)
print v(xbgr.mr_n82358112)
print v(xbgr.mr_n82358224)
print v(xbgr.mr_n82358544)
print v(xbgr.mr_n82358656)
print v(xbgr.mr_n82359088)
print v(xbgr.mr_n82359408)
print v(xbgr.mr_n82359520)
print v(xbgr.mr_n82360272)
print v(xbgr.mr_n82361136)
print v(xbgr.mr_n82362000)
print v(xbgr.mr_n82362864)
print v(xbgr.mr_n82362976)
print v(xbgr.mr_n82363296)
print v(xbgr.mr_n82363408)
print v(xbgr.mr_n82363728)
print v(xbgr.mr_n82363840)
print v(xbgr.mr_n82364160)
print v(xbgr.mr_n82364272)
print v(xbgr.mr_n82364592)
print v(xbgr.mr_n82365456)
print v(xbgr.mr_n82366752)
print v(xbgr.mr_n82366864)
print v(xbgr.mr_n82367184)
print v(xbgr.mr_n82367296)
print v(xbgr.mr_n82367728)
print v(xbgr.mr_n82368048)
print v(xbgr.mr_n82368160)
print v(xbgr.mr_n82368592)
print v(xbgr.mr_n82368912)
print v(xbgr.mr_n82369344)
print v(xbgr.mr_n82370208)
print v(xbgr.mr_n82371072)
print v(xbgr.mr_n82371184)
print v(xbgr.mr_n82371504)
print v(xbgr.mr_n82371616)
print v(xbgr.mr_n82372048)
print v(xbgr.mr_n82372368)
print v(xbgr.mr_n82372480)
print v(xbgr.mr_n82372800)
print v(xbgr.mr_n82372912)
print v(xbgr.mr_n82373232)
print v(xbgr.mr_n82373344)
print v(xbgr.mr_n82373664)
print v(xbgr.mr_n82373776)
print v(xbgr.mr_n82374208)
print v(xbgr.mr_n82374640)
print v(xbgr.mr_n82375072)
print v(xbgr.mr_n82375504)
print v(xbgr.mr_n82375824)
print v(xbgr.mr_n82375936)
print v(xbgr.mr_n82376368)
print v(xbgr.mr_n82376688)
print v(xbgr.mr_n82377552)
print v(xbgr.mr_n82378416)
print v(xbgr.mr_n82378848)
print v(xbgr.mr_n82379712)
print v(xbgr.mr_n82380144)
print v(xbgr.mr_n82380256)
print v(xbgr.mr_n82381008)
print v(xbgr.mr_n82381872)
print v(xbgr.mr_n82382736)
print v(xbgr.mr_n82382848)
print v(xbgr.mr_n82383280)
print v(xbgr.mr_n82383600)
print v(xbgr.mr_n82384464)
print v(xbgr.mr_n82384576)
print v(xbgr.mr_n82384896)
print v(xbgr.mr_n82385008)
print v(xbgr.mr_n82385328)
print v(xbgr.mr_n82385440)
print v(xbgr.mr_n82385760)
print v(xbgr.mr_n82385872)
print v(xbgr.mr_n82386192)
print v(xbgr.mr_n82386304)
print v(xbgr.mr_n82386624)
print v(xbgr.mr_n82386736)
print v(xbgr.mr_n82387056)
print v(xbgr.mr_n82387168)
print v(xbgr.mr_n82387488)
print v(xbgr.mr_n82387600)
print v(xbgr.mr_n82387920)
print v(xbgr.mr_n82388032)
print v(xbgr.mr_n82388352)
print v(xbgr.mr_n82388464)
print v(xbgr.mr_n82389216)
print v(xbgr.mr_n82390512)
print v(xbgr.mr_n82391376)
print v(xbgr.mr_n82392672)
print v(xbgr.mr_n82392784)
print v(xbgr.mr_n82393104)
print v(xbgr.mr_n82393216)
print v(xbgr.mr_n82393536)
print v(xbgr.mr_n82393648)
print v(xbgr.mr_n82393968)
print v(xbgr.mr_n82394080)
print v(xbgr.mr_n82394832)
print v(xbgr.mr_n82395696)
print v(xbgr.mr_n82396560)
print v(xbgr.mr_n82397424)
print v(xbgr.mr_n82397536)
print v(xbgr.mr_n82397856)
print v(xbgr.mr_n82397968)
print v(xbgr.mr_n82398288)
print v(xbgr.mr_n82398400)
print v(xbgr.mr_n82398720)
print v(xbgr.mr_n82398832)
print v(xbgr.mr_n82399152)
print v(xbgr.mr_n82399264)
print v(xbgr.mr_n82399584)
print v(xbgr.mr_n82400128)
print v(xbgr.mr_n82400880)
print v(xbgr.mr_n82401744)
print v(xbgr.mr_n82401856)
print v(xbgr.mr_n82402176)
print v(xbgr.mr_n82402288)
print v(xbgr.mr_n82402720)
print v(xbgr.mr_n82403040)
print v(xbgr.mr_n82403152)
print v(xbgr.mr_n82403472)
print v(xbgr.mr_n82403584)
print v(xbgr.mr_n82403904)
print v(xbgr.mr_n82404016)
print v(xbgr.mr_n82404336)
print v(xbgr.mr_n82404448)
print v(xbgr.mr_n82404768)
print v(xbgr.mr_n82405200)
print v(xbgr.mr_n82405312)
print v(xbgr.mr_n82405632)
print v(xbgr.mr_n82405744)
print v(xbgr.mr_n82406496)
print v(xbgr.mr_n82406608)
print v(xbgr.mr_n82406928)
print v(xbgr.mr_n82407040)
print v(xbgr.mr_n82407792)
print v(xbgr.mr_n82408656)
print v(xbgr.mr_n82408768)
print v(xbgr.mr_n82409088)
print v(xbgr.mr_n82409952)
print v(xbgr.mr_n82410496)
print v(xbgr.mr_n82410816)
print v(xbgr.mr_n82411360)
print v(xbgr.mr_n82411792)
print v(xbgr.mr_n82412112)
print v(xbgr.mr_n82412224)
print v(xbgr.mr_n82412976)
print v(xbgr.mr_n82413088)
print v(xbgr.mr_n82413408)
print v(xbgr.mr_n82413520)
print v(xbgr.mr_n82413840)
print v(xbgr.mr_n82414704)
print v(xbgr.mr_n82415136)
print v(xbgr.mr_n82415248)
print v(xbgr.mr_n82415568)
print v(xbgr.mr_n82415680)
print v(xbgr.mr_n82416000)
print v(xbgr.mr_n82416112)
print v(xbgr.mr_n82416432)
print v(xbgr.mr_n82416544)
print v(xbgr.mr_n82416864)
print v(xbgr.mr_n82416976)
print v(xbgr.mr_n82418160)
print v(xbgr.mr_n82418272)
print v(xbgr.mr_n82418592)
print v(xbgr.mr_n82418704)
print v(xbgr.mr_n82419024)
print v(xbgr.mr_n82419136)
print v(xbgr.mr_n82419456)
print v(xbgr.mr_n82419888)
print v(xbgr.mr_n82552272)
print v(xbgr.mr_n82552384)
print v(xbgr.mr_n82552704)
print v(xbgr.mr_n82552816)
print v(xbgr.mr_n82553136)
print v(xbgr.mr_n82553248)
print v(xbgr.mr_n82553568)
print v(xbgr.mr_n82553680)
print v(xbgr.mr_n82554000)
print v(xbgr.mr_n82554112)
print v(xbgr.mr_n82554432)
print v(xbgr.mr_n82554544)
print v(xbgr.mr_n82554864)
print v(xbgr.mr_n82554976)
print v(xbgr.mr_n82555296)
print v(xbgr.mr_n82555408)
print v(xbgr.mr_n82555728)
print v(xbgr.mr_n82555840)
print v(xbgr.mr_n82556160)
print v(xbgr.mr_n82556272)
print v(xbgr.mr_n82556592)
print v(xbgr.mr_n82556704)
print v(xbgr.mr_n82557024)
print v(xbgr.mr_n82557136)
print v(xbgr.mr_n82557456)
print v(xbgr.mr_n82557568)
print v(xbgr.mr_n82557888)
print v(xbgr.mr_n82558000)
print v(xbgr.mr_n82558320)
print v(xbgr.mr_n82558432)
print v(xbgr.mr_n82558752)
print v(xbgr.mr_n82558864)
print v(xbgr.mr_n82559184)
print v(xbgr.mr_n82559296)
print v(xbgr.mr_n82559616)
print v(xbgr.mr_n82559728)
print v(xbgr.mr_n82560048)
print v(xbgr.mr_n82560160)
print v(xbgr.mr_n82560480)
print v(xbgr.mr_n82560592)
print v(xbgr.mr_n82560912)
print v(xbgr.mr_n82561024)
print v(xbgr.mr_n82561344)
print v(xbgr.mr_n82561456)
print v(xbgr.mr_n82561776)
print v(xbgr.mr_n82561888)
print v(xbgr.mr_n82562208)
print v(xbgr.mr_n82562320)
print v(xbgr.mr_n82562640)
print v(xbgr.mr_n82562752)
print v(xbgr.mr_n82563072)
print v(xbgr.mr_n82563184)
print v(xbgr.mr_n82563504)
print v(xbgr.mr_n82563616)
print v(xbgr.mr_n82563936)
print v(xbgr.mr_n82564048)
print v(xbgr.mr_n82564368)
print v(xbgr.mr_n82564480)
print v(xbgr.mr_n82564800)
print v(xbgr.mr_n82564912)
print v(xbgr.mr_n82565232)
print v(xbgr.mr_n82565344)
print v(xbgr.mr_n82565664)
print v(xbgr.mr_n82565776)
print v(xbgr.mr_n82566096)
print v(xbgr.mr_n82566208)
print v(xbgr.mr_n82566528)
print v(xbgr.mr_n82566640)
print v(xbgr.mr_n82566960)
print v(xbgr.mr_n82567072)
print v(xbgr.mr_n82567392)
print v(xbgr.mr_n82567504)
print v(xbgr.mr_n82567824)
print v(xbgr.mr_n82567936)
print v(xbgr.mr_n82568256)
print v(xbgr.mr_n82568368)
print v(xbgr.mr_n82568688)
print v(xbgr.mr_n82568800)
print v(xbgr.mr_n82569120)
print v(xbgr.mr_n82569232)
print v(xbgr.mr_n82569552)
print v(xbgr.mr_n82569664)
print v(xbgr.mr_n82569984)
print v(xbgr.mr_n82570096)
print v(xbgr.mr_n82570416)
print v(xbgr.mr_n82570528)
print v(xbgr.mr_n82570848)
print v(xbgr.mr_n82570960)
print v(xbgr.mr_n82571280)
print v(xbgr.mr_n82571392)
print v(xbgr.mr_n82571712)
print v(xbgr.mr_n82571824)
print v(xbgr.mr_n82572144)
print v(xbgr.mr_n82572256)
print v(xbgr.mr_n82572576)
print v(xbgr.mr_n82572688)
print v(xbgr.mr_n82573008)
print v(xbgr.mr_n82573120)
print v(xbgr.mr_n82573440)
print v(xbgr.mr_n82573552)
print v(xbgr.mr_n82573872)
print v(xbgr.mr_n82573984)
print v(xbgr.mr_n82574304)
print v(xbgr.mr_n82574416)
print v(xbgr.mr_n82574736)
print v(xbgr.mr_n82574848)
print v(xbgr.mr_n82575168)
print v(xbgr.mr_n82575280)
print v(xbgr.mr_n82575600)
print v(xbgr.mr_n82575712)
print v(xbgr.mr_n82576032)
print v(xbgr.mr_n82576144)
print v(xbgr.mr_n82576464)
print v(xbgr.mr_n82576576)
print v(xbgr.mr_n82576896)
print v(xbgr.mr_n82577008)
print v(xbgr.mr_n82577328)
print v(xbgr.mr_n82577440)
print v(xbgr.mr_n82577760)
print v(xbgr.mr_n82577872)
print v(xbgr.mr_n82578192)
print v(xbgr.mr_n82578304)
print v(xbgr.mr_n82578624)
print v(xbgr.mr_n82578736)
print v(xbgr.mr_n82579056)
print v(xbgr.mr_n82579168)
print v(xbgr.mr_n82579488)
print v(xbgr.mr_n82579600)
print v(xbgr.mr_n82579920)
print v(xbgr.mr_n82580032)
print v(xbgr.mr_n82580352)
print v(xbgr.mr_n82580464)
print v(xbgr.mr_n82580784)
print v(xbgr.mr_n82580896)
print v(xbgr.mr_n82581216)
print v(xbgr.mr_n82581328)
print v(xbgr.mr_n82581648)
print v(xbgr.mr_n82581760)
print v(xbgr.mr_n82582080)
print v(xbgr.mr_n82582192)
print v(xbgr.mr_n82582512)
print v(xbgr.mr_n82582624)
print v(xbgr.mr_n82582944)
print v(xbgr.mr_n82583056)
print v(xbgr.mr_n82583376)
print v(xbgr.mr_n82583488)
print v(xbgr.mr_n82583808)
print v(xbgr.mr_n82583920)
print v(xbgr.mr_n82584240)
print v(xbgr.mr_n82584352)
print v(xbgr.mr_n82584672)
print v(xbgr.mr_n82584784)
print v(xbgr.mr_n82585104)
print v(xbgr.mr_n82585216)
print v(xbgr.mr_n82585536)
print v(xbgr.mr_n82585648)
print v(xbgr.mr_n82585968)
print v(xbgr.mr_n82586080)
print v(xbgr.mr_n82586400)
print v(xbgr.mr_n82586512)
print v(xbgr.mr_n82586832)
print v(xbgr.mr_n82586944)
print v(xbgr.mr_n82587264)
print v(xbgr.mr_n82587376)
print v(xbgr.mr_n82587696)
print v(xbgr.mr_n82587808)
print v(xbgr.mr_n82588128)
print v(xbgr.mr_n82588240)
print v(xbgr.mr_n82588560)
print v(xbgr.mr_n82588672)
print v(xbgr.mr_n82588992)
print v(xbgr.mr_n82589104)
print v(xbgr.mr_n82589424)
print v(xbgr.mr_n82589536)
print v(xbgr.mr_n82589856)
print v(xbgr.mr_n82589968)
print v(xbgr.mr_n82590288)
print v(xbgr.mr_n82590400)
print v(xbgr.mr_n82590720)
print v(xbgr.mr_n82590832)
print v(xbgr.mr_n82591152)
print v(xbgr.mr_n82591264)
print v(xbgr.mr_n82591584)
print v(xbgr.mr_n82591696)
print v(xbgr.mr_n82592016)
print v(xbgr.mr_n82592128)
print v(xbgr.mr_n82592448)
print v(xbgr.mr_n82592560)
print v(xbgr.mr_n82592880)
print v(xbgr.mr_n82592992)
print v(xbgr.mr_n82593312)
print v(xbgr.mr_n82593424)
print v(xbgr.mr_n82593744)
print v(xbgr.mr_n82593856)
print v(xbgr.mr_n82594176)
print v(xbgr.mr_n82594288)
print v(xbgr.mr_n82594608)
print v(xbgr.mr_n82594720)
print v(xbgr.mr_n82595040)
print v(xbgr.mr_n82595152)
print v(xbgr.mr_n82595472)
print v(xbgr.mr_n82595584)
print v(xbgr.mr_n82595904)
print v(xbgr.mr_n82596016)
print v(xbgr.mr_n82596336)
print v(xbgr.mr_n82596448)
print v(xbgr.mr_n82596768)
print v(xbgr.mr_n82596880)
print v(xbgr.mr_n82597200)
print v(xbgr.mr_n82597312)
print v(xbgr.mr_n82597632)
print v(xbgr.mr_n82597744)
print v(xbgr.mr_n82598064)
print v(xbgr.mr_n82598176)
print v(xbgr.mr_n82598496)
print v(xbgr.mr_n82598608)
print v(xbgr.mr_n82598928)
print v(xbgr.mr_n82599040)
print v(xbgr.mr_n82599360)
print v(xbgr.mr_n82599472)
print v(xbgr.mr_n82599792)
print v(xbgr.mr_n82599904)
print v(xbgr.mr_n82600224)
print v(xbgr.mr_n82600336)
print v(xbgr.mr_n82600656)
print v(xbgr.mr_n82600768)
print v(xbgr.mr_n82601088)
print v(xbgr.mr_n82601200)
print v(xbgr.mr_n82601520)
print v(xbgr.mr_n82601632)
print v(xbgr.mr_n82601952)
print v(xbgr.mr_n82602064)
print v(xbgr.mr_n82602384)
print v(xbgr.mr_n82602496)
print v(xbgr.mr_n82602816)
print v(xbgr.mr_n82602928)
print v(xbgr.mr_n82603248)
print v(xbgr.mr_n82603360)
print v(xbgr.mr_n82603680)
print v(xbgr.mr_n82603792)
print v(xbgr.mr_n82604112)
print v(xbgr.mr_n82604224)
print v(xbgr.mr_n82604544)
print v(xbgr.mr_n82604656)
print v(xbgr.mr_n82604976)
print v(xbgr.mr_n82605088)
print v(xbgr.mr_n82605408)
print v(xbgr.mr_n82605520)
print v(xbgr.mr_n82605840)
print v(xbgr.mr_n82605952)
print v(xbgr.mr_n82606272)
print v(xbgr.mr_n82606384)
print v(xbgr.mr_n82606704)
print v(xbgr.mr_n82606816)
print v(xbgr.mr_n82607136)
print v(xbgr.mr_n82607248)
print v(xbgr.mr_n82607568)
print v(xbgr.mr_n82607680)
print v(xbgr.mr_n82608000)
print v(xbgr.mr_n82608112)
print v(xbgr.mr_n82608432)
print v(xbgr.mr_n82608544)
print v(xbgr.mr_n82608864)
print v(xbgr.mr_n82608976)
print v(xbgr.mr_n82609296)
print v(xbgr.mr_n82609408)
print v(xbgr.mr_n82609728)
print v(xbgr.mr_n82609840)
print v(xbgr.mr_n82610160)
print v(xbgr.mr_n82610272)
print v(xbgr.mr_n82610592)
print v(xbgr.mr_n82610704)
print v(xbgr.mr_n82611024)
print v(xbgr.mr_n82611136)
print v(xbgr.mr_n82611456)
print v(xbgr.mr_n82611568)
print v(xbgr.mr_n82611888)
print v(xbgr.mr_n82612000)
print v(xbgr.mr_n82612320)
print v(xbgr.mr_n82612432)
print v(xbgr.mr_n82612752)
print v(xbgr.mr_n82612864)
print v(xbgr.mr_n82613184)
print v(xbgr.mr_n82613296)
print v(xbgr.mr_n82613616)
print v(xbgr.mr_n82613728)
print v(xbgr.mr_n82614048)
print v(xbgr.mr_n82614160)
print v(xbgr.mr_n82614480)
print v(xbgr.mr_n82614592)
print v(xbgr.mr_n82614912)
print v(xbgr.mr_n82615024)
print v(xbgr.mr_n82615344)
print v(xbgr.mr_n82615456)
print v(xbgr.mr_n82615776)
print v(xbgr.mr_n82615888)
print v(xbgr.mr_n82616208)
print v(xbgr.mr_n82616320)
print v(xbgr.mr_n82616640)
print v(xbgr.mr_n82616752)
print v(xbgr.mr_n82617072)
print v(xbgr.mr_n82617184)
print v(xbgr.mr_n82617504)
print v(xbgr.mr_n82617616)
print v(xbgr.mr_n82617936)
print v(xbgr.mr_n82618048)
print v(xbgr.mr_n82618368)
print v(xbgr.mr_n82618480)
print v(xbgr.mr_n82618800)
print v(xbgr.mr_n82618912)
print v(xbgr.mr_n82619232)
print v(xbgr.mr_n82619344)
print v(xbgr.mr_n82619664)
print v(xbgr.mr_n82619776)
print v(xbgr.mr_n82620096)
print v(xbgr.mr_n82620208)
print v(xbgr.mr_n82620528)
print v(xbgr.mr_n82620640)
print v(xbgr.mr_n82620960)
print v(xbgr.mr_n82621072)
print v(xbgr.mr_n82621392)
print v(xbgr.mr_n82621504)
print v(xbgr.mr_n82621824)
print v(xbgr.mr_n82621936)
print v(xbgr.mr_n82622256)
print v(xbgr.mr_n82622368)
print v(xbgr.mr_n82622688)
print v(xbgr.mr_n82622800)
print v(xbgr.mr_n82623120)
print v(xbgr.mr_n82623232)
print v(xbgr.mr_n82623552)
print v(xbgr.mr_n82623664)
print v(xbgr.mr_n82623984)
print v(xbgr.mr_n82624096)
print v(xbgr.mr_n82624416)
print v(xbgr.mr_n82624528)
print v(xbgr.mr_n82624848)
print v(xbgr.mr_n82624960)
print v(xbgr.mr_n82625280)
print v(xbgr.mr_n82625392)
print v(xbgr.mr_n82625712)
print v(xbgr.mr_n82625824)
print v(xbgr.mr_n82626144)
print v(xbgr.mr_n82626256)
print v(xbgr.mr_n82626576)
print v(xbgr.mr_n82626688)
print v(xbgr.mr_n82627008)
print v(xbgr.mr_n82627120)
print v(xbgr.mr_n82627440)
print v(xbgr.mr_n82627552)
print v(xbgr.mr_n82627872)
print v(xbgr.mr_n82627984)
print v(xbgr.mr_n82628304)
print v(xbgr.mr_n82628416)
print v(xbgr.mr_n82628736)
print v(xbgr.mr_n82628848)
print v(xbgr.mr_n82629168)
print v(xbgr.mr_n82629280)
print v(xbgr.mr_n82629600)
print v(xbgr.mr_n82629712)
print v(xbgr.mr_n82630032)
print v(xbgr.mr_n82630144)
print v(xbgr.mr_n82630464)
print v(xbgr.mr_n82630576)
print v(xbgr.mr_n82630896)
print v(xbgr.mr_n82631008)
print v(xbgr.mr_n82631328)
print v(xbgr.mr_n82631440)
print v(xbgr.mr_n82631760)
print v(xbgr.mr_n82631872)
print v(xbgr.mr_n82632192)
print v(xbgr.mr_n82632304)
print v(xbgr.mr_n82632624)
print v(xbgr.mr_n82632736)
print v(xbgr.mr_n82633056)
print v(xbgr.mr_n82633168)
print v(xbgr.mr_n82633488)
print v(xbgr.mr_n82633600)
print v(xbgr.mr_n82633920)
print v(xbgr.mr_n82634032)
print v(xbgr.mr_n82634352)
print v(xbgr.mr_n82634464)
print v(xbgr.mr_n82634784)
print v(xbgr.mr_n82634896)
print v(xbgr.mr_n82635200)
print v(xbgr.mr_n82635312)
print v(xbgr.mr_n82635632)
print v(xbgr.mr_n82635744)
print v(xbgr.mr_n82636064)
print v(xbgr.mr_n82636176)
print v(xbgr.mr_n82636496)
print v(xbgr.mr_n82636608)
print v(xbgr.mr_n82636928)
print v(xbgr.mr_n82637040)
print v(xbgr.mr_n82637360)
print v(xbgr.mr_n82637472)
print v(xbgr.mr_n82637792)
print v(xbgr.mr_n82637904)
print v(xbgr.mr_n82638224)
print v(xbgr.mr_n82638336)
print v(xbgr.mr_n82638656)
print v(xbgr.mr_n82638768)
print v(xbgr.mr_n82639088)
print v(xbgr.mr_n82639200)
print v(xbgr.mr_n82639520)
print v(xbgr.mr_n82639632)
print v(xbgr.mr_n82639952)
print v(xbgr.mr_n82640064)
print v(xbgr.mr_n82640384)
print v(xbgr.mr_n82640496)
print v(xbgr.mr_n82640816)
print v(xbgr.mr_n82640928)
print v(xbgr.mr_n82641248)
print v(xbgr.mr_n82641360)
print v(xbgr.mr_n82641680)
print v(xbgr.mr_n82641792)
print v(xbgr.mr_n82642112)
print v(xbgr.mr_n82642224)
print v(xbgr.mr_n82642544)
print v(xbgr.mr_n82642656)
print v(xbgr.mr_n82642976)
print v(xbgr.mr_n82643088)
print v(xbgr.mr_n82643408)
print v(xbgr.mr_n82643520)
print v(xbgr.mr_n82643840)
print v(xbgr.mr_n82643952)
print v(xbgr.mr_n82644272)
print v(xbgr.mr_n82644384)
print v(xbgr.mr_n82644704)
print v(xbgr.mr_n82644816)
print v(xbgr.mr_n82645136)
print v(xbgr.mr_n82645248)
print v(xbgr.mr_n82645568)
print v(xbgr.mr_n82645680)
print v(xbgr.mr_n82646000)
print v(xbgr.mr_n82646112)
print v(xbgr.mr_n82646432)
print v(xbgr.mr_n82646544)
print v(xbgr.mr_n82646864)
print v(xbgr.mr_n82646976)
print v(xbgr.mr_n82647296)
print v(xbgr.mr_n82647408)
print v(xbgr.mr_n82647728)
print v(xbgr.mr_n82647840)
print v(xbgr.mr_n82648160)
print v(xbgr.mr_n82648272)
print v(xbgr.mr_n82648592)
print v(xbgr.mr_n82648704)
print v(xbgr.mr_n82649024)
print v(xbgr.mr_n82649136)
print v(xbgr.mr_n82649456)
print v(xbgr.mr_n82649568)
print v(xbgr.mr_n82649888)
print v(xbgr.mr_n82650000)
print v(xbgr.mr_n82650320)
print v(xbgr.mr_n82650432)
print v(xbgr.mr_n82650752)
print v(xbgr.mr_n82650864)
print v(xbgr.mr_n82651184)
print v(xbgr.mr_n82651296)
print v(xbgr.mr_n82651616)
print v(xbgr.mr_n82651728)
print v(xbgr.mr_n82652048)
print v(xbgr.mr_n82652160)
print v(xbgr.mr_n82652480)
print v(xbgr.mr_n82652592)
print v(xbgr.mr_n82652912)
print v(xbgr.mr_n82653024)
print v(xbgr.mr_n82653344)
print v(xbgr.mr_n82653456)
print v(xbgr.mr_n82653776)
print v(xbgr.mr_n82653888)
print v(xbgr.mr_n82654208)
print v(xbgr.mr_n82654320)
print v(xbgr.mr_n82654640)
print v(xbgr.mr_n82654752)
print v(xbgr.mr_n82655072)
print v(xbgr.mr_n82655184)
print v(xbgr.mr_n82655504)
print v(xbgr.mr_n82655616)
print v(xbgr.mr_n82655936)
print v(xbgr.mr_n82656048)
print v(xbgr.mr_n82656368)
print v(xbgr.mr_n82656480)
print v(xbgr.mr_n82656800)
print v(xbgr.mr_n82656912)
print v(xbgr.mr_n82657232)
print v(xbgr.mr_n82657344)
print v(xbgr.mr_n82657664)
print v(xbgr.mr_n82657776)
print v(xbgr.mr_n82658096)
print v(xbgr.mr_n82658208)
print v(xbgr.mr_n82658528)
print v(xbgr.mr_n82658640)
print v(xbgr.mr_n82658960)
print v(xbgr.mr_n82659072)
print v(xbgr.mr_n82659392)
print v(xbgr.mr_n82659504)
print v(xbgr.mr_n82659824)
print v(xbgr.mr_n82659936)
print v(xbgr.mr_n82660256)
print v(xbgr.mr_n82660368)
print v(xbgr.mr_n82660688)
print v(xbgr.mr_n82660800)
print v(xbgr.mr_n82661120)
print v(xbgr.mr_n82661232)
print v(xbgr.mr_n82661552)
print v(xbgr.mr_n82661664)
print v(xbgr.mr_n82661984)
print v(xbgr.mr_n82662096)
print v(xbgr.mr_n82662416)
print v(xbgr.mr_n82662528)
print v(xbgr.mr_n82662848)
print v(xbgr.mr_n82662960)
print v(xbgr.mr_n82663280)
print v(xbgr.mr_n82663392)
print v(xbgr.mr_n82663712)
print v(xbgr.mr_n82663824)
print v(xbgr.mr_n82664144)
print v(xbgr.mr_n82664256)
print v(xbgr.mr_n82664576)
print v(xbgr.mr_n82664688)
print v(xbgr.mr_n82665008)
print v(xbgr.mr_n82665120)
print v(xbgr.mr_n82665440)
print v(xbgr.mr_n82665552)
print v(xbgr.mr_n82665872)
print v(xbgr.mr_n82665984)
print v(xbgr.mr_n82666304)
print v(xbgr.mr_n82666416)
print v(xbgr.mr_n82666736)
print v(xbgr.mr_n82666848)
print v(xbgr.mr_n82667168)
print v(xbgr.mr_n82667280)
print v(xbgr.mr_n82667600)
print v(xbgr.mr_n82667712)
print v(xbgr.mr_n82668032)
print v(xbgr.mr_n82668144)
print v(xbgr.mr_n82668464)
print v(xbgr.mr_n82668576)
print v(xbgr.mr_n82668896)
print v(xbgr.mr_n82669008)
print v(xbgr.mr_n82669328)
print v(xbgr.mr_n82669440)
print v(xbgr.mr_n82669760)
print v(xbgr.mr_n82669872)
print v(xbgr.mr_n82670192)
print v(xbgr.mr_n82670304)
print v(xbgr.mr_n82670624)
print v(xbgr.mr_n82670736)
print v(xbgr.mr_n82671056)
print v(xbgr.mr_n82671168)
print v(xbgr.mr_n82671488)
print v(xbgr.mr_n82671600)
print v(xbgr.mr_n82671920)
print v(xbgr.mr_n82672032)
print v(xbgr.mr_n82672352)
print v(xbgr.mr_n82672464)
print v(xbgr.mr_n82672784)
print v(xbgr.mr_n82672896)
print v(xbgr.mr_n82673216)
print v(xbgr.mr_n82673328)
print v(xbgr.mr_n82673648)
print v(xbgr.mr_n82673760)
print v(xbgr.mr_n82674080)
print v(xbgr.mr_n82674192)
print v(xbgr.mr_n82674512)
print v(xbgr.mr_n82674624)
print v(xbgr.mr_n82674944)
print v(xbgr.mr_n82675056)
print v(xbgr.mr_n82675376)
print v(xbgr.mr_n82675488)
print v(xbgr.mr_n82675808)
print v(xbgr.mr_n82675920)
print v(xbgr.mr_n82676240)
print v(xbgr.mr_n82676352)
print v(xbgr.mr_n82676672)
print v(xbgr.mr_n82676784)
print v(xbgr.mr_n82677104)
print v(xbgr.mr_n82677216)
print v(xbgr.mr_n82677536)
print v(xbgr.mr_n82677648)
print v(xbgr.mr_n82677968)
print v(xbgr.mr_n82678080)
print v(xbgr.mr_n82678400)
print v(xbgr.mr_n82678512)
print v(xbgr.mr_n82678832)
print v(xbgr.mr_n82678944)
print v(xbgr.mr_n82679264)
print v(xbgr.mr_n82679376)
print v(xbgr.mr_n82679696)
print v(xbgr.mr_n82679808)
print v(xbgr.mr_n82680128)
print v(xbgr.mr_n82680240)
print v(xbgr.mr_n82680560)
print v(xbgr.mr_n82680672)
print v(xbgr.mr_n82680992)
print v(xbgr.mr_n82681104)
print v(xbgr.mr_n82681424)
print v(xbgr.mr_n82681536)
print v(xbgr.mr_n82681856)
print v(xbgr.mr_n82681968)
print v(xbgr.mr_n82682288)
print v(xbgr.mr_n82682400)
print v(xbgr.mr_n82682720)
print v(xbgr.mr_n82682832)
print v(xbgr.mr_n82683152)
print v(xbgr.mr_n82683360)
print v(xbgr.mr_n82683600)
print v(xbgr.mr_n82684464)
print v(xbgr.mr_n82684576)
print v(xbgr.mr_n82684896)
print v(xbgr.mr_n82685008)
print v(xbgr.mr_n82685328)
print v(xbgr.mr_n82685440)
print v(xbgr.mr_n82685760)
print v(xbgr.mr_n82685872)
print v(xbgr.mr_n82686192)
print v(xbgr.mr_n82686304)
print v(xbgr.mr_n82686624)
print v(xbgr.mr_n82686736)
print v(xbgr.mr_n82687056)
print v(xbgr.mr_n82687920)
print v(xbgr.mr_n82688784)
print v(xbgr.mr_n82689648)
print v(xbgr.mr_n82689760)
print v(xbgr.mr_n82690512)
print v(xbgr.mr_n82690624)
print v(xbgr.mr_n82690944)
print v(xbgr.mr_n82691808)
print v(xbgr.mr_n82692672)
print v(xbgr.mr_n82693536)
print v(xbgr.mr_n82694400)
print v(xbgr.mr_n82694944)
print v(xbgr.mr_n82695696)
print v(xbgr.mr_n82696240)
print v(xbgr.mr_n82696672)
print v(xbgr.mr_n82697424)
print v(xbgr.mr_n82697536)
print v(xbgr.mr_n82697856)
print v(xbgr.mr_n82697968)
print v(xbgr.mr_n82698288)
print v(xbgr.mr_n82699152)
print v(xbgr.mr_n82700016)
print v(xbgr.mr_n82700880)
print v(xbgr.mr_n82700992)
print v(xbgr.mr_n82701312)
print v(xbgr.mr_n82701424)
print v(xbgr.mr_n82701856)
print v(xbgr.mr_n82702176)
print v(xbgr.mr_n82702288)
print v(xbgr.mr_n82702608)
print v(xbgr.mr_n82703472)
print v(xbgr.mr_n82703584)
print v(xbgr.mr_n82704016)
print v(xbgr.mr_n82704336)
print v(xbgr.mr_n82704448)
print v(xbgr.mr_n82704768)
print v(xbgr.mr_n82704880)
print v(xbgr.mr_n82705200)
print v(xbgr.mr_n82705312)
print v(xbgr.mr_n82705632)
print v(xbgr.mr_n82705744)
print v(xbgr.mr_n82706064)
print v(xbgr.mr_n82707040)
print v(xbgr.mr_n82707360)
print v(xbgr.mr_n82707472)
print v(xbgr.mr_n82707792)
print v(xbgr.mr_n82707904)
print v(xbgr.mr_n82708224)
print v(xbgr.mr_n82708336)
print v(xbgr.mr_n82708656)
print v(xbgr.mr_n82708768)
print v(xbgr.mr_n82709088)
print v(xbgr.mr_n82709520)
print v(xbgr.mr_n82710496)
print v(xbgr.mr_n82710816)
print v(xbgr.mr_n82711680)
print v(xbgr.mr_n82712544)
print v(xbgr.mr_n82712656)
print v(xbgr.mr_n82713408)
print v(xbgr.mr_n82714272)
print v(xbgr.mr_n82714384)
print v(xbgr.mr_n82714704)
print v(xbgr.mr_n82715568)
print v(xbgr.mr_n82715680)
print v(xbgr.mr_n82716000)
print v(xbgr.mr_n82716112)
print v(xbgr.mr_n82716432)
print v(xbgr.mr_n82717296)
print v(xbgr.mr_n82717408)
print v(xbgr.mr_n82717728)
print v(xbgr.mr_n82717840)
print v(xbgr.mr_n82718160)
print v(xbgr.mr_n82718272)
print v(xbgr.mr_n82718592)
print v(xbgr.mr_n82718704)
print v(xbgr.mr_n82719024)
print v(xbgr.mr_n82720000)
print v(xbgr.mr_n82720432)
print v(xbgr.mr_n82720752)
print v(xbgr.mr_n82721616)
print v(xbgr.mr_n82722480)
print v(xbgr.mr_n82722592)
print v(xbgr.mr_n82722912)
print v(xbgr.mr_n82723024)
print v(xbgr.mr_n82723344)
print v(xbgr.mr_n82723456)
print v(xbgr.mr_n82723776)
print v(xbgr.mr_n82723888)
print v(xbgr.mr_n82724320)
print v(xbgr.mr_n82724752)
print v(xbgr.mr_n82725072)
print v(xbgr.mr_n82725184)
print v(xbgr.mr_n82725504)
print v(xbgr.mr_n82725616)
print v(xbgr.mr_n82725936)
print v(xbgr.mr_n82726048)
print v(xbgr.mr_n82726368)
print v(xbgr.mr_n82726480)
print v(xbgr.mr_n82726800)
print v(xbgr.mr_n82727664)
print v(xbgr.mr_n82728528)
print v(xbgr.mr_n82728640)
print v(xbgr.mr_n82728960)
print v(xbgr.mr_n82729824)
print v(xbgr.mr_n82730688)
print v(xbgr.mr_n82730800)
print v(xbgr.mr_n82731120)
print v(xbgr.mr_n82731232)
print v(xbgr.mr_n82731664)
print v(xbgr.mr_n82731984)
print v(xbgr.mr_n82732096)
print v(xbgr.mr_n82732528)
print v(xbgr.mr_n82732848)
print v(xbgr.mr_n82733280)
print v(xbgr.mr_n82733392)
print v(xbgr.mr_n82733712)
print v(xbgr.mr_n82733824)
print v(xbgr.mr_n82734144)
print v(xbgr.mr_n82734576)
print v(xbgr.mr_n82734688)
print v(xbgr.mr_n82735440)
print v(xbgr.mr_n82735552)
print v(xbgr.mr_n82735872)
print v(xbgr.mr_n82735984)
print v(xbgr.mr_n82736304)
print v(xbgr.mr_n82736736)
print v(xbgr.mr_n82736848)
print v(xbgr.mr_n82737168)
print v(xbgr.mr_n82737600)
print v(xbgr.mr_n82738464)
print v(xbgr.mr_n82740192)
print v(xbgr.mr_n82740304)
print v(xbgr.mr_n82740624)
print v(xbgr.mr_n82740736)
print v(xbgr.mr_n82741056)
print v(xbgr.mr_n82741168)
print v(xbgr.mr_n82741600)
print v(xbgr.mr_n82742032)
print v(xbgr.mr_n82742352)
print v(xbgr.mr_n82742464)
print v(xbgr.mr_n82742784)
print v(xbgr.mr_n82744192)
print v(xbgr.mr_n82744512)
print v(xbgr.mr_n82745488)
print v(xbgr.mr_n82745808)
print v(xbgr.mr_n82745920)
print v(xbgr.mr_n82746240)
print v(xbgr.mr_n82746352)
print v(xbgr.mr_n82746784)
print v(xbgr.mr_n82747104)
print v(xbgr.mr_n82747216)
print v(xbgr.mr_n82747648)
print v(xbgr.mr_n82747968)
print v(xbgr.mr_n82748080)
print v(xbgr.mr_n82748400)
print v(xbgr.mr_n82748512)
print v(xbgr.mr_n82748832)
print v(xbgr.mr_n82749696)
print v(xbgr.mr_n82750128)
print v(xbgr.mr_n82750992)
print v(xbgr.mr_n82751104)
print v(xbgr.mr_n82751424)
print v(xbgr.mr_n82751536)
print v(xbgr.mr_n82751856)
print v(xbgr.mr_n82751968)
print v(xbgr.mr_n82752720)
print v(xbgr.mr_n82753152)
print v(xbgr.mr_n82753264)
print v(xbgr.mr_n82753584)
print v(xbgr.mr_n82754016)
print v(xbgr.mr_n82754128)
print v(xbgr.mr_n82754448)
print v(xbgr.mr_n82754560)
print v(xbgr.mr_n82754880)
print v(xbgr.mr_n82754992)
print v(xbgr.mr_n82755312)
print v(xbgr.mr_n82755424)
print v(xbgr.mr_n82755744)
print v(xbgr.mr_n82755856)
print v(xbgr.mr_n82756176)
print v(xbgr.mr_n82757584)
print v(xbgr.mr_n82757904)
print v(xbgr.mr_n82758016)
print v(xbgr.mr_n82758448)
print v(xbgr.mr_n82758768)
print v(xbgr.mr_n82758880)
print v(xbgr.mr_n82759200)
print v(xbgr.mr_n82759632)
print v(xbgr.mr_n82760496)
print v(xbgr.mr_n82761360)
print v(xbgr.mr_n82762224)
print v(xbgr.mr_n82763088)
print v(xbgr.mr_n82763952)
print v(xbgr.mr_n82765248)
print v(xbgr.mr_n82765680)
print v(xbgr.mr_n82765792)
print v(xbgr.mr_n82766112)
print v(xbgr.mr_n82766544)
print v(xbgr.mr_n82766656)
print v(xbgr.mr_n82766976)
print v(xbgr.mr_n82767840)
print v(xbgr.mr_n82767952)
print v(xbgr.mr_n82768272)
print v(xbgr.mr_n82768384)
print v(xbgr.mr_n82768704)
print v(xbgr.mr_n82769568)
print v(xbgr.mr_n82769680)
print v(xbgr.mr_n82770544)
print v(xbgr.mr_n82770976)
print v(xbgr.mr_n82771408)
print v(xbgr.mr_n82772160)
print v(xbgr.mr_n82772272)
print v(xbgr.mr_n82772704)
print v(xbgr.mr_n82773456)
print v(xbgr.mr_n82773888)
print v(xbgr.mr_n82774000)
print v(xbgr.mr_n82774432)
print v(xbgr.mr_n82775184)
print v(xbgr.mr_n82775296)
print v(xbgr.mr_n82775616)
print v(xbgr.mr_n82775728)
print v(xbgr.mr_n82776048)
print v(xbgr.mr_n82776160)
print v(xbgr.mr_n82776480)
print v(xbgr.mr_n82776592)
print v(xbgr.mr_n82776912)
print v(xbgr.mr_n82777024)
print v(xbgr.mr_n82777344)
print v(xbgr.mr_n82777456)
print v(xbgr.mr_n82777776)
print v(xbgr.mr_n82777888)
print v(xbgr.mr_n82778208)
print v(xbgr.mr_n82778320)
print v(xbgr.mr_n82778640)
print v(xbgr.mr_n82778752)
print v(xbgr.mr_n82779072)
print v(xbgr.mr_n82779184)
print v(xbgr.mr_n82779504)
print v(xbgr.mr_n82779616)
print v(xbgr.mr_n82779936)
print v(xbgr.mr_n82780048)
print v(xbgr.mr_n82780368)
print v(xbgr.mr_n82780480)
print v(xbgr.mr_n82780800)
print v(xbgr.mr_n82780912)
print v(xbgr.mr_n82781344)
print v(xbgr.mr_n82781664)
print v(xbgr.mr_n82781776)
print v(xbgr.mr_n82782208)
print v(xbgr.mr_n82782528)
print v(xbgr.mr_n82782640)
print v(xbgr.mr_n82783392)
print v(xbgr.mr_n82783824)
print v(xbgr.mr_n82784688)
print v(xbgr.mr_n82785552)
print v(xbgr.mr_n82786416)
print v(xbgr.mr_n82786528)
print v(xbgr.mr_n82786848)
print v(xbgr.mr_n82786960)
print v(xbgr.mr_n82787280)
print v(xbgr.mr_n82787392)
print v(xbgr.mr_n82787712)
print v(xbgr.mr_n82787824)
print v(xbgr.mr_n82788576)
print v(xbgr.mr_n82789440)
print v(xbgr.mr_n82790304)
print v(xbgr.mr_n82791168)
print v(xbgr.mr_n82792464)
print v(xbgr.mr_n82792576)
print v(xbgr.mr_n82792896)
print v(xbgr.mr_n82793008)
print v(xbgr.mr_n82793328)
print v(xbgr.mr_n82793440)
print v(xbgr.mr_n82793872)
print v(xbgr.mr_n82794304)
print v(xbgr.mr_n82794736)
print v(xbgr.mr_n82795056)
print v(xbgr.mr_n82795168)
print v(xbgr.mr_n82795600)
print v(xbgr.mr_n82795920)
print v(xbgr.mr_n82796032)
print v(xbgr.mr_n82796352)
print v(xbgr.mr_n82796464)
print v(xbgr.mr_n82796784)
print v(xbgr.mr_n82796896)
print v(xbgr.mr_n82797216)
print v(xbgr.mr_n82797328)
print v(xbgr.mr_n82797648)
print v(xbgr.mr_n82797760)
print v(xbgr.mr_n82798192)
print v(xbgr.mr_n82798512)
print v(xbgr.mr_n82798624)
print v(xbgr.mr_n82799056)
print v(xbgr.mr_n82799376)
print v(xbgr.mr_n82799808)
print v(xbgr.mr_n82799920)
print v(xbgr.mr_n82800352)
print v(xbgr.mr_n82800672)
print v(xbgr.mr_n82800784)
print v(xbgr.mr_n82801216)
print v(xbgr.mr_n82801536)
print v(xbgr.mr_n82801648)
print v(xbgr.mr_n82802080)
print v(xbgr.mr_n82802400)
print v(xbgr.mr_n82802512)
print v(xbgr.mr_n82802832)
print v(xbgr.mr_n82802944)
print v(xbgr.mr_n82803264)
print v(xbgr.mr_n82804128)
print v(xbgr.mr_n82804992)
print v(xbgr.mr_n82805856)
print v(xbgr.mr_n82806720)
print v(xbgr.mr_n82807584)
print v(xbgr.mr_n82808448)
print v(xbgr.mr_n82808560)
print v(xbgr.mr_n82809312)
print v(xbgr.mr_n82810176)
print v(xbgr.mr_n82811040)
print v(xbgr.mr_n82811904)
print v(xbgr.mr_n82812768)
print v(xbgr.mr_n82813632)
print v(xbgr.mr_n82813744)
print v(xbgr.mr_n82814064)
print v(xbgr.mr_n82814176)
print v(xbgr.mr_n82814496)
print v(xbgr.mr_n82814608)
print v(xbgr.mr_n82814928)
print v(xbgr.mr_n82815040)
print v(xbgr.mr_n82815360)
print v(xbgr.mr_n82816224)
print v(xbgr.mr_n82817088)
print v(xbgr.mr_n82817952)
print v(xbgr.mr_n82818064)
print v(xbgr.mr_n82818384)
print v(xbgr.mr_n82818496)
print v(xbgr.mr_n82818816)
print v(xbgr.mr_n82818928)
print v(xbgr.mr_n82819248)
print v(xbgr.mr_n82820112)
print v(xbgr.mr_n82820976)
print v(xbgr.mr_n82821840)
print v(xbgr.mr_n82821952)
print v(xbgr.mr_n82822272)
print v(xbgr.mr_n82822384)
print v(xbgr.mr_n82822704)
print v(xbgr.mr_n82822816)
print v(xbgr.mr_n82823248)
print v(xbgr.mr_n82823680)
print v(xbgr.mr_n82824112)
print v(xbgr.mr_n82824432)
print v(xbgr.mr_n82824544)
print v(xbgr.mr_n82824864)
print v(xbgr.mr_n82824976)
print v(xbgr.mr_n82825296)
print v(xbgr.mr_n82825408)
print v(xbgr.mr_n82825728)
print v(xbgr.mr_n82825840)
print v(xbgr.mr_n82826160)
print v(xbgr.mr_n82826272)
print v(xbgr.mr_n82826592)
print v(xbgr.mr_n82826704)
print v(xbgr.mr_n82827024)
print v(xbgr.mr_n82827136)
print v(xbgr.mr_n82827456)
print v(xbgr.mr_n82827568)
print v(xbgr.mr_n82827888)
print v(xbgr.mr_n82828000)
print v(xbgr.mr_n82828432)
print v(xbgr.mr_n82828752)
print v(xbgr.mr_n82828864)
print v(xbgr.mr_n82829184)
print v(xbgr.mr_n82829616)
print v(xbgr.mr_n82829728)
print v(xbgr.mr_n82830048)
print v(xbgr.mr_n82830160)
print v(xbgr.mr_n82830480)
print v(xbgr.mr_n82830592)
print v(xbgr.mr_n82830912)
print v(xbgr.mr_n82831024)
print v(xbgr.mr_n82831776)
print v(xbgr.mr_n82831888)
print v(xbgr.mr_n82832640)
print v(xbgr.mr_n82833504)
print v(xbgr.mr_n82833616)
print v(xbgr.mr_n82833936)
print v(xbgr.mr_n82834048)
print v(xbgr.mr_n82834368)
print v(xbgr.mr_n82834480)
print v(xbgr.mr_n82834800)
print v(xbgr.mr_n82834912)
print v(xbgr.mr_n82835344)
print v(xbgr.mr_n82835776)
print v(xbgr.mr_n82836096)
print v(xbgr.mr_n82836208)
print v(xbgr.mr_n82836528)
print v(xbgr.mr_n82836640)
print v(xbgr.mr_n82836960)
print v(xbgr.mr_n82837824)
print v(xbgr.mr_n82839120)
print v(xbgr.mr_n82839984)
print v(xbgr.mr_n82840096)
print v(xbgr.mr_n82840416)
print v(xbgr.mr_n82840528)
print v(xbgr.mr_n82840848)
print v(xbgr.mr_n82840960)
print v(xbgr.mr_n82841280)
print v(xbgr.mr_n82841392)
print v(xbgr.mr_n82841824)
print v(xbgr.mr_n82842144)
print v(xbgr.mr_n82842256)
print v(xbgr.mr_n82842576)
print v(xbgr.mr_n82842688)
print v(xbgr.mr_n82843008)
print v(xbgr.mr_n82843120)
print v(xbgr.mr_n82843552)
print v(xbgr.mr_n82843872)
print v(xbgr.mr_n82843984)
print v(xbgr.mr_n82844304)
print v(xbgr.mr_n82844416)
print v(xbgr.mr_n82844736)
print v(xbgr.mr_n82845600)
print v(xbgr.mr_n82846464)
print v(xbgr.mr_n82847328)
print v(xbgr.mr_n82848192)
print v(xbgr.mr_n82848304)
print v(xbgr.mr_n82848624)
print v(xbgr.mr_n82848736)
print v(xbgr.mr_n82849168)
print v(xbgr.mr_n82849600)
print v(xbgr.mr_n82849920)
print v(xbgr.mr_n82850032)
print v(xbgr.mr_n82850352)
print v(xbgr.mr_n82851216)
print v(xbgr.mr_n82852080)
print v(xbgr.mr_n82852192)
print v(xbgr.mr_n82852512)
print v(xbgr.mr_n82852624)
print v(xbgr.mr_n82852944)
print v(xbgr.mr_n82853056)
print v(xbgr.mr_n82853376)
print v(xbgr.mr_n82853488)
print v(xbgr.mr_n82853808)
print v(xbgr.mr_n82853920)
print v(xbgr.mr_n82854352)
print v(xbgr.mr_n82854672)
print v(xbgr.mr_n82854784)
print v(xbgr.mr_n82855536)
print v(xbgr.mr_n82856400)
print v(xbgr.mr_n82856512)
print v(xbgr.mr_n82856832)
print v(xbgr.mr_n82856944)
print v(xbgr.mr_n82857376)
print v(xbgr.mr_n82857696)
print v(xbgr.mr_n82857808)
print v(xbgr.mr_n82858128)
print v(xbgr.mr_n82858240)
print v(xbgr.mr_n82858560)
print v(xbgr.mr_n82858672)
print v(xbgr.mr_n82858992)
print v(xbgr.mr_n82859104)
print v(xbgr.mr_n82859424)
print v(xbgr.mr_n82859536)
print v(xbgr.mr_n82859856)
print v(xbgr.mr_n82860720)
print v(xbgr.mr_n82861696)
print v(xbgr.mr_n82862016)
print v(xbgr.mr_n82862880)
print v(xbgr.mr_n82863744)
print v(xbgr.mr_n82864608)
print v(xbgr.mr_n82865040)
print v(xbgr.mr_n82865472)
print v(xbgr.mr_n82865584)
print v(xbgr.mr_n82865904)
print v(xbgr.mr_n82866016)
print v(xbgr.mr_n82866336)
print v(xbgr.mr_n82866448)
print v(xbgr.mr_n82866768)
print v(xbgr.mr_n82866880)
print v(xbgr.mr_n82867200)
print v(xbgr.mr_n82867312)
print v(xbgr.mr_n82867632)
print v(xbgr.mr_n82867744)
print v(xbgr.mr_n82868064)
print v(xbgr.mr_n82868928)
print v(xbgr.mr_n82869792)
print v(xbgr.mr_n82869904)
print v(xbgr.mr_n82870224)
print v(xbgr.mr_n82870336)
print v(xbgr.mr_n82870656)
print v(xbgr.mr_n82870768)
print v(xbgr.mr_n82871088)
print v(xbgr.mr_n82871200)
print v(xbgr.mr_n82872816)
print v(xbgr.mr_n82873680)
print v(xbgr.mr_n82873792)
print v(xbgr.mr_n82874112)
print v(xbgr.mr_n82874224)
print v(xbgr.mr_n82874544)
print v(xbgr.mr_n82874976)
print v(xbgr.mr_n82875088)
print v(xbgr.mr_n82875408)
print v(xbgr.mr_n82875520)
print v(xbgr.mr_n82875840)
print v(xbgr.mr_n82875952)
print v(xbgr.mr_n82876384)
print v(xbgr.mr_n82876704)
print v(xbgr.mr_n82876816)
print v(xbgr.mr_n82877248)
print v(xbgr.mr_n82878000)
print v(xbgr.mr_n82878864)
print v(xbgr.mr_n82880160)
print v(xbgr.mr_n82880272)
print v(xbgr.mr_n82880704)
print v(xbgr.mr_n82881024)
print v(xbgr.mr_n82881888)
print v(xbgr.mr_n82882752)
print v(xbgr.mr_n82883184)
print v(xbgr.mr_n82884480)
print v(xbgr.mr_n82885344)
print v(xbgr.mr_n82885776)
print v(xbgr.mr_n82886640)
print v(xbgr.mr_n82887936)
print v(xbgr.mr_n82888048)
print v(xbgr.mr_n82888368)
print v(xbgr.mr_n82888480)
print v(xbgr.mr_n82888800)
print v(xbgr.mr_n82888912)
print v(xbgr.mr_n82889232)
print v(xbgr.mr_n82889344)
print v(xbgr.mr_n82889664)
print v(xbgr.mr_n82889776)
print v(xbgr.mr_n82890096)
print v(xbgr.mr_n82890208)
print v(xbgr.mr_n82890528)
print v(xbgr.mr_n82890640)
print v(xbgr.mr_n82891392)
print v(xbgr.mr_n82891504)
print v(xbgr.mr_n82891936)
print v(xbgr.mr_n82892256)
print v(xbgr.mr_n82892368)
print v(xbgr.mr_n82892688)
print v(xbgr.mr_n82892800)
print v(xbgr.mr_n82893120)
print v(xbgr.mr_n82893232)
print v(xbgr.mr_n82893552)
print v(xbgr.mr_n82893664)
print v(xbgr.mr_n82893984)
print v(xbgr.mr_n82894096)
print v(xbgr.mr_n82894528)
print v(xbgr.mr_n82894848)
print v(xbgr.mr_n82895392)
print v(xbgr.mr_n82895712)
print v(xbgr.mr_n82895824)
print v(xbgr.mr_n82896256)
print v(xbgr.mr_n82896576)
print v(xbgr.mr_n82896688)
print v(xbgr.mr_n82897120)
print v(xbgr.mr_n82897440)
print v(xbgr.mr_n82897552)
print v(xbgr.mr_n82897872)
print v(xbgr.mr_n82897984)
print v(xbgr.mr_n82898304)
print v(xbgr.mr_n82898416)
print v(xbgr.mr_n82898736)
print v(xbgr.mr_n82898848)
print v(xbgr.mr_n82899168)
print v(xbgr.mr_n82899280)
print v(xbgr.mr_n82899600)
print v(xbgr.mr_n82899712)
print v(xbgr.mr_n82900032)
print v(xbgr.mr_n82900144)
print v(xbgr.mr_n82900464)
print v(xbgr.mr_n82900576)
print v(xbgr.mr_n82900896)
print v(xbgr.mr_n82901760)
print v(xbgr.mr_n82901872)
print v(xbgr.mr_n82902192)
print v(xbgr.mr_n82902304)
print v(xbgr.mr_n82902624)
print v(xbgr.mr_n82902736)
print v(xbgr.mr_n82903056)
print v(xbgr.mr_n82903168)
print v(xbgr.mr_n82903488)
print v(xbgr.mr_n82904352)
print v(xbgr.mr_n82905216)
print v(xbgr.mr_n82906080)
print v(xbgr.mr_n82906624)
print v(xbgr.mr_n82907056)
print v(xbgr.mr_n82907376)
print v(xbgr.mr_n82907488)
print v(xbgr.mr_n82907808)
print v(xbgr.mr_n82907920)
print v(xbgr.mr_n82908240)
print v(xbgr.mr_n82908352)
print v(xbgr.mr_n82908672)
print v(xbgr.mr_n82908784)
print v(xbgr.mr_n82909104)
print v(xbgr.mr_n82910400)
print v(xbgr.mr_n82911264)
print v(xbgr.mr_n82912240)
print v(xbgr.mr_n82912672)
print v(xbgr.mr_n82912992)
print v(xbgr.mr_n82913424)
print v(xbgr.mr_n82914288)
print v(xbgr.mr_n82915152)
print v(xbgr.mr_n82915264)
print v(xbgr.mr_n82915584)
print v(xbgr.mr_n82915696)
print v(xbgr.mr_n82916016)
print v(xbgr.mr_n82916128)
print v(xbgr.mr_n82916448)
print v(xbgr.mr_n82916560)
print v(xbgr.mr_n82917744)
print v(xbgr.mr_n82917856)
print v(xbgr.mr_n82918176)
print v(xbgr.mr_n82918288)
print v(xbgr.mr_n82918608)
print v(xbgr.mr_n82918720)
print v(xbgr.mr_n82919152)
print v(xbgr.mr_n82919472)
print v(xbgr.mr_n82919904)
print v(xbgr.mr_n82920016)
print v(xbgr.mr_n82920448)
print v(xbgr.mr_n82920768)
print v(xbgr.mr_n82921632)
print v(xbgr.mr_n82921744)
print v(xbgr.mr_n82922176)
print v(xbgr.mr_n82922496)
print v(xbgr.mr_n82922608)
print v(xbgr.mr_n82923360)
print v(xbgr.mr_n82923904)
print v(xbgr.mr_n82924224)
print v(xbgr.mr_n82924336)
print v(xbgr.mr_n82924656)
print v(xbgr.mr_n82924768)
print v(xbgr.mr_n82925088)
print v(xbgr.mr_n82925200)
print v(xbgr.mr_n82925520)
print v(xbgr.mr_n82925952)
print v(xbgr.mr_n82926064)
print v(xbgr.mr_n82926384)
print v(xbgr.mr_n82926496)
print v(xbgr.mr_n82926816)
print v(xbgr.mr_n82926928)
print v(xbgr.mr_n82927680)
print v(xbgr.mr_n82927792)
print v(xbgr.mr_n82928224)
print v(xbgr.mr_n82928544)
print v(xbgr.mr_n82928656)
print v(xbgr.mr_n82928976)
print v(xbgr.mr_n82929088)
print v(xbgr.mr_n82929408)
print v(xbgr.mr_n82929520)
print v(xbgr.mr_n82929840)
print v(xbgr.mr_n82930704)
print v(xbgr.mr_n82931136)
print v(xbgr.mr_n82931568)
print v(xbgr.mr_n82931680)
print v(xbgr.mr_n82932000)
print v(xbgr.mr_n82932112)
print v(xbgr.mr_n82932864)
print v(xbgr.mr_n82932976)
print v(xbgr.mr_n82933296)
print v(xbgr.mr_n82933408)
print v(xbgr.mr_n82934160)
print v(xbgr.mr_n82935024)
print v(xbgr.mr_n82935136)
print v(xbgr.mr_n82935456)
print v(xbgr.mr_n82936320)
print v(xbgr.mr_n82936432)
print v(xbgr.mr_n82936752)
print v(xbgr.mr_n82936864)
print v(xbgr.mr_n82937184)
print v(xbgr.mr_n82937296)
print v(xbgr.mr_n82937616)
print v(xbgr.mr_n82937728)
print v(xbgr.mr_n82938048)
print v(xbgr.mr_n82938160)
print v(xbgr.mr_n82938480)
print v(xbgr.mr_n82938592)
print v(xbgr.mr_n82938912)
print v(xbgr.mr_n82939024)
print v(xbgr.mr_n82939456)
print v(xbgr.mr_n82939888)
print v(xbgr.mr_n82940208)
print v(xbgr.mr_n82940640)
print v(xbgr.mr_n82940752)
print v(xbgr.mr_n82941936)
print v(xbgr.mr_n82943664)
print v(xbgr.mr_n82943776)
print v(xbgr.mr_n82944208)
print v(xbgr.mr_n82944528)
print v(xbgr.mr_n82944640)
print v(xbgr.mr_n82944960)
print v(xbgr.mr_n82945072)
print v(xbgr.mr_n82945504)
print v(xbgr.mr_n82945824)
print v(xbgr.mr_n82945936)
print v(xbgr.mr_n82946256)
print v(xbgr.mr_n82946688)
print v(xbgr.mr_n82946800)
print v(xbgr.mr_n82947552)
print v(xbgr.mr_n82947664)
print v(xbgr.mr_n82947984)
print v(xbgr.mr_n82948096)
print v(xbgr.mr_n82948416)
print v(xbgr.mr_n82948528)
print v(xbgr.mr_n82948848)
print v(xbgr.mr_n82948960)
print v(xbgr.mr_n82949280)
print v(xbgr.mr_n82949392)
print v(xbgr.mr_n82949712)
print v(xbgr.mr_n82950576)
print v(xbgr.mr_n82951440)
print v(xbgr.mr_n82952304)
print v(xbgr.mr_n82952416)
print v(xbgr.mr_n82952736)
print v(xbgr.mr_n82953168)
print v(xbgr.mr_n82953280)
print v(xbgr.mr_n82953600)
print v(xbgr.mr_n82953712)
print v(xbgr.mr_n82954032)
print v(xbgr.mr_n82954144)
print v(xbgr.mr_n82954464)
print v(xbgr.mr_n82955328)
print v(xbgr.mr_n82956304)
print v(xbgr.mr_n82956624)
print v(xbgr.mr_n82956736)
print v(xbgr.mr_n82957056)
print v(xbgr.mr_n82957168)
print v(xbgr.mr_n82957488)
print v(xbgr.mr_n82957600)
print v(xbgr.mr_n82957920)
print v(xbgr.mr_n82958032)
print v(xbgr.mr_n82958352)
print v(xbgr.mr_n82958896)
print v(xbgr.mr_n82959328)
print v(xbgr.mr_n82959760)
print v(xbgr.mr_n82960944)
print v(xbgr.mr_n82961056)
print v(xbgr.mr_n82961376)
print v(xbgr.mr_n82961488)
print v(xbgr.mr_n82961808)
print v(xbgr.mr_n82962672)
print v(xbgr.mr_n82962784)
print v(xbgr.mr_n82963104)
print v(xbgr.mr_n82963216)
print v(xbgr.mr_n82963536)
print v(xbgr.mr_n82963968)
print v(xbgr.mr_n82964832)
print v(xbgr.mr_n82966128)
print v(xbgr.mr_n82966240)
print v(xbgr.mr_n82966560)
print v(xbgr.mr_n82966672)
print v(xbgr.mr_n82966992)
print v(xbgr.mr_n82967424)
print v(xbgr.mr_n82968288)
print v(xbgr.mr_n82968720)
print v(xbgr.mr_n82968832)
print v(xbgr.mr_n82969152)
print v(xbgr.mr_n82969264)
print v(xbgr.mr_n82969584)
print v(xbgr.mr_n82969696)
print v(xbgr.mr_n82970016)
print v(xbgr.mr_n82970128)
print v(xbgr.mr_n82970880)
print v(xbgr.mr_n82970992)
print v(xbgr.mr_n82971744)
print v(xbgr.mr_n82972720)
print v(xbgr.mr_n82973040)
print v(xbgr.mr_n82973152)
print v(xbgr.mr_n82973472)
print v(xbgr.mr_n82973584)
print v(xbgr.mr_n82973904)
print v(xbgr.mr_n82974336)
print v(xbgr.mr_n82975200)
print v(xbgr.mr_n82975312)
print v(xbgr.mr_n82975632)
print v(xbgr.mr_n82975744)
print v(xbgr.mr_n82976064)
print v(xbgr.mr_n82976176)
print v(xbgr.mr_n82976496)
print v(xbgr.mr_n82976608)
print v(xbgr.mr_n82976928)
print v(xbgr.mr_n82977040)
print v(xbgr.mr_n82977472)
print v(xbgr.mr_n82978224)
print v(xbgr.mr_n82979200)
print v(xbgr.mr_n82979632)
print v(xbgr.mr_n82979952)
print v(xbgr.mr_n82980384)
print v(xbgr.mr_n82981360)
print v(xbgr.mr_n82981792)
print v(xbgr.mr_n82982112)
print v(xbgr.mr_n82982544)
print v(xbgr.mr_n82982656)
print v(xbgr.mr_n82982976)
print v(xbgr.mr_n82983088)
print v(xbgr.mr_n82983408)
print v(xbgr.mr_n82983520)
print v(xbgr.mr_n82983840)
print v(xbgr.mr_n82983952)
print v(xbgr.mr_n82984704)
print v(xbgr.mr_n82985568)
print v(xbgr.mr_n82986864)
print v(xbgr.mr_n82986976)
print v(xbgr.mr_n82987296)
print v(xbgr.mr_n82987408)
print v(xbgr.mr_n82987728)
print v(xbgr.mr_n82987840)
print v(xbgr.mr_n82988160)
print v(xbgr.mr_n82988272)
print v(xbgr.mr_n82988592)
print v(xbgr.mr_n82988704)
print v(xbgr.mr_n82989024)
print v(xbgr.mr_n82989456)
print v(xbgr.mr_n82989568)
print v(xbgr.mr_n82989888)
print v(xbgr.mr_n82990000)
print v(xbgr.mr_n82990320)
print v(xbgr.mr_n82990432)
print v(xbgr.mr_n82990752)
print v(xbgr.mr_n82990864)
print v(xbgr.mr_n82991184)
print v(xbgr.mr_n82991296)
print v(xbgr.mr_n82991616)
print v(xbgr.mr_n82991728)
print v(xbgr.mr_n82992048)
print v(xbgr.mr_n82992160)
print v(xbgr.mr_n82992480)
print v(xbgr.mr_n82992592)
print v(xbgr.mr_n82992912)
print v(xbgr.mr_n82993024)
print v(xbgr.mr_n82993456)
print v(xbgr.mr_n82993776)
print v(xbgr.mr_n82993888)
print v(xbgr.mr_n82994320)
print v(xbgr.mr_n82994752)
print v(xbgr.mr_n82995072)
print v(xbgr.mr_n82995184)
print v(xbgr.mr_n82995504)
print v(xbgr.mr_n82995616)
print v(xbgr.mr_n82995936)
print v(xbgr.mr_n82996048)
print v(xbgr.mr_n82996368)
print v(xbgr.mr_n82996480)
print v(xbgr.mr_n82997232)
print v(xbgr.mr_n82997344)
print v(xbgr.mr_n82997776)
print v(xbgr.mr_n82998096)
print v(xbgr.mr_n82998640)
print v(xbgr.mr_n82998960)
print v(xbgr.mr_n82999824)
print v(xbgr.mr_n82999936)
print v(xbgr.mr_n83000256)
print v(xbgr.mr_n83000688)
print v(xbgr.mr_n83001120)
print v(xbgr.mr_n83001552)
print v(xbgr.mr_n83001664)
print v(xbgr.mr_n83002416)
print v(xbgr.mr_n83002528)
print v(xbgr.mr_n83002848)
print v(xbgr.mr_n83002960)
print v(xbgr.mr_n83003280)
print v(xbgr.mr_n83003712)
print v(xbgr.mr_n83003824)
print v(xbgr.mr_n83004144)
print v(xbgr.mr_n83004256)
print v(xbgr.mr_n83004576)
print v(xbgr.mr_n83004688)
print v(xbgr.mr_n83005008)
print v(xbgr.mr_n83005440)
print v(xbgr.mr_n83006304)
print v(xbgr.mr_n83007168)
print v(xbgr.mr_n83008464)
print v(xbgr.mr_n83009328)
print v(xbgr.mr_n83010192)
print v(xbgr.mr_n83011056)
print v(xbgr.mr_n83011168)
print v(xbgr.mr_n83011488)
print v(xbgr.mr_n83012352)
print v(xbgr.mr_n83013216)
print v(xbgr.mr_n83014080)
print v(xbgr.mr_n83014192)
print v(xbgr.mr_n83014512)
print v(xbgr.mr_n83014624)
print v(xbgr.mr_n83014944)
print v(xbgr.mr_n83015056)
print v(xbgr.mr_n83015376)
print v(xbgr.mr_n83015488)
print v(xbgr.mr_n83015808)
print v(xbgr.mr_n83015920)
print v(xbgr.mr_n83016240)
print v(xbgr.mr_n83016352)
print v(xbgr.mr_n83017968)
print v(xbgr.mr_n83018944)
print v(xbgr.mr_n83019376)
print v(xbgr.mr_n83019808)
print v(xbgr.mr_n83020128)
print v(xbgr.mr_n83020240)
print v(xbgr.mr_n83020560)
print v(xbgr.mr_n83020672)
print v(xbgr.mr_n83020992)
print v(xbgr.mr_n83021104)
print v(xbgr.mr_n83021424)
print v(xbgr.mr_n83021536)
print v(xbgr.mr_n83021856)
print v(xbgr.mr_n83021968)
print v(xbgr.mr_n83022288)
print v(xbgr.mr_n83022400)
print v(xbgr.mr_n83022720)
print v(xbgr.mr_n83022832)
print v(xbgr.mr_n83023264)
print v(xbgr.mr_n83023584)
print v(xbgr.mr_n83023696)
print v(xbgr.mr_n83024128)
print v(xbgr.mr_n83024560)
print v(xbgr.mr_n83025744)
print v(xbgr.mr_n83025856)
print v(xbgr.mr_n83026176)
print v(xbgr.mr_n83026288)
print v(xbgr.mr_n83026608)
print v(xbgr.mr_n83026720)
print v(xbgr.mr_n83027040)
print v(xbgr.mr_n83027152)
print v(xbgr.mr_n83027472)
print v(xbgr.mr_n83027584)
print v(xbgr.mr_n83027904)
print v(xbgr.mr_n83028336)
print v(xbgr.mr_n83028448)
print v(xbgr.mr_n83028768)
print v(xbgr.mr_n83028880)
print v(xbgr.mr_n83029200)
print v(xbgr.mr_n83029312)
print v(xbgr.mr_n83029632)
print v(xbgr.mr_n83029744)
print v(xbgr.mr_n83030176)
print v(xbgr.mr_n83030496)
print v(xbgr.mr_n83030928)
print v(xbgr.mr_n83031792)
print v(xbgr.mr_n83031904)
print v(xbgr.mr_n83032224)
print v(xbgr.mr_n83032656)
print v(xbgr.mr_n83033088)
print v(xbgr.mr_n83033632)
print v(xbgr.mr_n83033952)
print v(xbgr.mr_n83034816)
print v(xbgr.mr_n83034928)
print v(xbgr.mr_n83035248)
print v(xbgr.mr_n83035360)
print v(xbgr.mr_n83035792)
print v(xbgr.mr_n83036544)
print v(xbgr.mr_n83036976)
print v(xbgr.mr_n83037408)
print v(xbgr.mr_n83037840)
print v(xbgr.mr_n83037952)
print v(xbgr.mr_n83039136)
print v(xbgr.mr_n83040000)
print v(xbgr.mr_n83040976)
print v(xbgr.mr_n83041296)
print v(xbgr.mr_n83041408)
print v(xbgr.mr_n83041840)
print v(xbgr.mr_n83042160)
print v(xbgr.mr_n83042272)
print v(xbgr.mr_n83042592)
print v(xbgr.mr_n83042704)
print v(xbgr.mr_n83043024)
print v(xbgr.mr_n83043136)
print v(xbgr.mr_n83043456)
print v(xbgr.mr_n83043568)
print v(xbgr.mr_n83043888)
print v(xbgr.mr_n83044000)
print v(xbgr.mr_n83044320)
print v(xbgr.mr_n83044432)
print v(xbgr.mr_n83044864)
print v(xbgr.mr_n83045296)
print v(xbgr.mr_n83045728)
print v(xbgr.mr_n83046480)
print v(xbgr.mr_n83046912)
print v(xbgr.mr_n83047776)
print v(xbgr.mr_n83048640)
print v(xbgr.mr_n83050368)
print v(xbgr.mr_n83051232)
print v(xbgr.mr_n83051344)
print v(xbgr.mr_n83052096)
print v(xbgr.mr_n83052208)
print v(xbgr.mr_n83052528)
print v(xbgr.mr_n83052640)
print v(xbgr.mr_n83052960)
print v(xbgr.mr_n83053072)
print v(xbgr.mr_n83055120)
print v(xbgr.mr_n83055232)
print v(xbgr.mr_n83055552)
print v(xbgr.mr_n83055664)
print v(xbgr.mr_n83055984)
print v(xbgr.mr_n83056096)
print v(xbgr.mr_n83056416)
print v(xbgr.mr_n83056528)
print v(xbgr.mr_n83056848)
print v(xbgr.mr_n83056960)
print v(xbgr.mr_n83057280)
print v(xbgr.mr_n83057392)
print v(xbgr.mr_n83057712)
print v(xbgr.mr_n83057824)
print v(xbgr.mr_n83058256)
print v(xbgr.mr_n83058576)
print v(xbgr.mr_n83058688)
print v(xbgr.mr_n83059120)
print v(xbgr.mr_n83059440)
print v(xbgr.mr_n83059552)
print v(xbgr.mr_n83059984)
print v(xbgr.mr_n83060304)
print v(xbgr.mr_n83060416)
print v(xbgr.mr_n83060736)
print v(xbgr.mr_n83060848)
print v(xbgr.mr_n83061168)
print v(xbgr.mr_n83061280)
print v(xbgr.mr_n83061600)
print v(xbgr.mr_n83061712)
print v(xbgr.mr_n83062032)
print v(xbgr.mr_n83062144)
print v(xbgr.mr_n83062464)
print v(xbgr.mr_n83062576)
print v(xbgr.mr_n83062896)
print v(xbgr.mr_n83063008)
print v(xbgr.mr_n83063328)
print v(xbgr.mr_n83063440)
print v(xbgr.mr_n83063760)
print v(xbgr.mr_n83063872)
print v(xbgr.mr_n83064192)
print v(xbgr.mr_n83064304)
print v(xbgr.mr_n83064624)
print v(xbgr.mr_n83064736)
print v(xbgr.mr_n83065056)
print v(xbgr.mr_n83065168)
print v(xbgr.mr_n83065488)
print v(xbgr.mr_n83065600)
print v(xbgr.mr_n83065920)
print v(xbgr.mr_n83066032)
print v(xbgr.mr_n83066352)
print v(xbgr.mr_n83066464)
print v(xbgr.mr_n83066784)
print v(xbgr.mr_n83066896)
print v(xbgr.mr_n83067216)
print v(xbgr.mr_n83067328)
print v(xbgr.mr_n83067648)
print v(xbgr.mr_n83067760)
print v(xbgr.mr_n83068192)
print v(xbgr.mr_n83068512)
print v(xbgr.mr_n83068624)
print v(xbgr.mr_n83069056)
print v(xbgr.mr_n83069376)
print v(xbgr.mr_n83069488)
print v(xbgr.mr_n83069920)
print v(xbgr.mr_n83070240)
print v(xbgr.mr_n83071104)
print v(xbgr.mr_n83071968)
print v(xbgr.mr_n83072832)
print v(xbgr.mr_n83073696)
print v(xbgr.mr_n83074560)
print v(xbgr.mr_n83075424)
print v(xbgr.mr_n83075536)
print v(xbgr.mr_n83075856)
print v(xbgr.mr_n83075968)
print v(xbgr.mr_n83076288)
print v(xbgr.mr_n83076400)
print v(xbgr.mr_n83076720)
print v(xbgr.mr_n83076832)
print v(xbgr.mr_n83077152)
print v(xbgr.mr_n83077264)
print v(xbgr.mr_n83077584)
print v(xbgr.mr_n83077696)
print v(xbgr.mr_n83078016)
print v(xbgr.mr_n83078880)
print v(xbgr.mr_n83079744)
print v(xbgr.mr_n83080608)
print v(xbgr.mr_n83080720)
print v(xbgr.mr_n83081040)
print v(xbgr.mr_n83081152)
print v(xbgr.mr_n83081472)
print v(xbgr.mr_n83081584)
print v(xbgr.mr_n83082016)
print v(xbgr.mr_n83082448)
print v(xbgr.mr_n83082880)
print v(xbgr.mr_n83083200)
print v(xbgr.mr_n83083312)
print v(xbgr.mr_n83083744)
print v(xbgr.mr_n83084064)
print v(xbgr.mr_n83084176)
print v(xbgr.mr_n83084496)
print v(xbgr.mr_n83084608)
print v(xbgr.mr_n83084928)
print v(xbgr.mr_n83085040)
print v(xbgr.mr_n83085360)
print v(xbgr.mr_n83085472)
print v(xbgr.mr_n83085792)
print v(xbgr.mr_n83085904)
print v(xbgr.mr_n83086224)
print v(xbgr.mr_n83086336)
print v(xbgr.mr_n83086768)
print v(xbgr.mr_n83087200)
print v(xbgr.mr_n83087520)
print v(xbgr.mr_n83087632)
print v(xbgr.mr_n83088064)
print v(xbgr.mr_n83088384)
print v(xbgr.mr_n83088496)
print v(xbgr.mr_n83088928)
print v(xbgr.mr_n83089248)
print v(xbgr.mr_n83089360)
print v(xbgr.mr_n83089792)
print v(xbgr.mr_n83090112)
print v(xbgr.mr_n83090976)
print v(xbgr.mr_n83091840)
print v(xbgr.mr_n83092704)
print v(xbgr.mr_n83093568)
print v(xbgr.mr_n83094432)
print v(xbgr.mr_n83094544)
print v(xbgr.mr_n83094864)
print v(xbgr.mr_n83094976)
print v(xbgr.mr_n83095296)
print v(xbgr.mr_n83095408)
print v(xbgr.mr_n83095728)
print v(xbgr.mr_n83095840)
print v(xbgr.mr_n83096160)
print v(xbgr.mr_n83097024)
print v(xbgr.mr_n83097888)
print v(xbgr.mr_n83098752)
print v(xbgr.mr_n83098864)
print v(xbgr.mr_n83099184)
print v(xbgr.mr_n83099296)
print v(xbgr.mr_n83099616)
print v(xbgr.mr_n83099728)
print v(xbgr.mr_n83100048)
print v(xbgr.mr_n83100160)
print v(xbgr.mr_n83100480)
print v(xbgr.mr_n83100592)
print v(xbgr.mr_n83100912)
print v(xbgr.mr_n83101024)
print v(xbgr.mr_n83101344)
print v(xbgr.mr_n83102208)
print v(xbgr.mr_n83103072)
print v(xbgr.mr_n83103936)
print v(xbgr.mr_n83104800)
print v(xbgr.mr_n83105664)
print v(xbgr.mr_n83106528)
print v(xbgr.mr_n83107392)
print v(xbgr.mr_n83108256)
print v(xbgr.mr_n83109120)
print v(xbgr.mr_n83109232)
print v(xbgr.mr_n83109552)
print v(xbgr.mr_n83109664)
print v(xbgr.mr_n83109984)
print v(xbgr.mr_n83110096)
print v(xbgr.mr_n83110416)
print v(xbgr.mr_n83110528)
print v(xbgr.mr_n83110848)
print v(xbgr.mr_n83110960)
print v(xbgr.mr_n83111280)
print v(xbgr.mr_n83111392)
print v(xbgr.mr_n83111712)
print v(xbgr.mr_n83111824)
print v(xbgr.mr_n83112144)
print v(xbgr.mr_n83112256)
print v(xbgr.mr_n83112576)
print v(xbgr.mr_n83112688)
print v(xbgr.mr_n83113008)
print v(xbgr.mr_n83113120)
print v(xbgr.mr_n83113440)
print v(xbgr.mr_n83114304)
print v(xbgr.mr_n83114416)
print v(xbgr.mr_n83114736)
print v(xbgr.mr_n83114848)
print v(xbgr.mr_n83115168)
print v(xbgr.mr_n83115280)
print v(xbgr.mr_n83115600)
print v(xbgr.mr_n83115712)
print v(xbgr.mr_n83116032)
print v(xbgr.mr_n83116144)
print v(xbgr.mr_n83116464)
print v(xbgr.mr_n83116576)
print v(xbgr.mr_n83116896)
print v(xbgr.mr_n83117008)
print v(xbgr.mr_n83117328)
print v(xbgr.mr_n83117440)
print v(xbgr.mr_n83117760)
print v(xbgr.mr_n83117872)
print v(xbgr.mr_n83118192)
print v(xbgr.mr_n83118304)
print v(xbgr.mr_n83118624)
print v(xbgr.mr_n83118736)
print v(xbgr.mr_n83119168)
print v(xbgr.mr_n83119488)
print v(xbgr.mr_n83119600)
print v(xbgr.mr_n83120032)
print v(xbgr.mr_n83120352)
print v(xbgr.mr_n83120464)
print v(xbgr.mr_n83120896)
print v(xbgr.mr_n83121216)
print v(xbgr.mr_n83121328)
print v(xbgr.mr_n83121760)
print v(xbgr.mr_n83122080)
print v(xbgr.mr_n83122192)
print v(xbgr.mr_n83122512)
print v(xbgr.mr_n83122624)
print v(xbgr.mr_n83123056)
print v(xbgr.mr_n83123488)
print v(xbgr.mr_n83123808)
print v(xbgr.mr_n83123920)
print v(xbgr.mr_n83124240)
print v(xbgr.mr_n83124352)
print v(xbgr.mr_n83124672)
print v(xbgr.mr_n83124784)
print v(xbgr.mr_n83125104)
print v(xbgr.mr_n83125216)
print v(xbgr.mr_n83125536)
print v(xbgr.mr_n83125648)
print v(xbgr.mr_n83126080)
print v(xbgr.mr_n83126400)
print v(xbgr.mr_n83126512)
print v(xbgr.mr_n83126944)
print v(xbgr.mr_n83127264)
print v(xbgr.mr_n83128128)
print v(xbgr.mr_n83128992)
print v(xbgr.mr_n83129856)
print v(xbgr.mr_n83130720)
print v(xbgr.mr_n83130832)
print v(xbgr.mr_n83131152)
print v(xbgr.mr_n83131264)
print v(xbgr.mr_n83131584)
print v(xbgr.mr_n83131696)
print v(xbgr.mr_n83132016)
print v(xbgr.mr_n83132128)
print v(xbgr.mr_n83132448)
print v(xbgr.mr_n83133312)
print v(xbgr.mr_n83134176)
print v(xbgr.mr_n83134288)
print v(xbgr.mr_n83134608)
print v(xbgr.mr_n83134720)
print v(xbgr.mr_n83135152)
print v(xbgr.mr_n83135584)
print v(xbgr.mr_n83135904)
print v(xbgr.mr_n83136016)
print v(xbgr.mr_n83136336)
print v(xbgr.mr_n83136448)
print v(xbgr.mr_n83136768)
print v(xbgr.mr_n83136880)
print v(xbgr.mr_n83137200)
print v(xbgr.mr_n83137312)
print v(xbgr.mr_n83137632)
print v(xbgr.mr_n83137744)
print v(xbgr.mr_n83138176)
print v(xbgr.mr_n83138496)
print v(xbgr.mr_n83138608)
print v(xbgr.mr_n83139040)
print v(xbgr.mr_n83139360)
print v(xbgr.mr_n83139472)
print v(xbgr.mr_n83139792)
print v(xbgr.mr_n83139904)
print v(xbgr.mr_n83140224)
print v(xbgr.mr_n83140336)
print v(xbgr.mr_n83140656)
print v(xbgr.mr_n83140768)
print v(xbgr.mr_n83141088)
print v(xbgr.mr_n83141200)
print v(xbgr.mr_n83141520)
print v(xbgr.mr_n83141632)
print v(xbgr.mr_n83141952)
print v(xbgr.mr_n83142064)
print v(xbgr.mr_n83142384)
print v(xbgr.mr_n83142496)
print v(xbgr.mr_n83142816)
print v(xbgr.mr_n83142928)
print v(xbgr.mr_n83143248)
print v(xbgr.mr_n83143360)
print v(xbgr.mr_n83143680)
print v(xbgr.mr_n83144544)
print v(xbgr.mr_n83145408)
print v(xbgr.mr_n83146272)
print v(xbgr.mr_n83147136)
print v(xbgr.mr_n83147248)
print v(xbgr.mr_n83147568)
print v(xbgr.mr_n83147680)
print v(xbgr.mr_n83148000)
print v(xbgr.mr_n83148112)
print v(xbgr.mr_n83148432)
print v(xbgr.mr_n83148544)
print v(xbgr.mr_n83148976)
print v(xbgr.mr_n83149408)
print v(xbgr.mr_n83149840)
print v(xbgr.mr_n83150272)
print v(xbgr.mr_n83150592)
print v(xbgr.mr_n83150704)
print v(xbgr.mr_n83151024)
print v(xbgr.mr_n83151136)
print v(xbgr.mr_n83151456)
print v(xbgr.mr_n83151568)
print v(xbgr.mr_n83151888)
print v(xbgr.mr_n83152000)
print v(xbgr.mr_n83152320)
print v(xbgr.mr_n83153184)
print v(xbgr.mr_n83154048)
print v(xbgr.mr_n83154160)
print v(xbgr.mr_n83154592)
print v(xbgr.mr_n83154912)
print v(xbgr.mr_n83155776)
print v(xbgr.mr_n83155888)
print v(xbgr.mr_n83156208)
print v(xbgr.mr_n83156320)
print v(xbgr.mr_n83156640)
print v(xbgr.mr_n83156752)
print v(xbgr.mr_n83157072)
print v(xbgr.mr_n83157184)
print v(xbgr.mr_n83157504)
print v(xbgr.mr_n83158368)
print v(xbgr.mr_n83158480)
print v(xbgr.mr_n83158912)
print v(xbgr.mr_n83159232)
print v(xbgr.mr_n83159344)
print v(xbgr.mr_n83159664)
print v(xbgr.mr_n83159776)
print v(xbgr.mr_n83160096)
print v(xbgr.mr_n83160208)
print v(xbgr.mr_n83160528)
print v(xbgr.mr_n83160640)
print v(xbgr.mr_n83160960)
print v(xbgr.mr_n83161824)
print v(xbgr.mr_n83162256)
print v(xbgr.mr_n83162368)
print v(xbgr.mr_n83162688)
print v(xbgr.mr_n83162800)
print v(xbgr.mr_n83163120)
print v(xbgr.mr_n83163552)
print v(xbgr.mr_n83164416)
print v(xbgr.mr_n83165280)
print v(xbgr.mr_n83165392)
print v(xbgr.mr_n83166144)
print v(xbgr.mr_n83166256)
print v(xbgr.mr_n83166576)
print v(xbgr.mr_n83166688)
print v(xbgr.mr_n83167008)
print v(xbgr.mr_n83167872)
print v(xbgr.mr_n83168736)
print v(xbgr.mr_n83168848)
print v(xbgr.mr_n83169168)
print v(xbgr.mr_n83169280)
print v(xbgr.mr_n83169600)
print v(xbgr.mr_n83170464)
print v(xbgr.mr_n83170576)
print v(xbgr.mr_n83170896)
print v(xbgr.mr_n83171008)
print v(xbgr.mr_n83171328)
print v(xbgr.mr_n83171440)
print v(xbgr.mr_n83171760)
print v(xbgr.mr_n83171872)
print v(xbgr.mr_n83172192)
print v(xbgr.mr_n83172304)
print v(xbgr.mr_n83173056)
print v(xbgr.mr_n83173920)
print v(xbgr.mr_n83174784)
print v(xbgr.mr_n83174896)
print v(xbgr.mr_n83175216)
print v(xbgr.mr_n83175328)
print v(xbgr.mr_n83175648)
print v(xbgr.mr_n83175760)
print v(xbgr.mr_n83176080)
print v(xbgr.mr_n83176192)
print v(xbgr.mr_n83176512)
print v(xbgr.mr_n83176624)
print v(xbgr.mr_n83176944)
print v(xbgr.mr_n83177056)
print v(xbgr.mr_n83177376)
print v(xbgr.mr_n83177488)
print v(xbgr.mr_n83177920)
print v(xbgr.mr_n83178240)
print v(xbgr.mr_n83178352)
print v(xbgr.mr_n83178672)
print v(xbgr.mr_n83178784)
print v(xbgr.mr_n83179104)
print v(xbgr.mr_n83179968)
print v(xbgr.mr_n83180832)
print v(xbgr.mr_n83181696)
print v(xbgr.mr_n83182560)
print v(xbgr.mr_n83182992)
print v(xbgr.mr_n83183104)
print v(xbgr.mr_n83183424)
print v(xbgr.mr_n83183536)
print v(xbgr.mr_n83183856)
print v(xbgr.mr_n83183968)
print v(xbgr.mr_n83184400)
print v(xbgr.mr_n83185152)
print v(xbgr.mr_n83185264)
print v(xbgr.mr_n83185584)
print v(xbgr.mr_n83185696)
print v(xbgr.mr_n83186016)
print v(xbgr.mr_n83186880)
print v(xbgr.mr_n83187744)
print v(xbgr.mr_n83187856)
print v(xbgr.mr_n83188176)
print v(xbgr.mr_n83188288)
print v(xbgr.mr_n83188608)
print v(xbgr.mr_n83189472)
print v(xbgr.mr_n83190336)
print v(xbgr.mr_n83191200)
print v(xbgr.mr_n83191312)
print v(xbgr.mr_n83191632)
print v(xbgr.mr_n83191744)
print v(xbgr.mr_n83192064)
print v(xbgr.mr_n83192928)
print v(xbgr.mr_n83193792)
print v(xbgr.mr_n83193904)
print v(xbgr.mr_n83194224)
print v(xbgr.mr_n83194336)
print v(xbgr.mr_n83194656)
print v(xbgr.mr_n83194768)
print v(xbgr.mr_n83195088)
print v(xbgr.mr_n83195200)
print v(xbgr.mr_n83195520)
print v(xbgr.mr_n83195632)
print v(xbgr.mr_n83195952)
print v(xbgr.mr_n83196064)
print v(xbgr.mr_n83196384)
print v(xbgr.mr_n83196496)
print v(xbgr.mr_n83196816)
print v(xbgr.mr_n83196928)
print v(xbgr.mr_n83197248)
print v(xbgr.mr_n83197360)
print v(xbgr.mr_n83197680)
print v(xbgr.mr_n83197792)
print v(xbgr.mr_n83198112)
print v(xbgr.mr_n83198224)
print v(xbgr.mr_n83198544)
print v(xbgr.mr_n83198656)
print v(xbgr.mr_n83198976)
print v(xbgr.mr_n83199088)
print v(xbgr.mr_n83199408)
print v(xbgr.mr_n83199520)
print v(xbgr.mr_n83199840)
print v(xbgr.mr_n83199952)
print v(xbgr.mr_n83200272)
print v(xbgr.mr_n83200384)
print v(xbgr.mr_n83200704)
print v(xbgr.mr_n83200816)
print v(xbgr.mr_n83201136)
print v(xbgr.mr_n83201248)
print v(xbgr.mr_n83201568)
print v(xbgr.mr_n83201680)
print v(xbgr.mr_n83202000)
print v(xbgr.mr_n83202112)
print v(xbgr.mr_n83202432)
print v(xbgr.mr_n83202544)
print v(xbgr.mr_n83202864)
print v(xbgr.mr_n83202976)
print v(xbgr.mr_n83203296)
print v(xbgr.mr_n83203408)
print v(xbgr.mr_n83203728)
print v(xbgr.mr_n83203840)
print v(xbgr.mr_n83204160)
print v(xbgr.mr_n83204272)
print v(xbgr.mr_n83204592)
print v(xbgr.mr_n83204704)
print v(xbgr.mr_n83205136)
print v(xbgr.mr_n83205568)
print v(xbgr.mr_n83206000)
print v(xbgr.mr_n83206432)
print v(xbgr.mr_n83206864)
print v(xbgr.mr_n83207296)
print v(xbgr.mr_n83207728)
print v(xbgr.mr_n83208160)
print v(xbgr.mr_n83208592)
print v(xbgr.mr_n83209024)
print v(xbgr.mr_n83209456)
print v(xbgr.mr_n83209888)
print v(xbgr.mr_n83210320)
print v(xbgr.mr_n83210752)
print v(xbgr.mr_n83211184)
print v(xbgr.mr_n83211616)
print v(xbgr.mr_n83212048)
print v(xbgr.mr_n83212480)
print v(xbgr.mr_n83212912)
print v(xbgr.mr_n83213344)
print v(xbgr.mr_n83213776)
print v(xbgr.mr_n83214208)
print v(xbgr.mr_n83214640)
print v(xbgr.mr_n83215072)
print v(xbgr.mr_n83215504)
print v(xbgr.mr_n83215936)
print v(xbgr.mr_n83216256)
print v(xbgr.mr_n83216368)
print v(xbgr.mr_n83216688)
print v(xbgr.mr_n83216800)
print v(xbgr.mr_n83217120)
print v(xbgr.mr_n83217232)
print v(xbgr.mr_n83217552)
print v(xbgr.mr_n83217664)
print v(xbgr.mr_n83217984)
print v(xbgr.mr_n83218096)
print v(xbgr.mr_n83218416)
print v(xbgr.mr_n83218528)
print v(xbgr.mr_n83218848)
print v(xbgr.mr_n83218960)
print v(xbgr.mr_n83219280)
print v(xbgr.mr_n83219392)
print v(xbgr.mr_n83219712)
print v(xbgr.mr_n83219824)
print v(xbgr.mr_n83220144)
print v(xbgr.mr_n83220256)
print v(xbgr.mr_n83220576)
print v(xbgr.mr_n83220688)
print v(xbgr.mr_n83221008)
print v(xbgr.mr_n83221120)
print v(xbgr.mr_n83221440)
print v(xbgr.mr_n83221552)
print v(xbgr.mr_n83221872)
print v(xbgr.mr_n83221984)
print v(xbgr.mr_n83222304)
print v(xbgr.mr_n83222416)
print v(xbgr.mr_n83222736)
print v(xbgr.mr_n83222848)
print v(xbgr.mr_n83223168)
print v(xbgr.mr_n83223280)
print v(xbgr.mr_n83223600)
print v(xbgr.mr_n83223712)
print v(xbgr.mr_n83224032)
print v(xbgr.mr_n83224144)
print v(xbgr.mr_n83224464)
print v(xbgr.mr_n83224576)
print v(xbgr.mr_n83224896)
print v(xbgr.mr_n83225008)
print v(xbgr.mr_n83225328)
print v(xbgr.mr_n83225440)
print v(xbgr.mr_n83225760)
print v(xbgr.mr_n83225872)
print v(xbgr.mr_n83226192)
print v(xbgr.mr_n83226304)
print v(xbgr.mr_n83226736)
print v(xbgr.mr_n83227168)
print v(xbgr.mr_n83227600)
print v(xbgr.mr_n83228032)
print v(xbgr.mr_n83228352)
print v(xbgr.mr_n83228464)
print v(xbgr.mr_n83228784)
print v(xbgr.mr_n83228896)
print v(xbgr.mr_n83229328)
print v(xbgr.mr_n83229760)
print v(xbgr.mr_n83230192)
print v(xbgr.mr_n83230624)
print v(xbgr.mr_n83231056)
print v(xbgr.mr_n83231488)
print v(xbgr.mr_n83231920)
print v(xbgr.mr_n83232352)
print v(xbgr.mr_n83232784)
print v(xbgr.mr_n83233216)
print v(xbgr.mr_n83233648)
print v(xbgr.mr_n83234080)
print v(xbgr.mr_n83234512)
print v(xbgr.mr_n83234944)
print v(xbgr.mr_n83235376)
print v(xbgr.mr_n83235808)
print v(xbgr.mr_n83236240)
print v(xbgr.mr_n83236672)
print v(xbgr.mr_n83237104)
print v(xbgr.mr_n83237536)
print v(xbgr.mr_n83237968)
print v(xbgr.mr_n83238400)
print v(xbgr.mr_n83238720)
print v(xbgr.mr_n83238832)
print v(xbgr.mr_n83239264)
print v(xbgr.mr_n83239584)
print v(xbgr.mr_n83239696)
print v(xbgr.mr_n83240128)
print v(xbgr.mr_n83240448)
print v(xbgr.mr_n83240560)
print v(xbgr.mr_n83240992)
print v(xbgr.mr_n83241312)
print v(xbgr.mr_n83241424)
print v(xbgr.mr_n83241856)
print v(xbgr.mr_n83242176)
print v(xbgr.mr_n83242288)
print v(xbgr.mr_n83242720)
print v(xbgr.mr_n83243040)
print v(xbgr.mr_n83243152)
print v(xbgr.mr_n83243472)
print v(xbgr.mr_n83243584)
print v(xbgr.mr_n83243904)
print v(xbgr.mr_n83244016)
print v(xbgr.mr_n83244448)
print v(xbgr.mr_n83244880)
print v(xbgr.mr_n83245312)
print v(xbgr.mr_n83245632)
print v(xbgr.mr_n83245744)
print v(xbgr.mr_n83246064)
print v(xbgr.mr_n83246176)
print v(xbgr.mr_n83246496)
print v(xbgr.mr_n83246608)
print v(xbgr.mr_n83246928)
print v(xbgr.mr_n83247040)
print v(xbgr.mr_n83247360)
print v(xbgr.mr_n83247472)
print v(xbgr.mr_n83247792)
print v(xbgr.mr_n83247904)
print v(xbgr.mr_n83248224)
print v(xbgr.mr_n83248336)
print v(xbgr.mr_n83248768)
print v(xbgr.mr_n83249088)
print v(xbgr.mr_n83249200)
print v(xbgr.mr_n83249632)
print v(xbgr.mr_n83249952)
print v(xbgr.mr_n83250064)
print v(xbgr.mr_n83250496)
print v(xbgr.mr_n83250816)
print v(xbgr.mr_n83251680)
print v(xbgr.mr_n83252544)
print v(xbgr.mr_n83253408)
print v(xbgr.mr_n83254272)
print v(xbgr.mr_n83255136)
print v(xbgr.mr_n83256000)
print v(xbgr.mr_n83256112)
print v(xbgr.mr_n83256432)
print v(xbgr.mr_n83256544)
print v(xbgr.mr_n83256864)
print v(xbgr.mr_n83256976)
print v(xbgr.mr_n83257296)
print v(xbgr.mr_n83257408)
print v(xbgr.mr_n83257728)
print v(xbgr.mr_n83258592)
print v(xbgr.mr_n83259456)
print v(xbgr.mr_n83260320)
print v(xbgr.mr_n83260432)
print v(xbgr.mr_n83260752)
print v(xbgr.mr_n83260864)
print v(xbgr.mr_n83261184)
print v(xbgr.mr_n83261296)
print v(xbgr.mr_n83261728)
print v(xbgr.mr_n83262160)
print v(xbgr.mr_n83262592)
print v(xbgr.mr_n83262912)
print v(xbgr.mr_n83263024)
print v(xbgr.mr_n83263344)
print v(xbgr.mr_n83263456)
print v(xbgr.mr_n83263776)
print v(xbgr.mr_n83263888)
print v(xbgr.mr_n83264208)
print v(xbgr.mr_n83264320)
print v(xbgr.mr_n83264640)
print v(xbgr.mr_n83264752)
print v(xbgr.mr_n83265072)
print v(xbgr.mr_n83265184)
print v(xbgr.mr_n83265504)
print v(xbgr.mr_n83265616)
print v(xbgr.mr_n83265936)
print v(xbgr.mr_n83266048)
print v(xbgr.mr_n83266368)
print v(xbgr.mr_n83266480)
print v(xbgr.mr_n83266912)
print v(xbgr.mr_n83267232)
print v(xbgr.mr_n83267344)
print v(xbgr.mr_n83267776)
print v(xbgr.mr_n83268096)
print v(xbgr.mr_n83268208)
print v(xbgr.mr_n83268528)
print v(xbgr.mr_n83268640)
print v(xbgr.mr_n83268960)
print v(xbgr.mr_n83269824)
print v(xbgr.mr_n83270688)
print v(xbgr.mr_n83270800)
print v(xbgr.mr_n83271120)
print v(xbgr.mr_n83271232)
print v(xbgr.mr_n83271552)
print v(xbgr.mr_n83272416)
print v(xbgr.mr_n83272960)
print v(xbgr.mr_n83273392)
print v(xbgr.mr_n83274144)
print v(xbgr.mr_n83275008)
print v(xbgr.mr_n83275120)
print v(xbgr.mr_n83275440)
print v(xbgr.mr_n83275552)
print v(xbgr.mr_n83275872)
print v(xbgr.mr_n83275984)
print v(xbgr.mr_n83276304)
print v(xbgr.mr_n83276416)
print v(xbgr.mr_n83276736)
print v(xbgr.mr_n83276848)
print v(xbgr.mr_n83277168)
print v(xbgr.mr_n83277280)
print v(xbgr.mr_n83277600)
print v(xbgr.mr_n83277712)
print v(xbgr.mr_n83278032)
print v(xbgr.mr_n83278144)
print v(xbgr.mr_n83278464)
print v(xbgr.mr_n83279328)
print v(xbgr.mr_n83279440)
print v(xbgr.mr_n83279760)
print v(xbgr.mr_n83279872)
print v(xbgr.mr_n83280192)
print v(xbgr.mr_n83281056)
print v(xbgr.mr_n83281920)
print v(xbgr.mr_n83282032)
print v(xbgr.mr_n83282352)
print v(xbgr.mr_n83282464)
print v(xbgr.mr_n83282784)
print v(xbgr.mr_n83282896)
print v(xbgr.mr_n83283328)
print v(xbgr.mr_n83283648)
print v(xbgr.mr_n83284080)
print v(xbgr.mr_n83285376)
print v(xbgr.mr_n83285488)
print v(xbgr.mr_n83285808)
print v(xbgr.mr_n83285920)
print v(xbgr.mr_n83286240)
print v(xbgr.mr_n83286352)
print v(xbgr.mr_n83286672)
print v(xbgr.mr_n83286784)
print v(xbgr.mr_n83287104)
print v(xbgr.mr_n83287216)
print v(xbgr.mr_n83287648)
print v(xbgr.mr_n83287968)
print v(xbgr.mr_n83288080)
print v(xbgr.mr_n83288400)
print v(xbgr.mr_n83288512)
print v(xbgr.mr_n83288832)
print v(xbgr.mr_n83288944)
print v(xbgr.mr_n83289264)
print v(xbgr.mr_n83289376)
print v(xbgr.mr_n83289696)
print v(xbgr.mr_n83290560)
print v(xbgr.mr_n83291424)
print v(xbgr.mr_n83292288)
print v(xbgr.mr_n83293152)
print v(xbgr.mr_n83293264)
print v(xbgr.mr_n83293584)
print v(xbgr.mr_n83293696)
print v(xbgr.mr_n83294016)
print v(xbgr.mr_n83294128)
print v(xbgr.mr_n83294448)
print v(xbgr.mr_n83294560)
print v(xbgr.mr_n83294880)
print v(xbgr.mr_n83295744)
print v(xbgr.mr_n83296608)
print v(xbgr.mr_n83297472)
print v(xbgr.mr_n83298336)
print v(xbgr.mr_n83298768)
print v(xbgr.mr_n83298880)
print v(xbgr.mr_n83299200)
print v(xbgr.mr_n83299312)
print v(xbgr.mr_n83299632)
print v(xbgr.mr_n83299744)
print v(xbgr.mr_n83300064)
print v(xbgr.mr_n83300176)
print v(xbgr.mr_n83300496)
print v(xbgr.mr_n83300608)
print v(xbgr.mr_n83300928)
print v(xbgr.mr_n83301040)
print v(xbgr.mr_n83301360)
print v(xbgr.mr_n83301472)
print v(xbgr.mr_n83301792)
print v(xbgr.mr_n83301904)
print v(xbgr.mr_n83302336)
print v(xbgr.mr_n83302656)
print v(xbgr.mr_n83302768)
print v(xbgr.mr_n83303200)
print v(xbgr.mr_n83303520)
print v(xbgr.mr_n83303632)
print v(xbgr.mr_n83304064)
print v(xbgr.mr_n83304384)
print v(xbgr.mr_n83304496)
print v(xbgr.mr_n83304816)
print v(xbgr.mr_n83304928)
print v(xbgr.mr_n83305248)
print v(xbgr.mr_n83306112)
print v(xbgr.mr_n83306976)
print v(xbgr.mr_n83307840)
print v(xbgr.mr_n83308704)
print v(xbgr.mr_n83309568)
print v(xbgr.mr_n83310432)
print v(xbgr.mr_n83311296)
print v(xbgr.mr_n83312160)
print v(xbgr.mr_n83313024)
print v(xbgr.mr_n83313136)
print v(xbgr.mr_n83313456)
print v(xbgr.mr_n83313568)
print v(xbgr.mr_n83313888)
print v(xbgr.mr_n83314752)
print v(xbgr.mr_n83314864)
print v(xbgr.mr_n83315184)
print v(xbgr.mr_n83315296)
print v(xbgr.mr_n83315616)
print v(xbgr.mr_n83315728)
print v(xbgr.mr_n83316048)
print v(xbgr.mr_n83316160)
print v(xbgr.mr_n83316480)
print v(xbgr.mr_n83316592)
print v(xbgr.mr_n83316912)
print v(xbgr.mr_n83317024)
print v(xbgr.mr_n83317344)
print v(xbgr.mr_n83317456)
print v(xbgr.mr_n83317776)
print v(xbgr.mr_n83317888)
print v(xbgr.mr_n83318208)
print v(xbgr.mr_n83319072)
print v(xbgr.mr_n83319936)
print v(xbgr.mr_n83320800)
print v(xbgr.mr_n83320912)
print v(xbgr.mr_n83321232)
print v(xbgr.mr_n83322528)
print v(xbgr.mr_n83323392)
print v(xbgr.mr_n83324256)
print v(xbgr.mr_n83325120)
print v(xbgr.mr_n83325232)
print v(xbgr.mr_n83325552)
print v(xbgr.mr_n83325664)
print v(xbgr.mr_n83326096)
print v(xbgr.mr_n83326416)
print v(xbgr.mr_n83326528)
print v(xbgr.mr_n83326960)
print v(xbgr.mr_n83327280)
print v(xbgr.mr_n83327392)
print v(xbgr.mr_n83327824)
print v(xbgr.mr_n83328144)
print v(xbgr.mr_n83328256)
print v(xbgr.mr_n83328688)
print v(xbgr.mr_n83329008)
print v(xbgr.mr_n83329120)
print v(xbgr.mr_n83329552)
print v(xbgr.mr_n83329872)
print v(xbgr.mr_n83329984)
print v(xbgr.mr_n83330304)
print v(xbgr.mr_n83330416)
print v(xbgr.mr_n83330736)
print v(xbgr.mr_n83330848)
print v(xbgr.mr_n83331280)
print v(xbgr.mr_n83331600)
print v(xbgr.mr_n83331712)
print v(xbgr.mr_n83332032)
print v(xbgr.mr_n83332144)
print v(xbgr.mr_n83332464)
print v(xbgr.mr_n83332576)
print v(xbgr.mr_n83332896)
print v(xbgr.mr_n83333008)
print v(xbgr.mr_n83333328)
print v(xbgr.mr_n83333440)
print v(xbgr.mr_n83333760)
print v(xbgr.mr_n83333872)
print v(xbgr.mr_n83334192)
print v(xbgr.mr_n83334304)
print v(xbgr.mr_n83334624)
print v(xbgr.mr_n83334736)
print v(xbgr.mr_n83335168)
print v(xbgr.mr_n83335488)
print v(xbgr.mr_n83336464)
print v(xbgr.mr_n83336896)
print v(xbgr.mr_n83337216)
print v(xbgr.mr_n83338080)
print v(xbgr.mr_n83338192)
print v(xbgr.mr_n83338512)
print v(xbgr.mr_n83338624)
print v(xbgr.mr_n83338944)
print v(xbgr.mr_n83339056)
print v(xbgr.mr_n83339376)
print v(xbgr.mr_n83339488)
print v(xbgr.mr_n83339808)
print v(xbgr.mr_n83340672)
print v(xbgr.mr_n83341104)
print v(xbgr.mr_n83341968)
print v(xbgr.mr_n83342832)
print v(xbgr.mr_n83342944)
print v(xbgr.mr_n83343264)
print v(xbgr.mr_n83343376)
print v(xbgr.mr_n83343696)
print v(xbgr.mr_n83343808)
print v(xbgr.mr_n83344128)
print v(xbgr.mr_n83344240)
print v(xbgr.mr_n83344992)
print v(xbgr.mr_n83345104)
print v(xbgr.mr_n83345424)
print v(xbgr.mr_n83345536)
print v(xbgr.mr_n83345856)
print v(xbgr.mr_n83345968)
print v(xbgr.mr_n83346288)
print v(xbgr.mr_n83346400)
print v(xbgr.mr_n83346720)
print v(xbgr.mr_n83347264)
print v(xbgr.mr_n83347584)
print v(xbgr.mr_n83347696)
print v(xbgr.mr_n83348128)
print v(xbgr.mr_n83348448)
print v(xbgr.mr_n83348560)
print v(xbgr.mr_n83349744)
print v(xbgr.mr_n83350176)
print v(xbgr.mr_n83350288)
print v(xbgr.mr_n83350608)
print v(xbgr.mr_n83350720)
print v(xbgr.mr_n83351040)
print v(xbgr.mr_n83351152)
print v(xbgr.mr_n83351472)
print v(xbgr.mr_n83351584)
print v(xbgr.mr_n83351904)
print v(xbgr.mr_n83352016)
print v(xbgr.mr_n83352336)
print v(xbgr.mr_n83352448)
print v(xbgr.mr_n83353200)
print v(xbgr.mr_n83354064)
print v(xbgr.mr_n83354176)
print v(xbgr.mr_n83354496)
print v(xbgr.mr_n83354608)
print v(xbgr.mr_n83354928)
print v(xbgr.mr_n83355040)
print v(xbgr.mr_n83355360)
print v(xbgr.mr_n83355472)
print v(xbgr.mr_n83355792)
print v(xbgr.mr_n83355904)
print v(xbgr.mr_n83356224)
print v(xbgr.mr_n83356336)
print v(xbgr.mr_n83356656)
print v(xbgr.mr_n83356768)
print v(xbgr.mr_n83357088)
print v(xbgr.mr_n83357200)
print v(xbgr.mr_n83357520)
print v(xbgr.mr_n83358384)
print v(xbgr.mr_n83359248)
print v(xbgr.mr_n83360112)
print v(xbgr.mr_n83360224)
print v(xbgr.mr_n83360656)
print v(xbgr.mr_n83361088)
print v(xbgr.mr_n83361408)
print v(xbgr.mr_n83361840)
print v(xbgr.mr_n83361952)
print v(xbgr.mr_n83362272)
print v(xbgr.mr_n83362384)
print v(xbgr.mr_n83363136)
print v(xbgr.mr_n83364544)
print v(xbgr.mr_n83364864)
print v(xbgr.mr_n83364976)
print v(xbgr.mr_n83365296)
print v(xbgr.mr_n83365408)
print v(xbgr.mr_n83365728)
print v(xbgr.mr_n83365840)
print v(xbgr.mr_n83366272)
print v(xbgr.mr_n83366592)
print v(xbgr.mr_n83366704)
print v(xbgr.mr_n83367136)
print v(xbgr.mr_n83367456)
print v(xbgr.mr_n83367888)
print v(xbgr.mr_n83368320)
print v(xbgr.mr_n83368432)
print v(xbgr.mr_n83368752)
print v(xbgr.mr_n83368864)
print v(xbgr.mr_n83369184)
print v(xbgr.mr_n83369296)
print v(xbgr.mr_n83370048)
print v(xbgr.mr_n83370912)
print v(xbgr.mr_n83371024)
print v(xbgr.mr_n83371456)
print v(xbgr.mr_n83371776)
print v(xbgr.mr_n83372640)
print v(xbgr.mr_n83373504)
print v(xbgr.mr_n83374800)
print v(xbgr.mr_n83375232)
print v(xbgr.mr_n83375344)
print v(xbgr.mr_n83375664)
print v(xbgr.mr_n83375776)
print v(xbgr.mr_n83376096)
print v(xbgr.mr_n83376208)
print v(xbgr.mr_n83376528)
print v(xbgr.mr_n83376640)
print v(xbgr.mr_n83376960)
print v(xbgr.mr_n83377072)
print v(xbgr.mr_n83377392)
print v(xbgr.mr_n83377504)
print v(xbgr.mr_n83377824)
print v(xbgr.mr_n83377936)
print v(xbgr.mr_n83378256)
print v(xbgr.mr_n83378368)
print v(xbgr.mr_n83379120)
print v(xbgr.mr_n83379984)
print v(xbgr.mr_n83380848)
print v(xbgr.mr_n83380960)
print v(xbgr.mr_n83381280)
print v(xbgr.mr_n83381392)
print v(xbgr.mr_n83381712)
print v(xbgr.mr_n83381824)
print v(xbgr.mr_n83382144)
print v(xbgr.mr_n83383008)
print v(xbgr.mr_n83383872)
print v(xbgr.mr_n83384736)
print v(xbgr.mr_n83385600)
print v(xbgr.mr_n83386464)
print v(xbgr.mr_n83387328)
print v(xbgr.mr_n83387440)
print v(xbgr.mr_n83387760)
print v(xbgr.mr_n83388624)
print v(xbgr.mr_n83388736)
print v(xbgr.mr_n83389056)
print v(xbgr.mr_n83389168)
print v(xbgr.mr_n83389488)
print v(xbgr.mr_n83390352)
print v(xbgr.mr_n83390784)
print v(xbgr.mr_n83390896)
print v(xbgr.mr_n83391648)
print v(xbgr.mr_n83391760)
print v(xbgr.mr_n83392080)
print v(xbgr.mr_n83392192)
print v(xbgr.mr_n83392512)
print v(xbgr.mr_n83392624)
print v(xbgr.mr_n83392944)
print v(xbgr.mr_n83393056)
print v(xbgr.mr_n83393376)
print v(xbgr.mr_n83393488)
print v(xbgr.mr_n83393808)
print v(xbgr.mr_n83393920)
print v(xbgr.mr_n83394240)
print v(xbgr.mr_n83394352)
print v(xbgr.mr_n83394672)
print v(xbgr.mr_n83394784)
print v(xbgr.mr_n83395104)
print v(xbgr.mr_n83395216)
print v(xbgr.mr_n83395536)
print v(xbgr.mr_n83396080)
print v(xbgr.mr_n83396832)
print v(xbgr.mr_n83397696)
print v(xbgr.mr_n83398560)
print v(xbgr.mr_n83398672)
print v(xbgr.mr_n83399104)
print v(xbgr.mr_n83399424)
print v(xbgr.mr_n83400288)
print v(xbgr.mr_n83401152)
print v(xbgr.mr_n83402016)
print v(xbgr.mr_n83402880)
print v(xbgr.mr_n83403744)
print v(xbgr.mr_n83404608)
print v(xbgr.mr_n83404720)
print v(xbgr.mr_n83405040)
print v(xbgr.mr_n83405152)
print v(xbgr.mr_n83405472)
print v(xbgr.mr_n83406336)
print v(xbgr.mr_n83407200)
print v(xbgr.mr_n83407312)
print v(xbgr.mr_n83407632)
print v(xbgr.mr_n83407744)
print v(xbgr.mr_n83408064)
print v(xbgr.mr_n83408176)
print v(xbgr.mr_n83408496)
print v(xbgr.mr_n83408608)
print v(xbgr.mr_n83408928)
print v(xbgr.mr_n83409040)
print v(xbgr.mr_n83409360)
print v(xbgr.mr_n83409472)
print v(xbgr.mr_n83409792)
print v(xbgr.mr_n83409904)
print v(xbgr.mr_n83410224)
print v(xbgr.mr_n83411088)
print v(xbgr.mr_n83411200)
print v(xbgr.mr_n83411520)
print v(xbgr.mr_n83411632)
print v(xbgr.mr_n83411952)
print v(xbgr.mr_n83412064)
print v(xbgr.mr_n83412384)
print v(xbgr.mr_n83412496)
print v(xbgr.mr_n83412816)
print v(xbgr.mr_n83412928)
print v(xbgr.mr_n83413248)
print v(xbgr.mr_n83413360)
print v(xbgr.mr_n83413680)
print v(xbgr.mr_n83413792)
print v(xbgr.mr_n83414112)
print v(xbgr.mr_n83414224)
print v(xbgr.mr_n83414656)
print v(xbgr.mr_n83415088)
print v(xbgr.mr_n83415520)
print v(xbgr.mr_n83415840)
print v(xbgr.mr_n83415952)
print v(xbgr.mr_n83416272)
print v(xbgr.mr_n83416384)
print v(xbgr.mr_n83416704)
print v(xbgr.mr_n83416816)
print v(xbgr.mr_n83417136)
print v(xbgr.mr_n83417248)
print v(xbgr.mr_n83417568)
print v(xbgr.mr_n83417680)
print v(xbgr.mr_n83418000)
print v(xbgr.mr_n83418112)
print v(xbgr.mr_n83418432)
print v(xbgr.mr_n83418544)
print v(xbgr.mr_n83418864)
print v(xbgr.mr_n83418976)
print v(xbgr.mr_n83419296)
print v(xbgr.mr_n83419408)
print v(xbgr.mr_n83419728)
print v(xbgr.mr_n83419840)
print v(xbgr.mr_n83420160)
print v(xbgr.mr_n83420272)
print v(xbgr.mr_n83420592)
print v(xbgr.mr_n83420704)
print v(xbgr.mr_n83421024)
print v(xbgr.mr_n83421136)
print v(xbgr.mr_n83421456)
print v(xbgr.mr_n83421568)
print v(xbgr.mr_n83421888)
print v(xbgr.mr_n83422000)
print v(xbgr.mr_n83422320)
print v(xbgr.mr_n83422432)
print v(xbgr.mr_n83422864)
print v(xbgr.mr_n83423184)
print v(xbgr.mr_n83423296)
print v(xbgr.mr_n83423728)
print v(xbgr.mr_n83424160)
print v(xbgr.mr_n83424480)
print v(xbgr.mr_n83424592)
print v(xbgr.mr_n83424912)
print v(xbgr.mr_n83425024)
print v(xbgr.mr_n83425344)
print v(xbgr.mr_n83425456)
print v(xbgr.mr_n83425776)
print v(xbgr.mr_n83425888)
print v(xbgr.mr_n83426320)
print v(xbgr.mr_n83426752)
print v(xbgr.mr_n83427184)
print v(xbgr.mr_n83427616)
print v(xbgr.mr_n83428048)
print v(xbgr.mr_n83428480)
print v(xbgr.mr_n83428912)
print v(xbgr.mr_n83429344)
print v(xbgr.mr_n83429664)
print v(xbgr.mr_n83429776)
print v(xbgr.mr_n83430096)
print v(xbgr.mr_n83430208)
print v(xbgr.mr_n83430528)
print v(xbgr.mr_n83430640)
print v(xbgr.mr_n83430960)
print v(xbgr.mr_n83431072)
print v(xbgr.mr_n83431392)
print v(xbgr.mr_n83431504)
print v(xbgr.mr_n83431824)
print v(xbgr.mr_n83431936)
print v(xbgr.mr_n83432256)
print v(xbgr.mr_n83432368)
print v(xbgr.mr_n83432688)
print v(xbgr.mr_n83432800)
print v(xbgr.mr_n83433120)
print v(xbgr.mr_n83433232)
print v(xbgr.mr_n83433552)
print v(xbgr.mr_n83433664)
print v(xbgr.mr_n83433984)
print v(xbgr.mr_n83434096)
print v(xbgr.mr_n83434416)
print v(xbgr.mr_n83434528)
print v(xbgr.mr_n83434848)
print v(xbgr.mr_n83434960)
print v(xbgr.mr_n83435280)
print v(xbgr.mr_n83435392)
print v(xbgr.mr_n83435712)
print v(xbgr.mr_n83435824)
print v(xbgr.mr_n83436144)
print v(xbgr.mr_n83436256)
print v(xbgr.mr_n83436576)
print v(xbgr.mr_n83436688)
print v(xbgr.mr_n83437008)
print v(xbgr.mr_n83437120)
print v(xbgr.mr_n83437440)
print v(xbgr.mr_n83437552)
print v(xbgr.mr_n83437872)
print v(xbgr.mr_n83437984)
print v(xbgr.mr_n83438304)
print v(xbgr.mr_n83438416)
print v(xbgr.mr_n83438736)
print v(xbgr.mr_n83438848)
print v(xbgr.mr_n83439168)
print v(xbgr.mr_n83439280)
print v(xbgr.mr_n83439600)
print v(xbgr.mr_n83439712)
print v(xbgr.mr_n83440144)
print v(xbgr.mr_n83440576)
print v(xbgr.mr_n83440896)
print v(xbgr.mr_n83441008)
print v(xbgr.mr_n83441328)
print v(xbgr.mr_n83441440)
print v(xbgr.mr_n83441872)
print v(xbgr.mr_n83442304)
print v(xbgr.mr_n83442736)
print v(xbgr.mr_n83443168)
print v(xbgr.mr_n83443600)
print v(xbgr.mr_n83444032)
print v(xbgr.mr_n83444464)
print v(xbgr.mr_n83444896)
print v(xbgr.mr_n83445328)
print v(xbgr.mr_n83445760)
print v(xbgr.mr_n83446192)
print v(xbgr.mr_n83446624)
print v(xbgr.mr_n83447056)
print v(xbgr.mr_n83447488)
print v(xbgr.mr_n83447920)
print v(xbgr.mr_n83448352)
print v(xbgr.mr_n83448784)
print v(xbgr.mr_n83449216)
print v(xbgr.mr_n83449648)
print v(xbgr.mr_n83450080)
print v(xbgr.mr_n83450512)
print v(xbgr.mr_n83450944)
print v(xbgr.mr_n83451376)
print v(xbgr.mr_n83451808)
print v(xbgr.mr_n83452128)
print v(xbgr.mr_n83452240)
print v(xbgr.mr_n83452560)
print v(xbgr.mr_n83452672)
print v(xbgr.mr_n83452992)
print v(xbgr.mr_n83453104)
print v(xbgr.mr_n83453424)
print v(xbgr.mr_n83453536)
print v(xbgr.mr_n83453856)
print v(xbgr.mr_n83453968)
print v(xbgr.mr_n83454288)
print v(xbgr.mr_n83454400)
print v(xbgr.mr_n83454720)
print v(xbgr.mr_n83454832)
print v(xbgr.mr_n83455152)
print v(xbgr.mr_n83455264)
print v(xbgr.mr_n83455584)
print v(xbgr.mr_n83455696)
print v(xbgr.mr_n83456016)
print v(xbgr.mr_n83456128)
print v(xbgr.mr_n83456448)
print v(xbgr.mr_n83456560)
print v(xbgr.mr_n83456880)
print v(xbgr.mr_n83456992)
print v(xbgr.mr_n83457312)
print v(xbgr.mr_n83457424)
print v(xbgr.mr_n83457856)
print v(xbgr.mr_n83458288)
print v(xbgr.mr_n83458720)
print v(xbgr.mr_n83459152)
print v(xbgr.mr_n83459584)
print v(xbgr.mr_n83460016)
print v(xbgr.mr_n83460448)
print v(xbgr.mr_n83460880)
print v(xbgr.mr_n83461312)
print v(xbgr.mr_n83461744)
print v(xbgr.mr_n83462176)
print v(xbgr.mr_n83462608)
print v(xbgr.mr_n83463040)
print v(xbgr.mr_n83463360)
print v(xbgr.mr_n83463472)
print v(xbgr.mr_n83463792)
print v(xbgr.mr_n83463904)
print v(xbgr.mr_n83464224)
print v(xbgr.mr_n83464336)
print v(xbgr.mr_n83464656)
print v(xbgr.mr_n83464768)
print v(xbgr.mr_n83465088)
print v(xbgr.mr_n83465200)
print v(xbgr.mr_n83465520)
print v(xbgr.mr_n83465632)
print v(xbgr.mr_n83465952)
print v(xbgr.mr_n83466064)
print v(xbgr.mr_n83466384)
print v(xbgr.mr_n83466496)
print v(xbgr.mr_n83466816)
print v(xbgr.mr_n83466928)
print v(xbgr.mr_n83467248)
print v(xbgr.mr_n83467360)
print v(xbgr.mr_n83467680)
print v(xbgr.mr_n83467792)
print v(xbgr.mr_n83468112)
print v(xbgr.mr_n83468224)
print v(xbgr.mr_n83468544)
print v(xbgr.mr_n83468656)
print v(xbgr.mr_n83469088)
print v(xbgr.mr_n83469520)
print v(xbgr.mr_n83469952)
print v(xbgr.mr_n83470384)
print v(xbgr.mr_n83470816)
print v(xbgr.mr_n83471248)
print v(xbgr.mr_n83471680)
print v(xbgr.mr_n83472112)
print v(xbgr.mr_n83472544)
print v(xbgr.mr_n83472976)
print v(xbgr.mr_n83473408)
print v(xbgr.mr_n83473840)
print v(xbgr.mr_n83474272)
print v(xbgr.mr_n83474592)
print v(xbgr.mr_n83474704)
print v(xbgr.mr_n83475024)
print v(xbgr.mr_n83475136)
print v(xbgr.mr_n83475456)
print v(xbgr.mr_n83475568)
print v(xbgr.mr_n83475888)
print v(xbgr.mr_n83476000)
print v(xbgr.mr_n83476320)
print v(xbgr.mr_n83476432)
print v(xbgr.mr_n83476752)
print v(xbgr.mr_n83476864)
print v(xbgr.mr_n83477184)
print v(xbgr.mr_n83477296)
print v(xbgr.mr_n83477616)
print v(xbgr.mr_n83477728)
print v(xbgr.mr_n83478048)
print v(xbgr.mr_n83478160)
print v(xbgr.mr_n83478480)
print v(xbgr.mr_n83478592)
print v(xbgr.mr_n83478912)
print v(xbgr.mr_n83479024)
print v(xbgr.mr_n83479344)
print v(xbgr.mr_n83479456)
print v(xbgr.mr_n83479776)
print v(xbgr.mr_n83479888)
print v(xbgr.mr_n83480320)
print v(xbgr.mr_n83480752)
print v(xbgr.mr_n83481184)
print v(xbgr.mr_n83481616)
print v(xbgr.mr_n83482048)
print v(xbgr.mr_n83482480)
print v(xbgr.mr_n83482912)
print v(xbgr.mr_n83483344)
print v(xbgr.mr_n83483776)
print v(xbgr.mr_n83484208)
print v(xbgr.mr_n83484640)
print v(xbgr.mr_n83485072)
print v(xbgr.mr_n83485504)
print v(xbgr.mr_n83485824)
print v(xbgr.mr_n83485936)
print v(xbgr.mr_n83486256)
print v(xbgr.mr_n83486368)
print v(xbgr.mr_n83486688)
print v(xbgr.mr_n83486800)
print v(xbgr.mr_n83487120)
print v(xbgr.mr_n83487232)
print v(xbgr.mr_n83487552)
print v(xbgr.mr_n83487664)
print v(xbgr.mr_n83487984)
print v(xbgr.mr_n83488096)
print v(xbgr.mr_n83488416)
print v(xbgr.mr_n83488528)
print v(xbgr.mr_n83488960)
print v(xbgr.mr_n83489392)
print v(xbgr.mr_n83489824)
print v(xbgr.mr_n83490256)
print v(xbgr.mr_n83490576)
print v(xbgr.mr_n83490688)
print v(xbgr.mr_n83491008)
print v(xbgr.mr_n83491120)
print v(xbgr.mr_n83491440)
print v(xbgr.mr_n83491552)
print v(xbgr.mr_n83491872)
print v(xbgr.mr_n83491984)
print v(xbgr.mr_n83492304)
print v(xbgr.mr_n83492416)
print v(xbgr.mr_n83492736)
print v(xbgr.mr_n83492848)
print v(xbgr.mr_n83493280)
print v(xbgr.mr_n83493712)
print v(xbgr.mr_n83494144)
print v(xbgr.mr_n83494576)
print v(xbgr.mr_n83495008)
print v(xbgr.mr_n83495440)
print v(xbgr.mr_n83495872)
print v(xbgr.mr_n83496304)
print v(xbgr.mr_n83496736)
print v(xbgr.mr_n83497056)
print v(xbgr.mr_n83497168)
print v(xbgr.mr_n83497488)
print v(xbgr.mr_n83497600)
print v(xbgr.mr_n83497920)
print v(xbgr.mr_n83498032)
print v(xbgr.mr_n83498352)
print v(xbgr.mr_n83498464)
print v(xbgr.mr_n83498784)
print v(xbgr.mr_n83498896)
print v(xbgr.mr_n83499216)
print v(xbgr.mr_n83499328)
print v(xbgr.mr_n83499648)
print v(xbgr.mr_n83499760)
print v(xbgr.mr_n83500080)
print v(xbgr.mr_n83500192)
print v(xbgr.mr_n83500512)
print v(xbgr.mr_n83500624)
print v(xbgr.mr_n83500944)
print v(xbgr.mr_n83501056)
print v(xbgr.mr_n83501376)
print v(xbgr.mr_n83501488)
print v(xbgr.mr_n83501808)
print v(xbgr.mr_n83501920)
print v(xbgr.mr_n83502240)
print v(xbgr.mr_n83502352)
print v(xbgr.mr_n83502672)
print v(xbgr.mr_n83502784)
print v(xbgr.mr_n83503216)
print v(xbgr.mr_n83503648)
print v(xbgr.mr_n83504080)
print v(xbgr.mr_n83504512)
print v(xbgr.mr_n83504832)
print v(xbgr.mr_n83504944)
print v(xbgr.mr_n83505264)
print v(xbgr.mr_n83505376)
print v(xbgr.mr_n83505808)
print v(xbgr.mr_n83506240)
print v(xbgr.mr_n83506672)
print v(xbgr.mr_n83507104)
print v(xbgr.mr_n83507536)
print v(xbgr.mr_n83507968)
print v(xbgr.mr_n83508400)
print v(xbgr.mr_n83508832)
print v(xbgr.mr_n83509152)
print v(xbgr.mr_n83509264)
print v(xbgr.mr_n83509584)
print v(xbgr.mr_n83509696)
print v(xbgr.mr_n83510016)
print v(xbgr.mr_n83510128)
print v(xbgr.mr_n83510448)
print v(xbgr.mr_n83510560)
print v(xbgr.mr_n83510880)
print v(xbgr.mr_n83510992)
print v(xbgr.mr_n83511312)
print v(xbgr.mr_n83511424)
print v(xbgr.mr_n83511744)
print v(xbgr.mr_n83511856)
print v(xbgr.mr_n83512176)
print v(xbgr.mr_n83512288)
print v(xbgr.mr_n83512608)
print v(xbgr.mr_n83512720)
print v(xbgr.mr_n83513040)
print v(xbgr.mr_n83513152)
print v(xbgr.mr_n83513472)
print v(xbgr.mr_n83513584)
print v(xbgr.mr_n83513904)
print v(xbgr.mr_n83514016)
print v(xbgr.mr_n83514448)
print v(xbgr.mr_n83514880)
print v(xbgr.mr_n83515312)
print v(xbgr.mr_n83515744)
print v(xbgr.mr_n83516176)
print v(xbgr.mr_n83516608)
print v(xbgr.mr_n83516928)
print v(xbgr.mr_n83517040)
print v(xbgr.mr_n83517360)
print v(xbgr.mr_n83517472)
print v(xbgr.mr_n83517792)
print v(xbgr.mr_n83517904)
print v(xbgr.mr_n83518224)
print v(xbgr.mr_n83518336)
print v(xbgr.mr_n83518656)
print v(xbgr.mr_n83518768)
print v(xbgr.mr_n83519088)
print v(xbgr.mr_n83519200)
print v(xbgr.mr_n83519520)
print v(xbgr.mr_n83519632)
print v(xbgr.mr_n83519952)
print v(xbgr.mr_n83520064)
print v(xbgr.mr_n83520384)
print v(xbgr.mr_n83520496)
print v(xbgr.mr_n83520816)
print v(xbgr.mr_n83520928)
print v(xbgr.mr_n83521248)
print v(xbgr.mr_n83521360)
print v(xbgr.mr_n83521680)
print v(xbgr.mr_n83521792)
print v(xbgr.mr_n83522112)
print v(xbgr.mr_n83522224)
print v(xbgr.mr_n83522544)
print v(xbgr.mr_n83522656)
print v(xbgr.mr_n83522976)
print v(xbgr.mr_n83523088)
print v(xbgr.mr_n83523408)
print v(xbgr.mr_n83523520)
print v(xbgr.mr_n83523840)
print v(xbgr.mr_n83523952)
print v(xbgr.mr_n83524272)
print v(xbgr.mr_n83524384)
print v(xbgr.mr_n83524816)
print v(xbgr.mr_n83525248)
print v(xbgr.mr_n83525568)
print v(xbgr.mr_n83525680)
print v(xbgr.mr_n83526000)
print v(xbgr.mr_n83526112)
print v(xbgr.mr_n83526432)
print v(xbgr.mr_n83526544)
print v(xbgr.mr_n83526864)
print v(xbgr.mr_n83526976)
print v(xbgr.mr_n83527408)
print v(xbgr.mr_n83527840)
print v(xbgr.mr_n83528272)
print v(xbgr.mr_n83528704)
print v(xbgr.mr_n83529136)
print v(xbgr.mr_n83529568)
print v(xbgr.mr_n83530000)
print v(xbgr.mr_n83530432)
print v(xbgr.mr_n83530864)
print v(xbgr.mr_n83531296)
print v(xbgr.mr_n83531728)
print v(xbgr.mr_n83532160)
print v(xbgr.mr_n83532592)
print v(xbgr.mr_n83533024)
print v(xbgr.mr_n83533456)
print v(xbgr.mr_n83533888)
print v(xbgr.mr_n83534208)
print v(xbgr.mr_n83534320)
print v(xbgr.mr_n83534640)
print v(xbgr.mr_n83534752)
print v(xbgr.mr_n83535072)
print v(xbgr.mr_n83535184)
print v(xbgr.mr_n83535504)
print v(xbgr.mr_n83535616)
print v(xbgr.mr_n83535936)
print v(xbgr.mr_n83536048)
print v(xbgr.mr_n83536368)
print v(xbgr.mr_n83536480)
print v(xbgr.mr_n83536800)
print v(xbgr.mr_n83536912)
print v(xbgr.mr_n83537232)
print v(xbgr.mr_n83537344)
print v(xbgr.mr_n83537664)
print v(xbgr.mr_n83537776)
print v(xbgr.mr_n83538096)
print v(xbgr.mr_n83538208)
print v(xbgr.mr_n83538640)
print v(xbgr.mr_n83539072)
print v(xbgr.mr_n83539504)
print v(xbgr.mr_n83539936)
print v(xbgr.mr_n83540368)
print v(xbgr.mr_n83540800)
print v(xbgr.mr_n83541232)
print v(xbgr.mr_n83541664)
print v(xbgr.mr_n83541984)
print v(xbgr.mr_n83542096)
print v(xbgr.mr_n83542416)
print v(xbgr.mr_n83542528)
print v(xbgr.mr_n83542848)
print v(xbgr.mr_n83542960)
print v(xbgr.mr_n83543280)
print v(xbgr.mr_n83543392)
print v(xbgr.mr_n83543712)
print v(xbgr.mr_n83543824)
print v(xbgr.mr_n83544144)
print v(xbgr.mr_n83544256)
print v(xbgr.mr_n83544576)
print v(xbgr.mr_n83544688)
print v(xbgr.mr_n83545008)
print v(xbgr.mr_n83545120)
print v(xbgr.mr_n83545440)
print v(xbgr.mr_n83545552)
print v(xbgr.mr_n83545872)
print v(xbgr.mr_n83545984)
print v(xbgr.mr_n83546304)
print v(xbgr.mr_n83546416)
print v(xbgr.mr_n83546736)
print v(xbgr.mr_n83546848)
print v(xbgr.mr_n83547168)
print v(xbgr.mr_n83547280)
print v(xbgr.mr_n83547600)
print v(xbgr.mr_n83547712)
print v(xbgr.mr_n83548144)
print v(xbgr.mr_n83548576)
print v(xbgr.mr_n83549008)
print v(xbgr.mr_n83549440)
print v(xbgr.mr_n83549872)
print v(xbgr.mr_n83550304)
print v(xbgr.mr_n83550736)
print v(xbgr.mr_n83551168)
print v(xbgr.mr_n83551600)
print v(xbgr.mr_n83552032)
print v(xbgr.mr_n83552464)
print v(xbgr.mr_n83552896)
print v(xbgr.mr_n83553328)
print v(xbgr.mr_n83553760)
print v(xbgr.mr_n83554080)
print v(xbgr.mr_n83554192)
print v(xbgr.mr_n83554512)
print v(xbgr.mr_n83554624)
print v(xbgr.mr_n83554944)
print v(xbgr.mr_n83555056)
print v(xbgr.mr_n83555376)
print v(xbgr.mr_n83555488)
print v(xbgr.mr_n83555808)
print v(xbgr.mr_n83555920)
print v(xbgr.mr_n83556240)
print v(xbgr.mr_n83556352)
print v(xbgr.mr_n83556672)
print v(xbgr.mr_n83556784)
print v(xbgr.mr_n83557104)
print v(xbgr.mr_n83557216)
print v(xbgr.mr_n83557536)
print v(xbgr.mr_n83557648)
print v(xbgr.mr_n83557968)
print v(xbgr.mr_n83558080)
print v(xbgr.mr_n83558400)
print v(xbgr.mr_n83558512)
print v(xbgr.mr_n83558832)
print v(xbgr.mr_n83558944)
print v(xbgr.mr_n83559264)
print v(xbgr.mr_n83559376)
print v(xbgr.mr_n83559696)
print v(xbgr.mr_n83559808)
print v(xbgr.mr_n83560128)
print v(xbgr.mr_n83560240)
print v(xbgr.mr_n83560560)
print v(xbgr.mr_n83560672)
print v(xbgr.mr_n83560992)
print v(xbgr.mr_n83561104)
print v(xbgr.mr_n83561424)
print v(xbgr.mr_n83561536)
print v(xbgr.mr_n83561856)
print v(xbgr.mr_n83561968)
print v(xbgr.mr_n83562288)
print v(xbgr.mr_n83562400)
print v(xbgr.mr_n83562720)
print v(xbgr.mr_n83562832)
print v(xbgr.mr_n83563152)
print v(xbgr.mr_n83563264)
print v(xbgr.mr_n83563584)
print v(xbgr.mr_n83563696)
print v(xbgr.mr_n83564016)
print v(xbgr.mr_n83564128)
print v(xbgr.mr_n83564560)
print v(xbgr.mr_n83564992)
print v(xbgr.mr_n83565424)
print v(xbgr.mr_n83565856)
print v(xbgr.mr_n83566288)
print v(xbgr.mr_n83566720)
print v(xbgr.mr_n83567152)
print v(xbgr.mr_n83567584)
print v(xbgr.mr_n83568016)
print v(xbgr.mr_n83568448)
print v(xbgr.mr_n83568880)
print v(xbgr.mr_n83569312)
print v(xbgr.mr_n83569744)
print v(xbgr.mr_n83570176)
print v(xbgr.mr_n83570608)
print v(xbgr.mr_n83571040)
print v(xbgr.mr_n83571360)
print v(xbgr.mr_n83571472)
print v(xbgr.mr_n83571792)
print v(xbgr.mr_n83571904)
print v(xbgr.mr_n83572336)
print v(xbgr.mr_n83572768)
print v(xbgr.mr_n83573200)
print v(xbgr.mr_n83573632)
print v(xbgr.mr_n83574064)
print v(xbgr.mr_n83574496)
print v(xbgr.mr_n83574928)
print v(xbgr.mr_n83575360)
print v(xbgr.mr_n83575792)
print v(xbgr.mr_n83576224)
print v(xbgr.mr_n83576544)
print v(xbgr.mr_n83576656)
print v(xbgr.mr_n83576976)
print v(xbgr.mr_n83577088)
print v(xbgr.mr_n83577408)
print v(xbgr.mr_n83577520)
print v(xbgr.mr_n83577840)
print v(xbgr.mr_n83577952)
print v(xbgr.mr_n83578272)
print v(xbgr.mr_n83578384)
print v(xbgr.mr_n83578704)
print v(xbgr.mr_n83578816)
print v(xbgr.mr_n83579136)
print v(xbgr.mr_n83579248)
print v(xbgr.mr_n83579568)
print v(xbgr.mr_n83579680)
print v(xbgr.mr_n83580000)
print v(xbgr.mr_n83580112)
print v(xbgr.mr_n83580432)
print v(xbgr.mr_n83580544)
print v(xbgr.mr_n83580864)
print v(xbgr.mr_n83580976)
print v(xbgr.mr_n83581296)
print v(xbgr.mr_n83581408)
print v(xbgr.mr_n83581728)
print v(xbgr.mr_n83581840)
print v(xbgr.mr_n83582272)
print v(xbgr.mr_n83582704)
print v(xbgr.mr_n83583136)
print v(xbgr.mr_n83583568)
print v(xbgr.mr_n83584000)
print v(xbgr.mr_n83584432)
print v(xbgr.mr_n83584864)
print v(xbgr.mr_n83585296)
print v(xbgr.mr_n83585728)
print v(xbgr.mr_n83586160)
print v(xbgr.mr_n83586592)
print v(xbgr.mr_n83587024)
print v(xbgr.mr_n83587456)
print v(xbgr.mr_n83587776)
print v(xbgr.mr_n83587888)
print v(xbgr.mr_n83588208)
print v(xbgr.mr_n83588320)
print v(xbgr.mr_n83588640)
print v(xbgr.mr_n83588752)
print v(xbgr.mr_n83589072)
print v(xbgr.mr_n83589184)
print v(xbgr.mr_n83589504)
print v(xbgr.mr_n83589616)
print v(xbgr.mr_n83589936)
print v(xbgr.mr_n83590048)
print v(xbgr.mr_n83590368)
print v(xbgr.mr_n83590480)
print v(xbgr.mr_n83590800)
print v(xbgr.mr_n83590912)
print v(xbgr.mr_n83591232)
print v(xbgr.mr_n83591344)
print v(xbgr.mr_n83591664)
print v(xbgr.mr_n83591776)
print v(xbgr.mr_n83592096)
print v(xbgr.mr_n83592208)
print v(xbgr.mr_n83592528)
print v(xbgr.mr_n83592640)
print v(xbgr.mr_n83592960)
print v(xbgr.mr_n83593072)
print v(xbgr.mr_n83593504)
print v(xbgr.mr_n83593936)
print v(xbgr.mr_n83594368)
print v(xbgr.mr_n83594800)
print v(xbgr.mr_n83595232)
print v(xbgr.mr_n83595664)
print v(xbgr.mr_n83596096)
print v(xbgr.mr_n83596528)
print v(xbgr.mr_n83596960)
print v(xbgr.mr_n83597392)
print v(xbgr.mr_n83597824)
print v(xbgr.mr_n83598256)
print v(xbgr.mr_n83598688)
print v(xbgr.mr_n83599008)
print v(xbgr.mr_n83599120)
print v(xbgr.mr_n83599440)
print v(xbgr.mr_n83599552)
print v(xbgr.mr_n83599872)
print v(xbgr.mr_n83599984)
print v(xbgr.mr_n83600304)
print v(xbgr.mr_n83600416)
print v(xbgr.mr_n83600736)
print v(xbgr.mr_n83600848)
print v(xbgr.mr_n83601168)
print v(xbgr.mr_n83601280)
print v(xbgr.mr_n83601600)
print v(xbgr.mr_n83601712)
print v(xbgr.mr_n83602032)
print v(xbgr.mr_n83602144)
print v(xbgr.mr_n83602464)
print v(xbgr.mr_n83602576)
print v(xbgr.mr_n83602896)
print v(xbgr.mr_n83603008)
print v(xbgr.mr_n83603328)
print v(xbgr.mr_n83603440)
print v(xbgr.mr_n83603760)
print v(xbgr.mr_n83603872)
print v(xbgr.mr_n83604192)
print v(xbgr.mr_n83604304)
print v(xbgr.mr_n83604736)
print v(xbgr.mr_n83605168)
print v(xbgr.mr_n83605600)
print v(xbgr.mr_n83606032)
print v(xbgr.mr_n83606464)
print v(xbgr.mr_n83606896)
print v(xbgr.mr_n83607328)
print v(xbgr.mr_n83607760)
print v(xbgr.mr_n83608192)
print v(xbgr.mr_n83608624)
print v(xbgr.mr_n83609056)
print v(xbgr.mr_n83609488)
print v(xbgr.mr_n83609920)
print v(xbgr.mr_n83610240)
print v(xbgr.mr_n83610352)
print v(xbgr.mr_n83610672)
print v(xbgr.mr_n83610784)
print v(xbgr.mr_n83611104)
print v(xbgr.mr_n83611216)
print v(xbgr.mr_n83611536)
print v(xbgr.mr_n83611648)
print v(xbgr.mr_n83611968)
print v(xbgr.mr_n83612080)
print v(xbgr.mr_n83612400)
print v(xbgr.mr_n83612512)
print v(xbgr.mr_n83612832)
print v(xbgr.mr_n83612944)
print v(xbgr.mr_n83613264)
print v(xbgr.mr_n83613376)
print v(xbgr.mr_n83613696)
print v(xbgr.mr_n83613808)
print v(xbgr.mr_n83614128)
print v(xbgr.mr_n83614240)
print v(xbgr.mr_n83614560)
print v(xbgr.mr_n83614672)
print v(xbgr.mr_n83614992)
print v(xbgr.mr_n83615104)
print v(xbgr.mr_n83615424)
print v(xbgr.mr_n83615536)
print v(xbgr.mr_n83615968)
print v(xbgr.mr_n83616400)
print v(xbgr.mr_n83616832)
print v(xbgr.mr_n83617264)
print v(xbgr.mr_n83617696)
print v(xbgr.mr_n83618128)
print v(xbgr.mr_n83618560)
print v(xbgr.mr_n83618992)
print v(xbgr.mr_n83619424)
print v(xbgr.mr_n83619856)
print v(xbgr.mr_n83620288)
print v(xbgr.mr_n83620720)
print v(xbgr.mr_n83621152)
print v(xbgr.mr_n83621472)
print v(xbgr.mr_n83621584)
print v(xbgr.mr_n83621904)
print v(xbgr.mr_n83622016)
print v(xbgr.mr_n83622336)
print v(xbgr.mr_n83622448)
print v(xbgr.mr_n83622768)
print v(xbgr.mr_n83622880)
print v(xbgr.mr_n83623200)
print v(xbgr.mr_n83623312)
print v(xbgr.mr_n83623744)
print v(xbgr.mr_n83624176)
print v(xbgr.mr_n83624608)
print v(xbgr.mr_n83625040)
print v(xbgr.mr_n83625472)
print v(xbgr.mr_n83625792)
print v(xbgr.mr_n83625904)
print v(xbgr.mr_n83626224)
print v(xbgr.mr_n83626336)
print v(xbgr.mr_n83626656)
print v(xbgr.mr_n83626768)
print v(xbgr.mr_n83627088)
print v(xbgr.mr_n83627200)
print v(xbgr.mr_n83627520)
print v(xbgr.mr_n83627632)
print v(xbgr.mr_n83627952)
print v(xbgr.mr_n83628064)
print v(xbgr.mr_n83628384)
print v(xbgr.mr_n83628496)
print v(xbgr.mr_n83628816)
print v(xbgr.mr_n83628928)
print v(xbgr.mr_n83629360)
print v(xbgr.mr_n83629792)
print v(xbgr.mr_n83630224)
print v(xbgr.mr_n83630656)
print v(xbgr.mr_n83631088)
print v(xbgr.mr_n83631520)
print v(xbgr.mr_n83631952)
print v(xbgr.mr_n83632384)
print v(xbgr.mr_n83632704)
print v(xbgr.mr_n83632816)
print v(xbgr.mr_n83633136)
print v(xbgr.mr_n83633248)
print v(xbgr.mr_n83633568)
print v(xbgr.mr_n83633680)
print v(xbgr.mr_n83634000)
print v(xbgr.mr_n83634112)
print v(xbgr.mr_n83634432)
print v(xbgr.mr_n83634544)
print v(xbgr.mr_n83634864)
print v(xbgr.mr_n83634976)
print v(xbgr.mr_n83635296)
print v(xbgr.mr_n83635408)
print v(xbgr.mr_n83635728)
print v(xbgr.mr_n83635840)
print v(xbgr.mr_n83636272)
print v(xbgr.mr_n83636704)
print v(xbgr.mr_n83637136)
print v(xbgr.mr_n83637568)
print v(xbgr.mr_n83638000)
print v(xbgr.mr_n83638320)
print v(xbgr.mr_n83638432)
print v(xbgr.mr_n83638752)
print v(xbgr.mr_n83638864)
print v(xbgr.mr_n83639184)
print v(xbgr.mr_n83639296)
print v(xbgr.mr_n83639616)
print v(xbgr.mr_n83639728)
print v(xbgr.mr_n83640048)
print v(xbgr.mr_n83640160)
print v(xbgr.mr_n83640592)
print v(xbgr.mr_n83641024)
print v(xbgr.mr_n83641456)
print v(xbgr.mr_n83641888)
print v(xbgr.mr_n83642320)
print v(xbgr.mr_n83642752)
print v(xbgr.mr_n83643184)
print v(xbgr.mr_n83643616)
print v(xbgr.mr_n83643936)
print v(xbgr.mr_n83644048)
print v(xbgr.mr_n83644368)
print v(xbgr.mr_n83644480)
print v(xbgr.mr_n83644800)
print v(xbgr.mr_n83644912)
print v(xbgr.mr_n83645232)
print v(xbgr.mr_n83645344)
print v(xbgr.mr_n83645664)
print v(xbgr.mr_n83645776)
print v(xbgr.mr_n83646096)
print v(xbgr.mr_n83646208)
print v(xbgr.mr_n83646528)
print v(xbgr.mr_n83646640)
print v(xbgr.mr_n83647072)
print v(xbgr.mr_n83647504)
print v(xbgr.mr_n83647936)
print v(xbgr.mr_n83648368)
print v(xbgr.mr_n83648688)
print v(xbgr.mr_n83648800)
print v(xbgr.mr_n83649232)
print v(xbgr.mr_n83649664)
print v(xbgr.mr_n83649984)
print v(xbgr.mr_n83650096)
print v(xbgr.mr_n83650416)
print v(xbgr.mr_n83650528)
print v(xbgr.mr_n83650848)
print v(xbgr.mr_n83650960)
print v(xbgr.mr_n83651280)
print v(xbgr.mr_n83651392)
print v(xbgr.mr_n83651712)
print v(xbgr.mr_n83651824)
print v(xbgr.mr_n83652256)
print v(xbgr.mr_n83652688)
print v(xbgr.mr_n83653120)
print v(xbgr.mr_n83653552)
print v(xbgr.mr_n83653984)
print v(xbgr.mr_n83654416)
print v(xbgr.mr_n83654848)
print v(xbgr.mr_n83655168)
print v(xbgr.mr_n83655280)
print v(xbgr.mr_n83655600)
print v(xbgr.mr_n83655712)
print v(xbgr.mr_n83656032)
print v(xbgr.mr_n83656144)
print v(xbgr.mr_n83656464)
print v(xbgr.mr_n83656576)
print v(xbgr.mr_n83656896)
print v(xbgr.mr_n83657008)
print v(xbgr.mr_n83657328)
print v(xbgr.mr_n83657440)
print v(xbgr.mr_n83657760)
print v(xbgr.mr_n83657872)
print v(xbgr.mr_n83658192)
print v(xbgr.mr_n83658304)
print v(xbgr.mr_n83658624)
print v(xbgr.mr_n83658736)
print v(xbgr.mr_n83659056)
print v(xbgr.mr_n83659168)
print v(xbgr.mr_n83659488)
print v(xbgr.mr_n83659600)
print v(xbgr.mr_n83659920)
print v(xbgr.mr_n83660032)
print v(xbgr.mr_n83660352)
print v(xbgr.mr_n83660464)
print v(xbgr.mr_n83660896)
print v(xbgr.mr_n83661328)
print v(xbgr.mr_n83661760)
print v(xbgr.mr_n83662192)
print v(xbgr.mr_n83662624)
print v(xbgr.mr_n83663056)
print v(xbgr.mr_n83663488)
print v(xbgr.mr_n83663920)
print v(xbgr.mr_n83664352)
print v(xbgr.mr_n83664784)
print v(xbgr.mr_n83665216)
print v(xbgr.mr_n83665648)
print v(xbgr.mr_n83666080)
print v(xbgr.mr_n83666400)
print v(xbgr.mr_n83666512)
print v(xbgr.mr_n83666832)
print v(xbgr.mr_n83666944)
print v(xbgr.mr_n83667264)
print v(xbgr.mr_n83667376)
print v(xbgr.mr_n83667696)
print v(xbgr.mr_n83667808)
print v(xbgr.mr_n83668128)
print v(xbgr.mr_n83668240)
print v(xbgr.mr_n83668560)
print v(xbgr.mr_n83668672)
print v(xbgr.mr_n83668992)
print v(xbgr.mr_n83669104)
print v(xbgr.mr_n83669424)
print v(xbgr.mr_n83669536)
print v(xbgr.mr_n83669856)
print v(xbgr.mr_n83669968)
print v(xbgr.mr_n83670288)
print v(xbgr.mr_n83670400)
print v(xbgr.mr_n83670720)
print v(xbgr.mr_n83670832)
print v(xbgr.mr_n83671152)
print v(xbgr.mr_n83671264)
print v(xbgr.mr_n83671584)
print v(xbgr.mr_n83671696)
print v(xbgr.mr_n83672016)
print v(xbgr.mr_n83672128)
print v(xbgr.mr_n83672448)
print v(xbgr.mr_n83672560)
print v(xbgr.mr_n83672880)
print v(xbgr.mr_n83672992)
print v(xbgr.mr_n83673424)
print v(xbgr.mr_n83673856)
print v(xbgr.mr_n83674288)
print v(xbgr.mr_n83674720)
print v(xbgr.mr_n83675152)
print v(xbgr.mr_n83675584)
print v(xbgr.mr_n83675904)
print v(xbgr.mr_n83676016)
print v(xbgr.mr_n83676336)
print v(xbgr.mr_n83676448)
print v(xbgr.mr_n83676768)
print v(xbgr.mr_n83676880)
print v(xbgr.mr_n83677200)
print v(xbgr.mr_n83677312)
print v(xbgr.mr_n83677632)
print v(xbgr.mr_n83677744)
print v(xbgr.mr_n83678064)
print v(xbgr.mr_n83678176)
print v(xbgr.mr_n83678496)
print v(xbgr.mr_n83678608)
print v(xbgr.mr_n83678928)
print v(xbgr.mr_n83679040)
print v(xbgr.mr_n83679360)
print v(xbgr.mr_n83679472)
print v(xbgr.mr_n83679792)
print v(xbgr.mr_n83679904)
print v(xbgr.mr_n83680336)
print v(xbgr.mr_n83680768)
print v(xbgr.mr_n83681200)
print v(xbgr.mr_n83681632)
print v(xbgr.mr_n83682064)
print v(xbgr.mr_n83682496)
print v(xbgr.mr_n83682928)
print v(xbgr.mr_n83683360)
print v(xbgr.mr_n83683792)
print v(xbgr.mr_n83684224)
print v(xbgr.mr_n83684656)
print v(xbgr.mr_n83685088)
print v(xbgr.mr_n83685520)
print v(xbgr.mr_n83685952)
print v(xbgr.mr_n83686384)
print v(xbgr.mr_n83686816)
print v(xbgr.mr_n83687248)
print v(xbgr.mr_n83687680)
print v(xbgr.mr_n83688112)
print v(xbgr.mr_n83688544)
print v(xbgr.mr_n83688864)
print v(xbgr.mr_n83688976)
print v(xbgr.mr_n83689296)
print v(xbgr.mr_n83689408)
print v(xbgr.mr_n83689728)
print v(xbgr.mr_n83689840)
print v(xbgr.mr_n83690160)
print v(xbgr.mr_n83690272)
print v(xbgr.mr_n83690592)
print v(xbgr.mr_n83690704)
print v(xbgr.mr_n83691024)
print v(xbgr.mr_n83691136)
print v(xbgr.mr_n83691456)
print v(xbgr.mr_n83691568)
print v(xbgr.mr_n83691888)
print v(xbgr.mr_n83692000)
print v(xbgr.mr_n83692320)
print v(xbgr.mr_n83692432)
print v(xbgr.mr_n83692752)
print v(xbgr.mr_n83692864)
print v(xbgr.mr_n83693184)
print v(xbgr.mr_n83693296)
print v(xbgr.mr_n83693616)
print v(xbgr.mr_n83693728)
print v(xbgr.mr_n83694048)
print v(xbgr.mr_n83694160)
print v(xbgr.mr_n83694480)
print v(xbgr.mr_n83694592)
print v(xbgr.mr_n83695024)
print v(xbgr.mr_n83695456)
print v(xbgr.mr_n83695888)
print v(xbgr.mr_n83696320)
print v(xbgr.mr_n83696640)
print v(xbgr.mr_n83696752)
print v(xbgr.mr_n83697072)
print v(xbgr.mr_n83697184)
print v(xbgr.mr_n83697504)
print v(xbgr.mr_n83697616)
print v(xbgr.mr_n83697936)
print v(xbgr.mr_n83698048)
print v(xbgr.mr_n83698368)
print v(xbgr.mr_n83698480)
print v(xbgr.mr_n83698800)
print v(xbgr.mr_n83698912)
print v(xbgr.mr_n83699344)
print v(xbgr.mr_n83699776)
print v(xbgr.mr_n83700208)
print v(xbgr.mr_n83700640)
print v(xbgr.mr_n83701072)
print v(xbgr.mr_n83701504)
print v(xbgr.mr_n83701936)
print v(xbgr.mr_n83702368)
print v(xbgr.mr_n83702800)
print v(xbgr.mr_n83703232)
print v(xbgr.mr_n83703552)
print v(xbgr.mr_n83703664)
print v(xbgr.mr_n83703984)
print v(xbgr.mr_n83704096)
print v(xbgr.mr_n83704528)
print v(xbgr.mr_n83704960)
print v(xbgr.mr_n83705280)
print v(xbgr.mr_n83705392)
print v(xbgr.mr_n83705712)
print v(xbgr.mr_n83705824)
print v(xbgr.mr_n83706144)
print v(xbgr.mr_n83706256)
print v(xbgr.mr_n83706576)
print v(xbgr.mr_n83706688)
print v(xbgr.mr_n83707120)
print v(xbgr.mr_n83707552)
print v(xbgr.mr_n83707984)
print v(xbgr.mr_n83708416)
print v(xbgr.mr_n83708848)
print v(xbgr.mr_n83709280)
print v(xbgr.mr_n83709712)
print v(xbgr.mr_n83710144)
print v(xbgr.mr_n83710576)
print v(xbgr.mr_n83711008)
print v(xbgr.mr_n83711328)
print v(xbgr.mr_n83711440)
print v(xbgr.mr_n83711760)
print v(xbgr.mr_n83711872)
print v(xbgr.mr_n83712192)
print v(xbgr.mr_n83712304)
print v(xbgr.mr_n83712624)
print v(xbgr.mr_n83712736)
print v(xbgr.mr_n83713056)
print v(xbgr.mr_n83713168)
print v(xbgr.mr_n83713488)
print v(xbgr.mr_n83713600)
print v(xbgr.mr_n83713920)
print v(xbgr.mr_n83714032)
print v(xbgr.mr_n83714352)
print v(xbgr.mr_n83714464)
print v(xbgr.mr_n83714784)
print v(xbgr.mr_n83714896)
print v(xbgr.mr_n83715216)
print v(xbgr.mr_n83715328)
print v(xbgr.mr_n83715648)
print v(xbgr.mr_n83715760)
print v(xbgr.mr_n83716080)
print v(xbgr.mr_n83716192)
print v(xbgr.mr_n83716512)
print v(xbgr.mr_n83716624)
print v(xbgr.mr_n83716944)
print v(xbgr.mr_n83717056)
print v(xbgr.mr_n83717376)
print v(xbgr.mr_n83717488)
print v(xbgr.mr_n83717808)
print v(xbgr.mr_n83717920)
print v(xbgr.mr_n83718240)
print v(xbgr.mr_n83718352)
print v(xbgr.mr_n83718672)
print v(xbgr.mr_n83718784)
print v(xbgr.mr_n83719104)
print v(xbgr.mr_n83719216)
print v(xbgr.mr_n83719536)
print v(xbgr.mr_n83719648)
print v(xbgr.mr_n83719968)
print v(xbgr.mr_n83720080)
print v(xbgr.mr_n83720400)
print v(xbgr.mr_n83720832)
print v(xbgr.mr_n83720944)
print v(xbgr.mr_n83721264)
print v(xbgr.mr_n83721696)
print v(xbgr.mr_n83721808)
print v(xbgr.mr_n83722128)
print v(xbgr.mr_n83722560)
print v(xbgr.mr_n83722672)
print v(xbgr.mr_n83722992)
print v(xbgr.mr_n83723424)
print v(xbgr.mr_n83723536)
print v(xbgr.mr_n83723856)
print v(xbgr.mr_n83724288)
print v(xbgr.mr_n83724400)
print v(xbgr.mr_n83724720)
print v(xbgr.mr_n83724832)
print v(xbgr.mr_n83725152)
print v(xbgr.mr_n83725264)
print v(xbgr.mr_n83725584)
print v(xbgr.mr_n83725696)
print v(xbgr.mr_n83726016)
print v(xbgr.mr_n83726128)
print v(xbgr.mr_n83726448)
print v(xbgr.mr_n83726560)
print v(xbgr.mr_n83726880)
print v(xbgr.mr_n83726992)
print v(xbgr.mr_n83727312)
print v(xbgr.mr_n83727424)
print v(xbgr.mr_n83727744)
print v(xbgr.mr_n83727856)
print v(xbgr.mr_n83728176)
print v(xbgr.mr_n83728288)
print v(xbgr.mr_n83728608)
print v(xbgr.mr_n83728720)
print v(xbgr.mr_n83729040)
print v(xbgr.mr_n83729152)
print v(xbgr.mr_n83729472)
print v(xbgr.mr_n83729584)
print v(xbgr.mr_n83729904)
print v(xbgr.mr_n83730016)
print v(xbgr.mr_n83730336)
print v(xbgr.mr_n83730448)
print v(xbgr.mr_n83730768)
print v(xbgr.mr_n83730880)
print v(xbgr.mr_n83731200)
print v(xbgr.mr_n83731312)
print v(xbgr.mr_n83731632)
print v(xbgr.mr_n83731744)
print v(xbgr.mr_n83732064)
print v(xbgr.mr_n83732176)
print v(xbgr.mr_n83732496)
print v(xbgr.mr_n83732608)
print v(xbgr.mr_n83732928)
print v(xbgr.mr_n83733040)
print v(xbgr.mr_n83733360)
print v(xbgr.mr_n83733472)
print v(xbgr.mr_n83733792)
print v(xbgr.mr_n83733904)
print v(xbgr.mr_n83734224)
print v(xbgr.mr_n83734336)
print v(xbgr.mr_n83734656)
print v(xbgr.mr_n83734768)
print v(xbgr.mr_n83735088)
print v(xbgr.mr_n83735200)
print v(xbgr.mr_n83735520)
print v(xbgr.mr_n83735632)
print v(xbgr.mr_n83735952)
print v(xbgr.mr_n83736064)
print v(xbgr.mr_n83736384)
print v(xbgr.mr_n83736496)
print v(xbgr.mr_n83736816)
print v(xbgr.mr_n83736928)
print v(xbgr.mr_n83737248)
print v(xbgr.mr_n83737360)
print v(xbgr.mr_n83737680)
print v(xbgr.mr_n83737792)
print v(xbgr.mr_n83738112)
print v(xbgr.mr_n83738224)
print v(xbgr.mr_n83738544)
print v(xbgr.mr_n83738656)
print v(xbgr.mr_n83738976)
print v(xbgr.mr_n83739088)
print v(xbgr.mr_n83739408)
print v(xbgr.mr_n83739520)
print v(xbgr.mr_n83739840)
print v(xbgr.mr_n83739952)
print v(xbgr.mr_n83740272)
print v(xbgr.mr_n83740384)
print v(xbgr.mr_n83740704)
print v(xbgr.mr_n83740816)
print v(xbgr.mr_n83741136)
print v(xbgr.mr_n83741248)
print v(xbgr.mr_n83741568)
print v(xbgr.mr_n83741680)
print v(xbgr.mr_n83742000)
print v(xbgr.mr_n83742112)
print v(xbgr.mr_n83742432)
print v(xbgr.mr_n83742544)
print v(xbgr.mr_n83742864)
print v(xbgr.mr_n83742976)
print v(xbgr.mr_n83743296)
print v(xbgr.mr_n83743408)
print v(xbgr.mr_n83743728)
print v(xbgr.mr_n83743840)
print v(xbgr.mr_n83744160)
print v(xbgr.mr_n83744272)
print v(xbgr.mr_n83744592)
print v(xbgr.mr_n83744704)
print v(xbgr.mr_n83745024)
print v(xbgr.mr_n83745136)
print v(xbgr.mr_n83745456)
print v(xbgr.mr_n83745568)
print v(xbgr.mr_n83745888)
print v(xbgr.mr_n83746000)
print v(xbgr.mr_n83746320)
print v(xbgr.mr_n83746432)
print v(xbgr.mr_n83746752)
print v(xbgr.mr_n83746864)
print v(xbgr.mr_n83747184)
print v(xbgr.mr_n83747296)
print v(xbgr.mr_n83747616)
print v(xbgr.mr_n83747728)
print v(xbgr.mr_n83748048)
print v(xbgr.mr_n83748160)
print v(xbgr.mr_n83748480)
print v(xbgr.mr_n83748592)
print v(xbgr.mr_n83748912)
print v(xbgr.mr_n83749024)
print v(xbgr.mr_n83749344)
print v(xbgr.mr_n83749456)
print v(xbgr.mr_n83749776)
print v(xbgr.mr_n83749888)
print v(xbgr.mr_n83750208)
print v(xbgr.mr_n83750320)
print v(xbgr.mr_n83750640)
print v(xbgr.mr_n83750752)
print v(xbgr.mr_n83751072)
print v(xbgr.mr_n83751184)
print v(xbgr.mr_n83751504)
print v(xbgr.mr_n83751616)
print v(xbgr.mr_n83751936)
print v(xbgr.mr_n83752048)
print v(xbgr.mr_n83752368)
print v(xbgr.mr_n83752480)
print v(xbgr.mr_n83752800)
print v(xbgr.mr_n83752912)
print v(xbgr.mr_n83753232)
print v(xbgr.mr_n83753344)
print v(xbgr.mr_n83753664)
print v(xbgr.mr_n83753776)
print v(xbgr.mr_n83754096)
print v(xbgr.mr_n83754208)
print v(xbgr.mr_n83754528)
print v(xbgr.mr_n83754640)
print v(xbgr.mr_n83754960)
print v(xbgr.mr_n83755072)
print v(xbgr.mr_n83755392)
print v(xbgr.mr_n83755824)
print v(xbgr.mr_n83755936)
print v(xbgr.mr_n83756256)
print v(xbgr.mr_n83756688)
print v(xbgr.mr_n83756800)
print v(xbgr.mr_n83757120)
print v(xbgr.mr_n83757552)
print v(xbgr.mr_n83757664)
print v(xbgr.mr_n83757984)
print v(xbgr.mr_n83758416)
print v(xbgr.mr_n83758528)
print v(xbgr.mr_n83758848)
print v(xbgr.mr_n83758960)
print v(xbgr.mr_n83759280)
print v(xbgr.mr_n83759392)
print v(xbgr.mr_n83759712)
print v(xbgr.mr_n83759824)
print v(xbgr.mr_n83760144)
print v(xbgr.mr_n83760576)
print v(xbgr.mr_n83760688)
print v(xbgr.mr_n83761008)
print v(xbgr.mr_n83761440)
print v(xbgr.mr_n83761552)
print v(xbgr.mr_n83761872)
print v(xbgr.mr_n83762304)
print v(xbgr.mr_n83762416)
print v(xbgr.mr_n83762736)
print v(xbgr.mr_n83763168)
print v(xbgr.mr_n83763280)
print v(xbgr.mr_n83763600)
print v(xbgr.mr_n83763712)
print v(xbgr.mr_n83764032)
print v(xbgr.mr_n83764144)
print v(xbgr.mr_n83764464)
print v(xbgr.mr_n83764576)
print v(xbgr.mr_n83764896)
print v(xbgr.mr_n83765008)
print v(xbgr.mr_n83765328)
print v(xbgr.mr_n83765440)
print v(xbgr.mr_n83765760)
print v(xbgr.mr_n83765872)
print v(xbgr.mr_n83766192)
print v(xbgr.mr_n83766304)
print v(xbgr.mr_n83766624)
print v(xbgr.mr_n83766736)
print v(xbgr.mr_n83767056)
print v(xbgr.mr_n83767168)
print v(xbgr.mr_n83767488)
print v(xbgr.mr_n83767600)
print v(xbgr.mr_n83767920)
print v(xbgr.mr_n83768032)
print v(xbgr.mr_n83768352)
print v(xbgr.mr_n83768464)
print v(xbgr.mr_n83768784)
print v(xbgr.mr_n83768896)
print v(xbgr.mr_n83769216)
print v(xbgr.mr_n83769328)
print v(xbgr.mr_n83769648)
print v(xbgr.mr_n83769760)
print v(xbgr.mr_n83770080)
print v(xbgr.mr_n83770192)
print v(xbgr.mr_n83770512)
print v(xbgr.mr_n83770624)
print v(xbgr.mr_n83770944)
print v(xbgr.mr_n83771056)
print v(xbgr.mr_n83771376)
print v(xbgr.mr_n83771488)
print v(xbgr.mr_n83771808)
print v(xbgr.mr_n83771920)
print v(xbgr.mr_n83772240)
print v(xbgr.mr_n83772352)
print v(xbgr.mr_n83772672)
print v(xbgr.mr_n83772784)
print v(xbgr.mr_n83773104)
print v(xbgr.mr_n83773216)
print v(xbgr.mr_n83773536)
print v(xbgr.mr_n83773648)
print v(xbgr.mr_n83773968)
print v(xbgr.mr_n83774080)
print v(xbgr.mr_n83774400)
print v(xbgr.mr_n83774512)
print v(xbgr.mr_n83774832)
print v(xbgr.mr_n83774944)
print v(xbgr.mr_n83775376)
print v(xbgr.mr_n83775808)
print v(xbgr.mr_n83776240)
print v(xbgr.mr_n83776672)
print v(xbgr.mr_n83777104)
print v(xbgr.mr_n83777536)
print v(xbgr.mr_n83777968)
print v(xbgr.mr_n83778400)
print v(xbgr.mr_n83778832)
print v(xbgr.mr_n83779264)
print v(xbgr.mr_n83779696)
print v(xbgr.mr_n83780128)
print v(xbgr.mr_n83780560)
print v(xbgr.mr_n83780992)
print v(xbgr.mr_n83781424)
print v(xbgr.mr_n83781856)
print v(xbgr.mr_n83782288)
print v(xbgr.mr_n83782720)
print v(xbgr.mr_n83783152)
print v(xbgr.mr_n83783584)
print v(xbgr.mr_n83784016)
print v(xbgr.mr_n83784448)
print v(xbgr.mr_n83784880)
print v(xbgr.mr_n83785312)
print v(xbgr.mr_n83785744)
print v(xbgr.mr_n83786176)
print v(xbgr.mr_n83786496)
print v(xbgr.mr_n83786608)
print v(xbgr.mr_n83786928)
print v(xbgr.mr_n83787040)
print v(xbgr.mr_n83787360)
print v(xbgr.mr_n83787472)
print v(xbgr.mr_n83787792)
print v(xbgr.mr_n83787904)
print v(xbgr.mr_n83788224)
print v(xbgr.mr_n83788336)
print v(xbgr.mr_n83788656)
print v(xbgr.mr_n83788768)
print v(xbgr.mr_n83789088)
print v(xbgr.mr_n83789200)
print v(xbgr.mr_n83789520)
print v(xbgr.mr_n83789632)
print v(xbgr.mr_n83789952)
print v(xbgr.mr_n83790064)
print v(xbgr.mr_n83790384)
print v(xbgr.mr_n83790496)
print v(xbgr.mr_n83790816)
print v(xbgr.mr_n83790928)
print v(xbgr.mr_n83791248)
print v(xbgr.mr_n83791360)
print v(xbgr.mr_n83791680)
print v(xbgr.mr_n83791792)
print v(xbgr.mr_n83792112)
print v(xbgr.mr_n83792224)
print v(xbgr.mr_n83792544)
print v(xbgr.mr_n83792656)
print v(xbgr.mr_n83792976)
print v(xbgr.mr_n83793088)
print v(xbgr.mr_n83793408)
print v(xbgr.mr_n83793520)
print v(xbgr.mr_n83793840)
print v(xbgr.mr_n83793952)
print v(xbgr.mr_n83794272)
print v(xbgr.mr_n83794384)
print v(xbgr.mr_n83794704)
print v(xbgr.mr_n83794816)
print v(xbgr.mr_n83795248)
print v(xbgr.mr_n83795680)
print v(xbgr.mr_n83796112)
print v(xbgr.mr_n83796544)
print v(xbgr.mr_n83796976)
print v(xbgr.mr_n83797408)
print v(xbgr.mr_n83797840)
print v(xbgr.mr_n83798272)
print v(xbgr.mr_n83798704)
print v(xbgr.mr_n83799136)
print v(xbgr.mr_n83799568)
print v(xbgr.mr_n83800000)
print v(xbgr.mr_n83800320)
print v(xbgr.mr_n83800432)
print v(xbgr.mr_n83800752)
print v(xbgr.mr_n83800864)
print v(xbgr.mr_n83801296)
print v(xbgr.mr_n83801728)
print v(xbgr.mr_n83802160)
print v(xbgr.mr_n83802592)
print v(xbgr.mr_n83803024)
print v(xbgr.mr_n83803456)
print v(xbgr.mr_n83803888)
print v(xbgr.mr_n83804320)
print v(xbgr.mr_n83804752)
print v(xbgr.mr_n83805184)
print v(xbgr.mr_n83805504)
print v(xbgr.mr_n83805616)
print v(xbgr.mr_n83805936)
print v(xbgr.mr_n83806048)
print v(xbgr.mr_n83806368)
print v(xbgr.mr_n83806480)
print v(xbgr.mr_n83806800)
print v(xbgr.mr_n83806912)
print v(xbgr.mr_n83807232)
print v(xbgr.mr_n83807344)
print v(xbgr.mr_n83807664)
print v(xbgr.mr_n83807776)
print v(xbgr.mr_n83808096)
print v(xbgr.mr_n83808208)
print v(xbgr.mr_n83808528)
print v(xbgr.mr_n83808640)
print v(xbgr.mr_n83808960)
print v(xbgr.mr_n83809072)
print v(xbgr.mr_n83809392)
print v(xbgr.mr_n83809504)
print v(xbgr.mr_n83809824)
print v(xbgr.mr_n83809936)
print v(xbgr.mr_n83810256)
print v(xbgr.mr_n83810368)
print v(xbgr.mr_n83810688)
print v(xbgr.mr_n83810800)
print v(xbgr.mr_n83811120)
print v(xbgr.mr_n83811232)
print v(xbgr.mr_n83811552)
print v(xbgr.mr_n83811664)
print v(xbgr.mr_n83811984)
print v(xbgr.mr_n83812096)
print v(xbgr.mr_n83812416)
print v(xbgr.mr_n83812528)
print v(xbgr.mr_n83812848)
print v(xbgr.mr_n83812960)
print v(xbgr.mr_n83813280)
print v(xbgr.mr_n83813392)
print v(xbgr.mr_n83813712)
print v(xbgr.mr_n83813824)
print v(xbgr.mr_n83814144)
print v(xbgr.mr_n83814256)
print v(xbgr.mr_n83814576)
print v(xbgr.mr_n83814688)
print v(xbgr.mr_n83815008)
print v(xbgr.mr_n83815120)
print v(xbgr.mr_n83815440)
print v(xbgr.mr_n83815552)
print v(xbgr.mr_n83815872)
print v(xbgr.mr_n83815984)
print v(xbgr.mr_n83816304)
print v(xbgr.mr_n83816416)
print v(xbgr.mr_n83816736)
print v(xbgr.mr_n83817168)
print v(xbgr.mr_n83817280)
print v(xbgr.mr_n83817600)
print v(xbgr.mr_n83818032)
print v(xbgr.mr_n83818144)
print v(xbgr.mr_n83818464)
print v(xbgr.mr_n83818896)
print v(xbgr.mr_n83819008)
print v(xbgr.mr_n83819328)
print v(xbgr.mr_n83819760)
print v(xbgr.mr_n83819872)
print v(xbgr.mr_n83820192)
print v(xbgr.mr_n83820624)
print v(xbgr.mr_n83820736)
print v(xbgr.mr_n83821056)
print v(xbgr.mr_n83821168)
print v(xbgr.mr_n83821488)
print v(xbgr.mr_n83821600)
print v(xbgr.mr_n83821920)
print v(xbgr.mr_n83822032)
print v(xbgr.mr_n83822352)
print v(xbgr.mr_n83822464)
print v(xbgr.mr_n83822784)
print v(xbgr.mr_n83822896)
print v(xbgr.mr_n83823216)
print v(xbgr.mr_n83823328)
print v(xbgr.mr_n83823648)
print v(xbgr.mr_n83823760)
print v(xbgr.mr_n83824080)
print v(xbgr.mr_n83824192)
print v(xbgr.mr_n83824512)
print v(xbgr.mr_n83824624)
print v(xbgr.mr_n83824944)
print v(xbgr.mr_n83825056)
print v(xbgr.mr_n83825376)
print v(xbgr.mr_n83825488)
print v(xbgr.mr_n83825808)
print v(xbgr.mr_n83825920)
print v(xbgr.mr_n83826240)
print v(xbgr.mr_n83826352)
print v(xbgr.mr_n83826672)
print v(xbgr.mr_n83826784)
print v(xbgr.mr_n83827104)
print v(xbgr.mr_n83827216)
print v(xbgr.mr_n83827536)
print v(xbgr.mr_n83827648)
print v(xbgr.mr_n83827968)
print v(xbgr.mr_n83828080)
print v(xbgr.mr_n83828400)
print v(xbgr.mr_n83828512)
print v(xbgr.mr_n83828832)
print v(xbgr.mr_n83828944)
print v(xbgr.mr_n83829264)
print v(xbgr.mr_n83829376)
print v(xbgr.mr_n83829696)
print v(xbgr.mr_n83829808)
print v(xbgr.mr_n83830128)
print v(xbgr.mr_n83830240)
print v(xbgr.mr_n83830560)
print v(xbgr.mr_n83830672)
print v(xbgr.mr_n83830992)
print v(xbgr.mr_n83831104)
print v(xbgr.mr_n83831424)
print v(xbgr.mr_n83831536)
print v(xbgr.mr_n83831856)
print v(xbgr.mr_n83831968)
print v(xbgr.mr_n83832288)
print v(xbgr.mr_n83832400)
print v(xbgr.mr_n83832720)
print v(xbgr.mr_n83832832)
print v(xbgr.mr_n83833152)
print v(xbgr.mr_n83833264)
print v(xbgr.mr_n83833584)
print v(xbgr.mr_n83833696)
print v(xbgr.mr_n83834016)
print v(xbgr.mr_n83834128)
print v(xbgr.mr_n83834448)
print v(xbgr.mr_n83834560)
print v(xbgr.mr_n83834880)
print v(xbgr.mr_n83834992)
print v(xbgr.mr_n83835312)
print v(xbgr.mr_n83835424)
print v(xbgr.mr_n83835744)
print v(xbgr.mr_n83835856)
print v(xbgr.mr_n83836176)
print v(xbgr.mr_n83836288)
print v(xbgr.mr_n83836608)
print v(xbgr.mr_n83836720)
print v(xbgr.mr_n83837040)
print v(xbgr.mr_n83837152)
print v(xbgr.mr_n83837472)
print v(xbgr.mr_n83837584)
print v(xbgr.mr_n83837904)
print v(xbgr.mr_n83838016)
print v(xbgr.mr_n83838336)
print v(xbgr.mr_n83838448)
print v(xbgr.mr_n83838768)
print v(xbgr.mr_n83838880)
print v(xbgr.mr_n83839200)
print v(xbgr.mr_n83839632)
print v(xbgr.mr_n83839744)
print v(xbgr.mr_n83840064)
print v(xbgr.mr_n83840176)
print v(xbgr.mr_n83840496)
print v(xbgr.mr_n83840608)
print v(xbgr.mr_n83840928)
print v(xbgr.mr_n83841360)
print v(xbgr.mr_n83841472)
print v(xbgr.mr_n83841792)
print v(xbgr.mr_n83842224)
print v(xbgr.mr_n83842336)
print v(xbgr.mr_n83842656)
print v(xbgr.mr_n83842768)
print v(xbgr.mr_n83843088)
print v(xbgr.mr_n83843200)
print v(xbgr.mr_n83843520)
print v(xbgr.mr_n83843632)
print v(xbgr.mr_n83843952)
print v(xbgr.mr_n83844064)
print v(xbgr.mr_n83844384)
print v(xbgr.mr_n83844496)
print v(xbgr.mr_n83844816)
print v(xbgr.mr_n83844928)
print v(xbgr.mr_n83845248)
print v(xbgr.mr_n83845360)
print v(xbgr.mr_n83845680)
print v(xbgr.mr_n83845792)
print v(xbgr.mr_n83846112)
print v(xbgr.mr_n83846224)
print v(xbgr.mr_n83846544)
print v(xbgr.mr_n83846656)
print v(xbgr.mr_n83846976)
print v(xbgr.mr_n83847088)
print v(xbgr.mr_n83847408)
print v(xbgr.mr_n83847520)
print v(xbgr.mr_n83847840)
print v(xbgr.mr_n83848272)
print v(xbgr.mr_n83848384)
print v(xbgr.mr_n83848704)
print v(xbgr.mr_n83848816)
print v(xbgr.mr_n83849136)
print v(xbgr.mr_n83849248)
print v(xbgr.mr_n83849568)
print v(xbgr.mr_n83849680)
print v(xbgr.mr_n83850000)
print v(xbgr.mr_n83850112)
print v(xbgr.mr_n83850432)
print v(xbgr.mr_n83850544)
print v(xbgr.mr_n83850864)
print v(xbgr.mr_n83850976)
print v(xbgr.mr_n83851296)
print v(xbgr.mr_n83851408)
print v(xbgr.mr_n83851728)
print v(xbgr.mr_n83851840)
print v(xbgr.mr_n83852160)
print v(xbgr.mr_n83852272)
print v(xbgr.mr_n83852592)
print v(xbgr.mr_n83852704)
print v(xbgr.mr_n83853024)
print v(xbgr.mr_n83853136)
print v(xbgr.mr_n83853456)
print v(xbgr.mr_n83853568)
print v(xbgr.mr_n83853888)
print v(xbgr.mr_n83854000)
print v(xbgr.mr_n83854320)
print v(xbgr.mr_n83854432)
print v(xbgr.mr_n83854752)
print v(xbgr.mr_n83854864)
print v(xbgr.mr_n83855184)
print v(xbgr.mr_n83855296)
print v(xbgr.mr_n83855616)
print v(xbgr.mr_n83855728)
print v(xbgr.mr_n83856048)
print v(xbgr.mr_n83856160)
print v(xbgr.mr_n83856480)
print v(xbgr.mr_n83856592)
print v(xbgr.mr_n83856912)
print v(xbgr.mr_n83857024)
print v(xbgr.mr_n83857344)
print v(xbgr.mr_n83857456)
print v(xbgr.mr_n83857776)
print v(xbgr.mr_n83857888)
print v(xbgr.mr_n83858208)
print v(xbgr.mr_n83858320)
print v(xbgr.mr_n83858640)
print v(xbgr.mr_n83858752)
print v(xbgr.mr_n83859072)
print v(xbgr.mr_n83859184)
print v(xbgr.mr_n83859504)
print v(xbgr.mr_n83859616)
print v(xbgr.mr_n83859936)
print v(xbgr.mr_n83860048)
print v(xbgr.mr_n83860368)
print v(xbgr.mr_n83860480)
print v(xbgr.mr_n83860800)
print v(xbgr.mr_n83860912)
print v(xbgr.mr_n83861232)
print v(xbgr.mr_n83861344)
print v(xbgr.mr_n83861664)
print v(xbgr.mr_n83861776)
print v(xbgr.mr_n83862096)
print v(xbgr.mr_n83862208)
print v(xbgr.mr_n83862528)
print v(xbgr.mr_n83862640)
print v(xbgr.mr_n83862960)
print v(xbgr.mr_n83863072)
print v(xbgr.mr_n83863392)
print v(xbgr.mr_n83863504)
print v(xbgr.mr_n83863824)
print v(xbgr.mr_n83863936)
print v(xbgr.mr_n83864256)
print v(xbgr.mr_n83864368)
print v(xbgr.mr_n83864688)
print v(xbgr.mr_n83864800)
print v(xbgr.mr_n83865120)
print v(xbgr.mr_n83865232)
print v(xbgr.mr_n83865552)
print v(xbgr.mr_n83865664)
print v(xbgr.mr_n83865984)
print v(xbgr.mr_n83866096)
print v(xbgr.mr_n83866416)
print v(xbgr.mr_n83866528)
print v(xbgr.mr_n83866848)
print v(xbgr.mr_n83866960)
print v(xbgr.mr_n83867280)
print v(xbgr.mr_n83867392)
print v(xbgr.mr_n83867712)
print v(xbgr.mr_n83867824)
print v(xbgr.mr_n83868144)
print v(xbgr.mr_n83868256)
print v(xbgr.mr_n83868576)
print v(xbgr.mr_n83868688)
print v(xbgr.mr_n83869008)
print v(xbgr.mr_n83869120)
print v(xbgr.mr_n83869440)
print v(xbgr.mr_n83869552)
print v(xbgr.mr_n83869984)
print v(xbgr.mr_n83870416)
print v(xbgr.mr_n83870848)
print v(xbgr.mr_n83871280)
print v(xbgr.mr_n83871712)
print v(xbgr.mr_n83872144)
print v(xbgr.mr_n83872576)
print v(xbgr.mr_n83873008)
print v(xbgr.mr_n83873328)
print v(xbgr.mr_n83873440)
print v(xbgr.mr_n83873760)
print v(xbgr.mr_n83873872)
print v(xbgr.mr_n83874192)
print v(xbgr.mr_n83874304)
print v(xbgr.mr_n83874624)
print v(xbgr.mr_n83874736)
print v(xbgr.mr_n83875056)
print v(xbgr.mr_n83875168)
print v(xbgr.mr_n83875488)
print v(xbgr.mr_n83875600)
print v(xbgr.mr_n83875920)
print v(xbgr.mr_n83876032)
print v(xbgr.mr_n83876352)
print v(xbgr.mr_n83876464)
print v(xbgr.mr_n83876896)
print v(xbgr.mr_n83877328)
print v(xbgr.mr_n83877760)
print v(xbgr.mr_n83878192)
print v(xbgr.mr_n83878624)
print v(xbgr.mr_n83879056)
print v(xbgr.mr_n83879376)
print v(xbgr.mr_n83879488)
print v(xbgr.mr_n83879920)
print v(xbgr.mr_n83880352)
print v(xbgr.mr_n83880784)
print v(xbgr.mr_n83881216)
print v(xbgr.mr_n83881648)
print v(xbgr.mr_n83882080)
print v(xbgr.mr_n83882512)
print v(xbgr.mr_n83882944)
print v(xbgr.mr_n83883376)
print v(xbgr.mr_n83883808)
print v(xbgr.mr_n83884240)
print v(xbgr.mr_n83884672)
print v(xbgr.mr_n83884992)
print v(xbgr.mr_n83885104)
print v(xbgr.mr_n83885424)
print v(xbgr.mr_n83885536)
print v(xbgr.mr_n83885856)
print v(xbgr.mr_n83885968)
print v(xbgr.mr_n83886288)
print v(xbgr.mr_n83886400)
print v(xbgr.mr_n83886720)
print v(xbgr.mr_n83886832)
print v(xbgr.mr_n83887152)
print v(xbgr.mr_n83887264)
print v(xbgr.mr_n83887584)
print v(xbgr.mr_n83887696)
print v(xbgr.mr_n83888016)
print v(xbgr.mr_n83888128)
print v(xbgr.mr_n83888448)
print v(xbgr.mr_n83888560)
print v(xbgr.mr_n83888880)
print v(xbgr.mr_n83888992)
print v(xbgr.mr_n83889312)
print v(xbgr.mr_n83889424)
print v(xbgr.mr_n83889744)
print v(xbgr.mr_n83889856)
print v(xbgr.mr_n83890176)
print v(xbgr.mr_n83890288)
print v(xbgr.mr_n83890608)
print v(xbgr.mr_n83890720)
print v(xbgr.mr_n83891040)
print v(xbgr.mr_n83891152)
print v(xbgr.mr_n83891472)
print v(xbgr.mr_n83891584)
print v(xbgr.mr_n83891904)
print v(xbgr.mr_n83892016)
print v(xbgr.mr_n83892336)
print v(xbgr.mr_n83892448)
print v(xbgr.mr_n83892768)
print v(xbgr.mr_n83892880)
print v(xbgr.mr_n83893200)
print v(xbgr.mr_n83893312)
print v(xbgr.mr_n83893632)
print v(xbgr.mr_n83893744)
print v(xbgr.mr_n83894176)
print v(xbgr.mr_n83894608)
print v(xbgr.mr_n83895040)
print v(xbgr.mr_n83895472)
print v(xbgr.mr_n83895904)
print v(xbgr.mr_n83896336)
print v(xbgr.mr_n83896768)
print v(xbgr.mr_n83897200)
print v(xbgr.mr_n83897632)
print v(xbgr.mr_n83898064)
print v(xbgr.mr_n83898496)
print v(xbgr.mr_n83898928)
print v(xbgr.mr_n83899360)
print v(xbgr.mr_n83899792)
print v(xbgr.mr_n83900224)
print v(xbgr.mr_n83900656)
print v(xbgr.mr_n83901088)
print v(xbgr.mr_n83901520)
print v(xbgr.mr_n83901952)
print v(xbgr.mr_n83902272)
print v(xbgr.mr_n83902384)
print v(xbgr.mr_n83902704)
print v(xbgr.mr_n83902816)
print v(xbgr.mr_n83903136)
print v(xbgr.mr_n83903248)
print v(xbgr.mr_n83903568)
print v(xbgr.mr_n83903680)
print v(xbgr.mr_n83904000)
print v(xbgr.mr_n83904112)
print v(xbgr.mr_n83904544)
print v(xbgr.mr_n83904976)
print v(xbgr.mr_n83905408)
print v(xbgr.mr_n83905840)
print v(xbgr.mr_n83906272)
print v(xbgr.mr_n83906704)
print v(xbgr.mr_n83907136)
print v(xbgr.mr_n83907456)
print v(xbgr.mr_n83907568)
print v(xbgr.mr_n83907888)
print v(xbgr.mr_n83908000)
print v(xbgr.mr_n83908320)
print v(xbgr.mr_n83908432)
print v(xbgr.mr_n83908752)
print v(xbgr.mr_n83908864)
print v(xbgr.mr_n83909184)
print v(xbgr.mr_n83909296)
print v(xbgr.mr_n83909616)
print v(xbgr.mr_n83909728)
print v(xbgr.mr_n83910048)
print v(xbgr.mr_n83910160)
print v(xbgr.mr_n83910480)
print v(xbgr.mr_n83910592)
print v(xbgr.mr_n83910912)
print v(xbgr.mr_n83911024)
print v(xbgr.mr_n83911344)
print v(xbgr.mr_n83911456)
print v(xbgr.mr_n83911776)
print v(xbgr.mr_n83911888)
print v(xbgr.mr_n83912208)
print v(xbgr.mr_n83912320)
print v(xbgr.mr_n83912640)
print v(xbgr.mr_n83912752)
print v(xbgr.mr_n83913184)
print v(xbgr.mr_n83913616)
print v(xbgr.mr_n83914048)
print v(xbgr.mr_n83914480)
print v(xbgr.mr_n83914912)
print v(xbgr.mr_n83915344)
print v(xbgr.mr_n83915776)
print v(xbgr.mr_n83916208)
print v(xbgr.mr_n83916640)
print v(xbgr.mr_n83917072)
print v(xbgr.mr_n83917504)
print v(xbgr.mr_n83917936)
print v(xbgr.mr_n83918368)
print v(xbgr.mr_n83918688)
print v(xbgr.mr_n83918800)
print v(xbgr.mr_n83919120)
print v(xbgr.mr_n83919232)
print v(xbgr.mr_n83919552)
print v(xbgr.mr_n83919664)
print v(xbgr.mr_n83919984)
print v(xbgr.mr_n83920096)
print v(xbgr.mr_n83920416)
print v(xbgr.mr_n83920528)
print v(xbgr.mr_n83920848)
print v(xbgr.mr_n83920960)
print v(xbgr.mr_n83921280)
print v(xbgr.mr_n83921392)
print v(xbgr.mr_n83921712)
print v(xbgr.mr_n83921824)
print v(xbgr.mr_n83922144)
print v(xbgr.mr_n83922256)
print v(xbgr.mr_n83922576)
print v(xbgr.mr_n83922688)
print v(xbgr.mr_n83923008)
print v(xbgr.mr_n83923120)
print v(xbgr.mr_n83923440)
print v(xbgr.mr_n83923552)
print v(xbgr.mr_n83923984)
print v(xbgr.mr_n83924416)
print v(xbgr.mr_n83924848)
print v(xbgr.mr_n83925280)
print v(xbgr.mr_n83925712)
print v(xbgr.mr_n83926144)
print v(xbgr.mr_n83926576)
print v(xbgr.mr_n83927008)
print v(xbgr.mr_n83927440)
print v(xbgr.mr_n83927872)
print v(xbgr.mr_n83928304)
print v(xbgr.mr_n83928736)
print v(xbgr.mr_n83929056)
print v(xbgr.mr_n83929168)
print v(xbgr.mr_n83929600)
print v(xbgr.mr_n83929920)
print v(xbgr.mr_n83930032)
print v(xbgr.mr_n83930352)
print v(xbgr.mr_n83930464)
print v(xbgr.mr_n83930784)
print v(xbgr.mr_n83930896)
print v(xbgr.mr_n83931216)
print v(xbgr.mr_n83931328)
print v(xbgr.mr_n83931648)
print v(xbgr.mr_n83931760)
print v(xbgr.mr_n83932192)
print v(xbgr.mr_n83932624)
print v(xbgr.mr_n83932944)
print v(xbgr.mr_n83933056)
print v(xbgr.mr_n83933376)
print v(xbgr.mr_n83933488)
print v(xbgr.mr_n83933808)
print v(xbgr.mr_n83933920)
print v(xbgr.mr_n83934240)
print v(xbgr.mr_n83934352)
print v(xbgr.mr_n83934672)
print v(xbgr.mr_n83934784)
print v(xbgr.mr_n83935104)
print v(xbgr.mr_n83935216)
print v(xbgr.mr_n83935536)
print v(xbgr.mr_n83935648)
print v(xbgr.mr_n83935968)
print v(xbgr.mr_n83936080)
print v(xbgr.mr_n83936512)
print v(xbgr.mr_n83936944)
print v(xbgr.mr_n83937376)
print v(xbgr.mr_n83937808)
print v(xbgr.mr_n83938240)
print v(xbgr.mr_n83938672)
print v(xbgr.mr_n83939104)
print v(xbgr.mr_n83939536)
print v(xbgr.mr_n83939968)
print v(xbgr.mr_n83940400)
print v(xbgr.mr_n83940832)
print v(xbgr.mr_n83941152)
print v(xbgr.mr_n83941264)
print v(xbgr.mr_n83941584)
print v(xbgr.mr_n83941696)
print v(xbgr.mr_n83942016)
print v(xbgr.mr_n83942128)
print v(xbgr.mr_n83942560)
print v(xbgr.mr_n83942992)
print v(xbgr.mr_n83943312)
print v(xbgr.mr_n83943424)
print v(xbgr.mr_n83943744)
print v(xbgr.mr_n83943856)
print v(xbgr.mr_n83944176)
print v(xbgr.mr_n83944288)
print v(xbgr.mr_n83944608)
print v(xbgr.mr_n83944720)
print v(xbgr.mr_n83945152)
print v(xbgr.mr_n83945472)
print v(xbgr.mr_n83945584)
print v(xbgr.mr_n83945904)
print v(xbgr.mr_n83946016)
print v(xbgr.mr_n83946336)
print v(xbgr.mr_n83946448)
print v(xbgr.mr_n83946768)
print v(xbgr.mr_n83946880)
print v(xbgr.mr_n83947200)
print v(xbgr.mr_n83947312)
print v(xbgr.mr_n83947632)
print v(xbgr.mr_n83947744)
print v(xbgr.mr_n83948176)
print v(xbgr.mr_n83948608)
print v(xbgr.mr_n83949040)
print v(xbgr.mr_n83949472)
print v(xbgr.mr_n83949904)
print v(xbgr.mr_n83950336)
print v(xbgr.mr_n83950768)
print v(xbgr.mr_n83951200)
print v(xbgr.mr_n83951632)
print v(xbgr.mr_n83952064)
print v(xbgr.mr_n83952384)
print v(xbgr.mr_n83952496)
print v(xbgr.mr_n83952816)
print v(xbgr.mr_n83952928)
print v(xbgr.mr_n83953248)
print v(xbgr.mr_n83953360)
print v(xbgr.mr_n83953680)
print v(xbgr.mr_n83953792)
print v(xbgr.mr_n83954112)
print v(xbgr.mr_n83954224)
print v(xbgr.mr_n83954544)
print v(xbgr.mr_n83954656)
print v(xbgr.mr_n83954976)
print v(xbgr.mr_n83955088)
print v(xbgr.mr_n83955408)
print v(xbgr.mr_n83955520)
print v(xbgr.mr_n83955840)
print v(xbgr.mr_n83955952)
print v(xbgr.mr_n83956272)
print v(xbgr.mr_n83956384)
print v(xbgr.mr_n83956704)
print v(xbgr.mr_n83956816)
print v(xbgr.mr_n83957136)
print v(xbgr.mr_n83957248)
print v(xbgr.mr_n83957568)
print v(xbgr.mr_n83957680)
print v(xbgr.mr_n83958112)
print v(xbgr.mr_n83958544)
print v(xbgr.mr_n83958976)
print v(xbgr.mr_n83959408)
print v(xbgr.mr_n83959840)
print v(xbgr.mr_n83960272)
print v(xbgr.mr_n83960704)
print v(xbgr.mr_n83961136)
print v(xbgr.mr_n83961568)
print v(xbgr.mr_n83962000)
print v(xbgr.mr_n83962432)
print v(xbgr.mr_n83962864)
print v(xbgr.mr_n83963296)
print v(xbgr.mr_n83963616)
print v(xbgr.mr_n83963728)
print v(xbgr.mr_n83964048)
print v(xbgr.mr_n83964160)
print v(xbgr.mr_n83964480)
print v(xbgr.mr_n83964592)
print v(xbgr.mr_n83964912)
print v(xbgr.mr_n83965024)
print v(xbgr.mr_n83965344)
print v(xbgr.mr_n83965456)
print v(xbgr.mr_n83965776)
print v(xbgr.mr_n83965888)
print v(xbgr.mr_n83966208)
print v(xbgr.mr_n83966320)
print v(xbgr.mr_n83966640)
print v(xbgr.mr_n83966752)
print v(xbgr.mr_n83967072)
print v(xbgr.mr_n83967184)
print v(xbgr.mr_n83967504)
print v(xbgr.mr_n83967616)
print v(xbgr.mr_n83967936)
print v(xbgr.mr_n83968048)
print v(xbgr.mr_n83968368)
print v(xbgr.mr_n83968480)
print v(xbgr.mr_n83968800)
print v(xbgr.mr_n83968912)
print v(xbgr.mr_n83969344)
print v(xbgr.mr_n83969776)
print v(xbgr.mr_n83970208)
print v(xbgr.mr_n83970640)
print v(xbgr.mr_n83971072)
print v(xbgr.mr_n83971504)
print v(xbgr.mr_n83971936)
print v(xbgr.mr_n83972368)
print v(xbgr.mr_n83972800)
print v(xbgr.mr_n83973232)
print v(xbgr.mr_n83973664)
print v(xbgr.mr_n83974096)
print v(xbgr.mr_n83974528)
print v(xbgr.mr_n83974848)
print v(xbgr.mr_n83974960)
print v(xbgr.mr_n83975280)
print v(xbgr.mr_n83975392)
print v(xbgr.mr_n83975712)
print v(xbgr.mr_n83975824)
print v(xbgr.mr_n83976144)
print v(xbgr.mr_n83976256)
print v(xbgr.mr_n83976576)
print v(xbgr.mr_n83976688)
print v(xbgr.mr_n83977008)
print v(xbgr.mr_n83977120)
print v(xbgr.mr_n83977440)
print v(xbgr.mr_n83977552)
print v(xbgr.mr_n83977872)
print v(xbgr.mr_n83977984)
print v(xbgr.mr_n83978304)
print v(xbgr.mr_n83978416)
print v(xbgr.mr_n83978736)
print v(xbgr.mr_n83978848)
print v(xbgr.mr_n83979168)
print v(xbgr.mr_n83979280)
print v(xbgr.mr_n83979600)
print v(xbgr.mr_n83979712)
print v(xbgr.mr_n83980032)
print v(xbgr.mr_n83980144)
print v(xbgr.mr_n83980576)
print v(xbgr.mr_n83981008)
print v(xbgr.mr_n83981440)
print v(xbgr.mr_n83981872)
print v(xbgr.mr_n83982304)
print v(xbgr.mr_n83982736)
print v(xbgr.mr_n83983168)
print v(xbgr.mr_n83983600)
print v(xbgr.mr_n83984032)
print v(xbgr.mr_n83984464)
print v(xbgr.mr_n83984896)
print v(xbgr.mr_n83985328)
print v(xbgr.mr_n83985760)
print v(xbgr.mr_n83986080)
print v(xbgr.mr_n83986192)
print v(xbgr.mr_n83986512)
print v(xbgr.mr_n83986624)
print v(xbgr.mr_n83987056)
print v(xbgr.mr_n83987376)
print v(xbgr.mr_n83987488)
print v(xbgr.mr_n83987808)
print v(xbgr.mr_n83987920)
print v(xbgr.mr_n83988240)
print v(xbgr.mr_n83988352)
print v(xbgr.mr_n83988672)
print v(xbgr.mr_n83988784)
print v(xbgr.mr_n83989216)
print v(xbgr.mr_n83989648)
print v(xbgr.mr_n83990080)
print v(xbgr.mr_n83990512)
print v(xbgr.mr_n83990832)
print v(xbgr.mr_n83990944)
print v(xbgr.mr_n83991264)
print v(xbgr.mr_n83991376)
print v(xbgr.mr_n83991808)
print v(xbgr.mr_n83992240)
print v(xbgr.mr_n83992560)
print v(xbgr.mr_n83992672)
print v(xbgr.mr_n83992992)
print v(xbgr.mr_n83993104)
print v(xbgr.mr_n83993424)
print v(xbgr.mr_n83993536)
print v(xbgr.mr_n83993856)
print v(xbgr.mr_n83993968)
print v(xbgr.mr_n83994288)
print v(xbgr.mr_n83994400)
print v(xbgr.mr_n83994832)
print v(xbgr.mr_n83995264)
print v(xbgr.mr_n83995696)
print v(xbgr.mr_n83996128)
print v(xbgr.mr_n83996560)
print v(xbgr.mr_n83996992)
print v(xbgr.mr_n83997312)
print v(xbgr.mr_n83997424)
print v(xbgr.mr_n83997744)
print v(xbgr.mr_n83997856)
print v(xbgr.mr_n83998176)
print v(xbgr.mr_n83998288)
print v(xbgr.mr_n83998608)
print v(xbgr.mr_n83998720)
print v(xbgr.mr_n83999040)
print v(xbgr.mr_n83999152)
print v(xbgr.mr_n83999472)
print v(xbgr.mr_n83999584)
print v(xbgr.mr_n83999904)
print v(xbgr.mr_n84000016)
print v(xbgr.mr_n84000336)
print v(xbgr.mr_n84000448)
print v(xbgr.mr_n84000768)
print v(xbgr.mr_n84000880)
print v(xbgr.mr_n84001200)
print v(xbgr.mr_n84001312)
print v(xbgr.mr_n84001632)
print v(xbgr.mr_n84001744)
print v(xbgr.mr_n84002064)
print v(xbgr.mr_n84002176)
print v(xbgr.mr_n84002608)
print v(xbgr.mr_n84003040)
print v(xbgr.mr_n84003472)
print v(xbgr.mr_n84003904)
print v(xbgr.mr_n84004336)
print v(xbgr.mr_n84004768)
print v(xbgr.mr_n84005200)
print v(xbgr.mr_n84005632)
print v(xbgr.mr_n84005952)
print v(xbgr.mr_n84006064)
print v(xbgr.mr_n84006384)
print v(xbgr.mr_n84006496)
print v(xbgr.mr_n84006816)
print v(xbgr.mr_n84006928)
print v(xbgr.mr_n84007248)
print v(xbgr.mr_n84007360)
print v(xbgr.mr_n84007680)
print v(xbgr.mr_n84007792)
print v(xbgr.mr_n84008112)
print v(xbgr.mr_n84008224)
print v(xbgr.mr_n84008544)
print v(xbgr.mr_n84008656)
print v(xbgr.mr_n84008976)
print v(xbgr.mr_n84009088)
print v(xbgr.mr_n84009520)
print v(xbgr.mr_n84009952)
print v(xbgr.mr_n84010272)
print v(xbgr.mr_n84010384)
print v(xbgr.mr_n84010704)
print v(xbgr.mr_n84010816)
print v(xbgr.mr_n84011136)
print v(xbgr.mr_n84011248)
print v(xbgr.mr_n84011568)
print v(xbgr.mr_n84011680)
print v(xbgr.mr_n84012000)
print v(xbgr.mr_n84012112)
print v(xbgr.mr_n84012432)
print v(xbgr.mr_n84012544)
print v(xbgr.mr_n84012976)
print v(xbgr.mr_n84013408)
print v(xbgr.mr_n84013840)
print v(xbgr.mr_n84014272)
print v(xbgr.mr_n84014704)
print v(xbgr.mr_n84015136)
print v(xbgr.mr_n84015568)
print v(xbgr.mr_n84016000)
print v(xbgr.mr_n84016432)
print v(xbgr.mr_n84016864)
print v(xbgr.mr_n84017296)
print v(xbgr.mr_n84017728)
print v(xbgr.mr_n84018160)
print v(xbgr.mr_n84018592)
print v(xbgr.mr_n84019024)
print v(xbgr.mr_n84019456)
print v(xbgr.mr_n84019776)
print v(xbgr.mr_n84019888)
print v(xbgr.mr_n84020208)
print v(xbgr.mr_n84020320)
print v(xbgr.mr_n84020640)
print v(xbgr.mr_n84020752)
print v(xbgr.mr_n84021072)
print v(xbgr.mr_n84021184)
print v(xbgr.mr_n84021504)
print v(xbgr.mr_n84021616)
print v(xbgr.mr_n84021936)
print v(xbgr.mr_n84022048)
print v(xbgr.mr_n84022368)
print v(xbgr.mr_n84022480)
print v(xbgr.mr_n84022800)
print v(xbgr.mr_n84022912)
print v(xbgr.mr_n84023232)
print v(xbgr.mr_n84023344)
print v(xbgr.mr_n84023664)
print v(xbgr.mr_n84023776)
print v(xbgr.mr_n84024096)
print v(xbgr.mr_n84024208)
print v(xbgr.mr_n84024528)
print v(xbgr.mr_n84024640)
print v(xbgr.mr_n84024960)
print v(xbgr.mr_n84025072)
print v(xbgr.mr_n84025392)
print v(xbgr.mr_n84025504)
print v(xbgr.mr_n84025824)
print v(xbgr.mr_n84025936)
print v(xbgr.mr_n84026256)
print v(xbgr.mr_n84026368)
print v(xbgr.mr_n84026688)
print v(xbgr.mr_n84026800)
print v(xbgr.mr_n84027120)
print v(xbgr.mr_n84027232)
print v(xbgr.mr_n84027552)
print v(xbgr.mr_n84027664)
print v(xbgr.mr_n84027984)
print v(xbgr.mr_n84028096)
print v(xbgr.mr_n84028528)
print v(xbgr.mr_n84028960)
print v(xbgr.mr_n84029392)
print v(xbgr.mr_n84029824)
print v(xbgr.mr_n84030256)
print v(xbgr.mr_n84030688)
print v(xbgr.mr_n84031008)
print v(xbgr.mr_n84031120)
print v(xbgr.mr_n84031440)
print v(xbgr.mr_n84031552)
print v(xbgr.mr_n84031872)
print v(xbgr.mr_n84031984)
print v(xbgr.mr_n84032304)
print v(xbgr.mr_n84032416)
print v(xbgr.mr_n84032736)
print v(xbgr.mr_n84032848)
print v(xbgr.mr_n84033168)
print v(xbgr.mr_n84033280)
print v(xbgr.mr_n84033712)
print v(xbgr.mr_n84034144)
print v(xbgr.mr_n84034576)
print v(xbgr.mr_n84035008)
print v(xbgr.mr_n84035440)
print v(xbgr.mr_n84035872)
print v(xbgr.mr_n84036304)
print v(xbgr.mr_n84036736)
print v(xbgr.mr_n84037168)
print v(xbgr.mr_n84037600)
print v(xbgr.mr_n84038032)
print v(xbgr.mr_n84038464)
print v(xbgr.mr_n84038896)
print v(xbgr.mr_n84039328)
print v(xbgr.mr_n84039760)
print v(xbgr.mr_n84040192)
print v(xbgr.mr_n84040624)
print v(xbgr.mr_n84041056)
print v(xbgr.mr_n84041488)
print v(xbgr.mr_n84041920)
print v(xbgr.mr_n84042240)
print v(xbgr.mr_n84042352)
print v(xbgr.mr_n84042672)
print v(xbgr.mr_n84042784)
print v(xbgr.mr_n84043104)
print v(xbgr.mr_n84043216)
print v(xbgr.mr_n84043536)
print v(xbgr.mr_n84043648)
print v(xbgr.mr_n84043968)
print v(xbgr.mr_n84044080)
print v(xbgr.mr_n84044400)
print v(xbgr.mr_n84044512)
print v(xbgr.mr_n84044832)
print v(xbgr.mr_n84044944)
print v(xbgr.mr_n84045264)
print v(xbgr.mr_n84045376)
print v(xbgr.mr_n84045696)
print v(xbgr.mr_n84045808)
print v(xbgr.mr_n84046128)
print v(xbgr.mr_n84046240)
print v(xbgr.mr_n84046560)
print v(xbgr.mr_n84046672)
print v(xbgr.mr_n84046992)
print v(xbgr.mr_n84047104)
print v(xbgr.mr_n84047424)
print v(xbgr.mr_n84047536)
print v(xbgr.mr_n84047856)
print v(xbgr.mr_n84047968)
print v(xbgr.mr_n84048288)
print v(xbgr.mr_n84048400)
print v(xbgr.mr_n84048720)
print v(xbgr.mr_n84048832)
print v(xbgr.mr_n84049152)
print v(xbgr.mr_n84049264)
print v(xbgr.mr_n84049584)
print v(xbgr.mr_n84049696)
print v(xbgr.mr_n84050016)
print v(xbgr.mr_n84050128)
print v(xbgr.mr_n84050448)
print v(xbgr.mr_n84050560)
print v(xbgr.mr_n84050880)
print v(xbgr.mr_n84050992)
print v(xbgr.mr_n84051312)
print v(xbgr.mr_n84051424)
print v(xbgr.mr_n84051744)
print v(xbgr.mr_n84051856)
print v(xbgr.mr_n84052176)
print v(xbgr.mr_n84052288)
print v(xbgr.mr_n84052608)
print v(xbgr.mr_n84052720)
print v(xbgr.mr_n84053040)
print v(xbgr.mr_n84053152)
print v(xbgr.mr_n84053472)
print v(xbgr.mr_n84053584)
print v(xbgr.mr_n84053904)
print v(xbgr.mr_n84054016)
print v(xbgr.mr_n84054336)
print v(xbgr.mr_n84054448)
print v(xbgr.mr_n84054768)
print v(xbgr.mr_n84054880)
print v(xbgr.mr_n84055200)
print v(xbgr.mr_n84055312)
print v(xbgr.mr_n84055632)
print v(xbgr.mr_n84055744)
print v(xbgr.mr_n84056176)
print v(xbgr.mr_n84056608)
print v(xbgr.mr_n84056928)
print v(xbgr.mr_n84057040)
print v(xbgr.mr_n84057360)
print v(xbgr.mr_n84057472)
print v(xbgr.mr_n84057792)
print v(xbgr.mr_n84057904)
print v(xbgr.mr_n84058224)
print v(xbgr.mr_n84058336)
print v(xbgr.mr_n84058656)
print v(xbgr.mr_n84058768)
print v(xbgr.mr_n84059088)
print v(xbgr.mr_n84059200)
print v(xbgr.mr_n84059520)
print v(xbgr.mr_n84059632)
print v(xbgr.mr_n84059952)
print v(xbgr.mr_n84060064)
print v(xbgr.mr_n84060384)
print v(xbgr.mr_n84060496)
print v(xbgr.mr_n84060816)
print v(xbgr.mr_n84060928)
print v(xbgr.mr_n84061360)
print v(xbgr.mr_n84061792)
print v(xbgr.mr_n84062224)
print v(xbgr.mr_n84062544)
print v(xbgr.mr_n84062656)
print v(xbgr.mr_n84062976)
print v(xbgr.mr_n84063088)
print v(xbgr.mr_n84063520)
print v(xbgr.mr_n84063952)
print v(xbgr.mr_n84064384)
print v(xbgr.mr_n84064816)
print v(xbgr.mr_n84065248)
print v(xbgr.mr_n84065680)
print v(xbgr.mr_n84066112)
print v(xbgr.mr_n84066544)
print v(xbgr.mr_n84066976)
print v(xbgr.mr_n84067408)
print v(xbgr.mr_n84067840)
print v(xbgr.mr_n84068160)
print v(xbgr.mr_n84068272)
print v(xbgr.mr_n84068592)
print v(xbgr.mr_n84068704)
print v(xbgr.mr_n84069024)
print v(xbgr.mr_n84069136)
print v(xbgr.mr_n84069456)
print v(xbgr.mr_n84069568)
print v(xbgr.mr_n84069888)
print v(xbgr.mr_n84070000)
print v(xbgr.mr_n84070320)
print v(xbgr.mr_n84070432)
print v(xbgr.mr_n84070752)
print v(xbgr.mr_n84070864)
print v(xbgr.mr_n84071184)
print v(xbgr.mr_n84071296)
print v(xbgr.mr_n84071728)
print v(xbgr.mr_n84072160)
print v(xbgr.mr_n84072592)
print v(xbgr.mr_n84073024)
print v(xbgr.mr_n84073456)
print v(xbgr.mr_n84073888)
print v(xbgr.mr_n84074320)
print v(xbgr.mr_n84074752)
print v(xbgr.mr_n84075184)
print v(xbgr.mr_n84075616)
print v(xbgr.mr_n84076048)
print v(xbgr.mr_n84076480)
print v(xbgr.mr_n84076912)
print v(xbgr.mr_n84077344)
print v(xbgr.mr_n84077776)
print v(xbgr.mr_n84078208)
print v(xbgr.mr_n84078640)
print v(xbgr.mr_n84079072)
print v(xbgr.mr_n84079504)
print v(xbgr.mr_n84079936)
print v(xbgr.mr_n84080256)
print v(xbgr.mr_n84080368)
print v(xbgr.mr_n84080688)
print v(xbgr.mr_n84080800)
print v(xbgr.mr_n84081120)
print v(xbgr.mr_n84081232)
print v(xbgr.mr_n84081552)
print v(xbgr.mr_n84081664)
print v(xbgr.mr_n84081984)
print v(xbgr.mr_n84082096)
print v(xbgr.mr_n84082416)
print v(xbgr.mr_n84082528)
print v(xbgr.mr_n84082848)
print v(xbgr.mr_n84082960)
print v(xbgr.mr_n84083280)
print v(xbgr.mr_n84083392)
print v(xbgr.mr_n84083712)
print v(xbgr.mr_n84083824)
print v(xbgr.mr_n84084144)
print v(xbgr.mr_n84084256)
print v(xbgr.mr_n84084576)
print v(xbgr.mr_n84084688)
print v(xbgr.mr_n84085008)
print v(xbgr.mr_n84085120)
print v(xbgr.mr_n84085440)
print v(xbgr.mr_n84085552)
print v(xbgr.mr_n84085984)
print v(xbgr.mr_n84086416)
print v(xbgr.mr_n84086848)
print v(xbgr.mr_n84087280)
print v(xbgr.mr_n84087712)
print v(xbgr.mr_n84088144)
print v(xbgr.mr_n84088576)
print v(xbgr.mr_n84089008)
print v(xbgr.mr_n84089440)
print v(xbgr.mr_n84089872)
print v(xbgr.mr_n84090304)
print v(xbgr.mr_n84090736)
print v(xbgr.mr_n84091168)
print v(xbgr.mr_n84091488)
print v(xbgr.mr_n84091600)
print v(xbgr.mr_n84091920)
print v(xbgr.mr_n84092032)
print v(xbgr.mr_n84092352)
print v(xbgr.mr_n84092464)
print v(xbgr.mr_n84092784)
print v(xbgr.mr_n84092896)
print v(xbgr.mr_n84093216)
print v(xbgr.mr_n84093328)
print v(xbgr.mr_n84093648)
print v(xbgr.mr_n84093760)
print v(xbgr.mr_n84094080)
print v(xbgr.mr_n84094192)
print v(xbgr.mr_n84094512)
print v(xbgr.mr_n84094624)
print v(xbgr.mr_n84094944)
print v(xbgr.mr_n84095056)
print v(xbgr.mr_n84095376)
print v(xbgr.mr_n84095488)
print v(xbgr.mr_n84095808)
print v(xbgr.mr_n84095920)
print v(xbgr.mr_n84096240)
print v(xbgr.mr_n84096352)
print v(xbgr.mr_n84096784)
print v(xbgr.mr_n84097104)
print v(xbgr.mr_n84097216)
print v(xbgr.mr_n84097648)
print v(xbgr.mr_n84098080)
print v(xbgr.mr_n84098512)
print v(xbgr.mr_n84098944)
print v(xbgr.mr_n84099376)
print v(xbgr.mr_n84099808)
print v(xbgr.mr_n84100240)
print v(xbgr.mr_n84100672)
print v(xbgr.mr_n84101104)
print v(xbgr.mr_n84101536)
print v(xbgr.mr_n84101968)
print v(xbgr.mr_n84102400)
print v(xbgr.mr_n84102720)
print v(xbgr.mr_n84102832)
print v(xbgr.mr_n84103152)
print v(xbgr.mr_n84103264)
print v(xbgr.mr_n84103584)
print v(xbgr.mr_n84103696)
print v(xbgr.mr_n84104016)
print v(xbgr.mr_n84104128)
print v(xbgr.mr_n84104448)
print v(xbgr.mr_n84104560)
print v(xbgr.mr_n84104880)
print v(xbgr.mr_n84104992)
print v(xbgr.mr_n84105312)
print v(xbgr.mr_n84105424)
print v(xbgr.mr_n84105744)
print v(xbgr.mr_n84105856)
print v(xbgr.mr_n84106176)
print v(xbgr.mr_n84106288)
print v(xbgr.mr_n84106608)
print v(xbgr.mr_n84106720)
print v(xbgr.mr_n84107040)
print v(xbgr.mr_n84107152)
print v(xbgr.mr_n84107584)
print v(xbgr.mr_n84108016)
print v(xbgr.mr_n84108448)
print v(xbgr.mr_n84108768)
print v(xbgr.mr_n84108880)
print v(xbgr.mr_n84109200)
print v(xbgr.mr_n84109312)
print v(xbgr.mr_n84109744)
print v(xbgr.mr_n84110176)
print v(xbgr.mr_n84110608)
print v(xbgr.mr_n84111040)
print v(xbgr.mr_n84111472)
print v(xbgr.mr_n84111904)
print v(xbgr.mr_n84112336)
print v(xbgr.mr_n84112768)
print v(xbgr.mr_n84113200)
print v(xbgr.mr_n84113632)
print v(xbgr.mr_n84113952)
print v(xbgr.mr_n84114064)
print v(xbgr.mr_n84114384)
print v(xbgr.mr_n84114496)
print v(xbgr.mr_n84114816)
print v(xbgr.mr_n84114928)
print v(xbgr.mr_n84115248)
print v(xbgr.mr_n84115360)
print v(xbgr.mr_n84115680)
print v(xbgr.mr_n84115792)
print v(xbgr.mr_n84116112)
print v(xbgr.mr_n84116224)
print v(xbgr.mr_n84116544)
print v(xbgr.mr_n84116656)
print v(xbgr.mr_n84116976)
print v(xbgr.mr_n84117088)
print v(xbgr.mr_n84117408)
print v(xbgr.mr_n84117520)
print v(xbgr.mr_n84117840)
print v(xbgr.mr_n84117952)
print v(xbgr.mr_n84118272)
print v(xbgr.mr_n84118384)
print v(xbgr.mr_n84118704)
print v(xbgr.mr_n84118816)
print v(xbgr.mr_n84119248)
print v(xbgr.mr_n84119680)
print v(xbgr.mr_n84120112)
print v(xbgr.mr_n84120544)
print v(xbgr.mr_n84120976)
print v(xbgr.mr_n84121408)
print v(xbgr.mr_n84121840)
print v(xbgr.mr_n84122160)
print v(xbgr.mr_n84122272)
print v(xbgr.mr_n84122704)
print v(xbgr.mr_n84123136)
print v(xbgr.mr_n84123568)
print v(xbgr.mr_n84124000)
print v(xbgr.mr_n84124432)
print v(xbgr.mr_n84124864)
print v(xbgr.mr_n84125184)
print v(xbgr.mr_n84125296)
print v(xbgr.mr_n84125616)
print v(xbgr.mr_n84125728)
print v(xbgr.mr_n84126048)
print v(xbgr.mr_n84126160)
print v(xbgr.mr_n84126480)
print v(xbgr.mr_n84126592)
print v(xbgr.mr_n84126912)
print v(xbgr.mr_n84127024)
print v(xbgr.mr_n84127344)
print v(xbgr.mr_n84127456)
print v(xbgr.mr_n84127776)
print v(xbgr.mr_n84127888)
print v(xbgr.mr_n84128208)
print v(xbgr.mr_n84128320)
print v(xbgr.mr_n84128640)
print v(xbgr.mr_n84128752)
print v(xbgr.mr_n84129072)
print v(xbgr.mr_n84129184)
print v(xbgr.mr_n84129504)
print v(xbgr.mr_n84129616)
print v(xbgr.mr_n84129936)
print v(xbgr.mr_n84130048)
print v(xbgr.mr_n84130368)
print v(xbgr.mr_n84130480)
print v(xbgr.mr_n84130800)
print v(xbgr.mr_n84130912)
print v(xbgr.mr_n84131232)
print v(xbgr.mr_n84131344)
print v(xbgr.mr_n84131664)
print v(xbgr.mr_n84131776)
print v(xbgr.mr_n84132096)
print v(xbgr.mr_n84132208)
print v(xbgr.mr_n84132528)
print v(xbgr.mr_n84132640)
print v(xbgr.mr_n84132960)
print v(xbgr.mr_n84133072)
print v(xbgr.mr_n84133392)
print v(xbgr.mr_n84133504)
print v(xbgr.mr_n84133824)
print v(xbgr.mr_n84133936)
print v(xbgr.mr_n84134256)
print v(xbgr.mr_n84134368)
print v(xbgr.mr_n84134688)
print v(xbgr.mr_n84134800)
print v(xbgr.mr_n84135120)
print v(xbgr.mr_n84135232)
print v(xbgr.mr_n84135664)
print v(xbgr.mr_n84136096)
print v(xbgr.mr_n84136528)
print v(xbgr.mr_n84136848)
print v(xbgr.mr_n84136960)
print v(xbgr.mr_n84137280)
print v(xbgr.mr_n84137392)
print v(xbgr.mr_n84137824)
print v(xbgr.mr_n84138256)
print v(xbgr.mr_n84138688)
print v(xbgr.mr_n84139120)
print v(xbgr.mr_n84139552)
print v(xbgr.mr_n84139984)
print v(xbgr.mr_n84140416)
print v(xbgr.mr_n84140848)
print v(xbgr.mr_n84141280)
print v(xbgr.mr_n84141712)
print v(xbgr.mr_n84142144)
print v(xbgr.mr_n84142576)
print v(xbgr.mr_n84143008)
print v(xbgr.mr_n84143440)
print v(xbgr.mr_n84143872)
print v(xbgr.mr_n84144304)
print v(xbgr.mr_n84144736)
print v(xbgr.mr_n84145168)
print v(xbgr.mr_n84145600)
print v(xbgr.mr_n84146032)
print v(xbgr.mr_n84146464)
print v(xbgr.mr_n84146896)
print v(xbgr.mr_n84147328)
print v(xbgr.mr_n84147648)
print v(xbgr.mr_n84147760)
print v(xbgr.mr_n84148080)
print v(xbgr.mr_n84148192)
print v(xbgr.mr_n84148512)
print v(xbgr.mr_n84148624)
print v(xbgr.mr_n84148944)
print v(xbgr.mr_n84149056)
print v(xbgr.mr_n84149376)
print v(xbgr.mr_n84149488)
print v(xbgr.mr_n84149808)
print v(xbgr.mr_n84149920)
print v(xbgr.mr_n84150240)
print v(xbgr.mr_n84150352)
print v(xbgr.mr_n84150672)
print v(xbgr.mr_n84150784)
print v(xbgr.mr_n84151104)
print v(xbgr.mr_n84151216)
print v(xbgr.mr_n84151536)
print v(xbgr.mr_n84151648)
print v(xbgr.mr_n84151968)
print v(xbgr.mr_n84152080)
print v(xbgr.mr_n84152400)
print v(xbgr.mr_n84152512)
print v(xbgr.mr_n84152832)
print v(xbgr.mr_n84152944)
print v(xbgr.mr_n84153264)
print v(xbgr.mr_n84153376)
print v(xbgr.mr_n84153808)
print v(xbgr.mr_n84154240)
print v(xbgr.mr_n84154560)
print v(xbgr.mr_n84154672)
print v(xbgr.mr_n84154992)
print v(xbgr.mr_n84155104)
print v(xbgr.mr_n84155424)
print v(xbgr.mr_n84155536)
print v(xbgr.mr_n84155856)
print v(xbgr.mr_n84155968)
print v(xbgr.mr_n84156400)
print v(xbgr.mr_n84156832)
print v(xbgr.mr_n84157152)
print v(xbgr.mr_n84157264)
print v(xbgr.mr_n84157584)
print v(xbgr.mr_n84157696)
print v(xbgr.mr_n84158016)
print v(xbgr.mr_n84158128)
print v(xbgr.mr_n84158448)
print v(xbgr.mr_n84158560)
print v(xbgr.mr_n84158880)
print v(xbgr.mr_n84158992)
print v(xbgr.mr_n84159312)
print v(xbgr.mr_n84159424)
print v(xbgr.mr_n84159744)
print v(xbgr.mr_n84159856)
print v(xbgr.mr_n84160176)
print v(xbgr.mr_n84160288)
print v(xbgr.mr_n84160720)
print v(xbgr.mr_n84161152)
print v(xbgr.mr_n84161584)
print v(xbgr.mr_n84162016)
print v(xbgr.mr_n84162448)
print v(xbgr.mr_n84162880)
print v(xbgr.mr_n84163312)
print v(xbgr.mr_n84163744)
print v(xbgr.mr_n84164176)
print v(xbgr.mr_n84164608)
print v(xbgr.mr_n84164928)
print v(xbgr.mr_n84165040)
print v(xbgr.mr_n84165360)
print v(xbgr.mr_n84165472)
print v(xbgr.mr_n84165792)
print v(xbgr.mr_n84165904)
print v(xbgr.mr_n84166224)
print v(xbgr.mr_n84166336)
print v(xbgr.mr_n84171360)
print v(xbgr.mr_n84171472)
print v(xbgr.mr_n84171808)
print v(xbgr.mr_n84171920)
print v(xbgr.mr_n84172240)
print v(xbgr.mr_n84172352)
print v(xbgr.mr_n84172720)
print v(xbgr.mr_n84172832)
print v(xbgr.mr_n84173152)
print v(xbgr.mr_n84173264)
print v(xbgr.mr_n84173584)
print v(xbgr.mr_n84173696)
print v(xbgr.mr_n84173936)
print v(xbgr.mr_n84174048)
print v(xbgr.mr_n84174368)
print v(xbgr.mr_n84174480)
print v(xbgr.mr_n84174800)
print v(xbgr.mr_n84174912)
print v(xbgr.mr_n84175232)
print v(xbgr.mr_n84175344)
print v(xbgr.mr_n84175664)
print v(xbgr.mr_n84175776)
print v(xbgr.mr_n84176096)
print v(xbgr.mr_n84176208)
print v(xbgr.mr_n84176528)
print v(xbgr.mr_n84176640)
print v(xbgr.mr_n84176960)
print v(xbgr.mr_n84177072)
print v(xbgr.mr_n84177392)
print v(xbgr.mr_n84177504)
print v(xbgr.mr_n84177824)
print v(xbgr.mr_n84177936)
print v(xbgr.mr_n84178256)
print v(xbgr.mr_n84178368)
print v(xbgr.mr_n84178688)
print v(xbgr.mr_n84178800)
print v(xbgr.mr_n84179120)
print v(xbgr.mr_n84179232)
print v(xbgr.mr_n84179552)
print v(xbgr.mr_n84179664)
print v(xbgr.mr_n84179984)
print v(xbgr.mr_n84180096)
print v(xbgr.mr_n84180416)
print v(xbgr.mr_n84180528)
print v(xbgr.mr_n84180848)
print v(xbgr.mr_n84180960)
print v(xbgr.mr_n84181280)
print v(xbgr.mr_n84181392)
print v(xbgr.mr_n84181712)
print v(xbgr.mr_n84181824)
print v(xbgr.mr_n84182144)
print v(xbgr.mr_n84182256)
print v(xbgr.mr_n84182576)
print v(xbgr.mr_n84182688)
print v(xbgr.mr_n84183008)
print v(xbgr.mr_n84183120)
print v(xbgr.mr_n84183440)
print v(xbgr.mr_n84183552)
print v(xbgr.mr_n84183872)
print v(xbgr.mr_n84183984)
print v(xbgr.mr_n84184304)
print v(xbgr.mr_n84184416)
print v(xbgr.mr_n84184736)
print v(xbgr.mr_n84184848)
print v(xbgr.mr_n84185168)
print v(xbgr.mr_n84185280)
print v(xbgr.mr_n84185600)
print v(xbgr.mr_n84185712)
print v(xbgr.mr_n84186032)
print v(xbgr.mr_n84186144)
print v(xbgr.mr_n84186464)
print v(xbgr.mr_n84186576)
print v(xbgr.mr_n84186896)
print v(xbgr.mr_n84187008)
print v(xbgr.mr_n84187328)
print v(xbgr.mr_n84187440)
print v(xbgr.mr_n84187760)
print v(xbgr.mr_n84187872)
print v(xbgr.mr_n84188192)
print v(xbgr.mr_n84188304)
print v(xbgr.mr_n84188624)
print v(xbgr.mr_n84188736)
print v(xbgr.mr_n84189056)
print v(xbgr.mr_n84189168)
print v(xbgr.mr_n84189488)
print v(xbgr.mr_n84189600)
print v(xbgr.mr_n84189920)
print v(xbgr.mr_n84190032)
print v(xbgr.mr_n84190352)
print v(xbgr.mr_n84190464)
print v(xbgr.mr_n84190784)
print v(xbgr.mr_n84190896)
print v(xbgr.mr_n84191216)
print v(xbgr.mr_n84191328)
print v(xbgr.mr_n84191648)
print v(xbgr.mr_n84191760)
print v(xbgr.mr_n84192080)
print v(xbgr.mr_n84192192)
print v(xbgr.mr_n84192512)
print v(xbgr.mr_n84192624)
print v(xbgr.mr_n84192944)
print v(xbgr.mr_n84193056)
print v(xbgr.mr_n84193376)
print v(xbgr.mr_n84193488)
print v(xbgr.mr_n84193808)
print v(xbgr.mr_n84193920)
print v(xbgr.mr_n84194240)
print v(xbgr.mr_n84194352)
print v(xbgr.mr_n84194672)
print v(xbgr.mr_n84194784)
print v(xbgr.mr_n84195104)
print v(xbgr.mr_n84195216)
print v(xbgr.mr_n84195536)
print v(xbgr.mr_n84195648)
print v(xbgr.mr_n84195968)
print v(xbgr.mr_n84196080)
print v(xbgr.mr_n84196400)
print v(xbgr.mr_n84196512)
print v(xbgr.mr_n84196832)
print v(xbgr.mr_n84196944)
print v(xbgr.mr_n84197264)
print v(xbgr.mr_n84197376)
print v(xbgr.mr_n84197696)
print v(xbgr.mr_n84197808)
print v(xbgr.mr_n84198128)
print v(xbgr.mr_n84198240)
print v(xbgr.mr_n84198560)
print v(xbgr.mr_n84198672)
print v(xbgr.mr_n84198992)
print v(xbgr.mr_n84199104)
print v(xbgr.mr_n84199424)
print v(xbgr.mr_n84199536)
print v(xbgr.mr_n84199856)
print v(xbgr.mr_n84199968)
print v(xbgr.mr_n84200288)
print v(xbgr.mr_n84200400)
print v(xbgr.mr_n84200720)
print v(xbgr.mr_n84200832)
print v(xbgr.mr_n84201152)
print v(xbgr.mr_n84201264)
print v(xbgr.mr_n84201488)
print v(xbgr.mr_n84201600)
print v(xbgr.mr_n84201856)
print v(xbgr.mr_n84201968)
print v(xbgr.mr_n84202224)
print v(xbgr.mr_n84202336)
print v(xbgr.mr_n84202592)
print v(xbgr.mr_n84202704)
print v(xbgr.mr_n84202960)
print v(xbgr.mr_n84203072)
print v(xbgr.mr_n84203328)
print v(xbgr.mr_n84203440)
print v(xbgr.mr_n84203696)
print v(xbgr.mr_n84203808)
print v(xbgr.mr_n84204064)
print v(xbgr.mr_n84204176)
print v(xbgr.mr_n84204432)
print v(xbgr.mr_n84204544)
print v(xbgr.mr_n84204832)
print v(xbgr.mr_n84204944)
print v(xbgr.mr_n84205264)
print v(xbgr.mr_n84205376)
print v(xbgr.mr_n84205696)
print v(xbgr.mr_n84205808)
print v(xbgr.mr_n84206128)
print v(xbgr.mr_n84206240)
print v(xbgr.mr_n84206560)
print v(xbgr.mr_n84206672)
print v(xbgr.mr_n84206992)
print v(xbgr.mr_n84207104)
print v(xbgr.mr_n84207424)
print v(xbgr.mr_n84207536)
print v(xbgr.mr_n84207856)
print v(xbgr.mr_n84207968)
print v(xbgr.mr_n84208288)
print v(xbgr.mr_n84208400)
print v(xbgr.mr_n84208720)
print v(xbgr.mr_n84208832)
print v(xbgr.mr_n84209152)
print v(xbgr.mr_n84209264)
print v(xbgr.mr_n84209584)
print v(xbgr.mr_n84209696)
print v(xbgr.mr_n84210016)
print v(xbgr.mr_n84210128)
print v(xbgr.mr_n84210448)
print v(xbgr.mr_n84210560)
print v(xbgr.mr_n84210880)
print v(xbgr.mr_n84210992)
print v(xbgr.mr_n84211312)
print v(xbgr.mr_n84211424)
print v(xbgr.mr_n84211744)
print v(xbgr.mr_n84211856)
print v(xbgr.mr_n84212176)
print v(xbgr.mr_n84212288)
print v(xbgr.mr_n84212608)
print v(xbgr.mr_n84212720)
print v(xbgr.mr_n84213040)
print v(xbgr.mr_n84213152)
print v(xbgr.mr_n84213472)
print v(xbgr.mr_n84213584)
print v(xbgr.mr_n84213904)
print v(xbgr.mr_n84214016)
print v(xbgr.mr_n84214336)
print v(xbgr.mr_n84214448)
print v(xbgr.mr_n84214768)
print v(xbgr.mr_n84214880)
print v(xbgr.mr_n84215200)
print v(xbgr.mr_n84215312)
print v(xbgr.mr_n84215632)
print v(xbgr.mr_n84215744)
print v(xbgr.mr_n84216064)
print v(xbgr.mr_n84216176)
print v(xbgr.mr_n84216496)
print v(xbgr.mr_n84216608)
print v(xbgr.mr_n84216928)
print v(xbgr.mr_n84217040)
print v(xbgr.mr_n84217360)
print v(xbgr.mr_n84217472)
print v(xbgr.mr_n84217792)
print v(xbgr.mr_n84217904)
print v(xbgr.mr_n84218224)
print v(xbgr.mr_n84218336)
print v(xbgr.mr_n84218656)
print v(xbgr.mr_n84218768)
print v(xbgr.mr_n84219088)
print v(xbgr.mr_n84219200)
print v(xbgr.mr_n84219520)
print v(xbgr.mr_n84219632)
print v(xbgr.mr_n84219952)
print v(xbgr.mr_n84220064)
print v(xbgr.mr_n84220384)
print v(xbgr.mr_n84220496)
print v(xbgr.mr_n84220816)
print v(xbgr.mr_n84220928)
print v(xbgr.mr_n84221248)
print v(xbgr.mr_n84221360)
print v(xbgr.mr_n84221680)
print v(xbgr.mr_n84221792)
print v(xbgr.mr_n84222112)
print v(xbgr.mr_n84222224)
print v(xbgr.mr_n84222544)
print v(xbgr.mr_n84222656)
print v(xbgr.mr_n84222976)
print v(xbgr.mr_n84223088)
print v(xbgr.mr_n84223408)
print v(xbgr.mr_n84223520)
print v(xbgr.mr_n84223840)
print v(xbgr.mr_n84223952)
print v(xbgr.mr_n84224272)
print v(xbgr.mr_n84224384)
print v(xbgr.mr_n84224704)
print v(xbgr.mr_n84224816)
print v(xbgr.mr_n84225136)
print v(xbgr.mr_n84225248)
print v(xbgr.mr_n84225568)
print v(xbgr.mr_n84225680)
print v(xbgr.mr_n84226000)
print v(xbgr.mr_n84226112)
print v(xbgr.mr_n84226432)
print v(xbgr.mr_n84226544)
print v(xbgr.mr_n84226864)
print v(xbgr.mr_n84226976)
print v(xbgr.mr_n84227296)
print v(xbgr.mr_n84227408)
print v(xbgr.mr_n84227728)
print v(xbgr.mr_n84227840)
print v(xbgr.mr_n84228160)
print v(xbgr.mr_n84228272)
print v(xbgr.mr_n84228592)
print v(xbgr.mr_n84228704)
print v(xbgr.mr_n84229024)
print v(xbgr.mr_n84229136)
print v(xbgr.mr_n84229456)
print v(xbgr.mr_n84229568)
print v(xbgr.mr_n84229888)
print v(xbgr.mr_n84230000)
print v(xbgr.mr_n84230320)
print v(xbgr.mr_n84230432)
print v(xbgr.mr_n84230752)
print v(xbgr.mr_n84230864)
print v(xbgr.mr_n84231184)
print v(xbgr.mr_n84231296)
print v(xbgr.mr_n84231616)
print v(xbgr.mr_n84231728)
print v(xbgr.mr_n84232048)
print v(xbgr.mr_n84232160)
print v(xbgr.mr_n84232480)
print v(xbgr.mr_n84232592)
print v(xbgr.mr_n84232800)
print v(xbgr.mr_n84232912)
print v(xbgr.mr_n84233232)
print v(xbgr.mr_n84233344)
print v(xbgr.mr_n84233664)
print v(xbgr.mr_n84233776)
print v(xbgr.mr_n84234096)
print v(xbgr.mr_n84234208)
print v(xbgr.mr_n84234528)
print v(xbgr.mr_n84234640)
print v(xbgr.mr_n84234960)
print v(xbgr.mr_n84235072)
print v(xbgr.mr_n84235392)
print v(xbgr.mr_n84235504)
print v(xbgr.mr_n84235824)
print v(xbgr.mr_n84235936)
print v(xbgr.mr_n84236256)
print v(xbgr.mr_n84236368)
print v(xbgr.mr_n84236688)
print v(xbgr.mr_n84236800)
print v(xbgr.mr_n84237120)
print v(xbgr.mr_n84237232)
print v(xbgr.mr_n84237552)
print v(xbgr.mr_n84237664)
print v(xbgr.mr_n84237984)
print v(xbgr.mr_n84238096)
print v(xbgr.mr_n84238416)
print v(xbgr.mr_n84238528)
print v(xbgr.mr_n84238848)
print v(xbgr.mr_n84238960)
print v(xbgr.mr_n84239280)
print v(xbgr.mr_n84239392)
print v(xbgr.mr_n84239712)
print v(xbgr.mr_n84239824)
print v(xbgr.mr_n84240144)
print v(xbgr.mr_n84240256)
print v(xbgr.mr_n84240576)
print v(xbgr.mr_n84240688)
print v(xbgr.mr_n84241008)
print v(xbgr.mr_n84241120)
print v(xbgr.mr_n84241440)
print v(xbgr.mr_n84241552)
print v(xbgr.mr_n84241872)
print v(xbgr.mr_n84241984)
print v(xbgr.mr_n84242304)
print v(xbgr.mr_n84242416)
print v(xbgr.mr_n84242736)
print v(xbgr.mr_n84242848)
print v(xbgr.mr_n84243168)
print v(xbgr.mr_n84243280)
print v(xbgr.mr_n84243600)
print v(xbgr.mr_n84243712)
print v(xbgr.mr_n84244032)
print v(xbgr.mr_n84244144)
print v(xbgr.mr_n84244464)
print v(xbgr.mr_n84244576)
print v(xbgr.mr_n84244896)
print v(xbgr.mr_n84245008)
print v(xbgr.mr_n84245328)
print v(xbgr.mr_n84245440)
print v(xbgr.mr_n84245760)
print v(xbgr.mr_n84245872)
print v(xbgr.mr_n84246192)
print v(xbgr.mr_n84246304)
print v(xbgr.mr_n84246624)
print v(xbgr.mr_n84246736)
print v(xbgr.mr_n84247056)
print v(xbgr.mr_n84247168)
print v(xbgr.mr_n84247488)
print v(xbgr.mr_n84247600)
print v(xbgr.mr_n84247920)
print v(xbgr.mr_n84248032)
print v(xbgr.mr_n84248352)
print v(xbgr.mr_n84248464)
print v(xbgr.mr_n84248784)
print v(xbgr.mr_n84248896)
print v(xbgr.mr_n84249216)
print v(xbgr.mr_n84249328)
print v(xbgr.mr_n84249648)
print v(xbgr.mr_n84249760)
print v(xbgr.mr_n84250080)
print v(xbgr.mr_n84250192)
print v(xbgr.mr_n84250512)
print v(xbgr.mr_n84250624)
print v(xbgr.mr_n84250944)
print v(xbgr.mr_n84251056)
print v(xbgr.mr_n84251376)
print v(xbgr.mr_n84251488)
print v(xbgr.mr_n84251808)
print v(xbgr.mr_n84251920)
print v(xbgr.mr_n84252240)
print v(xbgr.mr_n84252352)
print v(xbgr.mr_n84252672)
print v(xbgr.mr_n84252784)
print v(xbgr.mr_n84253104)
print v(xbgr.mr_n84253216)
print v(xbgr.mr_n84253536)
print v(xbgr.mr_n84253648)
print v(xbgr.mr_n84253968)
print v(xbgr.mr_n84254080)
print v(xbgr.mr_n84254400)
print v(xbgr.mr_n84254512)
print v(xbgr.mr_n84254832)
print v(xbgr.mr_n84254944)
print v(xbgr.mr_n84255264)
print v(xbgr.mr_n84255376)
print v(xbgr.mr_n84255696)
print v(xbgr.mr_n84255808)
print v(xbgr.mr_n84256128)
print v(xbgr.mr_n84256240)
print v(xbgr.mr_n84256560)
print v(xbgr.mr_n84256672)
print v(xbgr.mr_n84256992)
print v(xbgr.mr_n84257104)
print v(xbgr.mr_n84257424)
print v(xbgr.mr_n84257536)
print v(xbgr.mr_n84257856)
print v(xbgr.mr_n84257968)
print v(xbgr.mr_n84258288)
print v(xbgr.mr_n84258400)
print v(xbgr.mr_n84258720)
print v(xbgr.mr_n84258832)
print v(xbgr.mr_n84259152)
print v(xbgr.mr_n84259264)
print v(xbgr.mr_n84259584)
print v(xbgr.mr_n84259696)
print v(xbgr.mr_n84260016)
print v(xbgr.mr_n84260128)
print v(xbgr.mr_n84260448)
print v(xbgr.mr_n84260560)
print v(xbgr.mr_n84260880)
print v(xbgr.mr_n84260992)
print v(xbgr.mr_n84261312)
print v(xbgr.mr_n84261424)
print v(xbgr.mr_n84261744)
print v(xbgr.mr_n84261856)
print v(xbgr.mr_n84262176)
print v(xbgr.mr_n84262288)
print v(xbgr.mr_n84262608)
print v(xbgr.mr_n84262720)
print v(xbgr.mr_n84263040)
print v(xbgr.mr_n84263152)
print v(xbgr.mr_n84263472)
print v(xbgr.mr_n84263584)
print v(xbgr.mr_n84263904)
print v(xbgr.mr_n84264016)
print v(xbgr.mr_n84264336)
print v(xbgr.mr_n84264448)
print v(xbgr.mr_n84264768)
print v(xbgr.mr_n84264880)
print v(xbgr.mr_n84265200)
print v(xbgr.mr_n84265312)
print v(xbgr.mr_n84265632)
print v(xbgr.mr_n84265744)
print v(xbgr.mr_n84266064)
print v(xbgr.mr_n84266176)
print v(xbgr.mr_n84266496)
print v(xbgr.mr_n84266608)
print v(xbgr.mr_n84266928)
print v(xbgr.mr_n84267040)
print v(xbgr.mr_n84267360)
print v(xbgr.mr_n84267472)
print v(xbgr.mr_n84267792)
print v(xbgr.mr_n84267904)
print v(xbgr.mr_n84268224)
print v(xbgr.mr_n84268336)
print v(xbgr.mr_n84268656)
print v(xbgr.mr_n84268768)
print v(xbgr.mr_n84269088)
print v(xbgr.mr_n84269200)
print v(xbgr.mr_n84269520)
print v(xbgr.mr_n84269632)
print v(xbgr.mr_n84269952)
print v(xbgr.mr_n84270064)
print v(xbgr.mr_n84270384)
print v(xbgr.mr_n84270496)
print v(xbgr.mr_n84270816)
print v(xbgr.mr_n84270928)
print v(xbgr.mr_n84271248)
print v(xbgr.mr_n84271360)
print v(xbgr.mr_n84271680)
print v(xbgr.mr_n84271792)
print v(xbgr.mr_n84272112)
print v(xbgr.mr_n84272224)
print v(xbgr.mr_n84272544)
print v(xbgr.mr_n84272656)
print v(xbgr.mr_n84272976)
print v(xbgr.mr_n84273088)
print v(xbgr.mr_n84273408)
print v(xbgr.mr_n84273520)
print v(xbgr.mr_n84273840)
print v(xbgr.mr_n84273952)
print v(xbgr.mr_n84274272)
print v(xbgr.mr_n84274384)
print v(xbgr.mr_n84274704)
print v(xbgr.mr_n84274816)
print v(xbgr.mr_n84275136)
print v(xbgr.mr_n84275248)
print v(xbgr.mr_n84275568)
print v(xbgr.mr_n84275680)
print v(xbgr.mr_n84276000)
print v(xbgr.mr_n84276112)
print v(xbgr.mr_n84276432)
print v(xbgr.mr_n84276544)
print v(xbgr.mr_n84276864)
print v(xbgr.mr_n84276976)
print v(xbgr.mr_n84277296)
print v(xbgr.mr_n84277408)
print v(xbgr.mr_n84277728)
print v(xbgr.mr_n84277840)
print v(xbgr.mr_n84278160)
print v(xbgr.mr_n84278272)
print v(xbgr.mr_n84278592)
print v(xbgr.mr_n84278704)
print v(xbgr.mr_n84279024)
print v(xbgr.mr_n84279136)
print v(xbgr.mr_n84279456)
print v(xbgr.mr_n84279568)
print v(xbgr.mr_n84279888)
print v(xbgr.mr_n84280000)
print v(xbgr.mr_n84280320)
print v(xbgr.mr_n84280432)
print v(xbgr.mr_n84280752)
print v(xbgr.mr_n84280864)
print v(xbgr.mr_n84281184)
print v(xbgr.mr_n84281296)
print v(xbgr.mr_n84281616)
print v(xbgr.mr_n84281728)
print v(xbgr.mr_n84282048)
print v(xbgr.mr_n84282160)
print v(xbgr.mr_n84282480)
print v(xbgr.mr_n84282592)
print v(xbgr.mr_n84282912)
print v(xbgr.mr_n84283024)
print v(xbgr.mr_n84283344)
print v(xbgr.mr_n84283456)
print v(xbgr.mr_n84283776)
print v(xbgr.mr_n84283888)
print v(xbgr.mr_n84284208)
print v(xbgr.mr_n84284320)
print v(xbgr.mr_n84284640)
print v(xbgr.mr_n84284752)
print v(xbgr.mr_n84285072)
print v(xbgr.mr_n84285184)
print v(xbgr.mr_n84285504)
print v(xbgr.mr_n84285616)
print v(xbgr.mr_n84285936)
print v(xbgr.mr_n84286048)
print v(xbgr.mr_n84286368)
print v(xbgr.mr_n84286480)
print v(xbgr.mr_n84286800)
print v(xbgr.mr_n84286912)
print v(xbgr.mr_n84287232)
print v(xbgr.mr_n84287344)
print v(xbgr.mr_n84287664)
print v(xbgr.mr_n84287776)
print v(xbgr.mr_n84288096)
print v(xbgr.mr_n84288208)
print v(xbgr.mr_n84288528)
print v(xbgr.mr_n84288640)
print v(xbgr.mr_n84288960)
print v(xbgr.mr_n84289072)
print v(xbgr.mr_n84289392)
print v(xbgr.mr_n84289504)
print v(xbgr.mr_n84289824)
print v(xbgr.mr_n84289936)
print v(xbgr.mr_n84290256)
print v(xbgr.mr_n84290368)
print v(xbgr.mr_n84290688)
print v(xbgr.mr_n84290800)
print v(xbgr.mr_n84291120)
print v(xbgr.mr_n84291232)
print v(xbgr.mr_n84291552)
print v(xbgr.mr_n84291664)
print v(xbgr.mr_n84291984)
print v(xbgr.mr_n84292096)
print v(xbgr.mr_n84292416)
print v(xbgr.mr_n84292528)
print v(xbgr.mr_n84292848)
print v(xbgr.mr_n84292960)
print v(xbgr.mr_n84293280)
print v(xbgr.mr_n84293392)
print v(xbgr.mr_n84293712)
print v(xbgr.mr_n84293824)
print v(xbgr.mr_n84294352)
print v(xbgr.mr_n84294464)
print v(xbgr.mr_n84294784)
print v(xbgr.mr_n84294896)
print v(xbgr.mr_n84295216)
print v(xbgr.mr_n84295328)
print v(xbgr.mr_n84295648)
print v(xbgr.mr_n84295760)
print v(xbgr.mr_n84296080)
print v(xbgr.mr_n84296192)
print v(xbgr.mr_n84296512)
print v(xbgr.mr_n84296624)
print v(xbgr.mr_n84296944)
print v(xbgr.mr_n84297056)
print v(xbgr.mr_n84297376)
print v(xbgr.mr_n84297488)
print v(xbgr.mr_n84297808)
print v(xbgr.mr_n84297920)
print v(xbgr.mr_n84298240)
print v(xbgr.mr_n84298352)
print v(xbgr.mr_n84298672)
print v(xbgr.mr_n84298784)
print v(xbgr.mr_n84299104)
print v(xbgr.mr_n84299216)
print v(xbgr.mr_n84299536)
print v(xbgr.mr_n84299648)
print v(xbgr.mr_n84299968)
print v(xbgr.mr_n84300080)
print v(xbgr.mr_n84300400)
print v(xbgr.mr_n84300512)
print v(xbgr.mr_n84300832)
print v(xbgr.mr_n84300944)
print v(xbgr.mr_n84301264)
print v(xbgr.mr_n84301376)
print v(xbgr.mr_n84301696)
print v(xbgr.mr_n84301808)
print v(xbgr.mr_n84302128)
print v(xbgr.mr_n84302240)
print v(xbgr.mr_n84302560)
print v(xbgr.mr_n84302672)
print v(xbgr.mr_n84302992)
print v(xbgr.mr_n84303104)
print v(xbgr.mr_n84303424)
print v(xbgr.mr_n84303536)
print v(xbgr.mr_n84303856)
print v(xbgr.mr_n84303968)
print v(xbgr.mr_n84304288)
print v(xbgr.mr_n84304400)
print v(xbgr.mr_n84304720)
print v(xbgr.mr_n84304832)
print v(xbgr.mr_n84305152)
print v(xbgr.mr_n84305264)
print v(xbgr.mr_n84305584)
print v(xbgr.mr_n84305696)
print v(xbgr.mr_n84306016)
print v(xbgr.mr_n84306128)
print v(xbgr.mr_n84306448)
print v(xbgr.mr_n84306560)
print v(xbgr.mr_n84306880)
print v(xbgr.mr_n84306992)
print v(xbgr.mr_n84307312)
print v(xbgr.mr_n84307424)
print v(xbgr.mr_n84307744)
print v(xbgr.mr_n84307856)
print v(xbgr.mr_n84308176)
print v(xbgr.mr_n84308288)
print v(xbgr.mr_n84308608)
print v(xbgr.mr_n84308720)
print v(xbgr.mr_n84309040)
print v(xbgr.mr_n84309152)
print v(xbgr.mr_n84309472)
print v(xbgr.mr_n84309584)
print v(xbgr.mr_n84309904)
print v(xbgr.mr_n84310016)
print v(xbgr.mr_n84310336)
print v(xbgr.mr_n84310448)
print v(xbgr.mr_n84310768)
print v(xbgr.mr_n84310880)
print v(xbgr.mr_n84311200)
print v(xbgr.mr_n84311312)
print v(xbgr.mr_n84311632)
print v(xbgr.mr_n84311744)
print v(xbgr.mr_n84312064)
print v(xbgr.mr_n84312176)
print v(xbgr.mr_n84312496)
print v(xbgr.mr_n84312608)
print v(xbgr.mr_n84312928)
print v(xbgr.mr_n84313040)
print v(xbgr.mr_n84313360)
print v(xbgr.mr_n84313472)
print v(xbgr.mr_n84313792)
print v(xbgr.mr_n84313904)
print v(xbgr.mr_n84314224)
print v(xbgr.mr_n84314336)
print v(xbgr.mr_n84314656)
print v(xbgr.mr_n84314768)
print v(xbgr.mr_n84315088)
print v(xbgr.mr_n84315200)
print v(xbgr.mr_n84315520)
print v(xbgr.mr_n84315632)
print v(xbgr.mr_n84315952)
print v(xbgr.mr_n84316064)
print v(xbgr.mr_n84316384)
print v(xbgr.mr_n84316496)
print v(xbgr.mr_n84316816)
print v(xbgr.mr_n84316928)
print v(xbgr.mr_n84317248)
print v(xbgr.mr_n84317360)
print v(xbgr.mr_n84317680)
print v(xbgr.mr_n84317792)
print v(xbgr.mr_n84318112)
print v(xbgr.mr_n84318224)
print v(xbgr.mr_n84318544)
print v(xbgr.mr_n84318656)
print v(xbgr.mr_n84318976)
print v(xbgr.mr_n84319088)
print v(xbgr.mr_n84319408)
print v(xbgr.mr_n84319520)
print v(xbgr.mr_n84319840)
print v(xbgr.mr_n84319952)
print v(xbgr.mr_n84320272)
print v(xbgr.mr_n84320384)
print v(xbgr.mr_n84320704)
print v(xbgr.mr_n84320816)
print v(xbgr.mr_n84321136)
print v(xbgr.mr_n84321248)
print v(xbgr.mr_n84321568)
print v(xbgr.mr_n84321680)
print v(xbgr.mr_n84322000)
print v(xbgr.mr_n84322112)
print v(xbgr.mr_n84322432)
print v(xbgr.mr_n84322544)
print v(xbgr.mr_n84322864)
print v(xbgr.mr_n84322976)
print v(xbgr.mr_n84323296)
print v(xbgr.mr_n84323408)
print v(xbgr.mr_n84323728)
print v(xbgr.mr_n84323840)
print v(xbgr.mr_n84324160)
print v(xbgr.mr_n84324272)
print v(xbgr.mr_n84324592)
print v(xbgr.mr_n84324704)
print v(xbgr.mr_n84325024)
print v(xbgr.mr_n84325136)
print v(xbgr.mr_n84325456)
print v(xbgr.mr_n84325568)
print v(xbgr.mr_n84325888)
print v(xbgr.mr_n84326000)
print v(xbgr.mr_n84326320)
print v(xbgr.mr_n84326432)
print v(xbgr.mr_n84326752)
print v(xbgr.mr_n84326864)
print v(xbgr.mr_n84327184)
print v(xbgr.mr_n84327296)
print v(xbgr.mr_n84327616)
print v(xbgr.mr_n84327728)
print v(xbgr.mr_n84328048)
print v(xbgr.mr_n84328160)
print v(xbgr.mr_n84328480)
print v(xbgr.mr_n84328592)
print v(xbgr.mr_n84328912)
print v(xbgr.mr_n84329024)
print v(xbgr.mr_n84329344)
print v(xbgr.mr_n84329456)
print v(xbgr.mr_n84329776)
print v(xbgr.mr_n84329888)
print v(xbgr.mr_n84330208)
print v(xbgr.mr_n84330320)
print v(xbgr.mr_n84330640)
print v(xbgr.mr_n84330752)
print v(xbgr.mr_n84331072)
print v(xbgr.mr_n84331184)
print v(xbgr.mr_n84331504)
print v(xbgr.mr_n84331616)
print v(xbgr.mr_n84331936)
print v(xbgr.mr_n84332048)
print v(xbgr.mr_n84332368)
print v(xbgr.mr_n84332480)
print v(xbgr.mr_n84332800)
print v(xbgr.mr_n84332912)
print v(xbgr.mr_n84333232)
print v(xbgr.mr_n84333344)
print v(xbgr.mr_n84333664)
print v(xbgr.mr_n84333776)
print v(xbgr.mr_n84596256)
print v(xbgr.mr_n84596496)
print v(xbgr.mr_n84596608)
print v(xbgr.mr_n84596928)
print v(xbgr.mr_n84597040)
print v(xbgr.mr_n84597360)
print v(xbgr.mr_n84597472)
print v(xbgr.mr_n84597792)
print v(xbgr.mr_n84597904)
print v(xbgr.mr_n84598224)
print v(xbgr.mr_n84598336)
print v(xbgr.mr_n84598656)
print v(xbgr.mr_n84598768)
print v(xbgr.mr_n84599088)
print v(xbgr.mr_n84599200)
print v(xbgr.mr_n84599520)
print v(xbgr.mr_n84599632)
print v(xbgr.mr_n84599952)
print v(xbgr.mr_n84600064)
print v(xbgr.mr_n84600384)
print v(xbgr.mr_n84600496)
print v(xbgr.mr_n84600816)
print v(xbgr.mr_n84600928)
print v(xbgr.mr_n84601248)
print v(xbgr.mr_n84601360)
print v(xbgr.mr_n84601680)
print v(xbgr.mr_n84601792)
print v(xbgr.mr_n84602112)
print v(xbgr.mr_n84602224)
print v(xbgr.mr_n84602544)
print v(xbgr.mr_n84602656)
print v(xbgr.mr_n84602976)
print v(xbgr.mr_n84603088)
print v(xbgr.mr_n84603408)
print v(xbgr.mr_n84603520)
print v(xbgr.mr_n84603840)
print v(xbgr.mr_n84603952)
print v(xbgr.mr_n84604272)
print v(xbgr.mr_n84604384)
print v(xbgr.mr_n84604704)
print v(xbgr.mr_n84604816)
print v(xbgr.mr_n84605136)
print v(xbgr.mr_n84605248)
print v(xbgr.mr_n84605568)
print v(xbgr.mr_n84605680)
print v(xbgr.mr_n84606000)
print v(xbgr.mr_n84606112)
print v(xbgr.mr_n84606432)
print v(xbgr.mr_n84606544)
print v(xbgr.mr_n84606864)
print v(xbgr.mr_n84606976)
print v(xbgr.mr_n84607296)
print v(xbgr.mr_n84607408)
print v(xbgr.mr_n84607728)
print v(xbgr.mr_n84607840)
print v(xbgr.mr_n84608160)
print v(xbgr.mr_n84608272)
print v(xbgr.mr_n84608592)
print v(xbgr.mr_n84608704)
print v(xbgr.mr_n84609024)
print v(xbgr.mr_n84609136)
print v(xbgr.mr_n84609456)
print v(xbgr.mr_n84609568)
print v(xbgr.mr_n84609888)
print v(xbgr.mr_n84610000)
print v(xbgr.mr_n84610320)
print v(xbgr.mr_n84610432)
print v(xbgr.mr_n84610752)
print v(xbgr.mr_n84610864)
print v(xbgr.mr_n84611184)
print v(xbgr.mr_n84611296)
print v(xbgr.mr_n84611616)
print v(xbgr.mr_n84611728)
print v(xbgr.mr_n84612048)
print v(xbgr.mr_n84612160)
print v(xbgr.mr_n84612480)
print v(xbgr.mr_n84612592)
print v(xbgr.mr_n84612912)
print v(xbgr.mr_n84613024)
print v(xbgr.mr_n84613344)
print v(xbgr.mr_n84613456)
print v(xbgr.mr_n84613776)
print v(xbgr.mr_n84613888)
print v(xbgr.mr_n84614208)
print v(xbgr.mr_n84614320)
print v(xbgr.mr_n84614640)
print v(xbgr.mr_n84614752)
print v(xbgr.mr_n84615072)
print v(xbgr.mr_n84615184)
print v(xbgr.mr_n84615504)
print v(xbgr.mr_n84615616)
print v(xbgr.mr_n84615936)
print v(xbgr.mr_n84616048)
print v(xbgr.mr_n84616368)
print v(xbgr.mr_n84616480)
print v(xbgr.mr_n84616800)
print v(xbgr.mr_n84616912)
print v(xbgr.mr_n84617232)
print v(xbgr.mr_n84617344)
print v(xbgr.mr_n84617664)
print v(xbgr.mr_n84617776)
print v(xbgr.mr_n84618096)
print v(xbgr.mr_n84618208)
print v(xbgr.mr_n84618528)
print v(xbgr.mr_n84618640)
print v(xbgr.mr_n84618960)
print v(xbgr.mr_n84619072)
print v(xbgr.mr_n84619392)
print v(xbgr.mr_n84619504)
print v(xbgr.mr_n84619824)
print v(xbgr.mr_n84619936)
print v(xbgr.mr_n84620256)
print v(xbgr.mr_n84620368)
print v(xbgr.mr_n84620688)
print v(xbgr.mr_n84620800)
print v(xbgr.mr_n84621120)
print v(xbgr.mr_n84621232)
print v(xbgr.mr_n84621552)
print v(xbgr.mr_n84621664)
print v(xbgr.mr_n84621984)
print v(xbgr.mr_n84622096)
print v(xbgr.mr_n84622416)
print v(xbgr.mr_n84622528)
print v(xbgr.mr_n84622848)
print v(xbgr.mr_n84622960)
print v(xbgr.mr_n84623280)
print v(xbgr.mr_n84623392)
print v(xbgr.mr_n84623712)
print v(xbgr.mr_n84623824)
print v(xbgr.mr_n84624144)
print v(xbgr.mr_n84624256)
print v(xbgr.mr_n84624576)
print v(xbgr.mr_n84624688)
print v(xbgr.mr_n84625008)
print v(xbgr.mr_n84625120)
print v(xbgr.mr_n84625440)
print v(xbgr.mr_n84625552)
print v(xbgr.mr_n84625872)
print v(xbgr.mr_n84625984)
print v(xbgr.mr_n84626304)
print v(xbgr.mr_n84626416)
print v(xbgr.mr_n84626736)
print v(xbgr.mr_n84626848)
print v(xbgr.mr_n84627168)
print v(xbgr.mr_n84627280)
print v(xbgr.mr_n84627600)
print v(xbgr.mr_n84627712)
print v(xbgr.mr_n84628032)
print v(xbgr.mr_n84628144)
print v(xbgr.mr_n84628464)
print v(xbgr.mr_n84628576)
print v(xbgr.mr_n84628896)
print v(xbgr.mr_n84629008)
print v(xbgr.mr_n84629328)
print v(xbgr.mr_n84629440)
print v(xbgr.mr_n84629760)
print v(xbgr.mr_n84629872)
print v(xbgr.mr_n84630192)
print v(xbgr.mr_n84630304)
print v(xbgr.mr_n84630624)
print v(xbgr.mr_n84630736)
print v(xbgr.mr_n84631056)
print v(xbgr.mr_n84631168)
print v(xbgr.mr_n84631488)
print v(xbgr.mr_n84631600)
print v(xbgr.mr_n84631920)
print v(xbgr.mr_n84632032)
print v(xbgr.mr_n84632352)
print v(xbgr.mr_n84632464)
print v(xbgr.mr_n84632784)
print v(xbgr.mr_n84632896)
print v(xbgr.mr_n84633216)
print v(xbgr.mr_n84633328)
print v(xbgr.mr_n84633648)
print v(xbgr.mr_n84633760)
print v(xbgr.mr_n84634080)
print v(xbgr.mr_n84634192)
print v(xbgr.mr_n84634512)
print v(xbgr.mr_n84634624)
print v(xbgr.mr_n84634944)
print v(xbgr.mr_n84635056)
print v(xbgr.mr_n84635376)
print v(xbgr.mr_n84635488)
print v(xbgr.mr_n84635808)
print v(xbgr.mr_n84635920)
print v(xbgr.mr_n84636240)
print v(xbgr.mr_n84636352)
print v(xbgr.mr_n84636672)
print v(xbgr.mr_n84636784)
print v(xbgr.mr_n84637104)
print v(xbgr.mr_n84637216)
print v(xbgr.mr_n84637536)
print v(xbgr.mr_n84637648)
print v(xbgr.mr_n84637968)
print v(xbgr.mr_n84638080)
print v(xbgr.mr_n84638400)
print v(xbgr.mr_n84638512)
print v(xbgr.mr_n84638832)
print v(xbgr.mr_n84638944)
print v(xbgr.mr_n84639264)
print v(xbgr.mr_n84639376)
print v(xbgr.mr_n84639696)
print v(xbgr.mr_n84639808)
print v(xbgr.mr_n84640128)
print v(xbgr.mr_n84640240)
print v(xbgr.mr_n84640560)
print v(xbgr.mr_n84640672)
print v(xbgr.mr_n84640992)
print v(xbgr.mr_n84641104)
print v(xbgr.mr_n84641424)
print v(xbgr.mr_n84641536)
print v(xbgr.mr_n84641856)
print v(xbgr.mr_n84641968)
print v(xbgr.mr_n84642288)
print v(xbgr.mr_n84642400)
print v(xbgr.mr_n84642720)
print v(xbgr.mr_n84642832)
print v(xbgr.mr_n84643152)
print v(xbgr.mr_n84643264)
print v(xbgr.mr_n84643584)
print v(xbgr.mr_n84643696)
print v(xbgr.mr_n84644016)
print v(xbgr.mr_n84644128)
print v(xbgr.mr_n84644448)
print v(xbgr.mr_n84644560)
print v(xbgr.mr_n84644880)
print v(xbgr.mr_n84644992)
print v(xbgr.mr_n84645312)
print v(xbgr.mr_n84645424)
print v(xbgr.mr_n84645744)
print v(xbgr.mr_n84645856)
print v(xbgr.mr_n84646176)
print v(xbgr.mr_n84646288)
print v(xbgr.mr_n84646608)
print v(xbgr.mr_n84646720)
print v(xbgr.mr_n84647040)
print v(xbgr.mr_n84647152)
print v(xbgr.mr_n84647472)
print v(xbgr.mr_n84647584)
print v(xbgr.mr_n84647904)
print v(xbgr.mr_n84648016)
print v(xbgr.mr_n84648336)
print v(xbgr.mr_n84648448)
print v(xbgr.mr_n84648768)
print v(xbgr.mr_n84648880)
print v(xbgr.mr_n84649200)
print v(xbgr.mr_n84649312)
print v(xbgr.mr_n84649632)
print v(xbgr.mr_n84649744)
print v(xbgr.mr_n84650064)
print v(xbgr.mr_n84650176)
print v(xbgr.mr_n84650496)
print v(xbgr.mr_n84650608)
print v(xbgr.mr_n84650928)
print v(xbgr.mr_n84651040)
print v(xbgr.mr_n84651360)
print v(xbgr.mr_n84651472)
print v(xbgr.mr_n84651792)
print v(xbgr.mr_n84651904)
print v(xbgr.mr_n84652224)
print v(xbgr.mr_n84652336)
print v(xbgr.mr_n84652656)
print v(xbgr.mr_n84652768)
print v(xbgr.mr_n84653088)
print v(xbgr.mr_n84653200)
print v(xbgr.mr_n84653520)
print v(xbgr.mr_n84653632)
print v(xbgr.mr_n84653952)
print v(xbgr.mr_n84654064)
print v(xbgr.mr_n84654384)
print v(xbgr.mr_n84654496)
print v(xbgr.mr_n84654816)
print v(xbgr.mr_n84654928)
print v(xbgr.mr_n84655248)
print v(xbgr.mr_n84655360)
print v(xbgr.mr_n84655680)
print v(xbgr.mr_n84655792)
print v(xbgr.mr_n84656112)
print v(xbgr.mr_n84656224)
print v(xbgr.mr_n84656544)
print v(xbgr.mr_n84656656)
print v(xbgr.mr_n84656976)
print v(xbgr.mr_n84657088)
print v(xbgr.mr_n84657408)
print v(xbgr.mr_n84657520)
print v(xbgr.mr_n84657840)
print v(xbgr.mr_n84657952)
print v(xbgr.mr_n84658272)
print v(xbgr.mr_n84658384)
print v(xbgr.mr_n84658704)
print v(xbgr.mr_n84658816)
print v(xbgr.mr_n84659136)
print v(xbgr.mr_n84659248)
print v(xbgr.mr_n84659568)
print v(xbgr.mr_n84659680)
print v(xbgr.mr_n84660000)
print v(xbgr.mr_n84660112)
print v(xbgr.mr_n84660432)
print v(xbgr.mr_n84660544)
print v(xbgr.mr_n84660864)
print v(xbgr.mr_n84660976)
print v(xbgr.mr_n84661296)
print v(xbgr.mr_n84661408)
print v(xbgr.mr_n84661728)
print v(xbgr.mr_n84661840)
print v(xbgr.mr_n84662160)
print v(xbgr.mr_n84662272)
print v(xbgr.mr_n84662592)
print v(xbgr.mr_n84662704)
print v(xbgr.mr_n84663024)
print v(xbgr.mr_n84663136)
print v(xbgr.mr_n84663456)
print v(xbgr.mr_n84663568)
print v(xbgr.mr_n84663888)
print v(xbgr.mr_n84664000)
print v(xbgr.mr_n84664320)
print v(xbgr.mr_n84664432)
print v(xbgr.mr_n84664752)
print v(xbgr.mr_n84664864)
print v(xbgr.mr_n84665184)
print v(xbgr.mr_n84665296)
print v(xbgr.mr_n84665616)
print v(xbgr.mr_n84665728)
print v(xbgr.mr_n84666048)
print v(xbgr.mr_n84666160)
print v(xbgr.mr_n84666480)
print v(xbgr.mr_n84666592)
print v(xbgr.mr_n84666912)
print v(xbgr.mr_n84667024)
print v(xbgr.mr_n84667344)
print v(xbgr.mr_n84667456)
print v(xbgr.mr_n84667776)
print v(xbgr.mr_n84667888)
print v(xbgr.mr_n84668208)
print v(xbgr.mr_n84668320)
print v(xbgr.mr_n84668640)
print v(xbgr.mr_n84668752)
print v(xbgr.mr_n84669072)
print v(xbgr.mr_n84669184)
print v(xbgr.mr_n84669504)
print v(xbgr.mr_n84669616)
print v(xbgr.mr_n84669936)
print v(xbgr.mr_n84670048)
print v(xbgr.mr_n84670368)
print v(xbgr.mr_n84670480)
print v(xbgr.mr_n84670800)
print v(xbgr.mr_n84670912)
print v(xbgr.mr_n84671232)
print v(xbgr.mr_n84671344)
print v(xbgr.mr_n84671664)
print v(xbgr.mr_n84671776)
print v(xbgr.mr_n84672096)
print v(xbgr.mr_n84672208)
print v(xbgr.mr_n84672528)
print v(xbgr.mr_n84672640)
print v(xbgr.mr_n84672960)
print v(xbgr.mr_n84673072)
print v(xbgr.mr_n84673392)
print v(xbgr.mr_n84673504)
print v(xbgr.mr_n84673824)
print v(xbgr.mr_n84673936)
print v(xbgr.mr_n84674256)
print v(xbgr.mr_n84674368)
print v(xbgr.mr_n84674688)
print v(xbgr.mr_n84674800)
print v(xbgr.mr_n84675120)
print v(xbgr.mr_n84675232)
print v(xbgr.mr_n84675552)
print v(xbgr.mr_n84675664)
print v(xbgr.mr_n84675984)
print v(xbgr.mr_n84676096)
print v(xbgr.mr_n84676416)
print v(xbgr.mr_n84676528)
print v(xbgr.mr_n84676848)
print v(xbgr.mr_n84676960)
print v(xbgr.mr_n84677280)
print v(xbgr.mr_n84677392)
print v(xbgr.mr_n84677712)
print v(xbgr.mr_n84677824)
print v(xbgr.mr_n84678144)
print v(xbgr.mr_n84678256)
print v(xbgr.mr_n84678576)
print v(xbgr.mr_n84678688)
print v(xbgr.mr_n84679008)
print v(xbgr.mr_n84679120)
print v(xbgr.mr_n84679440)
print v(xbgr.mr_n84679552)
print v(xbgr.mr_n84679872)
print v(xbgr.mr_n84679984)
print v(xbgr.mr_n84680304)
print v(xbgr.mr_n84680416)
print v(xbgr.mr_n84680736)
print v(xbgr.mr_n84680848)
print v(xbgr.mr_n84681168)
print v(xbgr.mr_n84681280)
print v(xbgr.mr_n84681600)
print v(xbgr.mr_n84681712)
print v(xbgr.mr_n84682032)
print v(xbgr.mr_n84682144)
print v(xbgr.mr_n84682464)
print v(xbgr.mr_n84682576)
print v(xbgr.mr_n84682896)
print v(xbgr.mr_n84683008)
print v(xbgr.mr_n84683328)
print v(xbgr.mr_n84683440)
print v(xbgr.mr_n84683760)
print v(xbgr.mr_n84683872)
print v(xbgr.mr_n84684192)
print v(xbgr.mr_n84684304)
print v(xbgr.mr_n84684624)
print v(xbgr.mr_n84684736)
print v(xbgr.mr_n84685056)
print v(xbgr.mr_n84685168)
print v(xbgr.mr_n84685488)
print v(xbgr.mr_n84685600)
print v(xbgr.mr_n84685920)
print v(xbgr.mr_n84686032)
print v(xbgr.mr_n84686352)
print v(xbgr.mr_n84686464)
print v(xbgr.mr_n84686784)
print v(xbgr.mr_n84686896)
print v(xbgr.mr_n84687216)
print v(xbgr.mr_n84687328)
print v(xbgr.mr_n84687648)
print v(xbgr.mr_n84687760)
print v(xbgr.mr_n84688080)
print v(xbgr.mr_n84688192)
print v(xbgr.mr_n84688512)
print v(xbgr.mr_n84688624)
print v(xbgr.mr_n84688944)
print v(xbgr.mr_n84689056)
print v(xbgr.mr_n84689376)
print v(xbgr.mr_n84689488)
print v(xbgr.mr_n84689808)
print v(xbgr.mr_n84689920)
print v(xbgr.mr_n84690240)
print v(xbgr.mr_n84690352)
print v(xbgr.mr_n84690672)
print v(xbgr.mr_n84690784)
print v(xbgr.mr_n84691104)
print v(xbgr.mr_n84691216)
print v(xbgr.mr_n84691536)
print v(xbgr.mr_n84691648)
print v(xbgr.mr_n84691968)
print v(xbgr.mr_n84692080)
print v(xbgr.mr_n84692400)
print v(xbgr.mr_n84692512)
print v(xbgr.mr_n84692832)
print v(xbgr.mr_n84692944)
print v(xbgr.mr_n84693264)
print v(xbgr.mr_n84693376)
print v(xbgr.mr_n84693696)
print v(xbgr.mr_n84693808)
print v(xbgr.mr_n84694128)
print v(xbgr.mr_n84694240)
print v(xbgr.mr_n84694560)
print v(xbgr.mr_n84694672)
print v(xbgr.mr_n84694992)
print v(xbgr.mr_n84695104)
print v(xbgr.mr_n84695424)
print v(xbgr.mr_n84695536)
print v(xbgr.mr_n84695856)
print v(xbgr.mr_n84695968)
print v(xbgr.mr_n84696288)
print v(xbgr.mr_n84696400)
print v(xbgr.mr_n84696720)
print v(xbgr.mr_n84696832)
print v(xbgr.mr_n84697152)
print v(xbgr.mr_n84697264)
print v(xbgr.mr_n84697584)
print v(xbgr.mr_n84697696)
print v(xbgr.mr_n84698016)
print v(xbgr.mr_n84698128)
print v(xbgr.mr_n84698448)
print v(xbgr.mr_n84698560)
print v(xbgr.mr_n84698880)
print v(xbgr.mr_n84698992)
print v(xbgr.mr_n84699312)
print v(xbgr.mr_n84699424)
print v(xbgr.mr_n84699744)
print v(xbgr.mr_n84699856)
print v(xbgr.mr_n84700176)
print v(xbgr.mr_n84700288)
print v(xbgr.mr_n84700608)
print v(xbgr.mr_n84700720)
print v(xbgr.mr_n84701040)
print v(xbgr.mr_n84701152)
print v(xbgr.mr_n84701472)
print v(xbgr.mr_n84701584)
print v(xbgr.mr_n84701904)
print v(xbgr.mr_n84702016)
print v(xbgr.mr_n84702336)
print v(xbgr.mr_n84702448)
print v(xbgr.mr_n84702768)
print v(xbgr.mr_n84702880)
print v(xbgr.mr_n84703200)
print v(xbgr.mr_n84703312)
print v(xbgr.mr_n84703632)
print v(xbgr.mr_n84703744)
print v(xbgr.mr_n84704064)
print v(xbgr.mr_n84704176)
print v(xbgr.mr_n84704496)
print v(xbgr.mr_n84704608)
print v(xbgr.mr_n84704928)
print v(xbgr.mr_n84705040)
print v(xbgr.mr_n84705360)
print v(xbgr.mr_n84705472)
print v(xbgr.mr_n84705792)
print v(xbgr.mr_n84705904)
print v(xbgr.mr_n84706224)
print v(xbgr.mr_n84706336)
print v(xbgr.mr_n84706656)
print v(xbgr.mr_n84706768)
print v(xbgr.mr_n84707088)
print v(xbgr.mr_n84707200)
print v(xbgr.mr_n84707520)
print v(xbgr.mr_n84707632)
print v(xbgr.mr_n84707952)
print v(xbgr.mr_n84708064)
print v(xbgr.mr_n84708384)
print v(xbgr.mr_n84708496)
print v(xbgr.mr_n84708816)
print v(xbgr.mr_n84708928)
print v(xbgr.mr_n84709248)
print v(xbgr.mr_n84709360)
print v(xbgr.mr_n84709680)
print v(xbgr.mr_n84709792)
print v(xbgr.mr_n84710112)
print v(xbgr.mr_n84710224)
print v(xbgr.mr_n84710544)
print v(xbgr.mr_n84710656)
print v(xbgr.mr_n84710976)
print v(xbgr.mr_n84711088)
print v(xbgr.mr_n84711408)
print v(xbgr.mr_n84711520)
print v(xbgr.mr_n84711840)
print v(xbgr.mr_n84711952)
print v(xbgr.mr_n84712272)
print v(xbgr.mr_n84712384)
print v(xbgr.mr_n84712704)
print v(xbgr.mr_n84712816)
print v(xbgr.mr_n84713136)
print v(xbgr.mr_n84713248)
print v(xbgr.mr_n84713568)
print v(xbgr.mr_n84713680)
print v(xbgr.mr_n84714000)
print v(xbgr.mr_n84714112)
print v(xbgr.mr_n84714432)
print v(xbgr.mr_n84714544)
print v(xbgr.mr_n84714864)
print v(xbgr.mr_n84714976)
print v(xbgr.mr_n84715296)
print v(xbgr.mr_n84715408)
print v(xbgr.mr_n84715728)
print v(xbgr.mr_n84715840)
print v(xbgr.mr_n84716160)
print v(xbgr.mr_n84716272)
print v(xbgr.mr_n84716592)
print v(xbgr.mr_n84716704)
print v(xbgr.mr_n84717024)
print v(xbgr.mr_n84717136)
print v(xbgr.mr_n84717456)
print v(xbgr.mr_n84717568)
print v(xbgr.mr_n84717888)
print v(xbgr.mr_n84718000)
print v(xbgr.mr_n84718320)
print v(xbgr.mr_n84718432)
print v(xbgr.mr_n84718752)
print v(xbgr.mr_n84718864)
print v(xbgr.mr_n84719184)
print v(xbgr.mr_n84719296)
print v(xbgr.mr_n84719616)
print v(xbgr.mr_n84719728)
print v(xbgr.mr_n84720048)
print v(xbgr.mr_n84720160)
print v(xbgr.mr_n84720480)
print v(xbgr.mr_n84720592)
print v(xbgr.mr_n84720912)
print v(xbgr.mr_n84721024)
print v(xbgr.mr_n84721344)
print v(xbgr.mr_n84721456)
print v(xbgr.mr_n84721776)
print v(xbgr.mr_n84721888)
print v(xbgr.mr_n84722208)
print v(xbgr.mr_n84722320)
print v(xbgr.mr_n84722640)
print v(xbgr.mr_n84722752)
print v(xbgr.mr_n84723072)
print v(xbgr.mr_n84723184)
print v(xbgr.mr_n84723504)
print v(xbgr.mr_n84723616)
print v(xbgr.mr_n84723936)
print v(xbgr.mr_n84724048)
print v(xbgr.mr_n84724368)
print v(xbgr.mr_n84724480)
print v(xbgr.mr_n84724800)
print v(xbgr.mr_n84724912)
print v(xbgr.mr_n84725232)
print v(xbgr.mr_n84725344)
print v(xbgr.mr_n84725664)
print v(xbgr.mr_n84725776)
print v(xbgr.mr_n84726096)
print v(xbgr.mr_n84726208)
print v(xbgr.mr_n84726528)
print v(xbgr.mr_n84726640)
print v(xbgr.mr_n84726960)
print v(xbgr.mr_n84727072)
print v(xbgr.mr_n84727392)
print v(xbgr.mr_n84727504)
print v(xbgr.mr_n84727824)
print v(xbgr.mr_n84727936)
print v(xbgr.mr_n84728256)
print v(xbgr.mr_n84728368)
print v(xbgr.mr_n84728688)
print v(xbgr.mr_n84728800)
print v(xbgr.mr_n84729120)
print v(xbgr.mr_n84729232)
print v(xbgr.mr_n84729552)
print v(xbgr.mr_n84729664)
print v(xbgr.mr_n84729984)
print v(xbgr.mr_n84730096)
print v(xbgr.mr_n84730416)
print v(xbgr.mr_n84730528)
print v(xbgr.mr_n84730848)
print v(xbgr.mr_n84730960)
print v(xbgr.mr_n84731280)
print v(xbgr.mr_n84731392)
print v(xbgr.mr_n84731712)
print v(xbgr.mr_n84731824)
print v(xbgr.mr_n84732144)
print v(xbgr.mr_n84732256)
print v(xbgr.mr_n84732576)
print v(xbgr.mr_n84732688)
print v(xbgr.mr_n84733008)
print v(xbgr.mr_n84733120)
print v(xbgr.mr_n84733440)
print v(xbgr.mr_n84733552)
print v(xbgr.mr_n84733872)
print v(xbgr.mr_n84733984)
print v(xbgr.mr_n84734304)
print v(xbgr.mr_n84734416)
print v(xbgr.mr_n84734736)
print v(xbgr.mr_n84734848)
print v(xbgr.mr_n84735168)
print v(xbgr.mr_n84735280)
print v(xbgr.mr_n84735600)
print v(xbgr.mr_n84735712)
print v(xbgr.mr_n84736032)
print v(xbgr.mr_n84736144)
print v(xbgr.mr_n84736464)
print v(xbgr.mr_n84736576)
print v(xbgr.mr_n84736896)
print v(xbgr.mr_n84737008)
print v(xbgr.mr_n84737328)
print v(xbgr.mr_n84737440)
print v(xbgr.mr_n84737760)
print v(xbgr.mr_n84737872)
print v(xbgr.mr_n84738192)
print v(xbgr.mr_n84738304)
print v(xbgr.mr_n84738624)
print v(xbgr.mr_n84738736)
print v(xbgr.mr_n84739056)
print v(xbgr.mr_n84739168)
print v(xbgr.mr_n84739488)
print v(xbgr.mr_n84739600)
print v(xbgr.mr_n84739920)
print v(xbgr.mr_n84740032)
print v(xbgr.mr_n84740352)
print v(xbgr.mr_n84740464)
print v(xbgr.mr_n84740784)
print v(xbgr.mr_n84740896)
print v(xbgr.mr_n84741216)
print v(xbgr.mr_n84741328)
print v(xbgr.mr_n84741648)
print v(xbgr.mr_n84741760)
print v(xbgr.mr_n84742080)
print v(xbgr.mr_n84742192)
print v(xbgr.mr_n84742512)
print v(xbgr.mr_n84742624)
print v(xbgr.mr_n84742944)
print v(xbgr.mr_n84743056)
print v(xbgr.mr_n84743376)
print v(xbgr.mr_n84743488)
print v(xbgr.mr_n84743808)
print v(xbgr.mr_n84743920)
print v(xbgr.mr_n84744240)
print v(xbgr.mr_n84744352)
print v(xbgr.mr_n84744672)
print v(xbgr.mr_n84744784)
print v(xbgr.mr_n84745104)
print v(xbgr.mr_n84745216)
print v(xbgr.mr_n84745536)
print v(xbgr.mr_n84745648)
print v(xbgr.mr_n84745968)
print v(xbgr.mr_n84746080)
print v(xbgr.mr_n84746400)
print v(xbgr.mr_n84746512)
print v(xbgr.mr_n84746832)
print v(xbgr.mr_n84746944)
print v(xbgr.mr_n84747264)
print v(xbgr.mr_n84747376)
print v(xbgr.mr_n84747696)
print v(xbgr.mr_n84747808)
print v(xbgr.mr_n84748128)
print v(xbgr.mr_n84748240)
print v(xbgr.mr_n84748560)
print v(xbgr.mr_n84748672)
print v(xbgr.mr_n84748992)
print v(xbgr.mr_n84749104)
print v(xbgr.mr_n84749424)
print v(xbgr.mr_n84749536)
print v(xbgr.mr_n84749856)
print v(xbgr.mr_n84749968)
print v(xbgr.mr_n84750288)
print v(xbgr.mr_n84750400)
print v(xbgr.mr_n84750720)
print v(xbgr.mr_n84750832)
print v(xbgr.mr_n84751152)
print v(xbgr.mr_n84751264)
print v(xbgr.mr_n84751584)
print v(xbgr.mr_n84751696)
print v(xbgr.mr_n84752016)
print v(xbgr.mr_n84752128)
print v(xbgr.mr_n84752448)
print v(xbgr.mr_n84752560)
print v(xbgr.mr_n84752880)
print v(xbgr.mr_n84752992)
print v(xbgr.mr_n84753312)
print v(xbgr.mr_n84753424)
print v(xbgr.mr_n84753744)
print v(xbgr.mr_n84753856)
print v(xbgr.mr_n84754176)
print v(xbgr.mr_n84754288)
print v(xbgr.mr_n84754608)
print v(xbgr.mr_n84754720)
print v(xbgr.mr_n84755040)
print v(xbgr.mr_n84755152)
print v(xbgr.mr_n84755472)
print v(xbgr.mr_n84755584)
print v(xbgr.mr_n84755904)
print v(xbgr.mr_n84756016)
print v(xbgr.mr_n84756336)
print v(xbgr.mr_n84756448)
print v(xbgr.mr_n84756768)
print v(xbgr.mr_n84756880)
print v(xbgr.mr_n84757200)
print v(xbgr.mr_n84757312)
print v(xbgr.mr_n84757632)
print v(xbgr.mr_n84757744)
print v(xbgr.mr_n84758064)
print v(xbgr.mr_n84758176)
print v(xbgr.mr_n84758496)
print v(xbgr.mr_n84758608)
print v(xbgr.mr_n84758928)
print v(xbgr.mr_n84759040)
print v(xbgr.mr_n84759360)
print v(xbgr.mr_n84759472)
print v(xbgr.mr_n84759792)
print v(xbgr.mr_n84759904)
print v(xbgr.mr_n84760224)
print v(xbgr.mr_n84760336)
print v(xbgr.mr_n84760656)
print v(xbgr.mr_n84760768)
print v(xbgr.mr_n84761088)
print v(xbgr.mr_n84761200)
print v(xbgr.mr_n84761520)
print v(xbgr.mr_n84761632)
print v(xbgr.mr_n84761952)
print v(xbgr.mr_n84762064)
print v(xbgr.mr_n84762384)
print v(xbgr.mr_n84762496)
print v(xbgr.mr_n84762816)
print v(xbgr.mr_n84762928)
print v(xbgr.mr_n84763248)
print v(xbgr.mr_n84763360)
print v(xbgr.mr_n84763680)
print v(xbgr.mr_n84763792)
print v(xbgr.mr_n84764112)
print v(xbgr.mr_n84764224)
print v(xbgr.mr_n84764544)
print v(xbgr.mr_n84764656)
print v(xbgr.mr_n84764976)
print v(xbgr.mr_n84765088)
print v(xbgr.mr_n84765408)
print v(xbgr.mr_n84765520)
print v(xbgr.mr_n84765840)
print v(xbgr.mr_n84765952)
print v(xbgr.mr_n84766272)
print v(xbgr.mr_n84766384)
print v(xbgr.mr_n84766704)
print v(xbgr.mr_n84766816)
print v(xbgr.mr_n84767136)
print v(xbgr.mr_n84767248)
print v(xbgr.mr_n84767568)
print v(xbgr.mr_n84767680)
print v(xbgr.mr_n84768000)
print v(xbgr.mr_n84768112)
print v(xbgr.mr_n84768432)
print v(xbgr.mr_n84768544)
print v(xbgr.mr_n84768864)
print v(xbgr.mr_n84768976)
print v(xbgr.mr_n84769296)
print v(xbgr.mr_n84769408)
print v(xbgr.mr_n84769728)
print v(xbgr.mr_n84769840)
print v(xbgr.mr_n84770160)
print v(xbgr.mr_n84770272)
print v(xbgr.mr_n84770592)
print v(xbgr.mr_n84770704)
print v(xbgr.mr_n84771024)
print v(xbgr.mr_n84771136)
print v(xbgr.mr_n84771456)
print v(xbgr.mr_n84771568)
print v(xbgr.mr_n84771888)
print v(xbgr.mr_n84772000)
print v(xbgr.mr_n84772320)
print v(xbgr.mr_n84772432)
print v(xbgr.mr_n84772752)
print v(xbgr.mr_n84772864)
print v(xbgr.mr_n84773184)
print v(xbgr.mr_n84773296)
print v(xbgr.mr_n84773616)
print v(xbgr.mr_n84773728)
print v(xbgr.mr_n84774048)
print v(xbgr.mr_n84774160)
print v(xbgr.mr_n84774480)
print v(xbgr.mr_n84774592)
print v(xbgr.mr_n84774912)
print v(xbgr.mr_n84775024)
print v(xbgr.mr_n84775344)
print v(xbgr.mr_n84775456)
print v(xbgr.mr_n84775776)
print v(xbgr.mr_n84775888)
print v(xbgr.mr_n84776208)
print v(xbgr.mr_n84776320)
print v(xbgr.mr_n84776640)
print v(xbgr.mr_n84776752)
print v(xbgr.mr_n84777072)
print v(xbgr.mr_n84777184)
print v(xbgr.mr_n84777504)
print v(xbgr.mr_n84777616)
print v(xbgr.mr_n84777936)
print v(xbgr.mr_n84778048)
print v(xbgr.mr_n84778368)
print v(xbgr.mr_n84778480)
print v(xbgr.mr_n84778800)
print v(xbgr.mr_n84778912)
print v(xbgr.mr_n84779232)
print v(xbgr.mr_n84779344)
print v(xbgr.mr_n84779664)
print v(xbgr.mr_n84779776)
print v(xbgr.mr_n84780096)
print v(xbgr.mr_n84780208)
print v(xbgr.mr_n84780528)
print v(xbgr.mr_n84780640)
print v(xbgr.mr_n84780960)
print v(xbgr.mr_n84781072)
print v(xbgr.mr_n84781392)
print v(xbgr.mr_n84781504)
print v(xbgr.mr_n84781824)
print v(xbgr.mr_n84781936)
print v(xbgr.mr_n84782256)
print v(xbgr.mr_n84782368)
print v(xbgr.mr_n84782688)
print v(xbgr.mr_n84782800)
print v(xbgr.mr_n84783120)
print v(xbgr.mr_n84783232)
print v(xbgr.mr_n84783552)
print v(xbgr.mr_n84783664)
print v(xbgr.mr_n84783984)
print v(xbgr.mr_n84784096)
print v(xbgr.mr_n84784416)
print v(xbgr.mr_n84784528)
print v(xbgr.mr_n84784848)
print v(xbgr.mr_n84784960)
print v(xbgr.mr_n84785280)
print v(xbgr.mr_n84785392)
print v(xbgr.mr_n84785712)
print v(xbgr.mr_n84785824)
print v(xbgr.mr_n84786144)
print v(xbgr.mr_n84786256)
print v(xbgr.mr_n84786576)
print v(xbgr.mr_n84786688)
print v(xbgr.mr_n84787008)
print v(xbgr.mr_n84787120)
print v(xbgr.mr_n84787440)
print v(xbgr.mr_n84787552)
print v(xbgr.mr_n84787872)
print v(xbgr.mr_n84787984)
print v(xbgr.mr_n84788304)
print v(xbgr.mr_n84788416)
print v(xbgr.mr_n84788736)
print v(xbgr.mr_n84788848)
print v(xbgr.mr_n84789168)
print v(xbgr.mr_n84789280)
print v(xbgr.mr_n84789600)
print v(xbgr.mr_n84789712)
print v(xbgr.mr_n84790032)
print v(xbgr.mr_n84790144)
print v(xbgr.mr_n84790464)
print v(xbgr.mr_n84790576)
print v(xbgr.mr_n84790896)
print v(xbgr.mr_n84791008)
print v(xbgr.mr_n84791328)
print v(xbgr.mr_n84791440)
print v(xbgr.mr_n84791760)
print v(xbgr.mr_n84791872)
print v(xbgr.mr_n84792192)
print v(xbgr.mr_n84792304)
print v(xbgr.mr_n84792624)
print v(xbgr.mr_n84792736)
print v(xbgr.mr_n84793056)
print v(xbgr.mr_n84793168)
print v(xbgr.mr_n84793488)
print v(xbgr.mr_n84793600)
print v(xbgr.mr_n84793904)
print v(xbgr.mr_n84794016)
print v(xbgr.mr_n84794336)
print v(xbgr.mr_n84794448)
print v(xbgr.mr_n84794768)
print v(xbgr.mr_n84794880)
print v(xbgr.mr_n84795200)
print v(xbgr.mr_n84795312)
print v(xbgr.mr_n84795632)
print v(xbgr.mr_n84795744)
print v(xbgr.mr_n84796064)
print v(xbgr.mr_n84796176)
print v(xbgr.mr_n84796496)
print v(xbgr.mr_n84796608)
print v(xbgr.mr_n84796928)
print v(xbgr.mr_n84797040)
print v(xbgr.mr_n84797360)
print v(xbgr.mr_n84797472)
print v(xbgr.mr_n84797792)
print v(xbgr.mr_n84797904)
print v(xbgr.mr_n84798224)
print v(xbgr.mr_n84798336)
print v(xbgr.mr_n84798656)
print v(xbgr.mr_n84798768)
print v(xbgr.mr_n84799088)
print v(xbgr.mr_n84799200)
print v(xbgr.mr_n84799520)
print v(xbgr.mr_n84799632)
print v(xbgr.mr_n84799952)
print v(xbgr.mr_n84800064)
print v(xbgr.mr_n84800384)
print v(xbgr.mr_n84800496)
print v(xbgr.mr_n84800816)
print v(xbgr.mr_n84800928)
print v(xbgr.mr_n84801248)
print v(xbgr.mr_n84801360)
print v(xbgr.mr_n84801680)
print v(xbgr.mr_n84801792)
print v(xbgr.mr_n84802112)
print v(xbgr.mr_n84802224)
print v(xbgr.mr_n84802544)
print v(xbgr.mr_n84802656)
print v(xbgr.mr_n84802976)
print v(xbgr.mr_n84803088)
print v(xbgr.mr_n84803408)
print v(xbgr.mr_n84803520)
print v(xbgr.mr_n84803840)
print v(xbgr.mr_n84803952)
print v(xbgr.mr_n84804272)
print v(xbgr.mr_n84804384)
print v(xbgr.mr_n84804704)
print v(xbgr.mr_n84804816)
print v(xbgr.mr_n84805136)
print v(xbgr.mr_n84805248)
print v(xbgr.mr_n84805568)
print v(xbgr.mr_n84805680)
print v(xbgr.mr_n84806000)
print v(xbgr.mr_n84806112)
print v(xbgr.mr_n84806432)
print v(xbgr.mr_n84806544)
print v(xbgr.mr_n84806864)
print v(xbgr.mr_n84806976)
print v(xbgr.mr_n84807296)
print v(xbgr.mr_n84807408)
print v(xbgr.mr_n84807728)
print v(xbgr.mr_n84807840)
print v(xbgr.mr_n84808160)
print v(xbgr.mr_n84808272)
print v(xbgr.mr_n84808592)
print v(xbgr.mr_n84808704)
print v(xbgr.mr_n84809024)
print v(xbgr.mr_n84809136)
print v(xbgr.mr_n84809456)
print v(xbgr.mr_n84809568)
print v(xbgr.mr_n84809888)
print v(xbgr.mr_n84810000)
print v(xbgr.mr_n84810320)
print v(xbgr.mr_n84810432)
print v(xbgr.mr_n84810752)
print v(xbgr.mr_n84810864)
print v(xbgr.mr_n84811184)
print v(xbgr.mr_n84811296)
print v(xbgr.mr_n84811616)
print v(xbgr.mr_n84811728)
print v(xbgr.mr_n84812048)
print v(xbgr.mr_n84812160)
print v(xbgr.mr_n84812480)
print v(xbgr.mr_n84812592)
print v(xbgr.mr_n84812912)
print v(xbgr.mr_n84813024)
print v(xbgr.mr_n84813344)
print v(xbgr.mr_n84813456)
print v(xbgr.mr_n84813776)
print v(xbgr.mr_n84813888)
print v(xbgr.mr_n84814208)
print v(xbgr.mr_n84814320)
print v(xbgr.mr_n84814640)
print v(xbgr.mr_n84814752)
print v(xbgr.mr_n84815072)
print v(xbgr.mr_n84815184)
print v(xbgr.mr_n84815504)
print v(xbgr.mr_n84815616)
print v(xbgr.mr_n84815936)
print v(xbgr.mr_n84816048)
print v(xbgr.mr_n84816368)
print v(xbgr.mr_n84816480)
print v(xbgr.mr_n84816800)
print v(xbgr.mr_n84816912)
print v(xbgr.mr_n84817232)
print v(xbgr.mr_n84817344)
print v(xbgr.mr_n84817664)
print v(xbgr.mr_n84817776)
print v(xbgr.mr_n84818096)
print v(xbgr.mr_n84818208)
print v(xbgr.mr_n84818528)
print v(xbgr.mr_n84818640)
print v(xbgr.mr_n84818960)
print v(xbgr.mr_n84819072)
print v(xbgr.mr_n84819392)
print v(xbgr.mr_n84819504)
print v(xbgr.mr_n84819824)
print v(xbgr.mr_n84819936)
print v(xbgr.mr_n84820256)
print v(xbgr.mr_n84820368)
print v(xbgr.mr_n84820688)
print v(xbgr.mr_n84820800)
print v(xbgr.mr_n84821120)
print v(xbgr.mr_n84821232)
print v(xbgr.mr_n84821552)
print v(xbgr.mr_n84821664)
print v(xbgr.mr_n84821984)
print v(xbgr.mr_n84822096)
print v(xbgr.mr_n84822416)
print v(xbgr.mr_n84822528)
print v(xbgr.mr_n84822848)
print v(xbgr.mr_n84822960)
print v(xbgr.mr_n84823280)
print v(xbgr.mr_n84823392)
print v(xbgr.mr_n84823712)
print v(xbgr.mr_n84823824)
print v(xbgr.mr_n84824144)
print v(xbgr.mr_n84824256)
print v(xbgr.mr_n84824576)
print v(xbgr.mr_n84824688)
print v(xbgr.mr_n84825008)
print v(xbgr.mr_n84825120)
print v(xbgr.mr_n84825440)
print v(xbgr.mr_n84825552)
print v(xbgr.mr_n84825872)
print v(xbgr.mr_n84825984)
print v(xbgr.mr_n84826304)
print v(xbgr.mr_n84826416)
print v(xbgr.mr_n84826736)
print v(xbgr.mr_n84826848)
print v(xbgr.mr_n84827168)
print v(xbgr.mr_n84827280)
print v(xbgr.mr_n84827600)
print v(xbgr.mr_n84827712)
print v(xbgr.mr_n84828032)
print v(xbgr.mr_n84828144)
print v(xbgr.mr_n84828464)
print v(xbgr.mr_n84828576)
print v(xbgr.mr_n84828896)
print v(xbgr.mr_n84829008)
print v(xbgr.mr_n84829328)
print v(xbgr.mr_n84829440)
print v(xbgr.mr_n84829760)
print v(xbgr.mr_n84829872)
print v(xbgr.mr_n84830192)
print v(xbgr.mr_n84830304)
print v(xbgr.mr_n84830624)
print v(xbgr.mr_n84830736)
print v(xbgr.mr_n84831056)
print v(xbgr.mr_n84831168)
print v(xbgr.mr_n84831488)
print v(xbgr.mr_n84831600)
print v(xbgr.mr_n84831920)
print v(xbgr.mr_n84832032)
print v(xbgr.mr_n84832352)
print v(xbgr.mr_n84832464)
print v(xbgr.mr_n84832784)
print v(xbgr.mr_n84832896)
print v(xbgr.mr_n84833216)
print v(xbgr.mr_n84833328)
print v(xbgr.mr_n84833648)
print v(xbgr.mr_n84833760)
print v(xbgr.mr_n84834080)
print v(xbgr.mr_n84834192)
print v(xbgr.mr_n84834512)
print v(xbgr.mr_n84834624)
print v(xbgr.mr_n84834944)
print v(xbgr.mr_n84835056)
print v(xbgr.mr_n84835376)
print v(xbgr.mr_n84835488)
print v(xbgr.mr_n84835808)
print v(xbgr.mr_n84835920)
print v(xbgr.mr_n84836240)
print v(xbgr.mr_n84836352)
print v(xbgr.mr_n84836672)
print v(xbgr.mr_n84836784)
print v(xbgr.mr_n84837104)
print v(xbgr.mr_n84837216)
print v(xbgr.mr_n84837536)
print v(xbgr.mr_n84837648)
print v(xbgr.mr_n84837968)
print v(xbgr.mr_n84838080)
print v(xbgr.mr_n84838400)
print v(xbgr.mr_n84838512)
print v(xbgr.mr_n84838832)
print v(xbgr.mr_n84838944)
print v(xbgr.mr_n84839264)
print v(xbgr.mr_n84839376)
print v(xbgr.mr_n84839696)
print v(xbgr.mr_n84839808)
print v(xbgr.mr_n84840128)
print v(xbgr.mr_n84840240)
print v(xbgr.mr_n84840560)
print v(xbgr.mr_n84840672)
print v(xbgr.mr_n84840992)
print v(xbgr.mr_n84841104)
print v(xbgr.mr_n84841424)
print v(xbgr.mr_n84841536)
print v(xbgr.mr_n84841856)
print v(xbgr.mr_n84841968)
print v(xbgr.mr_n84842288)
print v(xbgr.mr_n84842400)
print v(xbgr.mr_n84842720)
print v(xbgr.mr_n84842832)
print v(xbgr.mr_n84843152)
print v(xbgr.mr_n84843264)
print v(xbgr.mr_n84843584)
print v(xbgr.mr_n84843696)
print v(xbgr.mr_n84844016)
print v(xbgr.mr_n84844128)
print v(xbgr.mr_n84844448)
print v(xbgr.mr_n84844560)
print v(xbgr.mr_n84844880)
print v(xbgr.mr_n84844992)
print v(xbgr.mr_n84845312)
print v(xbgr.mr_n84845424)
print v(xbgr.mr_n84845744)
print v(xbgr.mr_n84845856)
print v(xbgr.mr_n84846176)
print v(xbgr.mr_n84846288)
print v(xbgr.mr_n84846608)
print v(xbgr.mr_n84846720)
print v(xbgr.mr_n84847040)
print v(xbgr.mr_n84847152)
print v(xbgr.mr_n84847472)
print v(xbgr.mr_n84847584)
print v(xbgr.mr_n84847904)
print v(xbgr.mr_n84848016)
print v(xbgr.mr_n84848336)
print v(xbgr.mr_n84848448)
print v(xbgr.mr_n84848768)
print v(xbgr.mr_n84848880)
print v(xbgr.mr_n84849200)
print v(xbgr.mr_n84849312)
print v(xbgr.mr_n84849632)
print v(xbgr.mr_n84849744)
print v(xbgr.mr_n84850064)
print v(xbgr.mr_n84850176)
print v(xbgr.mr_n84850496)
print v(xbgr.mr_n84850608)
print v(xbgr.mr_n84850928)
print v(xbgr.mr_n84851040)
print v(xbgr.mr_n84851360)
print v(xbgr.mr_n84851472)
print v(xbgr.mr_n84851792)
print v(xbgr.mr_n84851904)
print v(xbgr.mr_n84852224)
print v(xbgr.mr_n84852336)
print v(xbgr.mr_n84852656)
print v(xbgr.mr_n84852768)
print v(xbgr.mr_n84853088)
print v(xbgr.mr_n84853200)
print v(xbgr.mr_n84853520)
print v(xbgr.mr_n84853632)
print v(xbgr.mr_n84853952)
print v(xbgr.mr_n84854064)
print v(xbgr.mr_n84854384)
print v(xbgr.mr_n84854496)
print v(xbgr.mr_n84854816)
print v(xbgr.mr_n84854928)
print v(xbgr.mr_n84855248)
print v(xbgr.mr_n84855360)
print v(xbgr.mr_n84855680)
print v(xbgr.mr_n84855792)
print v(xbgr.mr_n84856112)
print v(xbgr.mr_n84856224)
print v(xbgr.mr_n84856544)
print v(xbgr.mr_n84856656)
print v(xbgr.mr_n84856976)
print v(xbgr.mr_n84857088)
print v(xbgr.mr_n84857408)
print v(xbgr.mr_n84857520)
print v(xbgr.mr_n84857840)
print v(xbgr.mr_n84857952)
print v(xbgr.mr_n84858272)
print v(xbgr.mr_n84858384)
print v(xbgr.mr_n84858704)
print v(xbgr.mr_n84858816)
print v(xbgr.mr_n84859136)
print v(xbgr.mr_n84859248)
print v(xbgr.mr_n84859568)
print v(xbgr.mr_n84859680)
print v(xbgr.mr_n84860000)
print v(xbgr.mr_n84860112)
print v(xbgr.mr_n84860432)
print v(xbgr.mr_n84860544)
print v(xbgr.mr_n84860864)
print v(xbgr.mr_n84860976)
print v(xbgr.mr_n84861296)
print v(xbgr.mr_n84861408)
print v(xbgr.mr_n84861728)
print v(xbgr.mr_n84861840)
print v(xbgr.mr_n84862160)
print v(xbgr.mr_n84862272)
print v(xbgr.mr_n84862592)
print v(xbgr.mr_n84862704)
print v(xbgr.mr_n84863024)
print v(xbgr.mr_n84863136)
print v(xbgr.mr_n84863456)
print v(xbgr.mr_n84863568)
print v(xbgr.mr_n84863888)
print v(xbgr.mr_n84864000)
print v(xbgr.mr_n84864320)
print v(xbgr.mr_n84864432)
print v(xbgr.mr_n84864752)
print v(xbgr.mr_n84864864)
print v(xbgr.mr_n84865184)
print v(xbgr.mr_n84865296)
print v(xbgr.mr_n84865616)
print v(xbgr.mr_n84865728)
print v(xbgr.mr_n84866048)
print v(xbgr.mr_n84866160)
print v(xbgr.mr_n84866480)
print v(xbgr.mr_n84866592)
print v(xbgr.mr_n84866912)
print v(xbgr.mr_n84867024)
print v(xbgr.mr_n84867344)
print v(xbgr.mr_n84867456)
print v(xbgr.mr_n84867776)
print v(xbgr.mr_n84867888)
print v(xbgr.mr_n84868208)
print v(xbgr.mr_n84868320)
print v(xbgr.mr_n84868640)
print v(xbgr.mr_n84868752)
print v(xbgr.mr_n84869072)
print v(xbgr.mr_n84869184)
print v(xbgr.mr_n84869504)
print v(xbgr.mr_n84869616)
print v(xbgr.mr_n84869936)
print v(xbgr.mr_n84870048)
print v(xbgr.mr_n84870368)
print v(xbgr.mr_n84870480)
print v(xbgr.mr_n84870800)
print v(xbgr.mr_n84870912)
print v(xbgr.mr_n84871232)
print v(xbgr.mr_n84871344)
print v(xbgr.mr_n84871664)
print v(xbgr.mr_n84871776)
print v(xbgr.mr_n84872096)
print v(xbgr.mr_n84872208)
print v(xbgr.mr_n84872528)
print v(xbgr.mr_n84872640)
print v(xbgr.mr_n84872960)
print v(xbgr.mr_n84873072)
print v(xbgr.mr_n84873392)
print v(xbgr.mr_n84873504)
print v(xbgr.mr_n84873824)
print v(xbgr.mr_n84873936)
print v(xbgr.mr_n84874256)
print v(xbgr.mr_n84874368)
print v(xbgr.mr_n84874688)
print v(xbgr.mr_n84874800)
print v(xbgr.mr_n84875120)
print v(xbgr.mr_n84875232)
print v(xbgr.mr_n84875552)
print v(xbgr.mr_n84875664)
print v(xbgr.mr_n84875984)
print v(xbgr.mr_n84876096)
print v(xbgr.mr_n84876416)
print v(xbgr.mr_n84876528)
print v(xbgr.mr_n84876848)
print v(xbgr.mr_n84876960)
print v(xbgr.mr_n84877280)
print v(xbgr.mr_n84877392)
print v(xbgr.mr_n84877712)
print v(xbgr.mr_n84877824)
print v(xbgr.mr_n84878144)
print v(xbgr.mr_n84878256)
print v(xbgr.mr_n84878576)
print v(xbgr.mr_n84878688)
print v(xbgr.mr_n84879008)
print v(xbgr.mr_n84879120)
print v(xbgr.mr_n84879440)
print v(xbgr.mr_n84879552)
print v(xbgr.mr_n84879872)
print v(xbgr.mr_n84879984)
print v(xbgr.mr_n84880304)
print v(xbgr.mr_n84880416)
print v(xbgr.mr_n84880736)
print v(xbgr.mr_n84880848)
print v(xbgr.mr_n84881168)
print v(xbgr.mr_n84881280)
print v(xbgr.mr_n84881600)
print v(xbgr.mr_n84881712)
print v(xbgr.mr_n84882032)
print v(xbgr.mr_n84882144)
print v(xbgr.mr_n84882464)
print v(xbgr.mr_n84882576)
print v(xbgr.mr_n84882896)
print v(xbgr.mr_n84883008)
print v(xbgr.mr_n84883328)
print v(xbgr.mr_n84883440)
print v(xbgr.mr_n84883760)
print v(xbgr.mr_n84883872)
print v(xbgr.mr_n84884192)
print v(xbgr.mr_n84884304)
print v(xbgr.mr_n84884624)
print v(xbgr.mr_n84884736)
print v(xbgr.mr_n84885056)
print v(xbgr.mr_n84885168)
print v(xbgr.mr_n84885488)
print v(xbgr.mr_n84885600)
print v(xbgr.mr_n84885920)
print v(xbgr.mr_n84886032)
print v(xbgr.mr_n84886352)
print v(xbgr.mr_n84886464)
print v(xbgr.mr_n84886784)
print v(xbgr.mr_n84886896)
print v(xbgr.mr_n84887216)
print v(xbgr.mr_n84887328)
print v(xbgr.mr_n84887648)
print v(xbgr.mr_n84887760)
print v(xbgr.mr_n84888080)
print v(xbgr.mr_n84888192)
print v(xbgr.mr_n84888512)
print v(xbgr.mr_n84888624)
print v(xbgr.mr_n84888944)
print v(xbgr.mr_n84889056)
print v(xbgr.mr_n84889376)
print v(xbgr.mr_n84889488)
print v(xbgr.mr_n84889808)
print v(xbgr.mr_n84889920)
print v(xbgr.mr_n84890240)
print v(xbgr.mr_n84890352)
print v(xbgr.mr_n84890672)
print v(xbgr.mr_n84890784)
print v(xbgr.mr_n84891104)
print v(xbgr.mr_n84891216)
print v(xbgr.mr_n84891536)
print v(xbgr.mr_n84891648)
print v(xbgr.mr_n84891968)
print v(xbgr.mr_n84892080)
print v(xbgr.mr_n84892400)
print v(xbgr.mr_n84892512)
print v(xbgr.mr_n84892832)
print v(xbgr.mr_n84892944)
print v(xbgr.mr_n84893264)
print v(xbgr.mr_n84893376)
print v(xbgr.mr_n84893696)
print v(xbgr.mr_n84893808)
print v(xbgr.mr_n84894128)
print v(xbgr.mr_n84894240)
print v(xbgr.mr_n84894560)
print v(xbgr.mr_n84894672)
print v(xbgr.mr_n84894992)
print v(xbgr.mr_n84895104)
print v(xbgr.mr_n84895424)
print v(xbgr.mr_n84895536)
print v(xbgr.mr_n84895856)
print v(xbgr.mr_n84895968)
print v(xbgr.mr_n84896288)
print v(xbgr.mr_n84896400)
print v(xbgr.mr_n84896720)
print v(xbgr.mr_n84896832)
print v(xbgr.mr_n84897152)
print v(xbgr.mr_n84897264)
print v(xbgr.mr_n84897584)
print v(xbgr.mr_n84897696)
print v(xbgr.mr_n84898016)
print v(xbgr.mr_n84898128)
print v(xbgr.mr_n84898448)
print v(xbgr.mr_n84898560)
print v(xbgr.mr_n84898880)
print v(xbgr.mr_n84898992)
print v(xbgr.mr_n84899312)
print v(xbgr.mr_n84899424)
print v(xbgr.mr_n84899744)
print v(xbgr.mr_n84899856)
print v(xbgr.mr_n84900176)
print v(xbgr.mr_n84900288)
print v(xbgr.mr_n84900608)
print v(xbgr.mr_n84900720)
print v(xbgr.mr_n84901040)
print v(xbgr.mr_n84901152)
print v(xbgr.mr_n84901472)
print v(xbgr.mr_n84901584)
print v(xbgr.mr_n84901904)
print v(xbgr.mr_n84902016)
print v(xbgr.mr_n84902336)
print v(xbgr.mr_n84902448)
print v(xbgr.mr_n84902768)
print v(xbgr.mr_n84902880)
print v(xbgr.mr_n84903200)
print v(xbgr.mr_n84903312)
print v(xbgr.mr_n84903632)
print v(xbgr.mr_n84903744)
print v(xbgr.mr_n84904064)
print v(xbgr.mr_n84904176)
print v(xbgr.mr_n84904496)
print v(xbgr.mr_n84904608)
print v(xbgr.mr_n84904928)
print v(xbgr.mr_n84905040)
print v(xbgr.mr_n84905360)
print v(xbgr.mr_n84905472)
print v(xbgr.mr_n84905792)
print v(xbgr.mr_n84905904)
print v(xbgr.mr_n84906224)
print v(xbgr.mr_n84906336)
print v(xbgr.mr_n84906656)
print v(xbgr.mr_n84906768)
print v(xbgr.mr_n84907088)
print v(xbgr.mr_n84907200)
print v(xbgr.mr_n84907520)
print v(xbgr.mr_n84907632)
print v(xbgr.mr_n84907952)
print v(xbgr.mr_n84908064)
print v(xbgr.mr_n84908384)
print v(xbgr.mr_n84908496)
print v(xbgr.mr_n84908816)
print v(xbgr.mr_n84908928)
print v(xbgr.mr_n84909248)
print v(xbgr.mr_n84909360)
print v(xbgr.mr_n84909680)
print v(xbgr.mr_n84909792)
print v(xbgr.mr_n84910112)
print v(xbgr.mr_n84910224)
print v(xbgr.mr_n84910544)
print v(xbgr.mr_n84910656)
print v(xbgr.mr_n84910976)
print v(xbgr.mr_n84911088)
print v(xbgr.mr_n84911408)
print v(xbgr.mr_n84911520)
print v(xbgr.mr_n84911840)
print v(xbgr.mr_n84911952)
print v(xbgr.mr_n84912272)
print v(xbgr.mr_n84912384)
print v(xbgr.mr_n84912704)
print v(xbgr.mr_n84912816)
print v(xbgr.mr_n84913136)
print v(xbgr.mr_n84913248)
print v(xbgr.mr_n84913568)
print v(xbgr.mr_n84913680)
print v(xbgr.mr_n84914000)
print v(xbgr.mr_n84914112)
print v(xbgr.mr_n84914432)
print v(xbgr.mr_n84914544)
print v(xbgr.mr_n84914864)
print v(xbgr.mr_n84914976)
print v(xbgr.mr_n84915296)
print v(xbgr.mr_n84915408)
print v(xbgr.mr_n84915728)
print v(xbgr.mr_n84915840)
print v(xbgr.mr_n84916160)
print v(xbgr.mr_n84916272)
print v(xbgr.mr_n84916592)
print v(xbgr.mr_n84916704)
print v(xbgr.mr_n84917024)
print v(xbgr.mr_n84917136)
print v(xbgr.mr_n84917456)
print v(xbgr.mr_n84917568)
print v(xbgr.mr_n84917888)
print v(xbgr.mr_n84918000)
print v(xbgr.mr_n84918320)
print v(xbgr.mr_n84918432)
print v(xbgr.mr_n84918752)
print v(xbgr.mr_n84918864)
print v(xbgr.mr_n84919184)
print v(xbgr.mr_n84919296)
print v(xbgr.mr_n84919616)
print v(xbgr.mr_n84919728)
print v(xbgr.mr_n84920048)
print v(xbgr.mr_n84920160)
print v(xbgr.mr_n84920480)
print v(xbgr.mr_n84920592)
print v(xbgr.mr_n84920912)
print v(xbgr.mr_n84921024)
print v(xbgr.mr_n84921344)
print v(xbgr.mr_n84921456)
print v(xbgr.mr_n84921776)
print v(xbgr.mr_n84921888)
print v(xbgr.mr_n84922208)
print v(xbgr.mr_n84922320)
print v(xbgr.mr_n84922640)
print v(xbgr.mr_n84922752)
print v(xbgr.mr_n84923072)
print v(xbgr.mr_n84923184)
print v(xbgr.mr_n84923504)
print v(xbgr.mr_n84923616)
print v(xbgr.mr_n84923936)
print v(xbgr.mr_n84924048)
print v(xbgr.mr_n84924368)
print v(xbgr.mr_n84924480)
print v(xbgr.mr_n84924800)
print v(xbgr.mr_n84924912)
print v(xbgr.mr_n84925232)
print v(xbgr.mr_n84925344)
print v(xbgr.mr_n84925664)
print v(xbgr.mr_n84925776)
print v(xbgr.mr_n84926096)
print v(xbgr.mr_n84926208)
print v(xbgr.mr_n84926528)
print v(xbgr.mr_n84926640)
print v(xbgr.mr_n84926960)
print v(xbgr.mr_n84927072)
print v(xbgr.mr_n84927392)
print v(xbgr.mr_n84927504)
print v(xbgr.mr_n84927824)
print v(xbgr.mr_n84927936)
print v(xbgr.mr_n84928256)
print v(xbgr.mr_n84928368)
print v(xbgr.mr_n84928688)
print v(xbgr.mr_n84928800)
print v(xbgr.mr_n84929120)
print v(xbgr.mr_n84929232)
print v(xbgr.mr_n84929552)
print v(xbgr.mr_n84929664)
print v(xbgr.mr_n84929984)
print v(xbgr.mr_n84930096)
print v(xbgr.mr_n84930416)
print v(xbgr.mr_n84930528)
print v(xbgr.mr_n84930848)
print v(xbgr.mr_n84930960)
print v(xbgr.mr_n84931280)
print v(xbgr.mr_n84931392)
print v(xbgr.mr_n84931712)
print v(xbgr.mr_n84931824)
print v(xbgr.mr_n84932144)
print v(xbgr.mr_n84932256)
print v(xbgr.mr_n84932576)
print v(xbgr.mr_n84932688)
print v(xbgr.mr_n84933008)
print v(xbgr.mr_n84933120)
print v(xbgr.mr_n84933440)
print v(xbgr.mr_n84933552)
print v(xbgr.mr_n84933872)
print v(xbgr.mr_n84933984)
print v(xbgr.mr_n84934304)
print v(xbgr.mr_n84934416)
print v(xbgr.mr_n84934736)
print v(xbgr.mr_n84934848)
print v(xbgr.mr_n84935168)
print v(xbgr.mr_n84935280)
print v(xbgr.mr_n84935600)
print v(xbgr.mr_n84935712)
print v(xbgr.mr_n84936032)
print v(xbgr.mr_n84936144)
print v(xbgr.mr_n84936464)
print v(xbgr.mr_n84936576)
print v(xbgr.mr_n84936896)
print v(xbgr.mr_n84937008)
print v(xbgr.mr_n84937328)
print v(xbgr.mr_n84937440)
print v(xbgr.mr_n84937760)
print v(xbgr.mr_n84937872)
print v(xbgr.mr_n84938192)
print v(xbgr.mr_n84938304)
print v(xbgr.mr_n84938624)
print v(xbgr.mr_n84938736)
print v(xbgr.mr_n84939056)
print v(xbgr.mr_n84939168)
print v(xbgr.mr_n84939488)
print v(xbgr.mr_n84939600)
print v(xbgr.mr_n84939920)
print v(xbgr.mr_n84940032)
print v(xbgr.mr_n84940352)
print v(xbgr.mr_n84940464)
print v(xbgr.mr_n84940784)
print v(xbgr.mr_n84940896)
print v(xbgr.mr_n84941216)
print v(xbgr.mr_n84941328)
print v(xbgr.mr_n84941648)
print v(xbgr.mr_n84941760)
print v(xbgr.mr_n84942080)
print v(xbgr.mr_n84942192)
print v(xbgr.mr_n84942512)
print v(xbgr.mr_n84942624)
print v(xbgr.mr_n84942944)
print v(xbgr.mr_n84943056)
print v(xbgr.mr_n84943376)
print v(xbgr.mr_n84943488)
print v(xbgr.mr_n84943808)
print v(xbgr.mr_n84943920)
print v(xbgr.mr_n84944240)
print v(xbgr.mr_n84944352)
print v(xbgr.mr_n84944672)
print v(xbgr.mr_n84944784)
print v(xbgr.mr_n84945104)
print v(xbgr.mr_n84945216)
print v(xbgr.mr_n84945536)
print v(xbgr.mr_n84945648)
print v(xbgr.mr_n84945968)
print v(xbgr.mr_n84946080)
print v(xbgr.mr_n84946400)
print v(xbgr.mr_n84946512)
print v(xbgr.mr_n84946832)
print v(xbgr.mr_n84946944)
print v(xbgr.mr_n84947264)
print v(xbgr.mr_n84947376)
print v(xbgr.mr_n84947696)
print v(xbgr.mr_n84947808)
print v(xbgr.mr_n84948128)
print v(xbgr.mr_n84948240)
print v(xbgr.mr_n84948560)
print v(xbgr.mr_n84948672)
print v(xbgr.mr_n84948992)
print v(xbgr.mr_n84949104)
print v(xbgr.mr_n84949424)
print v(xbgr.mr_n84949536)
print v(xbgr.mr_n84949856)
print v(xbgr.mr_n84949968)
print v(xbgr.mr_n84950288)
print v(xbgr.mr_n84950400)
print v(xbgr.mr_n84950720)
print v(xbgr.mr_n84950832)
print v(xbgr.mr_n84951152)
print v(xbgr.mr_n84951264)
print v(xbgr.mr_n84951584)
print v(xbgr.mr_n84951696)
print v(xbgr.mr_n84952016)
print v(xbgr.mr_n84952128)
print v(xbgr.mr_n84952448)
print v(xbgr.mr_n84952560)
print v(xbgr.mr_n84952880)
print v(xbgr.mr_n84952992)
print v(xbgr.mr_n84953312)
print v(xbgr.mr_n84953424)
print v(xbgr.mr_n84953744)
print v(xbgr.mr_n84953856)
print v(xbgr.mr_n84954176)
print v(xbgr.mr_n84954288)
print v(xbgr.mr_n84954608)
print v(xbgr.mr_n84954720)
print v(xbgr.mr_n84955040)
print v(xbgr.mr_n84955152)
print v(xbgr.mr_n84955472)
print v(xbgr.mr_n84955584)
print v(xbgr.mr_n84955904)
print v(xbgr.mr_n84956016)
print v(xbgr.mr_n84956336)
print v(xbgr.mr_n84956448)
print v(xbgr.mr_n84956768)
print v(xbgr.mr_n84956880)
print v(xbgr.mr_n84957200)
print v(xbgr.mr_n84957312)
print v(xbgr.mr_n84957632)
print v(xbgr.mr_n84957744)
print v(xbgr.mr_n84958064)
print v(xbgr.mr_n84958176)
print v(xbgr.mr_n84958496)
print v(xbgr.mr_n84958608)
print v(xbgr.mr_n84958928)
print v(xbgr.mr_n84959040)
print v(xbgr.mr_n84959360)
print v(xbgr.mr_n84959472)
print v(xbgr.mr_n84959792)
print v(xbgr.mr_n84959904)
print v(xbgr.mr_n84960224)
print v(xbgr.mr_n84960336)
print v(xbgr.mr_n84960656)
print v(xbgr.mr_n84960768)
print v(xbgr.mr_n84961088)
print v(xbgr.mr_n84961200)
print v(xbgr.mr_n84961520)
print v(xbgr.mr_n84961632)
print v(xbgr.mr_n84961952)
print v(xbgr.mr_n84962064)
print v(xbgr.mr_n84962384)
print v(xbgr.mr_n84962496)
print v(xbgr.mr_n84962816)
print v(xbgr.mr_n84962928)
print v(xbgr.mr_n84963248)
print v(xbgr.mr_n84963360)
print v(xbgr.mr_n84963680)
print v(xbgr.mr_n84963792)
print v(xbgr.mr_n84964112)
print v(xbgr.mr_n84964224)
print v(xbgr.mr_n84964544)
print v(xbgr.mr_n84964656)
print v(xbgr.mr_n84964976)
print v(xbgr.mr_n84965088)
print v(xbgr.mr_n84965408)
print v(xbgr.mr_n84965520)
print v(xbgr.mr_n84965840)
print v(xbgr.mr_n84965952)
print v(xbgr.mr_n84966272)
print v(xbgr.mr_n84966384)
print v(xbgr.mr_n84966704)
print v(xbgr.mr_n84966816)
print v(xbgr.mr_n84967136)
print v(xbgr.mr_n84967248)
print v(xbgr.mr_n84967568)
print v(xbgr.mr_n84967680)
print v(xbgr.mr_n84968000)
print v(xbgr.mr_n84968112)
print v(xbgr.mr_n84968432)
print v(xbgr.mr_n84968544)
print v(xbgr.mr_n84968864)
print v(xbgr.mr_n84968976)
print v(xbgr.mr_n84969296)
print v(xbgr.mr_n84969408)
print v(xbgr.mr_n84969728)
print v(xbgr.mr_n84969840)
print v(xbgr.mr_n84970160)
print v(xbgr.mr_n84970272)
print v(xbgr.mr_n84970592)
print v(xbgr.mr_n84970704)
print v(xbgr.mr_n84971024)
print v(xbgr.mr_n84971136)
print v(xbgr.mr_n84971456)
print v(xbgr.mr_n84971568)
print v(xbgr.mr_n84971888)
print v(xbgr.mr_n84972000)
print v(xbgr.mr_n84972320)
print v(xbgr.mr_n84972432)
print v(xbgr.mr_n84972752)
print v(xbgr.mr_n84972864)
print v(xbgr.mr_n84973184)
print v(xbgr.mr_n84973296)
print v(xbgr.mr_n84973616)
print v(xbgr.mr_n84973728)
print v(xbgr.mr_n84974048)
print v(xbgr.mr_n84974160)
print v(xbgr.mr_n84974480)
print v(xbgr.mr_n84974592)
print v(xbgr.mr_n84974912)
print v(xbgr.mr_n84975024)
print v(xbgr.mr_n84975344)
print v(xbgr.mr_n84975456)
print v(xbgr.mr_n84975776)
print v(xbgr.mr_n84975888)
print v(xbgr.mr_n84976208)
print v(xbgr.mr_n84976320)
print v(xbgr.mr_n84976640)
print v(xbgr.mr_n84976752)
print v(xbgr.mr_n84977072)
print v(xbgr.mr_n84977184)
print v(xbgr.mr_n84977504)
print v(xbgr.mr_n84977616)
print v(xbgr.mr_n84977936)
print v(xbgr.mr_n84978048)
print v(xbgr.mr_n84978368)
print v(xbgr.mr_n84978480)
print v(xbgr.mr_n84978800)
print v(xbgr.mr_n84978912)
print v(xbgr.mr_n84979232)
print v(xbgr.mr_n84979344)
print v(xbgr.mr_n84979664)
print v(xbgr.mr_n84979776)
print v(xbgr.mr_n84980096)
print v(xbgr.mr_n84980208)
print v(xbgr.mr_n84980528)
print v(xbgr.mr_n84980640)
print v(xbgr.mr_n84980960)
print v(xbgr.mr_n84981072)
print v(xbgr.mr_n84981392)
print v(xbgr.mr_n84981504)
print v(xbgr.mr_n84981824)
print v(xbgr.mr_n84981936)
print v(xbgr.mr_n84982256)
print v(xbgr.mr_n84982368)
print v(xbgr.mr_n84982688)
print v(xbgr.mr_n84982800)
print v(xbgr.mr_n84983120)
print v(xbgr.mr_n84983232)
print v(xbgr.mr_n84983552)
print v(xbgr.mr_n84983664)
print v(xbgr.mr_n84983984)
print v(xbgr.mr_n84984096)
print v(xbgr.mr_n84984416)
print v(xbgr.mr_n84984528)
print v(xbgr.mr_n84984848)
print v(xbgr.mr_n84984960)
print v(xbgr.mr_n84985280)
print v(xbgr.mr_n84985392)
print v(xbgr.mr_n84985712)
print v(xbgr.mr_n84985824)
print v(xbgr.mr_n84986144)
print v(xbgr.mr_n84986256)
print v(xbgr.mr_n84986576)
print v(xbgr.mr_n84986688)
print v(xbgr.mr_n84987008)
print v(xbgr.mr_n84987120)
print v(xbgr.mr_n84987440)
print v(xbgr.mr_n84987552)
print v(xbgr.mr_n84987872)
print v(xbgr.mr_n84987984)
print v(xbgr.mr_n84988304)
print v(xbgr.mr_n84988416)
print v(xbgr.mr_n84988736)
print v(xbgr.mr_n84988848)
print v(xbgr.mr_n84989168)
print v(xbgr.mr_n84989280)
print v(xbgr.mr_n84989600)
print v(xbgr.mr_n84989712)
print v(xbgr.mr_n84990032)
print v(xbgr.mr_n84990144)
print v(xbgr.mr_n84990464)
print v(xbgr.mr_n84990576)
print v(xbgr.mr_n84990896)
print v(xbgr.mr_n84991008)
print v(xbgr.mr_n84991328)
print v(xbgr.mr_n84991440)
print v(xbgr.mr_n84991760)
print v(xbgr.mr_n84991872)
print v(xbgr.mr_n84992192)
print v(xbgr.mr_n84992304)
print v(xbgr.mr_n84992624)
print v(xbgr.mr_n84992736)
print v(xbgr.mr_n84993056)
print v(xbgr.mr_n84993168)
print v(xbgr.mr_n84993488)
print v(xbgr.mr_n84993600)
print v(xbgr.mr_n84993920)
print v(xbgr.mr_n84994032)
print v(xbgr.mr_n84994352)
print v(xbgr.mr_n84994464)
print v(xbgr.mr_n84994784)
print v(xbgr.mr_n84994896)
print v(xbgr.mr_n84995216)
print v(xbgr.mr_n84995328)
print v(xbgr.mr_n84995648)
print v(xbgr.mr_n84995760)
print v(xbgr.mr_n84996080)
print v(xbgr.mr_n84996192)
print v(xbgr.mr_n84996512)
print v(xbgr.mr_n84996624)
print v(xbgr.mr_n84996944)
print v(xbgr.mr_n84997056)
print v(xbgr.mr_n84997376)
print v(xbgr.mr_n84997488)
print v(xbgr.mr_n84997808)
print v(xbgr.mr_n84997920)
print v(xbgr.mr_n84998240)
print v(xbgr.mr_n84998352)
print v(xbgr.mr_n84998672)
print v(xbgr.mr_n84998784)
print v(xbgr.mr_n84999104)
print v(xbgr.mr_n84999216)
print v(xbgr.mr_n84999536)
print v(xbgr.mr_n84999648)
print v(xbgr.mr_n84999968)
print v(xbgr.mr_n85000080)
print v(xbgr.mr_n85000400)
print v(xbgr.mr_n85000512)
print v(xbgr.mr_n85000832)
print v(xbgr.mr_n85000944)
print v(xbgr.mr_n85001264)
print v(xbgr.mr_n85001376)
print v(xbgr.mr_n85001696)
print v(xbgr.mr_n85001808)
print v(xbgr.mr_n85002128)
print v(xbgr.mr_n85002240)
print v(xbgr.mr_n85002560)
print v(xbgr.mr_n85002672)
print v(xbgr.mr_n85002992)
print v(xbgr.mr_n85003104)
print v(xbgr.mr_n85003424)
print v(xbgr.mr_n85003536)
print v(xbgr.mr_n85003856)
print v(xbgr.mr_n85003968)
print v(xbgr.mr_n85004288)
print v(xbgr.mr_n85004400)
print v(xbgr.mr_n85004720)
print v(xbgr.mr_n85004832)
print v(xbgr.mr_n85005152)
print v(xbgr.mr_n85005264)
print v(xbgr.mr_n85005584)
print v(xbgr.mr_n85005696)
print v(xbgr.mr_n85006016)
print v(xbgr.mr_n85006128)
print v(xbgr.mr_n85006448)
print v(xbgr.mr_n85006560)
print v(xbgr.mr_n85006880)
print v(xbgr.mr_n85006992)
print v(xbgr.mr_n85007312)
print v(xbgr.mr_n85007424)
print v(xbgr.mr_n85007744)
print v(xbgr.mr_n85007856)
print v(xbgr.mr_n85008176)
print v(xbgr.mr_n85008288)
print v(xbgr.mr_n85008608)
print v(xbgr.mr_n85008720)
print v(xbgr.mr_n85009040)
print v(xbgr.mr_n85009152)
print v(xbgr.mr_n85009472)
print v(xbgr.mr_n85009584)
print v(xbgr.mr_n85009904)
print v(xbgr.mr_n85010016)
print v(xbgr.mr_n85010336)
print v(xbgr.mr_n85010448)
print v(xbgr.mr_n85010768)
print v(xbgr.mr_n85010880)
print v(xbgr.mr_n85011200)
print v(xbgr.mr_n85011312)
print v(xbgr.mr_n85011632)
print v(xbgr.mr_n85011744)
print v(xbgr.mr_n85012064)
print v(xbgr.mr_n85012176)
print v(xbgr.mr_n85012496)
print v(xbgr.mr_n85012608)
print v(xbgr.mr_n85012928)
print v(xbgr.mr_n85013040)
print v(xbgr.mr_n85013360)
print v(xbgr.mr_n85013472)
print v(xbgr.mr_n85013792)
print v(xbgr.mr_n85013904)
print v(xbgr.mr_n85014224)
print v(xbgr.mr_n85014336)
print v(xbgr.mr_n85014656)
print v(xbgr.mr_n85014768)
print v(xbgr.mr_n85015088)
print v(xbgr.mr_n85015200)
print v(xbgr.mr_n85015520)
print v(xbgr.mr_n85015632)
print v(xbgr.mr_n85015952)
print v(xbgr.mr_n85016064)
print v(xbgr.mr_n85016384)
print v(xbgr.mr_n85016496)
print v(xbgr.mr_n85016816)
print v(xbgr.mr_n85016928)
print v(xbgr.mr_n85017248)
print v(xbgr.mr_n85017360)
print v(xbgr.mr_n85017680)
print v(xbgr.mr_n85017792)
print v(xbgr.mr_n85018112)
print v(xbgr.mr_n85018224)
print v(xbgr.mr_n85018544)
print v(xbgr.mr_n85018656)
print v(xbgr.mr_n85018976)
print v(xbgr.mr_n85019088)
print v(xbgr.mr_n85019408)
print v(xbgr.mr_n85019520)
print v(xbgr.mr_n85019840)
print v(xbgr.mr_n85019952)
print v(xbgr.mr_n85020272)
print v(xbgr.mr_n85020384)
print v(xbgr.mr_n85020704)
print v(xbgr.mr_n85020816)
print v(xbgr.mr_n85021136)
print v(xbgr.mr_n85021248)
print v(xbgr.mr_n85021568)
print v(xbgr.mr_n85021680)
print v(xbgr.mr_n85022000)
print v(xbgr.mr_n85022112)
print v(xbgr.mr_n85022432)
print v(xbgr.mr_n85022544)
print v(xbgr.mr_n85022864)
print v(xbgr.mr_n85022976)
print v(xbgr.mr_n85023296)
print v(xbgr.mr_n85023408)
print v(xbgr.mr_n85023728)
print v(xbgr.mr_n85023840)
print v(xbgr.mr_n85024160)
print v(xbgr.mr_n85024272)
print v(xbgr.mr_n85024592)
print v(xbgr.mr_n85024704)
print v(xbgr.mr_n85025024)
print v(xbgr.mr_n85025136)
print v(xbgr.mr_n85025456)
print v(xbgr.mr_n85025568)
print v(xbgr.mr_n85025888)
print v(xbgr.mr_n85026000)
print v(xbgr.mr_n85026320)
print v(xbgr.mr_n85026432)
print v(xbgr.mr_n85026752)
print v(xbgr.mr_n85026864)
print v(xbgr.mr_n85027184)
print v(xbgr.mr_n85027296)
print v(xbgr.mr_n85027616)
print v(xbgr.mr_n85027728)
print v(xbgr.mr_n85028048)
print v(xbgr.mr_n85028160)
print v(xbgr.mr_n85028480)
print v(xbgr.mr_n85028592)
print v(xbgr.mr_n85028912)
print v(xbgr.mr_n85029024)
print v(xbgr.mr_n85029344)
print v(xbgr.mr_n85029456)
print v(xbgr.mr_n85029776)
print v(xbgr.mr_n85029888)
print v(xbgr.mr_n85030208)
print v(xbgr.mr_n85030320)
print v(xbgr.mr_n85030640)
print v(xbgr.mr_n85030752)
print v(xbgr.mr_n85031072)
print v(xbgr.mr_n85031184)
print v(xbgr.mr_n85031504)
print v(xbgr.mr_n85031616)
print v(xbgr.mr_n85031936)
print v(xbgr.mr_n85032048)
print v(xbgr.mr_n85032368)
print v(xbgr.mr_n85032480)
print v(xbgr.mr_n85032800)
print v(xbgr.mr_n85032912)
print v(xbgr.mr_n85033232)
print v(xbgr.mr_n85033344)
print v(xbgr.mr_n85033664)
print v(xbgr.mr_n85033776)
print v(xbgr.mr_n85034096)
print v(xbgr.mr_n85034208)
print v(xbgr.mr_n85034528)
print v(xbgr.mr_n85034640)
print v(xbgr.mr_n85034960)
print v(xbgr.mr_n85035072)
print v(xbgr.mr_n85035392)
print v(xbgr.mr_n85035504)
print v(xbgr.mr_n85035824)
print v(xbgr.mr_n85035936)
print v(xbgr.mr_n85036256)
print v(xbgr.mr_n85036368)
print v(xbgr.mr_n85036688)
print v(xbgr.mr_n85036800)
print v(xbgr.mr_n85037120)
print v(xbgr.mr_n85037232)
print v(xbgr.mr_n85037552)
print v(xbgr.mr_n85037664)
print v(xbgr.mr_n85037984)
print v(xbgr.mr_n85038096)
print v(xbgr.mr_n85038416)
print v(xbgr.mr_n85038528)
print v(xbgr.mr_n85038848)
print v(xbgr.mr_n85038960)
print v(xbgr.mr_n85039280)
print v(xbgr.mr_n85039392)
print v(xbgr.mr_n85039712)
print v(xbgr.mr_n85039824)
print v(xbgr.mr_n85040144)
print v(xbgr.mr_n85040256)
print v(xbgr.mr_n85040576)
print v(xbgr.mr_n85040688)
print v(xbgr.mr_n85041008)
print v(xbgr.mr_n85041120)
print v(xbgr.mr_n85041440)
print v(xbgr.mr_n85041552)
print v(xbgr.mr_n85041872)
print v(xbgr.mr_n85041984)
print v(xbgr.mr_n85042304)
print v(xbgr.mr_n85042416)
print v(xbgr.mr_n85042736)
print v(xbgr.mr_n85042848)
print v(xbgr.mr_n85043168)
print v(xbgr.mr_n85043280)
print v(xbgr.mr_n85043600)
print v(xbgr.mr_n85043712)
print v(xbgr.mr_n85044032)
print v(xbgr.mr_n85044144)
print v(xbgr.mr_n85044464)
print v(xbgr.mr_n85044576)
print v(xbgr.mr_n85044896)
print v(xbgr.mr_n85045008)
print v(xbgr.mr_n85045328)
print v(xbgr.mr_n85045440)
print v(xbgr.mr_n85045760)
print v(xbgr.mr_n85045872)
print v(xbgr.mr_n85046192)
print v(xbgr.mr_n85046304)
print v(xbgr.mr_n85046624)
print v(xbgr.mr_n85046736)
print v(xbgr.mr_n85047056)
print v(xbgr.mr_n85047168)
print v(xbgr.mr_n85047488)
print v(xbgr.mr_n85047600)
print v(xbgr.mr_n85047920)
print v(xbgr.mr_n85048032)
print v(xbgr.mr_n85048352)
print v(xbgr.mr_n85048464)
print v(xbgr.mr_n85048784)
print v(xbgr.mr_n85048896)
print v(xbgr.mr_n85049216)
print v(xbgr.mr_n85049328)
print v(xbgr.mr_n85049648)
print v(xbgr.mr_n85049760)
print v(xbgr.mr_n85050080)
print v(xbgr.mr_n85050192)
print v(xbgr.mr_n85050512)
print v(xbgr.mr_n85050624)
print v(xbgr.mr_n85050944)
print v(xbgr.mr_n85051056)
print v(xbgr.mr_n85051376)
print v(xbgr.mr_n85051488)
print v(xbgr.mr_n85051808)
print v(xbgr.mr_n85051920)
print v(xbgr.mr_n85052240)
print v(xbgr.mr_n85052352)
print v(xbgr.mr_n85052672)
print v(xbgr.mr_n85052784)
print v(xbgr.mr_n85053104)
print v(xbgr.mr_n85053216)
print v(xbgr.mr_n85053536)
print v(xbgr.mr_n85053648)
print v(xbgr.mr_n85053968)
print v(xbgr.mr_n85054080)
print v(xbgr.mr_n85054400)
print v(xbgr.mr_n85054512)
print v(xbgr.mr_n85054832)
print v(xbgr.mr_n85054944)
print v(xbgr.mr_n85055264)
print v(xbgr.mr_n85055376)
print v(xbgr.mr_n85055696)
print v(xbgr.mr_n85055808)
print v(xbgr.mr_n85056128)
print v(xbgr.mr_n85056240)
print v(xbgr.mr_n85056560)
print v(xbgr.mr_n85056672)
print v(xbgr.mr_n85056992)
print v(xbgr.mr_n85057104)
print v(xbgr.mr_n85057424)
print v(xbgr.mr_n85057536)
print v(xbgr.mr_n85057856)
print v(xbgr.mr_n85057968)
print v(xbgr.mr_n85058288)
print v(xbgr.mr_n85058400)
print v(xbgr.mr_n85058720)
print v(xbgr.mr_n85058832)
print v(xbgr.mr_n85059152)
print v(xbgr.mr_n85059264)
print v(xbgr.mr_n85059584)
print v(xbgr.mr_n85059696)
print v(xbgr.mr_n85060016)
print v(xbgr.mr_n85060128)
print v(xbgr.mr_n85060448)
print v(xbgr.mr_n85060560)
print v(xbgr.mr_n85060880)
print v(xbgr.mr_n85060992)
print v(xbgr.mr_n85061312)
print v(xbgr.mr_n85061424)
print v(xbgr.mr_n85061744)
print v(xbgr.mr_n85061856)
print v(xbgr.mr_n85062176)
print v(xbgr.mr_n85062288)
print v(xbgr.mr_n85062608)
print v(xbgr.mr_n85062720)
print v(xbgr.mr_n85063040)
print v(xbgr.mr_n85063152)
print v(xbgr.mr_n85063472)
print v(xbgr.mr_n85063584)
print v(xbgr.mr_n85063904)
print v(xbgr.mr_n85064016)
print v(xbgr.mr_n85064336)
print v(xbgr.mr_n85064448)
print v(xbgr.mr_n85064768)
print v(xbgr.mr_n85064880)
print v(xbgr.mr_n85065200)
print v(xbgr.mr_n85065312)
print v(xbgr.mr_n85065632)
print v(xbgr.mr_n85065744)
print v(xbgr.mr_n85066064)
print v(xbgr.mr_n85066176)
print v(xbgr.mr_n85066496)
print v(xbgr.mr_n85066608)
print v(xbgr.mr_n85066928)
print v(xbgr.mr_n85067040)
print v(xbgr.mr_n85067360)
print v(xbgr.mr_n85067472)
print v(xbgr.mr_n85067792)
print v(xbgr.mr_n85067904)
print v(xbgr.mr_n85068224)
print v(xbgr.mr_n85068336)
print v(xbgr.mr_n85068656)
print v(xbgr.mr_n85068768)
print v(xbgr.mr_n85069088)
print v(xbgr.mr_n85069200)
print v(xbgr.mr_n85069520)
print v(xbgr.mr_n85069632)
print v(xbgr.mr_n85069952)
print v(xbgr.mr_n85070064)
print v(xbgr.mr_n85070384)
print v(xbgr.mr_n85070496)
print v(xbgr.mr_n85070816)
print v(xbgr.mr_n85070928)
print v(xbgr.mr_n85071248)
print v(xbgr.mr_n85071360)
print v(xbgr.mr_n85071680)
print v(xbgr.mr_n85071792)
print v(xbgr.mr_n85072112)
print v(xbgr.mr_n85072224)
print v(xbgr.mr_n85072544)
print v(xbgr.mr_n85072656)
print v(xbgr.mr_n85072976)
print v(xbgr.mr_n85073088)
print v(xbgr.mr_n85073408)
print v(xbgr.mr_n85073520)
print v(xbgr.mr_n85073840)
print v(xbgr.mr_n85073952)
print v(xbgr.mr_n85074272)
print v(xbgr.mr_n85074384)
print v(xbgr.mr_n85074704)
print v(xbgr.mr_n85074816)
print v(xbgr.mr_n85075136)
print v(xbgr.mr_n85075248)
print v(xbgr.mr_n85075568)
print v(xbgr.mr_n85075680)
print v(xbgr.mr_n85076000)
print v(xbgr.mr_n85076112)
print v(xbgr.mr_n85076432)
print v(xbgr.mr_n85076544)
print v(xbgr.mr_n85076864)
print v(xbgr.mr_n85076976)
print v(xbgr.mr_n85077296)
print v(xbgr.mr_n85077408)
print v(xbgr.mr_n85077728)
print v(xbgr.mr_n85077840)
print v(xbgr.mr_n85078160)
print v(xbgr.mr_n85078272)
print v(xbgr.mr_n85078592)
print v(xbgr.mr_n85078704)
print v(xbgr.mr_n85079024)
print v(xbgr.mr_n85079136)
print v(xbgr.mr_n85079456)
print v(xbgr.mr_n85079568)
print v(xbgr.mr_n85079888)
print v(xbgr.mr_n85080000)
print v(xbgr.mr_n85080320)
print v(xbgr.mr_n85080432)
print v(xbgr.mr_n85080752)
print v(xbgr.mr_n85080864)
print v(xbgr.mr_n85081184)
print v(xbgr.mr_n85081296)
print v(xbgr.mr_n85081616)
print v(xbgr.mr_n85081728)
print v(xbgr.mr_n85082048)
print v(xbgr.mr_n85082160)
print v(xbgr.mr_n85082480)
print v(xbgr.mr_n85082592)
print v(xbgr.mr_n85082912)
print v(xbgr.mr_n85083024)
print v(xbgr.mr_n85083344)
print v(xbgr.mr_n85083456)
print v(xbgr.mr_n85083776)
print v(xbgr.mr_n85083888)
print v(xbgr.mr_n85084208)
print v(xbgr.mr_n85084320)
print v(xbgr.mr_n85084640)
print v(xbgr.mr_n85084752)
print v(xbgr.mr_n85085072)
print v(xbgr.mr_n85085184)
print v(xbgr.mr_n85085504)
print v(xbgr.mr_n85085616)
print v(xbgr.mr_n85085936)
print v(xbgr.mr_n85086048)
print v(xbgr.mr_n85086368)
print v(xbgr.mr_n85086480)
print v(xbgr.mr_n85086800)
print v(xbgr.mr_n85086912)
print v(xbgr.mr_n85087232)
print v(xbgr.mr_n85087344)
print v(xbgr.mr_n85087664)
print v(xbgr.mr_n85087776)
print v(xbgr.mr_n85088096)
print v(xbgr.mr_n85088208)
print v(xbgr.mr_n85088528)
print v(xbgr.mr_n85088640)
print v(xbgr.mr_n85088960)
print v(xbgr.mr_n85089072)
print v(xbgr.mr_n85089392)
print v(xbgr.mr_n85089504)
print v(xbgr.mr_n85089824)
print v(xbgr.mr_n85089936)
print v(xbgr.mr_n85090256)
print v(xbgr.mr_n85090368)
print v(xbgr.mr_n85090688)
print v(xbgr.mr_n85090800)
print v(xbgr.mr_n85091120)
print v(xbgr.mr_n85091232)
print v(xbgr.mr_n85091552)
print v(xbgr.mr_n85091664)
print v(xbgr.mr_n85091984)
print v(xbgr.mr_n85092096)
print v(xbgr.mr_n85092416)
print v(xbgr.mr_n85092528)
print v(xbgr.mr_n85092848)
print v(xbgr.mr_n85092960)
print v(xbgr.mr_n85093280)
print v(xbgr.mr_n85093392)
print v(xbgr.mr_n85093712)
print v(xbgr.mr_n85093824)
print v(xbgr.mr_n85094144)
print v(xbgr.mr_n85094256)
print v(xbgr.mr_n85094576)
print v(xbgr.mr_n85094688)
print v(xbgr.mr_n85095008)
print v(xbgr.mr_n85095120)
print v(xbgr.mr_n85095440)
print v(xbgr.mr_n85095552)
print v(xbgr.mr_n85095872)
print v(xbgr.mr_n85095984)
print v(xbgr.mr_n85096304)
print v(xbgr.mr_n85096416)
print v(xbgr.mr_n85096736)
print v(xbgr.mr_n85096848)
print v(xbgr.mr_n85097168)
print v(xbgr.mr_n85097280)
print v(xbgr.mr_n85097600)
print v(xbgr.mr_n85097712)
print v(xbgr.mr_n85098032)
print v(xbgr.mr_n85098144)
print v(xbgr.mr_n85098464)
print v(xbgr.mr_n85098576)
print v(xbgr.mr_n85098896)
print v(xbgr.mr_n85099008)
print v(xbgr.mr_n85099328)
print v(xbgr.mr_n85099440)
print v(xbgr.mr_n85099760)
print v(xbgr.mr_n85099872)
print v(xbgr.mr_n85100192)
print v(xbgr.mr_n85100304)
print v(xbgr.mr_n85100624)
print v(xbgr.mr_n85100736)
print v(xbgr.mr_n85101056)
print v(xbgr.mr_n85101168)
print v(xbgr.mr_n85101488)
print v(xbgr.mr_n85101600)
print v(xbgr.mr_n85101920)
print v(xbgr.mr_n85102032)
print v(xbgr.mr_n85102352)
print v(xbgr.mr_n85102464)
print v(xbgr.mr_n85102784)
print v(xbgr.mr_n85102896)
print v(xbgr.mr_n85103216)
print v(xbgr.mr_n85103328)
print v(xbgr.mr_n85103648)
print v(xbgr.mr_n85103760)
print v(xbgr.mr_n85104080)
print v(xbgr.mr_n85104192)
print v(xbgr.mr_n85104512)
print v(xbgr.mr_n85104624)
print v(xbgr.mr_n85104944)
print v(xbgr.mr_n85105056)
print v(xbgr.mr_n85105376)
print v(xbgr.mr_n85105488)
print v(xbgr.mr_n85105808)
print v(xbgr.mr_n85105920)
print v(xbgr.mr_n85106240)
print v(xbgr.mr_n85106352)
print v(xbgr.mr_n85106672)
print v(xbgr.mr_n85106784)
print v(xbgr.mr_n85107104)
print v(xbgr.mr_n85107216)
print v(xbgr.mr_n85107536)
print v(xbgr.mr_n85107648)
print v(xbgr.mr_n85107968)
print v(xbgr.mr_n85108080)
print v(xbgr.mr_n85108400)
print v(xbgr.mr_n85108512)
print v(xbgr.mr_n85108832)
print v(xbgr.mr_n85108944)
print v(xbgr.mr_n85109264)
print v(xbgr.mr_n85109376)
print v(xbgr.mr_n85109696)
print v(xbgr.mr_n85109808)
print v(xbgr.mr_n85110128)
print v(xbgr.mr_n85110240)
print v(xbgr.mr_n85110560)
print v(xbgr.mr_n85110672)
print v(xbgr.mr_n85110992)
print v(xbgr.mr_n85111104)
print v(xbgr.mr_n85111424)
print v(xbgr.mr_n85111536)
print v(xbgr.mr_n85111856)
print v(xbgr.mr_n85111968)
print v(xbgr.mr_n85112288)
print v(xbgr.mr_n85112400)
print v(xbgr.mr_n85112720)
print v(xbgr.mr_n85112832)
print v(xbgr.mr_n85113152)
print v(xbgr.mr_n85113264)
print v(xbgr.mr_n85113584)
print v(xbgr.mr_n85113696)
print v(xbgr.mr_n85114016)
print v(xbgr.mr_n85114128)
print v(xbgr.mr_n85114448)
print v(xbgr.mr_n85114560)
print v(xbgr.mr_n85114880)
print v(xbgr.mr_n85114992)
print v(xbgr.mr_n85115312)
print v(xbgr.mr_n85115424)
print v(xbgr.mr_n85115744)
print v(xbgr.mr_n85115856)
print v(xbgr.mr_n85116176)
print v(xbgr.mr_n85116288)
print v(xbgr.mr_n85116608)
print v(xbgr.mr_n85116720)
print v(xbgr.mr_n85117040)
print v(xbgr.mr_n85117152)
print v(xbgr.mr_n85117472)
print v(xbgr.mr_n85117584)
print v(xbgr.mr_n85117904)
print v(xbgr.mr_n85118016)
print v(xbgr.mr_n85118336)
print v(xbgr.mr_n85118448)
print v(xbgr.mr_n85118768)
print v(xbgr.mr_n85118880)
print v(xbgr.mr_n85119200)
print v(xbgr.mr_n85119312)
print v(xbgr.mr_n85119632)
print v(xbgr.mr_n85119744)
print v(xbgr.mr_n85120064)
print v(xbgr.mr_n85120176)
print v(xbgr.mr_n85120496)
print v(xbgr.mr_n85120608)
print v(xbgr.mr_n85120928)
print v(xbgr.mr_n85121040)
print v(xbgr.mr_n85121360)
print v(xbgr.mr_n85121472)
print v(xbgr.mr_n85121792)
print v(xbgr.mr_n85121904)
print v(xbgr.mr_n85122224)
print v(xbgr.mr_n85122336)
print v(xbgr.mr_n85122656)
print v(xbgr.mr_n85122768)
print v(xbgr.mr_n85123088)
print v(xbgr.mr_n85123200)
print v(xbgr.mr_n85123520)
print v(xbgr.mr_n85123632)
print v(xbgr.mr_n85123952)
print v(xbgr.mr_n85124064)
print v(xbgr.mr_n85124384)
print v(xbgr.mr_n85124496)
print v(xbgr.mr_n85124816)
print v(xbgr.mr_n85124928)
print v(xbgr.mr_n85125248)
print v(xbgr.mr_n85125360)
print v(xbgr.mr_n85125680)
print v(xbgr.mr_n85125792)
print v(xbgr.mr_n85126112)
print v(xbgr.mr_n85126224)
print v(xbgr.mr_n85126544)
print v(xbgr.mr_n85126656)
print v(xbgr.mr_n85126976)
print v(xbgr.mr_n85127088)
print v(xbgr.mr_n85127408)
print v(xbgr.mr_n85127520)
print v(xbgr.mr_n85127840)
print v(xbgr.mr_n85127952)
print v(xbgr.mr_n85128272)
print v(xbgr.mr_n85128384)
print v(xbgr.mr_n85128704)
print v(xbgr.mr_n85128816)
print v(xbgr.mr_n85129136)
print v(xbgr.mr_n85129248)
print v(xbgr.mr_n85129568)
print v(xbgr.mr_n85129680)
print v(xbgr.mr_n85130000)
print v(xbgr.mr_n85130112)
print v(xbgr.mr_n85130432)
print v(xbgr.mr_n85130544)
print v(xbgr.mr_n85130864)
print v(xbgr.mr_n85130976)
print v(xbgr.mr_n85131296)
print v(xbgr.mr_n85131408)
print v(xbgr.mr_n85131728)
print v(xbgr.mr_n85131840)
print v(xbgr.mr_n85132160)
print v(xbgr.mr_n85132272)
print v(xbgr.mr_n85132592)
print v(xbgr.mr_n85132704)
print v(xbgr.mr_n85133024)
print v(xbgr.mr_n85133136)
print v(xbgr.mr_n85133456)
print v(xbgr.mr_n85133568)
print v(xbgr.mr_n85133888)
print v(xbgr.mr_n85134000)
print v(xbgr.mr_n85134320)
print v(xbgr.mr_n85134432)
print v(xbgr.mr_n85134752)
print v(xbgr.mr_n85134864)
print v(xbgr.mr_n85135184)
print v(xbgr.mr_n85135296)
print v(xbgr.mr_n85135616)
print v(xbgr.mr_n85135728)
print v(xbgr.mr_n85136048)
print v(xbgr.mr_n85136160)
print v(xbgr.mr_n85136480)
print v(xbgr.mr_n85136592)
print v(xbgr.mr_n85136912)
print v(xbgr.mr_n85137024)
print v(xbgr.mr_n85137344)
print v(xbgr.mr_n85137456)
print v(xbgr.mr_n85137776)
print v(xbgr.mr_n85137888)
print v(xbgr.mr_n85138208)
print v(xbgr.mr_n85138320)
print v(xbgr.mr_n85138640)
print v(xbgr.mr_n85138752)
print v(xbgr.mr_n85139072)
print v(xbgr.mr_n85139184)
print v(xbgr.mr_n85139504)
print v(xbgr.mr_n85139616)
print v(xbgr.mr_n85139936)
print v(xbgr.mr_n85140048)
print v(xbgr.mr_n85140368)
print v(xbgr.mr_n85140480)
print v(xbgr.mr_n85140800)
print v(xbgr.mr_n85140912)
print v(xbgr.mr_n85141232)
print v(xbgr.mr_n85141344)
print v(xbgr.mr_n85141664)
print v(xbgr.mr_n85141776)
print v(xbgr.mr_n85142096)
print v(xbgr.mr_n85142208)
print v(xbgr.mr_n85142528)
print v(xbgr.mr_n85142640)
print v(xbgr.mr_n85142960)
print v(xbgr.mr_n85143072)
print v(xbgr.mr_n85143392)
print v(xbgr.mr_n85143504)
print v(xbgr.mr_n85143824)
print v(xbgr.mr_n85143936)
print v(xbgr.mr_n85144256)
print v(xbgr.mr_n85144368)
print v(xbgr.mr_n85144688)
print v(xbgr.mr_n85144800)
print v(xbgr.mr_n85145120)
print v(xbgr.mr_n85145232)
print v(xbgr.mr_n85145552)
print v(xbgr.mr_n85145664)
print v(xbgr.mr_n85145984)
print v(xbgr.mr_n85146096)
print v(xbgr.mr_n85146416)
print v(xbgr.mr_n85146528)
print v(xbgr.mr_n85146848)
print v(xbgr.mr_n85146960)
print v(xbgr.mr_n85147280)
print v(xbgr.mr_n85147392)
print v(xbgr.mr_n85147712)
print v(xbgr.mr_n85147824)
print v(xbgr.mr_n85148144)
print v(xbgr.mr_n85148256)
print v(xbgr.mr_n85148576)
print v(xbgr.mr_n85148688)
print v(xbgr.mr_n85149008)
print v(xbgr.mr_n85149120)
print v(xbgr.mr_n85149440)
print v(xbgr.mr_n85149552)
print v(xbgr.mr_n85149872)
print v(xbgr.mr_n85149984)
print v(xbgr.mr_n85150304)
print v(xbgr.mr_n85150416)
print v(xbgr.mr_n85150736)
print v(xbgr.mr_n85150848)
print v(xbgr.mr_n85151168)
print v(xbgr.mr_n85151280)
print v(xbgr.mr_n85151600)
print v(xbgr.mr_n85151712)
print v(xbgr.mr_n85152032)
print v(xbgr.mr_n85152144)
print v(xbgr.mr_n85152464)
print v(xbgr.mr_n85152576)
print v(xbgr.mr_n85152896)
print v(xbgr.mr_n85153008)
print v(xbgr.mr_n85153328)
print v(xbgr.mr_n85153440)
print v(xbgr.mr_n85153760)
print v(xbgr.mr_n85153872)
print v(xbgr.mr_n85154192)
print v(xbgr.mr_n85154304)
print v(xbgr.mr_n85154624)
print v(xbgr.mr_n85154736)
print v(xbgr.mr_n85155056)
print v(xbgr.mr_n85155168)
print v(xbgr.mr_n85155488)
print v(xbgr.mr_n85155600)
print v(xbgr.mr_n85155920)
print v(xbgr.mr_n85156032)
print v(xbgr.mr_n85156352)
print v(xbgr.mr_n85156464)
print v(xbgr.mr_n85156784)
print v(xbgr.mr_n85156896)
print v(xbgr.mr_n85157216)
print v(xbgr.mr_n85157328)
print v(xbgr.mr_n85157648)
print v(xbgr.mr_n85157760)
print v(xbgr.mr_n85158080)
print v(xbgr.mr_n85158192)
print v(xbgr.mr_n85158512)
print v(xbgr.mr_n85158624)
print v(xbgr.mr_n85158944)
print v(xbgr.mr_n85159056)
print v(xbgr.mr_n85159376)
print v(xbgr.mr_n85159488)
print v(xbgr.mr_n85159808)
print v(xbgr.mr_n85159920)
print v(xbgr.mr_n85160240)
print v(xbgr.mr_n85160352)
print v(xbgr.mr_n85160672)
print v(xbgr.mr_n85160784)
print v(xbgr.mr_n85161104)
print v(xbgr.mr_n85161216)
print v(xbgr.mr_n85161536)
print v(xbgr.mr_n85161648)
print v(xbgr.mr_n85161968)
print v(xbgr.mr_n85162080)
print v(xbgr.mr_n85162400)
print v(xbgr.mr_n85162512)
print v(xbgr.mr_n85162832)
print v(xbgr.mr_n85162944)
print v(xbgr.mr_n85163264)
print v(xbgr.mr_n85163376)
print v(xbgr.mr_n85163696)
print v(xbgr.mr_n85163808)
print v(xbgr.mr_n85164128)
print v(xbgr.mr_n85164240)
print v(xbgr.mr_n85164560)
print v(xbgr.mr_n85164672)
print v(xbgr.mr_n85164992)
print v(xbgr.mr_n85165104)
print v(xbgr.mr_n85165424)
print v(xbgr.mr_n85165536)
print v(xbgr.mr_n85165856)
print v(xbgr.mr_n85165968)
print v(xbgr.mr_n85166288)
print v(xbgr.mr_n85166400)
print v(xbgr.mr_n85166720)
print v(xbgr.mr_n85166832)
print v(xbgr.mr_n85167152)
print v(xbgr.mr_n85167264)
print v(xbgr.mr_n85167584)
print v(xbgr.mr_n85167696)
print v(xbgr.mr_n85168016)
print v(xbgr.mr_n85168128)
print v(xbgr.mr_n85168448)
print v(xbgr.mr_n85168560)
print v(xbgr.mr_n85168880)
print v(xbgr.mr_n85168992)
print v(xbgr.mr_n85169312)
print v(xbgr.mr_n85169424)
print v(xbgr.mr_n85169744)
print v(xbgr.mr_n85169856)
print v(xbgr.mr_n85170176)
print v(xbgr.mr_n85170288)
print v(xbgr.mr_n85170608)
print v(xbgr.mr_n85170720)
print v(xbgr.mr_n85171040)
print v(xbgr.mr_n85171152)
print v(xbgr.mr_n85171584)
print v(xbgr.mr_n85171904)
print v(xbgr.mr_n85172016)
print v(xbgr.mr_n85172336)
print v(xbgr.mr_n85172448)
print v(xbgr.mr_n85172768)
print v(xbgr.mr_n85172880)
print v(xbgr.mr_n85173200)
print v(xbgr.mr_n85173312)
print v(xbgr.mr_n85173632)
print v(xbgr.mr_n85173744)
print v(xbgr.mr_n85174064)
print v(xbgr.mr_n85174176)
print v(xbgr.mr_n85174496)
print v(xbgr.mr_n85174608)
print v(xbgr.mr_n85174928)
print v(xbgr.mr_n85175040)
print v(xbgr.mr_n85175360)
print v(xbgr.mr_n85175472)
print v(xbgr.mr_n85175792)
print v(xbgr.mr_n85175904)
print v(xbgr.mr_n85176224)
print v(xbgr.mr_n85176336)
print v(xbgr.mr_n85176656)
print v(xbgr.mr_n85176768)
print v(xbgr.mr_n85177088)
print v(xbgr.mr_n85177200)
print v(xbgr.mr_n85177632)
print v(xbgr.mr_n85177952)
print v(xbgr.mr_n85178064)
print v(xbgr.mr_n85178384)
print v(xbgr.mr_n85178496)
print v(xbgr.mr_n85178816)
print v(xbgr.mr_n85178928)
print v(xbgr.mr_n85179248)
print v(xbgr.mr_n85179360)
print v(xbgr.mr_n85179680)
print v(xbgr.mr_n85179792)
print v(xbgr.mr_n85180112)
print v(xbgr.mr_n85180224)
print v(xbgr.mr_n85180544)
print v(xbgr.mr_n85180656)
print v(xbgr.mr_n85180976)
print v(xbgr.mr_n85181088)
print v(xbgr.mr_n85181408)
print v(xbgr.mr_n85181520)
print v(xbgr.mr_n85181840)
print v(xbgr.mr_n85181952)
print v(xbgr.mr_n85182272)
print v(xbgr.mr_n85182384)
print v(xbgr.mr_n85182704)
print v(xbgr.mr_n85182816)
print v(xbgr.mr_n85183136)
print v(xbgr.mr_n85183248)
print v(xbgr.mr_n85183568)
print v(xbgr.mr_n85183680)
print v(xbgr.mr_n85184000)
print v(xbgr.mr_n85184112)
print v(xbgr.mr_n85184432)
print v(xbgr.mr_n85184544)
print v(xbgr.mr_n85184864)
print v(xbgr.mr_n85184976)
print v(xbgr.mr_n85185296)
print v(xbgr.mr_n85185408)
print v(xbgr.mr_n85185728)
print v(xbgr.mr_n85185840)
print v(xbgr.mr_n85186160)
print v(xbgr.mr_n85186272)
print v(xbgr.mr_n85186592)
print v(xbgr.mr_n85186704)
print v(xbgr.mr_n85187024)
print v(xbgr.mr_n85187136)
print v(xbgr.mr_n85187456)
print v(xbgr.mr_n85187568)
print v(xbgr.mr_n85187888)
print v(xbgr.mr_n85188000)
print v(xbgr.mr_n85188320)
print v(xbgr.mr_n85188432)
print v(xbgr.mr_n85188752)
print v(xbgr.mr_n85188864)
print v(xbgr.mr_n85189184)
print v(xbgr.mr_n85189296)
print v(xbgr.mr_n85189616)
print v(xbgr.mr_n85189728)
print v(xbgr.mr_n85190048)
print v(xbgr.mr_n85190160)
print v(xbgr.mr_n85190480)
print v(xbgr.mr_n85190592)
print v(xbgr.mr_n85190912)
print v(xbgr.mr_n85191024)
print v(xbgr.mr_n85191344)
print v(xbgr.mr_n85191456)
print v(xbgr.mr_n85191776)
print v(xbgr.mr_n85191888)
print v(xbgr.mr_n85192208)
print v(xbgr.mr_n85192320)
print v(xbgr.mr_n85192640)
print v(xbgr.mr_n85192752)
print v(xbgr.mr_n85193072)
print v(xbgr.mr_n85193184)
print v(xbgr.mr_n85193504)
print v(xbgr.mr_n85193616)
print v(xbgr.mr_n85193936)
print v(xbgr.mr_n85194048)
print v(xbgr.mr_n85194368)
print v(xbgr.mr_n85194480)
print v(xbgr.mr_n85194800)
print v(xbgr.mr_n85194912)
print v(xbgr.mr_n85195232)
print v(xbgr.mr_n85195344)
print v(xbgr.mr_n85195664)
print v(xbgr.mr_n85195776)
print v(xbgr.mr_n85196096)
print v(xbgr.mr_n85196208)
print v(xbgr.mr_n85196528)
print v(xbgr.mr_n85196640)
print v(xbgr.mr_n85196960)
print v(xbgr.mr_n85197072)
print v(xbgr.mr_n85197392)
print v(xbgr.mr_n85197504)
print v(xbgr.mr_n85197824)
print v(xbgr.mr_n85197936)
print v(xbgr.mr_n85198256)
print v(xbgr.mr_n85198368)
print v(xbgr.mr_n85198688)
print v(xbgr.mr_n85198800)
print v(xbgr.mr_n85199120)
print v(xbgr.mr_n85199232)
print v(xbgr.mr_n85199552)
print v(xbgr.mr_n85199664)
print v(xbgr.mr_n85199984)
print v(xbgr.mr_n85200096)
print v(xbgr.mr_n85200416)
print v(xbgr.mr_n85200528)
print v(xbgr.mr_n85200848)
print v(xbgr.mr_n85200960)
print v(xbgr.mr_n85201280)
print v(xbgr.mr_n85201392)
print v(xbgr.mr_n85201712)
print v(xbgr.mr_n85201824)
print v(xbgr.mr_n85202144)
print v(xbgr.mr_n85202256)
print v(xbgr.mr_n85202576)
print v(xbgr.mr_n85202688)
print v(xbgr.mr_n85203008)
print v(xbgr.mr_n85203120)
print v(xbgr.mr_n85203440)
print v(xbgr.mr_n85203552)
print v(xbgr.mr_n85203872)
print v(xbgr.mr_n85203984)
print v(xbgr.mr_n85204304)
print v(xbgr.mr_n85204416)
print v(xbgr.mr_n85204736)
print v(xbgr.mr_n85204848)
print v(xbgr.mr_n85205168)
print v(xbgr.mr_n85205280)
print v(xbgr.mr_n85205600)
print v(xbgr.mr_n85205712)
print v(xbgr.mr_n85206032)
print v(xbgr.mr_n85206144)
print v(xbgr.mr_n85206464)
print v(xbgr.mr_n85206576)
print v(xbgr.mr_n85206896)
print v(xbgr.mr_n85207008)
print v(xbgr.mr_n85207328)
print v(xbgr.mr_n85207440)
print v(xbgr.mr_n85207760)
print v(xbgr.mr_n85207872)
print v(xbgr.mr_n85208192)
print v(xbgr.mr_n85208304)
print v(xbgr.mr_n85208624)
print v(xbgr.mr_n85208736)
print v(xbgr.mr_n85209056)
print v(xbgr.mr_n85209168)
print v(xbgr.mr_n85209488)
print v(xbgr.mr_n85209600)
print v(xbgr.mr_n85209920)
print v(xbgr.mr_n85210032)
print v(xbgr.mr_n85210464)
print v(xbgr.mr_n85210784)
print v(xbgr.mr_n85210896)
print v(xbgr.mr_n85211216)
print v(xbgr.mr_n85211328)
print v(xbgr.mr_n85211648)
print v(xbgr.mr_n85211760)
print v(xbgr.mr_n85212192)
print v(xbgr.mr_n85212512)
print v(xbgr.mr_n85212624)
print v(xbgr.mr_n85212944)
print v(xbgr.mr_n85213056)
print v(xbgr.mr_n85213376)
print v(xbgr.mr_n85213488)
print v(xbgr.mr_n85213920)
print v(xbgr.mr_n85214240)
print v(xbgr.mr_n85214352)
print v(xbgr.mr_n85214672)
print v(xbgr.mr_n85214784)
print v(xbgr.mr_n85215104)
print v(xbgr.mr_n85215216)
print v(xbgr.mr_n85215536)
print v(xbgr.mr_n85215648)
print v(xbgr.mr_n85215968)
print v(xbgr.mr_n85216080)
print v(xbgr.mr_n85216400)
print v(xbgr.mr_n85216512)
print v(xbgr.mr_n85216832)
print v(xbgr.mr_n85216944)
print v(xbgr.mr_n85217264)
print v(xbgr.mr_n85217376)
print v(xbgr.mr_n85217696)
print v(xbgr.mr_n85217808)
print v(xbgr.mr_n85218128)
print v(xbgr.mr_n85218240)
print v(xbgr.mr_n85218560)
print v(xbgr.mr_n85218672)
print v(xbgr.mr_n85218992)
print v(xbgr.mr_n85219104)
print v(xbgr.mr_n85219424)
print v(xbgr.mr_n85219536)
print v(xbgr.mr_n85219856)
print v(xbgr.mr_n85219968)
print v(xbgr.mr_n85220288)
print v(xbgr.mr_n85220400)
print v(xbgr.mr_n85220720)
print v(xbgr.mr_n85220832)
print v(xbgr.mr_n85221152)
print v(xbgr.mr_n85221264)
print v(xbgr.mr_n85221584)
print v(xbgr.mr_n85221696)
print v(xbgr.mr_n85222016)
print v(xbgr.mr_n85222128)
print v(xbgr.mr_n85222448)
print v(xbgr.mr_n85222560)
print v(xbgr.mr_n85222880)
print v(xbgr.mr_n85222992)
print v(xbgr.mr_n85223312)
print v(xbgr.mr_n85223424)
print v(xbgr.mr_n85223744)
print v(xbgr.mr_n85223856)
print v(xbgr.mr_n85224176)
print v(xbgr.mr_n85224288)
print v(xbgr.mr_n85224608)
print v(xbgr.mr_n85224720)
print v(xbgr.mr_n85225040)
print v(xbgr.mr_n85225152)
print v(xbgr.mr_n85225472)
print v(xbgr.mr_n85225584)
print v(xbgr.mr_n85225904)
print v(xbgr.mr_n85226016)
print v(xbgr.mr_n85226336)
print v(xbgr.mr_n85226448)
print v(xbgr.mr_n85226768)
print v(xbgr.mr_n85226880)
print v(xbgr.mr_n85227200)
print v(xbgr.mr_n85227312)
print v(xbgr.mr_n85227632)
print v(xbgr.mr_n85227744)
print v(xbgr.mr_n85228064)
print v(xbgr.mr_n85228176)
print v(xbgr.mr_n85228496)
print v(xbgr.mr_n85228608)
print v(xbgr.mr_n85228928)
print v(xbgr.mr_n85229040)
print v(xbgr.mr_n85229360)
print v(xbgr.mr_n85229472)
print v(xbgr.mr_n85229792)
print v(xbgr.mr_n85229904)
print v(xbgr.mr_n85230224)
print v(xbgr.mr_n85230336)
print v(xbgr.mr_n85230656)
print v(xbgr.mr_n85230768)
print v(xbgr.mr_n85231088)
print v(xbgr.mr_n85231200)
print v(xbgr.mr_n85231520)
print v(xbgr.mr_n85231632)
print v(xbgr.mr_n85231952)
print v(xbgr.mr_n85232064)
print v(xbgr.mr_n85232384)
print v(xbgr.mr_n85232496)
print v(xbgr.mr_n85232816)
print v(xbgr.mr_n85232928)
print v(xbgr.mr_n85233248)
print v(xbgr.mr_n85233360)
print v(xbgr.mr_n85233680)
print v(xbgr.mr_n85233792)
print v(xbgr.mr_n85234224)
print v(xbgr.mr_n85234656)
print v(xbgr.mr_n85235088)
print v(xbgr.mr_n85235520)
print v(xbgr.mr_n85235952)
print v(xbgr.mr_n85236384)
print v(xbgr.mr_n85236816)
print v(xbgr.mr_n85237248)
print v(xbgr.mr_n85237680)
print v(xbgr.mr_n85238112)
print v(xbgr.mr_n85238544)
print v(xbgr.mr_n85238976)
print v(xbgr.mr_n85239408)
print v(xbgr.mr_n85239840)
print v(xbgr.mr_n85240272)
print v(xbgr.mr_n85240704)
print v(xbgr.mr_n85241136)
print v(xbgr.mr_n85241568)
print v(xbgr.mr_n85242000)
print v(xbgr.mr_n85242432)
print v(xbgr.mr_n85242864)
print v(xbgr.mr_n85243296)
print v(xbgr.mr_n85243728)
print v(xbgr.mr_n85244160)
print v(xbgr.mr_n85244592)
print v(xbgr.mr_n85245024)
print v(xbgr.mr_n85245456)
print v(xbgr.mr_n85245888)
print v(xbgr.mr_n85246320)
print v(xbgr.mr_n85246752)
print v(xbgr.mr_n85247184)
print v(xbgr.mr_n85247616)
print v(xbgr.mr_n85248048)
print v(xbgr.mr_n85248480)
print v(xbgr.mr_n85248912)
print v(xbgr.mr_n85249344)
print v(xbgr.mr_n85249776)
print v(xbgr.mr_n85250208)
print v(xbgr.mr_n85250640)
print v(xbgr.mr_n85251072)
print v(xbgr.mr_n85251504)
print v(xbgr.mr_n85251936)
print v(xbgr.mr_n85252368)
print v(xbgr.mr_n85252800)
print v(xbgr.mr_n85253232)
print v(xbgr.mr_n85253664)
print v(xbgr.mr_n85254096)
print v(xbgr.mr_n85254528)
print v(xbgr.mr_n85254960)
print v(xbgr.mr_n85255392)
print v(xbgr.mr_n85255824)
print v(xbgr.mr_n85256256)
print v(xbgr.mr_n85256688)
print v(xbgr.mr_n85257120)
print v(xbgr.mr_n85257552)
print v(xbgr.mr_n85257984)
print v(xbgr.mr_n85258416)
print v(xbgr.mr_n85258848)
print v(xbgr.mr_n85259280)
print v(xbgr.mr_n85259712)
print v(xbgr.mr_n85260144)
print v(xbgr.mr_n85260576)
print v(xbgr.mr_n85261008)
print v(xbgr.mr_n85261440)
print v(xbgr.mr_n85261872)
print v(xbgr.mr_n85262304)
print v(xbgr.mr_n85262736)
print v(xbgr.mr_n85263168)
print v(xbgr.mr_n85263600)
print v(xbgr.mr_n85264032)
print v(xbgr.mr_n85264464)
print v(xbgr.mr_n85264896)
print v(xbgr.mr_n85265328)
print v(xbgr.mr_n85265760)
print v(xbgr.mr_n85266192)
print v(xbgr.mr_n85266624)
print v(xbgr.mr_n85267056)
print v(xbgr.mr_n85267488)
print v(xbgr.mr_n85267920)
print v(xbgr.mr_n85268352)
print v(xbgr.mr_n85268672)
print v(xbgr.mr_n85268784)
print v(xbgr.mr_n85269216)
print v(xbgr.mr_n85269536)
print v(xbgr.mr_n85269648)
print v(xbgr.mr_n85269968)
print v(xbgr.mr_n85270080)
print v(xbgr.mr_n85270400)
print v(xbgr.mr_n85270512)
print v(xbgr.mr_n85270832)
print v(xbgr.mr_n85270944)
print v(xbgr.mr_n85271264)
print v(xbgr.mr_n85271376)
print v(xbgr.mr_n85271696)
print v(xbgr.mr_n85271808)
print v(xbgr.mr_n85272128)
print v(xbgr.mr_n85272240)
print v(xbgr.mr_n85272560)
print v(xbgr.mr_n85272672)
print v(xbgr.mr_n85272992)
print v(xbgr.mr_n85273104)
print v(xbgr.mr_n85273424)
print v(xbgr.mr_n85273536)
print v(xbgr.mr_n85273968)
print v(xbgr.mr_n85274400)
print v(xbgr.mr_n85274832)
print v(xbgr.mr_n85275264)
print v(xbgr.mr_n85275696)
print v(xbgr.mr_n85276128)
print v(xbgr.mr_n85276560)
print v(xbgr.mr_n85276992)
print v(xbgr.mr_n85277424)
print v(xbgr.mr_n85277856)
print v(xbgr.mr_n85278288)
print v(xbgr.mr_n85278720)
print v(xbgr.mr_n85279152)
print v(xbgr.mr_n85279584)
print v(xbgr.mr_n85280016)
print v(xbgr.mr_n85280448)
print v(xbgr.mr_n85280880)
print v(xbgr.mr_n85281312)
print v(xbgr.mr_n85281744)
print v(xbgr.mr_n85282176)
print v(xbgr.mr_n85282608)
print v(xbgr.mr_n85283040)
print v(xbgr.mr_n85283472)
print v(xbgr.mr_n85283904)
print v(xbgr.mr_n85284336)
print v(xbgr.mr_n85284768)
print v(xbgr.mr_n85285200)
print v(xbgr.mr_n85285472)
print v(xbgr.mr_n85285584)
print v(xbgr.mr_n85285904)
print v(xbgr.mr_n85286016)
print v(xbgr.mr_n85286336)
print v(xbgr.mr_n85286448)
print v(xbgr.mr_n85286768)
print v(xbgr.mr_n85286880)
print v(xbgr.mr_n85287200)
print v(xbgr.mr_n85287312)
print v(xbgr.mr_n85287632)
print v(xbgr.mr_n85287744)
print v(xbgr.mr_n85288064)
print v(xbgr.mr_n85288176)
print v(xbgr.mr_n85288496)
print v(xbgr.mr_n85288608)
print v(xbgr.mr_n85288928)
print v(xbgr.mr_n85289040)
print v(xbgr.mr_n85289360)
print v(xbgr.mr_n85289472)
print v(xbgr.mr_n85289792)
print v(xbgr.mr_n85289904)
print v(xbgr.mr_n85290224)
print v(xbgr.mr_n85290336)
print v(xbgr.mr_n85290656)
print v(xbgr.mr_n85290768)
print v(xbgr.mr_n85291088)
print v(xbgr.mr_n85291200)
print v(xbgr.mr_n85291520)
print v(xbgr.mr_n85291632)
print v(xbgr.mr_n85291952)
print v(xbgr.mr_n85292064)
print v(xbgr.mr_n85292384)
print v(xbgr.mr_n85292496)
print v(xbgr.mr_n85292816)
print v(xbgr.mr_n85292928)
print v(xbgr.mr_n85293248)
print v(xbgr.mr_n85293360)
print v(xbgr.mr_n85293680)
print v(xbgr.mr_n85293792)
print v(xbgr.mr_n85294112)
print v(xbgr.mr_n85294224)
print v(xbgr.mr_n85294544)
print v(xbgr.mr_n85294656)
print v(xbgr.mr_n85294976)
print v(xbgr.mr_n85295088)
print v(xbgr.mr_n85295408)
print v(xbgr.mr_n85295520)
print v(xbgr.mr_n85295840)
print v(xbgr.mr_n85295952)
print v(xbgr.mr_n85296272)
print v(xbgr.mr_n85296384)
print v(xbgr.mr_n85296704)
print v(xbgr.mr_n85296816)
print v(xbgr.mr_n85297136)
print v(xbgr.mr_n85297248)
print v(xbgr.mr_n85297568)
print v(xbgr.mr_n85297680)
print v(xbgr.mr_n85298000)
print v(xbgr.mr_n85298112)
print v(xbgr.mr_n85298432)
print v(xbgr.mr_n85298544)
print v(xbgr.mr_n85298864)
print v(xbgr.mr_n85298976)
print v(xbgr.mr_n85299296)
print v(xbgr.mr_n85299408)
print v(xbgr.mr_n85299728)
print v(xbgr.mr_n85299840)
print v(xbgr.mr_n85300160)
print v(xbgr.mr_n85300272)
print v(xbgr.mr_n85300592)
print v(xbgr.mr_n85300704)
print v(xbgr.mr_n85301024)
print v(xbgr.mr_n85301136)
print v(xbgr.mr_n85301456)
print v(xbgr.mr_n85301568)
print v(xbgr.mr_n85301888)
print v(xbgr.mr_n85302000)
print v(xbgr.mr_n85302320)
print v(xbgr.mr_n85302432)
print v(xbgr.mr_n85302752)
print v(xbgr.mr_n85302864)
print v(xbgr.mr_n85303184)
print v(xbgr.mr_n85303296)
print v(xbgr.mr_n85303616)
print v(xbgr.mr_n85303728)
print v(xbgr.mr_n85304048)
print v(xbgr.mr_n85304160)
print v(xbgr.mr_n85304480)
print v(xbgr.mr_n85304592)
print v(xbgr.mr_n85304912)
print v(xbgr.mr_n85305024)
print v(xbgr.mr_n85305344)
print v(xbgr.mr_n85305456)
print v(xbgr.mr_n85305776)
print v(xbgr.mr_n85305888)
print v(xbgr.mr_n85306208)
print v(xbgr.mr_n85306320)
print v(xbgr.mr_n85306640)
print v(xbgr.mr_n85306752)
print v(xbgr.mr_n85307072)
print v(xbgr.mr_n85307184)
print v(xbgr.mr_n85307504)
print v(xbgr.mr_n85307616)
print v(xbgr.mr_n85307936)
print v(xbgr.mr_n85308048)
print v(xbgr.mr_n85308368)
print v(xbgr.mr_n85308480)
print v(xbgr.mr_n85308800)
print v(xbgr.mr_n85308912)
print v(xbgr.mr_n85309232)
print v(xbgr.mr_n85309344)
print v(xbgr.mr_n85309664)
print v(xbgr.mr_n85309776)
print v(xbgr.mr_n85310096)
print v(xbgr.mr_n85310208)
print v(xbgr.mr_n85310528)
print v(xbgr.mr_n85310640)
print v(xbgr.mr_n85310960)
print v(xbgr.mr_n85311072)
print v(xbgr.mr_n85311392)
print v(xbgr.mr_n85311504)
print v(xbgr.mr_n85311824)
print v(xbgr.mr_n85311936)
print v(xbgr.mr_n85312256)
print v(xbgr.mr_n85312368)
print v(xbgr.mr_n85312688)
print v(xbgr.mr_n85312800)
print v(xbgr.mr_n85313120)
print v(xbgr.mr_n85313232)
print v(xbgr.mr_n85313552)
print v(xbgr.mr_n85313664)
print v(xbgr.mr_n85313984)
print v(xbgr.mr_n85314096)
print v(xbgr.mr_n85314416)
print v(xbgr.mr_n85314528)
print v(xbgr.mr_n85314848)
print v(xbgr.mr_n85314960)
print v(xbgr.mr_n85315280)
print v(xbgr.mr_n85315392)
print v(xbgr.mr_n85315712)
print v(xbgr.mr_n85315824)
print v(xbgr.mr_n85316144)
print v(xbgr.mr_n85316256)
print v(xbgr.mr_n85316576)
print v(xbgr.mr_n85316688)
print v(xbgr.mr_n85317008)
print v(xbgr.mr_n85317120)
print v(xbgr.mr_n85317440)
print v(xbgr.mr_n85317552)
print v(xbgr.mr_n85317872)
print v(xbgr.mr_n85317984)
print v(xbgr.mr_n85318304)
print v(xbgr.mr_n85318416)
print v(xbgr.mr_n85318736)
print v(xbgr.mr_n85318848)
print v(xbgr.mr_n85319168)
print v(xbgr.mr_n85319280)
print v(xbgr.mr_n85319600)
print v(xbgr.mr_n85319712)
print v(xbgr.mr_n85320032)
print v(xbgr.mr_n85320144)
print v(xbgr.mr_n85320464)
print v(xbgr.mr_n85320576)
print v(xbgr.mr_n85320896)
print v(xbgr.mr_n85321008)
print v(xbgr.mr_n85321328)
print v(xbgr.mr_n85321440)
print v(xbgr.mr_n85321760)
print v(xbgr.mr_n85321872)
print v(xbgr.mr_n85322192)
print v(xbgr.mr_n85322304)
print v(xbgr.mr_n85322624)
print v(xbgr.mr_n85322736)
print v(xbgr.mr_n85323056)
print v(xbgr.mr_n85323168)
print v(xbgr.mr_n85323488)
print v(xbgr.mr_n85323600)
print v(xbgr.mr_n85323920)
print v(xbgr.mr_n85324032)
print v(xbgr.mr_n85324352)
print v(xbgr.mr_n85324464)
print v(xbgr.mr_n85324784)
print v(xbgr.mr_n85324896)
print v(xbgr.mr_n85325216)
print v(xbgr.mr_n85325328)
print v(xbgr.mr_n85325648)
print v(xbgr.mr_n85325760)
print v(xbgr.mr_n85326080)
print v(xbgr.mr_n85326192)
print v(xbgr.mr_n85326512)
print v(xbgr.mr_n85326624)
print v(xbgr.mr_n85326944)
print v(xbgr.mr_n85327056)
print v(xbgr.mr_n85327376)
print v(xbgr.mr_n85327488)
print v(xbgr.mr_n85327808)
print v(xbgr.mr_n85327920)
print v(xbgr.mr_n85328240)
print v(xbgr.mr_n85328352)
print v(xbgr.mr_n85328672)
print v(xbgr.mr_n85328784)
print v(xbgr.mr_n85329104)
print v(xbgr.mr_n85329216)
print v(xbgr.mr_n85329536)
print v(xbgr.mr_n85329648)
print v(xbgr.mr_n85329968)
print v(xbgr.mr_n85330080)
print v(xbgr.mr_n85330400)
print v(xbgr.mr_n85330512)
print v(xbgr.mr_n85330832)
print v(xbgr.mr_n85330944)
print v(xbgr.mr_n85331264)
print v(xbgr.mr_n85331376)
print v(xbgr.mr_n85331696)
print v(xbgr.mr_n85331808)
print v(xbgr.mr_n85332128)
print v(xbgr.mr_n85332240)
print v(xbgr.mr_n85332560)
print v(xbgr.mr_n85332672)
print v(xbgr.mr_n85332992)
print v(xbgr.mr_n85333104)
print v(xbgr.mr_n85333424)
print v(xbgr.mr_n85333536)
print v(xbgr.mr_n85333856)
print v(xbgr.mr_n85333968)
print v(xbgr.mr_n85334288)
print v(xbgr.mr_n85334400)
print v(xbgr.mr_n85334720)
print v(xbgr.mr_n85334832)
print v(xbgr.mr_n85335152)
print v(xbgr.mr_n85335264)
print v(xbgr.mr_n85335584)
print v(xbgr.mr_n85335696)
print v(xbgr.mr_n85336016)
print v(xbgr.mr_n85336128)
print v(xbgr.mr_n85336448)
print v(xbgr.mr_n85336560)
print v(xbgr.mr_n85336880)
print v(xbgr.mr_n85336992)
print v(xbgr.mr_n85337312)
print v(xbgr.mr_n85337424)
print v(xbgr.mr_n85337744)
print v(xbgr.mr_n85337856)
print v(xbgr.mr_n85338176)
print v(xbgr.mr_n85338288)
print v(xbgr.mr_n85338608)
print v(xbgr.mr_n85338720)
print v(xbgr.mr_n85339040)
print v(xbgr.mr_n85339152)
print v(xbgr.mr_n85339472)
print v(xbgr.mr_n85339584)
print v(xbgr.mr_n85339904)
print v(xbgr.mr_n85340016)
print v(xbgr.mr_n85340336)
print v(xbgr.mr_n85340448)
print v(xbgr.mr_n85340768)
print v(xbgr.mr_n85340880)
print v(xbgr.mr_n85341200)
print v(xbgr.mr_n85341312)
print v(xbgr.mr_n85341632)
print v(xbgr.mr_n85341744)
print v(xbgr.mr_n85342064)
print v(xbgr.mr_n85342176)
print v(xbgr.mr_n85342496)
print v(xbgr.mr_n85342608)
print v(xbgr.mr_n85342928)
print v(xbgr.mr_n85343040)
print v(xbgr.mr_n85343360)
print v(xbgr.mr_n85343472)
print v(xbgr.mr_n85343792)
print v(xbgr.mr_n85343904)
print v(xbgr.mr_n85344224)
print v(xbgr.mr_n85344336)
print v(xbgr.mr_n85344656)
print v(xbgr.mr_n85344768)
print v(xbgr.mr_n85345088)
print v(xbgr.mr_n85345200)
print v(xbgr.mr_n85345520)
print v(xbgr.mr_n85345632)
print v(xbgr.mr_n85345952)
print v(xbgr.mr_n85346064)
print v(xbgr.mr_n85346384)
print v(xbgr.mr_n85346496)
print v(xbgr.mr_n85346816)
print v(xbgr.mr_n85346928)
print v(xbgr.mr_n85347248)
print v(xbgr.mr_n85347360)
print v(xbgr.mr_n85347680)
print v(xbgr.mr_n85347792)
print v(xbgr.mr_n85348112)
print v(xbgr.mr_n85348224)
print v(xbgr.mr_n85348544)
print v(xbgr.mr_n85348656)
print v(xbgr.mr_n85348976)
print v(xbgr.mr_n85349088)
print v(xbgr.mr_n85349408)
print v(xbgr.mr_n85349520)
print v(xbgr.mr_n85349840)
print v(xbgr.mr_n85349952)
print v(xbgr.mr_n85350272)
print v(xbgr.mr_n85350384)
print v(xbgr.mr_n85350704)
print v(xbgr.mr_n85350816)
print v(xbgr.mr_n85351136)
print v(xbgr.mr_n85351248)
print v(xbgr.mr_n85351568)
print v(xbgr.mr_n85351680)
print v(xbgr.mr_n85352000)
print v(xbgr.mr_n85352112)
print v(xbgr.mr_n85352432)
print v(xbgr.mr_n85352544)
print v(xbgr.mr_n85352864)
print v(xbgr.mr_n85352976)
print v(xbgr.mr_n85353296)
print v(xbgr.mr_n85353408)
print v(xbgr.mr_n85353728)
print v(xbgr.mr_n85353840)
print v(xbgr.mr_n85354160)
print v(xbgr.mr_n85354272)
print v(xbgr.mr_n85354592)
print v(xbgr.mr_n85354704)
print v(xbgr.mr_n85355024)
print v(xbgr.mr_n85355136)
print v(xbgr.mr_n85355456)
print v(xbgr.mr_n85355568)
print v(xbgr.mr_n85355888)
print v(xbgr.mr_n85356000)
print v(xbgr.mr_n85356320)
print v(xbgr.mr_n85356432)
print v(xbgr.mr_n85356752)
print v(xbgr.mr_n85356864)
print v(xbgr.mr_n85357184)
print v(xbgr.mr_n85357296)
print v(xbgr.mr_n85357616)
print v(xbgr.mr_n85357728)
print v(xbgr.mr_n85358048)
print v(xbgr.mr_n85358160)
print v(xbgr.mr_n85358480)
print v(xbgr.mr_n85358592)
print v(xbgr.mr_n85358912)
print v(xbgr.mr_n85359024)
print v(xbgr.mr_n85359344)
print v(xbgr.mr_n85359456)
print v(xbgr.mr_n85359776)
print v(xbgr.mr_n85359888)
print v(xbgr.mr_n85360208)
print v(xbgr.mr_n85360320)
print v(xbgr.mr_n85360640)
print v(xbgr.mr_n85360752)
print v(xbgr.mr_n85361072)
print v(xbgr.mr_n85361184)
print v(xbgr.mr_n85361504)
print v(xbgr.mr_n85361616)
print v(xbgr.mr_n85361936)
print v(xbgr.mr_n85362048)
print v(xbgr.mr_n85362368)
print v(xbgr.mr_n85362480)
print v(xbgr.mr_n85362800)
print v(xbgr.mr_n85362912)
print v(xbgr.mr_n85363232)
print v(xbgr.mr_n85363344)
print v(xbgr.mr_n85363664)
print v(xbgr.mr_n85363776)
print v(xbgr.mr_n85364096)
print v(xbgr.mr_n85364208)
print v(xbgr.mr_n85364528)
print v(xbgr.mr_n85364640)
print v(xbgr.mr_n85364960)
print v(xbgr.mr_n85365072)
print v(xbgr.mr_n85365392)
print v(xbgr.mr_n85365504)
print v(xbgr.mr_n85365824)
print v(xbgr.mr_n85365936)
print v(xbgr.mr_n85366256)
print v(xbgr.mr_n85366368)
print v(xbgr.mr_n85366688)
print v(xbgr.mr_n85366800)
print v(xbgr.mr_n85367120)
print v(xbgr.mr_n85367232)
print v(xbgr.mr_n85367552)
print v(xbgr.mr_n85367664)
print v(xbgr.mr_n85367984)
print v(xbgr.mr_n85368096)
print v(xbgr.mr_n85368416)
print v(xbgr.mr_n85368528)
print v(xbgr.mr_n85368848)
print v(xbgr.mr_n85368960)
print v(xbgr.mr_n85369280)
print v(xbgr.mr_n85369392)
print v(xbgr.mr_n85369712)
print v(xbgr.mr_n85369824)
print v(xbgr.mr_n85370256)
print v(xbgr.mr_n85370576)
print v(xbgr.mr_n85370688)
print v(xbgr.mr_n85371008)
print v(xbgr.mr_n85371120)
print v(xbgr.mr_n85371440)
print v(xbgr.mr_n85371552)
print v(xbgr.mr_n85371984)
print v(xbgr.mr_n85372304)
print v(xbgr.mr_n85372416)
print v(xbgr.mr_n85372736)
print v(xbgr.mr_n85372848)
print v(xbgr.mr_n85373168)
print v(xbgr.mr_n85373280)
print v(xbgr.mr_n85373712)
print v(xbgr.mr_n85374032)
print v(xbgr.mr_n85374144)
print v(xbgr.mr_n85374464)
print v(xbgr.mr_n85374576)
print v(xbgr.mr_n85374896)
print v(xbgr.mr_n85375008)
print v(xbgr.mr_n85375440)
print v(xbgr.mr_n85375760)
print v(xbgr.mr_n85375872)
print v(xbgr.mr_n85376192)
print v(xbgr.mr_n85376304)
print v(xbgr.mr_n85376624)
print v(xbgr.mr_n85376736)
print v(xbgr.mr_n85377168)
print v(xbgr.mr_n85377488)
print v(xbgr.mr_n85377600)
print v(xbgr.mr_n85377920)
print v(xbgr.mr_n85378032)
print v(xbgr.mr_n85378352)
print v(xbgr.mr_n85378464)
print v(xbgr.mr_n85378896)
print v(xbgr.mr_n85379216)
print v(xbgr.mr_n85379328)
print v(xbgr.mr_n85379648)
print v(xbgr.mr_n85379760)
print v(xbgr.mr_n85380080)
print v(xbgr.mr_n85380192)
print v(xbgr.mr_n85380624)
print v(xbgr.mr_n85380944)
print v(xbgr.mr_n85381056)
print v(xbgr.mr_n85381376)
print v(xbgr.mr_n85381488)
print v(xbgr.mr_n85381808)
print v(xbgr.mr_n85381920)
print v(xbgr.mr_n85382352)
print v(xbgr.mr_n85382672)
print v(xbgr.mr_n85382784)
print v(xbgr.mr_n85383104)
print v(xbgr.mr_n85383216)
print v(xbgr.mr_n85383536)
print v(xbgr.mr_n85383648)
print v(xbgr.mr_n85383968)
print v(xbgr.mr_n85384080)
print v(xbgr.mr_n85384400)
print v(xbgr.mr_n85384512)
print v(xbgr.mr_n85384832)
print v(xbgr.mr_n85384944)
print v(xbgr.mr_n85385264)
print v(xbgr.mr_n85385376)
print v(xbgr.mr_n85385696)
print v(xbgr.mr_n85385808)
print v(xbgr.mr_n85386128)
print v(xbgr.mr_n85386240)
print v(xbgr.mr_n85386560)
print v(xbgr.mr_n85386672)
print v(xbgr.mr_n85386992)
print v(xbgr.mr_n85387104)
print v(xbgr.mr_n85387424)
print v(xbgr.mr_n85387536)
print v(xbgr.mr_n85387856)
print v(xbgr.mr_n85387968)
print v(xbgr.mr_n85388288)
print v(xbgr.mr_n85388400)
print v(xbgr.mr_n85388720)
print v(xbgr.mr_n85388832)
print v(xbgr.mr_n85389152)
print v(xbgr.mr_n85389264)
print v(xbgr.mr_n85389584)
print v(xbgr.mr_n85389696)
print v(xbgr.mr_n85390016)
print v(xbgr.mr_n85390128)
print v(xbgr.mr_n85390448)
print v(xbgr.mr_n85390560)
print v(xbgr.mr_n85390880)
print v(xbgr.mr_n85390992)
print v(xbgr.mr_n85391312)
print v(xbgr.mr_n85391424)
print v(xbgr.mr_n85391744)
print v(xbgr.mr_n85391856)
print v(xbgr.mr_n85392176)
print v(xbgr.mr_n85392288)
print v(xbgr.mr_n85392608)
print v(xbgr.mr_n85392720)
print v(xbgr.mr_n85393040)
print v(xbgr.mr_n85393152)
print v(xbgr.mr_n85393472)
print v(xbgr.mr_n85393584)
print v(xbgr.mr_n85393904)
print v(xbgr.mr_n85394016)
print v(xbgr.mr_n85394336)
print v(xbgr.mr_n85394448)
print v(xbgr.mr_n85394768)
print v(xbgr.mr_n85394880)
print v(xbgr.mr_n85395200)
print v(xbgr.mr_n85395312)
print v(xbgr.mr_n85395632)
print v(xbgr.mr_n85395744)
print v(xbgr.mr_n85396064)
print v(xbgr.mr_n85396176)
print v(xbgr.mr_n85396496)
print v(xbgr.mr_n85396608)
print v(xbgr.mr_n85396928)
print v(xbgr.mr_n85397040)
print v(xbgr.mr_n85397360)
print v(xbgr.mr_n85397472)
print v(xbgr.mr_n85397792)
print v(xbgr.mr_n85397904)
print v(xbgr.mr_n85398224)
print v(xbgr.mr_n85398336)
print v(xbgr.mr_n85398656)
print v(xbgr.mr_n85398768)
print v(xbgr.mr_n85399088)
print v(xbgr.mr_n85399200)
print v(xbgr.mr_n85399520)
print v(xbgr.mr_n85399632)
print v(xbgr.mr_n85399952)
print v(xbgr.mr_n85400064)
print v(xbgr.mr_n85400384)
print v(xbgr.mr_n85400496)
print v(xbgr.mr_n85400816)
print v(xbgr.mr_n85400928)
print v(xbgr.mr_n85401248)
print v(xbgr.mr_n85401360)
print v(xbgr.mr_n85401680)
print v(xbgr.mr_n85401792)
print v(xbgr.mr_n85402112)
print v(xbgr.mr_n85402224)
print v(xbgr.mr_n85402544)
print v(xbgr.mr_n85402656)
print v(xbgr.mr_n85402976)
print v(xbgr.mr_n85403088)
print v(xbgr.mr_n85403408)
print v(xbgr.mr_n85403520)
print v(xbgr.mr_n85403840)
print v(xbgr.mr_n85403952)
print v(xbgr.mr_n85404272)
print v(xbgr.mr_n85404384)
print v(xbgr.mr_n85404704)
print v(xbgr.mr_n85404816)
print v(xbgr.mr_n85405136)
print v(xbgr.mr_n85405248)
print v(xbgr.mr_n85405568)
print v(xbgr.mr_n85405680)
print v(xbgr.mr_n85406000)
print v(xbgr.mr_n85406112)
print v(xbgr.mr_n85406432)
print v(xbgr.mr_n85406544)
print v(xbgr.mr_n85406864)
print v(xbgr.mr_n85406976)
print v(xbgr.mr_n85407296)
print v(xbgr.mr_n85407408)
print v(xbgr.mr_n85407728)
print v(xbgr.mr_n85407840)
print v(xbgr.mr_n85408160)
print v(xbgr.mr_n85408272)
print v(xbgr.mr_n85408592)
print v(xbgr.mr_n85408704)
print v(xbgr.mr_n85409024)
print v(xbgr.mr_n85409136)
print v(xbgr.mr_n85409456)
print v(xbgr.mr_n85409568)
print v(xbgr.mr_n85409888)
print v(xbgr.mr_n85410000)
print v(xbgr.mr_n85410320)
print v(xbgr.mr_n85410432)
print v(xbgr.mr_n85410752)
print v(xbgr.mr_n85410864)
print v(xbgr.mr_n85411184)
print v(xbgr.mr_n85411296)
print v(xbgr.mr_n85411616)
print v(xbgr.mr_n85411728)
print v(xbgr.mr_n85412048)
print v(xbgr.mr_n85412160)
print v(xbgr.mr_n85412592)
print v(xbgr.mr_n85412912)
print v(xbgr.mr_n85413024)
print v(xbgr.mr_n85413344)
print v(xbgr.mr_n85413456)
print v(xbgr.mr_n85413776)
print v(xbgr.mr_n85413888)
print v(xbgr.mr_n85414320)
print v(xbgr.mr_n85414640)
print v(xbgr.mr_n85414752)
print v(xbgr.mr_n85415072)
print v(xbgr.mr_n85415184)
print v(xbgr.mr_n85415504)
print v(xbgr.mr_n85415616)
print v(xbgr.mr_n85416048)
print v(xbgr.mr_n85416368)
print v(xbgr.mr_n85416480)
print v(xbgr.mr_n85416800)
print v(xbgr.mr_n85416912)
print v(xbgr.mr_n85417232)
print v(xbgr.mr_n85417344)
print v(xbgr.mr_n85417664)
print v(xbgr.mr_n85417776)
print v(xbgr.mr_n85418096)
print v(xbgr.mr_n85418208)
print v(xbgr.mr_n85418528)
print v(xbgr.mr_n85418640)
print v(xbgr.mr_n85418960)
print v(xbgr.mr_n85419072)
print v(xbgr.mr_n85419392)
print v(xbgr.mr_n85419504)
print v(xbgr.mr_n85419824)
print v(xbgr.mr_n85419936)
print v(xbgr.mr_n85420368)
print v(xbgr.mr_n85420688)
print v(xbgr.mr_n85420800)
print v(xbgr.mr_n85421232)
print v(xbgr.mr_n85421552)
print v(xbgr.mr_n85421664)
print v(xbgr.mr_n85422096)
print v(xbgr.mr_n85422416)
print v(xbgr.mr_n85422528)
print v(xbgr.mr_n85422848)
print v(xbgr.mr_n85422960)
print v(xbgr.mr_n85423280)
print v(xbgr.mr_n85423392)
print v(xbgr.mr_n85423824)
print v(xbgr.mr_n85424144)
print v(xbgr.mr_n85424256)
print v(xbgr.mr_n85424576)
print v(xbgr.mr_n85424688)
print v(xbgr.mr_n85425008)
print v(xbgr.mr_n85425120)
print v(xbgr.mr_n85425440)
print v(xbgr.mr_n85425552)
print v(xbgr.mr_n85425872)
print v(xbgr.mr_n85425984)
print v(xbgr.mr_n85426416)
print v(xbgr.mr_n85426736)
print v(xbgr.mr_n85426848)
print v(xbgr.mr_n85427168)
print v(xbgr.mr_n85427280)
print v(xbgr.mr_n85427600)
print v(xbgr.mr_n85427712)
print v(xbgr.mr_n85428032)
print v(xbgr.mr_n85428144)
print v(xbgr.mr_n85428464)
print v(xbgr.mr_n85428576)
print v(xbgr.mr_n85428896)
print v(xbgr.mr_n85429008)
print v(xbgr.mr_n85429328)
print v(xbgr.mr_n85429440)
print v(xbgr.mr_n85429760)
print v(xbgr.mr_n85429872)
print v(xbgr.mr_n85430192)
print v(xbgr.mr_n85430304)
print v(xbgr.mr_n85430624)
print v(xbgr.mr_n85430736)
print v(xbgr.mr_n85431056)
print v(xbgr.mr_n85431168)
print v(xbgr.mr_n85431488)
print v(xbgr.mr_n85431600)
print v(xbgr.mr_n85431920)
print v(xbgr.mr_n85432032)
print v(xbgr.mr_n85432352)
print v(xbgr.mr_n85432464)
print v(xbgr.mr_n85432784)
print v(xbgr.mr_n85432896)
print v(xbgr.mr_n85433216)
print v(xbgr.mr_n85433328)
print v(xbgr.mr_n85433648)
print v(xbgr.mr_n85433760)
print v(xbgr.mr_n85434080)
print v(xbgr.mr_n85434192)
print v(xbgr.mr_n85434512)
print v(xbgr.mr_n85434624)
print v(xbgr.mr_n85434944)
print v(xbgr.mr_n85435056)
print v(xbgr.mr_n85435376)
print v(xbgr.mr_n85435488)
print v(xbgr.mr_n85435808)
print v(xbgr.mr_n85435920)
print v(xbgr.mr_n85436240)
print v(xbgr.mr_n85436352)
print v(xbgr.mr_n85436672)
print v(xbgr.mr_n85436784)
print v(xbgr.mr_n85437104)
print v(xbgr.mr_n85437216)
print v(xbgr.mr_n85437536)
print v(xbgr.mr_n85437648)
print v(xbgr.mr_n85437968)
print v(xbgr.mr_n85438080)
print v(xbgr.mr_n85438400)
print v(xbgr.mr_n85438512)
print v(xbgr.mr_n85438832)
print v(xbgr.mr_n85438944)
print v(xbgr.mr_n85439264)
print v(xbgr.mr_n85439376)
print v(xbgr.mr_n85439696)
print v(xbgr.mr_n85439808)
print v(xbgr.mr_n85440128)
print v(xbgr.mr_n85440240)
print v(xbgr.mr_n85440560)
print v(xbgr.mr_n85440672)
print v(xbgr.mr_n85440992)
print v(xbgr.mr_n85441104)
print v(xbgr.mr_n85441424)
print v(xbgr.mr_n85441536)
print v(xbgr.mr_n85441856)
print v(xbgr.mr_n85441968)
print v(xbgr.mr_n85442288)
print v(xbgr.mr_n85442400)
print v(xbgr.mr_n85442720)
print v(xbgr.mr_n85442832)
print v(xbgr.mr_n85443152)
print v(xbgr.mr_n85443264)
print v(xbgr.mr_n85443584)
print v(xbgr.mr_n85443696)
print v(xbgr.mr_n85444016)
print v(xbgr.mr_n85444128)
print v(xbgr.mr_n85444448)
print v(xbgr.mr_n85444560)
print v(xbgr.mr_n85444880)
print v(xbgr.mr_n85444992)
print v(xbgr.mr_n85445312)
print v(xbgr.mr_n85445424)
print v(xbgr.mr_n85445744)
print v(xbgr.mr_n85445856)
print v(xbgr.mr_n85446176)
print v(xbgr.mr_n85446288)
print v(xbgr.mr_n85446608)
print v(xbgr.mr_n85446720)
print v(xbgr.mr_n85447040)
print v(xbgr.mr_n85447152)
print v(xbgr.mr_n85447472)
print v(xbgr.mr_n85447584)
print v(xbgr.mr_n85447904)
print v(xbgr.mr_n85448016)
print v(xbgr.mr_n85448336)
print v(xbgr.mr_n85448448)
print v(xbgr.mr_n85448768)
print v(xbgr.mr_n85448880)
print v(xbgr.mr_n85449200)
print v(xbgr.mr_n85449312)
print v(xbgr.mr_n85449632)
print v(xbgr.mr_n85449744)
print v(xbgr.mr_n85450064)
print v(xbgr.mr_n85450176)
print v(xbgr.mr_n85450496)
print v(xbgr.mr_n85450608)
print v(xbgr.mr_n85450928)
print v(xbgr.mr_n85451040)
print v(xbgr.mr_n85451360)
print v(xbgr.mr_n85451472)
print v(xbgr.mr_n85451792)
print v(xbgr.mr_n85451904)
print v(xbgr.mr_n85452224)
print v(xbgr.mr_n85452336)
print v(xbgr.mr_n85452656)
print v(xbgr.mr_n85452768)
print v(xbgr.mr_n85453088)
print v(xbgr.mr_n85453200)
print v(xbgr.mr_n85453520)
print v(xbgr.mr_n85453632)
print v(xbgr.mr_n85453952)
print v(xbgr.mr_n85454064)
print v(xbgr.mr_n85454384)
print v(xbgr.mr_n85454496)
print v(xbgr.mr_n85454816)
print v(xbgr.mr_n85454928)
print v(xbgr.mr_n85455248)
print v(xbgr.mr_n85455360)
print v(xbgr.mr_n85455680)
print v(xbgr.mr_n85455792)
print v(xbgr.mr_n85456112)
print v(xbgr.mr_n85456224)
print v(xbgr.mr_n85456544)
print v(xbgr.mr_n85456656)
print v(xbgr.mr_n85456976)
print v(xbgr.mr_n85457088)
print v(xbgr.mr_n85457408)
print v(xbgr.mr_n85457520)
print v(xbgr.mr_n85457840)
print v(xbgr.mr_n85457952)
print v(xbgr.mr_n85458272)
print v(xbgr.mr_n85458384)
print v(xbgr.mr_n85458704)
print v(xbgr.mr_n85458816)
print v(xbgr.mr_n85459136)
print v(xbgr.mr_n85459248)
print v(xbgr.mr_n85459568)
print v(xbgr.mr_n85459680)
print v(xbgr.mr_n85460000)
print v(xbgr.mr_n85460112)
print v(xbgr.mr_n85460432)
print v(xbgr.mr_n85460544)
print v(xbgr.mr_n85460864)
print v(xbgr.mr_n85460976)
print v(xbgr.mr_n85461296)
print v(xbgr.mr_n85461408)
print v(xbgr.mr_n85461728)
print v(xbgr.mr_n85461840)
print v(xbgr.mr_n85462160)
print v(xbgr.mr_n85462272)
print v(xbgr.mr_n85462592)
print v(xbgr.mr_n85462704)
print v(xbgr.mr_n85463024)
print v(xbgr.mr_n85463136)
print v(xbgr.mr_n85463456)
print v(xbgr.mr_n85463568)
print v(xbgr.mr_n85463888)
print v(xbgr.mr_n85464000)
print v(xbgr.mr_n85464320)
print v(xbgr.mr_n85464432)
print v(xbgr.mr_n85464752)
print v(xbgr.mr_n85464864)
print v(xbgr.mr_n85465184)
print v(xbgr.mr_n85465296)
print v(xbgr.mr_n85465616)
print v(xbgr.mr_n85465728)
print v(xbgr.mr_n85466048)
print v(xbgr.mr_n85466160)
print v(xbgr.mr_n85466480)
print v(xbgr.mr_n85466592)
print v(xbgr.mr_n85466912)
print v(xbgr.mr_n85467024)
print v(xbgr.mr_n85467344)
print v(xbgr.mr_n85467456)
print v(xbgr.mr_n85467776)
print v(xbgr.mr_n85467888)
print v(xbgr.mr_n85468208)
print v(xbgr.mr_n85468320)
print v(xbgr.mr_n85468640)
print v(xbgr.mr_n85468752)
print v(xbgr.mr_n85469072)
print v(xbgr.mr_n85469184)
print v(xbgr.mr_n85469504)
print v(xbgr.mr_n85469616)
print v(xbgr.mr_n85469936)
print v(xbgr.mr_n85470048)
print v(xbgr.mr_n85470368)
print v(xbgr.mr_n85470480)
print v(xbgr.mr_n85470800)
print v(xbgr.mr_n85470912)
print v(xbgr.mr_n85471232)
print v(xbgr.mr_n85471344)
print v(xbgr.mr_n85471664)
print v(xbgr.mr_n85471776)
print v(xbgr.mr_n85472096)
print v(xbgr.mr_n85472208)
print v(xbgr.mr_n85472528)
print v(xbgr.mr_n85472640)
print v(xbgr.mr_n85472960)
print v(xbgr.mr_n85473072)
print v(xbgr.mr_n85473392)
print v(xbgr.mr_n85473504)
print v(xbgr.mr_n85473824)
print v(xbgr.mr_n85473936)
print v(xbgr.mr_n85474256)
print v(xbgr.mr_n85474368)
print v(xbgr.mr_n85474688)
print v(xbgr.mr_n85474800)
print v(xbgr.mr_n85475120)
print v(xbgr.mr_n85475232)
print v(xbgr.mr_n85475552)
print v(xbgr.mr_n85475664)
print v(xbgr.mr_n85475984)
print v(xbgr.mr_n85476096)
print v(xbgr.mr_n85476416)
print v(xbgr.mr_n85476528)
print v(xbgr.mr_n85476848)
print v(xbgr.mr_n85476960)
print v(xbgr.mr_n85477280)
print v(xbgr.mr_n85477392)
print v(xbgr.mr_n85477712)
print v(xbgr.mr_n85477824)
print v(xbgr.mr_n85478144)
print v(xbgr.mr_n85478256)
print v(xbgr.mr_n85478576)
print v(xbgr.mr_n85478688)
print v(xbgr.mr_n85479008)
print v(xbgr.mr_n85479120)
print v(xbgr.mr_n85479440)
print v(xbgr.mr_n85479552)
print v(xbgr.mr_n85479872)
print v(xbgr.mr_n85479984)
print v(xbgr.mr_n85480304)
print v(xbgr.mr_n85480416)
print v(xbgr.mr_n85480736)
print v(xbgr.mr_n85480848)
print v(xbgr.mr_n85481168)
print v(xbgr.mr_n85481280)
print v(xbgr.mr_n85481600)
print v(xbgr.mr_n85481712)
print v(xbgr.mr_n85482032)
print v(xbgr.mr_n85482144)
print v(xbgr.mr_n85482464)
print v(xbgr.mr_n85482576)
print v(xbgr.mr_n85482896)
print v(xbgr.mr_n85483008)
print v(xbgr.mr_n85483328)
print v(xbgr.mr_n85483440)
print v(xbgr.mr_n85483760)
print v(xbgr.mr_n85483872)
print v(xbgr.mr_n85484192)
print v(xbgr.mr_n85484304)
print v(xbgr.mr_n85484624)
print v(xbgr.mr_n85484736)
print v(xbgr.mr_n85485056)
print v(xbgr.mr_n85485168)
print v(xbgr.mr_n85485488)
print v(xbgr.mr_n85485600)
print v(xbgr.mr_n85485920)
print v(xbgr.mr_n85486032)
print v(xbgr.mr_n85486352)
print v(xbgr.mr_n85486464)
print v(xbgr.mr_n85486784)
print v(xbgr.mr_n85486896)
print v(xbgr.mr_n85487216)
print v(xbgr.mr_n85487328)
print v(xbgr.mr_n85487648)
print v(xbgr.mr_n85487760)
print v(xbgr.mr_n85488080)
print v(xbgr.mr_n85488192)
print v(xbgr.mr_n85488512)
print v(xbgr.mr_n85488624)
print v(xbgr.mr_n85488944)
print v(xbgr.mr_n85489056)
print v(xbgr.mr_n85489376)
print v(xbgr.mr_n85489488)
print v(xbgr.mr_n85489808)
print v(xbgr.mr_n85489920)
print v(xbgr.mr_n85490240)
print v(xbgr.mr_n85490352)
print v(xbgr.mr_n85490672)
print v(xbgr.mr_n85490784)
print v(xbgr.mr_n85491104)
print v(xbgr.mr_n85491216)
print v(xbgr.mr_n85491536)
print v(xbgr.mr_n85491648)
print v(xbgr.mr_n85491968)
print v(xbgr.mr_n85492080)
print v(xbgr.mr_n85492400)
print v(xbgr.mr_n85492512)
print v(xbgr.mr_n85492832)
print v(xbgr.mr_n85492944)
print v(xbgr.mr_n85493264)
print v(xbgr.mr_n85493376)
print v(xbgr.mr_n85493696)
print v(xbgr.mr_n85493808)
print v(xbgr.mr_n85494128)
print v(xbgr.mr_n85494240)
print v(xbgr.mr_n85494560)
print v(xbgr.mr_n85494672)
print v(xbgr.mr_n85494992)
print v(xbgr.mr_n85495104)
print v(xbgr.mr_n85495424)
print v(xbgr.mr_n85495536)
print v(xbgr.mr_n85495856)
print v(xbgr.mr_n85495968)
print v(xbgr.mr_n85496288)
print v(xbgr.mr_n85496400)
print v(xbgr.mr_n85496720)
print v(xbgr.mr_n85496832)
print v(xbgr.mr_n85497152)
print v(xbgr.mr_n85497264)
print v(xbgr.mr_n85497584)
print v(xbgr.mr_n85497696)
print v(xbgr.mr_n85498016)
print v(xbgr.mr_n85498128)
print v(xbgr.mr_n85498448)
print v(xbgr.mr_n85498560)
print v(xbgr.mr_n85498880)
print v(xbgr.mr_n85498992)
print v(xbgr.mr_n85499312)
print v(xbgr.mr_n85499424)
print v(xbgr.mr_n85499744)
print v(xbgr.mr_n85499856)
print v(xbgr.mr_n85500176)
print v(xbgr.mr_n85500288)
print v(xbgr.mr_n85500608)
print v(xbgr.mr_n85500720)
print v(xbgr.mr_n85501040)
print v(xbgr.mr_n85501152)
print v(xbgr.mr_n85501584)
print v(xbgr.mr_n85501904)
print v(xbgr.mr_n85502016)
print v(xbgr.mr_n85502448)
print v(xbgr.mr_n85502768)
print v(xbgr.mr_n85502880)
print v(xbgr.mr_n85503312)
print v(xbgr.mr_n85503632)
print v(xbgr.mr_n85504496)
print v(xbgr.mr_n85504608)
print v(xbgr.mr_n85505040)
print v(xbgr.mr_n85505360)
print v(xbgr.mr_n85505472)
print v(xbgr.mr_n85505792)
print v(xbgr.mr_n85505904)
print v(xbgr.mr_n85506224)
print v(xbgr.mr_n85506336)
print v(xbgr.mr_n85506656)
print v(xbgr.mr_n85506768)
print v(xbgr.mr_n85507088)
print v(xbgr.mr_n85507200)
print v(xbgr.mr_n85507520)
print v(xbgr.mr_n85507632)
print v(xbgr.mr_n85507952)
print v(xbgr.mr_n85508064)
print v(xbgr.mr_n85508384)
print v(xbgr.mr_n85508496)
print v(xbgr.mr_n85508816)
print v(xbgr.mr_n85509680)
print v(xbgr.mr_n85510544)
print v(xbgr.mr_n85510656)
print v(xbgr.mr_n85510976)
print v(xbgr.mr_n85511088)
print v(xbgr.mr_n85511408)
print v(xbgr.mr_n85512272)
print v(xbgr.mr_n85512384)
print v(xbgr.mr_n85512704)
print v(xbgr.mr_n85512816)
print v(xbgr.mr_n85513136)
print v(xbgr.mr_n85513248)
print v(xbgr.mr_n85513568)
print v(xbgr.mr_n85513680)
print v(xbgr.mr_n85514000)
print v(xbgr.mr_n85514112)
print v(xbgr.mr_n85514432)
print v(xbgr.mr_n85514544)
print v(xbgr.mr_n85514864)
print v(xbgr.mr_n85514976)
print v(xbgr.mr_n85515296)
print v(xbgr.mr_n85515408)
print v(xbgr.mr_n85515728)
print v(xbgr.mr_n85515840)
print v(xbgr.mr_n85516160)
print v(xbgr.mr_n85516272)
print v(xbgr.mr_n85516592)
print v(xbgr.mr_n85516704)
print v(xbgr.mr_n85517024)
print v(xbgr.mr_n85517136)
print v(xbgr.mr_n85517456)
print v(xbgr.mr_n85517568)
print v(xbgr.mr_n85517888)
print v(xbgr.mr_n85518000)
print v(xbgr.mr_n85518320)
print v(xbgr.mr_n85518432)
print v(xbgr.mr_n85518752)
print v(xbgr.mr_n85518864)
print v(xbgr.mr_n85519184)
print v(xbgr.mr_n85519296)
print v(xbgr.mr_n85519616)
print v(xbgr.mr_n85519728)
print v(xbgr.mr_n85520048)
print v(xbgr.mr_n85520160)
print v(xbgr.mr_n85520480)
print v(xbgr.mr_n85520592)
print v(xbgr.mr_n85520912)
print v(xbgr.mr_n85521024)
print v(xbgr.mr_n85521344)
print v(xbgr.mr_n85521456)
print v(xbgr.mr_n85521776)
print v(xbgr.mr_n85521888)
print v(xbgr.mr_n85522208)
print v(xbgr.mr_n85522320)
print v(xbgr.mr_n85522640)
print v(xbgr.mr_n85522752)
print v(xbgr.mr_n85523184)
print v(xbgr.mr_n85523504)
print v(xbgr.mr_n85523616)
print v(xbgr.mr_n85523936)
print v(xbgr.mr_n85524048)
print v(xbgr.mr_n85524368)
print v(xbgr.mr_n85524480)
print v(xbgr.mr_n85524800)
print v(xbgr.mr_n85524912)
print v(xbgr.mr_n85525232)
print v(xbgr.mr_n85525344)
print v(xbgr.mr_n85525664)
print v(xbgr.mr_n85525776)
print v(xbgr.mr_n85526096)
print v(xbgr.mr_n85526208)
print v(xbgr.mr_n85526528)
print v(xbgr.mr_n85526640)
print v(xbgr.mr_n85526960)
print v(xbgr.mr_n85527072)
print v(xbgr.mr_n85527392)
print v(xbgr.mr_n85527504)
print v(xbgr.mr_n85527824)
print v(xbgr.mr_n85527936)
print v(xbgr.mr_n85528256)
print v(xbgr.mr_n85528368)
print v(xbgr.mr_n85528688)
print v(xbgr.mr_n85528800)
print v(xbgr.mr_n85529120)
print v(xbgr.mr_n85529232)
print v(xbgr.mr_n85529552)
print v(xbgr.mr_n85530416)
print v(xbgr.mr_n85530528)
print v(xbgr.mr_n85530848)
print v(xbgr.mr_n85530960)
print v(xbgr.mr_n85531280)
print v(xbgr.mr_n85531392)
print v(xbgr.mr_n85531712)
print v(xbgr.mr_n85531824)
print v(xbgr.mr_n85532144)
print v(xbgr.mr_n85532256)
print v(xbgr.mr_n85532576)
print v(xbgr.mr_n85532688)
print v(xbgr.mr_n85533008)
print v(xbgr.mr_n85533120)
print v(xbgr.mr_n85533440)
print v(xbgr.mr_n85533552)
print v(xbgr.mr_n85533872)
print v(xbgr.mr_n85533984)
print v(xbgr.mr_n85534304)
print v(xbgr.mr_n85534416)
print v(xbgr.mr_n85534736)
print v(xbgr.mr_n85534848)
print v(xbgr.mr_n85535168)
print v(xbgr.mr_n85535280)
print v(xbgr.mr_n85535600)
print v(xbgr.mr_n85535712)
print v(xbgr.mr_n85536032)
print v(xbgr.mr_n85536144)
print v(xbgr.mr_n85536464)
print v(xbgr.mr_n85536576)
print v(xbgr.mr_n85536896)
print v(xbgr.mr_n85537008)
print v(xbgr.mr_n85537328)
print v(xbgr.mr_n85537440)
print v(xbgr.mr_n85537760)
print v(xbgr.mr_n85537872)
print v(xbgr.mr_n85538192)
print v(xbgr.mr_n85538304)
print v(xbgr.mr_n85538624)
print v(xbgr.mr_n85538736)
print v(xbgr.mr_n85539056)
print v(xbgr.mr_n85539168)
print v(xbgr.mr_n85539488)
print v(xbgr.mr_n85539600)
print v(xbgr.mr_n85539920)
print v(xbgr.mr_n85540032)
print v(xbgr.mr_n85540352)
print v(xbgr.mr_n85540464)
print v(xbgr.mr_n85540784)
print v(xbgr.mr_n85540896)
print v(xbgr.mr_n85541216)
print v(xbgr.mr_n85541328)
print v(xbgr.mr_n85541648)
print v(xbgr.mr_n85541760)
print v(xbgr.mr_n85542080)
print v(xbgr.mr_n85542192)
print v(xbgr.mr_n85542512)
print v(xbgr.mr_n85542624)
print v(xbgr.mr_n85542944)
print v(xbgr.mr_n85543056)
print v(xbgr.mr_n85543376)
print v(xbgr.mr_n85543488)
print v(xbgr.mr_n85543808)
print v(xbgr.mr_n85543920)
print v(xbgr.mr_n85544240)
print v(xbgr.mr_n85544352)
print v(xbgr.mr_n85544672)
print v(xbgr.mr_n85544784)
print v(xbgr.mr_n85545104)
print v(xbgr.mr_n85545216)
print v(xbgr.mr_n85545536)
print v(xbgr.mr_n85545648)
print v(xbgr.mr_n85545968)
print v(xbgr.mr_n85546080)
print v(xbgr.mr_n85546400)
print v(xbgr.mr_n85546512)
print v(xbgr.mr_n85546832)
print v(xbgr.mr_n85546944)
print v(xbgr.mr_n85547264)
print v(xbgr.mr_n85547376)
print v(xbgr.mr_n85547696)
print v(xbgr.mr_n85547808)
print v(xbgr.mr_n85548128)
print v(xbgr.mr_n85548240)
print v(xbgr.mr_n85548560)
print v(xbgr.mr_n85548672)
print v(xbgr.mr_n85548992)
print v(xbgr.mr_n85549104)
print v(xbgr.mr_n85549424)
print v(xbgr.mr_n85549536)
print v(xbgr.mr_n85549856)
print v(xbgr.mr_n85549968)
print v(xbgr.mr_n85550288)
print v(xbgr.mr_n85550400)
print v(xbgr.mr_n85550720)
print v(xbgr.mr_n85550832)
print v(xbgr.mr_n85551152)
print v(xbgr.mr_n85551264)
print v(xbgr.mr_n85551584)
print v(xbgr.mr_n85551696)
print v(xbgr.mr_n85552016)
print v(xbgr.mr_n85552128)
print v(xbgr.mr_n85552448)
print v(xbgr.mr_n85552560)
print v(xbgr.mr_n85552880)
print v(xbgr.mr_n85552992)
print v(xbgr.mr_n85553312)
print v(xbgr.mr_n85553424)
print v(xbgr.mr_n85553744)
print v(xbgr.mr_n85553856)
print v(xbgr.mr_n85554176)
print v(xbgr.mr_n85554288)
print v(xbgr.mr_n85554608)
print v(xbgr.mr_n85554720)
print v(xbgr.mr_n85555040)
print v(xbgr.mr_n85555152)
print v(xbgr.mr_n85555472)
print v(xbgr.mr_n85555584)
print v(xbgr.mr_n85555904)
print v(xbgr.mr_n85556016)
print v(xbgr.mr_n85556336)
print v(xbgr.mr_n85556448)
print v(xbgr.mr_n85556768)
print v(xbgr.mr_n85556880)
print v(xbgr.mr_n85557200)
print v(xbgr.mr_n85557312)
print v(xbgr.mr_n85557632)
print v(xbgr.mr_n85557744)
print v(xbgr.mr_n85558064)
print v(xbgr.mr_n85558176)
print v(xbgr.mr_n85558496)
print v(xbgr.mr_n85558608)
print v(xbgr.mr_n85558928)
print v(xbgr.mr_n85559040)
print v(xbgr.mr_n85559360)
print v(xbgr.mr_n85559472)
print v(xbgr.mr_n85559792)
print v(xbgr.mr_n85559904)
print v(xbgr.mr_n85560224)
print v(xbgr.mr_n85560336)
print v(xbgr.mr_n85560656)
print v(xbgr.mr_n85560768)
print v(xbgr.mr_n85561088)
print v(xbgr.mr_n85561200)
print v(xbgr.mr_n85561520)
print v(xbgr.mr_n85561632)
print v(xbgr.mr_n85561952)
print v(xbgr.mr_n85562064)
print v(xbgr.mr_n85562384)
print v(xbgr.mr_n85562496)
print v(xbgr.mr_n85562816)
print v(xbgr.mr_n85562928)
print v(xbgr.mr_n85563248)
print v(xbgr.mr_n85563360)
print v(xbgr.mr_n85563680)
print v(xbgr.mr_n85563792)
print v(xbgr.mr_n85564112)
print v(xbgr.mr_n85564224)
print v(xbgr.mr_n85564544)
print v(xbgr.mr_n85564656)
print v(xbgr.mr_n85564976)
print v(xbgr.mr_n85565088)
print v(xbgr.mr_n85565408)
print v(xbgr.mr_n85565520)
print v(xbgr.mr_n85565840)
print v(xbgr.mr_n85565952)
print v(xbgr.mr_n85566272)
print v(xbgr.mr_n85566384)
print v(xbgr.mr_n85566704)
print v(xbgr.mr_n85566816)
print v(xbgr.mr_n85567136)
print v(xbgr.mr_n85567248)
print v(xbgr.mr_n85567568)
print v(xbgr.mr_n85567680)
print v(xbgr.mr_n85568000)
print v(xbgr.mr_n85568112)
print v(xbgr.mr_n85568432)
print v(xbgr.mr_n85568544)
print v(xbgr.mr_n85568864)
print v(xbgr.mr_n85568976)
print v(xbgr.mr_n85569296)
print v(xbgr.mr_n85569408)
print v(xbgr.mr_n85569728)
print v(xbgr.mr_n85569840)
print v(xbgr.mr_n85570160)
print v(xbgr.mr_n85570272)
print v(xbgr.mr_n85570592)
print v(xbgr.mr_n85570704)
print v(xbgr.mr_n85571024)
print v(xbgr.mr_n85571136)
print v(xbgr.mr_n85571456)
print v(xbgr.mr_n85571568)
print v(xbgr.mr_n85571888)
print v(xbgr.mr_n85572000)
print v(xbgr.mr_n85572320)
print v(xbgr.mr_n85572432)
print v(xbgr.mr_n85572752)
print v(xbgr.mr_n85572864)
print v(xbgr.mr_n85573184)
print v(xbgr.mr_n85573296)
print v(xbgr.mr_n85573616)
print v(xbgr.mr_n85573728)
print v(xbgr.mr_n85574048)
print v(xbgr.mr_n85574160)
print v(xbgr.mr_n85574480)
print v(xbgr.mr_n85574592)
print v(xbgr.mr_n85574912)
print v(xbgr.mr_n85575024)
print v(xbgr.mr_n85575344)
print v(xbgr.mr_n85575456)
print v(xbgr.mr_n85575776)
print v(xbgr.mr_n85575888)
print v(xbgr.mr_n85576208)
print v(xbgr.mr_n85576320)
print v(xbgr.mr_n85576640)
print v(xbgr.mr_n85576752)
print v(xbgr.mr_n85577072)
print v(xbgr.mr_n85577184)
print v(xbgr.mr_n85577504)
print v(xbgr.mr_n85577616)
print v(xbgr.mr_n85577936)
print v(xbgr.mr_n85578048)
print v(xbgr.mr_n85578368)
print v(xbgr.mr_n85578480)
print v(xbgr.mr_n85578800)
print v(xbgr.mr_n85578912)
print v(xbgr.mr_n85579232)
print v(xbgr.mr_n85579344)
print v(xbgr.mr_n85579664)
print v(xbgr.mr_n85579776)
print v(xbgr.mr_n85580096)
print v(xbgr.mr_n85580208)
print v(xbgr.mr_n85580528)
print v(xbgr.mr_n85580640)
print v(xbgr.mr_n85580960)
print v(xbgr.mr_n85581072)
print v(xbgr.mr_n85581392)
print v(xbgr.mr_n85581504)
print v(xbgr.mr_n85581824)
print v(xbgr.mr_n85581936)
print v(xbgr.mr_n85582256)
print v(xbgr.mr_n85582368)
print v(xbgr.mr_n85582688)
print v(xbgr.mr_n85582800)
print v(xbgr.mr_n85583120)
print v(xbgr.mr_n85583232)
print v(xbgr.mr_n85583552)
print v(xbgr.mr_n85583664)
print v(xbgr.mr_n85583984)
print v(xbgr.mr_n85584096)
print v(xbgr.mr_n85584416)
print v(xbgr.mr_n85584528)
print v(xbgr.mr_n85584848)
print v(xbgr.mr_n85584960)
print v(xbgr.mr_n85585280)
print v(xbgr.mr_n85585392)
print v(xbgr.mr_n85585712)
print v(xbgr.mr_n85585824)
print v(xbgr.mr_n85586144)
print v(xbgr.mr_n85586256)
print v(xbgr.mr_n85586576)
print v(xbgr.mr_n85586688)
print v(xbgr.mr_n85587008)
print v(xbgr.mr_n85587120)
print v(xbgr.mr_n85587440)
print v(xbgr.mr_n85587552)
print v(xbgr.mr_n85587872)
print v(xbgr.mr_n85587984)
print v(xbgr.mr_n85588304)
print v(xbgr.mr_n85588416)
print v(xbgr.mr_n85588736)
print v(xbgr.mr_n85588848)
print v(xbgr.mr_n85589168)
print v(xbgr.mr_n85589280)
print v(xbgr.mr_n85589600)
print v(xbgr.mr_n85589712)
print v(xbgr.mr_n85590032)
print v(xbgr.mr_n85590144)
print v(xbgr.mr_n85590464)
print v(xbgr.mr_n85590576)
print v(xbgr.mr_n85590896)
print v(xbgr.mr_n85591008)
print v(xbgr.mr_n85591328)
print v(xbgr.mr_n85591440)
print v(xbgr.mr_n85591760)
print v(xbgr.mr_n85591872)
print v(xbgr.mr_n85592192)
print v(xbgr.mr_n85592304)
print v(xbgr.mr_n85592624)
print v(xbgr.mr_n85592736)
print v(xbgr.mr_n85593056)
print v(xbgr.mr_n85593168)
print v(xbgr.mr_n85593488)
print v(xbgr.mr_n85593600)
print v(xbgr.mr_n85593920)
print v(xbgr.mr_n85594032)
print v(xbgr.mr_n85594352)
print v(xbgr.mr_n85594464)
print v(xbgr.mr_n85594784)
print v(xbgr.mr_n85594896)
print v(xbgr.mr_n85595216)
print v(xbgr.mr_n85595328)
print v(xbgr.mr_n85595648)
print v(xbgr.mr_n85595760)
print v(xbgr.mr_n85596080)
print v(xbgr.mr_n85596192)
print v(xbgr.mr_n85596512)
print v(xbgr.mr_n85596624)
print v(xbgr.mr_n85596944)
print v(xbgr.mr_n85597056)
print v(xbgr.mr_n85597376)
print v(xbgr.mr_n85597488)
print v(xbgr.mr_n85597808)
print v(xbgr.mr_n85597920)
print v(xbgr.mr_n85598240)
print v(xbgr.mr_n85598352)
print v(xbgr.mr_n85598672)
print v(xbgr.mr_n85598784)
print v(xbgr.mr_n85599104)
print v(xbgr.mr_n85599216)
print v(xbgr.mr_n85599536)
print v(xbgr.mr_n85599648)
print v(xbgr.mr_n85599968)
print v(xbgr.mr_n85600080)
print v(xbgr.mr_n85600400)
print v(xbgr.mr_n85600512)
print v(xbgr.mr_n85600832)
print v(xbgr.mr_n85600944)
print v(xbgr.mr_n85601264)
print v(xbgr.mr_n85601376)
print v(xbgr.mr_n85601696)
print v(xbgr.mr_n85601808)
print v(xbgr.mr_n85602128)
print v(xbgr.mr_n85602240)
print v(xbgr.mr_n85602560)
print v(xbgr.mr_n85602672)
print v(xbgr.mr_n85602992)
print v(xbgr.mr_n85603104)
print v(xbgr.mr_n85603424)
print v(xbgr.mr_n85603536)
print v(xbgr.mr_n85603856)
print v(xbgr.mr_n85603968)
print v(xbgr.mr_n85604288)
print v(xbgr.mr_n85604400)
print v(xbgr.mr_n85604720)
print v(xbgr.mr_n85604832)
print v(xbgr.mr_n85605152)
print v(xbgr.mr_n85605264)
print v(xbgr.mr_n85605584)
print v(xbgr.mr_n85605696)
print v(xbgr.mr_n85606016)
print v(xbgr.mr_n85606128)
print v(xbgr.mr_n85606448)
print v(xbgr.mr_n85606560)
print v(xbgr.mr_n85606880)
print v(xbgr.mr_n85606992)
print v(xbgr.mr_n85607312)
print v(xbgr.mr_n85607424)
print v(xbgr.mr_n85607744)
print v(xbgr.mr_n85607856)
print v(xbgr.mr_n85608176)
print v(xbgr.mr_n85608288)
print v(xbgr.mr_n85608608)
print v(xbgr.mr_n85608720)
print v(xbgr.mr_n85609040)
print v(xbgr.mr_n85609152)
print v(xbgr.mr_n85609472)
print v(xbgr.mr_n85609584)
print v(xbgr.mr_n85609904)
print v(xbgr.mr_n85610016)
print v(xbgr.mr_n85610336)
print v(xbgr.mr_n85610448)
print v(xbgr.mr_n85610768)
print v(xbgr.mr_n85610880)
print v(xbgr.mr_n85611200)
print v(xbgr.mr_n85611312)
print v(xbgr.mr_n85611632)
print v(xbgr.mr_n85611744)
print v(xbgr.mr_n85612064)
print v(xbgr.mr_n85612176)
print v(xbgr.mr_n85612496)
print v(xbgr.mr_n85612608)
print v(xbgr.mr_n85612928)
print v(xbgr.mr_n85613040)
print v(xbgr.mr_n85613360)
print v(xbgr.mr_n85613472)
print v(xbgr.mr_n85613792)
print v(xbgr.mr_n85613904)
print v(xbgr.mr_n85614224)
print v(xbgr.mr_n85614336)
print v(xbgr.mr_n85614656)
print v(xbgr.mr_n85614768)
print v(xbgr.mr_n85615088)
print v(xbgr.mr_n85615200)
print v(xbgr.mr_n85615520)
print v(xbgr.mr_n85615632)
print v(xbgr.mr_n85615952)
print v(xbgr.mr_n85616064)
print v(xbgr.mr_n85616384)
print v(xbgr.mr_n85616496)
print v(xbgr.mr_n85616816)
print v(xbgr.mr_n85616928)
print v(xbgr.mr_n85617248)
print v(xbgr.mr_n85617360)
print v(xbgr.mr_n85617680)
print v(xbgr.mr_n85617792)
print v(xbgr.mr_n85618112)
print v(xbgr.mr_n85618224)
print v(xbgr.mr_n85618544)
print v(xbgr.mr_n85618656)
print v(xbgr.mr_n85618976)
print v(xbgr.mr_n85619088)
print v(xbgr.mr_n85619408)
print v(xbgr.mr_n85619520)
print v(xbgr.mr_n85619840)
print v(xbgr.mr_n85619952)
print v(xbgr.mr_n85620272)
print v(xbgr.mr_n85620384)
print v(xbgr.mr_n85620704)
print v(xbgr.mr_n85620816)
print v(xbgr.mr_n85621136)
print v(xbgr.mr_n85621248)
print v(xbgr.mr_n85621568)
print v(xbgr.mr_n85621680)
print v(xbgr.mr_n85622000)
print v(xbgr.mr_n85622112)
print v(xbgr.mr_n85622432)
print v(xbgr.mr_n85622544)
print v(xbgr.mr_n85622864)
print v(xbgr.mr_n85622976)
print v(xbgr.mr_n85623296)
print v(xbgr.mr_n85623408)
print v(xbgr.mr_n85623728)
print v(xbgr.mr_n85623840)
print v(xbgr.mr_n85624160)
print v(xbgr.mr_n85624272)
print v(xbgr.mr_n85624592)
print v(xbgr.mr_n85624704)
print v(xbgr.mr_n85625024)
print v(xbgr.mr_n85625136)
print v(xbgr.mr_n85625456)
print v(xbgr.mr_n85625568)
print v(xbgr.mr_n85625888)
print v(xbgr.mr_n85626000)
print v(xbgr.mr_n85626320)
print v(xbgr.mr_n85626432)
print v(xbgr.mr_n85626752)
print v(xbgr.mr_n85626864)
print v(xbgr.mr_n85627184)
print v(xbgr.mr_n85627296)
print v(xbgr.mr_n85627616)
print v(xbgr.mr_n85627728)
print v(xbgr.mr_n85628048)
print v(xbgr.mr_n85628160)
print v(xbgr.mr_n85628480)
print v(xbgr.mr_n85628592)
print v(xbgr.mr_n85628912)
print v(xbgr.mr_n85629024)
print v(xbgr.mr_n85629344)
print v(xbgr.mr_n85629456)
print v(xbgr.mr_n85629776)
print v(xbgr.mr_n85629888)
print v(xbgr.mr_n85630208)
print v(xbgr.mr_n85630320)
print v(xbgr.mr_n85630640)
print v(xbgr.mr_n85630752)
print v(xbgr.mr_n85631072)
print v(xbgr.mr_n85631184)
print v(xbgr.mr_n85631504)
print v(xbgr.mr_n85631616)
print v(xbgr.mr_n85631936)
print v(xbgr.mr_n85632048)
print v(xbgr.mr_n85632368)
print v(xbgr.mr_n85632480)
print v(xbgr.mr_n85632800)
print v(xbgr.mr_n85632912)
print v(xbgr.mr_n85633232)
print v(xbgr.mr_n85633344)
print v(xbgr.mr_n85633664)
print v(xbgr.mr_n85633776)
print v(xbgr.mr_n85634096)
print v(xbgr.mr_n85634208)
print v(xbgr.mr_n85634528)
print v(xbgr.mr_n85634640)
print v(xbgr.mr_n85634960)
print v(xbgr.mr_n85635072)
print v(xbgr.mr_n85635392)
print v(xbgr.mr_n85635504)
print v(xbgr.mr_n85635824)
print v(xbgr.mr_n85635936)
print v(xbgr.mr_n85636256)
print v(xbgr.mr_n85636368)
print v(xbgr.mr_n85636688)
print v(xbgr.mr_n85636800)
print v(xbgr.mr_n85637120)
print v(xbgr.mr_n85637232)
print v(xbgr.mr_n85637552)
print v(xbgr.mr_n85637664)
print v(xbgr.mr_n85637984)
print v(xbgr.mr_n85638096)
print v(xbgr.mr_n85638416)
print v(xbgr.mr_n85638528)
print v(xbgr.mr_n85638848)
print v(xbgr.mr_n85638960)
print v(xbgr.mr_n85639280)
print v(xbgr.mr_n85639392)
print v(xbgr.mr_n85639712)
print v(xbgr.mr_n85639824)
print v(xbgr.mr_n85640144)
print v(xbgr.mr_n85640256)
print v(xbgr.mr_n85640576)
print v(xbgr.mr_n85640688)
print v(xbgr.mr_n85641008)
print v(xbgr.mr_n85641120)
print v(xbgr.mr_n85641440)
print v(xbgr.mr_n85641552)
print v(xbgr.mr_n85641872)
print v(xbgr.mr_n85641984)
print v(xbgr.mr_n85642304)
print v(xbgr.mr_n85642416)
print v(xbgr.mr_n85642736)
print v(xbgr.mr_n85642848)
print v(xbgr.mr_n85643168)
print v(xbgr.mr_n85643280)
print v(xbgr.mr_n85643600)
print v(xbgr.mr_n85643712)
print v(xbgr.mr_n85644032)
print v(xbgr.mr_n85644144)
print v(xbgr.mr_n85644464)
print v(xbgr.mr_n85644576)
print v(xbgr.mr_n85644896)
print v(xbgr.mr_n85645008)
print v(xbgr.mr_n85645328)
print v(xbgr.mr_n85645440)
print v(xbgr.mr_n85645760)
print v(xbgr.mr_n85645872)
print v(xbgr.mr_n85646192)
print v(xbgr.mr_n85646304)
print v(xbgr.mr_n85646624)
print v(xbgr.mr_n85646736)
print v(xbgr.mr_n85647056)
print v(xbgr.mr_n85647168)
print v(xbgr.mr_n85647488)
print v(xbgr.mr_n85647600)
print v(xbgr.mr_n85647920)
print v(xbgr.mr_n85648032)
print v(xbgr.mr_n85648352)
print v(xbgr.mr_n85648464)
print v(xbgr.mr_n85648784)
print v(xbgr.mr_n85648896)
print v(xbgr.mr_n85649216)
print v(xbgr.mr_n85649328)
print v(xbgr.mr_n85649648)
print v(xbgr.mr_n85649760)
print v(xbgr.mr_n85650080)
print v(xbgr.mr_n85650192)
print v(xbgr.mr_n85650512)
print v(xbgr.mr_n85650624)
print v(xbgr.mr_n85650944)
print v(xbgr.mr_n85651056)
print v(xbgr.mr_n85651376)
print v(xbgr.mr_n85651488)
print v(xbgr.mr_n85651808)
print v(xbgr.mr_n85651920)
print v(xbgr.mr_n85652240)
print v(xbgr.mr_n85652352)
print v(xbgr.mr_n85652672)
print v(xbgr.mr_n85652784)
print v(xbgr.mr_n85653104)
print v(xbgr.mr_n85653216)
print v(xbgr.mr_n85653536)
print v(xbgr.mr_n85653648)
print v(xbgr.mr_n85653968)
print v(xbgr.mr_n85654080)
print v(xbgr.mr_n85654400)
print v(xbgr.mr_n85654512)
print v(xbgr.mr_n85654832)
print v(xbgr.mr_n85654944)
print v(xbgr.mr_n85655264)
print v(xbgr.mr_n85655376)
print v(xbgr.mr_n85655696)
print v(xbgr.mr_n85655808)
print v(xbgr.mr_n85656128)
print v(xbgr.mr_n85656240)
print v(xbgr.mr_n85656560)
print v(xbgr.mr_n85656672)
print v(xbgr.mr_n85656992)
print v(xbgr.mr_n85657104)
print v(xbgr.mr_n85657424)
print v(xbgr.mr_n85657536)
print v(xbgr.mr_n85657856)
print v(xbgr.mr_n85657968)
print v(xbgr.mr_n85658288)
print v(xbgr.mr_n85658400)
print v(xbgr.mr_n85658720)
print v(xbgr.mr_n85658832)
print v(xbgr.mr_n85659152)
print v(xbgr.mr_n85659264)
print v(xbgr.mr_n85659584)
print v(xbgr.mr_n85659696)
print v(xbgr.mr_n85660016)
print v(xbgr.mr_n85660128)
print v(xbgr.mr_n85660448)
print v(xbgr.mr_n85660560)
print v(xbgr.mr_n85660880)
print v(xbgr.mr_n85660992)
print v(xbgr.mr_n85661312)
print v(xbgr.mr_n85661424)
print v(xbgr.mr_n85661744)
print v(xbgr.mr_n85661856)
print v(xbgr.mr_n85662176)
print v(xbgr.mr_n85662288)
print v(xbgr.mr_n85662608)
print v(xbgr.mr_n85662720)
print v(xbgr.mr_n85663040)
print v(xbgr.mr_n85663152)
print v(xbgr.mr_n85663472)
print v(xbgr.mr_n85663584)
print v(xbgr.mr_n85663904)
print v(xbgr.mr_n85664016)
print v(xbgr.mr_n85664336)
print v(xbgr.mr_n85664448)
print v(xbgr.mr_n85664768)
print v(xbgr.mr_n85664880)
print v(xbgr.mr_n85665200)
print v(xbgr.mr_n85665312)
print v(xbgr.mr_n85665632)
print v(xbgr.mr_n85665744)
print v(xbgr.mr_n85666064)
print v(xbgr.mr_n85666176)
print v(xbgr.mr_n85666496)
print v(xbgr.mr_n85666608)
print v(xbgr.mr_n85666928)
print v(xbgr.mr_n85667040)
print v(xbgr.mr_n85667360)
print v(xbgr.mr_n85667472)
print v(xbgr.mr_n85667792)
print v(xbgr.mr_n85667904)
print v(xbgr.mr_n85668224)
print v(xbgr.mr_n85668336)
print v(xbgr.mr_n85668656)
print v(xbgr.mr_n85668768)
print v(xbgr.mr_n85669088)
print v(xbgr.mr_n85669200)
print v(xbgr.mr_n85669520)
print v(xbgr.mr_n85669632)
print v(xbgr.mr_n85669952)
print v(xbgr.mr_n85670064)
print v(xbgr.mr_n85670384)
print v(xbgr.mr_n85670496)
print v(xbgr.mr_n85670816)
print v(xbgr.mr_n85670928)
print v(xbgr.mr_n85671248)
print v(xbgr.mr_n85671360)
print v(xbgr.mr_n85671680)
print v(xbgr.mr_n85671792)
print v(xbgr.mr_n85672112)
print v(xbgr.mr_n85672224)
print v(xbgr.mr_n85672544)
print v(xbgr.mr_n85672656)
print v(xbgr.mr_n85672976)
print v(xbgr.mr_n85673088)
print v(xbgr.mr_n85673408)
print v(xbgr.mr_n85673520)
print v(xbgr.mr_n85673840)
print v(xbgr.mr_n85673952)
print v(xbgr.mr_n85674272)
print v(xbgr.mr_n85674384)
print v(xbgr.mr_n85674704)
print v(xbgr.mr_n85674816)
print v(xbgr.mr_n85675136)
print v(xbgr.mr_n85675248)
print v(xbgr.mr_n85675568)
print v(xbgr.mr_n85675680)
print v(xbgr.mr_n85676000)
print v(xbgr.mr_n85676112)
print v(xbgr.mr_n85676432)
print v(xbgr.mr_n85676544)
print v(xbgr.mr_n85676864)
print v(xbgr.mr_n85676976)
print v(xbgr.mr_n85677296)
print v(xbgr.mr_n85677408)
print v(xbgr.mr_n85677728)
print v(xbgr.mr_n85677840)
print v(xbgr.mr_n85678160)
print v(xbgr.mr_n85678272)
print v(xbgr.mr_n85678592)
print v(xbgr.mr_n85678704)
print v(xbgr.mr_n85679024)
print v(xbgr.mr_n85679136)
print v(xbgr.mr_n85679456)
print v(xbgr.mr_n85679568)
print v(xbgr.mr_n85679888)
print v(xbgr.mr_n85680000)
print v(xbgr.mr_n85680320)
print v(xbgr.mr_n85680432)
print v(xbgr.mr_n85680752)
print v(xbgr.mr_n85680864)
print v(xbgr.mr_n85681184)
print v(xbgr.mr_n85681296)
print v(xbgr.mr_n85681616)
print v(xbgr.mr_n85681728)
print v(xbgr.mr_n85682048)
print v(xbgr.mr_n85682160)
print v(xbgr.mr_n85682480)
print v(xbgr.mr_n85682592)
print v(xbgr.mr_n85682912)
print v(xbgr.mr_n85683024)
print v(xbgr.mr_n85683344)
print v(xbgr.mr_n85683456)
print v(xbgr.mr_n85683776)
print v(xbgr.mr_n85683888)
print v(xbgr.mr_n85684208)
print v(xbgr.mr_n85684320)
print v(xbgr.mr_n85684640)
print v(xbgr.mr_n85684752)
print v(xbgr.mr_n85685072)
print v(xbgr.mr_n85685184)
print v(xbgr.mr_n85685504)
print v(xbgr.mr_n85685616)
print v(xbgr.mr_n85685936)
print v(xbgr.mr_n85686048)
print v(xbgr.mr_n85686368)
print v(xbgr.mr_n85686480)
print v(xbgr.mr_n85686800)
print v(xbgr.mr_n85686912)
print v(xbgr.mr_n85687232)
print v(xbgr.mr_n85687344)
print v(xbgr.mr_n85687664)
print v(xbgr.mr_n85687776)
print v(xbgr.mr_n85688096)
print v(xbgr.mr_n85688208)
print v(xbgr.mr_n85688528)
print v(xbgr.mr_n85688640)
print v(xbgr.mr_n85688960)
print v(xbgr.mr_n85689072)
print v(xbgr.mr_n85689392)
print v(xbgr.mr_n85689504)
print v(xbgr.mr_n85689824)
print v(xbgr.mr_n85689936)
print v(xbgr.mr_n85690256)
print v(xbgr.mr_n85690368)
print v(xbgr.mr_n85690688)
print v(xbgr.mr_n85690800)
print v(xbgr.mr_n85691120)
print v(xbgr.mr_n85691232)
print v(xbgr.mr_n85691552)
print v(xbgr.mr_n85691664)
print v(xbgr.mr_n85691984)
print v(xbgr.mr_n85692096)
print v(xbgr.mr_n85692416)
print v(xbgr.mr_n85692528)
print v(xbgr.mr_n85692848)
print v(xbgr.mr_n85692960)
print v(xbgr.mr_n85693280)
print v(xbgr.mr_n85693392)
print v(xbgr.mr_n85693712)
print v(xbgr.mr_n85693824)
print v(xbgr.mr_n85694144)
print v(xbgr.mr_n85694256)
print v(xbgr.mr_n85694576)
print v(xbgr.mr_n85694688)
print v(xbgr.mr_n85695008)
print v(xbgr.mr_n85695120)
print v(xbgr.mr_n85695440)
print v(xbgr.mr_n85695552)
print v(xbgr.mr_n85695872)
print v(xbgr.mr_n85695984)
print v(xbgr.mr_n85696304)
print v(xbgr.mr_n85696416)
print v(xbgr.mr_n85696736)
print v(xbgr.mr_n85696848)
print v(xbgr.mr_n85697168)
print v(xbgr.mr_n85697280)
print v(xbgr.mr_n85697600)
print v(xbgr.mr_n85697712)
print v(xbgr.mr_n85698032)
print v(xbgr.mr_n85698144)
print v(xbgr.mr_n85698464)
print v(xbgr.mr_n85698576)
print v(xbgr.mr_n85698896)
print v(xbgr.mr_n85699008)
print v(xbgr.mr_n85699328)
print v(xbgr.mr_n85699440)
print v(xbgr.mr_n85699760)
print v(xbgr.mr_n85699872)
print v(xbgr.mr_n85700192)
print v(xbgr.mr_n85700304)
print v(xbgr.mr_n85700624)
print v(xbgr.mr_n85700736)
print v(xbgr.mr_n85701056)
print v(xbgr.mr_n85701168)
print v(xbgr.mr_n85701488)
print v(xbgr.mr_n85701600)
print v(xbgr.mr_n85702032)
print v(xbgr.mr_n85702352)
print v(xbgr.mr_n85702464)
print v(xbgr.mr_n85702784)
print v(xbgr.mr_n85702896)
print v(xbgr.mr_n85703216)
print v(xbgr.mr_n85703328)
print v(xbgr.mr_n85703648)
print v(xbgr.mr_n85703760)
print v(xbgr.mr_n85704080)
print v(xbgr.mr_n85704944)
print v(xbgr.mr_n85705056)
print v(xbgr.mr_n85705376)
print v(xbgr.mr_n85705488)
print v(xbgr.mr_n85705808)
print v(xbgr.mr_n85705920)
print v(xbgr.mr_n85706240)
print v(xbgr.mr_n85706352)
print v(xbgr.mr_n85706672)
print v(xbgr.mr_n85706784)
print v(xbgr.mr_n85707104)
print v(xbgr.mr_n85707216)
print v(xbgr.mr_n85707536)
print v(xbgr.mr_n85707648)
print v(xbgr.mr_n85707968)
print v(xbgr.mr_n85708080)
print v(xbgr.mr_n85708400)
print v(xbgr.mr_n85708512)
print v(xbgr.mr_n85708832)
print v(xbgr.mr_n85708944)
print v(xbgr.mr_n85709264)
print v(xbgr.mr_n85709376)
print v(xbgr.mr_n85709808)
print v(xbgr.mr_n85710128)
print v(xbgr.mr_n85710240)
print v(xbgr.mr_n85710560)
print v(xbgr.mr_n85710672)
print v(xbgr.mr_n85710992)
print v(xbgr.mr_n85711104)
print v(xbgr.mr_n85711424)
print v(xbgr.mr_n85711536)
print v(xbgr.mr_n85711856)
print v(xbgr.mr_n85711968)
print v(xbgr.mr_n85712288)
print v(xbgr.mr_n85712400)
print v(xbgr.mr_n85712720)
print v(xbgr.mr_n85712832)
print v(xbgr.mr_n85713152)
print v(xbgr.mr_n85713264)
print v(xbgr.mr_n85713584)
print v(xbgr.mr_n85713696)
print v(xbgr.mr_n85714016)
print v(xbgr.mr_n85714128)
print v(xbgr.mr_n85714448)
print v(xbgr.mr_n85714560)
print v(xbgr.mr_n85714880)
print v(xbgr.mr_n85714992)
print v(xbgr.mr_n85715312)
print v(xbgr.mr_n85715424)
print v(xbgr.mr_n85715744)
print v(xbgr.mr_n85715856)
print v(xbgr.mr_n85716176)
print v(xbgr.mr_n85716288)
print v(xbgr.mr_n85716608)
print v(xbgr.mr_n85716720)
print v(xbgr.mr_n85717040)
print v(xbgr.mr_n85717152)
print v(xbgr.mr_n85717472)
print v(xbgr.mr_n85717584)
print v(xbgr.mr_n85717904)
print v(xbgr.mr_n85718016)
print v(xbgr.mr_n85718336)
print v(xbgr.mr_n85718448)
print v(xbgr.mr_n85718768)
print v(xbgr.mr_n85718880)
print v(xbgr.mr_n85719200)
print v(xbgr.mr_n85719312)
print v(xbgr.mr_n85719632)
print v(xbgr.mr_n85719744)
print v(xbgr.mr_n85720064)
print v(xbgr.mr_n85720176)
print v(xbgr.mr_n85720496)
print v(xbgr.mr_n85720608)
print v(xbgr.mr_n85720928)
print v(xbgr.mr_n85721040)
print v(xbgr.mr_n85721360)
print v(xbgr.mr_n85721472)
print v(xbgr.mr_n85721792)
print v(xbgr.mr_n85721904)
print v(xbgr.mr_n85722224)
print v(xbgr.mr_n85722336)
print v(xbgr.mr_n85722656)
print v(xbgr.mr_n85722768)
print v(xbgr.mr_n85723088)
print v(xbgr.mr_n85723200)
print v(xbgr.mr_n85723520)
print v(xbgr.mr_n85723632)
print v(xbgr.mr_n85723952)
print v(xbgr.mr_n85724064)
print v(xbgr.mr_n85724384)
print v(xbgr.mr_n85724496)
print v(xbgr.mr_n85724816)
print v(xbgr.mr_n85724928)
print v(xbgr.mr_n85725248)
print v(xbgr.mr_n85725360)
print v(xbgr.mr_n85725680)
print v(xbgr.mr_n85725792)
print v(xbgr.mr_n85726112)
print v(xbgr.mr_n85726224)
print v(xbgr.mr_n85726544)
print v(xbgr.mr_n85727408)
print v(xbgr.mr_n85727520)
print v(xbgr.mr_n85727840)
print v(xbgr.mr_n85727952)
print v(xbgr.mr_n85728272)
print v(xbgr.mr_n85728384)
print v(xbgr.mr_n85728704)
print v(xbgr.mr_n85728816)
print v(xbgr.mr_n85729136)
print v(xbgr.mr_n85729248)
print v(xbgr.mr_n85729568)
print v(xbgr.mr_n85729680)
print v(xbgr.mr_n85730000)
print v(xbgr.mr_n85730112)
print v(xbgr.mr_n85730432)
print v(xbgr.mr_n85730544)
print v(xbgr.mr_n85730864)
print v(xbgr.mr_n85730976)
print v(xbgr.mr_n85731296)
print v(xbgr.mr_n85731408)
print v(xbgr.mr_n85731728)
print v(xbgr.mr_n85731840)
print v(xbgr.mr_n85732160)
print v(xbgr.mr_n85732272)
print v(xbgr.mr_n85732592)
print v(xbgr.mr_n85732704)
print v(xbgr.mr_n85733024)
print v(xbgr.mr_n85733136)
print v(xbgr.mr_n85733456)
print v(xbgr.mr_n85733568)
print v(xbgr.mr_n85733888)
print v(xbgr.mr_n85734000)
print v(xbgr.mr_n85734320)
print v(xbgr.mr_n85734432)
print v(xbgr.mr_n85734752)
print v(xbgr.mr_n85734864)
print v(xbgr.mr_n85735184)
print v(xbgr.mr_n85735296)
print v(xbgr.mr_n85735616)
print v(xbgr.mr_n85735728)
print v(xbgr.mr_n85736048)
print v(xbgr.mr_n85736160)
print v(xbgr.mr_n85736480)
print v(xbgr.mr_n85736592)
print v(xbgr.mr_n85736912)
print v(xbgr.mr_n85737024)
print v(xbgr.mr_n85737344)
print v(xbgr.mr_n85737456)
print v(xbgr.mr_n85737776)
print v(xbgr.mr_n85737888)
print v(xbgr.mr_n85738208)
print v(xbgr.mr_n85738320)
print v(xbgr.mr_n85738640)
print v(xbgr.mr_n85738752)
print v(xbgr.mr_n85739072)
print v(xbgr.mr_n85739184)
print v(xbgr.mr_n85739504)
print v(xbgr.mr_n85739616)
print v(xbgr.mr_n85739936)
print v(xbgr.mr_n85740048)
print v(xbgr.mr_n85740368)
print v(xbgr.mr_n85740480)
print v(xbgr.mr_n85740800)
print v(xbgr.mr_n85740912)
print v(xbgr.mr_n85741232)
print v(xbgr.mr_n85741344)
print v(xbgr.mr_n85741664)
print v(xbgr.mr_n85741776)
print v(xbgr.mr_n85742096)
print v(xbgr.mr_n85742208)
print v(xbgr.mr_n85742528)
print v(xbgr.mr_n85742640)
print v(xbgr.mr_n85742960)
print v(xbgr.mr_n85743072)
print v(xbgr.mr_n85743392)
print v(xbgr.mr_n85743504)
print v(xbgr.mr_n85743824)
print v(xbgr.mr_n85743936)
print v(xbgr.mr_n85744256)
print v(xbgr.mr_n85744368)
print v(xbgr.mr_n85744688)
print v(xbgr.mr_n85744800)
print v(xbgr.mr_n85745120)
print v(xbgr.mr_n85745232)
print v(xbgr.mr_n85745552)
print v(xbgr.mr_n85745664)
print v(xbgr.mr_n85745984)
print v(xbgr.mr_n85746096)
print v(xbgr.mr_n85746416)
print v(xbgr.mr_n85746528)
print v(xbgr.mr_n85746848)
print v(xbgr.mr_n85746960)
print v(xbgr.mr_n85747280)
print v(xbgr.mr_n85747392)
print v(xbgr.mr_n85747712)
print v(xbgr.mr_n85747824)
print v(xbgr.mr_n85748144)
print v(xbgr.mr_n85748256)
print v(xbgr.mr_n85748576)
print v(xbgr.mr_n85748688)
print v(xbgr.mr_n85749008)
print v(xbgr.mr_n85749120)
print v(xbgr.mr_n85749440)
print v(xbgr.mr_n85749552)
print v(xbgr.mr_n85749872)
print v(xbgr.mr_n85749984)
print v(xbgr.mr_n85750304)
print v(xbgr.mr_n85750416)
print v(xbgr.mr_n85750736)
print v(xbgr.mr_n85750848)
print v(xbgr.mr_n85751168)
print v(xbgr.mr_n85751280)
print v(xbgr.mr_n85751600)
print v(xbgr.mr_n85751712)
print v(xbgr.mr_n85752032)
print v(xbgr.mr_n85752144)
print v(xbgr.mr_n85752464)
print v(xbgr.mr_n85752576)
print v(xbgr.mr_n85752896)
print v(xbgr.mr_n85753008)
print v(xbgr.mr_n85753328)
print v(xbgr.mr_n85753440)
print v(xbgr.mr_n85753760)
print v(xbgr.mr_n85753872)
print v(xbgr.mr_n85754192)
print v(xbgr.mr_n85754304)
print v(xbgr.mr_n85754624)
print v(xbgr.mr_n85754736)
print v(xbgr.mr_n85755056)
print v(xbgr.mr_n85755168)
print v(xbgr.mr_n85755488)
print v(xbgr.mr_n85755600)
print v(xbgr.mr_n85755920)
print v(xbgr.mr_n85756032)
print v(xbgr.mr_n85756352)
print v(xbgr.mr_n85756464)
print v(xbgr.mr_n85756784)
print v(xbgr.mr_n85756896)
print v(xbgr.mr_n85757216)
print v(xbgr.mr_n85757328)
print v(xbgr.mr_n85757648)
print v(xbgr.mr_n85757760)
print v(xbgr.mr_n85758080)
print v(xbgr.mr_n85758192)
print v(xbgr.mr_n85758512)
print v(xbgr.mr_n85758624)
print v(xbgr.mr_n85758944)
print v(xbgr.mr_n85759056)
print v(xbgr.mr_n85759376)
print v(xbgr.mr_n85759488)
print v(xbgr.mr_n85759808)
print v(xbgr.mr_n85759920)
print v(xbgr.mr_n85760240)
print v(xbgr.mr_n85760352)
print v(xbgr.mr_n85760672)
print v(xbgr.mr_n85760784)
print v(xbgr.mr_n85761104)
print v(xbgr.mr_n85761216)
print v(xbgr.mr_n85761536)
print v(xbgr.mr_n85761648)
print v(xbgr.mr_n85761968)
print v(xbgr.mr_n85762080)
print v(xbgr.mr_n85762400)
print v(xbgr.mr_n85762512)
print v(xbgr.mr_n85762832)
print v(xbgr.mr_n85762944)
print v(xbgr.mr_n85763264)
print v(xbgr.mr_n85763376)
print v(xbgr.mr_n85763696)
print v(xbgr.mr_n85763808)
print v(xbgr.mr_n85764128)
print v(xbgr.mr_n85764240)
print v(xbgr.mr_n85764560)
print v(xbgr.mr_n85764672)
print v(xbgr.mr_n85764992)
print v(xbgr.mr_n85765104)
print v(xbgr.mr_n85765424)
print v(xbgr.mr_n85765536)
print v(xbgr.mr_n85765856)
print v(xbgr.mr_n85765968)
print v(xbgr.mr_n85766288)
print v(xbgr.mr_n85766400)
print v(xbgr.mr_n85766720)
print v(xbgr.mr_n85766832)
print v(xbgr.mr_n85767152)
print v(xbgr.mr_n85767264)
print v(xbgr.mr_n85767584)
print v(xbgr.mr_n85767696)
print v(xbgr.mr_n85768016)
print v(xbgr.mr_n85768128)
print v(xbgr.mr_n85768448)
print v(xbgr.mr_n85768560)
print v(xbgr.mr_n85768880)
print v(xbgr.mr_n85768992)
print v(xbgr.mr_n85769312)
print v(xbgr.mr_n85769424)
print v(xbgr.mr_n85769744)
print v(xbgr.mr_n85769856)
print v(xbgr.mr_n85770176)
print v(xbgr.mr_n85770288)
print v(xbgr.mr_n85770608)
print v(xbgr.mr_n85770720)
print v(xbgr.mr_n85771040)
print v(xbgr.mr_n85771152)
print v(xbgr.mr_n85771472)
print v(xbgr.mr_n85771584)
print v(xbgr.mr_n85771904)
print v(xbgr.mr_n85772016)
print v(xbgr.mr_n85772336)
print v(xbgr.mr_n85772448)
print v(xbgr.mr_n85772768)
print v(xbgr.mr_n85772880)
print v(xbgr.mr_n85773200)
print v(xbgr.mr_n85773312)
print v(xbgr.mr_n85773632)
print v(xbgr.mr_n85773744)
print v(xbgr.mr_n85774064)
print v(xbgr.mr_n85774176)
print v(xbgr.mr_n85774496)
print v(xbgr.mr_n85774608)
print v(xbgr.mr_n85774928)
print v(xbgr.mr_n85775040)
print v(xbgr.mr_n85775360)
print v(xbgr.mr_n85775472)
print v(xbgr.mr_n85775792)
print v(xbgr.mr_n85775904)
print v(xbgr.mr_n85776224)
print v(xbgr.mr_n85776336)
print v(xbgr.mr_n85776656)
print v(xbgr.mr_n85776768)
print v(xbgr.mr_n85777088)
print v(xbgr.mr_n85777200)
print v(xbgr.mr_n85777520)
print v(xbgr.mr_n85777632)
print v(xbgr.mr_n85777952)
print v(xbgr.mr_n85778064)
print v(xbgr.mr_n85778384)
print v(xbgr.mr_n85778496)
print v(xbgr.mr_n85778816)
print v(xbgr.mr_n85778928)
print v(xbgr.mr_n85779248)
print v(xbgr.mr_n85779360)
print v(xbgr.mr_n85779680)
print v(xbgr.mr_n85779792)
print v(xbgr.mr_n85780112)
print v(xbgr.mr_n85780224)
print v(xbgr.mr_n85780544)
print v(xbgr.mr_n85780656)
print v(xbgr.mr_n85780976)
print v(xbgr.mr_n85781088)
print v(xbgr.mr_n85781408)
print v(xbgr.mr_n85781520)
print v(xbgr.mr_n85781840)
print v(xbgr.mr_n85781952)
print v(xbgr.mr_n85782272)
print v(xbgr.mr_n85782384)
print v(xbgr.mr_n85782704)
print v(xbgr.mr_n85782816)
print v(xbgr.mr_n85783136)
print v(xbgr.mr_n85783248)
print v(xbgr.mr_n85783568)
print v(xbgr.mr_n85783680)
print v(xbgr.mr_n85784000)
print v(xbgr.mr_n85784112)
print v(xbgr.mr_n85784432)
print v(xbgr.mr_n85784544)
print v(xbgr.mr_n85784864)
print v(xbgr.mr_n85784976)
print v(xbgr.mr_n85785296)
print v(xbgr.mr_n85785408)
print v(xbgr.mr_n85785728)
print v(xbgr.mr_n85785840)
print v(xbgr.mr_n85786160)
print v(xbgr.mr_n85786272)
print v(xbgr.mr_n85786592)
print v(xbgr.mr_n85786704)
print v(xbgr.mr_n85787024)
print v(xbgr.mr_n85787136)
print v(xbgr.mr_n85787456)
print v(xbgr.mr_n85787568)
print v(xbgr.mr_n85787888)
print v(xbgr.mr_n85788000)
print v(xbgr.mr_n85788320)
print v(xbgr.mr_n85788432)
print v(xbgr.mr_n85788752)
print v(xbgr.mr_n85788864)
print v(xbgr.mr_n85789184)
print v(xbgr.mr_n85789296)
print v(xbgr.mr_n85789616)
print v(xbgr.mr_n85789728)
print v(xbgr.mr_n85790048)
print v(xbgr.mr_n85790160)
print v(xbgr.mr_n85790480)
print v(xbgr.mr_n85790592)
print v(xbgr.mr_n85790912)
print v(xbgr.mr_n85791024)
print v(xbgr.mr_n85791344)
print v(xbgr.mr_n85791456)
print v(xbgr.mr_n85791776)
print v(xbgr.mr_n85791888)
print v(xbgr.mr_n85792208)
print v(xbgr.mr_n85792320)
print v(xbgr.mr_n85792640)
print v(xbgr.mr_n85792752)
print v(xbgr.mr_n85793072)
print v(xbgr.mr_n85793184)
print v(xbgr.mr_n85793504)
print v(xbgr.mr_n85793616)
print v(xbgr.mr_n85793936)
print v(xbgr.mr_n85794048)
print v(xbgr.mr_n85794368)
print v(xbgr.mr_n85794480)
print v(xbgr.mr_n85794800)
print v(xbgr.mr_n85794912)
print v(xbgr.mr_n85795232)
print v(xbgr.mr_n85795344)
print v(xbgr.mr_n85795664)
print v(xbgr.mr_n85795776)
print v(xbgr.mr_n85796096)
print v(xbgr.mr_n85796208)
print v(xbgr.mr_n85796528)
print v(xbgr.mr_n85796640)
print v(xbgr.mr_n85796960)
print v(xbgr.mr_n85797072)
print v(xbgr.mr_n85797392)
print v(xbgr.mr_n85797504)
print v(xbgr.mr_n85797824)
print v(xbgr.mr_n85797936)
print v(xbgr.mr_n85798256)
print v(xbgr.mr_n85798368)
print v(xbgr.mr_n85798688)
print v(xbgr.mr_n85798800)
print v(xbgr.mr_n85799120)
print v(xbgr.mr_n85799232)
print v(xbgr.mr_n85799552)
print v(xbgr.mr_n85799664)
print v(xbgr.mr_n85799984)
print v(xbgr.mr_n85800096)
print v(xbgr.mr_n85800416)
print v(xbgr.mr_n85800528)
print v(xbgr.mr_n85800848)
print v(xbgr.mr_n85800960)
print v(xbgr.mr_n85801280)
print v(xbgr.mr_n85801392)
print v(xbgr.mr_n85801712)
print v(xbgr.mr_n85801824)
print v(xbgr.mr_n85802144)
print v(xbgr.mr_n85802256)
print v(xbgr.mr_n85802576)
print v(xbgr.mr_n85802688)
print v(xbgr.mr_n85803008)
print v(xbgr.mr_n85803120)
print v(xbgr.mr_n85803440)
print v(xbgr.mr_n85803552)
print v(xbgr.mr_n85803872)
print v(xbgr.mr_n85803984)
print v(xbgr.mr_n85804304)
print v(xbgr.mr_n85804416)
print v(xbgr.mr_n85804736)
print v(xbgr.mr_n85804848)
print v(xbgr.mr_n85805168)
print v(xbgr.mr_n85805280)
print v(xbgr.mr_n85805600)
print v(xbgr.mr_n85805712)
print v(xbgr.mr_n85806032)
print v(xbgr.mr_n85806144)
print v(xbgr.mr_n85806464)
print v(xbgr.mr_n85806576)
print v(xbgr.mr_n85806896)
print v(xbgr.mr_n85807008)
print v(xbgr.mr_n85807328)
print v(xbgr.mr_n85807440)
print v(xbgr.mr_n85807760)
print v(xbgr.mr_n85807872)
print v(xbgr.mr_n85808192)
print v(xbgr.mr_n85808304)
print v(xbgr.mr_n85808624)
print v(xbgr.mr_n85808736)
print v(xbgr.mr_n85809056)
print v(xbgr.mr_n85809168)
print v(xbgr.mr_n85809488)
print v(xbgr.mr_n85809600)
print v(xbgr.mr_n85809920)
print v(xbgr.mr_n85810032)
print v(xbgr.mr_n85810352)
print v(xbgr.mr_n85810464)
print v(xbgr.mr_n85810784)
print v(xbgr.mr_n85810896)
print v(xbgr.mr_n85811216)
print v(xbgr.mr_n85811328)
print v(xbgr.mr_n85811648)
print v(xbgr.mr_n85811760)
print v(xbgr.mr_n85812080)
print v(xbgr.mr_n85812192)
print v(xbgr.mr_n85812512)
print v(xbgr.mr_n85812624)
print v(xbgr.mr_n85812944)
print v(xbgr.mr_n85813056)
print v(xbgr.mr_n85813376)
print v(xbgr.mr_n85813488)
print v(xbgr.mr_n85813808)
print v(xbgr.mr_n85813920)
print v(xbgr.mr_n85814240)
print v(xbgr.mr_n85814352)
print v(xbgr.mr_n85814672)
print v(xbgr.mr_n85814784)
print v(xbgr.mr_n85815104)
print v(xbgr.mr_n85815216)
print v(xbgr.mr_n85815536)
print v(xbgr.mr_n85815648)
print v(xbgr.mr_n85815968)
print v(xbgr.mr_n85816080)
print v(xbgr.mr_n85816400)
print v(xbgr.mr_n85816512)
print v(xbgr.mr_n85816832)
print v(xbgr.mr_n85816944)
print v(xbgr.mr_n85817264)
print v(xbgr.mr_n85817376)
print v(xbgr.mr_n85817696)
print v(xbgr.mr_n85817808)
print v(xbgr.mr_n85818128)
print v(xbgr.mr_n85818240)
print v(xbgr.mr_n85818560)
print v(xbgr.mr_n85818672)
print v(xbgr.mr_n85818992)
print v(xbgr.mr_n85819104)
print v(xbgr.mr_n85819424)
print v(xbgr.mr_n85819536)
print v(xbgr.mr_n85819856)
print v(xbgr.mr_n85819968)
print v(xbgr.mr_n85820288)
print v(xbgr.mr_n85820400)
print v(xbgr.mr_n85820720)
print v(xbgr.mr_n85820832)
print v(xbgr.mr_n85821152)
print v(xbgr.mr_n85821264)
print v(xbgr.mr_n85821584)
print v(xbgr.mr_n85821696)
print v(xbgr.mr_n85822016)
print v(xbgr.mr_n85822128)
print v(xbgr.mr_n85822448)
print v(xbgr.mr_n85822560)
print v(xbgr.mr_n85822880)
print v(xbgr.mr_n85822992)
print v(xbgr.mr_n85823312)
print v(xbgr.mr_n85823424)
print v(xbgr.mr_n85823744)
print v(xbgr.mr_n85823856)
print v(xbgr.mr_n85824176)
print v(xbgr.mr_n85824288)
print v(xbgr.mr_n85824608)
print v(xbgr.mr_n85824720)
print v(xbgr.mr_n85825040)
print v(xbgr.mr_n85825152)
print v(xbgr.mr_n85825472)
print v(xbgr.mr_n85825584)
print v(xbgr.mr_n85825904)
print v(xbgr.mr_n85826016)
print v(xbgr.mr_n85826336)
print v(xbgr.mr_n85826448)
print v(xbgr.mr_n85826768)
print v(xbgr.mr_n85826880)
print v(xbgr.mr_n85827200)
print v(xbgr.mr_n85827312)
print v(xbgr.mr_n85827632)
print v(xbgr.mr_n85827744)
print v(xbgr.mr_n85828064)
print v(xbgr.mr_n85828176)
print v(xbgr.mr_n85828496)
print v(xbgr.mr_n85828608)
print v(xbgr.mr_n85828928)
print v(xbgr.mr_n85829040)
print v(xbgr.mr_n85829360)
print v(xbgr.mr_n85829472)
print v(xbgr.mr_n85829792)
print v(xbgr.mr_n85829904)
print v(xbgr.mr_n85830224)
print v(xbgr.mr_n85830336)
print v(xbgr.mr_n85830656)
print v(xbgr.mr_n85830768)
print v(xbgr.mr_n85831088)
print v(xbgr.mr_n85831200)
print v(xbgr.mr_n85831520)
print v(xbgr.mr_n85831632)
print v(xbgr.mr_n85831952)
print v(xbgr.mr_n85832064)
print v(xbgr.mr_n85832384)
print v(xbgr.mr_n85832496)
print v(xbgr.mr_n85832816)
print v(xbgr.mr_n85832928)
print v(xbgr.mr_n85833248)
print v(xbgr.mr_n85833360)
print v(xbgr.mr_n85833680)
print v(xbgr.mr_n85833792)
print v(xbgr.mr_n85834112)
print v(xbgr.mr_n85834224)
print v(xbgr.mr_n85834544)
print v(xbgr.mr_n85834656)
print v(xbgr.mr_n85834976)
print v(xbgr.mr_n85835088)
print v(xbgr.mr_n85835408)
print v(xbgr.mr_n85835520)
print v(xbgr.mr_n85835840)
print v(xbgr.mr_n85835952)
print v(xbgr.mr_n85836272)
print v(xbgr.mr_n85836384)
print v(xbgr.mr_n85836704)
print v(xbgr.mr_n85836816)
print v(xbgr.mr_n85837136)
print v(xbgr.mr_n85837248)
print v(xbgr.mr_n85837568)
print v(xbgr.mr_n85837680)
print v(xbgr.mr_n85838000)
print v(xbgr.mr_n85838112)
print v(xbgr.mr_n85838432)
print v(xbgr.mr_n85838544)
print v(xbgr.mr_n85838864)
print v(xbgr.mr_n85838976)
print v(xbgr.mr_n85839296)
print v(xbgr.mr_n85839408)
print v(xbgr.mr_n85839728)
print v(xbgr.mr_n85839840)
print v(xbgr.mr_n85840160)
print v(xbgr.mr_n85840272)
print v(xbgr.mr_n85840592)
print v(xbgr.mr_n85840704)
print v(xbgr.mr_n85841024)
print v(xbgr.mr_n85841136)
print v(xbgr.mr_n85841456)
print v(xbgr.mr_n85841568)
print v(xbgr.mr_n85841888)
print v(xbgr.mr_n85842000)
print v(xbgr.mr_n85842320)
print v(xbgr.mr_n85842432)
print v(xbgr.mr_n85842752)
print v(xbgr.mr_n85842864)
print v(xbgr.mr_n85843184)
print v(xbgr.mr_n85843296)
print v(xbgr.mr_n85843616)
print v(xbgr.mr_n85843728)
print v(xbgr.mr_n85844048)
print v(xbgr.mr_n85844160)
print v(xbgr.mr_n85844480)
print v(xbgr.mr_n85844592)
print v(xbgr.mr_n85844912)
print v(xbgr.mr_n85845024)
print v(xbgr.mr_n85845344)
print v(xbgr.mr_n85845456)
print v(xbgr.mr_n85845776)
print v(xbgr.mr_n85845888)
print v(xbgr.mr_n85846208)
print v(xbgr.mr_n85846320)
print v(xbgr.mr_n85846640)
print v(xbgr.mr_n85846752)
print v(xbgr.mr_n85847072)
print v(xbgr.mr_n85847184)
print v(xbgr.mr_n85847504)
print v(xbgr.mr_n85847616)
print v(xbgr.mr_n85847936)
print v(xbgr.mr_n85848048)
print v(xbgr.mr_n85848368)
print v(xbgr.mr_n85848480)
print v(xbgr.mr_n85848800)
print v(xbgr.mr_n85848912)
print v(xbgr.mr_n85849232)
print v(xbgr.mr_n85849344)
print v(xbgr.mr_n85849664)
print v(xbgr.mr_n85849776)
print v(xbgr.mr_n85850096)
print v(xbgr.mr_n85850208)
print v(xbgr.mr_n85850528)
print v(xbgr.mr_n85850640)
print v(xbgr.mr_n85850960)
print v(xbgr.mr_n85851072)
print v(xbgr.mr_n85851392)
print v(xbgr.mr_n85851504)
print v(xbgr.mr_n85851824)
print v(xbgr.mr_n85851936)
print v(xbgr.mr_n85852256)
print v(xbgr.mr_n85852368)
print v(xbgr.mr_n85852688)
print v(xbgr.mr_n85852800)
print v(xbgr.mr_n85853120)
print v(xbgr.mr_n85853232)
print v(xbgr.mr_n85853552)
print v(xbgr.mr_n85853664)
print v(xbgr.mr_n85854096)
print v(xbgr.mr_n85854416)
print v(xbgr.mr_n85854528)
print v(xbgr.mr_n85854848)
print v(xbgr.mr_n85854960)
print v(xbgr.mr_n85855280)
print v(xbgr.mr_n85855392)
print v(xbgr.mr_n85855824)
print v(xbgr.mr_n85856144)
print v(xbgr.mr_n85856256)
print v(xbgr.mr_n85856576)
print v(xbgr.mr_n85856688)
print v(xbgr.mr_n85857008)
print v(xbgr.mr_n85857120)
print v(xbgr.mr_n85857440)
print v(xbgr.mr_n85857552)
print v(xbgr.mr_n85857872)
print v(xbgr.mr_n85857984)
print v(xbgr.mr_n85858304)
print v(xbgr.mr_n85858416)
print v(xbgr.mr_n85858736)
print v(xbgr.mr_n85858848)
print v(xbgr.mr_n85859168)
print v(xbgr.mr_n85859280)
print v(xbgr.mr_n85859600)
print v(xbgr.mr_n85859712)
print v(xbgr.mr_n85860032)
print v(xbgr.mr_n85860144)
print v(xbgr.mr_n85860464)
print v(xbgr.mr_n85860576)
print v(xbgr.mr_n85860896)
print v(xbgr.mr_n85861008)
print v(xbgr.mr_n85861328)
print v(xbgr.mr_n85861440)
print v(xbgr.mr_n85861760)
print v(xbgr.mr_n85861872)
print v(xbgr.mr_n85862192)
print v(xbgr.mr_n85862304)
print v(xbgr.mr_n85862736)
print v(xbgr.mr_n85863056)
print v(xbgr.mr_n85863168)
print v(xbgr.mr_n85863488)
print v(xbgr.mr_n85863600)
print v(xbgr.mr_n85863920)
print v(xbgr.mr_n85864032)
print v(xbgr.mr_n85864352)
print v(xbgr.mr_n85864464)
print v(xbgr.mr_n85864784)
print v(xbgr.mr_n85864896)
print v(xbgr.mr_n85865216)
print v(xbgr.mr_n85865328)
print v(xbgr.mr_n85865648)
print v(xbgr.mr_n85865760)
print v(xbgr.mr_n85866192)
print v(xbgr.mr_n85866512)
print v(xbgr.mr_n85866624)
print v(xbgr.mr_n85866944)
print v(xbgr.mr_n85867056)
print v(xbgr.mr_n85867376)
print v(xbgr.mr_n85867488)
print v(xbgr.mr_n85867808)
print v(xbgr.mr_n85867920)
print v(xbgr.mr_n85868240)
print v(xbgr.mr_n85868352)
print v(xbgr.mr_n85868672)
print v(xbgr.mr_n85868784)
print v(xbgr.mr_n85869104)
print v(xbgr.mr_n85869216)
print v(xbgr.mr_n85869536)
print v(xbgr.mr_n85869648)
print v(xbgr.mr_n85869968)
print v(xbgr.mr_n85870080)
print v(xbgr.mr_n85870400)
print v(xbgr.mr_n85870512)
print v(xbgr.mr_n85870832)
print v(xbgr.mr_n85870944)
print v(xbgr.mr_n85871264)
print v(xbgr.mr_n85871376)
print v(xbgr.mr_n85871696)
print v(xbgr.mr_n85871808)
print v(xbgr.mr_n85872240)
print v(xbgr.mr_n85872560)
print v(xbgr.mr_n85872672)
print v(xbgr.mr_n85872992)
print v(xbgr.mr_n85873104)
print v(xbgr.mr_n85873424)
print v(xbgr.mr_n85873536)
print v(xbgr.mr_n85873968)
print v(xbgr.mr_n85874288)
print v(xbgr.mr_n85874400)
print v(xbgr.mr_n85874720)
print v(xbgr.mr_n85874832)
print v(xbgr.mr_n85875152)
print v(xbgr.mr_n85875264)
print v(xbgr.mr_n85875584)
print v(xbgr.mr_n85875696)
print v(xbgr.mr_n85876016)
print v(xbgr.mr_n85876128)
print v(xbgr.mr_n85876560)
print v(xbgr.mr_n85876880)
print v(xbgr.mr_n85876992)
print v(xbgr.mr_n85877312)
print v(xbgr.mr_n85877424)
print v(xbgr.mr_n85877744)
print v(xbgr.mr_n85877856)
print v(xbgr.mr_n85878176)
print v(xbgr.mr_n85878288)
print v(xbgr.mr_n85878608)
print v(xbgr.mr_n85878720)
print v(xbgr.mr_n85879040)
print v(xbgr.mr_n85879152)
print v(xbgr.mr_n85879472)
print v(xbgr.mr_n85879584)
print v(xbgr.mr_n85879904)
print v(xbgr.mr_n85880016)
print v(xbgr.mr_n85880336)
print v(xbgr.mr_n85880448)
print v(xbgr.mr_n85880768)
print v(xbgr.mr_n85880880)
print v(xbgr.mr_n85881200)
print v(xbgr.mr_n85881312)
print v(xbgr.mr_n85881632)
print v(xbgr.mr_n85881744)
print v(xbgr.mr_n85882064)
print v(xbgr.mr_n85882176)
print v(xbgr.mr_n85882608)
print v(xbgr.mr_n85882928)
print v(xbgr.mr_n85883040)
print v(xbgr.mr_n85883360)
print v(xbgr.mr_n85883472)
print v(xbgr.mr_n85883792)
print v(xbgr.mr_n85883904)
print v(xbgr.mr_n85884336)
print v(xbgr.mr_n85884656)
print v(xbgr.mr_n85884768)
print v(xbgr.mr_n85885200)
print v(xbgr.mr_n85885520)
print v(xbgr.mr_n85885632)
print v(xbgr.mr_n85885952)
print v(xbgr.mr_n85886064)
print v(xbgr.mr_n85886384)
print v(xbgr.mr_n85886496)
print v(xbgr.mr_n85886928)
print v(xbgr.mr_n85887248)
print v(xbgr.mr_n85887360)
print v(xbgr.mr_n85887680)
print v(xbgr.mr_n85887792)
print v(xbgr.mr_n85888112)
print v(xbgr.mr_n85888224)
print v(xbgr.mr_n85888544)
print v(xbgr.mr_n85888656)
print v(xbgr.mr_n85888976)
print v(xbgr.mr_n85889088)
print v(xbgr.mr_n85889408)
print v(xbgr.mr_n85889520)
print v(xbgr.mr_n85889840)
print v(xbgr.mr_n85889952)
print v(xbgr.mr_n85890272)
print v(xbgr.mr_n85890384)
print v(xbgr.mr_n85890704)
print v(xbgr.mr_n85890816)
print v(xbgr.mr_n85891248)
print v(xbgr.mr_n85891568)
print v(xbgr.mr_n85891680)
print v(xbgr.mr_n85892000)
print v(xbgr.mr_n85892112)
print v(xbgr.mr_n85892432)
print v(xbgr.mr_n85892544)
print v(xbgr.mr_n85892864)
print v(xbgr.mr_n85892976)
print v(xbgr.mr_n85893296)
print v(xbgr.mr_n85893408)
print v(xbgr.mr_n85893728)
print v(xbgr.mr_n85893840)
print v(xbgr.mr_n85894160)
print v(xbgr.mr_n85894272)
print v(xbgr.mr_n85894592)
print v(xbgr.mr_n85894704)
print v(xbgr.mr_n85895024)
print v(xbgr.mr_n85895136)
print v(xbgr.mr_n85895456)
print v(xbgr.mr_n85895568)
print v(xbgr.mr_n85895888)
print v(xbgr.mr_n85896000)
print v(xbgr.mr_n85896320)
print v(xbgr.mr_n85896432)
print v(xbgr.mr_n85896752)
print v(xbgr.mr_n85896864)
print v(xbgr.mr_n85897184)
print v(xbgr.mr_n85897296)
print v(xbgr.mr_n85897616)
print v(xbgr.mr_n85897728)
print v(xbgr.mr_n85898048)
print v(xbgr.mr_n85898160)
print v(xbgr.mr_n85898480)
print v(xbgr.mr_n85898592)
print v(xbgr.mr_n85898912)
print v(xbgr.mr_n85899024)
print v(xbgr.mr_n85899344)
print v(xbgr.mr_n85899456)
print v(xbgr.mr_n85899776)
print v(xbgr.mr_n85899888)
print v(xbgr.mr_n85900208)
print v(xbgr.mr_n85900320)
print v(xbgr.mr_n85900640)
print v(xbgr.mr_n85900752)
print v(xbgr.mr_n85901072)
print v(xbgr.mr_n85901184)
print v(xbgr.mr_n85901504)
print v(xbgr.mr_n85901616)
print v(xbgr.mr_n85901936)
print v(xbgr.mr_n85902048)
print v(xbgr.mr_n85902368)
print v(xbgr.mr_n85902480)
print v(xbgr.mr_n85902800)
print v(xbgr.mr_n85902912)
print v(xbgr.mr_n85903232)
print v(xbgr.mr_n85903344)
print v(xbgr.mr_n85903664)
print v(xbgr.mr_n85903776)
print v(xbgr.mr_n85904096)
print v(xbgr.mr_n85904208)
print v(xbgr.mr_n85904528)
print v(xbgr.mr_n85904640)
print v(xbgr.mr_n85904960)
print v(xbgr.mr_n85905072)
print v(xbgr.mr_n85905392)
print v(xbgr.mr_n85905504)
print v(xbgr.mr_n85905824)
print v(xbgr.mr_n85905936)
print v(xbgr.mr_n85906256)
print v(xbgr.mr_n85906368)
print v(xbgr.mr_n85906688)
print v(xbgr.mr_n85906800)
print v(xbgr.mr_n85907120)
print v(xbgr.mr_n85907232)
print v(xbgr.mr_n85907552)
print v(xbgr.mr_n85907664)
print v(xbgr.mr_n85907984)
print v(xbgr.mr_n85908096)
print v(xbgr.mr_n85908416)
print v(xbgr.mr_n85908528)
print v(xbgr.mr_n85908848)
print v(xbgr.mr_n85908960)
print v(xbgr.mr_n85909280)
print v(xbgr.mr_n85909392)
print v(xbgr.mr_n85909712)
print v(xbgr.mr_n85909824)
print v(xbgr.mr_n85910144)
print v(xbgr.mr_n85910256)
print v(xbgr.mr_n85910576)
print v(xbgr.mr_n85910688)
print v(xbgr.mr_n85911008)
print v(xbgr.mr_n85911120)
print v(xbgr.mr_n85911440)
print v(xbgr.mr_n85911552)
print v(xbgr.mr_n85911872)
print v(xbgr.mr_n85911984)
print v(xbgr.mr_n85912304)
print v(xbgr.mr_n85912416)
print v(xbgr.mr_n85912736)
print v(xbgr.mr_n85912848)
print v(xbgr.mr_n85913168)
print v(xbgr.mr_n85913280)
print v(xbgr.mr_n85913600)
print v(xbgr.mr_n85913712)
print v(xbgr.mr_n85914032)
print v(xbgr.mr_n85914144)
print v(xbgr.mr_n85914464)
print v(xbgr.mr_n85914576)
print v(xbgr.mr_n85914896)
print v(xbgr.mr_n85915008)
print v(xbgr.mr_n85915328)
print v(xbgr.mr_n85915440)
print v(xbgr.mr_n85915760)
print v(xbgr.mr_n85915872)
print v(xbgr.mr_n85916192)
print v(xbgr.mr_n85916304)
print v(xbgr.mr_n85916624)
print v(xbgr.mr_n85916736)
print v(xbgr.mr_n85917056)
print v(xbgr.mr_n85917168)
print v(xbgr.mr_n85917488)
print v(xbgr.mr_n85917600)
print v(xbgr.mr_n85917920)
print v(xbgr.mr_n85918032)
print v(xbgr.mr_n85918352)
print v(xbgr.mr_n85918464)
print v(xbgr.mr_n85918784)
print v(xbgr.mr_n85918896)
print v(xbgr.mr_n85919216)
print v(xbgr.mr_n85919328)
print v(xbgr.mr_n85919648)
print v(xbgr.mr_n85919760)
print v(xbgr.mr_n85920080)
print v(xbgr.mr_n85920192)
print v(xbgr.mr_n85920512)
print v(xbgr.mr_n85920624)
print v(xbgr.mr_n85920944)
print v(xbgr.mr_n85921056)
print v(xbgr.mr_n85921376)
print v(xbgr.mr_n85921488)
print v(xbgr.mr_n85921808)
print v(xbgr.mr_n85921920)
print v(xbgr.mr_n85922240)
print v(xbgr.mr_n85922352)
print v(xbgr.mr_n85922672)
print v(xbgr.mr_n85922784)
print v(xbgr.mr_n85923104)
print v(xbgr.mr_n85923216)
print v(xbgr.mr_n85923536)
print v(xbgr.mr_n85923648)
print v(xbgr.mr_n85923968)
print v(xbgr.mr_n85924080)
print v(xbgr.mr_n85924400)
print v(xbgr.mr_n85924512)
print v(xbgr.mr_n85924832)
print v(xbgr.mr_n85924944)
print v(xbgr.mr_n85925264)
print v(xbgr.mr_n85925376)
print v(xbgr.mr_n85925696)
print v(xbgr.mr_n85925808)
print v(xbgr.mr_n85926128)
print v(xbgr.mr_n85926240)
print v(xbgr.mr_n85926560)
print v(xbgr.mr_n85926672)
print v(xbgr.mr_n85926992)
print v(xbgr.mr_n85927104)
print v(xbgr.mr_n85927424)
print v(xbgr.mr_n85927536)
print v(xbgr.mr_n85927856)
print v(xbgr.mr_n85927968)
print v(xbgr.mr_n85928288)
print v(xbgr.mr_n85928400)
print v(xbgr.mr_n85928720)
print v(xbgr.mr_n85928832)
print v(xbgr.mr_n85929152)
print v(xbgr.mr_n85929264)
print v(xbgr.mr_n85929584)
print v(xbgr.mr_n85929696)
print v(xbgr.mr_n85930016)
print v(xbgr.mr_n85930128)
print v(xbgr.mr_n85930448)
print v(xbgr.mr_n85930560)
print v(xbgr.mr_n85930880)
print v(xbgr.mr_n85930992)
print v(xbgr.mr_n85931312)
print v(xbgr.mr_n85931424)
print v(xbgr.mr_n85931744)
print v(xbgr.mr_n85931856)
print v(xbgr.mr_n85932176)
print v(xbgr.mr_n85932288)
print v(xbgr.mr_n85932608)
print v(xbgr.mr_n85932720)
print v(xbgr.mr_n85933040)
print v(xbgr.mr_n85933152)
print v(xbgr.mr_n85933472)
print v(xbgr.mr_n85933584)
print v(xbgr.mr_n85933904)
print v(xbgr.mr_n85934016)
print v(xbgr.mr_n85934336)
print v(xbgr.mr_n85934448)
print v(xbgr.mr_n85934768)
print v(xbgr.mr_n85934880)
print v(xbgr.mr_n85935200)
print v(xbgr.mr_n85935312)
print v(xbgr.mr_n85935632)
print v(xbgr.mr_n85935744)
print v(xbgr.mr_n85936064)
print v(xbgr.mr_n85936176)
print v(xbgr.mr_n85936496)
print v(xbgr.mr_n85936608)
print v(xbgr.mr_n85936928)
print v(xbgr.mr_n85937040)
print v(xbgr.mr_n85937360)
print v(xbgr.mr_n85937472)
print v(xbgr.mr_n85937792)
print v(xbgr.mr_n85937904)
print v(xbgr.mr_n85938224)
print v(xbgr.mr_n85938336)
print v(xbgr.mr_n85938656)
print v(xbgr.mr_n85938768)
print v(xbgr.mr_n85939088)
print v(xbgr.mr_n85939200)
print v(xbgr.mr_n85939520)
print v(xbgr.mr_n85939632)
print v(xbgr.mr_n85939952)
print v(xbgr.mr_n85940064)
print v(xbgr.mr_n85940384)
print v(xbgr.mr_n85940496)
print v(xbgr.mr_n85940816)
print v(xbgr.mr_n85940928)
print v(xbgr.mr_n85941248)
print v(xbgr.mr_n85941360)
print v(xbgr.mr_n85941680)
print v(xbgr.mr_n85941792)
print v(xbgr.mr_n85942112)
print v(xbgr.mr_n85942224)
print v(xbgr.mr_n85942544)
print v(xbgr.mr_n85942656)
print v(xbgr.mr_n85942976)
print v(xbgr.mr_n85943088)
print v(xbgr.mr_n85943408)
print v(xbgr.mr_n85943520)
print v(xbgr.mr_n85943840)
print v(xbgr.mr_n85943952)
print v(xbgr.mr_n85944272)
print v(xbgr.mr_n85944384)
print v(xbgr.mr_n85944704)
print v(xbgr.mr_n85944816)
print v(xbgr.mr_n85945136)
print v(xbgr.mr_n85945248)
print v(xbgr.mr_n85945568)
print v(xbgr.mr_n85945680)
print v(xbgr.mr_n85946000)
print v(xbgr.mr_n85946112)
print v(xbgr.mr_n85946432)
print v(xbgr.mr_n85946544)
print v(xbgr.mr_n85946864)
print v(xbgr.mr_n85946976)
print v(xbgr.mr_n85947296)
print v(xbgr.mr_n85947408)
print v(xbgr.mr_n85947728)
print v(xbgr.mr_n85947840)
print v(xbgr.mr_n85948160)
print v(xbgr.mr_n85948272)
print v(xbgr.mr_n85948592)
print v(xbgr.mr_n85948704)
print v(xbgr.mr_n85949024)
print v(xbgr.mr_n85949136)
print v(xbgr.mr_n85949456)
print v(xbgr.mr_n85949568)
print v(xbgr.mr_n85949888)
print v(xbgr.mr_n85950000)
print v(xbgr.mr_n85950320)
print v(xbgr.mr_n85950432)
print v(xbgr.mr_n85950752)
print v(xbgr.mr_n85950864)
print v(xbgr.mr_n85951184)
print v(xbgr.mr_n85951296)
print v(xbgr.mr_n85951616)
print v(xbgr.mr_n85951728)
print v(xbgr.mr_n85952048)
print v(xbgr.mr_n85952160)
print v(xbgr.mr_n85952480)
print v(xbgr.mr_n85952592)
print v(xbgr.mr_n85952912)
print v(xbgr.mr_n85953024)
print v(xbgr.mr_n85953344)
print v(xbgr.mr_n85953456)
print v(xbgr.mr_n85953776)
print v(xbgr.mr_n85953888)
print v(xbgr.mr_n85954208)
print v(xbgr.mr_n85954320)
print v(xbgr.mr_n85954640)
print v(xbgr.mr_n85954752)
print v(xbgr.mr_n85955072)
print v(xbgr.mr_n85955184)
print v(xbgr.mr_n85955504)
print v(xbgr.mr_n85955616)
print v(xbgr.mr_n85955936)
print v(xbgr.mr_n85956048)
print v(xbgr.mr_n85956368)
print v(xbgr.mr_n85956480)
print v(xbgr.mr_n85956800)
print v(xbgr.mr_n85956912)
print v(xbgr.mr_n85957232)
print v(xbgr.mr_n85957344)
print v(xbgr.mr_n85957664)
print v(xbgr.mr_n85957776)
print v(xbgr.mr_n85958096)
print v(xbgr.mr_n85958208)
print v(xbgr.mr_n85958528)
print v(xbgr.mr_n85958640)
print v(xbgr.mr_n85958960)
print v(xbgr.mr_n85959072)
print v(xbgr.mr_n85959392)
print v(xbgr.mr_n85959504)
print v(xbgr.mr_n85959824)
print v(xbgr.mr_n85959936)
print v(xbgr.mr_n85960256)
print v(xbgr.mr_n85960368)
print v(xbgr.mr_n85960688)
print v(xbgr.mr_n85960800)
print v(xbgr.mr_n85961120)
print v(xbgr.mr_n85961232)
print v(xbgr.mr_n85961552)
print v(xbgr.mr_n85961664)
print v(xbgr.mr_n85961984)
print v(xbgr.mr_n85962096)
print v(xbgr.mr_n85962416)
print v(xbgr.mr_n85962528)
print v(xbgr.mr_n85962848)
print v(xbgr.mr_n85962960)
print v(xbgr.mr_n85963280)
print v(xbgr.mr_n85963392)
print v(xbgr.mr_n85963712)
print v(xbgr.mr_n85963824)
print v(xbgr.mr_n85964144)
print v(xbgr.mr_n85964256)
print v(xbgr.mr_n85964576)
print v(xbgr.mr_n85964688)
print v(xbgr.mr_n85965008)
print v(xbgr.mr_n85965120)
print v(xbgr.mr_n85965440)
print v(xbgr.mr_n85965552)
print v(xbgr.mr_n85965872)
print v(xbgr.mr_n85965984)
print v(xbgr.mr_n85966304)
print v(xbgr.mr_n85966416)
print v(xbgr.mr_n85966736)
print v(xbgr.mr_n85966848)
print v(xbgr.mr_n85967168)
print v(xbgr.mr_n85967280)
print v(xbgr.mr_n85967600)
print v(xbgr.mr_n85967712)
print v(xbgr.mr_n85968032)
print v(xbgr.mr_n85968144)
print v(xbgr.mr_n85968464)
print v(xbgr.mr_n85968576)
print v(xbgr.mr_n85968896)
print v(xbgr.mr_n85969008)
print v(xbgr.mr_n85969328)
print v(xbgr.mr_n85969440)
print v(xbgr.mr_n85969760)
print v(xbgr.mr_n85969872)
print v(xbgr.mr_n85970192)
print v(xbgr.mr_n85970304)
print v(xbgr.mr_n85970624)
print v(xbgr.mr_n85970736)
print v(xbgr.mr_n85971056)
print v(xbgr.mr_n85971168)
print v(xbgr.mr_n85971488)
print v(xbgr.mr_n85971600)
print v(xbgr.mr_n85971920)
print v(xbgr.mr_n85972032)
print v(xbgr.mr_n85972352)
print v(xbgr.mr_n85972464)
print v(xbgr.mr_n85972784)
print v(xbgr.mr_n85972896)
print v(xbgr.mr_n85973216)
print v(xbgr.mr_n85973328)
print v(xbgr.mr_n85973648)
print v(xbgr.mr_n85973760)
print v(xbgr.mr_n85974080)
print v(xbgr.mr_n85974192)
print v(xbgr.mr_n85974512)
print v(xbgr.mr_n85974624)
print v(xbgr.mr_n85974944)
print v(xbgr.mr_n85975056)
print v(xbgr.mr_n85975376)
print v(xbgr.mr_n85975488)
print v(xbgr.mr_n85975808)
print v(xbgr.mr_n85975920)
print v(xbgr.mr_n85976240)
print v(xbgr.mr_n85976352)
print v(xbgr.mr_n85976672)
print v(xbgr.mr_n85976784)
print v(xbgr.mr_n85977104)
print v(xbgr.mr_n85977216)
print v(xbgr.mr_n85977536)
print v(xbgr.mr_n85977648)
print v(xbgr.mr_n85977968)
print v(xbgr.mr_n85978080)
print v(xbgr.mr_n85978400)
print v(xbgr.mr_n85978512)
print v(xbgr.mr_n85978832)
print v(xbgr.mr_n85978944)
print v(xbgr.mr_n85979264)
print v(xbgr.mr_n85979376)
print v(xbgr.mr_n85979696)
print v(xbgr.mr_n85979808)
print v(xbgr.mr_n85980128)
print v(xbgr.mr_n85980240)
print v(xbgr.mr_n85980560)
print v(xbgr.mr_n85980672)
print v(xbgr.mr_n85980992)
print v(xbgr.mr_n85981104)
print v(xbgr.mr_n85981424)
print v(xbgr.mr_n85981536)
print v(xbgr.mr_n85981856)
print v(xbgr.mr_n85981968)
print v(xbgr.mr_n85982288)
print v(xbgr.mr_n85982400)
print v(xbgr.mr_n85982720)
print v(xbgr.mr_n85982832)
print v(xbgr.mr_n85983152)
print v(xbgr.mr_n85983264)
print v(xbgr.mr_n85983584)
print v(xbgr.mr_n85983696)
print v(xbgr.mr_n85984016)
print v(xbgr.mr_n85984128)
print v(xbgr.mr_n85984448)
print v(xbgr.mr_n85984560)
print v(xbgr.mr_n85984880)
print v(xbgr.mr_n85984992)
print v(xbgr.mr_n85985312)
print v(xbgr.mr_n85985424)
print v(xbgr.mr_n85985744)
print v(xbgr.mr_n85985856)
print v(xbgr.mr_n85986176)
print v(xbgr.mr_n85986288)
print v(xbgr.mr_n85986608)
print v(xbgr.mr_n85986720)
print v(xbgr.mr_n85987040)
print v(xbgr.mr_n85987152)
print v(xbgr.mr_n85987472)
print v(xbgr.mr_n85987584)
print v(xbgr.mr_n85987904)
print v(xbgr.mr_n85988016)
print v(xbgr.mr_n85988336)
print v(xbgr.mr_n85988448)
print v(xbgr.mr_n85988768)
print v(xbgr.mr_n85988880)
print v(xbgr.mr_n85989200)
print v(xbgr.mr_n85989312)
print v(xbgr.mr_n85989632)
print v(xbgr.mr_n85989744)
print v(xbgr.mr_n85990064)
print v(xbgr.mr_n85990176)
print v(xbgr.mr_n85990496)
print v(xbgr.mr_n85990608)
print v(xbgr.mr_n85990928)
print v(xbgr.mr_n85991040)
print v(xbgr.mr_n85991360)
print v(xbgr.mr_n85991472)
print v(xbgr.mr_n85991792)
print v(xbgr.mr_n85991904)
print v(xbgr.mr_n85992224)
print v(xbgr.mr_n85992336)
print v(xbgr.mr_n85992656)
print v(xbgr.mr_n85992768)
print v(xbgr.mr_n85993088)
print v(xbgr.mr_n85993200)
print v(xbgr.mr_n85993520)
print v(xbgr.mr_n85993632)
print v(xbgr.mr_n85993952)
print v(xbgr.mr_n85994064)
print v(xbgr.mr_n85994384)
print v(xbgr.mr_n85994496)
print v(xbgr.mr_n85994816)
print v(xbgr.mr_n85994928)
print v(xbgr.mr_n85995248)
print v(xbgr.mr_n85995360)
print v(xbgr.mr_n85995792)
print v(xbgr.mr_n85996112)
print v(xbgr.mr_n85996224)
print v(xbgr.mr_n85996544)
print v(xbgr.mr_n85996656)
print v(xbgr.mr_n85996976)
print v(xbgr.mr_n85997088)
print v(xbgr.mr_n85997408)
print v(xbgr.mr_n85997520)
print v(xbgr.mr_n85997840)
print v(xbgr.mr_n85997952)
print v(xbgr.mr_n85998384)
print v(xbgr.mr_n85998704)
print v(xbgr.mr_n85998816)
print v(xbgr.mr_n85999136)
print v(xbgr.mr_n85999248)
print v(xbgr.mr_n85999568)
print v(xbgr.mr_n85999680)
print v(xbgr.mr_n86000000)
print v(xbgr.mr_n86000112)
print v(xbgr.mr_n86000432)
print v(xbgr.mr_n86000544)
print v(xbgr.mr_n86000976)
print v(xbgr.mr_n86001296)
print v(xbgr.mr_n86001408)
print v(xbgr.mr_n86001728)
print v(xbgr.mr_n86001840)
print v(xbgr.mr_n86002160)
print v(xbgr.mr_n86002272)
print v(xbgr.mr_n86002592)
print v(xbgr.mr_n86002704)
print v(xbgr.mr_n86003024)
print v(xbgr.mr_n86003136)
print v(xbgr.mr_n86003456)
print v(xbgr.mr_n86003568)
print v(xbgr.mr_n86003888)
print v(xbgr.mr_n86004000)
print v(xbgr.mr_n86004432)
print v(xbgr.mr_n86004752)
print v(xbgr.mr_n86004864)
print v(xbgr.mr_n86005296)
print v(xbgr.mr_n86005616)
print v(xbgr.mr_n86005728)
print v(xbgr.mr_n86006048)
print v(xbgr.mr_n86006160)
print v(xbgr.mr_n86006480)
print v(xbgr.mr_n86006592)
print v(xbgr.mr_n86006912)
print v(xbgr.mr_n86007024)
print v(xbgr.mr_n86007344)
print v(xbgr.mr_n86007456)
print v(xbgr.mr_n86007888)
print v(xbgr.mr_n86008208)
print v(xbgr.mr_n86008320)
print v(xbgr.mr_n86008752)
print v(xbgr.mr_n86009072)
print v(xbgr.mr_n86009184)
print v(xbgr.mr_n86009504)
print v(xbgr.mr_n86009616)
print v(xbgr.mr_n86009936)
print v(xbgr.mr_n86010048)
print v(xbgr.mr_n86010368)
print v(xbgr.mr_n86010480)
print v(xbgr.mr_n86010800)
print v(xbgr.mr_n86010912)
print v(xbgr.mr_n86011232)
print v(xbgr.mr_n86011344)
print v(xbgr.mr_n86011664)
print v(xbgr.mr_n86011776)
print v(xbgr.mr_n86012096)
print v(xbgr.mr_n86012208)
print v(xbgr.mr_n86012528)
print v(xbgr.mr_n86012640)
print v(xbgr.mr_n86012960)
print v(xbgr.mr_n86013072)
print v(xbgr.mr_n86013392)
print v(xbgr.mr_n86013504)
print v(xbgr.mr_n86013824)
print v(xbgr.mr_n86013936)
print v(xbgr.mr_n86014256)
print v(xbgr.mr_n86014368)
print v(xbgr.mr_n86014688)
print v(xbgr.mr_n86014800)
print v(xbgr.mr_n86015120)
print v(xbgr.mr_n86015232)
print v(xbgr.mr_n86015552)
print v(xbgr.mr_n86015664)
print v(xbgr.mr_n86015984)
print v(xbgr.mr_n86016096)
print v(xbgr.mr_n86016416)
print v(xbgr.mr_n86016528)
print v(xbgr.mr_n86016848)
print v(xbgr.mr_n86016960)
print v(xbgr.mr_n86017280)
print v(xbgr.mr_n86017392)
print v(xbgr.mr_n86017712)
print v(xbgr.mr_n86017824)
print v(xbgr.mr_n86018144)
print v(xbgr.mr_n86018256)
print v(xbgr.mr_n86018576)
print v(xbgr.mr_n86018688)
print v(xbgr.mr_n86019008)
print v(xbgr.mr_n86019120)
print v(xbgr.mr_n86019440)
print v(xbgr.mr_n86019552)
print v(xbgr.mr_n86019872)
print v(xbgr.mr_n86019984)
print v(xbgr.mr_n86020304)
print v(xbgr.mr_n86020416)
print v(xbgr.mr_n86020736)
print v(xbgr.mr_n86020848)
print v(xbgr.mr_n86021168)
print v(xbgr.mr_n86021280)
print v(xbgr.mr_n86021600)
print v(xbgr.mr_n86021712)
print v(xbgr.mr_n86022032)
print v(xbgr.mr_n86022144)
print v(xbgr.mr_n86022464)
print v(xbgr.mr_n86022576)
print v(xbgr.mr_n86022896)
print v(xbgr.mr_n86023008)
print v(xbgr.mr_n86023328)
print v(xbgr.mr_n86023440)
print v(xbgr.mr_n86023760)
print v(xbgr.mr_n86023872)
print v(xbgr.mr_n86024192)
print v(xbgr.mr_n86024304)
print v(xbgr.mr_n86024624)
print v(xbgr.mr_n86024736)
print v(xbgr.mr_n86025056)
print v(xbgr.mr_n86025168)
print v(xbgr.mr_n86025488)
print v(xbgr.mr_n86025600)
print v(xbgr.mr_n86025920)
print v(xbgr.mr_n86026032)
print v(xbgr.mr_n86026352)
print v(xbgr.mr_n86026464)
print v(xbgr.mr_n86026784)
print v(xbgr.mr_n86026896)
print v(xbgr.mr_n86027216)
print v(xbgr.mr_n86027328)
print v(xbgr.mr_n86027648)
print v(xbgr.mr_n86027760)
print v(xbgr.mr_n86028080)
print v(xbgr.mr_n86028192)
print v(xbgr.mr_n86028512)
print v(xbgr.mr_n86028624)
print v(xbgr.mr_n86028944)
print v(xbgr.mr_n86029056)
print v(xbgr.mr_n86029376)
print v(xbgr.mr_n86029488)
print v(xbgr.mr_n86029808)
print v(xbgr.mr_n86029920)
print v(xbgr.mr_n86030240)
print v(xbgr.mr_n86030352)
print v(xbgr.mr_n86030672)
print v(xbgr.mr_n86030784)
print v(xbgr.mr_n86031104)
print v(xbgr.mr_n86031216)
print v(xbgr.mr_n86031536)
print v(xbgr.mr_n86031648)
print v(xbgr.mr_n86031968)
print v(xbgr.mr_n86032080)
print v(xbgr.mr_n86032400)
print v(xbgr.mr_n86032512)
print v(xbgr.mr_n86032832)
print v(xbgr.mr_n86032944)
print v(xbgr.mr_n86033264)
print v(xbgr.mr_n86033376)
print v(xbgr.mr_n86033696)
print v(xbgr.mr_n86033808)
print v(xbgr.mr_n86034128)
print v(xbgr.mr_n86034240)
print v(xbgr.mr_n86034560)
print v(xbgr.mr_n86034672)
print v(xbgr.mr_n86034992)
print v(xbgr.mr_n86035104)
print v(xbgr.mr_n86035424)
print v(xbgr.mr_n86035536)
print v(xbgr.mr_n86035856)
print v(xbgr.mr_n86035968)
print v(xbgr.mr_n86036288)
print v(xbgr.mr_n86036400)
print v(xbgr.mr_n86036720)
print v(xbgr.mr_n86036832)
print v(xbgr.mr_n86037152)
print v(xbgr.mr_n86037264)
print v(xbgr.mr_n86037584)
print v(xbgr.mr_n86037696)
print v(xbgr.mr_n86038016)
print v(xbgr.mr_n86038128)
print v(xbgr.mr_n86038448)
print v(xbgr.mr_n86038560)
print v(xbgr.mr_n86038880)
print v(xbgr.mr_n86038992)
print v(xbgr.mr_n86039312)
print v(xbgr.mr_n86039424)
print v(xbgr.mr_n86039744)
print v(xbgr.mr_n86039856)
print v(xbgr.mr_n86040176)
print v(xbgr.mr_n86040288)
print v(xbgr.mr_n86040608)
print v(xbgr.mr_n86040720)
print v(xbgr.mr_n86041040)
print v(xbgr.mr_n86041152)
print v(xbgr.mr_n86041472)
print v(xbgr.mr_n86041584)
print v(xbgr.mr_n86041904)
print v(xbgr.mr_n86042016)
print v(xbgr.mr_n86042448)
print v(xbgr.mr_n86042768)
print v(xbgr.mr_n86042880)
print v(xbgr.mr_n86043200)
print v(xbgr.mr_n86043312)
print v(xbgr.mr_n86043632)
print v(xbgr.mr_n86043744)
print v(xbgr.mr_n86044176)
print v(xbgr.mr_n86044496)
print v(xbgr.mr_n86044608)
print v(xbgr.mr_n86045040)
print v(xbgr.mr_n86045360)
print v(xbgr.mr_n86045472)
print v(xbgr.mr_n86045792)
print v(xbgr.mr_n86045904)
print v(xbgr.mr_n86046224)
print v(xbgr.mr_n86046336)
print v(xbgr.mr_n86046656)
print v(xbgr.mr_n86046768)
print v(xbgr.mr_n86047088)
print v(xbgr.mr_n86047200)
print v(xbgr.mr_n86047520)
print v(xbgr.mr_n86047632)
print v(xbgr.mr_n86047952)
print v(xbgr.mr_n86048064)
print v(xbgr.mr_n86048384)
print v(xbgr.mr_n86048496)
print v(xbgr.mr_n86048816)
print v(xbgr.mr_n86048928)
print v(xbgr.mr_n86049248)
print v(xbgr.mr_n86049360)
print v(xbgr.mr_n86049680)
print v(xbgr.mr_n86049792)
print v(xbgr.mr_n86050112)
print v(xbgr.mr_n86050224)
print v(xbgr.mr_n86050544)
print v(xbgr.mr_n86050656)
print v(xbgr.mr_n86050976)
print v(xbgr.mr_n86051088)
print v(xbgr.mr_n86051408)
print v(xbgr.mr_n86051520)
print v(xbgr.mr_n86051840)
print v(xbgr.mr_n86051952)
print v(xbgr.mr_n86052272)
print v(xbgr.mr_n86052384)
print v(xbgr.mr_n86052704)
print v(xbgr.mr_n86052816)
print v(xbgr.mr_n86053136)
print v(xbgr.mr_n86053248)
print v(xbgr.mr_n86053568)
print v(xbgr.mr_n86053680)
print v(xbgr.mr_n86054000)
print v(xbgr.mr_n86054112)
print v(xbgr.mr_n86054432)
print v(xbgr.mr_n86054544)
print v(xbgr.mr_n86054864)
print v(xbgr.mr_n86054976)
print v(xbgr.mr_n86055296)
print v(xbgr.mr_n86055408)
print v(xbgr.mr_n86055728)
print v(xbgr.mr_n86055840)
print v(xbgr.mr_n86056160)
print v(xbgr.mr_n86056272)
print v(xbgr.mr_n86056592)
print v(xbgr.mr_n86056704)
print v(xbgr.mr_n86057136)
print v(xbgr.mr_n86057456)
print v(xbgr.mr_n86057568)
print v(xbgr.mr_n86057888)
print v(xbgr.mr_n86058000)
print v(xbgr.mr_n86058320)
print v(xbgr.mr_n86058432)
print v(xbgr.mr_n86058752)
print v(xbgr.mr_n86058864)
print v(xbgr.mr_n86059184)
print v(xbgr.mr_n86059296)
print v(xbgr.mr_n86059616)
print v(xbgr.mr_n86059728)
print v(xbgr.mr_n86060048)
print v(xbgr.mr_n86060160)
print v(xbgr.mr_n86060480)
print v(xbgr.mr_n86060592)
print v(xbgr.mr_n86060912)
print v(xbgr.mr_n86061024)
print v(xbgr.mr_n86061456)
print v(xbgr.mr_n86061776)
print v(xbgr.mr_n86061888)
print v(xbgr.mr_n86062208)
print v(xbgr.mr_n86062320)
print v(xbgr.mr_n86062640)
print v(xbgr.mr_n86062752)
print v(xbgr.mr_n86063184)
print v(xbgr.mr_n86063504)
print v(xbgr.mr_n86063616)
print v(xbgr.mr_n86063936)
print v(xbgr.mr_n86064048)
print v(xbgr.mr_n86064368)
print v(xbgr.mr_n86064480)
print v(xbgr.mr_n86064800)
print v(xbgr.mr_n86064912)
print v(xbgr.mr_n86065232)
print v(xbgr.mr_n86065344)
print v(xbgr.mr_n86065776)
print v(xbgr.mr_n86066096)
print v(xbgr.mr_n86066208)
print v(xbgr.mr_n86066528)
print v(xbgr.mr_n86066640)
print v(xbgr.mr_n86066960)
print v(xbgr.mr_n86067072)
print v(xbgr.mr_n86067392)
print v(xbgr.mr_n86067504)
print v(xbgr.mr_n86067824)
print v(xbgr.mr_n86067936)
print v(xbgr.mr_n86068256)
print v(xbgr.mr_n86068368)
print v(xbgr.mr_n86068688)
print v(xbgr.mr_n86068800)
print v(xbgr.mr_n86069120)
print v(xbgr.mr_n86069232)
print v(xbgr.mr_n86069552)
print v(xbgr.mr_n86069664)
print v(xbgr.mr_n86069984)
print v(xbgr.mr_n86070096)
print v(xbgr.mr_n86070416)
print v(xbgr.mr_n86070528)
print v(xbgr.mr_n86070848)
print v(xbgr.mr_n86070960)
print v(xbgr.mr_n86071280)
print v(xbgr.mr_n86071392)
print v(xbgr.mr_n86071712)
print v(xbgr.mr_n86071824)
print v(xbgr.mr_n86072144)
print v(xbgr.mr_n86072256)
print v(xbgr.mr_n86072576)
print v(xbgr.mr_n86072688)
print v(xbgr.mr_n86073008)
print v(xbgr.mr_n86073120)
print v(xbgr.mr_n86073440)
print v(xbgr.mr_n86073552)
print v(xbgr.mr_n86073872)
print v(xbgr.mr_n86073984)
print v(xbgr.mr_n86074304)
print v(xbgr.mr_n86074416)
print v(xbgr.mr_n86074736)
print v(xbgr.mr_n86074848)
print v(xbgr.mr_n86075168)
print v(xbgr.mr_n86075280)
print v(xbgr.mr_n86075600)
print v(xbgr.mr_n86075712)
print v(xbgr.mr_n86076032)
print v(xbgr.mr_n86076144)
print v(xbgr.mr_n86076464)
print v(xbgr.mr_n86076576)
print v(xbgr.mr_n86076896)
print v(xbgr.mr_n86077008)
print v(xbgr.mr_n86077328)
print v(xbgr.mr_n86077440)
print v(xbgr.mr_n86077760)
print v(xbgr.mr_n86077872)
print v(xbgr.mr_n86078192)
print v(xbgr.mr_n86078304)
print v(xbgr.mr_n86078624)
print v(xbgr.mr_n86078736)
print v(xbgr.mr_n86079056)
print v(xbgr.mr_n86079168)
print v(xbgr.mr_n86079488)
print v(xbgr.mr_n86079600)
print v(xbgr.mr_n86079920)
print v(xbgr.mr_n86080032)
print v(xbgr.mr_n86080352)
print v(xbgr.mr_n86080464)
print v(xbgr.mr_n86080784)
print v(xbgr.mr_n86080896)
print v(xbgr.mr_n86081216)
print v(xbgr.mr_n86081328)
print v(xbgr.mr_n86081648)
print v(xbgr.mr_n86081760)
print v(xbgr.mr_n86082080)
print v(xbgr.mr_n86082192)
print v(xbgr.mr_n86082512)
print v(xbgr.mr_n86082624)
print v(xbgr.mr_n86082944)
print v(xbgr.mr_n86083056)
print v(xbgr.mr_n86083376)
print v(xbgr.mr_n86083488)
print v(xbgr.mr_n86083808)
print v(xbgr.mr_n86083920)
print v(xbgr.mr_n86084240)
print v(xbgr.mr_n86084352)
print v(xbgr.mr_n86084672)
print v(xbgr.mr_n86084784)
print v(xbgr.mr_n86085104)
print v(xbgr.mr_n86085216)
print v(xbgr.mr_n86085536)
print v(xbgr.mr_n86085648)
print v(xbgr.mr_n86085968)
print v(xbgr.mr_n86086080)
print v(xbgr.mr_n86086400)
print v(xbgr.mr_n86086512)
print v(xbgr.mr_n86086832)
print v(xbgr.mr_n86086944)
print v(xbgr.mr_n86087264)
print v(xbgr.mr_n86087376)
print v(xbgr.mr_n86087696)
print v(xbgr.mr_n86087808)
print v(xbgr.mr_n86088128)
print v(xbgr.mr_n86088240)
print v(xbgr.mr_n86088560)
print v(xbgr.mr_n86088672)
print v(xbgr.mr_n86088992)
print v(xbgr.mr_n86089104)
print v(xbgr.mr_n86089424)
print v(xbgr.mr_n86089536)
print v(xbgr.mr_n86089856)
print v(xbgr.mr_n86089968)
print v(xbgr.mr_n86090288)
print v(xbgr.mr_n86090400)
print v(xbgr.mr_n86090720)
print v(xbgr.mr_n86090832)
print v(xbgr.mr_n86091152)
print v(xbgr.mr_n86091264)
print v(xbgr.mr_n86091584)
print v(xbgr.mr_n86091696)
print v(xbgr.mr_n86092016)
print v(xbgr.mr_n86092128)
print v(xbgr.mr_n86092448)
print v(xbgr.mr_n86092560)
print v(xbgr.mr_n86092880)
print v(xbgr.mr_n86092992)
print v(xbgr.mr_n86093312)
print v(xbgr.mr_n86093424)
print v(xbgr.mr_n86093744)
print v(xbgr.mr_n86093856)
print v(xbgr.mr_n86094176)
print v(xbgr.mr_n86094288)
print v(xbgr.mr_n86094608)
print v(xbgr.mr_n86094720)
print v(xbgr.mr_n86095040)
print v(xbgr.mr_n86095152)
print v(xbgr.mr_n86095472)
print v(xbgr.mr_n86095584)
print v(xbgr.mr_n86096016)
print v(xbgr.mr_n86096336)
print v(xbgr.mr_n86096448)
print v(xbgr.mr_n86096768)
print v(xbgr.mr_n86096880)
print v(xbgr.mr_n86097200)
print v(xbgr.mr_n86097312)
print v(xbgr.mr_n86097744)
print v(xbgr.mr_n86098064)
print v(xbgr.mr_n86098176)
print v(xbgr.mr_n86098608)
print v(xbgr.mr_n86098928)
print v(xbgr.mr_n86099040)
print v(xbgr.mr_n86099360)
print v(xbgr.mr_n86099472)
print v(xbgr.mr_n86099792)
print v(xbgr.mr_n86099904)
print v(xbgr.mr_n86100224)
print v(xbgr.mr_n86100336)
print v(xbgr.mr_n86100656)
print v(xbgr.mr_n86100768)
print v(xbgr.mr_n86101088)
print v(xbgr.mr_n86101200)
print v(xbgr.mr_n86101520)
print v(xbgr.mr_n86101632)
print v(xbgr.mr_n86101952)
print v(xbgr.mr_n86102064)
print v(xbgr.mr_n86102384)
print v(xbgr.mr_n86102496)
print v(xbgr.mr_n86102816)
print v(xbgr.mr_n86102928)
print v(xbgr.mr_n86103248)
print v(xbgr.mr_n86103360)
print v(xbgr.mr_n86103680)
print v(xbgr.mr_n86103792)
print v(xbgr.mr_n86104112)
print v(xbgr.mr_n86104224)
print v(xbgr.mr_n86104544)
print v(xbgr.mr_n86104656)
print v(xbgr.mr_n86104976)
print v(xbgr.mr_n86105088)
print v(xbgr.mr_n86105408)
print v(xbgr.mr_n86105520)
print v(xbgr.mr_n86105840)
print v(xbgr.mr_n86105952)
print v(xbgr.mr_n86106272)
print v(xbgr.mr_n86106384)
print v(xbgr.mr_n86106704)
print v(xbgr.mr_n86106816)
print v(xbgr.mr_n86107136)
print v(xbgr.mr_n86107248)
print v(xbgr.mr_n86107568)
print v(xbgr.mr_n86107680)
print v(xbgr.mr_n86108000)
print v(xbgr.mr_n86108112)
print v(xbgr.mr_n86108432)
print v(xbgr.mr_n86108544)
print v(xbgr.mr_n86108864)
print v(xbgr.mr_n86108976)
print v(xbgr.mr_n86109296)
print v(xbgr.mr_n86109408)
print v(xbgr.mr_n86109728)
print v(xbgr.mr_n86109840)
print v(xbgr.mr_n86110160)
print v(xbgr.mr_n86110272)
print v(xbgr.mr_n86110592)
print v(xbgr.mr_n86110704)
print v(xbgr.mr_n86111024)
print v(xbgr.mr_n86111136)
print v(xbgr.mr_n86111456)
print v(xbgr.mr_n86111568)
print v(xbgr.mr_n86111888)
print v(xbgr.mr_n86112000)
print v(xbgr.mr_n86112320)
print v(xbgr.mr_n86112432)
print v(xbgr.mr_n86112752)
print v(xbgr.mr_n86112864)
print v(xbgr.mr_n86113184)
print v(xbgr.mr_n86113296)
print v(xbgr.mr_n86113616)
print v(xbgr.mr_n86113728)
print v(xbgr.mr_n86114048)
print v(xbgr.mr_n86114160)
print v(xbgr.mr_n86114480)
print v(xbgr.mr_n86114592)
print v(xbgr.mr_n86114912)
print v(xbgr.mr_n86115024)
print v(xbgr.mr_n86115344)
print v(xbgr.mr_n86115456)
print v(xbgr.mr_n86115776)
print v(xbgr.mr_n86115888)
print v(xbgr.mr_n86116208)
print v(xbgr.mr_n86116320)
print v(xbgr.mr_n86116640)
print v(xbgr.mr_n86116752)
print v(xbgr.mr_n86117072)
print v(xbgr.mr_n86117184)
print v(xbgr.mr_n86117504)
print v(xbgr.mr_n86117616)
print v(xbgr.mr_n86117936)
print v(xbgr.mr_n86118048)
print v(xbgr.mr_n86118368)
print v(xbgr.mr_n86118480)
print v(xbgr.mr_n86118800)
print v(xbgr.mr_n86118912)
print v(xbgr.mr_n86119232)
print v(xbgr.mr_n86119344)
print v(xbgr.mr_n86119664)
print v(xbgr.mr_n86119776)
print v(xbgr.mr_n86120096)
print v(xbgr.mr_n86120208)
print v(xbgr.mr_n86120528)
print v(xbgr.mr_n86120640)
print v(xbgr.mr_n86120960)
print v(xbgr.mr_n86121072)
print v(xbgr.mr_n86121392)
print v(xbgr.mr_n86121504)
print v(xbgr.mr_n86121824)
print v(xbgr.mr_n86121936)
print v(xbgr.mr_n86122256)
print v(xbgr.mr_n86122368)
print v(xbgr.mr_n86122688)
print v(xbgr.mr_n86122800)
print v(xbgr.mr_n86123120)
print v(xbgr.mr_n86123232)
print v(xbgr.mr_n86123552)
print v(xbgr.mr_n86123664)
print v(xbgr.mr_n86123984)
print v(xbgr.mr_n86124096)
print v(xbgr.mr_n86124416)
print v(xbgr.mr_n86124528)
print v(xbgr.mr_n86124848)
print v(xbgr.mr_n86124960)
print v(xbgr.mr_n86125280)
print v(xbgr.mr_n86125392)
print v(xbgr.mr_n86125712)
print v(xbgr.mr_n86125824)
print v(xbgr.mr_n86126144)
print v(xbgr.mr_n86126256)
print v(xbgr.mr_n86126576)
print v(xbgr.mr_n86126688)
print v(xbgr.mr_n86127008)
print v(xbgr.mr_n86127120)
print v(xbgr.mr_n86127440)
print v(xbgr.mr_n86127552)
print v(xbgr.mr_n86127872)
print v(xbgr.mr_n86127984)
print v(xbgr.mr_n86128304)
print v(xbgr.mr_n86128416)
print v(xbgr.mr_n86128736)
print v(xbgr.mr_n86128848)
print v(xbgr.mr_n86129168)
print v(xbgr.mr_n86129280)
print v(xbgr.mr_n86129600)
print v(xbgr.mr_n86129712)
print v(xbgr.mr_n86130032)
print v(xbgr.mr_n86130144)
print v(xbgr.mr_n86130464)
print v(xbgr.mr_n86130576)
print v(xbgr.mr_n86130896)
print v(xbgr.mr_n86131008)
print v(xbgr.mr_n86131328)
print v(xbgr.mr_n86131440)
print v(xbgr.mr_n86131760)
print v(xbgr.mr_n86131872)
print v(xbgr.mr_n86132192)
print v(xbgr.mr_n86132304)
print v(xbgr.mr_n86132624)
print v(xbgr.mr_n86132736)
print v(xbgr.mr_n86133056)
print v(xbgr.mr_n86133168)
print v(xbgr.mr_n86133488)
print v(xbgr.mr_n86133600)
print v(xbgr.mr_n86133920)
print v(xbgr.mr_n86134032)
print v(xbgr.mr_n86134352)
print v(xbgr.mr_n86134464)
print v(xbgr.mr_n86134784)
print v(xbgr.mr_n86134896)
print v(xbgr.mr_n86135216)
print v(xbgr.mr_n86135328)
print v(xbgr.mr_n86135648)
print v(xbgr.mr_n86135760)
print v(xbgr.mr_n86136080)
print v(xbgr.mr_n86136192)
print v(xbgr.mr_n86136512)
print v(xbgr.mr_n86136624)
print v(xbgr.mr_n86136944)
print v(xbgr.mr_n86137056)
print v(xbgr.mr_n86137376)
print v(xbgr.mr_n86137488)
print v(xbgr.mr_n86137808)
print v(xbgr.mr_n86137920)
print v(xbgr.mr_n86138240)
print v(xbgr.mr_n86138352)
print v(xbgr.mr_n86138672)
print v(xbgr.mr_n86138784)
print v(xbgr.mr_n86139104)
print v(xbgr.mr_n86139216)
print v(xbgr.mr_n86139536)
print v(xbgr.mr_n86139648)
print v(xbgr.mr_n86139968)
print v(xbgr.mr_n86140080)
print v(xbgr.mr_n86140400)
print v(xbgr.mr_n86140512)
print v(xbgr.mr_n86140832)
print v(xbgr.mr_n86140944)
print v(xbgr.mr_n86141264)
print v(xbgr.mr_n86141376)
print v(xbgr.mr_n86141696)
print v(xbgr.mr_n86141808)
print v(xbgr.mr_n86142128)
print v(xbgr.mr_n86142240)
print v(xbgr.mr_n86142560)
print v(xbgr.mr_n86142672)
print v(xbgr.mr_n86142992)
print v(xbgr.mr_n86143104)
print v(xbgr.mr_n86143424)
print v(xbgr.mr_n86143536)
print v(xbgr.mr_n86143856)
print v(xbgr.mr_n86143968)
print v(xbgr.mr_n86144288)
print v(xbgr.mr_n86144400)
print v(xbgr.mr_n86144720)
print v(xbgr.mr_n86144832)
print v(xbgr.mr_n86145152)
print v(xbgr.mr_n86145264)
print v(xbgr.mr_n86145584)
print v(xbgr.mr_n86145696)
print v(xbgr.mr_n86146016)
print v(xbgr.mr_n86146128)
print v(xbgr.mr_n86146448)
print v(xbgr.mr_n86146560)
print v(xbgr.mr_n86146880)
print v(xbgr.mr_n86146992)
print v(xbgr.mr_n86147312)
print v(xbgr.mr_n86147424)
print v(xbgr.mr_n86147744)
print v(xbgr.mr_n86147856)
print v(xbgr.mr_n86148176)
print v(xbgr.mr_n86148288)
print v(xbgr.mr_n86148608)
print v(xbgr.mr_n86148720)
print v(xbgr.mr_n86149040)
print v(xbgr.mr_n86149152)
print v(xbgr.mr_n86149472)
print v(xbgr.mr_n86149584)
print v(xbgr.mr_n86149904)
print v(xbgr.mr_n86150016)
print v(xbgr.mr_n86150336)
print v(xbgr.mr_n86150448)
print v(xbgr.mr_n86150768)
print v(xbgr.mr_n86150880)
print v(xbgr.mr_n86151200)
print v(xbgr.mr_n86151312)
print v(xbgr.mr_n86151632)
print v(xbgr.mr_n86151744)
print v(xbgr.mr_n86152064)
print v(xbgr.mr_n86152176)
print v(xbgr.mr_n86152496)
print v(xbgr.mr_n86152608)
print v(xbgr.mr_n86152928)
print v(xbgr.mr_n86153040)
print v(xbgr.mr_n86153360)
print v(xbgr.mr_n86153472)
print v(xbgr.mr_n86153792)
print v(xbgr.mr_n86153904)
print v(xbgr.mr_n86154224)
print v(xbgr.mr_n86154336)
print v(xbgr.mr_n86154656)
print v(xbgr.mr_n86154768)
print v(xbgr.mr_n86155088)
print v(xbgr.mr_n86155200)
print v(xbgr.mr_n86155520)
print v(xbgr.mr_n86155632)
print v(xbgr.mr_n86155952)
print v(xbgr.mr_n86156064)
print v(xbgr.mr_n86156384)
print v(xbgr.mr_n86156496)
print v(xbgr.mr_n86156816)
print v(xbgr.mr_n86156928)
print v(xbgr.mr_n86157248)
print v(xbgr.mr_n86157360)
print v(xbgr.mr_n86157680)
print v(xbgr.mr_n86157792)
print v(xbgr.mr_n86158112)
print v(xbgr.mr_n86158224)
print v(xbgr.mr_n86158544)
print v(xbgr.mr_n86158656)
print v(xbgr.mr_n86158976)
print v(xbgr.mr_n86159088)
print v(xbgr.mr_n86159408)
print v(xbgr.mr_n86159520)
print v(xbgr.mr_n86159840)
print v(xbgr.mr_n86159952)
print v(xbgr.mr_n86160272)
print v(xbgr.mr_n86160384)
print v(xbgr.mr_n86160704)
print v(xbgr.mr_n86160816)
print v(xbgr.mr_n86161136)
print v(xbgr.mr_n86161248)
print v(xbgr.mr_n86161568)
print v(xbgr.mr_n86161680)
print v(xbgr.mr_n86162000)
print v(xbgr.mr_n86162112)
print v(xbgr.mr_n86162432)
print v(xbgr.mr_n86162544)
print v(xbgr.mr_n86162864)
print v(xbgr.mr_n86162976)
print v(xbgr.mr_n86163296)
print v(xbgr.mr_n86163408)
print v(xbgr.mr_n86163728)
print v(xbgr.mr_n86163840)
print v(xbgr.mr_n86164160)
print v(xbgr.mr_n86164272)
print v(xbgr.mr_n86164592)
print v(xbgr.mr_n86164704)
print v(xbgr.mr_n86165024)
print v(xbgr.mr_n86165136)
print v(xbgr.mr_n86165456)
print v(xbgr.mr_n86165568)
print v(xbgr.mr_n86165888)
print v(xbgr.mr_n86166000)
print v(xbgr.mr_n86166320)
print v(xbgr.mr_n86166432)
print v(xbgr.mr_n86166752)
print v(xbgr.mr_n86166864)
print v(xbgr.mr_n86167184)
print v(xbgr.mr_n86167296)
print v(xbgr.mr_n86167616)
print v(xbgr.mr_n86167728)
print v(xbgr.mr_n86168048)
print v(xbgr.mr_n86168160)
print v(xbgr.mr_n86168480)
print v(xbgr.mr_n86168592)
print v(xbgr.mr_n86168912)
print v(xbgr.mr_n86169024)
print v(xbgr.mr_n86169344)
print v(xbgr.mr_n86169456)
print v(xbgr.mr_n86169776)
print v(xbgr.mr_n86169888)
print v(xbgr.mr_n86170208)
print v(xbgr.mr_n86170320)
print v(xbgr.mr_n86170640)
print v(xbgr.mr_n86170752)
print v(xbgr.mr_n86171072)
print v(xbgr.mr_n86171184)
print v(xbgr.mr_n86171504)
print v(xbgr.mr_n86171616)
print v(xbgr.mr_n86171936)
print v(xbgr.mr_n86172048)
print v(xbgr.mr_n86172368)
print v(xbgr.mr_n86172480)
print v(xbgr.mr_n86172800)
print v(xbgr.mr_n86172912)
print v(xbgr.mr_n86173232)
print v(xbgr.mr_n86173344)
print v(xbgr.mr_n86173664)
print v(xbgr.mr_n86173776)
print v(xbgr.mr_n86174096)
print v(xbgr.mr_n86174208)
print v(xbgr.mr_n86174528)
print v(xbgr.mr_n86174640)
print v(xbgr.mr_n86174960)
print v(xbgr.mr_n86175072)
print v(xbgr.mr_n86175392)
print v(xbgr.mr_n86175504)
print v(xbgr.mr_n86175824)
print v(xbgr.mr_n86175936)
print v(xbgr.mr_n86176256)
print v(xbgr.mr_n86176368)
print v(xbgr.mr_n86176688)
print v(xbgr.mr_n86176800)
print v(xbgr.mr_n86177120)
print v(xbgr.mr_n86177232)
print v(xbgr.mr_n86177552)
print v(xbgr.mr_n86177664)
print v(xbgr.mr_n86177984)
print v(xbgr.mr_n86178096)
print v(xbgr.mr_n86178416)
print v(xbgr.mr_n86178528)
print v(xbgr.mr_n86178848)
print v(xbgr.mr_n86178960)
print v(xbgr.mr_n86179280)
print v(xbgr.mr_n86179392)
print v(xbgr.mr_n86179712)
print v(xbgr.mr_n86179824)
print v(xbgr.mr_n86180144)
print v(xbgr.mr_n86180256)
print v(xbgr.mr_n86180576)
print v(xbgr.mr_n86180688)
print v(xbgr.mr_n86181008)
print v(xbgr.mr_n86181120)
print v(xbgr.mr_n86181440)
print v(xbgr.mr_n86181552)
print v(xbgr.mr_n86181872)
print v(xbgr.mr_n86181984)
print v(xbgr.mr_n86182304)
print v(xbgr.mr_n86182416)
print v(xbgr.mr_n86182736)
print v(xbgr.mr_n86182848)
print v(xbgr.mr_n86183168)
print v(xbgr.mr_n86183280)
print v(xbgr.mr_n86183600)
print v(xbgr.mr_n86183712)
print v(xbgr.mr_n86184032)
print v(xbgr.mr_n86184144)
print v(xbgr.mr_n86184464)
print v(xbgr.mr_n86184576)
print v(xbgr.mr_n86184896)
print v(xbgr.mr_n86185008)
print v(xbgr.mr_n86185328)
print v(xbgr.mr_n86185440)
print v(xbgr.mr_n86185760)
print v(xbgr.mr_n86185872)
print v(xbgr.mr_n86186192)
print v(xbgr.mr_n86186304)
print v(xbgr.mr_n86186624)
print v(xbgr.mr_n86186736)
print v(xbgr.mr_n86187056)
print v(xbgr.mr_n86187168)
print v(xbgr.mr_n86187488)
print v(xbgr.mr_n86187600)
print v(xbgr.mr_n86187920)
print v(xbgr.mr_n86188032)
print v(xbgr.mr_n86188352)
print v(xbgr.mr_n86188464)
print v(xbgr.mr_n86188784)
print v(xbgr.mr_n86188896)
print v(xbgr.mr_n86254768)
print v(xbgr.mr_n86254880)
print v(xbgr.mr_n86255200)
print v(xbgr.mr_n86255312)
print v(xbgr.mr_n86255632)
print v(xbgr.mr_n86255744)
print v(xbgr.mr_n86256176)
print v(xbgr.mr_n86256496)
print v(xbgr.mr_n86256608)
print v(xbgr.mr_n86256928)
print v(xbgr.mr_n86257040)
print v(xbgr.mr_n86257472)
print v(xbgr.mr_n86257904)
print v(xbgr.mr_n86258224)
print v(xbgr.mr_n86258336)
print v(xbgr.mr_n86258656)
print v(xbgr.mr_n86258768)
print v(xbgr.mr_n86259088)
print v(xbgr.mr_n86259200)
print v(xbgr.mr_n86259520)
print v(xbgr.mr_n86259632)
print v(xbgr.mr_n86259952)
print v(xbgr.mr_n86260064)
print v(xbgr.mr_n86260384)
print v(xbgr.mr_n86260496)
print v(xbgr.mr_n86260816)
print v(xbgr.mr_n86260928)
print v(xbgr.mr_n86261248)
print v(xbgr.mr_n86261360)
print v(xbgr.mr_n86261680)
print v(xbgr.mr_n86261792)
print v(xbgr.mr_n86262112)
print v(xbgr.mr_n86262224)
print v(xbgr.mr_n86262544)
print v(xbgr.mr_n86262656)
print v(xbgr.mr_n86262976)
print v(xbgr.mr_n86263088)
print v(xbgr.mr_n86263520)
print v(xbgr.mr_n86263840)
print v(xbgr.mr_n86263952)
print v(xbgr.mr_n86264272)
print v(xbgr.mr_n86264384)
print v(xbgr.mr_n86264704)
print v(xbgr.mr_n86264816)
print v(xbgr.mr_n86265136)
print v(xbgr.mr_n86265248)
print v(xbgr.mr_n86265568)
print v(xbgr.mr_n86265680)
print v(xbgr.mr_n86266000)
print v(xbgr.mr_n86266112)
print v(xbgr.mr_n86266432)
print v(xbgr.mr_n86266544)
print v(xbgr.mr_n86266864)
print v(xbgr.mr_n86266976)
print v(xbgr.mr_n86267296)
print v(xbgr.mr_n86267408)
print v(xbgr.mr_n86267728)
print v(xbgr.mr_n86267840)
print v(xbgr.mr_n86268272)
print v(xbgr.mr_n86268704)
print v(xbgr.mr_n86269024)
print v(xbgr.mr_n86269136)
print v(xbgr.mr_n86269456)
print v(xbgr.mr_n86269568)
print v(xbgr.mr_n86269888)
print v(xbgr.mr_n86270000)
print v(xbgr.mr_n86270320)
print v(xbgr.mr_n86270432)
print v(xbgr.mr_n86270752)
print v(xbgr.mr_n86270864)
print v(xbgr.mr_n86271184)
print v(xbgr.mr_n86271296)
print v(xbgr.mr_n86271616)
print v(xbgr.mr_n86271728)
print v(xbgr.mr_n86272048)
print v(xbgr.mr_n86272160)
print v(xbgr.mr_n86272480)
print v(xbgr.mr_n86272592)
print v(xbgr.mr_n86272912)
print v(xbgr.mr_n86273024)
print v(xbgr.mr_n86273344)
print v(xbgr.mr_n86273456)
print v(xbgr.mr_n86273776)
print v(xbgr.mr_n86273888)
print v(xbgr.mr_n86274208)
print v(xbgr.mr_n86274320)
print v(xbgr.mr_n86274640)
print v(xbgr.mr_n86274752)
print v(xbgr.mr_n86275072)
print v(xbgr.mr_n86275184)
print v(xbgr.mr_n86275504)
print v(xbgr.mr_n86275616)
print v(xbgr.mr_n86275936)
print v(xbgr.mr_n86276048)
print v(xbgr.mr_n86276368)
print v(xbgr.mr_n86276480)
print v(xbgr.mr_n86276800)
print v(xbgr.mr_n86276912)
print v(xbgr.mr_n86277232)
print v(xbgr.mr_n86277344)
print v(xbgr.mr_n86277664)
print v(xbgr.mr_n86277776)
print v(xbgr.mr_n86278096)
print v(xbgr.mr_n86278208)
print v(xbgr.mr_n86278528)
print v(xbgr.mr_n86278640)
print v(xbgr.mr_n86278960)
print v(xbgr.mr_n86279072)
print v(xbgr.mr_n86279392)
print v(xbgr.mr_n86279504)
print v(xbgr.mr_n86279824)
print v(xbgr.mr_n86279936)
print v(xbgr.mr_n86280256)
print v(xbgr.mr_n86280368)
print v(xbgr.mr_n86280688)
print v(xbgr.mr_n86280800)
print v(xbgr.mr_n86281120)
print v(xbgr.mr_n86281232)
print v(xbgr.mr_n86281552)
print v(xbgr.mr_n86281664)
print v(xbgr.mr_n86281984)
print v(xbgr.mr_n86282096)
print v(xbgr.mr_n86282416)
print v(xbgr.mr_n86282528)
print v(xbgr.mr_n86282848)
print v(xbgr.mr_n86282960)
print v(xbgr.mr_n86283280)
print v(xbgr.mr_n86283392)
print v(xbgr.mr_n86283712)
print v(xbgr.mr_n86283824)
print v(xbgr.mr_n86284144)
print v(xbgr.mr_n86284256)
print v(xbgr.mr_n86284576)
print v(xbgr.mr_n86284688)
print v(xbgr.mr_n86285008)
print v(xbgr.mr_n86285120)
print v(xbgr.mr_n86285440)
print v(xbgr.mr_n86285552)
print v(xbgr.mr_n86285872)
print v(xbgr.mr_n86285984)
print v(xbgr.mr_n86286304)
print v(xbgr.mr_n86286416)
print v(xbgr.mr_n86286736)
print v(xbgr.mr_n86286848)
print v(xbgr.mr_n86287168)
print v(xbgr.mr_n86287280)
print v(xbgr.mr_n86287600)
print v(xbgr.mr_n86287712)
print v(xbgr.mr_n86288032)
print v(xbgr.mr_n86288144)
print v(xbgr.mr_n86288464)
print v(xbgr.mr_n86288576)
print v(xbgr.mr_n86288896)
print v(xbgr.mr_n86289008)
print v(xbgr.mr_n86289328)
print v(xbgr.mr_n86289440)
print v(xbgr.mr_n86289760)
print v(xbgr.mr_n86289872)
print v(xbgr.mr_n86290192)
print v(xbgr.mr_n86290304)
print v(xbgr.mr_n86290624)
print v(xbgr.mr_n86290736)
print v(xbgr.mr_n86291056)
print v(xbgr.mr_n86291168)
print v(xbgr.mr_n86291488)
print v(xbgr.mr_n86291600)
print v(xbgr.mr_n86291920)
print v(xbgr.mr_n86292032)
print v(xbgr.mr_n86292352)
print v(xbgr.mr_n86292464)
print v(xbgr.mr_n86292784)
print v(xbgr.mr_n86292896)
print v(xbgr.mr_n86293216)
print v(xbgr.mr_n86293328)
print v(xbgr.mr_n86293648)
print v(xbgr.mr_n86293760)
print v(xbgr.mr_n86294080)
print v(xbgr.mr_n86294192)
print v(xbgr.mr_n86294512)
print v(xbgr.mr_n86294624)
print v(xbgr.mr_n86294944)
print v(xbgr.mr_n86295056)
print v(xbgr.mr_n86295376)
print v(xbgr.mr_n86295488)
print v(xbgr.mr_n86295808)
print v(xbgr.mr_n86295920)
print v(xbgr.mr_n86296240)
print v(xbgr.mr_n86296352)
print v(xbgr.mr_n86296672)
print v(xbgr.mr_n86296784)
print v(xbgr.mr_n86297104)
print v(xbgr.mr_n86297216)
print v(xbgr.mr_n86297536)
print v(xbgr.mr_n86297648)
print v(xbgr.mr_n86297968)
print v(xbgr.mr_n86298080)
print v(xbgr.mr_n86298400)
print v(xbgr.mr_n86298512)
print v(xbgr.mr_n86298832)
print v(xbgr.mr_n86298944)
print v(xbgr.mr_n86299264)
print v(xbgr.mr_n86299376)
print v(xbgr.mr_n86299696)
print v(xbgr.mr_n86299808)
print v(xbgr.mr_n86300128)
print v(xbgr.mr_n86300240)
print v(xbgr.mr_n86300560)
print v(xbgr.mr_n86300672)
print v(xbgr.mr_n86300992)
print v(xbgr.mr_n86301104)
print v(xbgr.mr_n86301424)
print v(xbgr.mr_n86301536)
print v(xbgr.mr_n86301856)
print v(xbgr.mr_n86301968)
print v(xbgr.mr_n86302288)
print v(xbgr.mr_n86302400)
print v(xbgr.mr_n86302720)
print v(xbgr.mr_n86302832)
print v(xbgr.mr_n86303152)
print v(xbgr.mr_n86303264)
print v(xbgr.mr_n86303584)
print v(xbgr.mr_n86303696)
print v(xbgr.mr_n86304016)
print v(xbgr.mr_n86304128)
print v(xbgr.mr_n86304448)
print v(xbgr.mr_n86304560)
print v(xbgr.mr_n86304880)
print v(xbgr.mr_n86304992)
print v(xbgr.mr_n86305312)
print v(xbgr.mr_n86305424)
print v(xbgr.mr_n86305744)
print v(xbgr.mr_n86305856)
print v(xbgr.mr_n86306176)
print v(xbgr.mr_n86306288)
print v(xbgr.mr_n86306608)
print v(xbgr.mr_n86306720)
print v(xbgr.mr_n86307040)
print v(xbgr.mr_n86307152)
print v(xbgr.mr_n86307472)
print v(xbgr.mr_n86307584)
print v(xbgr.mr_n86307904)
print v(xbgr.mr_n86308016)
print v(xbgr.mr_n86308336)
print v(xbgr.mr_n86308448)
print v(xbgr.mr_n86308768)
print v(xbgr.mr_n86308880)
print v(xbgr.mr_n86309200)
print v(xbgr.mr_n86309312)
print v(xbgr.mr_n86309632)
print v(xbgr.mr_n86309744)
print v(xbgr.mr_n86310064)
print v(xbgr.mr_n86310176)
print v(xbgr.mr_n86310496)
print v(xbgr.mr_n86310608)
print v(xbgr.mr_n86310928)
print v(xbgr.mr_n86311040)
print v(xbgr.mr_n86311360)
print v(xbgr.mr_n86311472)
print v(xbgr.mr_n86311792)
print v(xbgr.mr_n86311904)
print v(xbgr.mr_n86312224)
print v(xbgr.mr_n86312336)
print v(xbgr.mr_n86312656)
print v(xbgr.mr_n86312768)
print v(xbgr.mr_n86313088)
print v(xbgr.mr_n86313200)
print v(xbgr.mr_n86313520)
print v(xbgr.mr_n86313632)
print v(xbgr.mr_n86313952)
print v(xbgr.mr_n86314064)
print v(xbgr.mr_n86314384)
print v(xbgr.mr_n86314496)
print v(xbgr.mr_n86314816)
print v(xbgr.mr_n86314928)
print v(xbgr.mr_n86315248)
print v(xbgr.mr_n86315360)
print v(xbgr.mr_n86315680)
print v(xbgr.mr_n86315792)
print v(xbgr.mr_n86316112)
print v(xbgr.mr_n86316224)
print v(xbgr.mr_n86316544)
print v(xbgr.mr_n86316656)
print v(xbgr.mr_n86316976)
print v(xbgr.mr_n86317088)
print v(xbgr.mr_n86317408)
print v(xbgr.mr_n86317520)
print v(xbgr.mr_n86317840)
print v(xbgr.mr_n86317952)
print v(xbgr.mr_n86318272)
print v(xbgr.mr_n86318384)
print v(xbgr.mr_n86318704)
print v(xbgr.mr_n86318816)
print v(xbgr.mr_n86319136)
print v(xbgr.mr_n86319248)
print v(xbgr.mr_n86319568)
print v(xbgr.mr_n86319680)
print v(xbgr.mr_n86320000)
print v(xbgr.mr_n86320112)
print v(xbgr.mr_n86320432)
print v(xbgr.mr_n86320544)
print v(xbgr.mr_n86320864)
print v(xbgr.mr_n86320976)
print v(xbgr.mr_n86321296)
print v(xbgr.mr_n86321408)
print v(xbgr.mr_n86321728)
print v(xbgr.mr_n86321840)
print v(xbgr.mr_n86322160)
print v(xbgr.mr_n86322272)
print v(xbgr.mr_n86322592)
print v(xbgr.mr_n86322704)
print v(xbgr.mr_n86323024)
print v(xbgr.mr_n86323136)
print v(xbgr.mr_n86323456)
print v(xbgr.mr_n86323568)
print v(xbgr.mr_n86323888)
print v(xbgr.mr_n86324000)
print v(xbgr.mr_n86324320)
print v(xbgr.mr_n86324432)
print v(xbgr.mr_n86324752)
print v(xbgr.mr_n86324864)
print v(xbgr.mr_n86325184)
print v(xbgr.mr_n86325296)
print v(xbgr.mr_n86325616)
print v(xbgr.mr_n86325728)
print v(xbgr.mr_n86326048)
print v(xbgr.mr_n86326160)
print v(xbgr.mr_n86326480)
print v(xbgr.mr_n86326592)
print v(xbgr.mr_n86326912)
print v(xbgr.mr_n86327024)
print v(xbgr.mr_n86327344)
print v(xbgr.mr_n86327456)
print v(xbgr.mr_n86327776)
print v(xbgr.mr_n86327888)
print v(xbgr.mr_n86328208)
print v(xbgr.mr_n86328320)
print v(xbgr.mr_n86328640)
print v(xbgr.mr_n86328752)
print v(xbgr.mr_n86329072)
print v(xbgr.mr_n86329184)
print v(xbgr.mr_n86329504)
print v(xbgr.mr_n86329616)
print v(xbgr.mr_n86329936)
print v(xbgr.mr_n86330048)
print v(xbgr.mr_n86330368)
print v(xbgr.mr_n86330480)
print v(xbgr.mr_n86330800)
print v(xbgr.mr_n86330912)
print v(xbgr.mr_n86331232)
print v(xbgr.mr_n86331344)
print v(xbgr.mr_n86331664)
print v(xbgr.mr_n86331776)
print v(xbgr.mr_n86332096)
print v(xbgr.mr_n86332208)
print v(xbgr.mr_n86332528)
print v(xbgr.mr_n86332640)
print v(xbgr.mr_n86332960)
print v(xbgr.mr_n86333072)
print v(xbgr.mr_n86333392)
print v(xbgr.mr_n86333504)
print v(xbgr.mr_n86333824)
print v(xbgr.mr_n86333936)
print v(xbgr.mr_n86334256)
print v(xbgr.mr_n86334368)
print v(xbgr.mr_n86334688)
print v(xbgr.mr_n86334800)
print v(xbgr.mr_n86335120)
print v(xbgr.mr_n86335232)
print v(xbgr.mr_n86335552)
print v(xbgr.mr_n86335664)
print v(xbgr.mr_n86335984)
print v(xbgr.mr_n86336096)
print v(xbgr.mr_n86336416)
print v(xbgr.mr_n86336528)
print v(xbgr.mr_n86336960)
print v(xbgr.mr_n86337280)
print v(xbgr.mr_n86337392)
print v(xbgr.mr_n86337712)
print v(xbgr.mr_n86337824)
print v(xbgr.mr_n86338144)
print v(xbgr.mr_n86338256)
print v(xbgr.mr_n86338576)
print v(xbgr.mr_n86338688)
print v(xbgr.mr_n86339008)
print v(xbgr.mr_n86339872)
print v(xbgr.mr_n86339984)
print v(xbgr.mr_n86340304)
print v(xbgr.mr_n86340416)
print v(xbgr.mr_n86340736)
print v(xbgr.mr_n86340848)
print v(xbgr.mr_n86341168)
print v(xbgr.mr_n86341280)
print v(xbgr.mr_n86341600)
print v(xbgr.mr_n86341712)
print v(xbgr.mr_n86342144)
print v(xbgr.mr_n86342464)
print v(xbgr.mr_n86342576)
print v(xbgr.mr_n86342896)
print v(xbgr.mr_n86343008)
print v(xbgr.mr_n86343328)
print v(xbgr.mr_n86343440)
print v(xbgr.mr_n86343760)
print v(xbgr.mr_n86343872)
print v(xbgr.mr_n86344192)
print v(xbgr.mr_n86344304)
print v(xbgr.mr_n86344736)
print v(xbgr.mr_n86345056)
print v(xbgr.mr_n86345920)
print v(xbgr.mr_n86346032)
print v(xbgr.mr_n86346464)
print v(xbgr.mr_n86346784)
print v(xbgr.mr_n86347648)
print v(xbgr.mr_n86347760)
print v(xbgr.mr_n86348192)
print v(xbgr.mr_n86348512)
print v(xbgr.mr_n86348624)
print v(xbgr.mr_n86348944)
print v(xbgr.mr_n86349056)
print v(xbgr.mr_n86349376)
print v(xbgr.mr_n86349488)
print v(xbgr.mr_n86349808)
print v(xbgr.mr_n86349920)
print v(xbgr.mr_n86350240)
print v(xbgr.mr_n86350352)
print v(xbgr.mr_n86350672)
print v(xbgr.mr_n86350784)
print v(xbgr.mr_n86351104)
print v(xbgr.mr_n86351968)
print v(xbgr.mr_n86352080)
print v(xbgr.mr_n86352400)
print v(xbgr.mr_n86352512)
print v(xbgr.mr_n86352832)
print v(xbgr.mr_n86353696)
print v(xbgr.mr_n86353808)
print v(xbgr.mr_n86354128)
print v(xbgr.mr_n86354240)
print v(xbgr.mr_n86354560)
print v(xbgr.mr_n86354672)
print v(xbgr.mr_n86354992)
print v(xbgr.mr_n86355104)
print v(xbgr.mr_n86355424)
print v(xbgr.mr_n86355536)
print v(xbgr.mr_n86355856)
print v(xbgr.mr_n86355968)
print v(xbgr.mr_n86356288)
print v(xbgr.mr_n86356400)
print v(xbgr.mr_n86356720)
print v(xbgr.mr_n86356832)
print v(xbgr.mr_n86357152)
print v(xbgr.mr_n86357264)
print v(xbgr.mr_n86357584)
print v(xbgr.mr_n86357696)
print v(xbgr.mr_n86358016)
print v(xbgr.mr_n86358128)
print v(xbgr.mr_n86358448)
print v(xbgr.mr_n86358560)
print v(xbgr.mr_n86358880)
print v(xbgr.mr_n86358992)
print v(xbgr.mr_n86359312)
print v(xbgr.mr_n86359424)
print v(xbgr.mr_n86359744)
print v(xbgr.mr_n86359856)
print v(xbgr.mr_n86360176)
print v(xbgr.mr_n86360288)
print v(xbgr.mr_n86360608)
print v(xbgr.mr_n86360720)
print v(xbgr.mr_n86361040)
print v(xbgr.mr_n86361152)
print v(xbgr.mr_n86361472)
print v(xbgr.mr_n86361584)
print v(xbgr.mr_n86361904)
print v(xbgr.mr_n86362016)
print v(xbgr.mr_n86362336)
print v(xbgr.mr_n86362448)
print v(xbgr.mr_n86362768)
print v(xbgr.mr_n86362880)
print v(xbgr.mr_n86363200)
print v(xbgr.mr_n86363312)
print v(xbgr.mr_n86363632)
print v(xbgr.mr_n86363744)
print v(xbgr.mr_n86364064)
print v(xbgr.mr_n86364176)
print v(xbgr.mr_n86364496)
print v(xbgr.mr_n86364608)
print v(xbgr.mr_n86365040)
print v(xbgr.mr_n86365472)
print v(xbgr.mr_n86365904)
print v(xbgr.mr_n86366336)
print v(xbgr.mr_n86366768)
print v(xbgr.mr_n86367200)
print v(xbgr.mr_n86367632)
print v(xbgr.mr_n86368064)
print v(xbgr.mr_n86368496)
print v(xbgr.mr_n86368928)
print v(xbgr.mr_n86369360)
print v(xbgr.mr_n86369792)
print v(xbgr.mr_n86370224)
print v(xbgr.mr_n86370656)
print v(xbgr.mr_n86371088)
print v(xbgr.mr_n86371520)
print v(xbgr.mr_n86371952)
print v(xbgr.mr_n86372384)
print v(xbgr.mr_n86372816)
print v(xbgr.mr_n86373248)
print v(xbgr.mr_n86373680)
print v(xbgr.mr_n86374112)
print v(xbgr.mr_n86374432)
print v(xbgr.mr_n86374544)
print v(xbgr.mr_n86374976)
print v(xbgr.mr_n86375408)
print v(xbgr.mr_n86375840)
print v(xbgr.mr_n86376272)
print v(xbgr.mr_n86376704)
print v(xbgr.mr_n86377136)
print v(xbgr.mr_n86377568)
print v(xbgr.mr_n86378000)
print v(xbgr.mr_n86378432)
print v(xbgr.mr_n86378864)
print v(xbgr.mr_n86379296)
print v(xbgr.mr_n86379728)
print v(xbgr.mr_n86380160)
print v(xbgr.mr_n86380592)
print v(xbgr.mr_n86381024)
print v(xbgr.mr_n86381456)
print v(xbgr.mr_n86381888)
print v(xbgr.mr_n86382320)
print v(xbgr.mr_n86382752)
print v(xbgr.mr_n86383184)
print v(xbgr.mr_n86383616)
print v(xbgr.mr_n86384048)
print v(xbgr.mr_n86384480)
print v(xbgr.mr_n86384912)
print v(xbgr.mr_n86385344)
print v(xbgr.mr_n86385776)
print v(xbgr.mr_n86386208)
print v(xbgr.mr_n86386640)
print v(xbgr.mr_n86387072)
print v(xbgr.mr_n86387504)
print v(xbgr.mr_n86387936)
print v(xbgr.mr_n86388368)
print v(xbgr.mr_n86388800)
print v(xbgr.mr_n86389232)
print v(xbgr.mr_n86389664)
print v(xbgr.mr_n86390096)
print v(xbgr.mr_n86390528)
print v(xbgr.mr_n86390960)
print v(xbgr.mr_n86391392)
print v(xbgr.mr_n86391824)
print v(xbgr.mr_n86392256)
print v(xbgr.mr_n86392688)
print v(xbgr.mr_n86393120)
print v(xbgr.mr_n86393552)
print v(xbgr.mr_n86393984)
print v(xbgr.mr_n86394416)
print v(xbgr.mr_n86394848)
print v(xbgr.mr_n86395280)
print v(xbgr.mr_n86395712)
print v(xbgr.mr_n86396144)
print v(xbgr.mr_n86396576)
print v(xbgr.mr_n86397008)
print v(xbgr.mr_n86397440)
print v(xbgr.mr_n86397872)
print v(xbgr.mr_n86398304)
print v(xbgr.mr_n86398736)
print v(xbgr.mr_n86399168)
print v(xbgr.mr_n86399600)
print v(xbgr.mr_n86400032)
print v(xbgr.mr_n86400464)
print v(xbgr.mr_n86400896)
print v(xbgr.mr_n86401328)
print v(xbgr.mr_n86401760)
print v(xbgr.mr_n86402080)
print v(xbgr.mr_n86402192)
print v(xbgr.mr_n86402512)
print v(xbgr.mr_n86402624)
print v(xbgr.mr_n86402944)
print v(xbgr.mr_n86403056)
print v(xbgr.mr_n86403376)
print v(xbgr.mr_n86403488)
print v(xbgr.mr_n86403808)
print v(xbgr.mr_n86403920)
print v(xbgr.mr_n86404240)
print v(xbgr.mr_n86404352)
print v(xbgr.mr_n86404672)
print v(xbgr.mr_n86404784)
print v(xbgr.mr_n86405104)
print v(xbgr.mr_n86405216)
print v(xbgr.mr_n86405536)
print v(xbgr.mr_n86405648)
print v(xbgr.mr_n86405968)
print v(xbgr.mr_n86406080)
print v(xbgr.mr_n86406400)
print v(xbgr.mr_n86406512)
print v(xbgr.mr_n86406832)
print v(xbgr.mr_n86406944)
print v(xbgr.mr_n86407264)
print v(xbgr.mr_n86407696)
print v(xbgr.mr_n86407808)
print v(xbgr.mr_n86408128)
print v(xbgr.mr_n86408240)
print v(xbgr.mr_n86408560)
print v(xbgr.mr_n86408672)
print v(xbgr.mr_n86408992)
print v(xbgr.mr_n86409104)
print v(xbgr.mr_n86409424)
print v(xbgr.mr_n86409536)
print v(xbgr.mr_n86409856)
print v(xbgr.mr_n86409968)
print v(xbgr.mr_n86410288)
print v(xbgr.mr_n86410400)
print v(xbgr.mr_n86410720)
print v(xbgr.mr_n86410832)
print v(xbgr.mr_n86411152)
print v(xbgr.mr_n86411264)
print v(xbgr.mr_n86411584)
print v(xbgr.mr_n86411696)
print v(xbgr.mr_n86412016)
print v(xbgr.mr_n86412128)
print v(xbgr.mr_n86412560)
print v(xbgr.mr_n86412992)
print v(xbgr.mr_n86413424)
print v(xbgr.mr_n86413856)
print v(xbgr.mr_n86414288)
print v(xbgr.mr_n86414720)
print v(xbgr.mr_n86415152)
print v(xbgr.mr_n86415584)
print v(xbgr.mr_n86416016)
print v(xbgr.mr_n86416448)
print v(xbgr.mr_n86416880)
print v(xbgr.mr_n86417312)
print v(xbgr.mr_n86417744)
print v(xbgr.mr_n86418176)
print v(xbgr.mr_n86418608)
print v(xbgr.mr_n86419040)
print v(xbgr.mr_n86419472)
print v(xbgr.mr_n86419904)
print v(xbgr.mr_n86420336)
print v(xbgr.mr_n86420768)
print v(xbgr.mr_n86421200)
print v(xbgr.mr_n86421632)
print v(xbgr.mr_n86422064)
print v(xbgr.mr_n86422496)
print v(xbgr.mr_n86422928)
print v(xbgr.mr_n86423360)
print v(xbgr.mr_n86423792)
print v(xbgr.mr_n86424224)
print v(xbgr.mr_n86424656)
print v(xbgr.mr_n86425088)
print v(xbgr.mr_n86425520)
print v(xbgr.mr_n86425952)
print v(xbgr.mr_n86426384)
print v(xbgr.mr_n86426816)
print v(xbgr.mr_n86427248)
print v(xbgr.mr_n86427680)
print v(xbgr.mr_n86428112)
print v(xbgr.mr_n86428544)
print v(xbgr.mr_n86428976)
print v(xbgr.mr_n86429408)
print v(xbgr.mr_n86429840)
print v(xbgr.mr_n86430272)
print v(xbgr.mr_n86430704)
print v(xbgr.mr_n86431136)
print v(xbgr.mr_n86431568)
print v(xbgr.mr_n86432000)
print v(xbgr.mr_n86432432)
print v(xbgr.mr_n86432864)
print v(xbgr.mr_n86433296)
print v(xbgr.mr_n86433728)
print v(xbgr.mr_n86434160)
print v(xbgr.mr_n86434592)
print v(xbgr.mr_n86435024)
print v(xbgr.mr_n86435456)
print v(xbgr.mr_n86435888)
print v(xbgr.mr_n86436320)
print v(xbgr.mr_n86436752)
print v(xbgr.mr_n86437184)
print v(xbgr.mr_n86437616)
print v(xbgr.mr_n86438048)
print v(xbgr.mr_n86438480)
print v(xbgr.mr_n86438912)
print v(xbgr.mr_n86439344)
print v(xbgr.mr_n86439776)
print v(xbgr.mr_n86440208)
print v(xbgr.mr_n86440640)
print v(xbgr.mr_n86441072)
print v(xbgr.mr_n86441504)
print v(xbgr.mr_n86441936)
print v(xbgr.mr_n86442368)
print v(xbgr.mr_n86442800)
print v(xbgr.mr_n86443232)
print v(xbgr.mr_n86443664)
print v(xbgr.mr_n86444096)
print v(xbgr.mr_n86444528)
print v(xbgr.mr_n86444960)
print v(xbgr.mr_n86445392)
print v(xbgr.mr_n86445824)
print v(xbgr.mr_n86446256)
print v(xbgr.mr_n86446688)
print v(xbgr.mr_n86447120)
print v(xbgr.mr_n86447552)
print v(xbgr.mr_n86447984)
print v(xbgr.mr_n86448416)
print v(xbgr.mr_n86448848)
print v(xbgr.mr_n86449280)
print v(xbgr.mr_n86449600)
print v(xbgr.mr_n86449712)
print v(xbgr.mr_n86450032)
print v(xbgr.mr_n86450144)
print v(xbgr.mr_n86450464)
print v(xbgr.mr_n86450576)
print v(xbgr.mr_n86450896)
print v(xbgr.mr_n86451008)
print v(xbgr.mr_n86451328)
print v(xbgr.mr_n86451440)
print v(xbgr.mr_n86451760)
print v(xbgr.mr_n86451872)
print v(xbgr.mr_n86452192)
print v(xbgr.mr_n86452304)
print v(xbgr.mr_n86452624)
print v(xbgr.mr_n86452736)
print v(xbgr.mr_n86453056)
print v(xbgr.mr_n86453168)
print v(xbgr.mr_n86453488)
print v(xbgr.mr_n86453600)
print v(xbgr.mr_n86453920)
print v(xbgr.mr_n86454032)
print v(xbgr.mr_n86454352)
print v(xbgr.mr_n86454464)
print v(xbgr.mr_n86454784)
print v(xbgr.mr_n86454896)
print v(xbgr.mr_n86455216)
print v(xbgr.mr_n86455328)
print v(xbgr.mr_n86455648)
print v(xbgr.mr_n86455760)
print v(xbgr.mr_n86456080)
print v(xbgr.mr_n86456192)
print v(xbgr.mr_n86456512)
print v(xbgr.mr_n86456624)
print v(xbgr.mr_n86456944)
print v(xbgr.mr_n86457056)
print v(xbgr.mr_n86457376)
print v(xbgr.mr_n86457920)
print v(xbgr.mr_n86458240)
print v(xbgr.mr_n86458672)
print v(xbgr.mr_n86458784)
print v(xbgr.mr_n86459104)
print v(xbgr.mr_n86459216)
print v(xbgr.mr_n86459648)
print v(xbgr.mr_n86459968)
print v(xbgr.mr_n86460832)
print v(xbgr.mr_n86460944)
print v(xbgr.mr_n86461376)
print v(xbgr.mr_n86461696)
print v(xbgr.mr_n86462560)
print v(xbgr.mr_n86462672)
print v(xbgr.mr_n86463104)
print v(xbgr.mr_n86463424)
print v(xbgr.mr_n86463536)
print v(xbgr.mr_n86463968)
print v(xbgr.mr_n86464400)
print v(xbgr.mr_n86464720)
print v(xbgr.mr_n86465584)
print v(xbgr.mr_n86466560)
print v(xbgr.mr_n86466880)
print v(xbgr.mr_n86466992)
print v(xbgr.mr_n86467424)
print v(xbgr.mr_n86467744)
print v(xbgr.mr_n86467856)
print v(xbgr.mr_n86468288)
print v(xbgr.mr_n86468608)
print v(xbgr.mr_n86468720)
print v(xbgr.mr_n86469040)
print v(xbgr.mr_n86469152)
print v(xbgr.mr_n86469472)
print v(xbgr.mr_n86469584)
print v(xbgr.mr_n86469904)
print v(xbgr.mr_n86470016)
print v(xbgr.mr_n86470336)
print v(xbgr.mr_n86470448)
print v(xbgr.mr_n86470768)
print v(xbgr.mr_n86470880)
print v(xbgr.mr_n86471200)
print v(xbgr.mr_n86471312)
print v(xbgr.mr_n86471632)
print v(xbgr.mr_n86471744)
print v(xbgr.mr_n86472064)
print v(xbgr.mr_n86472176)
print v(xbgr.mr_n86472496)
print v(xbgr.mr_n86472608)
print v(xbgr.mr_n86472928)
print v(xbgr.mr_n86473040)
print v(xbgr.mr_n86473360)
print v(xbgr.mr_n86473472)
print v(xbgr.mr_n86473792)
print v(xbgr.mr_n86474656)
print v(xbgr.mr_n86475520)
print v(xbgr.mr_n86475952)
print v(xbgr.mr_n86476384)
print v(xbgr.mr_n86476816)
print v(xbgr.mr_n86477248)
print v(xbgr.mr_n86477680)
print v(xbgr.mr_n86478112)
print v(xbgr.mr_n86478544)
print v(xbgr.mr_n86478976)
print v(xbgr.mr_n86479408)
print v(xbgr.mr_n86479840)
print v(xbgr.mr_n86480272)
print v(xbgr.mr_n86480704)
print v(xbgr.mr_n86480816)
print v(xbgr.mr_n86481136)
print v(xbgr.mr_n86481248)
print v(xbgr.mr_n86481568)
print v(xbgr.mr_n86481680)
print v(xbgr.mr_n86482000)
print v(xbgr.mr_n86482112)
print v(xbgr.mr_n86482432)
print v(xbgr.mr_n86482544)
print v(xbgr.mr_n86482864)
print v(xbgr.mr_n86482976)
print v(xbgr.mr_n86483296)
print v(xbgr.mr_n86483408)
print v(xbgr.mr_n86483728)
print v(xbgr.mr_n86483840)
print v(xbgr.mr_n86484160)
print v(xbgr.mr_n86484272)
print v(xbgr.mr_n86484592)
print v(xbgr.mr_n86484704)
print v(xbgr.mr_n86485024)
print v(xbgr.mr_n86485136)
print v(xbgr.mr_n86485456)
print v(xbgr.mr_n86485568)
print v(xbgr.mr_n86485888)
print v(xbgr.mr_n86486320)
print v(xbgr.mr_n86486432)
print v(xbgr.mr_n86486752)
print v(xbgr.mr_n86486864)
print v(xbgr.mr_n86487184)
print v(xbgr.mr_n86487296)
print v(xbgr.mr_n86487616)
print v(xbgr.mr_n86487728)
print v(xbgr.mr_n86488048)
print v(xbgr.mr_n86488160)
print v(xbgr.mr_n86488480)
print v(xbgr.mr_n86488592)
print v(xbgr.mr_n86488912)
print v(xbgr.mr_n86489024)
print v(xbgr.mr_n86489344)
print v(xbgr.mr_n86489456)
print v(xbgr.mr_n86489776)
print v(xbgr.mr_n86489888)
print v(xbgr.mr_n86490208)
print v(xbgr.mr_n86490320)
print v(xbgr.mr_n86490640)
print v(xbgr.mr_n86490752)
print v(xbgr.mr_n86491072)
print v(xbgr.mr_n86491184)
print v(xbgr.mr_n86491504)
print v(xbgr.mr_n86491616)
print v(xbgr.mr_n86491936)
print v(xbgr.mr_n86492048)
print v(xbgr.mr_n86492368)
print v(xbgr.mr_n86492480)
print v(xbgr.mr_n86492800)
print v(xbgr.mr_n86492912)
print v(xbgr.mr_n86493232)
print v(xbgr.mr_n86493344)
print v(xbgr.mr_n86493664)
print v(xbgr.mr_n86493776)
print v(xbgr.mr_n86494096)
print v(xbgr.mr_n86494208)
print v(xbgr.mr_n86494528)
print v(xbgr.mr_n86494640)
print v(xbgr.mr_n86494960)
print v(xbgr.mr_n86495072)
print v(xbgr.mr_n86495392)
print v(xbgr.mr_n86495504)
print v(xbgr.mr_n86495824)
print v(xbgr.mr_n86495936)
print v(xbgr.mr_n86496256)
print v(xbgr.mr_n86496368)
print v(xbgr.mr_n86496688)
print v(xbgr.mr_n86496800)
print v(xbgr.mr_n86497120)
print v(xbgr.mr_n86497232)
print v(xbgr.mr_n86497552)
print v(xbgr.mr_n86497664)
print v(xbgr.mr_n86497984)
print v(xbgr.mr_n86498096)
print v(xbgr.mr_n86498416)
print v(xbgr.mr_n86498528)
print v(xbgr.mr_n86498848)
print v(xbgr.mr_n86498960)
print v(xbgr.mr_n86499280)
print v(xbgr.mr_n86499392)
print v(xbgr.mr_n86499712)
print v(xbgr.mr_n86499824)
print v(xbgr.mr_n86500144)
print v(xbgr.mr_n86500256)
print v(xbgr.mr_n86500576)
print v(xbgr.mr_n86500688)
print v(xbgr.mr_n86501008)
print v(xbgr.mr_n86501120)
print v(xbgr.mr_n86501440)
print v(xbgr.mr_n86501552)
print v(xbgr.mr_n86501872)
print v(xbgr.mr_n86501984)
print v(xbgr.mr_n86502304)
print v(xbgr.mr_n86502416)
print v(xbgr.mr_n86502736)
print v(xbgr.mr_n86502848)
print v(xbgr.mr_n86503168)
print v(xbgr.mr_n86503280)
print v(xbgr.mr_n86503600)
print v(xbgr.mr_n86503712)
print v(xbgr.mr_n86504032)
print v(xbgr.mr_n86504144)
print v(xbgr.mr_n86504464)
print v(xbgr.mr_n86504576)
print v(xbgr.mr_n86504896)
print v(xbgr.mr_n86505008)
print v(xbgr.mr_n86505328)
print v(xbgr.mr_n86505440)
print v(xbgr.mr_n86505760)
print v(xbgr.mr_n86505872)
print v(xbgr.mr_n86506192)
print v(xbgr.mr_n86506304)
print v(xbgr.mr_n86506624)
print v(xbgr.mr_n86506736)
print v(xbgr.mr_n86507056)
print v(xbgr.mr_n86507168)
print v(xbgr.mr_n86507488)
print v(xbgr.mr_n86507600)
print v(xbgr.mr_n86507920)
print v(xbgr.mr_n86508032)
print v(xbgr.mr_n86508352)
print v(xbgr.mr_n86508464)
print v(xbgr.mr_n86508784)
print v(xbgr.mr_n86508896)
print v(xbgr.mr_n86509216)
print v(xbgr.mr_n86509328)
print v(xbgr.mr_n86509648)
print v(xbgr.mr_n86509760)
print v(xbgr.mr_n86510080)
print v(xbgr.mr_n86510192)
print v(xbgr.mr_n86510512)
print v(xbgr.mr_n86510624)
print v(xbgr.mr_n86510944)
print v(xbgr.mr_n86511056)
print v(xbgr.mr_n86511376)
print v(xbgr.mr_n86511488)
print v(xbgr.mr_n86511808)
print v(xbgr.mr_n86511920)
print v(xbgr.mr_n86512240)
print v(xbgr.mr_n86512352)
print v(xbgr.mr_n86512672)
print v(xbgr.mr_n86512784)
print v(xbgr.mr_n86513104)
print v(xbgr.mr_n86513216)
print v(xbgr.mr_n86513536)
print v(xbgr.mr_n86513648)
print v(xbgr.mr_n86513968)
print v(xbgr.mr_n86514080)
print v(xbgr.mr_n86514400)
print v(xbgr.mr_n86514512)
print v(xbgr.mr_n86514832)
print v(xbgr.mr_n86514944)
print v(xbgr.mr_n86515264)
print v(xbgr.mr_n86515376)
print v(xbgr.mr_n86515696)
print v(xbgr.mr_n86515808)
print v(xbgr.mr_n86516128)
print v(xbgr.mr_n86516240)
print v(xbgr.mr_n86516560)
print v(xbgr.mr_n86516672)
print v(xbgr.mr_n86516992)
print v(xbgr.mr_n86517104)
print v(xbgr.mr_n86517424)
print v(xbgr.mr_n86517536)
print v(xbgr.mr_n86517856)
print v(xbgr.mr_n86518288)
print v(xbgr.mr_n86518400)
print v(xbgr.mr_n86518720)
print v(xbgr.mr_n86518832)
print v(xbgr.mr_n86519152)
print v(xbgr.mr_n86519264)
print v(xbgr.mr_n86519584)
print v(xbgr.mr_n86519696)
print v(xbgr.mr_n86520016)
print v(xbgr.mr_n86520128)
print v(xbgr.mr_n86520448)
print v(xbgr.mr_n86520560)
print v(xbgr.mr_n86520880)
print v(xbgr.mr_n86520992)
print v(xbgr.mr_n86521312)
print v(xbgr.mr_n86521424)
print v(xbgr.mr_n86521744)
print v(xbgr.mr_n86521856)
print v(xbgr.mr_n86522176)
print v(xbgr.mr_n86522288)
print v(xbgr.mr_n86522608)
print v(xbgr.mr_n86522720)
print v(xbgr.mr_n86523040)
print v(xbgr.mr_n86523152)
print v(xbgr.mr_n86523472)
print v(xbgr.mr_n86523584)
print v(xbgr.mr_n86523904)
print v(xbgr.mr_n86524016)
print v(xbgr.mr_n86524336)
print v(xbgr.mr_n86524448)
print v(xbgr.mr_n86524768)
print v(xbgr.mr_n86524880)
print v(xbgr.mr_n86525200)
print v(xbgr.mr_n86525312)
print v(xbgr.mr_n86525632)
print v(xbgr.mr_n86525744)
print v(xbgr.mr_n86526064)
print v(xbgr.mr_n86526608)
print v(xbgr.mr_n86526928)
print v(xbgr.mr_n86527040)
print v(xbgr.mr_n86527360)
print v(xbgr.mr_n86527472)
print v(xbgr.mr_n86527904)
print v(xbgr.mr_n86528336)
print v(xbgr.mr_n86528768)
print v(xbgr.mr_n86529200)
print v(xbgr.mr_n86529632)
print v(xbgr.mr_n86530064)
print v(xbgr.mr_n86530496)
print v(xbgr.mr_n86530928)
print v(xbgr.mr_n86531360)
print v(xbgr.mr_n86531792)
print v(xbgr.mr_n86532224)
print v(xbgr.mr_n86532656)
print v(xbgr.mr_n86533088)
print v(xbgr.mr_n86533520)
print v(xbgr.mr_n86533952)
print v(xbgr.mr_n86534384)
print v(xbgr.mr_n86534816)
print v(xbgr.mr_n86535248)
print v(xbgr.mr_n86535680)
print v(xbgr.mr_n86536112)
print v(xbgr.mr_n86536544)
print v(xbgr.mr_n86536976)
print v(xbgr.mr_n86537408)
print v(xbgr.mr_n86537840)
print v(xbgr.mr_n86538272)
print v(xbgr.mr_n86538704)
print v(xbgr.mr_n86539136)
print v(xbgr.mr_n86539568)
print v(xbgr.mr_n86540000)
print v(xbgr.mr_n86540432)
print v(xbgr.mr_n86540864)
print v(xbgr.mr_n86541296)
print v(xbgr.mr_n86541728)
print v(xbgr.mr_n86542160)
print v(xbgr.mr_n86542592)
print v(xbgr.mr_n86543024)
print v(xbgr.mr_n86543456)
print v(xbgr.mr_n86543888)
print v(xbgr.mr_n86544320)
print v(xbgr.mr_n86544752)
print v(xbgr.mr_n86545184)
print v(xbgr.mr_n86545616)
print v(xbgr.mr_n86546048)
print v(xbgr.mr_n86546480)
print v(xbgr.mr_n86546912)
print v(xbgr.mr_n86547344)
print v(xbgr.mr_n86547776)
print v(xbgr.mr_n86548208)
print v(xbgr.mr_n86548640)
print v(xbgr.mr_n86549072)
print v(xbgr.mr_n86549504)
print v(xbgr.mr_n86549936)
print v(xbgr.mr_n86550368)
print v(xbgr.mr_n86550800)
print v(xbgr.mr_n86551232)
print v(xbgr.mr_n86551664)
print v(xbgr.mr_n86552096)
print v(xbgr.mr_n86552528)
print v(xbgr.mr_n86552960)
print v(xbgr.mr_n86553392)
print v(xbgr.mr_n86553824)
print v(xbgr.mr_n86554256)
print v(xbgr.mr_n86554688)
print v(xbgr.mr_n86555120)
print v(xbgr.mr_n86555552)
print v(xbgr.mr_n86555984)
print v(xbgr.mr_n86556416)
print v(xbgr.mr_n86556848)
print v(xbgr.mr_n86557280)
print v(xbgr.mr_n86557712)
print v(xbgr.mr_n86558144)
print v(xbgr.mr_n86558576)
print v(xbgr.mr_n86559008)
print v(xbgr.mr_n86559440)
print v(xbgr.mr_n86559872)
print v(xbgr.mr_n86560304)
print v(xbgr.mr_n86560736)
print v(xbgr.mr_n86561168)
print v(xbgr.mr_n86561600)
print v(xbgr.mr_n86562032)
print v(xbgr.mr_n86562464)
print v(xbgr.mr_n86562896)
print v(xbgr.mr_n86563328)
print v(xbgr.mr_n86563760)
print v(xbgr.mr_n86564192)
print v(xbgr.mr_n86564624)
print v(xbgr.mr_n86565056)
print v(xbgr.mr_n86565488)
print v(xbgr.mr_n86565920)
print v(xbgr.mr_n86566352)
print v(xbgr.mr_n86566784)
print v(xbgr.mr_n86567216)
print v(xbgr.mr_n86567648)
print v(xbgr.mr_n86568080)
print v(xbgr.mr_n86568512)
print v(xbgr.mr_n86568944)
print v(xbgr.mr_n86569376)
print v(xbgr.mr_n86569808)
print v(xbgr.mr_n86570240)
print v(xbgr.mr_n86570672)
print v(xbgr.mr_n86571104)
print v(xbgr.mr_n86571536)
print v(xbgr.mr_n86571968)
print v(xbgr.mr_n86572400)
print v(xbgr.mr_n86572832)
print v(xbgr.mr_n86573152)
print v(xbgr.mr_n86573264)
print v(xbgr.mr_n86573584)
print v(xbgr.mr_n86573696)
print v(xbgr.mr_n86574016)
print v(xbgr.mr_n86574128)
print v(xbgr.mr_n86574448)
print v(xbgr.mr_n86574560)
print v(xbgr.mr_n86574880)
print v(xbgr.mr_n86574992)
print v(xbgr.mr_n86575312)
print v(xbgr.mr_n86575424)
print v(xbgr.mr_n86575744)
print v(xbgr.mr_n86575856)
print v(xbgr.mr_n86576176)
print v(xbgr.mr_n86576288)
print v(xbgr.mr_n86576608)
print v(xbgr.mr_n86576720)
print v(xbgr.mr_n86577040)
print v(xbgr.mr_n86577152)
print v(xbgr.mr_n86577472)
print v(xbgr.mr_n86577584)
print v(xbgr.mr_n86577904)
print v(xbgr.mr_n86578016)
print v(xbgr.mr_n86578336)
print v(xbgr.mr_n86578448)
print v(xbgr.mr_n86578768)
print v(xbgr.mr_n86578880)
print v(xbgr.mr_n86579200)
print v(xbgr.mr_n86579312)
print v(xbgr.mr_n86579632)
print v(xbgr.mr_n86579744)
print v(xbgr.mr_n86580064)
print v(xbgr.mr_n86580176)
print v(xbgr.mr_n86580496)
print v(xbgr.mr_n86580608)
print v(xbgr.mr_n86580928)
print v(xbgr.mr_n86581040)
print v(xbgr.mr_n86581360)
print v(xbgr.mr_n86581472)
print v(xbgr.mr_n86581792)
print v(xbgr.mr_n86581904)
print v(xbgr.mr_n86582224)
print v(xbgr.mr_n86582336)
print v(xbgr.mr_n86582656)
print v(xbgr.mr_n86582768)
print v(xbgr.mr_n86583088)
print v(xbgr.mr_n86583200)
print v(xbgr.mr_n86583520)
print v(xbgr.mr_n86583632)
print v(xbgr.mr_n86583952)
print v(xbgr.mr_n86584064)
print v(xbgr.mr_n86584384)
print v(xbgr.mr_n86584496)
print v(xbgr.mr_n86584816)
print v(xbgr.mr_n86584928)
print v(xbgr.mr_n86585248)
print v(xbgr.mr_n86585360)
print v(xbgr.mr_n86585680)
print v(xbgr.mr_n86585792)
print v(xbgr.mr_n86586112)
print v(xbgr.mr_n86586224)
print v(xbgr.mr_n86586544)
print v(xbgr.mr_n86586656)
print v(xbgr.mr_n86586976)
print v(xbgr.mr_n86587088)
print v(xbgr.mr_n86587408)
print v(xbgr.mr_n86587520)
print v(xbgr.mr_n86587840)
print v(xbgr.mr_n86587952)
print v(xbgr.mr_n86588272)
print v(xbgr.mr_n86588384)
print v(xbgr.mr_n86588704)
print v(xbgr.mr_n86588816)
print v(xbgr.mr_n86589136)
print v(xbgr.mr_n86589248)
print v(xbgr.mr_n86589568)
print v(xbgr.mr_n86589680)
print v(xbgr.mr_n86590000)
print v(xbgr.mr_n86590112)
print v(xbgr.mr_n86590432)
print v(xbgr.mr_n86590544)
print v(xbgr.mr_n86590864)
print v(xbgr.mr_n86590976)
print v(xbgr.mr_n86591296)
print v(xbgr.mr_n86591728)
print v(xbgr.mr_n86591840)
print v(xbgr.mr_n86592160)
print v(xbgr.mr_n86592272)
print v(xbgr.mr_n86592592)
print v(xbgr.mr_n86592704)
print v(xbgr.mr_n86593024)
print v(xbgr.mr_n86593136)
print v(xbgr.mr_n86593456)
print v(xbgr.mr_n86593568)
print v(xbgr.mr_n86593888)
print v(xbgr.mr_n86594000)
print v(xbgr.mr_n86594320)
print v(xbgr.mr_n86594432)
print v(xbgr.mr_n86594752)
print v(xbgr.mr_n86594864)
print v(xbgr.mr_n86595184)
print v(xbgr.mr_n86595296)
print v(xbgr.mr_n86595616)
print v(xbgr.mr_n86595728)
print v(xbgr.mr_n86596048)
print v(xbgr.mr_n86596160)
print v(xbgr.mr_n86596480)
print v(xbgr.mr_n86596592)
print v(xbgr.mr_n86596912)
print v(xbgr.mr_n86597024)
print v(xbgr.mr_n86597344)
print v(xbgr.mr_n86597456)
print v(xbgr.mr_n86597776)
print v(xbgr.mr_n86597888)
print v(xbgr.mr_n86598208)
print v(xbgr.mr_n86598320)
print v(xbgr.mr_n86598640)
print v(xbgr.mr_n86598752)
print v(xbgr.mr_n86599072)
print v(xbgr.mr_n86599184)
print v(xbgr.mr_n86599504)
print v(xbgr.mr_n86599616)
print v(xbgr.mr_n86599936)
print v(xbgr.mr_n86600048)
print v(xbgr.mr_n86600368)
print v(xbgr.mr_n86600480)
print v(xbgr.mr_n86600800)
print v(xbgr.mr_n86600912)
print v(xbgr.mr_n86601232)
print v(xbgr.mr_n86601344)
print v(xbgr.mr_n86601664)
print v(xbgr.mr_n86601776)
print v(xbgr.mr_n86602096)
print v(xbgr.mr_n86602208)
print v(xbgr.mr_n86602528)
print v(xbgr.mr_n86602640)
print v(xbgr.mr_n86602960)
print v(xbgr.mr_n86603072)
print v(xbgr.mr_n86603392)
print v(xbgr.mr_n86603504)
print v(xbgr.mr_n86603824)
print v(xbgr.mr_n86603936)
print v(xbgr.mr_n86604256)
print v(xbgr.mr_n86604368)
print v(xbgr.mr_n86604688)
print v(xbgr.mr_n86604800)
print v(xbgr.mr_n86605120)
print v(xbgr.mr_n86605232)
print v(xbgr.mr_n86605552)
print v(xbgr.mr_n86605664)
print v(xbgr.mr_n86605984)
print v(xbgr.mr_n86606096)
print v(xbgr.mr_n86606416)
print v(xbgr.mr_n86606528)
print v(xbgr.mr_n86606848)
print v(xbgr.mr_n86606960)
print v(xbgr.mr_n86607280)
print v(xbgr.mr_n86607392)
print v(xbgr.mr_n86607712)
print v(xbgr.mr_n86607824)
print v(xbgr.mr_n86608144)
print v(xbgr.mr_n86608256)
print v(xbgr.mr_n86608576)
print v(xbgr.mr_n86608688)
print v(xbgr.mr_n86609008)
print v(xbgr.mr_n86609120)
print v(xbgr.mr_n86609440)
print v(xbgr.mr_n86609552)
print v(xbgr.mr_n86609872)
print v(xbgr.mr_n86609984)
print v(xbgr.mr_n86610304)
print v(xbgr.mr_n86610416)
print v(xbgr.mr_n86610736)
print v(xbgr.mr_n86610848)
print v(xbgr.mr_n86611168)
print v(xbgr.mr_n86611280)
print v(xbgr.mr_n86611600)
print v(xbgr.mr_n86611712)
print v(xbgr.mr_n86612032)
print v(xbgr.mr_n86612144)
print v(xbgr.mr_n86612464)
print v(xbgr.mr_n86612576)
print v(xbgr.mr_n86612896)
print v(xbgr.mr_n86613008)
print v(xbgr.mr_n86613328)
print v(xbgr.mr_n86613440)
print v(xbgr.mr_n86613760)
print v(xbgr.mr_n86613872)
print v(xbgr.mr_n86614192)
print v(xbgr.mr_n86614304)
print v(xbgr.mr_n86614624)
print v(xbgr.mr_n86614736)
print v(xbgr.mr_n86615056)
print v(xbgr.mr_n86615168)
print v(xbgr.mr_n86615488)
print v(xbgr.mr_n86615600)
print v(xbgr.mr_n86615920)
print v(xbgr.mr_n86616032)
print v(xbgr.mr_n86616352)
print v(xbgr.mr_n86616464)
print v(xbgr.mr_n86616784)
print v(xbgr.mr_n86616896)
print v(xbgr.mr_n86617216)
print v(xbgr.mr_n86617328)
print v(xbgr.mr_n86617648)
print v(xbgr.mr_n86617760)
print v(xbgr.mr_n86618080)
print v(xbgr.mr_n86618192)
print v(xbgr.mr_n86618512)
print v(xbgr.mr_n86618624)
print v(xbgr.mr_n86618944)
print v(xbgr.mr_n86619056)
print v(xbgr.mr_n86619376)
print v(xbgr.mr_n86619488)
print v(xbgr.mr_n86619808)
print v(xbgr.mr_n86619920)
print v(xbgr.mr_n86620240)
print v(xbgr.mr_n86620352)
print v(xbgr.mr_n86620672)
print v(xbgr.mr_n86620784)
print v(xbgr.mr_n86621104)
print v(xbgr.mr_n86621216)
print v(xbgr.mr_n86621536)
print v(xbgr.mr_n86621648)
print v(xbgr.mr_n86621968)
print v(xbgr.mr_n86622080)
print v(xbgr.mr_n86622400)
print v(xbgr.mr_n86622512)
print v(xbgr.mr_n86622832)
print v(xbgr.mr_n86622944)
print v(xbgr.mr_n86623264)
print v(xbgr.mr_n86623376)
print v(xbgr.mr_n86623696)
print v(xbgr.mr_n86623808)
print v(xbgr.mr_n86624128)
print v(xbgr.mr_n86624240)
print v(xbgr.mr_n86624560)
print v(xbgr.mr_n86624672)
print v(xbgr.mr_n86624992)
print v(xbgr.mr_n86625104)
print v(xbgr.mr_n86625424)
print v(xbgr.mr_n86625536)
print v(xbgr.mr_n86625856)
print v(xbgr.mr_n86625968)
print v(xbgr.mr_n86626288)
print v(xbgr.mr_n86626400)
print v(xbgr.mr_n86626720)
print v(xbgr.mr_n86626832)
print v(xbgr.mr_n86627152)
print v(xbgr.mr_n86627264)
print v(xbgr.mr_n86627584)
print v(xbgr.mr_n86627696)
print v(xbgr.mr_n86628016)
print v(xbgr.mr_n86628128)
print v(xbgr.mr_n86628448)
print v(xbgr.mr_n86628560)
print v(xbgr.mr_n86628880)
print v(xbgr.mr_n86628992)
print v(xbgr.mr_n86629312)
print v(xbgr.mr_n86629424)
print v(xbgr.mr_n86629744)
print v(xbgr.mr_n86629856)
print v(xbgr.mr_n86630176)
print v(xbgr.mr_n86630288)
print v(xbgr.mr_n86630608)
print v(xbgr.mr_n86630720)
print v(xbgr.mr_n86631040)
print v(xbgr.mr_n86631152)
print v(xbgr.mr_n86631472)
print v(xbgr.mr_n86631584)
print v(xbgr.mr_n86631904)
print v(xbgr.mr_n86632016)
print v(xbgr.mr_n86632336)
print v(xbgr.mr_n86632448)
print v(xbgr.mr_n86632768)
print v(xbgr.mr_n86632880)
print v(xbgr.mr_n86633200)
print v(xbgr.mr_n86633312)
print v(xbgr.mr_n86633632)
print v(xbgr.mr_n86633744)
print v(xbgr.mr_n86634064)
print v(xbgr.mr_n86634176)
print v(xbgr.mr_n86634496)
print v(xbgr.mr_n86634608)
print v(xbgr.mr_n86634928)
print v(xbgr.mr_n86635040)
print v(xbgr.mr_n86635360)
print v(xbgr.mr_n86635472)
print v(xbgr.mr_n86635792)
print v(xbgr.mr_n86635904)
print v(xbgr.mr_n86636224)
print v(xbgr.mr_n86636336)
print v(xbgr.mr_n86636656)
print v(xbgr.mr_n86636768)
print v(xbgr.mr_n86637088)
print v(xbgr.mr_n86637200)
print v(xbgr.mr_n86637520)
print v(xbgr.mr_n86637632)
print v(xbgr.mr_n86637952)
print v(xbgr.mr_n86638064)
print v(xbgr.mr_n86638384)
print v(xbgr.mr_n86638496)
print v(xbgr.mr_n86638816)
print v(xbgr.mr_n86638928)
print v(xbgr.mr_n86639248)
print v(xbgr.mr_n86639360)
print v(xbgr.mr_n86639680)
print v(xbgr.mr_n86639792)
print v(xbgr.mr_n86640112)
print v(xbgr.mr_n86640224)
print v(xbgr.mr_n86640544)
print v(xbgr.mr_n86640656)
print v(xbgr.mr_n86640976)
print v(xbgr.mr_n86641088)
print v(xbgr.mr_n86641408)
print v(xbgr.mr_n86641840)
print v(xbgr.mr_n86641952)
print v(xbgr.mr_n86642272)
print v(xbgr.mr_n86642384)
print v(xbgr.mr_n86642704)
print v(xbgr.mr_n86642816)
print v(xbgr.mr_n86643136)
print v(xbgr.mr_n86643248)
print v(xbgr.mr_n86643568)
print v(xbgr.mr_n86643680)
print v(xbgr.mr_n86644000)
print v(xbgr.mr_n86644112)
print v(xbgr.mr_n86644432)
print v(xbgr.mr_n86644544)
print v(xbgr.mr_n86644864)
print v(xbgr.mr_n86644976)
print v(xbgr.mr_n86645296)
print v(xbgr.mr_n86645408)
print v(xbgr.mr_n86645728)
print v(xbgr.mr_n86645840)
print v(xbgr.mr_n86646160)
print v(xbgr.mr_n86646272)
print v(xbgr.mr_n86646592)
print v(xbgr.mr_n86646704)
print v(xbgr.mr_n86647024)
print v(xbgr.mr_n86647136)
print v(xbgr.mr_n86647456)
print v(xbgr.mr_n86647568)
print v(xbgr.mr_n86647888)
print v(xbgr.mr_n86648000)
print v(xbgr.mr_n86648320)
print v(xbgr.mr_n86648432)
print v(xbgr.mr_n86648752)
print v(xbgr.mr_n86648864)
print v(xbgr.mr_n86649184)
print v(xbgr.mr_n86649296)
print v(xbgr.mr_n86649616)
print v(xbgr.mr_n86649728)
print v(xbgr.mr_n86650048)
print v(xbgr.mr_n86650160)
print v(xbgr.mr_n86650480)
print v(xbgr.mr_n86650592)
print v(xbgr.mr_n86650912)
print v(xbgr.mr_n86651024)
print v(xbgr.mr_n86651344)
print v(xbgr.mr_n86651456)
print v(xbgr.mr_n86651776)
print v(xbgr.mr_n86651888)
print v(xbgr.mr_n86652208)
print v(xbgr.mr_n86652320)
print v(xbgr.mr_n86652640)
print v(xbgr.mr_n86652752)
print v(xbgr.mr_n86653072)
print v(xbgr.mr_n86653184)
print v(xbgr.mr_n86653504)
print v(xbgr.mr_n86653616)
print v(xbgr.mr_n86653936)
print v(xbgr.mr_n86654048)
print v(xbgr.mr_n86654368)
print v(xbgr.mr_n86654480)
print v(xbgr.mr_n86654800)
print v(xbgr.mr_n86654912)
print v(xbgr.mr_n86655232)
print v(xbgr.mr_n86655344)
print v(xbgr.mr_n86655664)
print v(xbgr.mr_n86655776)
print v(xbgr.mr_n86656096)
print v(xbgr.mr_n86656208)
print v(xbgr.mr_n86656528)
print v(xbgr.mr_n86656640)
print v(xbgr.mr_n86656960)
print v(xbgr.mr_n86657072)
print v(xbgr.mr_n86657392)
print v(xbgr.mr_n86657504)
print v(xbgr.mr_n86657824)
print v(xbgr.mr_n86657936)
print v(xbgr.mr_n86658256)
print v(xbgr.mr_n86658368)
print v(xbgr.mr_n86658688)
print v(xbgr.mr_n86658800)
print v(xbgr.mr_n86659120)
print v(xbgr.mr_n86659232)
print v(xbgr.mr_n86659552)
print v(xbgr.mr_n86659664)
print v(xbgr.mr_n86659984)
print v(xbgr.mr_n86660096)
print v(xbgr.mr_n86660416)
print v(xbgr.mr_n86660528)
print v(xbgr.mr_n86660848)
print v(xbgr.mr_n86660960)
print v(xbgr.mr_n86661280)
print v(xbgr.mr_n86661392)
print v(xbgr.mr_n86661712)
print v(xbgr.mr_n86661824)
print v(xbgr.mr_n86662144)
print v(xbgr.mr_n86662576)
print v(xbgr.mr_n86662688)
print v(xbgr.mr_n86663008)
print v(xbgr.mr_n86663120)
print v(xbgr.mr_n86663440)
print v(xbgr.mr_n86663552)
print v(xbgr.mr_n86663872)
print v(xbgr.mr_n86663984)
print v(xbgr.mr_n86664304)
print v(xbgr.mr_n86664416)
print v(xbgr.mr_n86664736)
print v(xbgr.mr_n86664848)
print v(xbgr.mr_n86665280)
print v(xbgr.mr_n86665712)
print v(xbgr.mr_n86666032)
print v(xbgr.mr_n86666144)
print v(xbgr.mr_n86666464)
print v(xbgr.mr_n86666576)
print v(xbgr.mr_n86666896)
print v(xbgr.mr_n86667008)
print v(xbgr.mr_n86667328)
print v(xbgr.mr_n86667440)
print v(xbgr.mr_n86667760)
print v(xbgr.mr_n86667872)
print v(xbgr.mr_n86668192)
print v(xbgr.mr_n86668304)
print v(xbgr.mr_n86668624)
print v(xbgr.mr_n86668736)
print v(xbgr.mr_n86669056)
print v(xbgr.mr_n86669168)
print v(xbgr.mr_n86669488)
print v(xbgr.mr_n86669600)
print v(xbgr.mr_n86669920)
print v(xbgr.mr_n86670032)
print v(xbgr.mr_n86670352)
print v(xbgr.mr_n86670464)
print v(xbgr.mr_n86670784)
print v(xbgr.mr_n86670896)
print v(xbgr.mr_n86671216)
print v(xbgr.mr_n86671328)
print v(xbgr.mr_n86671648)
print v(xbgr.mr_n86671760)
print v(xbgr.mr_n86672080)
print v(xbgr.mr_n86672192)
print v(xbgr.mr_n86672512)
print v(xbgr.mr_n86672624)
print v(xbgr.mr_n86672944)
print v(xbgr.mr_n86673056)
print v(xbgr.mr_n86673376)
print v(xbgr.mr_n86673488)
print v(xbgr.mr_n86673808)
print v(xbgr.mr_n86673920)
print v(xbgr.mr_n86674240)
print v(xbgr.mr_n86674352)
print v(xbgr.mr_n86674672)
print v(xbgr.mr_n86674784)
print v(xbgr.mr_n86675104)
print v(xbgr.mr_n86675216)
print v(xbgr.mr_n86675536)
print v(xbgr.mr_n86675648)
print v(xbgr.mr_n86675968)
print v(xbgr.mr_n86676080)
print v(xbgr.mr_n86676400)
print v(xbgr.mr_n86676512)
print v(xbgr.mr_n86676832)
print v(xbgr.mr_n86676944)
print v(xbgr.mr_n86677264)
print v(xbgr.mr_n86677376)
print v(xbgr.mr_n86677696)
print v(xbgr.mr_n86677808)
print v(xbgr.mr_n86678128)
print v(xbgr.mr_n86678240)
print v(xbgr.mr_n86678560)
print v(xbgr.mr_n86678672)
print v(xbgr.mr_n86678992)
print v(xbgr.mr_n86679104)
print v(xbgr.mr_n86679424)
print v(xbgr.mr_n86679536)
print v(xbgr.mr_n86679856)
print v(xbgr.mr_n86679968)
print v(xbgr.mr_n86680288)
print v(xbgr.mr_n86680400)
print v(xbgr.mr_n86680720)
print v(xbgr.mr_n86680832)
print v(xbgr.mr_n86681152)
print v(xbgr.mr_n86681264)
print v(xbgr.mr_n86681584)
print v(xbgr.mr_n86681696)
print v(xbgr.mr_n86682016)
print v(xbgr.mr_n86682128)
print v(xbgr.mr_n86682448)
print v(xbgr.mr_n86682560)
print v(xbgr.mr_n86682880)
print v(xbgr.mr_n86682992)
print v(xbgr.mr_n86683312)
print v(xbgr.mr_n86683424)
print v(xbgr.mr_n86683744)
print v(xbgr.mr_n86683856)
print v(xbgr.mr_n86684176)
print v(xbgr.mr_n86684288)
print v(xbgr.mr_n86684608)
print v(xbgr.mr_n86684720)
print v(xbgr.mr_n86685040)
print v(xbgr.mr_n86685152)
print v(xbgr.mr_n86685472)
print v(xbgr.mr_n86685584)
print v(xbgr.mr_n86685904)
print v(xbgr.mr_n86686016)
print v(xbgr.mr_n86686336)
print v(xbgr.mr_n86686448)
print v(xbgr.mr_n86686768)
print v(xbgr.mr_n86686880)
print v(xbgr.mr_n86687200)
print v(xbgr.mr_n86687312)
print v(xbgr.mr_n86687632)
print v(xbgr.mr_n86687744)
print v(xbgr.mr_n86688064)
print v(xbgr.mr_n86688176)
print v(xbgr.mr_n86688496)
print v(xbgr.mr_n86688608)
print v(xbgr.mr_n86688928)
print v(xbgr.mr_n86689040)
print v(xbgr.mr_n86689360)
print v(xbgr.mr_n86689472)
print v(xbgr.mr_n86689792)
print v(xbgr.mr_n86689904)
print v(xbgr.mr_n86690224)
print v(xbgr.mr_n86690336)
print v(xbgr.mr_n86690656)
print v(xbgr.mr_n86690768)
print v(xbgr.mr_n86691088)
print v(xbgr.mr_n86691200)
print v(xbgr.mr_n86691520)
print v(xbgr.mr_n86691632)
print v(xbgr.mr_n86691952)
print v(xbgr.mr_n86692064)
print v(xbgr.mr_n86692384)
print v(xbgr.mr_n86692496)
print v(xbgr.mr_n86692816)
print v(xbgr.mr_n86692928)
print v(xbgr.mr_n86693248)
print v(xbgr.mr_n86693360)
print v(xbgr.mr_n86693680)
print v(xbgr.mr_n86693792)
print v(xbgr.mr_n86694112)
print v(xbgr.mr_n86694224)
print v(xbgr.mr_n86694544)
print v(xbgr.mr_n86694656)
print v(xbgr.mr_n86694976)
print v(xbgr.mr_n86695088)
print v(xbgr.mr_n86695408)
print v(xbgr.mr_n86695520)
print v(xbgr.mr_n86695840)
print v(xbgr.mr_n86695952)
print v(xbgr.mr_n86696272)
print v(xbgr.mr_n86696384)
print v(xbgr.mr_n86696704)
print v(xbgr.mr_n86696816)
print v(xbgr.mr_n86697136)
print v(xbgr.mr_n86697248)
print v(xbgr.mr_n86697568)
print v(xbgr.mr_n86697680)
print v(xbgr.mr_n86698000)
print v(xbgr.mr_n86698112)
print v(xbgr.mr_n86698432)
print v(xbgr.mr_n86698544)
print v(xbgr.mr_n86698864)
print v(xbgr.mr_n86698976)
print v(xbgr.mr_n86699296)
print v(xbgr.mr_n86699408)
print v(xbgr.mr_n86699728)
print v(xbgr.mr_n86699840)
print v(xbgr.mr_n86700160)
print v(xbgr.mr_n86700272)
print v(xbgr.mr_n86700592)
print v(xbgr.mr_n86700704)
print v(xbgr.mr_n86701024)
print v(xbgr.mr_n86701136)
print v(xbgr.mr_n86701456)
print v(xbgr.mr_n86701568)
print v(xbgr.mr_n86701888)
print v(xbgr.mr_n86702000)
print v(xbgr.mr_n86702320)
print v(xbgr.mr_n86702432)
print v(xbgr.mr_n86702752)
print v(xbgr.mr_n86702864)
print v(xbgr.mr_n86703184)
print v(xbgr.mr_n86703296)
print v(xbgr.mr_n86703616)
print v(xbgr.mr_n86703728)
print v(xbgr.mr_n86704048)
print v(xbgr.mr_n86704160)
print v(xbgr.mr_n86704480)
print v(xbgr.mr_n86704592)
print v(xbgr.mr_n86704912)
print v(xbgr.mr_n86705024)
print v(xbgr.mr_n86705344)
print v(xbgr.mr_n86705456)
print v(xbgr.mr_n86705776)
print v(xbgr.mr_n86705888)
print v(xbgr.mr_n86706208)
print v(xbgr.mr_n86706320)
print v(xbgr.mr_n86706640)
print v(xbgr.mr_n86706752)
print v(xbgr.mr_n86707072)
print v(xbgr.mr_n86707184)
print v(xbgr.mr_n86707504)
print v(xbgr.mr_n86707616)
print v(xbgr.mr_n86707936)
print v(xbgr.mr_n86708048)
print v(xbgr.mr_n86708368)
print v(xbgr.mr_n86708480)
print v(xbgr.mr_n86708800)
print v(xbgr.mr_n86708912)
print v(xbgr.mr_n86709232)
print v(xbgr.mr_n86709344)
print v(xbgr.mr_n86709664)
print v(xbgr.mr_n86709776)
print v(xbgr.mr_n86710096)
print v(xbgr.mr_n86710208)
print v(xbgr.mr_n86710528)
print v(xbgr.mr_n86710640)
print v(xbgr.mr_n86710960)
print v(xbgr.mr_n86711072)
print v(xbgr.mr_n86711392)
print v(xbgr.mr_n86711504)
print v(xbgr.mr_n86711824)
print v(xbgr.mr_n86711936)
print v(xbgr.mr_n86712256)
print v(xbgr.mr_n86712368)
print v(xbgr.mr_n86712688)
print v(xbgr.mr_n86712800)
print v(xbgr.mr_n86713120)
print v(xbgr.mr_n86713232)
print v(xbgr.mr_n86713552)
print v(xbgr.mr_n86713664)
print v(xbgr.mr_n86713984)
print v(xbgr.mr_n86714096)
print v(xbgr.mr_n86714416)
print v(xbgr.mr_n86714528)
print v(xbgr.mr_n86714848)
print v(xbgr.mr_n86714960)
print v(xbgr.mr_n86715280)
print v(xbgr.mr_n86715392)
print v(xbgr.mr_n86715712)
print v(xbgr.mr_n86715824)
print v(xbgr.mr_n86716144)
print v(xbgr.mr_n86716256)
print v(xbgr.mr_n86716576)
print v(xbgr.mr_n86716688)
print v(xbgr.mr_n86717008)
print v(xbgr.mr_n86717120)
print v(xbgr.mr_n86717440)
print v(xbgr.mr_n86717552)
print v(xbgr.mr_n86717872)
print v(xbgr.mr_n86717984)
print v(xbgr.mr_n86718304)
print v(xbgr.mr_n86718416)
print v(xbgr.mr_n86718736)
print v(xbgr.mr_n86718848)
print v(xbgr.mr_n86719168)
print v(xbgr.mr_n86719280)
print v(xbgr.mr_n86719600)
print v(xbgr.mr_n86719712)
print v(xbgr.mr_n86720032)
print v(xbgr.mr_n86720144)
print v(xbgr.mr_n86720464)
print v(xbgr.mr_n86720576)
print v(xbgr.mr_n86720896)
print v(xbgr.mr_n86721008)
print v(xbgr.mr_n86721328)
print v(xbgr.mr_n86721440)
print v(xbgr.mr_n86721872)
print v(xbgr.mr_n86722304)
print v(xbgr.mr_n86722736)
print v(xbgr.mr_n86723168)
print v(xbgr.mr_n86723600)
print v(xbgr.mr_n86724032)
print v(xbgr.mr_n86724464)
print v(xbgr.mr_n86724896)
print v(xbgr.mr_n86725328)
print v(xbgr.mr_n86725760)
print v(xbgr.mr_n86726192)
print v(xbgr.mr_n86726624)
print v(xbgr.mr_n86727056)
print v(xbgr.mr_n86727488)
print v(xbgr.mr_n86727920)
print v(xbgr.mr_n86728352)
print v(xbgr.mr_n86728784)
print v(xbgr.mr_n86729216)
print v(xbgr.mr_n86729648)
print v(xbgr.mr_n86730080)
print v(xbgr.mr_n86730512)
print v(xbgr.mr_n86730944)
print v(xbgr.mr_n86731376)
print v(xbgr.mr_n86731808)
print v(xbgr.mr_n86732240)
print v(xbgr.mr_n86732672)
print v(xbgr.mr_n86733104)
print v(xbgr.mr_n86733536)
print v(xbgr.mr_n86733968)
print v(xbgr.mr_n86734400)
print v(xbgr.mr_n86734832)
print v(xbgr.mr_n86735264)
print v(xbgr.mr_n86735696)
print v(xbgr.mr_n86736128)
print v(xbgr.mr_n86736560)
print v(xbgr.mr_n86736992)
print v(xbgr.mr_n86737424)
print v(xbgr.mr_n86737856)
print v(xbgr.mr_n86738288)
print v(xbgr.mr_n86738720)
print v(xbgr.mr_n86739152)
print v(xbgr.mr_n86739584)
print v(xbgr.mr_n86740016)
print v(xbgr.mr_n86740448)
print v(xbgr.mr_n86740880)
print v(xbgr.mr_n86741312)
print v(xbgr.mr_n86741744)
print v(xbgr.mr_n86742176)
print v(xbgr.mr_n86742608)
print v(xbgr.mr_n86743040)
print v(xbgr.mr_n86743472)
print v(xbgr.mr_n86743904)
print v(xbgr.mr_n86744336)
print v(xbgr.mr_n86744768)
print v(xbgr.mr_n86745200)
print v(xbgr.mr_n86745632)
print v(xbgr.mr_n86746064)
print v(xbgr.mr_n86746496)
print v(xbgr.mr_n86746928)
print v(xbgr.mr_n86747360)
print v(xbgr.mr_n86747792)
print v(xbgr.mr_n86748224)
print v(xbgr.mr_n86748656)
print v(xbgr.mr_n86749088)
print v(xbgr.mr_n86749520)
print v(xbgr.mr_n86749952)
print v(xbgr.mr_n86750384)
print v(xbgr.mr_n86750816)
print v(xbgr.mr_n86751248)
print v(xbgr.mr_n86751680)
print v(xbgr.mr_n86752112)
print v(xbgr.mr_n86752544)
print v(xbgr.mr_n86752976)
print v(xbgr.mr_n86753408)
print v(xbgr.mr_n86753840)
print v(xbgr.mr_n86754272)
print v(xbgr.mr_n86754704)
print v(xbgr.mr_n86755136)
print v(xbgr.mr_n86755568)
print v(xbgr.mr_n86756000)
print v(xbgr.mr_n86756432)
print v(xbgr.mr_n86756864)
print v(xbgr.mr_n86757296)
print v(xbgr.mr_n86757728)
print v(xbgr.mr_n86758160)
print v(xbgr.mr_n86758592)
print v(xbgr.mr_n86759024)
print v(xbgr.mr_n86759456)
print v(xbgr.mr_n86759888)
print v(xbgr.mr_n86760320)
print v(xbgr.mr_n86760752)
print v(xbgr.mr_n86761184)
print v(xbgr.mr_n86761616)
print v(xbgr.mr_n86762048)
print v(xbgr.mr_n86762480)
print v(xbgr.mr_n86762912)
print v(xbgr.mr_n86763344)
print v(xbgr.mr_n86763776)
print v(xbgr.mr_n86764096)
print v(xbgr.mr_n86764208)
print v(xbgr.mr_n86764528)
print v(xbgr.mr_n86764640)
print v(xbgr.mr_n86764960)
print v(xbgr.mr_n86765072)
print v(xbgr.mr_n86765392)
print v(xbgr.mr_n86765504)
print v(xbgr.mr_n86765824)
print v(xbgr.mr_n86765936)
print v(xbgr.mr_n86766256)
print v(xbgr.mr_n86766368)
print v(xbgr.mr_n86766688)
print v(xbgr.mr_n86766800)
print v(xbgr.mr_n86767120)
print v(xbgr.mr_n86767232)
print v(xbgr.mr_n86767552)
print v(xbgr.mr_n86767664)
print v(xbgr.mr_n86767984)
print v(xbgr.mr_n86768096)
print v(xbgr.mr_n86768416)
print v(xbgr.mr_n86768528)
print v(xbgr.mr_n86768848)
print v(xbgr.mr_n86768960)
print v(xbgr.mr_n86769280)
print v(xbgr.mr_n86769392)
print v(xbgr.mr_n86769712)
print v(xbgr.mr_n86769824)
print v(xbgr.mr_n86770144)
print v(xbgr.mr_n86770256)
print v(xbgr.mr_n86770576)
print v(xbgr.mr_n86770688)
print v(xbgr.mr_n86771008)
print v(xbgr.mr_n86771120)
print v(xbgr.mr_n86771440)
print v(xbgr.mr_n86771552)
print v(xbgr.mr_n86771872)
print v(xbgr.mr_n86771984)
print v(xbgr.mr_n86772304)
print v(xbgr.mr_n86772416)
print v(xbgr.mr_n86772736)
print v(xbgr.mr_n86772848)
print v(xbgr.mr_n86773168)
print v(xbgr.mr_n86773280)
print v(xbgr.mr_n86773600)
print v(xbgr.mr_n86773712)
print v(xbgr.mr_n86774032)
print v(xbgr.mr_n86774144)
print v(xbgr.mr_n86774464)
print v(xbgr.mr_n86774576)
print v(xbgr.mr_n86774896)
print v(xbgr.mr_n86775008)
print v(xbgr.mr_n86775328)
print v(xbgr.mr_n86775440)
print v(xbgr.mr_n86775760)
print v(xbgr.mr_n86775872)
print v(xbgr.mr_n86776192)
print v(xbgr.mr_n86776304)
print v(xbgr.mr_n86776624)
print v(xbgr.mr_n86776736)
print v(xbgr.mr_n86777056)
print v(xbgr.mr_n86777168)
print v(xbgr.mr_n86777488)
print v(xbgr.mr_n86777600)
print v(xbgr.mr_n86777920)
print v(xbgr.mr_n86778032)
print v(xbgr.mr_n86778352)
print v(xbgr.mr_n86778464)
print v(xbgr.mr_n86778784)
print v(xbgr.mr_n86778896)
print v(xbgr.mr_n86779216)
print v(xbgr.mr_n86779328)
print v(xbgr.mr_n86779648)
print v(xbgr.mr_n86779760)
print v(xbgr.mr_n86780080)
print v(xbgr.mr_n86780192)
print v(xbgr.mr_n86780512)
print v(xbgr.mr_n86780624)
print v(xbgr.mr_n86780944)
print v(xbgr.mr_n86781056)
print v(xbgr.mr_n86781376)
print v(xbgr.mr_n86781488)
print v(xbgr.mr_n86781808)
print v(xbgr.mr_n86781920)
print v(xbgr.mr_n86782240)
print v(xbgr.mr_n86782352)
print v(xbgr.mr_n86782672)
print v(xbgr.mr_n86782784)
print v(xbgr.mr_n86783104)
print v(xbgr.mr_n86783216)
print v(xbgr.mr_n86783536)
print v(xbgr.mr_n86783648)
print v(xbgr.mr_n86783968)
print v(xbgr.mr_n86784080)
print v(xbgr.mr_n86784400)
print v(xbgr.mr_n86784512)
print v(xbgr.mr_n86784832)
print v(xbgr.mr_n86784944)
print v(xbgr.mr_n86785264)
print v(xbgr.mr_n86785376)
print v(xbgr.mr_n86785696)
print v(xbgr.mr_n86785808)
print v(xbgr.mr_n86786128)
print v(xbgr.mr_n86786240)
print v(xbgr.mr_n86786560)
print v(xbgr.mr_n86786672)
print v(xbgr.mr_n86786992)
print v(xbgr.mr_n86787104)
print v(xbgr.mr_n86787424)
print v(xbgr.mr_n86787536)
print v(xbgr.mr_n86787856)
print v(xbgr.mr_n86787968)
print v(xbgr.mr_n86788288)
print v(xbgr.mr_n86788400)
print v(xbgr.mr_n86788720)
print v(xbgr.mr_n86788832)
print v(xbgr.mr_n86789152)
print v(xbgr.mr_n86789264)
print v(xbgr.mr_n86789584)
print v(xbgr.mr_n86789696)
print v(xbgr.mr_n86790016)
print v(xbgr.mr_n86790128)
print v(xbgr.mr_n86790448)
print v(xbgr.mr_n86790560)
print v(xbgr.mr_n86790880)
print v(xbgr.mr_n86790992)
print v(xbgr.mr_n86791312)
print v(xbgr.mr_n86791424)
print v(xbgr.mr_n86791744)
print v(xbgr.mr_n86791856)
print v(xbgr.mr_n86792176)
print v(xbgr.mr_n86792288)
print v(xbgr.mr_n86792608)
print v(xbgr.mr_n86792720)
print v(xbgr.mr_n86793040)
print v(xbgr.mr_n86793152)
print v(xbgr.mr_n86793472)
print v(xbgr.mr_n86793584)
print v(xbgr.mr_n86793904)
print v(xbgr.mr_n86794016)
print v(xbgr.mr_n86794336)
print v(xbgr.mr_n86794448)
print v(xbgr.mr_n86794768)
print v(xbgr.mr_n86794880)
print v(xbgr.mr_n86795200)
print v(xbgr.mr_n86795312)
print v(xbgr.mr_n86795632)
print v(xbgr.mr_n86795744)
print v(xbgr.mr_n86796064)
print v(xbgr.mr_n86796176)
print v(xbgr.mr_n86796496)
print v(xbgr.mr_n86796608)
print v(xbgr.mr_n86796928)
print v(xbgr.mr_n86797040)
print v(xbgr.mr_n86797360)
print v(xbgr.mr_n86797472)
print v(xbgr.mr_n86797792)
print v(xbgr.mr_n86797904)
print v(xbgr.mr_n86798224)
print v(xbgr.mr_n86798336)
print v(xbgr.mr_n86798656)
print v(xbgr.mr_n86798768)
print v(xbgr.mr_n86799088)
print v(xbgr.mr_n86799200)
print v(xbgr.mr_n86799520)
print v(xbgr.mr_n86799632)
print v(xbgr.mr_n86799952)
print v(xbgr.mr_n86800064)
print v(xbgr.mr_n86800384)
print v(xbgr.mr_n86800496)
print v(xbgr.mr_n86800816)
print v(xbgr.mr_n86800928)
print v(xbgr.mr_n86801248)
print v(xbgr.mr_n86801360)
print v(xbgr.mr_n86801680)
print v(xbgr.mr_n86801792)
print v(xbgr.mr_n86802112)
print v(xbgr.mr_n86802224)
print v(xbgr.mr_n86802544)
print v(xbgr.mr_n86802656)
print v(xbgr.mr_n86802976)
print v(xbgr.mr_n86803088)
print v(xbgr.mr_n86803408)
print v(xbgr.mr_n86803520)
print v(xbgr.mr_n86803840)
print v(xbgr.mr_n86803952)
print v(xbgr.mr_n86804272)
print v(xbgr.mr_n86804384)
print v(xbgr.mr_n86804704)
print v(xbgr.mr_n86804816)
print v(xbgr.mr_n86805136)
print v(xbgr.mr_n86805248)
print v(xbgr.mr_n86805568)
print v(xbgr.mr_n86805680)
print v(xbgr.mr_n86806000)
print v(xbgr.mr_n86806112)
print v(xbgr.mr_n86806432)
print v(xbgr.mr_n86806544)
print v(xbgr.mr_n86806864)
print v(xbgr.mr_n86806976)
print v(xbgr.mr_n86807296)
print v(xbgr.mr_n86807408)
print v(xbgr.mr_n86807728)
print v(xbgr.mr_n86807840)
print v(xbgr.mr_n86808160)
print v(xbgr.mr_n86808272)
print v(xbgr.mr_n86808592)
print v(xbgr.mr_n86808704)
print v(xbgr.mr_n86809024)
print v(xbgr.mr_n86809136)
print v(xbgr.mr_n86809456)
print v(xbgr.mr_n86809568)
print v(xbgr.mr_n86809888)
print v(xbgr.mr_n86810000)
print v(xbgr.mr_n86810320)
print v(xbgr.mr_n86810432)
print v(xbgr.mr_n86810752)
print v(xbgr.mr_n86810864)
print v(xbgr.mr_n86811184)
print v(xbgr.mr_n86811296)
print v(xbgr.mr_n86811616)
print v(xbgr.mr_n86811728)
print v(xbgr.mr_n86812048)
print v(xbgr.mr_n86812160)
print v(xbgr.mr_n86812480)
print v(xbgr.mr_n86812592)
print v(xbgr.mr_n86812912)
print v(xbgr.mr_n86813024)
print v(xbgr.mr_n86813344)
print v(xbgr.mr_n86813456)
print v(xbgr.mr_n86813776)
print v(xbgr.mr_n86813888)
print v(xbgr.mr_n86814208)
print v(xbgr.mr_n86814320)
print v(xbgr.mr_n86814640)
print v(xbgr.mr_n86814752)
print v(xbgr.mr_n86815072)
print v(xbgr.mr_n86815184)
print v(xbgr.mr_n86815504)
print v(xbgr.mr_n86815616)
print v(xbgr.mr_n86815936)
print v(xbgr.mr_n86816048)
print v(xbgr.mr_n86816368)
print v(xbgr.mr_n86816480)
print v(xbgr.mr_n86816800)
print v(xbgr.mr_n86816912)
print v(xbgr.mr_n86817232)
print v(xbgr.mr_n86817344)
print v(xbgr.mr_n86817664)
print v(xbgr.mr_n86817776)
print v(xbgr.mr_n86818096)
print v(xbgr.mr_n86818208)
print v(xbgr.mr_n86818528)
print v(xbgr.mr_n86818640)
print v(xbgr.mr_n86818960)
print v(xbgr.mr_n86819072)
print v(xbgr.mr_n86819392)
print v(xbgr.mr_n86819504)
print v(xbgr.mr_n86819824)
print v(xbgr.mr_n86819936)
print v(xbgr.mr_n86820256)
print v(xbgr.mr_n86820368)
print v(xbgr.mr_n86820688)
print v(xbgr.mr_n86820800)
print v(xbgr.mr_n86821120)
print v(xbgr.mr_n86821232)
print v(xbgr.mr_n86821552)
print v(xbgr.mr_n86821664)
print v(xbgr.mr_n86821984)
print v(xbgr.mr_n86822096)
print v(xbgr.mr_n86822416)
print v(xbgr.mr_n86822528)
print v(xbgr.mr_n86822848)
print v(xbgr.mr_n86822960)
print v(xbgr.mr_n86823280)
print v(xbgr.mr_n86823392)
print v(xbgr.mr_n86823712)
print v(xbgr.mr_n86823824)
print v(xbgr.mr_n86824144)
print v(xbgr.mr_n86824256)
print v(xbgr.mr_n86824576)
print v(xbgr.mr_n86824688)
print v(xbgr.mr_n86825008)
print v(xbgr.mr_n86825120)
print v(xbgr.mr_n86825440)
print v(xbgr.mr_n86825552)
print v(xbgr.mr_n86825872)
print v(xbgr.mr_n86825984)
print v(xbgr.mr_n86826304)
print v(xbgr.mr_n86826416)
print v(xbgr.mr_n86826736)
print v(xbgr.mr_n86826848)
print v(xbgr.mr_n86827280)
print v(xbgr.mr_n86827712)
print v(xbgr.mr_n86828144)
print v(xbgr.mr_n86828576)
print v(xbgr.mr_n86829008)
print v(xbgr.mr_n86829440)
print v(xbgr.mr_n86829872)
print v(xbgr.mr_n86830304)
print v(xbgr.mr_n86830736)
print v(xbgr.mr_n86831168)
print v(xbgr.mr_n86831600)
print v(xbgr.mr_n86832032)
print v(xbgr.mr_n86832464)
print v(xbgr.mr_n86832896)
print v(xbgr.mr_n86833328)
print v(xbgr.mr_n86833760)
print v(xbgr.mr_n86834192)
print v(xbgr.mr_n86834624)
print v(xbgr.mr_n86835056)
print v(xbgr.mr_n86835488)
print v(xbgr.mr_n86835920)
print v(xbgr.mr_n86836352)
print v(xbgr.mr_n86836784)
print v(xbgr.mr_n86837216)
print v(xbgr.mr_n86837648)
print v(xbgr.mr_n86838080)
print v(xbgr.mr_n86838512)
print v(xbgr.mr_n86838944)
print v(xbgr.mr_n86839376)
print v(xbgr.mr_n86839808)
print v(xbgr.mr_n86840240)
print v(xbgr.mr_n86840672)
print v(xbgr.mr_n86841104)
print v(xbgr.mr_n86841536)
print v(xbgr.mr_n86841968)
print v(xbgr.mr_n86842400)
print v(xbgr.mr_n86842832)
print v(xbgr.mr_n86843264)
print v(xbgr.mr_n86843696)
print v(xbgr.mr_n86844128)
print v(xbgr.mr_n86844560)
print v(xbgr.mr_n86844992)
print v(xbgr.mr_n86845424)
print v(xbgr.mr_n86845856)
print v(xbgr.mr_n86846288)
print v(xbgr.mr_n86846720)
print v(xbgr.mr_n86847152)
print v(xbgr.mr_n86847584)
print v(xbgr.mr_n86848016)
print v(xbgr.mr_n86848448)
print v(xbgr.mr_n86848880)
print v(xbgr.mr_n86849312)
print v(xbgr.mr_n86849744)
print v(xbgr.mr_n86850176)
print v(xbgr.mr_n86850608)
print v(xbgr.mr_n86851040)
print v(xbgr.mr_n86851472)
print v(xbgr.mr_n86851904)
print v(xbgr.mr_n86852336)
print v(xbgr.mr_n86852768)
print v(xbgr.mr_n86853200)
print v(xbgr.mr_n86853632)
print v(xbgr.mr_n86854064)
print v(xbgr.mr_n86854496)
print v(xbgr.mr_n86854928)
print v(xbgr.mr_n86855360)
print v(xbgr.mr_n86855792)
print v(xbgr.mr_n86856224)
print v(xbgr.mr_n86856656)
print v(xbgr.mr_n86857088)
print v(xbgr.mr_n86857520)
print v(xbgr.mr_n86857952)
print v(xbgr.mr_n86858384)
print v(xbgr.mr_n86858816)
print v(xbgr.mr_n86859248)
print v(xbgr.mr_n86859680)
print v(xbgr.mr_n86860112)
print v(xbgr.mr_n86860544)
print v(xbgr.mr_n86860976)
print v(xbgr.mr_n86861408)
print v(xbgr.mr_n86861840)
print v(xbgr.mr_n86862272)
print v(xbgr.mr_n86862704)
print v(xbgr.mr_n86863136)
print v(xbgr.mr_n86863568)
print v(xbgr.mr_n86864000)
print v(xbgr.mr_n86864432)
print v(xbgr.mr_n86864864)
print v(xbgr.mr_n86865296)
print v(xbgr.mr_n86865728)
print v(xbgr.mr_n86866160)
print v(xbgr.mr_n86866592)
print v(xbgr.mr_n86867024)
print v(xbgr.mr_n86867456)
print v(xbgr.mr_n86867888)
print v(xbgr.mr_n86868320)
print v(xbgr.mr_n86868752)
print v(xbgr.mr_n86869184)
print v(xbgr.mr_n86869616)
print v(xbgr.mr_n86870048)
print v(xbgr.mr_n86870480)
print v(xbgr.mr_n86870912)
print v(xbgr.mr_n86871344)
print v(xbgr.mr_n86871776)
print v(xbgr.mr_n86872208)
print v(xbgr.mr_n86872640)
print v(xbgr.mr_n86873072)
print v(xbgr.mr_n86873504)
print v(xbgr.mr_n86873936)
print v(xbgr.mr_n86874368)
print v(xbgr.mr_n86874800)
print v(xbgr.mr_n86875232)
print v(xbgr.mr_n86875664)
print v(xbgr.mr_n86876096)
print v(xbgr.mr_n86876528)
print v(xbgr.mr_n86876960)
print v(xbgr.mr_n86877392)
print v(xbgr.mr_n86877824)
print v(xbgr.mr_n86878256)
print v(xbgr.mr_n86878688)
print v(xbgr.mr_n86879120)
print v(xbgr.mr_n86879552)
print v(xbgr.mr_n86879984)
print v(xbgr.mr_n86880416)
print v(xbgr.mr_n86880848)
print v(xbgr.mr_n86881280)
print v(xbgr.mr_n86881712)
print v(xbgr.mr_n86882144)
print v(xbgr.mr_n86882576)
print v(xbgr.mr_n86883008)
print v(xbgr.mr_n86883440)
print v(xbgr.mr_n86883872)
print v(xbgr.mr_n86884304)
print v(xbgr.mr_n86884736)
print v(xbgr.mr_n86885168)
print v(xbgr.mr_n86885600)
print v(xbgr.mr_n86886032)
print v(xbgr.mr_n86886464)
print v(xbgr.mr_n86886896)
print v(xbgr.mr_n86887328)
print v(xbgr.mr_n86887760)
print v(xbgr.mr_n86888192)
print v(xbgr.mr_n86888624)
print v(xbgr.mr_n86889056)
print v(xbgr.mr_n86889488)
print v(xbgr.mr_n86889920)
print v(xbgr.mr_n86890352)
print v(xbgr.mr_n86890784)
print v(xbgr.mr_n86891216)
print v(xbgr.mr_n86891648)
print v(xbgr.mr_n86892080)
print v(xbgr.mr_n86892512)
print v(xbgr.mr_n86892944)
print v(xbgr.mr_n86893376)
print v(xbgr.mr_n86893808)
print v(xbgr.mr_n86894240)
print v(xbgr.mr_n86894672)
print v(xbgr.mr_n86895104)
print v(xbgr.mr_n86895536)
print v(xbgr.mr_n86895968)
print v(xbgr.mr_n86896400)
print v(xbgr.mr_n86896832)
print v(xbgr.mr_n86897264)
print v(xbgr.mr_n86897696)
print v(xbgr.mr_n86898128)
print v(xbgr.mr_n86898560)
print v(xbgr.mr_n86898992)
print v(xbgr.mr_n86899424)
print v(xbgr.mr_n86899856)
print v(xbgr.mr_n86900288)
print v(xbgr.mr_n86900720)
print v(xbgr.mr_n86901152)
print v(xbgr.mr_n86901584)
print v(xbgr.mr_n86902016)
print v(xbgr.mr_n86902448)
print v(xbgr.mr_n86902880)
print v(xbgr.mr_n86903312)
print v(xbgr.mr_n86903744)
print v(xbgr.mr_n86904176)
print v(xbgr.mr_n86904608)
print v(xbgr.mr_n86905040)
print v(xbgr.mr_n86905472)
print v(xbgr.mr_n86905904)
print v(xbgr.mr_n86906336)
print v(xbgr.mr_n86906768)
print v(xbgr.mr_n86907200)
print v(xbgr.mr_n86907632)
print v(xbgr.mr_n86908064)
print v(xbgr.mr_n86908496)
print v(xbgr.mr_n86908928)
print v(xbgr.mr_n86909360)
print v(xbgr.mr_n86909792)
print v(xbgr.mr_n86910224)
print v(xbgr.mr_n86910656)
print v(xbgr.mr_n86911088)
print v(xbgr.mr_n86911520)
print v(xbgr.mr_n86911952)
print v(xbgr.mr_n86912384)
print v(xbgr.mr_n86912816)
print v(xbgr.mr_n86913248)
print v(xbgr.mr_n86913680)
print v(xbgr.mr_n86914112)
print v(xbgr.mr_n86914544)
print v(xbgr.mr_n86914976)
print v(xbgr.mr_n86915408)
print v(xbgr.mr_n86915840)
print v(xbgr.mr_n86916272)
print v(xbgr.mr_n86916704)
print v(xbgr.mr_n86917136)
print v(xbgr.mr_n86917568)
print v(xbgr.mr_n86918000)
print v(xbgr.mr_n86918432)
print v(xbgr.mr_n86918864)
print v(xbgr.mr_n86919296)
print v(xbgr.mr_n86919616)
print v(xbgr.mr_n86919728)
print v(xbgr.mr_n86920048)
print v(xbgr.mr_n86920160)
print v(xbgr.mr_n86920480)
print v(xbgr.mr_n86920592)
print v(xbgr.mr_n86920912)
print v(xbgr.mr_n86921024)
print v(xbgr.mr_n86921344)
print v(xbgr.mr_n86921456)
print v(xbgr.mr_n86921776)
print v(xbgr.mr_n86921888)
print v(xbgr.mr_n86922208)
print v(xbgr.mr_n86922320)
print v(xbgr.mr_n86922640)
print v(xbgr.mr_n86922752)
print v(xbgr.mr_n86923072)
print v(xbgr.mr_n86923184)
print v(xbgr.mr_n86923504)
print v(xbgr.mr_n86923616)
print v(xbgr.mr_n86923936)
print v(xbgr.mr_n86924048)
print v(xbgr.mr_n86924368)
print v(xbgr.mr_n86924480)
print v(xbgr.mr_n86924800)
print v(xbgr.mr_n86924912)
print v(xbgr.mr_n86925232)
print v(xbgr.mr_n86925344)
print v(xbgr.mr_n86925664)
print v(xbgr.mr_n86925776)
print v(xbgr.mr_n86926096)
print v(xbgr.mr_n86926208)
print v(xbgr.mr_n86926528)
print v(xbgr.mr_n86926640)
print v(xbgr.mr_n86926960)
print v(xbgr.mr_n86927072)
print v(xbgr.mr_n86927392)
print v(xbgr.mr_n86927504)
print v(xbgr.mr_n86927824)
print v(xbgr.mr_n86927936)
print v(xbgr.mr_n86928256)
print v(xbgr.mr_n86928368)
print v(xbgr.mr_n86928688)
print v(xbgr.mr_n86928800)
print v(xbgr.mr_n86929120)
print v(xbgr.mr_n86929232)
print v(xbgr.mr_n86929552)
print v(xbgr.mr_n86929664)
print v(xbgr.mr_n86929984)
print v(xbgr.mr_n86930096)
print v(xbgr.mr_n86930416)
print v(xbgr.mr_n86930528)
print v(xbgr.mr_n86930848)
print v(xbgr.mr_n86930960)
print v(xbgr.mr_n86931280)
print v(xbgr.mr_n86931392)
print v(xbgr.mr_n86931712)
print v(xbgr.mr_n86931824)
print v(xbgr.mr_n86932144)
print v(xbgr.mr_n86932256)
print v(xbgr.mr_n86932576)
print v(xbgr.mr_n86932688)
print v(xbgr.mr_n86933008)
print v(xbgr.mr_n86933120)
print v(xbgr.mr_n86933440)
print v(xbgr.mr_n86933552)
print v(xbgr.mr_n86933872)
print v(xbgr.mr_n86933984)
print v(xbgr.mr_n86934304)
print v(xbgr.mr_n86934416)
print v(xbgr.mr_n86934736)
print v(xbgr.mr_n86934848)
print v(xbgr.mr_n86935168)
print v(xbgr.mr_n86935280)
print v(xbgr.mr_n86935600)
print v(xbgr.mr_n86935712)
print v(xbgr.mr_n86936032)
print v(xbgr.mr_n86936144)
print v(xbgr.mr_n86936464)
print v(xbgr.mr_n86936576)
print v(xbgr.mr_n86936896)
print v(xbgr.mr_n86937008)
print v(xbgr.mr_n86937328)
print v(xbgr.mr_n86937440)
print v(xbgr.mr_n86937760)
print v(xbgr.mr_n86937872)
print v(xbgr.mr_n86938192)
print v(xbgr.mr_n86938304)
print v(xbgr.mr_n86938624)
print v(xbgr.mr_n86938736)
print v(xbgr.mr_n86939056)
print v(xbgr.mr_n86939168)
print v(xbgr.mr_n86939488)
print v(xbgr.mr_n86939600)
print v(xbgr.mr_n86939920)
print v(xbgr.mr_n86940032)
print v(xbgr.mr_n86940352)
print v(xbgr.mr_n86940464)
print v(xbgr.mr_n86940784)
print v(xbgr.mr_n86940896)
print v(xbgr.mr_n86941216)
print v(xbgr.mr_n86941328)
print v(xbgr.mr_n86941648)
print v(xbgr.mr_n86941760)
print v(xbgr.mr_n86942080)
print v(xbgr.mr_n86942192)
print v(xbgr.mr_n86942512)
print v(xbgr.mr_n86942624)
print v(xbgr.mr_n86942944)
print v(xbgr.mr_n86943056)
print v(xbgr.mr_n86943376)
print v(xbgr.mr_n86943488)
print v(xbgr.mr_n86943808)
print v(xbgr.mr_n86943920)
print v(xbgr.mr_n86944240)
print v(xbgr.mr_n86944352)
print v(xbgr.mr_n86944672)
print v(xbgr.mr_n86944784)
print v(xbgr.mr_n86945104)
print v(xbgr.mr_n86945216)
print v(xbgr.mr_n86945536)
print v(xbgr.mr_n86945648)
print v(xbgr.mr_n86945968)
print v(xbgr.mr_n86946080)
print v(xbgr.mr_n86946400)
print v(xbgr.mr_n86946512)
print v(xbgr.mr_n86946832)
print v(xbgr.mr_n86946944)
print v(xbgr.mr_n86947264)
print v(xbgr.mr_n86947376)
print v(xbgr.mr_n86947696)
print v(xbgr.mr_n86947808)
print v(xbgr.mr_n86948128)
print v(xbgr.mr_n86948240)
print v(xbgr.mr_n86948560)
print v(xbgr.mr_n86948672)
print v(xbgr.mr_n86948992)
print v(xbgr.mr_n86949104)
print v(xbgr.mr_n86949424)
print v(xbgr.mr_n86949536)
print v(xbgr.mr_n86949856)
print v(xbgr.mr_n86949968)
print v(xbgr.mr_n86950288)
print v(xbgr.mr_n86950400)
print v(xbgr.mr_n86950720)
print v(xbgr.mr_n86950832)
print v(xbgr.mr_n86951152)
print v(xbgr.mr_n86951264)
print v(xbgr.mr_n86951584)
print v(xbgr.mr_n86951696)
print v(xbgr.mr_n86952016)
print v(xbgr.mr_n86952128)
print v(xbgr.mr_n86952448)
print v(xbgr.mr_n86952560)
print v(xbgr.mr_n86952880)
print v(xbgr.mr_n86952992)
print v(xbgr.mr_n86953312)
print v(xbgr.mr_n86953424)
print v(xbgr.mr_n86953744)
print v(xbgr.mr_n86953856)
print v(xbgr.mr_n86954176)
print v(xbgr.mr_n86954288)
print v(xbgr.mr_n86954608)
print v(xbgr.mr_n86954720)
print v(xbgr.mr_n86955040)
print v(xbgr.mr_n86955152)
print v(xbgr.mr_n86955472)
print v(xbgr.mr_n86955584)
print v(xbgr.mr_n86955904)
print v(xbgr.mr_n86956016)
print v(xbgr.mr_n86956336)
print v(xbgr.mr_n86956448)
print v(xbgr.mr_n86956768)
print v(xbgr.mr_n86956880)
print v(xbgr.mr_n86957200)
print v(xbgr.mr_n86957312)
print v(xbgr.mr_n86957632)
print v(xbgr.mr_n86957744)
print v(xbgr.mr_n86958064)
print v(xbgr.mr_n86958176)
print v(xbgr.mr_n86958496)
print v(xbgr.mr_n86958608)
print v(xbgr.mr_n86958928)
print v(xbgr.mr_n86959040)
print v(xbgr.mr_n86959360)
print v(xbgr.mr_n86959472)
print v(xbgr.mr_n86959792)
print v(xbgr.mr_n86959904)
print v(xbgr.mr_n86960224)
print v(xbgr.mr_n86960336)
print v(xbgr.mr_n86960656)
print v(xbgr.mr_n86960768)
print v(xbgr.mr_n86961088)
print v(xbgr.mr_n86961200)
print v(xbgr.mr_n86961520)
print v(xbgr.mr_n86961632)
print v(xbgr.mr_n86961952)
print v(xbgr.mr_n86962064)
print v(xbgr.mr_n86962384)
print v(xbgr.mr_n86962496)
print v(xbgr.mr_n86962816)
print v(xbgr.mr_n86962928)
print v(xbgr.mr_n86963248)
print v(xbgr.mr_n86963360)
print v(xbgr.mr_n86963680)
print v(xbgr.mr_n86963792)
print v(xbgr.mr_n86964112)
print v(xbgr.mr_n86964224)
print v(xbgr.mr_n86964544)
print v(xbgr.mr_n86964656)
print v(xbgr.mr_n86964976)
print v(xbgr.mr_n86965088)
print v(xbgr.mr_n86965408)
print v(xbgr.mr_n86965520)
print v(xbgr.mr_n86965840)
print v(xbgr.mr_n86965952)
print v(xbgr.mr_n86966272)
print v(xbgr.mr_n86966384)
print v(xbgr.mr_n86966704)
print v(xbgr.mr_n86966816)
print v(xbgr.mr_n86967136)
print v(xbgr.mr_n86967248)
print v(xbgr.mr_n86967568)
print v(xbgr.mr_n86967680)
print v(xbgr.mr_n86968000)
print v(xbgr.mr_n86968112)
print v(xbgr.mr_n86968432)
print v(xbgr.mr_n86968544)
print v(xbgr.mr_n86968864)
print v(xbgr.mr_n86968976)
print v(xbgr.mr_n86969296)
print v(xbgr.mr_n86969408)
print v(xbgr.mr_n86969728)
print v(xbgr.mr_n86969840)
print v(xbgr.mr_n86970160)
print v(xbgr.mr_n86970272)
print v(xbgr.mr_n86970592)
print v(xbgr.mr_n86970704)
print v(xbgr.mr_n86971024)
print v(xbgr.mr_n86971136)
print v(xbgr.mr_n86971456)
print v(xbgr.mr_n86971568)
print v(xbgr.mr_n86971888)
print v(xbgr.mr_n86972000)
print v(xbgr.mr_n86972320)
print v(xbgr.mr_n86972432)
print v(xbgr.mr_n86972752)
print v(xbgr.mr_n86972864)
print v(xbgr.mr_n86973184)
print v(xbgr.mr_n86973296)
print v(xbgr.mr_n86973616)
print v(xbgr.mr_n86973728)
print v(xbgr.mr_n86974048)
print v(xbgr.mr_n86974160)
print v(xbgr.mr_n86974480)
print v(xbgr.mr_n86974592)
print v(xbgr.mr_n86974912)
print v(xbgr.mr_n86975024)
print v(xbgr.mr_n86975344)
print v(xbgr.mr_n86975456)
print v(xbgr.mr_n86975776)
print v(xbgr.mr_n86975888)
print v(xbgr.mr_n86976208)
print v(xbgr.mr_n86976320)
print v(xbgr.mr_n86976640)
print v(xbgr.mr_n86976752)
print v(xbgr.mr_n86977072)
print v(xbgr.mr_n86977184)
print v(xbgr.mr_n86977504)
print v(xbgr.mr_n86977616)
print v(xbgr.mr_n86977936)
print v(xbgr.mr_n86978048)
print v(xbgr.mr_n86978368)
print v(xbgr.mr_n86978480)
print v(xbgr.mr_n86978800)
print v(xbgr.mr_n86978912)
print v(xbgr.mr_n86979232)
print v(xbgr.mr_n86979344)
print v(xbgr.mr_n86979664)
print v(xbgr.mr_n86979776)
print v(xbgr.mr_n86980096)
print v(xbgr.mr_n86980208)
print v(xbgr.mr_n86980528)
print v(xbgr.mr_n86980640)
print v(xbgr.mr_n86980960)
print v(xbgr.mr_n86981072)
print v(xbgr.mr_n86981392)
print v(xbgr.mr_n86981504)
print v(xbgr.mr_n86981824)
print v(xbgr.mr_n86981936)
print v(xbgr.mr_n86982256)
print v(xbgr.mr_n86982368)
print v(xbgr.mr_n86982688)
print v(xbgr.mr_n86982800)
print v(xbgr.mr_n86983120)
print v(xbgr.mr_n86983232)
print v(xbgr.mr_n86983552)
print v(xbgr.mr_n86983664)
print v(xbgr.mr_n86983984)
print v(xbgr.mr_n86984096)
print v(xbgr.mr_n86984416)
print v(xbgr.mr_n86984528)
print v(xbgr.mr_n86984848)
print v(xbgr.mr_n86984960)
print v(xbgr.mr_n86985280)
print v(xbgr.mr_n86985392)
print v(xbgr.mr_n86985712)
print v(xbgr.mr_n86985824)
print v(xbgr.mr_n86986144)
print v(xbgr.mr_n86986256)
print v(xbgr.mr_n86986576)
print v(xbgr.mr_n86986688)
print v(xbgr.mr_n86987008)
print v(xbgr.mr_n86987120)
print v(xbgr.mr_n86987440)
print v(xbgr.mr_n86987552)
print v(xbgr.mr_n86987872)
print v(xbgr.mr_n86987984)
print v(xbgr.mr_n86988304)
print v(xbgr.mr_n86988416)
print v(xbgr.mr_n86988736)
print v(xbgr.mr_n86988848)
print v(xbgr.mr_n86989168)
print v(xbgr.mr_n86989280)
print v(xbgr.mr_n86989600)
print v(xbgr.mr_n86989712)
print v(xbgr.mr_n86990032)
print v(xbgr.mr_n86990144)
print v(xbgr.mr_n86990464)
print v(xbgr.mr_n86990576)
print v(xbgr.mr_n86990896)
print v(xbgr.mr_n86991008)
print v(xbgr.mr_n86991328)
print v(xbgr.mr_n86991440)
print v(xbgr.mr_n86991760)
print v(xbgr.mr_n86991872)
print v(xbgr.mr_n86992192)
print v(xbgr.mr_n86992304)
print v(xbgr.mr_n86992624)
print v(xbgr.mr_n86992736)
print v(xbgr.mr_n86993056)
print v(xbgr.mr_n86993168)
print v(xbgr.mr_n86993488)
print v(xbgr.mr_n86993600)
print v(xbgr.mr_n86993920)
print v(xbgr.mr_n86994032)
print v(xbgr.mr_n86994352)
print v(xbgr.mr_n86994464)
print v(xbgr.mr_n86994784)
print v(xbgr.mr_n86994896)
print v(xbgr.mr_n86995216)
print v(xbgr.mr_n86995328)
print v(xbgr.mr_n86995648)
print v(xbgr.mr_n86995760)
print v(xbgr.mr_n86996080)
print v(xbgr.mr_n86996192)
print v(xbgr.mr_n86996512)
print v(xbgr.mr_n86996624)
print v(xbgr.mr_n86996944)
print v(xbgr.mr_n86997056)
print v(xbgr.mr_n86997376)
print v(xbgr.mr_n86997488)
print v(xbgr.mr_n86997808)
print v(xbgr.mr_n86997920)
print v(xbgr.mr_n86998240)
print v(xbgr.mr_n86998352)
print v(xbgr.mr_n86998672)
print v(xbgr.mr_n86998784)
print v(xbgr.mr_n86999104)
print v(xbgr.mr_n86999216)
print v(xbgr.mr_n86999536)
print v(xbgr.mr_n86999648)
print v(xbgr.mr_n86999968)
print v(xbgr.mr_n87000080)
print v(xbgr.mr_n87000400)
print v(xbgr.mr_n87000512)
print v(xbgr.mr_n87000832)
print v(xbgr.mr_n87000944)
print v(xbgr.mr_n87001264)
print v(xbgr.mr_n87001376)
print v(xbgr.mr_n87001696)
print v(xbgr.mr_n87001808)
print v(xbgr.mr_n87002128)
print v(xbgr.mr_n87002240)
print v(xbgr.mr_n87002560)
print v(xbgr.mr_n87002672)
print v(xbgr.mr_n87002992)
print v(xbgr.mr_n87003104)
print v(xbgr.mr_n87003424)
print v(xbgr.mr_n87003536)
print v(xbgr.mr_n87003856)
print v(xbgr.mr_n87003968)
print v(xbgr.mr_n87004288)
print v(xbgr.mr_n87004400)
print v(xbgr.mr_n87004720)
print v(xbgr.mr_n87004832)
print v(xbgr.mr_n87005152)
print v(xbgr.mr_n87005264)
print v(xbgr.mr_n87005584)
print v(xbgr.mr_n87005696)
print v(xbgr.mr_n87006016)
print v(xbgr.mr_n87006128)
print v(xbgr.mr_n87006448)
print v(xbgr.mr_n87006560)
print v(xbgr.mr_n87006880)
print v(xbgr.mr_n87006992)
print v(xbgr.mr_n87007312)
print v(xbgr.mr_n87007424)
print v(xbgr.mr_n87007744)
print v(xbgr.mr_n87007856)
print v(xbgr.mr_n87008176)
print v(xbgr.mr_n87008288)
print v(xbgr.mr_n87008608)
print v(xbgr.mr_n87008720)
print v(xbgr.mr_n87009040)
print v(xbgr.mr_n87009152)
print v(xbgr.mr_n87009472)
print v(xbgr.mr_n87009584)
print v(xbgr.mr_n87009904)
print v(xbgr.mr_n87010016)
print v(xbgr.mr_n87010336)
print v(xbgr.mr_n87010448)
print v(xbgr.mr_n87010768)
print v(xbgr.mr_n87010880)
print v(xbgr.mr_n87011200)
print v(xbgr.mr_n87011312)
print v(xbgr.mr_n87011632)
print v(xbgr.mr_n87011744)
print v(xbgr.mr_n87012064)
print v(xbgr.mr_n87012176)
print v(xbgr.mr_n87012496)
print v(xbgr.mr_n87012608)
print v(xbgr.mr_n87012928)
print v(xbgr.mr_n87013040)
print v(xbgr.mr_n87013360)
print v(xbgr.mr_n87013472)
print v(xbgr.mr_n87014336)
print v(xbgr.mr_n87014768)
print v(xbgr.mr_n87015200)
print v(xbgr.mr_n87015632)
print v(xbgr.mr_n87016064)
print v(xbgr.mr_n87016496)
print v(xbgr.mr_n87016928)
print v(xbgr.mr_n87017360)
print v(xbgr.mr_n87017792)
print v(xbgr.mr_n87018224)
print v(xbgr.mr_n87018656)
print v(xbgr.mr_n87019088)
print v(xbgr.mr_n87019520)
print v(xbgr.mr_n87019952)
print v(xbgr.mr_n87020384)
print v(xbgr.mr_n87020816)
print v(xbgr.mr_n87021248)
print v(xbgr.mr_n87021680)
print v(xbgr.mr_n87022112)
print v(xbgr.mr_n87022544)
print v(xbgr.mr_n87022976)
print v(xbgr.mr_n87023408)
print v(xbgr.mr_n87023840)
print v(xbgr.mr_n87024272)
print v(xbgr.mr_n87026432)
print v(xbgr.mr_n87026864)
print v(xbgr.mr_n87027296)
print v(xbgr.mr_n87027728)
print v(xbgr.mr_n87028160)
print v(xbgr.mr_n87028592)
print v(xbgr.mr_n87029024)
print v(xbgr.mr_n87029456)
print v(xbgr.mr_n87029888)
print v(xbgr.mr_n87030320)
print v(xbgr.mr_n87030752)
print v(xbgr.mr_n87031184)
print v(xbgr.mr_n87031616)
print v(xbgr.mr_n87032048)
print v(xbgr.mr_n87032480)
print v(xbgr.mr_n87032912)
print v(xbgr.mr_n87033344)
print v(xbgr.mr_n87033776)
print v(xbgr.mr_n87034208)
print v(xbgr.mr_n87034640)
print v(xbgr.mr_n87035072)
print v(xbgr.mr_n87035504)
print v(xbgr.mr_n87035936)
print v(xbgr.mr_n87036368)
print v(xbgr.mr_n87040256)
print v(xbgr.mr_n87040688)
print v(xbgr.mr_n87041120)
print v(xbgr.mr_n87041552)
print v(xbgr.mr_n87041984)
print v(xbgr.mr_n87042416)
print v(xbgr.mr_n87042848)
print v(xbgr.mr_n87043280)
print v(xbgr.mr_n87043712)
print v(xbgr.mr_n87044144)
print v(xbgr.mr_n87044576)
print v(xbgr.mr_n87045008)
print v(xbgr.mr_n87045440)
print v(xbgr.mr_n87045872)
print v(xbgr.mr_n87046304)
print v(xbgr.mr_n87047600)
print v(xbgr.mr_n87048032)
print v(xbgr.mr_n87048464)
print v(xbgr.mr_n87048896)
print v(xbgr.mr_n87049328)
print v(xbgr.mr_n87049760)
print v(xbgr.mr_n87050192)
print v(xbgr.mr_n87050624)
print v(xbgr.mr_n87051056)
print v(xbgr.mr_n87051488)
print v(xbgr.mr_n87052784)
print v(xbgr.mr_n87053216)
print v(xbgr.mr_n87053648)
print v(xbgr.mr_n87054080)
print v(xbgr.mr_n87054512)
print v(xbgr.mr_n87054944)
print v(xbgr.mr_n87055376)
print v(xbgr.mr_n87055808)
print v(xbgr.mr_n87056128)
print v(xbgr.mr_n87056240)
print v(xbgr.mr_n87056560)
print v(xbgr.mr_n87056672)
print v(xbgr.mr_n87056992)
print v(xbgr.mr_n87057104)
print v(xbgr.mr_n87057424)
print v(xbgr.mr_n87057536)
print v(xbgr.mr_n87057856)
print v(xbgr.mr_n87057968)
print v(xbgr.mr_n87058288)
print v(xbgr.mr_n87058400)
print v(xbgr.mr_n87058720)
print v(xbgr.mr_n87058832)
print v(xbgr.mr_n87059152)
print v(xbgr.mr_n87059264)
print v(xbgr.mr_n87059584)
print v(xbgr.mr_n87059696)
print v(xbgr.mr_n87060016)
print v(xbgr.mr_n87060128)
print v(xbgr.mr_n87060448)
print v(xbgr.mr_n87060560)
print v(xbgr.mr_n87060880)
print v(xbgr.mr_n87060992)
print v(xbgr.mr_n87061312)
print v(xbgr.mr_n87061424)
print v(xbgr.mr_n87061744)
print v(xbgr.mr_n87061856)
print v(xbgr.mr_n87062176)
print v(xbgr.mr_n87062288)
print v(xbgr.mr_n87062608)
print v(xbgr.mr_n87062720)
print v(xbgr.mr_n87063040)
print v(xbgr.mr_n87063152)
print v(xbgr.mr_n87063472)
print v(xbgr.mr_n87063584)
print v(xbgr.mr_n87063904)
print v(xbgr.mr_n87064016)
print v(xbgr.mr_n87064336)
print v(xbgr.mr_n87064448)
print v(xbgr.mr_n87064768)
print v(xbgr.mr_n87064880)
print v(xbgr.mr_n87065200)
print v(xbgr.mr_n87065312)
print v(xbgr.mr_n87065632)
print v(xbgr.mr_n87065744)
print v(xbgr.mr_n87066064)
print v(xbgr.mr_n87066176)
print v(xbgr.mr_n87066496)
print v(xbgr.mr_n87066608)
print v(xbgr.mr_n87066928)
print v(xbgr.mr_n87067040)
print v(xbgr.mr_n87067360)
print v(xbgr.mr_n87067472)
print v(xbgr.mr_n87067792)
print v(xbgr.mr_n87067904)
print v(xbgr.mr_n87068224)
print v(xbgr.mr_n87068336)
print v(xbgr.mr_n87068656)
print v(xbgr.mr_n87068768)
print v(xbgr.mr_n87069088)
print v(xbgr.mr_n87069200)
print v(xbgr.mr_n87069520)
print v(xbgr.mr_n87069632)
print v(xbgr.mr_n87069952)
print v(xbgr.mr_n87070064)
print v(xbgr.mr_n87070384)
print v(xbgr.mr_n87070496)
print v(xbgr.mr_n87070816)
print v(xbgr.mr_n87070928)
print v(xbgr.mr_n87071248)
print v(xbgr.mr_n87071360)
print v(xbgr.mr_n87071680)
print v(xbgr.mr_n87071792)
print v(xbgr.mr_n87072112)
print v(xbgr.mr_n87072224)
print v(xbgr.mr_n87072544)
print v(xbgr.mr_n87072656)
print v(xbgr.mr_n87072976)
print v(xbgr.mr_n87073088)
print v(xbgr.mr_n87073408)
print v(xbgr.mr_n87073520)
print v(xbgr.mr_n87073840)
print v(xbgr.mr_n87073952)
print v(xbgr.mr_n87074272)
print v(xbgr.mr_n87074384)
print v(xbgr.mr_n87074704)
print v(xbgr.mr_n87074816)
print v(xbgr.mr_n87075136)
print v(xbgr.mr_n87075248)
print v(xbgr.mr_n87075568)
print v(xbgr.mr_n87075680)
print v(xbgr.mr_n87076000)
print v(xbgr.mr_n87076112)
print v(xbgr.mr_n87076432)
print v(xbgr.mr_n87076544)
print v(xbgr.mr_n87076864)
print v(xbgr.mr_n87076976)
print v(xbgr.mr_n87077296)
print v(xbgr.mr_n87077408)
print v(xbgr.mr_n87077728)
print v(xbgr.mr_n87077840)
print v(xbgr.mr_n87078160)
print v(xbgr.mr_n87078272)
print v(xbgr.mr_n87078592)
print v(xbgr.mr_n87078704)
print v(xbgr.mr_n87079024)
print v(xbgr.mr_n87079136)
print v(xbgr.mr_n87079456)
print v(xbgr.mr_n87079568)
print v(xbgr.mr_n87079888)
print v(xbgr.mr_n87080000)
print v(xbgr.mr_n87080320)
print v(xbgr.mr_n87080432)
print v(xbgr.mr_n87080752)
print v(xbgr.mr_n87080864)
print v(xbgr.mr_n87081184)
print v(xbgr.mr_n87081296)
print v(xbgr.mr_n87081616)
print v(xbgr.mr_n87081728)
print v(xbgr.mr_n87082048)
print v(xbgr.mr_n87082160)
print v(xbgr.mr_n87082480)
print v(xbgr.mr_n87082592)
print v(xbgr.mr_n87082912)
print v(xbgr.mr_n87083024)
print v(xbgr.mr_n87083344)
print v(xbgr.mr_n87083456)
print v(xbgr.mr_n87083776)
print v(xbgr.mr_n87083888)
print v(xbgr.mr_n87084208)
print v(xbgr.mr_n87084320)
print v(xbgr.mr_n87084640)
print v(xbgr.mr_n87084752)
print v(xbgr.mr_n87085072)
print v(xbgr.mr_n87085184)
print v(xbgr.mr_n87085504)
print v(xbgr.mr_n87085616)
print v(xbgr.mr_n87085936)
print v(xbgr.mr_n87086048)
print v(xbgr.mr_n87086368)
print v(xbgr.mr_n87086480)
print v(xbgr.mr_n87086800)
print v(xbgr.mr_n87086912)
print v(xbgr.mr_n87087232)
print v(xbgr.mr_n87087344)
print v(xbgr.mr_n87087664)
print v(xbgr.mr_n87087776)
print v(xbgr.mr_n87088096)
print v(xbgr.mr_n87088208)
print v(xbgr.mr_n87088528)
print v(xbgr.mr_n87088640)
print v(xbgr.mr_n87088960)
print v(xbgr.mr_n87089072)
print v(xbgr.mr_n87089392)
print v(xbgr.mr_n87089504)
print v(xbgr.mr_n87089824)
print v(xbgr.mr_n87089936)
print v(xbgr.mr_n87090256)
print v(xbgr.mr_n87090368)
print v(xbgr.mr_n87090688)
print v(xbgr.mr_n87090800)
print v(xbgr.mr_n87091120)
print v(xbgr.mr_n87091232)
print v(xbgr.mr_n87091552)
print v(xbgr.mr_n87091664)
print v(xbgr.mr_n87091984)
print v(xbgr.mr_n87092096)
print v(xbgr.mr_n87092416)
print v(xbgr.mr_n87092528)
print v(xbgr.mr_n87092848)
print v(xbgr.mr_n87092960)
print v(xbgr.mr_n87093280)
print v(xbgr.mr_n87093392)
print v(xbgr.mr_n87093712)
print v(xbgr.mr_n87093824)
print v(xbgr.mr_n87094144)
print v(xbgr.mr_n87094256)
print v(xbgr.mr_n87094576)
print v(xbgr.mr_n87094688)
print v(xbgr.mr_n87095008)
print v(xbgr.mr_n87095120)
print v(xbgr.mr_n87095440)
print v(xbgr.mr_n87095552)
print v(xbgr.mr_n87095872)
print v(xbgr.mr_n87095984)
print v(xbgr.mr_n87096304)
print v(xbgr.mr_n87096416)
print v(xbgr.mr_n87096736)
print v(xbgr.mr_n87096848)
print v(xbgr.mr_n87097168)
print v(xbgr.mr_n87097280)
print v(xbgr.mr_n87097600)
print v(xbgr.mr_n87097712)
print v(xbgr.mr_n87098032)
print v(xbgr.mr_n87098144)
print v(xbgr.mr_n87098464)
print v(xbgr.mr_n87098576)
print v(xbgr.mr_n87098896)
print v(xbgr.mr_n87099008)
print v(xbgr.mr_n87099328)
print v(xbgr.mr_n87099440)
print v(xbgr.mr_n87099760)
print v(xbgr.mr_n87099872)
print v(xbgr.mr_n87100192)
print v(xbgr.mr_n87100304)
print v(xbgr.mr_n87100624)
print v(xbgr.mr_n87100736)
print v(xbgr.mr_n87101056)
print v(xbgr.mr_n87101168)
print v(xbgr.mr_n87101488)
print v(xbgr.mr_n87101600)
print v(xbgr.mr_n87101920)
print v(xbgr.mr_n87102032)
print v(xbgr.mr_n87102352)
print v(xbgr.mr_n87102464)
print v(xbgr.mr_n87102784)
print v(xbgr.mr_n87103216)
print v(xbgr.mr_n87103328)
print v(xbgr.mr_n87103648)
print v(xbgr.mr_n87103760)
print v(xbgr.mr_n87104080)
print v(xbgr.mr_n87104192)
print v(xbgr.mr_n87104512)
print v(xbgr.mr_n87104624)
print v(xbgr.mr_n87104944)
print v(xbgr.mr_n87105056)
print v(xbgr.mr_n87105376)
print v(xbgr.mr_n87105488)
print v(xbgr.mr_n87105808)
print v(xbgr.mr_n87105920)
print v(xbgr.mr_n87106240)
print v(xbgr.mr_n87106352)
print v(xbgr.mr_n87106672)
print v(xbgr.mr_n87106784)
print v(xbgr.mr_n87107104)
print v(xbgr.mr_n87107216)
print v(xbgr.mr_n87107536)
print v(xbgr.mr_n87107648)
print v(xbgr.mr_n87107968)
print v(xbgr.mr_n87108080)
print v(xbgr.mr_n87108400)
print v(xbgr.mr_n87108512)
print v(xbgr.mr_n87108832)
print v(xbgr.mr_n87108944)
print v(xbgr.mr_n87109264)
print v(xbgr.mr_n87109376)
print v(xbgr.mr_n87109696)
print v(xbgr.mr_n87109808)
print v(xbgr.mr_n87110128)
print v(xbgr.mr_n87110240)
print v(xbgr.mr_n87110560)
print v(xbgr.mr_n87110672)
print v(xbgr.mr_n87110992)
print v(xbgr.mr_n87111104)
print v(xbgr.mr_n87111424)
print v(xbgr.mr_n87111536)
print v(xbgr.mr_n87111856)
print v(xbgr.mr_n87111968)
print v(xbgr.mr_n87112288)
print v(xbgr.mr_n87112400)
print v(xbgr.mr_n87112720)
print v(xbgr.mr_n87112832)
print v(xbgr.mr_n87113152)
print v(xbgr.mr_n87113264)
print v(xbgr.mr_n87113584)
print v(xbgr.mr_n87113696)
print v(xbgr.mr_n87114016)
print v(xbgr.mr_n87114128)
print v(xbgr.mr_n87114448)
print v(xbgr.mr_n87114560)
print v(xbgr.mr_n87114880)
print v(xbgr.mr_n87114992)
print v(xbgr.mr_n87115312)
print v(xbgr.mr_n87115424)
print v(xbgr.mr_n87115744)
print v(xbgr.mr_n87115856)
print v(xbgr.mr_n87116176)
print v(xbgr.mr_n87116288)
print v(xbgr.mr_n87116608)
print v(xbgr.mr_n87116720)
print v(xbgr.mr_n87117040)
print v(xbgr.mr_n87117152)
print v(xbgr.mr_n87117472)
print v(xbgr.mr_n87117584)
print v(xbgr.mr_n87117904)
print v(xbgr.mr_n87118016)
print v(xbgr.mr_n87118336)
print v(xbgr.mr_n87118768)
print v(xbgr.mr_n87118880)
print v(xbgr.mr_n87119200)
print v(xbgr.mr_n87119312)
print v(xbgr.mr_n87119632)
print v(xbgr.mr_n87119744)
print v(xbgr.mr_n87120064)
print v(xbgr.mr_n87120496)
print v(xbgr.mr_n87120608)
print v(xbgr.mr_n87120928)
print v(xbgr.mr_n87121040)
print v(xbgr.mr_n87121360)
print v(xbgr.mr_n87121472)
print v(xbgr.mr_n87121792)
print v(xbgr.mr_n87122224)
print v(xbgr.mr_n87122336)
print v(xbgr.mr_n87122656)
print v(xbgr.mr_n87122768)
print v(xbgr.mr_n87123088)
print v(xbgr.mr_n87123200)
print v(xbgr.mr_n87123520)
print v(xbgr.mr_n87123632)
print v(xbgr.mr_n87123952)
print v(xbgr.mr_n87124064)
print v(xbgr.mr_n87124384)
print v(xbgr.mr_n87124496)
print v(xbgr.mr_n87124816)
print v(xbgr.mr_n87124928)
print v(xbgr.mr_n87125248)
print v(xbgr.mr_n87125360)
print v(xbgr.mr_n87125680)
print v(xbgr.mr_n87125792)
print v(xbgr.mr_n87126112)
print v(xbgr.mr_n87126224)
print v(xbgr.mr_n87126544)
print v(xbgr.mr_n87126656)
print v(xbgr.mr_n87126976)
print v(xbgr.mr_n87127088)
print v(xbgr.mr_n87127408)
print v(xbgr.mr_n87127520)
print v(xbgr.mr_n87127840)
print v(xbgr.mr_n87127952)
print v(xbgr.mr_n87128272)
print v(xbgr.mr_n87128384)
print v(xbgr.mr_n87128704)
print v(xbgr.mr_n87128816)
print v(xbgr.mr_n87129136)
print v(xbgr.mr_n87129568)
print v(xbgr.mr_n87129680)
print v(xbgr.mr_n87130000)
print v(xbgr.mr_n87130112)
print v(xbgr.mr_n87130432)
print v(xbgr.mr_n87130544)
print v(xbgr.mr_n87130864)
print v(xbgr.mr_n87130976)
print v(xbgr.mr_n87131296)
print v(xbgr.mr_n87131408)
print v(xbgr.mr_n87131728)
print v(xbgr.mr_n87131840)
print v(xbgr.mr_n87132160)
print v(xbgr.mr_n87132272)
print v(xbgr.mr_n87132592)
print v(xbgr.mr_n87132704)
print v(xbgr.mr_n87133024)
print v(xbgr.mr_n87133136)
print v(xbgr.mr_n87133456)
print v(xbgr.mr_n87133568)
print v(xbgr.mr_n87133888)
print v(xbgr.mr_n87134320)
print v(xbgr.mr_n87134432)
print v(xbgr.mr_n87134752)
print v(xbgr.mr_n87135184)
print v(xbgr.mr_n87135296)
print v(xbgr.mr_n87135616)
print v(xbgr.mr_n87135728)
print v(xbgr.mr_n87136048)
print v(xbgr.mr_n87136160)
print v(xbgr.mr_n87136480)
print v(xbgr.mr_n87136592)
print v(xbgr.mr_n87136912)
print v(xbgr.mr_n87137024)
print v(xbgr.mr_n87137344)
print v(xbgr.mr_n87137776)
print v(xbgr.mr_n87137888)
print v(xbgr.mr_n87138208)
print v(xbgr.mr_n87138320)
print v(xbgr.mr_n87138640)
print v(xbgr.mr_n87138752)
print v(xbgr.mr_n87142912)
print v(xbgr.mr_n87143024)
print v(xbgr.mr_n87143360)
print v(xbgr.mr_n87143472)
print v(xbgr.mr_n87143792)
print v(xbgr.mr_n87143904)
print v(xbgr.mr_n87144272)
print v(xbgr.mr_n87144384)
print v(xbgr.mr_n87144704)
print v(xbgr.mr_n87144816)
print v(xbgr.mr_n87145136)
print v(xbgr.mr_n87145488)
print v(xbgr.mr_n87145600)
print v(xbgr.mr_n87145920)
print v(xbgr.mr_n87146352)
print v(xbgr.mr_n87146464)
print v(xbgr.mr_n87146784)
print v(xbgr.mr_n87146896)
print v(xbgr.mr_n87147216)
print v(xbgr.mr_n87147328)
print v(xbgr.mr_n87147648)
print v(xbgr.mr_n87147760)
print v(xbgr.mr_n87148080)
print v(xbgr.mr_n87148192)
print v(xbgr.mr_n87148512)
print v(xbgr.mr_n87148944)
print v(xbgr.mr_n87149056)
print v(xbgr.mr_n87149376)
print v(xbgr.mr_n87149808)
print v(xbgr.mr_n87149920)
print v(xbgr.mr_n87150240)
print v(xbgr.mr_n87150352)
print v(xbgr.mr_n87150672)
print v(xbgr.mr_n87150784)
print v(xbgr.mr_n87151104)
print v(xbgr.mr_n87151216)
print v(xbgr.mr_n87151536)
print v(xbgr.mr_n87151648)
print v(xbgr.mr_n87151968)
print v(xbgr.mr_n87152080)
print v(xbgr.mr_n87152400)
print v(xbgr.mr_n87152512)
print v(xbgr.mr_n87152832)
print v(xbgr.mr_n87153264)
print v(xbgr.mr_n87153376)
print v(xbgr.mr_n87153696)
print v(xbgr.mr_n87153808)
print v(xbgr.mr_n87154128)
print v(xbgr.mr_n87154240)
print v(xbgr.mr_n87154560)
print v(xbgr.mr_n87154672)
print v(xbgr.mr_n87154992)
print v(xbgr.mr_n87155104)
print v(xbgr.mr_n87155424)
print v(xbgr.mr_n87155536)
print v(xbgr.mr_n87155856)
print v(xbgr.mr_n87155968)
print v(xbgr.mr_n87156288)
print v(xbgr.mr_n87156720)
print v(xbgr.mr_n87156832)
print v(xbgr.mr_n87157152)
print v(xbgr.mr_n87157584)
print v(xbgr.mr_n87157696)
print v(xbgr.mr_n87158016)
print v(xbgr.mr_n87158128)
print v(xbgr.mr_n87158448)
print v(xbgr.mr_n87158560)
print v(xbgr.mr_n87158880)
print v(xbgr.mr_n87158992)
print v(xbgr.mr_n87159312)
print v(xbgr.mr_n87159424)
print v(xbgr.mr_n87159744)
print v(xbgr.mr_n87159856)
print v(xbgr.mr_n87160176)
print v(xbgr.mr_n87160288)
print v(xbgr.mr_n87160608)
print v(xbgr.mr_n87161040)
print v(xbgr.mr_n87161152)
print v(xbgr.mr_n87161472)
print v(xbgr.mr_n87161584)
print v(xbgr.mr_n87161904)
print v(xbgr.mr_n87162016)
print v(xbgr.mr_n87162336)
print v(xbgr.mr_n87162768)
print v(xbgr.mr_n87162880)
print v(xbgr.mr_n87163200)
print v(xbgr.mr_n87163312)
print v(xbgr.mr_n87163632)
print v(xbgr.mr_n87163744)
print v(xbgr.mr_n87164064)
print v(xbgr.mr_n87164176)
print v(xbgr.mr_n87164496)
print v(xbgr.mr_n87164608)
print v(xbgr.mr_n87164928)
print v(xbgr.mr_n87165040)
print v(xbgr.mr_n87165360)
print v(xbgr.mr_n87165472)
print v(xbgr.mr_n87165792)
print v(xbgr.mr_n87166224)
print v(xbgr.mr_n87166336)
print v(xbgr.mr_n87166656)
print v(xbgr.mr_n87166768)
print v(xbgr.mr_n87167088)
print v(xbgr.mr_n87167200)
print v(xbgr.mr_n87167520)
print v(xbgr.mr_n87167952)
print v(xbgr.mr_n87168064)
print v(xbgr.mr_n87168384)
print v(xbgr.mr_n87168496)
print v(xbgr.mr_n87168816)
print v(xbgr.mr_n87168928)
print v(xbgr.mr_n87169248)
print v(xbgr.mr_n87169360)
print v(xbgr.mr_n87169680)
print v(xbgr.mr_n87169792)
print v(xbgr.mr_n87170112)
print v(xbgr.mr_n87170224)
print v(xbgr.mr_n87170544)
print v(xbgr.mr_n87170656)
print v(xbgr.mr_n87170976)
print v(xbgr.mr_n87171088)
print v(xbgr.mr_n87171408)
print v(xbgr.mr_n87171520)
print v(xbgr.mr_n87171840)
print v(xbgr.mr_n87172272)
print v(xbgr.mr_n87172384)
print v(xbgr.mr_n87172704)
print v(xbgr.mr_n87172816)
print v(xbgr.mr_n87173040)
print v(xbgr.mr_n87173408)
print v(xbgr.mr_n87173520)
print v(xbgr.mr_n87173776)
print v(xbgr.mr_n87173888)
print v(xbgr.mr_n87174144)
print v(xbgr.mr_n87174256)
print v(xbgr.mr_n87174512)
print v(xbgr.mr_n87174624)
print v(xbgr.mr_n87174880)
print v(xbgr.mr_n87174992)
print v(xbgr.mr_n87175248)
print v(xbgr.mr_n87175616)
print v(xbgr.mr_n87175728)
print v(xbgr.mr_n87175984)
print v(xbgr.mr_n87176352)
print v(xbgr.mr_n87176464)
print v(xbgr.mr_n87176720)
print v(xbgr.mr_n87177088)
print v(xbgr.mr_n87177200)
print v(xbgr.mr_n87177456)
print v(xbgr.mr_n87177568)
print v(xbgr.mr_n87177824)
print v(xbgr.mr_n87177936)
print v(xbgr.mr_n87178192)
print v(xbgr.mr_n87178560)
print v(xbgr.mr_n87178672)
print v(xbgr.mr_n87178928)
print v(xbgr.mr_n87179296)
print v(xbgr.mr_n87179408)
print v(xbgr.mr_n87179664)
print v(xbgr.mr_n87180032)
print v(xbgr.mr_n87180144)
print v(xbgr.mr_n87180400)
print v(xbgr.mr_n87180512)
print v(xbgr.mr_n87180768)
print v(xbgr.mr_n87180880)
print v(xbgr.mr_n87181136)
print v(xbgr.mr_n87181248)
print v(xbgr.mr_n87181504)
print v(xbgr.mr_n87181616)
print v(xbgr.mr_n87181872)
print v(xbgr.mr_n87182240)
print v(xbgr.mr_n87182352)
print v(xbgr.mr_n87182608)
print v(xbgr.mr_n87182720)
print v(xbgr.mr_n87182976)
print v(xbgr.mr_n87183088)
print v(xbgr.mr_n87183344)
print v(xbgr.mr_n87183456)
print v(xbgr.mr_n87183712)
print v(xbgr.mr_n87183824)
print v(xbgr.mr_n87184080)
print v(xbgr.mr_n87184448)
print v(xbgr.mr_n87184560)
print v(xbgr.mr_n87184816)
print v(xbgr.mr_n87185184)
print v(xbgr.mr_n87185296)
print v(xbgr.mr_n87185552)
print v(xbgr.mr_n87185664)
print v(xbgr.mr_n87185920)
print v(xbgr.mr_n87186032)
print v(xbgr.mr_n87186288)
print v(xbgr.mr_n87186720)
print v(xbgr.mr_n87186832)
print v(xbgr.mr_n87187152)
print v(xbgr.mr_n87187584)
print v(xbgr.mr_n87187696)
print v(xbgr.mr_n87188016)
print v(xbgr.mr_n87188128)
print v(xbgr.mr_n87188448)
print v(xbgr.mr_n87188560)
print v(xbgr.mr_n87188880)
print v(xbgr.mr_n87188992)
print v(xbgr.mr_n87189312)
print v(xbgr.mr_n87189424)
print v(xbgr.mr_n87189744)
print v(xbgr.mr_n87189856)
print v(xbgr.mr_n87190176)
print v(xbgr.mr_n87190288)
print v(xbgr.mr_n87190608)
print v(xbgr.mr_n87191040)
print v(xbgr.mr_n87191152)
print v(xbgr.mr_n87191472)
print v(xbgr.mr_n87191584)
print v(xbgr.mr_n87191904)
print v(xbgr.mr_n87192016)
print v(xbgr.mr_n87192336)
print v(xbgr.mr_n87192448)
print v(xbgr.mr_n87192768)
print v(xbgr.mr_n87192880)
print v(xbgr.mr_n87193200)
print v(xbgr.mr_n87193632)
print v(xbgr.mr_n87193744)
print v(xbgr.mr_n87194064)
print v(xbgr.mr_n87194496)
print v(xbgr.mr_n87194608)
print v(xbgr.mr_n87194928)
print v(xbgr.mr_n87195040)
print v(xbgr.mr_n87195360)
print v(xbgr.mr_n87195472)
print v(xbgr.mr_n87195792)
print v(xbgr.mr_n87195904)
print v(xbgr.mr_n87196224)
print v(xbgr.mr_n87196336)
print v(xbgr.mr_n87196656)
print v(xbgr.mr_n87196768)
print v(xbgr.mr_n87197088)
print v(xbgr.mr_n87197200)
print v(xbgr.mr_n87197520)
print v(xbgr.mr_n87197632)
print v(xbgr.mr_n87197952)
print v(xbgr.mr_n87198496)
print v(xbgr.mr_n87198928)
print v(xbgr.mr_n87199360)
print v(xbgr.mr_n87199792)
print v(xbgr.mr_n87200224)
print v(xbgr.mr_n87200656)
print v(xbgr.mr_n87201088)
print v(xbgr.mr_n87201520)
print v(xbgr.mr_n87201952)
print v(xbgr.mr_n87202384)
print v(xbgr.mr_n87202704)
print v(xbgr.mr_n87203136)
print v(xbgr.mr_n87203568)
print v(xbgr.mr_n87204000)
print v(xbgr.mr_n87204432)
print v(xbgr.mr_n87204864)
print v(xbgr.mr_n87205296)
print v(xbgr.mr_n87205728)
print v(xbgr.mr_n87206160)
print v(xbgr.mr_n87206592)
print v(xbgr.mr_n87207024)
print v(xbgr.mr_n87207456)
print v(xbgr.mr_n87207888)
print v(xbgr.mr_n87208320)
print v(xbgr.mr_n87208752)
print v(xbgr.mr_n87209184)
print v(xbgr.mr_n87209616)
print v(xbgr.mr_n87210048)
print v(xbgr.mr_n87210480)
print v(xbgr.mr_n87210912)
print v(xbgr.mr_n87211344)
print v(xbgr.mr_n87211776)
print v(xbgr.mr_n87212208)
print v(xbgr.mr_n87212640)
print v(xbgr.mr_n87213072)
print v(xbgr.mr_n87213504)
print v(xbgr.mr_n87213936)
print v(xbgr.mr_n87214368)
print v(xbgr.mr_n87214800)
print v(xbgr.mr_n87215232)
print v(xbgr.mr_n87215664)
print v(xbgr.mr_n87216096)
print v(xbgr.mr_n87216528)
print v(xbgr.mr_n87216960)
print v(xbgr.mr_n87217392)
print v(xbgr.mr_n87217824)
print v(xbgr.mr_n87218256)
print v(xbgr.mr_n87218688)
print v(xbgr.mr_n87219120)
print v(xbgr.mr_n87219552)
print v(xbgr.mr_n87219984)
print v(xbgr.mr_n87220416)
print v(xbgr.mr_n87220848)
print v(xbgr.mr_n87221280)
print v(xbgr.mr_n87221712)
print v(xbgr.mr_n87222144)
print v(xbgr.mr_n87222576)
print v(xbgr.mr_n87223008)
print v(xbgr.mr_n87224304)
print v(xbgr.mr_n87224736)
print v(xbgr.mr_n87225168)
print v(xbgr.mr_n87225600)
print v(xbgr.mr_n87226032)
print v(xbgr.mr_n87226464)
print v(xbgr.mr_n87226896)
print v(xbgr.mr_n87227328)
print v(xbgr.mr_n87227760)
print v(xbgr.mr_n87228192)
print v(xbgr.mr_n87228624)
print v(xbgr.mr_n87229056)
print v(xbgr.mr_n87231216)
print v(xbgr.mr_n87231648)
print v(xbgr.mr_n87232080)
print v(xbgr.mr_n87232512)
print v(xbgr.mr_n87232944)
print v(xbgr.mr_n87233376)
print v(xbgr.mr_n87233808)
print v(xbgr.mr_n87234240)
print v(xbgr.mr_n87234672)
print v(xbgr.mr_n87235104)
print v(xbgr.mr_n87236400)
print v(xbgr.mr_n87236832)
print v(xbgr.mr_n87237264)
print v(xbgr.mr_n87237696)
print v(xbgr.mr_n87238128)
print v(xbgr.mr_n87238560)
print v(xbgr.mr_n87238992)
print v(xbgr.mr_n87239424)
print v(xbgr.mr_n87239856)
print v(xbgr.mr_n87240288)
print v(xbgr.mr_n87240720)
print v(xbgr.mr_n87241152)
print v(xbgr.mr_n87242448)
print v(xbgr.mr_n87242880)
print v(xbgr.mr_n87244176)
print v(xbgr.mr_n87244608)
print v(xbgr.mr_n87245040)
print v(xbgr.mr_n87245472)
print v(xbgr.mr_n87245904)
print v(xbgr.mr_n87246336)
print v(xbgr.mr_n87246768)
print v(xbgr.mr_n87247200)
print v(xbgr.mr_n87248496)
print v(xbgr.mr_n87248928)
print v(xbgr.mr_n87249248)
print v(xbgr.mr_n87249360)
print v(xbgr.mr_n87249680)
print v(xbgr.mr_n87249792)
print v(xbgr.mr_n87250112)
print v(xbgr.mr_n87250224)
print v(xbgr.mr_n87250544)
print v(xbgr.mr_n87250656)
print v(xbgr.mr_n87250976)
print v(xbgr.mr_n87251088)
print v(xbgr.mr_n87251408)
print v(xbgr.mr_n87251520)
print v(xbgr.mr_n87251840)
print v(xbgr.mr_n87251952)
print v(xbgr.mr_n87252272)
print v(xbgr.mr_n87252384)
print v(xbgr.mr_n87252816)
print v(xbgr.mr_n87253248)
print v(xbgr.mr_n87253680)
print v(xbgr.mr_n87254112)
print v(xbgr.mr_n87254544)
print v(xbgr.mr_n87254976)
print v(xbgr.mr_n87255408)
print v(xbgr.mr_n87255840)
print v(xbgr.mr_n87256272)
print v(xbgr.mr_n87256704)
print v(xbgr.mr_n87257136)
print v(xbgr.mr_n87257568)
print v(xbgr.mr_n87258000)
print v(xbgr.mr_n87258432)
print v(xbgr.mr_n87258864)
print v(xbgr.mr_n87259296)
print v(xbgr.mr_n87259728)
print v(xbgr.mr_n87260160)
print v(xbgr.mr_n87260592)
print v(xbgr.mr_n87261024)
print v(xbgr.mr_n87261456)
print v(xbgr.mr_n87261888)
print v(xbgr.mr_n87262320)
print v(xbgr.mr_n87262752)
print v(xbgr.mr_n87263184)
print v(xbgr.mr_n87263616)
print v(xbgr.mr_n87264256)
print v(xbgr.mr_n87264688)
print v(xbgr.mr_n87265120)
print v(xbgr.mr_n87265552)
print v(xbgr.mr_n87265984)
print v(xbgr.mr_n87266416)
print v(xbgr.mr_n87266848)
print v(xbgr.mr_n87267280)
print v(xbgr.mr_n87267712)
print v(xbgr.mr_n87268144)
print v(xbgr.mr_n87268576)
print v(xbgr.mr_n87269008)
print v(xbgr.mr_n87269440)
print v(xbgr.mr_n87269872)
print v(xbgr.mr_n87270304)
print v(xbgr.mr_n87270736)
print v(xbgr.mr_n87271168)
print v(xbgr.mr_n87271600)
print v(xbgr.mr_n87272032)
print v(xbgr.mr_n87272464)
print v(xbgr.mr_n87272896)
print v(xbgr.mr_n87273328)
print v(xbgr.mr_n87273760)
print v(xbgr.mr_n87274192)
print v(xbgr.mr_n87274624)
print v(xbgr.mr_n87275056)
print v(xbgr.mr_n87275488)
print v(xbgr.mr_n87275920)
print v(xbgr.mr_n87276352)
print v(xbgr.mr_n87276784)
print v(xbgr.mr_n87277216)
print v(xbgr.mr_n87277648)
print v(xbgr.mr_n87278080)
print v(xbgr.mr_n87278512)
print v(xbgr.mr_n87278944)
print v(xbgr.mr_n87279376)
print v(xbgr.mr_n87279808)
print v(xbgr.mr_n87280240)
print v(xbgr.mr_n87280672)
print v(xbgr.mr_n87281104)
print v(xbgr.mr_n87281536)
print v(xbgr.mr_n87281968)
print v(xbgr.mr_n87282400)
print v(xbgr.mr_n87282832)
print v(xbgr.mr_n87283264)
print v(xbgr.mr_n87283696)
print v(xbgr.mr_n87284128)
print v(xbgr.mr_n87284560)
print v(xbgr.mr_n87284992)
print v(xbgr.mr_n87285424)
print v(xbgr.mr_n87285856)
print v(xbgr.mr_n87286288)
print v(xbgr.mr_n87286720)
print v(xbgr.mr_n87287152)
print v(xbgr.mr_n87287584)
print v(xbgr.mr_n87288016)
print v(xbgr.mr_n87288448)
print v(xbgr.mr_n87288880)
print v(xbgr.mr_n87289312)
print v(xbgr.mr_n87289744)
print v(xbgr.mr_n87290176)
print v(xbgr.mr_n87290608)
print v(xbgr.mr_n87291040)
print v(xbgr.mr_n87291472)
print v(xbgr.mr_n87291904)
print v(xbgr.mr_n87292336)
print v(xbgr.mr_n87292768)
print v(xbgr.mr_n87293200)
print v(xbgr.mr_n87293632)
print v(xbgr.mr_n87294064)
print v(xbgr.mr_n87294496)
print v(xbgr.mr_n87294928)
print v(xbgr.mr_n87295360)
print v(xbgr.mr_n87295792)
print v(xbgr.mr_n87296224)
print v(xbgr.mr_n87296656)
print v(xbgr.mr_n87297088)
print v(xbgr.mr_n87297520)
print v(xbgr.mr_n87297952)
print v(xbgr.mr_n87298384)
print v(xbgr.mr_n87298816)
print v(xbgr.mr_n87299248)
print v(xbgr.mr_n87299680)
print v(xbgr.mr_n87300112)
print v(xbgr.mr_n87300544)
print v(xbgr.mr_n87300864)
print v(xbgr.mr_n87300976)
print v(xbgr.mr_n87301296)
print v(xbgr.mr_n87301408)
print v(xbgr.mr_n87301728)
print v(xbgr.mr_n87301840)
print v(xbgr.mr_n87302160)
print v(xbgr.mr_n87302272)
print v(xbgr.mr_n87302704)
print v(xbgr.mr_n87303136)
print v(xbgr.mr_n87303568)
print v(xbgr.mr_n87304000)
print v(xbgr.mr_n87304432)
print v(xbgr.mr_n87304864)
print v(xbgr.mr_n87305296)
print v(xbgr.mr_n87305728)
print v(xbgr.mr_n87306160)
print v(xbgr.mr_n87306592)
print v(xbgr.mr_n87307024)
print v(xbgr.mr_n87307456)
print v(xbgr.mr_n87307888)
print v(xbgr.mr_n87308320)
print v(xbgr.mr_n87308752)
print v(xbgr.mr_n87309184)
print v(xbgr.mr_n87309616)
print v(xbgr.mr_n87310048)
print v(xbgr.mr_n87310480)
print v(xbgr.mr_n87310912)
print v(xbgr.mr_n87311344)
print v(xbgr.mr_n87311776)
print v(xbgr.mr_n87312208)
print v(xbgr.mr_n87312640)
print v(xbgr.mr_n87313072)
print v(xbgr.mr_n87313504)
print v(xbgr.mr_n87313936)
print v(xbgr.mr_n87314368)
print v(xbgr.mr_n87314800)
print v(xbgr.mr_n87315232)
print v(xbgr.mr_n87315664)
print v(xbgr.mr_n87316096)
print v(xbgr.mr_n87316528)
print v(xbgr.mr_n87316960)
print v(xbgr.mr_n87317392)
print v(xbgr.mr_n87317824)
print v(xbgr.mr_n87318256)
print v(xbgr.mr_n87318688)
print v(xbgr.mr_n87319120)
print v(xbgr.mr_n87319552)
print v(xbgr.mr_n87319984)
print v(xbgr.mr_n87320416)
print v(xbgr.mr_n87320848)
print v(xbgr.mr_n87321280)
print v(xbgr.mr_n87321712)
print v(xbgr.mr_n87322144)
print v(xbgr.mr_n87322576)
print v(xbgr.mr_n87323008)
print v(xbgr.mr_n87323440)
print v(xbgr.mr_n87323872)
print v(xbgr.mr_n87324304)
print v(xbgr.mr_n87324736)
print v(xbgr.mr_n87325168)
print v(xbgr.mr_n87325600)
print v(xbgr.mr_n87326032)
print v(xbgr.mr_n87326464)
print v(xbgr.mr_n87326896)
print v(xbgr.mr_n87327328)
print v(xbgr.mr_n87327760)
print v(xbgr.mr_n87328192)
print v(xbgr.mr_n87328624)
print v(xbgr.mr_n87329056)
print v(xbgr.mr_n87329488)
print v(xbgr.mr_n87329920)
print v(xbgr.mr_n87331216)
print v(xbgr.mr_n87331648)
print v(xbgr.mr_n87332944)
print v(xbgr.mr_n87333376)
print v(xbgr.mr_n87334672)
print v(xbgr.mr_n87335104)
print v(xbgr.mr_n87335536)
print v(xbgr.mr_n87335968)
print v(xbgr.mr_n87336400)
print v(xbgr.mr_n87336832)
print v(xbgr.mr_n87337264)
print v(xbgr.mr_n87337696)
print v(xbgr.mr_n87338128)
print v(xbgr.mr_n87338560)
print v(xbgr.mr_n87338992)
print v(xbgr.mr_n87339424)
print v(xbgr.mr_n87339856)
print v(xbgr.mr_n87340288)
print v(xbgr.mr_n87340720)
print v(xbgr.mr_n87341152)
print v(xbgr.mr_n87342448)
print v(xbgr.mr_n87342880)
print v(xbgr.mr_n87343312)
print v(xbgr.mr_n87343744)
print v(xbgr.mr_n87344176)
print v(xbgr.mr_n87344608)
print v(xbgr.mr_n87345904)
print v(xbgr.mr_n87346336)
print v(xbgr.mr_n87346768)
print v(xbgr.mr_n87347200)
print v(xbgr.mr_n87347632)
print v(xbgr.mr_n87348064)
print v(xbgr.mr_n87348496)
print v(xbgr.mr_n87348928)
print v(xbgr.mr_n87349360)
print v(xbgr.mr_n87349792)
print v(xbgr.mr_n87350224)
print v(xbgr.mr_n87350656)
print v(xbgr.mr_n87351088)
print v(xbgr.mr_n87351520)
print v(xbgr.mr_n87351952)
print v(xbgr.mr_n87352384)
print v(xbgr.mr_n87352816)
print v(xbgr.mr_n87353248)
print v(xbgr.mr_n87353680)
print v(xbgr.mr_n87354112)
print v(xbgr.mr_n87354544)
print v(xbgr.mr_n87354976)
print v(xbgr.mr_n87355408)
print v(xbgr.mr_n87355840)
print v(xbgr.mr_n87356272)
print v(xbgr.mr_n87356704)
print v(xbgr.mr_n87357136)
print v(xbgr.mr_n87357568)
print v(xbgr.mr_n87358000)
print v(xbgr.mr_n87358432)
print v(xbgr.mr_n87358864)
print v(xbgr.mr_n87359296)
print v(xbgr.mr_n87359728)
print v(xbgr.mr_n87360160)
print v(xbgr.mr_n87360592)
print v(xbgr.mr_n87361024)
print v(xbgr.mr_n87361456)
print v(xbgr.mr_n87361888)
print v(xbgr.mr_n87362320)
print v(xbgr.mr_n87362752)
print v(xbgr.mr_n87363184)
print v(xbgr.mr_n87363616)
print v(xbgr.mr_n87364048)
print v(xbgr.mr_n87364480)
print v(xbgr.mr_n87364912)
print v(xbgr.mr_n87365344)
print v(xbgr.mr_n87365776)
print v(xbgr.mr_n87366208)
print v(xbgr.mr_n87366640)
print v(xbgr.mr_n87367072)
print v(xbgr.mr_n87367504)
print v(xbgr.mr_n87367936)
print v(xbgr.mr_n87368368)
print v(xbgr.mr_n87368800)
print v(xbgr.mr_n87369232)
print v(xbgr.mr_n87369664)
print v(xbgr.mr_n87370096)
print v(xbgr.mr_n87370416)
print v(xbgr.mr_n87370528)
print v(xbgr.mr_n87370848)
print v(xbgr.mr_n87370960)
print v(xbgr.mr_n87371280)
print v(xbgr.mr_n87371392)
print v(xbgr.mr_n87371712)
print v(xbgr.mr_n87371824)
print v(xbgr.mr_n87372144)
print v(xbgr.mr_n87372256)
print v(xbgr.mr_n87372576)
print v(xbgr.mr_n87372688)
print v(xbgr.mr_n87373008)
print v(xbgr.mr_n87373120)
print v(xbgr.mr_n87373440)
print v(xbgr.mr_n87373552)
print v(xbgr.mr_n87373872)
print v(xbgr.mr_n87373984)
print v(xbgr.mr_n87374304)
print v(xbgr.mr_n87374416)
print v(xbgr.mr_n87374736)
print v(xbgr.mr_n87374848)
print v(xbgr.mr_n87375168)
print v(xbgr.mr_n87375280)
print v(xbgr.mr_n87375600)
print v(xbgr.mr_n87375712)
print v(xbgr.mr_n87376032)
print v(xbgr.mr_n87376144)
print v(xbgr.mr_n87376464)
print v(xbgr.mr_n87376576)
print v(xbgr.mr_n87376896)
print v(xbgr.mr_n87377008)
print v(xbgr.mr_n87377328)
print v(xbgr.mr_n87377440)
print v(xbgr.mr_n87377760)
print v(xbgr.mr_n87377872)
print v(xbgr.mr_n87378192)
print v(xbgr.mr_n87378304)
print v(xbgr.mr_n87378624)
print v(xbgr.mr_n87378736)
print v(xbgr.mr_n87379056)
print v(xbgr.mr_n87379168)
print v(xbgr.mr_n87379488)
print v(xbgr.mr_n87379600)
print v(xbgr.mr_n87379920)
print v(xbgr.mr_n87380032)
print v(xbgr.mr_n87380352)
print v(xbgr.mr_n87380464)
print v(xbgr.mr_n87380784)
print v(xbgr.mr_n87380896)
print v(xbgr.mr_n87381216)
print v(xbgr.mr_n87381328)
print v(xbgr.mr_n87381648)
print v(xbgr.mr_n87381760)
print v(xbgr.mr_n87382080)
print v(xbgr.mr_n87382192)
print v(xbgr.mr_n87382512)
print v(xbgr.mr_n87382624)
print v(xbgr.mr_n87382944)
print v(xbgr.mr_n87383056)
print v(xbgr.mr_n87383376)
print v(xbgr.mr_n87383488)
print v(xbgr.mr_n87383808)
print v(xbgr.mr_n87383920)
print v(xbgr.mr_n87384240)
print v(xbgr.mr_n87384352)
print v(xbgr.mr_n87384672)
print v(xbgr.mr_n87384784)
print v(xbgr.mr_n87385104)
print v(xbgr.mr_n87385216)
print v(xbgr.mr_n87385536)
print v(xbgr.mr_n87385648)
print v(xbgr.mr_n87385968)
print v(xbgr.mr_n87386080)
print v(xbgr.mr_n87386400)
print v(xbgr.mr_n87386512)
print v(xbgr.mr_n87386928)
print v(xbgr.mr_n87387360)
print v(xbgr.mr_n87387792)
print v(xbgr.mr_n87388224)
print v(xbgr.mr_n87388656)
print v(xbgr.mr_n87389088)
print v(xbgr.mr_n87389520)
print v(xbgr.mr_n87389952)
print v(xbgr.mr_n87390384)
print v(xbgr.mr_n87390816)
print v(xbgr.mr_n87391248)
print v(xbgr.mr_n87391680)
print v(xbgr.mr_n87392000)
print v(xbgr.mr_n87392112)
print v(xbgr.mr_n87392432)
print v(xbgr.mr_n87392544)
print v(xbgr.mr_n87392976)
print v(xbgr.mr_n87393408)
print v(xbgr.mr_n87393840)
print v(xbgr.mr_n87394272)
print v(xbgr.mr_n87394704)
print v(xbgr.mr_n87395136)
print v(xbgr.mr_n87395568)
print v(xbgr.mr_n87396000)
print v(xbgr.mr_n87396432)
print v(xbgr.mr_n87396864)
print v(xbgr.mr_n87397296)
print v(xbgr.mr_n87397728)
print v(xbgr.mr_n87398160)
print v(xbgr.mr_n87398592)
print v(xbgr.mr_n87399024)
print v(xbgr.mr_n87399456)
print v(xbgr.mr_n87399888)
print v(xbgr.mr_n87400320)
print v(xbgr.mr_n87400752)
print v(xbgr.mr_n87401184)
print v(xbgr.mr_n87401616)
print v(xbgr.mr_n87402048)
print v(xbgr.mr_n87402480)
print v(xbgr.mr_n87402912)
print v(xbgr.mr_n87403344)
print v(xbgr.mr_n87403776)
print v(xbgr.mr_n87404208)
print v(xbgr.mr_n87404640)
print v(xbgr.mr_n87405072)
print v(xbgr.mr_n87405504)
print v(xbgr.mr_n87405936)
print v(xbgr.mr_n87406368)
print v(xbgr.mr_n87406800)
print v(xbgr.mr_n87407232)
print v(xbgr.mr_n87407664)
print v(xbgr.mr_n87408096)
print v(xbgr.mr_n87408528)
print v(xbgr.mr_n87408960)
print v(xbgr.mr_n87409392)
print v(xbgr.mr_n87409824)
print v(xbgr.mr_n87410144)
print v(xbgr.mr_n87410256)
print v(xbgr.mr_n87410576)
print v(xbgr.mr_n87410688)
print v(xbgr.mr_n87411120)
print v(xbgr.mr_n87411440)
print v(xbgr.mr_n87411552)
print v(xbgr.mr_n87411984)
print v(xbgr.mr_n87412416)
print v(xbgr.mr_n87412848)
print v(xbgr.mr_n87413280)
print v(xbgr.mr_n87413712)
print v(xbgr.mr_n87414144)
print v(xbgr.mr_n87414576)
print v(xbgr.mr_n87415008)
print v(xbgr.mr_n87415440)
print v(xbgr.mr_n87415872)
print v(xbgr.mr_n87416304)
print v(xbgr.mr_n87416736)
print v(xbgr.mr_n87417168)
print v(xbgr.mr_n87417600)
print v(xbgr.mr_n87418032)
print v(xbgr.mr_n87418464)
print v(xbgr.mr_n87418896)
print v(xbgr.mr_n87419328)
print v(xbgr.mr_n87419760)
print v(xbgr.mr_n87420192)
print v(xbgr.mr_n87420624)
print v(xbgr.mr_n87421056)
print v(xbgr.mr_n87421488)
print v(xbgr.mr_n87421920)
print v(xbgr.mr_n87422352)
print v(xbgr.mr_n87422784)
print v(xbgr.mr_n87423216)
print v(xbgr.mr_n87423648)
print v(xbgr.mr_n87424080)
print v(xbgr.mr_n87424512)
print v(xbgr.mr_n87424944)
print v(xbgr.mr_n87425376)
print v(xbgr.mr_n87425808)
print v(xbgr.mr_n87426240)
print v(xbgr.mr_n87426672)
print v(xbgr.mr_n87427104)
print v(xbgr.mr_n87427536)
print v(xbgr.mr_n87427968)
print v(xbgr.mr_n87428400)
print v(xbgr.mr_n87428832)
print v(xbgr.mr_n87429264)
print v(xbgr.mr_n87429696)
print v(xbgr.mr_n87430128)
print v(xbgr.mr_n87430560)
print v(xbgr.mr_n87430992)
print v(xbgr.mr_n87431424)
print v(xbgr.mr_n87431856)
print v(xbgr.mr_n87432176)
print v(xbgr.mr_n87432288)
print v(xbgr.mr_n87432720)
print v(xbgr.mr_n87433152)
print v(xbgr.mr_n87433472)
print v(xbgr.mr_n87433584)
print v(xbgr.mr_n87433904)
print v(xbgr.mr_n87434016)
print v(xbgr.mr_n87434336)
print v(xbgr.mr_n87434448)
print v(xbgr.mr_n87434768)
print v(xbgr.mr_n87434880)
print v(xbgr.mr_n87435200)
print v(xbgr.mr_n87435312)
print v(xbgr.mr_n87435632)
print v(xbgr.mr_n87435744)
print v(xbgr.mr_n87436176)
print v(xbgr.mr_n87436496)
print v(xbgr.mr_n87436608)
print v(xbgr.mr_n87436928)
print v(xbgr.mr_n87437040)
print v(xbgr.mr_n87437360)
print v(xbgr.mr_n87437472)
print v(xbgr.mr_n87437792)
print v(xbgr.mr_n87437904)
print v(xbgr.mr_n87438224)
print v(xbgr.mr_n87438336)
print v(xbgr.mr_n87438656)
print v(xbgr.mr_n87438768)
print v(xbgr.mr_n87439200)
print v(xbgr.mr_n87439520)
print v(xbgr.mr_n87439632)
print v(xbgr.mr_n87439952)
print v(xbgr.mr_n87440064)
print v(xbgr.mr_n87440384)
print v(xbgr.mr_n87440496)
print v(xbgr.mr_n87440816)
print v(xbgr.mr_n87440928)
print v(xbgr.mr_n87441248)
print v(xbgr.mr_n87441360)
print v(xbgr.mr_n87441680)
print v(xbgr.mr_n87441792)
print v(xbgr.mr_n87442224)
print v(xbgr.mr_n87442544)
print v(xbgr.mr_n87442656)
print v(xbgr.mr_n87442976)
print v(xbgr.mr_n87443088)
print v(xbgr.mr_n87443408)
print v(xbgr.mr_n87443520)
print v(xbgr.mr_n87443952)
print v(xbgr.mr_n87444272)
print v(xbgr.mr_n87444384)
print v(xbgr.mr_n87444816)
print v(xbgr.mr_n87445248)
print v(xbgr.mr_n87445680)
print v(xbgr.mr_n87446112)
print v(xbgr.mr_n87447408)
print v(xbgr.mr_n87447840)
print v(xbgr.mr_n87449136)
print v(xbgr.mr_n87449568)
print v(xbgr.mr_n87449888)
print v(xbgr.mr_n87450000)
print v(xbgr.mr_n87450320)
print v(xbgr.mr_n87450432)
print v(xbgr.mr_n87450752)
print v(xbgr.mr_n87450864)
print v(xbgr.mr_n87451184)
print v(xbgr.mr_n87451728)
print v(xbgr.mr_n87452480)
print v(xbgr.mr_n87452592)
print v(xbgr.mr_n87452912)
print v(xbgr.mr_n87455184)
print v(xbgr.mr_n87456048)
print v(xbgr.mr_n87456912)
print v(xbgr.mr_n87457344)
print v(xbgr.mr_n87457776)
print v(xbgr.mr_n87458208)
print v(xbgr.mr_n87460256)
print v(xbgr.mr_n87460368)
print v(xbgr.mr_n87460800)
print v(xbgr.mr_n87461120)
print v(xbgr.mr_n87461232)
print v(xbgr.mr_n87461552)
print v(xbgr.mr_n87461664)
print v(xbgr.mr_n87462096)
print v(xbgr.mr_n87462416)
print v(xbgr.mr_n87462528)
print v(xbgr.mr_n87462848)
print v(xbgr.mr_n87462960)
print v(xbgr.mr_n87463280)
print v(xbgr.mr_n87463392)
print v(xbgr.mr_n87463824)
print v(xbgr.mr_n87464144)
print v(xbgr.mr_n87464256)
print v(xbgr.mr_n87464576)
print v(xbgr.mr_n87464688)
print v(xbgr.mr_n87465008)
print v(xbgr.mr_n87465120)
print v(xbgr.mr_n87465552)
print v(xbgr.mr_n87465872)
print v(xbgr.mr_n87465984)
print v(xbgr.mr_n87466304)
print v(xbgr.mr_n87466416)
print v(xbgr.mr_n87466736)
print v(xbgr.mr_n87466848)
print v(xbgr.mr_n87467168)
print v(xbgr.mr_n87467280)
print v(xbgr.mr_n87467600)
print v(xbgr.mr_n87467712)
print v(xbgr.mr_n87468144)
print v(xbgr.mr_n87468464)
print v(xbgr.mr_n87468576)
print v(xbgr.mr_n87468896)
print v(xbgr.mr_n87469008)
print v(xbgr.mr_n87469328)
print v(xbgr.mr_n87469440)
print v(xbgr.mr_n87469760)
print v(xbgr.mr_n87469872)
print v(xbgr.mr_n87470304)
print v(xbgr.mr_n87470624)
print v(xbgr.mr_n87470736)
print v(xbgr.mr_n87471056)
print v(xbgr.mr_n87471168)
print v(xbgr.mr_n87471600)
print v(xbgr.mr_n87471920)
print v(xbgr.mr_n87472032)
print v(xbgr.mr_n87472352)
print v(xbgr.mr_n87472464)
print v(xbgr.mr_n87472784)
print v(xbgr.mr_n87472896)
print v(xbgr.mr_n87473328)
print v(xbgr.mr_n87473648)
print v(xbgr.mr_n87473760)
print v(xbgr.mr_n87474080)
print v(xbgr.mr_n87474192)
print v(xbgr.mr_n87474512)
print v(xbgr.mr_n87474624)
print v(xbgr.mr_n87475056)
print v(xbgr.mr_n87475376)
print v(xbgr.mr_n87475488)
print v(xbgr.mr_n87475808)
print v(xbgr.mr_n87475920)
print v(xbgr.mr_n87476240)
print v(xbgr.mr_n87476352)
print v(xbgr.mr_n87476672)
print v(xbgr.mr_n87476784)
print v(xbgr.mr_n87477104)
print v(xbgr.mr_n87477216)
print v(xbgr.mr_n87477536)
print v(xbgr.mr_n87477648)
print v(xbgr.mr_n87477968)
print v(xbgr.mr_n87478080)
print v(xbgr.mr_n87478400)
print v(xbgr.mr_n87478512)
print v(xbgr.mr_n87478832)
print v(xbgr.mr_n87478944)
print v(xbgr.mr_n87479264)
print v(xbgr.mr_n87479376)
print v(xbgr.mr_n87479696)
print v(xbgr.mr_n87479808)
print v(xbgr.mr_n87480128)
print v(xbgr.mr_n87480240)
print v(xbgr.mr_n87480560)
print v(xbgr.mr_n87480672)
print v(xbgr.mr_n87481104)
print v(xbgr.mr_n87481424)
print v(xbgr.mr_n87481536)
print v(xbgr.mr_n87481856)
print v(xbgr.mr_n87481968)
print v(xbgr.mr_n87482288)
print v(xbgr.mr_n87482400)
print v(xbgr.mr_n87482720)
print v(xbgr.mr_n87482832)
print v(xbgr.mr_n87483152)
print v(xbgr.mr_n87483264)
print v(xbgr.mr_n87483584)
print v(xbgr.mr_n87483696)
print v(xbgr.mr_n87484016)
print v(xbgr.mr_n87484128)
print v(xbgr.mr_n87484448)
print v(xbgr.mr_n87484560)
print v(xbgr.mr_n87484880)
print v(xbgr.mr_n87484992)
print v(xbgr.mr_n87485312)
print v(xbgr.mr_n87485424)
print v(xbgr.mr_n87485856)
print v(xbgr.mr_n87486176)
print v(xbgr.mr_n87486288)
print v(xbgr.mr_n87486608)
print v(xbgr.mr_n87486720)
print v(xbgr.mr_n87487040)
print v(xbgr.mr_n87487152)
print v(xbgr.mr_n87487472)
print v(xbgr.mr_n87487584)
print v(xbgr.mr_n87487904)
print v(xbgr.mr_n87488016)
print v(xbgr.mr_n87488336)
print v(xbgr.mr_n87488448)
print v(xbgr.mr_n87488768)
print v(xbgr.mr_n87488880)
print v(xbgr.mr_n87489200)
print v(xbgr.mr_n87489312)
print v(xbgr.mr_n87489632)
print v(xbgr.mr_n87489744)
print v(xbgr.mr_n87490064)
print v(xbgr.mr_n87490176)
print v(xbgr.mr_n87490496)
print v(xbgr.mr_n87490608)
print v(xbgr.mr_n87490928)
print v(xbgr.mr_n87491040)
print v(xbgr.mr_n87491360)
print v(xbgr.mr_n87491472)
print v(xbgr.mr_n87491792)
print v(xbgr.mr_n87491904)
print v(xbgr.mr_n87492224)
print v(xbgr.mr_n87492336)
print v(xbgr.mr_n87492656)
print v(xbgr.mr_n87492768)
print v(xbgr.mr_n87493200)
print v(xbgr.mr_n87493520)
print v(xbgr.mr_n87493632)
print v(xbgr.mr_n87493952)
print v(xbgr.mr_n87494064)
print v(xbgr.mr_n87494384)
print v(xbgr.mr_n87494496)
print v(xbgr.mr_n87494816)
print v(xbgr.mr_n87494928)
print v(xbgr.mr_n87495248)
print v(xbgr.mr_n87495360)
print v(xbgr.mr_n87495680)
print v(xbgr.mr_n87495792)
print v(xbgr.mr_n87496112)
print v(xbgr.mr_n87496224)
print v(xbgr.mr_n87496544)
print v(xbgr.mr_n87496656)
print v(xbgr.mr_n87496976)
print v(xbgr.mr_n87497088)
print v(xbgr.mr_n87497408)
print v(xbgr.mr_n87497520)
print v(xbgr.mr_n87497840)
print v(xbgr.mr_n87497952)
print v(xbgr.mr_n87498272)
print v(xbgr.mr_n87498384)
print v(xbgr.mr_n87498816)
print v(xbgr.mr_n87499136)
print v(xbgr.mr_n87499248)
print v(xbgr.mr_n87499568)
print v(xbgr.mr_n87499680)
print v(xbgr.mr_n87500000)
print v(xbgr.mr_n87500112)
print v(xbgr.mr_n87500432)
print v(xbgr.mr_n87500544)
print v(xbgr.mr_n87500864)
print v(xbgr.mr_n87500976)
print v(xbgr.mr_n87501296)
print v(xbgr.mr_n87501408)
print v(xbgr.mr_n87501728)
print v(xbgr.mr_n87501840)
print v(xbgr.mr_n87502160)
print v(xbgr.mr_n87502272)
print v(xbgr.mr_n87502592)
print v(xbgr.mr_n87502704)
print v(xbgr.mr_n87503024)
print v(xbgr.mr_n87503136)
print v(xbgr.mr_n87503456)
print v(xbgr.mr_n87503568)
print v(xbgr.mr_n87503888)
print v(xbgr.mr_n87504000)
print v(xbgr.mr_n87504320)
print v(xbgr.mr_n87504432)
print v(xbgr.mr_n87504752)
print v(xbgr.mr_n87504864)
print v(xbgr.mr_n87505184)
print v(xbgr.mr_n87505296)
print v(xbgr.mr_n87505616)
print v(xbgr.mr_n87505728)
print v(xbgr.mr_n87506048)
print v(xbgr.mr_n87506160)
print v(xbgr.mr_n87506480)
print v(xbgr.mr_n87506592)
print v(xbgr.mr_n87506912)
print v(xbgr.mr_n87507024)
print v(xbgr.mr_n87507344)
print v(xbgr.mr_n87507456)
print v(xbgr.mr_n87507888)
print v(xbgr.mr_n87508208)
print v(xbgr.mr_n87508320)
print v(xbgr.mr_n87508640)
print v(xbgr.mr_n87508752)
print v(xbgr.mr_n87509072)
print v(xbgr.mr_n87509184)
print v(xbgr.mr_n87509504)
print v(xbgr.mr_n87509616)
print v(xbgr.mr_n87509936)
print v(xbgr.mr_n87510048)
print v(xbgr.mr_n87510368)
print v(xbgr.mr_n87510480)
print v(xbgr.mr_n87510800)
print v(xbgr.mr_n87510912)
print v(xbgr.mr_n87511232)
print v(xbgr.mr_n87511344)
print v(xbgr.mr_n87511664)
print v(xbgr.mr_n87511776)
print v(xbgr.mr_n87512096)
print v(xbgr.mr_n87512208)
print v(xbgr.mr_n87512528)
print v(xbgr.mr_n87512640)
print v(xbgr.mr_n87512960)
print v(xbgr.mr_n87513072)
print v(xbgr.mr_n87513392)
print v(xbgr.mr_n87513504)
print v(xbgr.mr_n87513824)
print v(xbgr.mr_n87513936)
print v(xbgr.mr_n87514256)
print v(xbgr.mr_n87514368)
print v(xbgr.mr_n87514688)
print v(xbgr.mr_n87514800)
print v(xbgr.mr_n87515120)
print v(xbgr.mr_n87515232)
print v(xbgr.mr_n87515552)
print v(xbgr.mr_n87515664)
print v(xbgr.mr_n87515984)
print v(xbgr.mr_n87516096)
print v(xbgr.mr_n87516416)
print v(xbgr.mr_n87516528)
print v(xbgr.mr_n87516848)
print v(xbgr.mr_n87516960)
print v(xbgr.mr_n87517280)
print v(xbgr.mr_n87517392)
print v(xbgr.mr_n87517824)
print v(xbgr.mr_n87518144)
print v(xbgr.mr_n87518256)
print v(xbgr.mr_n87518576)
print v(xbgr.mr_n87518688)
print v(xbgr.mr_n87519008)
print v(xbgr.mr_n87519120)
print v(xbgr.mr_n87519440)
print v(xbgr.mr_n87519552)
print v(xbgr.mr_n87519872)
print v(xbgr.mr_n87519984)
print v(xbgr.mr_n87520304)
print v(xbgr.mr_n87520416)
print v(xbgr.mr_n87520736)
print v(xbgr.mr_n87520848)
print v(xbgr.mr_n87521168)
print v(xbgr.mr_n87521280)
print v(xbgr.mr_n87521600)
print v(xbgr.mr_n87521712)
print v(xbgr.mr_n87522032)
print v(xbgr.mr_n87522144)
print v(xbgr.mr_n87522464)
print v(xbgr.mr_n87522576)
print v(xbgr.mr_n87522896)
print v(xbgr.mr_n87523008)
print v(xbgr.mr_n87523440)
print v(xbgr.mr_n87523872)
print v(xbgr.mr_n87524304)
print v(xbgr.mr_n87524736)
print v(xbgr.mr_n87525168)
print v(xbgr.mr_n87525600)
print v(xbgr.mr_n87526032)
print v(xbgr.mr_n87526464)
print v(xbgr.mr_n87526896)
print v(xbgr.mr_n87527328)
print v(xbgr.mr_n87527760)
print v(xbgr.mr_n87528192)
print v(xbgr.mr_n87528624)
print v(xbgr.mr_n87529056)
print v(xbgr.mr_n87529488)
print v(xbgr.mr_n87529920)
print v(xbgr.mr_n87530352)
print v(xbgr.mr_n87530784)
print v(xbgr.mr_n87531216)
print v(xbgr.mr_n87531648)
print v(xbgr.mr_n87532080)
print v(xbgr.mr_n87532512)
print v(xbgr.mr_n87532944)
print v(xbgr.mr_n87533376)
print v(xbgr.mr_n87533808)
print v(xbgr.mr_n87534240)
print v(xbgr.mr_n87534672)
print v(xbgr.mr_n87535104)
print v(xbgr.mr_n87535536)
print v(xbgr.mr_n87535968)
print v(xbgr.mr_n87536400)
print v(xbgr.mr_n87536832)
print v(xbgr.mr_n87537264)
print v(xbgr.mr_n87537696)
print v(xbgr.mr_n87538128)
print v(xbgr.mr_n87538560)
print v(xbgr.mr_n87538992)
print v(xbgr.mr_n87539424)
print v(xbgr.mr_n87539856)
print v(xbgr.mr_n87540288)
print v(xbgr.mr_n87540720)
print v(xbgr.mr_n87541152)
print v(xbgr.mr_n87541584)
print v(xbgr.mr_n87542016)
print v(xbgr.mr_n87542448)
print v(xbgr.mr_n87542880)
print v(xbgr.mr_n87543312)
print v(xbgr.mr_n87543744)
print v(xbgr.mr_n87544176)
print v(xbgr.mr_n87544608)
print v(xbgr.mr_n87545040)
print v(xbgr.mr_n87545472)
print v(xbgr.mr_n87545904)
print v(xbgr.mr_n87546336)
print v(xbgr.mr_n87546768)
print v(xbgr.mr_n87547200)
print v(xbgr.mr_n87547632)
print v(xbgr.mr_n87548064)
print v(xbgr.mr_n87548496)
print v(xbgr.mr_n87548928)
print v(xbgr.mr_n87549360)
print v(xbgr.mr_n87549792)
print v(xbgr.mr_n87550224)
print v(xbgr.mr_n87550656)
print v(xbgr.mr_n87551088)
print v(xbgr.mr_n87551520)
print v(xbgr.mr_n87551952)
print v(xbgr.mr_n87552384)
print v(xbgr.mr_n87552816)
print v(xbgr.mr_n87553248)
print v(xbgr.mr_n87553680)
print v(xbgr.mr_n87554112)
print v(xbgr.mr_n87554544)
print v(xbgr.mr_n87554976)
print v(xbgr.mr_n87555408)
print v(xbgr.mr_n87555840)
print v(xbgr.mr_n87556272)
print v(xbgr.mr_n87556704)
print v(xbgr.mr_n87557136)
print v(xbgr.mr_n87557568)
print v(xbgr.mr_n87558000)
print v(xbgr.mr_n87558432)
print v(xbgr.mr_n87558864)
print v(xbgr.mr_n87559296)
print v(xbgr.mr_n87559728)
print v(xbgr.mr_n87560160)
print v(xbgr.mr_n87560592)
print v(xbgr.mr_n87561024)
print v(xbgr.mr_n87561456)
print v(xbgr.mr_n87561888)
print v(xbgr.mr_n87562320)
print v(xbgr.mr_n87562752)
print v(xbgr.mr_n87563184)
print v(xbgr.mr_n87563616)
print v(xbgr.mr_n87564048)
print v(xbgr.mr_n87564480)
print v(xbgr.mr_n87564912)
print v(xbgr.mr_n87565344)
print v(xbgr.mr_n87565776)
print v(xbgr.mr_n87566208)
print v(xbgr.mr_n87566640)
print v(xbgr.mr_n87567072)
print v(xbgr.mr_n87567504)
print v(xbgr.mr_n87567936)
print v(xbgr.mr_n87568368)
print v(xbgr.mr_n87568800)
print v(xbgr.mr_n87569232)
print v(xbgr.mr_n87569664)
print v(xbgr.mr_n87570096)
print v(xbgr.mr_n87570528)
print v(xbgr.mr_n87570848)
print v(xbgr.mr_n87570960)
print v(xbgr.mr_n87571280)
print v(xbgr.mr_n87571392)
print v(xbgr.mr_n87571712)
print v(xbgr.mr_n87571824)
print v(xbgr.mr_n87572144)
print v(xbgr.mr_n87572256)
print v(xbgr.mr_n87572576)
print v(xbgr.mr_n87572688)
print v(xbgr.mr_n87573008)
print v(xbgr.mr_n87573120)
print v(xbgr.mr_n87573440)
print v(xbgr.mr_n87573552)
print v(xbgr.mr_n87573872)
print v(xbgr.mr_n87573984)
print v(xbgr.mr_n87574304)
print v(xbgr.mr_n87574416)
print v(xbgr.mr_n87574736)
print v(xbgr.mr_n87574848)
print v(xbgr.mr_n87575168)
print v(xbgr.mr_n87575280)
print v(xbgr.mr_n87575600)
print v(xbgr.mr_n87575712)
print v(xbgr.mr_n87576032)
print v(xbgr.mr_n87576144)
print v(xbgr.mr_n87576464)
print v(xbgr.mr_n87576576)
print v(xbgr.mr_n87576896)
print v(xbgr.mr_n87577008)
print v(xbgr.mr_n87577328)
print v(xbgr.mr_n87577440)
print v(xbgr.mr_n87577760)
print v(xbgr.mr_n87577872)
print v(xbgr.mr_n87578192)
print v(xbgr.mr_n87578304)
print v(xbgr.mr_n87578624)
print v(xbgr.mr_n87578736)
print v(xbgr.mr_n87579056)
print v(xbgr.mr_n87579168)
print v(xbgr.mr_n87579488)
print v(xbgr.mr_n87579600)
print v(xbgr.mr_n87579920)
print v(xbgr.mr_n87580032)
print v(xbgr.mr_n87580352)
print v(xbgr.mr_n87580464)
print v(xbgr.mr_n87580784)
print v(xbgr.mr_n87580896)
print v(xbgr.mr_n87581216)
print v(xbgr.mr_n87581328)
print v(xbgr.mr_n87581648)
print v(xbgr.mr_n87581760)
print v(xbgr.mr_n87582080)
print v(xbgr.mr_n87582192)
print v(xbgr.mr_n87582512)
print v(xbgr.mr_n87582624)
print v(xbgr.mr_n87582944)
print v(xbgr.mr_n87583056)
print v(xbgr.mr_n87583376)
print v(xbgr.mr_n87583488)
print v(xbgr.mr_n87583808)
print v(xbgr.mr_n87583920)
print v(xbgr.mr_n87584240)
print v(xbgr.mr_n87584352)
print v(xbgr.mr_n87584672)
print v(xbgr.mr_n87584784)
print v(xbgr.mr_n87585104)
print v(xbgr.mr_n87585216)
print v(xbgr.mr_n87585536)
print v(xbgr.mr_n87585648)
print v(xbgr.mr_n87585968)
print v(xbgr.mr_n87586080)
print v(xbgr.mr_n87586400)
print v(xbgr.mr_n87586512)
print v(xbgr.mr_n87586832)
print v(xbgr.mr_n87586944)
print v(xbgr.mr_n87587264)
print v(xbgr.mr_n87587376)
print v(xbgr.mr_n87587696)
print v(xbgr.mr_n87587808)
print v(xbgr.mr_n87588128)
print v(xbgr.mr_n87588240)
print v(xbgr.mr_n87588560)
print v(xbgr.mr_n87588672)
print v(xbgr.mr_n87588992)
print v(xbgr.mr_n87589104)
print v(xbgr.mr_n87589424)
print v(xbgr.mr_n87589536)
print v(xbgr.mr_n87589856)
print v(xbgr.mr_n87589968)
print v(xbgr.mr_n87590288)
print v(xbgr.mr_n87590400)
print v(xbgr.mr_n87590720)
print v(xbgr.mr_n87590832)
print v(xbgr.mr_n87591152)
print v(xbgr.mr_n87591264)
print v(xbgr.mr_n87591584)
print v(xbgr.mr_n87591696)
print v(xbgr.mr_n87592016)
print v(xbgr.mr_n87592128)
print v(xbgr.mr_n87592560)
print v(xbgr.mr_n87592880)
print v(xbgr.mr_n87592992)
print v(xbgr.mr_n87593312)
print v(xbgr.mr_n87593424)
print v(xbgr.mr_n87593744)
print v(xbgr.mr_n87593856)
print v(xbgr.mr_n87594176)
print v(xbgr.mr_n87594288)
print v(xbgr.mr_n87594608)
print v(xbgr.mr_n87594720)
print v(xbgr.mr_n87595040)
print v(xbgr.mr_n87595152)
print v(xbgr.mr_n87595472)
print v(xbgr.mr_n87595584)
print v(xbgr.mr_n87595904)
print v(xbgr.mr_n87596016)
print v(xbgr.mr_n87596336)
print v(xbgr.mr_n87596448)
print v(xbgr.mr_n87596768)
print v(xbgr.mr_n87596880)
print v(xbgr.mr_n87597200)
print v(xbgr.mr_n87597312)
print v(xbgr.mr_n87597632)
print v(xbgr.mr_n87597744)
print v(xbgr.mr_n87598064)
print v(xbgr.mr_n87598176)
print v(xbgr.mr_n87598496)
print v(xbgr.mr_n87598608)
print v(xbgr.mr_n87598928)
print v(xbgr.mr_n87599040)
print v(xbgr.mr_n87599360)
print v(xbgr.mr_n87599472)
print v(xbgr.mr_n87599920)
print v(xbgr.mr_n87600032)
print v(xbgr.mr_n87600352)
print v(xbgr.mr_n87600464)
print v(xbgr.mr_n87600784)
print v(xbgr.mr_n87600896)
print v(xbgr.mr_n87601216)
print v(xbgr.mr_n87601328)
print v(xbgr.mr_n87601648)
print v(xbgr.mr_n87601760)
print v(xbgr.mr_n87602080)
print v(xbgr.mr_n87602192)
print v(xbgr.mr_n87602512)
print v(xbgr.mr_n87602624)
print v(xbgr.mr_n87602944)
print v(xbgr.mr_n87603056)
print v(xbgr.mr_n87603376)
print v(xbgr.mr_n87603488)
print v(xbgr.mr_n87603808)
print v(xbgr.mr_n87603920)
print v(xbgr.mr_n87604240)
print v(xbgr.mr_n87604352)
print v(xbgr.mr_n87604672)
print v(xbgr.mr_n87604784)
print v(xbgr.mr_n87605104)
print v(xbgr.mr_n87605216)
print v(xbgr.mr_n87605536)
print v(xbgr.mr_n87605648)
print v(xbgr.mr_n87605968)
print v(xbgr.mr_n87606080)
print v(xbgr.mr_n87606400)
print v(xbgr.mr_n87606512)
print v(xbgr.mr_n87606944)
print v(xbgr.mr_n87607376)
print v(xbgr.mr_n87607696)
print v(xbgr.mr_n87607808)
print v(xbgr.mr_n87608128)
print v(xbgr.mr_n87608240)
print v(xbgr.mr_n87608560)
print v(xbgr.mr_n87608672)
print v(xbgr.mr_n87608992)
print v(xbgr.mr_n87609104)
print v(xbgr.mr_n87609424)
print v(xbgr.mr_n87609536)
print v(xbgr.mr_n87609856)
print v(xbgr.mr_n87609968)
print v(xbgr.mr_n87610400)
print v(xbgr.mr_n87610720)
print v(xbgr.mr_n87610832)
print v(xbgr.mr_n87611152)
print v(xbgr.mr_n87611264)
print v(xbgr.mr_n87611584)
print v(xbgr.mr_n87611696)
print v(xbgr.mr_n87612016)
print v(xbgr.mr_n87612128)
print v(xbgr.mr_n87612448)
print v(xbgr.mr_n87612560)
print v(xbgr.mr_n87612880)
print v(xbgr.mr_n87612992)
print v(xbgr.mr_n87613312)
print v(xbgr.mr_n87613424)
print v(xbgr.mr_n87613744)
print v(xbgr.mr_n87613856)
print v(xbgr.mr_n87614176)
print v(xbgr.mr_n87614288)
print v(xbgr.mr_n87614608)
print v(xbgr.mr_n87614720)
print v(xbgr.mr_n87615040)
print v(xbgr.mr_n87615152)
print v(xbgr.mr_n87615472)
print v(xbgr.mr_n87615584)
print v(xbgr.mr_n87616016)
print v(xbgr.mr_n87616448)
print v(xbgr.mr_n87616880)
print v(xbgr.mr_n87617312)
print v(xbgr.mr_n87617808)
print v(xbgr.mr_n87617920)
print v(xbgr.mr_n87618256)
print v(xbgr.mr_n87618368)
print v(xbgr.mr_n87618688)
print v(xbgr.mr_n87618800)
print v(xbgr.mr_n87619168)
print v(xbgr.mr_n87619280)
print v(xbgr.mr_n87619600)
print v(xbgr.mr_n87619712)
print v(xbgr.mr_n87620032)
print v(xbgr.mr_n87620144)
print v(xbgr.mr_n87620384)
print v(xbgr.mr_n87620496)
print v(xbgr.mr_n87620816)
print v(xbgr.mr_n87620928)
print v(xbgr.mr_n87621248)
print v(xbgr.mr_n87621360)
print v(xbgr.mr_n87621680)
print v(xbgr.mr_n87621792)
print v(xbgr.mr_n87622112)
print v(xbgr.mr_n87622224)
print v(xbgr.mr_n87622544)
print v(xbgr.mr_n87622656)
print v(xbgr.mr_n87622976)
print v(xbgr.mr_n87623088)
print v(xbgr.mr_n87623408)
print v(xbgr.mr_n87623520)
print v(xbgr.mr_n87623840)
print v(xbgr.mr_n87623952)
print v(xbgr.mr_n87624272)
print v(xbgr.mr_n87624384)
print v(xbgr.mr_n87624704)
print v(xbgr.mr_n87624816)
print v(xbgr.mr_n87625136)
print v(xbgr.mr_n87625248)
print v(xbgr.mr_n87625568)
print v(xbgr.mr_n87625680)
print v(xbgr.mr_n87626000)
print v(xbgr.mr_n87626112)
print v(xbgr.mr_n87626432)
print v(xbgr.mr_n87626544)
print v(xbgr.mr_n87626864)
print v(xbgr.mr_n87626976)
print v(xbgr.mr_n87627296)
print v(xbgr.mr_n87627408)
print v(xbgr.mr_n87627728)
print v(xbgr.mr_n87627840)
print v(xbgr.mr_n87628160)
print v(xbgr.mr_n87628272)
print v(xbgr.mr_n87628592)
print v(xbgr.mr_n87628704)
print v(xbgr.mr_n87629024)
print v(xbgr.mr_n87629136)
print v(xbgr.mr_n87629456)
print v(xbgr.mr_n87629568)
print v(xbgr.mr_n87629888)
print v(xbgr.mr_n87630000)
print v(xbgr.mr_n87630320)
print v(xbgr.mr_n87630432)
print v(xbgr.mr_n87630752)
print v(xbgr.mr_n87630864)
print v(xbgr.mr_n87631296)
print v(xbgr.mr_n87631616)
print v(xbgr.mr_n87632608)
print v(xbgr.mr_n87632720)
print v(xbgr.mr_n87633040)
print v(xbgr.mr_n87633152)
print v(xbgr.mr_n87633472)
print v(xbgr.mr_n87633584)
print v(xbgr.mr_n87634016)
print v(xbgr.mr_n87634336)
print v(xbgr.mr_n87634448)
print v(xbgr.mr_n87634768)
print v(xbgr.mr_n87634880)
print v(xbgr.mr_n87635200)
print v(xbgr.mr_n87635312)
print v(xbgr.mr_n87635632)
print v(xbgr.mr_n87635744)
print v(xbgr.mr_n87636064)
print v(xbgr.mr_n87636176)
print v(xbgr.mr_n87636608)
print v(xbgr.mr_n87637040)
print v(xbgr.mr_n87637472)
print v(xbgr.mr_n87637904)
print v(xbgr.mr_n87638224)
print v(xbgr.mr_n87638336)
print v(xbgr.mr_n87638656)
print v(xbgr.mr_n87638768)
print v(xbgr.mr_n87639088)
print v(xbgr.mr_n87639200)
print v(xbgr.mr_n87639632)
print v(xbgr.mr_n87640064)
print v(xbgr.mr_n87640384)
print v(xbgr.mr_n87640496)
print v(xbgr.mr_n87640816)
print v(xbgr.mr_n87640928)
print v(xbgr.mr_n87641248)
print v(xbgr.mr_n87641360)
print v(xbgr.mr_n87641680)
print v(xbgr.mr_n87641792)
print v(xbgr.mr_n87642224)
print v(xbgr.mr_n87642656)
print v(xbgr.mr_n87643088)
print v(xbgr.mr_n87643520)
print v(xbgr.mr_n87643952)
print v(xbgr.mr_n87644272)
print v(xbgr.mr_n87644384)
print v(xbgr.mr_n87644704)
print v(xbgr.mr_n87644816)
print v(xbgr.mr_n87645136)
print v(xbgr.mr_n87645248)
print v(xbgr.mr_n87645568)
print v(xbgr.mr_n87645680)
print v(xbgr.mr_n87646000)
print v(xbgr.mr_n87646112)
print v(xbgr.mr_n87646432)
print v(xbgr.mr_n87646544)
print v(xbgr.mr_n87646864)
print v(xbgr.mr_n87646976)
print v(xbgr.mr_n87647296)
print v(xbgr.mr_n87647408)
print v(xbgr.mr_n87647728)
print v(xbgr.mr_n87647840)
print v(xbgr.mr_n87648160)
print v(xbgr.mr_n87648272)
print v(xbgr.mr_n87648592)
print v(xbgr.mr_n87648704)
print v(xbgr.mr_n87649024)
print v(xbgr.mr_n87649136)
print v(xbgr.mr_n87649568)
print v(xbgr.mr_n87649888)
print v(xbgr.mr_n87650000)
print v(xbgr.mr_n87650320)
print v(xbgr.mr_n87650432)
print v(xbgr.mr_n87650752)
print v(xbgr.mr_n87650864)
print v(xbgr.mr_n87651184)
print v(xbgr.mr_n87651296)
print v(xbgr.mr_n87651616)
print v(xbgr.mr_n87651728)
print v(xbgr.mr_n87652160)
print v(xbgr.mr_n87652592)
print v(xbgr.mr_n87653024)
print v(xbgr.mr_n87653456)
print v(xbgr.mr_n87653776)
print v(xbgr.mr_n87653888)
print v(xbgr.mr_n87654208)
print v(xbgr.mr_n87654320)
print v(xbgr.mr_n87654640)
print v(xbgr.mr_n87654752)
print v(xbgr.mr_n87655072)
print v(xbgr.mr_n87655184)
print v(xbgr.mr_n87655504)
print v(xbgr.mr_n87655616)
print v(xbgr.mr_n87655936)
print v(xbgr.mr_n87656048)
print v(xbgr.mr_n87656368)
print v(xbgr.mr_n87656480)
print v(xbgr.mr_n87656800)
print v(xbgr.mr_n87656912)
print v(xbgr.mr_n87657232)
print v(xbgr.mr_n87657344)
print v(xbgr.mr_n87657664)
print v(xbgr.mr_n87657776)
print v(xbgr.mr_n87658096)
print v(xbgr.mr_n87658208)
print v(xbgr.mr_n87658528)
print v(xbgr.mr_n87658640)
print v(xbgr.mr_n87658960)
print v(xbgr.mr_n87659072)
print v(xbgr.mr_n87659392)
print v(xbgr.mr_n87659504)
print v(xbgr.mr_n87659824)
print v(xbgr.mr_n87659936)
print v(xbgr.mr_n87660256)
print v(xbgr.mr_n87660368)
print v(xbgr.mr_n87660688)
print v(xbgr.mr_n87660800)
print v(xbgr.mr_n87661120)
print v(xbgr.mr_n87661232)
print v(xbgr.mr_n87661552)
print v(xbgr.mr_n87661664)
print v(xbgr.mr_n87661984)
print v(xbgr.mr_n87662096)
print v(xbgr.mr_n87662416)
print v(xbgr.mr_n87662528)
print v(xbgr.mr_n87662848)
print v(xbgr.mr_n87662960)
print v(xbgr.mr_n87663280)
print v(xbgr.mr_n87663392)
print v(xbgr.mr_n87663712)
print v(xbgr.mr_n87663824)
print v(xbgr.mr_n87664144)
print v(xbgr.mr_n87664256)
print v(xbgr.mr_n87664576)
print v(xbgr.mr_n87664688)
print v(xbgr.mr_n87665008)
print v(xbgr.mr_n87665120)
print v(xbgr.mr_n87665440)
print v(xbgr.mr_n87665552)
print v(xbgr.mr_n87665872)
print v(xbgr.mr_n87665984)
print v(xbgr.mr_n87666304)
print v(xbgr.mr_n87666416)
print v(xbgr.mr_n87666736)
print v(xbgr.mr_n87666848)
print v(xbgr.mr_n87667168)
print v(xbgr.mr_n87667280)
print v(xbgr.mr_n87667600)
print v(xbgr.mr_n87667712)
print v(xbgr.mr_n87668032)
print v(xbgr.mr_n87668144)
print v(xbgr.mr_n87668464)
print v(xbgr.mr_n87668576)
print v(xbgr.mr_n87668896)
print v(xbgr.mr_n87669008)
print v(xbgr.mr_n87669328)
print v(xbgr.mr_n87669440)
print v(xbgr.mr_n87669760)
print v(xbgr.mr_n87669872)
print v(xbgr.mr_n87670192)
print v(xbgr.mr_n87670304)
print v(xbgr.mr_n87670624)
print v(xbgr.mr_n87670736)
print v(xbgr.mr_n87671056)
print v(xbgr.mr_n87671168)
print v(xbgr.mr_n87671488)
print v(xbgr.mr_n87671600)
print v(xbgr.mr_n87671920)
print v(xbgr.mr_n87672032)
print v(xbgr.mr_n87672352)
print v(xbgr.mr_n87672464)
print v(xbgr.mr_n87672896)
print v(xbgr.mr_n87673328)
print v(xbgr.mr_n87673648)
print v(xbgr.mr_n87673760)
print v(xbgr.mr_n87674080)
print v(xbgr.mr_n87674192)
print v(xbgr.mr_n87674512)
print v(xbgr.mr_n87674624)
print v(xbgr.mr_n87674944)
print v(xbgr.mr_n87675056)
print v(xbgr.mr_n87675488)
print v(xbgr.mr_n87675920)
print v(xbgr.mr_n87676240)
print v(xbgr.mr_n87676352)
print v(xbgr.mr_n87676672)
print v(xbgr.mr_n87676784)
print v(xbgr.mr_n87677104)
print v(xbgr.mr_n87677216)
print v(xbgr.mr_n87677536)
print v(xbgr.mr_n87677648)
print v(xbgr.mr_n87678080)
print v(xbgr.mr_n87678512)
print v(xbgr.mr_n87678944)
print v(xbgr.mr_n87679376)
print v(xbgr.mr_n87679808)
print v(xbgr.mr_n87680240)
print v(xbgr.mr_n87680672)
print v(xbgr.mr_n87681104)
print v(xbgr.mr_n87681536)
print v(xbgr.mr_n87681968)
print v(xbgr.mr_n87682400)
print v(xbgr.mr_n87682832)
print v(xbgr.mr_n87683152)
print v(xbgr.mr_n87683584)
print v(xbgr.mr_n87684016)
print v(xbgr.mr_n87684448)
print v(xbgr.mr_n87684880)
print v(xbgr.mr_n87685312)
print v(xbgr.mr_n87685744)
print v(xbgr.mr_n87686176)
print v(xbgr.mr_n87686608)
print v(xbgr.mr_n87686720)
print v(xbgr.mr_n87687040)
print v(xbgr.mr_n87687152)
print v(xbgr.mr_n87687472)
print v(xbgr.mr_n87687584)
print v(xbgr.mr_n87687904)
print v(xbgr.mr_n87688016)
print v(xbgr.mr_n87688336)
print v(xbgr.mr_n87688448)
print v(xbgr.mr_n87688768)
print v(xbgr.mr_n87688880)
print v(xbgr.mr_n87689200)
print v(xbgr.mr_n87689312)
print v(xbgr.mr_n87689632)
print v(xbgr.mr_n87689744)
print v(xbgr.mr_n87690064)
print v(xbgr.mr_n87690496)
print v(xbgr.mr_n87690928)
print v(xbgr.mr_n87691360)
print v(xbgr.mr_n87691792)
print v(xbgr.mr_n87692224)
print v(xbgr.mr_n87692656)
print v(xbgr.mr_n87693088)
print v(xbgr.mr_n87693520)
print v(xbgr.mr_n87693952)
print v(xbgr.mr_n87694496)
print v(xbgr.mr_n87694928)
print v(xbgr.mr_n87695360)
print v(xbgr.mr_n87695792)
print v(xbgr.mr_n87696224)
print v(xbgr.mr_n87696656)
print v(xbgr.mr_n87697088)
print v(xbgr.mr_n87697520)
print v(xbgr.mr_n87697952)
print v(xbgr.mr_n87698384)
print v(xbgr.mr_n87698816)
print v(xbgr.mr_n87699248)
print v(xbgr.mr_n87699680)
print v(xbgr.mr_n87700112)
print v(xbgr.mr_n87700544)
print v(xbgr.mr_n87700976)
print v(xbgr.mr_n87701408)
print v(xbgr.mr_n87701840)
print v(xbgr.mr_n87702272)
print v(xbgr.mr_n87702704)
print v(xbgr.mr_n87703136)
print v(xbgr.mr_n87703568)
print v(xbgr.mr_n87704000)
print v(xbgr.mr_n87704432)
print v(xbgr.mr_n87704864)
print v(xbgr.mr_n87705296)
print v(xbgr.mr_n87705728)
print v(xbgr.mr_n87706160)
print v(xbgr.mr_n87706592)
print v(xbgr.mr_n87707024)
print v(xbgr.mr_n87707456)
print v(xbgr.mr_n87707888)
print v(xbgr.mr_n87708320)
print v(xbgr.mr_n87708752)
print v(xbgr.mr_n87709184)
print v(xbgr.mr_n87709616)
print v(xbgr.mr_n87710048)
print v(xbgr.mr_n87710480)
print v(xbgr.mr_n87710912)
print v(xbgr.mr_n87711344)
print v(xbgr.mr_n87711776)
print v(xbgr.mr_n87712208)
print v(xbgr.mr_n87712640)
print v(xbgr.mr_n87713072)
print v(xbgr.mr_n87713504)
print v(xbgr.mr_n87713936)
print v(xbgr.mr_n87714368)
print v(xbgr.mr_n87714800)
print v(xbgr.mr_n87715232)
print v(xbgr.mr_n87715664)
print v(xbgr.mr_n87716096)
print v(xbgr.mr_n87716528)
print v(xbgr.mr_n87716960)
print v(xbgr.mr_n87717392)
print v(xbgr.mr_n87717824)
print v(xbgr.mr_n87718256)
print v(xbgr.mr_n87718688)
print v(xbgr.mr_n87719120)
print v(xbgr.mr_n87719552)
print v(xbgr.mr_n87719984)
print v(xbgr.mr_n87720416)
print v(xbgr.mr_n87720848)
print v(xbgr.mr_n87721280)
print v(xbgr.mr_n87721712)
print v(xbgr.mr_n87722032)
print v(xbgr.mr_n87722464)
print v(xbgr.mr_n87722896)
print v(xbgr.mr_n87723328)
print v(xbgr.mr_n87723760)
print v(xbgr.mr_n87724192)
print v(xbgr.mr_n87724736)
print v(xbgr.mr_n87725168)
print v(xbgr.mr_n87725600)
print v(xbgr.mr_n87726032)
print v(xbgr.mr_n87726464)
print v(xbgr.mr_n87726896)
print v(xbgr.mr_n87727328)
print v(xbgr.mr_n87727760)
print v(xbgr.mr_n87728192)
print v(xbgr.mr_n87728624)
print v(xbgr.mr_n87729056)
print v(xbgr.mr_n87729488)
print v(xbgr.mr_n87729920)
print v(xbgr.mr_n87730352)
print v(xbgr.mr_n87730784)
print v(xbgr.mr_n87731216)
print v(xbgr.mr_n87731648)
print v(xbgr.mr_n87732080)
print v(xbgr.mr_n87732512)
print v(xbgr.mr_n87732944)
print v(xbgr.mr_n87733376)
print v(xbgr.mr_n87733808)
print v(xbgr.mr_n87734240)
print v(xbgr.mr_n87734672)
print v(xbgr.mr_n87735104)
print v(xbgr.mr_n87735536)
print v(xbgr.mr_n87735856)
print v(xbgr.mr_n87735968)
print v(xbgr.mr_n87736288)
print v(xbgr.mr_n87736400)
print v(xbgr.mr_n87736720)
print v(xbgr.mr_n87736832)
print v(xbgr.mr_n87737152)
print v(xbgr.mr_n87737264)
print v(xbgr.mr_n87737584)
print v(xbgr.mr_n87737696)
print v(xbgr.mr_n87738016)
print v(xbgr.mr_n87738128)
print v(xbgr.mr_n87738448)
print v(xbgr.mr_n87738560)
print v(xbgr.mr_n87738880)
print v(xbgr.mr_n87738992)
print v(xbgr.mr_n87739312)
print v(xbgr.mr_n87739424)
print v(xbgr.mr_n87739744)
print v(xbgr.mr_n87739856)
print v(xbgr.mr_n87740176)
print v(xbgr.mr_n87740288)
print v(xbgr.mr_n87740608)
print v(xbgr.mr_n87740720)
print v(xbgr.mr_n87741040)
print v(xbgr.mr_n87741152)
print v(xbgr.mr_n87741472)
print v(xbgr.mr_n87741584)
print v(xbgr.mr_n87741904)
print v(xbgr.mr_n87742016)
print v(xbgr.mr_n87742336)
print v(xbgr.mr_n87742768)
print v(xbgr.mr_n87742880)
print v(xbgr.mr_n87743200)
print v(xbgr.mr_n87743632)
print v(xbgr.mr_n87743744)
print v(xbgr.mr_n87744064)
print v(xbgr.mr_n87744176)
print v(xbgr.mr_n87744496)
print v(xbgr.mr_n87744608)
print v(xbgr.mr_n87744928)
print v(xbgr.mr_n87745040)
print v(xbgr.mr_n87745360)
print v(xbgr.mr_n87745472)
print v(xbgr.mr_n87745792)
print v(xbgr.mr_n87745904)
print v(xbgr.mr_n87746224)
print v(xbgr.mr_n87746336)
print v(xbgr.mr_n87746656)
print v(xbgr.mr_n87747088)
print v(xbgr.mr_n87747200)
print v(xbgr.mr_n87747520)
print v(xbgr.mr_n87747632)
print v(xbgr.mr_n87747952)
print v(xbgr.mr_n87748064)
print v(xbgr.mr_n87748384)
print v(xbgr.mr_n87748496)
print v(xbgr.mr_n87748816)
print v(xbgr.mr_n87748928)
print v(xbgr.mr_n87749248)
print v(xbgr.mr_n87749360)
print v(xbgr.mr_n87749680)
print v(xbgr.mr_n87749792)
print v(xbgr.mr_n87750112)
print v(xbgr.mr_n87750224)
print v(xbgr.mr_n87750544)
print v(xbgr.mr_n87750656)
print v(xbgr.mr_n87750976)
print v(xbgr.mr_n87751088)
print v(xbgr.mr_n87751408)
print v(xbgr.mr_n87751520)
print v(xbgr.mr_n87751840)
print v(xbgr.mr_n87752272)
print v(xbgr.mr_n87752384)
print v(xbgr.mr_n87752704)
print v(xbgr.mr_n87752816)
print v(xbgr.mr_n87753136)
print v(xbgr.mr_n87753248)
print v(xbgr.mr_n87753568)
print v(xbgr.mr_n87753680)
print v(xbgr.mr_n87754000)
print v(xbgr.mr_n87754112)
print v(xbgr.mr_n87754432)
print v(xbgr.mr_n87754544)
print v(xbgr.mr_n87754864)
print v(xbgr.mr_n87754976)
print v(xbgr.mr_n87755296)
print v(xbgr.mr_n87755408)
print v(xbgr.mr_n87755728)
print v(xbgr.mr_n87755840)
print v(xbgr.mr_n87756160)
print v(xbgr.mr_n87756272)
print v(xbgr.mr_n87756592)
print v(xbgr.mr_n87756704)
print v(xbgr.mr_n87757024)
print v(xbgr.mr_n87757136)
print v(xbgr.mr_n87757456)
print v(xbgr.mr_n87757568)
print v(xbgr.mr_n87757888)
print v(xbgr.mr_n87758320)
print v(xbgr.mr_n87758432)
print v(xbgr.mr_n87758752)
print v(xbgr.mr_n87758864)
print v(xbgr.mr_n87759184)
print v(xbgr.mr_n87759296)
print v(xbgr.mr_n87759616)
print v(xbgr.mr_n87759728)
print v(xbgr.mr_n87760048)
print v(xbgr.mr_n87760160)
print v(xbgr.mr_n87760480)
print v(xbgr.mr_n87760592)
print v(xbgr.mr_n87760912)
print v(xbgr.mr_n87761024)
print v(xbgr.mr_n87761344)
print v(xbgr.mr_n87761776)
print v(xbgr.mr_n87761888)
print v(xbgr.mr_n87762208)
print v(xbgr.mr_n87762640)
print v(xbgr.mr_n87762752)
print v(xbgr.mr_n87763072)
print v(xbgr.mr_n87763184)
print v(xbgr.mr_n87763504)
print v(xbgr.mr_n87763616)
print v(xbgr.mr_n87763936)
print v(xbgr.mr_n87764048)
print v(xbgr.mr_n87764368)
print v(xbgr.mr_n87764480)
print v(xbgr.mr_n87764800)
print v(xbgr.mr_n87764912)
print v(xbgr.mr_n87765232)
print v(xbgr.mr_n87765344)
print v(xbgr.mr_n87765664)
print v(xbgr.mr_n87765776)
print v(xbgr.mr_n87766096)
print v(xbgr.mr_n87766208)
print v(xbgr.mr_n87766528)
print v(xbgr.mr_n87766640)
print v(xbgr.mr_n87766960)
print v(xbgr.mr_n87767072)
print v(xbgr.mr_n87767392)
print v(xbgr.mr_n87767504)
print v(xbgr.mr_n87767936)
print v(xbgr.mr_n87768368)
print v(xbgr.mr_n87768800)
print v(xbgr.mr_n87769232)
print v(xbgr.mr_n87769664)
print v(xbgr.mr_n87770096)
print v(xbgr.mr_n87770528)
print v(xbgr.mr_n87770960)
print v(xbgr.mr_n87771392)
print v(xbgr.mr_n87771824)
print v(xbgr.mr_n87772256)
print v(xbgr.mr_n87772688)
print v(xbgr.mr_n87773120)
print v(xbgr.mr_n87773552)
print v(xbgr.mr_n87773984)
print v(xbgr.mr_n87774416)
print v(xbgr.mr_n87774848)
print v(xbgr.mr_n87775280)
print v(xbgr.mr_n87775712)
print v(xbgr.mr_n87776144)
print v(xbgr.mr_n87776576)
print v(xbgr.mr_n87777008)
print v(xbgr.mr_n87777440)
print v(xbgr.mr_n87777872)
print v(xbgr.mr_n87778304)
print v(xbgr.mr_n87778736)
print v(xbgr.mr_n87779168)
print v(xbgr.mr_n87779600)
print v(xbgr.mr_n87780032)
print v(xbgr.mr_n87780464)
print v(xbgr.mr_n87780896)
print v(xbgr.mr_n87781328)
print v(xbgr.mr_n87781760)
print v(xbgr.mr_n87782192)
print v(xbgr.mr_n87782624)
print v(xbgr.mr_n87783056)
print v(xbgr.mr_n87783488)
print v(xbgr.mr_n87783920)
print v(xbgr.mr_n87784352)
print v(xbgr.mr_n87784784)
print v(xbgr.mr_n87785216)
print v(xbgr.mr_n87785648)
print v(xbgr.mr_n87786080)
print v(xbgr.mr_n87786512)
print v(xbgr.mr_n87786944)
print v(xbgr.mr_n87787376)
print v(xbgr.mr_n87787808)
print v(xbgr.mr_n87788240)
print v(xbgr.mr_n87788672)
print v(xbgr.mr_n87789104)
print v(xbgr.mr_n87789536)
print v(xbgr.mr_n87789968)
print v(xbgr.mr_n87790400)
print v(xbgr.mr_n87790832)
print v(xbgr.mr_n87791264)
print v(xbgr.mr_n87791696)
print v(xbgr.mr_n87792128)
print v(xbgr.mr_n87792560)
print v(xbgr.mr_n87792992)
print v(xbgr.mr_n87793424)
print v(xbgr.mr_n87793856)
print v(xbgr.mr_n87794288)
print v(xbgr.mr_n87794720)
print v(xbgr.mr_n87795152)
print v(xbgr.mr_n87795584)
print v(xbgr.mr_n87796016)
print v(xbgr.mr_n87796448)
print v(xbgr.mr_n87796880)
print v(xbgr.mr_n87797312)
print v(xbgr.mr_n87797744)
print v(xbgr.mr_n87798176)
print v(xbgr.mr_n87798608)
print v(xbgr.mr_n87799040)
print v(xbgr.mr_n87799472)
print v(xbgr.mr_n87799904)
print v(xbgr.mr_n87800336)
print v(xbgr.mr_n87800768)
print v(xbgr.mr_n87801200)
print v(xbgr.mr_n87801520)
print v(xbgr.mr_n87801632)
print v(xbgr.mr_n87801952)
print v(xbgr.mr_n87802064)
print v(xbgr.mr_n87802496)
print v(xbgr.mr_n87802928)
print v(xbgr.mr_n87803248)
print v(xbgr.mr_n87803360)
print v(xbgr.mr_n87803680)
print v(xbgr.mr_n87804224)
print v(xbgr.mr_n87804656)
print v(xbgr.mr_n87804976)
print v(xbgr.mr_n87805088)
print v(xbgr.mr_n87805408)
print v(xbgr.mr_n87805520)
print v(xbgr.mr_n87805840)
print v(xbgr.mr_n87805952)
print v(xbgr.mr_n87806272)
print v(xbgr.mr_n87806384)
print v(xbgr.mr_n87806704)
print v(xbgr.mr_n87806816)
print v(xbgr.mr_n87807136)
print v(xbgr.mr_n87807248)
print v(xbgr.mr_n87807568)
print v(xbgr.mr_n87807680)
print v(xbgr.mr_n87808000)
print v(xbgr.mr_n87808112)
print v(xbgr.mr_n87808432)
print v(xbgr.mr_n87808544)
print v(xbgr.mr_n87808864)
print v(xbgr.mr_n87808976)
print v(xbgr.mr_n87809296)
print v(xbgr.mr_n87809408)
print v(xbgr.mr_n87809728)
print v(xbgr.mr_n87809840)
print v(xbgr.mr_n87810272)
print v(xbgr.mr_n87810704)
print v(xbgr.mr_n87811024)
print v(xbgr.mr_n87811136)
print v(xbgr.mr_n87811456)
print v(xbgr.mr_n87811568)
print v(xbgr.mr_n87812000)
print v(xbgr.mr_n87812432)
print v(xbgr.mr_n87812864)
print v(xbgr.mr_n87813296)
print v(xbgr.mr_n87813728)
print v(xbgr.mr_n87814160)
print v(xbgr.mr_n87814592)
print v(xbgr.mr_n87815024)
print v(xbgr.mr_n87815456)
print v(xbgr.mr_n87815888)
print v(xbgr.mr_n87816320)
print v(xbgr.mr_n87816752)
print v(xbgr.mr_n87817184)
print v(xbgr.mr_n87817616)
print v(xbgr.mr_n87818048)
print v(xbgr.mr_n87818480)
print v(xbgr.mr_n87818912)
print v(xbgr.mr_n87819344)
print v(xbgr.mr_n87819776)
print v(xbgr.mr_n87820208)
print v(xbgr.mr_n87820640)
print v(xbgr.mr_n87821072)
print v(xbgr.mr_n87821504)
print v(xbgr.mr_n87821936)
print v(xbgr.mr_n87822368)
print v(xbgr.mr_n87822800)
print v(xbgr.mr_n87823232)
print v(xbgr.mr_n87823664)
print v(xbgr.mr_n87824096)
print v(xbgr.mr_n87824528)
print v(xbgr.mr_n87824960)
print v(xbgr.mr_n87825392)
print v(xbgr.mr_n87825824)
print v(xbgr.mr_n87826256)
print v(xbgr.mr_n87826688)
print v(xbgr.mr_n87827120)
print v(xbgr.mr_n87827552)
print v(xbgr.mr_n87827984)
print v(xbgr.mr_n87828416)
print v(xbgr.mr_n87828848)
print v(xbgr.mr_n87829280)
print v(xbgr.mr_n87829712)
print v(xbgr.mr_n87830144)
print v(xbgr.mr_n87830576)
print v(xbgr.mr_n87831008)
print v(xbgr.mr_n87831440)
print v(xbgr.mr_n87831872)
print v(xbgr.mr_n87832304)
print v(xbgr.mr_n87832736)
print v(xbgr.mr_n87833168)
print v(xbgr.mr_n87833600)
print v(xbgr.mr_n87834032)
print v(xbgr.mr_n87834464)
print v(xbgr.mr_n87834896)
print v(xbgr.mr_n87835328)
print v(xbgr.mr_n87835760)
print v(xbgr.mr_n87836192)
print v(xbgr.mr_n87836624)
print v(xbgr.mr_n87837056)
print v(xbgr.mr_n87837488)
print v(xbgr.mr_n87837920)
print v(xbgr.mr_n87838352)
print v(xbgr.mr_n87838784)
print v(xbgr.mr_n87839216)
print v(xbgr.mr_n87839648)
print v(xbgr.mr_n87840080)
print v(xbgr.mr_n87840512)
print v(xbgr.mr_n87840944)
print v(xbgr.mr_n87841376)
print v(xbgr.mr_n87841808)
print v(xbgr.mr_n87842240)
print v(xbgr.mr_n87842672)
print v(xbgr.mr_n87843104)
print v(xbgr.mr_n87843536)
print v(xbgr.mr_n87843968)
print v(xbgr.mr_n87844400)
print v(xbgr.mr_n87844832)
print v(xbgr.mr_n87845264)
print v(xbgr.mr_n87845696)
print v(xbgr.mr_n87846128)
print v(xbgr.mr_n87846560)
print v(xbgr.mr_n87846992)
print v(xbgr.mr_n87847424)
print v(xbgr.mr_n87847856)
print v(xbgr.mr_n87848288)
print v(xbgr.mr_n87848720)
print v(xbgr.mr_n87849152)
print v(xbgr.mr_n87849584)
print v(xbgr.mr_n87850016)
print v(xbgr.mr_n87850448)
print v(xbgr.mr_n87850880)
print v(xbgr.mr_n87851312)
print v(xbgr.mr_n87851744)
print v(xbgr.mr_n87852176)
print v(xbgr.mr_n87852608)
print v(xbgr.mr_n87853040)
print v(xbgr.mr_n87853472)
print v(xbgr.mr_n87853904)
print v(xbgr.mr_n87854336)
print v(xbgr.mr_n87854768)
print v(xbgr.mr_n87855200)
print v(xbgr.mr_n87855632)
print v(xbgr.mr_n87856064)
print v(xbgr.mr_n87856496)
print v(xbgr.mr_n87856928)
print v(xbgr.mr_n87857360)
print v(xbgr.mr_n87857792)
print v(xbgr.mr_n87858224)
print v(xbgr.mr_n87858656)
print v(xbgr.mr_n87859088)
print v(xbgr.mr_n87859520)
print v(xbgr.mr_n87859952)
print v(xbgr.mr_n87860384)
print v(xbgr.mr_n87860816)
print v(xbgr.mr_n87861248)
print v(xbgr.mr_n87861680)
print v(xbgr.mr_n87862112)
print v(xbgr.mr_n87862544)
print v(xbgr.mr_n87862976)
print v(xbgr.mr_n87863408)
print v(xbgr.mr_n87863840)
print v(xbgr.mr_n87864272)
print v(xbgr.mr_n87864704)
print v(xbgr.mr_n87865136)
print v(xbgr.mr_n87865568)
print v(xbgr.mr_n87866000)
print v(xbgr.mr_n87866432)
print v(xbgr.mr_n87866864)
print v(xbgr.mr_n87867296)
print v(xbgr.mr_n87867728)
print v(xbgr.mr_n87868160)
print v(xbgr.mr_n87868592)
print v(xbgr.mr_n87869024)
print v(xbgr.mr_n87869456)
print v(xbgr.mr_n87869888)
print v(xbgr.mr_n87870320)
print v(xbgr.mr_n87870640)
print v(xbgr.mr_n87870752)
print v(xbgr.mr_n87871072)
print v(xbgr.mr_n87871184)
print v(xbgr.mr_n87871504)
print v(xbgr.mr_n87871616)
print v(xbgr.mr_n87871936)
print v(xbgr.mr_n87872048)
print v(xbgr.mr_n87872368)
print v(xbgr.mr_n87872480)
print v(xbgr.mr_n87872800)
print v(xbgr.mr_n87872912)
print v(xbgr.mr_n87873232)
print v(xbgr.mr_n87873344)
print v(xbgr.mr_n87873664)
print v(xbgr.mr_n87873776)
print v(xbgr.mr_n87874096)
print v(xbgr.mr_n87874208)
print v(xbgr.mr_n87874528)
print v(xbgr.mr_n87874640)
print v(xbgr.mr_n87874960)
print v(xbgr.mr_n87875072)
print v(xbgr.mr_n87875392)
print v(xbgr.mr_n87875504)
print v(xbgr.mr_n87875824)
print v(xbgr.mr_n87875936)
print v(xbgr.mr_n87876256)
print v(xbgr.mr_n87876368)
print v(xbgr.mr_n87876688)
print v(xbgr.mr_n87876800)
print v(xbgr.mr_n87877120)
print v(xbgr.mr_n87877232)
print v(xbgr.mr_n87877552)
print v(xbgr.mr_n87877664)
print v(xbgr.mr_n87877984)
print v(xbgr.mr_n87878096)
print v(xbgr.mr_n87878416)
print v(xbgr.mr_n87878528)
print v(xbgr.mr_n87878848)
print v(xbgr.mr_n87878960)
print v(xbgr.mr_n87879280)
print v(xbgr.mr_n87879392)
print v(xbgr.mr_n87879712)
print v(xbgr.mr_n87879824)
print v(xbgr.mr_n87880144)
print v(xbgr.mr_n87880256)
print v(xbgr.mr_n87880576)
print v(xbgr.mr_n87880688)
print v(xbgr.mr_n87881008)
print v(xbgr.mr_n87881120)
print v(xbgr.mr_n87881440)
print v(xbgr.mr_n87881552)
print v(xbgr.mr_n87881872)
print v(xbgr.mr_n87881984)
print v(xbgr.mr_n87882304)
print v(xbgr.mr_n87882416)
print v(xbgr.mr_n87882736)
print v(xbgr.mr_n87882848)
print v(xbgr.mr_n87883168)
print v(xbgr.mr_n87883280)
print v(xbgr.mr_n87883712)
print v(xbgr.mr_n87884144)
print v(xbgr.mr_n87884576)
print v(xbgr.mr_n87885008)
print v(xbgr.mr_n87885328)
print v(xbgr.mr_n87885440)
print v(xbgr.mr_n87885760)
print v(xbgr.mr_n87885872)
print v(xbgr.mr_n87886192)
print v(xbgr.mr_n87886304)
print v(xbgr.mr_n87886624)
print v(xbgr.mr_n87886736)
print v(xbgr.mr_n87887056)
print v(xbgr.mr_n87887168)
print v(xbgr.mr_n87887488)
print v(xbgr.mr_n87887600)
print v(xbgr.mr_n87888032)
print v(xbgr.mr_n87888464)
print v(xbgr.mr_n87888896)
print v(xbgr.mr_n87889216)
print v(xbgr.mr_n87889328)
print v(xbgr.mr_n87889648)
print v(xbgr.mr_n87889760)
print v(xbgr.mr_n87890080)
print v(xbgr.mr_n87890192)
print v(xbgr.mr_n87890512)
print v(xbgr.mr_n87890624)
print v(xbgr.mr_n87890944)
print v(xbgr.mr_n87891056)
print v(xbgr.mr_n87891376)
print v(xbgr.mr_n87891488)
print v(xbgr.mr_n87891808)
print v(xbgr.mr_n87891920)
print v(xbgr.mr_n87892240)
print v(xbgr.mr_n87892352)
print v(xbgr.mr_n87892672)
print v(xbgr.mr_n87892784)
print v(xbgr.mr_n87893104)
print v(xbgr.mr_n87893216)
print v(xbgr.mr_n87893648)
print v(xbgr.mr_n87894080)
print v(xbgr.mr_n87894512)
print v(xbgr.mr_n87894944)
print v(xbgr.mr_n87895376)
print v(xbgr.mr_n87895808)
print v(xbgr.mr_n87896240)
print v(xbgr.mr_n87896672)
print v(xbgr.mr_n87897104)
print v(xbgr.mr_n87897536)
print v(xbgr.mr_n87897968)
print v(xbgr.mr_n87898400)
print v(xbgr.mr_n87898832)
print v(xbgr.mr_n87899152)
print v(xbgr.mr_n87899264)
print v(xbgr.mr_n87899584)
print v(xbgr.mr_n87899696)
print v(xbgr.mr_n87900016)
print v(xbgr.mr_n87900128)
print v(xbgr.mr_n87900448)
print v(xbgr.mr_n87900560)
print v(xbgr.mr_n87900880)
print v(xbgr.mr_n87900992)
print v(xbgr.mr_n87901424)
print v(xbgr.mr_n87901856)
print v(xbgr.mr_n87902288)
print v(xbgr.mr_n87902720)
print v(xbgr.mr_n87903152)
print v(xbgr.mr_n87903584)
print v(xbgr.mr_n87903904)
print v(xbgr.mr_n87904016)
print v(xbgr.mr_n87904336)
print v(xbgr.mr_n87904448)
print v(xbgr.mr_n87904880)
print v(xbgr.mr_n87905312)
print v(xbgr.mr_n87905632)
print v(xbgr.mr_n87905744)
print v(xbgr.mr_n87906064)
print v(xbgr.mr_n87906176)
print v(xbgr.mr_n87906496)
print v(xbgr.mr_n87906608)
print v(xbgr.mr_n87906928)
print v(xbgr.mr_n87907040)
print v(xbgr.mr_n87907360)
print v(xbgr.mr_n87907472)
print v(xbgr.mr_n87907792)
print v(xbgr.mr_n87907904)
print v(xbgr.mr_n87908224)
print v(xbgr.mr_n87908336)
print v(xbgr.mr_n87908656)
print v(xbgr.mr_n87908768)
print v(xbgr.mr_n87909088)
print v(xbgr.mr_n87909200)
print v(xbgr.mr_n87909520)
print v(xbgr.mr_n87909632)
print v(xbgr.mr_n87909952)
print v(xbgr.mr_n87910064)
print v(xbgr.mr_n87910384)
print v(xbgr.mr_n87910496)
print v(xbgr.mr_n87910816)
print v(xbgr.mr_n87910928)
print v(xbgr.mr_n87911248)
print v(xbgr.mr_n87911360)
print v(xbgr.mr_n87911792)
print v(xbgr.mr_n87912224)
print v(xbgr.mr_n87912544)
print v(xbgr.mr_n87912656)
print v(xbgr.mr_n87912976)
print v(xbgr.mr_n87913088)
print v(xbgr.mr_n87913408)
print v(xbgr.mr_n87913520)
print v(xbgr.mr_n87913840)
print v(xbgr.mr_n87913952)
print v(xbgr.mr_n87914272)
print v(xbgr.mr_n87914384)
print v(xbgr.mr_n87914704)
print v(xbgr.mr_n87914816)
print v(xbgr.mr_n87915248)
print v(xbgr.mr_n87915680)
print v(xbgr.mr_n87916000)
print v(xbgr.mr_n87916112)
print v(xbgr.mr_n87916432)
print v(xbgr.mr_n87916544)
print v(xbgr.mr_n87916864)
print v(xbgr.mr_n87916976)
print v(xbgr.mr_n87917296)
print v(xbgr.mr_n87917408)
print v(xbgr.mr_n87917728)
print v(xbgr.mr_n87917840)
print v(xbgr.mr_n87918160)
print v(xbgr.mr_n87918272)
print v(xbgr.mr_n87918592)
print v(xbgr.mr_n87918704)
print v(xbgr.mr_n87919024)
print v(xbgr.mr_n87919136)
print v(xbgr.mr_n87919456)
print v(xbgr.mr_n87919568)
print v(xbgr.mr_n87919888)
print v(xbgr.mr_n87920000)
print v(xbgr.mr_n87920320)
print v(xbgr.mr_n87920432)
print v(xbgr.mr_n87920752)
print v(xbgr.mr_n87920864)
print v(xbgr.mr_n87921184)
print v(xbgr.mr_n87921296)
print v(xbgr.mr_n87921616)
print v(xbgr.mr_n87921728)
print v(xbgr.mr_n87922048)
print v(xbgr.mr_n87922160)
print v(xbgr.mr_n87922480)
print v(xbgr.mr_n87922592)
print v(xbgr.mr_n87922912)
print v(xbgr.mr_n87923024)
print v(xbgr.mr_n87923344)
print v(xbgr.mr_n87923456)
print v(xbgr.mr_n87923776)
print v(xbgr.mr_n87923888)
print v(xbgr.mr_n87924208)
print v(xbgr.mr_n87924320)
print v(xbgr.mr_n87924640)
print v(xbgr.mr_n87924752)
print v(xbgr.mr_n87925072)
print v(xbgr.mr_n87925184)
print v(xbgr.mr_n87925504)
print v(xbgr.mr_n87925616)
print v(xbgr.mr_n87925936)
print v(xbgr.mr_n87926048)
print v(xbgr.mr_n87926368)
print v(xbgr.mr_n87926480)
print v(xbgr.mr_n87926800)
print v(xbgr.mr_n87926912)
print v(xbgr.mr_n87927232)
print v(xbgr.mr_n87927344)
print v(xbgr.mr_n87927664)
print v(xbgr.mr_n87927776)
print v(xbgr.mr_n87928096)
print v(xbgr.mr_n87928208)
print v(xbgr.mr_n87928528)
print v(xbgr.mr_n87928640)
print v(xbgr.mr_n87928960)
print v(xbgr.mr_n87929072)
print v(xbgr.mr_n87929392)
print v(xbgr.mr_n87929504)
print v(xbgr.mr_n87929824)
print v(xbgr.mr_n87929936)
print v(xbgr.mr_n87930256)
print v(xbgr.mr_n87930368)
print v(xbgr.mr_n87930688)
print v(xbgr.mr_n87930800)
print v(xbgr.mr_n87931120)
print v(xbgr.mr_n87931232)
print v(xbgr.mr_n87931552)
print v(xbgr.mr_n87931664)
print v(xbgr.mr_n87931984)
print v(xbgr.mr_n87932096)
print v(xbgr.mr_n87932416)
print v(xbgr.mr_n87932528)
print v(xbgr.mr_n87932848)
print v(xbgr.mr_n87932960)
print v(xbgr.mr_n87933280)
print v(xbgr.mr_n87933392)
print v(xbgr.mr_n87933712)
print v(xbgr.mr_n87933824)
print v(xbgr.mr_n87934144)
print v(xbgr.mr_n87934256)
print v(xbgr.mr_n87934576)
print v(xbgr.mr_n87934688)
print v(xbgr.mr_n87935008)
print v(xbgr.mr_n87935120)
print v(xbgr.mr_n87935440)
print v(xbgr.mr_n87935552)
print v(xbgr.mr_n87935872)
print v(xbgr.mr_n87935984)
print v(xbgr.mr_n87936304)
print v(xbgr.mr_n87936416)
print v(xbgr.mr_n87936736)
print v(xbgr.mr_n87936848)
print v(xbgr.mr_n87937168)
print v(xbgr.mr_n87937280)
print v(xbgr.mr_n87937600)
print v(xbgr.mr_n87937712)
print v(xbgr.mr_n87938032)
print v(xbgr.mr_n87938144)
print v(xbgr.mr_n87938464)
print v(xbgr.mr_n87938576)
print v(xbgr.mr_n87938896)
print v(xbgr.mr_n87939008)
print v(xbgr.mr_n87939328)
print v(xbgr.mr_n87939440)
print v(xbgr.mr_n87939760)
print v(xbgr.mr_n87939872)
print v(xbgr.mr_n87940192)
print v(xbgr.mr_n87940304)
print v(xbgr.mr_n87940624)
print v(xbgr.mr_n87940736)
print v(xbgr.mr_n87941056)
print v(xbgr.mr_n87941168)
print v(xbgr.mr_n87941488)
print v(xbgr.mr_n87941600)
print v(xbgr.mr_n87941920)
print v(xbgr.mr_n87942032)
print v(xbgr.mr_n87942352)
print v(xbgr.mr_n87942464)
print v(xbgr.mr_n87942784)
print v(xbgr.mr_n87942896)
print v(xbgr.mr_n87943216)
print v(xbgr.mr_n87943328)
print v(xbgr.mr_n87943648)
print v(xbgr.mr_n87943760)
print v(xbgr.mr_n87944080)
print v(xbgr.mr_n87944192)
print v(xbgr.mr_n87944512)
print v(xbgr.mr_n87944624)
print v(xbgr.mr_n87944944)
print v(xbgr.mr_n87945056)
print v(xbgr.mr_n87945376)
print v(xbgr.mr_n87945488)
print v(xbgr.mr_n87945808)
print v(xbgr.mr_n87945920)
print v(xbgr.mr_n87946240)
print v(xbgr.mr_n87946352)
print v(xbgr.mr_n87946672)
print v(xbgr.mr_n87946784)
print v(xbgr.mr_n87947104)
print v(xbgr.mr_n87947216)
print v(xbgr.mr_n87947536)
print v(xbgr.mr_n87947648)
print v(xbgr.mr_n87947968)
print v(xbgr.mr_n87948080)
print v(xbgr.mr_n87948400)
print v(xbgr.mr_n87948512)
print v(xbgr.mr_n87948832)
print v(xbgr.mr_n87948944)
print v(xbgr.mr_n87949264)
print v(xbgr.mr_n87949376)
print v(xbgr.mr_n87949696)
print v(xbgr.mr_n87949808)
print v(xbgr.mr_n87950128)
print v(xbgr.mr_n87950240)
print v(xbgr.mr_n87950560)
print v(xbgr.mr_n87950672)
print v(xbgr.mr_n87950992)
print v(xbgr.mr_n87951104)
print v(xbgr.mr_n87951424)
print v(xbgr.mr_n87951536)
print v(xbgr.mr_n87951856)
print v(xbgr.mr_n87951968)
print v(xbgr.mr_n87952288)
print v(xbgr.mr_n87952400)
print v(xbgr.mr_n87952720)
print v(xbgr.mr_n87952832)
print v(xbgr.mr_n87953152)
print v(xbgr.mr_n87953264)
print v(xbgr.mr_n87953584)
print v(xbgr.mr_n87953696)
print v(xbgr.mr_n87954016)
print v(xbgr.mr_n87954128)
print v(xbgr.mr_n87954448)
print v(xbgr.mr_n87954560)
print v(xbgr.mr_n87954880)
print v(xbgr.mr_n87954992)
print v(xbgr.mr_n87955312)
print v(xbgr.mr_n87955424)
print v(xbgr.mr_n87955744)
print v(xbgr.mr_n87955856)
print v(xbgr.mr_n87956176)
print v(xbgr.mr_n87956288)
print v(xbgr.mr_n87956608)
print v(xbgr.mr_n87956720)
print v(xbgr.mr_n87957040)
print v(xbgr.mr_n87957152)
print v(xbgr.mr_n87957472)
print v(xbgr.mr_n87957584)
print v(xbgr.mr_n87957904)
print v(xbgr.mr_n87958016)
print v(xbgr.mr_n87958336)
print v(xbgr.mr_n87958448)
print v(xbgr.mr_n87958768)
print v(xbgr.mr_n87958880)
print v(xbgr.mr_n87959200)
print v(xbgr.mr_n87959312)
print v(xbgr.mr_n87959632)
print v(xbgr.mr_n87959744)
print v(xbgr.mr_n87960064)
print v(xbgr.mr_n87960176)
print v(xbgr.mr_n87960496)
print v(xbgr.mr_n87960608)
print v(xbgr.mr_n87960928)
print v(xbgr.mr_n87961040)
print v(xbgr.mr_n87961360)
print v(xbgr.mr_n87961472)
print v(xbgr.mr_n87961792)
print v(xbgr.mr_n87961904)
print v(xbgr.mr_n87962224)
print v(xbgr.mr_n87962336)
print v(xbgr.mr_n87962656)
print v(xbgr.mr_n87962768)
print v(xbgr.mr_n87963088)
print v(xbgr.mr_n87963200)
print v(xbgr.mr_n87963520)
print v(xbgr.mr_n87963632)
print v(xbgr.mr_n87963952)
print v(xbgr.mr_n87964064)
print v(xbgr.mr_n87964384)
print v(xbgr.mr_n87964496)
print v(xbgr.mr_n87964816)
print v(xbgr.mr_n87964928)
print v(xbgr.mr_n87965248)
print v(xbgr.mr_n87965360)
print v(xbgr.mr_n87965680)
print v(xbgr.mr_n87965792)
print v(xbgr.mr_n87966112)
print v(xbgr.mr_n87966224)
print v(xbgr.mr_n87966656)
print v(xbgr.mr_n87967088)
print v(xbgr.mr_n87967520)
print v(xbgr.mr_n87967952)
print v(xbgr.mr_n87968384)
print v(xbgr.mr_n87968816)
print v(xbgr.mr_n87969248)
print v(xbgr.mr_n87969680)
print v(xbgr.mr_n87970112)
print v(xbgr.mr_n87970544)
print v(xbgr.mr_n87970976)
print v(xbgr.mr_n87971408)
print v(xbgr.mr_n87971840)
print v(xbgr.mr_n87972272)
print v(xbgr.mr_n87972704)
print v(xbgr.mr_n87973136)
print v(xbgr.mr_n87973568)
print v(xbgr.mr_n87974000)
print v(xbgr.mr_n87974432)
print v(xbgr.mr_n87974864)
print v(xbgr.mr_n87975296)
print v(xbgr.mr_n87975728)
print v(xbgr.mr_n87976160)
print v(xbgr.mr_n87976592)
print v(xbgr.mr_n87977024)
print v(xbgr.mr_n87977456)
print v(xbgr.mr_n87977888)
print v(xbgr.mr_n87978320)
print v(xbgr.mr_n87978752)
print v(xbgr.mr_n87979184)
print v(xbgr.mr_n87979616)
print v(xbgr.mr_n87980048)
print v(xbgr.mr_n87980480)
print v(xbgr.mr_n87980912)
print v(xbgr.mr_n87981232)
print v(xbgr.mr_n87981344)
print v(xbgr.mr_n87981664)
print v(xbgr.mr_n87981776)
print v(xbgr.mr_n87982208)
print v(xbgr.mr_n87982528)
print v(xbgr.mr_n87982640)
print v(xbgr.mr_n87982960)
print v(xbgr.mr_n87983072)
print v(xbgr.mr_n87983392)
print v(xbgr.mr_n87983504)
print v(xbgr.mr_n87983824)
print v(xbgr.mr_n87983936)
print v(xbgr.mr_n87984256)
print v(xbgr.mr_n87984368)
print v(xbgr.mr_n87984688)
print v(xbgr.mr_n87984800)
print v(xbgr.mr_n87985120)
print v(xbgr.mr_n87985232)
print v(xbgr.mr_n87985552)
print v(xbgr.mr_n87985664)
print v(xbgr.mr_n87986096)
print v(xbgr.mr_n87986528)
print v(xbgr.mr_n87986960)
print v(xbgr.mr_n87987392)
print v(xbgr.mr_n87987824)
print v(xbgr.mr_n87988256)
print v(xbgr.mr_n87988688)
print v(xbgr.mr_n87989120)
print v(xbgr.mr_n87989552)
print v(xbgr.mr_n87989872)
print v(xbgr.mr_n87989984)
print v(xbgr.mr_n87990304)
print v(xbgr.mr_n87990416)
print v(xbgr.mr_n87990736)
print v(xbgr.mr_n87990848)
print v(xbgr.mr_n87991168)
print v(xbgr.mr_n87991280)
print v(xbgr.mr_n87991712)
print v(xbgr.mr_n87992144)
print v(xbgr.mr_n87992576)
print v(xbgr.mr_n87993008)
print v(xbgr.mr_n87993440)
print v(xbgr.mr_n87993872)
print v(xbgr.mr_n87994304)
print v(xbgr.mr_n87994736)
print v(xbgr.mr_n87995168)
print v(xbgr.mr_n87995600)
print v(xbgr.mr_n87996032)
print v(xbgr.mr_n87996464)
print v(xbgr.mr_n87996896)
print v(xbgr.mr_n87997328)
print v(xbgr.mr_n87997760)
print v(xbgr.mr_n87998192)
print v(xbgr.mr_n87998624)
print v(xbgr.mr_n87999056)
print v(xbgr.mr_n87999488)
print v(xbgr.mr_n87999920)
print v(xbgr.mr_n88000352)
print v(xbgr.mr_n88000784)
print v(xbgr.mr_n88001216)
print v(xbgr.mr_n88001648)
print v(xbgr.mr_n88002080)
print v(xbgr.mr_n88002512)
print v(xbgr.mr_n88002944)
print v(xbgr.mr_n88003376)
print v(xbgr.mr_n88003808)
print v(xbgr.mr_n88004128)
print v(xbgr.mr_n88004240)
print v(xbgr.mr_n88004560)
print v(xbgr.mr_n88004672)
print v(xbgr.mr_n88004992)
print v(xbgr.mr_n88005104)
print v(xbgr.mr_n88005424)
print v(xbgr.mr_n88005536)
print v(xbgr.mr_n88005856)
print v(xbgr.mr_n88005968)
print v(xbgr.mr_n88006288)
print v(xbgr.mr_n88006400)
print v(xbgr.mr_n88268880)
print v(xbgr.mr_n88269664)
print v(xbgr.mr_n88270528)
print v(xbgr.mr_n88270640)
print v(xbgr.mr_n88270960)
print v(xbgr.mr_n88271392)
print v(xbgr.mr_n88271824)
print v(xbgr.mr_n88272256)
print v(xbgr.mr_n88272368)
print v(xbgr.mr_n88272688)
print v(xbgr.mr_n88273120)
print v(xbgr.mr_n88273552)
print v(xbgr.mr_n88273984)
print v(xbgr.mr_n88274096)
print v(xbgr.mr_n88274416)
print v(xbgr.mr_n88274528)
print v(xbgr.mr_n88274848)
print v(xbgr.mr_n88274960)
print v(xbgr.mr_n88275392)
print v(xbgr.mr_n88275824)
print v(xbgr.mr_n88276256)
print v(xbgr.mr_n88276576)
print v(xbgr.mr_n88277440)
print v(xbgr.mr_n88277552)
print v(xbgr.mr_n88277872)
print v(xbgr.mr_n88277984)
print v(xbgr.mr_n88278304)
print v(xbgr.mr_n88279280)
print v(xbgr.mr_n88279712)
print v(xbgr.mr_n88280032)
print v(xbgr.mr_n88280896)
print v(xbgr.mr_n88281008)
print v(xbgr.mr_n88281328)
print v(xbgr.mr_n88281440)
print v(xbgr.mr_n88281760)
print v(xbgr.mr_n88281872)
print v(xbgr.mr_n88284368)
print v(xbgr.mr_n88284800)
print v(xbgr.mr_n88285120)
print v(xbgr.mr_n88286096)
print v(xbgr.mr_n88286416)
print v(xbgr.mr_n88287392)
print v(xbgr.mr_n88287712)
print v(xbgr.mr_n88288688)
print v(xbgr.mr_n88289008)
print v(xbgr.mr_n88289120)
print v(xbgr.mr_n88289552)
print v(xbgr.mr_n88289984)
print v(xbgr.mr_n88290304)
print v(xbgr.mr_n88291280)
print v(xbgr.mr_n88291600)
print v(xbgr.mr_n88292576)
print v(xbgr.mr_n88292896)
print v(xbgr.mr_n88293872)
print v(xbgr.mr_n88294304)
print v(xbgr.mr_n88294736)
print v(xbgr.mr_n88295168)
print v(xbgr.mr_n88295600)
print v(xbgr.mr_n88296032)
print v(xbgr.mr_n88296464)
print v(xbgr.mr_n88296896)
print v(xbgr.mr_n88297328)
print v(xbgr.mr_n88297760)
print v(xbgr.mr_n88298192)
print v(xbgr.mr_n88298624)
print v(xbgr.mr_n88299056)
print v(xbgr.mr_n88299488)
print v(xbgr.mr_n88299920)
print v(xbgr.mr_n88300352)
print v(xbgr.mr_n88300784)
print v(xbgr.mr_n88301216)
print v(xbgr.mr_n88301648)
print v(xbgr.mr_n88302080)
print v(xbgr.mr_n88302512)
print v(xbgr.mr_n88302944)
print v(xbgr.mr_n88303376)
print v(xbgr.mr_n88303808)
print v(xbgr.mr_n88304240)
print v(xbgr.mr_n88365008)
print v(xbgr.mr_n88366240)
print v(xbgr.mr_n88366800)
print v(xbgr.mr_n88368592)
print v(xbgr.mr_n88369104)
print v(xbgr.mr_n88372208)
print v(xbgr.mr_n88372832)
print v(xbgr.mr_n88373184)
print v(xbgr.mr_n88375120)
print v(xbgr.mr_n88377264)
print v(xbgr.mr_n88377952)
print v(xbgr.mr_n88378304)
print v(xbgr.mr_n88379344)
print v(xbgr.mr_n88379856)
print v(xbgr.mr_n88380640)
print v(xbgr.mr_n88380816)
print v(xbgr.mr_n88381888)
print v(xbgr.mr_n88388304)
print v(xbgr.mr_n88389888)
print v(xbgr.mr_n88393616)
print v(xbgr.mr_n88394864)
print v(xbgr.mr_n88395248)
print v(xbgr.mr_n88395568)
print v(xbgr.mr_n88395872)
print v(xbgr.mr_n88400352)
print v(xbgr.mr_n88401120)
print v(xbgr.mr_n88402400)
print v(xbgr.mr_n88403632)
print v(xbgr.mr_n88403920)
print v(xbgr.mr_n88406176)
print v(xbgr.mr_n88407264)
print v(xbgr.mr_n88407648)
print v(xbgr.mr_n88408048)
print v(xbgr.mr_n88408672)
print v(xbgr.mr_n88409696)
print v(xbgr.mr_n88410784)
print v(xbgr.mr_n88411184)
print v(xbgr.mr_n88411808)
print v(xbgr.mr_n88411984)
print v(xbgr.mr_n88413152)
print v(xbgr.mr_n88415456)
print v(xbgr.mr_n88417824)
print v(xbgr.mr_n88419152)
print v(xbgr.mr_n88419632)
print v(xbgr.mr_n88419904)
print v(xbgr.mr_n88420192)
print v(xbgr.mr_n88420432)
print v(xbgr.mr_n88420576)
print v(xbgr.mr_n88421536)
print v(xbgr.mr_n88423664)
print v(xbgr.mr_n88426976)
print v(xbgr.mr_n88427760)
print v(xbgr.mr_n88428256)
print v(xbgr.mr_n88428704)
print v(xbgr.mr_n88429600)
print v(xbgr.mr_n88431728)
print v(xbgr.mr_n88432176)
print v(xbgr.mr_n88432352)
print v(xbgr.mr_n88433248)
print v(xbgr.mr_n88433696)
print v(xbgr.mr_n88435424)
print v(xbgr.mr_n88436560)
print v(xbgr.mr_n88436768)
print v(xbgr.mr_n88437456)
print v(xbgr.mr_n88437600)
print v(xbgr.mr_n88438304)
print v(xbgr.mr_n88452352)
print v(xbgr.mr_n88452688)
print v(xbgr.mr_n88452960)
print v(xbgr.mr_n88453296)
print v(xbgr.mr_n88453632)
print v(xbgr.mr_n88454224)
print v(xbgr.mr_n88454608)
print v(xbgr.mr_n88457776)
print v(xbgr.mr_n88458352)
print v(xbgr.mr_n88463824)
print v(xbgr.mr_n88464352)
print v(xbgr.mr_n88467504)
print v(xbgr.mr_n88531248)
print v(xbgr.mr_n88549648)
print v(xbgr.mr_n88550336)
print v(xbgr.mr_n88550720)
print v(xbgr.mr_n88551824)
print v(xbgr.mr_n88558288)
print v(xbgr.mr_n88560256)
print v(xbgr.mr_n88560768)
print v(xbgr.mr_n88566032)
print v(xbgr.mr_n88567168)
print v(xbgr.mr_n88635648)
print v(xbgr.mr_n88635792)
print v(xbgr.mr_n88665680)
print v(xbgr.mr_n88675072)
print v(xbgr.mr_n88679056)
print v(xbgr.mr_n88682960)
print v(xbgr.mr_n88684720)
print v(xbgr.mr_n88685488)
print v(xbgr.mr_n88838880)
print v(xbgr.mr_n88915488)
print v(xbgr.mr_n88915680)
print v(xbgr.mr_n88915872)
print v(xbgr.mr_n88916384)
print v(xbgr.mr_n88929856)
print v(xbgr.mr_n89054032)
print v(xbgr.mr_n89065552)
print v(xbgr.mr_n89065936)
print v(xbgr.mr_n89072096)
print v(xbgr.mr_n89085456)
print v(xbgr.mr_n89090512)
print v(xbgr.mr_n89103984)
print v(xbgr.mr_n89104416)
print v(xbgr.mr_n89222560)
print v(xbgr.mr_n89222704)
print v(xbgr.mr_n89224704)
print v(xbgr.mr_n89224816)
print v(xbgr.mr_n89225408)
print v(xbgr.mr_n89226720)
print v(xbgr.mr_n89227424)
print v(xbgr.mr_n89227632)
print v(xbgr.mr_n89229360)
print v(xbgr.mr_n89229616)
print v(xbgr.mr_n89233568)
print v(xbgr.mr_n89234832)
print v(xbgr.mr_n89237136)
print v(xbgr.mr_n89238672)
print v(xbgr.mr_n89239296)
print v(xbgr.mr_n89242176)
print v(xbgr.mr_n89242288)
print v(xbgr.mr_n89242400)
print v(xbgr.mr_n89242512)
print v(xbgr.mr_n89242816)
print v(xbgr.mr_n89243088)
print v(xbgr.mr_n89243360)
print v(xbgr.mr_n89245472)
print v(xbgr.mr_n89245936)
print v(xbgr.mr_n89246400)
print v(xbgr.mr_n89246864)
print v(xbgr.mr_n89247328)
print v(xbgr.mr_n89247792)
print v(xbgr.mr_n89248256)
print v(xbgr.mr_n89248720)
print v(xbgr.mr_n89249184)
print v(xbgr.mr_n89249648)
print v(xbgr.mr_n89250112)
print v(xbgr.mr_n89251040)
print v(xbgr.mr_n89253600)
print v(xbgr.mr_n89254448)
print v(xbgr.mr_n89254944)
print v(xbgr.mr_n89259744)
print v(xbgr.mr_n89261392)
print v(xbgr.mr_n89261568)
print v(xbgr.mr_n89262000)
print v(xbgr.mr_n89262784)
print v(xbgr.mr_n89263024)
print v(xbgr.mr_n89263568)
print v(xbgr.mr_n89263824)
print v(xbgr.mr_n89264000)
print v(xbgr.mr_n89264608)
print v(xbgr.mr_n89265168)
print v(xbgr.mr_n89266432)
print v(xbgr.mr_n89268080)
print v(xbgr.mr_n89270096)
print v(xbgr.mr_n89272032)
print v(xbgr.mr_n89272480)
print v(xbgr.mr_n89273504)
print v(xbgr.mr_n89274000)
print v(xbgr.mr_n89275792)
print v(xbgr.mr_n89277520)
print v(xbgr.mr_n89277728)
print v(xbgr.mr_n89278608)
print v(xbgr.mr_n89279136)
print v(xbgr.mr_n89280432)
print v(xbgr.mr_n89282720)
print v(xbgr.mr_n89283536)
print v(xbgr.mr_n89284560)
print v(xbgr.mr_n89284768)
print v(xbgr.mr_n89285264)
print v(xbgr.mr_n89285776)
print v(xbgr.mr_n89285968)
print v(xbgr.mr_n89286416)
print v(xbgr.mr_n89286800)
print v(xbgr.mr_n89287648)
print v(xbgr.mr_n89288080)
print v(xbgr.mr_n89288992)
print v(xbgr.mr_n89290720)
print v(xbgr.mr_n89290896)
print v(xbgr.mr_n89292400)
print v(xbgr.mr_n89293712)
print v(xbgr.mr_n89294416)
print v(xbgr.mr_n89296224)
print v(xbgr.mr_n89297264)
print v(xbgr.mr_n89297936)
print v(xbgr.mr_n89300752)
print v(xbgr.mr_n89303248)
print v(xbgr.mr_n89303568)
print v(xbgr.mr_n89304272)
print v(xbgr.mr_n89304976)
print v(xbgr.mr_n89305184)
print v(xbgr.mr_n89306592)
print v(xbgr.mr_n89310176)
print v(xbgr.mr_n89310608)
print v(xbgr.mr_n89313760)
print v(xbgr.mr_n89314336)
print v(xbgr.mr_n89314528)
print v(xbgr.mr_n89315536)
print v(xbgr.mr_n89316336)
print v(xbgr.mr_n89316448)
print v(xbgr.mr_n89317856)
print v(xbgr.mr_n89318560)
print v(xbgr.mr_n89319968)
print v(xbgr.mr_n89321168)
print v(xbgr.mr_n89322080)
print v(xbgr.mr_n89323680)
print v(xbgr.mr_n89325392)
print v(xbgr.mr_n89326096)
print v(xbgr.mr_n89326848)
print v(xbgr.mr_n89326992)
print v(xbgr.mr_n89327200)
print v(xbgr.mr_n89327344)
print v(xbgr.mr_n89327808)
print v(xbgr.mr_n89329104)
print v(xbgr.mr_n89330384)
print v(xbgr.mr_n89330880)
print v(xbgr.mr_n89332256)
print v(xbgr.mr_n89332720)
print v(xbgr.mr_n89333184)
print v(xbgr.mr_n89333648)
print v(xbgr.mr_n89334112)
print v(xbgr.mr_n89334576)
print v(xbgr.mr_n89335040)
print v(xbgr.mr_n89335504)
print v(xbgr.mr_n89335968)
print v(xbgr.mr_n89336432)
print v(xbgr.mr_n89336896)
print v(xbgr.mr_n89337168)
print v(xbgr.mr_n89338512)
print v(xbgr.mr_n89338688)
print v(xbgr.mr_n89338800)
print v(xbgr.mr_n89340016)
print v(xbgr.mr_n89343104)
print v(xbgr.mr_n89343776)
print v(xbgr.mr_n89345296)
print v(xbgr.mr_n89345536)
print v(xbgr.mr_n89345648)
print v(xbgr.mr_n89346032)
print v(xbgr.mr_n89346816)
print v(xbgr.mr_n89347056)
print v(xbgr.mr_n89351680)
print v(xbgr.mr_n89352224)
print v(xbgr.mr_n89352528)
print v(xbgr.mr_n89354048)
print v(xbgr.mr_n89354656)
print v(xbgr.mr_n89355152)
print v(xbgr.mr_n89356544)
print v(xbgr.mr_n89356784)
print v(xbgr.mr_n89359520)
print v(xbgr.mr_n89359760)
print v(xbgr.mr_n89360192)
print v(xbgr.mr_n89361104)
print v(xbgr.mr_n89361648)
print v(xbgr.mr_n89363536)
print v(xbgr.mr_n89363776)
print v(xbgr.mr_n89364080)
print v(xbgr.mr_n89365968)
print v(xbgr.mr_n89366512)
print v(xbgr.mr_n89367184)
print v(xbgr.mr_n89368496)
print v(xbgr.mr_n89369232)
print v(xbgr.mr_n89369504)
print v(xbgr.mr_n89370512)
print v(xbgr.mr_n89371520)
print v(xbgr.mr_n89371776)
print v(xbgr.mr_n89372528)
print v(xbgr.mr_n89372640)
print v(xbgr.mr_n89373536)
print v(xbgr.mr_n89374272)
print v(xbgr.mr_n89375104)
print v(xbgr.mr_n89375552)
print v(xbgr.mr_n89375664)
print v(xbgr.mr_n89376288)
print v(xbgr.mr_n89377040)
print v(xbgr.mr_n89377648)
print v(xbgr.mr_n89377792)
print v(xbgr.mr_n89378240)
print v(xbgr.mr_n89378560)
print v(xbgr.mr_n89378704)
print v(xbgr.mr_n89379792)
print v(xbgr.mr_n89380432)
print v(xbgr.mr_n89381024)
print v(xbgr.mr_n89381216)
print v(xbgr.mr_n89381728)
print v(xbgr.mr_n89383328)
print v(xbgr.mr_n89383792)
print v(xbgr.mr_n89384064)
print v(xbgr.mr_n89384256)
print v(xbgr.mr_n89384720)
print v(xbgr.mr_n89385184)
print v(xbgr.mr_n89385648)
print v(xbgr.mr_n89386112)
print v(xbgr.mr_n89386576)
print v(xbgr.mr_n89387040)
print v(xbgr.mr_n89387504)
print v(xbgr.mr_n89387968)
print v(xbgr.mr_n89388432)
print v(xbgr.mr_n89388896)
print v(xbgr.mr_n89389360)
print v(xbgr.mr_n89389824)
print v(xbgr.mr_n89390288)
print v(xbgr.mr_n89390752)
print v(xbgr.mr_n89391216)
print v(xbgr.mr_n89391680)
print v(xbgr.mr_n89392144)
print v(xbgr.mr_n89392608)
print v(xbgr.mr_n89393072)
print v(xbgr.mr_n89393536)
print v(xbgr.mr_n89394000)
print v(xbgr.mr_n89394464)
print v(xbgr.mr_n89394928)
print v(xbgr.mr_n89395392)
print v(xbgr.mr_n89395744)
print v(xbgr.mr_n89395856)
print v(xbgr.mr_n89396320)
print v(xbgr.mr_n89396784)
print v(xbgr.mr_n89397248)
print v(xbgr.mr_n89397712)
print v(xbgr.mr_n89398176)
print v(xbgr.mr_n89398640)
print v(xbgr.mr_n89399104)
print v(xbgr.mr_n89399568)
print v(xbgr.mr_n89400032)
print v(xbgr.mr_n89400496)
print v(xbgr.mr_n89400960)
print v(xbgr.mr_n89401424)
print v(xbgr.mr_n89401888)
print v(xbgr.mr_n89402352)
print v(xbgr.mr_n89402624)
print v(xbgr.mr_n89402816)
print v(xbgr.mr_n89403280)
print v(xbgr.mr_n89403744)
print v(xbgr.mr_n89404208)
print v(xbgr.mr_n89404672)
print v(xbgr.mr_n89405136)
print v(xbgr.mr_n89405600)
print v(xbgr.mr_n89406064)
print v(xbgr.mr_n89406528)
print v(xbgr.mr_n89406992)
print v(xbgr.mr_n89407456)
print v(xbgr.mr_n89407920)
print v(xbgr.mr_n89408384)
print v(xbgr.mr_n89408848)
print v(xbgr.mr_n89409312)
print v(xbgr.mr_n89409776)
print v(xbgr.mr_n89410240)
print v(xbgr.mr_n89410704)
print v(xbgr.mr_n89411168)
print v(xbgr.mr_n89411632)
print v(xbgr.mr_n89412096)
print v(xbgr.mr_n89412368)
print v(xbgr.mr_n89412560)
print v(xbgr.mr_n89413024)
print v(xbgr.mr_n89413488)
print v(xbgr.mr_n89413952)
print v(xbgr.mr_n89414416)
print v(xbgr.mr_n89414880)
print v(xbgr.mr_n89415344)
print v(xbgr.mr_n89415808)
print v(xbgr.mr_n89416272)
print v(xbgr.mr_n89416736)
print v(xbgr.mr_n89417200)
print v(xbgr.mr_n89417664)
print v(xbgr.mr_n89418128)
print v(xbgr.mr_n89418592)
print v(xbgr.mr_n89419056)
print v(xbgr.mr_n89419520)
print v(xbgr.mr_n89419920)
print v(xbgr.mr_n89420384)
print v(xbgr.mr_n89420848)
print v(xbgr.mr_n89421312)
print v(xbgr.mr_n89421760)
print v(xbgr.mr_n89422224)
print v(xbgr.mr_n89422688)
print v(xbgr.mr_n89423152)
print v(xbgr.mr_n89423616)
print v(xbgr.mr_n89423888)
print v(xbgr.mr_n89424080)
print v(xbgr.mr_n89424544)
print v(xbgr.mr_n89425008)
print v(xbgr.mr_n89425472)
print v(xbgr.mr_n89425936)
print v(xbgr.mr_n89426400)
print v(xbgr.mr_n89426864)
print v(xbgr.mr_n89427328)
print v(xbgr.mr_n89427792)
print v(xbgr.mr_n89428256)
print v(xbgr.mr_n89428720)
print v(xbgr.mr_n89429184)
print v(xbgr.mr_n89429648)
print v(xbgr.mr_n89430112)
print v(xbgr.mr_n89430576)
print v(xbgr.mr_n89431040)
print v(xbgr.mr_n89431504)
print v(xbgr.mr_n89431968)
print v(xbgr.mr_n89432432)
print v(xbgr.mr_n89432896)
print v(xbgr.mr_n89433360)
print v(xbgr.mr_n89433824)
print v(xbgr.mr_n89434288)
print v(xbgr.mr_n89434752)
print v(xbgr.mr_n89435216)
print v(xbgr.mr_n89435680)
print v(xbgr.mr_n89436144)
print v(xbgr.mr_n89436608)
print v(xbgr.mr_n89437072)
print v(xbgr.mr_n89437536)
print v(xbgr.mr_n89437888)
print v(xbgr.mr_n89438000)
print v(xbgr.mr_n89438464)
print v(xbgr.mr_n89438576)
print v(xbgr.mr_n89439120)
print v(xbgr.mr_n89439344)
print v(xbgr.mr_n89439856)
print v(xbgr.mr_n89440080)
print v(xbgr.mr_n89440592)
print v(xbgr.mr_n89440816)
print v(xbgr.mr_n89441328)
print v(xbgr.mr_n89441440)
print v(xbgr.mr_n89441552)
print v(xbgr.mr_n89442064)
print v(xbgr.mr_n89442176)
print v(xbgr.mr_n89442288)
print v(xbgr.mr_n89442800)
print v(xbgr.mr_n89442912)
print v(xbgr.mr_n89443024)
print v(xbgr.mr_n89443536)
print v(xbgr.mr_n89443808)
print v(xbgr.mr_n89444080)
print v(xbgr.mr_n89444352)
print v(xbgr.mr_n89444464)
print v(xbgr.mr_n89444576)
print v(xbgr.mr_n89445088)
print v(xbgr.mr_n89445360)
print v(xbgr.mr_n89445632)
print v(xbgr.mr_n89445904)
print v(xbgr.mr_n89446176)
print v(xbgr.mr_n89446720)
print v(xbgr.mr_n89446992)
print v(xbgr.mr_n89447264)
print v(xbgr.mr_n89447536)
print v(xbgr.mr_n89447808)
print v(xbgr.mr_n89448080)
print v(xbgr.mr_n89448624)
print v(xbgr.mr_n89448896)
print v(xbgr.mr_n89449168)
print v(xbgr.mr_n89449440)
print v(xbgr.mr_n89449712)
print v(xbgr.mr_n89449984)
print v(xbgr.mr_n89450256)
print v(xbgr.mr_n89450528)
print v(xbgr.mr_n89450800)
print v(xbgr.mr_n89451072)
print v(xbgr.mr_n89451344)
print v(xbgr.mr_n89451616)
print v(xbgr.mr_n89451952)
print v(xbgr.mr_n89452416)
print v(xbgr.mr_n89452880)
print v(xbgr.mr_n89453344)
print v(xbgr.mr_n89453808)
print v(xbgr.mr_n89454272)
print v(xbgr.mr_n89454736)
print v(xbgr.mr_n89455200)
print v(xbgr.mr_n89455664)
print v(xbgr.mr_n89456128)
print v(xbgr.mr_n89456592)
print v(xbgr.mr_n89457056)
print v(xbgr.mr_n89457392)
print v(xbgr.mr_n89460592)
print v(xbgr.mr_n89467696)
print v(xbgr.mr_n89468784)
print v(xbgr.mr_n89472688)
print v(xbgr.mr_n89474160)
print v(xbgr.mr_n89474704)
print v(xbgr.mr_n89475088)
print v(xbgr.mr_n89475664)
print v(xbgr.mr_n89476256)
print v(xbgr.mr_n89476768)
print v(xbgr.mr_n89477104)
print v(xbgr.mr_n89477744)
print v(xbgr.mr_n89478208)
print v(xbgr.mr_n89478928)
print v(xbgr.mr_n89480992)
print v(xbgr.mr_n89482336)
print v(xbgr.mr_n89483680)
print v(xbgr.mr_n89486064)
print v(xbgr.mr_n89486544)
print v(xbgr.mr_n89487344)
print v(xbgr.mr_n89490992)
print v(xbgr.mr_n89491952)
print v(xbgr.mr_n89495584)
print v(xbgr.mr_n89498288)
print v(xbgr.mr_n89499312)
print v(xbgr.mr_n89502528)
print v(xbgr.mr_n89504704)
print v(xbgr.mr_n89510112)
print v(xbgr.mr_n89513152)
print v(xbgr.mr_n89513600)
print v(xbgr.mr_n89513712)
print v(xbgr.mr_n89513904)
print v(xbgr.mr_n89514576)
print v(xbgr.mr_n89518816)
print v(xbgr.mr_n89519680)
print v(xbgr.mr_n89534976)
print v(xbgr.mr_n89535584)
print v(xbgr.mr_n89536368)
print v(xbgr.mr_n89536624)
print v(xbgr.mr_n89537104)
print v(xbgr.mr_n89537728)
print v(xbgr.mr_n89538240)
print v(xbgr.mr_n89538352)
print v(xbgr.mr_n89538960)
print v(xbgr.mr_n89539072)
print v(xbgr.mr_n89539808)
print v(xbgr.mr_n89539920)
print v(xbgr.mr_n89540720)
print v(xbgr.mr_n89541632)
print v(xbgr.mr_n89541744)
print v(xbgr.mr_n89542544)
print v(xbgr.mr_n89543456)
print v(xbgr.mr_n89544688)
print v(xbgr.mr_n89548096)
print v(xbgr.mr_n89548336)
print v(xbgr.mr_n89549312)
print v(xbgr.mr_n89549616)
print v(xbgr.mr_n89551072)
print v(xbgr.mr_n89552288)
print v(xbgr.mr_n89553504)
print v(xbgr.mr_n89556000)
print v(xbgr.mr_n89556544)
print v(xbgr.mr_n89559280)
print v(xbgr.mr_n89559520)
print v(xbgr.mr_n89559952)
print v(xbgr.mr_n89560864)
print v(xbgr.mr_n89562080)
print v(xbgr.mr_n89564208)
print v(xbgr.mr_n89564512)
print v(xbgr.mr_n89567792)
print v(xbgr.mr_n89569616)
print v(xbgr.mr_n89572848)
print v(xbgr.mr_n89574240)
print v(xbgr.mr_n89576944)
print v(xbgr.mr_n89579232)
print v(xbgr.mr_n89580976)
print v(xbgr.mr_n89581984)
print v(xbgr.mr_n89582368)
print v(xbgr.mr_n89582992)
print v(xbgr.mr_n89584208)
print v(xbgr.mr_n89584448)
print v(xbgr.mr_n89585360)
print v(xbgr.mr_n89585504)
print v(xbgr.mr_n89586464)
print v(xbgr.mr_n89587120)
print v(xbgr.mr_n89588032)
print v(xbgr.mr_n89588528)
print v(xbgr.mr_n89588800)
print v(xbgr.mr_n89589312)
print v(xbgr.mr_n89589488)
print v(xbgr.mr_n89591280)
print v(xbgr.mr_n89591568)
print v(xbgr.mr_n89591872)
print v(xbgr.mr_n89593376)
print v(xbgr.mr_n89594976)
print v(xbgr.mr_n89595232)
print v(xbgr.mr_n89595568)
print v(xbgr.mr_n89597872)
print v(xbgr.mr_n89598464)
print v(xbgr.mr_n89599056)
print v(xbgr.mr_n89599648)
print v(xbgr.mr_n89600240)
print v(xbgr.mr_n89600832)
print v(xbgr.mr_n89601424)
print v(xbgr.mr_n89602016)
print v(xbgr.mr_n89602608)
print v(xbgr.mr_n89603200)
print v(xbgr.mr_n89603792)
print v(xbgr.mr_n89604320)
print v(xbgr.mr_n89604976)
print v(xbgr.mr_n89605568)
print v(xbgr.mr_n89606160)
print v(xbgr.mr_n89606752)
print v(xbgr.mr_n89607344)
print v(xbgr.mr_n89607936)
print v(xbgr.mr_n89608528)
print v(xbgr.mr_n89609120)
print v(xbgr.mr_n89610304)
print v(xbgr.mr_n89610896)
print v(xbgr.mr_n89611488)
print v(xbgr.mr_n89612080)
print v(xbgr.mr_n89612256)
print v(xbgr.mr_n89612432)
print v(xbgr.mr_n89613328)
print v(xbgr.mr_n89614016)
print v(xbgr.mr_n89615200)
print v(xbgr.mr_n89615792)
print v(xbgr.mr_n89616384)
print v(xbgr.mr_n89616976)
print v(xbgr.mr_n89617568)
print v(xbgr.mr_n89618160)
print v(xbgr.mr_n89618752)
print v(xbgr.mr_n89619344)
print v(xbgr.mr_n89619760)
print v(xbgr.mr_n89619936)
print v(xbgr.mr_n89620528)
print v(xbgr.mr_n89621120)
print v(xbgr.mr_n89621712)
print v(xbgr.mr_n89622304)
print v(xbgr.mr_n89622896)
print v(xbgr.mr_n89623488)
print v(xbgr.mr_n89624080)
print v(xbgr.mr_n89624672)
print v(xbgr.mr_n89625200)
print v(xbgr.mr_n89625856)
print v(xbgr.mr_n89626448)
print v(xbgr.mr_n89627024)
print v(xbgr.mr_n89627440)
print v(xbgr.mr_n89627616)
print v(xbgr.mr_n89628208)
print v(xbgr.mr_n89628800)
print v(xbgr.mr_n89629392)
print v(xbgr.mr_n89629984)
print v(xbgr.mr_n89630576)
print v(xbgr.mr_n89630912)
print v(xbgr.mr_n89631168)
print v(xbgr.mr_n89631760)
print v(xbgr.mr_n89632352)
print v(xbgr.mr_n89632944)
print v(xbgr.mr_n89633536)
print v(xbgr.mr_n89634128)
print v(xbgr.mr_n89634720)
print v(xbgr.mr_n89635312)
print v(xbgr.mr_n89635904)
print v(xbgr.mr_n89636496)
print v(xbgr.mr_n89637088)
print v(xbgr.mr_n89637680)
print v(xbgr.mr_n89638272)
print v(xbgr.mr_n89638864)
print v(xbgr.mr_n89639456)
print v(xbgr.mr_n89640048)
print v(xbgr.mr_n89640640)
print v(xbgr.mr_n89641232)
print v(xbgr.mr_n89641760)
print v(xbgr.mr_n89642416)
print v(xbgr.mr_n89643008)
print v(xbgr.mr_n89643600)
print v(xbgr.mr_n89644192)
print v(xbgr.mr_n89644784)
print v(xbgr.mr_n89645376)
print v(xbgr.mr_n89645968)
print v(xbgr.mr_n89646560)
print v(xbgr.mr_n89647152)
print v(xbgr.mr_n89647744)
print v(xbgr.mr_n89648336)
print v(xbgr.mr_n89648928)
print v(xbgr.mr_n89649520)
print v(xbgr.mr_n89650048)
print v(xbgr.mr_n89650704)
print v(xbgr.mr_n89651296)
print v(xbgr.mr_n89651888)
print v(xbgr.mr_n89652480)
print v(xbgr.mr_n89653072)
print v(xbgr.mr_n89653664)
print v(xbgr.mr_n89654256)
print v(xbgr.mr_n89654848)
print v(xbgr.mr_n89655440)
print v(xbgr.mr_n89656032)
print v(xbgr.mr_n89656624)
print v(xbgr.mr_n89657216)
print v(xbgr.mr_n89657808)
print v(xbgr.mr_n89658400)
print v(xbgr.mr_n89658992)
print v(xbgr.mr_n89659584)
print v(xbgr.mr_n89660176)
print v(xbgr.mr_n89660768)
print v(xbgr.mr_n89661360)
print v(xbgr.mr_n89661952)
print v(xbgr.mr_n89662544)
print v(xbgr.mr_n89663136)
print v(xbgr.mr_n89663728)
print v(xbgr.mr_n89664320)
print v(xbgr.mr_n89664912)
print v(xbgr.mr_n89665504)
print v(xbgr.mr_n89666096)
print v(xbgr.mr_n89666624)
print v(xbgr.mr_n89667280)
print v(xbgr.mr_n89667872)
print v(xbgr.mr_n89668464)
print v(xbgr.mr_n89669056)
print v(xbgr.mr_n89669648)
print v(xbgr.mr_n89670240)
print v(xbgr.mr_n89670832)
print v(xbgr.mr_n89671424)
print v(xbgr.mr_n89672608)
print v(xbgr.mr_n89673200)
print v(xbgr.mr_n89673792)
print v(xbgr.mr_n89674384)
print v(xbgr.mr_n89674976)
print v(xbgr.mr_n89675568)
print v(xbgr.mr_n89675984)
print v(xbgr.mr_n89676160)
print v(xbgr.mr_n89676752)
print v(xbgr.mr_n89677344)
print v(xbgr.mr_n89677936)
print v(xbgr.mr_n89678928)
print v(xbgr.mr_n89679328)
print v(xbgr.mr_n89679728)
print v(xbgr.mr_n89680528)
print v(xbgr.mr_n89681328)
print v(xbgr.mr_n89681728)
print v(xbgr.mr_n89682128)
print v(xbgr.mr_n89682528)
print v(xbgr.mr_n89682928)
print v(xbgr.mr_n89683664)
print v(xbgr.mr_n89684864)
print v(xbgr.mr_n89693776)
print v(xbgr.mr_n89695824)
print v(xbgr.mr_n89696976)
print v(xbgr.mr_n89698576)
print v(xbgr.mr_n89709120)
print v(xbgr.mr_n89709312)
print v(xbgr.mr_n89709472)
print v(xbgr.mr_n89711376)
print v(xbgr.mr_n89711968)
print v(xbgr.mr_n89712560)
print v(xbgr.mr_n89713152)
print v(xbgr.mr_n89713744)
print v(xbgr.mr_n89714336)
print v(xbgr.mr_n89714928)
print v(xbgr.mr_n89715264)
print v(xbgr.mr_n89715520)
print v(xbgr.mr_n89716112)
print v(xbgr.mr_n89716704)
print v(xbgr.mr_n89717296)
print v(xbgr.mr_n89722384)
print v(xbgr.mr_n89723536)
print v(xbgr.mr_n89729664)
print v(xbgr.mr_n89730816)
print v(xbgr.mr_n89735296)
print v(xbgr.mr_n89738432)
print v(xbgr.mr_n89739648)
print v(xbgr.mr_n89744448)
print v(xbgr.mr_n89749664)
print v(xbgr.mr_n89750192)
print v(xbgr.mr_n89750736)
print v(xbgr.mr_n89750992)
print v(xbgr.mr_n89751104)
print v(xbgr.mr_n89751296)
print v(xbgr.mr_n89751520)
print v(xbgr.mr_n89752704)
print v(xbgr.mr_n89753600)
print v(xbgr.mr_n89754624)
print v(xbgr.mr_n89755744)
print v(xbgr.mr_n89756080)
print v(xbgr.mr_n89756336)
print v(xbgr.mr_n89756928)
print v(xbgr.mr_n89757520)
print v(xbgr.mr_n89758112)
print v(xbgr.mr_n89758704)
print v(xbgr.mr_n89759888)
print v(xbgr.mr_n89760480)
print v(xbgr.mr_n89761072)
print v(xbgr.mr_n89761664)
print v(xbgr.mr_n89762256)
print v(xbgr.mr_n89762848)
print v(xbgr.mr_n89763440)
print v(xbgr.mr_n89764032)
print v(xbgr.mr_n89764624)
print v(xbgr.mr_n89765216)
print v(xbgr.mr_n89765808)
print v(xbgr.mr_n89766992)
print v(xbgr.mr_n89768176)
print v(xbgr.mr_n89768768)
print v(xbgr.mr_n89769360)
print v(xbgr.mr_n89769952)
print v(xbgr.mr_n89770544)
print v(xbgr.mr_n89771136)
print v(xbgr.mr_n89771728)
print v(xbgr.mr_n89772320)
print v(xbgr.mr_n89772912)
print v(xbgr.mr_n89773504)
print v(xbgr.mr_n89774096)
print v(xbgr.mr_n89774688)
print v(xbgr.mr_n89775280)
print v(xbgr.mr_n89775872)
print v(xbgr.mr_n89776464)
print v(xbgr.mr_n89777056)
print v(xbgr.mr_n89777648)
print v(xbgr.mr_n89778240)
print v(xbgr.mr_n89778832)
print v(xbgr.mr_n89779424)
print v(xbgr.mr_n89780016)
print v(xbgr.mr_n89781200)
print v(xbgr.mr_n89781792)
print v(xbgr.mr_n89782384)
print v(xbgr.mr_n89782976)
print v(xbgr.mr_n89783568)
print v(xbgr.mr_n89784160)
print v(xbgr.mr_n89784752)
print v(xbgr.mr_n89785344)
print v(xbgr.mr_n89785936)
print v(xbgr.mr_n89786528)
print v(xbgr.mr_n89787120)
print v(xbgr.mr_n89787712)
print v(xbgr.mr_n89788304)
print v(xbgr.mr_n89788896)
print v(xbgr.mr_n89789488)
print v(xbgr.mr_n89790080)
print v(xbgr.mr_n89790672)
print v(xbgr.mr_n89791264)
print v(xbgr.mr_n89791856)
print v(xbgr.mr_n89792448)
print v(xbgr.mr_n89793040)
print v(xbgr.mr_n89793632)
print v(xbgr.mr_n89794224)
print v(xbgr.mr_n89795408)
print v(xbgr.mr_n89796000)
print v(xbgr.mr_n89796592)
print v(xbgr.mr_n89797184)
print v(xbgr.mr_n89797776)
print v(xbgr.mr_n89798368)
print v(xbgr.mr_n89798960)
print v(xbgr.mr_n89799552)
print v(xbgr.mr_n89800144)
print v(xbgr.mr_n89800736)
print v(xbgr.mr_n89801328)
print v(xbgr.mr_n89801920)
print v(xbgr.mr_n89802512)
print v(xbgr.mr_n89803104)
print v(xbgr.mr_n89803696)
print v(xbgr.mr_n89804288)
print v(xbgr.mr_n89804880)
print v(xbgr.mr_n89805472)
print v(xbgr.mr_n89806064)
print v(xbgr.mr_n89806656)
print v(xbgr.mr_n89807248)
print v(xbgr.mr_n89807840)
print v(xbgr.mr_n89808432)
print v(xbgr.mr_n89808848)
print v(xbgr.mr_n89809024)
print v(xbgr.mr_n89809616)
print v(xbgr.mr_n89810208)
print v(xbgr.mr_n89810800)
print v(xbgr.mr_n89811392)
print v(xbgr.mr_n89811984)
print v(xbgr.mr_n89812576)
print v(xbgr.mr_n89813168)
print v(xbgr.mr_n89813760)
print v(xbgr.mr_n89814352)
print v(xbgr.mr_n89814944)
print v(xbgr.mr_n89815360)
print v(xbgr.mr_n89815536)
print v(xbgr.mr_n89816128)
print v(xbgr.mr_n89816720)
print v(xbgr.mr_n89817312)
print v(xbgr.mr_n89817904)
print v(xbgr.mr_n89818496)
print v(xbgr.mr_n89819088)
print v(xbgr.mr_n89819680)
print v(xbgr.mr_n89820272)
print v(xbgr.mr_n89820864)
print v(xbgr.mr_n89821456)
print v(xbgr.mr_n89822048)
print v(xbgr.mr_n89822640)
print v(xbgr.mr_n89823232)
print v(xbgr.mr_n89823824)
print v(xbgr.mr_n89824416)
print v(xbgr.mr_n89825008)
print v(xbgr.mr_n89825600)
print v(xbgr.mr_n89826128)
print v(xbgr.mr_n89826592)
print v(xbgr.mr_n89827056)
print v(xbgr.mr_n89827168)
print v(xbgr.mr_n89827520)
print v(xbgr.mr_n89827984)
print v(xbgr.mr_n89828096)
print v(xbgr.mr_n89828448)
print v(xbgr.mr_n89828560)
print v(xbgr.mr_n89829952)
print v(xbgr.mr_n89830208)
print v(xbgr.mr_n89830544)
print v(xbgr.mr_n89831184)
print v(xbgr.mr_n89831584)
print v(xbgr.mr_n89831984)
print v(xbgr.mr_n89832384)
print v(xbgr.mr_n89832784)
print v(xbgr.mr_n89833184)
print v(xbgr.mr_n89833584)
print v(xbgr.mr_n89833984)
print v(xbgr.mr_n89834384)
print v(xbgr.mr_n89834784)
print v(xbgr.mr_n89835184)
print v(xbgr.mr_n89835584)
print v(xbgr.mr_n89835904)
print v(xbgr.mr_n89836304)
print v(xbgr.mr_n89836704)
print v(xbgr.mr_n89837104)
print v(xbgr.mr_n89837504)
print v(xbgr.mr_n89837904)
print v(xbgr.mr_n89838304)
print v(xbgr.mr_n89838704)
print v(xbgr.mr_n89839104)
print v(xbgr.mr_n89839504)
print v(xbgr.mr_n89839904)
print v(xbgr.mr_n89840304)
print v(xbgr.mr_n89840704)
print v(xbgr.mr_n89841104)
print v(xbgr.mr_n89841504)
print v(xbgr.mr_n89841904)
print v(xbgr.mr_n89842304)
print v(xbgr.mr_n89842704)
print v(xbgr.mr_n89843504)
print v(xbgr.mr_n89843904)
print v(xbgr.mr_n89844304)
print v(xbgr.mr_n89844704)
print v(xbgr.mr_n89845104)
print v(xbgr.mr_n89845632)
print v(xbgr.mr_n89846224)
print v(xbgr.mr_n89846816)
print v(xbgr.mr_n89847408)
print v(xbgr.mr_n89848000)
print v(xbgr.mr_n89848592)
print v(xbgr.mr_n89849184)
print v(xbgr.mr_n89849776)
print v(xbgr.mr_n89850368)
print v(xbgr.mr_n89850960)
print v(xbgr.mr_n89851552)
print v(xbgr.mr_n89853376)
print v(xbgr.mr_n89853888)
print v(xbgr.mr_n89857856)
print v(xbgr.mr_n89862960)
print v(xbgr.mr_n89866992)
print v(xbgr.mr_n89868592)
print v(xbgr.mr_n89869184)
print v(xbgr.mr_n89869776)
print v(xbgr.mr_n89870368)
print v(xbgr.mr_n89870960)
print v(xbgr.mr_n89871296)
print v(xbgr.mr_n89871552)
print v(xbgr.mr_n89872144)
print v(xbgr.mr_n89872736)
print v(xbgr.mr_n89873328)
print v(xbgr.mr_n89873920)
print v(xbgr.mr_n89874512)
print v(xbgr.mr_n89875104)
print v(xbgr.mr_n89875696)
print v(xbgr.mr_n89876288)
print v(xbgr.mr_n89876880)
print v(xbgr.mr_n89877472)
print v(xbgr.mr_n89878064)
print v(xbgr.mr_n89878656)
print v(xbgr.mr_n89879248)
print v(xbgr.mr_n89879840)
print v(xbgr.mr_n89880432)
print v(xbgr.mr_n89881024)
print v(xbgr.mr_n89881616)
print v(xbgr.mr_n89882208)
print v(xbgr.mr_n89882608)
print v(xbgr.mr_n89882736)
print v(xbgr.mr_n89882848)
print v(xbgr.mr_n89884000)
print v(xbgr.mr_n89886112)
print v(xbgr.mr_n89889776)
print v(xbgr.mr_n89902896)
print v(xbgr.mr_n89907504)
print v(xbgr.mr_n89908848)
print v(xbgr.mr_n89909472)
print v(xbgr.mr_n89913712)
print v(xbgr.mr_n89918704)
print v(xbgr.mr_n89935840)
print v(xbgr.mr_n89936352)
print v(xbgr.mr_n89936496)
print v(xbgr.mr_n89937680)
print v(xbgr.mr_n89938496)
print v(xbgr.mr_n89938608)
print v(xbgr.mr_n89938800)
print v(xbgr.mr_n89939216)
print v(xbgr.mr_n89939936)
print v(xbgr.mr_n89940048)
print v(xbgr.mr_n89940656)
print v(xbgr.mr_n89941376)
print v(xbgr.mr_n89941488)
print v(xbgr.mr_n89946768)
print v(xbgr.mr_n89948960)
print v(xbgr.mr_n89955728)
print v(xbgr.mr_n89956704)
print v(xbgr.mr_n89958240)
print v(xbgr.mr_n89959456)
print v(xbgr.mr_n89960208)
print v(xbgr.mr_n89965008)
print v(xbgr.mr_n89967888)
print v(xbgr.mr_n89968000)
print v(xbgr.mr_n89968736)
print v(xbgr.mr_n89970400)
print v(xbgr.mr_n89976512)
print v(xbgr.mr_n89978880)
print v(xbgr.mr_n89979408)
print v(xbgr.mr_n89979936)
print v(xbgr.mr_n89981200)
print v(xbgr.mr_n89981344)
print v(xbgr.mr_n89984512)
print v(xbgr.mr_n89985248)
print v(xbgr.mr_n89985504)
print v(xbgr.mr_n89988144)
print v(xbgr.mr_n89989328)
print v(xbgr.mr_n89989920)
print v(xbgr.mr_n89990512)
print v(xbgr.mr_n89991696)
print v(xbgr.mr_n89992288)
print v(xbgr.mr_n89992880)
print v(xbgr.mr_n89993472)
print v(xbgr.mr_n89994064)
print v(xbgr.mr_n89994656)
print v(xbgr.mr_n89994992)
print v(xbgr.mr_n89995248)
print v(xbgr.mr_n89995840)
print v(xbgr.mr_n89996432)
print v(xbgr.mr_n89996960)
print v(xbgr.mr_n89997616)
print v(xbgr.mr_n89998208)
print v(xbgr.mr_n89998800)
print v(xbgr.mr_n89999392)
print v(xbgr.mr_n89999984)
print v(xbgr.mr_n90000576)
print v(xbgr.mr_n90001168)
print v(xbgr.mr_n90001760)
print v(xbgr.mr_n90002272)
print v(xbgr.mr_n90002880)
print v(xbgr.mr_n90003536)
print v(xbgr.mr_n90004192)
print v(xbgr.mr_n90004720)
print v(xbgr.mr_n90005312)
print v(xbgr.mr_n90005904)
print v(xbgr.mr_n90006496)
print v(xbgr.mr_n90007088)
print v(xbgr.mr_n90007616)
print v(xbgr.mr_n90008272)
print v(xbgr.mr_n90009456)
print v(xbgr.mr_n90009968)
print v(xbgr.mr_n90010640)
print v(xbgr.mr_n90011232)
print v(xbgr.mr_n90011824)
print v(xbgr.mr_n90012416)
print v(xbgr.mr_n90013008)
print v(xbgr.mr_n90013600)
print v(xbgr.mr_n90014192)
print v(xbgr.mr_n90014784)
print v(xbgr.mr_n90015200)
print v(xbgr.mr_n90015376)
print v(xbgr.mr_n90015968)
print v(xbgr.mr_n90016560)
print v(xbgr.mr_n90016896)
print v(xbgr.mr_n90017152)
print v(xbgr.mr_n90017744)
print v(xbgr.mr_n90017856)
print v(xbgr.mr_n90018560)
print v(xbgr.mr_n90019184)
print v(xbgr.mr_n90019728)
print v(xbgr.mr_n90020672)
print v(xbgr.mr_n90021552)
print v(xbgr.mr_n90022144)
print v(xbgr.mr_n90022736)
print v(xbgr.mr_n90023328)
print v(xbgr.mr_n90023744)
print v(xbgr.mr_n90023920)
print v(xbgr.mr_n90024512)
print v(xbgr.mr_n90025104)
print v(xbgr.mr_n90025696)
print v(xbgr.mr_n90026288)
print v(xbgr.mr_n90026880)
print v(xbgr.mr_n90027472)
print v(xbgr.mr_n90028064)
print v(xbgr.mr_n90028480)
print v(xbgr.mr_n90028656)
print v(xbgr.mr_n90029248)
print v(xbgr.mr_n90029840)
print v(xbgr.mr_n90030432)
print v(xbgr.mr_n90031024)
print v(xbgr.mr_n90031616)
print v(xbgr.mr_n90032208)
print v(xbgr.mr_n90032800)
print v(xbgr.mr_n90033392)
print v(xbgr.mr_n90033984)
print v(xbgr.mr_n90034576)
print v(xbgr.mr_n90035168)
print v(xbgr.mr_n90035760)
print v(xbgr.mr_n90036352)
print v(xbgr.mr_n90036944)
print v(xbgr.mr_n90037536)
print v(xbgr.mr_n90038128)
print v(xbgr.mr_n90038720)
print v(xbgr.mr_n90039312)
print v(xbgr.mr_n90039728)
print v(xbgr.mr_n90039904)
print v(xbgr.mr_n90040384)
print v(xbgr.mr_n90040560)
print v(xbgr.mr_n90044128)
print v(xbgr.mr_n90044672)
print v(xbgr.mr_n90045664)
print v(xbgr.mr_n90045776)
print v(xbgr.mr_n90045888)
print v(xbgr.mr_n90046000)
print v(xbgr.mr_n90046112)
print v(xbgr.mr_n90046384)
print v(xbgr.mr_n90046656)
print v(xbgr.mr_n90046928)
print v(xbgr.mr_n90047200)
print v(xbgr.mr_n90047472)
print v(xbgr.mr_n90047744)
print v(xbgr.mr_n90048016)
print v(xbgr.mr_n90048288)
print v(xbgr.mr_n90048560)
print v(xbgr.mr_n90048832)
print v(xbgr.mr_n90049104)
print v(xbgr.mr_n90049504)
print v(xbgr.mr_n90049904)
print v(xbgr.mr_n90050304)
print v(xbgr.mr_n90050704)
print v(xbgr.mr_n90051104)
print v(xbgr.mr_n90051504)
print v(xbgr.mr_n90051904)
print v(xbgr.mr_n90052304)
print v(xbgr.mr_n90052704)
print v(xbgr.mr_n90053104)
print v(xbgr.mr_n90053504)
print v(xbgr.mr_n90053904)
print v(xbgr.mr_n90054304)
print v(xbgr.mr_n90054704)
print v(xbgr.mr_n90055104)
print v(xbgr.mr_n90055504)
print v(xbgr.mr_n90055904)
print v(xbgr.mr_n90056304)
print v(xbgr.mr_n90056704)
print v(xbgr.mr_n90057104)
print v(xbgr.mr_n90057504)
print v(xbgr.mr_n90057904)
print v(xbgr.mr_n90058304)
print v(xbgr.mr_n90058704)
print v(xbgr.mr_n90059104)
print v(xbgr.mr_n90059504)
print v(xbgr.mr_n90059904)
print v(xbgr.mr_n90060304)
print v(xbgr.mr_n90060720)
print v(xbgr.mr_n90060992)
print v(xbgr.mr_n90061264)
print v(xbgr.mr_n90061536)
print v(xbgr.mr_n90061808)
print v(xbgr.mr_n90062080)
print v(xbgr.mr_n90062352)
print v(xbgr.mr_n90062624)
print v(xbgr.mr_n90062896)
print v(xbgr.mr_n90063168)
print v(xbgr.mr_n90063440)
print v(xbgr.mr_n90063712)
print v(xbgr.mr_n90063984)
print v(xbgr.mr_n90064256)
print v(xbgr.mr_n90064528)
print v(xbgr.mr_n90064800)
print v(xbgr.mr_n90065072)
print v(xbgr.mr_n90065344)
print v(xbgr.mr_n90065632)
print v(xbgr.mr_n90065824)
print v(xbgr.mr_n90066016)
print v(xbgr.mr_n90066208)
print v(xbgr.mr_n90066400)
print v(xbgr.mr_n90067488)
print v(xbgr.mr_n90067600)
print v(xbgr.mr_n90071008)
print v(xbgr.mr_n90071840)
print v(xbgr.mr_n90071952)
print v(xbgr.mr_n90073360)
print v(xbgr.mr_n90073472)
print v(xbgr.mr_n90073584)
print v(xbgr.mr_n90074416)
print v(xbgr.mr_n90074528)
print v(xbgr.mr_n90075280)
print v(xbgr.mr_n90076768)
print v(xbgr.mr_n90077600)
print v(xbgr.mr_n90077712)
print v(xbgr.mr_n90079120)
print v(xbgr.mr_n90079232)
print v(xbgr.mr_n90079344)
print v(xbgr.mr_n90080176)
print v(xbgr.mr_n90080288)
print v(xbgr.mr_n90081040)
print v(xbgr.mr_n90082528)
print v(xbgr.mr_n90083360)
print v(xbgr.mr_n90083472)
print v(xbgr.mr_n90084880)
print v(xbgr.mr_n90084992)
print v(xbgr.mr_n90085104)
print v(xbgr.mr_n90085936)
print v(xbgr.mr_n90086048)
print v(xbgr.mr_n90086800)
print v(xbgr.mr_n90088288)
print v(xbgr.mr_n90089120)
print v(xbgr.mr_n90089232)
print v(xbgr.mr_n90090640)
print v(xbgr.mr_n90090752)
print v(xbgr.mr_n90090864)
print v(xbgr.mr_n90091696)
print v(xbgr.mr_n90091808)
print v(xbgr.mr_n90092560)
print v(xbgr.mr_n90094048)
print v(xbgr.mr_n90094880)
print v(xbgr.mr_n90094992)
print v(xbgr.mr_n90096400)
print v(xbgr.mr_n90096512)
print v(xbgr.mr_n90096624)
print v(xbgr.mr_n90097456)
print v(xbgr.mr_n90097568)
print v(xbgr.mr_n90098320)
print v(xbgr.mr_n90099808)
print v(xbgr.mr_n90100640)
print v(xbgr.mr_n90100752)
print v(xbgr.mr_n90104304)
print v(xbgr.mr_n90104960)
print v(xbgr.mr_n90105600)
print v(xbgr.mr_n90106128)
print v(xbgr.mr_n90106304)
print v(xbgr.mr_n90106480)
print v(xbgr.mr_n90107264)
print v(xbgr.mr_n90107440)
print v(xbgr.mr_n90108064)
print v(xbgr.mr_n90108240)
print v(xbgr.mr_n90108800)
print v(xbgr.mr_n90109264)
print v(xbgr.mr_n90109440)
print v(xbgr.mr_n90110064)
print v(xbgr.mr_n90110240)
print v(xbgr.mr_n90110928)
print v(xbgr.mr_n90111104)
print v(xbgr.mr_n90111280)
print v(xbgr.mr_n90112000)
print v(xbgr.mr_n90112464)
print v(xbgr.mr_n90112640)
print v(xbgr.mr_n90113264)
print v(xbgr.mr_n90113440)
print v(xbgr.mr_n90114064)
print v(xbgr.mr_n90114240)
print v(xbgr.mr_n90114928)
print v(xbgr.mr_n90115104)
print v(xbgr.mr_n90115360)
print v(xbgr.mr_n90116064)
print v(xbgr.mr_n90116240)
print v(xbgr.mr_n90116800)
print v(xbgr.mr_n90117328)
print v(xbgr.mr_n90117504)
print v(xbgr.mr_n90117680)
print v(xbgr.mr_n90118272)
print v(xbgr.mr_n90118384)
print v(xbgr.mr_n90118496)
print v(xbgr.mr_n90118608)
print v(xbgr.mr_n90118960)
print v(xbgr.mr_n90119072)
print v(xbgr.mr_n90119424)
print v(xbgr.mr_n90119536)
print v(xbgr.mr_n90119888)
print v(xbgr.mr_n90120000)
print v(xbgr.mr_n90120480)
print v(xbgr.mr_n90120656)
print v(xbgr.mr_n90121136)
print v(xbgr.mr_n90121312)
print v(xbgr.mr_n90121792)
print v(xbgr.mr_n90121968)
print v(xbgr.mr_n90122448)
print v(xbgr.mr_n90122624)
print v(xbgr.mr_n90123104)
print v(xbgr.mr_n90123280)
print v(xbgr.mr_n90123760)
print v(xbgr.mr_n90123936)
print v(xbgr.mr_n90124416)
print v(xbgr.mr_n90124592)
print v(xbgr.mr_n90125072)
print v(xbgr.mr_n90125248)
print v(xbgr.mr_n90125728)
print v(xbgr.mr_n90125904)
print v(xbgr.mr_n90126384)
print v(xbgr.mr_n90126560)
print v(xbgr.mr_n90127040)
print v(xbgr.mr_n90127216)
print v(xbgr.mr_n90127696)
print v(xbgr.mr_n90127872)
print v(xbgr.mr_n90128352)
print v(xbgr.mr_n90128528)
print v(xbgr.mr_n90129184)
print v(xbgr.mr_n90129840)
print v(xbgr.mr_n90130320)
print v(xbgr.mr_n90130496)
print v(xbgr.mr_n90130976)
print v(xbgr.mr_n90131152)
print v(xbgr.mr_n90131504)
print v(xbgr.mr_n90131616)
print v(xbgr.mr_n90131808)
print v(xbgr.mr_n90132080)
print v(xbgr.mr_n90132352)
print v(xbgr.mr_n90132624)
print v(xbgr.mr_n90132896)
print v(xbgr.mr_n90133168)
print v(xbgr.mr_n90133360)
print v(xbgr.mr_n90133552)
print v(xbgr.mr_n90133744)
print v(xbgr.mr_n90133936)
print v(xbgr.mr_n90134128)
print v(xbgr.mr_n90134960)
print v(xbgr.mr_n90135072)
print v(xbgr.mr_n90135824)
print v(xbgr.mr_n90136576)
print v(xbgr.mr_n90137328)
print v(xbgr.mr_n90138272)
print v(xbgr.mr_n90139536)
print v(xbgr.mr_n90140800)
print v(xbgr.mr_n90142064)
print v(xbgr.mr_n90143328)
print v(xbgr.mr_n90144592)
print v(xbgr.mr_n90145856)
print v(xbgr.mr_n90147120)
print v(xbgr.mr_n90148384)
print v(xbgr.mr_n90149648)
print v(xbgr.mr_n90150912)
print v(xbgr.mr_n90152176)
print v(xbgr.mr_n90152976)
print v(xbgr.mr_n90153088)
print v(xbgr.mr_n90153712)
print v(xbgr.mr_n90153824)
print v(xbgr.mr_n90154288)
print v(xbgr.mr_n90154752)
print v(xbgr.mr_n90155216)
print v(xbgr.mr_n90155680)
print v(xbgr.mr_n90156144)
print v(xbgr.mr_n90156608)
print v(xbgr.mr_n90160912)
print v(xbgr.mr_n90161088)
print v(xbgr.mr_n90165072)
print v(xbgr.mr_n90165280)
print v(xbgr.mr_n90165536)
print v(xbgr.mr_n90168592)
print v(xbgr.mr_n90169120)
print v(xbgr.mr_n90169232)
print v(xbgr.mr_n90169424)
print v(xbgr.mr_n90170512)
print v(xbgr.mr_n90170624)
print v(xbgr.mr_n90172448)
print v(xbgr.mr_n90173536)
print v(xbgr.mr_n90173648)
print v(xbgr.mr_n90174528)
print v(xbgr.mr_n90175472)
print v(xbgr.mr_n90176560)
print v(xbgr.mr_n90176672)
print v(xbgr.mr_n90178496)
print v(xbgr.mr_n90179584)
print v(xbgr.mr_n90179696)
print v(xbgr.mr_n90181520)
print v(xbgr.mr_n90182608)
print v(xbgr.mr_n90182720)
print v(xbgr.mr_n90183600)
print v(xbgr.mr_n90184544)
print v(xbgr.mr_n90185632)
print v(xbgr.mr_n90185744)
print v(xbgr.mr_n90187568)
print v(xbgr.mr_n90188656)
print v(xbgr.mr_n90188768)
print v(xbgr.mr_n90190592)
print v(xbgr.mr_n90191680)
print v(xbgr.mr_n90191792)
print v(xbgr.mr_n90193616)
print v(xbgr.mr_n90194704)
print v(xbgr.mr_n90194816)
print v(xbgr.mr_n90196144)
print v(xbgr.mr_n90197472)
print v(xbgr.mr_n90198784)
print v(xbgr.mr_n90200112)
print v(xbgr.mr_n90201504)
print v(xbgr.mr_n90203344)
print v(xbgr.mr_n90205184)
print v(xbgr.mr_n90207024)
print v(xbgr.mr_n90214608)
print v(xbgr.mr_n90215248)
print v(xbgr.mr_n90215680)
print v(xbgr.mr_n90215856)
print v(xbgr.mr_n90216112)
print v(xbgr.mr_n90216896)
print v(xbgr.mr_n90217072)
print v(xbgr.mr_n90217760)
print v(xbgr.mr_n90217936)
print v(xbgr.mr_n90218112)
print v(xbgr.mr_n90218368)
print v(xbgr.mr_n90219216)
print v(xbgr.mr_n90219392)
print v(xbgr.mr_n90219568)
print v(xbgr.mr_n90219904)
print v(xbgr.mr_n90220672)
print v(xbgr.mr_n90220848)
print v(xbgr.mr_n90221024)
print v(xbgr.mr_n90221280)
print v(xbgr.mr_n90222128)
print v(xbgr.mr_n90222304)
print v(xbgr.mr_n90222480)
print v(xbgr.mr_n90222736)
print v(xbgr.mr_n90223584)
print v(xbgr.mr_n90223760)
print v(xbgr.mr_n90223936)
print v(xbgr.mr_n90224272)
print v(xbgr.mr_n90225040)
print v(xbgr.mr_n90225216)
print v(xbgr.mr_n90225392)
print v(xbgr.mr_n90225648)
print v(xbgr.mr_n90226240)
print v(xbgr.mr_n90226352)
print v(xbgr.mr_n90226464)
print v(xbgr.mr_n90227088)
print v(xbgr.mr_n90227264)
print v(xbgr.mr_n90227840)
print v(xbgr.mr_n90228352)
print v(xbgr.mr_n90228784)
print v(xbgr.mr_n90228960)
print v(xbgr.mr_n90229296)
print v(xbgr.mr_n90230000)
print v(xbgr.mr_n90230176)
print v(xbgr.mr_n90230608)
print v(xbgr.mr_n90230720)
print v(xbgr.mr_n90230832)
print v(xbgr.mr_n90231456)
print v(xbgr.mr_n90231632)
print v(xbgr.mr_n90232208)
print v(xbgr.mr_n90232912)
print v(xbgr.mr_n90233088)
print v(xbgr.mr_n90233520)
print v(xbgr.mr_n90233632)
print v(xbgr.mr_n90233744)
print v(xbgr.mr_n90234368)
print v(xbgr.mr_n90234544)
print v(xbgr.mr_n90235120)
print v(xbgr.mr_n90235632)
print v(xbgr.mr_n90236064)
print v(xbgr.mr_n90236240)
print v(xbgr.mr_n90236416)
print v(xbgr.mr_n90237520)
print v(xbgr.mr_n90237696)
print v(xbgr.mr_n90237872)
print v(xbgr.mr_n90238464)
print v(xbgr.mr_n90240320)
print v(xbgr.mr_n90243824)
print v(xbgr.mr_n90248816)
print v(xbgr.mr_n90254656)
print v(xbgr.mr_n90256240)
print v(xbgr.mr_n90258800)
print v(xbgr.mr_n90259520)
print v(xbgr.mr_n90262816)
print v(xbgr.mr_n90263424)
print v(xbgr.mr_n90263808)
print v(xbgr.mr_n90264272)
print v(xbgr.mr_n90264736)
print v(xbgr.mr_n90265200)
print v(xbgr.mr_n90265664)
print v(xbgr.mr_n90266128)
print v(xbgr.mr_n90266592)
print v(xbgr.mr_n90267056)
print v(xbgr.mr_n90267520)
print v(xbgr.mr_n90267984)
print v(xbgr.mr_n90268448)
print v(xbgr.mr_n90268912)
print v(xbgr.mr_n90269376)
print v(xbgr.mr_n90269840)
print v(xbgr.mr_n90270304)
print v(xbgr.mr_n90276896)
print v(xbgr.mr_n90277632)
print v(xbgr.mr_n90278640)
print v(xbgr.mr_n90280960)
print v(xbgr.mr_n90281552)
print v(xbgr.mr_n90282304)
print v(xbgr.mr_n90282816)
print v(xbgr.mr_n90288528)
print v(xbgr.mr_n90289952)
print v(xbgr.mr_n90290064)
print v(xbgr.mr_n90290816)
print v(xbgr.mr_n90293904)
print v(xbgr.mr_n90296256)
print v(xbgr.mr_n90296368)
print v(xbgr.mr_n90296528)
print v(xbgr.mr_n90297232)
print v(xbgr.mr_n90298384)
print v(xbgr.mr_n90298848)
print v(xbgr.mr_n90299200)
print v(xbgr.mr_n90302272)
print v(xbgr.mr_n90302384)
print v(xbgr.mr_n90303296)
print v(xbgr.mr_n90303488)
print v(xbgr.mr_n90303840)
print v(xbgr.mr_n90304752)
print v(xbgr.mr_n90305264)
print v(xbgr.mr_n90306048)
print v(xbgr.mr_n90306160)
print v(xbgr.mr_n90306272)
print v(xbgr.mr_n90306864)
print v(xbgr.mr_n90307616)
print v(xbgr.mr_n90308752)
print v(xbgr.mr_n90310080)
print v(xbgr.mr_n90311408)
print v(xbgr.mr_n90312736)
print v(xbgr.mr_n90314064)
print v(xbgr.mr_n90315392)
print v(xbgr.mr_n90316720)
print v(xbgr.mr_n90318048)
print v(xbgr.mr_n90319856)
print v(xbgr.mr_n90321728)
print v(xbgr.mr_n90323568)
print v(xbgr.mr_n90325408)
print v(xbgr.mr_n90332000)
print v(xbgr.mr_n90332176)
print v(xbgr.mr_n90332736)
print v(xbgr.mr_n90333264)
print v(xbgr.mr_n90333440)
print v(xbgr.mr_n90333616)
print v(xbgr.mr_n90334400)
print v(xbgr.mr_n90334576)
print v(xbgr.mr_n90335136)
print v(xbgr.mr_n90335600)
print v(xbgr.mr_n90335776)
print v(xbgr.mr_n90336304)
print v(xbgr.mr_n90336480)
print v(xbgr.mr_n90336656)
print v(xbgr.mr_n90337376)
print v(xbgr.mr_n90337840)
print v(xbgr.mr_n90338016)
print v(xbgr.mr_n90338704)
print v(xbgr.mr_n90338880)
print v(xbgr.mr_n90339056)
print v(xbgr.mr_n90339776)
print v(xbgr.mr_n90340304)
print v(xbgr.mr_n90340480)
print v(xbgr.mr_n90340736)
print v(xbgr.mr_n90341440)
print v(xbgr.mr_n90341616)
print v(xbgr.mr_n90342176)
print v(xbgr.mr_n90342704)
print v(xbgr.mr_n90342880)
print v(xbgr.mr_n90343136)
print v(xbgr.mr_n90343840)
print v(xbgr.mr_n90344016)
print v(xbgr.mr_n90344448)
print v(xbgr.mr_n90344560)
print v(xbgr.mr_n90344672)
print v(xbgr.mr_n90344784)
print v(xbgr.mr_n90344896)
print v(xbgr.mr_n90345168)
print v(xbgr.mr_n90345440)
print v(xbgr.mr_n90345712)
print v(xbgr.mr_n90345984)
print v(xbgr.mr_n90346256)
print v(xbgr.mr_n90346528)
print v(xbgr.mr_n90346800)
print v(xbgr.mr_n90347072)
print v(xbgr.mr_n90349504)
print v(xbgr.mr_n90351376)
print v(xbgr.mr_n90351840)
print v(xbgr.mr_n90352304)
print v(xbgr.mr_n90352768)
print v(xbgr.mr_n90353232)
print v(xbgr.mr_n90353696)
print v(xbgr.mr_n90354160)
print v(xbgr.mr_n90354624)
print v(xbgr.mr_n90355088)
print v(xbgr.mr_n90355552)
print v(xbgr.mr_n90356016)
print v(xbgr.mr_n90356480)
print v(xbgr.mr_n90356944)
print v(xbgr.mr_n90357408)
print v(xbgr.mr_n90357872)
print v(xbgr.mr_n90358336)
print v(xbgr.mr_n90358800)
print v(xbgr.mr_n90359888)
print v(xbgr.mr_n90363200)
print v(xbgr.mr_n90364096)
print v(xbgr.mr_n90364432)
print v(xbgr.mr_n90365264)
print v(xbgr.mr_n90369936)
print v(xbgr.mr_n90389712)
print v(xbgr.mr_n90391440)
print v(xbgr.mr_n90391632)
print v(xbgr.mr_n90391888)
print v(xbgr.mr_n90392144)
print v(xbgr.mr_n90392400)
print v(xbgr.mr_n90394576)
print v(xbgr.mr_n90394688)
print v(xbgr.mr_n90396864)
print v(xbgr.mr_n90397200)
print v(xbgr.mr_n90398464)
print v(xbgr.mr_n90398576)
print v(xbgr.mr_n90400896)
print v(xbgr.mr_n90401008)
print v(xbgr.mr_n90402336)
print v(xbgr.mr_n90404160)
print v(xbgr.mr_n90404416)
print v(xbgr.mr_n90405760)
print v(xbgr.mr_n90405872)
print v(xbgr.mr_n90408192)
print v(xbgr.mr_n90408304)
print v(xbgr.mr_n90409632)
print v(xbgr.mr_n90411456)
print v(xbgr.mr_n90411792)
print v(xbgr.mr_n90413056)
print v(xbgr.mr_n90413168)
print v(xbgr.mr_n90415488)
print v(xbgr.mr_n90415600)
print v(xbgr.mr_n90416928)
print v(xbgr.mr_n90418752)
print v(xbgr.mr_n90420352)
print v(xbgr.mr_n90420464)
print v(xbgr.mr_n90422784)
print v(xbgr.mr_n90422896)
print v(xbgr.mr_n90423280)
print v(xbgr.mr_n90423392)
print v(xbgr.mr_n90423696)
print v(xbgr.mr_n90424704)
print v(xbgr.mr_n90424896)
print v(xbgr.mr_n90425088)
print v(xbgr.mr_n90426688)
print v(xbgr.mr_n90426800)
print v(xbgr.mr_n90429216)
print v(xbgr.mr_n90429792)
print v(xbgr.mr_n90437552)
print v(xbgr.mr_n90437952)
print v(xbgr.mr_n90438352)
print v(xbgr.mr_n90438752)
print v(xbgr.mr_n90439152)
print v(xbgr.mr_n90439552)
print v(xbgr.mr_n90439952)
print v(xbgr.mr_n90440352)
print v(xbgr.mr_n90440752)
print v(xbgr.mr_n90441152)
print v(xbgr.mr_n90441552)
print v(xbgr.mr_n90441952)
print v(xbgr.mr_n90442352)
print v(xbgr.mr_n90442752)
print v(xbgr.mr_n90443152)
print v(xbgr.mr_n90443424)
print v(xbgr.mr_n90443536)
print v(xbgr.mr_n90443648)
print v(xbgr.mr_n90443760)
print v(xbgr.mr_n90443872)
print v(xbgr.mr_n90444064)
print v(xbgr.mr_n90444336)
print v(xbgr.mr_n90444608)
print v(xbgr.mr_n90444880)
print v(xbgr.mr_n90445152)
print v(xbgr.mr_n90445424)
print v(xbgr.mr_n90445696)
print v(xbgr.mr_n90445968)
print v(xbgr.mr_n90446304)
print v(xbgr.mr_n90446704)
print v(xbgr.mr_n90453264)
print v(xbgr.mr_n90457984)
print v(xbgr.mr_n90458304)
print v(xbgr.mr_n90458448)
print v(xbgr.mr_n90459296)
print v(xbgr.mr_n90459648)
print v(xbgr.mr_n90460256)
print v(xbgr.mr_n90460432)
print v(xbgr.mr_n90461216)
print v(xbgr.mr_n90461760)
print v(xbgr.mr_n90462192)
print v(xbgr.mr_n90462800)
print v(xbgr.mr_n90462976)
print v(xbgr.mr_n90463760)
print v(xbgr.mr_n90464304)
print v(xbgr.mr_n90464736)
print v(xbgr.mr_n90465344)
print v(xbgr.mr_n90465520)
print v(xbgr.mr_n90466304)
print v(xbgr.mr_n90466848)
print v(xbgr.mr_n90467280)
print v(xbgr.mr_n90467888)
print v(xbgr.mr_n90468064)
print v(xbgr.mr_n90468848)
print v(xbgr.mr_n90469392)
print v(xbgr.mr_n90469888)
print v(xbgr.mr_n90470432)
print v(xbgr.mr_n90470608)
print v(xbgr.mr_n90471392)
print v(xbgr.mr_n90471936)
print v(xbgr.mr_n90472432)
print v(xbgr.mr_n90472976)
print v(xbgr.mr_n90473152)
print v(xbgr.mr_n90474000)
print v(xbgr.mr_n90474480)
print v(xbgr.mr_n90474976)
print v(xbgr.mr_n90475520)
print v(xbgr.mr_n90475696)
print v(xbgr.mr_n90476544)
print v(xbgr.mr_n90477024)
print v(xbgr.mr_n90477264)
print v(xbgr.mr_n90477456)
print v(xbgr.mr_n90478064)
print v(xbgr.mr_n90479024)
print v(xbgr.mr_n90479568)
print v(xbgr.mr_n90480000)
print v(xbgr.mr_n90480416)
print v(xbgr.mr_n90480528)
print v(xbgr.mr_n90480720)
print v(xbgr.mr_n90481184)
print v(xbgr.mr_n90481648)
print v(xbgr.mr_n90482112)
print v(xbgr.mr_n90482576)
print v(xbgr.mr_n90488592)
print v(xbgr.mr_n90493904)
print v(xbgr.mr_n90496720)
print v(xbgr.mr_n90496912)
print v(xbgr.mr_n90497168)
print v(xbgr.mr_n90497424)
print v(xbgr.mr_n90497680)
print v(xbgr.mr_n90499856)
print v(xbgr.mr_n90499968)
print v(xbgr.mr_n90501296)
print v(xbgr.mr_n90502624)
print v(xbgr.mr_n90503952)
print v(xbgr.mr_n90505344)
print v(xbgr.mr_n90507184)
print v(xbgr.mr_n90509024)
print v(xbgr.mr_n90510864)
print v(xbgr.mr_n90512704)
print v(xbgr.mr_n90514544)
print v(xbgr.mr_n90516384)
print v(xbgr.mr_n90518224)
print v(xbgr.mr_n90520064)
print v(xbgr.mr_n90521904)
print v(xbgr.mr_n90523744)
print v(xbgr.mr_n90525584)
print v(xbgr.mr_n90527424)
print v(xbgr.mr_n90530528)
print v(xbgr.mr_n90530832)
print v(xbgr.mr_n90531328)
print v(xbgr.mr_n90531632)
print v(xbgr.mr_n90532128)
print v(xbgr.mr_n90532432)
print v(xbgr.mr_n90533248)
print v(xbgr.mr_n90533552)
print v(xbgr.mr_n90534432)
print v(xbgr.mr_n90534736)
print v(xbgr.mr_n90535616)
print v(xbgr.mr_n90535920)
print v(xbgr.mr_n90536800)
print v(xbgr.mr_n90537104)
print v(xbgr.mr_n90537984)
print v(xbgr.mr_n90538288)
print v(xbgr.mr_n90539168)
print v(xbgr.mr_n90539472)
print v(xbgr.mr_n90540352)
print v(xbgr.mr_n90540656)
print v(xbgr.mr_n90541536)
print v(xbgr.mr_n90541840)
print v(xbgr.mr_n90542720)
print v(xbgr.mr_n90543024)
print v(xbgr.mr_n90543904)
print v(xbgr.mr_n90544208)
print v(xbgr.mr_n90545088)
print v(xbgr.mr_n90545392)
print v(xbgr.mr_n90546272)
print v(xbgr.mr_n90546464)
print v(xbgr.mr_n90546736)
print v(xbgr.mr_n90547200)
print v(xbgr.mr_n90548592)
print v(xbgr.mr_n90550560)
print v(xbgr.mr_n90552624)
print v(xbgr.mr_n90558608)
print v(xbgr.mr_n90558880)
print v(xbgr.mr_n90559152)
print v(xbgr.mr_n90559424)
print v(xbgr.mr_n90561392)
print v(xbgr.mr_n90562032)
print v(xbgr.mr_n90562304)
print v(xbgr.mr_n90563536)
print v(xbgr.mr_n90564192)
print v(xbgr.mr_n90564592)
print v(xbgr.mr_n90564992)
print v(xbgr.mr_n90565392)
print v(xbgr.mr_n90565792)
print v(xbgr.mr_n90566192)
print v(xbgr.mr_n90566592)
print v(xbgr.mr_n90566992)
print v(xbgr.mr_n90567392)
print v(xbgr.mr_n90567792)
print v(xbgr.mr_n90568192)
print v(xbgr.mr_n90568592)
print v(xbgr.mr_n90568992)
print v(xbgr.mr_n90570032)
print v(xbgr.mr_n90570416)
print v(xbgr.mr_n90571632)
print v(xbgr.mr_n90574336)
print v(xbgr.mr_n90577088)
print v(xbgr.mr_n90581680)
print v(xbgr.mr_n90587056)
print v(xbgr.mr_n90588544)
print v(xbgr.mr_n90591664)
print v(xbgr.mr_n90596144)
print v(xbgr.mr_n90596448)
print v(xbgr.mr_n90596752)
print v(xbgr.mr_n90597056)
print v(xbgr.mr_n90597440)
print v(xbgr.mr_n90597904)
print v(xbgr.mr_n90598368)
print v(xbgr.mr_n90598832)
print v(xbgr.mr_n90599296)
print v(xbgr.mr_n90599760)
print v(xbgr.mr_n90600224)
print v(xbgr.mr_n90600688)
print v(xbgr.mr_n90601152)
print v(xbgr.mr_n90603328)
print v(xbgr.mr_n90603520)
print v(xbgr.mr_n90603776)
print v(xbgr.mr_n90604032)
print v(xbgr.mr_n90604288)
print v(xbgr.mr_n90606464)
print v(xbgr.mr_n90606576)
print v(xbgr.mr_n90607904)
print v(xbgr.mr_n90609232)
print v(xbgr.mr_n90610560)
print v(xbgr.mr_n90611888)
print v(xbgr.mr_n90613536)
print v(xbgr.mr_n90615376)
print v(xbgr.mr_n90617216)
print v(xbgr.mr_n90619056)
print v(xbgr.mr_n90620896)
print v(xbgr.mr_n90622736)
print v(xbgr.mr_n90624576)
print v(xbgr.mr_n90626416)
print v(xbgr.mr_n90628256)
print v(xbgr.mr_n90630096)
print v(xbgr.mr_n90631936)
print v(xbgr.mr_n90633776)
print v(xbgr.mr_n90638064)
print v(xbgr.mr_n90640432)
print v(xbgr.mr_n90650064)
print v(xbgr.mr_n90657200)
print v(xbgr.mr_n90657312)
print v(xbgr.mr_n90657872)
print v(xbgr.mr_n90658048)
print v(xbgr.mr_n90658544)
print v(xbgr.mr_n90659056)
print v(xbgr.mr_n90659168)
print v(xbgr.mr_n90659728)
print v(xbgr.mr_n90659904)
print v(xbgr.mr_n90660400)
print v(xbgr.mr_n90660912)
print v(xbgr.mr_n90661024)
print v(xbgr.mr_n90661584)
print v(xbgr.mr_n90661760)
print v(xbgr.mr_n90662256)
print v(xbgr.mr_n90662768)
print v(xbgr.mr_n90662880)
print v(xbgr.mr_n90663440)
print v(xbgr.mr_n90663616)
print v(xbgr.mr_n90664112)
print v(xbgr.mr_n90664624)
print v(xbgr.mr_n90664736)
print v(xbgr.mr_n90665296)
print v(xbgr.mr_n90665472)
print v(xbgr.mr_n90665728)
print v(xbgr.mr_n90666480)
print v(xbgr.mr_n90666592)
print v(xbgr.mr_n90667152)
print v(xbgr.mr_n90667328)
print v(xbgr.mr_n90667824)
print v(xbgr.mr_n90668592)
print v(xbgr.mr_n90668768)
print v(xbgr.mr_n90668944)
print v(xbgr.mr_n90669200)
print v(xbgr.mr_n90669792)
print v(xbgr.mr_n90670288)
print v(xbgr.mr_n90670464)
print v(xbgr.mr_n90670640)
print v(xbgr.mr_n90671056)
print v(xbgr.mr_n90671648)
print v(xbgr.mr_n90672144)
print v(xbgr.mr_n90672320)
print v(xbgr.mr_n90672496)
print v(xbgr.mr_n90672992)
print v(xbgr.mr_n90673504)
print v(xbgr.mr_n90673616)
print v(xbgr.mr_n90673728)
print v(xbgr.mr_n90674416)
print v(xbgr.mr_n90674592)
print v(xbgr.mr_n90675248)
print v(xbgr.mr_n90675760)
print v(xbgr.mr_n90675872)
print v(xbgr.mr_n90676432)
print v(xbgr.mr_n90676608)
print v(xbgr.mr_n90677104)
print v(xbgr.mr_n90677616)
print v(xbgr.mr_n90677728)
print v(xbgr.mr_n90678288)
print v(xbgr.mr_n90678464)
print v(xbgr.mr_n90678800)
print v(xbgr.mr_n90679472)
print v(xbgr.mr_n90679584)
print v(xbgr.mr_n90680144)
print v(xbgr.mr_n90680320)
print v(xbgr.mr_n90680736)
print v(xbgr.mr_n90681584)
print v(xbgr.mr_n90681760)
print v(xbgr.mr_n90681936)
print v(xbgr.mr_n90682192)
print v(xbgr.mr_n90682784)
print v(xbgr.mr_n90683280)
print v(xbgr.mr_n90683456)
print v(xbgr.mr_n90683632)
print v(xbgr.mr_n90684128)
print v(xbgr.mr_n90684640)
print v(xbgr.mr_n90685136)
print v(xbgr.mr_n90685312)
print v(xbgr.mr_n90685488)
print v(xbgr.mr_n90685984)
print v(xbgr.mr_n90686496)
print v(xbgr.mr_n90686608)
print v(xbgr.mr_n90686720)
print v(xbgr.mr_n90686832)
print v(xbgr.mr_n90687104)
print v(xbgr.mr_n90687216)
print v(xbgr.mr_n90687488)
print v(xbgr.mr_n90687840)
print v(xbgr.mr_n90687952)
print v(xbgr.mr_n90688224)
print v(xbgr.mr_n90688576)
print v(xbgr.mr_n90688944)
print v(xbgr.mr_n90689280)
print v(xbgr.mr_n90689632)
print v(xbgr.mr_n90689744)
print v(xbgr.mr_n90689936)
print v(xbgr.mr_n90690208)
print v(xbgr.mr_n90695536)
print v(xbgr.mr_n90696000)
print v(xbgr.mr_n90696464)
print v(xbgr.mr_n90696928)
print v(xbgr.mr_n90697392)
print v(xbgr.mr_n90697856)
print v(xbgr.mr_n90698320)
print v(xbgr.mr_n90698784)
print v(xbgr.mr_n90699248)
print v(xbgr.mr_n90699712)
print v(xbgr.mr_n90700176)
print v(xbgr.mr_n90700640)
print v(xbgr.mr_n90701104)
print v(xbgr.mr_n90701568)
print v(xbgr.mr_n90702032)
print v(xbgr.mr_n90702496)
print v(xbgr.mr_n90702960)
print v(xbgr.mr_n90703424)
print v(xbgr.mr_n90703888)
print v(xbgr.mr_n90704352)
print v(xbgr.mr_n90706528)
print v(xbgr.mr_n90712208)
print v(xbgr.mr_n90715344)
print v(xbgr.mr_n90717024)
print v(xbgr.mr_n90719520)
print v(xbgr.mr_n90720080)
print v(xbgr.mr_n90721504)
print v(xbgr.mr_n90725408)
print v(xbgr.mr_n90730464)
print v(xbgr.mr_n90732192)
print v(xbgr.mr_n90736624)
print v(xbgr.mr_n90738688)
print v(xbgr.mr_n90741472)
print v(xbgr.mr_n90741664)
print v(xbgr.mr_n90741920)
print v(xbgr.mr_n90742176)
print v(xbgr.mr_n90742432)
print v(xbgr.mr_n90742880)
print v(xbgr.mr_n90744608)
print v(xbgr.mr_n90748800)
print v(xbgr.mr_n90748912)
print v(xbgr.mr_n90749728)
print v(xbgr.mr_n90754304)
print v(xbgr.mr_n90754416)
print v(xbgr.mr_n90755248)
print v(xbgr.mr_n90755360)
print v(xbgr.mr_n90756560)
print v(xbgr.mr_n90758496)
print v(xbgr.mr_n90759328)
print v(xbgr.mr_n90759440)
print v(xbgr.mr_n90761216)
print v(xbgr.mr_n90761328)
print v(xbgr.mr_n90762160)
print v(xbgr.mr_n90762272)
print v(xbgr.mr_n90763472)
print v(xbgr.mr_n90765408)
print v(xbgr.mr_n90766240)
print v(xbgr.mr_n90766352)
print v(xbgr.mr_n90768128)
print v(xbgr.mr_n90768240)
print v(xbgr.mr_n90769072)
print v(xbgr.mr_n90769184)
print v(xbgr.mr_n90770384)
print v(xbgr.mr_n90772288)
print v(xbgr.mr_n90773120)
print v(xbgr.mr_n90773232)
print v(xbgr.mr_n90775008)
print v(xbgr.mr_n90775120)
print v(xbgr.mr_n90775952)
print v(xbgr.mr_n90776064)
print v(xbgr.mr_n90777264)
print v(xbgr.mr_n90779200)
print v(xbgr.mr_n90780032)
print v(xbgr.mr_n90780144)
print v(xbgr.mr_n90781872)
print v(xbgr.mr_n90781984)
print v(xbgr.mr_n90782096)
print v(xbgr.mr_n90782928)
print v(xbgr.mr_n90783040)
print v(xbgr.mr_n90783984)
print v(xbgr.mr_n90785920)
print v(xbgr.mr_n90786752)
print v(xbgr.mr_n90786864)
print v(xbgr.mr_n90789968)
print v(xbgr.mr_n90791760)
print v(xbgr.mr_n90792416)
print v(xbgr.mr_n90793056)
print v(xbgr.mr_n90793520)
print v(xbgr.mr_n90793696)
print v(xbgr.mr_n90793872)
print v(xbgr.mr_n90794384)
print v(xbgr.mr_n90794816)
print v(xbgr.mr_n90794992)
print v(xbgr.mr_n90795248)
print v(xbgr.mr_n90796032)
print v(xbgr.mr_n90796208)
print v(xbgr.mr_n90796832)
print v(xbgr.mr_n90797008)
print v(xbgr.mr_n90797184)
print v(xbgr.mr_n90797824)
print v(xbgr.mr_n90798288)
print v(xbgr.mr_n90798464)
print v(xbgr.mr_n90799088)
print v(xbgr.mr_n90799264)
print v(xbgr.mr_n90799440)
print v(xbgr.mr_n90800144)
print v(xbgr.mr_n90800320)
print v(xbgr.mr_n90800944)
print v(xbgr.mr_n90801120)
print v(xbgr.mr_n90801296)
print v(xbgr.mr_n90801808)
print v(xbgr.mr_n90802240)
print v(xbgr.mr_n90802416)
print v(xbgr.mr_n90802672)
print v(xbgr.mr_n90803392)
print v(xbgr.mr_n90803856)
print v(xbgr.mr_n90804032)
print v(xbgr.mr_n90804656)
print v(xbgr.mr_n90804832)
print v(xbgr.mr_n90805008)
print v(xbgr.mr_n90805712)
print v(xbgr.mr_n90805888)
print v(xbgr.mr_n90806512)
print v(xbgr.mr_n90806688)
print v(xbgr.mr_n90806864)
print v(xbgr.mr_n90807376)
print v(xbgr.mr_n90807488)
print v(xbgr.mr_n90807600)
print v(xbgr.mr_n90807712)
print v(xbgr.mr_n90807824)
print v(xbgr.mr_n90808096)
print v(xbgr.mr_n90808448)
print v(xbgr.mr_n90808560)
print v(xbgr.mr_n90808672)
print v(xbgr.mr_n90809104)
print v(xbgr.mr_n90809584)
print v(xbgr.mr_n90809760)
print v(xbgr.mr_n90810112)
print v(xbgr.mr_n90810480)
print v(xbgr.mr_n90810816)
print v(xbgr.mr_n90811168)
print v(xbgr.mr_n90811280)
print v(xbgr.mr_n90811776)
print v(xbgr.mr_n90812272)
print v(xbgr.mr_n90812752)
print v(xbgr.mr_n90812928)
print v(xbgr.mr_n90813280)
print v(xbgr.mr_n90813648)
print v(xbgr.mr_n90813984)
print v(xbgr.mr_n90814336)
print v(xbgr.mr_n90814448)
print v(xbgr.mr_n90814944)
print v(xbgr.mr_n90815440)
print v(xbgr.mr_n90815920)
print v(xbgr.mr_n90816096)
print v(xbgr.mr_n90816448)
print v(xbgr.mr_n90816816)
print v(xbgr.mr_n90817152)
print v(xbgr.mr_n90817504)
print v(xbgr.mr_n90819536)
print v(xbgr.mr_n90819920)
print v(xbgr.mr_n90820384)
print v(xbgr.mr_n90820848)
print v(xbgr.mr_n90821312)
print v(xbgr.mr_n90821776)
print v(xbgr.mr_n90822240)
print v(xbgr.mr_n90822704)
print v(xbgr.mr_n90823168)
print v(xbgr.mr_n90823632)
print v(xbgr.mr_n90824096)
print v(xbgr.mr_n90824560)
print v(xbgr.mr_n90825024)
print v(xbgr.mr_n90825488)
print v(xbgr.mr_n90825952)
print v(xbgr.mr_n90826416)
print v(xbgr.mr_n90826880)
print v(xbgr.mr_n90827344)
print v(xbgr.mr_n90827808)
print v(xbgr.mr_n90828272)
print v(xbgr.mr_n90838112)
print v(xbgr.mr_n90842176)
print v(xbgr.mr_n90842448)
print v(xbgr.mr_n90849344)
print v(xbgr.mr_n90850464)
print v(xbgr.mr_n90853728)
print v(xbgr.mr_n90858832)
print v(xbgr.mr_n90859040)
print v(xbgr.mr_n90859232)
print v(xbgr.mr_n90859504)
print v(xbgr.mr_n90859680)
print v(xbgr.mr_n90859824)
print v(xbgr.mr_n90860096)
print v(xbgr.mr_n90860672)
print v(xbgr.mr_n90860944)
print v(xbgr.mr_n90861216)
print v(xbgr.mr_n90861488)
print v(xbgr.mr_n90861760)
print v(xbgr.mr_n90862144)
print v(xbgr.mr_n90862448)
print v(xbgr.mr_n90862704)
print v(xbgr.mr_n90863040)
print v(xbgr.mr_n90864112)
print v(xbgr.mr_n90865104)
print v(xbgr.mr_n90865216)
print v(xbgr.mr_n90865328)
print v(xbgr.mr_n90865440)
print v(xbgr.mr_n90866272)
print v(xbgr.mr_n90866384)
print v(xbgr.mr_n90867584)
print v(xbgr.mr_n90870256)
print v(xbgr.mr_n90871088)
print v(xbgr.mr_n90871200)
print v(xbgr.mr_n90872400)
print v(xbgr.mr_n90873728)
print v(xbgr.mr_n90875056)
print v(xbgr.mr_n90876384)
print v(xbgr.mr_n90877840)
print v(xbgr.mr_n90879680)
print v(xbgr.mr_n90881520)
print v(xbgr.mr_n90884352)
print v(xbgr.mr_n90884624)
print v(xbgr.mr_n90886080)
print v(xbgr.mr_n90887552)
print v(xbgr.mr_n90890976)
print v(xbgr.mr_n90892048)
print v(xbgr.mr_n90892480)
print v(xbgr.mr_n90892656)
print v(xbgr.mr_n90892912)
print v(xbgr.mr_n90893696)
print v(xbgr.mr_n90893872)
print v(xbgr.mr_n90894496)
print v(xbgr.mr_n90894672)
print v(xbgr.mr_n90894864)
print v(xbgr.mr_n90895296)
print v(xbgr.mr_n90895472)
print v(xbgr.mr_n90896096)
print v(xbgr.mr_n90896272)
print v(xbgr.mr_n90896896)
print v(xbgr.mr_n90897072)
print v(xbgr.mr_n90897696)
print v(xbgr.mr_n90897872)
print v(xbgr.mr_n90898496)
print v(xbgr.mr_n90898672)
print v(xbgr.mr_n90899232)
print v(xbgr.mr_n90899664)
print v(xbgr.mr_n90900016)
print v(xbgr.mr_n90900144)
print v(xbgr.mr_n90900368)
print v(xbgr.mr_n90901136)
print v(xbgr.mr_n90902256)
print v(xbgr.mr_n90904752)
print v(xbgr.mr_n90905616)
print v(xbgr.mr_n90906208)
print v(xbgr.mr_n90906416)
print v(xbgr.mr_n90907040)
print v(xbgr.mr_n90907600)
print v(xbgr.mr_n90908752)
print v(xbgr.mr_n90908864)
print v(xbgr.mr_n90911280)
print v(xbgr.mr_n90912208)
print v(xbgr.mr_n90913360)
print v(xbgr.mr_n90914576)
print v(xbgr.mr_n90916240)
print v(xbgr.mr_n90917168)
print v(xbgr.mr_n90918544)
print v(xbgr.mr_n90921264)
print v(xbgr.mr_n90922160)
print v(xbgr.mr_n90922400)
print v(xbgr.mr_n90922896)
print v(xbgr.mr_n90923472)
print v(xbgr.mr_n90923632)
print v(xbgr.mr_n90924032)
print v(xbgr.mr_n90925344)
print v(xbgr.mr_n90925456)
print v(xbgr.mr_n90925648)
print v(xbgr.mr_n90926704)
print v(xbgr.mr_n90927088)
print v(xbgr.mr_n90927376)
print v(xbgr.mr_n90928144)
print v(xbgr.mr_n90928336)
print v(xbgr.mr_n90928528)
print v(xbgr.mr_n90928720)
print v(xbgr.mr_n90928992)
print v(xbgr.mr_n90929264)
print v(xbgr.mr_n90929616)
print v(xbgr.mr_n90929728)
print v(xbgr.mr_n90930928)
print v(xbgr.mr_n90933600)
print v(xbgr.mr_n90934912)
print v(xbgr.mr_n90935024)
print v(xbgr.mr_n90935136)
print v(xbgr.mr_n90936256)
print v(xbgr.mr_n90936752)
print v(xbgr.mr_n90936944)
print v(xbgr.mr_n90938704)
print v(xbgr.mr_n90939136)
print v(xbgr.mr_n90939392)
print v(xbgr.mr_n90939584)
print v(xbgr.mr_n90939792)
print v(xbgr.mr_n90940192)
print v(xbgr.mr_n90940832)
print v(xbgr.mr_n90940944)
print v(xbgr.mr_n90942048)
print v(xbgr.mr_n90942160)
print v(xbgr.mr_n90942272)
print v(xbgr.mr_n90942384)
print v(xbgr.mr_n90943088)
print v(xbgr.mr_n90943728)
print v(xbgr.mr_n90944048)
print v(xbgr.mr_n90944160)
print v(xbgr.mr_n90944272)
print v(xbgr.mr_n90946384)
print v(xbgr.mr_n90947968)
print v(xbgr.mr_n90948080)
print v(xbgr.mr_n90949792)
print v(xbgr.mr_n90949968)
print v(xbgr.mr_n90950080)
print v(xbgr.mr_n90950400)
print v(xbgr.mr_n90950592)
print v(xbgr.mr_n90951120)
print v(xbgr.mr_n90951408)
print v(xbgr.mr_n90952528)
print v(xbgr.mr_n90952720)
print v(xbgr.mr_n90952912)
print v(xbgr.mr_n90953264)
print v(xbgr.mr_n90953376)
print v(xbgr.mr_n90954704)
print v(xbgr.mr_n90955312)
print v(xbgr.mr_n90955952)
print v(xbgr.mr_n90957280)
print v(xbgr.mr_n90957616)
print v(xbgr.mr_n90957888)
print v(xbgr.mr_n90958640)
print v(xbgr.mr_n90959616)
print v(xbgr.mr_n90959728)
print v(xbgr.mr_n90959840)
print v(xbgr.mr_n90959952)
print v(xbgr.mr_n90960064)
print v(xbgr.mr_n90960176)
print v(xbgr.mr_n90960288)
print v(xbgr.mr_n90960400)
print v(xbgr.mr_n90960512)
print v(xbgr.mr_n90960864)
print v(xbgr.mr_n90960976)
print v(xbgr.mr_n90961328)
print v(xbgr.mr_n90961440)
print v(xbgr.mr_n90961840)
print v(xbgr.mr_n90962192)
print v(xbgr.mr_n90962624)
print v(xbgr.mr_n90962928)
print v(xbgr.mr_n90963488)
print v(xbgr.mr_n90966128)
print v(xbgr.mr_n90969632)
print v(xbgr.mr_n90970480)
print v(xbgr.mr_n90970592)
print v(xbgr.mr_n90971520)
print v(xbgr.mr_n90971712)
print v(xbgr.mr_n90972592)
print v(xbgr.mr_n90973504)
print v(xbgr.mr_n90974112)
print v(xbgr.mr_n90974256)
print v(xbgr.mr_n90974384)
print v(xbgr.mr_n90975040)
print v(xbgr.mr_n90975248)
print v(xbgr.mr_n90975440)
print v(xbgr.mr_n90975856)
print v(xbgr.mr_n90976288)
print v(xbgr.mr_n90976816)
print v(xbgr.mr_n90977296)
print v(xbgr.mr_n90977920)
print v(xbgr.mr_n90978032)
print v(xbgr.mr_n90978368)
print v(xbgr.mr_n90978656)
print v(xbgr.mr_n90978976)
print v(xbgr.mr_n90979088)
print v(xbgr.mr_n90979584)
print v(xbgr.mr_n90979696)
print v(xbgr.mr_n90979888)
print v(xbgr.mr_n90980000)
print v(xbgr.mr_n90980112)
print v(xbgr.mr_n90981408)
print v(xbgr.mr_n90988240)
print v(xbgr.mr_n90990304)
print v(xbgr.mr_n90991120)
print v(xbgr.mr_n90992080)
print v(xbgr.mr_n90992496)
print v(xbgr.mr_n90993008)
print v(xbgr.mr_n90993712)
print v(xbgr.mr_n90994016)
print v(xbgr.mr_n90996720)
print v(xbgr.mr_n90997728)
print v(xbgr.mr_n91000432)
print v(xbgr.mr_n91000848)
print v(xbgr.mr_n91001136)
print v(xbgr.mr_n91007456)
print v(xbgr.mr_n91007792)
print v(xbgr.mr_n91007968)
print v(xbgr.mr_n91008128)
print v(xbgr.mr_n91008720)
print v(xbgr.mr_n91009072)
print v(xbgr.mr_n91009184)
print v(xbgr.mr_n91009296)
print v(xbgr.mr_n91009408)
print v(xbgr.mr_n91009760)
print v(xbgr.mr_n91010112)
print v(xbgr.mr_n91010224)
print v(xbgr.mr_n91010576)
print v(xbgr.mr_n91010688)
print v(xbgr.mr_n91011024)
print v(xbgr.mr_n91011216)
print v(xbgr.mr_n91011488)
print v(xbgr.mr_n91011600)
print v(xbgr.mr_n91011760)
print v(xbgr.mr_n91012032)
print v(xbgr.mr_n91013536)
print v(xbgr.mr_n91015136)
print v(xbgr.mr_n91015248)
print v(xbgr.mr_n91015760)
print v(xbgr.mr_n91017824)
print v(xbgr.mr_n91018464)
print v(xbgr.mr_n91018576)
print v(xbgr.mr_n91018688)
print v(xbgr.mr_n91018800)
print v(xbgr.mr_n91018912)
print v(xbgr.mr_n91019024)
print v(xbgr.mr_n91019136)
print v(xbgr.mr_n91021664)
print v(xbgr.mr_n91022000)
print v(xbgr.mr_n91022368)
print v(xbgr.mr_n91022720)
print v(xbgr.mr_n91022912)
print v(xbgr.mr_n91023264)
print v(xbgr.mr_n91023824)
print v(xbgr.mr_n91024016)
print v(xbgr.mr_n91024208)
print v(xbgr.mr_n91024400)
print v(xbgr.mr_n91025360)
print v(xbgr.mr_n91025776)
print v(xbgr.mr_n91027040)
print v(xbgr.mr_n91027472)
print v(xbgr.mr_n91027776)
print v(xbgr.mr_n91028336)
print v(xbgr.mr_n91028752)
print v(xbgr.mr_n91029120)
print v(xbgr.mr_n91029536)
print v(xbgr.mr_n91029968)
print v(xbgr.mr_n91030432)
print v(xbgr.mr_n91030784)
print v(xbgr.mr_n91031216)
print v(xbgr.mr_n91031520)
print v(xbgr.mr_n91032080)
print v(xbgr.mr_n91032496)
print v(xbgr.mr_n91032928)
print v(xbgr.mr_n91033280)
print v(xbgr.mr_n91033456)
print v(xbgr.mr_n91033712)
print v(xbgr.mr_n91034176)
print v(xbgr.mr_n91034528)
print v(xbgr.mr_n91034960)
print v(xbgr.mr_n91035264)
print v(xbgr.mr_n91035824)
print v(xbgr.mr_n91036240)
print v(xbgr.mr_n91036736)
print v(xbgr.mr_n91037008)
print v(xbgr.mr_n91037440)
print v(xbgr.mr_n91037904)
print v(xbgr.mr_n91038256)
print v(xbgr.mr_n91038688)
print v(xbgr.mr_n91038992)
print v(xbgr.mr_n91039616)
print v(xbgr.mr_n91039968)
print v(xbgr.mr_n91040080)
print v(xbgr.mr_n91040272)
print v(xbgr.mr_n91040544)
print v(xbgr.mr_n91040816)
print v(xbgr.mr_n91041088)
print v(xbgr.mr_n91041360)
print v(xbgr.mr_n91041632)
print v(xbgr.mr_n91041904)
print v(xbgr.mr_n91042176)
print v(xbgr.mr_n91042448)
print v(xbgr.mr_n91042720)
print v(xbgr.mr_n91042992)
print v(xbgr.mr_n91043264)
print v(xbgr.mr_n91043536)
print v(xbgr.mr_n91043808)
print v(xbgr.mr_n91044080)
print v(xbgr.mr_n91044544)
print v(xbgr.mr_n91050128)
print v(xbgr.mr_n91050592)
print v(xbgr.mr_n91051056)
print v(xbgr.mr_n91051520)
print v(xbgr.mr_n91051984)
print v(xbgr.mr_n91052448)
print v(xbgr.mr_n91052912)
print v(xbgr.mr_n91053376)
print v(xbgr.mr_n91061424)
print v(xbgr.mr_n91063168)
print v(xbgr.mr_n91065024)
print v(xbgr.mr_n91066544)
print v(xbgr.mr_n91066800)
print v(xbgr.mr_n91067696)
print v(xbgr.mr_n91069248)
print v(xbgr.mr_n91073344)
print v(xbgr.mr_n91078512)
print v(xbgr.mr_n91081584)
print v(xbgr.mr_n91083648)
print v(xbgr.mr_n91086320)
print v(xbgr.mr_n91087808)
print v(xbgr.mr_n91088000)
print v(xbgr.mr_n91088256)
print v(xbgr.mr_n91088512)
print v(xbgr.mr_n91088768)
print v(xbgr.mr_n91090944)
print v(xbgr.mr_n91091056)
print v(xbgr.mr_n91095696)
print v(xbgr.mr_n91096336)
print v(xbgr.mr_n91096448)
print v(xbgr.mr_n91096560)
print v(xbgr.mr_n91098064)
print v(xbgr.mr_n91098768)
print v(xbgr.mr_n91098880)
print v(xbgr.mr_n91099120)
print v(xbgr.mr_n91099232)
print v(xbgr.mr_n91099344)
print v(xbgr.mr_n91099456)
print v(xbgr.mr_n91099808)
print v(xbgr.mr_n91101280)
print v(xbgr.mr_n91102048)
print v(xbgr.mr_n91103104)
print v(xbgr.mr_n91103664)
print v(xbgr.mr_n91104800)
print v(xbgr.mr_n91105488)
print v(xbgr.mr_n91105968)
print v(xbgr.mr_n91106400)
print v(xbgr.mr_n91106816)
print v(xbgr.mr_n91107504)
print v(xbgr.mr_n91108032)
print v(xbgr.mr_n91108384)
print v(xbgr.mr_n91108816)
print v(xbgr.mr_n91109504)
print v(xbgr.mr_n91110128)
print v(xbgr.mr_n91110672)
print v(xbgr.mr_n91111168)
print v(xbgr.mr_n91111520)
print v(xbgr.mr_n91112208)
print v(xbgr.mr_n91112736)
print v(xbgr.mr_n91113088)
print v(xbgr.mr_n91113520)
print v(xbgr.mr_n91114208)
print v(xbgr.mr_n91114832)
print v(xbgr.mr_n91115376)
print v(xbgr.mr_n91115808)
print v(xbgr.mr_n91116224)
print v(xbgr.mr_n91116912)
print v(xbgr.mr_n91117792)
print v(xbgr.mr_n91118224)
print v(xbgr.mr_n91118912)
print v(xbgr.mr_n91119600)
print v(xbgr.mr_n91120080)
print v(xbgr.mr_n91120512)
print v(xbgr.mr_n91120928)
print v(xbgr.mr_n91121616)
print v(xbgr.mr_n91122144)
print v(xbgr.mr_n91122496)
print v(xbgr.mr_n91122928)
print v(xbgr.mr_n91123616)
print v(xbgr.mr_n91124160)
print v(xbgr.mr_n91124784)
print v(xbgr.mr_n91125216)
print v(xbgr.mr_n91125632)
print v(xbgr.mr_n91126320)
print v(xbgr.mr_n91126848)
print v(xbgr.mr_n91127200)
print v(xbgr.mr_n91127632)
print v(xbgr.mr_n91127824)
print v(xbgr.mr_n91128096)
print v(xbgr.mr_n91128368)
print v(xbgr.mr_n91128640)
print v(xbgr.mr_n91128912)
print v(xbgr.mr_n91129184)
print v(xbgr.mr_n91129456)
print v(xbgr.mr_n91129728)
print v(xbgr.mr_n91130000)
print v(xbgr.mr_n91130272)
print v(xbgr.mr_n91130544)
print v(xbgr.mr_n91130816)
print v(xbgr.mr_n91131088)
print v(xbgr.mr_n91133776)
print v(xbgr.mr_n91138880)
print v(xbgr.mr_n91143104)
print v(xbgr.mr_n91147984)
print v(xbgr.mr_n91149008)
print v(xbgr.mr_n91149584)
print v(xbgr.mr_n91150736)
print v(xbgr.mr_n91151936)
print v(xbgr.mr_n91155808)
print v(xbgr.mr_n91156272)
print v(xbgr.mr_n91156736)
print v(xbgr.mr_n91157200)
print v(xbgr.mr_n91157664)
print v(xbgr.mr_n91158576)
print v(xbgr.mr_n91160848)
print v(xbgr.mr_n91164688)
print v(xbgr.mr_n91185248)
print v(xbgr.mr_n91187488)
print v(xbgr.mr_n91188944)
print v(xbgr.mr_n91193024)
print v(xbgr.mr_n91193216)
print v(xbgr.mr_n91193472)
print v(xbgr.mr_n91193728)
print v(xbgr.mr_n91193984)
print v(xbgr.mr_n91194432)
print v(xbgr.mr_n91196160)
print v(xbgr.mr_n91196272)
print v(xbgr.mr_n91199008)
print v(xbgr.mr_n91199392)
print v(xbgr.mr_n91199648)
print v(xbgr.mr_n91200256)
print v(xbgr.mr_n91202112)
print v(xbgr.mr_n91202784)
print v(xbgr.mr_n91202896)
print v(xbgr.mr_n91203136)
print v(xbgr.mr_n91207280)
print v(xbgr.mr_n91207392)
print v(xbgr.mr_n91207504)
print v(xbgr.mr_n91209344)
print v(xbgr.mr_n91209456)
print v(xbgr.mr_n91209568)
print v(xbgr.mr_n91211408)
print v(xbgr.mr_n91211520)
print v(xbgr.mr_n91211632)
print v(xbgr.mr_n91213472)
print v(xbgr.mr_n91213584)
print v(xbgr.mr_n91213696)
print v(xbgr.mr_n91215200)
print v(xbgr.mr_n91215792)
print v(xbgr.mr_n91215904)
print v(xbgr.mr_n91216016)
print v(xbgr.mr_n91217600)
print v(xbgr.mr_n91218112)
print v(xbgr.mr_n91218224)
print v(xbgr.mr_n91218336)
print v(xbgr.mr_n91219760)
print v(xbgr.mr_n91220432)
print v(xbgr.mr_n91220544)
print v(xbgr.mr_n91220656)
print v(xbgr.mr_n91222160)
print v(xbgr.mr_n91222752)
print v(xbgr.mr_n91222864)
print v(xbgr.mr_n91222976)
print v(xbgr.mr_n91223536)
print v(xbgr.mr_n91224560)
print v(xbgr.mr_n91225072)
print v(xbgr.mr_n91225184)
print v(xbgr.mr_n91225296)
print v(xbgr.mr_n91226880)
print v(xbgr.mr_n91227392)
print v(xbgr.mr_n91227504)
print v(xbgr.mr_n91227616)
print v(xbgr.mr_n91228960)
print v(xbgr.mr_n91229712)
print v(xbgr.mr_n91229824)
print v(xbgr.mr_n91229936)
print v(xbgr.mr_n91231520)
print v(xbgr.mr_n91232032)
print v(xbgr.mr_n91232144)
print v(xbgr.mr_n91232256)
print v(xbgr.mr_n91232784)
print v(xbgr.mr_n91232896)
print v(xbgr.mr_n91233840)
print v(xbgr.mr_n91234912)
print v(xbgr.mr_n91235040)
print v(xbgr.mr_n91235152)
print v(xbgr.mr_n91235504)
print v(xbgr.mr_n91236176)
print v(xbgr.mr_n91236528)
print v(xbgr.mr_n91236640)
print v(xbgr.mr_n91236912)
print v(xbgr.mr_n91237360)
print v(xbgr.mr_n91237536)
print v(xbgr.mr_n91237888)
print v(xbgr.mr_n91238064)
print v(xbgr.mr_n91239136)
print v(xbgr.mr_n91239824)
print v(xbgr.mr_n91240304)
print v(xbgr.mr_n91240800)
print v(xbgr.mr_n91241152)
print v(xbgr.mr_n91241840)
print v(xbgr.mr_n91242368)
print v(xbgr.mr_n91242720)
print v(xbgr.mr_n91243152)
print v(xbgr.mr_n91243840)
print v(xbgr.mr_n91244464)
print v(xbgr.mr_n91245008)
print v(xbgr.mr_n91245504)
print v(xbgr.mr_n91245856)
print v(xbgr.mr_n91246544)
print v(xbgr.mr_n91247072)
print v(xbgr.mr_n91247424)
print v(xbgr.mr_n91247856)
print v(xbgr.mr_n91248544)
print v(xbgr.mr_n91249168)
print v(xbgr.mr_n91249712)
print v(xbgr.mr_n91250144)
print v(xbgr.mr_n91250560)
print v(xbgr.mr_n91251248)
print v(xbgr.mr_n91251712)
print v(xbgr.mr_n91252128)
print v(xbgr.mr_n91252560)
print v(xbgr.mr_n91253248)
print v(xbgr.mr_n91253872)
print v(xbgr.mr_n91254416)
print v(xbgr.mr_n91254912)
print v(xbgr.mr_n91255264)
print v(xbgr.mr_n91255952)
print v(xbgr.mr_n91256480)
print v(xbgr.mr_n91256832)
print v(xbgr.mr_n91257264)
print v(xbgr.mr_n91257952)
print v(xbgr.mr_n91258640)
print v(xbgr.mr_n91258992)
print v(xbgr.mr_n91259104)
print v(xbgr.mr_n91259296)
print v(xbgr.mr_n91259568)
print v(xbgr.mr_n91259840)
print v(xbgr.mr_n91260112)
print v(xbgr.mr_n91260384)
print v(xbgr.mr_n91260656)
print v(xbgr.mr_n91260928)
print v(xbgr.mr_n91261200)
print v(xbgr.mr_n91261472)
print v(xbgr.mr_n91261744)
print v(xbgr.mr_n91262016)
print v(xbgr.mr_n91262288)
print v(xbgr.mr_n91262560)
print v(xbgr.mr_n91262832)
print v(xbgr.mr_n91263104)
print v(xbgr.mr_n91263376)
print v(xbgr.mr_n91267152)
print v(xbgr.mr_n91267984)
print v(xbgr.mr_n91271824)
print v(xbgr.mr_n91277520)
print v(xbgr.mr_n91281248)
print v(xbgr.mr_n91281712)
print v(xbgr.mr_n91282176)
print v(xbgr.mr_n91282640)
print v(xbgr.mr_n91283104)
print v(xbgr.mr_n91283568)
print v(xbgr.mr_n91284032)
print v(xbgr.mr_n91284560)
print v(xbgr.mr_n91285152)
print v(xbgr.mr_n91285744)
print v(xbgr.mr_n91286336)
print v(xbgr.mr_n91286928)
print v(xbgr.mr_n91287520)
print v(xbgr.mr_n91288112)
print v(xbgr.mr_n91288704)
print v(xbgr.mr_n91289296)
print v(xbgr.mr_n91289888)
print v(xbgr.mr_n91298592)
print v(xbgr.mr_n91304544)
print v(xbgr.mr_n91305440)
print v(xbgr.mr_n91316816)
print v(xbgr.mr_n91320864)
print v(xbgr.mr_n91321056)
print v(xbgr.mr_n91321312)
print v(xbgr.mr_n91321568)
print v(xbgr.mr_n91321824)
print v(xbgr.mr_n91322352)
print v(xbgr.mr_n91324256)
print v(xbgr.mr_n91324368)
print v(xbgr.mr_n91327040)
print v(xbgr.mr_n91327616)
print v(xbgr.mr_n91328896)
print v(xbgr.mr_n91329440)
print v(xbgr.mr_n91333680)
print v(xbgr.mr_n91333792)
print v(xbgr.mr_n91333904)
print v(xbgr.mr_n91335744)
print v(xbgr.mr_n91335856)
print v(xbgr.mr_n91335968)
print v(xbgr.mr_n91337808)
print v(xbgr.mr_n91337920)
print v(xbgr.mr_n91338032)
print v(xbgr.mr_n91339872)
print v(xbgr.mr_n91339984)
print v(xbgr.mr_n91340096)
print v(xbgr.mr_n91341936)
print v(xbgr.mr_n91342048)
print v(xbgr.mr_n91342160)
print v(xbgr.mr_n91344000)
print v(xbgr.mr_n91344112)
print v(xbgr.mr_n91344224)
print v(xbgr.mr_n91346064)
print v(xbgr.mr_n91346176)
print v(xbgr.mr_n91346288)
print v(xbgr.mr_n91348128)
print v(xbgr.mr_n91348240)
print v(xbgr.mr_n91348352)
print v(xbgr.mr_n91350192)
print v(xbgr.mr_n91350304)
print v(xbgr.mr_n91350416)
print v(xbgr.mr_n91352256)
print v(xbgr.mr_n91352368)
print v(xbgr.mr_n91352480)
print v(xbgr.mr_n91354320)
print v(xbgr.mr_n91354432)
print v(xbgr.mr_n91354544)
print v(xbgr.mr_n91356384)
print v(xbgr.mr_n91356496)
print v(xbgr.mr_n91356608)
print v(xbgr.mr_n91358448)
print v(xbgr.mr_n91358560)
print v(xbgr.mr_n91358672)
print v(xbgr.mr_n91360512)
print v(xbgr.mr_n91360624)
print v(xbgr.mr_n91360736)
print v(xbgr.mr_n91362576)
print v(xbgr.mr_n91362688)
print v(xbgr.mr_n91362800)
print v(xbgr.mr_n91364640)
print v(xbgr.mr_n91364752)
print v(xbgr.mr_n91364864)
print v(xbgr.mr_n91366704)
print v(xbgr.mr_n91366816)
print v(xbgr.mr_n91366928)
print v(xbgr.mr_n91367040)
print v(xbgr.mr_n91367312)
print v(xbgr.mr_n91367424)
print v(xbgr.mr_n91367776)
print v(xbgr.mr_n91367888)
print v(xbgr.mr_n91368208)
print v(xbgr.mr_n91368704)
print v(xbgr.mr_n91369024)
print v(xbgr.mr_n91369136)
print v(xbgr.mr_n91369440)
print v(xbgr.mr_n91369552)
print v(xbgr.mr_n91369664)
print v(xbgr.mr_n91369776)
print v(xbgr.mr_n91369888)
print v(xbgr.mr_n91371232)
print v(xbgr.mr_n91371584)
print v(xbgr.mr_n91372016)
print v(xbgr.mr_n91372320)
print v(xbgr.mr_n91372944)
print v(xbgr.mr_n91373296)
print v(xbgr.mr_n91373664)
print v(xbgr.mr_n91374624)
print v(xbgr.mr_n91376208)
print v(xbgr.mr_n91376672)
print v(xbgr.mr_n91377088)
print v(xbgr.mr_n91377520)
print v(xbgr.mr_n91378208)
print v(xbgr.mr_n91378832)
print v(xbgr.mr_n91379376)
print v(xbgr.mr_n91379872)
print v(xbgr.mr_n91380224)
print v(xbgr.mr_n91380912)
print v(xbgr.mr_n91381376)
print v(xbgr.mr_n91381792)
print v(xbgr.mr_n91382224)
print v(xbgr.mr_n91382912)
print v(xbgr.mr_n91383600)
print v(xbgr.mr_n91384080)
print v(xbgr.mr_n91384576)
print v(xbgr.mr_n91384928)
print v(xbgr.mr_n91385616)
print v(xbgr.mr_n91386144)
print v(xbgr.mr_n91386496)
print v(xbgr.mr_n91386928)
print v(xbgr.mr_n91387616)
print v(xbgr.mr_n91387952)
print v(xbgr.mr_n91388720)
print v(xbgr.mr_n91388832)
print v(xbgr.mr_n91389024)
print v(xbgr.mr_n91389296)
print v(xbgr.mr_n91389568)
print v(xbgr.mr_n91389840)
print v(xbgr.mr_n91390112)
print v(xbgr.mr_n91390384)
print v(xbgr.mr_n91390656)
print v(xbgr.mr_n91390928)
print v(xbgr.mr_n91391200)
print v(xbgr.mr_n91391472)
print v(xbgr.mr_n91391744)
print v(xbgr.mr_n91392016)
print v(xbgr.mr_n91392288)
print v(xbgr.mr_n91392560)
print v(xbgr.mr_n91392832)
print v(xbgr.mr_n91393104)
print v(xbgr.mr_n91398528)
print v(xbgr.mr_n91412480)
print v(xbgr.mr_n91416992)
print v(xbgr.mr_n91417456)
print v(xbgr.mr_n91417920)
print v(xbgr.mr_n91418384)
print v(xbgr.mr_n91418848)
print v(xbgr.mr_n91419312)
print v(xbgr.mr_n91419776)
print v(xbgr.mr_n91420304)
print v(xbgr.mr_n91420896)
print v(xbgr.mr_n91421488)
print v(xbgr.mr_n91422080)
print v(xbgr.mr_n91422672)
print v(xbgr.mr_n91423264)
print v(xbgr.mr_n91423856)
print v(xbgr.mr_n91424448)
print v(xbgr.mr_n91425040)
print v(xbgr.mr_n91425632)
print v(xbgr.mr_n91432352)
print v(xbgr.mr_n91434832)
print v(xbgr.mr_n91438432)
print v(xbgr.mr_n91446512)
print v(xbgr.mr_n91448624)
print v(xbgr.mr_n91449936)
print v(xbgr.mr_n91450112)
print v(xbgr.mr_n91450448)
print v(xbgr.mr_n91452320)
print v(xbgr.mr_n91452912)
print v(xbgr.mr_n91453504)
print v(xbgr.mr_n91454096)
print v(xbgr.mr_n91454688)
print v(xbgr.mr_n91455280)
print v(xbgr.mr_n91455872)
print v(xbgr.mr_n91456464)
print v(xbgr.mr_n91457056)
print v(xbgr.mr_n91457648)
print v(xbgr.mr_n91458240)
print v(xbgr.mr_n91458832)
print v(xbgr.mr_n91459424)
print v(xbgr.mr_n91460016)
print v(xbgr.mr_n91460608)
print v(xbgr.mr_n91461200)
print v(xbgr.mr_n91461792)
print v(xbgr.mr_n91462384)
print v(xbgr.mr_n91462976)
print v(xbgr.mr_n91464224)
print v(xbgr.mr_n91466128)
print v(xbgr.mr_n91468144)
print v(xbgr.mr_n91469392)
print v(xbgr.mr_n91470064)
print v(xbgr.mr_n91470544)
print v(xbgr.mr_n91470976)
print v(xbgr.mr_n91471392)
print v(xbgr.mr_n91471504)
print v(xbgr.mr_n91471616)
print v(xbgr.mr_n91472512)
print v(xbgr.mr_n91472624)
print v(xbgr.mr_n91474624)
print v(xbgr.mr_n91475184)
print v(xbgr.mr_n91475296)
print v(xbgr.mr_n91475408)
print v(xbgr.mr_n91476304)
print v(xbgr.mr_n91476416)
print v(xbgr.mr_n91478976)
print v(xbgr.mr_n91479088)
print v(xbgr.mr_n91479200)
print v(xbgr.mr_n91480096)
print v(xbgr.mr_n91480208)
print v(xbgr.mr_n91482768)
print v(xbgr.mr_n91482880)
print v(xbgr.mr_n91482992)
print v(xbgr.mr_n91483888)
print v(xbgr.mr_n91484000)
print v(xbgr.mr_n91486560)
print v(xbgr.mr_n91486672)
print v(xbgr.mr_n91486784)
print v(xbgr.mr_n91487680)
print v(xbgr.mr_n91487792)
print v(xbgr.mr_n91490352)
print v(xbgr.mr_n91490464)
print v(xbgr.mr_n91490576)
print v(xbgr.mr_n91491472)
print v(xbgr.mr_n91491584)
print v(xbgr.mr_n91492672)
print v(xbgr.mr_n91493712)
print v(xbgr.mr_n91494144)
print v(xbgr.mr_n91494256)
print v(xbgr.mr_n91494368)
print v(xbgr.mr_n91495264)
print v(xbgr.mr_n91495376)
print v(xbgr.mr_n91497936)
print v(xbgr.mr_n91498048)
print v(xbgr.mr_n91498160)
print v(xbgr.mr_n91499056)
print v(xbgr.mr_n91499168)
print v(xbgr.mr_n91501728)
print v(xbgr.mr_n91501840)
print v(xbgr.mr_n91501952)
print v(xbgr.mr_n91502848)
print v(xbgr.mr_n91502960)
print v(xbgr.mr_n91503552)
print v(xbgr.mr_n91504144)
print v(xbgr.mr_n91505696)
print v(xbgr.mr_n91507824)
print v(xbgr.mr_n91509152)
print v(xbgr.mr_n91509856)
print v(xbgr.mr_n91510080)
print v(xbgr.mr_n91511024)
print v(xbgr.mr_n91511136)
print v(xbgr.mr_n91514416)
print v(xbgr.mr_n91515376)
print v(xbgr.mr_n91521408)
print v(xbgr.mr_n91522032)
print v(xbgr.mr_n91522208)
print v(xbgr.mr_n91522832)
print v(xbgr.mr_n91523008)
print v(xbgr.mr_n91523632)
print v(xbgr.mr_n91523808)
print v(xbgr.mr_n91524432)
print v(xbgr.mr_n91524608)
print v(xbgr.mr_n91525232)
print v(xbgr.mr_n91525408)
print v(xbgr.mr_n91526032)
print v(xbgr.mr_n91526208)
print v(xbgr.mr_n91526832)
print v(xbgr.mr_n91527008)
print v(xbgr.mr_n91527632)
print v(xbgr.mr_n91527808)
print v(xbgr.mr_n91528432)
print v(xbgr.mr_n91528608)
print v(xbgr.mr_n91529232)
print v(xbgr.mr_n91529408)
print v(xbgr.mr_n91530032)
print v(xbgr.mr_n91530208)
print v(xbgr.mr_n91530832)
print v(xbgr.mr_n91531008)
print v(xbgr.mr_n91531632)
print v(xbgr.mr_n91531808)
print v(xbgr.mr_n91532432)
print v(xbgr.mr_n91532608)
print v(xbgr.mr_n91533232)
print v(xbgr.mr_n91533408)
print v(xbgr.mr_n91533840)
print v(xbgr.mr_n91533952)
print v(xbgr.mr_n91534064)
print v(xbgr.mr_n91534176)
print v(xbgr.mr_n91534368)
print v(xbgr.mr_n91534640)
print v(xbgr.mr_n91534912)
print v(xbgr.mr_n91535184)
print v(xbgr.mr_n91535456)
print v(xbgr.mr_n91535728)
print v(xbgr.mr_n91536000)
print v(xbgr.mr_n91536272)
print v(xbgr.mr_n91536544)
print v(xbgr.mr_n91536816)
print v(xbgr.mr_n91537088)
print v(xbgr.mr_n91537360)
print v(xbgr.mr_n91537632)
print v(xbgr.mr_n91539616)
print v(xbgr.mr_n91541776)
print v(xbgr.mr_n91545744)
print v(xbgr.mr_n91553632)
print v(xbgr.mr_n91555536)
print v(xbgr.mr_n91572624)
print v(xbgr.mr_n91578928)
print v(xbgr.mr_n91579104)
print v(xbgr.mr_n91579440)
print v(xbgr.mr_n91579936)
print v(xbgr.mr_n91581376)
print v(xbgr.mr_n91581552)
print v(xbgr.mr_n91582496)
print v(xbgr.mr_n91583152)
print v(xbgr.mr_n91583328)
print v(xbgr.mr_n91584272)
print v(xbgr.mr_n91584928)
print v(xbgr.mr_n91585104)
print v(xbgr.mr_n91586048)
print v(xbgr.mr_n91586704)
print v(xbgr.mr_n91586880)
print v(xbgr.mr_n91587824)
print v(xbgr.mr_n91588480)
print v(xbgr.mr_n91588656)
print v(xbgr.mr_n91589600)
print v(xbgr.mr_n91590256)
print v(xbgr.mr_n91590432)
print v(xbgr.mr_n91591376)
print v(xbgr.mr_n91592032)
print v(xbgr.mr_n91592208)
print v(xbgr.mr_n91593152)
print v(xbgr.mr_n91593808)
print v(xbgr.mr_n91593984)
print v(xbgr.mr_n91594928)
print v(xbgr.mr_n91595584)
print v(xbgr.mr_n91595760)
print v(xbgr.mr_n91596704)
print v(xbgr.mr_n91597360)
print v(xbgr.mr_n91597536)
print v(xbgr.mr_n91598576)
print v(xbgr.mr_n91598848)
print v(xbgr.mr_n91599120)
print v(xbgr.mr_n91599456)
print v(xbgr.mr_n91599920)
print v(xbgr.mr_n91600112)
print v(xbgr.mr_n91600304)
print v(xbgr.mr_n91600496)
print v(xbgr.mr_n91600688)
print v(xbgr.mr_n91600880)
print v(xbgr.mr_n91601712)
print v(xbgr.mr_n91601824)
print v(xbgr.mr_n91605088)
print v(xbgr.mr_n91605200)
print v(xbgr.mr_n91605312)
print v(xbgr.mr_n91605824)
print v(xbgr.mr_n91605936)
print v(xbgr.mr_n91607664)
print v(xbgr.mr_n91607776)
print v(xbgr.mr_n91607888)
print v(xbgr.mr_n91608720)
print v(xbgr.mr_n91608832)
print v(xbgr.mr_n91611392)
print v(xbgr.mr_n91611504)
print v(xbgr.mr_n91611616)
print v(xbgr.mr_n91612512)
print v(xbgr.mr_n91612624)
print v(xbgr.mr_n91615184)
print v(xbgr.mr_n91615296)
print v(xbgr.mr_n91615408)
print v(xbgr.mr_n91616304)
print v(xbgr.mr_n91616416)
print v(xbgr.mr_n91617568)
print v(xbgr.mr_n91618976)
print v(xbgr.mr_n91619088)
print v(xbgr.mr_n91619200)
print v(xbgr.mr_n91620096)
print v(xbgr.mr_n91620208)
print v(xbgr.mr_n91622768)
print v(xbgr.mr_n91622880)
print v(xbgr.mr_n91622992)
print v(xbgr.mr_n91623888)
print v(xbgr.mr_n91624000)
print v(xbgr.mr_n91625088)
print v(xbgr.mr_n91626560)
print v(xbgr.mr_n91626672)
print v(xbgr.mr_n91626784)
print v(xbgr.mr_n91627680)
print v(xbgr.mr_n91627792)
print v(xbgr.mr_n91630352)
print v(xbgr.mr_n91630464)
print v(xbgr.mr_n91630576)
print v(xbgr.mr_n91631472)
print v(xbgr.mr_n91631584)
print v(xbgr.mr_n91634144)
print v(xbgr.mr_n91634256)
print v(xbgr.mr_n91634368)
print v(xbgr.mr_n91635264)
print v(xbgr.mr_n91635376)
print v(xbgr.mr_n91637936)
print v(xbgr.mr_n91638048)
print v(xbgr.mr_n91638160)
print v(xbgr.mr_n91639056)
print v(xbgr.mr_n91639168)
print v(xbgr.mr_n91640432)
print v(xbgr.mr_n91641392)
print v(xbgr.mr_n91642800)
print v(xbgr.mr_n91644704)
print v(xbgr.mr_n91646048)
print v(xbgr.mr_n91650832)
print v(xbgr.mr_n91651008)
print v(xbgr.mr_n91651632)
print v(xbgr.mr_n91651808)
print v(xbgr.mr_n91652432)
print v(xbgr.mr_n91652608)
print v(xbgr.mr_n91653232)
print v(xbgr.mr_n91653408)
print v(xbgr.mr_n91654032)
print v(xbgr.mr_n91654208)
print v(xbgr.mr_n91654832)
print v(xbgr.mr_n91655008)
print v(xbgr.mr_n91655632)
print v(xbgr.mr_n91655808)
print v(xbgr.mr_n91656432)
print v(xbgr.mr_n91656608)
print v(xbgr.mr_n91657232)
print v(xbgr.mr_n91657408)
print v(xbgr.mr_n91658032)
print v(xbgr.mr_n91658208)
print v(xbgr.mr_n91658832)
print v(xbgr.mr_n91659008)
print v(xbgr.mr_n91659632)
print v(xbgr.mr_n91659808)
print v(xbgr.mr_n91660432)
print v(xbgr.mr_n91660608)
print v(xbgr.mr_n91661232)
print v(xbgr.mr_n91661408)
print v(xbgr.mr_n91662032)
print v(xbgr.mr_n91662208)
print v(xbgr.mr_n91664960)
print v(xbgr.mr_n91669616)
print v(xbgr.mr_n91672752)
print v(xbgr.mr_n91673056)
print v(xbgr.mr_n91673360)
print v(xbgr.mr_n91673664)
print v(xbgr.mr_n91674048)
print v(xbgr.mr_n91674512)
print v(xbgr.mr_n91674976)
print v(xbgr.mr_n91675440)
print v(xbgr.mr_n91675904)
print v(xbgr.mr_n91676368)
print v(xbgr.mr_n91676832)
print v(xbgr.mr_n91677296)
print v(xbgr.mr_n91677760)
print v(xbgr.mr_n91678224)
print v(xbgr.mr_n91678688)
print v(xbgr.mr_n91679152)
print v(xbgr.mr_n91679616)
print v(xbgr.mr_n91680080)
print v(xbgr.mr_n91680544)
print v(xbgr.mr_n91681008)
print v(xbgr.mr_n91681472)
print v(xbgr.mr_n91681936)
print v(xbgr.mr_n91682400)
print v(xbgr.mr_n91682864)
print v(xbgr.mr_n91683328)
print v(xbgr.mr_n91683792)
print v(xbgr.mr_n91684256)
print v(xbgr.mr_n91684720)
print v(xbgr.mr_n91685184)
print v(xbgr.mr_n91685648)
print v(xbgr.mr_n91685760)
print v(xbgr.mr_n91695232)
print v(xbgr.mr_n91703696)
print v(xbgr.mr_n91703952)
print v(xbgr.mr_n91705280)
print v(xbgr.mr_n91710240)
print v(xbgr.mr_n91710704)
print v(xbgr.mr_n91711168)
print v(xbgr.mr_n91711696)
print v(xbgr.mr_n91712288)
print v(xbgr.mr_n91712880)
print v(xbgr.mr_n91713472)
print v(xbgr.mr_n91714064)
print v(xbgr.mr_n91714656)
print v(xbgr.mr_n91715248)
print v(xbgr.mr_n91715840)
print v(xbgr.mr_n91716432)
print v(xbgr.mr_n91717024)
print v(xbgr.mr_n91717616)
print v(xbgr.mr_n91718208)
print v(xbgr.mr_n91718800)
print v(xbgr.mr_n91719392)
print v(xbgr.mr_n91723488)
print v(xbgr.mr_n91724432)
print v(xbgr.mr_n91724816)
print v(xbgr.mr_n91730496)
print v(xbgr.mr_n91742032)
print v(xbgr.mr_n91742912)
print v(xbgr.mr_n91743104)
print v(xbgr.mr_n91743360)
print v(xbgr.mr_n91743616)
print v(xbgr.mr_n91743872)
print v(xbgr.mr_n91746304)
print v(xbgr.mr_n91746416)
print v(xbgr.mr_n91748256)
print v(xbgr.mr_n91750096)
print v(xbgr.mr_n91751936)
print v(xbgr.mr_n91753776)
print v(xbgr.mr_n91755616)
print v(xbgr.mr_n91757456)
print v(xbgr.mr_n91759296)
print v(xbgr.mr_n91761136)
print v(xbgr.mr_n91762976)
print v(xbgr.mr_n91764816)
print v(xbgr.mr_n91766656)
print v(xbgr.mr_n91768496)
print v(xbgr.mr_n91772176)
print v(xbgr.mr_n91774016)
print v(xbgr.mr_n91776112)
print v(xbgr.mr_n91779488)
print v(xbgr.mr_n91791440)
print v(xbgr.mr_n91795488)
print v(xbgr.mr_n91797376)
print v(xbgr.mr_n91799776)
print v(xbgr.mr_n91800640)
print v(xbgr.mr_n91800832)
print v(xbgr.mr_n91801088)
print v(xbgr.mr_n91802064)
print v(xbgr.mr_n91803152)
print v(xbgr.mr_n91805712)
print v(xbgr.mr_n91806016)
print v(xbgr.mr_n91806256)
print v(xbgr.mr_n91806624)
print v(xbgr.mr_n91807536)
print v(xbgr.mr_n91808144)
print v(xbgr.mr_n91808752)
print v(xbgr.mr_n91809664)
print v(xbgr.mr_n91811488)
print v(xbgr.mr_n91812384)
print v(xbgr.mr_n91812912)
print v(xbgr.mr_n91813632)
print v(xbgr.mr_n91814144)
print v(xbgr.mr_n91814752)
print v(xbgr.mr_n91815360)
print v(xbgr.mr_n91817760)
print v(xbgr.mr_n91818176)
print v(xbgr.mr_n91818464)
print v(xbgr.mr_n91818688)
print v(xbgr.mr_n91820736)
print v(xbgr.mr_n91822576)
print v(xbgr.mr_n91825056)
print v(xbgr.mr_n91826320)
print v(xbgr.mr_n91826688)
print v(xbgr.mr_n91828016)
print v(xbgr.mr_n91828576)
print v(xbgr.mr_n91828752)
print v(xbgr.mr_n91829168)
print v(xbgr.mr_n91830080)
print v(xbgr.mr_n91830256)
print v(xbgr.mr_n91830432)
print v(xbgr.mr_n91830768)
print v(xbgr.mr_n91831744)
print v(xbgr.mr_n91831920)
print v(xbgr.mr_n91832096)
print v(xbgr.mr_n91832592)
print v(xbgr.mr_n91833104)
print v(xbgr.mr_n91833664)
print v(xbgr.mr_n91833840)
print v(xbgr.mr_n91834336)
print v(xbgr.mr_n91834848)
print v(xbgr.mr_n91834960)
print v(xbgr.mr_n91835072)
print v(xbgr.mr_n91836064)
print v(xbgr.mr_n91836240)
print v(xbgr.mr_n91837248)
print v(xbgr.mr_n91837424)
print v(xbgr.mr_n91837600)
print v(xbgr.mr_n91838192)
print v(xbgr.mr_n91838752)
print v(xbgr.mr_n91838928)
print v(xbgr.mr_n91839424)
print v(xbgr.mr_n91839936)
print v(xbgr.mr_n91840048)
print v(xbgr.mr_n91840160)
print v(xbgr.mr_n91841152)
print v(xbgr.mr_n91841488)
print v(xbgr.mr_n91842080)
print v(xbgr.mr_n91842576)
print v(xbgr.mr_n91842752)
print v(xbgr.mr_n91843088)
print v(xbgr.mr_n91844000)
print v(xbgr.mr_n91844176)
print v(xbgr.mr_n91844432)
print v(xbgr.mr_n91845024)
print v(xbgr.mr_n91845136)
print v(xbgr.mr_n91845248)
print v(xbgr.mr_n91846240)
print v(xbgr.mr_n91846656)
print v(xbgr.mr_n91847168)
print v(xbgr.mr_n91847664)
print v(xbgr.mr_n91847840)
print v(xbgr.mr_n91848176)
print v(xbgr.mr_n91848768)
print v(xbgr.mr_n91849328)
print v(xbgr.mr_n91849504)
print v(xbgr.mr_n91849920)
print v(xbgr.mr_n91850512)
print v(xbgr.mr_n91850624)
print v(xbgr.mr_n91851328)
print v(xbgr.mr_n91851664)
print v(xbgr.mr_n91852256)
print v(xbgr.mr_n91852752)
print v(xbgr.mr_n91852928)
print v(xbgr.mr_n91853104)
print v(xbgr.mr_n91853856)
print v(xbgr.mr_n91854416)
print v(xbgr.mr_n91854592)
print v(xbgr.mr_n91855088)
print v(xbgr.mr_n91855600)
print v(xbgr.mr_n91855712)
print v(xbgr.mr_n91855824)
print v(xbgr.mr_n91856176)
print v(xbgr.mr_n91856288)
print v(xbgr.mr_n91856800)
print v(xbgr.mr_n91856912)
print v(xbgr.mr_n91857024)
print v(xbgr.mr_n91857248)
print v(xbgr.mr_n91858064)
print v(xbgr.mr_n91858496)
print v(xbgr.mr_n91858672)
print v(xbgr.mr_n91859408)
print v(xbgr.mr_n91859840)
print v(xbgr.mr_n91860016)
print v(xbgr.mr_n91860752)
print v(xbgr.mr_n91861184)
print v(xbgr.mr_n91861360)
print v(xbgr.mr_n91862096)
print v(xbgr.mr_n91862528)
print v(xbgr.mr_n91862704)
print v(xbgr.mr_n91863440)
print v(xbgr.mr_n91863872)
print v(xbgr.mr_n91864048)
print v(xbgr.mr_n91864784)
print v(xbgr.mr_n91865216)
print v(xbgr.mr_n91865392)
print v(xbgr.mr_n91866128)
print v(xbgr.mr_n91866560)
print v(xbgr.mr_n91866736)
print v(xbgr.mr_n91867472)
print v(xbgr.mr_n91867904)
print v(xbgr.mr_n91868080)
print v(xbgr.mr_n91868816)
print v(xbgr.mr_n91869248)
print v(xbgr.mr_n91869424)
print v(xbgr.mr_n91870160)
print v(xbgr.mr_n91870656)
print v(xbgr.mr_n91871392)
print v(xbgr.mr_n91871824)
print v(xbgr.mr_n91872000)
print v(xbgr.mr_n91872736)
print v(xbgr.mr_n91873168)
print v(xbgr.mr_n91873344)
print v(xbgr.mr_n91874080)
print v(xbgr.mr_n91874512)
print v(xbgr.mr_n91874688)
print v(xbgr.mr_n91875424)
print v(xbgr.mr_n91875856)
print v(xbgr.mr_n91876032)
print v(xbgr.mr_n91876768)
print v(xbgr.mr_n91877200)
print v(xbgr.mr_n91877376)
print v(xbgr.mr_n91878112)
print v(xbgr.mr_n91878544)
print v(xbgr.mr_n91878720)
print v(xbgr.mr_n91879456)
print v(xbgr.mr_n91879888)
print v(xbgr.mr_n91880064)
print v(xbgr.mr_n91880800)
print v(xbgr.mr_n91881232)
print v(xbgr.mr_n91881408)
print v(xbgr.mr_n91882144)
print v(xbgr.mr_n91882576)
print v(xbgr.mr_n91882752)
print v(xbgr.mr_n91883488)
print v(xbgr.mr_n91883600)
print v(xbgr.mr_n91883792)
print v(xbgr.mr_n91884064)
print v(xbgr.mr_n91884336)
print v(xbgr.mr_n91884608)
print v(xbgr.mr_n91884880)
print v(xbgr.mr_n91885152)
print v(xbgr.mr_n91885424)
print v(xbgr.mr_n91885696)
print v(xbgr.mr_n91885968)
print v(xbgr.mr_n91886240)
print v(xbgr.mr_n91886512)
print v(xbgr.mr_n91886784)
print v(xbgr.mr_n91888272)
print v(xbgr.mr_n91889584)
print v(xbgr.mr_n91889696)
print v(xbgr.mr_n91894784)
print v(xbgr.mr_n91896752)
print v(xbgr.mr_n91897472)
print v(xbgr.mr_n91905216)
print v(xbgr.mr_n91905664)
print v(xbgr.mr_n91910272)
print v(xbgr.mr_n91911136)
print v(xbgr.mr_n91911600)
print v(xbgr.mr_n91912064)
print v(xbgr.mr_n91912528)
print v(xbgr.mr_n91912992)
print v(xbgr.mr_n91913456)
print v(xbgr.mr_n91913920)
print v(xbgr.mr_n91914384)
print v(xbgr.mr_n91915008)
print v(xbgr.mr_n91915984)
print v(xbgr.mr_n91916576)
print v(xbgr.mr_n91917168)
print v(xbgr.mr_n91917760)
print v(xbgr.mr_n91919536)
print v(xbgr.mr_n91932512)
print v(xbgr.mr_n91944624)
print v(xbgr.mr_n91944736)
print v(xbgr.mr_n91947056)
print v(xbgr.mr_n91950832)
print v(xbgr.mr_n91951728)
print v(xbgr.mr_n91954512)
print v(xbgr.mr_n91956464)
print v(xbgr.mr_n91956800)
print v(xbgr.mr_n91957136)
print v(xbgr.mr_n91957472)
print v(xbgr.mr_n91959504)
print v(xbgr.mr_n91960144)
print v(xbgr.mr_n91960256)
print v(xbgr.mr_n91960368)
print v(xbgr.mr_n91960480)
print v(xbgr.mr_n91962320)
print v(xbgr.mr_n91962432)
print v(xbgr.mr_n91962544)
print v(xbgr.mr_n91964384)
print v(xbgr.mr_n91964496)
print v(xbgr.mr_n91964608)
print v(xbgr.mr_n91966448)
print v(xbgr.mr_n91966560)
print v(xbgr.mr_n91966672)
print v(xbgr.mr_n91968512)
print v(xbgr.mr_n91968624)
print v(xbgr.mr_n91968736)
print v(xbgr.mr_n91970576)
print v(xbgr.mr_n91970688)
print v(xbgr.mr_n91970800)
print v(xbgr.mr_n91972640)
print v(xbgr.mr_n91972752)
print v(xbgr.mr_n91972864)
print v(xbgr.mr_n91974704)
print v(xbgr.mr_n91974816)
print v(xbgr.mr_n91974928)
print v(xbgr.mr_n91976768)
print v(xbgr.mr_n91976880)
print v(xbgr.mr_n91976992)
print v(xbgr.mr_n91978832)
print v(xbgr.mr_n91978944)
print v(xbgr.mr_n91979056)
print v(xbgr.mr_n91980896)
print v(xbgr.mr_n91981008)
print v(xbgr.mr_n91981120)
print v(xbgr.mr_n91982960)
print v(xbgr.mr_n91983072)
print v(xbgr.mr_n91983184)
print v(xbgr.mr_n91985024)
print v(xbgr.mr_n91985136)
print v(xbgr.mr_n91985248)
print v(xbgr.mr_n91987088)
print v(xbgr.mr_n91987200)
print v(xbgr.mr_n91987312)
print v(xbgr.mr_n91989152)
print v(xbgr.mr_n91989264)
print v(xbgr.mr_n91989376)
print v(xbgr.mr_n91991216)
print v(xbgr.mr_n91991328)
print v(xbgr.mr_n91991440)
print v(xbgr.mr_n91993280)
print v(xbgr.mr_n91993392)
print v(xbgr.mr_n91993504)
print v(xbgr.mr_n91994352)
print v(xbgr.mr_n91996128)
print v(xbgr.mr_n92002208)
print v(xbgr.mr_n92015264)
print v(xbgr.mr_n92020688)
print v(xbgr.mr_n92025376)
print v(xbgr.mr_n92025488)
print v(xbgr.mr_n92026304)
print v(xbgr.mr_n92026768)
print v(xbgr.mr_n92026880)
print v(xbgr.mr_n92027696)
print v(xbgr.mr_n92028288)
print v(xbgr.mr_n92028464)
print v(xbgr.mr_n92029408)
print v(xbgr.mr_n92030064)
print v(xbgr.mr_n92030240)
print v(xbgr.mr_n92031184)
print v(xbgr.mr_n92031840)
print v(xbgr.mr_n92032016)
print v(xbgr.mr_n92032960)
print v(xbgr.mr_n92033616)
print v(xbgr.mr_n92033792)
print v(xbgr.mr_n92034736)
print v(xbgr.mr_n92035392)
print v(xbgr.mr_n92035568)
print v(xbgr.mr_n92036512)
print v(xbgr.mr_n92037168)
print v(xbgr.mr_n92037344)
print v(xbgr.mr_n92038288)
print v(xbgr.mr_n92038944)
print v(xbgr.mr_n92039120)
print v(xbgr.mr_n92040064)
print v(xbgr.mr_n92040656)
print v(xbgr.mr_n92041248)
print v(xbgr.mr_n92041840)
print v(xbgr.mr_n92042432)
print v(xbgr.mr_n92043024)
print v(xbgr.mr_n92043616)
print v(xbgr.mr_n92043728)
print v(xbgr.mr_n92044208)
print v(xbgr.mr_n92044800)
print v(xbgr.mr_n92045248)
print v(xbgr.mr_n92045360)
print v(xbgr.mr_n92045472)
print v(xbgr.mr_n92045584)
print v(xbgr.mr_n92046240)
print v(xbgr.mr_n92046512)
print v(xbgr.mr_n92047712)
print v(xbgr.mr_n92048784)
print v(xbgr.mr_n92049376)
print v(xbgr.mr_n92049968)
print v(xbgr.mr_n92050560)
print v(xbgr.mr_n92051152)
print v(xbgr.mr_n92051744)
print v(xbgr.mr_n92052336)
print v(xbgr.mr_n92052928)
print v(xbgr.mr_n92053520)
print v(xbgr.mr_n92054112)
print v(xbgr.mr_n92054704)
print v(xbgr.mr_n92055296)
print v(xbgr.mr_n92055888)
print v(xbgr.mr_n92056480)
print v(xbgr.mr_n92057072)
print v(xbgr.mr_n92057664)
print v(xbgr.mr_n92060480)
print v(xbgr.mr_n92065680)
print v(xbgr.mr_n92069600)
print v(xbgr.mr_n92079856)
print v(xbgr.mr_n92080192)
print v(xbgr.mr_n92080768)
print v(xbgr.mr_n92081360)
print v(xbgr.mr_n92081472)
print v(xbgr.mr_n92081584)
print v(xbgr.mr_n92081696)
print v(xbgr.mr_n92083536)
print v(xbgr.mr_n92083648)
print v(xbgr.mr_n92083760)
print v(xbgr.mr_n92085600)
print v(xbgr.mr_n92085712)
print v(xbgr.mr_n92085824)
print v(xbgr.mr_n92087664)
print v(xbgr.mr_n92087776)
print v(xbgr.mr_n92087888)
print v(xbgr.mr_n92089728)
print v(xbgr.mr_n92089840)
print v(xbgr.mr_n92089952)
print v(xbgr.mr_n92091792)
print v(xbgr.mr_n92091904)
print v(xbgr.mr_n92092016)
print v(xbgr.mr_n92093856)
print v(xbgr.mr_n92093968)
print v(xbgr.mr_n92094080)
print v(xbgr.mr_n92095920)
print v(xbgr.mr_n92096032)
print v(xbgr.mr_n92096144)
print v(xbgr.mr_n92097984)
print v(xbgr.mr_n92098096)
print v(xbgr.mr_n92098208)
print v(xbgr.mr_n92100048)
print v(xbgr.mr_n92100160)
print v(xbgr.mr_n92100272)
print v(xbgr.mr_n92102112)
print v(xbgr.mr_n92102224)
print v(xbgr.mr_n92102336)
print v(xbgr.mr_n92102448)
print v(xbgr.mr_n92104432)
print v(xbgr.mr_n92104544)
print v(xbgr.mr_n92104656)
print v(xbgr.mr_n92104768)
print v(xbgr.mr_n92106752)
print v(xbgr.mr_n92106864)
print v(xbgr.mr_n92106976)
print v(xbgr.mr_n92107088)
print v(xbgr.mr_n92109072)
print v(xbgr.mr_n92109184)
print v(xbgr.mr_n92109296)
print v(xbgr.mr_n92109408)
print v(xbgr.mr_n92111392)
print v(xbgr.mr_n92111504)
print v(xbgr.mr_n92111616)
print v(xbgr.mr_n92111728)
print v(xbgr.mr_n92113712)
print v(xbgr.mr_n92113824)
print v(xbgr.mr_n92113936)
print v(xbgr.mr_n92114048)
print v(xbgr.mr_n92116032)
print v(xbgr.mr_n92116144)
print v(xbgr.mr_n92116256)
print v(xbgr.mr_n92116368)
print v(xbgr.mr_n92117632)
print v(xbgr.mr_n92118176)
print v(xbgr.mr_n92118720)
print v(xbgr.mr_n92119264)
print v(xbgr.mr_n92119808)
print v(xbgr.mr_n92120352)
print v(xbgr.mr_n92120896)
print v(xbgr.mr_n92121440)
print v(xbgr.mr_n92121984)
print v(xbgr.mr_n92122528)
print v(xbgr.mr_n92123072)
print v(xbgr.mr_n92123616)
print v(xbgr.mr_n92124160)
print v(xbgr.mr_n92124704)
print v(xbgr.mr_n92125248)
print v(xbgr.mr_n92125792)
print v(xbgr.mr_n92126336)
print v(xbgr.mr_n92126880)
print v(xbgr.mr_n92127424)
print v(xbgr.mr_n92127968)
print v(xbgr.mr_n92128512)
print v(xbgr.mr_n92129056)
print v(xbgr.mr_n92129600)
print v(xbgr.mr_n92130144)
print v(xbgr.mr_n92130688)
print v(xbgr.mr_n92131232)
print v(xbgr.mr_n92131776)
print v(xbgr.mr_n92132192)
print v(xbgr.mr_n92132304)
print v(xbgr.mr_n92132496)
print v(xbgr.mr_n92132768)
print v(xbgr.mr_n92133040)
print v(xbgr.mr_n92133312)
print v(xbgr.mr_n92133584)
print v(xbgr.mr_n92133856)
print v(xbgr.mr_n92134128)
print v(xbgr.mr_n92134400)
print v(xbgr.mr_n92134800)
print v(xbgr.mr_n92135264)
print v(xbgr.mr_n92135728)
print v(xbgr.mr_n92136192)
print v(xbgr.mr_n92136656)
print v(xbgr.mr_n92137120)
print v(xbgr.mr_n92137584)
print v(xbgr.mr_n92138048)
print v(xbgr.mr_n92138512)
print v(xbgr.mr_n92138976)
print v(xbgr.mr_n92139440)
print v(xbgr.mr_n92139904)
print v(xbgr.mr_n92140368)
print v(xbgr.mr_n92140864)
print v(xbgr.mr_n92141456)
print v(xbgr.mr_n92142048)
print v(xbgr.mr_n92142640)
print v(xbgr.mr_n92143232)
print v(xbgr.mr_n92143824)
print v(xbgr.mr_n92144416)
print v(xbgr.mr_n92146608)
print v(xbgr.mr_n92148112)
print v(xbgr.mr_n92148560)
print v(xbgr.mr_n92150432)
print v(xbgr.mr_n92152720)
print v(xbgr.mr_n92155152)
print v(xbgr.mr_n92158304)
print v(xbgr.mr_n92159584)
print v(xbgr.mr_n92161632)
print v(xbgr.mr_n92163808)
print v(xbgr.mr_n92165056)
print v(xbgr.mr_n92168432)
print v(xbgr.mr_n92168608)
print v(xbgr.mr_n92169760)
print v(xbgr.mr_n92170384)
print v(xbgr.mr_n92171888)
print v(xbgr.mr_n92174624)
print v(xbgr.mr_n92176416)
print v(xbgr.mr_n92178272)
print v(xbgr.mr_n92178448)
print v(xbgr.mr_n92178656)
print v(xbgr.mr_n92181472)
print v(xbgr.mr_n92181984)
print v(xbgr.mr_n92182160)
print v(xbgr.mr_n92184016)
print v(xbgr.mr_n92186192)
print v(xbgr.mr_n92187456)
print v(xbgr.mr_n92191504)
print v(xbgr.mr_n92203088)
print v(xbgr.mr_n92205840)
print v(xbgr.mr_n92211280)
print v(xbgr.mr_n92212224)
print v(xbgr.mr_n92213216)
print v(xbgr.mr_n92213776)
print v(xbgr.mr_n92214160)
print v(xbgr.mr_n92216128)
print v(xbgr.mr_n92217568)
print v(xbgr.mr_n92221904)
print v(xbgr.mr_n92223872)
print v(xbgr.mr_n92228304)
print v(xbgr.mr_n92229680)
print v(xbgr.mr_n92231120)
print v(xbgr.mr_n92232912)
print v(xbgr.mr_n92234560)
print v(xbgr.mr_n92234736)
print v(xbgr.mr_n92234912)
print v(xbgr.mr_n92236816)
print v(xbgr.mr_n92236992)
print v(xbgr.mr_n92237168)
print v(xbgr.mr_n92241424)
print v(xbgr.mr_n92246208)
print v(xbgr.mr_n92246736)
print v(xbgr.mr_n92247584)
print v(xbgr.mr_n92248576)
print v(xbgr.mr_n92248816)
print v(xbgr.mr_n92248992)
print v(xbgr.mr_n92249408)
print v(xbgr.mr_n92250672)
print v(xbgr.mr_n92251536)
print v(xbgr.mr_n92255104)
print v(xbgr.mr_n92259504)
print v(xbgr.mr_n92259840)
print v(xbgr.mr_n92260176)
print v(xbgr.mr_n92260512)
print v(xbgr.mr_n92260928)
print v(xbgr.mr_n92261168)
print v(xbgr.mr_n92261552)
print v(xbgr.mr_n92262064)
print v(xbgr.mr_n92262176)
print v(xbgr.mr_n92262288)
print v(xbgr.mr_n92262400)
print v(xbgr.mr_n92262512)
print v(xbgr.mr_n92264496)
print v(xbgr.mr_n92264608)
print v(xbgr.mr_n92264720)
print v(xbgr.mr_n92264832)
print v(xbgr.mr_n92266816)
print v(xbgr.mr_n92266928)
print v(xbgr.mr_n92267040)
print v(xbgr.mr_n92267152)
print v(xbgr.mr_n92269136)
print v(xbgr.mr_n92269248)
print v(xbgr.mr_n92269360)
print v(xbgr.mr_n92269472)
print v(xbgr.mr_n92271456)
print v(xbgr.mr_n92271568)
print v(xbgr.mr_n92271680)
print v(xbgr.mr_n92271792)
print v(xbgr.mr_n92273776)
print v(xbgr.mr_n92273888)
print v(xbgr.mr_n92274000)
print v(xbgr.mr_n92274112)
print v(xbgr.mr_n92276096)
print v(xbgr.mr_n92276208)
print v(xbgr.mr_n92276320)
print v(xbgr.mr_n92276432)
print v(xbgr.mr_n92278416)
print v(xbgr.mr_n92278528)
print v(xbgr.mr_n92278640)
print v(xbgr.mr_n92278752)
print v(xbgr.mr_n92280736)
print v(xbgr.mr_n92280848)
print v(xbgr.mr_n92280960)
print v(xbgr.mr_n92281072)
print v(xbgr.mr_n92283056)
print v(xbgr.mr_n92283168)
print v(xbgr.mr_n92283280)
print v(xbgr.mr_n92283392)
print v(xbgr.mr_n92285376)
print v(xbgr.mr_n92285488)
print v(xbgr.mr_n92285600)
print v(xbgr.mr_n92285712)
print v(xbgr.mr_n92287696)
print v(xbgr.mr_n92287808)
print v(xbgr.mr_n92287920)
print v(xbgr.mr_n92288032)
print v(xbgr.mr_n92290016)
print v(xbgr.mr_n92290128)
print v(xbgr.mr_n92290240)
print v(xbgr.mr_n92290352)
print v(xbgr.mr_n92292336)
print v(xbgr.mr_n92292448)
print v(xbgr.mr_n92292944)
print v(xbgr.mr_n92293056)
print v(xbgr.mr_n92293232)
print v(xbgr.mr_n92296704)
print v(xbgr.mr_n92296816)
print v(xbgr.mr_n92297008)
print v(xbgr.mr_n92297376)
print v(xbgr.mr_n92297488)
print v(xbgr.mr_n92301136)
print v(xbgr.mr_n92301248)
print v(xbgr.mr_n92301808)
print v(xbgr.mr_n92301920)
print v(xbgr.mr_n92305568)
print v(xbgr.mr_n92305680)
print v(xbgr.mr_n92306240)
print v(xbgr.mr_n92306352)
print v(xbgr.mr_n92309024)
print v(xbgr.mr_n92310528)
print v(xbgr.mr_n92311312)
print v(xbgr.mr_n92311488)
print v(xbgr.mr_n92312368)
print v(xbgr.mr_n92313056)
print v(xbgr.mr_n92313872)
print v(xbgr.mr_n92314048)
print v(xbgr.mr_n92314352)
print v(xbgr.mr_n92314928)
print v(xbgr.mr_n92315696)
print v(xbgr.mr_n92316464)
print v(xbgr.mr_n92316576)
print v(xbgr.mr_n92316752)
print v(xbgr.mr_n92317504)
print v(xbgr.mr_n92317616)
print v(xbgr.mr_n92319120)
print v(xbgr.mr_n92319616)
print v(xbgr.mr_n92319728)
print v(xbgr.mr_n92322192)
print v(xbgr.mr_n92323360)
print v(xbgr.mr_n92323536)
print v(xbgr.mr_n92325104)
print v(xbgr.mr_n92325920)
print v(xbgr.mr_n92326096)
print v(xbgr.mr_n92326800)
print v(xbgr.mr_n92327664)
print v(xbgr.mr_n92328480)
print v(xbgr.mr_n92328656)
print v(xbgr.mr_n92330224)
print v(xbgr.mr_n92331040)
print v(xbgr.mr_n92331216)
print v(xbgr.mr_n92332784)
print v(xbgr.mr_n92333600)
print v(xbgr.mr_n92333776)
print v(xbgr.mr_n92335344)
print v(xbgr.mr_n92335584)
print v(xbgr.mr_n92336160)
print v(xbgr.mr_n92336336)
print v(xbgr.mr_n92337904)
print v(xbgr.mr_n92338720)
print v(xbgr.mr_n92338896)
print v(xbgr.mr_n92340464)
print v(xbgr.mr_n92341280)
print v(xbgr.mr_n92341456)
print v(xbgr.mr_n92343024)
print v(xbgr.mr_n92343840)
print v(xbgr.mr_n92344016)
print v(xbgr.mr_n92345584)
print v(xbgr.mr_n92346400)
print v(xbgr.mr_n92346576)
print v(xbgr.mr_n92348144)
print v(xbgr.mr_n92348960)
print v(xbgr.mr_n92349136)
print v(xbgr.mr_n92350704)
print v(xbgr.mr_n92351520)
print v(xbgr.mr_n92351696)
print v(xbgr.mr_n92353264)
print v(xbgr.mr_n92354080)
print v(xbgr.mr_n92354256)
print v(xbgr.mr_n92354832)
print v(xbgr.mr_n92355824)
print v(xbgr.mr_n92356640)
print v(xbgr.mr_n92356816)
print v(xbgr.mr_n92358384)
print v(xbgr.mr_n92359200)
print v(xbgr.mr_n92359376)
print v(xbgr.mr_n92360944)
print v(xbgr.mr_n92361760)
print v(xbgr.mr_n92361936)
print v(xbgr.mr_n92363504)
print v(xbgr.mr_n92364320)
print v(xbgr.mr_n92364496)
print v(xbgr.mr_n92366064)
print v(xbgr.mr_n92366880)
print v(xbgr.mr_n92367056)
print v(xbgr.mr_n92368624)
print v(xbgr.mr_n92369440)
print v(xbgr.mr_n92369616)
print v(xbgr.mr_n92371184)
print v(xbgr.mr_n92372000)
print v(xbgr.mr_n92372176)
print v(xbgr.mr_n92373744)
print v(xbgr.mr_n92374416)
print v(xbgr.mr_n92374560)
print v(xbgr.mr_n92374736)
print v(xbgr.mr_n92375504)
print v(xbgr.mr_n92376304)
print v(xbgr.mr_n92377120)
print v(xbgr.mr_n92377296)
print v(xbgr.mr_n92378864)
print v(xbgr.mr_n92400624)
print v(xbgr.mr_n92400880)
print v(xbgr.mr_n92405104)
print v(xbgr.mr_n92407536)
print v(xbgr.mr_n92407792)
print v(xbgr.mr_n92413360)
print v(xbgr.mr_n92422128)
print v(xbgr.mr_n92433840)
print v(xbgr.mr_n92443952)
print v(xbgr.mr_n92548448)
print v(xbgr.mr_n92548560)
print v(xbgr.mr_n92548992)
print v(xbgr.mr_n92549104)
print v(xbgr.mr_n92549536)
print v(xbgr.mr_n92549648)
print v(xbgr.mr_n92550080)
print v(xbgr.mr_n92550192)
print v(xbgr.mr_n92550864)
print v(xbgr.mr_n92550976)
print v(xbgr.mr_n92551808)
print v(xbgr.mr_n92551920)
print v(xbgr.mr_n92552752)
print v(xbgr.mr_n92552864)
print v(xbgr.mr_n92553696)
print v(xbgr.mr_n92553808)
print v(xbgr.mr_n92554640)
print v(xbgr.mr_n92554752)
print v(xbgr.mr_n92555584)
print v(xbgr.mr_n92555696)
print v(xbgr.mr_n92556528)
print v(xbgr.mr_n92556640)
print v(xbgr.mr_n92557472)
print v(xbgr.mr_n92557584)
print v(xbgr.mr_n92558416)
print v(xbgr.mr_n92558528)
print v(xbgr.mr_n92559360)
print v(xbgr.mr_n92559472)
print v(xbgr.mr_n92560304)
print v(xbgr.mr_n92560416)
print v(xbgr.mr_n92561248)
print v(xbgr.mr_n92561360)
print v(xbgr.mr_n92562192)
print v(xbgr.mr_n92562304)
print v(xbgr.mr_n92562960)
print v(xbgr.mr_n92563216)
print v(xbgr.mr_n92563472)
print v(xbgr.mr_n92565856)
print v(xbgr.mr_n92586016)
print v(xbgr.mr_n92586208)
print v(xbgr.mr_n92586928)
print v(xbgr.mr_n92587312)
print v(xbgr.mr_n92587760)
print v(xbgr.mr_n92589280)
print v(xbgr.mr_n92598704)
print v(xbgr.mr_n92599392)
print v(xbgr.mr_n92604832)
print v(xbgr.mr_n92615680)
print v(xbgr.mr_n92616016)
print v(xbgr.mr_n92616784)
print v(xbgr.mr_n92618192)
print v(xbgr.mr_n92618528)
print v(xbgr.mr_n92620704)
print v(xbgr.mr_n92621040)
print v(xbgr.mr_n92623216)
print v(xbgr.mr_n92623552)
print v(xbgr.mr_n92625728)
print v(xbgr.mr_n92626064)
print v(xbgr.mr_n92628240)
print v(xbgr.mr_n92628576)
print v(xbgr.mr_n92630496)
print v(xbgr.mr_n92631056)
print v(xbgr.mr_n92631744)
print v(xbgr.mr_n92632496)
print v(xbgr.mr_n92633440)
print v(xbgr.mr_n92634384)
print v(xbgr.mr_n92635328)
print v(xbgr.mr_n92636272)
print v(xbgr.mr_n92637216)
print v(xbgr.mr_n92638160)
print v(xbgr.mr_n92639104)
print v(xbgr.mr_n92640048)
print v(xbgr.mr_n92640992)
print v(xbgr.mr_n92641936)
print v(xbgr.mr_n92642880)
print v(xbgr.mr_n92643824)
print v(xbgr.mr_n92644768)
print v(xbgr.mr_n92645712)
print v(xbgr.mr_n92646656)
print v(xbgr.mr_n92647600)
print v(xbgr.mr_n92648544)
print v(xbgr.mr_n92649488)
print v(xbgr.mr_n92650432)
print v(xbgr.mr_n92651376)
print v(xbgr.mr_n92652320)
print v(xbgr.mr_n92653264)
print v(xbgr.mr_n92654208)
print v(xbgr.mr_n92655152)
print v(xbgr.mr_n92656096)
print v(xbgr.mr_n92657040)
print v(xbgr.mr_n92657984)
print v(xbgr.mr_n92658928)
print v(xbgr.mr_n92659872)
print v(xbgr.mr_n92660816)
print v(xbgr.mr_n92661760)
print v(xbgr.mr_n92662704)
print v(xbgr.mr_n92664320)
print v(xbgr.mr_n92664656)
print v(xbgr.mr_n92664768)
print v(xbgr.mr_n92665600)
print v(xbgr.mr_n92665712)
print v(xbgr.mr_n92666544)
print v(xbgr.mr_n92666656)
print v(xbgr.mr_n92667808)
print v(xbgr.mr_n92667920)
print v(xbgr.mr_n92669072)
print v(xbgr.mr_n92669184)
print v(xbgr.mr_n92670336)
print v(xbgr.mr_n92670448)
print v(xbgr.mr_n92671600)
print v(xbgr.mr_n92671712)
print v(xbgr.mr_n92672800)
print v(xbgr.mr_n92672912)
print v(xbgr.mr_n92674128)
print v(xbgr.mr_n92674240)
print v(xbgr.mr_n92675392)
print v(xbgr.mr_n92675504)
print v(xbgr.mr_n92676656)
print v(xbgr.mr_n92676768)
print v(xbgr.mr_n92677920)
print v(xbgr.mr_n92678032)
print v(xbgr.mr_n92679184)
print v(xbgr.mr_n92679296)
print v(xbgr.mr_n92680448)
print v(xbgr.mr_n92680560)
print v(xbgr.mr_n92681712)
print v(xbgr.mr_n92681824)
print v(xbgr.mr_n92682976)
print v(xbgr.mr_n92683088)
print v(xbgr.mr_n92684240)
print v(xbgr.mr_n92684352)
print v(xbgr.mr_n92684720)
print v(xbgr.mr_n92686640)
print v(xbgr.mr_n92689472)
print v(xbgr.mr_n92689584)
print v(xbgr.mr_n92690736)
print v(xbgr.mr_n92690848)
print v(xbgr.mr_n92691936)
print v(xbgr.mr_n92692048)
print v(xbgr.mr_n92693264)
print v(xbgr.mr_n92693376)
print v(xbgr.mr_n92694528)
print v(xbgr.mr_n92694640)
print v(xbgr.mr_n92695792)
print v(xbgr.mr_n92695904)
print v(xbgr.mr_n92697056)
print v(xbgr.mr_n92697168)
print v(xbgr.mr_n92698320)
print v(xbgr.mr_n92698432)
print v(xbgr.mr_n92699520)
print v(xbgr.mr_n92699632)
print v(xbgr.mr_n92700848)
print v(xbgr.mr_n92700960)
print v(xbgr.mr_n92702112)
print v(xbgr.mr_n92702224)
print v(xbgr.mr_n92703376)
print v(xbgr.mr_n92703488)
print v(xbgr.mr_n92704640)
print v(xbgr.mr_n92704752)
print v(xbgr.mr_n92705904)
print v(xbgr.mr_n92706016)
print v(xbgr.mr_n92707168)
print v(xbgr.mr_n92707280)
print v(xbgr.mr_n92708432)
print v(xbgr.mr_n92708544)
print v(xbgr.mr_n92709696)
print v(xbgr.mr_n92709808)
print v(xbgr.mr_n92721632)
print v(xbgr.mr_n92721744)
print v(xbgr.mr_n92728544)
print v(xbgr.mr_n92729376)
print v(xbgr.mr_n92729488)
print v(xbgr.mr_n92730528)
print v(xbgr.mr_n92734080)
print v(xbgr.mr_n92735472)
print v(xbgr.mr_n92735744)
print v(xbgr.mr_n92735936)
print v(xbgr.mr_n92738912)
print v(xbgr.mr_n92742992)
print v(xbgr.mr_n92743264)
print v(xbgr.mr_n92743456)
print v(xbgr.mr_n92746432)
print v(xbgr.mr_n92750512)
print v(xbgr.mr_n92750784)
print v(xbgr.mr_n92750976)
print v(xbgr.mr_n92752528)
print v(xbgr.mr_n92753952)
print v(xbgr.mr_n92758032)
print v(xbgr.mr_n92758304)
print v(xbgr.mr_n92758496)
print v(xbgr.mr_n92763024)
print v(xbgr.mr_n92766144)
print v(xbgr.mr_n92766256)
print v(xbgr.mr_n92766448)
print v(xbgr.mr_n92767424)
print v(xbgr.mr_n92771456)
print v(xbgr.mr_n92772432)
print v(xbgr.mr_n92784640)
print v(xbgr.mr_n92784752)
print v(xbgr.mr_n92785584)
print v(xbgr.mr_n92785696)
print v(xbgr.mr_n92786528)
print v(xbgr.mr_n92786640)
print v(xbgr.mr_n92787472)
print v(xbgr.mr_n92787584)
print v(xbgr.mr_n92788672)
print v(xbgr.mr_n92788784)
print v(xbgr.mr_n92789936)
print v(xbgr.mr_n92790048)
print v(xbgr.mr_n92791200)
print v(xbgr.mr_n92791312)
print v(xbgr.mr_n92792464)
print v(xbgr.mr_n92792576)
print v(xbgr.mr_n92793728)
print v(xbgr.mr_n92793840)
print v(xbgr.mr_n92794992)
print v(xbgr.mr_n92795104)
print v(xbgr.mr_n92796256)
print v(xbgr.mr_n92796368)
print v(xbgr.mr_n92797520)
print v(xbgr.mr_n92797632)
print v(xbgr.mr_n92798784)
print v(xbgr.mr_n92798896)
print v(xbgr.mr_n92800048)
print v(xbgr.mr_n92800160)
print v(xbgr.mr_n92801312)
print v(xbgr.mr_n92801424)
print v(xbgr.mr_n92802576)
print v(xbgr.mr_n92802688)
print v(xbgr.mr_n92810096)
print v(xbgr.mr_n92810784)
print v(xbgr.mr_n92811472)
print v(xbgr.mr_n92812192)
print v(xbgr.mr_n92813808)
print v(xbgr.mr_n92814176)
print v(xbgr.mr_n92815088)
print v(xbgr.mr_n92815200)
print v(xbgr.mr_n92816144)
print v(xbgr.mr_n92817296)
print v(xbgr.mr_n92817408)
print v(xbgr.mr_n92818032)
print v(xbgr.mr_n92819568)
print v(xbgr.mr_n92820112)
print v(xbgr.mr_n92821456)
print v(xbgr.mr_n92822000)
print v(xbgr.mr_n92823344)
print v(xbgr.mr_n92823888)
print v(xbgr.mr_n92825232)
print v(xbgr.mr_n92825776)
print v(xbgr.mr_n92827120)
print v(xbgr.mr_n92827664)
print v(xbgr.mr_n92829008)
print v(xbgr.mr_n92829552)
print v(xbgr.mr_n92830896)
print v(xbgr.mr_n92831440)
print v(xbgr.mr_n92832784)
print v(xbgr.mr_n92833328)
print v(xbgr.mr_n92834672)
print v(xbgr.mr_n92835216)
print v(xbgr.mr_n92836560)
print v(xbgr.mr_n92837104)
print v(xbgr.mr_n92838448)
print v(xbgr.mr_n92838992)
print v(xbgr.mr_n92840336)
print v(xbgr.mr_n92841200)
print v(xbgr.mr_n92842096)
print v(xbgr.mr_n92842208)
print v(xbgr.mr_n92843152)
print v(xbgr.mr_n92844304)
print v(xbgr.mr_n92844416)
print v(xbgr.mr_n92845360)
print v(xbgr.mr_n92846576)
print v(xbgr.mr_n92846688)
print v(xbgr.mr_n92847376)
print v(xbgr.mr_n92850128)
print v(xbgr.mr_n92853456)
print v(xbgr.mr_n92853776)
print v(xbgr.mr_n92854352)
print v(xbgr.mr_n92861152)
print v(xbgr.mr_n92861584)
print v(xbgr.mr_n92861696)
print v(xbgr.mr_n92862176)
print v(xbgr.mr_n92864880)
print v(xbgr.mr_n92865568)
print v(xbgr.mr_n92866256)
print v(xbgr.mr_n92867616)
print v(xbgr.mr_n92868816)
print v(xbgr.mr_n92869008)
print v(xbgr.mr_n92869200)
print v(xbgr.mr_n92869392)
print v(xbgr.mr_n92869584)
print v(xbgr.mr_n92871456)
print v(xbgr.mr_n92873344)
print v(xbgr.mr_n92875216)
print v(xbgr.mr_n92880112)
print v(xbgr.mr_n92881056)
print v(xbgr.mr_n92882000)
print v(xbgr.mr_n92883392)
print v(xbgr.mr_n92884224)
print v(xbgr.mr_n92894592)
print v(xbgr.mr_n92895536)
print v(xbgr.mr_n92896480)
print v(xbgr.mr_n92897424)
print v(xbgr.mr_n92899584)
print v(xbgr.mr_n92902112)
print v(xbgr.mr_n92903936)
print v(xbgr.mr_n92904128)
print v(xbgr.mr_n92904960)
print v(xbgr.mr_n92906288)
print v(xbgr.mr_n92906480)
print v(xbgr.mr_n92907168)
print v(xbgr.mr_n92908496)
print v(xbgr.mr_n92908688)
print v(xbgr.mr_n92909376)
print v(xbgr.mr_n92909488)
print v(xbgr.mr_n92909600)
print v(xbgr.mr_n92909712)
print v(xbgr.mr_n92911104)
print v(xbgr.mr_n92911376)
print v(xbgr.mr_n92911568)
print v(xbgr.mr_n92911920)
print v(xbgr.mr_n92912032)
print v(xbgr.mr_n92915696)
print v(xbgr.mr_n92915968)
print v(xbgr.mr_n92916160)
print v(xbgr.mr_n92916512)
print v(xbgr.mr_n92916624)
print v(xbgr.mr_n92920288)
print v(xbgr.mr_n92920560)
print v(xbgr.mr_n92920752)
print v(xbgr.mr_n92921104)
print v(xbgr.mr_n92921216)
print v(xbgr.mr_n92924880)
print v(xbgr.mr_n92925152)
print v(xbgr.mr_n92925344)
print v(xbgr.mr_n92925696)
print v(xbgr.mr_n92925808)
print v(xbgr.mr_n92929472)
print v(xbgr.mr_n92929744)
print v(xbgr.mr_n92929936)
print v(xbgr.mr_n92930288)
print v(xbgr.mr_n92930400)
print v(xbgr.mr_n92934064)
print v(xbgr.mr_n92934336)
print v(xbgr.mr_n92934528)
print v(xbgr.mr_n92934880)
print v(xbgr.mr_n92934992)
print v(xbgr.mr_n92938656)
print v(xbgr.mr_n92938928)
print v(xbgr.mr_n92939120)
print v(xbgr.mr_n92939472)
print v(xbgr.mr_n92939584)
print v(xbgr.mr_n92943248)
print v(xbgr.mr_n92943520)
print v(xbgr.mr_n92943712)
print v(xbgr.mr_n92944064)
print v(xbgr.mr_n92944176)
print v(xbgr.mr_n92947840)
print v(xbgr.mr_n92948112)
print v(xbgr.mr_n92948304)
print v(xbgr.mr_n92948656)
print v(xbgr.mr_n92948768)
print v(xbgr.mr_n92952432)
print v(xbgr.mr_n92952704)
print v(xbgr.mr_n92952896)
print v(xbgr.mr_n92953248)
print v(xbgr.mr_n92953360)
print v(xbgr.mr_n92957024)
print v(xbgr.mr_n92957296)
print v(xbgr.mr_n92957488)
print v(xbgr.mr_n92957840)
print v(xbgr.mr_n92957952)
print v(xbgr.mr_n92961616)
print v(xbgr.mr_n92961888)
print v(xbgr.mr_n92962080)
print v(xbgr.mr_n92962432)
print v(xbgr.mr_n92962544)
print v(xbgr.mr_n92966208)
print v(xbgr.mr_n92966480)
print v(xbgr.mr_n92966672)
print v(xbgr.mr_n92967024)
print v(xbgr.mr_n92967136)
print v(xbgr.mr_n92970800)
print v(xbgr.mr_n92971072)
print v(xbgr.mr_n92971264)
print v(xbgr.mr_n92971616)
print v(xbgr.mr_n92971728)
print v(xbgr.mr_n92974192)
print v(xbgr.mr_n92975728)
print v(xbgr.mr_n92975920)
print v(xbgr.mr_n92976272)
print v(xbgr.mr_n92976384)
print v(xbgr.mr_n92979840)
print v(xbgr.mr_n92980416)
print v(xbgr.mr_n92980528)
print v(xbgr.mr_n92981360)
print v(xbgr.mr_n92981472)
print v(xbgr.mr_n92982304)
print v(xbgr.mr_n92982416)
print v(xbgr.mr_n92983248)
print v(xbgr.mr_n92983360)
print v(xbgr.mr_n92984192)
print v(xbgr.mr_n92984304)
print v(xbgr.mr_n92985136)
print v(xbgr.mr_n92985248)
print v(xbgr.mr_n92986080)
print v(xbgr.mr_n92986192)
print v(xbgr.mr_n92987024)
print v(xbgr.mr_n92987136)
print v(xbgr.mr_n92987968)
print v(xbgr.mr_n92988080)
print v(xbgr.mr_n92988912)
print v(xbgr.mr_n92989024)
print v(xbgr.mr_n92989856)
print v(xbgr.mr_n92989968)
print v(xbgr.mr_n92991056)
print v(xbgr.mr_n92991168)
print v(xbgr.mr_n92991952)
print v(xbgr.mr_n92992144)
print v(xbgr.mr_n92994176)
print v(xbgr.mr_n92994816)
print v(xbgr.mr_n92995040)
print v(xbgr.mr_n92995328)
print v(xbgr.mr_n92995472)
print v(xbgr.mr_n92995728)
print v(xbgr.mr_n92997104)
print v(xbgr.mr_n92997216)
print v(xbgr.mr_n92998048)
print v(xbgr.mr_n92998160)
print v(xbgr.mr_n92999696)
print v(xbgr.mr_n92999808)
print v(xbgr.mr_n93001728)
print v(xbgr.mr_n93001840)
print v(xbgr.mr_n93002992)
print v(xbgr.mr_n93003104)
print v(xbgr.mr_n93004256)
print v(xbgr.mr_n93004368)
print v(xbgr.mr_n93005520)
print v(xbgr.mr_n93005632)
print v(xbgr.mr_n93006784)
print v(xbgr.mr_n93006896)
print v(xbgr.mr_n93008048)
print v(xbgr.mr_n93008160)
print v(xbgr.mr_n93009312)
print v(xbgr.mr_n93009424)
print v(xbgr.mr_n93010576)
print v(xbgr.mr_n93010688)
print v(xbgr.mr_n93011840)
print v(xbgr.mr_n93011952)
print v(xbgr.mr_n93013104)
print v(xbgr.mr_n93013216)
print v(xbgr.mr_n93014368)
print v(xbgr.mr_n93014480)
print v(xbgr.mr_n93015632)
print v(xbgr.mr_n93015744)
print v(xbgr.mr_n93016896)
print v(xbgr.mr_n93017008)
print v(xbgr.mr_n93018160)
print v(xbgr.mr_n93018272)
print v(xbgr.mr_n93023248)
print v(xbgr.mr_n93025776)
print v(xbgr.mr_n93026112)
print v(xbgr.mr_n93028272)
print v(xbgr.mr_n93032432)
print v(xbgr.mr_n93035312)
print v(xbgr.mr_n93036720)
print v(xbgr.mr_n93040976)
print v(xbgr.mr_n93041664)
print v(xbgr.mr_n93042352)
print v(xbgr.mr_n93043104)
print v(xbgr.mr_n93044048)
print v(xbgr.mr_n93044960)
print v(xbgr.mr_n93045904)
print v(xbgr.mr_n93054208)
print v(xbgr.mr_n93055264)
print v(xbgr.mr_n93055872)
print v(xbgr.mr_n93057376)
print v(xbgr.mr_n93059424)
print v(xbgr.mr_n93059536)
print v(xbgr.mr_n93060576)
print v(xbgr.mr_n93060768)
print v(xbgr.mr_n93060960)
print v(xbgr.mr_n93062944)
print v(xbgr.mr_n93063216)
print v(xbgr.mr_n93063408)
print v(xbgr.mr_n93063760)
print v(xbgr.mr_n93063872)
print v(xbgr.mr_n93067184)
print v(xbgr.mr_n93067760)
print v(xbgr.mr_n93070448)
print v(xbgr.mr_n93070560)
print v(xbgr.mr_n93070672)
print v(xbgr.mr_n93072064)
print v(xbgr.mr_n93072336)
print v(xbgr.mr_n93072528)
print v(xbgr.mr_n93072880)
print v(xbgr.mr_n93072992)
print v(xbgr.mr_n93074560)
print v(xbgr.mr_n93074672)
print v(xbgr.mr_n93077968)
print v(xbgr.mr_n93079360)
print v(xbgr.mr_n93079632)
print v(xbgr.mr_n93079824)
print v(xbgr.mr_n93080176)
print v(xbgr.mr_n93080288)
print v(xbgr.mr_n93083920)
print v(xbgr.mr_n93084032)
print v(xbgr.mr_n93084144)
print v(xbgr.mr_n93085536)
print v(xbgr.mr_n93085808)
print v(xbgr.mr_n93086000)
print v(xbgr.mr_n93086352)
print v(xbgr.mr_n93086464)
print v(xbgr.mr_n93090096)
print v(xbgr.mr_n93090208)
print v(xbgr.mr_n93090320)
print v(xbgr.mr_n93091712)
print v(xbgr.mr_n93091984)
print v(xbgr.mr_n93092176)
print v(xbgr.mr_n93092528)
print v(xbgr.mr_n93092640)
print v(xbgr.mr_n93094208)
print v(xbgr.mr_n93094320)
print v(xbgr.mr_n93097616)
print v(xbgr.mr_n93097808)
print v(xbgr.mr_n93099344)
print v(xbgr.mr_n93099536)
print v(xbgr.mr_n93099888)
print v(xbgr.mr_n93100000)
print v(xbgr.mr_n93103568)
print v(xbgr.mr_n93103680)
print v(xbgr.mr_n93103792)
print v(xbgr.mr_n93105184)
print v(xbgr.mr_n93105456)
print v(xbgr.mr_n93105648)
print v(xbgr.mr_n93106000)
print v(xbgr.mr_n93106112)
print v(xbgr.mr_n93108432)
print v(xbgr.mr_n93109744)
print v(xbgr.mr_n93109856)
print v(xbgr.mr_n93109968)
print v(xbgr.mr_n93111360)
print v(xbgr.mr_n93111632)
print v(xbgr.mr_n93111824)
print v(xbgr.mr_n93112176)
print v(xbgr.mr_n93112288)
print v(xbgr.mr_n93113856)
print v(xbgr.mr_n93113968)
print v(xbgr.mr_n93117264)
print v(xbgr.mr_n93118656)
print v(xbgr.mr_n93118928)
print v(xbgr.mr_n93119120)
print v(xbgr.mr_n93119472)
print v(xbgr.mr_n93119584)
print v(xbgr.mr_n93123216)
print v(xbgr.mr_n93123328)
print v(xbgr.mr_n93123440)
print v(xbgr.mr_n93124832)
print v(xbgr.mr_n93125104)
print v(xbgr.mr_n93125296)
print v(xbgr.mr_n93125648)
print v(xbgr.mr_n93125760)
print v(xbgr.mr_n93126896)
print v(xbgr.mr_n93127008)
print v(xbgr.mr_n93130656)
print v(xbgr.mr_n93131728)
print v(xbgr.mr_n93131840)
print v(xbgr.mr_n93131952)
print v(xbgr.mr_n93133344)
print v(xbgr.mr_n93133616)
print v(xbgr.mr_n93133808)
print v(xbgr.mr_n93134160)
print v(xbgr.mr_n93134272)
print v(xbgr.mr_n93138992)
print v(xbgr.mr_n93139104)
print v(xbgr.mr_n93139216)
print v(xbgr.mr_n93140608)
print v(xbgr.mr_n93140880)
print v(xbgr.mr_n93141072)
print v(xbgr.mr_n93141424)
print v(xbgr.mr_n93141536)
print v(xbgr.mr_n93148400)
print v(xbgr.mr_n93148544)
print v(xbgr.mr_n93151056)
print v(xbgr.mr_n93151168)
print v(xbgr.mr_n93152320)
print v(xbgr.mr_n93152432)
print v(xbgr.mr_n93153584)
print v(xbgr.mr_n93153696)
print v(xbgr.mr_n93154848)
print v(xbgr.mr_n93154960)
print v(xbgr.mr_n93156112)
print v(xbgr.mr_n93156224)
print v(xbgr.mr_n93157376)
print v(xbgr.mr_n93157488)
print v(xbgr.mr_n93158640)
print v(xbgr.mr_n93158752)
print v(xbgr.mr_n93159904)
print v(xbgr.mr_n93160016)
print v(xbgr.mr_n93161168)
print v(xbgr.mr_n93161280)
print v(xbgr.mr_n93162432)
print v(xbgr.mr_n93162544)
print v(xbgr.mr_n93163696)
print v(xbgr.mr_n93163808)
print v(xbgr.mr_n93164960)
print v(xbgr.mr_n93165072)
print v(xbgr.mr_n93166224)
print v(xbgr.mr_n93166336)
print v(xbgr.mr_n93167488)
print v(xbgr.mr_n93167600)
print v(xbgr.mr_n93168752)
print v(xbgr.mr_n93168864)
print v(xbgr.mr_n93172128)
print v(xbgr.mr_n93173600)
print v(xbgr.mr_n93174624)
print v(xbgr.mr_n93176016)
print v(xbgr.mr_n93181200)
print v(xbgr.mr_n93181488)
print v(xbgr.mr_n93181632)
print v(xbgr.mr_n93191232)
print v(xbgr.mr_n93193088)
print v(xbgr.mr_n93193264)
print v(xbgr.mr_n93194080)
print v(xbgr.mr_n93195024)
print v(xbgr.mr_n93195312)
print v(xbgr.mr_n93197312)
print v(xbgr.mr_n93198720)
print v(xbgr.mr_n93199248)
print v(xbgr.mr_n93199712)
print v(xbgr.mr_n93200128)
print v(xbgr.mr_n93201088)
print v(xbgr.mr_n93201296)
print v(xbgr.mr_n93201472)
print v(xbgr.mr_n93201648)
print v(xbgr.mr_n93203872)
print v(xbgr.mr_n93205056)
print v(xbgr.mr_n93205280)
print v(xbgr.mr_n93205872)
print v(xbgr.mr_n93206112)
print v(xbgr.mr_n93206464)
print v(xbgr.mr_n93206640)
print v(xbgr.mr_n93206816)
print v(xbgr.mr_n93208576)
print v(xbgr.mr_n93213744)
print v(xbgr.mr_n93214432)
print v(xbgr.mr_n93215120)
print v(xbgr.mr_n93221264)
print v(xbgr.mr_n93221456)
print v(xbgr.mr_n93222144)
print v(xbgr.mr_n93222256)
print v(xbgr.mr_n93222368)
print v(xbgr.mr_n93222480)
print v(xbgr.mr_n93223872)
print v(xbgr.mr_n93224144)
print v(xbgr.mr_n93224336)
print v(xbgr.mr_n93224688)
print v(xbgr.mr_n93224800)
print v(xbgr.mr_n93228464)
print v(xbgr.mr_n93228736)
print v(xbgr.mr_n93228928)
print v(xbgr.mr_n93229280)
print v(xbgr.mr_n93229392)
print v(xbgr.mr_n93233056)
print v(xbgr.mr_n93233328)
print v(xbgr.mr_n93233520)
print v(xbgr.mr_n93233872)
print v(xbgr.mr_n93233984)
print v(xbgr.mr_n93236608)
print v(xbgr.mr_n93236800)
print v(xbgr.mr_n93236992)
print v(xbgr.mr_n93238784)
print v(xbgr.mr_n93238896)
print v(xbgr.mr_n93242240)
print v(xbgr.mr_n93242512)
print v(xbgr.mr_n93242704)
print v(xbgr.mr_n93243056)
print v(xbgr.mr_n93243168)
print v(xbgr.mr_n93246832)
print v(xbgr.mr_n93247104)
print v(xbgr.mr_n93247296)
print v(xbgr.mr_n93247648)
print v(xbgr.mr_n93247760)
print v(xbgr.mr_n93251424)
print v(xbgr.mr_n93251696)
print v(xbgr.mr_n93251888)
print v(xbgr.mr_n93252240)
print v(xbgr.mr_n93252352)
print v(xbgr.mr_n93256016)
print v(xbgr.mr_n93256288)
print v(xbgr.mr_n93256480)
print v(xbgr.mr_n93256832)
print v(xbgr.mr_n93256944)
print v(xbgr.mr_n93260880)
print v(xbgr.mr_n93261424)
print v(xbgr.mr_n93261536)
print v(xbgr.mr_n93262416)
print v(xbgr.mr_n93262608)
print v(xbgr.mr_n93263296)
print v(xbgr.mr_n93263504)
print v(xbgr.mr_n93263616)
print v(xbgr.mr_n93263728)
print v(xbgr.mr_n93265200)
print v(xbgr.mr_n93265472)
print v(xbgr.mr_n93265664)
print v(xbgr.mr_n93266016)
print v(xbgr.mr_n93266128)
print v(xbgr.mr_n93270064)
print v(xbgr.mr_n93271600)
print v(xbgr.mr_n93271792)
print v(xbgr.mr_n93272144)
print v(xbgr.mr_n93272256)
print v(xbgr.mr_n93275856)
print v(xbgr.mr_n93276128)
print v(xbgr.mr_n93276320)
print v(xbgr.mr_n93276672)
print v(xbgr.mr_n93276784)
print v(xbgr.mr_n93280448)
print v(xbgr.mr_n93280720)
print v(xbgr.mr_n93280912)
print v(xbgr.mr_n93281264)
print v(xbgr.mr_n93281376)
print v(xbgr.mr_n93285040)
print v(xbgr.mr_n93285312)
print v(xbgr.mr_n93285504)
print v(xbgr.mr_n93285856)
print v(xbgr.mr_n93285968)
print v(xbgr.mr_n93289632)
print v(xbgr.mr_n93289904)
print v(xbgr.mr_n93290096)
print v(xbgr.mr_n93290448)
print v(xbgr.mr_n93290560)
print v(xbgr.mr_n93294224)
print v(xbgr.mr_n93294496)
print v(xbgr.mr_n93294688)
print v(xbgr.mr_n93295040)
print v(xbgr.mr_n93295152)
print v(xbgr.mr_n93298432)
print v(xbgr.mr_n93299216)
print v(xbgr.mr_n93300864)
print v(xbgr.mr_n93301200)
print v(xbgr.mr_n93303408)
print v(xbgr.mr_n93305072)
print v(xbgr.mr_n93305504)
print v(xbgr.mr_n93305936)
print v(xbgr.mr_n93307360)
print v(xbgr.mr_n93307936)
print v(xbgr.mr_n93308048)
print v(xbgr.mr_n93308992)
print v(xbgr.mr_n93309824)
print v(xbgr.mr_n93309936)
print v(xbgr.mr_n93310880)
print v(xbgr.mr_n93312032)
print v(xbgr.mr_n93312144)
print v(xbgr.mr_n93313088)
print v(xbgr.mr_n93314240)
print v(xbgr.mr_n93314352)
print v(xbgr.mr_n93315296)
print v(xbgr.mr_n93316448)
print v(xbgr.mr_n93316560)
print v(xbgr.mr_n93317504)
print v(xbgr.mr_n93318656)
print v(xbgr.mr_n93318768)
print v(xbgr.mr_n93319712)
print v(xbgr.mr_n93319968)
print v(xbgr.mr_n93320864)
print v(xbgr.mr_n93320976)
print v(xbgr.mr_n93321920)
print v(xbgr.mr_n93323072)
print v(xbgr.mr_n93323184)
print v(xbgr.mr_n93324128)
print v(xbgr.mr_n93325280)
print v(xbgr.mr_n93325392)
print v(xbgr.mr_n93326336)
print v(xbgr.mr_n93327488)
print v(xbgr.mr_n93327600)
print v(xbgr.mr_n93328544)
print v(xbgr.mr_n93329696)
print v(xbgr.mr_n93329808)
print v(xbgr.mr_n93330752)
print v(xbgr.mr_n93331904)
print v(xbgr.mr_n93332016)
print v(xbgr.mr_n93332960)
print v(xbgr.mr_n93334112)
print v(xbgr.mr_n93334224)
print v(xbgr.mr_n93335168)
print v(xbgr.mr_n93336320)
print v(xbgr.mr_n93336432)
print v(xbgr.mr_n93337376)
print v(xbgr.mr_n93338528)
print v(xbgr.mr_n93338640)
print v(xbgr.mr_n93339792)
print v(xbgr.mr_n93339904)
print v(xbgr.mr_n93341056)
print v(xbgr.mr_n93341168)
print v(xbgr.mr_n93344864)
print v(xbgr.mr_n93346160)
print v(xbgr.mr_n93346272)
print v(xbgr.mr_n93347424)
print v(xbgr.mr_n93347536)
print v(xbgr.mr_n93348688)
print v(xbgr.mr_n93348800)
print v(xbgr.mr_n93349952)
print v(xbgr.mr_n93350064)
print v(xbgr.mr_n93351216)
print v(xbgr.mr_n93351328)
print v(xbgr.mr_n93352480)
print v(xbgr.mr_n93352592)
print v(xbgr.mr_n93353744)
print v(xbgr.mr_n93353856)
print v(xbgr.mr_n93355008)
print v(xbgr.mr_n93355120)
print v(xbgr.mr_n93356272)
print v(xbgr.mr_n93356384)
print v(xbgr.mr_n93357536)
print v(xbgr.mr_n93357648)
print v(xbgr.mr_n93358800)
print v(xbgr.mr_n93358912)
print v(xbgr.mr_n93360064)
print v(xbgr.mr_n93360176)
print v(xbgr.mr_n93361328)
print v(xbgr.mr_n93361440)
print v(xbgr.mr_n93362592)
print v(xbgr.mr_n93362704)
print v(xbgr.mr_n93363856)
print v(xbgr.mr_n93363968)
print v(xbgr.mr_n93365120)
print v(xbgr.mr_n93365232)
print v(xbgr.mr_n93366384)
print v(xbgr.mr_n93366496)
print v(xbgr.mr_n93371312)
print v(xbgr.mr_n93372496)
print v(xbgr.mr_n93374240)
print v(xbgr.mr_n93380448)
print v(xbgr.mr_n93391056)
print v(xbgr.mr_n93394944)
print v(xbgr.mr_n93395056)
print v(xbgr.mr_n93395424)
print v(xbgr.mr_n93395840)
print v(xbgr.mr_n93396032)
print v(xbgr.mr_n93396224)
print v(xbgr.mr_n93397936)
print v(xbgr.mr_n93400736)
print v(xbgr.mr_n93404864)
print v(xbgr.mr_n93404976)
print v(xbgr.mr_n93405088)
print v(xbgr.mr_n93406480)
print v(xbgr.mr_n93406752)
print v(xbgr.mr_n93406944)
print v(xbgr.mr_n93407296)
print v(xbgr.mr_n93407408)
print v(xbgr.mr_n93410000)
print v(xbgr.mr_n93411392)
print v(xbgr.mr_n93411664)
print v(xbgr.mr_n93411856)
print v(xbgr.mr_n93412208)
print v(xbgr.mr_n93412320)
print v(xbgr.mr_n93414912)
print v(xbgr.mr_n93416304)
print v(xbgr.mr_n93416576)
print v(xbgr.mr_n93416768)
print v(xbgr.mr_n93417120)
print v(xbgr.mr_n93417232)
print v(xbgr.mr_n93419824)
print v(xbgr.mr_n93421216)
print v(xbgr.mr_n93421408)
print v(xbgr.mr_n93421600)
print v(xbgr.mr_n93422032)
print v(xbgr.mr_n93422144)
print v(xbgr.mr_n93424736)
print v(xbgr.mr_n93426128)
print v(xbgr.mr_n93426320)
print v(xbgr.mr_n93426512)
print v(xbgr.mr_n93426944)
print v(xbgr.mr_n93427056)
print v(xbgr.mr_n93429648)
print v(xbgr.mr_n93431040)
print v(xbgr.mr_n93431312)
print v(xbgr.mr_n93431504)
print v(xbgr.mr_n93431856)
print v(xbgr.mr_n93431968)
print v(xbgr.mr_n93434560)
print v(xbgr.mr_n93435952)
print v(xbgr.mr_n93436224)
print v(xbgr.mr_n93436416)
print v(xbgr.mr_n93436768)
print v(xbgr.mr_n93436880)
print v(xbgr.mr_n93439472)
print v(xbgr.mr_n93440864)
print v(xbgr.mr_n93441136)
print v(xbgr.mr_n93441328)
print v(xbgr.mr_n93441680)
print v(xbgr.mr_n93441792)
print v(xbgr.mr_n93444384)
print v(xbgr.mr_n93445776)
print v(xbgr.mr_n93446048)
print v(xbgr.mr_n93446240)
print v(xbgr.mr_n93446592)
print v(xbgr.mr_n93446704)
print v(xbgr.mr_n93449296)
print v(xbgr.mr_n93450688)
print v(xbgr.mr_n93450960)
print v(xbgr.mr_n93451152)
print v(xbgr.mr_n93451504)
print v(xbgr.mr_n93451616)
print v(xbgr.mr_n93454208)
print v(xbgr.mr_n93455600)
print v(xbgr.mr_n93455872)
print v(xbgr.mr_n93456064)
print v(xbgr.mr_n93456416)
print v(xbgr.mr_n93456528)
print v(xbgr.mr_n93459120)
print v(xbgr.mr_n93460512)
print v(xbgr.mr_n93460784)
print v(xbgr.mr_n93460976)
print v(xbgr.mr_n93461328)
print v(xbgr.mr_n93461440)
print v(xbgr.mr_n93464032)
print v(xbgr.mr_n93465424)
print v(xbgr.mr_n93465696)
print v(xbgr.mr_n93465888)
print v(xbgr.mr_n93466240)
print v(xbgr.mr_n93466352)
print v(xbgr.mr_n93468944)
print v(xbgr.mr_n93470336)
print v(xbgr.mr_n93470608)
print v(xbgr.mr_n93470800)
print v(xbgr.mr_n93471152)
print v(xbgr.mr_n93471264)
print v(xbgr.mr_n93473856)
print v(xbgr.mr_n93475248)
print v(xbgr.mr_n93475520)
print v(xbgr.mr_n93475712)
print v(xbgr.mr_n93476064)
print v(xbgr.mr_n93476176)
print v(xbgr.mr_n93478768)
print v(xbgr.mr_n93480160)
print v(xbgr.mr_n93480352)
print v(xbgr.mr_n93480544)
print v(xbgr.mr_n93480976)
print v(xbgr.mr_n93481088)
print v(xbgr.mr_n93486016)
print v(xbgr.mr_n93490864)
print v(xbgr.mr_n93491120)
print v(xbgr.mr_n93502928)
print v(xbgr.mr_n93503712)
print v(xbgr.mr_n93504656)
print v(xbgr.mr_n93505600)
print v(xbgr.mr_n93506544)
print v(xbgr.mr_n93507488)
print v(xbgr.mr_n93508432)
print v(xbgr.mr_n93509376)
print v(xbgr.mr_n93510320)
print v(xbgr.mr_n93511264)
print v(xbgr.mr_n93512208)
print v(xbgr.mr_n93513152)
print v(xbgr.mr_n93514096)
print v(xbgr.mr_n93515040)
print v(xbgr.mr_n93515984)
print v(xbgr.mr_n93516928)
print v(xbgr.mr_n93517872)
print v(xbgr.mr_n93518816)
print v(xbgr.mr_n93519760)
print v(xbgr.mr_n93520704)
print v(xbgr.mr_n93521648)
print v(xbgr.mr_n93522592)
print v(xbgr.mr_n93523536)
print v(xbgr.mr_n93524480)
print v(xbgr.mr_n93526128)
print v(xbgr.mr_n93526464)
print v(xbgr.mr_n93529024)
print v(xbgr.mr_n93529360)
print v(xbgr.mr_n93530608)
print v(xbgr.mr_n93531536)
print v(xbgr.mr_n93531872)
print v(xbgr.mr_n93532416)
print v(xbgr.mr_n93533776)
print v(xbgr.mr_n93534048)
print v(xbgr.mr_n93538240)
print v(xbgr.mr_n93538576)
print v(xbgr.mr_n93540752)
print v(xbgr.mr_n93541088)
print v(xbgr.mr_n93543008)
print v(xbgr.mr_n93543568)
print v(xbgr.mr_n93544256)
print v(xbgr.mr_n93545008)
print v(xbgr.mr_n93545952)
print v(xbgr.mr_n93547568)
print v(xbgr.mr_n93548144)
print v(xbgr.mr_n93548256)
print v(xbgr.mr_n93549088)
print v(xbgr.mr_n93549200)
print v(xbgr.mr_n93550032)
print v(xbgr.mr_n93550144)
print v(xbgr.mr_n93550976)
print v(xbgr.mr_n93551088)
print v(xbgr.mr_n93551920)
print v(xbgr.mr_n93552032)
print v(xbgr.mr_n93553120)
print v(xbgr.mr_n93553232)
print v(xbgr.mr_n93554384)
print v(xbgr.mr_n93554496)
print v(xbgr.mr_n93555648)
print v(xbgr.mr_n93555760)
print v(xbgr.mr_n93556912)
print v(xbgr.mr_n93557024)
print v(xbgr.mr_n93558176)
print v(xbgr.mr_n93558288)
print v(xbgr.mr_n93559440)
print v(xbgr.mr_n93559552)
print v(xbgr.mr_n93560704)
print v(xbgr.mr_n93560816)
print v(xbgr.mr_n93561968)
print v(xbgr.mr_n93562080)
print v(xbgr.mr_n93563232)
print v(xbgr.mr_n93563344)
print v(xbgr.mr_n93564496)
print v(xbgr.mr_n93564608)
print v(xbgr.mr_n93565760)
print v(xbgr.mr_n93565872)
print v(xbgr.mr_n93567024)
print v(xbgr.mr_n93567136)
print v(xbgr.mr_n93576464)
print v(xbgr.mr_n93577184)
print v(xbgr.mr_n93588464)
print v(xbgr.mr_n93588656)
print v(xbgr.mr_n93588848)
print v(xbgr.mr_n93590896)
print v(xbgr.mr_n93591168)
print v(xbgr.mr_n93591360)
print v(xbgr.mr_n93591712)
print v(xbgr.mr_n93591824)
print v(xbgr.mr_n93593920)
print v(xbgr.mr_n93594944)
print v(xbgr.mr_n93597760)
print v(xbgr.mr_n93597952)
print v(xbgr.mr_n93598304)
print v(xbgr.mr_n93598416)
print v(xbgr.mr_n93601008)
print v(xbgr.mr_n93602400)
print v(xbgr.mr_n93602672)
print v(xbgr.mr_n93602864)
print v(xbgr.mr_n93603216)
print v(xbgr.mr_n93603328)
print v(xbgr.mr_n93604896)
print v(xbgr.mr_n93605008)
print v(xbgr.mr_n93608704)
print v(xbgr.mr_n93608896)
print v(xbgr.mr_n93609248)
print v(xbgr.mr_n93609360)
print v(xbgr.mr_n93611952)
print v(xbgr.mr_n93612144)
print v(xbgr.mr_n93613680)
print v(xbgr.mr_n93613872)
print v(xbgr.mr_n93614224)
print v(xbgr.mr_n93614336)
print v(xbgr.mr_n93615840)
print v(xbgr.mr_n93615952)
print v(xbgr.mr_n93619648)
print v(xbgr.mr_n93619840)
print v(xbgr.mr_n93620192)
print v(xbgr.mr_n93620304)
print v(xbgr.mr_n93622896)
print v(xbgr.mr_n93624288)
print v(xbgr.mr_n93624560)
print v(xbgr.mr_n93624752)
print v(xbgr.mr_n93625104)
print v(xbgr.mr_n93625216)
print v(xbgr.mr_n93626784)
print v(xbgr.mr_n93626896)
print v(xbgr.mr_n93630592)
print v(xbgr.mr_n93630784)
print v(xbgr.mr_n93631136)
print v(xbgr.mr_n93631248)
print v(xbgr.mr_n93633840)
print v(xbgr.mr_n93635232)
print v(xbgr.mr_n93635504)
print v(xbgr.mr_n93635696)
print v(xbgr.mr_n93636048)
print v(xbgr.mr_n93636160)
print v(xbgr.mr_n93636272)
print v(xbgr.mr_n93637728)
print v(xbgr.mr_n93637840)
print v(xbgr.mr_n93641456)
print v(xbgr.mr_n93641648)
print v(xbgr.mr_n93642080)
print v(xbgr.mr_n93642192)
print v(xbgr.mr_n93644784)
print v(xbgr.mr_n93646176)
print v(xbgr.mr_n93646448)
print v(xbgr.mr_n93646640)
print v(xbgr.mr_n93646992)
print v(xbgr.mr_n93647104)
print v(xbgr.mr_n93648672)
print v(xbgr.mr_n93648784)
print v(xbgr.mr_n93652480)
print v(xbgr.mr_n93652672)
print v(xbgr.mr_n93653024)
print v(xbgr.mr_n93653136)
print v(xbgr.mr_n93656432)
print v(xbgr.mr_n93658528)
print v(xbgr.mr_n93658640)
print v(xbgr.mr_n93659472)
print v(xbgr.mr_n93659584)
print v(xbgr.mr_n93660416)
print v(xbgr.mr_n93660528)
print v(xbgr.mr_n93661616)
print v(xbgr.mr_n93661728)
print v(xbgr.mr_n93662880)
print v(xbgr.mr_n93662992)
print v(xbgr.mr_n93664144)
print v(xbgr.mr_n93664256)
print v(xbgr.mr_n93665408)
print v(xbgr.mr_n93665520)
print v(xbgr.mr_n93666672)
print v(xbgr.mr_n93666784)
print v(xbgr.mr_n93666896)
print v(xbgr.mr_n93667424)
print v(xbgr.mr_n93667616)
print v(xbgr.mr_n93667808)
print v(xbgr.mr_n93667920)
print v(xbgr.mr_n93668592)
print v(xbgr.mr_n93668704)
print v(xbgr.mr_n93670256)
print v(xbgr.mr_n93671088)
print v(xbgr.mr_n93671200)
print v(xbgr.mr_n93674592)
print v(xbgr.mr_n93674704)
print v(xbgr.mr_n93676240)
print v(xbgr.mr_n93676352)
print v(xbgr.mr_n93677504)
print v(xbgr.mr_n93677616)
print v(xbgr.mr_n93678704)
print v(xbgr.mr_n93678816)
print v(xbgr.mr_n93680032)
print v(xbgr.mr_n93680144)
print v(xbgr.mr_n93681296)
print v(xbgr.mr_n93681408)
print v(xbgr.mr_n93682560)
print v(xbgr.mr_n93682672)
print v(xbgr.mr_n93683824)
print v(xbgr.mr_n93683936)
print v(xbgr.mr_n93685088)
print v(xbgr.mr_n93685200)
print v(xbgr.mr_n93686352)
print v(xbgr.mr_n93686464)
print v(xbgr.mr_n93687616)
print v(xbgr.mr_n93687728)
print v(xbgr.mr_n93688880)
print v(xbgr.mr_n93688992)
print v(xbgr.mr_n93690144)
print v(xbgr.mr_n93690256)
print v(xbgr.mr_n93691408)
print v(xbgr.mr_n93691520)
print v(xbgr.mr_n93692672)
print v(xbgr.mr_n93692784)
print v(xbgr.mr_n93693936)
print v(xbgr.mr_n93694048)
print v(xbgr.mr_n93699792)
print v(xbgr.mr_n93700432)
print v(xbgr.mr_n93710304)
print v(xbgr.mr_n93712720)
print v(xbgr.mr_n93724464)
print v(xbgr.mr_n93727872)
print v(xbgr.mr_n93731664)
print v(xbgr.mr_n93732352)
print v(xbgr.mr_n93733040)
print v(xbgr.mr_n93733760)
print v(xbgr.mr_n93734704)
print v(xbgr.mr_n93735648)
print v(xbgr.mr_n93736592)
print v(xbgr.mr_n93737536)
print v(xbgr.mr_n93738480)
print v(xbgr.mr_n93739424)
print v(xbgr.mr_n93740368)
print v(xbgr.mr_n93741312)
print v(xbgr.mr_n93742256)
print v(xbgr.mr_n93743200)
print v(xbgr.mr_n93744144)
print v(xbgr.mr_n93745088)
print v(xbgr.mr_n93746032)
print v(xbgr.mr_n93746976)
print v(xbgr.mr_n93747920)
print v(xbgr.mr_n93753984)
print v(xbgr.mr_n93755552)
print v(xbgr.mr_n93758928)
print v(xbgr.mr_n93762672)
print v(xbgr.mr_n93762784)
print v(xbgr.mr_n93763616)
print v(xbgr.mr_n93763728)
print v(xbgr.mr_n93763840)
print v(xbgr.mr_n93763952)
print v(xbgr.mr_n93765344)
print v(xbgr.mr_n93765616)
print v(xbgr.mr_n93765808)
print v(xbgr.mr_n93766160)
print v(xbgr.mr_n93766272)
print v(xbgr.mr_n93768848)
print v(xbgr.mr_n93769120)
print v(xbgr.mr_n93769312)
print v(xbgr.mr_n93769664)
print v(xbgr.mr_n93769776)
print v(xbgr.mr_n93773520)
print v(xbgr.mr_n93773712)
print v(xbgr.mr_n93774064)
print v(xbgr.mr_n93774176)
print v(xbgr.mr_n93777968)
print v(xbgr.mr_n93778240)
print v(xbgr.mr_n93778432)
print v(xbgr.mr_n93778784)
print v(xbgr.mr_n93778896)
print v(xbgr.mr_n93782640)
print v(xbgr.mr_n93782832)
print v(xbgr.mr_n93783184)
print v(xbgr.mr_n93783296)
print v(xbgr.mr_n93787088)
print v(xbgr.mr_n93787360)
print v(xbgr.mr_n93787552)
print v(xbgr.mr_n93787904)
print v(xbgr.mr_n93788016)
print v(xbgr.mr_n93791760)
print v(xbgr.mr_n93791952)
print v(xbgr.mr_n93792304)
print v(xbgr.mr_n93792416)
print v(xbgr.mr_n93796208)
print v(xbgr.mr_n93796480)
print v(xbgr.mr_n93796672)
print v(xbgr.mr_n93797024)
print v(xbgr.mr_n93797136)
print v(xbgr.mr_n93800880)
print v(xbgr.mr_n93801072)
print v(xbgr.mr_n93801424)
print v(xbgr.mr_n93801536)
print v(xbgr.mr_n93802960)
print v(xbgr.mr_n93803152)
print v(xbgr.mr_n93803344)
print v(xbgr.mr_n93803776)
print v(xbgr.mr_n93803888)
print v(xbgr.mr_n93805184)
print v(xbgr.mr_n93805296)
print v(xbgr.mr_n93809728)
print v(xbgr.mr_n93810000)
print v(xbgr.mr_n93810192)
print v(xbgr.mr_n93810544)
print v(xbgr.mr_n93810656)
print v(xbgr.mr_n93814160)
print v(xbgr.mr_n93814352)
print v(xbgr.mr_n93814704)
print v(xbgr.mr_n93814816)
print v(xbgr.mr_n93819520)
print v(xbgr.mr_n93820912)
print v(xbgr.mr_n93821184)
print v(xbgr.mr_n93821376)
print v(xbgr.mr_n93821728)
print v(xbgr.mr_n93821840)
print v(xbgr.mr_n93824432)
print v(xbgr.mr_n93825824)
print v(xbgr.mr_n93826096)
print v(xbgr.mr_n93826288)
print v(xbgr.mr_n93826640)
print v(xbgr.mr_n93826752)
print v(xbgr.mr_n93829344)
print v(xbgr.mr_n93830736)
print v(xbgr.mr_n93831008)
print v(xbgr.mr_n93831200)
print v(xbgr.mr_n93831552)
print v(xbgr.mr_n93831664)
print v(xbgr.mr_n93834256)
print v(xbgr.mr_n93835648)
print v(xbgr.mr_n93835920)
print v(xbgr.mr_n93836112)
print v(xbgr.mr_n93836464)
print v(xbgr.mr_n93836576)
print v(xbgr.mr_n93842192)
print v(xbgr.mr_n93844384)
print v(xbgr.mr_n93845952)
print v(xbgr.mr_n93846896)
print v(xbgr.mr_n93849088)
print v(xbgr.mr_n93850656)
print v(xbgr.mr_n93851600)
print v(xbgr.mr_n93853792)
print v(xbgr.mr_n93855408)
print v(xbgr.mr_n93855984)
print v(xbgr.mr_n93856096)
print v(xbgr.mr_n93856928)
print v(xbgr.mr_n93857040)
print v(xbgr.mr_n93857872)
print v(xbgr.mr_n93857984)
print v(xbgr.mr_n93858816)
print v(xbgr.mr_n93858928)
print v(xbgr.mr_n93859760)
print v(xbgr.mr_n93859872)
print v(xbgr.mr_n93860704)
print v(xbgr.mr_n93860816)
print v(xbgr.mr_n93861648)
print v(xbgr.mr_n93861760)
print v(xbgr.mr_n93862592)
print v(xbgr.mr_n93862704)
print v(xbgr.mr_n93863536)
print v(xbgr.mr_n93863648)
print v(xbgr.mr_n93864608)
print v(xbgr.mr_n93864720)
print v(xbgr.mr_n93865808)
print v(xbgr.mr_n93868880)
print v(xbgr.mr_n93872016)
print v(xbgr.mr_n93880608)
print v(xbgr.mr_n93883856)
print v(xbgr.mr_n93886464)
print v(xbgr.mr_n93893264)
print v(xbgr.mr_n93893472)
print v(xbgr.mr_n93895168)
print v(xbgr.mr_n93896512)
print v(xbgr.mr_n93897200)
print v(xbgr.mr_n93897888)
print v(xbgr.mr_n93898608)
print v(xbgr.mr_n93899552)
print v(xbgr.mr_n93900496)
print v(xbgr.mr_n93901440)
print v(xbgr.mr_n93902384)
print v(xbgr.mr_n93903328)
print v(xbgr.mr_n93904272)
print v(xbgr.mr_n93905216)
print v(xbgr.mr_n93906160)
print v(xbgr.mr_n93907104)
print v(xbgr.mr_n93908992)
print v(xbgr.mr_n93909936)
print v(xbgr.mr_n93910880)
print v(xbgr.mr_n93911824)
print v(xbgr.mr_n93912768)
print v(xbgr.mr_n93912960)
print v(xbgr.mr_n93913152)
print v(xbgr.mr_n93915408)
print v(xbgr.mr_n93929840)
print v(xbgr.mr_n93931696)
print v(xbgr.mr_n93938112)
print v(xbgr.mr_n93943152)
print v(xbgr.mr_n93944560)
print v(xbgr.mr_n93944752)
print v(xbgr.mr_n93945712)
print v(xbgr.mr_n93945824)
print v(xbgr.mr_n93945936)
print v(xbgr.mr_n93947328)
print v(xbgr.mr_n93947600)
print v(xbgr.mr_n93947792)
print v(xbgr.mr_n93948144)
print v(xbgr.mr_n93948256)
print v(xbgr.mr_n93953008)
print v(xbgr.mr_n93953280)
print v(xbgr.mr_n93953472)
print v(xbgr.mr_n93953824)
print v(xbgr.mr_n93953936)
print v(xbgr.mr_n93957552)
print v(xbgr.mr_n93957744)
print v(xbgr.mr_n93958096)
print v(xbgr.mr_n93958208)
print v(xbgr.mr_n93961872)
print v(xbgr.mr_n93962144)
print v(xbgr.mr_n93962336)
print v(xbgr.mr_n93962688)
print v(xbgr.mr_n93962800)
print v(xbgr.mr_n93966336)
print v(xbgr.mr_n93966528)
print v(xbgr.mr_n93966960)
print v(xbgr.mr_n93967072)
print v(xbgr.mr_n93970736)
print v(xbgr.mr_n93971008)
print v(xbgr.mr_n93971200)
print v(xbgr.mr_n93971552)
print v(xbgr.mr_n93971664)
print v(xbgr.mr_n93975280)
print v(xbgr.mr_n93975472)
print v(xbgr.mr_n93975824)
print v(xbgr.mr_n93975936)
print v(xbgr.mr_n93979600)
print v(xbgr.mr_n93979872)
print v(xbgr.mr_n93980064)
print v(xbgr.mr_n93980416)
print v(xbgr.mr_n93980528)
print v(xbgr.mr_n93988640)
print v(xbgr.mr_n93990208)
print v(xbgr.mr_n93991776)
print v(xbgr.mr_n93993344)
print v(xbgr.mr_n93994912)
print v(xbgr.mr_n93996480)
print v(xbgr.mr_n93998048)
print v(xbgr.mr_n94000528)
print v(xbgr.mr_n94000864)
print v(xbgr.mr_n94000976)
print v(xbgr.mr_n94001808)
print v(xbgr.mr_n94001920)
print v(xbgr.mr_n94002752)
print v(xbgr.mr_n94002864)
print v(xbgr.mr_n94003696)
print v(xbgr.mr_n94003808)
print v(xbgr.mr_n94004640)
print v(xbgr.mr_n94004752)
print v(xbgr.mr_n94005584)
print v(xbgr.mr_n94005696)
print v(xbgr.mr_n94006528)
print v(xbgr.mr_n94006640)
print v(xbgr.mr_n94007472)
print v(xbgr.mr_n94007584)
print v(xbgr.mr_n94008416)
print v(xbgr.mr_n94008528)
print v(xbgr.mr_n94009360)
print v(xbgr.mr_n94009472)
print v(xbgr.mr_n94010304)
print v(xbgr.mr_n94010416)
print v(xbgr.mr_n94011248)
print v(xbgr.mr_n94011360)
print v(xbgr.mr_n94012384)
print v(xbgr.mr_n94012496)
print v(xbgr.mr_n94013648)
print v(xbgr.mr_n94013760)
print v(xbgr.mr_n94014912)
print v(xbgr.mr_n94015024)
print v(xbgr.mr_n94016176)
print v(xbgr.mr_n94016288)
print v(xbgr.mr_n94017440)
print v(xbgr.mr_n94017552)
print v(xbgr.mr_n94023296)
print v(xbgr.mr_n94023984)
print v(xbgr.mr_n94024672)
print v(xbgr.mr_n94025392)
print v(xbgr.mr_n94026336)
print v(xbgr.mr_n94027280)
print v(xbgr.mr_n94028224)
print v(xbgr.mr_n94029168)
print v(xbgr.mr_n94030112)
print v(xbgr.mr_n94031056)
print v(xbgr.mr_n94032000)
print v(xbgr.mr_n94032944)
print v(xbgr.mr_n94033888)
print v(xbgr.mr_n94034832)
print v(xbgr.mr_n94035776)
print v(xbgr.mr_n94036720)
print v(xbgr.mr_n94037664)
print v(xbgr.mr_n94038608)
print v(xbgr.mr_n94039552)
print v(xbgr.mr_n94039664)
print v(xbgr.mr_n94043056)
print v(xbgr.mr_n94046592)
print v(xbgr.mr_n94047152)
print v(xbgr.mr_n94054320)
print v(xbgr.mr_n94055888)
print v(xbgr.mr_n94056928)
print v(xbgr.mr_n94057120)
print v(xbgr.mr_n94058448)
print v(xbgr.mr_n94060592)
print v(xbgr.mr_n94061344)
print v(xbgr.mr_n94062352)
print v(xbgr.mr_n94065008)
print v(xbgr.mr_n94066128)
print v(xbgr.mr_n94067600)
print v(xbgr.mr_n94069168)
print v(xbgr.mr_n94070736)
print v(xbgr.mr_n94072304)
print v(xbgr.mr_n94073056)
print v(xbgr.mr_n94073328)
print v(xbgr.mr_n94075152)
print v(xbgr.mr_n94075344)
print v(xbgr.mr_n94075536)
print v(xbgr.mr_n94076784)
print v(xbgr.mr_n94076896)
print v(xbgr.mr_n94081008)
print v(xbgr.mr_n94083200)
print v(xbgr.mr_n94084768)
print v(xbgr.mr_n94085712)
print v(xbgr.mr_n94087904)
print v(xbgr.mr_n94089472)
print v(xbgr.mr_n94090416)
print v(xbgr.mr_n94092608)
print v(xbgr.mr_n94094016)
print v(xbgr.mr_n94097568)
print v(xbgr.mr_n94099184)
print v(xbgr.mr_n94099296)
print v(xbgr.mr_n94100448)
print v(xbgr.mr_n94100560)
print v(xbgr.mr_n94101712)
print v(xbgr.mr_n94101824)
print v(xbgr.mr_n94102976)
print v(xbgr.mr_n94103088)
print v(xbgr.mr_n94104240)
print v(xbgr.mr_n94104352)
print v(xbgr.mr_n94105504)
print v(xbgr.mr_n94105616)
print v(xbgr.mr_n94106768)
print v(xbgr.mr_n94106880)
print v(xbgr.mr_n94108032)
print v(xbgr.mr_n94108144)
print v(xbgr.mr_n94109296)
print v(xbgr.mr_n94109408)
print v(xbgr.mr_n94110560)
print v(xbgr.mr_n94110672)
print v(xbgr.mr_n94110928)
print v(xbgr.mr_n94120032)
print v(xbgr.mr_n94123136)
print v(xbgr.mr_n94124288)
print v(xbgr.mr_n94124608)
print v(xbgr.mr_n94129280)
print v(xbgr.mr_n94133920)
print v(xbgr.mr_n94134032)
print v(xbgr.mr_n94134224)
print v(xbgr.mr_n94134416)
print v(xbgr.mr_n94134608)
print v(xbgr.mr_n94137024)
print v(xbgr.mr_n94142032)
print v(xbgr.mr_n94147552)
print v(xbgr.mr_n94148496)
print v(xbgr.mr_n94149440)
print v(xbgr.mr_n94150384)
print v(xbgr.mr_n94151328)
print v(xbgr.mr_n94152272)
print v(xbgr.mr_n94153216)
print v(xbgr.mr_n94154160)
print v(xbgr.mr_n94155104)
print v(xbgr.mr_n94156048)
print v(xbgr.mr_n94156992)
print v(xbgr.mr_n94157936)
print v(xbgr.mr_n94158880)
print v(xbgr.mr_n94159824)
print v(xbgr.mr_n94160768)
print v(xbgr.mr_n94161712)
print v(xbgr.mr_n94162656)
print v(xbgr.mr_n94163600)
print v(xbgr.mr_n94164544)
print v(xbgr.mr_n94165488)
print v(xbgr.mr_n94166432)
print v(xbgr.mr_n94167376)
print v(xbgr.mr_n94168320)
print v(xbgr.mr_n94169264)
print v(xbgr.mr_n94170208)
print v(xbgr.mr_n94171152)
print v(xbgr.mr_n94172096)
print v(xbgr.mr_n94173040)
print v(xbgr.mr_n94173984)
print v(xbgr.mr_n94174928)
print v(xbgr.mr_n94178048)
print v(xbgr.mr_n94178992)
print v(xbgr.mr_n94179936)
print v(xbgr.mr_n94181552)
print v(xbgr.mr_n94182832)
print v(xbgr.mr_n94182944)
print v(xbgr.mr_n94184096)
print v(xbgr.mr_n94184208)
print v(xbgr.mr_n94187056)
print v(xbgr.mr_n94187888)
print v(xbgr.mr_n94188000)
print v(xbgr.mr_n94188112)
print v(xbgr.mr_n94188224)
print v(xbgr.mr_n94189616)
print v(xbgr.mr_n94189888)
print v(xbgr.mr_n94190080)
print v(xbgr.mr_n94190432)
print v(xbgr.mr_n94190544)
print v(xbgr.mr_n94193136)
print v(xbgr.mr_n94194528)
print v(xbgr.mr_n94194800)
print v(xbgr.mr_n94194992)
print v(xbgr.mr_n94195344)
print v(xbgr.mr_n94195456)
print v(xbgr.mr_n94198048)
print v(xbgr.mr_n94199440)
print v(xbgr.mr_n94199712)
print v(xbgr.mr_n94199904)
print v(xbgr.mr_n94200256)
print v(xbgr.mr_n94200368)
print v(xbgr.mr_n94202960)
print v(xbgr.mr_n94204352)
print v(xbgr.mr_n94204624)
print v(xbgr.mr_n94204816)
print v(xbgr.mr_n94205168)
print v(xbgr.mr_n94205280)
print v(xbgr.mr_n94207872)
print v(xbgr.mr_n94208112)
print v(xbgr.mr_n94208224)
print v(xbgr.mr_n94208816)
print v(xbgr.mr_n94209008)
print v(xbgr.mr_n94209200)
print v(xbgr.mr_n94210672)
print v(xbgr.mr_n94210944)
print v(xbgr.mr_n94211136)
print v(xbgr.mr_n94211488)
print v(xbgr.mr_n94211600)
print v(xbgr.mr_n94215760)
print v(xbgr.mr_n94217152)
print v(xbgr.mr_n94217424)
print v(xbgr.mr_n94217616)
print v(xbgr.mr_n94217968)
print v(xbgr.mr_n94218080)
print v(xbgr.mr_n94220864)
print v(xbgr.mr_n94221056)
print v(xbgr.mr_n94222592)
print v(xbgr.mr_n94222784)
print v(xbgr.mr_n94223136)
print v(xbgr.mr_n94223248)
print v(xbgr.mr_n94226032)
print v(xbgr.mr_n94226720)
print v(xbgr.mr_n94227568)
print v(xbgr.mr_n94228512)
print v(xbgr.mr_n94229456)
print v(xbgr.mr_n94230400)
print v(xbgr.mr_n94231344)
print v(xbgr.mr_n94232288)
print v(xbgr.mr_n94233232)
print v(xbgr.mr_n94234176)
print v(xbgr.mr_n94235120)
print v(xbgr.mr_n94236064)
print v(xbgr.mr_n94240576)
print v(xbgr.mr_n94240880)
print v(xbgr.mr_n94241904)
print v(xbgr.mr_n94242176)
print v(xbgr.mr_n94244624)
print v(xbgr.mr_n94244816)
print v(xbgr.mr_n94245008)
print v(xbgr.mr_n94246112)
print v(xbgr.mr_n94246224)
print v(xbgr.mr_n94252544)
print v(xbgr.mr_n94253232)
print v(xbgr.mr_n94253920)
print v(xbgr.mr_n94254608)
print v(xbgr.mr_n94255296)
print v(xbgr.mr_n94255984)
print v(xbgr.mr_n94256672)
print v(xbgr.mr_n94257360)
print v(xbgr.mr_n94258048)
print v(xbgr.mr_n94258736)
print v(xbgr.mr_n94259424)
print v(xbgr.mr_n94261136)
print v(xbgr.mr_n94263888)
print v(xbgr.mr_n94264640)
print v(xbgr.mr_n94267072)
print v(xbgr.mr_n94272544)
print v(xbgr.mr_n94274400)
print v(xbgr.mr_n94274512)
print v(xbgr.mr_n94275664)
print v(xbgr.mr_n94275776)
print v(xbgr.mr_n94276928)
print v(xbgr.mr_n94277040)
print v(xbgr.mr_n94278192)
print v(xbgr.mr_n94278304)
print v(xbgr.mr_n94279456)
print v(xbgr.mr_n94279568)
print v(xbgr.mr_n94280720)
print v(xbgr.mr_n94280832)
print v(xbgr.mr_n94281984)
print v(xbgr.mr_n94282096)
print v(xbgr.mr_n94283248)
print v(xbgr.mr_n94283360)
print v(xbgr.mr_n94284512)
print v(xbgr.mr_n94284624)
print v(xbgr.mr_n94285776)
print v(xbgr.mr_n94285888)
print v(xbgr.mr_n94287040)
print v(xbgr.mr_n94287152)
print v(xbgr.mr_n94288240)
print v(xbgr.mr_n94288352)
print v(xbgr.mr_n94289568)
print v(xbgr.mr_n94289680)
print v(xbgr.mr_n94290832)
print v(xbgr.mr_n94290944)
print v(xbgr.mr_n94292096)
print v(xbgr.mr_n94292208)
print v(xbgr.mr_n94293360)
print v(xbgr.mr_n94293472)
print v(xbgr.mr_n94294624)
print v(xbgr.mr_n94294736)
print v(xbgr.mr_n94296144)
print v(xbgr.mr_n94298480)
print v(xbgr.mr_n94299600)
print v(xbgr.mr_n94301072)
print v(xbgr.mr_n94302640)
print v(xbgr.mr_n94304208)
print v(xbgr.mr_n94305776)
print v(xbgr.mr_n94307344)
print v(xbgr.mr_n94308912)
print v(xbgr.mr_n94310480)
print v(xbgr.mr_n94312048)
print v(xbgr.mr_n94313616)
print v(xbgr.mr_n94315184)
print v(xbgr.mr_n94317376)
print v(xbgr.mr_n94318944)
print v(xbgr.mr_n94320512)
print v(xbgr.mr_n94327216)
print v(xbgr.mr_n94335248)
print v(xbgr.mr_n94336320)
print v(xbgr.mr_n94336512)
print v(xbgr.mr_n94336704)
print v(xbgr.mr_n94338752)
print v(xbgr.mr_n94339024)
print v(xbgr.mr_n94339216)
print v(xbgr.mr_n94339568)
print v(xbgr.mr_n94339680)
print v(xbgr.mr_n94343104)
print v(xbgr.mr_n94344592)
print v(xbgr.mr_n94345152)
print v(xbgr.mr_n94348224)
print v(xbgr.mr_n94349056)
print v(xbgr.mr_n94349168)
print v(xbgr.mr_n94349280)
print v(xbgr.mr_n94349392)
print v(xbgr.mr_n94349584)
print v(xbgr.mr_n94349856)
print v(xbgr.mr_n94351120)
print v(xbgr.mr_n94351312)
print v(xbgr.mr_n94351664)
print v(xbgr.mr_n94351776)
print v(xbgr.mr_n94353280)
print v(xbgr.mr_n94353392)
print v(xbgr.mr_n94357312)
print v(xbgr.mr_n94357504)
print v(xbgr.mr_n94357856)
print v(xbgr.mr_n94357968)
print v(xbgr.mr_n94359664)
print v(xbgr.mr_n94359776)
print v(xbgr.mr_n94361792)
print v(xbgr.mr_n94361904)
print v(xbgr.mr_n94364304)
print v(xbgr.mr_n94364416)
print v(xbgr.mr_n94366816)
print v(xbgr.mr_n94366928)
print v(xbgr.mr_n94369328)
print v(xbgr.mr_n94369440)
print v(xbgr.mr_n94371840)
print v(xbgr.mr_n94371952)
print v(xbgr.mr_n94374352)
print v(xbgr.mr_n94374464)
print v(xbgr.mr_n94376864)
print v(xbgr.mr_n94376976)
print v(xbgr.mr_n94379376)
print v(xbgr.mr_n94379488)
print v(xbgr.mr_n94381888)
print v(xbgr.mr_n94382000)
print v(xbgr.mr_n94384400)
print v(xbgr.mr_n94384512)
print v(xbgr.mr_n94385712)
print v(xbgr.mr_n94386800)
print v(xbgr.mr_n94393008)
print v(xbgr.mr_n94393120)
print v(xbgr.mr_n94394272)
print v(xbgr.mr_n94394384)
print v(xbgr.mr_n94395536)
print v(xbgr.mr_n94395648)
print v(xbgr.mr_n94396800)
print v(xbgr.mr_n94396912)
print v(xbgr.mr_n94398064)
print v(xbgr.mr_n94398176)
print v(xbgr.mr_n94399328)
print v(xbgr.mr_n94399440)
print v(xbgr.mr_n94400592)
print v(xbgr.mr_n94400704)
print v(xbgr.mr_n94401856)
print v(xbgr.mr_n94401968)
print v(xbgr.mr_n94403120)
print v(xbgr.mr_n94403232)
print v(xbgr.mr_n94404384)
print v(xbgr.mr_n94404496)
print v(xbgr.mr_n94405648)
print v(xbgr.mr_n94405760)
print v(xbgr.mr_n94406912)
print v(xbgr.mr_n94407024)
print v(xbgr.mr_n94408176)
print v(xbgr.mr_n94408288)
print v(xbgr.mr_n94409440)
print v(xbgr.mr_n94409552)
print v(xbgr.mr_n94410960)
print v(xbgr.mr_n94411728)
print v(xbgr.mr_n94417872)
print v(xbgr.mr_n94425248)
print v(xbgr.mr_n94425680)
print v(xbgr.mr_n94426128)
print v(xbgr.mr_n94428032)
print v(xbgr.mr_n94428720)
print v(xbgr.mr_n94429408)
print v(xbgr.mr_n94430128)
print v(xbgr.mr_n94431072)
print v(xbgr.mr_n94432016)
print v(xbgr.mr_n94432960)
print v(xbgr.mr_n94433904)
print v(xbgr.mr_n94434848)
print v(xbgr.mr_n94435792)
print v(xbgr.mr_n94436736)
print v(xbgr.mr_n94437680)
print v(xbgr.mr_n94438624)
print v(xbgr.mr_n94439568)
print v(xbgr.mr_n94440512)
print v(xbgr.mr_n94441456)
print v(xbgr.mr_n94442400)
print v(xbgr.mr_n94443344)
print v(xbgr.mr_n94444288)
print v(xbgr.mr_n94450608)
print v(xbgr.mr_n94452176)
print v(xbgr.mr_n94454752)
print v(xbgr.mr_n94455248)
print v(xbgr.mr_n94455984)
print v(xbgr.mr_n94456096)
print v(xbgr.mr_n94457040)
print v(xbgr.mr_n94458192)
print v(xbgr.mr_n94458304)
print v(xbgr.mr_n94460080)
print v(xbgr.mr_n94460192)
print v(xbgr.mr_n94461136)
print v(xbgr.mr_n94462288)
print v(xbgr.mr_n94462400)
print v(xbgr.mr_n94464176)
print v(xbgr.mr_n94464288)
print v(xbgr.mr_n94465232)
print v(xbgr.mr_n94466384)
print v(xbgr.mr_n94466496)
print v(xbgr.mr_n94467744)
print v(xbgr.mr_n94468272)
print v(xbgr.mr_n94468384)
print v(xbgr.mr_n94469328)
print v(xbgr.mr_n94470480)
print v(xbgr.mr_n94470592)
print v(xbgr.mr_n94472368)
print v(xbgr.mr_n94472480)
print v(xbgr.mr_n94473424)
print v(xbgr.mr_n94474576)
print v(xbgr.mr_n94474688)
print v(xbgr.mr_n94475856)
print v(xbgr.mr_n94476464)
print v(xbgr.mr_n94476576)
print v(xbgr.mr_n94477520)
print v(xbgr.mr_n94478448)
print v(xbgr.mr_n94479216)
print v(xbgr.mr_n94479328)
print v(xbgr.mr_n94480528)
print v(xbgr.mr_n94481056)
print v(xbgr.mr_n94481168)
print v(xbgr.mr_n94483776)
print v(xbgr.mr_n94484928)
print v(xbgr.mr_n94485040)
print v(xbgr.mr_n94486816)
print v(xbgr.mr_n94486928)
print v(xbgr.mr_n94488240)
print v(xbgr.mr_n94489360)
print v(xbgr.mr_n94491456)
print v(xbgr.mr_n94493024)
print v(xbgr.mr_n94494592)
print v(xbgr.mr_n94496160)
print v(xbgr.mr_n94497728)
print v(xbgr.mr_n94499296)
print v(xbgr.mr_n94500864)
print v(xbgr.mr_n94520032)
print v(xbgr.mr_n94520224)
print v(xbgr.mr_n94520912)
print v(xbgr.mr_n94521344)
print v(xbgr.mr_n94522176)
print v(xbgr.mr_n94522752)
print v(xbgr.mr_n94523440)
print v(xbgr.mr_n94523872)
print v(xbgr.mr_n94524704)
print v(xbgr.mr_n94525136)
print v(xbgr.mr_n94525968)
print v(xbgr.mr_n94526400)
print v(xbgr.mr_n94527232)
print v(xbgr.mr_n94527808)
print v(xbgr.mr_n94528496)
print v(xbgr.mr_n94528928)
print v(xbgr.mr_n94529760)
print v(xbgr.mr_n94530192)
print v(xbgr.mr_n94531024)
print v(xbgr.mr_n94531600)
print v(xbgr.mr_n94532288)
print v(xbgr.mr_n94532864)
print v(xbgr.mr_n94533552)
print v(xbgr.mr_n94533984)
print v(xbgr.mr_n94534816)
print v(xbgr.mr_n94535248)
print v(xbgr.mr_n94536080)
print v(xbgr.mr_n94536512)
print v(xbgr.mr_n94537344)
print v(xbgr.mr_n94537920)
print v(xbgr.mr_n94538608)
print v(xbgr.mr_n94539040)
print v(xbgr.mr_n94539872)
print v(xbgr.mr_n94540304)
print v(xbgr.mr_n94541136)
print v(xbgr.mr_n94544640)
print v(xbgr.mr_n94544752)
print v(xbgr.mr_n94544864)
print v(xbgr.mr_n94545056)
print v(xbgr.mr_n94547168)
print v(xbgr.mr_n94547360)
print v(xbgr.mr_n94547712)
print v(xbgr.mr_n94547824)
print v(xbgr.mr_n94549328)
print v(xbgr.mr_n94549440)
print v(xbgr.mr_n94551328)
print v(xbgr.mr_n94551440)
print v(xbgr.mr_n94552256)
print v(xbgr.mr_n94553776)
print v(xbgr.mr_n94553888)
print v(xbgr.mr_n94556096)
print v(xbgr.mr_n94556208)
print v(xbgr.mr_n94558480)
print v(xbgr.mr_n94558592)
print v(xbgr.mr_n94560928)
print v(xbgr.mr_n94561040)
print v(xbgr.mr_n94563248)
print v(xbgr.mr_n94563360)
print v(xbgr.mr_n94565632)
print v(xbgr.mr_n94565744)
print v(xbgr.mr_n94568080)
print v(xbgr.mr_n94568192)
print v(xbgr.mr_n94570400)
print v(xbgr.mr_n94570512)
print v(xbgr.mr_n94571328)
print v(xbgr.mr_n94572784)
print v(xbgr.mr_n94572896)
print v(xbgr.mr_n94575168)
print v(xbgr.mr_n94575280)
print v(xbgr.mr_n94577552)
print v(xbgr.mr_n94577664)
print v(xbgr.mr_n94579936)
print v(xbgr.mr_n94580048)
print v(xbgr.mr_n94582320)
print v(xbgr.mr_n94582432)
print v(xbgr.mr_n94584768)
print v(xbgr.mr_n94584880)
print v(xbgr.mr_n94594304)
print v(xbgr.mr_n94594416)
print v(xbgr.mr_n94595568)
print v(xbgr.mr_n94595680)
print v(xbgr.mr_n94596832)
print v(xbgr.mr_n94596944)
print v(xbgr.mr_n94598096)
print v(xbgr.mr_n94598208)
print v(xbgr.mr_n94599360)
print v(xbgr.mr_n94599472)
print v(xbgr.mr_n94600624)
print v(xbgr.mr_n94600736)
print v(xbgr.mr_n94601888)
print v(xbgr.mr_n94602000)
print v(xbgr.mr_n94603152)
print v(xbgr.mr_n94603264)
print v(xbgr.mr_n94604416)
print v(xbgr.mr_n94604528)
print v(xbgr.mr_n94605680)
print v(xbgr.mr_n94605792)
print v(xbgr.mr_n94606944)
print v(xbgr.mr_n94607056)
print v(xbgr.mr_n94608208)
print v(xbgr.mr_n94608320)
print v(xbgr.mr_n94609472)
print v(xbgr.mr_n94609584)
print v(xbgr.mr_n94610736)
print v(xbgr.mr_n94610848)
print v(xbgr.mr_n94613808)
print v(xbgr.mr_n94614880)
print v(xbgr.mr_n94615568)
print v(xbgr.mr_n94616672)
print v(xbgr.mr_n94618704)
print v(xbgr.mr_n94619648)
print v(xbgr.mr_n94620592)
print v(xbgr.mr_n94621536)
print v(xbgr.mr_n94622480)
print v(xbgr.mr_n94623424)
print v(xbgr.mr_n94624368)
print v(xbgr.mr_n94625312)
print v(xbgr.mr_n94626256)
print v(xbgr.mr_n94627200)
print v(xbgr.mr_n94628144)
print v(xbgr.mr_n94629088)
print v(xbgr.mr_n94630032)
print v(xbgr.mr_n94630976)
print v(xbgr.mr_n94631920)
print v(xbgr.mr_n94636000)
print v(xbgr.mr_n94637552)
print v(xbgr.mr_n94641264)
print v(xbgr.mr_n94641440)
print v(xbgr.mr_n94642592)
print v(xbgr.mr_n94644160)
print v(xbgr.mr_n94645728)
print v(xbgr.mr_n94647296)
print v(xbgr.mr_n94648864)
print v(xbgr.mr_n94650432)
print v(xbgr.mr_n94652000)
print v(xbgr.mr_n94653568)
print v(xbgr.mr_n94655136)
print v(xbgr.mr_n94656704)
print v(xbgr.mr_n94658272)
print v(xbgr.mr_n94659840)
print v(xbgr.mr_n94661408)
print v(xbgr.mr_n94663600)
print v(xbgr.mr_n94665168)
print v(xbgr.mr_n94666736)
print v(xbgr.mr_n94668304)
print v(xbgr.mr_n94669872)
print v(xbgr.mr_n94671440)
print v(xbgr.mr_n94673008)
print v(xbgr.mr_n94673952)
print v(xbgr.mr_n94675168)
print v(xbgr.mr_n94675840)
print v(xbgr.mr_n94677696)
print v(xbgr.mr_n94677808)
print v(xbgr.mr_n94678960)
print v(xbgr.mr_n94679072)
print v(xbgr.mr_n94680224)
print v(xbgr.mr_n94680336)
print v(xbgr.mr_n94681488)
print v(xbgr.mr_n94681600)
print v(xbgr.mr_n94682752)
print v(xbgr.mr_n94682864)
print v(xbgr.mr_n94684016)
print v(xbgr.mr_n94684128)
print v(xbgr.mr_n94685280)
print v(xbgr.mr_n94685392)
print v(xbgr.mr_n94686544)
print v(xbgr.mr_n94686656)
print v(xbgr.mr_n94687808)
print v(xbgr.mr_n94687920)
print v(xbgr.mr_n94689072)
print v(xbgr.mr_n94689184)
print v(xbgr.mr_n94690336)
print v(xbgr.mr_n94690448)
print v(xbgr.mr_n94691600)
print v(xbgr.mr_n94691712)
print v(xbgr.mr_n94692864)
print v(xbgr.mr_n94692976)
print v(xbgr.mr_n94694128)
print v(xbgr.mr_n94694240)
print v(xbgr.mr_n94695392)
print v(xbgr.mr_n94695504)
print v(xbgr.mr_n94696656)
print v(xbgr.mr_n94696768)
print v(xbgr.mr_n94697920)
print v(xbgr.mr_n94698032)
print v(xbgr.mr_n94698144)
print v(xbgr.mr_n94708128)
print v(xbgr.mr_n94716896)
print v(xbgr.mr_n94717440)
print v(xbgr.mr_n94720192)
print v(xbgr.mr_n94720752)
print v(xbgr.mr_n94721328)
print v(xbgr.mr_n94722016)
print v(xbgr.mr_n94722448)
print v(xbgr.mr_n94723280)
print v(xbgr.mr_n94723712)
print v(xbgr.mr_n94724544)
print v(xbgr.mr_n94725120)
print v(xbgr.mr_n94725808)
print v(xbgr.mr_n94726384)
print v(xbgr.mr_n94727072)
print v(xbgr.mr_n94727648)
print v(xbgr.mr_n94728336)
print v(xbgr.mr_n94728912)
print v(xbgr.mr_n94729600)
print v(xbgr.mr_n94730032)
print v(xbgr.mr_n94730864)
print v(xbgr.mr_n94731296)
print v(xbgr.mr_n94732128)
print v(xbgr.mr_n94732704)
print v(xbgr.mr_n94733392)
print v(xbgr.mr_n94733824)
print v(xbgr.mr_n94734656)
print v(xbgr.mr_n94735088)
print v(xbgr.mr_n94735920)
print v(xbgr.mr_n94736352)
print v(xbgr.mr_n94737184)
print v(xbgr.mr_n94737616)
print v(xbgr.mr_n94738448)
print v(xbgr.mr_n94739152)
print v(xbgr.mr_n94739712)
print v(xbgr.mr_n94740144)
print v(xbgr.mr_n94740976)
print v(xbgr.mr_n94746672)
print v(xbgr.mr_n94746944)
print v(xbgr.mr_n94747136)
print v(xbgr.mr_n94747488)
print v(xbgr.mr_n94747600)
print v(xbgr.mr_n94748880)
print v(xbgr.mr_n94748992)
print v(xbgr.mr_n94750112)
print v(xbgr.mr_n94750384)
print v(xbgr.mr_n94750576)
print v(xbgr.mr_n94750928)
print v(xbgr.mr_n94751040)
print v(xbgr.mr_n94753600)
print v(xbgr.mr_n94753712)
print v(xbgr.mr_n94757200)
print v(xbgr.mr_n94757312)
print v(xbgr.mr_n94759584)
print v(xbgr.mr_n94759696)
print v(xbgr.mr_n94762032)
print v(xbgr.mr_n94762144)
print v(xbgr.mr_n94764352)
print v(xbgr.mr_n94764464)
print v(xbgr.mr_n94766736)
print v(xbgr.mr_n94766848)
print v(xbgr.mr_n94769120)
print v(xbgr.mr_n94769232)
print v(xbgr.mr_n94771504)
print v(xbgr.mr_n94771616)
print v(xbgr.mr_n94773888)
print v(xbgr.mr_n94774000)
print v(xbgr.mr_n94776272)
print v(xbgr.mr_n94776384)
print v(xbgr.mr_n94778656)
print v(xbgr.mr_n94778768)
print v(xbgr.mr_n94781104)
print v(xbgr.mr_n94781216)
print v(xbgr.mr_n94783424)
print v(xbgr.mr_n94783536)
print v(xbgr.mr_n94784368)
print v(xbgr.mr_n94791904)
print v(xbgr.mr_n94793056)
print v(xbgr.mr_n94793168)
print v(xbgr.mr_n94794320)
print v(xbgr.mr_n94794432)
print v(xbgr.mr_n94795584)
print v(xbgr.mr_n94795696)
print v(xbgr.mr_n94796848)
print v(xbgr.mr_n94796960)
print v(xbgr.mr_n94798048)
print v(xbgr.mr_n94798160)
print v(xbgr.mr_n94799376)
print v(xbgr.mr_n94799488)
print v(xbgr.mr_n94800640)
print v(xbgr.mr_n94800752)
print v(xbgr.mr_n94801904)
print v(xbgr.mr_n94802016)
print v(xbgr.mr_n94803168)
print v(xbgr.mr_n94803280)
print v(xbgr.mr_n94804432)
print v(xbgr.mr_n94804544)
print v(xbgr.mr_n94805696)
print v(xbgr.mr_n94805808)
print v(xbgr.mr_n94806960)
print v(xbgr.mr_n94807072)
print v(xbgr.mr_n94808224)
print v(xbgr.mr_n94808336)
print v(xbgr.mr_n94809488)
print v(xbgr.mr_n94809600)
print v(xbgr.mr_n94810752)
print v(xbgr.mr_n94810864)
print v(xbgr.mr_n94811744)
print v(xbgr.mr_n94812432)
print v(xbgr.mr_n94813120)
print v(xbgr.mr_n94813840)
print v(xbgr.mr_n94814784)
print v(xbgr.mr_n94815728)
print v(xbgr.mr_n94816672)
print v(xbgr.mr_n94817616)
print v(xbgr.mr_n94818560)
print v(xbgr.mr_n94819504)
print v(xbgr.mr_n94820448)
print v(xbgr.mr_n94821392)
print v(xbgr.mr_n94822336)
print v(xbgr.mr_n94823280)
print v(xbgr.mr_n94824224)
print v(xbgr.mr_n94825168)
print v(xbgr.mr_n94845824)
print v(xbgr.mr_n94847392)
print v(xbgr.mr_n94849872)
print v(xbgr.mr_n94850912)
print v(xbgr.mr_n94851024)
print v(xbgr.mr_n94851968)
print v(xbgr.mr_n94853120)
print v(xbgr.mr_n94853232)
print v(xbgr.mr_n94855008)
print v(xbgr.mr_n94855120)
print v(xbgr.mr_n94856064)
print v(xbgr.mr_n94857216)
print v(xbgr.mr_n94857328)
print v(xbgr.mr_n94858576)
print v(xbgr.mr_n94859104)
print v(xbgr.mr_n94859216)
print v(xbgr.mr_n94860160)
print v(xbgr.mr_n94861312)
print v(xbgr.mr_n94861424)
print v(xbgr.mr_n94862672)
print v(xbgr.mr_n94863200)
print v(xbgr.mr_n94863312)
print v(xbgr.mr_n94864256)
print v(xbgr.mr_n94865408)
print v(xbgr.mr_n94865520)
print v(xbgr.mr_n94867296)
print v(xbgr.mr_n94867408)
print v(xbgr.mr_n94868352)
print v(xbgr.mr_n94869504)
print v(xbgr.mr_n94869616)
print v(xbgr.mr_n94870784)
print v(xbgr.mr_n94871392)
print v(xbgr.mr_n94871504)
print v(xbgr.mr_n94872448)
print v(xbgr.mr_n94873600)
print v(xbgr.mr_n94873712)
print v(xbgr.mr_n94874960)
print v(xbgr.mr_n94875488)
print v(xbgr.mr_n94875600)
print v(xbgr.mr_n94876384)
print v(xbgr.mr_n94876544)
print v(xbgr.mr_n94877696)
print v(xbgr.mr_n94877808)
print v(xbgr.mr_n94879584)
print v(xbgr.mr_n94879696)
print v(xbgr.mr_n94880640)
print v(xbgr.mr_n94880832)
print v(xbgr.mr_n94881792)
print v(xbgr.mr_n94881904)
print v(xbgr.mr_n94883680)
print v(xbgr.mr_n94883792)
print v(xbgr.mr_n94883904)
print v(xbgr.mr_n94884992)
print v(xbgr.mr_n94887632)
print v(xbgr.mr_n94889616)
print v(xbgr.mr_n94891184)
print v(xbgr.mr_n94892752)
print v(xbgr.mr_n94905984)
print v(xbgr.mr_n94910048)
print v(xbgr.mr_n94910496)
print v(xbgr.mr_n94911232)
print v(xbgr.mr_n94913536)
print v(xbgr.mr_n94914208)
print v(xbgr.mr_n94915472)
print v(xbgr.mr_n94915664)
print v(xbgr.mr_n94915856)
print v(xbgr.mr_n94917904)
print v(xbgr.mr_n94918176)
print v(xbgr.mr_n94918368)
print v(xbgr.mr_n94918720)
print v(xbgr.mr_n94918832)
print v(xbgr.mr_n94921408)
print v(xbgr.mr_n94922720)
print v(xbgr.mr_n94924768)
print v(xbgr.mr_n94924960)
print v(xbgr.mr_n94925312)
print v(xbgr.mr_n94925424)
print v(xbgr.mr_n94928416)
print v(xbgr.mr_n94928608)
print v(xbgr.mr_n94928960)
print v(xbgr.mr_n94929072)
print v(xbgr.mr_n94931664)
print v(xbgr.mr_n94933056)
print v(xbgr.mr_n94933328)
print v(xbgr.mr_n94933520)
print v(xbgr.mr_n94933872)
print v(xbgr.mr_n94933984)
print v(xbgr.mr_n94935552)
print v(xbgr.mr_n94935664)
print v(xbgr.mr_n94939360)
print v(xbgr.mr_n94939552)
print v(xbgr.mr_n94939904)
print v(xbgr.mr_n94940016)
print v(xbgr.mr_n94942608)
print v(xbgr.mr_n94944000)
print v(xbgr.mr_n94944272)
print v(xbgr.mr_n94944464)
print v(xbgr.mr_n94944816)
print v(xbgr.mr_n94944928)
print v(xbgr.mr_n94946496)
print v(xbgr.mr_n94946608)
print v(xbgr.mr_n94950224)
print v(xbgr.mr_n94950416)
print v(xbgr.mr_n94950848)
print v(xbgr.mr_n94950960)
print v(xbgr.mr_n94953552)
print v(xbgr.mr_n94954944)
print v(xbgr.mr_n94955216)
print v(xbgr.mr_n94955408)
print v(xbgr.mr_n94955760)
print v(xbgr.mr_n94955872)
print v(xbgr.mr_n94957440)
print v(xbgr.mr_n94957552)
print v(xbgr.mr_n94961248)
print v(xbgr.mr_n94961440)
print v(xbgr.mr_n94961792)
print v(xbgr.mr_n94961904)
print v(xbgr.mr_n94964496)
print v(xbgr.mr_n94965888)
print v(xbgr.mr_n94966160)
print v(xbgr.mr_n94966352)
print v(xbgr.mr_n94966704)
print v(xbgr.mr_n94966816)
print v(xbgr.mr_n94968384)
print v(xbgr.mr_n94968496)
print v(xbgr.mr_n94972192)
print v(xbgr.mr_n94972384)
print v(xbgr.mr_n94972736)
print v(xbgr.mr_n94972848)
print v(xbgr.mr_n94975440)
print v(xbgr.mr_n94976832)
print v(xbgr.mr_n94977104)
print v(xbgr.mr_n94977296)
print v(xbgr.mr_n94977648)
print v(xbgr.mr_n94977760)
print v(xbgr.mr_n94977952)
print v(xbgr.mr_n94979328)
print v(xbgr.mr_n94979440)
print v(xbgr.mr_n94981360)
print v(xbgr.mr_n94982656)
print v(xbgr.mr_n94982768)
print v(xbgr.mr_n94983280)
print v(xbgr.mr_n94983392)
print v(xbgr.mr_n94983904)
print v(xbgr.mr_n94984016)
print v(xbgr.mr_n94984784)
print v(xbgr.mr_n94984896)
print v(xbgr.mr_n94985728)
print v(xbgr.mr_n94985840)
print v(xbgr.mr_n94986672)
print v(xbgr.mr_n94986784)
print v(xbgr.mr_n94987616)
print v(xbgr.mr_n94987728)
print v(xbgr.mr_n94988688)
print v(xbgr.mr_n94988800)
print v(xbgr.mr_n94989952)
print v(xbgr.mr_n94990064)
print v(xbgr.mr_n94991216)
print v(xbgr.mr_n94991328)
print v(xbgr.mr_n94992416)
print v(xbgr.mr_n94992528)
print v(xbgr.mr_n94993680)
print v(xbgr.mr_n94993792)
print v(xbgr.mr_n94995008)
print v(xbgr.mr_n94995120)
print v(xbgr.mr_n94996272)
print v(xbgr.mr_n94996384)
print v(xbgr.mr_n94997536)
print v(xbgr.mr_n94997648)
print v(xbgr.mr_n94999824)
print v(xbgr.mr_n95005632)
print v(xbgr.mr_n95009904)
print v(xbgr.mr_n95010656)
print v(xbgr.mr_n95011056)
print v(xbgr.mr_n95011600)
print v(xbgr.mr_n95015296)
print v(xbgr.mr_n95021248)
print v(xbgr.mr_n95025728)
print v(xbgr.mr_n95026336)
print v(xbgr.mr_n95030704)
print v(xbgr.mr_n95030816)
print v(xbgr.mr_n95033344)
print v(xbgr.mr_n95033456)
print v(xbgr.mr_n95034608)
print v(xbgr.mr_n95034720)
print v(xbgr.mr_n95035872)
print v(xbgr.mr_n95035984)
print v(xbgr.mr_n95037136)
print v(xbgr.mr_n95037248)
print v(xbgr.mr_n95038400)
print v(xbgr.mr_n95038512)
print v(xbgr.mr_n95039664)
print v(xbgr.mr_n95039776)
print v(xbgr.mr_n95040928)
print v(xbgr.mr_n95041040)
print v(xbgr.mr_n95042192)
print v(xbgr.mr_n95042304)
print v(xbgr.mr_n95043456)
print v(xbgr.mr_n95043568)
print v(xbgr.mr_n95044720)
print v(xbgr.mr_n95044832)
print v(xbgr.mr_n95045984)
print v(xbgr.mr_n95046096)
print v(xbgr.mr_n95047248)
print v(xbgr.mr_n95047360)
print v(xbgr.mr_n95048512)
print v(xbgr.mr_n95048624)
print v(xbgr.mr_n95049776)
print v(xbgr.mr_n95049888)
print v(xbgr.mr_n95051040)
print v(xbgr.mr_n95051152)
print v(xbgr.mr_n95052304)
print v(xbgr.mr_n95052416)
print v(xbgr.mr_n95060400)
print v(xbgr.mr_n95061088)
print v(xbgr.mr_n95061776)
print v(xbgr.mr_n95062496)
print v(xbgr.mr_n95063440)
print v(xbgr.mr_n95064384)
print v(xbgr.mr_n95065328)
print v(xbgr.mr_n95066272)
print v(xbgr.mr_n95067216)
print v(xbgr.mr_n95068160)
print v(xbgr.mr_n95069104)
print v(xbgr.mr_n95070048)
print v(xbgr.mr_n95070992)
print v(xbgr.mr_n95071936)
print v(xbgr.mr_n95072880)
print v(xbgr.mr_n95073824)
print v(xbgr.mr_n95074768)
print v(xbgr.mr_n95075712)
print v(xbgr.mr_n95076656)
print v(xbgr.mr_n95077600)
print v(xbgr.mr_n95078544)
print v(xbgr.mr_n95079488)
print v(xbgr.mr_n95080432)
print v(xbgr.mr_n95081376)
print v(xbgr.mr_n95082320)
print v(xbgr.mr_n95083264)
print v(xbgr.mr_n95084208)
print v(xbgr.mr_n95085152)
print v(xbgr.mr_n95086096)
print v(xbgr.mr_n95087040)
print v(xbgr.mr_n95087984)
print v(xbgr.mr_n95088928)
print v(xbgr.mr_n95093472)
print v(xbgr.mr_n95094112)
print v(xbgr.mr_n95102928)
print v(xbgr.mr_n95104128)
print v(xbgr.mr_n95104912)
print v(xbgr.mr_n95107120)
print v(xbgr.mr_n95108944)
print v(xbgr.mr_n95109056)
print v(xbgr.mr_n95109936)
print v(xbgr.mr_n95110640)
print v(xbgr.mr_n95111408)
print v(xbgr.mr_n95111936)
print v(xbgr.mr_n95112400)
print v(xbgr.mr_n95113520)
print v(xbgr.mr_n95114160)
print v(xbgr.mr_n95114336)
print v(xbgr.mr_n95115568)
print v(xbgr.mr_n95116160)
print v(xbgr.mr_n95116624)
print v(xbgr.mr_n95117920)
print v(xbgr.mr_n95118624)
print v(xbgr.mr_n95118800)
print v(xbgr.mr_n95119088)
print v(xbgr.mr_n95120208)
print v(xbgr.mr_n95121376)
print v(xbgr.mr_n95121552)
print v(xbgr.mr_n95122144)
print v(xbgr.mr_n95122320)
print v(xbgr.mr_n95122848)
print v(xbgr.mr_n95123024)
print v(xbgr.mr_n95124016)
print v(xbgr.mr_n95124256)
print v(xbgr.mr_n95124432)
print v(xbgr.mr_n95125312)
print v(xbgr.mr_n95126192)
print v(xbgr.mr_n95126368)
print v(xbgr.mr_n95126544)
print v(xbgr.mr_n95126832)
print v(xbgr.mr_n95127600)
print v(xbgr.mr_n95127776)
print v(xbgr.mr_n95128832)
print v(xbgr.mr_n95129008)
print v(xbgr.mr_n95130064)
print v(xbgr.mr_n95131024)
print v(xbgr.mr_n95132832)
print v(xbgr.mr_n95133776)
print v(xbgr.mr_n95134720)
print v(xbgr.mr_n95135664)
print v(xbgr.mr_n95136608)
print v(xbgr.mr_n95137552)
print v(xbgr.mr_n95138496)
print v(xbgr.mr_n95139440)
print v(xbgr.mr_n95140384)
print v(xbgr.mr_n95141328)
print v(xbgr.mr_n95142272)
print v(xbgr.mr_n95143216)
print v(xbgr.mr_n95144160)
print v(xbgr.mr_n95145104)
print v(xbgr.mr_n95146048)
print v(xbgr.mr_n95146992)
print v(xbgr.mr_n95147936)
print v(xbgr.mr_n95148880)
print v(xbgr.mr_n95149824)
print v(xbgr.mr_n95150768)
print v(xbgr.mr_n95151712)
print v(xbgr.mr_n95152656)
print v(xbgr.mr_n95153600)
print v(xbgr.mr_n95154256)
print v(xbgr.mr_n95154720)
print v(xbgr.mr_n95156928)
print v(xbgr.mr_n95157936)
print v(xbgr.mr_n95158880)
print v(xbgr.mr_n95159824)
print v(xbgr.mr_n95160768)
print v(xbgr.mr_n95161712)
print v(xbgr.mr_n95162656)
print v(xbgr.mr_n95163600)
print v(xbgr.mr_n95164544)
print v(xbgr.mr_n95165488)
print v(xbgr.mr_n95166432)
print v(xbgr.mr_n95167376)
print v(xbgr.mr_n95168320)
print v(xbgr.mr_n95169264)
print v(xbgr.mr_n95170208)
print v(xbgr.mr_n95171152)
print v(xbgr.mr_n95172096)
print v(xbgr.mr_n95173040)
print v(xbgr.mr_n95173984)
print v(xbgr.mr_n95174928)
print v(xbgr.mr_n95175872)
print v(xbgr.mr_n95176816)
print v(xbgr.mr_n95177760)
print v(xbgr.mr_n95178704)
print v(xbgr.mr_n95179648)
print v(xbgr.mr_n95180592)
print v(xbgr.mr_n95181536)
print v(xbgr.mr_n95182480)
print v(xbgr.mr_n95183424)
print v(xbgr.mr_n95184368)
print v(xbgr.mr_n95185312)
print v(xbgr.mr_n95186256)
print v(xbgr.mr_n95187200)
print v(xbgr.mr_n95188144)
print v(xbgr.mr_n95189088)
print v(xbgr.mr_n95190032)
print v(xbgr.mr_n95190976)
print v(xbgr.mr_n95191920)
print v(xbgr.mr_n95192864)
print v(xbgr.mr_n95193808)
print v(xbgr.mr_n95194752)
print v(xbgr.mr_n95195696)
print v(xbgr.mr_n95196640)
print v(xbgr.mr_n95197584)
print v(xbgr.mr_n95198528)
print v(xbgr.mr_n95199472)
print v(xbgr.mr_n95200416)
print v(xbgr.mr_n95201360)
print v(xbgr.mr_n95202304)
print v(xbgr.mr_n95203248)
print v(xbgr.mr_n95204192)
print v(xbgr.mr_n95205136)
print v(xbgr.mr_n95206080)
print v(xbgr.mr_n95207024)
print v(xbgr.mr_n95207968)
print v(xbgr.mr_n95208912)
print v(xbgr.mr_n95209856)
print v(xbgr.mr_n95210800)
print v(xbgr.mr_n95211744)
print v(xbgr.mr_n95212688)
print v(xbgr.mr_n95213632)
print v(xbgr.mr_n95214576)
print v(xbgr.mr_n95215520)
print v(xbgr.mr_n95216464)
print v(xbgr.mr_n95217408)
print v(xbgr.mr_n95218352)
print v(xbgr.mr_n95219296)
print v(xbgr.mr_n95220240)
print v(xbgr.mr_n95221184)
print v(xbgr.mr_n95222128)
print v(xbgr.mr_n95224512)
print v(xbgr.mr_n95225088)
print v(xbgr.mr_n95225200)
print v(xbgr.mr_n95226144)
print v(xbgr.mr_n95226336)
print v(xbgr.mr_n95226528)
print v(xbgr.mr_n95227360)
print v(xbgr.mr_n95227632)
print v(xbgr.mr_n95227824)
print v(xbgr.mr_n95228176)
print v(xbgr.mr_n95228288)
print v(xbgr.mr_n95232288)
print v(xbgr.mr_n95233040)
print v(xbgr.mr_n95233312)
print v(xbgr.mr_n95233504)
print v(xbgr.mr_n95233856)
print v(xbgr.mr_n95233968)
print v(xbgr.mr_n95236960)
print v(xbgr.mr_n95237072)
print v(xbgr.mr_n95237184)
print v(xbgr.mr_n95238576)
print v(xbgr.mr_n95238848)
print v(xbgr.mr_n95239040)
print v(xbgr.mr_n95239392)
print v(xbgr.mr_n95239504)
print v(xbgr.mr_n95241072)
print v(xbgr.mr_n95241184)
print v(xbgr.mr_n95244480)
print v(xbgr.mr_n95245872)
print v(xbgr.mr_n95246144)
print v(xbgr.mr_n95246336)
print v(xbgr.mr_n95246688)
print v(xbgr.mr_n95246800)
print v(xbgr.mr_n95250432)
print v(xbgr.mr_n95250544)
print v(xbgr.mr_n95250656)
print v(xbgr.mr_n95252048)
print v(xbgr.mr_n95252320)
print v(xbgr.mr_n95252512)
print v(xbgr.mr_n95252864)
print v(xbgr.mr_n95252976)
print v(xbgr.mr_n95255296)
print v(xbgr.mr_n95256608)
print v(xbgr.mr_n95256720)
print v(xbgr.mr_n95256832)
print v(xbgr.mr_n95258224)
print v(xbgr.mr_n95258496)
print v(xbgr.mr_n95258688)
print v(xbgr.mr_n95259040)
print v(xbgr.mr_n95259152)
print v(xbgr.mr_n95260720)
print v(xbgr.mr_n95260832)
print v(xbgr.mr_n95264128)
print v(xbgr.mr_n95265520)
print v(xbgr.mr_n95265792)
print v(xbgr.mr_n95265984)
print v(xbgr.mr_n95266336)
print v(xbgr.mr_n95266448)
print v(xbgr.mr_n95270080)
print v(xbgr.mr_n95270192)
print v(xbgr.mr_n95270304)
print v(xbgr.mr_n95271696)
print v(xbgr.mr_n95271968)
print v(xbgr.mr_n95272160)
print v(xbgr.mr_n95272512)
print v(xbgr.mr_n95272624)
print v(xbgr.mr_n95273472)
print v(xbgr.mr_n95274944)
print v(xbgr.mr_n95276256)
print v(xbgr.mr_n95276368)
print v(xbgr.mr_n95276480)
print v(xbgr.mr_n95277872)
print v(xbgr.mr_n95278144)
print v(xbgr.mr_n95278336)
print v(xbgr.mr_n95278688)
print v(xbgr.mr_n95278800)
print v(xbgr.mr_n95280368)
print v(xbgr.mr_n95280480)
print v(xbgr.mr_n95283776)
print v(xbgr.mr_n95285168)
print v(xbgr.mr_n95285440)
print v(xbgr.mr_n95285632)
print v(xbgr.mr_n95285984)
print v(xbgr.mr_n95286096)
print v(xbgr.mr_n95287168)
print v(xbgr.mr_n95288096)
print v(xbgr.mr_n95290576)
print v(xbgr.mr_n95291744)
print v(xbgr.mr_n95292864)
print v(xbgr.mr_n95295216)
print v(xbgr.mr_n95295328)
print v(xbgr.mr_n95295440)
print v(xbgr.mr_n95295632)
print v(xbgr.mr_n95297168)
print v(xbgr.mr_n95297360)
print v(xbgr.mr_n95297712)
print v(xbgr.mr_n95297824)
print v(xbgr.mr_n95301360)
print v(xbgr.mr_n95301472)
print v(xbgr.mr_n95301984)
print v(xbgr.mr_n95302096)
print v(xbgr.mr_n95302608)
print v(xbgr.mr_n95302720)
print v(xbgr.mr_n95303488)
print v(xbgr.mr_n95303600)
print v(xbgr.mr_n95304432)
print v(xbgr.mr_n95304544)
print v(xbgr.mr_n95305632)
print v(xbgr.mr_n95305744)
print v(xbgr.mr_n95306896)
print v(xbgr.mr_n95307008)
print v(xbgr.mr_n95308160)
print v(xbgr.mr_n95308272)
print v(xbgr.mr_n95309424)
print v(xbgr.mr_n95309536)
print v(xbgr.mr_n95310688)
print v(xbgr.mr_n95310800)
print v(xbgr.mr_n95311952)
print v(xbgr.mr_n95312064)
print v(xbgr.mr_n95313216)
print v(xbgr.mr_n95313328)
print v(xbgr.mr_n95314480)
print v(xbgr.mr_n95314592)
print v(xbgr.mr_n95315744)
print v(xbgr.mr_n95315856)
print v(xbgr.mr_n95317008)
print v(xbgr.mr_n95317120)
print v(xbgr.mr_n95318272)
print v(xbgr.mr_n95318384)
print v(xbgr.mr_n95340752)
print v(xbgr.mr_n95347904)
print v(xbgr.mr_n95348128)
print v(xbgr.mr_n95349152)
print v(xbgr.mr_n95349408)
print v(xbgr.mr_n95349664)
print v(xbgr.mr_n95352048)
print v(xbgr.mr_n95380144)
print v(xbgr.mr_n95380816)
print v(xbgr.mr_n95386592)
print v(xbgr.mr_n95387536)
print v(xbgr.mr_n95388480)
print v(xbgr.mr_n95389424)
print v(xbgr.mr_n95390368)
print v(xbgr.mr_n95391312)
print v(xbgr.mr_n95392256)
print v(xbgr.mr_n95393200)
print v(xbgr.mr_n95394144)
print v(xbgr.mr_n95395088)
print v(xbgr.mr_n95396032)
print v(xbgr.mr_n95396976)
print v(xbgr.mr_n95397920)
print v(xbgr.mr_n95398864)
print v(xbgr.mr_n95399808)
print v(xbgr.mr_n95400752)
print v(xbgr.mr_n95401696)
print v(xbgr.mr_n95402640)
print v(xbgr.mr_n95403584)
print v(xbgr.mr_n95404528)
print v(xbgr.mr_n95405472)
print v(xbgr.mr_n95406416)
print v(xbgr.mr_n95407360)
print v(xbgr.mr_n95408304)
print v(xbgr.mr_n95409248)
print v(xbgr.mr_n95413984)
print v(xbgr.mr_n95415184)
print v(xbgr.mr_n95416128)
print v(xbgr.mr_n95417072)
print v(xbgr.mr_n95421616)
print v(xbgr.mr_n95421808)
print v(xbgr.mr_n95422496)
print v(xbgr.mr_n95422608)
print v(xbgr.mr_n95424784)
print v(xbgr.mr_n95424976)
print v(xbgr.mr_n95425808)
print v(xbgr.mr_n95425920)
print v(xbgr.mr_n95426032)
print v(xbgr.mr_n95426144)
print v(xbgr.mr_n95427536)
print v(xbgr.mr_n95427808)
print v(xbgr.mr_n95428000)
print v(xbgr.mr_n95428352)
print v(xbgr.mr_n95428464)
print v(xbgr.mr_n95432896)
print v(xbgr.mr_n95433168)
print v(xbgr.mr_n95433360)
print v(xbgr.mr_n95433712)
print v(xbgr.mr_n95433824)
print v(xbgr.mr_n95437936)
print v(xbgr.mr_n95438208)
print v(xbgr.mr_n95438400)
print v(xbgr.mr_n95438752)
print v(xbgr.mr_n95438864)
print v(xbgr.mr_n95442528)
print v(xbgr.mr_n95442800)
print v(xbgr.mr_n95442992)
print v(xbgr.mr_n95443344)
print v(xbgr.mr_n95443456)
print v(xbgr.mr_n95447120)
print v(xbgr.mr_n95447392)
print v(xbgr.mr_n95447584)
print v(xbgr.mr_n95447936)
print v(xbgr.mr_n95448048)
print v(xbgr.mr_n95451712)
print v(xbgr.mr_n95451984)
print v(xbgr.mr_n95452176)
print v(xbgr.mr_n95452528)
print v(xbgr.mr_n95452640)
print v(xbgr.mr_n95456304)
print v(xbgr.mr_n95456576)
print v(xbgr.mr_n95456768)
print v(xbgr.mr_n95457120)
print v(xbgr.mr_n95457232)
print v(xbgr.mr_n95460896)
print v(xbgr.mr_n95461168)
print v(xbgr.mr_n95461360)
print v(xbgr.mr_n95461712)
print v(xbgr.mr_n95461824)
print v(xbgr.mr_n95465488)
print v(xbgr.mr_n95465760)
print v(xbgr.mr_n95465952)
print v(xbgr.mr_n95466304)
print v(xbgr.mr_n95466416)
print v(xbgr.mr_n95468880)
print v(xbgr.mr_n95470416)
print v(xbgr.mr_n95470608)
print v(xbgr.mr_n95470960)
print v(xbgr.mr_n95471072)
print v(xbgr.mr_n95474672)
print v(xbgr.mr_n95474944)
print v(xbgr.mr_n95475136)
print v(xbgr.mr_n95475488)
print v(xbgr.mr_n95475600)
print v(xbgr.mr_n95479264)
print v(xbgr.mr_n95479536)
print v(xbgr.mr_n95479728)
print v(xbgr.mr_n95480080)
print v(xbgr.mr_n95480192)
print v(xbgr.mr_n95483856)
print v(xbgr.mr_n95484048)
print v(xbgr.mr_n95484240)
print v(xbgr.mr_n95484672)
print v(xbgr.mr_n95484784)
print v(xbgr.mr_n95488448)
print v(xbgr.mr_n95488720)
print v(xbgr.mr_n95488912)
print v(xbgr.mr_n95489264)
print v(xbgr.mr_n95489376)
print v(xbgr.mr_n95492160)
print v(xbgr.mr_n95494032)
print v(xbgr.mr_n95495536)
print v(xbgr.mr_n95496320)
print v(xbgr.mr_n95497424)
print v(xbgr.mr_n95497808)
print v(xbgr.mr_n95505152)
print v(xbgr.mr_n95505264)
print v(xbgr.mr_n95505728)
print v(xbgr.mr_n95505840)
print v(xbgr.mr_n95506304)
print v(xbgr.mr_n95507456)
print v(xbgr.mr_n95513088)
print v(xbgr.mr_n95516832)
print v(xbgr.mr_n95518592)
print v(xbgr.mr_n95520976)
print v(xbgr.mr_n95524720)
print v(xbgr.mr_n95525296)
print v(xbgr.mr_n95525776)
print v(xbgr.mr_n95526064)
print v(xbgr.mr_n95526512)
print v(xbgr.mr_n95527312)
print v(xbgr.mr_n95527760)
print v(xbgr.mr_n95528272)
print v(xbgr.mr_n95528784)
print v(xbgr.mr_n95529104)
print v(xbgr.mr_n95530768)
print v(xbgr.mr_n95531280)
print v(xbgr.mr_n95531568)
print v(xbgr.mr_n95531792)
print v(xbgr.mr_n95532528)
print v(xbgr.mr_n95533776)
print v(xbgr.mr_n95534064)
print v(xbgr.mr_n95535536)
print v(xbgr.mr_n95537072)
print v(xbgr.mr_n95539792)
print v(xbgr.mr_n95540080)
print v(xbgr.mr_n95540304)
print v(xbgr.mr_n95543392)
print v(xbgr.mr_n95543824)
print v(xbgr.mr_n95545536)
print v(xbgr.mr_n95546320)
print v(xbgr.mr_n95547568)
print v(xbgr.mr_n95548896)
print v(xbgr.mr_n95549104)
print v(xbgr.mr_n95549840)
print v(xbgr.mr_n95552336)
print v(xbgr.mr_n95552624)
print v(xbgr.mr_n95553584)
print v(xbgr.mr_n95554608)
print v(xbgr.mr_n95554832)
print v(xbgr.mr_n95555344)
print v(xbgr.mr_n95555936)
print v(xbgr.mr_n95556208)
print v(xbgr.mr_n95556720)
print v(xbgr.mr_n95556832)
print v(xbgr.mr_n95557264)
print v(xbgr.mr_n95557776)
print v(xbgr.mr_n95557888)
print v(xbgr.mr_n95558320)
print v(xbgr.mr_n95558832)
print v(xbgr.mr_n95558944)
print v(xbgr.mr_n95559376)
print v(xbgr.mr_n95560256)
print v(xbgr.mr_n95560512)
print v(xbgr.mr_n95560624)
print v(xbgr.mr_n95560800)
print v(xbgr.mr_n95562176)
print v(xbgr.mr_n95562288)
print v(xbgr.mr_n95563472)
print v(xbgr.mr_n95564240)
print v(xbgr.mr_n95566112)
print v(xbgr.mr_n95566304)
print v(xbgr.mr_n95566496)
print v(xbgr.mr_n95568896)
print v(xbgr.mr_n95569312)
print v(xbgr.mr_n95569536)
print v(xbgr.mr_n95571360)
print v(xbgr.mr_n95572176)
print v(xbgr.mr_n95573168)
print v(xbgr.mr_n95577296)
print v(xbgr.mr_n95578352)
print v(xbgr.mr_n95578544)
print v(xbgr.mr_n95578736)
print v(xbgr.mr_n95578928)
print v(xbgr.mr_n95579872)
print v(xbgr.mr_n95580352)
print v(xbgr.mr_n95580528)
print v(xbgr.mr_n95580800)
print v(xbgr.mr_n95582304)
print v(xbgr.mr_n95583088)
print v(xbgr.mr_n95583232)
print v(xbgr.mr_n95584128)
print v(xbgr.mr_n95584576)
print v(xbgr.mr_n95587504)
print v(xbgr.mr_n95588048)
print v(xbgr.mr_n95588976)
print v(xbgr.mr_n95589984)
print v(xbgr.mr_n95590800)
print v(xbgr.mr_n95591136)
print v(xbgr.mr_n95591600)
print v(xbgr.mr_n95592064)
print v(xbgr.mr_n95592528)
print v(xbgr.mr_n95592720)
print v(xbgr.mr_n95593184)
print v(xbgr.mr_n95595840)
print v(xbgr.mr_n95596112)
print v(xbgr.mr_n95596512)
print v(xbgr.mr_n95597056)
print v(xbgr.mr_n95597248)
print v(xbgr.mr_n95598208)
print v(xbgr.mr_n95598544)
print v(xbgr.mr_n95599488)
print v(xbgr.mr_n95605568)
print v(xbgr.mr_n95605680)
print v(xbgr.mr_n95606560)
print v(xbgr.mr_n95607248)
print v(xbgr.mr_n95607936)
print v(xbgr.mr_n95608624)
print v(xbgr.mr_n95609312)
print v(xbgr.mr_n95610000)
print v(xbgr.mr_n95610688)
print v(xbgr.mr_n95611376)
print v(xbgr.mr_n95612064)
print v(xbgr.mr_n95612752)
print v(xbgr.mr_n95613440)
print v(xbgr.mr_n95614128)
print v(xbgr.mr_n95614816)
print v(xbgr.mr_n95615504)
print v(xbgr.mr_n95616192)
print v(xbgr.mr_n95616880)
print v(xbgr.mr_n95617568)
print v(xbgr.mr_n95618256)
print v(xbgr.mr_n95618944)
print v(xbgr.mr_n95619632)
print v(xbgr.mr_n95620320)
print v(xbgr.mr_n95621008)
print v(xbgr.mr_n95621696)
print v(xbgr.mr_n95622384)
print v(xbgr.mr_n95623072)
print v(xbgr.mr_n95623760)
print v(xbgr.mr_n95624448)
print v(xbgr.mr_n95625136)
print v(xbgr.mr_n95625824)
print v(xbgr.mr_n95626512)
print v(xbgr.mr_n95627200)
print v(xbgr.mr_n95627888)
print v(xbgr.mr_n95628576)
print v(xbgr.mr_n95629264)
print v(xbgr.mr_n95629952)
print v(xbgr.mr_n95630640)
print v(xbgr.mr_n95631328)
print v(xbgr.mr_n95633072)
print v(xbgr.mr_n95634368)
print v(xbgr.mr_n95642192)
print v(xbgr.mr_n95642704)
print v(xbgr.mr_n95642816)
print v(xbgr.mr_n95643760)
print v(xbgr.mr_n95657216)
print v(xbgr.mr_n95660704)
print v(xbgr.mr_n95661088)
print v(xbgr.mr_n95663136)
print v(xbgr.mr_n95663408)
print v(xbgr.mr_n95663600)
print v(xbgr.mr_n95664112)
print v(xbgr.mr_n95664224)
print v(xbgr.mr_n95664528)
print v(xbgr.mr_n95664720)
print v(xbgr.mr_n95665104)
print v(xbgr.mr_n95665296)
print v(xbgr.mr_n95668992)
print v(xbgr.mr_n95696688)
print v(xbgr.mr_n95698576)
print v(xbgr.mr_n95699264)
print v(xbgr.mr_n95699520)
print v(xbgr.mr_n95700208)
print v(xbgr.mr_n95700592)
print v(xbgr.mr_n95701152)
print v(xbgr.mr_n95701408)
print v(xbgr.mr_n95702096)
print v(xbgr.mr_n95702352)
print v(xbgr.mr_n95703040)
print v(xbgr.mr_n95703296)
print v(xbgr.mr_n95703984)
print v(xbgr.mr_n95704240)
print v(xbgr.mr_n95704928)
print v(xbgr.mr_n95705184)
print v(xbgr.mr_n95705872)
print v(xbgr.mr_n95711168)
print v(xbgr.mr_n95723424)
print v(xbgr.mr_n95725472)
print v(xbgr.mr_n95725728)
print v(xbgr.mr_n95725984)
print v(xbgr.mr_n95726240)
print v(xbgr.mr_n95726496)
print v(xbgr.mr_n95727008)
print v(xbgr.mr_n95727264)
print v(xbgr.mr_n95727520)
print v(xbgr.mr_n95728368)
print v(xbgr.mr_n95730624)
print v(xbgr.mr_n95735360)
print v(xbgr.mr_n95738336)
print v(xbgr.mr_n95739680)
print v(xbgr.mr_n95748240)
print v(xbgr.mr_n95749728)
print v(xbgr.mr_n95752144)
print v(xbgr.mr_n95752336)
print v(xbgr.mr_n95752448)
print v(xbgr.mr_n95752560)
print v(xbgr.mr_n95752672)
print v(xbgr.mr_n95752784)
print v(xbgr.mr_n95752896)
print v(xbgr.mr_n95753008)
print v(xbgr.mr_n95753520)
print v(xbgr.mr_n95753632)
print v(xbgr.mr_n95753968)
print v(xbgr.mr_n95754160)
print v(xbgr.mr_n95754352)
print v(xbgr.mr_n95755040)
print v(xbgr.mr_n95755216)
print v(xbgr.mr_n95756496)
print v(xbgr.mr_n95756832)
print v(xbgr.mr_n95757024)
print v(xbgr.mr_n95757216)
print v(xbgr.mr_n95758032)
print v(xbgr.mr_n95758304)
print v(xbgr.mr_n95759056)
print v(xbgr.mr_n95761760)
print v(xbgr.mr_n95761872)
print v(xbgr.mr_n95762384)
print v(xbgr.mr_n95762496)
print v(xbgr.mr_n95763008)
print v(xbgr.mr_n95763120)
print v(xbgr.mr_n95763632)
print v(xbgr.mr_n95763744)
print v(xbgr.mr_n95764256)
print v(xbgr.mr_n95764368)
print v(xbgr.mr_n95764880)
print v(xbgr.mr_n95764992)
print v(xbgr.mr_n95765504)
print v(xbgr.mr_n95765616)
print v(xbgr.mr_n95767728)
print v(xbgr.mr_n95779232)
print v(xbgr.mr_n95779920)
print v(xbgr.mr_n95780608)
print v(xbgr.mr_n95781296)
print v(xbgr.mr_n95781984)
print v(xbgr.mr_n95782672)
print v(xbgr.mr_n95783360)
print v(xbgr.mr_n95784048)
print v(xbgr.mr_n95784736)
print v(xbgr.mr_n95786704)
print v(xbgr.mr_n95787680)
print v(xbgr.mr_n95788624)
print v(xbgr.mr_n95789568)
print v(xbgr.mr_n95790512)
print v(xbgr.mr_n95791456)
print v(xbgr.mr_n95792400)
print v(xbgr.mr_n95793344)
print v(xbgr.mr_n95794288)
print v(xbgr.mr_n95801040)
print v(xbgr.mr_n95801728)
print v(xbgr.mr_n95802496)
print v(xbgr.mr_n95802960)
print v(xbgr.mr_n95804416)
print v(xbgr.mr_n95804800)
print v(xbgr.mr_n95805184)
print v(xbgr.mr_n95805952)
print v(xbgr.mr_n95806336)
print v(xbgr.mr_n95806800)
print v(xbgr.mr_n95808256)
print v(xbgr.mr_n95808640)
print v(xbgr.mr_n95809024)
print v(xbgr.mr_n95810176)
print v(xbgr.mr_n95810560)
print v(xbgr.mr_n95811024)
print v(xbgr.mr_n95811328)
print v(xbgr.mr_n95811712)
print v(xbgr.mr_n95812176)
print v(xbgr.mr_n95812960)
print v(xbgr.mr_n95815008)
print v(xbgr.mr_n95815200)
print v(xbgr.mr_n95816512)
print v(xbgr.mr_n95818160)
print v(xbgr.mr_n95824832)
print v(xbgr.mr_n95827520)
print v(xbgr.mr_n95827744)
print v(xbgr.mr_n95827968)
print v(xbgr.mr_n95828864)
print v(xbgr.mr_n95830064)
print v(xbgr.mr_n95836320)
print v(xbgr.mr_n95839072)
print v(xbgr.mr_n95840800)
print v(xbgr.mr_n95841360)
print v(xbgr.mr_n95842272)
print v(xbgr.mr_n95843520)
print v(xbgr.mr_n95845248)
print v(xbgr.mr_n95846272)
print v(xbgr.mr_n95847552)
print v(xbgr.mr_n95848288)
print v(xbgr.mr_n95849024)
print v(xbgr.mr_n95849136)
print v(xbgr.mr_n95849936)
print v(xbgr.mr_n95850752)
print v(xbgr.mr_n95851264)
print v(xbgr.mr_n95851376)
print v(xbgr.mr_n95851808)
print v(xbgr.mr_n95852320)
print v(xbgr.mr_n95852432)
print v(xbgr.mr_n95852864)
print v(xbgr.mr_n95853376)
print v(xbgr.mr_n95853488)
print v(xbgr.mr_n95853920)
print v(xbgr.mr_n95854432)
print v(xbgr.mr_n95854544)
print v(xbgr.mr_n95855552)
print v(xbgr.mr_n95856784)
print v(xbgr.mr_n95857056)
print v(xbgr.mr_n95857424)
print v(xbgr.mr_n95861264)
print v(xbgr.mr_n95862480)
print v(xbgr.mr_n95863728)
print v(xbgr.mr_n95865168)
print v(xbgr.mr_n95865456)
print v(xbgr.mr_n95867472)
print v(xbgr.mr_n95872576)
print v(xbgr.mr_n95874304)
print v(xbgr.mr_n95876144)
print v(xbgr.mr_n95879088)
print v(xbgr.mr_n95887600)
print v(xbgr.mr_n95888192)
print v(xbgr.mr_n95891200)
print v(xbgr.mr_n95898128)
print v(xbgr.mr_n95900576)
print v(xbgr.mr_n95900944)
print v(xbgr.mr_n95901136)
print v(xbgr.mr_n95901664)
print v(xbgr.mr_n95902208)
print v(xbgr.mr_n95902672)
print v(xbgr.mr_n95902864)
print v(xbgr.mr_n95903328)
print v(xbgr.mr_n95905024)
print v(xbgr.mr_n95905360)
print v(xbgr.mr_n95905696)
print v(xbgr.mr_n95905888)
print v(xbgr.mr_n95906336)
print v(xbgr.mr_n95906976)
print v(xbgr.mr_n95910592)
print v(xbgr.mr_n95911408)
print v(xbgr.mr_n95911744)
print v(xbgr.mr_n95911936)
print v(xbgr.mr_n95912400)
print v(xbgr.mr_n95913344)
print v(xbgr.mr_n95913680)
print v(xbgr.mr_n95914144)
print v(xbgr.mr_n95914544)
print v(xbgr.mr_n95914736)
print v(xbgr.mr_n95915200)
print v(xbgr.mr_n95915872)
print v(xbgr.mr_n95916336)
print v(xbgr.mr_n95916800)
print v(xbgr.mr_n95917744)
print v(xbgr.mr_n95918832)
print v(xbgr.mr_n95919168)
print v(xbgr.mr_n95920176)
print v(xbgr.mr_n95920672)
print v(xbgr.mr_n95927120)
print v(xbgr.mr_n95927312)
print v(xbgr.mr_n95927712)
print v(xbgr.mr_n95928144)
print v(xbgr.mr_n95928480)
print v(xbgr.mr_n95936736)
print v(xbgr.mr_n95937248)
print v(xbgr.mr_n95937360)
print v(xbgr.mr_n95937792)
print v(xbgr.mr_n95938304)
print v(xbgr.mr_n95938416)
print v(xbgr.mr_n95938848)
print v(xbgr.mr_n95939360)
print v(xbgr.mr_n95939472)
print v(xbgr.mr_n95939904)
print v(xbgr.mr_n95940416)
print v(xbgr.mr_n95940528)
print v(xbgr.mr_n95940960)
print v(xbgr.mr_n95941472)
print v(xbgr.mr_n95941584)
print v(xbgr.mr_n95942016)
print v(xbgr.mr_n95942528)
print v(xbgr.mr_n95942640)
print v(xbgr.mr_n95943072)
print v(xbgr.mr_n95943584)
print v(xbgr.mr_n95943696)
print v(xbgr.mr_n95944128)
print v(xbgr.mr_n95944832)
print v(xbgr.mr_n95944944)
print v(xbgr.mr_n95945376)
print v(xbgr.mr_n95946464)
print v(xbgr.mr_n95946576)
print v(xbgr.mr_n95947456)
print v(xbgr.mr_n95948144)
print v(xbgr.mr_n95948832)
print v(xbgr.mr_n95949520)
print v(xbgr.mr_n95950208)
print v(xbgr.mr_n95950896)
print v(xbgr.mr_n95951584)
print v(xbgr.mr_n95952272)
print v(xbgr.mr_n95952960)
print v(xbgr.mr_n95953648)
print v(xbgr.mr_n95954336)
print v(xbgr.mr_n95955024)
print v(xbgr.mr_n95955712)
print v(xbgr.mr_n95956400)
print v(xbgr.mr_n95957088)
print v(xbgr.mr_n95957776)
print v(xbgr.mr_n95958464)
print v(xbgr.mr_n95959152)
print v(xbgr.mr_n95959840)
print v(xbgr.mr_n95960528)
print v(xbgr.mr_n95961504)
print v(xbgr.mr_n95962640)
print v(xbgr.mr_n95963584)
print v(xbgr.mr_n95964528)
print v(xbgr.mr_n95965152)
print v(xbgr.mr_n95965408)
print v(xbgr.mr_n95966736)
print v(xbgr.mr_n95967008)
print v(xbgr.mr_n95967200)
print v(xbgr.mr_n95968912)
print v(xbgr.mr_n95971216)
print v(xbgr.mr_n95977600)
print v(xbgr.mr_n95977872)
print v(xbgr.mr_n95978064)
print v(xbgr.mr_n95981680)
print v(xbgr.mr_n95983088)
print v(xbgr.mr_n95983200)
print v(xbgr.mr_n95984608)
print v(xbgr.mr_n95984720)
print v(xbgr.mr_n95986128)
print v(xbgr.mr_n95986240)
print v(xbgr.mr_n95987648)
print v(xbgr.mr_n95987760)
print v(xbgr.mr_n95989168)
print v(xbgr.mr_n95989280)
print v(xbgr.mr_n95990688)
print v(xbgr.mr_n95990800)
print v(xbgr.mr_n95992144)
print v(xbgr.mr_n95992256)
print v(xbgr.mr_n95993728)
print v(xbgr.mr_n95993840)
print v(xbgr.mr_n95995360)
print v(xbgr.mr_n95996880)
print v(xbgr.mr_n96014304)
print v(xbgr.mr_n96019216)
print v(xbgr.mr_n96348416)
print v(xbgr.mr_n96348640)
print v(xbgr.mr_n96348784)
print v(xbgr.mr_n96362288)
print v(xbgr.mr_n96362640)
print v(xbgr.mr_n96362832)
print v(xbgr.mr_n96363024)
print v(xbgr.mr_n96363456)
print v(xbgr.mr_n96363648)
print v(xbgr.mr_n96404912)
print v(xbgr.mr_n96405104)
print v(xbgr.mr_n96405376)
print v(xbgr.mr_n96405920)
print v(xbgr.mr_n96406272)
print v(xbgr.mr_n96432128)
print v(xbgr.mr_n96432848)
print v(xbgr.mr_n96473648)
print v(xbgr.mr_n96501104)
print v(xbgr.mr_n96501840)
print v(xbgr.mr_n96564784)
print v(xbgr.mr_n96568672)
print v(xbgr.mr_n96568864)
print v(xbgr.mr_n96587056)
print v(xbgr.mr_n96587248)
print v(xbgr.mr_n96587760)
print v(xbgr.mr_n96587952)
print v(xbgr.mr_n96636176)
print v(xbgr.mr_n96644992)
print v(xbgr.mr_n96668960)
print v(xbgr.mr_n96669104)
print v(xbgr.mr_n96669760)
print v(xbgr.mr_n96670048)
print v(xbgr.mr_n96683072)
print v(xbgr.mr_n96689552)
print v(xbgr.mr_n96752320)
print v(xbgr.mr_n96752512)
print v(xbgr.mr_n96752912)
print v(xbgr.mr_n96792272)
print v(xbgr.mr_n96836496)
print v(xbgr.mr_n96871952)
print v(xbgr.mr_n96908752)
print v(xbgr.mr_n96912208)
print v(xbgr.mr_n96912592)
print v(xbgr.mr_n96912976)
print v(xbgr.mr_n96913648)
print v(xbgr.mr_n96914400)
print v(xbgr.mr_n96941968)
print v(xbgr.mr_n96948080)
print v(xbgr.mr_n96948448)
print v(xbgr.mr_n96950784)
print v(xbgr.mr_n96953088)
print v(xbgr.mr_n96956656)
print v(xbgr.mr_n96960256)
print v(xbgr.mr_n96963744)
print v(xbgr.mr_n96964128)
print v(xbgr.mr_n96965120)
print v(xbgr.mr_n96994848)
print v(xbgr.mr_n96997104)
print v(xbgr.mr_n96997360)
print v(xbgr.mr_n97000368)
print v(xbgr.mr_n97001296)
print v(xbgr.mr_n97002176)
print v(xbgr.mr_n97031472)
print v(xbgr.mr_n97031664)
print v(xbgr.mr_n97031856)
print v(xbgr.mr_n97073184)
print v(xbgr.mr_n97088176)
print v(xbgr.mr_n97090272)
print v(xbgr.mr_n97091856)
print v(xbgr.mr_n97092272)
print v(xbgr.mr_n97118000)
print v(xbgr.mr_n97135520)
print v(xbgr.mr_n97135776)
print v(xbgr.mr_n97136544)
print v(xbgr.mr_n97137056)
print v(xbgr.mr_n97137312)
print v(xbgr.mr_n97140640)
print v(xbgr.mr_n97141072)
print v(xbgr.mr_n97141568)
print v(xbgr.mr_n97141856)
print v(xbgr.mr_n97172272)
print v(xbgr.mr_n97172688)
print v(xbgr.mr_n97173616)
print v(xbgr.mr_n97173760)
print v(xbgr.mr_n97173952)
print v(xbgr.n1)
print v(xbgr.n_10)
print v(xbgr.n_11)
print v(xbgr.n_12)
print v(xbgr.n_13)
print v(xbgr.n_14)
print v(xbgr.n_15)
print v(xbgr.n_16)
print v(xbgr.n_17)
print v(xbgr.n_18)
print v(xbgr.n_19)
print v(xbgr.n_2)
print v(xbgr.n_21)
print v(xbgr.n_22)
print v(xbgr.n_23)
print v(xbgr.n_24)
print v(xbgr.n_25)
print v(xbgr.n_26)
print v(xbgr.n_27)
print v(xbgr.n_3)
print v(xbgr.n_30)
print v(xbgr.n_31)
print v(xbgr.n_33)
print v(xbgr.n_34)
print v(xbgr.n_36)
print v(xbgr.n_37)
print v(xbgr.n_4)
print v(xbgr.n_5)
print v(xbgr.n_6)
print v(xbgr.n_7)
print v(xbgr.n_8)
print v(xbgr.n_9)
print v(pbias)
print v(pcasc)
print v(r4)
print v(xbgr.r4n)
print v(xbgr.vb2)
print v(vbe)
print v(xbgr.vbe3)
print v(xbgr.vd1)
print v(xbgr.vd2)
print v(vdd)
print v(vref)
print v(vdd)-v(vdd)
echo METALLIC_ALL_NODE_VOLTAGES_END
quit
.endc
.end
