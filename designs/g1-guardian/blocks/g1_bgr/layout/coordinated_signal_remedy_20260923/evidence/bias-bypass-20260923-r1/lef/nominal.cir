* G1_BGR standalone capacitance-PEX qualification
.lib /foss/pdks/ihp-sg13g2/libs.tech/ngspice/models/cornerHBT.lib hbt_typ
.lib /foss/pdks/ihp-sg13g2/libs.tech/ngspice/models/cornerMOShv.lib mos_tt
.lib /foss/pdks/ihp-sg13g2/libs.tech/ngspice/models/cornerRES.lib res_typ
.include conditional_metal.spice
.option seed=44001 gmin=1e-15 abstol=1e-14 reltol=1e-5 vntol=1e-7
.global sub!
Vsub sub! 0 0
Vdd vdd 0 3.3
Vr4 r4 0 0
Xbgr vdd 0 r4 vref iptat pbias pcasc vbe dvbe g1_bgr
Vload iptat 0 1
Cload vref 0 1e-12
.control
set num_threads=1
set numdgt=15
set wr_singlescale
set wr_vecnames
op
echo RAW_CURRENT_LEDGER_BEGIN
print @n.xbgr.xr1.nr1[ibody]
print @n.xbgr.xr2.nr1[ibody]
print @n.xbgr.xr3.nr1[ibody]
print @n.xbgr.xr4.nr1[ibody]
print @n.xbgr.xr5.nr1[ibody]
print @n.xbgr.xr6.nr1[ibody]
print @n.xbgr.xr7.nr1[ibody]
print @n.xbgr.xr8.nr1[ibody]
print @n.xbgr.xr9.nr1[ibody]
print @n.xbgr.xr10.nr1[ibody]
print @n.xbgr.xr11.nr1[ibody]
print @n.xbgr.xr12.nr1[ibody]
print @n.xbgr.xr13.nr1[ibody]
print @n.xbgr.xr14.nr1[ibody]
print @n.xbgr.xr15.nr1[ibody]
print @n.xbgr.xr16.nr1[ibody]
print @n.xbgr.xr17.nr1[ibody]
print @n.xbgr.xr18.nr1[ibody]
print @n.xbgr.xr19.nr1[ibody]
print @n.xbgr.xr20.nr1[ibody]
print @n.xbgr.xr21.nr1[ibody]
print @n.xbgr.xr22.nr1[ibody]
print @n.xbgr.xr23.nr1[ibody]
print @n.xbgr.xr24.nr1[ibody]
print @n.xbgr.xr25.nr1[ibody]
print @n.xbgr.xr26.nr1[ibody]
print @n.xbgr.xm27.nsg13_hv_pmos[ide]
print @n.xbgr.xm27.nsg13_hv_pmos[ige]
print @n.xbgr.xm27.nsg13_hv_pmos[ise]
print @n.xbgr.xm27.nsg13_hv_pmos[ibe]
print @n.xbgr.xm27.nsg13_hv_pmos[ctype]
print @n.xbgr.xm28.nsg13_hv_pmos[ide]
print @n.xbgr.xm28.nsg13_hv_pmos[ige]
print @n.xbgr.xm28.nsg13_hv_pmos[ise]
print @n.xbgr.xm28.nsg13_hv_pmos[ibe]
print @n.xbgr.xm28.nsg13_hv_pmos[ctype]
print @n.xbgr.xm29.nsg13_hv_nmos[ide]
print @n.xbgr.xm29.nsg13_hv_nmos[ige]
print @n.xbgr.xm29.nsg13_hv_nmos[ise]
print @n.xbgr.xm29.nsg13_hv_nmos[ibe]
print @n.xbgr.xm29.nsg13_hv_nmos[ctype]
print @n.xbgr.xm30.nsg13_hv_nmos[ide]
print @n.xbgr.xm30.nsg13_hv_nmos[ige]
print @n.xbgr.xm30.nsg13_hv_nmos[ise]
print @n.xbgr.xm30.nsg13_hv_nmos[ibe]
print @n.xbgr.xm30.nsg13_hv_nmos[ctype]
print @n.xbgr.xm31.nsg13_hv_nmos[ide]
print @n.xbgr.xm31.nsg13_hv_nmos[ige]
print @n.xbgr.xm31.nsg13_hv_nmos[ise]
print @n.xbgr.xm31.nsg13_hv_nmos[ibe]
print @n.xbgr.xm31.nsg13_hv_nmos[ctype]
print @n.xbgr.xm32.nsg13_hv_nmos[ide]
print @n.xbgr.xm32.nsg13_hv_nmos[ige]
print @n.xbgr.xm32.nsg13_hv_nmos[ise]
print @n.xbgr.xm32.nsg13_hv_nmos[ibe]
print @n.xbgr.xm32.nsg13_hv_nmos[ctype]
print @n.xbgr.xm33.nsg13_hv_nmos[ide]
print @n.xbgr.xm33.nsg13_hv_nmos[ige]
print @n.xbgr.xm33.nsg13_hv_nmos[ise]
print @n.xbgr.xm33.nsg13_hv_nmos[ibe]
print @n.xbgr.xm33.nsg13_hv_nmos[ctype]
print @n.xbgr.xm34.nsg13_hv_nmos[ide]
print @n.xbgr.xm34.nsg13_hv_nmos[ige]
print @n.xbgr.xm34.nsg13_hv_nmos[ise]
print @n.xbgr.xm34.nsg13_hv_nmos[ibe]
print @n.xbgr.xm34.nsg13_hv_nmos[ctype]
print @n.xbgr.xm35.nsg13_hv_nmos[ide]
print @n.xbgr.xm35.nsg13_hv_nmos[ige]
print @n.xbgr.xm35.nsg13_hv_nmos[ise]
print @n.xbgr.xm35.nsg13_hv_nmos[ibe]
print @n.xbgr.xm35.nsg13_hv_nmos[ctype]
print @n.xbgr.xm36.nsg13_hv_nmos[ide]
print @n.xbgr.xm36.nsg13_hv_nmos[ige]
print @n.xbgr.xm36.nsg13_hv_nmos[ise]
print @n.xbgr.xm36.nsg13_hv_nmos[ibe]
print @n.xbgr.xm36.nsg13_hv_nmos[ctype]
print @n.xbgr.xm37.nsg13_hv_nmos[ide]
print @n.xbgr.xm37.nsg13_hv_nmos[ige]
print @n.xbgr.xm37.nsg13_hv_nmos[ise]
print @n.xbgr.xm37.nsg13_hv_nmos[ibe]
print @n.xbgr.xm37.nsg13_hv_nmos[ctype]
print @n.xbgr.xm38.nsg13_hv_pmos[ide]
print @n.xbgr.xm38.nsg13_hv_pmos[ige]
print @n.xbgr.xm38.nsg13_hv_pmos[ise]
print @n.xbgr.xm38.nsg13_hv_pmos[ibe]
print @n.xbgr.xm38.nsg13_hv_pmos[ctype]
print @n.xbgr.xm39.nsg13_hv_pmos[ide]
print @n.xbgr.xm39.nsg13_hv_pmos[ige]
print @n.xbgr.xm39.nsg13_hv_pmos[ise]
print @n.xbgr.xm39.nsg13_hv_pmos[ibe]
print @n.xbgr.xm39.nsg13_hv_pmos[ctype]
print @n.xbgr.xm40.nsg13_hv_pmos[ide]
print @n.xbgr.xm40.nsg13_hv_pmos[ige]
print @n.xbgr.xm40.nsg13_hv_pmos[ise]
print @n.xbgr.xm40.nsg13_hv_pmos[ibe]
print @n.xbgr.xm40.nsg13_hv_pmos[ctype]
print @n.xbgr.xm41.nsg13_hv_pmos[ide]
print @n.xbgr.xm41.nsg13_hv_pmos[ige]
print @n.xbgr.xm41.nsg13_hv_pmos[ise]
print @n.xbgr.xm41.nsg13_hv_pmos[ibe]
print @n.xbgr.xm41.nsg13_hv_pmos[ctype]
print @n.xbgr.xm42.nsg13_hv_pmos[ide]
print @n.xbgr.xm42.nsg13_hv_pmos[ige]
print @n.xbgr.xm42.nsg13_hv_pmos[ise]
print @n.xbgr.xm42.nsg13_hv_pmos[ibe]
print @n.xbgr.xm42.nsg13_hv_pmos[ctype]
print @n.xbgr.xm43.nsg13_hv_pmos[ide]
print @n.xbgr.xm43.nsg13_hv_pmos[ige]
print @n.xbgr.xm43.nsg13_hv_pmos[ise]
print @n.xbgr.xm43.nsg13_hv_pmos[ibe]
print @n.xbgr.xm43.nsg13_hv_pmos[ctype]
print @n.xbgr.xm44.nsg13_hv_pmos[ide]
print @n.xbgr.xm44.nsg13_hv_pmos[ige]
print @n.xbgr.xm44.nsg13_hv_pmos[ise]
print @n.xbgr.xm44.nsg13_hv_pmos[ibe]
print @n.xbgr.xm44.nsg13_hv_pmos[ctype]
print @n.xbgr.xm45.nsg13_hv_pmos[ide]
print @n.xbgr.xm45.nsg13_hv_pmos[ige]
print @n.xbgr.xm45.nsg13_hv_pmos[ise]
print @n.xbgr.xm45.nsg13_hv_pmos[ibe]
print @n.xbgr.xm45.nsg13_hv_pmos[ctype]
print @n.xbgr.xm46.nsg13_hv_pmos[ide]
print @n.xbgr.xm46.nsg13_hv_pmos[ige]
print @n.xbgr.xm46.nsg13_hv_pmos[ise]
print @n.xbgr.xm46.nsg13_hv_pmos[ibe]
print @n.xbgr.xm46.nsg13_hv_pmos[ctype]
print @n.xbgr.xm47.nsg13_hv_pmos[ide]
print @n.xbgr.xm47.nsg13_hv_pmos[ige]
print @n.xbgr.xm47.nsg13_hv_pmos[ise]
print @n.xbgr.xm47.nsg13_hv_pmos[ibe]
print @n.xbgr.xm47.nsg13_hv_pmos[ctype]
print @n.xbgr.xm48.nsg13_hv_pmos[ide]
print @n.xbgr.xm48.nsg13_hv_pmos[ige]
print @n.xbgr.xm48.nsg13_hv_pmos[ise]
print @n.xbgr.xm48.nsg13_hv_pmos[ibe]
print @n.xbgr.xm48.nsg13_hv_pmos[ctype]
print @n.xbgr.xm49.nsg13_hv_pmos[ide]
print @n.xbgr.xm49.nsg13_hv_pmos[ige]
print @n.xbgr.xm49.nsg13_hv_pmos[ise]
print @n.xbgr.xm49.nsg13_hv_pmos[ibe]
print @n.xbgr.xm49.nsg13_hv_pmos[ctype]
print @n.xbgr.xm50.nsg13_hv_pmos[ide]
print @n.xbgr.xm50.nsg13_hv_pmos[ige]
print @n.xbgr.xm50.nsg13_hv_pmos[ise]
print @n.xbgr.xm50.nsg13_hv_pmos[ibe]
print @n.xbgr.xm50.nsg13_hv_pmos[ctype]
print @n.xbgr.xm51.nsg13_hv_pmos[ide]
print @n.xbgr.xm51.nsg13_hv_pmos[ige]
print @n.xbgr.xm51.nsg13_hv_pmos[ise]
print @n.xbgr.xm51.nsg13_hv_pmos[ibe]
print @n.xbgr.xm51.nsg13_hv_pmos[ctype]
print @n.xbgr.xm52.nsg13_hv_pmos[ide]
print @n.xbgr.xm52.nsg13_hv_pmos[ige]
print @n.xbgr.xm52.nsg13_hv_pmos[ise]
print @n.xbgr.xm52.nsg13_hv_pmos[ibe]
print @n.xbgr.xm52.nsg13_hv_pmos[ctype]
print @n.xbgr.xm53.nsg13_hv_pmos[ide]
print @n.xbgr.xm53.nsg13_hv_pmos[ige]
print @n.xbgr.xm53.nsg13_hv_pmos[ise]
print @n.xbgr.xm53.nsg13_hv_pmos[ibe]
print @n.xbgr.xm53.nsg13_hv_pmos[ctype]
print @n.xbgr.xm54.nsg13_hv_pmos[ide]
print @n.xbgr.xm54.nsg13_hv_pmos[ige]
print @n.xbgr.xm54.nsg13_hv_pmos[ise]
print @n.xbgr.xm54.nsg13_hv_pmos[ibe]
print @n.xbgr.xm54.nsg13_hv_pmos[ctype]
print @q.xbgr.xq55.qnpn13g2[ic]
print @q.xbgr.xq55.qnpn13g2[ib]
print @q.xbgr.xq55.qnpn13g2[ie]
print @q.xbgr.xq55.qnpn13g2[is]
print @r.xbgr.xq55.rsub[i]
print @c.xbgr.xq55.csub[i]
print @q.xbgr.xq56.qnpn13g2[ic]
print @q.xbgr.xq56.qnpn13g2[ib]
print @q.xbgr.xq56.qnpn13g2[ie]
print @q.xbgr.xq56.qnpn13g2[is]
print @r.xbgr.xq56.rsub[i]
print @c.xbgr.xq56.csub[i]
print @q.xbgr.xq57.qnpn13g2[ic]
print @q.xbgr.xq57.qnpn13g2[ib]
print @q.xbgr.xq57.qnpn13g2[ie]
print @q.xbgr.xq57.qnpn13g2[is]
print @r.xbgr.xq57.rsub[i]
print @c.xbgr.xq57.csub[i]
print @q.xbgr.xq58.qnpn13g2[ic]
print @q.xbgr.xq58.qnpn13g2[ib]
print @q.xbgr.xq58.qnpn13g2[ie]
print @q.xbgr.xq58.qnpn13g2[is]
print @r.xbgr.xq58.rsub[i]
print @c.xbgr.xq58.csub[i]
print @q.xbgr.xq59.qnpn13g2[ic]
print @q.xbgr.xq59.qnpn13g2[ib]
print @q.xbgr.xq59.qnpn13g2[ie]
print @q.xbgr.xq59.qnpn13g2[is]
print @r.xbgr.xq59.rsub[i]
print @c.xbgr.xq59.csub[i]
print @q.xbgr.xq60.qnpn13g2[ic]
print @q.xbgr.xq60.qnpn13g2[ib]
print @q.xbgr.xq60.qnpn13g2[ie]
print @q.xbgr.xq60.qnpn13g2[is]
print @r.xbgr.xq60.rsub[i]
print @c.xbgr.xq60.csub[i]
print @q.xbgr.xq61.qnpn13g2[ic]
print @q.xbgr.xq61.qnpn13g2[ib]
print @q.xbgr.xq61.qnpn13g2[ie]
print @q.xbgr.xq61.qnpn13g2[is]
print @r.xbgr.xq61.rsub[i]
print @c.xbgr.xq61.csub[i]
print @q.xbgr.xq62.qnpn13g2[ic]
print @q.xbgr.xq62.qnpn13g2[ib]
print @q.xbgr.xq62.qnpn13g2[ie]
print @q.xbgr.xq62.qnpn13g2[is]
print @r.xbgr.xq62.rsub[i]
print @c.xbgr.xq62.csub[i]
print @q.xbgr.xq63.qnpn13g2[ic]
print @q.xbgr.xq63.qnpn13g2[ib]
print @q.xbgr.xq63.qnpn13g2[ie]
print @q.xbgr.xq63.qnpn13g2[is]
print @r.xbgr.xq63.rsub[i]
print @c.xbgr.xq63.csub[i]
print @q.xbgr.xq64.qnpn13g2[ic]
print @q.xbgr.xq64.qnpn13g2[ib]
print @q.xbgr.xq64.qnpn13g2[ie]
print @q.xbgr.xq64.qnpn13g2[is]
print @r.xbgr.xq64.rsub[i]
print @c.xbgr.xq64.csub[i]
print @q.xbgr.xq65.qnpn13g2[ic]
print @q.xbgr.xq65.qnpn13g2[ib]
print @q.xbgr.xq65.qnpn13g2[ie]
print @q.xbgr.xq65.qnpn13g2[is]
print @r.xbgr.xq65.rsub[i]
print @c.xbgr.xq65.csub[i]
print @q.xbgr.xq66.qnpn13g2[ic]
print @q.xbgr.xq66.qnpn13g2[ib]
print @q.xbgr.xq66.qnpn13g2[ie]
print @q.xbgr.xq66.qnpn13g2[is]
print @r.xbgr.xq66.rsub[i]
print @c.xbgr.xq66.csub[i]
print @q.xbgr.xq67.qnpn13g2[ic]
print @q.xbgr.xq67.qnpn13g2[ib]
print @q.xbgr.xq67.qnpn13g2[ie]
print @q.xbgr.xq67.qnpn13g2[is]
print @r.xbgr.xq67.rsub[i]
print @c.xbgr.xq67.csub[i]
print @q.xbgr.xq68.qnpn13g2[ic]
print @q.xbgr.xq68.qnpn13g2[ib]
print @q.xbgr.xq68.qnpn13g2[ie]
print @q.xbgr.xq68.qnpn13g2[is]
print @r.xbgr.xq68.rsub[i]
print @c.xbgr.xq68.csub[i]
print @q.xbgr.xq69.qnpn13g2[ic]
print @q.xbgr.xq69.qnpn13g2[ib]
print @q.xbgr.xq69.qnpn13g2[ie]
print @q.xbgr.xq69.qnpn13g2[is]
print @r.xbgr.xq69.rsub[i]
print @c.xbgr.xq69.csub[i]
print @q.xbgr.xq70.qnpn13g2[ic]
print @q.xbgr.xq70.qnpn13g2[ib]
print @q.xbgr.xq70.qnpn13g2[ie]
print @q.xbgr.xq70.qnpn13g2[is]
print @r.xbgr.xq70.rsub[i]
print @c.xbgr.xq70.csub[i]
print @q.xbgr.xq71.qnpn13g2[ic]
print @q.xbgr.xq71.qnpn13g2[ib]
print @q.xbgr.xq71.qnpn13g2[ie]
print @q.xbgr.xq71.qnpn13g2[is]
print @r.xbgr.xq71.rsub[i]
print @c.xbgr.xq71.csub[i]
print @q.xbgr.xq72.qnpn13g2[ic]
print @q.xbgr.xq72.qnpn13g2[ib]
print @q.xbgr.xq72.qnpn13g2[ie]
print @q.xbgr.xq72.qnpn13g2[is]
print @r.xbgr.xq72.rsub[i]
print @c.xbgr.xq72.csub[i]
print @q.xbgr.xq73.qnpn13g2[ic]
print @q.xbgr.xq73.qnpn13g2[ib]
print @q.xbgr.xq73.qnpn13g2[ie]
print @q.xbgr.xq73.qnpn13g2[is]
print @r.xbgr.xq73.rsub[i]
print @c.xbgr.xq73.csub[i]
print @q.xbgr.xq74.qnpn13g2[ic]
print @q.xbgr.xq74.qnpn13g2[ib]
print @q.xbgr.xq74.qnpn13g2[ie]
print @q.xbgr.xq74.qnpn13g2[is]
print @r.xbgr.xq74.rsub[i]
print @c.xbgr.xq74.csub[i]
print @q.xbgr.xq75.qnpn13g2[ic]
print @q.xbgr.xq75.qnpn13g2[ib]
print @q.xbgr.xq75.qnpn13g2[ie]
print @q.xbgr.xq75.qnpn13g2[is]
print @r.xbgr.xq75.rsub[i]
print @c.xbgr.xq75.csub[i]
print @q.xbgr.xq76.qnpn13g2[ic]
print @q.xbgr.xq76.qnpn13g2[ib]
print @q.xbgr.xq76.qnpn13g2[ie]
print @q.xbgr.xq76.qnpn13g2[is]
print @r.xbgr.xq76.rsub[i]
print @c.xbgr.xq76.csub[i]
print @n.xbgr.xr77.nr1[ibody]
print @n.xbgr.xr78.nr1[ibody]
print @n.xbgr.xr79.nr1[ibody]
print @n.xbgr.xr80.nr1[ibody]
print @n.xbgr.xr81.nr1[ibody]
print @n.xbgr.xr82.nr1[ibody]
print @n.xbgr.xr83.nr1[ibody]
print @n.xbgr.xr84.nr1[ibody]
print @n.xbgr.xr85.nr1[ibody]
print @n.xbgr.xr86.nr1[ibody]
print @n.xbgr.xr16_u2.nr1[ibody]
print @n.xbgr.xr16_u3.nr1[ibody]
print @n.xbgr.xr16_u4.nr1[ibody]
print @n.xbgr.xr16_u5.nr1[ibody]
print @n.xbgr.xr16_u6.nr1[ibody]
print @n.xbgr.xr16_u7.nr1[ibody]
print @n.xbgr.xr16_u8.nr1[ibody]
print @n.xbgr.xr16_u9.nr1[ibody]
print @n.xbgr.xr16_u10.nr1[ibody]
print @n.xbgr.xr16_u11.nr1[ibody]
print @n.xbgr.xr16_u12.nr1[ibody]
print @n.xbgr.xr16_u13.nr1[ibody]
print @n.xbgr.xr16_u14.nr1[ibody]
print @n.xbgr.xr16_u15.nr1[ibody]
print @n.xbgr.xr16_u16.nr1[ibody]
print @n.xbgr.xr16_u17.nr1[ibody]
print @n.xbgr.xr16_u18.nr1[ibody]
print @n.xbgr.xr16_u19.nr1[ibody]
print @n.xbgr.xr16_u20.nr1[ibody]
print @n.xbgr.xr16_u21.nr1[ibody]
print @n.xbgr.xr16_u22.nr1[ibody]
print @n.xbgr.xr16_u23.nr1[ibody]
print @n.xbgr.xr16_u24.nr1[ibody]
print @n.xbgr.xr17_u2.nr1[ibody]
print @n.xbgr.xr17_u3.nr1[ibody]
print @n.xbgr.xr17_u4.nr1[ibody]
print @n.xbgr.xr18_u2.nr1[ibody]
print @n.xbgr.xr18_u3.nr1[ibody]
print @n.xbgr.xr18_u4.nr1[ibody]
print @n.xbgr.xr19_u2.nr1[ibody]
print @n.xbgr.xr19_u3.nr1[ibody]
print @n.xbgr.xr19_u4.nr1[ibody]
print @n.xbgr.xr20_u2.nr1[ibody]
print @n.xbgr.xr20_u3.nr1[ibody]
print @n.xbgr.xr20_u4.nr1[ibody]
print @n.xbgr.xr21_u2.nr1[ibody]
print @n.xbgr.xr21_u3.nr1[ibody]
print @n.xbgr.xr21_u4.nr1[ibody]
print @n.xbgr.xr22_u2.nr1[ibody]
print @n.xbgr.xr22_u3.nr1[ibody]
print @n.xbgr.xr22_u4.nr1[ibody]
print @n.xbgr.xr23_u2.nr1[ibody]
print @n.xbgr.xr23_u3.nr1[ibody]
print @n.xbgr.xr23_u4.nr1[ibody]
print @n.xbgr.xr23_u5.nr1[ibody]
print @n.xbgr.xr23_u6.nr1[ibody]
print @n.xbgr.xr23_u7.nr1[ibody]
print @n.xbgr.xr23_u8.nr1[ibody]
print @n.xbgr.xr23_u9.nr1[ibody]
print @n.xbgr.xr23_u10.nr1[ibody]
print @n.xbgr.xr23_u11.nr1[ibody]
print @n.xbgr.xr23_u12.nr1[ibody]
print @n.xbgr.xr23_u13.nr1[ibody]
print @n.xbgr.xr23_u14.nr1[ibody]
print @n.xbgr.xr23_u15.nr1[ibody]
print @n.xbgr.xr23_u16.nr1[ibody]
print @n.xbgr.xr23_u17.nr1[ibody]
print @n.xbgr.xr23_u18.nr1[ibody]
print @n.xbgr.xr23_u19.nr1[ibody]
print @n.xbgr.xr23_u20.nr1[ibody]
print @n.xbgr.xr23_u21.nr1[ibody]
print @n.xbgr.xr23_u22.nr1[ibody]
print @n.xbgr.xr23_u23.nr1[ibody]
print @n.xbgr.xr23_u24.nr1[ibody]
print @n.xbgr.xr24_u2.nr1[ibody]
print @n.xbgr.xr24_u3.nr1[ibody]
print @n.xbgr.xr24_u4.nr1[ibody]
print @n.xbgr.xr24_u5.nr1[ibody]
print @n.xbgr.xr24_u6.nr1[ibody]
print @n.xbgr.xr24_u7.nr1[ibody]
print @n.xbgr.xr24_u8.nr1[ibody]
print @n.xbgr.xr24_u9.nr1[ibody]
print @n.xbgr.xr24_u10.nr1[ibody]
print @n.xbgr.xr24_u11.nr1[ibody]
print @n.xbgr.xr24_u12.nr1[ibody]
print @n.xbgr.xr24_u13.nr1[ibody]
print @n.xbgr.xr24_u14.nr1[ibody]
print @n.xbgr.xr24_u15.nr1[ibody]
print @n.xbgr.xr24_u16.nr1[ibody]
print @n.xbgr.xr24_u17.nr1[ibody]
print @n.xbgr.xr24_u18.nr1[ibody]
print @n.xbgr.xr24_u19.nr1[ibody]
print @n.xbgr.xr24_u20.nr1[ibody]
print @n.xbgr.xr24_u21.nr1[ibody]
print @n.xbgr.xr24_u22.nr1[ibody]
print @n.xbgr.xr24_u23.nr1[ibody]
print @n.xbgr.xr24_u24.nr1[ibody]
print @n.xbgr.xr25_u2.nr1[ibody]
print @n.xbgr.xr25_u3.nr1[ibody]
print @n.xbgr.xr25_u4.nr1[ibody]
print @n.xbgr.xr25_u5.nr1[ibody]
print @n.xbgr.xr25_u6.nr1[ibody]
print @n.xbgr.xr25_u7.nr1[ibody]
print @n.xbgr.xr25_u8.nr1[ibody]
print @n.xbgr.xr25_u9.nr1[ibody]
print @n.xbgr.xr25_u10.nr1[ibody]
print @n.xbgr.xr25_u11.nr1[ibody]
print @n.xbgr.xr25_u12.nr1[ibody]
print @n.xbgr.xr25_u13.nr1[ibody]
print @n.xbgr.xr25_u14.nr1[ibody]
print @n.xbgr.xr25_u15.nr1[ibody]
print @n.xbgr.xr25_u16.nr1[ibody]
print @n.xbgr.xr25_u17.nr1[ibody]
print @n.xbgr.xr25_u18.nr1[ibody]
print @n.xbgr.xr25_u19.nr1[ibody]
print @n.xbgr.xr25_u20.nr1[ibody]
print @n.xbgr.xr25_u21.nr1[ibody]
print @n.xbgr.xr25_u22.nr1[ibody]
print @n.xbgr.xr25_u23.nr1[ibody]
print @n.xbgr.xr25_u24.nr1[ibody]
print @n.xbgr.xr26_u2.nr1[ibody]
print @n.xbgr.xr26_u3.nr1[ibody]
print @n.xbgr.xr26_u4.nr1[ibody]
print @n.xbgr.xr26_u5.nr1[ibody]
print @n.xbgr.xr26_u6.nr1[ibody]
print @n.xbgr.xr26_u7.nr1[ibody]
print @n.xbgr.xr26_u8.nr1[ibody]
print @n.xbgr.xr26_u9.nr1[ibody]
print @n.xbgr.xr26_u10.nr1[ibody]
print @n.xbgr.xr26_u11.nr1[ibody]
print @n.xbgr.xr26_u12.nr1[ibody]
print @n.xbgr.xr26_u13.nr1[ibody]
print @n.xbgr.xr26_u14.nr1[ibody]
print @n.xbgr.xr26_u15.nr1[ibody]
print @n.xbgr.xr26_u16.nr1[ibody]
print @n.xbgr.xr26_u17.nr1[ibody]
print @n.xbgr.xr26_u18.nr1[ibody]
print @n.xbgr.xr26_u19.nr1[ibody]
print @n.xbgr.xr26_u20.nr1[ibody]
print @n.xbgr.xr26_u21.nr1[ibody]
print @n.xbgr.xr26_u22.nr1[ibody]
print @n.xbgr.xr26_u23.nr1[ibody]
print @n.xbgr.xr26_u24.nr1[ibody]
print @n.xbgr.xm34_u2.nsg13_hv_nmos[ide]
print @n.xbgr.xm34_u2.nsg13_hv_nmos[ige]
print @n.xbgr.xm34_u2.nsg13_hv_nmos[ise]
print @n.xbgr.xm34_u2.nsg13_hv_nmos[ibe]
print @n.xbgr.xm34_u2.nsg13_hv_nmos[ctype]
print @n.xbgr.xm34_u3.nsg13_hv_nmos[ide]
print @n.xbgr.xm34_u3.nsg13_hv_nmos[ige]
print @n.xbgr.xm34_u3.nsg13_hv_nmos[ise]
print @n.xbgr.xm34_u3.nsg13_hv_nmos[ibe]
print @n.xbgr.xm34_u3.nsg13_hv_nmos[ctype]
print @n.xbgr.xm34_u4.nsg13_hv_nmos[ide]
print @n.xbgr.xm34_u4.nsg13_hv_nmos[ige]
print @n.xbgr.xm34_u4.nsg13_hv_nmos[ise]
print @n.xbgr.xm34_u4.nsg13_hv_nmos[ibe]
print @n.xbgr.xm34_u4.nsg13_hv_nmos[ctype]
print @n.xbgr.xm34_u5.nsg13_hv_nmos[ide]
print @n.xbgr.xm34_u5.nsg13_hv_nmos[ige]
print @n.xbgr.xm34_u5.nsg13_hv_nmos[ise]
print @n.xbgr.xm34_u5.nsg13_hv_nmos[ibe]
print @n.xbgr.xm34_u5.nsg13_hv_nmos[ctype]
print @n.xbgr.xm34_u6.nsg13_hv_nmos[ide]
print @n.xbgr.xm34_u6.nsg13_hv_nmos[ige]
print @n.xbgr.xm34_u6.nsg13_hv_nmos[ise]
print @n.xbgr.xm34_u6.nsg13_hv_nmos[ibe]
print @n.xbgr.xm34_u6.nsg13_hv_nmos[ctype]
print @n.xbgr.xm34_u7.nsg13_hv_nmos[ide]
print @n.xbgr.xm34_u7.nsg13_hv_nmos[ige]
print @n.xbgr.xm34_u7.nsg13_hv_nmos[ise]
print @n.xbgr.xm34_u7.nsg13_hv_nmos[ibe]
print @n.xbgr.xm34_u7.nsg13_hv_nmos[ctype]
print @n.xbgr.xm34_u8.nsg13_hv_nmos[ide]
print @n.xbgr.xm34_u8.nsg13_hv_nmos[ige]
print @n.xbgr.xm34_u8.nsg13_hv_nmos[ise]
print @n.xbgr.xm34_u8.nsg13_hv_nmos[ibe]
print @n.xbgr.xm34_u8.nsg13_hv_nmos[ctype]
print @n.xbgr.xm34_u9.nsg13_hv_nmos[ide]
print @n.xbgr.xm34_u9.nsg13_hv_nmos[ige]
print @n.xbgr.xm34_u9.nsg13_hv_nmos[ise]
print @n.xbgr.xm34_u9.nsg13_hv_nmos[ibe]
print @n.xbgr.xm34_u9.nsg13_hv_nmos[ctype]
print @n.xbgr.xm34_u10.nsg13_hv_nmos[ide]
print @n.xbgr.xm34_u10.nsg13_hv_nmos[ige]
print @n.xbgr.xm34_u10.nsg13_hv_nmos[ise]
print @n.xbgr.xm34_u10.nsg13_hv_nmos[ibe]
print @n.xbgr.xm34_u10.nsg13_hv_nmos[ctype]
print @n.xbgr.xm34_u11.nsg13_hv_nmos[ide]
print @n.xbgr.xm34_u11.nsg13_hv_nmos[ige]
print @n.xbgr.xm34_u11.nsg13_hv_nmos[ise]
print @n.xbgr.xm34_u11.nsg13_hv_nmos[ibe]
print @n.xbgr.xm34_u11.nsg13_hv_nmos[ctype]
print @n.xbgr.xm34_u12.nsg13_hv_nmos[ide]
print @n.xbgr.xm34_u12.nsg13_hv_nmos[ige]
print @n.xbgr.xm34_u12.nsg13_hv_nmos[ise]
print @n.xbgr.xm34_u12.nsg13_hv_nmos[ibe]
print @n.xbgr.xm34_u12.nsg13_hv_nmos[ctype]
print @n.xbgr.xm34_u13.nsg13_hv_nmos[ide]
print @n.xbgr.xm34_u13.nsg13_hv_nmos[ige]
print @n.xbgr.xm34_u13.nsg13_hv_nmos[ise]
print @n.xbgr.xm34_u13.nsg13_hv_nmos[ibe]
print @n.xbgr.xm34_u13.nsg13_hv_nmos[ctype]
print @n.xbgr.xm34_u14.nsg13_hv_nmos[ide]
print @n.xbgr.xm34_u14.nsg13_hv_nmos[ige]
print @n.xbgr.xm34_u14.nsg13_hv_nmos[ise]
print @n.xbgr.xm34_u14.nsg13_hv_nmos[ibe]
print @n.xbgr.xm34_u14.nsg13_hv_nmos[ctype]
print @n.xbgr.xm34_u15.nsg13_hv_nmos[ide]
print @n.xbgr.xm34_u15.nsg13_hv_nmos[ige]
print @n.xbgr.xm34_u15.nsg13_hv_nmos[ise]
print @n.xbgr.xm34_u15.nsg13_hv_nmos[ibe]
print @n.xbgr.xm34_u15.nsg13_hv_nmos[ctype]
print @n.xbgr.xm34_u16.nsg13_hv_nmos[ide]
print @n.xbgr.xm34_u16.nsg13_hv_nmos[ige]
print @n.xbgr.xm34_u16.nsg13_hv_nmos[ise]
print @n.xbgr.xm34_u16.nsg13_hv_nmos[ibe]
print @n.xbgr.xm34_u16.nsg13_hv_nmos[ctype]
print @n.xbgr.xm34_u17.nsg13_hv_nmos[ide]
print @n.xbgr.xm34_u17.nsg13_hv_nmos[ige]
print @n.xbgr.xm34_u17.nsg13_hv_nmos[ise]
print @n.xbgr.xm34_u17.nsg13_hv_nmos[ibe]
print @n.xbgr.xm34_u17.nsg13_hv_nmos[ctype]
print @n.xbgr.xm34_u18.nsg13_hv_nmos[ide]
print @n.xbgr.xm34_u18.nsg13_hv_nmos[ige]
print @n.xbgr.xm34_u18.nsg13_hv_nmos[ise]
print @n.xbgr.xm34_u18.nsg13_hv_nmos[ibe]
print @n.xbgr.xm34_u18.nsg13_hv_nmos[ctype]
print @n.xbgr.xm34_u19.nsg13_hv_nmos[ide]
print @n.xbgr.xm34_u19.nsg13_hv_nmos[ige]
print @n.xbgr.xm34_u19.nsg13_hv_nmos[ise]
print @n.xbgr.xm34_u19.nsg13_hv_nmos[ibe]
print @n.xbgr.xm34_u19.nsg13_hv_nmos[ctype]
print @n.xbgr.xm34_u20.nsg13_hv_nmos[ide]
print @n.xbgr.xm34_u20.nsg13_hv_nmos[ige]
print @n.xbgr.xm34_u20.nsg13_hv_nmos[ise]
print @n.xbgr.xm34_u20.nsg13_hv_nmos[ibe]
print @n.xbgr.xm34_u20.nsg13_hv_nmos[ctype]
print @n.xbgr.xm34_u21.nsg13_hv_nmos[ide]
print @n.xbgr.xm34_u21.nsg13_hv_nmos[ige]
print @n.xbgr.xm34_u21.nsg13_hv_nmos[ise]
print @n.xbgr.xm34_u21.nsg13_hv_nmos[ibe]
print @n.xbgr.xm34_u21.nsg13_hv_nmos[ctype]
print @n.xbgr.xm34_u22.nsg13_hv_nmos[ide]
print @n.xbgr.xm34_u22.nsg13_hv_nmos[ige]
print @n.xbgr.xm34_u22.nsg13_hv_nmos[ise]
print @n.xbgr.xm34_u22.nsg13_hv_nmos[ibe]
print @n.xbgr.xm34_u22.nsg13_hv_nmos[ctype]
print @n.xbgr.xm34_u23.nsg13_hv_nmos[ide]
print @n.xbgr.xm34_u23.nsg13_hv_nmos[ige]
print @n.xbgr.xm34_u23.nsg13_hv_nmos[ise]
print @n.xbgr.xm34_u23.nsg13_hv_nmos[ibe]
print @n.xbgr.xm34_u23.nsg13_hv_nmos[ctype]
print @n.xbgr.xm34_u24.nsg13_hv_nmos[ide]
print @n.xbgr.xm34_u24.nsg13_hv_nmos[ige]
print @n.xbgr.xm34_u24.nsg13_hv_nmos[ise]
print @n.xbgr.xm34_u24.nsg13_hv_nmos[ibe]
print @n.xbgr.xm34_u24.nsg13_hv_nmos[ctype]
print @n.xbgr.xm35_u2.nsg13_hv_nmos[ide]
print @n.xbgr.xm35_u2.nsg13_hv_nmos[ige]
print @n.xbgr.xm35_u2.nsg13_hv_nmos[ise]
print @n.xbgr.xm35_u2.nsg13_hv_nmos[ibe]
print @n.xbgr.xm35_u2.nsg13_hv_nmos[ctype]
print @n.xbgr.xm35_u3.nsg13_hv_nmos[ide]
print @n.xbgr.xm35_u3.nsg13_hv_nmos[ige]
print @n.xbgr.xm35_u3.nsg13_hv_nmos[ise]
print @n.xbgr.xm35_u3.nsg13_hv_nmos[ibe]
print @n.xbgr.xm35_u3.nsg13_hv_nmos[ctype]
print @n.xbgr.xm35_u4.nsg13_hv_nmos[ide]
print @n.xbgr.xm35_u4.nsg13_hv_nmos[ige]
print @n.xbgr.xm35_u4.nsg13_hv_nmos[ise]
print @n.xbgr.xm35_u4.nsg13_hv_nmos[ibe]
print @n.xbgr.xm35_u4.nsg13_hv_nmos[ctype]
print @n.xbgr.xm35_u5.nsg13_hv_nmos[ide]
print @n.xbgr.xm35_u5.nsg13_hv_nmos[ige]
print @n.xbgr.xm35_u5.nsg13_hv_nmos[ise]
print @n.xbgr.xm35_u5.nsg13_hv_nmos[ibe]
print @n.xbgr.xm35_u5.nsg13_hv_nmos[ctype]
print @n.xbgr.xm35_u6.nsg13_hv_nmos[ide]
print @n.xbgr.xm35_u6.nsg13_hv_nmos[ige]
print @n.xbgr.xm35_u6.nsg13_hv_nmos[ise]
print @n.xbgr.xm35_u6.nsg13_hv_nmos[ibe]
print @n.xbgr.xm35_u6.nsg13_hv_nmos[ctype]
print @n.xbgr.xm35_u7.nsg13_hv_nmos[ide]
print @n.xbgr.xm35_u7.nsg13_hv_nmos[ige]
print @n.xbgr.xm35_u7.nsg13_hv_nmos[ise]
print @n.xbgr.xm35_u7.nsg13_hv_nmos[ibe]
print @n.xbgr.xm35_u7.nsg13_hv_nmos[ctype]
print @n.xbgr.xm35_u8.nsg13_hv_nmos[ide]
print @n.xbgr.xm35_u8.nsg13_hv_nmos[ige]
print @n.xbgr.xm35_u8.nsg13_hv_nmos[ise]
print @n.xbgr.xm35_u8.nsg13_hv_nmos[ibe]
print @n.xbgr.xm35_u8.nsg13_hv_nmos[ctype]
print @n.xbgr.xm35_u9.nsg13_hv_nmos[ide]
print @n.xbgr.xm35_u9.nsg13_hv_nmos[ige]
print @n.xbgr.xm35_u9.nsg13_hv_nmos[ise]
print @n.xbgr.xm35_u9.nsg13_hv_nmos[ibe]
print @n.xbgr.xm35_u9.nsg13_hv_nmos[ctype]
print @n.xbgr.xm35_u10.nsg13_hv_nmos[ide]
print @n.xbgr.xm35_u10.nsg13_hv_nmos[ige]
print @n.xbgr.xm35_u10.nsg13_hv_nmos[ise]
print @n.xbgr.xm35_u10.nsg13_hv_nmos[ibe]
print @n.xbgr.xm35_u10.nsg13_hv_nmos[ctype]
print @n.xbgr.xm35_u11.nsg13_hv_nmos[ide]
print @n.xbgr.xm35_u11.nsg13_hv_nmos[ige]
print @n.xbgr.xm35_u11.nsg13_hv_nmos[ise]
print @n.xbgr.xm35_u11.nsg13_hv_nmos[ibe]
print @n.xbgr.xm35_u11.nsg13_hv_nmos[ctype]
print @n.xbgr.xm35_u12.nsg13_hv_nmos[ide]
print @n.xbgr.xm35_u12.nsg13_hv_nmos[ige]
print @n.xbgr.xm35_u12.nsg13_hv_nmos[ise]
print @n.xbgr.xm35_u12.nsg13_hv_nmos[ibe]
print @n.xbgr.xm35_u12.nsg13_hv_nmos[ctype]
print @n.xbgr.xm35_u13.nsg13_hv_nmos[ide]
print @n.xbgr.xm35_u13.nsg13_hv_nmos[ige]
print @n.xbgr.xm35_u13.nsg13_hv_nmos[ise]
print @n.xbgr.xm35_u13.nsg13_hv_nmos[ibe]
print @n.xbgr.xm35_u13.nsg13_hv_nmos[ctype]
print @n.xbgr.xm35_u14.nsg13_hv_nmos[ide]
print @n.xbgr.xm35_u14.nsg13_hv_nmos[ige]
print @n.xbgr.xm35_u14.nsg13_hv_nmos[ise]
print @n.xbgr.xm35_u14.nsg13_hv_nmos[ibe]
print @n.xbgr.xm35_u14.nsg13_hv_nmos[ctype]
print @n.xbgr.xm35_u15.nsg13_hv_nmos[ide]
print @n.xbgr.xm35_u15.nsg13_hv_nmos[ige]
print @n.xbgr.xm35_u15.nsg13_hv_nmos[ise]
print @n.xbgr.xm35_u15.nsg13_hv_nmos[ibe]
print @n.xbgr.xm35_u15.nsg13_hv_nmos[ctype]
print @n.xbgr.xm35_u16.nsg13_hv_nmos[ide]
print @n.xbgr.xm35_u16.nsg13_hv_nmos[ige]
print @n.xbgr.xm35_u16.nsg13_hv_nmos[ise]
print @n.xbgr.xm35_u16.nsg13_hv_nmos[ibe]
print @n.xbgr.xm35_u16.nsg13_hv_nmos[ctype]
print @n.xbgr.xm35_u17.nsg13_hv_nmos[ide]
print @n.xbgr.xm35_u17.nsg13_hv_nmos[ige]
print @n.xbgr.xm35_u17.nsg13_hv_nmos[ise]
print @n.xbgr.xm35_u17.nsg13_hv_nmos[ibe]
print @n.xbgr.xm35_u17.nsg13_hv_nmos[ctype]
print @n.xbgr.xm35_u18.nsg13_hv_nmos[ide]
print @n.xbgr.xm35_u18.nsg13_hv_nmos[ige]
print @n.xbgr.xm35_u18.nsg13_hv_nmos[ise]
print @n.xbgr.xm35_u18.nsg13_hv_nmos[ibe]
print @n.xbgr.xm35_u18.nsg13_hv_nmos[ctype]
print @n.xbgr.xm35_u19.nsg13_hv_nmos[ide]
print @n.xbgr.xm35_u19.nsg13_hv_nmos[ige]
print @n.xbgr.xm35_u19.nsg13_hv_nmos[ise]
print @n.xbgr.xm35_u19.nsg13_hv_nmos[ibe]
print @n.xbgr.xm35_u19.nsg13_hv_nmos[ctype]
print @n.xbgr.xm35_u20.nsg13_hv_nmos[ide]
print @n.xbgr.xm35_u20.nsg13_hv_nmos[ige]
print @n.xbgr.xm35_u20.nsg13_hv_nmos[ise]
print @n.xbgr.xm35_u20.nsg13_hv_nmos[ibe]
print @n.xbgr.xm35_u20.nsg13_hv_nmos[ctype]
print @n.xbgr.xm35_u21.nsg13_hv_nmos[ide]
print @n.xbgr.xm35_u21.nsg13_hv_nmos[ige]
print @n.xbgr.xm35_u21.nsg13_hv_nmos[ise]
print @n.xbgr.xm35_u21.nsg13_hv_nmos[ibe]
print @n.xbgr.xm35_u21.nsg13_hv_nmos[ctype]
print @n.xbgr.xm35_u22.nsg13_hv_nmos[ide]
print @n.xbgr.xm35_u22.nsg13_hv_nmos[ige]
print @n.xbgr.xm35_u22.nsg13_hv_nmos[ise]
print @n.xbgr.xm35_u22.nsg13_hv_nmos[ibe]
print @n.xbgr.xm35_u22.nsg13_hv_nmos[ctype]
print @n.xbgr.xm35_u23.nsg13_hv_nmos[ide]
print @n.xbgr.xm35_u23.nsg13_hv_nmos[ige]
print @n.xbgr.xm35_u23.nsg13_hv_nmos[ise]
print @n.xbgr.xm35_u23.nsg13_hv_nmos[ibe]
print @n.xbgr.xm35_u23.nsg13_hv_nmos[ctype]
print @n.xbgr.xm35_u24.nsg13_hv_nmos[ide]
print @n.xbgr.xm35_u24.nsg13_hv_nmos[ige]
print @n.xbgr.xm35_u24.nsg13_hv_nmos[ise]
print @n.xbgr.xm35_u24.nsg13_hv_nmos[ibe]
print @n.xbgr.xm35_u24.nsg13_hv_nmos[ctype]
print @n.xbgr.xm36_u2.nsg13_hv_nmos[ide]
print @n.xbgr.xm36_u2.nsg13_hv_nmos[ige]
print @n.xbgr.xm36_u2.nsg13_hv_nmos[ise]
print @n.xbgr.xm36_u2.nsg13_hv_nmos[ibe]
print @n.xbgr.xm36_u2.nsg13_hv_nmos[ctype]
print @n.xbgr.xm36_u3.nsg13_hv_nmos[ide]
print @n.xbgr.xm36_u3.nsg13_hv_nmos[ige]
print @n.xbgr.xm36_u3.nsg13_hv_nmos[ise]
print @n.xbgr.xm36_u3.nsg13_hv_nmos[ibe]
print @n.xbgr.xm36_u3.nsg13_hv_nmos[ctype]
print @n.xbgr.xm36_u4.nsg13_hv_nmos[ide]
print @n.xbgr.xm36_u4.nsg13_hv_nmos[ige]
print @n.xbgr.xm36_u4.nsg13_hv_nmos[ise]
print @n.xbgr.xm36_u4.nsg13_hv_nmos[ibe]
print @n.xbgr.xm36_u4.nsg13_hv_nmos[ctype]
print @n.xbgr.xm36_u5.nsg13_hv_nmos[ide]
print @n.xbgr.xm36_u5.nsg13_hv_nmos[ige]
print @n.xbgr.xm36_u5.nsg13_hv_nmos[ise]
print @n.xbgr.xm36_u5.nsg13_hv_nmos[ibe]
print @n.xbgr.xm36_u5.nsg13_hv_nmos[ctype]
print @n.xbgr.xm36_u6.nsg13_hv_nmos[ide]
print @n.xbgr.xm36_u6.nsg13_hv_nmos[ige]
print @n.xbgr.xm36_u6.nsg13_hv_nmos[ise]
print @n.xbgr.xm36_u6.nsg13_hv_nmos[ibe]
print @n.xbgr.xm36_u6.nsg13_hv_nmos[ctype]
print @n.xbgr.xm36_u7.nsg13_hv_nmos[ide]
print @n.xbgr.xm36_u7.nsg13_hv_nmos[ige]
print @n.xbgr.xm36_u7.nsg13_hv_nmos[ise]
print @n.xbgr.xm36_u7.nsg13_hv_nmos[ibe]
print @n.xbgr.xm36_u7.nsg13_hv_nmos[ctype]
print @n.xbgr.xm36_u8.nsg13_hv_nmos[ide]
print @n.xbgr.xm36_u8.nsg13_hv_nmos[ige]
print @n.xbgr.xm36_u8.nsg13_hv_nmos[ise]
print @n.xbgr.xm36_u8.nsg13_hv_nmos[ibe]
print @n.xbgr.xm36_u8.nsg13_hv_nmos[ctype]
print @n.xbgr.xm36_u9.nsg13_hv_nmos[ide]
print @n.xbgr.xm36_u9.nsg13_hv_nmos[ige]
print @n.xbgr.xm36_u9.nsg13_hv_nmos[ise]
print @n.xbgr.xm36_u9.nsg13_hv_nmos[ibe]
print @n.xbgr.xm36_u9.nsg13_hv_nmos[ctype]
print @n.xbgr.xm36_u10.nsg13_hv_nmos[ide]
print @n.xbgr.xm36_u10.nsg13_hv_nmos[ige]
print @n.xbgr.xm36_u10.nsg13_hv_nmos[ise]
print @n.xbgr.xm36_u10.nsg13_hv_nmos[ibe]
print @n.xbgr.xm36_u10.nsg13_hv_nmos[ctype]
print @n.xbgr.xm36_u11.nsg13_hv_nmos[ide]
print @n.xbgr.xm36_u11.nsg13_hv_nmos[ige]
print @n.xbgr.xm36_u11.nsg13_hv_nmos[ise]
print @n.xbgr.xm36_u11.nsg13_hv_nmos[ibe]
print @n.xbgr.xm36_u11.nsg13_hv_nmos[ctype]
print @n.xbgr.xm36_u12.nsg13_hv_nmos[ide]
print @n.xbgr.xm36_u12.nsg13_hv_nmos[ige]
print @n.xbgr.xm36_u12.nsg13_hv_nmos[ise]
print @n.xbgr.xm36_u12.nsg13_hv_nmos[ibe]
print @n.xbgr.xm36_u12.nsg13_hv_nmos[ctype]
print @n.xbgr.xm36_u13.nsg13_hv_nmos[ide]
print @n.xbgr.xm36_u13.nsg13_hv_nmos[ige]
print @n.xbgr.xm36_u13.nsg13_hv_nmos[ise]
print @n.xbgr.xm36_u13.nsg13_hv_nmos[ibe]
print @n.xbgr.xm36_u13.nsg13_hv_nmos[ctype]
print @n.xbgr.xm36_u14.nsg13_hv_nmos[ide]
print @n.xbgr.xm36_u14.nsg13_hv_nmos[ige]
print @n.xbgr.xm36_u14.nsg13_hv_nmos[ise]
print @n.xbgr.xm36_u14.nsg13_hv_nmos[ibe]
print @n.xbgr.xm36_u14.nsg13_hv_nmos[ctype]
print @n.xbgr.xm36_u15.nsg13_hv_nmos[ide]
print @n.xbgr.xm36_u15.nsg13_hv_nmos[ige]
print @n.xbgr.xm36_u15.nsg13_hv_nmos[ise]
print @n.xbgr.xm36_u15.nsg13_hv_nmos[ibe]
print @n.xbgr.xm36_u15.nsg13_hv_nmos[ctype]
print @n.xbgr.xm36_u16.nsg13_hv_nmos[ide]
print @n.xbgr.xm36_u16.nsg13_hv_nmos[ige]
print @n.xbgr.xm36_u16.nsg13_hv_nmos[ise]
print @n.xbgr.xm36_u16.nsg13_hv_nmos[ibe]
print @n.xbgr.xm36_u16.nsg13_hv_nmos[ctype]
print @n.xbgr.xm36_u17.nsg13_hv_nmos[ide]
print @n.xbgr.xm36_u17.nsg13_hv_nmos[ige]
print @n.xbgr.xm36_u17.nsg13_hv_nmos[ise]
print @n.xbgr.xm36_u17.nsg13_hv_nmos[ibe]
print @n.xbgr.xm36_u17.nsg13_hv_nmos[ctype]
print @n.xbgr.xm36_u18.nsg13_hv_nmos[ide]
print @n.xbgr.xm36_u18.nsg13_hv_nmos[ige]
print @n.xbgr.xm36_u18.nsg13_hv_nmos[ise]
print @n.xbgr.xm36_u18.nsg13_hv_nmos[ibe]
print @n.xbgr.xm36_u18.nsg13_hv_nmos[ctype]
print @n.xbgr.xm36_u19.nsg13_hv_nmos[ide]
print @n.xbgr.xm36_u19.nsg13_hv_nmos[ige]
print @n.xbgr.xm36_u19.nsg13_hv_nmos[ise]
print @n.xbgr.xm36_u19.nsg13_hv_nmos[ibe]
print @n.xbgr.xm36_u19.nsg13_hv_nmos[ctype]
print @n.xbgr.xm36_u20.nsg13_hv_nmos[ide]
print @n.xbgr.xm36_u20.nsg13_hv_nmos[ige]
print @n.xbgr.xm36_u20.nsg13_hv_nmos[ise]
print @n.xbgr.xm36_u20.nsg13_hv_nmos[ibe]
print @n.xbgr.xm36_u20.nsg13_hv_nmos[ctype]
print @n.xbgr.xm36_u21.nsg13_hv_nmos[ide]
print @n.xbgr.xm36_u21.nsg13_hv_nmos[ige]
print @n.xbgr.xm36_u21.nsg13_hv_nmos[ise]
print @n.xbgr.xm36_u21.nsg13_hv_nmos[ibe]
print @n.xbgr.xm36_u21.nsg13_hv_nmos[ctype]
print @n.xbgr.xm36_u22.nsg13_hv_nmos[ide]
print @n.xbgr.xm36_u22.nsg13_hv_nmos[ige]
print @n.xbgr.xm36_u22.nsg13_hv_nmos[ise]
print @n.xbgr.xm36_u22.nsg13_hv_nmos[ibe]
print @n.xbgr.xm36_u22.nsg13_hv_nmos[ctype]
print @n.xbgr.xm36_u23.nsg13_hv_nmos[ide]
print @n.xbgr.xm36_u23.nsg13_hv_nmos[ige]
print @n.xbgr.xm36_u23.nsg13_hv_nmos[ise]
print @n.xbgr.xm36_u23.nsg13_hv_nmos[ibe]
print @n.xbgr.xm36_u23.nsg13_hv_nmos[ctype]
print @n.xbgr.xm36_u24.nsg13_hv_nmos[ide]
print @n.xbgr.xm36_u24.nsg13_hv_nmos[ige]
print @n.xbgr.xm36_u24.nsg13_hv_nmos[ise]
print @n.xbgr.xm36_u24.nsg13_hv_nmos[ibe]
print @n.xbgr.xm36_u24.nsg13_hv_nmos[ctype]
print @n.xbgr.xm37_u2.nsg13_hv_nmos[ide]
print @n.xbgr.xm37_u2.nsg13_hv_nmos[ige]
print @n.xbgr.xm37_u2.nsg13_hv_nmos[ise]
print @n.xbgr.xm37_u2.nsg13_hv_nmos[ibe]
print @n.xbgr.xm37_u2.nsg13_hv_nmos[ctype]
print @n.xbgr.xm37_u3.nsg13_hv_nmos[ide]
print @n.xbgr.xm37_u3.nsg13_hv_nmos[ige]
print @n.xbgr.xm37_u3.nsg13_hv_nmos[ise]
print @n.xbgr.xm37_u3.nsg13_hv_nmos[ibe]
print @n.xbgr.xm37_u3.nsg13_hv_nmos[ctype]
print @n.xbgr.xm37_u4.nsg13_hv_nmos[ide]
print @n.xbgr.xm37_u4.nsg13_hv_nmos[ige]
print @n.xbgr.xm37_u4.nsg13_hv_nmos[ise]
print @n.xbgr.xm37_u4.nsg13_hv_nmos[ibe]
print @n.xbgr.xm37_u4.nsg13_hv_nmos[ctype]
print @n.xbgr.xm37_u5.nsg13_hv_nmos[ide]
print @n.xbgr.xm37_u5.nsg13_hv_nmos[ige]
print @n.xbgr.xm37_u5.nsg13_hv_nmos[ise]
print @n.xbgr.xm37_u5.nsg13_hv_nmos[ibe]
print @n.xbgr.xm37_u5.nsg13_hv_nmos[ctype]
print @n.xbgr.xm37_u6.nsg13_hv_nmos[ide]
print @n.xbgr.xm37_u6.nsg13_hv_nmos[ige]
print @n.xbgr.xm37_u6.nsg13_hv_nmos[ise]
print @n.xbgr.xm37_u6.nsg13_hv_nmos[ibe]
print @n.xbgr.xm37_u6.nsg13_hv_nmos[ctype]
print @n.xbgr.xm37_u7.nsg13_hv_nmos[ide]
print @n.xbgr.xm37_u7.nsg13_hv_nmos[ige]
print @n.xbgr.xm37_u7.nsg13_hv_nmos[ise]
print @n.xbgr.xm37_u7.nsg13_hv_nmos[ibe]
print @n.xbgr.xm37_u7.nsg13_hv_nmos[ctype]
print @n.xbgr.xm37_u8.nsg13_hv_nmos[ide]
print @n.xbgr.xm37_u8.nsg13_hv_nmos[ige]
print @n.xbgr.xm37_u8.nsg13_hv_nmos[ise]
print @n.xbgr.xm37_u8.nsg13_hv_nmos[ibe]
print @n.xbgr.xm37_u8.nsg13_hv_nmos[ctype]
print @n.xbgr.xm37_u9.nsg13_hv_nmos[ide]
print @n.xbgr.xm37_u9.nsg13_hv_nmos[ige]
print @n.xbgr.xm37_u9.nsg13_hv_nmos[ise]
print @n.xbgr.xm37_u9.nsg13_hv_nmos[ibe]
print @n.xbgr.xm37_u9.nsg13_hv_nmos[ctype]
print @n.xbgr.xm37_u10.nsg13_hv_nmos[ide]
print @n.xbgr.xm37_u10.nsg13_hv_nmos[ige]
print @n.xbgr.xm37_u10.nsg13_hv_nmos[ise]
print @n.xbgr.xm37_u10.nsg13_hv_nmos[ibe]
print @n.xbgr.xm37_u10.nsg13_hv_nmos[ctype]
print @n.xbgr.xm37_u11.nsg13_hv_nmos[ide]
print @n.xbgr.xm37_u11.nsg13_hv_nmos[ige]
print @n.xbgr.xm37_u11.nsg13_hv_nmos[ise]
print @n.xbgr.xm37_u11.nsg13_hv_nmos[ibe]
print @n.xbgr.xm37_u11.nsg13_hv_nmos[ctype]
print @n.xbgr.xm37_u12.nsg13_hv_nmos[ide]
print @n.xbgr.xm37_u12.nsg13_hv_nmos[ige]
print @n.xbgr.xm37_u12.nsg13_hv_nmos[ise]
print @n.xbgr.xm37_u12.nsg13_hv_nmos[ibe]
print @n.xbgr.xm37_u12.nsg13_hv_nmos[ctype]
print @n.xbgr.xm37_u13.nsg13_hv_nmos[ide]
print @n.xbgr.xm37_u13.nsg13_hv_nmos[ige]
print @n.xbgr.xm37_u13.nsg13_hv_nmos[ise]
print @n.xbgr.xm37_u13.nsg13_hv_nmos[ibe]
print @n.xbgr.xm37_u13.nsg13_hv_nmos[ctype]
print @n.xbgr.xm37_u14.nsg13_hv_nmos[ide]
print @n.xbgr.xm37_u14.nsg13_hv_nmos[ige]
print @n.xbgr.xm37_u14.nsg13_hv_nmos[ise]
print @n.xbgr.xm37_u14.nsg13_hv_nmos[ibe]
print @n.xbgr.xm37_u14.nsg13_hv_nmos[ctype]
print @n.xbgr.xm37_u15.nsg13_hv_nmos[ide]
print @n.xbgr.xm37_u15.nsg13_hv_nmos[ige]
print @n.xbgr.xm37_u15.nsg13_hv_nmos[ise]
print @n.xbgr.xm37_u15.nsg13_hv_nmos[ibe]
print @n.xbgr.xm37_u15.nsg13_hv_nmos[ctype]
print @n.xbgr.xm37_u16.nsg13_hv_nmos[ide]
print @n.xbgr.xm37_u16.nsg13_hv_nmos[ige]
print @n.xbgr.xm37_u16.nsg13_hv_nmos[ise]
print @n.xbgr.xm37_u16.nsg13_hv_nmos[ibe]
print @n.xbgr.xm37_u16.nsg13_hv_nmos[ctype]
print @n.xbgr.xm37_u17.nsg13_hv_nmos[ide]
print @n.xbgr.xm37_u17.nsg13_hv_nmos[ige]
print @n.xbgr.xm37_u17.nsg13_hv_nmos[ise]
print @n.xbgr.xm37_u17.nsg13_hv_nmos[ibe]
print @n.xbgr.xm37_u17.nsg13_hv_nmos[ctype]
print @n.xbgr.xm37_u18.nsg13_hv_nmos[ide]
print @n.xbgr.xm37_u18.nsg13_hv_nmos[ige]
print @n.xbgr.xm37_u18.nsg13_hv_nmos[ise]
print @n.xbgr.xm37_u18.nsg13_hv_nmos[ibe]
print @n.xbgr.xm37_u18.nsg13_hv_nmos[ctype]
print @n.xbgr.xm37_u19.nsg13_hv_nmos[ide]
print @n.xbgr.xm37_u19.nsg13_hv_nmos[ige]
print @n.xbgr.xm37_u19.nsg13_hv_nmos[ise]
print @n.xbgr.xm37_u19.nsg13_hv_nmos[ibe]
print @n.xbgr.xm37_u19.nsg13_hv_nmos[ctype]
print @n.xbgr.xm37_u20.nsg13_hv_nmos[ide]
print @n.xbgr.xm37_u20.nsg13_hv_nmos[ige]
print @n.xbgr.xm37_u20.nsg13_hv_nmos[ise]
print @n.xbgr.xm37_u20.nsg13_hv_nmos[ibe]
print @n.xbgr.xm37_u20.nsg13_hv_nmos[ctype]
print @n.xbgr.xm37_u21.nsg13_hv_nmos[ide]
print @n.xbgr.xm37_u21.nsg13_hv_nmos[ige]
print @n.xbgr.xm37_u21.nsg13_hv_nmos[ise]
print @n.xbgr.xm37_u21.nsg13_hv_nmos[ibe]
print @n.xbgr.xm37_u21.nsg13_hv_nmos[ctype]
print @n.xbgr.xm37_u22.nsg13_hv_nmos[ide]
print @n.xbgr.xm37_u22.nsg13_hv_nmos[ige]
print @n.xbgr.xm37_u22.nsg13_hv_nmos[ise]
print @n.xbgr.xm37_u22.nsg13_hv_nmos[ibe]
print @n.xbgr.xm37_u22.nsg13_hv_nmos[ctype]
print @n.xbgr.xm37_u23.nsg13_hv_nmos[ide]
print @n.xbgr.xm37_u23.nsg13_hv_nmos[ige]
print @n.xbgr.xm37_u23.nsg13_hv_nmos[ise]
print @n.xbgr.xm37_u23.nsg13_hv_nmos[ibe]
print @n.xbgr.xm37_u23.nsg13_hv_nmos[ctype]
print @n.xbgr.xm37_u24.nsg13_hv_nmos[ide]
print @n.xbgr.xm37_u24.nsg13_hv_nmos[ige]
print @n.xbgr.xm37_u24.nsg13_hv_nmos[ise]
print @n.xbgr.xm37_u24.nsg13_hv_nmos[ibe]
print @n.xbgr.xm37_u24.nsg13_hv_nmos[ctype]
print @n.xbgr.xm38_u2.nsg13_hv_pmos[ide]
print @n.xbgr.xm38_u2.nsg13_hv_pmos[ige]
print @n.xbgr.xm38_u2.nsg13_hv_pmos[ise]
print @n.xbgr.xm38_u2.nsg13_hv_pmos[ibe]
print @n.xbgr.xm38_u2.nsg13_hv_pmos[ctype]
print @n.xbgr.xm38_u3.nsg13_hv_pmos[ide]
print @n.xbgr.xm38_u3.nsg13_hv_pmos[ige]
print @n.xbgr.xm38_u3.nsg13_hv_pmos[ise]
print @n.xbgr.xm38_u3.nsg13_hv_pmos[ibe]
print @n.xbgr.xm38_u3.nsg13_hv_pmos[ctype]
print @n.xbgr.xm38_u4.nsg13_hv_pmos[ide]
print @n.xbgr.xm38_u4.nsg13_hv_pmos[ige]
print @n.xbgr.xm38_u4.nsg13_hv_pmos[ise]
print @n.xbgr.xm38_u4.nsg13_hv_pmos[ibe]
print @n.xbgr.xm38_u4.nsg13_hv_pmos[ctype]
print @n.xbgr.xm38_u5.nsg13_hv_pmos[ide]
print @n.xbgr.xm38_u5.nsg13_hv_pmos[ige]
print @n.xbgr.xm38_u5.nsg13_hv_pmos[ise]
print @n.xbgr.xm38_u5.nsg13_hv_pmos[ibe]
print @n.xbgr.xm38_u5.nsg13_hv_pmos[ctype]
print @n.xbgr.xm38_u6.nsg13_hv_pmos[ide]
print @n.xbgr.xm38_u6.nsg13_hv_pmos[ige]
print @n.xbgr.xm38_u6.nsg13_hv_pmos[ise]
print @n.xbgr.xm38_u6.nsg13_hv_pmos[ibe]
print @n.xbgr.xm38_u6.nsg13_hv_pmos[ctype]
print @n.xbgr.xm38_u7.nsg13_hv_pmos[ide]
print @n.xbgr.xm38_u7.nsg13_hv_pmos[ige]
print @n.xbgr.xm38_u7.nsg13_hv_pmos[ise]
print @n.xbgr.xm38_u7.nsg13_hv_pmos[ibe]
print @n.xbgr.xm38_u7.nsg13_hv_pmos[ctype]
print @n.xbgr.xm38_u8.nsg13_hv_pmos[ide]
print @n.xbgr.xm38_u8.nsg13_hv_pmos[ige]
print @n.xbgr.xm38_u8.nsg13_hv_pmos[ise]
print @n.xbgr.xm38_u8.nsg13_hv_pmos[ibe]
print @n.xbgr.xm38_u8.nsg13_hv_pmos[ctype]
print @n.xbgr.xm38_u9.nsg13_hv_pmos[ide]
print @n.xbgr.xm38_u9.nsg13_hv_pmos[ige]
print @n.xbgr.xm38_u9.nsg13_hv_pmos[ise]
print @n.xbgr.xm38_u9.nsg13_hv_pmos[ibe]
print @n.xbgr.xm38_u9.nsg13_hv_pmos[ctype]
print @n.xbgr.xm38_u10.nsg13_hv_pmos[ide]
print @n.xbgr.xm38_u10.nsg13_hv_pmos[ige]
print @n.xbgr.xm38_u10.nsg13_hv_pmos[ise]
print @n.xbgr.xm38_u10.nsg13_hv_pmos[ibe]
print @n.xbgr.xm38_u10.nsg13_hv_pmos[ctype]
print @n.xbgr.xm38_u11.nsg13_hv_pmos[ide]
print @n.xbgr.xm38_u11.nsg13_hv_pmos[ige]
print @n.xbgr.xm38_u11.nsg13_hv_pmos[ise]
print @n.xbgr.xm38_u11.nsg13_hv_pmos[ibe]
print @n.xbgr.xm38_u11.nsg13_hv_pmos[ctype]
print @n.xbgr.xm38_u12.nsg13_hv_pmos[ide]
print @n.xbgr.xm38_u12.nsg13_hv_pmos[ige]
print @n.xbgr.xm38_u12.nsg13_hv_pmos[ise]
print @n.xbgr.xm38_u12.nsg13_hv_pmos[ibe]
print @n.xbgr.xm38_u12.nsg13_hv_pmos[ctype]
print @n.xbgr.xm38_u13.nsg13_hv_pmos[ide]
print @n.xbgr.xm38_u13.nsg13_hv_pmos[ige]
print @n.xbgr.xm38_u13.nsg13_hv_pmos[ise]
print @n.xbgr.xm38_u13.nsg13_hv_pmos[ibe]
print @n.xbgr.xm38_u13.nsg13_hv_pmos[ctype]
print @n.xbgr.xm38_u14.nsg13_hv_pmos[ide]
print @n.xbgr.xm38_u14.nsg13_hv_pmos[ige]
print @n.xbgr.xm38_u14.nsg13_hv_pmos[ise]
print @n.xbgr.xm38_u14.nsg13_hv_pmos[ibe]
print @n.xbgr.xm38_u14.nsg13_hv_pmos[ctype]
print @n.xbgr.xm38_u15.nsg13_hv_pmos[ide]
print @n.xbgr.xm38_u15.nsg13_hv_pmos[ige]
print @n.xbgr.xm38_u15.nsg13_hv_pmos[ise]
print @n.xbgr.xm38_u15.nsg13_hv_pmos[ibe]
print @n.xbgr.xm38_u15.nsg13_hv_pmos[ctype]
print @n.xbgr.xm38_u16.nsg13_hv_pmos[ide]
print @n.xbgr.xm38_u16.nsg13_hv_pmos[ige]
print @n.xbgr.xm38_u16.nsg13_hv_pmos[ise]
print @n.xbgr.xm38_u16.nsg13_hv_pmos[ibe]
print @n.xbgr.xm38_u16.nsg13_hv_pmos[ctype]
print @n.xbgr.xm38_u17.nsg13_hv_pmos[ide]
print @n.xbgr.xm38_u17.nsg13_hv_pmos[ige]
print @n.xbgr.xm38_u17.nsg13_hv_pmos[ise]
print @n.xbgr.xm38_u17.nsg13_hv_pmos[ibe]
print @n.xbgr.xm38_u17.nsg13_hv_pmos[ctype]
print @n.xbgr.xm38_u18.nsg13_hv_pmos[ide]
print @n.xbgr.xm38_u18.nsg13_hv_pmos[ige]
print @n.xbgr.xm38_u18.nsg13_hv_pmos[ise]
print @n.xbgr.xm38_u18.nsg13_hv_pmos[ibe]
print @n.xbgr.xm38_u18.nsg13_hv_pmos[ctype]
print @n.xbgr.xm38_u19.nsg13_hv_pmos[ide]
print @n.xbgr.xm38_u19.nsg13_hv_pmos[ige]
print @n.xbgr.xm38_u19.nsg13_hv_pmos[ise]
print @n.xbgr.xm38_u19.nsg13_hv_pmos[ibe]
print @n.xbgr.xm38_u19.nsg13_hv_pmos[ctype]
print @n.xbgr.xm38_u20.nsg13_hv_pmos[ide]
print @n.xbgr.xm38_u20.nsg13_hv_pmos[ige]
print @n.xbgr.xm38_u20.nsg13_hv_pmos[ise]
print @n.xbgr.xm38_u20.nsg13_hv_pmos[ibe]
print @n.xbgr.xm38_u20.nsg13_hv_pmos[ctype]
print @n.xbgr.xm38_u21.nsg13_hv_pmos[ide]
print @n.xbgr.xm38_u21.nsg13_hv_pmos[ige]
print @n.xbgr.xm38_u21.nsg13_hv_pmos[ise]
print @n.xbgr.xm38_u21.nsg13_hv_pmos[ibe]
print @n.xbgr.xm38_u21.nsg13_hv_pmos[ctype]
print @n.xbgr.xm38_u22.nsg13_hv_pmos[ide]
print @n.xbgr.xm38_u22.nsg13_hv_pmos[ige]
print @n.xbgr.xm38_u22.nsg13_hv_pmos[ise]
print @n.xbgr.xm38_u22.nsg13_hv_pmos[ibe]
print @n.xbgr.xm38_u22.nsg13_hv_pmos[ctype]
print @n.xbgr.xm38_u23.nsg13_hv_pmos[ide]
print @n.xbgr.xm38_u23.nsg13_hv_pmos[ige]
print @n.xbgr.xm38_u23.nsg13_hv_pmos[ise]
print @n.xbgr.xm38_u23.nsg13_hv_pmos[ibe]
print @n.xbgr.xm38_u23.nsg13_hv_pmos[ctype]
print @n.xbgr.xm38_u24.nsg13_hv_pmos[ide]
print @n.xbgr.xm38_u24.nsg13_hv_pmos[ige]
print @n.xbgr.xm38_u24.nsg13_hv_pmos[ise]
print @n.xbgr.xm38_u24.nsg13_hv_pmos[ibe]
print @n.xbgr.xm38_u24.nsg13_hv_pmos[ctype]
print @n.xbgr.xm39_u2.nsg13_hv_pmos[ide]
print @n.xbgr.xm39_u2.nsg13_hv_pmos[ige]
print @n.xbgr.xm39_u2.nsg13_hv_pmos[ise]
print @n.xbgr.xm39_u2.nsg13_hv_pmos[ibe]
print @n.xbgr.xm39_u2.nsg13_hv_pmos[ctype]
print @n.xbgr.xm39_u3.nsg13_hv_pmos[ide]
print @n.xbgr.xm39_u3.nsg13_hv_pmos[ige]
print @n.xbgr.xm39_u3.nsg13_hv_pmos[ise]
print @n.xbgr.xm39_u3.nsg13_hv_pmos[ibe]
print @n.xbgr.xm39_u3.nsg13_hv_pmos[ctype]
print @n.xbgr.xm39_u4.nsg13_hv_pmos[ide]
print @n.xbgr.xm39_u4.nsg13_hv_pmos[ige]
print @n.xbgr.xm39_u4.nsg13_hv_pmos[ise]
print @n.xbgr.xm39_u4.nsg13_hv_pmos[ibe]
print @n.xbgr.xm39_u4.nsg13_hv_pmos[ctype]
print @n.xbgr.xm39_u5.nsg13_hv_pmos[ide]
print @n.xbgr.xm39_u5.nsg13_hv_pmos[ige]
print @n.xbgr.xm39_u5.nsg13_hv_pmos[ise]
print @n.xbgr.xm39_u5.nsg13_hv_pmos[ibe]
print @n.xbgr.xm39_u5.nsg13_hv_pmos[ctype]
print @n.xbgr.xm39_u6.nsg13_hv_pmos[ide]
print @n.xbgr.xm39_u6.nsg13_hv_pmos[ige]
print @n.xbgr.xm39_u6.nsg13_hv_pmos[ise]
print @n.xbgr.xm39_u6.nsg13_hv_pmos[ibe]
print @n.xbgr.xm39_u6.nsg13_hv_pmos[ctype]
print @n.xbgr.xm39_u7.nsg13_hv_pmos[ide]
print @n.xbgr.xm39_u7.nsg13_hv_pmos[ige]
print @n.xbgr.xm39_u7.nsg13_hv_pmos[ise]
print @n.xbgr.xm39_u7.nsg13_hv_pmos[ibe]
print @n.xbgr.xm39_u7.nsg13_hv_pmos[ctype]
print @n.xbgr.xm39_u8.nsg13_hv_pmos[ide]
print @n.xbgr.xm39_u8.nsg13_hv_pmos[ige]
print @n.xbgr.xm39_u8.nsg13_hv_pmos[ise]
print @n.xbgr.xm39_u8.nsg13_hv_pmos[ibe]
print @n.xbgr.xm39_u8.nsg13_hv_pmos[ctype]
print @n.xbgr.xm39_u9.nsg13_hv_pmos[ide]
print @n.xbgr.xm39_u9.nsg13_hv_pmos[ige]
print @n.xbgr.xm39_u9.nsg13_hv_pmos[ise]
print @n.xbgr.xm39_u9.nsg13_hv_pmos[ibe]
print @n.xbgr.xm39_u9.nsg13_hv_pmos[ctype]
print @n.xbgr.xm39_u10.nsg13_hv_pmos[ide]
print @n.xbgr.xm39_u10.nsg13_hv_pmos[ige]
print @n.xbgr.xm39_u10.nsg13_hv_pmos[ise]
print @n.xbgr.xm39_u10.nsg13_hv_pmos[ibe]
print @n.xbgr.xm39_u10.nsg13_hv_pmos[ctype]
print @n.xbgr.xm39_u11.nsg13_hv_pmos[ide]
print @n.xbgr.xm39_u11.nsg13_hv_pmos[ige]
print @n.xbgr.xm39_u11.nsg13_hv_pmos[ise]
print @n.xbgr.xm39_u11.nsg13_hv_pmos[ibe]
print @n.xbgr.xm39_u11.nsg13_hv_pmos[ctype]
print @n.xbgr.xm39_u12.nsg13_hv_pmos[ide]
print @n.xbgr.xm39_u12.nsg13_hv_pmos[ige]
print @n.xbgr.xm39_u12.nsg13_hv_pmos[ise]
print @n.xbgr.xm39_u12.nsg13_hv_pmos[ibe]
print @n.xbgr.xm39_u12.nsg13_hv_pmos[ctype]
print @n.xbgr.xm39_u13.nsg13_hv_pmos[ide]
print @n.xbgr.xm39_u13.nsg13_hv_pmos[ige]
print @n.xbgr.xm39_u13.nsg13_hv_pmos[ise]
print @n.xbgr.xm39_u13.nsg13_hv_pmos[ibe]
print @n.xbgr.xm39_u13.nsg13_hv_pmos[ctype]
print @n.xbgr.xm39_u14.nsg13_hv_pmos[ide]
print @n.xbgr.xm39_u14.nsg13_hv_pmos[ige]
print @n.xbgr.xm39_u14.nsg13_hv_pmos[ise]
print @n.xbgr.xm39_u14.nsg13_hv_pmos[ibe]
print @n.xbgr.xm39_u14.nsg13_hv_pmos[ctype]
print @n.xbgr.xm39_u15.nsg13_hv_pmos[ide]
print @n.xbgr.xm39_u15.nsg13_hv_pmos[ige]
print @n.xbgr.xm39_u15.nsg13_hv_pmos[ise]
print @n.xbgr.xm39_u15.nsg13_hv_pmos[ibe]
print @n.xbgr.xm39_u15.nsg13_hv_pmos[ctype]
print @n.xbgr.xm39_u16.nsg13_hv_pmos[ide]
print @n.xbgr.xm39_u16.nsg13_hv_pmos[ige]
print @n.xbgr.xm39_u16.nsg13_hv_pmos[ise]
print @n.xbgr.xm39_u16.nsg13_hv_pmos[ibe]
print @n.xbgr.xm39_u16.nsg13_hv_pmos[ctype]
print @n.xbgr.xm39_u17.nsg13_hv_pmos[ide]
print @n.xbgr.xm39_u17.nsg13_hv_pmos[ige]
print @n.xbgr.xm39_u17.nsg13_hv_pmos[ise]
print @n.xbgr.xm39_u17.nsg13_hv_pmos[ibe]
print @n.xbgr.xm39_u17.nsg13_hv_pmos[ctype]
print @n.xbgr.xm39_u18.nsg13_hv_pmos[ide]
print @n.xbgr.xm39_u18.nsg13_hv_pmos[ige]
print @n.xbgr.xm39_u18.nsg13_hv_pmos[ise]
print @n.xbgr.xm39_u18.nsg13_hv_pmos[ibe]
print @n.xbgr.xm39_u18.nsg13_hv_pmos[ctype]
print @n.xbgr.xm39_u19.nsg13_hv_pmos[ide]
print @n.xbgr.xm39_u19.nsg13_hv_pmos[ige]
print @n.xbgr.xm39_u19.nsg13_hv_pmos[ise]
print @n.xbgr.xm39_u19.nsg13_hv_pmos[ibe]
print @n.xbgr.xm39_u19.nsg13_hv_pmos[ctype]
print @n.xbgr.xm39_u20.nsg13_hv_pmos[ide]
print @n.xbgr.xm39_u20.nsg13_hv_pmos[ige]
print @n.xbgr.xm39_u20.nsg13_hv_pmos[ise]
print @n.xbgr.xm39_u20.nsg13_hv_pmos[ibe]
print @n.xbgr.xm39_u20.nsg13_hv_pmos[ctype]
print @n.xbgr.xm39_u21.nsg13_hv_pmos[ide]
print @n.xbgr.xm39_u21.nsg13_hv_pmos[ige]
print @n.xbgr.xm39_u21.nsg13_hv_pmos[ise]
print @n.xbgr.xm39_u21.nsg13_hv_pmos[ibe]
print @n.xbgr.xm39_u21.nsg13_hv_pmos[ctype]
print @n.xbgr.xm39_u22.nsg13_hv_pmos[ide]
print @n.xbgr.xm39_u22.nsg13_hv_pmos[ige]
print @n.xbgr.xm39_u22.nsg13_hv_pmos[ise]
print @n.xbgr.xm39_u22.nsg13_hv_pmos[ibe]
print @n.xbgr.xm39_u22.nsg13_hv_pmos[ctype]
print @n.xbgr.xm39_u23.nsg13_hv_pmos[ide]
print @n.xbgr.xm39_u23.nsg13_hv_pmos[ige]
print @n.xbgr.xm39_u23.nsg13_hv_pmos[ise]
print @n.xbgr.xm39_u23.nsg13_hv_pmos[ibe]
print @n.xbgr.xm39_u23.nsg13_hv_pmos[ctype]
print @n.xbgr.xm39_u24.nsg13_hv_pmos[ide]
print @n.xbgr.xm39_u24.nsg13_hv_pmos[ige]
print @n.xbgr.xm39_u24.nsg13_hv_pmos[ise]
print @n.xbgr.xm39_u24.nsg13_hv_pmos[ibe]
print @n.xbgr.xm39_u24.nsg13_hv_pmos[ctype]
print @n.xbgr.xm41_u2.nsg13_hv_pmos[ide]
print @n.xbgr.xm41_u2.nsg13_hv_pmos[ige]
print @n.xbgr.xm41_u2.nsg13_hv_pmos[ise]
print @n.xbgr.xm41_u2.nsg13_hv_pmos[ibe]
print @n.xbgr.xm41_u2.nsg13_hv_pmos[ctype]
print @n.xbgr.xm41_u3.nsg13_hv_pmos[ide]
print @n.xbgr.xm41_u3.nsg13_hv_pmos[ige]
print @n.xbgr.xm41_u3.nsg13_hv_pmos[ise]
print @n.xbgr.xm41_u3.nsg13_hv_pmos[ibe]
print @n.xbgr.xm41_u3.nsg13_hv_pmos[ctype]
print @n.xbgr.xm41_u4.nsg13_hv_pmos[ide]
print @n.xbgr.xm41_u4.nsg13_hv_pmos[ige]
print @n.xbgr.xm41_u4.nsg13_hv_pmos[ise]
print @n.xbgr.xm41_u4.nsg13_hv_pmos[ibe]
print @n.xbgr.xm41_u4.nsg13_hv_pmos[ctype]
print @n.xbgr.xm41_u5.nsg13_hv_pmos[ide]
print @n.xbgr.xm41_u5.nsg13_hv_pmos[ige]
print @n.xbgr.xm41_u5.nsg13_hv_pmos[ise]
print @n.xbgr.xm41_u5.nsg13_hv_pmos[ibe]
print @n.xbgr.xm41_u5.nsg13_hv_pmos[ctype]
print @n.xbgr.xm41_u6.nsg13_hv_pmos[ide]
print @n.xbgr.xm41_u6.nsg13_hv_pmos[ige]
print @n.xbgr.xm41_u6.nsg13_hv_pmos[ise]
print @n.xbgr.xm41_u6.nsg13_hv_pmos[ibe]
print @n.xbgr.xm41_u6.nsg13_hv_pmos[ctype]
print @n.xbgr.xm41_u7.nsg13_hv_pmos[ide]
print @n.xbgr.xm41_u7.nsg13_hv_pmos[ige]
print @n.xbgr.xm41_u7.nsg13_hv_pmos[ise]
print @n.xbgr.xm41_u7.nsg13_hv_pmos[ibe]
print @n.xbgr.xm41_u7.nsg13_hv_pmos[ctype]
print @n.xbgr.xm41_u8.nsg13_hv_pmos[ide]
print @n.xbgr.xm41_u8.nsg13_hv_pmos[ige]
print @n.xbgr.xm41_u8.nsg13_hv_pmos[ise]
print @n.xbgr.xm41_u8.nsg13_hv_pmos[ibe]
print @n.xbgr.xm41_u8.nsg13_hv_pmos[ctype]
print @n.xbgr.xm41_u9.nsg13_hv_pmos[ide]
print @n.xbgr.xm41_u9.nsg13_hv_pmos[ige]
print @n.xbgr.xm41_u9.nsg13_hv_pmos[ise]
print @n.xbgr.xm41_u9.nsg13_hv_pmos[ibe]
print @n.xbgr.xm41_u9.nsg13_hv_pmos[ctype]
print @n.xbgr.xm41_u10.nsg13_hv_pmos[ide]
print @n.xbgr.xm41_u10.nsg13_hv_pmos[ige]
print @n.xbgr.xm41_u10.nsg13_hv_pmos[ise]
print @n.xbgr.xm41_u10.nsg13_hv_pmos[ibe]
print @n.xbgr.xm41_u10.nsg13_hv_pmos[ctype]
print @n.xbgr.xm41_u11.nsg13_hv_pmos[ide]
print @n.xbgr.xm41_u11.nsg13_hv_pmos[ige]
print @n.xbgr.xm41_u11.nsg13_hv_pmos[ise]
print @n.xbgr.xm41_u11.nsg13_hv_pmos[ibe]
print @n.xbgr.xm41_u11.nsg13_hv_pmos[ctype]
print @n.xbgr.xm41_u12.nsg13_hv_pmos[ide]
print @n.xbgr.xm41_u12.nsg13_hv_pmos[ige]
print @n.xbgr.xm41_u12.nsg13_hv_pmos[ise]
print @n.xbgr.xm41_u12.nsg13_hv_pmos[ibe]
print @n.xbgr.xm41_u12.nsg13_hv_pmos[ctype]
print @n.xbgr.xm41_u13.nsg13_hv_pmos[ide]
print @n.xbgr.xm41_u13.nsg13_hv_pmos[ige]
print @n.xbgr.xm41_u13.nsg13_hv_pmos[ise]
print @n.xbgr.xm41_u13.nsg13_hv_pmos[ibe]
print @n.xbgr.xm41_u13.nsg13_hv_pmos[ctype]
print @n.xbgr.xm41_u14.nsg13_hv_pmos[ide]
print @n.xbgr.xm41_u14.nsg13_hv_pmos[ige]
print @n.xbgr.xm41_u14.nsg13_hv_pmos[ise]
print @n.xbgr.xm41_u14.nsg13_hv_pmos[ibe]
print @n.xbgr.xm41_u14.nsg13_hv_pmos[ctype]
print @n.xbgr.xm41_u15.nsg13_hv_pmos[ide]
print @n.xbgr.xm41_u15.nsg13_hv_pmos[ige]
print @n.xbgr.xm41_u15.nsg13_hv_pmos[ise]
print @n.xbgr.xm41_u15.nsg13_hv_pmos[ibe]
print @n.xbgr.xm41_u15.nsg13_hv_pmos[ctype]
print @n.xbgr.xm41_u16.nsg13_hv_pmos[ide]
print @n.xbgr.xm41_u16.nsg13_hv_pmos[ige]
print @n.xbgr.xm41_u16.nsg13_hv_pmos[ise]
print @n.xbgr.xm41_u16.nsg13_hv_pmos[ibe]
print @n.xbgr.xm41_u16.nsg13_hv_pmos[ctype]
print @n.xbgr.xm41_u17.nsg13_hv_pmos[ide]
print @n.xbgr.xm41_u17.nsg13_hv_pmos[ige]
print @n.xbgr.xm41_u17.nsg13_hv_pmos[ise]
print @n.xbgr.xm41_u17.nsg13_hv_pmos[ibe]
print @n.xbgr.xm41_u17.nsg13_hv_pmos[ctype]
print @n.xbgr.xm41_u18.nsg13_hv_pmos[ide]
print @n.xbgr.xm41_u18.nsg13_hv_pmos[ige]
print @n.xbgr.xm41_u18.nsg13_hv_pmos[ise]
print @n.xbgr.xm41_u18.nsg13_hv_pmos[ibe]
print @n.xbgr.xm41_u18.nsg13_hv_pmos[ctype]
print @n.xbgr.xm41_u19.nsg13_hv_pmos[ide]
print @n.xbgr.xm41_u19.nsg13_hv_pmos[ige]
print @n.xbgr.xm41_u19.nsg13_hv_pmos[ise]
print @n.xbgr.xm41_u19.nsg13_hv_pmos[ibe]
print @n.xbgr.xm41_u19.nsg13_hv_pmos[ctype]
print @n.xbgr.xm41_u20.nsg13_hv_pmos[ide]
print @n.xbgr.xm41_u20.nsg13_hv_pmos[ige]
print @n.xbgr.xm41_u20.nsg13_hv_pmos[ise]
print @n.xbgr.xm41_u20.nsg13_hv_pmos[ibe]
print @n.xbgr.xm41_u20.nsg13_hv_pmos[ctype]
print @n.xbgr.xm41_u21.nsg13_hv_pmos[ide]
print @n.xbgr.xm41_u21.nsg13_hv_pmos[ige]
print @n.xbgr.xm41_u21.nsg13_hv_pmos[ise]
print @n.xbgr.xm41_u21.nsg13_hv_pmos[ibe]
print @n.xbgr.xm41_u21.nsg13_hv_pmos[ctype]
print @n.xbgr.xm41_u22.nsg13_hv_pmos[ide]
print @n.xbgr.xm41_u22.nsg13_hv_pmos[ige]
print @n.xbgr.xm41_u22.nsg13_hv_pmos[ise]
print @n.xbgr.xm41_u22.nsg13_hv_pmos[ibe]
print @n.xbgr.xm41_u22.nsg13_hv_pmos[ctype]
print @n.xbgr.xm41_u23.nsg13_hv_pmos[ide]
print @n.xbgr.xm41_u23.nsg13_hv_pmos[ige]
print @n.xbgr.xm41_u23.nsg13_hv_pmos[ise]
print @n.xbgr.xm41_u23.nsg13_hv_pmos[ibe]
print @n.xbgr.xm41_u23.nsg13_hv_pmos[ctype]
print @n.xbgr.xm41_u24.nsg13_hv_pmos[ide]
print @n.xbgr.xm41_u24.nsg13_hv_pmos[ige]
print @n.xbgr.xm41_u24.nsg13_hv_pmos[ise]
print @n.xbgr.xm41_u24.nsg13_hv_pmos[ibe]
print @n.xbgr.xm41_u24.nsg13_hv_pmos[ctype]
print @n.xbgr.xm43_u2.nsg13_hv_pmos[ide]
print @n.xbgr.xm43_u2.nsg13_hv_pmos[ige]
print @n.xbgr.xm43_u2.nsg13_hv_pmos[ise]
print @n.xbgr.xm43_u2.nsg13_hv_pmos[ibe]
print @n.xbgr.xm43_u2.nsg13_hv_pmos[ctype]
print @n.xbgr.xm43_u3.nsg13_hv_pmos[ide]
print @n.xbgr.xm43_u3.nsg13_hv_pmos[ige]
print @n.xbgr.xm43_u3.nsg13_hv_pmos[ise]
print @n.xbgr.xm43_u3.nsg13_hv_pmos[ibe]
print @n.xbgr.xm43_u3.nsg13_hv_pmos[ctype]
print @n.xbgr.xm43_u4.nsg13_hv_pmos[ide]
print @n.xbgr.xm43_u4.nsg13_hv_pmos[ige]
print @n.xbgr.xm43_u4.nsg13_hv_pmos[ise]
print @n.xbgr.xm43_u4.nsg13_hv_pmos[ibe]
print @n.xbgr.xm43_u4.nsg13_hv_pmos[ctype]
print @n.xbgr.xm44_u2.nsg13_hv_pmos[ide]
print @n.xbgr.xm44_u2.nsg13_hv_pmos[ige]
print @n.xbgr.xm44_u2.nsg13_hv_pmos[ise]
print @n.xbgr.xm44_u2.nsg13_hv_pmos[ibe]
print @n.xbgr.xm44_u2.nsg13_hv_pmos[ctype]
print @n.xbgr.xm44_u3.nsg13_hv_pmos[ide]
print @n.xbgr.xm44_u3.nsg13_hv_pmos[ige]
print @n.xbgr.xm44_u3.nsg13_hv_pmos[ise]
print @n.xbgr.xm44_u3.nsg13_hv_pmos[ibe]
print @n.xbgr.xm44_u3.nsg13_hv_pmos[ctype]
print @n.xbgr.xm44_u4.nsg13_hv_pmos[ide]
print @n.xbgr.xm44_u4.nsg13_hv_pmos[ige]
print @n.xbgr.xm44_u4.nsg13_hv_pmos[ise]
print @n.xbgr.xm44_u4.nsg13_hv_pmos[ibe]
print @n.xbgr.xm44_u4.nsg13_hv_pmos[ctype]
print @n.xbgr.xm45_u2.nsg13_hv_pmos[ide]
print @n.xbgr.xm45_u2.nsg13_hv_pmos[ige]
print @n.xbgr.xm45_u2.nsg13_hv_pmos[ise]
print @n.xbgr.xm45_u2.nsg13_hv_pmos[ibe]
print @n.xbgr.xm45_u2.nsg13_hv_pmos[ctype]
print @n.xbgr.xm45_u3.nsg13_hv_pmos[ide]
print @n.xbgr.xm45_u3.nsg13_hv_pmos[ige]
print @n.xbgr.xm45_u3.nsg13_hv_pmos[ise]
print @n.xbgr.xm45_u3.nsg13_hv_pmos[ibe]
print @n.xbgr.xm45_u3.nsg13_hv_pmos[ctype]
print @n.xbgr.xm45_u4.nsg13_hv_pmos[ide]
print @n.xbgr.xm45_u4.nsg13_hv_pmos[ige]
print @n.xbgr.xm45_u4.nsg13_hv_pmos[ise]
print @n.xbgr.xm45_u4.nsg13_hv_pmos[ibe]
print @n.xbgr.xm45_u4.nsg13_hv_pmos[ctype]
print @n.xbgr.xm45_u5.nsg13_hv_pmos[ide]
print @n.xbgr.xm45_u5.nsg13_hv_pmos[ige]
print @n.xbgr.xm45_u5.nsg13_hv_pmos[ise]
print @n.xbgr.xm45_u5.nsg13_hv_pmos[ibe]
print @n.xbgr.xm45_u5.nsg13_hv_pmos[ctype]
print @n.xbgr.xm45_u6.nsg13_hv_pmos[ide]
print @n.xbgr.xm45_u6.nsg13_hv_pmos[ige]
print @n.xbgr.xm45_u6.nsg13_hv_pmos[ise]
print @n.xbgr.xm45_u6.nsg13_hv_pmos[ibe]
print @n.xbgr.xm45_u6.nsg13_hv_pmos[ctype]
print @n.xbgr.xm45_u7.nsg13_hv_pmos[ide]
print @n.xbgr.xm45_u7.nsg13_hv_pmos[ige]
print @n.xbgr.xm45_u7.nsg13_hv_pmos[ise]
print @n.xbgr.xm45_u7.nsg13_hv_pmos[ibe]
print @n.xbgr.xm45_u7.nsg13_hv_pmos[ctype]
print @n.xbgr.xm45_u8.nsg13_hv_pmos[ide]
print @n.xbgr.xm45_u8.nsg13_hv_pmos[ige]
print @n.xbgr.xm45_u8.nsg13_hv_pmos[ise]
print @n.xbgr.xm45_u8.nsg13_hv_pmos[ibe]
print @n.xbgr.xm45_u8.nsg13_hv_pmos[ctype]
print @n.xbgr.xm45_u9.nsg13_hv_pmos[ide]
print @n.xbgr.xm45_u9.nsg13_hv_pmos[ige]
print @n.xbgr.xm45_u9.nsg13_hv_pmos[ise]
print @n.xbgr.xm45_u9.nsg13_hv_pmos[ibe]
print @n.xbgr.xm45_u9.nsg13_hv_pmos[ctype]
print @n.xbgr.xm45_u10.nsg13_hv_pmos[ide]
print @n.xbgr.xm45_u10.nsg13_hv_pmos[ige]
print @n.xbgr.xm45_u10.nsg13_hv_pmos[ise]
print @n.xbgr.xm45_u10.nsg13_hv_pmos[ibe]
print @n.xbgr.xm45_u10.nsg13_hv_pmos[ctype]
print @n.xbgr.xm45_u11.nsg13_hv_pmos[ide]
print @n.xbgr.xm45_u11.nsg13_hv_pmos[ige]
print @n.xbgr.xm45_u11.nsg13_hv_pmos[ise]
print @n.xbgr.xm45_u11.nsg13_hv_pmos[ibe]
print @n.xbgr.xm45_u11.nsg13_hv_pmos[ctype]
print @n.xbgr.xm45_u12.nsg13_hv_pmos[ide]
print @n.xbgr.xm45_u12.nsg13_hv_pmos[ige]
print @n.xbgr.xm45_u12.nsg13_hv_pmos[ise]
print @n.xbgr.xm45_u12.nsg13_hv_pmos[ibe]
print @n.xbgr.xm45_u12.nsg13_hv_pmos[ctype]
print @n.xbgr.xm45_u13.nsg13_hv_pmos[ide]
print @n.xbgr.xm45_u13.nsg13_hv_pmos[ige]
print @n.xbgr.xm45_u13.nsg13_hv_pmos[ise]
print @n.xbgr.xm45_u13.nsg13_hv_pmos[ibe]
print @n.xbgr.xm45_u13.nsg13_hv_pmos[ctype]
print @n.xbgr.xm45_u14.nsg13_hv_pmos[ide]
print @n.xbgr.xm45_u14.nsg13_hv_pmos[ige]
print @n.xbgr.xm45_u14.nsg13_hv_pmos[ise]
print @n.xbgr.xm45_u14.nsg13_hv_pmos[ibe]
print @n.xbgr.xm45_u14.nsg13_hv_pmos[ctype]
print @n.xbgr.xm45_u15.nsg13_hv_pmos[ide]
print @n.xbgr.xm45_u15.nsg13_hv_pmos[ige]
print @n.xbgr.xm45_u15.nsg13_hv_pmos[ise]
print @n.xbgr.xm45_u15.nsg13_hv_pmos[ibe]
print @n.xbgr.xm45_u15.nsg13_hv_pmos[ctype]
print @n.xbgr.xm45_u16.nsg13_hv_pmos[ide]
print @n.xbgr.xm45_u16.nsg13_hv_pmos[ige]
print @n.xbgr.xm45_u16.nsg13_hv_pmos[ise]
print @n.xbgr.xm45_u16.nsg13_hv_pmos[ibe]
print @n.xbgr.xm45_u16.nsg13_hv_pmos[ctype]
print @n.xbgr.xm45_u17.nsg13_hv_pmos[ide]
print @n.xbgr.xm45_u17.nsg13_hv_pmos[ige]
print @n.xbgr.xm45_u17.nsg13_hv_pmos[ise]
print @n.xbgr.xm45_u17.nsg13_hv_pmos[ibe]
print @n.xbgr.xm45_u17.nsg13_hv_pmos[ctype]
print @n.xbgr.xm45_u18.nsg13_hv_pmos[ide]
print @n.xbgr.xm45_u18.nsg13_hv_pmos[ige]
print @n.xbgr.xm45_u18.nsg13_hv_pmos[ise]
print @n.xbgr.xm45_u18.nsg13_hv_pmos[ibe]
print @n.xbgr.xm45_u18.nsg13_hv_pmos[ctype]
print @n.xbgr.xm45_u19.nsg13_hv_pmos[ide]
print @n.xbgr.xm45_u19.nsg13_hv_pmos[ige]
print @n.xbgr.xm45_u19.nsg13_hv_pmos[ise]
print @n.xbgr.xm45_u19.nsg13_hv_pmos[ibe]
print @n.xbgr.xm45_u19.nsg13_hv_pmos[ctype]
print @n.xbgr.xm45_u20.nsg13_hv_pmos[ide]
print @n.xbgr.xm45_u20.nsg13_hv_pmos[ige]
print @n.xbgr.xm45_u20.nsg13_hv_pmos[ise]
print @n.xbgr.xm45_u20.nsg13_hv_pmos[ibe]
print @n.xbgr.xm45_u20.nsg13_hv_pmos[ctype]
print @n.xbgr.xm45_u21.nsg13_hv_pmos[ide]
print @n.xbgr.xm45_u21.nsg13_hv_pmos[ige]
print @n.xbgr.xm45_u21.nsg13_hv_pmos[ise]
print @n.xbgr.xm45_u21.nsg13_hv_pmos[ibe]
print @n.xbgr.xm45_u21.nsg13_hv_pmos[ctype]
print @n.xbgr.xm45_u22.nsg13_hv_pmos[ide]
print @n.xbgr.xm45_u22.nsg13_hv_pmos[ige]
print @n.xbgr.xm45_u22.nsg13_hv_pmos[ise]
print @n.xbgr.xm45_u22.nsg13_hv_pmos[ibe]
print @n.xbgr.xm45_u22.nsg13_hv_pmos[ctype]
print @n.xbgr.xm45_u23.nsg13_hv_pmos[ide]
print @n.xbgr.xm45_u23.nsg13_hv_pmos[ige]
print @n.xbgr.xm45_u23.nsg13_hv_pmos[ise]
print @n.xbgr.xm45_u23.nsg13_hv_pmos[ibe]
print @n.xbgr.xm45_u23.nsg13_hv_pmos[ctype]
print @n.xbgr.xm45_u24.nsg13_hv_pmos[ide]
print @n.xbgr.xm45_u24.nsg13_hv_pmos[ige]
print @n.xbgr.xm45_u24.nsg13_hv_pmos[ise]
print @n.xbgr.xm45_u24.nsg13_hv_pmos[ibe]
print @n.xbgr.xm45_u24.nsg13_hv_pmos[ctype]
print @n.xbgr.xm47_u2.nsg13_hv_pmos[ide]
print @n.xbgr.xm47_u2.nsg13_hv_pmos[ige]
print @n.xbgr.xm47_u2.nsg13_hv_pmos[ise]
print @n.xbgr.xm47_u2.nsg13_hv_pmos[ibe]
print @n.xbgr.xm47_u2.nsg13_hv_pmos[ctype]
print @n.xbgr.xm47_u3.nsg13_hv_pmos[ide]
print @n.xbgr.xm47_u3.nsg13_hv_pmos[ige]
print @n.xbgr.xm47_u3.nsg13_hv_pmos[ise]
print @n.xbgr.xm47_u3.nsg13_hv_pmos[ibe]
print @n.xbgr.xm47_u3.nsg13_hv_pmos[ctype]
print @n.xbgr.xm47_u4.nsg13_hv_pmos[ide]
print @n.xbgr.xm47_u4.nsg13_hv_pmos[ige]
print @n.xbgr.xm47_u4.nsg13_hv_pmos[ise]
print @n.xbgr.xm47_u4.nsg13_hv_pmos[ibe]
print @n.xbgr.xm47_u4.nsg13_hv_pmos[ctype]
print @n.xbgr.xm47_u5.nsg13_hv_pmos[ide]
print @n.xbgr.xm47_u5.nsg13_hv_pmos[ige]
print @n.xbgr.xm47_u5.nsg13_hv_pmos[ise]
print @n.xbgr.xm47_u5.nsg13_hv_pmos[ibe]
print @n.xbgr.xm47_u5.nsg13_hv_pmos[ctype]
print @n.xbgr.xm47_u6.nsg13_hv_pmos[ide]
print @n.xbgr.xm47_u6.nsg13_hv_pmos[ige]
print @n.xbgr.xm47_u6.nsg13_hv_pmos[ise]
print @n.xbgr.xm47_u6.nsg13_hv_pmos[ibe]
print @n.xbgr.xm47_u6.nsg13_hv_pmos[ctype]
print @n.xbgr.xm47_u7.nsg13_hv_pmos[ide]
print @n.xbgr.xm47_u7.nsg13_hv_pmos[ige]
print @n.xbgr.xm47_u7.nsg13_hv_pmos[ise]
print @n.xbgr.xm47_u7.nsg13_hv_pmos[ibe]
print @n.xbgr.xm47_u7.nsg13_hv_pmos[ctype]
print @n.xbgr.xm47_u8.nsg13_hv_pmos[ide]
print @n.xbgr.xm47_u8.nsg13_hv_pmos[ige]
print @n.xbgr.xm47_u8.nsg13_hv_pmos[ise]
print @n.xbgr.xm47_u8.nsg13_hv_pmos[ibe]
print @n.xbgr.xm47_u8.nsg13_hv_pmos[ctype]
print @n.xbgr.xm47_u9.nsg13_hv_pmos[ide]
print @n.xbgr.xm47_u9.nsg13_hv_pmos[ige]
print @n.xbgr.xm47_u9.nsg13_hv_pmos[ise]
print @n.xbgr.xm47_u9.nsg13_hv_pmos[ibe]
print @n.xbgr.xm47_u9.nsg13_hv_pmos[ctype]
print @n.xbgr.xm47_u10.nsg13_hv_pmos[ide]
print @n.xbgr.xm47_u10.nsg13_hv_pmos[ige]
print @n.xbgr.xm47_u10.nsg13_hv_pmos[ise]
print @n.xbgr.xm47_u10.nsg13_hv_pmos[ibe]
print @n.xbgr.xm47_u10.nsg13_hv_pmos[ctype]
print @n.xbgr.xm47_u11.nsg13_hv_pmos[ide]
print @n.xbgr.xm47_u11.nsg13_hv_pmos[ige]
print @n.xbgr.xm47_u11.nsg13_hv_pmos[ise]
print @n.xbgr.xm47_u11.nsg13_hv_pmos[ibe]
print @n.xbgr.xm47_u11.nsg13_hv_pmos[ctype]
print @n.xbgr.xm47_u12.nsg13_hv_pmos[ide]
print @n.xbgr.xm47_u12.nsg13_hv_pmos[ige]
print @n.xbgr.xm47_u12.nsg13_hv_pmos[ise]
print @n.xbgr.xm47_u12.nsg13_hv_pmos[ibe]
print @n.xbgr.xm47_u12.nsg13_hv_pmos[ctype]
print @n.xbgr.xm47_u13.nsg13_hv_pmos[ide]
print @n.xbgr.xm47_u13.nsg13_hv_pmos[ige]
print @n.xbgr.xm47_u13.nsg13_hv_pmos[ise]
print @n.xbgr.xm47_u13.nsg13_hv_pmos[ibe]
print @n.xbgr.xm47_u13.nsg13_hv_pmos[ctype]
print @n.xbgr.xm47_u14.nsg13_hv_pmos[ide]
print @n.xbgr.xm47_u14.nsg13_hv_pmos[ige]
print @n.xbgr.xm47_u14.nsg13_hv_pmos[ise]
print @n.xbgr.xm47_u14.nsg13_hv_pmos[ibe]
print @n.xbgr.xm47_u14.nsg13_hv_pmos[ctype]
print @n.xbgr.xm47_u15.nsg13_hv_pmos[ide]
print @n.xbgr.xm47_u15.nsg13_hv_pmos[ige]
print @n.xbgr.xm47_u15.nsg13_hv_pmos[ise]
print @n.xbgr.xm47_u15.nsg13_hv_pmos[ibe]
print @n.xbgr.xm47_u15.nsg13_hv_pmos[ctype]
print @n.xbgr.xm47_u16.nsg13_hv_pmos[ide]
print @n.xbgr.xm47_u16.nsg13_hv_pmos[ige]
print @n.xbgr.xm47_u16.nsg13_hv_pmos[ise]
print @n.xbgr.xm47_u16.nsg13_hv_pmos[ibe]
print @n.xbgr.xm47_u16.nsg13_hv_pmos[ctype]
print @n.xbgr.xm47_u17.nsg13_hv_pmos[ide]
print @n.xbgr.xm47_u17.nsg13_hv_pmos[ige]
print @n.xbgr.xm47_u17.nsg13_hv_pmos[ise]
print @n.xbgr.xm47_u17.nsg13_hv_pmos[ibe]
print @n.xbgr.xm47_u17.nsg13_hv_pmos[ctype]
print @n.xbgr.xm47_u18.nsg13_hv_pmos[ide]
print @n.xbgr.xm47_u18.nsg13_hv_pmos[ige]
print @n.xbgr.xm47_u18.nsg13_hv_pmos[ise]
print @n.xbgr.xm47_u18.nsg13_hv_pmos[ibe]
print @n.xbgr.xm47_u18.nsg13_hv_pmos[ctype]
print @n.xbgr.xm47_u19.nsg13_hv_pmos[ide]
print @n.xbgr.xm47_u19.nsg13_hv_pmos[ige]
print @n.xbgr.xm47_u19.nsg13_hv_pmos[ise]
print @n.xbgr.xm47_u19.nsg13_hv_pmos[ibe]
print @n.xbgr.xm47_u19.nsg13_hv_pmos[ctype]
print @n.xbgr.xm47_u20.nsg13_hv_pmos[ide]
print @n.xbgr.xm47_u20.nsg13_hv_pmos[ige]
print @n.xbgr.xm47_u20.nsg13_hv_pmos[ise]
print @n.xbgr.xm47_u20.nsg13_hv_pmos[ibe]
print @n.xbgr.xm47_u20.nsg13_hv_pmos[ctype]
print @n.xbgr.xm47_u21.nsg13_hv_pmos[ide]
print @n.xbgr.xm47_u21.nsg13_hv_pmos[ige]
print @n.xbgr.xm47_u21.nsg13_hv_pmos[ise]
print @n.xbgr.xm47_u21.nsg13_hv_pmos[ibe]
print @n.xbgr.xm47_u21.nsg13_hv_pmos[ctype]
print @n.xbgr.xm47_u22.nsg13_hv_pmos[ide]
print @n.xbgr.xm47_u22.nsg13_hv_pmos[ige]
print @n.xbgr.xm47_u22.nsg13_hv_pmos[ise]
print @n.xbgr.xm47_u22.nsg13_hv_pmos[ibe]
print @n.xbgr.xm47_u22.nsg13_hv_pmos[ctype]
print @n.xbgr.xm47_u23.nsg13_hv_pmos[ide]
print @n.xbgr.xm47_u23.nsg13_hv_pmos[ige]
print @n.xbgr.xm47_u23.nsg13_hv_pmos[ise]
print @n.xbgr.xm47_u23.nsg13_hv_pmos[ibe]
print @n.xbgr.xm47_u23.nsg13_hv_pmos[ctype]
print @n.xbgr.xm47_u24.nsg13_hv_pmos[ide]
print @n.xbgr.xm47_u24.nsg13_hv_pmos[ige]
print @n.xbgr.xm47_u24.nsg13_hv_pmos[ise]
print @n.xbgr.xm47_u24.nsg13_hv_pmos[ibe]
print @n.xbgr.xm47_u24.nsg13_hv_pmos[ctype]
print @n.xbgr.xm48_u2.nsg13_hv_pmos[ide]
print @n.xbgr.xm48_u2.nsg13_hv_pmos[ige]
print @n.xbgr.xm48_u2.nsg13_hv_pmos[ise]
print @n.xbgr.xm48_u2.nsg13_hv_pmos[ibe]
print @n.xbgr.xm48_u2.nsg13_hv_pmos[ctype]
print @n.xbgr.xm48_u3.nsg13_hv_pmos[ide]
print @n.xbgr.xm48_u3.nsg13_hv_pmos[ige]
print @n.xbgr.xm48_u3.nsg13_hv_pmos[ise]
print @n.xbgr.xm48_u3.nsg13_hv_pmos[ibe]
print @n.xbgr.xm48_u3.nsg13_hv_pmos[ctype]
print @n.xbgr.xm48_u4.nsg13_hv_pmos[ide]
print @n.xbgr.xm48_u4.nsg13_hv_pmos[ige]
print @n.xbgr.xm48_u4.nsg13_hv_pmos[ise]
print @n.xbgr.xm48_u4.nsg13_hv_pmos[ibe]
print @n.xbgr.xm48_u4.nsg13_hv_pmos[ctype]
print @n.xbgr.xm48_u5.nsg13_hv_pmos[ide]
print @n.xbgr.xm48_u5.nsg13_hv_pmos[ige]
print @n.xbgr.xm48_u5.nsg13_hv_pmos[ise]
print @n.xbgr.xm48_u5.nsg13_hv_pmos[ibe]
print @n.xbgr.xm48_u5.nsg13_hv_pmos[ctype]
print @n.xbgr.xm48_u6.nsg13_hv_pmos[ide]
print @n.xbgr.xm48_u6.nsg13_hv_pmos[ige]
print @n.xbgr.xm48_u6.nsg13_hv_pmos[ise]
print @n.xbgr.xm48_u6.nsg13_hv_pmos[ibe]
print @n.xbgr.xm48_u6.nsg13_hv_pmos[ctype]
print @n.xbgr.xm48_u7.nsg13_hv_pmos[ide]
print @n.xbgr.xm48_u7.nsg13_hv_pmos[ige]
print @n.xbgr.xm48_u7.nsg13_hv_pmos[ise]
print @n.xbgr.xm48_u7.nsg13_hv_pmos[ibe]
print @n.xbgr.xm48_u7.nsg13_hv_pmos[ctype]
print @n.xbgr.xm48_u8.nsg13_hv_pmos[ide]
print @n.xbgr.xm48_u8.nsg13_hv_pmos[ige]
print @n.xbgr.xm48_u8.nsg13_hv_pmos[ise]
print @n.xbgr.xm48_u8.nsg13_hv_pmos[ibe]
print @n.xbgr.xm48_u8.nsg13_hv_pmos[ctype]
print @n.xbgr.xm48_u9.nsg13_hv_pmos[ide]
print @n.xbgr.xm48_u9.nsg13_hv_pmos[ige]
print @n.xbgr.xm48_u9.nsg13_hv_pmos[ise]
print @n.xbgr.xm48_u9.nsg13_hv_pmos[ibe]
print @n.xbgr.xm48_u9.nsg13_hv_pmos[ctype]
print @n.xbgr.xm48_u10.nsg13_hv_pmos[ide]
print @n.xbgr.xm48_u10.nsg13_hv_pmos[ige]
print @n.xbgr.xm48_u10.nsg13_hv_pmos[ise]
print @n.xbgr.xm48_u10.nsg13_hv_pmos[ibe]
print @n.xbgr.xm48_u10.nsg13_hv_pmos[ctype]
print @n.xbgr.xm48_u11.nsg13_hv_pmos[ide]
print @n.xbgr.xm48_u11.nsg13_hv_pmos[ige]
print @n.xbgr.xm48_u11.nsg13_hv_pmos[ise]
print @n.xbgr.xm48_u11.nsg13_hv_pmos[ibe]
print @n.xbgr.xm48_u11.nsg13_hv_pmos[ctype]
print @n.xbgr.xm48_u12.nsg13_hv_pmos[ide]
print @n.xbgr.xm48_u12.nsg13_hv_pmos[ige]
print @n.xbgr.xm48_u12.nsg13_hv_pmos[ise]
print @n.xbgr.xm48_u12.nsg13_hv_pmos[ibe]
print @n.xbgr.xm48_u12.nsg13_hv_pmos[ctype]
print @n.xbgr.xm48_u13.nsg13_hv_pmos[ide]
print @n.xbgr.xm48_u13.nsg13_hv_pmos[ige]
print @n.xbgr.xm48_u13.nsg13_hv_pmos[ise]
print @n.xbgr.xm48_u13.nsg13_hv_pmos[ibe]
print @n.xbgr.xm48_u13.nsg13_hv_pmos[ctype]
print @n.xbgr.xm48_u14.nsg13_hv_pmos[ide]
print @n.xbgr.xm48_u14.nsg13_hv_pmos[ige]
print @n.xbgr.xm48_u14.nsg13_hv_pmos[ise]
print @n.xbgr.xm48_u14.nsg13_hv_pmos[ibe]
print @n.xbgr.xm48_u14.nsg13_hv_pmos[ctype]
print @n.xbgr.xm48_u15.nsg13_hv_pmos[ide]
print @n.xbgr.xm48_u15.nsg13_hv_pmos[ige]
print @n.xbgr.xm48_u15.nsg13_hv_pmos[ise]
print @n.xbgr.xm48_u15.nsg13_hv_pmos[ibe]
print @n.xbgr.xm48_u15.nsg13_hv_pmos[ctype]
print @n.xbgr.xm48_u16.nsg13_hv_pmos[ide]
print @n.xbgr.xm48_u16.nsg13_hv_pmos[ige]
print @n.xbgr.xm48_u16.nsg13_hv_pmos[ise]
print @n.xbgr.xm48_u16.nsg13_hv_pmos[ibe]
print @n.xbgr.xm48_u16.nsg13_hv_pmos[ctype]
print @n.xbgr.xm48_u17.nsg13_hv_pmos[ide]
print @n.xbgr.xm48_u17.nsg13_hv_pmos[ige]
print @n.xbgr.xm48_u17.nsg13_hv_pmos[ise]
print @n.xbgr.xm48_u17.nsg13_hv_pmos[ibe]
print @n.xbgr.xm48_u17.nsg13_hv_pmos[ctype]
print @n.xbgr.xm48_u18.nsg13_hv_pmos[ide]
print @n.xbgr.xm48_u18.nsg13_hv_pmos[ige]
print @n.xbgr.xm48_u18.nsg13_hv_pmos[ise]
print @n.xbgr.xm48_u18.nsg13_hv_pmos[ibe]
print @n.xbgr.xm48_u18.nsg13_hv_pmos[ctype]
print @n.xbgr.xm48_u19.nsg13_hv_pmos[ide]
print @n.xbgr.xm48_u19.nsg13_hv_pmos[ige]
print @n.xbgr.xm48_u19.nsg13_hv_pmos[ise]
print @n.xbgr.xm48_u19.nsg13_hv_pmos[ibe]
print @n.xbgr.xm48_u19.nsg13_hv_pmos[ctype]
print @n.xbgr.xm48_u20.nsg13_hv_pmos[ide]
print @n.xbgr.xm48_u20.nsg13_hv_pmos[ige]
print @n.xbgr.xm48_u20.nsg13_hv_pmos[ise]
print @n.xbgr.xm48_u20.nsg13_hv_pmos[ibe]
print @n.xbgr.xm48_u20.nsg13_hv_pmos[ctype]
print @n.xbgr.xm48_u21.nsg13_hv_pmos[ide]
print @n.xbgr.xm48_u21.nsg13_hv_pmos[ige]
print @n.xbgr.xm48_u21.nsg13_hv_pmos[ise]
print @n.xbgr.xm48_u21.nsg13_hv_pmos[ibe]
print @n.xbgr.xm48_u21.nsg13_hv_pmos[ctype]
print @n.xbgr.xm48_u22.nsg13_hv_pmos[ide]
print @n.xbgr.xm48_u22.nsg13_hv_pmos[ige]
print @n.xbgr.xm48_u22.nsg13_hv_pmos[ise]
print @n.xbgr.xm48_u22.nsg13_hv_pmos[ibe]
print @n.xbgr.xm48_u22.nsg13_hv_pmos[ctype]
print @n.xbgr.xm48_u23.nsg13_hv_pmos[ide]
print @n.xbgr.xm48_u23.nsg13_hv_pmos[ige]
print @n.xbgr.xm48_u23.nsg13_hv_pmos[ise]
print @n.xbgr.xm48_u23.nsg13_hv_pmos[ibe]
print @n.xbgr.xm48_u23.nsg13_hv_pmos[ctype]
print @n.xbgr.xm48_u24.nsg13_hv_pmos[ide]
print @n.xbgr.xm48_u24.nsg13_hv_pmos[ige]
print @n.xbgr.xm48_u24.nsg13_hv_pmos[ise]
print @n.xbgr.xm48_u24.nsg13_hv_pmos[ibe]
print @n.xbgr.xm48_u24.nsg13_hv_pmos[ctype]
print @n.xbgr.xm50_u2.nsg13_hv_pmos[ide]
print @n.xbgr.xm50_u2.nsg13_hv_pmos[ige]
print @n.xbgr.xm50_u2.nsg13_hv_pmos[ise]
print @n.xbgr.xm50_u2.nsg13_hv_pmos[ibe]
print @n.xbgr.xm50_u2.nsg13_hv_pmos[ctype]
print @n.xbgr.xm50_u3.nsg13_hv_pmos[ide]
print @n.xbgr.xm50_u3.nsg13_hv_pmos[ige]
print @n.xbgr.xm50_u3.nsg13_hv_pmos[ise]
print @n.xbgr.xm50_u3.nsg13_hv_pmos[ibe]
print @n.xbgr.xm50_u3.nsg13_hv_pmos[ctype]
print @n.xbgr.xm50_u4.nsg13_hv_pmos[ide]
print @n.xbgr.xm50_u4.nsg13_hv_pmos[ige]
print @n.xbgr.xm50_u4.nsg13_hv_pmos[ise]
print @n.xbgr.xm50_u4.nsg13_hv_pmos[ibe]
print @n.xbgr.xm50_u4.nsg13_hv_pmos[ctype]
print @n.xbgr.xm50_u5.nsg13_hv_pmos[ide]
print @n.xbgr.xm50_u5.nsg13_hv_pmos[ige]
print @n.xbgr.xm50_u5.nsg13_hv_pmos[ise]
print @n.xbgr.xm50_u5.nsg13_hv_pmos[ibe]
print @n.xbgr.xm50_u5.nsg13_hv_pmos[ctype]
print @n.xbgr.xm50_u6.nsg13_hv_pmos[ide]
print @n.xbgr.xm50_u6.nsg13_hv_pmos[ige]
print @n.xbgr.xm50_u6.nsg13_hv_pmos[ise]
print @n.xbgr.xm50_u6.nsg13_hv_pmos[ibe]
print @n.xbgr.xm50_u6.nsg13_hv_pmos[ctype]
print @n.xbgr.xm50_u7.nsg13_hv_pmos[ide]
print @n.xbgr.xm50_u7.nsg13_hv_pmos[ige]
print @n.xbgr.xm50_u7.nsg13_hv_pmos[ise]
print @n.xbgr.xm50_u7.nsg13_hv_pmos[ibe]
print @n.xbgr.xm50_u7.nsg13_hv_pmos[ctype]
print @n.xbgr.xm50_u8.nsg13_hv_pmos[ide]
print @n.xbgr.xm50_u8.nsg13_hv_pmos[ige]
print @n.xbgr.xm50_u8.nsg13_hv_pmos[ise]
print @n.xbgr.xm50_u8.nsg13_hv_pmos[ibe]
print @n.xbgr.xm50_u8.nsg13_hv_pmos[ctype]
print @n.xbgr.xm50_u9.nsg13_hv_pmos[ide]
print @n.xbgr.xm50_u9.nsg13_hv_pmos[ige]
print @n.xbgr.xm50_u9.nsg13_hv_pmos[ise]
print @n.xbgr.xm50_u9.nsg13_hv_pmos[ibe]
print @n.xbgr.xm50_u9.nsg13_hv_pmos[ctype]
print @n.xbgr.xm50_u10.nsg13_hv_pmos[ide]
print @n.xbgr.xm50_u10.nsg13_hv_pmos[ige]
print @n.xbgr.xm50_u10.nsg13_hv_pmos[ise]
print @n.xbgr.xm50_u10.nsg13_hv_pmos[ibe]
print @n.xbgr.xm50_u10.nsg13_hv_pmos[ctype]
print @n.xbgr.xm50_u11.nsg13_hv_pmos[ide]
print @n.xbgr.xm50_u11.nsg13_hv_pmos[ige]
print @n.xbgr.xm50_u11.nsg13_hv_pmos[ise]
print @n.xbgr.xm50_u11.nsg13_hv_pmos[ibe]
print @n.xbgr.xm50_u11.nsg13_hv_pmos[ctype]
print @n.xbgr.xm50_u12.nsg13_hv_pmos[ide]
print @n.xbgr.xm50_u12.nsg13_hv_pmos[ige]
print @n.xbgr.xm50_u12.nsg13_hv_pmos[ise]
print @n.xbgr.xm50_u12.nsg13_hv_pmos[ibe]
print @n.xbgr.xm50_u12.nsg13_hv_pmos[ctype]
print @n.xbgr.xm50_u13.nsg13_hv_pmos[ide]
print @n.xbgr.xm50_u13.nsg13_hv_pmos[ige]
print @n.xbgr.xm50_u13.nsg13_hv_pmos[ise]
print @n.xbgr.xm50_u13.nsg13_hv_pmos[ibe]
print @n.xbgr.xm50_u13.nsg13_hv_pmos[ctype]
print @n.xbgr.xm50_u14.nsg13_hv_pmos[ide]
print @n.xbgr.xm50_u14.nsg13_hv_pmos[ige]
print @n.xbgr.xm50_u14.nsg13_hv_pmos[ise]
print @n.xbgr.xm50_u14.nsg13_hv_pmos[ibe]
print @n.xbgr.xm50_u14.nsg13_hv_pmos[ctype]
print @n.xbgr.xm50_u15.nsg13_hv_pmos[ide]
print @n.xbgr.xm50_u15.nsg13_hv_pmos[ige]
print @n.xbgr.xm50_u15.nsg13_hv_pmos[ise]
print @n.xbgr.xm50_u15.nsg13_hv_pmos[ibe]
print @n.xbgr.xm50_u15.nsg13_hv_pmos[ctype]
print @n.xbgr.xm50_u16.nsg13_hv_pmos[ide]
print @n.xbgr.xm50_u16.nsg13_hv_pmos[ige]
print @n.xbgr.xm50_u16.nsg13_hv_pmos[ise]
print @n.xbgr.xm50_u16.nsg13_hv_pmos[ibe]
print @n.xbgr.xm50_u16.nsg13_hv_pmos[ctype]
print @n.xbgr.xm50_u17.nsg13_hv_pmos[ide]
print @n.xbgr.xm50_u17.nsg13_hv_pmos[ige]
print @n.xbgr.xm50_u17.nsg13_hv_pmos[ise]
print @n.xbgr.xm50_u17.nsg13_hv_pmos[ibe]
print @n.xbgr.xm50_u17.nsg13_hv_pmos[ctype]
print @n.xbgr.xm50_u18.nsg13_hv_pmos[ide]
print @n.xbgr.xm50_u18.nsg13_hv_pmos[ige]
print @n.xbgr.xm50_u18.nsg13_hv_pmos[ise]
print @n.xbgr.xm50_u18.nsg13_hv_pmos[ibe]
print @n.xbgr.xm50_u18.nsg13_hv_pmos[ctype]
print @n.xbgr.xm50_u19.nsg13_hv_pmos[ide]
print @n.xbgr.xm50_u19.nsg13_hv_pmos[ige]
print @n.xbgr.xm50_u19.nsg13_hv_pmos[ise]
print @n.xbgr.xm50_u19.nsg13_hv_pmos[ibe]
print @n.xbgr.xm50_u19.nsg13_hv_pmos[ctype]
print @n.xbgr.xm50_u20.nsg13_hv_pmos[ide]
print @n.xbgr.xm50_u20.nsg13_hv_pmos[ige]
print @n.xbgr.xm50_u20.nsg13_hv_pmos[ise]
print @n.xbgr.xm50_u20.nsg13_hv_pmos[ibe]
print @n.xbgr.xm50_u20.nsg13_hv_pmos[ctype]
print @n.xbgr.xm50_u21.nsg13_hv_pmos[ide]
print @n.xbgr.xm50_u21.nsg13_hv_pmos[ige]
print @n.xbgr.xm50_u21.nsg13_hv_pmos[ise]
print @n.xbgr.xm50_u21.nsg13_hv_pmos[ibe]
print @n.xbgr.xm50_u21.nsg13_hv_pmos[ctype]
print @n.xbgr.xm50_u22.nsg13_hv_pmos[ide]
print @n.xbgr.xm50_u22.nsg13_hv_pmos[ige]
print @n.xbgr.xm50_u22.nsg13_hv_pmos[ise]
print @n.xbgr.xm50_u22.nsg13_hv_pmos[ibe]
print @n.xbgr.xm50_u22.nsg13_hv_pmos[ctype]
print @n.xbgr.xm50_u23.nsg13_hv_pmos[ide]
print @n.xbgr.xm50_u23.nsg13_hv_pmos[ige]
print @n.xbgr.xm50_u23.nsg13_hv_pmos[ise]
print @n.xbgr.xm50_u23.nsg13_hv_pmos[ibe]
print @n.xbgr.xm50_u23.nsg13_hv_pmos[ctype]
print @n.xbgr.xm50_u24.nsg13_hv_pmos[ide]
print @n.xbgr.xm50_u24.nsg13_hv_pmos[ige]
print @n.xbgr.xm50_u24.nsg13_hv_pmos[ise]
print @n.xbgr.xm50_u24.nsg13_hv_pmos[ibe]
print @n.xbgr.xm50_u24.nsg13_hv_pmos[ctype]
print @n.xbgr.xm51_u2.nsg13_hv_pmos[ide]
print @n.xbgr.xm51_u2.nsg13_hv_pmos[ige]
print @n.xbgr.xm51_u2.nsg13_hv_pmos[ise]
print @n.xbgr.xm51_u2.nsg13_hv_pmos[ibe]
print @n.xbgr.xm51_u2.nsg13_hv_pmos[ctype]
print @n.xbgr.xm51_u3.nsg13_hv_pmos[ide]
print @n.xbgr.xm51_u3.nsg13_hv_pmos[ige]
print @n.xbgr.xm51_u3.nsg13_hv_pmos[ise]
print @n.xbgr.xm51_u3.nsg13_hv_pmos[ibe]
print @n.xbgr.xm51_u3.nsg13_hv_pmos[ctype]
print @n.xbgr.xm51_u4.nsg13_hv_pmos[ide]
print @n.xbgr.xm51_u4.nsg13_hv_pmos[ige]
print @n.xbgr.xm51_u4.nsg13_hv_pmos[ise]
print @n.xbgr.xm51_u4.nsg13_hv_pmos[ibe]
print @n.xbgr.xm51_u4.nsg13_hv_pmos[ctype]
print @n.xbgr.xm52_u2.nsg13_hv_pmos[ide]
print @n.xbgr.xm52_u2.nsg13_hv_pmos[ige]
print @n.xbgr.xm52_u2.nsg13_hv_pmos[ise]
print @n.xbgr.xm52_u2.nsg13_hv_pmos[ibe]
print @n.xbgr.xm52_u2.nsg13_hv_pmos[ctype]
print @n.xbgr.xm52_u3.nsg13_hv_pmos[ide]
print @n.xbgr.xm52_u3.nsg13_hv_pmos[ige]
print @n.xbgr.xm52_u3.nsg13_hv_pmos[ise]
print @n.xbgr.xm52_u3.nsg13_hv_pmos[ibe]
print @n.xbgr.xm52_u3.nsg13_hv_pmos[ctype]
print @n.xbgr.xm52_u4.nsg13_hv_pmos[ide]
print @n.xbgr.xm52_u4.nsg13_hv_pmos[ige]
print @n.xbgr.xm52_u4.nsg13_hv_pmos[ise]
print @n.xbgr.xm52_u4.nsg13_hv_pmos[ibe]
print @n.xbgr.xm52_u4.nsg13_hv_pmos[ctype]
print @n.xbgr.xm52_u5.nsg13_hv_pmos[ide]
print @n.xbgr.xm52_u5.nsg13_hv_pmos[ige]
print @n.xbgr.xm52_u5.nsg13_hv_pmos[ise]
print @n.xbgr.xm52_u5.nsg13_hv_pmos[ibe]
print @n.xbgr.xm52_u5.nsg13_hv_pmos[ctype]
print @n.xbgr.xm52_u6.nsg13_hv_pmos[ide]
print @n.xbgr.xm52_u6.nsg13_hv_pmos[ige]
print @n.xbgr.xm52_u6.nsg13_hv_pmos[ise]
print @n.xbgr.xm52_u6.nsg13_hv_pmos[ibe]
print @n.xbgr.xm52_u6.nsg13_hv_pmos[ctype]
print @n.xbgr.xm52_u7.nsg13_hv_pmos[ide]
print @n.xbgr.xm52_u7.nsg13_hv_pmos[ige]
print @n.xbgr.xm52_u7.nsg13_hv_pmos[ise]
print @n.xbgr.xm52_u7.nsg13_hv_pmos[ibe]
print @n.xbgr.xm52_u7.nsg13_hv_pmos[ctype]
print @n.xbgr.xm52_u8.nsg13_hv_pmos[ide]
print @n.xbgr.xm52_u8.nsg13_hv_pmos[ige]
print @n.xbgr.xm52_u8.nsg13_hv_pmos[ise]
print @n.xbgr.xm52_u8.nsg13_hv_pmos[ibe]
print @n.xbgr.xm52_u8.nsg13_hv_pmos[ctype]
print @n.xbgr.xm52_u9.nsg13_hv_pmos[ide]
print @n.xbgr.xm52_u9.nsg13_hv_pmos[ige]
print @n.xbgr.xm52_u9.nsg13_hv_pmos[ise]
print @n.xbgr.xm52_u9.nsg13_hv_pmos[ibe]
print @n.xbgr.xm52_u9.nsg13_hv_pmos[ctype]
print @n.xbgr.xm52_u10.nsg13_hv_pmos[ide]
print @n.xbgr.xm52_u10.nsg13_hv_pmos[ige]
print @n.xbgr.xm52_u10.nsg13_hv_pmos[ise]
print @n.xbgr.xm52_u10.nsg13_hv_pmos[ibe]
print @n.xbgr.xm52_u10.nsg13_hv_pmos[ctype]
print @n.xbgr.xm52_u11.nsg13_hv_pmos[ide]
print @n.xbgr.xm52_u11.nsg13_hv_pmos[ige]
print @n.xbgr.xm52_u11.nsg13_hv_pmos[ise]
print @n.xbgr.xm52_u11.nsg13_hv_pmos[ibe]
print @n.xbgr.xm52_u11.nsg13_hv_pmos[ctype]
print @n.xbgr.xm52_u12.nsg13_hv_pmos[ide]
print @n.xbgr.xm52_u12.nsg13_hv_pmos[ige]
print @n.xbgr.xm52_u12.nsg13_hv_pmos[ise]
print @n.xbgr.xm52_u12.nsg13_hv_pmos[ibe]
print @n.xbgr.xm52_u12.nsg13_hv_pmos[ctype]
print @n.xbgr.xm52_u13.nsg13_hv_pmos[ide]
print @n.xbgr.xm52_u13.nsg13_hv_pmos[ige]
print @n.xbgr.xm52_u13.nsg13_hv_pmos[ise]
print @n.xbgr.xm52_u13.nsg13_hv_pmos[ibe]
print @n.xbgr.xm52_u13.nsg13_hv_pmos[ctype]
print @n.xbgr.xm52_u14.nsg13_hv_pmos[ide]
print @n.xbgr.xm52_u14.nsg13_hv_pmos[ige]
print @n.xbgr.xm52_u14.nsg13_hv_pmos[ise]
print @n.xbgr.xm52_u14.nsg13_hv_pmos[ibe]
print @n.xbgr.xm52_u14.nsg13_hv_pmos[ctype]
print @n.xbgr.xm52_u15.nsg13_hv_pmos[ide]
print @n.xbgr.xm52_u15.nsg13_hv_pmos[ige]
print @n.xbgr.xm52_u15.nsg13_hv_pmos[ise]
print @n.xbgr.xm52_u15.nsg13_hv_pmos[ibe]
print @n.xbgr.xm52_u15.nsg13_hv_pmos[ctype]
print @n.xbgr.xm52_u16.nsg13_hv_pmos[ide]
print @n.xbgr.xm52_u16.nsg13_hv_pmos[ige]
print @n.xbgr.xm52_u16.nsg13_hv_pmos[ise]
print @n.xbgr.xm52_u16.nsg13_hv_pmos[ibe]
print @n.xbgr.xm52_u16.nsg13_hv_pmos[ctype]
print @n.xbgr.xm52_u17.nsg13_hv_pmos[ide]
print @n.xbgr.xm52_u17.nsg13_hv_pmos[ige]
print @n.xbgr.xm52_u17.nsg13_hv_pmos[ise]
print @n.xbgr.xm52_u17.nsg13_hv_pmos[ibe]
print @n.xbgr.xm52_u17.nsg13_hv_pmos[ctype]
print @n.xbgr.xm52_u18.nsg13_hv_pmos[ide]
print @n.xbgr.xm52_u18.nsg13_hv_pmos[ige]
print @n.xbgr.xm52_u18.nsg13_hv_pmos[ise]
print @n.xbgr.xm52_u18.nsg13_hv_pmos[ibe]
print @n.xbgr.xm52_u18.nsg13_hv_pmos[ctype]
print @n.xbgr.xm52_u19.nsg13_hv_pmos[ide]
print @n.xbgr.xm52_u19.nsg13_hv_pmos[ige]
print @n.xbgr.xm52_u19.nsg13_hv_pmos[ise]
print @n.xbgr.xm52_u19.nsg13_hv_pmos[ibe]
print @n.xbgr.xm52_u19.nsg13_hv_pmos[ctype]
print @n.xbgr.xm52_u20.nsg13_hv_pmos[ide]
print @n.xbgr.xm52_u20.nsg13_hv_pmos[ige]
print @n.xbgr.xm52_u20.nsg13_hv_pmos[ise]
print @n.xbgr.xm52_u20.nsg13_hv_pmos[ibe]
print @n.xbgr.xm52_u20.nsg13_hv_pmos[ctype]
print @n.xbgr.xm52_u21.nsg13_hv_pmos[ide]
print @n.xbgr.xm52_u21.nsg13_hv_pmos[ige]
print @n.xbgr.xm52_u21.nsg13_hv_pmos[ise]
print @n.xbgr.xm52_u21.nsg13_hv_pmos[ibe]
print @n.xbgr.xm52_u21.nsg13_hv_pmos[ctype]
print @n.xbgr.xm52_u22.nsg13_hv_pmos[ide]
print @n.xbgr.xm52_u22.nsg13_hv_pmos[ige]
print @n.xbgr.xm52_u22.nsg13_hv_pmos[ise]
print @n.xbgr.xm52_u22.nsg13_hv_pmos[ibe]
print @n.xbgr.xm52_u22.nsg13_hv_pmos[ctype]
print @n.xbgr.xm52_u23.nsg13_hv_pmos[ide]
print @n.xbgr.xm52_u23.nsg13_hv_pmos[ige]
print @n.xbgr.xm52_u23.nsg13_hv_pmos[ise]
print @n.xbgr.xm52_u23.nsg13_hv_pmos[ibe]
print @n.xbgr.xm52_u23.nsg13_hv_pmos[ctype]
print @n.xbgr.xm52_u24.nsg13_hv_pmos[ide]
print @n.xbgr.xm52_u24.nsg13_hv_pmos[ige]
print @n.xbgr.xm52_u24.nsg13_hv_pmos[ise]
print @n.xbgr.xm52_u24.nsg13_hv_pmos[ibe]
print @n.xbgr.xm52_u24.nsg13_hv_pmos[ctype]
print @n.xbgr.xm54_u2.nsg13_hv_pmos[ide]
print @n.xbgr.xm54_u2.nsg13_hv_pmos[ige]
print @n.xbgr.xm54_u2.nsg13_hv_pmos[ise]
print @n.xbgr.xm54_u2.nsg13_hv_pmos[ibe]
print @n.xbgr.xm54_u2.nsg13_hv_pmos[ctype]
print @n.xbgr.xm54_u3.nsg13_hv_pmos[ide]
print @n.xbgr.xm54_u3.nsg13_hv_pmos[ige]
print @n.xbgr.xm54_u3.nsg13_hv_pmos[ise]
print @n.xbgr.xm54_u3.nsg13_hv_pmos[ibe]
print @n.xbgr.xm54_u3.nsg13_hv_pmos[ctype]
print @n.xbgr.xm54_u4.nsg13_hv_pmos[ide]
print @n.xbgr.xm54_u4.nsg13_hv_pmos[ige]
print @n.xbgr.xm54_u4.nsg13_hv_pmos[ise]
print @n.xbgr.xm54_u4.nsg13_hv_pmos[ibe]
print @n.xbgr.xm54_u4.nsg13_hv_pmos[ctype]
print @n.xbgr.xm54_u5.nsg13_hv_pmos[ide]
print @n.xbgr.xm54_u5.nsg13_hv_pmos[ige]
print @n.xbgr.xm54_u5.nsg13_hv_pmos[ise]
print @n.xbgr.xm54_u5.nsg13_hv_pmos[ibe]
print @n.xbgr.xm54_u5.nsg13_hv_pmos[ctype]
print @n.xbgr.xm54_u6.nsg13_hv_pmos[ide]
print @n.xbgr.xm54_u6.nsg13_hv_pmos[ige]
print @n.xbgr.xm54_u6.nsg13_hv_pmos[ise]
print @n.xbgr.xm54_u6.nsg13_hv_pmos[ibe]
print @n.xbgr.xm54_u6.nsg13_hv_pmos[ctype]
print @n.xbgr.xm54_u7.nsg13_hv_pmos[ide]
print @n.xbgr.xm54_u7.nsg13_hv_pmos[ige]
print @n.xbgr.xm54_u7.nsg13_hv_pmos[ise]
print @n.xbgr.xm54_u7.nsg13_hv_pmos[ibe]
print @n.xbgr.xm54_u7.nsg13_hv_pmos[ctype]
print @n.xbgr.xm54_u8.nsg13_hv_pmos[ide]
print @n.xbgr.xm54_u8.nsg13_hv_pmos[ige]
print @n.xbgr.xm54_u8.nsg13_hv_pmos[ise]
print @n.xbgr.xm54_u8.nsg13_hv_pmos[ibe]
print @n.xbgr.xm54_u8.nsg13_hv_pmos[ctype]
print @n.xbgr.xm54_u9.nsg13_hv_pmos[ide]
print @n.xbgr.xm54_u9.nsg13_hv_pmos[ige]
print @n.xbgr.xm54_u9.nsg13_hv_pmos[ise]
print @n.xbgr.xm54_u9.nsg13_hv_pmos[ibe]
print @n.xbgr.xm54_u9.nsg13_hv_pmos[ctype]
print @n.xbgr.xm54_u10.nsg13_hv_pmos[ide]
print @n.xbgr.xm54_u10.nsg13_hv_pmos[ige]
print @n.xbgr.xm54_u10.nsg13_hv_pmos[ise]
print @n.xbgr.xm54_u10.nsg13_hv_pmos[ibe]
print @n.xbgr.xm54_u10.nsg13_hv_pmos[ctype]
print @n.xbgr.xm54_u11.nsg13_hv_pmos[ide]
print @n.xbgr.xm54_u11.nsg13_hv_pmos[ige]
print @n.xbgr.xm54_u11.nsg13_hv_pmos[ise]
print @n.xbgr.xm54_u11.nsg13_hv_pmos[ibe]
print @n.xbgr.xm54_u11.nsg13_hv_pmos[ctype]
print @n.xbgr.xm54_u12.nsg13_hv_pmos[ide]
print @n.xbgr.xm54_u12.nsg13_hv_pmos[ige]
print @n.xbgr.xm54_u12.nsg13_hv_pmos[ise]
print @n.xbgr.xm54_u12.nsg13_hv_pmos[ibe]
print @n.xbgr.xm54_u12.nsg13_hv_pmos[ctype]
print @n.xbgr.xm54_u13.nsg13_hv_pmos[ide]
print @n.xbgr.xm54_u13.nsg13_hv_pmos[ige]
print @n.xbgr.xm54_u13.nsg13_hv_pmos[ise]
print @n.xbgr.xm54_u13.nsg13_hv_pmos[ibe]
print @n.xbgr.xm54_u13.nsg13_hv_pmos[ctype]
print @n.xbgr.xm54_u14.nsg13_hv_pmos[ide]
print @n.xbgr.xm54_u14.nsg13_hv_pmos[ige]
print @n.xbgr.xm54_u14.nsg13_hv_pmos[ise]
print @n.xbgr.xm54_u14.nsg13_hv_pmos[ibe]
print @n.xbgr.xm54_u14.nsg13_hv_pmos[ctype]
print @n.xbgr.xm54_u15.nsg13_hv_pmos[ide]
print @n.xbgr.xm54_u15.nsg13_hv_pmos[ige]
print @n.xbgr.xm54_u15.nsg13_hv_pmos[ise]
print @n.xbgr.xm54_u15.nsg13_hv_pmos[ibe]
print @n.xbgr.xm54_u15.nsg13_hv_pmos[ctype]
print @n.xbgr.xm54_u16.nsg13_hv_pmos[ide]
print @n.xbgr.xm54_u16.nsg13_hv_pmos[ige]
print @n.xbgr.xm54_u16.nsg13_hv_pmos[ise]
print @n.xbgr.xm54_u16.nsg13_hv_pmos[ibe]
print @n.xbgr.xm54_u16.nsg13_hv_pmos[ctype]
print @n.xbgr.xm54_u17.nsg13_hv_pmos[ide]
print @n.xbgr.xm54_u17.nsg13_hv_pmos[ige]
print @n.xbgr.xm54_u17.nsg13_hv_pmos[ise]
print @n.xbgr.xm54_u17.nsg13_hv_pmos[ibe]
print @n.xbgr.xm54_u17.nsg13_hv_pmos[ctype]
print @n.xbgr.xm54_u18.nsg13_hv_pmos[ide]
print @n.xbgr.xm54_u18.nsg13_hv_pmos[ige]
print @n.xbgr.xm54_u18.nsg13_hv_pmos[ise]
print @n.xbgr.xm54_u18.nsg13_hv_pmos[ibe]
print @n.xbgr.xm54_u18.nsg13_hv_pmos[ctype]
print @n.xbgr.xm54_u19.nsg13_hv_pmos[ide]
print @n.xbgr.xm54_u19.nsg13_hv_pmos[ige]
print @n.xbgr.xm54_u19.nsg13_hv_pmos[ise]
print @n.xbgr.xm54_u19.nsg13_hv_pmos[ibe]
print @n.xbgr.xm54_u19.nsg13_hv_pmos[ctype]
print @n.xbgr.xm54_u20.nsg13_hv_pmos[ide]
print @n.xbgr.xm54_u20.nsg13_hv_pmos[ige]
print @n.xbgr.xm54_u20.nsg13_hv_pmos[ise]
print @n.xbgr.xm54_u20.nsg13_hv_pmos[ibe]
print @n.xbgr.xm54_u20.nsg13_hv_pmos[ctype]
print @n.xbgr.xm54_u21.nsg13_hv_pmos[ide]
print @n.xbgr.xm54_u21.nsg13_hv_pmos[ige]
print @n.xbgr.xm54_u21.nsg13_hv_pmos[ise]
print @n.xbgr.xm54_u21.nsg13_hv_pmos[ibe]
print @n.xbgr.xm54_u21.nsg13_hv_pmos[ctype]
print @n.xbgr.xm54_u22.nsg13_hv_pmos[ide]
print @n.xbgr.xm54_u22.nsg13_hv_pmos[ige]
print @n.xbgr.xm54_u22.nsg13_hv_pmos[ise]
print @n.xbgr.xm54_u22.nsg13_hv_pmos[ibe]
print @n.xbgr.xm54_u22.nsg13_hv_pmos[ctype]
print @n.xbgr.xm54_u23.nsg13_hv_pmos[ide]
print @n.xbgr.xm54_u23.nsg13_hv_pmos[ige]
print @n.xbgr.xm54_u23.nsg13_hv_pmos[ise]
print @n.xbgr.xm54_u23.nsg13_hv_pmos[ibe]
print @n.xbgr.xm54_u23.nsg13_hv_pmos[ctype]
print @n.xbgr.xm54_u24.nsg13_hv_pmos[ide]
print @n.xbgr.xm54_u24.nsg13_hv_pmos[ige]
print @n.xbgr.xm54_u24.nsg13_hv_pmos[ise]
print @n.xbgr.xm54_u24.nsg13_hv_pmos[ibe]
print @n.xbgr.xm54_u24.nsg13_hv_pmos[ctype]
print @q.xbgr.xq56_u2.qnpn13g2[ic]
print @q.xbgr.xq56_u2.qnpn13g2[ib]
print @q.xbgr.xq56_u2.qnpn13g2[ie]
print @q.xbgr.xq56_u2.qnpn13g2[is]
print @r.xbgr.xq56_u2.rsub[i]
print @c.xbgr.xq56_u2.csub[i]
print @q.xbgr.xq56_u3.qnpn13g2[ic]
print @q.xbgr.xq56_u3.qnpn13g2[ib]
print @q.xbgr.xq56_u3.qnpn13g2[ie]
print @q.xbgr.xq56_u3.qnpn13g2[is]
print @r.xbgr.xq56_u3.rsub[i]
print @c.xbgr.xq56_u3.csub[i]
print @q.xbgr.xq56_u4.qnpn13g2[ic]
print @q.xbgr.xq56_u4.qnpn13g2[ib]
print @q.xbgr.xq56_u4.qnpn13g2[ie]
print @q.xbgr.xq56_u4.qnpn13g2[is]
print @r.xbgr.xq56_u4.rsub[i]
print @c.xbgr.xq56_u4.csub[i]
print @q.xbgr.xq56_u5.qnpn13g2[ic]
print @q.xbgr.xq56_u5.qnpn13g2[ib]
print @q.xbgr.xq56_u5.qnpn13g2[ie]
print @q.xbgr.xq56_u5.qnpn13g2[is]
print @r.xbgr.xq56_u5.rsub[i]
print @c.xbgr.xq56_u5.csub[i]
print @q.xbgr.xq56_u6.qnpn13g2[ic]
print @q.xbgr.xq56_u6.qnpn13g2[ib]
print @q.xbgr.xq56_u6.qnpn13g2[ie]
print @q.xbgr.xq56_u6.qnpn13g2[is]
print @r.xbgr.xq56_u6.rsub[i]
print @c.xbgr.xq56_u6.csub[i]
print @q.xbgr.xq56_u7.qnpn13g2[ic]
print @q.xbgr.xq56_u7.qnpn13g2[ib]
print @q.xbgr.xq56_u7.qnpn13g2[ie]
print @q.xbgr.xq56_u7.qnpn13g2[is]
print @r.xbgr.xq56_u7.rsub[i]
print @c.xbgr.xq56_u7.csub[i]
print @q.xbgr.xq56_u8.qnpn13g2[ic]
print @q.xbgr.xq56_u8.qnpn13g2[ib]
print @q.xbgr.xq56_u8.qnpn13g2[ie]
print @q.xbgr.xq56_u8.qnpn13g2[is]
print @r.xbgr.xq56_u8.rsub[i]
print @c.xbgr.xq56_u8.csub[i]
print @q.xbgr.xq56_u9.qnpn13g2[ic]
print @q.xbgr.xq56_u9.qnpn13g2[ib]
print @q.xbgr.xq56_u9.qnpn13g2[ie]
print @q.xbgr.xq56_u9.qnpn13g2[is]
print @r.xbgr.xq56_u9.rsub[i]
print @c.xbgr.xq56_u9.csub[i]
print @q.xbgr.xq56_u10.qnpn13g2[ic]
print @q.xbgr.xq56_u10.qnpn13g2[ib]
print @q.xbgr.xq56_u10.qnpn13g2[ie]
print @q.xbgr.xq56_u10.qnpn13g2[is]
print @r.xbgr.xq56_u10.rsub[i]
print @c.xbgr.xq56_u10.csub[i]
print @q.xbgr.xq56_u11.qnpn13g2[ic]
print @q.xbgr.xq56_u11.qnpn13g2[ib]
print @q.xbgr.xq56_u11.qnpn13g2[ie]
print @q.xbgr.xq56_u11.qnpn13g2[is]
print @r.xbgr.xq56_u11.rsub[i]
print @c.xbgr.xq56_u11.csub[i]
print @q.xbgr.xq56_u12.qnpn13g2[ic]
print @q.xbgr.xq56_u12.qnpn13g2[ib]
print @q.xbgr.xq56_u12.qnpn13g2[ie]
print @q.xbgr.xq56_u12.qnpn13g2[is]
print @r.xbgr.xq56_u12.rsub[i]
print @c.xbgr.xq56_u12.csub[i]
print @q.xbgr.xq56_u13.qnpn13g2[ic]
print @q.xbgr.xq56_u13.qnpn13g2[ib]
print @q.xbgr.xq56_u13.qnpn13g2[ie]
print @q.xbgr.xq56_u13.qnpn13g2[is]
print @r.xbgr.xq56_u13.rsub[i]
print @c.xbgr.xq56_u13.csub[i]
print @q.xbgr.xq56_u14.qnpn13g2[ic]
print @q.xbgr.xq56_u14.qnpn13g2[ib]
print @q.xbgr.xq56_u14.qnpn13g2[ie]
print @q.xbgr.xq56_u14.qnpn13g2[is]
print @r.xbgr.xq56_u14.rsub[i]
print @c.xbgr.xq56_u14.csub[i]
print @q.xbgr.xq56_u15.qnpn13g2[ic]
print @q.xbgr.xq56_u15.qnpn13g2[ib]
print @q.xbgr.xq56_u15.qnpn13g2[ie]
print @q.xbgr.xq56_u15.qnpn13g2[is]
print @r.xbgr.xq56_u15.rsub[i]
print @c.xbgr.xq56_u15.csub[i]
print @q.xbgr.xq56_u16.qnpn13g2[ic]
print @q.xbgr.xq56_u16.qnpn13g2[ib]
print @q.xbgr.xq56_u16.qnpn13g2[ie]
print @q.xbgr.xq56_u16.qnpn13g2[is]
print @r.xbgr.xq56_u16.rsub[i]
print @c.xbgr.xq56_u16.csub[i]
print @q.xbgr.xq56_u17.qnpn13g2[ic]
print @q.xbgr.xq56_u17.qnpn13g2[ib]
print @q.xbgr.xq56_u17.qnpn13g2[ie]
print @q.xbgr.xq56_u17.qnpn13g2[is]
print @r.xbgr.xq56_u17.rsub[i]
print @c.xbgr.xq56_u17.csub[i]
print @q.xbgr.xq56_u18.qnpn13g2[ic]
print @q.xbgr.xq56_u18.qnpn13g2[ib]
print @q.xbgr.xq56_u18.qnpn13g2[ie]
print @q.xbgr.xq56_u18.qnpn13g2[is]
print @r.xbgr.xq56_u18.rsub[i]
print @c.xbgr.xq56_u18.csub[i]
print @q.xbgr.xq56_u19.qnpn13g2[ic]
print @q.xbgr.xq56_u19.qnpn13g2[ib]
print @q.xbgr.xq56_u19.qnpn13g2[ie]
print @q.xbgr.xq56_u19.qnpn13g2[is]
print @r.xbgr.xq56_u19.rsub[i]
print @c.xbgr.xq56_u19.csub[i]
print @q.xbgr.xq56_u20.qnpn13g2[ic]
print @q.xbgr.xq56_u20.qnpn13g2[ib]
print @q.xbgr.xq56_u20.qnpn13g2[ie]
print @q.xbgr.xq56_u20.qnpn13g2[is]
print @r.xbgr.xq56_u20.rsub[i]
print @c.xbgr.xq56_u20.csub[i]
print @q.xbgr.xq56_u21.qnpn13g2[ic]
print @q.xbgr.xq56_u21.qnpn13g2[ib]
print @q.xbgr.xq56_u21.qnpn13g2[ie]
print @q.xbgr.xq56_u21.qnpn13g2[is]
print @r.xbgr.xq56_u21.rsub[i]
print @c.xbgr.xq56_u21.csub[i]
print @q.xbgr.xq56_u22.qnpn13g2[ic]
print @q.xbgr.xq56_u22.qnpn13g2[ib]
print @q.xbgr.xq56_u22.qnpn13g2[ie]
print @q.xbgr.xq56_u22.qnpn13g2[is]
print @r.xbgr.xq56_u22.rsub[i]
print @c.xbgr.xq56_u22.csub[i]
print @q.xbgr.xq56_u23.qnpn13g2[ic]
print @q.xbgr.xq56_u23.qnpn13g2[ib]
print @q.xbgr.xq56_u23.qnpn13g2[ie]
print @q.xbgr.xq56_u23.qnpn13g2[is]
print @r.xbgr.xq56_u23.rsub[i]
print @c.xbgr.xq56_u23.csub[i]
print @q.xbgr.xq56_u24.qnpn13g2[ic]
print @q.xbgr.xq56_u24.qnpn13g2[ib]
print @q.xbgr.xq56_u24.qnpn13g2[ie]
print @q.xbgr.xq56_u24.qnpn13g2[is]
print @r.xbgr.xq56_u24.rsub[i]
print @c.xbgr.xq56_u24.csub[i]
print @q.xbgr.xq60_u2.qnpn13g2[ic]
print @q.xbgr.xq60_u2.qnpn13g2[ib]
print @q.xbgr.xq60_u2.qnpn13g2[ie]
print @q.xbgr.xq60_u2.qnpn13g2[is]
print @r.xbgr.xq60_u2.rsub[i]
print @c.xbgr.xq60_u2.csub[i]
print @q.xbgr.xq60_u3.qnpn13g2[ic]
print @q.xbgr.xq60_u3.qnpn13g2[ib]
print @q.xbgr.xq60_u3.qnpn13g2[ie]
print @q.xbgr.xq60_u3.qnpn13g2[is]
print @r.xbgr.xq60_u3.rsub[i]
print @c.xbgr.xq60_u3.csub[i]
print @q.xbgr.xq60_u4.qnpn13g2[ic]
print @q.xbgr.xq60_u4.qnpn13g2[ib]
print @q.xbgr.xq60_u4.qnpn13g2[ie]
print @q.xbgr.xq60_u4.qnpn13g2[is]
print @r.xbgr.xq60_u4.rsub[i]
print @c.xbgr.xq60_u4.csub[i]
print @q.xbgr.xq62_u2.qnpn13g2[ic]
print @q.xbgr.xq62_u2.qnpn13g2[ib]
print @q.xbgr.xq62_u2.qnpn13g2[ie]
print @q.xbgr.xq62_u2.qnpn13g2[is]
print @r.xbgr.xq62_u2.rsub[i]
print @c.xbgr.xq62_u2.csub[i]
print @q.xbgr.xq62_u3.qnpn13g2[ic]
print @q.xbgr.xq62_u3.qnpn13g2[ib]
print @q.xbgr.xq62_u3.qnpn13g2[ie]
print @q.xbgr.xq62_u3.qnpn13g2[is]
print @r.xbgr.xq62_u3.rsub[i]
print @c.xbgr.xq62_u3.csub[i]
print @q.xbgr.xq62_u4.qnpn13g2[ic]
print @q.xbgr.xq62_u4.qnpn13g2[ib]
print @q.xbgr.xq62_u4.qnpn13g2[ie]
print @q.xbgr.xq62_u4.qnpn13g2[is]
print @r.xbgr.xq62_u4.rsub[i]
print @c.xbgr.xq62_u4.csub[i]
print @q.xbgr.xq62_u5.qnpn13g2[ic]
print @q.xbgr.xq62_u5.qnpn13g2[ib]
print @q.xbgr.xq62_u5.qnpn13g2[ie]
print @q.xbgr.xq62_u5.qnpn13g2[is]
print @r.xbgr.xq62_u5.rsub[i]
print @c.xbgr.xq62_u5.csub[i]
print @q.xbgr.xq62_u6.qnpn13g2[ic]
print @q.xbgr.xq62_u6.qnpn13g2[ib]
print @q.xbgr.xq62_u6.qnpn13g2[ie]
print @q.xbgr.xq62_u6.qnpn13g2[is]
print @r.xbgr.xq62_u6.rsub[i]
print @c.xbgr.xq62_u6.csub[i]
print @q.xbgr.xq62_u7.qnpn13g2[ic]
print @q.xbgr.xq62_u7.qnpn13g2[ib]
print @q.xbgr.xq62_u7.qnpn13g2[ie]
print @q.xbgr.xq62_u7.qnpn13g2[is]
print @r.xbgr.xq62_u7.rsub[i]
print @c.xbgr.xq62_u7.csub[i]
print @q.xbgr.xq62_u8.qnpn13g2[ic]
print @q.xbgr.xq62_u8.qnpn13g2[ib]
print @q.xbgr.xq62_u8.qnpn13g2[ie]
print @q.xbgr.xq62_u8.qnpn13g2[is]
print @r.xbgr.xq62_u8.rsub[i]
print @c.xbgr.xq62_u8.csub[i]
print @q.xbgr.xq62_u9.qnpn13g2[ic]
print @q.xbgr.xq62_u9.qnpn13g2[ib]
print @q.xbgr.xq62_u9.qnpn13g2[ie]
print @q.xbgr.xq62_u9.qnpn13g2[is]
print @r.xbgr.xq62_u9.rsub[i]
print @c.xbgr.xq62_u9.csub[i]
print @q.xbgr.xq62_u10.qnpn13g2[ic]
print @q.xbgr.xq62_u10.qnpn13g2[ib]
print @q.xbgr.xq62_u10.qnpn13g2[ie]
print @q.xbgr.xq62_u10.qnpn13g2[is]
print @r.xbgr.xq62_u10.rsub[i]
print @c.xbgr.xq62_u10.csub[i]
print @q.xbgr.xq62_u11.qnpn13g2[ic]
print @q.xbgr.xq62_u11.qnpn13g2[ib]
print @q.xbgr.xq62_u11.qnpn13g2[ie]
print @q.xbgr.xq62_u11.qnpn13g2[is]
print @r.xbgr.xq62_u11.rsub[i]
print @c.xbgr.xq62_u11.csub[i]
print @q.xbgr.xq62_u12.qnpn13g2[ic]
print @q.xbgr.xq62_u12.qnpn13g2[ib]
print @q.xbgr.xq62_u12.qnpn13g2[ie]
print @q.xbgr.xq62_u12.qnpn13g2[is]
print @r.xbgr.xq62_u12.rsub[i]
print @c.xbgr.xq62_u12.csub[i]
print @q.xbgr.xq62_u13.qnpn13g2[ic]
print @q.xbgr.xq62_u13.qnpn13g2[ib]
print @q.xbgr.xq62_u13.qnpn13g2[ie]
print @q.xbgr.xq62_u13.qnpn13g2[is]
print @r.xbgr.xq62_u13.rsub[i]
print @c.xbgr.xq62_u13.csub[i]
print @q.xbgr.xq62_u14.qnpn13g2[ic]
print @q.xbgr.xq62_u14.qnpn13g2[ib]
print @q.xbgr.xq62_u14.qnpn13g2[ie]
print @q.xbgr.xq62_u14.qnpn13g2[is]
print @r.xbgr.xq62_u14.rsub[i]
print @c.xbgr.xq62_u14.csub[i]
print @q.xbgr.xq62_u15.qnpn13g2[ic]
print @q.xbgr.xq62_u15.qnpn13g2[ib]
print @q.xbgr.xq62_u15.qnpn13g2[ie]
print @q.xbgr.xq62_u15.qnpn13g2[is]
print @r.xbgr.xq62_u15.rsub[i]
print @c.xbgr.xq62_u15.csub[i]
print @q.xbgr.xq62_u16.qnpn13g2[ic]
print @q.xbgr.xq62_u16.qnpn13g2[ib]
print @q.xbgr.xq62_u16.qnpn13g2[ie]
print @q.xbgr.xq62_u16.qnpn13g2[is]
print @r.xbgr.xq62_u16.rsub[i]
print @c.xbgr.xq62_u16.csub[i]
print @q.xbgr.xq62_u17.qnpn13g2[ic]
print @q.xbgr.xq62_u17.qnpn13g2[ib]
print @q.xbgr.xq62_u17.qnpn13g2[ie]
print @q.xbgr.xq62_u17.qnpn13g2[is]
print @r.xbgr.xq62_u17.rsub[i]
print @c.xbgr.xq62_u17.csub[i]
print @q.xbgr.xq62_u18.qnpn13g2[ic]
print @q.xbgr.xq62_u18.qnpn13g2[ib]
print @q.xbgr.xq62_u18.qnpn13g2[ie]
print @q.xbgr.xq62_u18.qnpn13g2[is]
print @r.xbgr.xq62_u18.rsub[i]
print @c.xbgr.xq62_u18.csub[i]
print @q.xbgr.xq62_u19.qnpn13g2[ic]
print @q.xbgr.xq62_u19.qnpn13g2[ib]
print @q.xbgr.xq62_u19.qnpn13g2[ie]
print @q.xbgr.xq62_u19.qnpn13g2[is]
print @r.xbgr.xq62_u19.rsub[i]
print @c.xbgr.xq62_u19.csub[i]
print @q.xbgr.xq62_u20.qnpn13g2[ic]
print @q.xbgr.xq62_u20.qnpn13g2[ib]
print @q.xbgr.xq62_u20.qnpn13g2[ie]
print @q.xbgr.xq62_u20.qnpn13g2[is]
print @r.xbgr.xq62_u20.rsub[i]
print @c.xbgr.xq62_u20.csub[i]
print @q.xbgr.xq62_u21.qnpn13g2[ic]
print @q.xbgr.xq62_u21.qnpn13g2[ib]
print @q.xbgr.xq62_u21.qnpn13g2[ie]
print @q.xbgr.xq62_u21.qnpn13g2[is]
print @r.xbgr.xq62_u21.rsub[i]
print @c.xbgr.xq62_u21.csub[i]
print @q.xbgr.xq62_u22.qnpn13g2[ic]
print @q.xbgr.xq62_u22.qnpn13g2[ib]
print @q.xbgr.xq62_u22.qnpn13g2[ie]
print @q.xbgr.xq62_u22.qnpn13g2[is]
print @r.xbgr.xq62_u22.rsub[i]
print @c.xbgr.xq62_u22.csub[i]
print @q.xbgr.xq62_u23.qnpn13g2[ic]
print @q.xbgr.xq62_u23.qnpn13g2[ib]
print @q.xbgr.xq62_u23.qnpn13g2[ie]
print @q.xbgr.xq62_u23.qnpn13g2[is]
print @r.xbgr.xq62_u23.rsub[i]
print @c.xbgr.xq62_u23.csub[i]
print @q.xbgr.xq62_u24.qnpn13g2[ic]
print @q.xbgr.xq62_u24.qnpn13g2[ib]
print @q.xbgr.xq62_u24.qnpn13g2[ie]
print @q.xbgr.xq62_u24.qnpn13g2[is]
print @r.xbgr.xq62_u24.rsub[i]
print @c.xbgr.xq62_u24.csub[i]
print @q.xbgr.xq67_u2.qnpn13g2[ic]
print @q.xbgr.xq67_u2.qnpn13g2[ib]
print @q.xbgr.xq67_u2.qnpn13g2[ie]
print @q.xbgr.xq67_u2.qnpn13g2[is]
print @r.xbgr.xq67_u2.rsub[i]
print @c.xbgr.xq67_u2.csub[i]
print @q.xbgr.xq67_u3.qnpn13g2[ic]
print @q.xbgr.xq67_u3.qnpn13g2[ib]
print @q.xbgr.xq67_u3.qnpn13g2[ie]
print @q.xbgr.xq67_u3.qnpn13g2[is]
print @r.xbgr.xq67_u3.rsub[i]
print @c.xbgr.xq67_u3.csub[i]
print @q.xbgr.xq67_u4.qnpn13g2[ic]
print @q.xbgr.xq67_u4.qnpn13g2[ib]
print @q.xbgr.xq67_u4.qnpn13g2[ie]
print @q.xbgr.xq67_u4.qnpn13g2[is]
print @r.xbgr.xq67_u4.rsub[i]
print @c.xbgr.xq67_u4.csub[i]
print @q.xbgr.xq67_u5.qnpn13g2[ic]
print @q.xbgr.xq67_u5.qnpn13g2[ib]
print @q.xbgr.xq67_u5.qnpn13g2[ie]
print @q.xbgr.xq67_u5.qnpn13g2[is]
print @r.xbgr.xq67_u5.rsub[i]
print @c.xbgr.xq67_u5.csub[i]
print @q.xbgr.xq67_u6.qnpn13g2[ic]
print @q.xbgr.xq67_u6.qnpn13g2[ib]
print @q.xbgr.xq67_u6.qnpn13g2[ie]
print @q.xbgr.xq67_u6.qnpn13g2[is]
print @r.xbgr.xq67_u6.rsub[i]
print @c.xbgr.xq67_u6.csub[i]
print @q.xbgr.xq67_u7.qnpn13g2[ic]
print @q.xbgr.xq67_u7.qnpn13g2[ib]
print @q.xbgr.xq67_u7.qnpn13g2[ie]
print @q.xbgr.xq67_u7.qnpn13g2[is]
print @r.xbgr.xq67_u7.rsub[i]
print @c.xbgr.xq67_u7.csub[i]
print @q.xbgr.xq67_u8.qnpn13g2[ic]
print @q.xbgr.xq67_u8.qnpn13g2[ib]
print @q.xbgr.xq67_u8.qnpn13g2[ie]
print @q.xbgr.xq67_u8.qnpn13g2[is]
print @r.xbgr.xq67_u8.rsub[i]
print @c.xbgr.xq67_u8.csub[i]
print @q.xbgr.xq67_u9.qnpn13g2[ic]
print @q.xbgr.xq67_u9.qnpn13g2[ib]
print @q.xbgr.xq67_u9.qnpn13g2[ie]
print @q.xbgr.xq67_u9.qnpn13g2[is]
print @r.xbgr.xq67_u9.rsub[i]
print @c.xbgr.xq67_u9.csub[i]
print @q.xbgr.xq67_u10.qnpn13g2[ic]
print @q.xbgr.xq67_u10.qnpn13g2[ib]
print @q.xbgr.xq67_u10.qnpn13g2[ie]
print @q.xbgr.xq67_u10.qnpn13g2[is]
print @r.xbgr.xq67_u10.rsub[i]
print @c.xbgr.xq67_u10.csub[i]
print @q.xbgr.xq67_u11.qnpn13g2[ic]
print @q.xbgr.xq67_u11.qnpn13g2[ib]
print @q.xbgr.xq67_u11.qnpn13g2[ie]
print @q.xbgr.xq67_u11.qnpn13g2[is]
print @r.xbgr.xq67_u11.rsub[i]
print @c.xbgr.xq67_u11.csub[i]
print @q.xbgr.xq67_u12.qnpn13g2[ic]
print @q.xbgr.xq67_u12.qnpn13g2[ib]
print @q.xbgr.xq67_u12.qnpn13g2[ie]
print @q.xbgr.xq67_u12.qnpn13g2[is]
print @r.xbgr.xq67_u12.rsub[i]
print @c.xbgr.xq67_u12.csub[i]
print @q.xbgr.xq67_u13.qnpn13g2[ic]
print @q.xbgr.xq67_u13.qnpn13g2[ib]
print @q.xbgr.xq67_u13.qnpn13g2[ie]
print @q.xbgr.xq67_u13.qnpn13g2[is]
print @r.xbgr.xq67_u13.rsub[i]
print @c.xbgr.xq67_u13.csub[i]
print @q.xbgr.xq67_u14.qnpn13g2[ic]
print @q.xbgr.xq67_u14.qnpn13g2[ib]
print @q.xbgr.xq67_u14.qnpn13g2[ie]
print @q.xbgr.xq67_u14.qnpn13g2[is]
print @r.xbgr.xq67_u14.rsub[i]
print @c.xbgr.xq67_u14.csub[i]
print @q.xbgr.xq67_u15.qnpn13g2[ic]
print @q.xbgr.xq67_u15.qnpn13g2[ib]
print @q.xbgr.xq67_u15.qnpn13g2[ie]
print @q.xbgr.xq67_u15.qnpn13g2[is]
print @r.xbgr.xq67_u15.rsub[i]
print @c.xbgr.xq67_u15.csub[i]
print @q.xbgr.xq67_u16.qnpn13g2[ic]
print @q.xbgr.xq67_u16.qnpn13g2[ib]
print @q.xbgr.xq67_u16.qnpn13g2[ie]
print @q.xbgr.xq67_u16.qnpn13g2[is]
print @r.xbgr.xq67_u16.rsub[i]
print @c.xbgr.xq67_u16.csub[i]
print @q.xbgr.xq67_u17.qnpn13g2[ic]
print @q.xbgr.xq67_u17.qnpn13g2[ib]
print @q.xbgr.xq67_u17.qnpn13g2[ie]
print @q.xbgr.xq67_u17.qnpn13g2[is]
print @r.xbgr.xq67_u17.rsub[i]
print @c.xbgr.xq67_u17.csub[i]
print @q.xbgr.xq67_u18.qnpn13g2[ic]
print @q.xbgr.xq67_u18.qnpn13g2[ib]
print @q.xbgr.xq67_u18.qnpn13g2[ie]
print @q.xbgr.xq67_u18.qnpn13g2[is]
print @r.xbgr.xq67_u18.rsub[i]
print @c.xbgr.xq67_u18.csub[i]
print @q.xbgr.xq67_u19.qnpn13g2[ic]
print @q.xbgr.xq67_u19.qnpn13g2[ib]
print @q.xbgr.xq67_u19.qnpn13g2[ie]
print @q.xbgr.xq67_u19.qnpn13g2[is]
print @r.xbgr.xq67_u19.rsub[i]
print @c.xbgr.xq67_u19.csub[i]
print @q.xbgr.xq67_u20.qnpn13g2[ic]
print @q.xbgr.xq67_u20.qnpn13g2[ib]
print @q.xbgr.xq67_u20.qnpn13g2[ie]
print @q.xbgr.xq67_u20.qnpn13g2[is]
print @r.xbgr.xq67_u20.rsub[i]
print @c.xbgr.xq67_u20.csub[i]
print @q.xbgr.xq67_u21.qnpn13g2[ic]
print @q.xbgr.xq67_u21.qnpn13g2[ib]
print @q.xbgr.xq67_u21.qnpn13g2[ie]
print @q.xbgr.xq67_u21.qnpn13g2[is]
print @r.xbgr.xq67_u21.rsub[i]
print @c.xbgr.xq67_u21.csub[i]
print @q.xbgr.xq67_u22.qnpn13g2[ic]
print @q.xbgr.xq67_u22.qnpn13g2[ib]
print @q.xbgr.xq67_u22.qnpn13g2[ie]
print @q.xbgr.xq67_u22.qnpn13g2[is]
print @r.xbgr.xq67_u22.rsub[i]
print @c.xbgr.xq67_u22.csub[i]
print @q.xbgr.xq67_u23.qnpn13g2[ic]
print @q.xbgr.xq67_u23.qnpn13g2[ib]
print @q.xbgr.xq67_u23.qnpn13g2[ie]
print @q.xbgr.xq67_u23.qnpn13g2[is]
print @r.xbgr.xq67_u23.rsub[i]
print @c.xbgr.xq67_u23.csub[i]
print @q.xbgr.xq67_u24.qnpn13g2[ic]
print @q.xbgr.xq67_u24.qnpn13g2[ib]
print @q.xbgr.xq67_u24.qnpn13g2[ie]
print @q.xbgr.xq67_u24.qnpn13g2[is]
print @r.xbgr.xq67_u24.rsub[i]
print @c.xbgr.xq67_u24.csub[i]
print @q.xbgr.xq68_u2.qnpn13g2[ic]
print @q.xbgr.xq68_u2.qnpn13g2[ib]
print @q.xbgr.xq68_u2.qnpn13g2[ie]
print @q.xbgr.xq68_u2.qnpn13g2[is]
print @r.xbgr.xq68_u2.rsub[i]
print @c.xbgr.xq68_u2.csub[i]
print @q.xbgr.xq68_u3.qnpn13g2[ic]
print @q.xbgr.xq68_u3.qnpn13g2[ib]
print @q.xbgr.xq68_u3.qnpn13g2[ie]
print @q.xbgr.xq68_u3.qnpn13g2[is]
print @r.xbgr.xq68_u3.rsub[i]
print @c.xbgr.xq68_u3.csub[i]
print @q.xbgr.xq68_u4.qnpn13g2[ic]
print @q.xbgr.xq68_u4.qnpn13g2[ib]
print @q.xbgr.xq68_u4.qnpn13g2[ie]
print @q.xbgr.xq68_u4.qnpn13g2[is]
print @r.xbgr.xq68_u4.rsub[i]
print @c.xbgr.xq68_u4.csub[i]
print @q.xbgr.xq68_u5.qnpn13g2[ic]
print @q.xbgr.xq68_u5.qnpn13g2[ib]
print @q.xbgr.xq68_u5.qnpn13g2[ie]
print @q.xbgr.xq68_u5.qnpn13g2[is]
print @r.xbgr.xq68_u5.rsub[i]
print @c.xbgr.xq68_u5.csub[i]
print @q.xbgr.xq68_u6.qnpn13g2[ic]
print @q.xbgr.xq68_u6.qnpn13g2[ib]
print @q.xbgr.xq68_u6.qnpn13g2[ie]
print @q.xbgr.xq68_u6.qnpn13g2[is]
print @r.xbgr.xq68_u6.rsub[i]
print @c.xbgr.xq68_u6.csub[i]
print @q.xbgr.xq68_u7.qnpn13g2[ic]
print @q.xbgr.xq68_u7.qnpn13g2[ib]
print @q.xbgr.xq68_u7.qnpn13g2[ie]
print @q.xbgr.xq68_u7.qnpn13g2[is]
print @r.xbgr.xq68_u7.rsub[i]
print @c.xbgr.xq68_u7.csub[i]
print @q.xbgr.xq68_u8.qnpn13g2[ic]
print @q.xbgr.xq68_u8.qnpn13g2[ib]
print @q.xbgr.xq68_u8.qnpn13g2[ie]
print @q.xbgr.xq68_u8.qnpn13g2[is]
print @r.xbgr.xq68_u8.rsub[i]
print @c.xbgr.xq68_u8.csub[i]
print @q.xbgr.xq68_u9.qnpn13g2[ic]
print @q.xbgr.xq68_u9.qnpn13g2[ib]
print @q.xbgr.xq68_u9.qnpn13g2[ie]
print @q.xbgr.xq68_u9.qnpn13g2[is]
print @r.xbgr.xq68_u9.rsub[i]
print @c.xbgr.xq68_u9.csub[i]
print @q.xbgr.xq68_u10.qnpn13g2[ic]
print @q.xbgr.xq68_u10.qnpn13g2[ib]
print @q.xbgr.xq68_u10.qnpn13g2[ie]
print @q.xbgr.xq68_u10.qnpn13g2[is]
print @r.xbgr.xq68_u10.rsub[i]
print @c.xbgr.xq68_u10.csub[i]
print @q.xbgr.xq68_u11.qnpn13g2[ic]
print @q.xbgr.xq68_u11.qnpn13g2[ib]
print @q.xbgr.xq68_u11.qnpn13g2[ie]
print @q.xbgr.xq68_u11.qnpn13g2[is]
print @r.xbgr.xq68_u11.rsub[i]
print @c.xbgr.xq68_u11.csub[i]
print @q.xbgr.xq68_u12.qnpn13g2[ic]
print @q.xbgr.xq68_u12.qnpn13g2[ib]
print @q.xbgr.xq68_u12.qnpn13g2[ie]
print @q.xbgr.xq68_u12.qnpn13g2[is]
print @r.xbgr.xq68_u12.rsub[i]
print @c.xbgr.xq68_u12.csub[i]
print @q.xbgr.xq68_u13.qnpn13g2[ic]
print @q.xbgr.xq68_u13.qnpn13g2[ib]
print @q.xbgr.xq68_u13.qnpn13g2[ie]
print @q.xbgr.xq68_u13.qnpn13g2[is]
print @r.xbgr.xq68_u13.rsub[i]
print @c.xbgr.xq68_u13.csub[i]
print @q.xbgr.xq68_u14.qnpn13g2[ic]
print @q.xbgr.xq68_u14.qnpn13g2[ib]
print @q.xbgr.xq68_u14.qnpn13g2[ie]
print @q.xbgr.xq68_u14.qnpn13g2[is]
print @r.xbgr.xq68_u14.rsub[i]
print @c.xbgr.xq68_u14.csub[i]
print @q.xbgr.xq68_u15.qnpn13g2[ic]
print @q.xbgr.xq68_u15.qnpn13g2[ib]
print @q.xbgr.xq68_u15.qnpn13g2[ie]
print @q.xbgr.xq68_u15.qnpn13g2[is]
print @r.xbgr.xq68_u15.rsub[i]
print @c.xbgr.xq68_u15.csub[i]
print @q.xbgr.xq68_u16.qnpn13g2[ic]
print @q.xbgr.xq68_u16.qnpn13g2[ib]
print @q.xbgr.xq68_u16.qnpn13g2[ie]
print @q.xbgr.xq68_u16.qnpn13g2[is]
print @r.xbgr.xq68_u16.rsub[i]
print @c.xbgr.xq68_u16.csub[i]
print @q.xbgr.xq68_u17.qnpn13g2[ic]
print @q.xbgr.xq68_u17.qnpn13g2[ib]
print @q.xbgr.xq68_u17.qnpn13g2[ie]
print @q.xbgr.xq68_u17.qnpn13g2[is]
print @r.xbgr.xq68_u17.rsub[i]
print @c.xbgr.xq68_u17.csub[i]
print @q.xbgr.xq68_u18.qnpn13g2[ic]
print @q.xbgr.xq68_u18.qnpn13g2[ib]
print @q.xbgr.xq68_u18.qnpn13g2[ie]
print @q.xbgr.xq68_u18.qnpn13g2[is]
print @r.xbgr.xq68_u18.rsub[i]
print @c.xbgr.xq68_u18.csub[i]
print @q.xbgr.xq68_u19.qnpn13g2[ic]
print @q.xbgr.xq68_u19.qnpn13g2[ib]
print @q.xbgr.xq68_u19.qnpn13g2[ie]
print @q.xbgr.xq68_u19.qnpn13g2[is]
print @r.xbgr.xq68_u19.rsub[i]
print @c.xbgr.xq68_u19.csub[i]
print @q.xbgr.xq68_u20.qnpn13g2[ic]
print @q.xbgr.xq68_u20.qnpn13g2[ib]
print @q.xbgr.xq68_u20.qnpn13g2[ie]
print @q.xbgr.xq68_u20.qnpn13g2[is]
print @r.xbgr.xq68_u20.rsub[i]
print @c.xbgr.xq68_u20.csub[i]
print @q.xbgr.xq68_u21.qnpn13g2[ic]
print @q.xbgr.xq68_u21.qnpn13g2[ib]
print @q.xbgr.xq68_u21.qnpn13g2[ie]
print @q.xbgr.xq68_u21.qnpn13g2[is]
print @r.xbgr.xq68_u21.rsub[i]
print @c.xbgr.xq68_u21.csub[i]
print @q.xbgr.xq68_u22.qnpn13g2[ic]
print @q.xbgr.xq68_u22.qnpn13g2[ib]
print @q.xbgr.xq68_u22.qnpn13g2[ie]
print @q.xbgr.xq68_u22.qnpn13g2[is]
print @r.xbgr.xq68_u22.rsub[i]
print @c.xbgr.xq68_u22.csub[i]
print @q.xbgr.xq68_u23.qnpn13g2[ic]
print @q.xbgr.xq68_u23.qnpn13g2[ib]
print @q.xbgr.xq68_u23.qnpn13g2[ie]
print @q.xbgr.xq68_u23.qnpn13g2[is]
print @r.xbgr.xq68_u23.rsub[i]
print @c.xbgr.xq68_u23.csub[i]
print @q.xbgr.xq68_u24.qnpn13g2[ic]
print @q.xbgr.xq68_u24.qnpn13g2[ib]
print @q.xbgr.xq68_u24.qnpn13g2[ie]
print @q.xbgr.xq68_u24.qnpn13g2[is]
print @r.xbgr.xq68_u24.rsub[i]
print @c.xbgr.xq68_u24.csub[i]
print @q.xbgr.xq69_u2.qnpn13g2[ic]
print @q.xbgr.xq69_u2.qnpn13g2[ib]
print @q.xbgr.xq69_u2.qnpn13g2[ie]
print @q.xbgr.xq69_u2.qnpn13g2[is]
print @r.xbgr.xq69_u2.rsub[i]
print @c.xbgr.xq69_u2.csub[i]
print @q.xbgr.xq69_u3.qnpn13g2[ic]
print @q.xbgr.xq69_u3.qnpn13g2[ib]
print @q.xbgr.xq69_u3.qnpn13g2[ie]
print @q.xbgr.xq69_u3.qnpn13g2[is]
print @r.xbgr.xq69_u3.rsub[i]
print @c.xbgr.xq69_u3.csub[i]
print @q.xbgr.xq69_u4.qnpn13g2[ic]
print @q.xbgr.xq69_u4.qnpn13g2[ib]
print @q.xbgr.xq69_u4.qnpn13g2[ie]
print @q.xbgr.xq69_u4.qnpn13g2[is]
print @r.xbgr.xq69_u4.rsub[i]
print @c.xbgr.xq69_u4.csub[i]
print @q.xbgr.xq69_u5.qnpn13g2[ic]
print @q.xbgr.xq69_u5.qnpn13g2[ib]
print @q.xbgr.xq69_u5.qnpn13g2[ie]
print @q.xbgr.xq69_u5.qnpn13g2[is]
print @r.xbgr.xq69_u5.rsub[i]
print @c.xbgr.xq69_u5.csub[i]
print @q.xbgr.xq69_u6.qnpn13g2[ic]
print @q.xbgr.xq69_u6.qnpn13g2[ib]
print @q.xbgr.xq69_u6.qnpn13g2[ie]
print @q.xbgr.xq69_u6.qnpn13g2[is]
print @r.xbgr.xq69_u6.rsub[i]
print @c.xbgr.xq69_u6.csub[i]
print @q.xbgr.xq69_u7.qnpn13g2[ic]
print @q.xbgr.xq69_u7.qnpn13g2[ib]
print @q.xbgr.xq69_u7.qnpn13g2[ie]
print @q.xbgr.xq69_u7.qnpn13g2[is]
print @r.xbgr.xq69_u7.rsub[i]
print @c.xbgr.xq69_u7.csub[i]
print @q.xbgr.xq69_u8.qnpn13g2[ic]
print @q.xbgr.xq69_u8.qnpn13g2[ib]
print @q.xbgr.xq69_u8.qnpn13g2[ie]
print @q.xbgr.xq69_u8.qnpn13g2[is]
print @r.xbgr.xq69_u8.rsub[i]
print @c.xbgr.xq69_u8.csub[i]
print @q.xbgr.xq69_u9.qnpn13g2[ic]
print @q.xbgr.xq69_u9.qnpn13g2[ib]
print @q.xbgr.xq69_u9.qnpn13g2[ie]
print @q.xbgr.xq69_u9.qnpn13g2[is]
print @r.xbgr.xq69_u9.rsub[i]
print @c.xbgr.xq69_u9.csub[i]
print @q.xbgr.xq69_u10.qnpn13g2[ic]
print @q.xbgr.xq69_u10.qnpn13g2[ib]
print @q.xbgr.xq69_u10.qnpn13g2[ie]
print @q.xbgr.xq69_u10.qnpn13g2[is]
print @r.xbgr.xq69_u10.rsub[i]
print @c.xbgr.xq69_u10.csub[i]
print @q.xbgr.xq69_u11.qnpn13g2[ic]
print @q.xbgr.xq69_u11.qnpn13g2[ib]
print @q.xbgr.xq69_u11.qnpn13g2[ie]
print @q.xbgr.xq69_u11.qnpn13g2[is]
print @r.xbgr.xq69_u11.rsub[i]
print @c.xbgr.xq69_u11.csub[i]
print @q.xbgr.xq69_u12.qnpn13g2[ic]
print @q.xbgr.xq69_u12.qnpn13g2[ib]
print @q.xbgr.xq69_u12.qnpn13g2[ie]
print @q.xbgr.xq69_u12.qnpn13g2[is]
print @r.xbgr.xq69_u12.rsub[i]
print @c.xbgr.xq69_u12.csub[i]
print @q.xbgr.xq69_u13.qnpn13g2[ic]
print @q.xbgr.xq69_u13.qnpn13g2[ib]
print @q.xbgr.xq69_u13.qnpn13g2[ie]
print @q.xbgr.xq69_u13.qnpn13g2[is]
print @r.xbgr.xq69_u13.rsub[i]
print @c.xbgr.xq69_u13.csub[i]
print @q.xbgr.xq69_u14.qnpn13g2[ic]
print @q.xbgr.xq69_u14.qnpn13g2[ib]
print @q.xbgr.xq69_u14.qnpn13g2[ie]
print @q.xbgr.xq69_u14.qnpn13g2[is]
print @r.xbgr.xq69_u14.rsub[i]
print @c.xbgr.xq69_u14.csub[i]
print @q.xbgr.xq69_u15.qnpn13g2[ic]
print @q.xbgr.xq69_u15.qnpn13g2[ib]
print @q.xbgr.xq69_u15.qnpn13g2[ie]
print @q.xbgr.xq69_u15.qnpn13g2[is]
print @r.xbgr.xq69_u15.rsub[i]
print @c.xbgr.xq69_u15.csub[i]
print @q.xbgr.xq69_u16.qnpn13g2[ic]
print @q.xbgr.xq69_u16.qnpn13g2[ib]
print @q.xbgr.xq69_u16.qnpn13g2[ie]
print @q.xbgr.xq69_u16.qnpn13g2[is]
print @r.xbgr.xq69_u16.rsub[i]
print @c.xbgr.xq69_u16.csub[i]
print @q.xbgr.xq69_u17.qnpn13g2[ic]
print @q.xbgr.xq69_u17.qnpn13g2[ib]
print @q.xbgr.xq69_u17.qnpn13g2[ie]
print @q.xbgr.xq69_u17.qnpn13g2[is]
print @r.xbgr.xq69_u17.rsub[i]
print @c.xbgr.xq69_u17.csub[i]
print @q.xbgr.xq69_u18.qnpn13g2[ic]
print @q.xbgr.xq69_u18.qnpn13g2[ib]
print @q.xbgr.xq69_u18.qnpn13g2[ie]
print @q.xbgr.xq69_u18.qnpn13g2[is]
print @r.xbgr.xq69_u18.rsub[i]
print @c.xbgr.xq69_u18.csub[i]
print @q.xbgr.xq69_u19.qnpn13g2[ic]
print @q.xbgr.xq69_u19.qnpn13g2[ib]
print @q.xbgr.xq69_u19.qnpn13g2[ie]
print @q.xbgr.xq69_u19.qnpn13g2[is]
print @r.xbgr.xq69_u19.rsub[i]
print @c.xbgr.xq69_u19.csub[i]
print @q.xbgr.xq69_u20.qnpn13g2[ic]
print @q.xbgr.xq69_u20.qnpn13g2[ib]
print @q.xbgr.xq69_u20.qnpn13g2[ie]
print @q.xbgr.xq69_u20.qnpn13g2[is]
print @r.xbgr.xq69_u20.rsub[i]
print @c.xbgr.xq69_u20.csub[i]
print @q.xbgr.xq69_u21.qnpn13g2[ic]
print @q.xbgr.xq69_u21.qnpn13g2[ib]
print @q.xbgr.xq69_u21.qnpn13g2[ie]
print @q.xbgr.xq69_u21.qnpn13g2[is]
print @r.xbgr.xq69_u21.rsub[i]
print @c.xbgr.xq69_u21.csub[i]
print @q.xbgr.xq69_u22.qnpn13g2[ic]
print @q.xbgr.xq69_u22.qnpn13g2[ib]
print @q.xbgr.xq69_u22.qnpn13g2[ie]
print @q.xbgr.xq69_u22.qnpn13g2[is]
print @r.xbgr.xq69_u22.rsub[i]
print @c.xbgr.xq69_u22.csub[i]
print @q.xbgr.xq69_u23.qnpn13g2[ic]
print @q.xbgr.xq69_u23.qnpn13g2[ib]
print @q.xbgr.xq69_u23.qnpn13g2[ie]
print @q.xbgr.xq69_u23.qnpn13g2[is]
print @r.xbgr.xq69_u23.rsub[i]
print @c.xbgr.xq69_u23.csub[i]
print @q.xbgr.xq69_u24.qnpn13g2[ic]
print @q.xbgr.xq69_u24.qnpn13g2[ib]
print @q.xbgr.xq69_u24.qnpn13g2[ie]
print @q.xbgr.xq69_u24.qnpn13g2[is]
print @r.xbgr.xq69_u24.rsub[i]
print @c.xbgr.xq69_u24.csub[i]
print @q.xbgr.xq70_u2.qnpn13g2[ic]
print @q.xbgr.xq70_u2.qnpn13g2[ib]
print @q.xbgr.xq70_u2.qnpn13g2[ie]
print @q.xbgr.xq70_u2.qnpn13g2[is]
print @r.xbgr.xq70_u2.rsub[i]
print @c.xbgr.xq70_u2.csub[i]
print @q.xbgr.xq70_u3.qnpn13g2[ic]
print @q.xbgr.xq70_u3.qnpn13g2[ib]
print @q.xbgr.xq70_u3.qnpn13g2[ie]
print @q.xbgr.xq70_u3.qnpn13g2[is]
print @r.xbgr.xq70_u3.rsub[i]
print @c.xbgr.xq70_u3.csub[i]
print @q.xbgr.xq70_u4.qnpn13g2[ic]
print @q.xbgr.xq70_u4.qnpn13g2[ib]
print @q.xbgr.xq70_u4.qnpn13g2[ie]
print @q.xbgr.xq70_u4.qnpn13g2[is]
print @r.xbgr.xq70_u4.rsub[i]
print @c.xbgr.xq70_u4.csub[i]
print @q.xbgr.xq70_u5.qnpn13g2[ic]
print @q.xbgr.xq70_u5.qnpn13g2[ib]
print @q.xbgr.xq70_u5.qnpn13g2[ie]
print @q.xbgr.xq70_u5.qnpn13g2[is]
print @r.xbgr.xq70_u5.rsub[i]
print @c.xbgr.xq70_u5.csub[i]
print @q.xbgr.xq70_u6.qnpn13g2[ic]
print @q.xbgr.xq70_u6.qnpn13g2[ib]
print @q.xbgr.xq70_u6.qnpn13g2[ie]
print @q.xbgr.xq70_u6.qnpn13g2[is]
print @r.xbgr.xq70_u6.rsub[i]
print @c.xbgr.xq70_u6.csub[i]
print @q.xbgr.xq70_u7.qnpn13g2[ic]
print @q.xbgr.xq70_u7.qnpn13g2[ib]
print @q.xbgr.xq70_u7.qnpn13g2[ie]
print @q.xbgr.xq70_u7.qnpn13g2[is]
print @r.xbgr.xq70_u7.rsub[i]
print @c.xbgr.xq70_u7.csub[i]
print @q.xbgr.xq70_u8.qnpn13g2[ic]
print @q.xbgr.xq70_u8.qnpn13g2[ib]
print @q.xbgr.xq70_u8.qnpn13g2[ie]
print @q.xbgr.xq70_u8.qnpn13g2[is]
print @r.xbgr.xq70_u8.rsub[i]
print @c.xbgr.xq70_u8.csub[i]
print @q.xbgr.xq70_u9.qnpn13g2[ic]
print @q.xbgr.xq70_u9.qnpn13g2[ib]
print @q.xbgr.xq70_u9.qnpn13g2[ie]
print @q.xbgr.xq70_u9.qnpn13g2[is]
print @r.xbgr.xq70_u9.rsub[i]
print @c.xbgr.xq70_u9.csub[i]
print @q.xbgr.xq70_u10.qnpn13g2[ic]
print @q.xbgr.xq70_u10.qnpn13g2[ib]
print @q.xbgr.xq70_u10.qnpn13g2[ie]
print @q.xbgr.xq70_u10.qnpn13g2[is]
print @r.xbgr.xq70_u10.rsub[i]
print @c.xbgr.xq70_u10.csub[i]
print @q.xbgr.xq70_u11.qnpn13g2[ic]
print @q.xbgr.xq70_u11.qnpn13g2[ib]
print @q.xbgr.xq70_u11.qnpn13g2[ie]
print @q.xbgr.xq70_u11.qnpn13g2[is]
print @r.xbgr.xq70_u11.rsub[i]
print @c.xbgr.xq70_u11.csub[i]
print @q.xbgr.xq70_u12.qnpn13g2[ic]
print @q.xbgr.xq70_u12.qnpn13g2[ib]
print @q.xbgr.xq70_u12.qnpn13g2[ie]
print @q.xbgr.xq70_u12.qnpn13g2[is]
print @r.xbgr.xq70_u12.rsub[i]
print @c.xbgr.xq70_u12.csub[i]
print @q.xbgr.xq70_u13.qnpn13g2[ic]
print @q.xbgr.xq70_u13.qnpn13g2[ib]
print @q.xbgr.xq70_u13.qnpn13g2[ie]
print @q.xbgr.xq70_u13.qnpn13g2[is]
print @r.xbgr.xq70_u13.rsub[i]
print @c.xbgr.xq70_u13.csub[i]
print @q.xbgr.xq70_u14.qnpn13g2[ic]
print @q.xbgr.xq70_u14.qnpn13g2[ib]
print @q.xbgr.xq70_u14.qnpn13g2[ie]
print @q.xbgr.xq70_u14.qnpn13g2[is]
print @r.xbgr.xq70_u14.rsub[i]
print @c.xbgr.xq70_u14.csub[i]
print @q.xbgr.xq70_u15.qnpn13g2[ic]
print @q.xbgr.xq70_u15.qnpn13g2[ib]
print @q.xbgr.xq70_u15.qnpn13g2[ie]
print @q.xbgr.xq70_u15.qnpn13g2[is]
print @r.xbgr.xq70_u15.rsub[i]
print @c.xbgr.xq70_u15.csub[i]
print @q.xbgr.xq70_u16.qnpn13g2[ic]
print @q.xbgr.xq70_u16.qnpn13g2[ib]
print @q.xbgr.xq70_u16.qnpn13g2[ie]
print @q.xbgr.xq70_u16.qnpn13g2[is]
print @r.xbgr.xq70_u16.rsub[i]
print @c.xbgr.xq70_u16.csub[i]
print @q.xbgr.xq70_u17.qnpn13g2[ic]
print @q.xbgr.xq70_u17.qnpn13g2[ib]
print @q.xbgr.xq70_u17.qnpn13g2[ie]
print @q.xbgr.xq70_u17.qnpn13g2[is]
print @r.xbgr.xq70_u17.rsub[i]
print @c.xbgr.xq70_u17.csub[i]
print @q.xbgr.xq70_u18.qnpn13g2[ic]
print @q.xbgr.xq70_u18.qnpn13g2[ib]
print @q.xbgr.xq70_u18.qnpn13g2[ie]
print @q.xbgr.xq70_u18.qnpn13g2[is]
print @r.xbgr.xq70_u18.rsub[i]
print @c.xbgr.xq70_u18.csub[i]
print @q.xbgr.xq70_u19.qnpn13g2[ic]
print @q.xbgr.xq70_u19.qnpn13g2[ib]
print @q.xbgr.xq70_u19.qnpn13g2[ie]
print @q.xbgr.xq70_u19.qnpn13g2[is]
print @r.xbgr.xq70_u19.rsub[i]
print @c.xbgr.xq70_u19.csub[i]
print @q.xbgr.xq70_u20.qnpn13g2[ic]
print @q.xbgr.xq70_u20.qnpn13g2[ib]
print @q.xbgr.xq70_u20.qnpn13g2[ie]
print @q.xbgr.xq70_u20.qnpn13g2[is]
print @r.xbgr.xq70_u20.rsub[i]
print @c.xbgr.xq70_u20.csub[i]
print @q.xbgr.xq70_u21.qnpn13g2[ic]
print @q.xbgr.xq70_u21.qnpn13g2[ib]
print @q.xbgr.xq70_u21.qnpn13g2[ie]
print @q.xbgr.xq70_u21.qnpn13g2[is]
print @r.xbgr.xq70_u21.rsub[i]
print @c.xbgr.xq70_u21.csub[i]
print @q.xbgr.xq70_u22.qnpn13g2[ic]
print @q.xbgr.xq70_u22.qnpn13g2[ib]
print @q.xbgr.xq70_u22.qnpn13g2[ie]
print @q.xbgr.xq70_u22.qnpn13g2[is]
print @r.xbgr.xq70_u22.rsub[i]
print @c.xbgr.xq70_u22.csub[i]
print @q.xbgr.xq70_u23.qnpn13g2[ic]
print @q.xbgr.xq70_u23.qnpn13g2[ib]
print @q.xbgr.xq70_u23.qnpn13g2[ie]
print @q.xbgr.xq70_u23.qnpn13g2[is]
print @r.xbgr.xq70_u23.rsub[i]
print @c.xbgr.xq70_u23.csub[i]
print @q.xbgr.xq70_u24.qnpn13g2[ic]
print @q.xbgr.xq70_u24.qnpn13g2[ib]
print @q.xbgr.xq70_u24.qnpn13g2[ie]
print @q.xbgr.xq70_u24.qnpn13g2[is]
print @r.xbgr.xq70_u24.rsub[i]
print @c.xbgr.xq70_u24.csub[i]
print @q.xbgr.xq71_u2.qnpn13g2[ic]
print @q.xbgr.xq71_u2.qnpn13g2[ib]
print @q.xbgr.xq71_u2.qnpn13g2[ie]
print @q.xbgr.xq71_u2.qnpn13g2[is]
print @r.xbgr.xq71_u2.rsub[i]
print @c.xbgr.xq71_u2.csub[i]
print @q.xbgr.xq71_u3.qnpn13g2[ic]
print @q.xbgr.xq71_u3.qnpn13g2[ib]
print @q.xbgr.xq71_u3.qnpn13g2[ie]
print @q.xbgr.xq71_u3.qnpn13g2[is]
print @r.xbgr.xq71_u3.rsub[i]
print @c.xbgr.xq71_u3.csub[i]
print @q.xbgr.xq71_u4.qnpn13g2[ic]
print @q.xbgr.xq71_u4.qnpn13g2[ib]
print @q.xbgr.xq71_u4.qnpn13g2[ie]
print @q.xbgr.xq71_u4.qnpn13g2[is]
print @r.xbgr.xq71_u4.rsub[i]
print @c.xbgr.xq71_u4.csub[i]
print @q.xbgr.xq71_u5.qnpn13g2[ic]
print @q.xbgr.xq71_u5.qnpn13g2[ib]
print @q.xbgr.xq71_u5.qnpn13g2[ie]
print @q.xbgr.xq71_u5.qnpn13g2[is]
print @r.xbgr.xq71_u5.rsub[i]
print @c.xbgr.xq71_u5.csub[i]
print @q.xbgr.xq71_u6.qnpn13g2[ic]
print @q.xbgr.xq71_u6.qnpn13g2[ib]
print @q.xbgr.xq71_u6.qnpn13g2[ie]
print @q.xbgr.xq71_u6.qnpn13g2[is]
print @r.xbgr.xq71_u6.rsub[i]
print @c.xbgr.xq71_u6.csub[i]
print @q.xbgr.xq71_u7.qnpn13g2[ic]
print @q.xbgr.xq71_u7.qnpn13g2[ib]
print @q.xbgr.xq71_u7.qnpn13g2[ie]
print @q.xbgr.xq71_u7.qnpn13g2[is]
print @r.xbgr.xq71_u7.rsub[i]
print @c.xbgr.xq71_u7.csub[i]
print @q.xbgr.xq71_u8.qnpn13g2[ic]
print @q.xbgr.xq71_u8.qnpn13g2[ib]
print @q.xbgr.xq71_u8.qnpn13g2[ie]
print @q.xbgr.xq71_u8.qnpn13g2[is]
print @r.xbgr.xq71_u8.rsub[i]
print @c.xbgr.xq71_u8.csub[i]
print @q.xbgr.xq71_u9.qnpn13g2[ic]
print @q.xbgr.xq71_u9.qnpn13g2[ib]
print @q.xbgr.xq71_u9.qnpn13g2[ie]
print @q.xbgr.xq71_u9.qnpn13g2[is]
print @r.xbgr.xq71_u9.rsub[i]
print @c.xbgr.xq71_u9.csub[i]
print @q.xbgr.xq71_u10.qnpn13g2[ic]
print @q.xbgr.xq71_u10.qnpn13g2[ib]
print @q.xbgr.xq71_u10.qnpn13g2[ie]
print @q.xbgr.xq71_u10.qnpn13g2[is]
print @r.xbgr.xq71_u10.rsub[i]
print @c.xbgr.xq71_u10.csub[i]
print @q.xbgr.xq71_u11.qnpn13g2[ic]
print @q.xbgr.xq71_u11.qnpn13g2[ib]
print @q.xbgr.xq71_u11.qnpn13g2[ie]
print @q.xbgr.xq71_u11.qnpn13g2[is]
print @r.xbgr.xq71_u11.rsub[i]
print @c.xbgr.xq71_u11.csub[i]
print @q.xbgr.xq71_u12.qnpn13g2[ic]
print @q.xbgr.xq71_u12.qnpn13g2[ib]
print @q.xbgr.xq71_u12.qnpn13g2[ie]
print @q.xbgr.xq71_u12.qnpn13g2[is]
print @r.xbgr.xq71_u12.rsub[i]
print @c.xbgr.xq71_u12.csub[i]
print @q.xbgr.xq71_u13.qnpn13g2[ic]
print @q.xbgr.xq71_u13.qnpn13g2[ib]
print @q.xbgr.xq71_u13.qnpn13g2[ie]
print @q.xbgr.xq71_u13.qnpn13g2[is]
print @r.xbgr.xq71_u13.rsub[i]
print @c.xbgr.xq71_u13.csub[i]
print @q.xbgr.xq71_u14.qnpn13g2[ic]
print @q.xbgr.xq71_u14.qnpn13g2[ib]
print @q.xbgr.xq71_u14.qnpn13g2[ie]
print @q.xbgr.xq71_u14.qnpn13g2[is]
print @r.xbgr.xq71_u14.rsub[i]
print @c.xbgr.xq71_u14.csub[i]
print @q.xbgr.xq71_u15.qnpn13g2[ic]
print @q.xbgr.xq71_u15.qnpn13g2[ib]
print @q.xbgr.xq71_u15.qnpn13g2[ie]
print @q.xbgr.xq71_u15.qnpn13g2[is]
print @r.xbgr.xq71_u15.rsub[i]
print @c.xbgr.xq71_u15.csub[i]
print @q.xbgr.xq71_u16.qnpn13g2[ic]
print @q.xbgr.xq71_u16.qnpn13g2[ib]
print @q.xbgr.xq71_u16.qnpn13g2[ie]
print @q.xbgr.xq71_u16.qnpn13g2[is]
print @r.xbgr.xq71_u16.rsub[i]
print @c.xbgr.xq71_u16.csub[i]
print @q.xbgr.xq71_u17.qnpn13g2[ic]
print @q.xbgr.xq71_u17.qnpn13g2[ib]
print @q.xbgr.xq71_u17.qnpn13g2[ie]
print @q.xbgr.xq71_u17.qnpn13g2[is]
print @r.xbgr.xq71_u17.rsub[i]
print @c.xbgr.xq71_u17.csub[i]
print @q.xbgr.xq71_u18.qnpn13g2[ic]
print @q.xbgr.xq71_u18.qnpn13g2[ib]
print @q.xbgr.xq71_u18.qnpn13g2[ie]
print @q.xbgr.xq71_u18.qnpn13g2[is]
print @r.xbgr.xq71_u18.rsub[i]
print @c.xbgr.xq71_u18.csub[i]
print @q.xbgr.xq71_u19.qnpn13g2[ic]
print @q.xbgr.xq71_u19.qnpn13g2[ib]
print @q.xbgr.xq71_u19.qnpn13g2[ie]
print @q.xbgr.xq71_u19.qnpn13g2[is]
print @r.xbgr.xq71_u19.rsub[i]
print @c.xbgr.xq71_u19.csub[i]
print @q.xbgr.xq71_u20.qnpn13g2[ic]
print @q.xbgr.xq71_u20.qnpn13g2[ib]
print @q.xbgr.xq71_u20.qnpn13g2[ie]
print @q.xbgr.xq71_u20.qnpn13g2[is]
print @r.xbgr.xq71_u20.rsub[i]
print @c.xbgr.xq71_u20.csub[i]
print @q.xbgr.xq71_u21.qnpn13g2[ic]
print @q.xbgr.xq71_u21.qnpn13g2[ib]
print @q.xbgr.xq71_u21.qnpn13g2[ie]
print @q.xbgr.xq71_u21.qnpn13g2[is]
print @r.xbgr.xq71_u21.rsub[i]
print @c.xbgr.xq71_u21.csub[i]
print @q.xbgr.xq71_u22.qnpn13g2[ic]
print @q.xbgr.xq71_u22.qnpn13g2[ib]
print @q.xbgr.xq71_u22.qnpn13g2[ie]
print @q.xbgr.xq71_u22.qnpn13g2[is]
print @r.xbgr.xq71_u22.rsub[i]
print @c.xbgr.xq71_u22.csub[i]
print @q.xbgr.xq71_u23.qnpn13g2[ic]
print @q.xbgr.xq71_u23.qnpn13g2[ib]
print @q.xbgr.xq71_u23.qnpn13g2[ie]
print @q.xbgr.xq71_u23.qnpn13g2[is]
print @r.xbgr.xq71_u23.rsub[i]
print @c.xbgr.xq71_u23.csub[i]
print @q.xbgr.xq71_u24.qnpn13g2[ic]
print @q.xbgr.xq71_u24.qnpn13g2[ib]
print @q.xbgr.xq71_u24.qnpn13g2[ie]
print @q.xbgr.xq71_u24.qnpn13g2[is]
print @r.xbgr.xq71_u24.rsub[i]
print @c.xbgr.xq71_u24.csub[i]
print @q.xbgr.xq72_u2.qnpn13g2[ic]
print @q.xbgr.xq72_u2.qnpn13g2[ib]
print @q.xbgr.xq72_u2.qnpn13g2[ie]
print @q.xbgr.xq72_u2.qnpn13g2[is]
print @r.xbgr.xq72_u2.rsub[i]
print @c.xbgr.xq72_u2.csub[i]
print @q.xbgr.xq72_u3.qnpn13g2[ic]
print @q.xbgr.xq72_u3.qnpn13g2[ib]
print @q.xbgr.xq72_u3.qnpn13g2[ie]
print @q.xbgr.xq72_u3.qnpn13g2[is]
print @r.xbgr.xq72_u3.rsub[i]
print @c.xbgr.xq72_u3.csub[i]
print @q.xbgr.xq72_u4.qnpn13g2[ic]
print @q.xbgr.xq72_u4.qnpn13g2[ib]
print @q.xbgr.xq72_u4.qnpn13g2[ie]
print @q.xbgr.xq72_u4.qnpn13g2[is]
print @r.xbgr.xq72_u4.rsub[i]
print @c.xbgr.xq72_u4.csub[i]
print @q.xbgr.xq72_u5.qnpn13g2[ic]
print @q.xbgr.xq72_u5.qnpn13g2[ib]
print @q.xbgr.xq72_u5.qnpn13g2[ie]
print @q.xbgr.xq72_u5.qnpn13g2[is]
print @r.xbgr.xq72_u5.rsub[i]
print @c.xbgr.xq72_u5.csub[i]
print @q.xbgr.xq72_u6.qnpn13g2[ic]
print @q.xbgr.xq72_u6.qnpn13g2[ib]
print @q.xbgr.xq72_u6.qnpn13g2[ie]
print @q.xbgr.xq72_u6.qnpn13g2[is]
print @r.xbgr.xq72_u6.rsub[i]
print @c.xbgr.xq72_u6.csub[i]
print @q.xbgr.xq72_u7.qnpn13g2[ic]
print @q.xbgr.xq72_u7.qnpn13g2[ib]
print @q.xbgr.xq72_u7.qnpn13g2[ie]
print @q.xbgr.xq72_u7.qnpn13g2[is]
print @r.xbgr.xq72_u7.rsub[i]
print @c.xbgr.xq72_u7.csub[i]
print @q.xbgr.xq72_u8.qnpn13g2[ic]
print @q.xbgr.xq72_u8.qnpn13g2[ib]
print @q.xbgr.xq72_u8.qnpn13g2[ie]
print @q.xbgr.xq72_u8.qnpn13g2[is]
print @r.xbgr.xq72_u8.rsub[i]
print @c.xbgr.xq72_u8.csub[i]
print @q.xbgr.xq72_u9.qnpn13g2[ic]
print @q.xbgr.xq72_u9.qnpn13g2[ib]
print @q.xbgr.xq72_u9.qnpn13g2[ie]
print @q.xbgr.xq72_u9.qnpn13g2[is]
print @r.xbgr.xq72_u9.rsub[i]
print @c.xbgr.xq72_u9.csub[i]
print @q.xbgr.xq72_u10.qnpn13g2[ic]
print @q.xbgr.xq72_u10.qnpn13g2[ib]
print @q.xbgr.xq72_u10.qnpn13g2[ie]
print @q.xbgr.xq72_u10.qnpn13g2[is]
print @r.xbgr.xq72_u10.rsub[i]
print @c.xbgr.xq72_u10.csub[i]
print @q.xbgr.xq72_u11.qnpn13g2[ic]
print @q.xbgr.xq72_u11.qnpn13g2[ib]
print @q.xbgr.xq72_u11.qnpn13g2[ie]
print @q.xbgr.xq72_u11.qnpn13g2[is]
print @r.xbgr.xq72_u11.rsub[i]
print @c.xbgr.xq72_u11.csub[i]
print @q.xbgr.xq72_u12.qnpn13g2[ic]
print @q.xbgr.xq72_u12.qnpn13g2[ib]
print @q.xbgr.xq72_u12.qnpn13g2[ie]
print @q.xbgr.xq72_u12.qnpn13g2[is]
print @r.xbgr.xq72_u12.rsub[i]
print @c.xbgr.xq72_u12.csub[i]
print @q.xbgr.xq72_u13.qnpn13g2[ic]
print @q.xbgr.xq72_u13.qnpn13g2[ib]
print @q.xbgr.xq72_u13.qnpn13g2[ie]
print @q.xbgr.xq72_u13.qnpn13g2[is]
print @r.xbgr.xq72_u13.rsub[i]
print @c.xbgr.xq72_u13.csub[i]
print @q.xbgr.xq72_u14.qnpn13g2[ic]
print @q.xbgr.xq72_u14.qnpn13g2[ib]
print @q.xbgr.xq72_u14.qnpn13g2[ie]
print @q.xbgr.xq72_u14.qnpn13g2[is]
print @r.xbgr.xq72_u14.rsub[i]
print @c.xbgr.xq72_u14.csub[i]
print @q.xbgr.xq72_u15.qnpn13g2[ic]
print @q.xbgr.xq72_u15.qnpn13g2[ib]
print @q.xbgr.xq72_u15.qnpn13g2[ie]
print @q.xbgr.xq72_u15.qnpn13g2[is]
print @r.xbgr.xq72_u15.rsub[i]
print @c.xbgr.xq72_u15.csub[i]
print @q.xbgr.xq72_u16.qnpn13g2[ic]
print @q.xbgr.xq72_u16.qnpn13g2[ib]
print @q.xbgr.xq72_u16.qnpn13g2[ie]
print @q.xbgr.xq72_u16.qnpn13g2[is]
print @r.xbgr.xq72_u16.rsub[i]
print @c.xbgr.xq72_u16.csub[i]
print @q.xbgr.xq72_u17.qnpn13g2[ic]
print @q.xbgr.xq72_u17.qnpn13g2[ib]
print @q.xbgr.xq72_u17.qnpn13g2[ie]
print @q.xbgr.xq72_u17.qnpn13g2[is]
print @r.xbgr.xq72_u17.rsub[i]
print @c.xbgr.xq72_u17.csub[i]
print @q.xbgr.xq72_u18.qnpn13g2[ic]
print @q.xbgr.xq72_u18.qnpn13g2[ib]
print @q.xbgr.xq72_u18.qnpn13g2[ie]
print @q.xbgr.xq72_u18.qnpn13g2[is]
print @r.xbgr.xq72_u18.rsub[i]
print @c.xbgr.xq72_u18.csub[i]
print @q.xbgr.xq72_u19.qnpn13g2[ic]
print @q.xbgr.xq72_u19.qnpn13g2[ib]
print @q.xbgr.xq72_u19.qnpn13g2[ie]
print @q.xbgr.xq72_u19.qnpn13g2[is]
print @r.xbgr.xq72_u19.rsub[i]
print @c.xbgr.xq72_u19.csub[i]
print @q.xbgr.xq72_u20.qnpn13g2[ic]
print @q.xbgr.xq72_u20.qnpn13g2[ib]
print @q.xbgr.xq72_u20.qnpn13g2[ie]
print @q.xbgr.xq72_u20.qnpn13g2[is]
print @r.xbgr.xq72_u20.rsub[i]
print @c.xbgr.xq72_u20.csub[i]
print @q.xbgr.xq72_u21.qnpn13g2[ic]
print @q.xbgr.xq72_u21.qnpn13g2[ib]
print @q.xbgr.xq72_u21.qnpn13g2[ie]
print @q.xbgr.xq72_u21.qnpn13g2[is]
print @r.xbgr.xq72_u21.rsub[i]
print @c.xbgr.xq72_u21.csub[i]
print @q.xbgr.xq72_u22.qnpn13g2[ic]
print @q.xbgr.xq72_u22.qnpn13g2[ib]
print @q.xbgr.xq72_u22.qnpn13g2[ie]
print @q.xbgr.xq72_u22.qnpn13g2[is]
print @r.xbgr.xq72_u22.rsub[i]
print @c.xbgr.xq72_u22.csub[i]
print @q.xbgr.xq72_u23.qnpn13g2[ic]
print @q.xbgr.xq72_u23.qnpn13g2[ib]
print @q.xbgr.xq72_u23.qnpn13g2[ie]
print @q.xbgr.xq72_u23.qnpn13g2[is]
print @r.xbgr.xq72_u23.rsub[i]
print @c.xbgr.xq72_u23.csub[i]
print @q.xbgr.xq72_u24.qnpn13g2[ic]
print @q.xbgr.xq72_u24.qnpn13g2[ib]
print @q.xbgr.xq72_u24.qnpn13g2[ie]
print @q.xbgr.xq72_u24.qnpn13g2[is]
print @r.xbgr.xq72_u24.rsub[i]
print @c.xbgr.xq72_u24.csub[i]
print @q.xbgr.xq73_u2.qnpn13g2[ic]
print @q.xbgr.xq73_u2.qnpn13g2[ib]
print @q.xbgr.xq73_u2.qnpn13g2[ie]
print @q.xbgr.xq73_u2.qnpn13g2[is]
print @r.xbgr.xq73_u2.rsub[i]
print @c.xbgr.xq73_u2.csub[i]
print @q.xbgr.xq73_u3.qnpn13g2[ic]
print @q.xbgr.xq73_u3.qnpn13g2[ib]
print @q.xbgr.xq73_u3.qnpn13g2[ie]
print @q.xbgr.xq73_u3.qnpn13g2[is]
print @r.xbgr.xq73_u3.rsub[i]
print @c.xbgr.xq73_u3.csub[i]
print @q.xbgr.xq73_u4.qnpn13g2[ic]
print @q.xbgr.xq73_u4.qnpn13g2[ib]
print @q.xbgr.xq73_u4.qnpn13g2[ie]
print @q.xbgr.xq73_u4.qnpn13g2[is]
print @r.xbgr.xq73_u4.rsub[i]
print @c.xbgr.xq73_u4.csub[i]
print @q.xbgr.xq73_u5.qnpn13g2[ic]
print @q.xbgr.xq73_u5.qnpn13g2[ib]
print @q.xbgr.xq73_u5.qnpn13g2[ie]
print @q.xbgr.xq73_u5.qnpn13g2[is]
print @r.xbgr.xq73_u5.rsub[i]
print @c.xbgr.xq73_u5.csub[i]
print @q.xbgr.xq73_u6.qnpn13g2[ic]
print @q.xbgr.xq73_u6.qnpn13g2[ib]
print @q.xbgr.xq73_u6.qnpn13g2[ie]
print @q.xbgr.xq73_u6.qnpn13g2[is]
print @r.xbgr.xq73_u6.rsub[i]
print @c.xbgr.xq73_u6.csub[i]
print @q.xbgr.xq73_u7.qnpn13g2[ic]
print @q.xbgr.xq73_u7.qnpn13g2[ib]
print @q.xbgr.xq73_u7.qnpn13g2[ie]
print @q.xbgr.xq73_u7.qnpn13g2[is]
print @r.xbgr.xq73_u7.rsub[i]
print @c.xbgr.xq73_u7.csub[i]
print @q.xbgr.xq73_u8.qnpn13g2[ic]
print @q.xbgr.xq73_u8.qnpn13g2[ib]
print @q.xbgr.xq73_u8.qnpn13g2[ie]
print @q.xbgr.xq73_u8.qnpn13g2[is]
print @r.xbgr.xq73_u8.rsub[i]
print @c.xbgr.xq73_u8.csub[i]
print @q.xbgr.xq73_u9.qnpn13g2[ic]
print @q.xbgr.xq73_u9.qnpn13g2[ib]
print @q.xbgr.xq73_u9.qnpn13g2[ie]
print @q.xbgr.xq73_u9.qnpn13g2[is]
print @r.xbgr.xq73_u9.rsub[i]
print @c.xbgr.xq73_u9.csub[i]
print @q.xbgr.xq73_u10.qnpn13g2[ic]
print @q.xbgr.xq73_u10.qnpn13g2[ib]
print @q.xbgr.xq73_u10.qnpn13g2[ie]
print @q.xbgr.xq73_u10.qnpn13g2[is]
print @r.xbgr.xq73_u10.rsub[i]
print @c.xbgr.xq73_u10.csub[i]
print @q.xbgr.xq73_u11.qnpn13g2[ic]
print @q.xbgr.xq73_u11.qnpn13g2[ib]
print @q.xbgr.xq73_u11.qnpn13g2[ie]
print @q.xbgr.xq73_u11.qnpn13g2[is]
print @r.xbgr.xq73_u11.rsub[i]
print @c.xbgr.xq73_u11.csub[i]
print @q.xbgr.xq73_u12.qnpn13g2[ic]
print @q.xbgr.xq73_u12.qnpn13g2[ib]
print @q.xbgr.xq73_u12.qnpn13g2[ie]
print @q.xbgr.xq73_u12.qnpn13g2[is]
print @r.xbgr.xq73_u12.rsub[i]
print @c.xbgr.xq73_u12.csub[i]
print @q.xbgr.xq73_u13.qnpn13g2[ic]
print @q.xbgr.xq73_u13.qnpn13g2[ib]
print @q.xbgr.xq73_u13.qnpn13g2[ie]
print @q.xbgr.xq73_u13.qnpn13g2[is]
print @r.xbgr.xq73_u13.rsub[i]
print @c.xbgr.xq73_u13.csub[i]
print @q.xbgr.xq73_u14.qnpn13g2[ic]
print @q.xbgr.xq73_u14.qnpn13g2[ib]
print @q.xbgr.xq73_u14.qnpn13g2[ie]
print @q.xbgr.xq73_u14.qnpn13g2[is]
print @r.xbgr.xq73_u14.rsub[i]
print @c.xbgr.xq73_u14.csub[i]
print @q.xbgr.xq73_u15.qnpn13g2[ic]
print @q.xbgr.xq73_u15.qnpn13g2[ib]
print @q.xbgr.xq73_u15.qnpn13g2[ie]
print @q.xbgr.xq73_u15.qnpn13g2[is]
print @r.xbgr.xq73_u15.rsub[i]
print @c.xbgr.xq73_u15.csub[i]
print @q.xbgr.xq73_u16.qnpn13g2[ic]
print @q.xbgr.xq73_u16.qnpn13g2[ib]
print @q.xbgr.xq73_u16.qnpn13g2[ie]
print @q.xbgr.xq73_u16.qnpn13g2[is]
print @r.xbgr.xq73_u16.rsub[i]
print @c.xbgr.xq73_u16.csub[i]
print @q.xbgr.xq73_u17.qnpn13g2[ic]
print @q.xbgr.xq73_u17.qnpn13g2[ib]
print @q.xbgr.xq73_u17.qnpn13g2[ie]
print @q.xbgr.xq73_u17.qnpn13g2[is]
print @r.xbgr.xq73_u17.rsub[i]
print @c.xbgr.xq73_u17.csub[i]
print @q.xbgr.xq73_u18.qnpn13g2[ic]
print @q.xbgr.xq73_u18.qnpn13g2[ib]
print @q.xbgr.xq73_u18.qnpn13g2[ie]
print @q.xbgr.xq73_u18.qnpn13g2[is]
print @r.xbgr.xq73_u18.rsub[i]
print @c.xbgr.xq73_u18.csub[i]
print @q.xbgr.xq73_u19.qnpn13g2[ic]
print @q.xbgr.xq73_u19.qnpn13g2[ib]
print @q.xbgr.xq73_u19.qnpn13g2[ie]
print @q.xbgr.xq73_u19.qnpn13g2[is]
print @r.xbgr.xq73_u19.rsub[i]
print @c.xbgr.xq73_u19.csub[i]
print @q.xbgr.xq73_u20.qnpn13g2[ic]
print @q.xbgr.xq73_u20.qnpn13g2[ib]
print @q.xbgr.xq73_u20.qnpn13g2[ie]
print @q.xbgr.xq73_u20.qnpn13g2[is]
print @r.xbgr.xq73_u20.rsub[i]
print @c.xbgr.xq73_u20.csub[i]
print @q.xbgr.xq73_u21.qnpn13g2[ic]
print @q.xbgr.xq73_u21.qnpn13g2[ib]
print @q.xbgr.xq73_u21.qnpn13g2[ie]
print @q.xbgr.xq73_u21.qnpn13g2[is]
print @r.xbgr.xq73_u21.rsub[i]
print @c.xbgr.xq73_u21.csub[i]
print @q.xbgr.xq73_u22.qnpn13g2[ic]
print @q.xbgr.xq73_u22.qnpn13g2[ib]
print @q.xbgr.xq73_u22.qnpn13g2[ie]
print @q.xbgr.xq73_u22.qnpn13g2[is]
print @r.xbgr.xq73_u22.rsub[i]
print @c.xbgr.xq73_u22.csub[i]
print @q.xbgr.xq73_u23.qnpn13g2[ic]
print @q.xbgr.xq73_u23.qnpn13g2[ib]
print @q.xbgr.xq73_u23.qnpn13g2[ie]
print @q.xbgr.xq73_u23.qnpn13g2[is]
print @r.xbgr.xq73_u23.rsub[i]
print @c.xbgr.xq73_u23.csub[i]
print @q.xbgr.xq73_u24.qnpn13g2[ic]
print @q.xbgr.xq73_u24.qnpn13g2[ib]
print @q.xbgr.xq73_u24.qnpn13g2[ie]
print @q.xbgr.xq73_u24.qnpn13g2[is]
print @r.xbgr.xq73_u24.rsub[i]
print @c.xbgr.xq73_u24.csub[i]
print @q.xbgr.xq74_u2.qnpn13g2[ic]
print @q.xbgr.xq74_u2.qnpn13g2[ib]
print @q.xbgr.xq74_u2.qnpn13g2[ie]
print @q.xbgr.xq74_u2.qnpn13g2[is]
print @r.xbgr.xq74_u2.rsub[i]
print @c.xbgr.xq74_u2.csub[i]
print @q.xbgr.xq74_u3.qnpn13g2[ic]
print @q.xbgr.xq74_u3.qnpn13g2[ib]
print @q.xbgr.xq74_u3.qnpn13g2[ie]
print @q.xbgr.xq74_u3.qnpn13g2[is]
print @r.xbgr.xq74_u3.rsub[i]
print @c.xbgr.xq74_u3.csub[i]
print @q.xbgr.xq74_u4.qnpn13g2[ic]
print @q.xbgr.xq74_u4.qnpn13g2[ib]
print @q.xbgr.xq74_u4.qnpn13g2[ie]
print @q.xbgr.xq74_u4.qnpn13g2[is]
print @r.xbgr.xq74_u4.rsub[i]
print @c.xbgr.xq74_u4.csub[i]
print @q.xbgr.xq74_u5.qnpn13g2[ic]
print @q.xbgr.xq74_u5.qnpn13g2[ib]
print @q.xbgr.xq74_u5.qnpn13g2[ie]
print @q.xbgr.xq74_u5.qnpn13g2[is]
print @r.xbgr.xq74_u5.rsub[i]
print @c.xbgr.xq74_u5.csub[i]
print @q.xbgr.xq74_u6.qnpn13g2[ic]
print @q.xbgr.xq74_u6.qnpn13g2[ib]
print @q.xbgr.xq74_u6.qnpn13g2[ie]
print @q.xbgr.xq74_u6.qnpn13g2[is]
print @r.xbgr.xq74_u6.rsub[i]
print @c.xbgr.xq74_u6.csub[i]
print @q.xbgr.xq74_u7.qnpn13g2[ic]
print @q.xbgr.xq74_u7.qnpn13g2[ib]
print @q.xbgr.xq74_u7.qnpn13g2[ie]
print @q.xbgr.xq74_u7.qnpn13g2[is]
print @r.xbgr.xq74_u7.rsub[i]
print @c.xbgr.xq74_u7.csub[i]
print @q.xbgr.xq74_u8.qnpn13g2[ic]
print @q.xbgr.xq74_u8.qnpn13g2[ib]
print @q.xbgr.xq74_u8.qnpn13g2[ie]
print @q.xbgr.xq74_u8.qnpn13g2[is]
print @r.xbgr.xq74_u8.rsub[i]
print @c.xbgr.xq74_u8.csub[i]
print @q.xbgr.xq74_u9.qnpn13g2[ic]
print @q.xbgr.xq74_u9.qnpn13g2[ib]
print @q.xbgr.xq74_u9.qnpn13g2[ie]
print @q.xbgr.xq74_u9.qnpn13g2[is]
print @r.xbgr.xq74_u9.rsub[i]
print @c.xbgr.xq74_u9.csub[i]
print @q.xbgr.xq74_u10.qnpn13g2[ic]
print @q.xbgr.xq74_u10.qnpn13g2[ib]
print @q.xbgr.xq74_u10.qnpn13g2[ie]
print @q.xbgr.xq74_u10.qnpn13g2[is]
print @r.xbgr.xq74_u10.rsub[i]
print @c.xbgr.xq74_u10.csub[i]
print @q.xbgr.xq74_u11.qnpn13g2[ic]
print @q.xbgr.xq74_u11.qnpn13g2[ib]
print @q.xbgr.xq74_u11.qnpn13g2[ie]
print @q.xbgr.xq74_u11.qnpn13g2[is]
print @r.xbgr.xq74_u11.rsub[i]
print @c.xbgr.xq74_u11.csub[i]
print @q.xbgr.xq74_u12.qnpn13g2[ic]
print @q.xbgr.xq74_u12.qnpn13g2[ib]
print @q.xbgr.xq74_u12.qnpn13g2[ie]
print @q.xbgr.xq74_u12.qnpn13g2[is]
print @r.xbgr.xq74_u12.rsub[i]
print @c.xbgr.xq74_u12.csub[i]
print @q.xbgr.xq74_u13.qnpn13g2[ic]
print @q.xbgr.xq74_u13.qnpn13g2[ib]
print @q.xbgr.xq74_u13.qnpn13g2[ie]
print @q.xbgr.xq74_u13.qnpn13g2[is]
print @r.xbgr.xq74_u13.rsub[i]
print @c.xbgr.xq74_u13.csub[i]
print @q.xbgr.xq74_u14.qnpn13g2[ic]
print @q.xbgr.xq74_u14.qnpn13g2[ib]
print @q.xbgr.xq74_u14.qnpn13g2[ie]
print @q.xbgr.xq74_u14.qnpn13g2[is]
print @r.xbgr.xq74_u14.rsub[i]
print @c.xbgr.xq74_u14.csub[i]
print @q.xbgr.xq74_u15.qnpn13g2[ic]
print @q.xbgr.xq74_u15.qnpn13g2[ib]
print @q.xbgr.xq74_u15.qnpn13g2[ie]
print @q.xbgr.xq74_u15.qnpn13g2[is]
print @r.xbgr.xq74_u15.rsub[i]
print @c.xbgr.xq74_u15.csub[i]
print @q.xbgr.xq74_u16.qnpn13g2[ic]
print @q.xbgr.xq74_u16.qnpn13g2[ib]
print @q.xbgr.xq74_u16.qnpn13g2[ie]
print @q.xbgr.xq74_u16.qnpn13g2[is]
print @r.xbgr.xq74_u16.rsub[i]
print @c.xbgr.xq74_u16.csub[i]
print @q.xbgr.xq74_u17.qnpn13g2[ic]
print @q.xbgr.xq74_u17.qnpn13g2[ib]
print @q.xbgr.xq74_u17.qnpn13g2[ie]
print @q.xbgr.xq74_u17.qnpn13g2[is]
print @r.xbgr.xq74_u17.rsub[i]
print @c.xbgr.xq74_u17.csub[i]
print @q.xbgr.xq74_u18.qnpn13g2[ic]
print @q.xbgr.xq74_u18.qnpn13g2[ib]
print @q.xbgr.xq74_u18.qnpn13g2[ie]
print @q.xbgr.xq74_u18.qnpn13g2[is]
print @r.xbgr.xq74_u18.rsub[i]
print @c.xbgr.xq74_u18.csub[i]
print @q.xbgr.xq74_u19.qnpn13g2[ic]
print @q.xbgr.xq74_u19.qnpn13g2[ib]
print @q.xbgr.xq74_u19.qnpn13g2[ie]
print @q.xbgr.xq74_u19.qnpn13g2[is]
print @r.xbgr.xq74_u19.rsub[i]
print @c.xbgr.xq74_u19.csub[i]
print @q.xbgr.xq74_u20.qnpn13g2[ic]
print @q.xbgr.xq74_u20.qnpn13g2[ib]
print @q.xbgr.xq74_u20.qnpn13g2[ie]
print @q.xbgr.xq74_u20.qnpn13g2[is]
print @r.xbgr.xq74_u20.rsub[i]
print @c.xbgr.xq74_u20.csub[i]
print @q.xbgr.xq74_u21.qnpn13g2[ic]
print @q.xbgr.xq74_u21.qnpn13g2[ib]
print @q.xbgr.xq74_u21.qnpn13g2[ie]
print @q.xbgr.xq74_u21.qnpn13g2[is]
print @r.xbgr.xq74_u21.rsub[i]
print @c.xbgr.xq74_u21.csub[i]
print @q.xbgr.xq74_u22.qnpn13g2[ic]
print @q.xbgr.xq74_u22.qnpn13g2[ib]
print @q.xbgr.xq74_u22.qnpn13g2[ie]
print @q.xbgr.xq74_u22.qnpn13g2[is]
print @r.xbgr.xq74_u22.rsub[i]
print @c.xbgr.xq74_u22.csub[i]
print @q.xbgr.xq74_u23.qnpn13g2[ic]
print @q.xbgr.xq74_u23.qnpn13g2[ib]
print @q.xbgr.xq74_u23.qnpn13g2[ie]
print @q.xbgr.xq74_u23.qnpn13g2[is]
print @r.xbgr.xq74_u23.rsub[i]
print @c.xbgr.xq74_u23.csub[i]
print @q.xbgr.xq74_u24.qnpn13g2[ic]
print @q.xbgr.xq74_u24.qnpn13g2[ib]
print @q.xbgr.xq74_u24.qnpn13g2[ie]
print @q.xbgr.xq74_u24.qnpn13g2[is]
print @r.xbgr.xq74_u24.rsub[i]
print @c.xbgr.xq74_u24.csub[i]
print @q.xbgr.xq75_u2.qnpn13g2[ic]
print @q.xbgr.xq75_u2.qnpn13g2[ib]
print @q.xbgr.xq75_u2.qnpn13g2[ie]
print @q.xbgr.xq75_u2.qnpn13g2[is]
print @r.xbgr.xq75_u2.rsub[i]
print @c.xbgr.xq75_u2.csub[i]
print @q.xbgr.xq75_u3.qnpn13g2[ic]
print @q.xbgr.xq75_u3.qnpn13g2[ib]
print @q.xbgr.xq75_u3.qnpn13g2[ie]
print @q.xbgr.xq75_u3.qnpn13g2[is]
print @r.xbgr.xq75_u3.rsub[i]
print @c.xbgr.xq75_u3.csub[i]
print @q.xbgr.xq75_u4.qnpn13g2[ic]
print @q.xbgr.xq75_u4.qnpn13g2[ib]
print @q.xbgr.xq75_u4.qnpn13g2[ie]
print @q.xbgr.xq75_u4.qnpn13g2[is]
print @r.xbgr.xq75_u4.rsub[i]
print @c.xbgr.xq75_u4.csub[i]
print @q.xbgr.xq75_u5.qnpn13g2[ic]
print @q.xbgr.xq75_u5.qnpn13g2[ib]
print @q.xbgr.xq75_u5.qnpn13g2[ie]
print @q.xbgr.xq75_u5.qnpn13g2[is]
print @r.xbgr.xq75_u5.rsub[i]
print @c.xbgr.xq75_u5.csub[i]
print @q.xbgr.xq75_u6.qnpn13g2[ic]
print @q.xbgr.xq75_u6.qnpn13g2[ib]
print @q.xbgr.xq75_u6.qnpn13g2[ie]
print @q.xbgr.xq75_u6.qnpn13g2[is]
print @r.xbgr.xq75_u6.rsub[i]
print @c.xbgr.xq75_u6.csub[i]
print @q.xbgr.xq75_u7.qnpn13g2[ic]
print @q.xbgr.xq75_u7.qnpn13g2[ib]
print @q.xbgr.xq75_u7.qnpn13g2[ie]
print @q.xbgr.xq75_u7.qnpn13g2[is]
print @r.xbgr.xq75_u7.rsub[i]
print @c.xbgr.xq75_u7.csub[i]
print @q.xbgr.xq75_u8.qnpn13g2[ic]
print @q.xbgr.xq75_u8.qnpn13g2[ib]
print @q.xbgr.xq75_u8.qnpn13g2[ie]
print @q.xbgr.xq75_u8.qnpn13g2[is]
print @r.xbgr.xq75_u8.rsub[i]
print @c.xbgr.xq75_u8.csub[i]
print @q.xbgr.xq75_u9.qnpn13g2[ic]
print @q.xbgr.xq75_u9.qnpn13g2[ib]
print @q.xbgr.xq75_u9.qnpn13g2[ie]
print @q.xbgr.xq75_u9.qnpn13g2[is]
print @r.xbgr.xq75_u9.rsub[i]
print @c.xbgr.xq75_u9.csub[i]
print @q.xbgr.xq75_u10.qnpn13g2[ic]
print @q.xbgr.xq75_u10.qnpn13g2[ib]
print @q.xbgr.xq75_u10.qnpn13g2[ie]
print @q.xbgr.xq75_u10.qnpn13g2[is]
print @r.xbgr.xq75_u10.rsub[i]
print @c.xbgr.xq75_u10.csub[i]
print @q.xbgr.xq75_u11.qnpn13g2[ic]
print @q.xbgr.xq75_u11.qnpn13g2[ib]
print @q.xbgr.xq75_u11.qnpn13g2[ie]
print @q.xbgr.xq75_u11.qnpn13g2[is]
print @r.xbgr.xq75_u11.rsub[i]
print @c.xbgr.xq75_u11.csub[i]
print @q.xbgr.xq75_u12.qnpn13g2[ic]
print @q.xbgr.xq75_u12.qnpn13g2[ib]
print @q.xbgr.xq75_u12.qnpn13g2[ie]
print @q.xbgr.xq75_u12.qnpn13g2[is]
print @r.xbgr.xq75_u12.rsub[i]
print @c.xbgr.xq75_u12.csub[i]
print @q.xbgr.xq75_u13.qnpn13g2[ic]
print @q.xbgr.xq75_u13.qnpn13g2[ib]
print @q.xbgr.xq75_u13.qnpn13g2[ie]
print @q.xbgr.xq75_u13.qnpn13g2[is]
print @r.xbgr.xq75_u13.rsub[i]
print @c.xbgr.xq75_u13.csub[i]
print @q.xbgr.xq75_u14.qnpn13g2[ic]
print @q.xbgr.xq75_u14.qnpn13g2[ib]
print @q.xbgr.xq75_u14.qnpn13g2[ie]
print @q.xbgr.xq75_u14.qnpn13g2[is]
print @r.xbgr.xq75_u14.rsub[i]
print @c.xbgr.xq75_u14.csub[i]
print @q.xbgr.xq75_u15.qnpn13g2[ic]
print @q.xbgr.xq75_u15.qnpn13g2[ib]
print @q.xbgr.xq75_u15.qnpn13g2[ie]
print @q.xbgr.xq75_u15.qnpn13g2[is]
print @r.xbgr.xq75_u15.rsub[i]
print @c.xbgr.xq75_u15.csub[i]
print @q.xbgr.xq75_u16.qnpn13g2[ic]
print @q.xbgr.xq75_u16.qnpn13g2[ib]
print @q.xbgr.xq75_u16.qnpn13g2[ie]
print @q.xbgr.xq75_u16.qnpn13g2[is]
print @r.xbgr.xq75_u16.rsub[i]
print @c.xbgr.xq75_u16.csub[i]
print @q.xbgr.xq75_u17.qnpn13g2[ic]
print @q.xbgr.xq75_u17.qnpn13g2[ib]
print @q.xbgr.xq75_u17.qnpn13g2[ie]
print @q.xbgr.xq75_u17.qnpn13g2[is]
print @r.xbgr.xq75_u17.rsub[i]
print @c.xbgr.xq75_u17.csub[i]
print @q.xbgr.xq75_u18.qnpn13g2[ic]
print @q.xbgr.xq75_u18.qnpn13g2[ib]
print @q.xbgr.xq75_u18.qnpn13g2[ie]
print @q.xbgr.xq75_u18.qnpn13g2[is]
print @r.xbgr.xq75_u18.rsub[i]
print @c.xbgr.xq75_u18.csub[i]
print @q.xbgr.xq75_u19.qnpn13g2[ic]
print @q.xbgr.xq75_u19.qnpn13g2[ib]
print @q.xbgr.xq75_u19.qnpn13g2[ie]
print @q.xbgr.xq75_u19.qnpn13g2[is]
print @r.xbgr.xq75_u19.rsub[i]
print @c.xbgr.xq75_u19.csub[i]
print @q.xbgr.xq75_u20.qnpn13g2[ic]
print @q.xbgr.xq75_u20.qnpn13g2[ib]
print @q.xbgr.xq75_u20.qnpn13g2[ie]
print @q.xbgr.xq75_u20.qnpn13g2[is]
print @r.xbgr.xq75_u20.rsub[i]
print @c.xbgr.xq75_u20.csub[i]
print @q.xbgr.xq75_u21.qnpn13g2[ic]
print @q.xbgr.xq75_u21.qnpn13g2[ib]
print @q.xbgr.xq75_u21.qnpn13g2[ie]
print @q.xbgr.xq75_u21.qnpn13g2[is]
print @r.xbgr.xq75_u21.rsub[i]
print @c.xbgr.xq75_u21.csub[i]
print @q.xbgr.xq75_u22.qnpn13g2[ic]
print @q.xbgr.xq75_u22.qnpn13g2[ib]
print @q.xbgr.xq75_u22.qnpn13g2[ie]
print @q.xbgr.xq75_u22.qnpn13g2[is]
print @r.xbgr.xq75_u22.rsub[i]
print @c.xbgr.xq75_u22.csub[i]
print @q.xbgr.xq75_u23.qnpn13g2[ic]
print @q.xbgr.xq75_u23.qnpn13g2[ib]
print @q.xbgr.xq75_u23.qnpn13g2[ie]
print @q.xbgr.xq75_u23.qnpn13g2[is]
print @r.xbgr.xq75_u23.rsub[i]
print @c.xbgr.xq75_u23.csub[i]
print @q.xbgr.xq75_u24.qnpn13g2[ic]
print @q.xbgr.xq75_u24.qnpn13g2[ib]
print @q.xbgr.xq75_u24.qnpn13g2[ie]
print @q.xbgr.xq75_u24.qnpn13g2[is]
print @r.xbgr.xq75_u24.rsub[i]
print @c.xbgr.xq75_u24.csub[i]
print @q.xbgr.xq76_u2.qnpn13g2[ic]
print @q.xbgr.xq76_u2.qnpn13g2[ib]
print @q.xbgr.xq76_u2.qnpn13g2[ie]
print @q.xbgr.xq76_u2.qnpn13g2[is]
print @r.xbgr.xq76_u2.rsub[i]
print @c.xbgr.xq76_u2.csub[i]
print @q.xbgr.xq76_u3.qnpn13g2[ic]
print @q.xbgr.xq76_u3.qnpn13g2[ib]
print @q.xbgr.xq76_u3.qnpn13g2[ie]
print @q.xbgr.xq76_u3.qnpn13g2[is]
print @r.xbgr.xq76_u3.rsub[i]
print @c.xbgr.xq76_u3.csub[i]
print @q.xbgr.xq76_u4.qnpn13g2[ic]
print @q.xbgr.xq76_u4.qnpn13g2[ib]
print @q.xbgr.xq76_u4.qnpn13g2[ie]
print @q.xbgr.xq76_u4.qnpn13g2[is]
print @r.xbgr.xq76_u4.rsub[i]
print @c.xbgr.xq76_u4.csub[i]
print @q.xbgr.xq76_u5.qnpn13g2[ic]
print @q.xbgr.xq76_u5.qnpn13g2[ib]
print @q.xbgr.xq76_u5.qnpn13g2[ie]
print @q.xbgr.xq76_u5.qnpn13g2[is]
print @r.xbgr.xq76_u5.rsub[i]
print @c.xbgr.xq76_u5.csub[i]
print @q.xbgr.xq76_u6.qnpn13g2[ic]
print @q.xbgr.xq76_u6.qnpn13g2[ib]
print @q.xbgr.xq76_u6.qnpn13g2[ie]
print @q.xbgr.xq76_u6.qnpn13g2[is]
print @r.xbgr.xq76_u6.rsub[i]
print @c.xbgr.xq76_u6.csub[i]
print @q.xbgr.xq76_u7.qnpn13g2[ic]
print @q.xbgr.xq76_u7.qnpn13g2[ib]
print @q.xbgr.xq76_u7.qnpn13g2[ie]
print @q.xbgr.xq76_u7.qnpn13g2[is]
print @r.xbgr.xq76_u7.rsub[i]
print @c.xbgr.xq76_u7.csub[i]
print @q.xbgr.xq76_u8.qnpn13g2[ic]
print @q.xbgr.xq76_u8.qnpn13g2[ib]
print @q.xbgr.xq76_u8.qnpn13g2[ie]
print @q.xbgr.xq76_u8.qnpn13g2[is]
print @r.xbgr.xq76_u8.rsub[i]
print @c.xbgr.xq76_u8.csub[i]
print @q.xbgr.xq76_u9.qnpn13g2[ic]
print @q.xbgr.xq76_u9.qnpn13g2[ib]
print @q.xbgr.xq76_u9.qnpn13g2[ie]
print @q.xbgr.xq76_u9.qnpn13g2[is]
print @r.xbgr.xq76_u9.rsub[i]
print @c.xbgr.xq76_u9.csub[i]
print @q.xbgr.xq76_u10.qnpn13g2[ic]
print @q.xbgr.xq76_u10.qnpn13g2[ib]
print @q.xbgr.xq76_u10.qnpn13g2[ie]
print @q.xbgr.xq76_u10.qnpn13g2[is]
print @r.xbgr.xq76_u10.rsub[i]
print @c.xbgr.xq76_u10.csub[i]
print @q.xbgr.xq76_u11.qnpn13g2[ic]
print @q.xbgr.xq76_u11.qnpn13g2[ib]
print @q.xbgr.xq76_u11.qnpn13g2[ie]
print @q.xbgr.xq76_u11.qnpn13g2[is]
print @r.xbgr.xq76_u11.rsub[i]
print @c.xbgr.xq76_u11.csub[i]
print @q.xbgr.xq76_u12.qnpn13g2[ic]
print @q.xbgr.xq76_u12.qnpn13g2[ib]
print @q.xbgr.xq76_u12.qnpn13g2[ie]
print @q.xbgr.xq76_u12.qnpn13g2[is]
print @r.xbgr.xq76_u12.rsub[i]
print @c.xbgr.xq76_u12.csub[i]
print @q.xbgr.xq76_u13.qnpn13g2[ic]
print @q.xbgr.xq76_u13.qnpn13g2[ib]
print @q.xbgr.xq76_u13.qnpn13g2[ie]
print @q.xbgr.xq76_u13.qnpn13g2[is]
print @r.xbgr.xq76_u13.rsub[i]
print @c.xbgr.xq76_u13.csub[i]
print @q.xbgr.xq76_u14.qnpn13g2[ic]
print @q.xbgr.xq76_u14.qnpn13g2[ib]
print @q.xbgr.xq76_u14.qnpn13g2[ie]
print @q.xbgr.xq76_u14.qnpn13g2[is]
print @r.xbgr.xq76_u14.rsub[i]
print @c.xbgr.xq76_u14.csub[i]
print @q.xbgr.xq76_u15.qnpn13g2[ic]
print @q.xbgr.xq76_u15.qnpn13g2[ib]
print @q.xbgr.xq76_u15.qnpn13g2[ie]
print @q.xbgr.xq76_u15.qnpn13g2[is]
print @r.xbgr.xq76_u15.rsub[i]
print @c.xbgr.xq76_u15.csub[i]
print @q.xbgr.xq76_u16.qnpn13g2[ic]
print @q.xbgr.xq76_u16.qnpn13g2[ib]
print @q.xbgr.xq76_u16.qnpn13g2[ie]
print @q.xbgr.xq76_u16.qnpn13g2[is]
print @r.xbgr.xq76_u16.rsub[i]
print @c.xbgr.xq76_u16.csub[i]
print @q.xbgr.xq76_u17.qnpn13g2[ic]
print @q.xbgr.xq76_u17.qnpn13g2[ib]
print @q.xbgr.xq76_u17.qnpn13g2[ie]
print @q.xbgr.xq76_u17.qnpn13g2[is]
print @r.xbgr.xq76_u17.rsub[i]
print @c.xbgr.xq76_u17.csub[i]
print @q.xbgr.xq76_u18.qnpn13g2[ic]
print @q.xbgr.xq76_u18.qnpn13g2[ib]
print @q.xbgr.xq76_u18.qnpn13g2[ie]
print @q.xbgr.xq76_u18.qnpn13g2[is]
print @r.xbgr.xq76_u18.rsub[i]
print @c.xbgr.xq76_u18.csub[i]
print @q.xbgr.xq76_u19.qnpn13g2[ic]
print @q.xbgr.xq76_u19.qnpn13g2[ib]
print @q.xbgr.xq76_u19.qnpn13g2[ie]
print @q.xbgr.xq76_u19.qnpn13g2[is]
print @r.xbgr.xq76_u19.rsub[i]
print @c.xbgr.xq76_u19.csub[i]
print @q.xbgr.xq76_u20.qnpn13g2[ic]
print @q.xbgr.xq76_u20.qnpn13g2[ib]
print @q.xbgr.xq76_u20.qnpn13g2[ie]
print @q.xbgr.xq76_u20.qnpn13g2[is]
print @r.xbgr.xq76_u20.rsub[i]
print @c.xbgr.xq76_u20.csub[i]
print @q.xbgr.xq76_u21.qnpn13g2[ic]
print @q.xbgr.xq76_u21.qnpn13g2[ib]
print @q.xbgr.xq76_u21.qnpn13g2[ie]
print @q.xbgr.xq76_u21.qnpn13g2[is]
print @r.xbgr.xq76_u21.rsub[i]
print @c.xbgr.xq76_u21.csub[i]
print @q.xbgr.xq76_u22.qnpn13g2[ic]
print @q.xbgr.xq76_u22.qnpn13g2[ib]
print @q.xbgr.xq76_u22.qnpn13g2[ie]
print @q.xbgr.xq76_u22.qnpn13g2[is]
print @r.xbgr.xq76_u22.rsub[i]
print @c.xbgr.xq76_u22.csub[i]
print @q.xbgr.xq76_u23.qnpn13g2[ic]
print @q.xbgr.xq76_u23.qnpn13g2[ib]
print @q.xbgr.xq76_u23.qnpn13g2[ie]
print @q.xbgr.xq76_u23.qnpn13g2[is]
print @r.xbgr.xq76_u23.rsub[i]
print @c.xbgr.xq76_u23.csub[i]
print @q.xbgr.xq76_u24.qnpn13g2[ic]
print @q.xbgr.xq76_u24.qnpn13g2[ib]
print @q.xbgr.xq76_u24.qnpn13g2[ie]
print @q.xbgr.xq76_u24.qnpn13g2[is]
print @r.xbgr.xq76_u24.rsub[i]
print @c.xbgr.xq76_u24.csub[i]
print @n.xbgr.xr77_u2.nr1[ibody]
print @n.xbgr.xr77_u3.nr1[ibody]
print @n.xbgr.xr77_u4.nr1[ibody]
print @n.xbgr.xr77_u5.nr1[ibody]
print @n.xbgr.xr77_u6.nr1[ibody]
print @n.xbgr.xr77_u7.nr1[ibody]
print @n.xbgr.xr77_u8.nr1[ibody]
print @n.xbgr.xr77_u9.nr1[ibody]
print @n.xbgr.xr77_u10.nr1[ibody]
print @n.xbgr.xr77_u11.nr1[ibody]
print @n.xbgr.xr77_u12.nr1[ibody]
print @n.xbgr.xr77_u13.nr1[ibody]
print @n.xbgr.xr77_u14.nr1[ibody]
print @n.xbgr.xr77_u15.nr1[ibody]
print @n.xbgr.xr77_u16.nr1[ibody]
print @n.xbgr.xr77_u17.nr1[ibody]
print @n.xbgr.xr77_u18.nr1[ibody]
print @n.xbgr.xr77_u19.nr1[ibody]
print @n.xbgr.xr77_u20.nr1[ibody]
print @n.xbgr.xr77_u21.nr1[ibody]
print @n.xbgr.xr77_u22.nr1[ibody]
print @n.xbgr.xr77_u23.nr1[ibody]
print @n.xbgr.xr77_u24.nr1[ibody]
print @n.xbgr.xr78_u2.nr1[ibody]
print @n.xbgr.xr78_u3.nr1[ibody]
print @n.xbgr.xr78_u4.nr1[ibody]
print @n.xbgr.xr78_u5.nr1[ibody]
print @n.xbgr.xr78_u6.nr1[ibody]
print @n.xbgr.xr78_u7.nr1[ibody]
print @n.xbgr.xr78_u8.nr1[ibody]
print @n.xbgr.xr78_u9.nr1[ibody]
print @n.xbgr.xr78_u10.nr1[ibody]
print @n.xbgr.xr78_u11.nr1[ibody]
print @n.xbgr.xr78_u12.nr1[ibody]
print @n.xbgr.xr78_u13.nr1[ibody]
print @n.xbgr.xr78_u14.nr1[ibody]
print @n.xbgr.xr78_u15.nr1[ibody]
print @n.xbgr.xr78_u16.nr1[ibody]
print @n.xbgr.xr78_u17.nr1[ibody]
print @n.xbgr.xr78_u18.nr1[ibody]
print @n.xbgr.xr78_u19.nr1[ibody]
print @n.xbgr.xr78_u20.nr1[ibody]
print @n.xbgr.xr78_u21.nr1[ibody]
print @n.xbgr.xr78_u22.nr1[ibody]
print @n.xbgr.xr78_u23.nr1[ibody]
print @n.xbgr.xr78_u24.nr1[ibody]
print @n.xbgr.xr79_u2.nr1[ibody]
print @n.xbgr.xr79_u3.nr1[ibody]
print @n.xbgr.xr79_u4.nr1[ibody]
print @n.xbgr.xr79_u5.nr1[ibody]
print @n.xbgr.xr79_u6.nr1[ibody]
print @n.xbgr.xr79_u7.nr1[ibody]
print @n.xbgr.xr79_u8.nr1[ibody]
print @n.xbgr.xr79_u9.nr1[ibody]
print @n.xbgr.xr79_u10.nr1[ibody]
print @n.xbgr.xr79_u11.nr1[ibody]
print @n.xbgr.xr79_u12.nr1[ibody]
print @n.xbgr.xr79_u13.nr1[ibody]
print @n.xbgr.xr79_u14.nr1[ibody]
print @n.xbgr.xr79_u15.nr1[ibody]
print @n.xbgr.xr79_u16.nr1[ibody]
print @n.xbgr.xr79_u17.nr1[ibody]
print @n.xbgr.xr79_u18.nr1[ibody]
print @n.xbgr.xr79_u19.nr1[ibody]
print @n.xbgr.xr79_u20.nr1[ibody]
print @n.xbgr.xr79_u21.nr1[ibody]
print @n.xbgr.xr79_u22.nr1[ibody]
print @n.xbgr.xr79_u23.nr1[ibody]
print @n.xbgr.xr79_u24.nr1[ibody]
print @n.xbgr.xr80_u2.nr1[ibody]
print @n.xbgr.xr80_u3.nr1[ibody]
print @n.xbgr.xr80_u4.nr1[ibody]
print @n.xbgr.xr80_u5.nr1[ibody]
print @n.xbgr.xr80_u6.nr1[ibody]
print @n.xbgr.xr80_u7.nr1[ibody]
print @n.xbgr.xr80_u8.nr1[ibody]
print @n.xbgr.xr80_u9.nr1[ibody]
print @n.xbgr.xr80_u10.nr1[ibody]
print @n.xbgr.xr80_u11.nr1[ibody]
print @n.xbgr.xr80_u12.nr1[ibody]
print @n.xbgr.xr80_u13.nr1[ibody]
print @n.xbgr.xr80_u14.nr1[ibody]
print @n.xbgr.xr80_u15.nr1[ibody]
print @n.xbgr.xr80_u16.nr1[ibody]
print @n.xbgr.xr80_u17.nr1[ibody]
print @n.xbgr.xr80_u18.nr1[ibody]
print @n.xbgr.xr80_u19.nr1[ibody]
print @n.xbgr.xr80_u20.nr1[ibody]
print @n.xbgr.xr80_u21.nr1[ibody]
print @n.xbgr.xr80_u22.nr1[ibody]
print @n.xbgr.xr80_u23.nr1[ibody]
print @n.xbgr.xr80_u24.nr1[ibody]
print @n.xbgr.xr81_u2.nr1[ibody]
print @n.xbgr.xr81_u3.nr1[ibody]
print @n.xbgr.xr81_u4.nr1[ibody]
print @n.xbgr.xr81_u5.nr1[ibody]
print @n.xbgr.xr81_u6.nr1[ibody]
print @n.xbgr.xr81_u7.nr1[ibody]
print @n.xbgr.xr81_u8.nr1[ibody]
print @n.xbgr.xr81_u9.nr1[ibody]
print @n.xbgr.xr81_u10.nr1[ibody]
print @n.xbgr.xr81_u11.nr1[ibody]
print @n.xbgr.xr81_u12.nr1[ibody]
print @n.xbgr.xr81_u13.nr1[ibody]
print @n.xbgr.xr81_u14.nr1[ibody]
print @n.xbgr.xr81_u15.nr1[ibody]
print @n.xbgr.xr81_u16.nr1[ibody]
print @n.xbgr.xr81_u17.nr1[ibody]
print @n.xbgr.xr81_u18.nr1[ibody]
print @n.xbgr.xr81_u19.nr1[ibody]
print @n.xbgr.xr81_u20.nr1[ibody]
print @n.xbgr.xr81_u21.nr1[ibody]
print @n.xbgr.xr81_u22.nr1[ibody]
print @n.xbgr.xr81_u23.nr1[ibody]
print @n.xbgr.xr81_u24.nr1[ibody]
print @n.xbgr.xr82_u2.nr1[ibody]
print @n.xbgr.xr82_u3.nr1[ibody]
print @n.xbgr.xr82_u4.nr1[ibody]
print @n.xbgr.xr82_u5.nr1[ibody]
print @n.xbgr.xr82_u6.nr1[ibody]
print @n.xbgr.xr82_u7.nr1[ibody]
print @n.xbgr.xr82_u8.nr1[ibody]
print @n.xbgr.xr82_u9.nr1[ibody]
print @n.xbgr.xr82_u10.nr1[ibody]
print @n.xbgr.xr82_u11.nr1[ibody]
print @n.xbgr.xr82_u12.nr1[ibody]
print @n.xbgr.xr82_u13.nr1[ibody]
print @n.xbgr.xr82_u14.nr1[ibody]
print @n.xbgr.xr82_u15.nr1[ibody]
print @n.xbgr.xr82_u16.nr1[ibody]
print @n.xbgr.xr82_u17.nr1[ibody]
print @n.xbgr.xr82_u18.nr1[ibody]
print @n.xbgr.xr82_u19.nr1[ibody]
print @n.xbgr.xr82_u20.nr1[ibody]
print @n.xbgr.xr82_u21.nr1[ibody]
print @n.xbgr.xr82_u22.nr1[ibody]
print @n.xbgr.xr82_u23.nr1[ibody]
print @n.xbgr.xr82_u24.nr1[ibody]
print @n.xbgr.xr83_u2.nr1[ibody]
print @n.xbgr.xr83_u3.nr1[ibody]
print @n.xbgr.xr83_u4.nr1[ibody]
print @n.xbgr.xr83_u5.nr1[ibody]
print @n.xbgr.xr83_u6.nr1[ibody]
print @n.xbgr.xr83_u7.nr1[ibody]
print @n.xbgr.xr83_u8.nr1[ibody]
print @n.xbgr.xr83_u9.nr1[ibody]
print @n.xbgr.xr83_u10.nr1[ibody]
print @n.xbgr.xr83_u11.nr1[ibody]
print @n.xbgr.xr83_u12.nr1[ibody]
print @n.xbgr.xr83_u13.nr1[ibody]
print @n.xbgr.xr83_u14.nr1[ibody]
print @n.xbgr.xr83_u15.nr1[ibody]
print @n.xbgr.xr83_u16.nr1[ibody]
print @n.xbgr.xr83_u17.nr1[ibody]
print @n.xbgr.xr83_u18.nr1[ibody]
print @n.xbgr.xr83_u19.nr1[ibody]
print @n.xbgr.xr83_u20.nr1[ibody]
print @n.xbgr.xr83_u21.nr1[ibody]
print @n.xbgr.xr83_u22.nr1[ibody]
print @n.xbgr.xr83_u23.nr1[ibody]
print @n.xbgr.xr83_u24.nr1[ibody]
print @n.xbgr.xr84_u2.nr1[ibody]
print @n.xbgr.xr84_u3.nr1[ibody]
print @n.xbgr.xr84_u4.nr1[ibody]
print @n.xbgr.xr84_u5.nr1[ibody]
print @n.xbgr.xr84_u6.nr1[ibody]
print @n.xbgr.xr84_u7.nr1[ibody]
print @n.xbgr.xr84_u8.nr1[ibody]
print @n.xbgr.xr84_u9.nr1[ibody]
print @n.xbgr.xr84_u10.nr1[ibody]
print @n.xbgr.xr84_u11.nr1[ibody]
print @n.xbgr.xr84_u12.nr1[ibody]
print @n.xbgr.xr84_u13.nr1[ibody]
print @n.xbgr.xr84_u14.nr1[ibody]
print @n.xbgr.xr84_u15.nr1[ibody]
print @n.xbgr.xr84_u16.nr1[ibody]
print @n.xbgr.xr84_u17.nr1[ibody]
print @n.xbgr.xr84_u18.nr1[ibody]
print @n.xbgr.xr84_u19.nr1[ibody]
print @n.xbgr.xr84_u20.nr1[ibody]
print @n.xbgr.xr84_u21.nr1[ibody]
print @n.xbgr.xr84_u22.nr1[ibody]
print @n.xbgr.xr84_u23.nr1[ibody]
print @n.xbgr.xr84_u24.nr1[ibody]
print @n.xbgr.xr85_u2.nr1[ibody]
print @n.xbgr.xr85_u3.nr1[ibody]
print @n.xbgr.xr85_u4.nr1[ibody]
print @n.xbgr.xr85_u5.nr1[ibody]
print @n.xbgr.xr85_u6.nr1[ibody]
print @n.xbgr.xr85_u7.nr1[ibody]
print @n.xbgr.xr85_u8.nr1[ibody]
print @n.xbgr.xr85_u9.nr1[ibody]
print @n.xbgr.xr85_u10.nr1[ibody]
print @n.xbgr.xr85_u11.nr1[ibody]
print @n.xbgr.xr85_u12.nr1[ibody]
print @n.xbgr.xr85_u13.nr1[ibody]
print @n.xbgr.xr85_u14.nr1[ibody]
print @n.xbgr.xr85_u15.nr1[ibody]
print @n.xbgr.xr85_u16.nr1[ibody]
print @n.xbgr.xr85_u17.nr1[ibody]
print @n.xbgr.xr85_u18.nr1[ibody]
print @n.xbgr.xr85_u19.nr1[ibody]
print @n.xbgr.xr85_u20.nr1[ibody]
print @n.xbgr.xr85_u21.nr1[ibody]
print @n.xbgr.xr85_u22.nr1[ibody]
print @n.xbgr.xr85_u23.nr1[ibody]
print @n.xbgr.xr85_u24.nr1[ibody]
print @n.xbgr.xr86_u2.nr1[ibody]
print @n.xbgr.xr86_u3.nr1[ibody]
print @n.xbgr.xr86_u4.nr1[ibody]
print @n.xbgr.xr86_u5.nr1[ibody]
print @n.xbgr.xr86_u6.nr1[ibody]
print @n.xbgr.xr86_u7.nr1[ibody]
print @n.xbgr.xr86_u8.nr1[ibody]
print @n.xbgr.xr86_u9.nr1[ibody]
print @n.xbgr.xr86_u10.nr1[ibody]
print @n.xbgr.xr86_u11.nr1[ibody]
print @n.xbgr.xr86_u12.nr1[ibody]
print @n.xbgr.xr86_u13.nr1[ibody]
print @n.xbgr.xr86_u14.nr1[ibody]
print @n.xbgr.xr86_u15.nr1[ibody]
print @n.xbgr.xr86_u16.nr1[ibody]
print @n.xbgr.xr86_u17.nr1[ibody]
print @n.xbgr.xr86_u18.nr1[ibody]
print @n.xbgr.xr86_u19.nr1[ibody]
print @n.xbgr.xr86_u20.nr1[ibody]
print @n.xbgr.xr86_u21.nr1[ibody]
print @n.xbgr.xr86_u22.nr1[ibody]
print @n.xbgr.xr86_u23.nr1[ibody]
print @n.xbgr.xr86_u24.nr1[ibody]
echo RAW_CURRENT_LEDGER_END
wrdata op_nodes.dat v(xbgr.b1b) v(xbgr.c2) v(xbgr.d1) v(xbgr.d2) v(xbgr.d3) v(xbgr.d4) v(xbgr.d5) v(xbgr.det) v(dvbe) v(iptat) v(xbgr.kick) v(xbgr.n1) v(xbgr.n_10) v(xbgr.n_11) v(xbgr.n_12) v(xbgr.n_13) v(xbgr.n_14) v(xbgr.n_15) v(xbgr.n_16) v(xbgr.n_17) v(xbgr.n_18) v(xbgr.n_19) v(xbgr.n_2) v(xbgr.n_21) v(xbgr.n_22) v(xbgr.n_23) v(xbgr.n_24) v(xbgr.n_25) v(xbgr.n_26) v(xbgr.n_27) v(xbgr.n_3) v(xbgr.n_30) v(xbgr.n_31) v(xbgr.n_33) v(xbgr.n_34) v(xbgr.n_36) v(xbgr.n_37) v(xbgr.n_4) v(xbgr.n_5) v(xbgr.n_6) v(xbgr.n_7) v(xbgr.n_8) v(xbgr.n_9) v(pbias) v(pcasc) v(r4) v(xbgr.r4n) v(xbgr.vb2) v(vbe) v(xbgr.vbe3) v(xbgr.vd1) v(xbgr.vd2) v(vdd) v(vref) v(vdd)-v(vdd) i(vdd) i(vload) i(vr4) i(vsub)
print @n.xbgr.xr1.nr1[nsmm_rsh]
print @n.xbgr.xr1.nr1[nsmm_w]
print @n.xbgr.xr1.nr1[nsmm_l]
print @n.xbgr.xr2.nr1[nsmm_rsh]
print @n.xbgr.xr2.nr1[nsmm_w]
print @n.xbgr.xr2.nr1[nsmm_l]
print @n.xbgr.xr3.nr1[nsmm_rsh]
print @n.xbgr.xr3.nr1[nsmm_w]
print @n.xbgr.xr3.nr1[nsmm_l]
print @n.xbgr.xr4.nr1[nsmm_rsh]
print @n.xbgr.xr4.nr1[nsmm_w]
print @n.xbgr.xr4.nr1[nsmm_l]
print @n.xbgr.xr5.nr1[nsmm_rsh]
print @n.xbgr.xr5.nr1[nsmm_w]
print @n.xbgr.xr5.nr1[nsmm_l]
print @n.xbgr.xr6.nr1[nsmm_rsh]
print @n.xbgr.xr6.nr1[nsmm_w]
print @n.xbgr.xr6.nr1[nsmm_l]
print @n.xbgr.xr7.nr1[nsmm_rsh]
print @n.xbgr.xr7.nr1[nsmm_w]
print @n.xbgr.xr7.nr1[nsmm_l]
print @n.xbgr.xr8.nr1[nsmm_rsh]
print @n.xbgr.xr8.nr1[nsmm_w]
print @n.xbgr.xr8.nr1[nsmm_l]
print @n.xbgr.xr9.nr1[nsmm_rsh]
print @n.xbgr.xr9.nr1[nsmm_w]
print @n.xbgr.xr9.nr1[nsmm_l]
print @n.xbgr.xr10.nr1[nsmm_rsh]
print @n.xbgr.xr10.nr1[nsmm_w]
print @n.xbgr.xr10.nr1[nsmm_l]
print @n.xbgr.xr11.nr1[nsmm_rsh]
print @n.xbgr.xr11.nr1[nsmm_w]
print @n.xbgr.xr11.nr1[nsmm_l]
print @n.xbgr.xr12.nr1[nsmm_rsh]
print @n.xbgr.xr12.nr1[nsmm_w]
print @n.xbgr.xr12.nr1[nsmm_l]
print @n.xbgr.xr13.nr1[nsmm_rsh]
print @n.xbgr.xr13.nr1[nsmm_w]
print @n.xbgr.xr13.nr1[nsmm_l]
print @n.xbgr.xr14.nr1[nsmm_rsh]
print @n.xbgr.xr14.nr1[nsmm_w]
print @n.xbgr.xr14.nr1[nsmm_l]
print @n.xbgr.xr15.nr1[nsmm_rsh]
print @n.xbgr.xr15.nr1[nsmm_w]
print @n.xbgr.xr15.nr1[nsmm_l]
print @n.xbgr.xr16.nr1[nsmm_rsh]
print @n.xbgr.xr16.nr1[nsmm_w]
print @n.xbgr.xr16.nr1[nsmm_l]
print @n.xbgr.xr17.nr1[nsmm_rsh]
print @n.xbgr.xr17.nr1[nsmm_w]
print @n.xbgr.xr17.nr1[nsmm_l]
print @n.xbgr.xr18.nr1[nsmm_rsh]
print @n.xbgr.xr18.nr1[nsmm_w]
print @n.xbgr.xr18.nr1[nsmm_l]
print @n.xbgr.xr19.nr1[nsmm_rsh]
print @n.xbgr.xr19.nr1[nsmm_w]
print @n.xbgr.xr19.nr1[nsmm_l]
print @n.xbgr.xr20.nr1[nsmm_rsh]
print @n.xbgr.xr20.nr1[nsmm_w]
print @n.xbgr.xr20.nr1[nsmm_l]
print @n.xbgr.xr21.nr1[nsmm_rsh]
print @n.xbgr.xr21.nr1[nsmm_w]
print @n.xbgr.xr21.nr1[nsmm_l]
print @n.xbgr.xr22.nr1[nsmm_rsh]
print @n.xbgr.xr22.nr1[nsmm_w]
print @n.xbgr.xr22.nr1[nsmm_l]
print @n.xbgr.xr23.nr1[nsmm_rsh]
print @n.xbgr.xr23.nr1[nsmm_w]
print @n.xbgr.xr23.nr1[nsmm_l]
print @n.xbgr.xr24.nr1[nsmm_rsh]
print @n.xbgr.xr24.nr1[nsmm_w]
print @n.xbgr.xr24.nr1[nsmm_l]
print @n.xbgr.xr25.nr1[nsmm_rsh]
print @n.xbgr.xr25.nr1[nsmm_w]
print @n.xbgr.xr25.nr1[nsmm_l]
print @n.xbgr.xr26.nr1[nsmm_rsh]
print @n.xbgr.xr26.nr1[nsmm_w]
print @n.xbgr.xr26.nr1[nsmm_l]
print @n.xbgr.xm27.nsg13_hv_pmos[w]
print @n.xbgr.xm27.nsg13_hv_pmos[l]
print @n.xbgr.xm27.nsg13_hv_pmos[delvto]
print @n.xbgr.xm27.nsg13_hv_pmos[factuo]
print @n.xbgr.xm28.nsg13_hv_pmos[w]
print @n.xbgr.xm28.nsg13_hv_pmos[l]
print @n.xbgr.xm28.nsg13_hv_pmos[delvto]
print @n.xbgr.xm28.nsg13_hv_pmos[factuo]
print @n.xbgr.xm29.nsg13_hv_nmos[w]
print @n.xbgr.xm29.nsg13_hv_nmos[l]
print @n.xbgr.xm29.nsg13_hv_nmos[delvto]
print @n.xbgr.xm29.nsg13_hv_nmos[factuo]
print @n.xbgr.xm30.nsg13_hv_nmos[w]
print @n.xbgr.xm30.nsg13_hv_nmos[l]
print @n.xbgr.xm30.nsg13_hv_nmos[delvto]
print @n.xbgr.xm30.nsg13_hv_nmos[factuo]
print @n.xbgr.xm31.nsg13_hv_nmos[w]
print @n.xbgr.xm31.nsg13_hv_nmos[l]
print @n.xbgr.xm31.nsg13_hv_nmos[delvto]
print @n.xbgr.xm31.nsg13_hv_nmos[factuo]
print @n.xbgr.xm32.nsg13_hv_nmos[w]
print @n.xbgr.xm32.nsg13_hv_nmos[l]
print @n.xbgr.xm32.nsg13_hv_nmos[delvto]
print @n.xbgr.xm32.nsg13_hv_nmos[factuo]
print @n.xbgr.xm33.nsg13_hv_nmos[w]
print @n.xbgr.xm33.nsg13_hv_nmos[l]
print @n.xbgr.xm33.nsg13_hv_nmos[delvto]
print @n.xbgr.xm33.nsg13_hv_nmos[factuo]
print @n.xbgr.xm34.nsg13_hv_nmos[w]
print @n.xbgr.xm34.nsg13_hv_nmos[l]
print @n.xbgr.xm34.nsg13_hv_nmos[delvto]
print @n.xbgr.xm34.nsg13_hv_nmos[factuo]
print @n.xbgr.xm35.nsg13_hv_nmos[w]
print @n.xbgr.xm35.nsg13_hv_nmos[l]
print @n.xbgr.xm35.nsg13_hv_nmos[delvto]
print @n.xbgr.xm35.nsg13_hv_nmos[factuo]
print @n.xbgr.xm36.nsg13_hv_nmos[w]
print @n.xbgr.xm36.nsg13_hv_nmos[l]
print @n.xbgr.xm36.nsg13_hv_nmos[delvto]
print @n.xbgr.xm36.nsg13_hv_nmos[factuo]
print @n.xbgr.xm37.nsg13_hv_nmos[w]
print @n.xbgr.xm37.nsg13_hv_nmos[l]
print @n.xbgr.xm37.nsg13_hv_nmos[delvto]
print @n.xbgr.xm37.nsg13_hv_nmos[factuo]
print @n.xbgr.xm38.nsg13_hv_pmos[w]
print @n.xbgr.xm38.nsg13_hv_pmos[l]
print @n.xbgr.xm38.nsg13_hv_pmos[delvto]
print @n.xbgr.xm38.nsg13_hv_pmos[factuo]
print @n.xbgr.xm39.nsg13_hv_pmos[w]
print @n.xbgr.xm39.nsg13_hv_pmos[l]
print @n.xbgr.xm39.nsg13_hv_pmos[delvto]
print @n.xbgr.xm39.nsg13_hv_pmos[factuo]
print @n.xbgr.xm40.nsg13_hv_pmos[w]
print @n.xbgr.xm40.nsg13_hv_pmos[l]
print @n.xbgr.xm40.nsg13_hv_pmos[delvto]
print @n.xbgr.xm40.nsg13_hv_pmos[factuo]
print @n.xbgr.xm41.nsg13_hv_pmos[w]
print @n.xbgr.xm41.nsg13_hv_pmos[l]
print @n.xbgr.xm41.nsg13_hv_pmos[delvto]
print @n.xbgr.xm41.nsg13_hv_pmos[factuo]
print @n.xbgr.xm42.nsg13_hv_pmos[w]
print @n.xbgr.xm42.nsg13_hv_pmos[l]
print @n.xbgr.xm42.nsg13_hv_pmos[delvto]
print @n.xbgr.xm42.nsg13_hv_pmos[factuo]
print @n.xbgr.xm43.nsg13_hv_pmos[w]
print @n.xbgr.xm43.nsg13_hv_pmos[l]
print @n.xbgr.xm43.nsg13_hv_pmos[delvto]
print @n.xbgr.xm43.nsg13_hv_pmos[factuo]
print @n.xbgr.xm44.nsg13_hv_pmos[w]
print @n.xbgr.xm44.nsg13_hv_pmos[l]
print @n.xbgr.xm44.nsg13_hv_pmos[delvto]
print @n.xbgr.xm44.nsg13_hv_pmos[factuo]
print @n.xbgr.xm45.nsg13_hv_pmos[w]
print @n.xbgr.xm45.nsg13_hv_pmos[l]
print @n.xbgr.xm45.nsg13_hv_pmos[delvto]
print @n.xbgr.xm45.nsg13_hv_pmos[factuo]
print @n.xbgr.xm46.nsg13_hv_pmos[w]
print @n.xbgr.xm46.nsg13_hv_pmos[l]
print @n.xbgr.xm46.nsg13_hv_pmos[delvto]
print @n.xbgr.xm46.nsg13_hv_pmos[factuo]
print @n.xbgr.xm47.nsg13_hv_pmos[w]
print @n.xbgr.xm47.nsg13_hv_pmos[l]
print @n.xbgr.xm47.nsg13_hv_pmos[delvto]
print @n.xbgr.xm47.nsg13_hv_pmos[factuo]
print @n.xbgr.xm48.nsg13_hv_pmos[w]
print @n.xbgr.xm48.nsg13_hv_pmos[l]
print @n.xbgr.xm48.nsg13_hv_pmos[delvto]
print @n.xbgr.xm48.nsg13_hv_pmos[factuo]
print @n.xbgr.xm49.nsg13_hv_pmos[w]
print @n.xbgr.xm49.nsg13_hv_pmos[l]
print @n.xbgr.xm49.nsg13_hv_pmos[delvto]
print @n.xbgr.xm49.nsg13_hv_pmos[factuo]
print @n.xbgr.xm50.nsg13_hv_pmos[w]
print @n.xbgr.xm50.nsg13_hv_pmos[l]
print @n.xbgr.xm50.nsg13_hv_pmos[delvto]
print @n.xbgr.xm50.nsg13_hv_pmos[factuo]
print @n.xbgr.xm51.nsg13_hv_pmos[w]
print @n.xbgr.xm51.nsg13_hv_pmos[l]
print @n.xbgr.xm51.nsg13_hv_pmos[delvto]
print @n.xbgr.xm51.nsg13_hv_pmos[factuo]
print @n.xbgr.xm52.nsg13_hv_pmos[w]
print @n.xbgr.xm52.nsg13_hv_pmos[l]
print @n.xbgr.xm52.nsg13_hv_pmos[delvto]
print @n.xbgr.xm52.nsg13_hv_pmos[factuo]
print @n.xbgr.xm53.nsg13_hv_pmos[w]
print @n.xbgr.xm53.nsg13_hv_pmos[l]
print @n.xbgr.xm53.nsg13_hv_pmos[delvto]
print @n.xbgr.xm53.nsg13_hv_pmos[factuo]
print @n.xbgr.xm54.nsg13_hv_pmos[w]
print @n.xbgr.xm54.nsg13_hv_pmos[l]
print @n.xbgr.xm54.nsg13_hv_pmos[delvto]
print @n.xbgr.xm54.nsg13_hv_pmos[factuo]
print @q.xbgr.xq55.qnpn13g2[area]
print @q.xbgr.xq56.qnpn13g2[area]
print @q.xbgr.xq57.qnpn13g2[area]
print @q.xbgr.xq58.qnpn13g2[area]
print @q.xbgr.xq59.qnpn13g2[area]
print @q.xbgr.xq60.qnpn13g2[area]
print @q.xbgr.xq61.qnpn13g2[area]
print @q.xbgr.xq62.qnpn13g2[area]
print @q.xbgr.xq63.qnpn13g2[area]
print @q.xbgr.xq64.qnpn13g2[area]
print @q.xbgr.xq65.qnpn13g2[area]
print @q.xbgr.xq66.qnpn13g2[area]
print @q.xbgr.xq67.qnpn13g2[area]
print @q.xbgr.xq68.qnpn13g2[area]
print @q.xbgr.xq69.qnpn13g2[area]
print @q.xbgr.xq70.qnpn13g2[area]
print @q.xbgr.xq71.qnpn13g2[area]
print @q.xbgr.xq72.qnpn13g2[area]
print @q.xbgr.xq73.qnpn13g2[area]
print @q.xbgr.xq74.qnpn13g2[area]
print @q.xbgr.xq75.qnpn13g2[area]
print @q.xbgr.xq76.qnpn13g2[area]
print @n.xbgr.xr77.nr1[nsmm_rsh]
print @n.xbgr.xr77.nr1[nsmm_w]
print @n.xbgr.xr77.nr1[nsmm_l]
print @n.xbgr.xr78.nr1[nsmm_rsh]
print @n.xbgr.xr78.nr1[nsmm_w]
print @n.xbgr.xr78.nr1[nsmm_l]
print @n.xbgr.xr79.nr1[nsmm_rsh]
print @n.xbgr.xr79.nr1[nsmm_w]
print @n.xbgr.xr79.nr1[nsmm_l]
print @n.xbgr.xr80.nr1[nsmm_rsh]
print @n.xbgr.xr80.nr1[nsmm_w]
print @n.xbgr.xr80.nr1[nsmm_l]
print @n.xbgr.xr81.nr1[nsmm_rsh]
print @n.xbgr.xr81.nr1[nsmm_w]
print @n.xbgr.xr81.nr1[nsmm_l]
print @n.xbgr.xr82.nr1[nsmm_rsh]
print @n.xbgr.xr82.nr1[nsmm_w]
print @n.xbgr.xr82.nr1[nsmm_l]
print @n.xbgr.xr83.nr1[nsmm_rsh]
print @n.xbgr.xr83.nr1[nsmm_w]
print @n.xbgr.xr83.nr1[nsmm_l]
print @n.xbgr.xr84.nr1[nsmm_rsh]
print @n.xbgr.xr84.nr1[nsmm_w]
print @n.xbgr.xr84.nr1[nsmm_l]
print @n.xbgr.xr85.nr1[nsmm_rsh]
print @n.xbgr.xr85.nr1[nsmm_w]
print @n.xbgr.xr85.nr1[nsmm_l]
print @n.xbgr.xr86.nr1[nsmm_rsh]
print @n.xbgr.xr86.nr1[nsmm_w]
print @n.xbgr.xr86.nr1[nsmm_l]
print @n.xbgr.xr16_u2.nr1[nsmm_rsh]
print @n.xbgr.xr16_u2.nr1[nsmm_w]
print @n.xbgr.xr16_u2.nr1[nsmm_l]
print @n.xbgr.xr16_u3.nr1[nsmm_rsh]
print @n.xbgr.xr16_u3.nr1[nsmm_w]
print @n.xbgr.xr16_u3.nr1[nsmm_l]
print @n.xbgr.xr16_u4.nr1[nsmm_rsh]
print @n.xbgr.xr16_u4.nr1[nsmm_w]
print @n.xbgr.xr16_u4.nr1[nsmm_l]
print @n.xbgr.xr16_u5.nr1[nsmm_rsh]
print @n.xbgr.xr16_u5.nr1[nsmm_w]
print @n.xbgr.xr16_u5.nr1[nsmm_l]
print @n.xbgr.xr16_u6.nr1[nsmm_rsh]
print @n.xbgr.xr16_u6.nr1[nsmm_w]
print @n.xbgr.xr16_u6.nr1[nsmm_l]
print @n.xbgr.xr16_u7.nr1[nsmm_rsh]
print @n.xbgr.xr16_u7.nr1[nsmm_w]
print @n.xbgr.xr16_u7.nr1[nsmm_l]
print @n.xbgr.xr16_u8.nr1[nsmm_rsh]
print @n.xbgr.xr16_u8.nr1[nsmm_w]
print @n.xbgr.xr16_u8.nr1[nsmm_l]
print @n.xbgr.xr16_u9.nr1[nsmm_rsh]
print @n.xbgr.xr16_u9.nr1[nsmm_w]
print @n.xbgr.xr16_u9.nr1[nsmm_l]
print @n.xbgr.xr16_u10.nr1[nsmm_rsh]
print @n.xbgr.xr16_u10.nr1[nsmm_w]
print @n.xbgr.xr16_u10.nr1[nsmm_l]
print @n.xbgr.xr16_u11.nr1[nsmm_rsh]
print @n.xbgr.xr16_u11.nr1[nsmm_w]
print @n.xbgr.xr16_u11.nr1[nsmm_l]
print @n.xbgr.xr16_u12.nr1[nsmm_rsh]
print @n.xbgr.xr16_u12.nr1[nsmm_w]
print @n.xbgr.xr16_u12.nr1[nsmm_l]
print @n.xbgr.xr16_u13.nr1[nsmm_rsh]
print @n.xbgr.xr16_u13.nr1[nsmm_w]
print @n.xbgr.xr16_u13.nr1[nsmm_l]
print @n.xbgr.xr16_u14.nr1[nsmm_rsh]
print @n.xbgr.xr16_u14.nr1[nsmm_w]
print @n.xbgr.xr16_u14.nr1[nsmm_l]
print @n.xbgr.xr16_u15.nr1[nsmm_rsh]
print @n.xbgr.xr16_u15.nr1[nsmm_w]
print @n.xbgr.xr16_u15.nr1[nsmm_l]
print @n.xbgr.xr16_u16.nr1[nsmm_rsh]
print @n.xbgr.xr16_u16.nr1[nsmm_w]
print @n.xbgr.xr16_u16.nr1[nsmm_l]
print @n.xbgr.xr16_u17.nr1[nsmm_rsh]
print @n.xbgr.xr16_u17.nr1[nsmm_w]
print @n.xbgr.xr16_u17.nr1[nsmm_l]
print @n.xbgr.xr16_u18.nr1[nsmm_rsh]
print @n.xbgr.xr16_u18.nr1[nsmm_w]
print @n.xbgr.xr16_u18.nr1[nsmm_l]
print @n.xbgr.xr16_u19.nr1[nsmm_rsh]
print @n.xbgr.xr16_u19.nr1[nsmm_w]
print @n.xbgr.xr16_u19.nr1[nsmm_l]
print @n.xbgr.xr16_u20.nr1[nsmm_rsh]
print @n.xbgr.xr16_u20.nr1[nsmm_w]
print @n.xbgr.xr16_u20.nr1[nsmm_l]
print @n.xbgr.xr16_u21.nr1[nsmm_rsh]
print @n.xbgr.xr16_u21.nr1[nsmm_w]
print @n.xbgr.xr16_u21.nr1[nsmm_l]
print @n.xbgr.xr16_u22.nr1[nsmm_rsh]
print @n.xbgr.xr16_u22.nr1[nsmm_w]
print @n.xbgr.xr16_u22.nr1[nsmm_l]
print @n.xbgr.xr16_u23.nr1[nsmm_rsh]
print @n.xbgr.xr16_u23.nr1[nsmm_w]
print @n.xbgr.xr16_u23.nr1[nsmm_l]
print @n.xbgr.xr16_u24.nr1[nsmm_rsh]
print @n.xbgr.xr16_u24.nr1[nsmm_w]
print @n.xbgr.xr16_u24.nr1[nsmm_l]
print @n.xbgr.xr17_u2.nr1[nsmm_rsh]
print @n.xbgr.xr17_u2.nr1[nsmm_w]
print @n.xbgr.xr17_u2.nr1[nsmm_l]
print @n.xbgr.xr17_u3.nr1[nsmm_rsh]
print @n.xbgr.xr17_u3.nr1[nsmm_w]
print @n.xbgr.xr17_u3.nr1[nsmm_l]
print @n.xbgr.xr17_u4.nr1[nsmm_rsh]
print @n.xbgr.xr17_u4.nr1[nsmm_w]
print @n.xbgr.xr17_u4.nr1[nsmm_l]
print @n.xbgr.xr18_u2.nr1[nsmm_rsh]
print @n.xbgr.xr18_u2.nr1[nsmm_w]
print @n.xbgr.xr18_u2.nr1[nsmm_l]
print @n.xbgr.xr18_u3.nr1[nsmm_rsh]
print @n.xbgr.xr18_u3.nr1[nsmm_w]
print @n.xbgr.xr18_u3.nr1[nsmm_l]
print @n.xbgr.xr18_u4.nr1[nsmm_rsh]
print @n.xbgr.xr18_u4.nr1[nsmm_w]
print @n.xbgr.xr18_u4.nr1[nsmm_l]
print @n.xbgr.xr19_u2.nr1[nsmm_rsh]
print @n.xbgr.xr19_u2.nr1[nsmm_w]
print @n.xbgr.xr19_u2.nr1[nsmm_l]
print @n.xbgr.xr19_u3.nr1[nsmm_rsh]
print @n.xbgr.xr19_u3.nr1[nsmm_w]
print @n.xbgr.xr19_u3.nr1[nsmm_l]
print @n.xbgr.xr19_u4.nr1[nsmm_rsh]
print @n.xbgr.xr19_u4.nr1[nsmm_w]
print @n.xbgr.xr19_u4.nr1[nsmm_l]
print @n.xbgr.xr20_u2.nr1[nsmm_rsh]
print @n.xbgr.xr20_u2.nr1[nsmm_w]
print @n.xbgr.xr20_u2.nr1[nsmm_l]
print @n.xbgr.xr20_u3.nr1[nsmm_rsh]
print @n.xbgr.xr20_u3.nr1[nsmm_w]
print @n.xbgr.xr20_u3.nr1[nsmm_l]
print @n.xbgr.xr20_u4.nr1[nsmm_rsh]
print @n.xbgr.xr20_u4.nr1[nsmm_w]
print @n.xbgr.xr20_u4.nr1[nsmm_l]
print @n.xbgr.xr21_u2.nr1[nsmm_rsh]
print @n.xbgr.xr21_u2.nr1[nsmm_w]
print @n.xbgr.xr21_u2.nr1[nsmm_l]
print @n.xbgr.xr21_u3.nr1[nsmm_rsh]
print @n.xbgr.xr21_u3.nr1[nsmm_w]
print @n.xbgr.xr21_u3.nr1[nsmm_l]
print @n.xbgr.xr21_u4.nr1[nsmm_rsh]
print @n.xbgr.xr21_u4.nr1[nsmm_w]
print @n.xbgr.xr21_u4.nr1[nsmm_l]
print @n.xbgr.xr22_u2.nr1[nsmm_rsh]
print @n.xbgr.xr22_u2.nr1[nsmm_w]
print @n.xbgr.xr22_u2.nr1[nsmm_l]
print @n.xbgr.xr22_u3.nr1[nsmm_rsh]
print @n.xbgr.xr22_u3.nr1[nsmm_w]
print @n.xbgr.xr22_u3.nr1[nsmm_l]
print @n.xbgr.xr22_u4.nr1[nsmm_rsh]
print @n.xbgr.xr22_u4.nr1[nsmm_w]
print @n.xbgr.xr22_u4.nr1[nsmm_l]
print @n.xbgr.xr23_u2.nr1[nsmm_rsh]
print @n.xbgr.xr23_u2.nr1[nsmm_w]
print @n.xbgr.xr23_u2.nr1[nsmm_l]
print @n.xbgr.xr23_u3.nr1[nsmm_rsh]
print @n.xbgr.xr23_u3.nr1[nsmm_w]
print @n.xbgr.xr23_u3.nr1[nsmm_l]
print @n.xbgr.xr23_u4.nr1[nsmm_rsh]
print @n.xbgr.xr23_u4.nr1[nsmm_w]
print @n.xbgr.xr23_u4.nr1[nsmm_l]
print @n.xbgr.xr23_u5.nr1[nsmm_rsh]
print @n.xbgr.xr23_u5.nr1[nsmm_w]
print @n.xbgr.xr23_u5.nr1[nsmm_l]
print @n.xbgr.xr23_u6.nr1[nsmm_rsh]
print @n.xbgr.xr23_u6.nr1[nsmm_w]
print @n.xbgr.xr23_u6.nr1[nsmm_l]
print @n.xbgr.xr23_u7.nr1[nsmm_rsh]
print @n.xbgr.xr23_u7.nr1[nsmm_w]
print @n.xbgr.xr23_u7.nr1[nsmm_l]
print @n.xbgr.xr23_u8.nr1[nsmm_rsh]
print @n.xbgr.xr23_u8.nr1[nsmm_w]
print @n.xbgr.xr23_u8.nr1[nsmm_l]
print @n.xbgr.xr23_u9.nr1[nsmm_rsh]
print @n.xbgr.xr23_u9.nr1[nsmm_w]
print @n.xbgr.xr23_u9.nr1[nsmm_l]
print @n.xbgr.xr23_u10.nr1[nsmm_rsh]
print @n.xbgr.xr23_u10.nr1[nsmm_w]
print @n.xbgr.xr23_u10.nr1[nsmm_l]
print @n.xbgr.xr23_u11.nr1[nsmm_rsh]
print @n.xbgr.xr23_u11.nr1[nsmm_w]
print @n.xbgr.xr23_u11.nr1[nsmm_l]
print @n.xbgr.xr23_u12.nr1[nsmm_rsh]
print @n.xbgr.xr23_u12.nr1[nsmm_w]
print @n.xbgr.xr23_u12.nr1[nsmm_l]
print @n.xbgr.xr23_u13.nr1[nsmm_rsh]
print @n.xbgr.xr23_u13.nr1[nsmm_w]
print @n.xbgr.xr23_u13.nr1[nsmm_l]
print @n.xbgr.xr23_u14.nr1[nsmm_rsh]
print @n.xbgr.xr23_u14.nr1[nsmm_w]
print @n.xbgr.xr23_u14.nr1[nsmm_l]
print @n.xbgr.xr23_u15.nr1[nsmm_rsh]
print @n.xbgr.xr23_u15.nr1[nsmm_w]
print @n.xbgr.xr23_u15.nr1[nsmm_l]
print @n.xbgr.xr23_u16.nr1[nsmm_rsh]
print @n.xbgr.xr23_u16.nr1[nsmm_w]
print @n.xbgr.xr23_u16.nr1[nsmm_l]
print @n.xbgr.xr23_u17.nr1[nsmm_rsh]
print @n.xbgr.xr23_u17.nr1[nsmm_w]
print @n.xbgr.xr23_u17.nr1[nsmm_l]
print @n.xbgr.xr23_u18.nr1[nsmm_rsh]
print @n.xbgr.xr23_u18.nr1[nsmm_w]
print @n.xbgr.xr23_u18.nr1[nsmm_l]
print @n.xbgr.xr23_u19.nr1[nsmm_rsh]
print @n.xbgr.xr23_u19.nr1[nsmm_w]
print @n.xbgr.xr23_u19.nr1[nsmm_l]
print @n.xbgr.xr23_u20.nr1[nsmm_rsh]
print @n.xbgr.xr23_u20.nr1[nsmm_w]
print @n.xbgr.xr23_u20.nr1[nsmm_l]
print @n.xbgr.xr23_u21.nr1[nsmm_rsh]
print @n.xbgr.xr23_u21.nr1[nsmm_w]
print @n.xbgr.xr23_u21.nr1[nsmm_l]
print @n.xbgr.xr23_u22.nr1[nsmm_rsh]
print @n.xbgr.xr23_u22.nr1[nsmm_w]
print @n.xbgr.xr23_u22.nr1[nsmm_l]
print @n.xbgr.xr23_u23.nr1[nsmm_rsh]
print @n.xbgr.xr23_u23.nr1[nsmm_w]
print @n.xbgr.xr23_u23.nr1[nsmm_l]
print @n.xbgr.xr23_u24.nr1[nsmm_rsh]
print @n.xbgr.xr23_u24.nr1[nsmm_w]
print @n.xbgr.xr23_u24.nr1[nsmm_l]
print @n.xbgr.xr24_u2.nr1[nsmm_rsh]
print @n.xbgr.xr24_u2.nr1[nsmm_w]
print @n.xbgr.xr24_u2.nr1[nsmm_l]
print @n.xbgr.xr24_u3.nr1[nsmm_rsh]
print @n.xbgr.xr24_u3.nr1[nsmm_w]
print @n.xbgr.xr24_u3.nr1[nsmm_l]
print @n.xbgr.xr24_u4.nr1[nsmm_rsh]
print @n.xbgr.xr24_u4.nr1[nsmm_w]
print @n.xbgr.xr24_u4.nr1[nsmm_l]
print @n.xbgr.xr24_u5.nr1[nsmm_rsh]
print @n.xbgr.xr24_u5.nr1[nsmm_w]
print @n.xbgr.xr24_u5.nr1[nsmm_l]
print @n.xbgr.xr24_u6.nr1[nsmm_rsh]
print @n.xbgr.xr24_u6.nr1[nsmm_w]
print @n.xbgr.xr24_u6.nr1[nsmm_l]
print @n.xbgr.xr24_u7.nr1[nsmm_rsh]
print @n.xbgr.xr24_u7.nr1[nsmm_w]
print @n.xbgr.xr24_u7.nr1[nsmm_l]
print @n.xbgr.xr24_u8.nr1[nsmm_rsh]
print @n.xbgr.xr24_u8.nr1[nsmm_w]
print @n.xbgr.xr24_u8.nr1[nsmm_l]
print @n.xbgr.xr24_u9.nr1[nsmm_rsh]
print @n.xbgr.xr24_u9.nr1[nsmm_w]
print @n.xbgr.xr24_u9.nr1[nsmm_l]
print @n.xbgr.xr24_u10.nr1[nsmm_rsh]
print @n.xbgr.xr24_u10.nr1[nsmm_w]
print @n.xbgr.xr24_u10.nr1[nsmm_l]
print @n.xbgr.xr24_u11.nr1[nsmm_rsh]
print @n.xbgr.xr24_u11.nr1[nsmm_w]
print @n.xbgr.xr24_u11.nr1[nsmm_l]
print @n.xbgr.xr24_u12.nr1[nsmm_rsh]
print @n.xbgr.xr24_u12.nr1[nsmm_w]
print @n.xbgr.xr24_u12.nr1[nsmm_l]
print @n.xbgr.xr24_u13.nr1[nsmm_rsh]
print @n.xbgr.xr24_u13.nr1[nsmm_w]
print @n.xbgr.xr24_u13.nr1[nsmm_l]
print @n.xbgr.xr24_u14.nr1[nsmm_rsh]
print @n.xbgr.xr24_u14.nr1[nsmm_w]
print @n.xbgr.xr24_u14.nr1[nsmm_l]
print @n.xbgr.xr24_u15.nr1[nsmm_rsh]
print @n.xbgr.xr24_u15.nr1[nsmm_w]
print @n.xbgr.xr24_u15.nr1[nsmm_l]
print @n.xbgr.xr24_u16.nr1[nsmm_rsh]
print @n.xbgr.xr24_u16.nr1[nsmm_w]
print @n.xbgr.xr24_u16.nr1[nsmm_l]
print @n.xbgr.xr24_u17.nr1[nsmm_rsh]
print @n.xbgr.xr24_u17.nr1[nsmm_w]
print @n.xbgr.xr24_u17.nr1[nsmm_l]
print @n.xbgr.xr24_u18.nr1[nsmm_rsh]
print @n.xbgr.xr24_u18.nr1[nsmm_w]
print @n.xbgr.xr24_u18.nr1[nsmm_l]
print @n.xbgr.xr24_u19.nr1[nsmm_rsh]
print @n.xbgr.xr24_u19.nr1[nsmm_w]
print @n.xbgr.xr24_u19.nr1[nsmm_l]
print @n.xbgr.xr24_u20.nr1[nsmm_rsh]
print @n.xbgr.xr24_u20.nr1[nsmm_w]
print @n.xbgr.xr24_u20.nr1[nsmm_l]
print @n.xbgr.xr24_u21.nr1[nsmm_rsh]
print @n.xbgr.xr24_u21.nr1[nsmm_w]
print @n.xbgr.xr24_u21.nr1[nsmm_l]
print @n.xbgr.xr24_u22.nr1[nsmm_rsh]
print @n.xbgr.xr24_u22.nr1[nsmm_w]
print @n.xbgr.xr24_u22.nr1[nsmm_l]
print @n.xbgr.xr24_u23.nr1[nsmm_rsh]
print @n.xbgr.xr24_u23.nr1[nsmm_w]
print @n.xbgr.xr24_u23.nr1[nsmm_l]
print @n.xbgr.xr24_u24.nr1[nsmm_rsh]
print @n.xbgr.xr24_u24.nr1[nsmm_w]
print @n.xbgr.xr24_u24.nr1[nsmm_l]
print @n.xbgr.xr25_u2.nr1[nsmm_rsh]
print @n.xbgr.xr25_u2.nr1[nsmm_w]
print @n.xbgr.xr25_u2.nr1[nsmm_l]
print @n.xbgr.xr25_u3.nr1[nsmm_rsh]
print @n.xbgr.xr25_u3.nr1[nsmm_w]
print @n.xbgr.xr25_u3.nr1[nsmm_l]
print @n.xbgr.xr25_u4.nr1[nsmm_rsh]
print @n.xbgr.xr25_u4.nr1[nsmm_w]
print @n.xbgr.xr25_u4.nr1[nsmm_l]
print @n.xbgr.xr25_u5.nr1[nsmm_rsh]
print @n.xbgr.xr25_u5.nr1[nsmm_w]
print @n.xbgr.xr25_u5.nr1[nsmm_l]
print @n.xbgr.xr25_u6.nr1[nsmm_rsh]
print @n.xbgr.xr25_u6.nr1[nsmm_w]
print @n.xbgr.xr25_u6.nr1[nsmm_l]
print @n.xbgr.xr25_u7.nr1[nsmm_rsh]
print @n.xbgr.xr25_u7.nr1[nsmm_w]
print @n.xbgr.xr25_u7.nr1[nsmm_l]
print @n.xbgr.xr25_u8.nr1[nsmm_rsh]
print @n.xbgr.xr25_u8.nr1[nsmm_w]
print @n.xbgr.xr25_u8.nr1[nsmm_l]
print @n.xbgr.xr25_u9.nr1[nsmm_rsh]
print @n.xbgr.xr25_u9.nr1[nsmm_w]
print @n.xbgr.xr25_u9.nr1[nsmm_l]
print @n.xbgr.xr25_u10.nr1[nsmm_rsh]
print @n.xbgr.xr25_u10.nr1[nsmm_w]
print @n.xbgr.xr25_u10.nr1[nsmm_l]
print @n.xbgr.xr25_u11.nr1[nsmm_rsh]
print @n.xbgr.xr25_u11.nr1[nsmm_w]
print @n.xbgr.xr25_u11.nr1[nsmm_l]
print @n.xbgr.xr25_u12.nr1[nsmm_rsh]
print @n.xbgr.xr25_u12.nr1[nsmm_w]
print @n.xbgr.xr25_u12.nr1[nsmm_l]
print @n.xbgr.xr25_u13.nr1[nsmm_rsh]
print @n.xbgr.xr25_u13.nr1[nsmm_w]
print @n.xbgr.xr25_u13.nr1[nsmm_l]
print @n.xbgr.xr25_u14.nr1[nsmm_rsh]
print @n.xbgr.xr25_u14.nr1[nsmm_w]
print @n.xbgr.xr25_u14.nr1[nsmm_l]
print @n.xbgr.xr25_u15.nr1[nsmm_rsh]
print @n.xbgr.xr25_u15.nr1[nsmm_w]
print @n.xbgr.xr25_u15.nr1[nsmm_l]
print @n.xbgr.xr25_u16.nr1[nsmm_rsh]
print @n.xbgr.xr25_u16.nr1[nsmm_w]
print @n.xbgr.xr25_u16.nr1[nsmm_l]
print @n.xbgr.xr25_u17.nr1[nsmm_rsh]
print @n.xbgr.xr25_u17.nr1[nsmm_w]
print @n.xbgr.xr25_u17.nr1[nsmm_l]
print @n.xbgr.xr25_u18.nr1[nsmm_rsh]
print @n.xbgr.xr25_u18.nr1[nsmm_w]
print @n.xbgr.xr25_u18.nr1[nsmm_l]
print @n.xbgr.xr25_u19.nr1[nsmm_rsh]
print @n.xbgr.xr25_u19.nr1[nsmm_w]
print @n.xbgr.xr25_u19.nr1[nsmm_l]
print @n.xbgr.xr25_u20.nr1[nsmm_rsh]
print @n.xbgr.xr25_u20.nr1[nsmm_w]
print @n.xbgr.xr25_u20.nr1[nsmm_l]
print @n.xbgr.xr25_u21.nr1[nsmm_rsh]
print @n.xbgr.xr25_u21.nr1[nsmm_w]
print @n.xbgr.xr25_u21.nr1[nsmm_l]
print @n.xbgr.xr25_u22.nr1[nsmm_rsh]
print @n.xbgr.xr25_u22.nr1[nsmm_w]
print @n.xbgr.xr25_u22.nr1[nsmm_l]
print @n.xbgr.xr25_u23.nr1[nsmm_rsh]
print @n.xbgr.xr25_u23.nr1[nsmm_w]
print @n.xbgr.xr25_u23.nr1[nsmm_l]
print @n.xbgr.xr25_u24.nr1[nsmm_rsh]
print @n.xbgr.xr25_u24.nr1[nsmm_w]
print @n.xbgr.xr25_u24.nr1[nsmm_l]
print @n.xbgr.xr26_u2.nr1[nsmm_rsh]
print @n.xbgr.xr26_u2.nr1[nsmm_w]
print @n.xbgr.xr26_u2.nr1[nsmm_l]
print @n.xbgr.xr26_u3.nr1[nsmm_rsh]
print @n.xbgr.xr26_u3.nr1[nsmm_w]
print @n.xbgr.xr26_u3.nr1[nsmm_l]
print @n.xbgr.xr26_u4.nr1[nsmm_rsh]
print @n.xbgr.xr26_u4.nr1[nsmm_w]
print @n.xbgr.xr26_u4.nr1[nsmm_l]
print @n.xbgr.xr26_u5.nr1[nsmm_rsh]
print @n.xbgr.xr26_u5.nr1[nsmm_w]
print @n.xbgr.xr26_u5.nr1[nsmm_l]
print @n.xbgr.xr26_u6.nr1[nsmm_rsh]
print @n.xbgr.xr26_u6.nr1[nsmm_w]
print @n.xbgr.xr26_u6.nr1[nsmm_l]
print @n.xbgr.xr26_u7.nr1[nsmm_rsh]
print @n.xbgr.xr26_u7.nr1[nsmm_w]
print @n.xbgr.xr26_u7.nr1[nsmm_l]
print @n.xbgr.xr26_u8.nr1[nsmm_rsh]
print @n.xbgr.xr26_u8.nr1[nsmm_w]
print @n.xbgr.xr26_u8.nr1[nsmm_l]
print @n.xbgr.xr26_u9.nr1[nsmm_rsh]
print @n.xbgr.xr26_u9.nr1[nsmm_w]
print @n.xbgr.xr26_u9.nr1[nsmm_l]
print @n.xbgr.xr26_u10.nr1[nsmm_rsh]
print @n.xbgr.xr26_u10.nr1[nsmm_w]
print @n.xbgr.xr26_u10.nr1[nsmm_l]
print @n.xbgr.xr26_u11.nr1[nsmm_rsh]
print @n.xbgr.xr26_u11.nr1[nsmm_w]
print @n.xbgr.xr26_u11.nr1[nsmm_l]
print @n.xbgr.xr26_u12.nr1[nsmm_rsh]
print @n.xbgr.xr26_u12.nr1[nsmm_w]
print @n.xbgr.xr26_u12.nr1[nsmm_l]
print @n.xbgr.xr26_u13.nr1[nsmm_rsh]
print @n.xbgr.xr26_u13.nr1[nsmm_w]
print @n.xbgr.xr26_u13.nr1[nsmm_l]
print @n.xbgr.xr26_u14.nr1[nsmm_rsh]
print @n.xbgr.xr26_u14.nr1[nsmm_w]
print @n.xbgr.xr26_u14.nr1[nsmm_l]
print @n.xbgr.xr26_u15.nr1[nsmm_rsh]
print @n.xbgr.xr26_u15.nr1[nsmm_w]
print @n.xbgr.xr26_u15.nr1[nsmm_l]
print @n.xbgr.xr26_u16.nr1[nsmm_rsh]
print @n.xbgr.xr26_u16.nr1[nsmm_w]
print @n.xbgr.xr26_u16.nr1[nsmm_l]
print @n.xbgr.xr26_u17.nr1[nsmm_rsh]
print @n.xbgr.xr26_u17.nr1[nsmm_w]
print @n.xbgr.xr26_u17.nr1[nsmm_l]
print @n.xbgr.xr26_u18.nr1[nsmm_rsh]
print @n.xbgr.xr26_u18.nr1[nsmm_w]
print @n.xbgr.xr26_u18.nr1[nsmm_l]
print @n.xbgr.xr26_u19.nr1[nsmm_rsh]
print @n.xbgr.xr26_u19.nr1[nsmm_w]
print @n.xbgr.xr26_u19.nr1[nsmm_l]
print @n.xbgr.xr26_u20.nr1[nsmm_rsh]
print @n.xbgr.xr26_u20.nr1[nsmm_w]
print @n.xbgr.xr26_u20.nr1[nsmm_l]
print @n.xbgr.xr26_u21.nr1[nsmm_rsh]
print @n.xbgr.xr26_u21.nr1[nsmm_w]
print @n.xbgr.xr26_u21.nr1[nsmm_l]
print @n.xbgr.xr26_u22.nr1[nsmm_rsh]
print @n.xbgr.xr26_u22.nr1[nsmm_w]
print @n.xbgr.xr26_u22.nr1[nsmm_l]
print @n.xbgr.xr26_u23.nr1[nsmm_rsh]
print @n.xbgr.xr26_u23.nr1[nsmm_w]
print @n.xbgr.xr26_u23.nr1[nsmm_l]
print @n.xbgr.xr26_u24.nr1[nsmm_rsh]
print @n.xbgr.xr26_u24.nr1[nsmm_w]
print @n.xbgr.xr26_u24.nr1[nsmm_l]
print @n.xbgr.xm34_u2.nsg13_hv_nmos[w]
print @n.xbgr.xm34_u2.nsg13_hv_nmos[l]
print @n.xbgr.xm34_u2.nsg13_hv_nmos[delvto]
print @n.xbgr.xm34_u2.nsg13_hv_nmos[factuo]
print @n.xbgr.xm34_u3.nsg13_hv_nmos[w]
print @n.xbgr.xm34_u3.nsg13_hv_nmos[l]
print @n.xbgr.xm34_u3.nsg13_hv_nmos[delvto]
print @n.xbgr.xm34_u3.nsg13_hv_nmos[factuo]
print @n.xbgr.xm34_u4.nsg13_hv_nmos[w]
print @n.xbgr.xm34_u4.nsg13_hv_nmos[l]
print @n.xbgr.xm34_u4.nsg13_hv_nmos[delvto]
print @n.xbgr.xm34_u4.nsg13_hv_nmos[factuo]
print @n.xbgr.xm34_u5.nsg13_hv_nmos[w]
print @n.xbgr.xm34_u5.nsg13_hv_nmos[l]
print @n.xbgr.xm34_u5.nsg13_hv_nmos[delvto]
print @n.xbgr.xm34_u5.nsg13_hv_nmos[factuo]
print @n.xbgr.xm34_u6.nsg13_hv_nmos[w]
print @n.xbgr.xm34_u6.nsg13_hv_nmos[l]
print @n.xbgr.xm34_u6.nsg13_hv_nmos[delvto]
print @n.xbgr.xm34_u6.nsg13_hv_nmos[factuo]
print @n.xbgr.xm34_u7.nsg13_hv_nmos[w]
print @n.xbgr.xm34_u7.nsg13_hv_nmos[l]
print @n.xbgr.xm34_u7.nsg13_hv_nmos[delvto]
print @n.xbgr.xm34_u7.nsg13_hv_nmos[factuo]
print @n.xbgr.xm34_u8.nsg13_hv_nmos[w]
print @n.xbgr.xm34_u8.nsg13_hv_nmos[l]
print @n.xbgr.xm34_u8.nsg13_hv_nmos[delvto]
print @n.xbgr.xm34_u8.nsg13_hv_nmos[factuo]
print @n.xbgr.xm34_u9.nsg13_hv_nmos[w]
print @n.xbgr.xm34_u9.nsg13_hv_nmos[l]
print @n.xbgr.xm34_u9.nsg13_hv_nmos[delvto]
print @n.xbgr.xm34_u9.nsg13_hv_nmos[factuo]
print @n.xbgr.xm34_u10.nsg13_hv_nmos[w]
print @n.xbgr.xm34_u10.nsg13_hv_nmos[l]
print @n.xbgr.xm34_u10.nsg13_hv_nmos[delvto]
print @n.xbgr.xm34_u10.nsg13_hv_nmos[factuo]
print @n.xbgr.xm34_u11.nsg13_hv_nmos[w]
print @n.xbgr.xm34_u11.nsg13_hv_nmos[l]
print @n.xbgr.xm34_u11.nsg13_hv_nmos[delvto]
print @n.xbgr.xm34_u11.nsg13_hv_nmos[factuo]
print @n.xbgr.xm34_u12.nsg13_hv_nmos[w]
print @n.xbgr.xm34_u12.nsg13_hv_nmos[l]
print @n.xbgr.xm34_u12.nsg13_hv_nmos[delvto]
print @n.xbgr.xm34_u12.nsg13_hv_nmos[factuo]
print @n.xbgr.xm34_u13.nsg13_hv_nmos[w]
print @n.xbgr.xm34_u13.nsg13_hv_nmos[l]
print @n.xbgr.xm34_u13.nsg13_hv_nmos[delvto]
print @n.xbgr.xm34_u13.nsg13_hv_nmos[factuo]
print @n.xbgr.xm34_u14.nsg13_hv_nmos[w]
print @n.xbgr.xm34_u14.nsg13_hv_nmos[l]
print @n.xbgr.xm34_u14.nsg13_hv_nmos[delvto]
print @n.xbgr.xm34_u14.nsg13_hv_nmos[factuo]
print @n.xbgr.xm34_u15.nsg13_hv_nmos[w]
print @n.xbgr.xm34_u15.nsg13_hv_nmos[l]
print @n.xbgr.xm34_u15.nsg13_hv_nmos[delvto]
print @n.xbgr.xm34_u15.nsg13_hv_nmos[factuo]
print @n.xbgr.xm34_u16.nsg13_hv_nmos[w]
print @n.xbgr.xm34_u16.nsg13_hv_nmos[l]
print @n.xbgr.xm34_u16.nsg13_hv_nmos[delvto]
print @n.xbgr.xm34_u16.nsg13_hv_nmos[factuo]
print @n.xbgr.xm34_u17.nsg13_hv_nmos[w]
print @n.xbgr.xm34_u17.nsg13_hv_nmos[l]
print @n.xbgr.xm34_u17.nsg13_hv_nmos[delvto]
print @n.xbgr.xm34_u17.nsg13_hv_nmos[factuo]
print @n.xbgr.xm34_u18.nsg13_hv_nmos[w]
print @n.xbgr.xm34_u18.nsg13_hv_nmos[l]
print @n.xbgr.xm34_u18.nsg13_hv_nmos[delvto]
print @n.xbgr.xm34_u18.nsg13_hv_nmos[factuo]
print @n.xbgr.xm34_u19.nsg13_hv_nmos[w]
print @n.xbgr.xm34_u19.nsg13_hv_nmos[l]
print @n.xbgr.xm34_u19.nsg13_hv_nmos[delvto]
print @n.xbgr.xm34_u19.nsg13_hv_nmos[factuo]
print @n.xbgr.xm34_u20.nsg13_hv_nmos[w]
print @n.xbgr.xm34_u20.nsg13_hv_nmos[l]
print @n.xbgr.xm34_u20.nsg13_hv_nmos[delvto]
print @n.xbgr.xm34_u20.nsg13_hv_nmos[factuo]
print @n.xbgr.xm34_u21.nsg13_hv_nmos[w]
print @n.xbgr.xm34_u21.nsg13_hv_nmos[l]
print @n.xbgr.xm34_u21.nsg13_hv_nmos[delvto]
print @n.xbgr.xm34_u21.nsg13_hv_nmos[factuo]
print @n.xbgr.xm34_u22.nsg13_hv_nmos[w]
print @n.xbgr.xm34_u22.nsg13_hv_nmos[l]
print @n.xbgr.xm34_u22.nsg13_hv_nmos[delvto]
print @n.xbgr.xm34_u22.nsg13_hv_nmos[factuo]
print @n.xbgr.xm34_u23.nsg13_hv_nmos[w]
print @n.xbgr.xm34_u23.nsg13_hv_nmos[l]
print @n.xbgr.xm34_u23.nsg13_hv_nmos[delvto]
print @n.xbgr.xm34_u23.nsg13_hv_nmos[factuo]
print @n.xbgr.xm34_u24.nsg13_hv_nmos[w]
print @n.xbgr.xm34_u24.nsg13_hv_nmos[l]
print @n.xbgr.xm34_u24.nsg13_hv_nmos[delvto]
print @n.xbgr.xm34_u24.nsg13_hv_nmos[factuo]
print @n.xbgr.xm35_u2.nsg13_hv_nmos[w]
print @n.xbgr.xm35_u2.nsg13_hv_nmos[l]
print @n.xbgr.xm35_u2.nsg13_hv_nmos[delvto]
print @n.xbgr.xm35_u2.nsg13_hv_nmos[factuo]
print @n.xbgr.xm35_u3.nsg13_hv_nmos[w]
print @n.xbgr.xm35_u3.nsg13_hv_nmos[l]
print @n.xbgr.xm35_u3.nsg13_hv_nmos[delvto]
print @n.xbgr.xm35_u3.nsg13_hv_nmos[factuo]
print @n.xbgr.xm35_u4.nsg13_hv_nmos[w]
print @n.xbgr.xm35_u4.nsg13_hv_nmos[l]
print @n.xbgr.xm35_u4.nsg13_hv_nmos[delvto]
print @n.xbgr.xm35_u4.nsg13_hv_nmos[factuo]
print @n.xbgr.xm35_u5.nsg13_hv_nmos[w]
print @n.xbgr.xm35_u5.nsg13_hv_nmos[l]
print @n.xbgr.xm35_u5.nsg13_hv_nmos[delvto]
print @n.xbgr.xm35_u5.nsg13_hv_nmos[factuo]
print @n.xbgr.xm35_u6.nsg13_hv_nmos[w]
print @n.xbgr.xm35_u6.nsg13_hv_nmos[l]
print @n.xbgr.xm35_u6.nsg13_hv_nmos[delvto]
print @n.xbgr.xm35_u6.nsg13_hv_nmos[factuo]
print @n.xbgr.xm35_u7.nsg13_hv_nmos[w]
print @n.xbgr.xm35_u7.nsg13_hv_nmos[l]
print @n.xbgr.xm35_u7.nsg13_hv_nmos[delvto]
print @n.xbgr.xm35_u7.nsg13_hv_nmos[factuo]
print @n.xbgr.xm35_u8.nsg13_hv_nmos[w]
print @n.xbgr.xm35_u8.nsg13_hv_nmos[l]
print @n.xbgr.xm35_u8.nsg13_hv_nmos[delvto]
print @n.xbgr.xm35_u8.nsg13_hv_nmos[factuo]
print @n.xbgr.xm35_u9.nsg13_hv_nmos[w]
print @n.xbgr.xm35_u9.nsg13_hv_nmos[l]
print @n.xbgr.xm35_u9.nsg13_hv_nmos[delvto]
print @n.xbgr.xm35_u9.nsg13_hv_nmos[factuo]
print @n.xbgr.xm35_u10.nsg13_hv_nmos[w]
print @n.xbgr.xm35_u10.nsg13_hv_nmos[l]
print @n.xbgr.xm35_u10.nsg13_hv_nmos[delvto]
print @n.xbgr.xm35_u10.nsg13_hv_nmos[factuo]
print @n.xbgr.xm35_u11.nsg13_hv_nmos[w]
print @n.xbgr.xm35_u11.nsg13_hv_nmos[l]
print @n.xbgr.xm35_u11.nsg13_hv_nmos[delvto]
print @n.xbgr.xm35_u11.nsg13_hv_nmos[factuo]
print @n.xbgr.xm35_u12.nsg13_hv_nmos[w]
print @n.xbgr.xm35_u12.nsg13_hv_nmos[l]
print @n.xbgr.xm35_u12.nsg13_hv_nmos[delvto]
print @n.xbgr.xm35_u12.nsg13_hv_nmos[factuo]
print @n.xbgr.xm35_u13.nsg13_hv_nmos[w]
print @n.xbgr.xm35_u13.nsg13_hv_nmos[l]
print @n.xbgr.xm35_u13.nsg13_hv_nmos[delvto]
print @n.xbgr.xm35_u13.nsg13_hv_nmos[factuo]
print @n.xbgr.xm35_u14.nsg13_hv_nmos[w]
print @n.xbgr.xm35_u14.nsg13_hv_nmos[l]
print @n.xbgr.xm35_u14.nsg13_hv_nmos[delvto]
print @n.xbgr.xm35_u14.nsg13_hv_nmos[factuo]
print @n.xbgr.xm35_u15.nsg13_hv_nmos[w]
print @n.xbgr.xm35_u15.nsg13_hv_nmos[l]
print @n.xbgr.xm35_u15.nsg13_hv_nmos[delvto]
print @n.xbgr.xm35_u15.nsg13_hv_nmos[factuo]
print @n.xbgr.xm35_u16.nsg13_hv_nmos[w]
print @n.xbgr.xm35_u16.nsg13_hv_nmos[l]
print @n.xbgr.xm35_u16.nsg13_hv_nmos[delvto]
print @n.xbgr.xm35_u16.nsg13_hv_nmos[factuo]
print @n.xbgr.xm35_u17.nsg13_hv_nmos[w]
print @n.xbgr.xm35_u17.nsg13_hv_nmos[l]
print @n.xbgr.xm35_u17.nsg13_hv_nmos[delvto]
print @n.xbgr.xm35_u17.nsg13_hv_nmos[factuo]
print @n.xbgr.xm35_u18.nsg13_hv_nmos[w]
print @n.xbgr.xm35_u18.nsg13_hv_nmos[l]
print @n.xbgr.xm35_u18.nsg13_hv_nmos[delvto]
print @n.xbgr.xm35_u18.nsg13_hv_nmos[factuo]
print @n.xbgr.xm35_u19.nsg13_hv_nmos[w]
print @n.xbgr.xm35_u19.nsg13_hv_nmos[l]
print @n.xbgr.xm35_u19.nsg13_hv_nmos[delvto]
print @n.xbgr.xm35_u19.nsg13_hv_nmos[factuo]
print @n.xbgr.xm35_u20.nsg13_hv_nmos[w]
print @n.xbgr.xm35_u20.nsg13_hv_nmos[l]
print @n.xbgr.xm35_u20.nsg13_hv_nmos[delvto]
print @n.xbgr.xm35_u20.nsg13_hv_nmos[factuo]
print @n.xbgr.xm35_u21.nsg13_hv_nmos[w]
print @n.xbgr.xm35_u21.nsg13_hv_nmos[l]
print @n.xbgr.xm35_u21.nsg13_hv_nmos[delvto]
print @n.xbgr.xm35_u21.nsg13_hv_nmos[factuo]
print @n.xbgr.xm35_u22.nsg13_hv_nmos[w]
print @n.xbgr.xm35_u22.nsg13_hv_nmos[l]
print @n.xbgr.xm35_u22.nsg13_hv_nmos[delvto]
print @n.xbgr.xm35_u22.nsg13_hv_nmos[factuo]
print @n.xbgr.xm35_u23.nsg13_hv_nmos[w]
print @n.xbgr.xm35_u23.nsg13_hv_nmos[l]
print @n.xbgr.xm35_u23.nsg13_hv_nmos[delvto]
print @n.xbgr.xm35_u23.nsg13_hv_nmos[factuo]
print @n.xbgr.xm35_u24.nsg13_hv_nmos[w]
print @n.xbgr.xm35_u24.nsg13_hv_nmos[l]
print @n.xbgr.xm35_u24.nsg13_hv_nmos[delvto]
print @n.xbgr.xm35_u24.nsg13_hv_nmos[factuo]
print @n.xbgr.xm36_u2.nsg13_hv_nmos[w]
print @n.xbgr.xm36_u2.nsg13_hv_nmos[l]
print @n.xbgr.xm36_u2.nsg13_hv_nmos[delvto]
print @n.xbgr.xm36_u2.nsg13_hv_nmos[factuo]
print @n.xbgr.xm36_u3.nsg13_hv_nmos[w]
print @n.xbgr.xm36_u3.nsg13_hv_nmos[l]
print @n.xbgr.xm36_u3.nsg13_hv_nmos[delvto]
print @n.xbgr.xm36_u3.nsg13_hv_nmos[factuo]
print @n.xbgr.xm36_u4.nsg13_hv_nmos[w]
print @n.xbgr.xm36_u4.nsg13_hv_nmos[l]
print @n.xbgr.xm36_u4.nsg13_hv_nmos[delvto]
print @n.xbgr.xm36_u4.nsg13_hv_nmos[factuo]
print @n.xbgr.xm36_u5.nsg13_hv_nmos[w]
print @n.xbgr.xm36_u5.nsg13_hv_nmos[l]
print @n.xbgr.xm36_u5.nsg13_hv_nmos[delvto]
print @n.xbgr.xm36_u5.nsg13_hv_nmos[factuo]
print @n.xbgr.xm36_u6.nsg13_hv_nmos[w]
print @n.xbgr.xm36_u6.nsg13_hv_nmos[l]
print @n.xbgr.xm36_u6.nsg13_hv_nmos[delvto]
print @n.xbgr.xm36_u6.nsg13_hv_nmos[factuo]
print @n.xbgr.xm36_u7.nsg13_hv_nmos[w]
print @n.xbgr.xm36_u7.nsg13_hv_nmos[l]
print @n.xbgr.xm36_u7.nsg13_hv_nmos[delvto]
print @n.xbgr.xm36_u7.nsg13_hv_nmos[factuo]
print @n.xbgr.xm36_u8.nsg13_hv_nmos[w]
print @n.xbgr.xm36_u8.nsg13_hv_nmos[l]
print @n.xbgr.xm36_u8.nsg13_hv_nmos[delvto]
print @n.xbgr.xm36_u8.nsg13_hv_nmos[factuo]
print @n.xbgr.xm36_u9.nsg13_hv_nmos[w]
print @n.xbgr.xm36_u9.nsg13_hv_nmos[l]
print @n.xbgr.xm36_u9.nsg13_hv_nmos[delvto]
print @n.xbgr.xm36_u9.nsg13_hv_nmos[factuo]
print @n.xbgr.xm36_u10.nsg13_hv_nmos[w]
print @n.xbgr.xm36_u10.nsg13_hv_nmos[l]
print @n.xbgr.xm36_u10.nsg13_hv_nmos[delvto]
print @n.xbgr.xm36_u10.nsg13_hv_nmos[factuo]
print @n.xbgr.xm36_u11.nsg13_hv_nmos[w]
print @n.xbgr.xm36_u11.nsg13_hv_nmos[l]
print @n.xbgr.xm36_u11.nsg13_hv_nmos[delvto]
print @n.xbgr.xm36_u11.nsg13_hv_nmos[factuo]
print @n.xbgr.xm36_u12.nsg13_hv_nmos[w]
print @n.xbgr.xm36_u12.nsg13_hv_nmos[l]
print @n.xbgr.xm36_u12.nsg13_hv_nmos[delvto]
print @n.xbgr.xm36_u12.nsg13_hv_nmos[factuo]
print @n.xbgr.xm36_u13.nsg13_hv_nmos[w]
print @n.xbgr.xm36_u13.nsg13_hv_nmos[l]
print @n.xbgr.xm36_u13.nsg13_hv_nmos[delvto]
print @n.xbgr.xm36_u13.nsg13_hv_nmos[factuo]
print @n.xbgr.xm36_u14.nsg13_hv_nmos[w]
print @n.xbgr.xm36_u14.nsg13_hv_nmos[l]
print @n.xbgr.xm36_u14.nsg13_hv_nmos[delvto]
print @n.xbgr.xm36_u14.nsg13_hv_nmos[factuo]
print @n.xbgr.xm36_u15.nsg13_hv_nmos[w]
print @n.xbgr.xm36_u15.nsg13_hv_nmos[l]
print @n.xbgr.xm36_u15.nsg13_hv_nmos[delvto]
print @n.xbgr.xm36_u15.nsg13_hv_nmos[factuo]
print @n.xbgr.xm36_u16.nsg13_hv_nmos[w]
print @n.xbgr.xm36_u16.nsg13_hv_nmos[l]
print @n.xbgr.xm36_u16.nsg13_hv_nmos[delvto]
print @n.xbgr.xm36_u16.nsg13_hv_nmos[factuo]
print @n.xbgr.xm36_u17.nsg13_hv_nmos[w]
print @n.xbgr.xm36_u17.nsg13_hv_nmos[l]
print @n.xbgr.xm36_u17.nsg13_hv_nmos[delvto]
print @n.xbgr.xm36_u17.nsg13_hv_nmos[factuo]
print @n.xbgr.xm36_u18.nsg13_hv_nmos[w]
print @n.xbgr.xm36_u18.nsg13_hv_nmos[l]
print @n.xbgr.xm36_u18.nsg13_hv_nmos[delvto]
print @n.xbgr.xm36_u18.nsg13_hv_nmos[factuo]
print @n.xbgr.xm36_u19.nsg13_hv_nmos[w]
print @n.xbgr.xm36_u19.nsg13_hv_nmos[l]
print @n.xbgr.xm36_u19.nsg13_hv_nmos[delvto]
print @n.xbgr.xm36_u19.nsg13_hv_nmos[factuo]
print @n.xbgr.xm36_u20.nsg13_hv_nmos[w]
print @n.xbgr.xm36_u20.nsg13_hv_nmos[l]
print @n.xbgr.xm36_u20.nsg13_hv_nmos[delvto]
print @n.xbgr.xm36_u20.nsg13_hv_nmos[factuo]
print @n.xbgr.xm36_u21.nsg13_hv_nmos[w]
print @n.xbgr.xm36_u21.nsg13_hv_nmos[l]
print @n.xbgr.xm36_u21.nsg13_hv_nmos[delvto]
print @n.xbgr.xm36_u21.nsg13_hv_nmos[factuo]
print @n.xbgr.xm36_u22.nsg13_hv_nmos[w]
print @n.xbgr.xm36_u22.nsg13_hv_nmos[l]
print @n.xbgr.xm36_u22.nsg13_hv_nmos[delvto]
print @n.xbgr.xm36_u22.nsg13_hv_nmos[factuo]
print @n.xbgr.xm36_u23.nsg13_hv_nmos[w]
print @n.xbgr.xm36_u23.nsg13_hv_nmos[l]
print @n.xbgr.xm36_u23.nsg13_hv_nmos[delvto]
print @n.xbgr.xm36_u23.nsg13_hv_nmos[factuo]
print @n.xbgr.xm36_u24.nsg13_hv_nmos[w]
print @n.xbgr.xm36_u24.nsg13_hv_nmos[l]
print @n.xbgr.xm36_u24.nsg13_hv_nmos[delvto]
print @n.xbgr.xm36_u24.nsg13_hv_nmos[factuo]
print @n.xbgr.xm37_u2.nsg13_hv_nmos[w]
print @n.xbgr.xm37_u2.nsg13_hv_nmos[l]
print @n.xbgr.xm37_u2.nsg13_hv_nmos[delvto]
print @n.xbgr.xm37_u2.nsg13_hv_nmos[factuo]
print @n.xbgr.xm37_u3.nsg13_hv_nmos[w]
print @n.xbgr.xm37_u3.nsg13_hv_nmos[l]
print @n.xbgr.xm37_u3.nsg13_hv_nmos[delvto]
print @n.xbgr.xm37_u3.nsg13_hv_nmos[factuo]
print @n.xbgr.xm37_u4.nsg13_hv_nmos[w]
print @n.xbgr.xm37_u4.nsg13_hv_nmos[l]
print @n.xbgr.xm37_u4.nsg13_hv_nmos[delvto]
print @n.xbgr.xm37_u4.nsg13_hv_nmos[factuo]
print @n.xbgr.xm37_u5.nsg13_hv_nmos[w]
print @n.xbgr.xm37_u5.nsg13_hv_nmos[l]
print @n.xbgr.xm37_u5.nsg13_hv_nmos[delvto]
print @n.xbgr.xm37_u5.nsg13_hv_nmos[factuo]
print @n.xbgr.xm37_u6.nsg13_hv_nmos[w]
print @n.xbgr.xm37_u6.nsg13_hv_nmos[l]
print @n.xbgr.xm37_u6.nsg13_hv_nmos[delvto]
print @n.xbgr.xm37_u6.nsg13_hv_nmos[factuo]
print @n.xbgr.xm37_u7.nsg13_hv_nmos[w]
print @n.xbgr.xm37_u7.nsg13_hv_nmos[l]
print @n.xbgr.xm37_u7.nsg13_hv_nmos[delvto]
print @n.xbgr.xm37_u7.nsg13_hv_nmos[factuo]
print @n.xbgr.xm37_u8.nsg13_hv_nmos[w]
print @n.xbgr.xm37_u8.nsg13_hv_nmos[l]
print @n.xbgr.xm37_u8.nsg13_hv_nmos[delvto]
print @n.xbgr.xm37_u8.nsg13_hv_nmos[factuo]
print @n.xbgr.xm37_u9.nsg13_hv_nmos[w]
print @n.xbgr.xm37_u9.nsg13_hv_nmos[l]
print @n.xbgr.xm37_u9.nsg13_hv_nmos[delvto]
print @n.xbgr.xm37_u9.nsg13_hv_nmos[factuo]
print @n.xbgr.xm37_u10.nsg13_hv_nmos[w]
print @n.xbgr.xm37_u10.nsg13_hv_nmos[l]
print @n.xbgr.xm37_u10.nsg13_hv_nmos[delvto]
print @n.xbgr.xm37_u10.nsg13_hv_nmos[factuo]
print @n.xbgr.xm37_u11.nsg13_hv_nmos[w]
print @n.xbgr.xm37_u11.nsg13_hv_nmos[l]
print @n.xbgr.xm37_u11.nsg13_hv_nmos[delvto]
print @n.xbgr.xm37_u11.nsg13_hv_nmos[factuo]
print @n.xbgr.xm37_u12.nsg13_hv_nmos[w]
print @n.xbgr.xm37_u12.nsg13_hv_nmos[l]
print @n.xbgr.xm37_u12.nsg13_hv_nmos[delvto]
print @n.xbgr.xm37_u12.nsg13_hv_nmos[factuo]
print @n.xbgr.xm37_u13.nsg13_hv_nmos[w]
print @n.xbgr.xm37_u13.nsg13_hv_nmos[l]
print @n.xbgr.xm37_u13.nsg13_hv_nmos[delvto]
print @n.xbgr.xm37_u13.nsg13_hv_nmos[factuo]
print @n.xbgr.xm37_u14.nsg13_hv_nmos[w]
print @n.xbgr.xm37_u14.nsg13_hv_nmos[l]
print @n.xbgr.xm37_u14.nsg13_hv_nmos[delvto]
print @n.xbgr.xm37_u14.nsg13_hv_nmos[factuo]
print @n.xbgr.xm37_u15.nsg13_hv_nmos[w]
print @n.xbgr.xm37_u15.nsg13_hv_nmos[l]
print @n.xbgr.xm37_u15.nsg13_hv_nmos[delvto]
print @n.xbgr.xm37_u15.nsg13_hv_nmos[factuo]
print @n.xbgr.xm37_u16.nsg13_hv_nmos[w]
print @n.xbgr.xm37_u16.nsg13_hv_nmos[l]
print @n.xbgr.xm37_u16.nsg13_hv_nmos[delvto]
print @n.xbgr.xm37_u16.nsg13_hv_nmos[factuo]
print @n.xbgr.xm37_u17.nsg13_hv_nmos[w]
print @n.xbgr.xm37_u17.nsg13_hv_nmos[l]
print @n.xbgr.xm37_u17.nsg13_hv_nmos[delvto]
print @n.xbgr.xm37_u17.nsg13_hv_nmos[factuo]
print @n.xbgr.xm37_u18.nsg13_hv_nmos[w]
print @n.xbgr.xm37_u18.nsg13_hv_nmos[l]
print @n.xbgr.xm37_u18.nsg13_hv_nmos[delvto]
print @n.xbgr.xm37_u18.nsg13_hv_nmos[factuo]
print @n.xbgr.xm37_u19.nsg13_hv_nmos[w]
print @n.xbgr.xm37_u19.nsg13_hv_nmos[l]
print @n.xbgr.xm37_u19.nsg13_hv_nmos[delvto]
print @n.xbgr.xm37_u19.nsg13_hv_nmos[factuo]
print @n.xbgr.xm37_u20.nsg13_hv_nmos[w]
print @n.xbgr.xm37_u20.nsg13_hv_nmos[l]
print @n.xbgr.xm37_u20.nsg13_hv_nmos[delvto]
print @n.xbgr.xm37_u20.nsg13_hv_nmos[factuo]
print @n.xbgr.xm37_u21.nsg13_hv_nmos[w]
print @n.xbgr.xm37_u21.nsg13_hv_nmos[l]
print @n.xbgr.xm37_u21.nsg13_hv_nmos[delvto]
print @n.xbgr.xm37_u21.nsg13_hv_nmos[factuo]
print @n.xbgr.xm37_u22.nsg13_hv_nmos[w]
print @n.xbgr.xm37_u22.nsg13_hv_nmos[l]
print @n.xbgr.xm37_u22.nsg13_hv_nmos[delvto]
print @n.xbgr.xm37_u22.nsg13_hv_nmos[factuo]
print @n.xbgr.xm37_u23.nsg13_hv_nmos[w]
print @n.xbgr.xm37_u23.nsg13_hv_nmos[l]
print @n.xbgr.xm37_u23.nsg13_hv_nmos[delvto]
print @n.xbgr.xm37_u23.nsg13_hv_nmos[factuo]
print @n.xbgr.xm37_u24.nsg13_hv_nmos[w]
print @n.xbgr.xm37_u24.nsg13_hv_nmos[l]
print @n.xbgr.xm37_u24.nsg13_hv_nmos[delvto]
print @n.xbgr.xm37_u24.nsg13_hv_nmos[factuo]
print @n.xbgr.xm38_u2.nsg13_hv_pmos[w]
print @n.xbgr.xm38_u2.nsg13_hv_pmos[l]
print @n.xbgr.xm38_u2.nsg13_hv_pmos[delvto]
print @n.xbgr.xm38_u2.nsg13_hv_pmos[factuo]
print @n.xbgr.xm38_u3.nsg13_hv_pmos[w]
print @n.xbgr.xm38_u3.nsg13_hv_pmos[l]
print @n.xbgr.xm38_u3.nsg13_hv_pmos[delvto]
print @n.xbgr.xm38_u3.nsg13_hv_pmos[factuo]
print @n.xbgr.xm38_u4.nsg13_hv_pmos[w]
print @n.xbgr.xm38_u4.nsg13_hv_pmos[l]
print @n.xbgr.xm38_u4.nsg13_hv_pmos[delvto]
print @n.xbgr.xm38_u4.nsg13_hv_pmos[factuo]
print @n.xbgr.xm38_u5.nsg13_hv_pmos[w]
print @n.xbgr.xm38_u5.nsg13_hv_pmos[l]
print @n.xbgr.xm38_u5.nsg13_hv_pmos[delvto]
print @n.xbgr.xm38_u5.nsg13_hv_pmos[factuo]
print @n.xbgr.xm38_u6.nsg13_hv_pmos[w]
print @n.xbgr.xm38_u6.nsg13_hv_pmos[l]
print @n.xbgr.xm38_u6.nsg13_hv_pmos[delvto]
print @n.xbgr.xm38_u6.nsg13_hv_pmos[factuo]
print @n.xbgr.xm38_u7.nsg13_hv_pmos[w]
print @n.xbgr.xm38_u7.nsg13_hv_pmos[l]
print @n.xbgr.xm38_u7.nsg13_hv_pmos[delvto]
print @n.xbgr.xm38_u7.nsg13_hv_pmos[factuo]
print @n.xbgr.xm38_u8.nsg13_hv_pmos[w]
print @n.xbgr.xm38_u8.nsg13_hv_pmos[l]
print @n.xbgr.xm38_u8.nsg13_hv_pmos[delvto]
print @n.xbgr.xm38_u8.nsg13_hv_pmos[factuo]
print @n.xbgr.xm38_u9.nsg13_hv_pmos[w]
print @n.xbgr.xm38_u9.nsg13_hv_pmos[l]
print @n.xbgr.xm38_u9.nsg13_hv_pmos[delvto]
print @n.xbgr.xm38_u9.nsg13_hv_pmos[factuo]
print @n.xbgr.xm38_u10.nsg13_hv_pmos[w]
print @n.xbgr.xm38_u10.nsg13_hv_pmos[l]
print @n.xbgr.xm38_u10.nsg13_hv_pmos[delvto]
print @n.xbgr.xm38_u10.nsg13_hv_pmos[factuo]
print @n.xbgr.xm38_u11.nsg13_hv_pmos[w]
print @n.xbgr.xm38_u11.nsg13_hv_pmos[l]
print @n.xbgr.xm38_u11.nsg13_hv_pmos[delvto]
print @n.xbgr.xm38_u11.nsg13_hv_pmos[factuo]
print @n.xbgr.xm38_u12.nsg13_hv_pmos[w]
print @n.xbgr.xm38_u12.nsg13_hv_pmos[l]
print @n.xbgr.xm38_u12.nsg13_hv_pmos[delvto]
print @n.xbgr.xm38_u12.nsg13_hv_pmos[factuo]
print @n.xbgr.xm38_u13.nsg13_hv_pmos[w]
print @n.xbgr.xm38_u13.nsg13_hv_pmos[l]
print @n.xbgr.xm38_u13.nsg13_hv_pmos[delvto]
print @n.xbgr.xm38_u13.nsg13_hv_pmos[factuo]
print @n.xbgr.xm38_u14.nsg13_hv_pmos[w]
print @n.xbgr.xm38_u14.nsg13_hv_pmos[l]
print @n.xbgr.xm38_u14.nsg13_hv_pmos[delvto]
print @n.xbgr.xm38_u14.nsg13_hv_pmos[factuo]
print @n.xbgr.xm38_u15.nsg13_hv_pmos[w]
print @n.xbgr.xm38_u15.nsg13_hv_pmos[l]
print @n.xbgr.xm38_u15.nsg13_hv_pmos[delvto]
print @n.xbgr.xm38_u15.nsg13_hv_pmos[factuo]
print @n.xbgr.xm38_u16.nsg13_hv_pmos[w]
print @n.xbgr.xm38_u16.nsg13_hv_pmos[l]
print @n.xbgr.xm38_u16.nsg13_hv_pmos[delvto]
print @n.xbgr.xm38_u16.nsg13_hv_pmos[factuo]
print @n.xbgr.xm38_u17.nsg13_hv_pmos[w]
print @n.xbgr.xm38_u17.nsg13_hv_pmos[l]
print @n.xbgr.xm38_u17.nsg13_hv_pmos[delvto]
print @n.xbgr.xm38_u17.nsg13_hv_pmos[factuo]
print @n.xbgr.xm38_u18.nsg13_hv_pmos[w]
print @n.xbgr.xm38_u18.nsg13_hv_pmos[l]
print @n.xbgr.xm38_u18.nsg13_hv_pmos[delvto]
print @n.xbgr.xm38_u18.nsg13_hv_pmos[factuo]
print @n.xbgr.xm38_u19.nsg13_hv_pmos[w]
print @n.xbgr.xm38_u19.nsg13_hv_pmos[l]
print @n.xbgr.xm38_u19.nsg13_hv_pmos[delvto]
print @n.xbgr.xm38_u19.nsg13_hv_pmos[factuo]
print @n.xbgr.xm38_u20.nsg13_hv_pmos[w]
print @n.xbgr.xm38_u20.nsg13_hv_pmos[l]
print @n.xbgr.xm38_u20.nsg13_hv_pmos[delvto]
print @n.xbgr.xm38_u20.nsg13_hv_pmos[factuo]
print @n.xbgr.xm38_u21.nsg13_hv_pmos[w]
print @n.xbgr.xm38_u21.nsg13_hv_pmos[l]
print @n.xbgr.xm38_u21.nsg13_hv_pmos[delvto]
print @n.xbgr.xm38_u21.nsg13_hv_pmos[factuo]
print @n.xbgr.xm38_u22.nsg13_hv_pmos[w]
print @n.xbgr.xm38_u22.nsg13_hv_pmos[l]
print @n.xbgr.xm38_u22.nsg13_hv_pmos[delvto]
print @n.xbgr.xm38_u22.nsg13_hv_pmos[factuo]
print @n.xbgr.xm38_u23.nsg13_hv_pmos[w]
print @n.xbgr.xm38_u23.nsg13_hv_pmos[l]
print @n.xbgr.xm38_u23.nsg13_hv_pmos[delvto]
print @n.xbgr.xm38_u23.nsg13_hv_pmos[factuo]
print @n.xbgr.xm38_u24.nsg13_hv_pmos[w]
print @n.xbgr.xm38_u24.nsg13_hv_pmos[l]
print @n.xbgr.xm38_u24.nsg13_hv_pmos[delvto]
print @n.xbgr.xm38_u24.nsg13_hv_pmos[factuo]
print @n.xbgr.xm39_u2.nsg13_hv_pmos[w]
print @n.xbgr.xm39_u2.nsg13_hv_pmos[l]
print @n.xbgr.xm39_u2.nsg13_hv_pmos[delvto]
print @n.xbgr.xm39_u2.nsg13_hv_pmos[factuo]
print @n.xbgr.xm39_u3.nsg13_hv_pmos[w]
print @n.xbgr.xm39_u3.nsg13_hv_pmos[l]
print @n.xbgr.xm39_u3.nsg13_hv_pmos[delvto]
print @n.xbgr.xm39_u3.nsg13_hv_pmos[factuo]
print @n.xbgr.xm39_u4.nsg13_hv_pmos[w]
print @n.xbgr.xm39_u4.nsg13_hv_pmos[l]
print @n.xbgr.xm39_u4.nsg13_hv_pmos[delvto]
print @n.xbgr.xm39_u4.nsg13_hv_pmos[factuo]
print @n.xbgr.xm39_u5.nsg13_hv_pmos[w]
print @n.xbgr.xm39_u5.nsg13_hv_pmos[l]
print @n.xbgr.xm39_u5.nsg13_hv_pmos[delvto]
print @n.xbgr.xm39_u5.nsg13_hv_pmos[factuo]
print @n.xbgr.xm39_u6.nsg13_hv_pmos[w]
print @n.xbgr.xm39_u6.nsg13_hv_pmos[l]
print @n.xbgr.xm39_u6.nsg13_hv_pmos[delvto]
print @n.xbgr.xm39_u6.nsg13_hv_pmos[factuo]
print @n.xbgr.xm39_u7.nsg13_hv_pmos[w]
print @n.xbgr.xm39_u7.nsg13_hv_pmos[l]
print @n.xbgr.xm39_u7.nsg13_hv_pmos[delvto]
print @n.xbgr.xm39_u7.nsg13_hv_pmos[factuo]
print @n.xbgr.xm39_u8.nsg13_hv_pmos[w]
print @n.xbgr.xm39_u8.nsg13_hv_pmos[l]
print @n.xbgr.xm39_u8.nsg13_hv_pmos[delvto]
print @n.xbgr.xm39_u8.nsg13_hv_pmos[factuo]
print @n.xbgr.xm39_u9.nsg13_hv_pmos[w]
print @n.xbgr.xm39_u9.nsg13_hv_pmos[l]
print @n.xbgr.xm39_u9.nsg13_hv_pmos[delvto]
print @n.xbgr.xm39_u9.nsg13_hv_pmos[factuo]
print @n.xbgr.xm39_u10.nsg13_hv_pmos[w]
print @n.xbgr.xm39_u10.nsg13_hv_pmos[l]
print @n.xbgr.xm39_u10.nsg13_hv_pmos[delvto]
print @n.xbgr.xm39_u10.nsg13_hv_pmos[factuo]
print @n.xbgr.xm39_u11.nsg13_hv_pmos[w]
print @n.xbgr.xm39_u11.nsg13_hv_pmos[l]
print @n.xbgr.xm39_u11.nsg13_hv_pmos[delvto]
print @n.xbgr.xm39_u11.nsg13_hv_pmos[factuo]
print @n.xbgr.xm39_u12.nsg13_hv_pmos[w]
print @n.xbgr.xm39_u12.nsg13_hv_pmos[l]
print @n.xbgr.xm39_u12.nsg13_hv_pmos[delvto]
print @n.xbgr.xm39_u12.nsg13_hv_pmos[factuo]
print @n.xbgr.xm39_u13.nsg13_hv_pmos[w]
print @n.xbgr.xm39_u13.nsg13_hv_pmos[l]
print @n.xbgr.xm39_u13.nsg13_hv_pmos[delvto]
print @n.xbgr.xm39_u13.nsg13_hv_pmos[factuo]
print @n.xbgr.xm39_u14.nsg13_hv_pmos[w]
print @n.xbgr.xm39_u14.nsg13_hv_pmos[l]
print @n.xbgr.xm39_u14.nsg13_hv_pmos[delvto]
print @n.xbgr.xm39_u14.nsg13_hv_pmos[factuo]
print @n.xbgr.xm39_u15.nsg13_hv_pmos[w]
print @n.xbgr.xm39_u15.nsg13_hv_pmos[l]
print @n.xbgr.xm39_u15.nsg13_hv_pmos[delvto]
print @n.xbgr.xm39_u15.nsg13_hv_pmos[factuo]
print @n.xbgr.xm39_u16.nsg13_hv_pmos[w]
print @n.xbgr.xm39_u16.nsg13_hv_pmos[l]
print @n.xbgr.xm39_u16.nsg13_hv_pmos[delvto]
print @n.xbgr.xm39_u16.nsg13_hv_pmos[factuo]
print @n.xbgr.xm39_u17.nsg13_hv_pmos[w]
print @n.xbgr.xm39_u17.nsg13_hv_pmos[l]
print @n.xbgr.xm39_u17.nsg13_hv_pmos[delvto]
print @n.xbgr.xm39_u17.nsg13_hv_pmos[factuo]
print @n.xbgr.xm39_u18.nsg13_hv_pmos[w]
print @n.xbgr.xm39_u18.nsg13_hv_pmos[l]
print @n.xbgr.xm39_u18.nsg13_hv_pmos[delvto]
print @n.xbgr.xm39_u18.nsg13_hv_pmos[factuo]
print @n.xbgr.xm39_u19.nsg13_hv_pmos[w]
print @n.xbgr.xm39_u19.nsg13_hv_pmos[l]
print @n.xbgr.xm39_u19.nsg13_hv_pmos[delvto]
print @n.xbgr.xm39_u19.nsg13_hv_pmos[factuo]
print @n.xbgr.xm39_u20.nsg13_hv_pmos[w]
print @n.xbgr.xm39_u20.nsg13_hv_pmos[l]
print @n.xbgr.xm39_u20.nsg13_hv_pmos[delvto]
print @n.xbgr.xm39_u20.nsg13_hv_pmos[factuo]
print @n.xbgr.xm39_u21.nsg13_hv_pmos[w]
print @n.xbgr.xm39_u21.nsg13_hv_pmos[l]
print @n.xbgr.xm39_u21.nsg13_hv_pmos[delvto]
print @n.xbgr.xm39_u21.nsg13_hv_pmos[factuo]
print @n.xbgr.xm39_u22.nsg13_hv_pmos[w]
print @n.xbgr.xm39_u22.nsg13_hv_pmos[l]
print @n.xbgr.xm39_u22.nsg13_hv_pmos[delvto]
print @n.xbgr.xm39_u22.nsg13_hv_pmos[factuo]
print @n.xbgr.xm39_u23.nsg13_hv_pmos[w]
print @n.xbgr.xm39_u23.nsg13_hv_pmos[l]
print @n.xbgr.xm39_u23.nsg13_hv_pmos[delvto]
print @n.xbgr.xm39_u23.nsg13_hv_pmos[factuo]
print @n.xbgr.xm39_u24.nsg13_hv_pmos[w]
print @n.xbgr.xm39_u24.nsg13_hv_pmos[l]
print @n.xbgr.xm39_u24.nsg13_hv_pmos[delvto]
print @n.xbgr.xm39_u24.nsg13_hv_pmos[factuo]
print @n.xbgr.xm41_u2.nsg13_hv_pmos[w]
print @n.xbgr.xm41_u2.nsg13_hv_pmos[l]
print @n.xbgr.xm41_u2.nsg13_hv_pmos[delvto]
print @n.xbgr.xm41_u2.nsg13_hv_pmos[factuo]
print @n.xbgr.xm41_u3.nsg13_hv_pmos[w]
print @n.xbgr.xm41_u3.nsg13_hv_pmos[l]
print @n.xbgr.xm41_u3.nsg13_hv_pmos[delvto]
print @n.xbgr.xm41_u3.nsg13_hv_pmos[factuo]
print @n.xbgr.xm41_u4.nsg13_hv_pmos[w]
print @n.xbgr.xm41_u4.nsg13_hv_pmos[l]
print @n.xbgr.xm41_u4.nsg13_hv_pmos[delvto]
print @n.xbgr.xm41_u4.nsg13_hv_pmos[factuo]
print @n.xbgr.xm41_u5.nsg13_hv_pmos[w]
print @n.xbgr.xm41_u5.nsg13_hv_pmos[l]
print @n.xbgr.xm41_u5.nsg13_hv_pmos[delvto]
print @n.xbgr.xm41_u5.nsg13_hv_pmos[factuo]
print @n.xbgr.xm41_u6.nsg13_hv_pmos[w]
print @n.xbgr.xm41_u6.nsg13_hv_pmos[l]
print @n.xbgr.xm41_u6.nsg13_hv_pmos[delvto]
print @n.xbgr.xm41_u6.nsg13_hv_pmos[factuo]
print @n.xbgr.xm41_u7.nsg13_hv_pmos[w]
print @n.xbgr.xm41_u7.nsg13_hv_pmos[l]
print @n.xbgr.xm41_u7.nsg13_hv_pmos[delvto]
print @n.xbgr.xm41_u7.nsg13_hv_pmos[factuo]
print @n.xbgr.xm41_u8.nsg13_hv_pmos[w]
print @n.xbgr.xm41_u8.nsg13_hv_pmos[l]
print @n.xbgr.xm41_u8.nsg13_hv_pmos[delvto]
print @n.xbgr.xm41_u8.nsg13_hv_pmos[factuo]
print @n.xbgr.xm41_u9.nsg13_hv_pmos[w]
print @n.xbgr.xm41_u9.nsg13_hv_pmos[l]
print @n.xbgr.xm41_u9.nsg13_hv_pmos[delvto]
print @n.xbgr.xm41_u9.nsg13_hv_pmos[factuo]
print @n.xbgr.xm41_u10.nsg13_hv_pmos[w]
print @n.xbgr.xm41_u10.nsg13_hv_pmos[l]
print @n.xbgr.xm41_u10.nsg13_hv_pmos[delvto]
print @n.xbgr.xm41_u10.nsg13_hv_pmos[factuo]
print @n.xbgr.xm41_u11.nsg13_hv_pmos[w]
print @n.xbgr.xm41_u11.nsg13_hv_pmos[l]
print @n.xbgr.xm41_u11.nsg13_hv_pmos[delvto]
print @n.xbgr.xm41_u11.nsg13_hv_pmos[factuo]
print @n.xbgr.xm41_u12.nsg13_hv_pmos[w]
print @n.xbgr.xm41_u12.nsg13_hv_pmos[l]
print @n.xbgr.xm41_u12.nsg13_hv_pmos[delvto]
print @n.xbgr.xm41_u12.nsg13_hv_pmos[factuo]
print @n.xbgr.xm41_u13.nsg13_hv_pmos[w]
print @n.xbgr.xm41_u13.nsg13_hv_pmos[l]
print @n.xbgr.xm41_u13.nsg13_hv_pmos[delvto]
print @n.xbgr.xm41_u13.nsg13_hv_pmos[factuo]
print @n.xbgr.xm41_u14.nsg13_hv_pmos[w]
print @n.xbgr.xm41_u14.nsg13_hv_pmos[l]
print @n.xbgr.xm41_u14.nsg13_hv_pmos[delvto]
print @n.xbgr.xm41_u14.nsg13_hv_pmos[factuo]
print @n.xbgr.xm41_u15.nsg13_hv_pmos[w]
print @n.xbgr.xm41_u15.nsg13_hv_pmos[l]
print @n.xbgr.xm41_u15.nsg13_hv_pmos[delvto]
print @n.xbgr.xm41_u15.nsg13_hv_pmos[factuo]
print @n.xbgr.xm41_u16.nsg13_hv_pmos[w]
print @n.xbgr.xm41_u16.nsg13_hv_pmos[l]
print @n.xbgr.xm41_u16.nsg13_hv_pmos[delvto]
print @n.xbgr.xm41_u16.nsg13_hv_pmos[factuo]
print @n.xbgr.xm41_u17.nsg13_hv_pmos[w]
print @n.xbgr.xm41_u17.nsg13_hv_pmos[l]
print @n.xbgr.xm41_u17.nsg13_hv_pmos[delvto]
print @n.xbgr.xm41_u17.nsg13_hv_pmos[factuo]
print @n.xbgr.xm41_u18.nsg13_hv_pmos[w]
print @n.xbgr.xm41_u18.nsg13_hv_pmos[l]
print @n.xbgr.xm41_u18.nsg13_hv_pmos[delvto]
print @n.xbgr.xm41_u18.nsg13_hv_pmos[factuo]
print @n.xbgr.xm41_u19.nsg13_hv_pmos[w]
print @n.xbgr.xm41_u19.nsg13_hv_pmos[l]
print @n.xbgr.xm41_u19.nsg13_hv_pmos[delvto]
print @n.xbgr.xm41_u19.nsg13_hv_pmos[factuo]
print @n.xbgr.xm41_u20.nsg13_hv_pmos[w]
print @n.xbgr.xm41_u20.nsg13_hv_pmos[l]
print @n.xbgr.xm41_u20.nsg13_hv_pmos[delvto]
print @n.xbgr.xm41_u20.nsg13_hv_pmos[factuo]
print @n.xbgr.xm41_u21.nsg13_hv_pmos[w]
print @n.xbgr.xm41_u21.nsg13_hv_pmos[l]
print @n.xbgr.xm41_u21.nsg13_hv_pmos[delvto]
print @n.xbgr.xm41_u21.nsg13_hv_pmos[factuo]
print @n.xbgr.xm41_u22.nsg13_hv_pmos[w]
print @n.xbgr.xm41_u22.nsg13_hv_pmos[l]
print @n.xbgr.xm41_u22.nsg13_hv_pmos[delvto]
print @n.xbgr.xm41_u22.nsg13_hv_pmos[factuo]
print @n.xbgr.xm41_u23.nsg13_hv_pmos[w]
print @n.xbgr.xm41_u23.nsg13_hv_pmos[l]
print @n.xbgr.xm41_u23.nsg13_hv_pmos[delvto]
print @n.xbgr.xm41_u23.nsg13_hv_pmos[factuo]
print @n.xbgr.xm41_u24.nsg13_hv_pmos[w]
print @n.xbgr.xm41_u24.nsg13_hv_pmos[l]
print @n.xbgr.xm41_u24.nsg13_hv_pmos[delvto]
print @n.xbgr.xm41_u24.nsg13_hv_pmos[factuo]
print @n.xbgr.xm43_u2.nsg13_hv_pmos[w]
print @n.xbgr.xm43_u2.nsg13_hv_pmos[l]
print @n.xbgr.xm43_u2.nsg13_hv_pmos[delvto]
print @n.xbgr.xm43_u2.nsg13_hv_pmos[factuo]
print @n.xbgr.xm43_u3.nsg13_hv_pmos[w]
print @n.xbgr.xm43_u3.nsg13_hv_pmos[l]
print @n.xbgr.xm43_u3.nsg13_hv_pmos[delvto]
print @n.xbgr.xm43_u3.nsg13_hv_pmos[factuo]
print @n.xbgr.xm43_u4.nsg13_hv_pmos[w]
print @n.xbgr.xm43_u4.nsg13_hv_pmos[l]
print @n.xbgr.xm43_u4.nsg13_hv_pmos[delvto]
print @n.xbgr.xm43_u4.nsg13_hv_pmos[factuo]
print @n.xbgr.xm44_u2.nsg13_hv_pmos[w]
print @n.xbgr.xm44_u2.nsg13_hv_pmos[l]
print @n.xbgr.xm44_u2.nsg13_hv_pmos[delvto]
print @n.xbgr.xm44_u2.nsg13_hv_pmos[factuo]
print @n.xbgr.xm44_u3.nsg13_hv_pmos[w]
print @n.xbgr.xm44_u3.nsg13_hv_pmos[l]
print @n.xbgr.xm44_u3.nsg13_hv_pmos[delvto]
print @n.xbgr.xm44_u3.nsg13_hv_pmos[factuo]
print @n.xbgr.xm44_u4.nsg13_hv_pmos[w]
print @n.xbgr.xm44_u4.nsg13_hv_pmos[l]
print @n.xbgr.xm44_u4.nsg13_hv_pmos[delvto]
print @n.xbgr.xm44_u4.nsg13_hv_pmos[factuo]
print @n.xbgr.xm45_u2.nsg13_hv_pmos[w]
print @n.xbgr.xm45_u2.nsg13_hv_pmos[l]
print @n.xbgr.xm45_u2.nsg13_hv_pmos[delvto]
print @n.xbgr.xm45_u2.nsg13_hv_pmos[factuo]
print @n.xbgr.xm45_u3.nsg13_hv_pmos[w]
print @n.xbgr.xm45_u3.nsg13_hv_pmos[l]
print @n.xbgr.xm45_u3.nsg13_hv_pmos[delvto]
print @n.xbgr.xm45_u3.nsg13_hv_pmos[factuo]
print @n.xbgr.xm45_u4.nsg13_hv_pmos[w]
print @n.xbgr.xm45_u4.nsg13_hv_pmos[l]
print @n.xbgr.xm45_u4.nsg13_hv_pmos[delvto]
print @n.xbgr.xm45_u4.nsg13_hv_pmos[factuo]
print @n.xbgr.xm45_u5.nsg13_hv_pmos[w]
print @n.xbgr.xm45_u5.nsg13_hv_pmos[l]
print @n.xbgr.xm45_u5.nsg13_hv_pmos[delvto]
print @n.xbgr.xm45_u5.nsg13_hv_pmos[factuo]
print @n.xbgr.xm45_u6.nsg13_hv_pmos[w]
print @n.xbgr.xm45_u6.nsg13_hv_pmos[l]
print @n.xbgr.xm45_u6.nsg13_hv_pmos[delvto]
print @n.xbgr.xm45_u6.nsg13_hv_pmos[factuo]
print @n.xbgr.xm45_u7.nsg13_hv_pmos[w]
print @n.xbgr.xm45_u7.nsg13_hv_pmos[l]
print @n.xbgr.xm45_u7.nsg13_hv_pmos[delvto]
print @n.xbgr.xm45_u7.nsg13_hv_pmos[factuo]
print @n.xbgr.xm45_u8.nsg13_hv_pmos[w]
print @n.xbgr.xm45_u8.nsg13_hv_pmos[l]
print @n.xbgr.xm45_u8.nsg13_hv_pmos[delvto]
print @n.xbgr.xm45_u8.nsg13_hv_pmos[factuo]
print @n.xbgr.xm45_u9.nsg13_hv_pmos[w]
print @n.xbgr.xm45_u9.nsg13_hv_pmos[l]
print @n.xbgr.xm45_u9.nsg13_hv_pmos[delvto]
print @n.xbgr.xm45_u9.nsg13_hv_pmos[factuo]
print @n.xbgr.xm45_u10.nsg13_hv_pmos[w]
print @n.xbgr.xm45_u10.nsg13_hv_pmos[l]
print @n.xbgr.xm45_u10.nsg13_hv_pmos[delvto]
print @n.xbgr.xm45_u10.nsg13_hv_pmos[factuo]
print @n.xbgr.xm45_u11.nsg13_hv_pmos[w]
print @n.xbgr.xm45_u11.nsg13_hv_pmos[l]
print @n.xbgr.xm45_u11.nsg13_hv_pmos[delvto]
print @n.xbgr.xm45_u11.nsg13_hv_pmos[factuo]
print @n.xbgr.xm45_u12.nsg13_hv_pmos[w]
print @n.xbgr.xm45_u12.nsg13_hv_pmos[l]
print @n.xbgr.xm45_u12.nsg13_hv_pmos[delvto]
print @n.xbgr.xm45_u12.nsg13_hv_pmos[factuo]
print @n.xbgr.xm45_u13.nsg13_hv_pmos[w]
print @n.xbgr.xm45_u13.nsg13_hv_pmos[l]
print @n.xbgr.xm45_u13.nsg13_hv_pmos[delvto]
print @n.xbgr.xm45_u13.nsg13_hv_pmos[factuo]
print @n.xbgr.xm45_u14.nsg13_hv_pmos[w]
print @n.xbgr.xm45_u14.nsg13_hv_pmos[l]
print @n.xbgr.xm45_u14.nsg13_hv_pmos[delvto]
print @n.xbgr.xm45_u14.nsg13_hv_pmos[factuo]
print @n.xbgr.xm45_u15.nsg13_hv_pmos[w]
print @n.xbgr.xm45_u15.nsg13_hv_pmos[l]
print @n.xbgr.xm45_u15.nsg13_hv_pmos[delvto]
print @n.xbgr.xm45_u15.nsg13_hv_pmos[factuo]
print @n.xbgr.xm45_u16.nsg13_hv_pmos[w]
print @n.xbgr.xm45_u16.nsg13_hv_pmos[l]
print @n.xbgr.xm45_u16.nsg13_hv_pmos[delvto]
print @n.xbgr.xm45_u16.nsg13_hv_pmos[factuo]
print @n.xbgr.xm45_u17.nsg13_hv_pmos[w]
print @n.xbgr.xm45_u17.nsg13_hv_pmos[l]
print @n.xbgr.xm45_u17.nsg13_hv_pmos[delvto]
print @n.xbgr.xm45_u17.nsg13_hv_pmos[factuo]
print @n.xbgr.xm45_u18.nsg13_hv_pmos[w]
print @n.xbgr.xm45_u18.nsg13_hv_pmos[l]
print @n.xbgr.xm45_u18.nsg13_hv_pmos[delvto]
print @n.xbgr.xm45_u18.nsg13_hv_pmos[factuo]
print @n.xbgr.xm45_u19.nsg13_hv_pmos[w]
print @n.xbgr.xm45_u19.nsg13_hv_pmos[l]
print @n.xbgr.xm45_u19.nsg13_hv_pmos[delvto]
print @n.xbgr.xm45_u19.nsg13_hv_pmos[factuo]
print @n.xbgr.xm45_u20.nsg13_hv_pmos[w]
print @n.xbgr.xm45_u20.nsg13_hv_pmos[l]
print @n.xbgr.xm45_u20.nsg13_hv_pmos[delvto]
print @n.xbgr.xm45_u20.nsg13_hv_pmos[factuo]
print @n.xbgr.xm45_u21.nsg13_hv_pmos[w]
print @n.xbgr.xm45_u21.nsg13_hv_pmos[l]
print @n.xbgr.xm45_u21.nsg13_hv_pmos[delvto]
print @n.xbgr.xm45_u21.nsg13_hv_pmos[factuo]
print @n.xbgr.xm45_u22.nsg13_hv_pmos[w]
print @n.xbgr.xm45_u22.nsg13_hv_pmos[l]
print @n.xbgr.xm45_u22.nsg13_hv_pmos[delvto]
print @n.xbgr.xm45_u22.nsg13_hv_pmos[factuo]
print @n.xbgr.xm45_u23.nsg13_hv_pmos[w]
print @n.xbgr.xm45_u23.nsg13_hv_pmos[l]
print @n.xbgr.xm45_u23.nsg13_hv_pmos[delvto]
print @n.xbgr.xm45_u23.nsg13_hv_pmos[factuo]
print @n.xbgr.xm45_u24.nsg13_hv_pmos[w]
print @n.xbgr.xm45_u24.nsg13_hv_pmos[l]
print @n.xbgr.xm45_u24.nsg13_hv_pmos[delvto]
print @n.xbgr.xm45_u24.nsg13_hv_pmos[factuo]
print @n.xbgr.xm47_u2.nsg13_hv_pmos[w]
print @n.xbgr.xm47_u2.nsg13_hv_pmos[l]
print @n.xbgr.xm47_u2.nsg13_hv_pmos[delvto]
print @n.xbgr.xm47_u2.nsg13_hv_pmos[factuo]
print @n.xbgr.xm47_u3.nsg13_hv_pmos[w]
print @n.xbgr.xm47_u3.nsg13_hv_pmos[l]
print @n.xbgr.xm47_u3.nsg13_hv_pmos[delvto]
print @n.xbgr.xm47_u3.nsg13_hv_pmos[factuo]
print @n.xbgr.xm47_u4.nsg13_hv_pmos[w]
print @n.xbgr.xm47_u4.nsg13_hv_pmos[l]
print @n.xbgr.xm47_u4.nsg13_hv_pmos[delvto]
print @n.xbgr.xm47_u4.nsg13_hv_pmos[factuo]
print @n.xbgr.xm47_u5.nsg13_hv_pmos[w]
print @n.xbgr.xm47_u5.nsg13_hv_pmos[l]
print @n.xbgr.xm47_u5.nsg13_hv_pmos[delvto]
print @n.xbgr.xm47_u5.nsg13_hv_pmos[factuo]
print @n.xbgr.xm47_u6.nsg13_hv_pmos[w]
print @n.xbgr.xm47_u6.nsg13_hv_pmos[l]
print @n.xbgr.xm47_u6.nsg13_hv_pmos[delvto]
print @n.xbgr.xm47_u6.nsg13_hv_pmos[factuo]
print @n.xbgr.xm47_u7.nsg13_hv_pmos[w]
print @n.xbgr.xm47_u7.nsg13_hv_pmos[l]
print @n.xbgr.xm47_u7.nsg13_hv_pmos[delvto]
print @n.xbgr.xm47_u7.nsg13_hv_pmos[factuo]
print @n.xbgr.xm47_u8.nsg13_hv_pmos[w]
print @n.xbgr.xm47_u8.nsg13_hv_pmos[l]
print @n.xbgr.xm47_u8.nsg13_hv_pmos[delvto]
print @n.xbgr.xm47_u8.nsg13_hv_pmos[factuo]
print @n.xbgr.xm47_u9.nsg13_hv_pmos[w]
print @n.xbgr.xm47_u9.nsg13_hv_pmos[l]
print @n.xbgr.xm47_u9.nsg13_hv_pmos[delvto]
print @n.xbgr.xm47_u9.nsg13_hv_pmos[factuo]
print @n.xbgr.xm47_u10.nsg13_hv_pmos[w]
print @n.xbgr.xm47_u10.nsg13_hv_pmos[l]
print @n.xbgr.xm47_u10.nsg13_hv_pmos[delvto]
print @n.xbgr.xm47_u10.nsg13_hv_pmos[factuo]
print @n.xbgr.xm47_u11.nsg13_hv_pmos[w]
print @n.xbgr.xm47_u11.nsg13_hv_pmos[l]
print @n.xbgr.xm47_u11.nsg13_hv_pmos[delvto]
print @n.xbgr.xm47_u11.nsg13_hv_pmos[factuo]
print @n.xbgr.xm47_u12.nsg13_hv_pmos[w]
print @n.xbgr.xm47_u12.nsg13_hv_pmos[l]
print @n.xbgr.xm47_u12.nsg13_hv_pmos[delvto]
print @n.xbgr.xm47_u12.nsg13_hv_pmos[factuo]
print @n.xbgr.xm47_u13.nsg13_hv_pmos[w]
print @n.xbgr.xm47_u13.nsg13_hv_pmos[l]
print @n.xbgr.xm47_u13.nsg13_hv_pmos[delvto]
print @n.xbgr.xm47_u13.nsg13_hv_pmos[factuo]
print @n.xbgr.xm47_u14.nsg13_hv_pmos[w]
print @n.xbgr.xm47_u14.nsg13_hv_pmos[l]
print @n.xbgr.xm47_u14.nsg13_hv_pmos[delvto]
print @n.xbgr.xm47_u14.nsg13_hv_pmos[factuo]
print @n.xbgr.xm47_u15.nsg13_hv_pmos[w]
print @n.xbgr.xm47_u15.nsg13_hv_pmos[l]
print @n.xbgr.xm47_u15.nsg13_hv_pmos[delvto]
print @n.xbgr.xm47_u15.nsg13_hv_pmos[factuo]
print @n.xbgr.xm47_u16.nsg13_hv_pmos[w]
print @n.xbgr.xm47_u16.nsg13_hv_pmos[l]
print @n.xbgr.xm47_u16.nsg13_hv_pmos[delvto]
print @n.xbgr.xm47_u16.nsg13_hv_pmos[factuo]
print @n.xbgr.xm47_u17.nsg13_hv_pmos[w]
print @n.xbgr.xm47_u17.nsg13_hv_pmos[l]
print @n.xbgr.xm47_u17.nsg13_hv_pmos[delvto]
print @n.xbgr.xm47_u17.nsg13_hv_pmos[factuo]
print @n.xbgr.xm47_u18.nsg13_hv_pmos[w]
print @n.xbgr.xm47_u18.nsg13_hv_pmos[l]
print @n.xbgr.xm47_u18.nsg13_hv_pmos[delvto]
print @n.xbgr.xm47_u18.nsg13_hv_pmos[factuo]
print @n.xbgr.xm47_u19.nsg13_hv_pmos[w]
print @n.xbgr.xm47_u19.nsg13_hv_pmos[l]
print @n.xbgr.xm47_u19.nsg13_hv_pmos[delvto]
print @n.xbgr.xm47_u19.nsg13_hv_pmos[factuo]
print @n.xbgr.xm47_u20.nsg13_hv_pmos[w]
print @n.xbgr.xm47_u20.nsg13_hv_pmos[l]
print @n.xbgr.xm47_u20.nsg13_hv_pmos[delvto]
print @n.xbgr.xm47_u20.nsg13_hv_pmos[factuo]
print @n.xbgr.xm47_u21.nsg13_hv_pmos[w]
print @n.xbgr.xm47_u21.nsg13_hv_pmos[l]
print @n.xbgr.xm47_u21.nsg13_hv_pmos[delvto]
print @n.xbgr.xm47_u21.nsg13_hv_pmos[factuo]
print @n.xbgr.xm47_u22.nsg13_hv_pmos[w]
print @n.xbgr.xm47_u22.nsg13_hv_pmos[l]
print @n.xbgr.xm47_u22.nsg13_hv_pmos[delvto]
print @n.xbgr.xm47_u22.nsg13_hv_pmos[factuo]
print @n.xbgr.xm47_u23.nsg13_hv_pmos[w]
print @n.xbgr.xm47_u23.nsg13_hv_pmos[l]
print @n.xbgr.xm47_u23.nsg13_hv_pmos[delvto]
print @n.xbgr.xm47_u23.nsg13_hv_pmos[factuo]
print @n.xbgr.xm47_u24.nsg13_hv_pmos[w]
print @n.xbgr.xm47_u24.nsg13_hv_pmos[l]
print @n.xbgr.xm47_u24.nsg13_hv_pmos[delvto]
print @n.xbgr.xm47_u24.nsg13_hv_pmos[factuo]
print @n.xbgr.xm48_u2.nsg13_hv_pmos[w]
print @n.xbgr.xm48_u2.nsg13_hv_pmos[l]
print @n.xbgr.xm48_u2.nsg13_hv_pmos[delvto]
print @n.xbgr.xm48_u2.nsg13_hv_pmos[factuo]
print @n.xbgr.xm48_u3.nsg13_hv_pmos[w]
print @n.xbgr.xm48_u3.nsg13_hv_pmos[l]
print @n.xbgr.xm48_u3.nsg13_hv_pmos[delvto]
print @n.xbgr.xm48_u3.nsg13_hv_pmos[factuo]
print @n.xbgr.xm48_u4.nsg13_hv_pmos[w]
print @n.xbgr.xm48_u4.nsg13_hv_pmos[l]
print @n.xbgr.xm48_u4.nsg13_hv_pmos[delvto]
print @n.xbgr.xm48_u4.nsg13_hv_pmos[factuo]
print @n.xbgr.xm48_u5.nsg13_hv_pmos[w]
print @n.xbgr.xm48_u5.nsg13_hv_pmos[l]
print @n.xbgr.xm48_u5.nsg13_hv_pmos[delvto]
print @n.xbgr.xm48_u5.nsg13_hv_pmos[factuo]
print @n.xbgr.xm48_u6.nsg13_hv_pmos[w]
print @n.xbgr.xm48_u6.nsg13_hv_pmos[l]
print @n.xbgr.xm48_u6.nsg13_hv_pmos[delvto]
print @n.xbgr.xm48_u6.nsg13_hv_pmos[factuo]
print @n.xbgr.xm48_u7.nsg13_hv_pmos[w]
print @n.xbgr.xm48_u7.nsg13_hv_pmos[l]
print @n.xbgr.xm48_u7.nsg13_hv_pmos[delvto]
print @n.xbgr.xm48_u7.nsg13_hv_pmos[factuo]
print @n.xbgr.xm48_u8.nsg13_hv_pmos[w]
print @n.xbgr.xm48_u8.nsg13_hv_pmos[l]
print @n.xbgr.xm48_u8.nsg13_hv_pmos[delvto]
print @n.xbgr.xm48_u8.nsg13_hv_pmos[factuo]
print @n.xbgr.xm48_u9.nsg13_hv_pmos[w]
print @n.xbgr.xm48_u9.nsg13_hv_pmos[l]
print @n.xbgr.xm48_u9.nsg13_hv_pmos[delvto]
print @n.xbgr.xm48_u9.nsg13_hv_pmos[factuo]
print @n.xbgr.xm48_u10.nsg13_hv_pmos[w]
print @n.xbgr.xm48_u10.nsg13_hv_pmos[l]
print @n.xbgr.xm48_u10.nsg13_hv_pmos[delvto]
print @n.xbgr.xm48_u10.nsg13_hv_pmos[factuo]
print @n.xbgr.xm48_u11.nsg13_hv_pmos[w]
print @n.xbgr.xm48_u11.nsg13_hv_pmos[l]
print @n.xbgr.xm48_u11.nsg13_hv_pmos[delvto]
print @n.xbgr.xm48_u11.nsg13_hv_pmos[factuo]
print @n.xbgr.xm48_u12.nsg13_hv_pmos[w]
print @n.xbgr.xm48_u12.nsg13_hv_pmos[l]
print @n.xbgr.xm48_u12.nsg13_hv_pmos[delvto]
print @n.xbgr.xm48_u12.nsg13_hv_pmos[factuo]
print @n.xbgr.xm48_u13.nsg13_hv_pmos[w]
print @n.xbgr.xm48_u13.nsg13_hv_pmos[l]
print @n.xbgr.xm48_u13.nsg13_hv_pmos[delvto]
print @n.xbgr.xm48_u13.nsg13_hv_pmos[factuo]
print @n.xbgr.xm48_u14.nsg13_hv_pmos[w]
print @n.xbgr.xm48_u14.nsg13_hv_pmos[l]
print @n.xbgr.xm48_u14.nsg13_hv_pmos[delvto]
print @n.xbgr.xm48_u14.nsg13_hv_pmos[factuo]
print @n.xbgr.xm48_u15.nsg13_hv_pmos[w]
print @n.xbgr.xm48_u15.nsg13_hv_pmos[l]
print @n.xbgr.xm48_u15.nsg13_hv_pmos[delvto]
print @n.xbgr.xm48_u15.nsg13_hv_pmos[factuo]
print @n.xbgr.xm48_u16.nsg13_hv_pmos[w]
print @n.xbgr.xm48_u16.nsg13_hv_pmos[l]
print @n.xbgr.xm48_u16.nsg13_hv_pmos[delvto]
print @n.xbgr.xm48_u16.nsg13_hv_pmos[factuo]
print @n.xbgr.xm48_u17.nsg13_hv_pmos[w]
print @n.xbgr.xm48_u17.nsg13_hv_pmos[l]
print @n.xbgr.xm48_u17.nsg13_hv_pmos[delvto]
print @n.xbgr.xm48_u17.nsg13_hv_pmos[factuo]
print @n.xbgr.xm48_u18.nsg13_hv_pmos[w]
print @n.xbgr.xm48_u18.nsg13_hv_pmos[l]
print @n.xbgr.xm48_u18.nsg13_hv_pmos[delvto]
print @n.xbgr.xm48_u18.nsg13_hv_pmos[factuo]
print @n.xbgr.xm48_u19.nsg13_hv_pmos[w]
print @n.xbgr.xm48_u19.nsg13_hv_pmos[l]
print @n.xbgr.xm48_u19.nsg13_hv_pmos[delvto]
print @n.xbgr.xm48_u19.nsg13_hv_pmos[factuo]
print @n.xbgr.xm48_u20.nsg13_hv_pmos[w]
print @n.xbgr.xm48_u20.nsg13_hv_pmos[l]
print @n.xbgr.xm48_u20.nsg13_hv_pmos[delvto]
print @n.xbgr.xm48_u20.nsg13_hv_pmos[factuo]
print @n.xbgr.xm48_u21.nsg13_hv_pmos[w]
print @n.xbgr.xm48_u21.nsg13_hv_pmos[l]
print @n.xbgr.xm48_u21.nsg13_hv_pmos[delvto]
print @n.xbgr.xm48_u21.nsg13_hv_pmos[factuo]
print @n.xbgr.xm48_u22.nsg13_hv_pmos[w]
print @n.xbgr.xm48_u22.nsg13_hv_pmos[l]
print @n.xbgr.xm48_u22.nsg13_hv_pmos[delvto]
print @n.xbgr.xm48_u22.nsg13_hv_pmos[factuo]
print @n.xbgr.xm48_u23.nsg13_hv_pmos[w]
print @n.xbgr.xm48_u23.nsg13_hv_pmos[l]
print @n.xbgr.xm48_u23.nsg13_hv_pmos[delvto]
print @n.xbgr.xm48_u23.nsg13_hv_pmos[factuo]
print @n.xbgr.xm48_u24.nsg13_hv_pmos[w]
print @n.xbgr.xm48_u24.nsg13_hv_pmos[l]
print @n.xbgr.xm48_u24.nsg13_hv_pmos[delvto]
print @n.xbgr.xm48_u24.nsg13_hv_pmos[factuo]
print @n.xbgr.xm50_u2.nsg13_hv_pmos[w]
print @n.xbgr.xm50_u2.nsg13_hv_pmos[l]
print @n.xbgr.xm50_u2.nsg13_hv_pmos[delvto]
print @n.xbgr.xm50_u2.nsg13_hv_pmos[factuo]
print @n.xbgr.xm50_u3.nsg13_hv_pmos[w]
print @n.xbgr.xm50_u3.nsg13_hv_pmos[l]
print @n.xbgr.xm50_u3.nsg13_hv_pmos[delvto]
print @n.xbgr.xm50_u3.nsg13_hv_pmos[factuo]
print @n.xbgr.xm50_u4.nsg13_hv_pmos[w]
print @n.xbgr.xm50_u4.nsg13_hv_pmos[l]
print @n.xbgr.xm50_u4.nsg13_hv_pmos[delvto]
print @n.xbgr.xm50_u4.nsg13_hv_pmos[factuo]
print @n.xbgr.xm50_u5.nsg13_hv_pmos[w]
print @n.xbgr.xm50_u5.nsg13_hv_pmos[l]
print @n.xbgr.xm50_u5.nsg13_hv_pmos[delvto]
print @n.xbgr.xm50_u5.nsg13_hv_pmos[factuo]
print @n.xbgr.xm50_u6.nsg13_hv_pmos[w]
print @n.xbgr.xm50_u6.nsg13_hv_pmos[l]
print @n.xbgr.xm50_u6.nsg13_hv_pmos[delvto]
print @n.xbgr.xm50_u6.nsg13_hv_pmos[factuo]
print @n.xbgr.xm50_u7.nsg13_hv_pmos[w]
print @n.xbgr.xm50_u7.nsg13_hv_pmos[l]
print @n.xbgr.xm50_u7.nsg13_hv_pmos[delvto]
print @n.xbgr.xm50_u7.nsg13_hv_pmos[factuo]
print @n.xbgr.xm50_u8.nsg13_hv_pmos[w]
print @n.xbgr.xm50_u8.nsg13_hv_pmos[l]
print @n.xbgr.xm50_u8.nsg13_hv_pmos[delvto]
print @n.xbgr.xm50_u8.nsg13_hv_pmos[factuo]
print @n.xbgr.xm50_u9.nsg13_hv_pmos[w]
print @n.xbgr.xm50_u9.nsg13_hv_pmos[l]
print @n.xbgr.xm50_u9.nsg13_hv_pmos[delvto]
print @n.xbgr.xm50_u9.nsg13_hv_pmos[factuo]
print @n.xbgr.xm50_u10.nsg13_hv_pmos[w]
print @n.xbgr.xm50_u10.nsg13_hv_pmos[l]
print @n.xbgr.xm50_u10.nsg13_hv_pmos[delvto]
print @n.xbgr.xm50_u10.nsg13_hv_pmos[factuo]
print @n.xbgr.xm50_u11.nsg13_hv_pmos[w]
print @n.xbgr.xm50_u11.nsg13_hv_pmos[l]
print @n.xbgr.xm50_u11.nsg13_hv_pmos[delvto]
print @n.xbgr.xm50_u11.nsg13_hv_pmos[factuo]
print @n.xbgr.xm50_u12.nsg13_hv_pmos[w]
print @n.xbgr.xm50_u12.nsg13_hv_pmos[l]
print @n.xbgr.xm50_u12.nsg13_hv_pmos[delvto]
print @n.xbgr.xm50_u12.nsg13_hv_pmos[factuo]
print @n.xbgr.xm50_u13.nsg13_hv_pmos[w]
print @n.xbgr.xm50_u13.nsg13_hv_pmos[l]
print @n.xbgr.xm50_u13.nsg13_hv_pmos[delvto]
print @n.xbgr.xm50_u13.nsg13_hv_pmos[factuo]
print @n.xbgr.xm50_u14.nsg13_hv_pmos[w]
print @n.xbgr.xm50_u14.nsg13_hv_pmos[l]
print @n.xbgr.xm50_u14.nsg13_hv_pmos[delvto]
print @n.xbgr.xm50_u14.nsg13_hv_pmos[factuo]
print @n.xbgr.xm50_u15.nsg13_hv_pmos[w]
print @n.xbgr.xm50_u15.nsg13_hv_pmos[l]
print @n.xbgr.xm50_u15.nsg13_hv_pmos[delvto]
print @n.xbgr.xm50_u15.nsg13_hv_pmos[factuo]
print @n.xbgr.xm50_u16.nsg13_hv_pmos[w]
print @n.xbgr.xm50_u16.nsg13_hv_pmos[l]
print @n.xbgr.xm50_u16.nsg13_hv_pmos[delvto]
print @n.xbgr.xm50_u16.nsg13_hv_pmos[factuo]
print @n.xbgr.xm50_u17.nsg13_hv_pmos[w]
print @n.xbgr.xm50_u17.nsg13_hv_pmos[l]
print @n.xbgr.xm50_u17.nsg13_hv_pmos[delvto]
print @n.xbgr.xm50_u17.nsg13_hv_pmos[factuo]
print @n.xbgr.xm50_u18.nsg13_hv_pmos[w]
print @n.xbgr.xm50_u18.nsg13_hv_pmos[l]
print @n.xbgr.xm50_u18.nsg13_hv_pmos[delvto]
print @n.xbgr.xm50_u18.nsg13_hv_pmos[factuo]
print @n.xbgr.xm50_u19.nsg13_hv_pmos[w]
print @n.xbgr.xm50_u19.nsg13_hv_pmos[l]
print @n.xbgr.xm50_u19.nsg13_hv_pmos[delvto]
print @n.xbgr.xm50_u19.nsg13_hv_pmos[factuo]
print @n.xbgr.xm50_u20.nsg13_hv_pmos[w]
print @n.xbgr.xm50_u20.nsg13_hv_pmos[l]
print @n.xbgr.xm50_u20.nsg13_hv_pmos[delvto]
print @n.xbgr.xm50_u20.nsg13_hv_pmos[factuo]
print @n.xbgr.xm50_u21.nsg13_hv_pmos[w]
print @n.xbgr.xm50_u21.nsg13_hv_pmos[l]
print @n.xbgr.xm50_u21.nsg13_hv_pmos[delvto]
print @n.xbgr.xm50_u21.nsg13_hv_pmos[factuo]
print @n.xbgr.xm50_u22.nsg13_hv_pmos[w]
print @n.xbgr.xm50_u22.nsg13_hv_pmos[l]
print @n.xbgr.xm50_u22.nsg13_hv_pmos[delvto]
print @n.xbgr.xm50_u22.nsg13_hv_pmos[factuo]
print @n.xbgr.xm50_u23.nsg13_hv_pmos[w]
print @n.xbgr.xm50_u23.nsg13_hv_pmos[l]
print @n.xbgr.xm50_u23.nsg13_hv_pmos[delvto]
print @n.xbgr.xm50_u23.nsg13_hv_pmos[factuo]
print @n.xbgr.xm50_u24.nsg13_hv_pmos[w]
print @n.xbgr.xm50_u24.nsg13_hv_pmos[l]
print @n.xbgr.xm50_u24.nsg13_hv_pmos[delvto]
print @n.xbgr.xm50_u24.nsg13_hv_pmos[factuo]
print @n.xbgr.xm51_u2.nsg13_hv_pmos[w]
print @n.xbgr.xm51_u2.nsg13_hv_pmos[l]
print @n.xbgr.xm51_u2.nsg13_hv_pmos[delvto]
print @n.xbgr.xm51_u2.nsg13_hv_pmos[factuo]
print @n.xbgr.xm51_u3.nsg13_hv_pmos[w]
print @n.xbgr.xm51_u3.nsg13_hv_pmos[l]
print @n.xbgr.xm51_u3.nsg13_hv_pmos[delvto]
print @n.xbgr.xm51_u3.nsg13_hv_pmos[factuo]
print @n.xbgr.xm51_u4.nsg13_hv_pmos[w]
print @n.xbgr.xm51_u4.nsg13_hv_pmos[l]
print @n.xbgr.xm51_u4.nsg13_hv_pmos[delvto]
print @n.xbgr.xm51_u4.nsg13_hv_pmos[factuo]
print @n.xbgr.xm52_u2.nsg13_hv_pmos[w]
print @n.xbgr.xm52_u2.nsg13_hv_pmos[l]
print @n.xbgr.xm52_u2.nsg13_hv_pmos[delvto]
print @n.xbgr.xm52_u2.nsg13_hv_pmos[factuo]
print @n.xbgr.xm52_u3.nsg13_hv_pmos[w]
print @n.xbgr.xm52_u3.nsg13_hv_pmos[l]
print @n.xbgr.xm52_u3.nsg13_hv_pmos[delvto]
print @n.xbgr.xm52_u3.nsg13_hv_pmos[factuo]
print @n.xbgr.xm52_u4.nsg13_hv_pmos[w]
print @n.xbgr.xm52_u4.nsg13_hv_pmos[l]
print @n.xbgr.xm52_u4.nsg13_hv_pmos[delvto]
print @n.xbgr.xm52_u4.nsg13_hv_pmos[factuo]
print @n.xbgr.xm52_u5.nsg13_hv_pmos[w]
print @n.xbgr.xm52_u5.nsg13_hv_pmos[l]
print @n.xbgr.xm52_u5.nsg13_hv_pmos[delvto]
print @n.xbgr.xm52_u5.nsg13_hv_pmos[factuo]
print @n.xbgr.xm52_u6.nsg13_hv_pmos[w]
print @n.xbgr.xm52_u6.nsg13_hv_pmos[l]
print @n.xbgr.xm52_u6.nsg13_hv_pmos[delvto]
print @n.xbgr.xm52_u6.nsg13_hv_pmos[factuo]
print @n.xbgr.xm52_u7.nsg13_hv_pmos[w]
print @n.xbgr.xm52_u7.nsg13_hv_pmos[l]
print @n.xbgr.xm52_u7.nsg13_hv_pmos[delvto]
print @n.xbgr.xm52_u7.nsg13_hv_pmos[factuo]
print @n.xbgr.xm52_u8.nsg13_hv_pmos[w]
print @n.xbgr.xm52_u8.nsg13_hv_pmos[l]
print @n.xbgr.xm52_u8.nsg13_hv_pmos[delvto]
print @n.xbgr.xm52_u8.nsg13_hv_pmos[factuo]
print @n.xbgr.xm52_u9.nsg13_hv_pmos[w]
print @n.xbgr.xm52_u9.nsg13_hv_pmos[l]
print @n.xbgr.xm52_u9.nsg13_hv_pmos[delvto]
print @n.xbgr.xm52_u9.nsg13_hv_pmos[factuo]
print @n.xbgr.xm52_u10.nsg13_hv_pmos[w]
print @n.xbgr.xm52_u10.nsg13_hv_pmos[l]
print @n.xbgr.xm52_u10.nsg13_hv_pmos[delvto]
print @n.xbgr.xm52_u10.nsg13_hv_pmos[factuo]
print @n.xbgr.xm52_u11.nsg13_hv_pmos[w]
print @n.xbgr.xm52_u11.nsg13_hv_pmos[l]
print @n.xbgr.xm52_u11.nsg13_hv_pmos[delvto]
print @n.xbgr.xm52_u11.nsg13_hv_pmos[factuo]
print @n.xbgr.xm52_u12.nsg13_hv_pmos[w]
print @n.xbgr.xm52_u12.nsg13_hv_pmos[l]
print @n.xbgr.xm52_u12.nsg13_hv_pmos[delvto]
print @n.xbgr.xm52_u12.nsg13_hv_pmos[factuo]
print @n.xbgr.xm52_u13.nsg13_hv_pmos[w]
print @n.xbgr.xm52_u13.nsg13_hv_pmos[l]
print @n.xbgr.xm52_u13.nsg13_hv_pmos[delvto]
print @n.xbgr.xm52_u13.nsg13_hv_pmos[factuo]
print @n.xbgr.xm52_u14.nsg13_hv_pmos[w]
print @n.xbgr.xm52_u14.nsg13_hv_pmos[l]
print @n.xbgr.xm52_u14.nsg13_hv_pmos[delvto]
print @n.xbgr.xm52_u14.nsg13_hv_pmos[factuo]
print @n.xbgr.xm52_u15.nsg13_hv_pmos[w]
print @n.xbgr.xm52_u15.nsg13_hv_pmos[l]
print @n.xbgr.xm52_u15.nsg13_hv_pmos[delvto]
print @n.xbgr.xm52_u15.nsg13_hv_pmos[factuo]
print @n.xbgr.xm52_u16.nsg13_hv_pmos[w]
print @n.xbgr.xm52_u16.nsg13_hv_pmos[l]
print @n.xbgr.xm52_u16.nsg13_hv_pmos[delvto]
print @n.xbgr.xm52_u16.nsg13_hv_pmos[factuo]
print @n.xbgr.xm52_u17.nsg13_hv_pmos[w]
print @n.xbgr.xm52_u17.nsg13_hv_pmos[l]
print @n.xbgr.xm52_u17.nsg13_hv_pmos[delvto]
print @n.xbgr.xm52_u17.nsg13_hv_pmos[factuo]
print @n.xbgr.xm52_u18.nsg13_hv_pmos[w]
print @n.xbgr.xm52_u18.nsg13_hv_pmos[l]
print @n.xbgr.xm52_u18.nsg13_hv_pmos[delvto]
print @n.xbgr.xm52_u18.nsg13_hv_pmos[factuo]
print @n.xbgr.xm52_u19.nsg13_hv_pmos[w]
print @n.xbgr.xm52_u19.nsg13_hv_pmos[l]
print @n.xbgr.xm52_u19.nsg13_hv_pmos[delvto]
print @n.xbgr.xm52_u19.nsg13_hv_pmos[factuo]
print @n.xbgr.xm52_u20.nsg13_hv_pmos[w]
print @n.xbgr.xm52_u20.nsg13_hv_pmos[l]
print @n.xbgr.xm52_u20.nsg13_hv_pmos[delvto]
print @n.xbgr.xm52_u20.nsg13_hv_pmos[factuo]
print @n.xbgr.xm52_u21.nsg13_hv_pmos[w]
print @n.xbgr.xm52_u21.nsg13_hv_pmos[l]
print @n.xbgr.xm52_u21.nsg13_hv_pmos[delvto]
print @n.xbgr.xm52_u21.nsg13_hv_pmos[factuo]
print @n.xbgr.xm52_u22.nsg13_hv_pmos[w]
print @n.xbgr.xm52_u22.nsg13_hv_pmos[l]
print @n.xbgr.xm52_u22.nsg13_hv_pmos[delvto]
print @n.xbgr.xm52_u22.nsg13_hv_pmos[factuo]
print @n.xbgr.xm52_u23.nsg13_hv_pmos[w]
print @n.xbgr.xm52_u23.nsg13_hv_pmos[l]
print @n.xbgr.xm52_u23.nsg13_hv_pmos[delvto]
print @n.xbgr.xm52_u23.nsg13_hv_pmos[factuo]
print @n.xbgr.xm52_u24.nsg13_hv_pmos[w]
print @n.xbgr.xm52_u24.nsg13_hv_pmos[l]
print @n.xbgr.xm52_u24.nsg13_hv_pmos[delvto]
print @n.xbgr.xm52_u24.nsg13_hv_pmos[factuo]
print @n.xbgr.xm54_u2.nsg13_hv_pmos[w]
print @n.xbgr.xm54_u2.nsg13_hv_pmos[l]
print @n.xbgr.xm54_u2.nsg13_hv_pmos[delvto]
print @n.xbgr.xm54_u2.nsg13_hv_pmos[factuo]
print @n.xbgr.xm54_u3.nsg13_hv_pmos[w]
print @n.xbgr.xm54_u3.nsg13_hv_pmos[l]
print @n.xbgr.xm54_u3.nsg13_hv_pmos[delvto]
print @n.xbgr.xm54_u3.nsg13_hv_pmos[factuo]
print @n.xbgr.xm54_u4.nsg13_hv_pmos[w]
print @n.xbgr.xm54_u4.nsg13_hv_pmos[l]
print @n.xbgr.xm54_u4.nsg13_hv_pmos[delvto]
print @n.xbgr.xm54_u4.nsg13_hv_pmos[factuo]
print @n.xbgr.xm54_u5.nsg13_hv_pmos[w]
print @n.xbgr.xm54_u5.nsg13_hv_pmos[l]
print @n.xbgr.xm54_u5.nsg13_hv_pmos[delvto]
print @n.xbgr.xm54_u5.nsg13_hv_pmos[factuo]
print @n.xbgr.xm54_u6.nsg13_hv_pmos[w]
print @n.xbgr.xm54_u6.nsg13_hv_pmos[l]
print @n.xbgr.xm54_u6.nsg13_hv_pmos[delvto]
print @n.xbgr.xm54_u6.nsg13_hv_pmos[factuo]
print @n.xbgr.xm54_u7.nsg13_hv_pmos[w]
print @n.xbgr.xm54_u7.nsg13_hv_pmos[l]
print @n.xbgr.xm54_u7.nsg13_hv_pmos[delvto]
print @n.xbgr.xm54_u7.nsg13_hv_pmos[factuo]
print @n.xbgr.xm54_u8.nsg13_hv_pmos[w]
print @n.xbgr.xm54_u8.nsg13_hv_pmos[l]
print @n.xbgr.xm54_u8.nsg13_hv_pmos[delvto]
print @n.xbgr.xm54_u8.nsg13_hv_pmos[factuo]
print @n.xbgr.xm54_u9.nsg13_hv_pmos[w]
print @n.xbgr.xm54_u9.nsg13_hv_pmos[l]
print @n.xbgr.xm54_u9.nsg13_hv_pmos[delvto]
print @n.xbgr.xm54_u9.nsg13_hv_pmos[factuo]
print @n.xbgr.xm54_u10.nsg13_hv_pmos[w]
print @n.xbgr.xm54_u10.nsg13_hv_pmos[l]
print @n.xbgr.xm54_u10.nsg13_hv_pmos[delvto]
print @n.xbgr.xm54_u10.nsg13_hv_pmos[factuo]
print @n.xbgr.xm54_u11.nsg13_hv_pmos[w]
print @n.xbgr.xm54_u11.nsg13_hv_pmos[l]
print @n.xbgr.xm54_u11.nsg13_hv_pmos[delvto]
print @n.xbgr.xm54_u11.nsg13_hv_pmos[factuo]
print @n.xbgr.xm54_u12.nsg13_hv_pmos[w]
print @n.xbgr.xm54_u12.nsg13_hv_pmos[l]
print @n.xbgr.xm54_u12.nsg13_hv_pmos[delvto]
print @n.xbgr.xm54_u12.nsg13_hv_pmos[factuo]
print @n.xbgr.xm54_u13.nsg13_hv_pmos[w]
print @n.xbgr.xm54_u13.nsg13_hv_pmos[l]
print @n.xbgr.xm54_u13.nsg13_hv_pmos[delvto]
print @n.xbgr.xm54_u13.nsg13_hv_pmos[factuo]
print @n.xbgr.xm54_u14.nsg13_hv_pmos[w]
print @n.xbgr.xm54_u14.nsg13_hv_pmos[l]
print @n.xbgr.xm54_u14.nsg13_hv_pmos[delvto]
print @n.xbgr.xm54_u14.nsg13_hv_pmos[factuo]
print @n.xbgr.xm54_u15.nsg13_hv_pmos[w]
print @n.xbgr.xm54_u15.nsg13_hv_pmos[l]
print @n.xbgr.xm54_u15.nsg13_hv_pmos[delvto]
print @n.xbgr.xm54_u15.nsg13_hv_pmos[factuo]
print @n.xbgr.xm54_u16.nsg13_hv_pmos[w]
print @n.xbgr.xm54_u16.nsg13_hv_pmos[l]
print @n.xbgr.xm54_u16.nsg13_hv_pmos[delvto]
print @n.xbgr.xm54_u16.nsg13_hv_pmos[factuo]
print @n.xbgr.xm54_u17.nsg13_hv_pmos[w]
print @n.xbgr.xm54_u17.nsg13_hv_pmos[l]
print @n.xbgr.xm54_u17.nsg13_hv_pmos[delvto]
print @n.xbgr.xm54_u17.nsg13_hv_pmos[factuo]
print @n.xbgr.xm54_u18.nsg13_hv_pmos[w]
print @n.xbgr.xm54_u18.nsg13_hv_pmos[l]
print @n.xbgr.xm54_u18.nsg13_hv_pmos[delvto]
print @n.xbgr.xm54_u18.nsg13_hv_pmos[factuo]
print @n.xbgr.xm54_u19.nsg13_hv_pmos[w]
print @n.xbgr.xm54_u19.nsg13_hv_pmos[l]
print @n.xbgr.xm54_u19.nsg13_hv_pmos[delvto]
print @n.xbgr.xm54_u19.nsg13_hv_pmos[factuo]
print @n.xbgr.xm54_u20.nsg13_hv_pmos[w]
print @n.xbgr.xm54_u20.nsg13_hv_pmos[l]
print @n.xbgr.xm54_u20.nsg13_hv_pmos[delvto]
print @n.xbgr.xm54_u20.nsg13_hv_pmos[factuo]
print @n.xbgr.xm54_u21.nsg13_hv_pmos[w]
print @n.xbgr.xm54_u21.nsg13_hv_pmos[l]
print @n.xbgr.xm54_u21.nsg13_hv_pmos[delvto]
print @n.xbgr.xm54_u21.nsg13_hv_pmos[factuo]
print @n.xbgr.xm54_u22.nsg13_hv_pmos[w]
print @n.xbgr.xm54_u22.nsg13_hv_pmos[l]
print @n.xbgr.xm54_u22.nsg13_hv_pmos[delvto]
print @n.xbgr.xm54_u22.nsg13_hv_pmos[factuo]
print @n.xbgr.xm54_u23.nsg13_hv_pmos[w]
print @n.xbgr.xm54_u23.nsg13_hv_pmos[l]
print @n.xbgr.xm54_u23.nsg13_hv_pmos[delvto]
print @n.xbgr.xm54_u23.nsg13_hv_pmos[factuo]
print @n.xbgr.xm54_u24.nsg13_hv_pmos[w]
print @n.xbgr.xm54_u24.nsg13_hv_pmos[l]
print @n.xbgr.xm54_u24.nsg13_hv_pmos[delvto]
print @n.xbgr.xm54_u24.nsg13_hv_pmos[factuo]
print @q.xbgr.xq56_u2.qnpn13g2[area]
print @q.xbgr.xq56_u3.qnpn13g2[area]
print @q.xbgr.xq56_u4.qnpn13g2[area]
print @q.xbgr.xq56_u5.qnpn13g2[area]
print @q.xbgr.xq56_u6.qnpn13g2[area]
print @q.xbgr.xq56_u7.qnpn13g2[area]
print @q.xbgr.xq56_u8.qnpn13g2[area]
print @q.xbgr.xq56_u9.qnpn13g2[area]
print @q.xbgr.xq56_u10.qnpn13g2[area]
print @q.xbgr.xq56_u11.qnpn13g2[area]
print @q.xbgr.xq56_u12.qnpn13g2[area]
print @q.xbgr.xq56_u13.qnpn13g2[area]
print @q.xbgr.xq56_u14.qnpn13g2[area]
print @q.xbgr.xq56_u15.qnpn13g2[area]
print @q.xbgr.xq56_u16.qnpn13g2[area]
print @q.xbgr.xq56_u17.qnpn13g2[area]
print @q.xbgr.xq56_u18.qnpn13g2[area]
print @q.xbgr.xq56_u19.qnpn13g2[area]
print @q.xbgr.xq56_u20.qnpn13g2[area]
print @q.xbgr.xq56_u21.qnpn13g2[area]
print @q.xbgr.xq56_u22.qnpn13g2[area]
print @q.xbgr.xq56_u23.qnpn13g2[area]
print @q.xbgr.xq56_u24.qnpn13g2[area]
print @q.xbgr.xq60_u2.qnpn13g2[area]
print @q.xbgr.xq60_u3.qnpn13g2[area]
print @q.xbgr.xq60_u4.qnpn13g2[area]
print @q.xbgr.xq62_u2.qnpn13g2[area]
print @q.xbgr.xq62_u3.qnpn13g2[area]
print @q.xbgr.xq62_u4.qnpn13g2[area]
print @q.xbgr.xq62_u5.qnpn13g2[area]
print @q.xbgr.xq62_u6.qnpn13g2[area]
print @q.xbgr.xq62_u7.qnpn13g2[area]
print @q.xbgr.xq62_u8.qnpn13g2[area]
print @q.xbgr.xq62_u9.qnpn13g2[area]
print @q.xbgr.xq62_u10.qnpn13g2[area]
print @q.xbgr.xq62_u11.qnpn13g2[area]
print @q.xbgr.xq62_u12.qnpn13g2[area]
print @q.xbgr.xq62_u13.qnpn13g2[area]
print @q.xbgr.xq62_u14.qnpn13g2[area]
print @q.xbgr.xq62_u15.qnpn13g2[area]
print @q.xbgr.xq62_u16.qnpn13g2[area]
print @q.xbgr.xq62_u17.qnpn13g2[area]
print @q.xbgr.xq62_u18.qnpn13g2[area]
print @q.xbgr.xq62_u19.qnpn13g2[area]
print @q.xbgr.xq62_u20.qnpn13g2[area]
print @q.xbgr.xq62_u21.qnpn13g2[area]
print @q.xbgr.xq62_u22.qnpn13g2[area]
print @q.xbgr.xq62_u23.qnpn13g2[area]
print @q.xbgr.xq62_u24.qnpn13g2[area]
print @q.xbgr.xq67_u2.qnpn13g2[area]
print @q.xbgr.xq67_u3.qnpn13g2[area]
print @q.xbgr.xq67_u4.qnpn13g2[area]
print @q.xbgr.xq67_u5.qnpn13g2[area]
print @q.xbgr.xq67_u6.qnpn13g2[area]
print @q.xbgr.xq67_u7.qnpn13g2[area]
print @q.xbgr.xq67_u8.qnpn13g2[area]
print @q.xbgr.xq67_u9.qnpn13g2[area]
print @q.xbgr.xq67_u10.qnpn13g2[area]
print @q.xbgr.xq67_u11.qnpn13g2[area]
print @q.xbgr.xq67_u12.qnpn13g2[area]
print @q.xbgr.xq67_u13.qnpn13g2[area]
print @q.xbgr.xq67_u14.qnpn13g2[area]
print @q.xbgr.xq67_u15.qnpn13g2[area]
print @q.xbgr.xq67_u16.qnpn13g2[area]
print @q.xbgr.xq67_u17.qnpn13g2[area]
print @q.xbgr.xq67_u18.qnpn13g2[area]
print @q.xbgr.xq67_u19.qnpn13g2[area]
print @q.xbgr.xq67_u20.qnpn13g2[area]
print @q.xbgr.xq67_u21.qnpn13g2[area]
print @q.xbgr.xq67_u22.qnpn13g2[area]
print @q.xbgr.xq67_u23.qnpn13g2[area]
print @q.xbgr.xq67_u24.qnpn13g2[area]
print @q.xbgr.xq68_u2.qnpn13g2[area]
print @q.xbgr.xq68_u3.qnpn13g2[area]
print @q.xbgr.xq68_u4.qnpn13g2[area]
print @q.xbgr.xq68_u5.qnpn13g2[area]
print @q.xbgr.xq68_u6.qnpn13g2[area]
print @q.xbgr.xq68_u7.qnpn13g2[area]
print @q.xbgr.xq68_u8.qnpn13g2[area]
print @q.xbgr.xq68_u9.qnpn13g2[area]
print @q.xbgr.xq68_u10.qnpn13g2[area]
print @q.xbgr.xq68_u11.qnpn13g2[area]
print @q.xbgr.xq68_u12.qnpn13g2[area]
print @q.xbgr.xq68_u13.qnpn13g2[area]
print @q.xbgr.xq68_u14.qnpn13g2[area]
print @q.xbgr.xq68_u15.qnpn13g2[area]
print @q.xbgr.xq68_u16.qnpn13g2[area]
print @q.xbgr.xq68_u17.qnpn13g2[area]
print @q.xbgr.xq68_u18.qnpn13g2[area]
print @q.xbgr.xq68_u19.qnpn13g2[area]
print @q.xbgr.xq68_u20.qnpn13g2[area]
print @q.xbgr.xq68_u21.qnpn13g2[area]
print @q.xbgr.xq68_u22.qnpn13g2[area]
print @q.xbgr.xq68_u23.qnpn13g2[area]
print @q.xbgr.xq68_u24.qnpn13g2[area]
print @q.xbgr.xq69_u2.qnpn13g2[area]
print @q.xbgr.xq69_u3.qnpn13g2[area]
print @q.xbgr.xq69_u4.qnpn13g2[area]
print @q.xbgr.xq69_u5.qnpn13g2[area]
print @q.xbgr.xq69_u6.qnpn13g2[area]
print @q.xbgr.xq69_u7.qnpn13g2[area]
print @q.xbgr.xq69_u8.qnpn13g2[area]
print @q.xbgr.xq69_u9.qnpn13g2[area]
print @q.xbgr.xq69_u10.qnpn13g2[area]
print @q.xbgr.xq69_u11.qnpn13g2[area]
print @q.xbgr.xq69_u12.qnpn13g2[area]
print @q.xbgr.xq69_u13.qnpn13g2[area]
print @q.xbgr.xq69_u14.qnpn13g2[area]
print @q.xbgr.xq69_u15.qnpn13g2[area]
print @q.xbgr.xq69_u16.qnpn13g2[area]
print @q.xbgr.xq69_u17.qnpn13g2[area]
print @q.xbgr.xq69_u18.qnpn13g2[area]
print @q.xbgr.xq69_u19.qnpn13g2[area]
print @q.xbgr.xq69_u20.qnpn13g2[area]
print @q.xbgr.xq69_u21.qnpn13g2[area]
print @q.xbgr.xq69_u22.qnpn13g2[area]
print @q.xbgr.xq69_u23.qnpn13g2[area]
print @q.xbgr.xq69_u24.qnpn13g2[area]
print @q.xbgr.xq70_u2.qnpn13g2[area]
print @q.xbgr.xq70_u3.qnpn13g2[area]
print @q.xbgr.xq70_u4.qnpn13g2[area]
print @q.xbgr.xq70_u5.qnpn13g2[area]
print @q.xbgr.xq70_u6.qnpn13g2[area]
print @q.xbgr.xq70_u7.qnpn13g2[area]
print @q.xbgr.xq70_u8.qnpn13g2[area]
print @q.xbgr.xq70_u9.qnpn13g2[area]
print @q.xbgr.xq70_u10.qnpn13g2[area]
print @q.xbgr.xq70_u11.qnpn13g2[area]
print @q.xbgr.xq70_u12.qnpn13g2[area]
print @q.xbgr.xq70_u13.qnpn13g2[area]
print @q.xbgr.xq70_u14.qnpn13g2[area]
print @q.xbgr.xq70_u15.qnpn13g2[area]
print @q.xbgr.xq70_u16.qnpn13g2[area]
print @q.xbgr.xq70_u17.qnpn13g2[area]
print @q.xbgr.xq70_u18.qnpn13g2[area]
print @q.xbgr.xq70_u19.qnpn13g2[area]
print @q.xbgr.xq70_u20.qnpn13g2[area]
print @q.xbgr.xq70_u21.qnpn13g2[area]
print @q.xbgr.xq70_u22.qnpn13g2[area]
print @q.xbgr.xq70_u23.qnpn13g2[area]
print @q.xbgr.xq70_u24.qnpn13g2[area]
print @q.xbgr.xq71_u2.qnpn13g2[area]
print @q.xbgr.xq71_u3.qnpn13g2[area]
print @q.xbgr.xq71_u4.qnpn13g2[area]
print @q.xbgr.xq71_u5.qnpn13g2[area]
print @q.xbgr.xq71_u6.qnpn13g2[area]
print @q.xbgr.xq71_u7.qnpn13g2[area]
print @q.xbgr.xq71_u8.qnpn13g2[area]
print @q.xbgr.xq71_u9.qnpn13g2[area]
print @q.xbgr.xq71_u10.qnpn13g2[area]
print @q.xbgr.xq71_u11.qnpn13g2[area]
print @q.xbgr.xq71_u12.qnpn13g2[area]
print @q.xbgr.xq71_u13.qnpn13g2[area]
print @q.xbgr.xq71_u14.qnpn13g2[area]
print @q.xbgr.xq71_u15.qnpn13g2[area]
print @q.xbgr.xq71_u16.qnpn13g2[area]
print @q.xbgr.xq71_u17.qnpn13g2[area]
print @q.xbgr.xq71_u18.qnpn13g2[area]
print @q.xbgr.xq71_u19.qnpn13g2[area]
print @q.xbgr.xq71_u20.qnpn13g2[area]
print @q.xbgr.xq71_u21.qnpn13g2[area]
print @q.xbgr.xq71_u22.qnpn13g2[area]
print @q.xbgr.xq71_u23.qnpn13g2[area]
print @q.xbgr.xq71_u24.qnpn13g2[area]
print @q.xbgr.xq72_u2.qnpn13g2[area]
print @q.xbgr.xq72_u3.qnpn13g2[area]
print @q.xbgr.xq72_u4.qnpn13g2[area]
print @q.xbgr.xq72_u5.qnpn13g2[area]
print @q.xbgr.xq72_u6.qnpn13g2[area]
print @q.xbgr.xq72_u7.qnpn13g2[area]
print @q.xbgr.xq72_u8.qnpn13g2[area]
print @q.xbgr.xq72_u9.qnpn13g2[area]
print @q.xbgr.xq72_u10.qnpn13g2[area]
print @q.xbgr.xq72_u11.qnpn13g2[area]
print @q.xbgr.xq72_u12.qnpn13g2[area]
print @q.xbgr.xq72_u13.qnpn13g2[area]
print @q.xbgr.xq72_u14.qnpn13g2[area]
print @q.xbgr.xq72_u15.qnpn13g2[area]
print @q.xbgr.xq72_u16.qnpn13g2[area]
print @q.xbgr.xq72_u17.qnpn13g2[area]
print @q.xbgr.xq72_u18.qnpn13g2[area]
print @q.xbgr.xq72_u19.qnpn13g2[area]
print @q.xbgr.xq72_u20.qnpn13g2[area]
print @q.xbgr.xq72_u21.qnpn13g2[area]
print @q.xbgr.xq72_u22.qnpn13g2[area]
print @q.xbgr.xq72_u23.qnpn13g2[area]
print @q.xbgr.xq72_u24.qnpn13g2[area]
print @q.xbgr.xq73_u2.qnpn13g2[area]
print @q.xbgr.xq73_u3.qnpn13g2[area]
print @q.xbgr.xq73_u4.qnpn13g2[area]
print @q.xbgr.xq73_u5.qnpn13g2[area]
print @q.xbgr.xq73_u6.qnpn13g2[area]
print @q.xbgr.xq73_u7.qnpn13g2[area]
print @q.xbgr.xq73_u8.qnpn13g2[area]
print @q.xbgr.xq73_u9.qnpn13g2[area]
print @q.xbgr.xq73_u10.qnpn13g2[area]
print @q.xbgr.xq73_u11.qnpn13g2[area]
print @q.xbgr.xq73_u12.qnpn13g2[area]
print @q.xbgr.xq73_u13.qnpn13g2[area]
print @q.xbgr.xq73_u14.qnpn13g2[area]
print @q.xbgr.xq73_u15.qnpn13g2[area]
print @q.xbgr.xq73_u16.qnpn13g2[area]
print @q.xbgr.xq73_u17.qnpn13g2[area]
print @q.xbgr.xq73_u18.qnpn13g2[area]
print @q.xbgr.xq73_u19.qnpn13g2[area]
print @q.xbgr.xq73_u20.qnpn13g2[area]
print @q.xbgr.xq73_u21.qnpn13g2[area]
print @q.xbgr.xq73_u22.qnpn13g2[area]
print @q.xbgr.xq73_u23.qnpn13g2[area]
print @q.xbgr.xq73_u24.qnpn13g2[area]
print @q.xbgr.xq74_u2.qnpn13g2[area]
print @q.xbgr.xq74_u3.qnpn13g2[area]
print @q.xbgr.xq74_u4.qnpn13g2[area]
print @q.xbgr.xq74_u5.qnpn13g2[area]
print @q.xbgr.xq74_u6.qnpn13g2[area]
print @q.xbgr.xq74_u7.qnpn13g2[area]
print @q.xbgr.xq74_u8.qnpn13g2[area]
print @q.xbgr.xq74_u9.qnpn13g2[area]
print @q.xbgr.xq74_u10.qnpn13g2[area]
print @q.xbgr.xq74_u11.qnpn13g2[area]
print @q.xbgr.xq74_u12.qnpn13g2[area]
print @q.xbgr.xq74_u13.qnpn13g2[area]
print @q.xbgr.xq74_u14.qnpn13g2[area]
print @q.xbgr.xq74_u15.qnpn13g2[area]
print @q.xbgr.xq74_u16.qnpn13g2[area]
print @q.xbgr.xq74_u17.qnpn13g2[area]
print @q.xbgr.xq74_u18.qnpn13g2[area]
print @q.xbgr.xq74_u19.qnpn13g2[area]
print @q.xbgr.xq74_u20.qnpn13g2[area]
print @q.xbgr.xq74_u21.qnpn13g2[area]
print @q.xbgr.xq74_u22.qnpn13g2[area]
print @q.xbgr.xq74_u23.qnpn13g2[area]
print @q.xbgr.xq74_u24.qnpn13g2[area]
print @q.xbgr.xq75_u2.qnpn13g2[area]
print @q.xbgr.xq75_u3.qnpn13g2[area]
print @q.xbgr.xq75_u4.qnpn13g2[area]
print @q.xbgr.xq75_u5.qnpn13g2[area]
print @q.xbgr.xq75_u6.qnpn13g2[area]
print @q.xbgr.xq75_u7.qnpn13g2[area]
print @q.xbgr.xq75_u8.qnpn13g2[area]
print @q.xbgr.xq75_u9.qnpn13g2[area]
print @q.xbgr.xq75_u10.qnpn13g2[area]
print @q.xbgr.xq75_u11.qnpn13g2[area]
print @q.xbgr.xq75_u12.qnpn13g2[area]
print @q.xbgr.xq75_u13.qnpn13g2[area]
print @q.xbgr.xq75_u14.qnpn13g2[area]
print @q.xbgr.xq75_u15.qnpn13g2[area]
print @q.xbgr.xq75_u16.qnpn13g2[area]
print @q.xbgr.xq75_u17.qnpn13g2[area]
print @q.xbgr.xq75_u18.qnpn13g2[area]
print @q.xbgr.xq75_u19.qnpn13g2[area]
print @q.xbgr.xq75_u20.qnpn13g2[area]
print @q.xbgr.xq75_u21.qnpn13g2[area]
print @q.xbgr.xq75_u22.qnpn13g2[area]
print @q.xbgr.xq75_u23.qnpn13g2[area]
print @q.xbgr.xq75_u24.qnpn13g2[area]
print @q.xbgr.xq76_u2.qnpn13g2[area]
print @q.xbgr.xq76_u3.qnpn13g2[area]
print @q.xbgr.xq76_u4.qnpn13g2[area]
print @q.xbgr.xq76_u5.qnpn13g2[area]
print @q.xbgr.xq76_u6.qnpn13g2[area]
print @q.xbgr.xq76_u7.qnpn13g2[area]
print @q.xbgr.xq76_u8.qnpn13g2[area]
print @q.xbgr.xq76_u9.qnpn13g2[area]
print @q.xbgr.xq76_u10.qnpn13g2[area]
print @q.xbgr.xq76_u11.qnpn13g2[area]
print @q.xbgr.xq76_u12.qnpn13g2[area]
print @q.xbgr.xq76_u13.qnpn13g2[area]
print @q.xbgr.xq76_u14.qnpn13g2[area]
print @q.xbgr.xq76_u15.qnpn13g2[area]
print @q.xbgr.xq76_u16.qnpn13g2[area]
print @q.xbgr.xq76_u17.qnpn13g2[area]
print @q.xbgr.xq76_u18.qnpn13g2[area]
print @q.xbgr.xq76_u19.qnpn13g2[area]
print @q.xbgr.xq76_u20.qnpn13g2[area]
print @q.xbgr.xq76_u21.qnpn13g2[area]
print @q.xbgr.xq76_u22.qnpn13g2[area]
print @q.xbgr.xq76_u23.qnpn13g2[area]
print @q.xbgr.xq76_u24.qnpn13g2[area]
print @n.xbgr.xr77_u2.nr1[nsmm_rsh]
print @n.xbgr.xr77_u2.nr1[nsmm_w]
print @n.xbgr.xr77_u2.nr1[nsmm_l]
print @n.xbgr.xr77_u3.nr1[nsmm_rsh]
print @n.xbgr.xr77_u3.nr1[nsmm_w]
print @n.xbgr.xr77_u3.nr1[nsmm_l]
print @n.xbgr.xr77_u4.nr1[nsmm_rsh]
print @n.xbgr.xr77_u4.nr1[nsmm_w]
print @n.xbgr.xr77_u4.nr1[nsmm_l]
print @n.xbgr.xr77_u5.nr1[nsmm_rsh]
print @n.xbgr.xr77_u5.nr1[nsmm_w]
print @n.xbgr.xr77_u5.nr1[nsmm_l]
print @n.xbgr.xr77_u6.nr1[nsmm_rsh]
print @n.xbgr.xr77_u6.nr1[nsmm_w]
print @n.xbgr.xr77_u6.nr1[nsmm_l]
print @n.xbgr.xr77_u7.nr1[nsmm_rsh]
print @n.xbgr.xr77_u7.nr1[nsmm_w]
print @n.xbgr.xr77_u7.nr1[nsmm_l]
print @n.xbgr.xr77_u8.nr1[nsmm_rsh]
print @n.xbgr.xr77_u8.nr1[nsmm_w]
print @n.xbgr.xr77_u8.nr1[nsmm_l]
print @n.xbgr.xr77_u9.nr1[nsmm_rsh]
print @n.xbgr.xr77_u9.nr1[nsmm_w]
print @n.xbgr.xr77_u9.nr1[nsmm_l]
print @n.xbgr.xr77_u10.nr1[nsmm_rsh]
print @n.xbgr.xr77_u10.nr1[nsmm_w]
print @n.xbgr.xr77_u10.nr1[nsmm_l]
print @n.xbgr.xr77_u11.nr1[nsmm_rsh]
print @n.xbgr.xr77_u11.nr1[nsmm_w]
print @n.xbgr.xr77_u11.nr1[nsmm_l]
print @n.xbgr.xr77_u12.nr1[nsmm_rsh]
print @n.xbgr.xr77_u12.nr1[nsmm_w]
print @n.xbgr.xr77_u12.nr1[nsmm_l]
print @n.xbgr.xr77_u13.nr1[nsmm_rsh]
print @n.xbgr.xr77_u13.nr1[nsmm_w]
print @n.xbgr.xr77_u13.nr1[nsmm_l]
print @n.xbgr.xr77_u14.nr1[nsmm_rsh]
print @n.xbgr.xr77_u14.nr1[nsmm_w]
print @n.xbgr.xr77_u14.nr1[nsmm_l]
print @n.xbgr.xr77_u15.nr1[nsmm_rsh]
print @n.xbgr.xr77_u15.nr1[nsmm_w]
print @n.xbgr.xr77_u15.nr1[nsmm_l]
print @n.xbgr.xr77_u16.nr1[nsmm_rsh]
print @n.xbgr.xr77_u16.nr1[nsmm_w]
print @n.xbgr.xr77_u16.nr1[nsmm_l]
print @n.xbgr.xr77_u17.nr1[nsmm_rsh]
print @n.xbgr.xr77_u17.nr1[nsmm_w]
print @n.xbgr.xr77_u17.nr1[nsmm_l]
print @n.xbgr.xr77_u18.nr1[nsmm_rsh]
print @n.xbgr.xr77_u18.nr1[nsmm_w]
print @n.xbgr.xr77_u18.nr1[nsmm_l]
print @n.xbgr.xr77_u19.nr1[nsmm_rsh]
print @n.xbgr.xr77_u19.nr1[nsmm_w]
print @n.xbgr.xr77_u19.nr1[nsmm_l]
print @n.xbgr.xr77_u20.nr1[nsmm_rsh]
print @n.xbgr.xr77_u20.nr1[nsmm_w]
print @n.xbgr.xr77_u20.nr1[nsmm_l]
print @n.xbgr.xr77_u21.nr1[nsmm_rsh]
print @n.xbgr.xr77_u21.nr1[nsmm_w]
print @n.xbgr.xr77_u21.nr1[nsmm_l]
print @n.xbgr.xr77_u22.nr1[nsmm_rsh]
print @n.xbgr.xr77_u22.nr1[nsmm_w]
print @n.xbgr.xr77_u22.nr1[nsmm_l]
print @n.xbgr.xr77_u23.nr1[nsmm_rsh]
print @n.xbgr.xr77_u23.nr1[nsmm_w]
print @n.xbgr.xr77_u23.nr1[nsmm_l]
print @n.xbgr.xr77_u24.nr1[nsmm_rsh]
print @n.xbgr.xr77_u24.nr1[nsmm_w]
print @n.xbgr.xr77_u24.nr1[nsmm_l]
print @n.xbgr.xr78_u2.nr1[nsmm_rsh]
print @n.xbgr.xr78_u2.nr1[nsmm_w]
print @n.xbgr.xr78_u2.nr1[nsmm_l]
print @n.xbgr.xr78_u3.nr1[nsmm_rsh]
print @n.xbgr.xr78_u3.nr1[nsmm_w]
print @n.xbgr.xr78_u3.nr1[nsmm_l]
print @n.xbgr.xr78_u4.nr1[nsmm_rsh]
print @n.xbgr.xr78_u4.nr1[nsmm_w]
print @n.xbgr.xr78_u4.nr1[nsmm_l]
print @n.xbgr.xr78_u5.nr1[nsmm_rsh]
print @n.xbgr.xr78_u5.nr1[nsmm_w]
print @n.xbgr.xr78_u5.nr1[nsmm_l]
print @n.xbgr.xr78_u6.nr1[nsmm_rsh]
print @n.xbgr.xr78_u6.nr1[nsmm_w]
print @n.xbgr.xr78_u6.nr1[nsmm_l]
print @n.xbgr.xr78_u7.nr1[nsmm_rsh]
print @n.xbgr.xr78_u7.nr1[nsmm_w]
print @n.xbgr.xr78_u7.nr1[nsmm_l]
print @n.xbgr.xr78_u8.nr1[nsmm_rsh]
print @n.xbgr.xr78_u8.nr1[nsmm_w]
print @n.xbgr.xr78_u8.nr1[nsmm_l]
print @n.xbgr.xr78_u9.nr1[nsmm_rsh]
print @n.xbgr.xr78_u9.nr1[nsmm_w]
print @n.xbgr.xr78_u9.nr1[nsmm_l]
print @n.xbgr.xr78_u10.nr1[nsmm_rsh]
print @n.xbgr.xr78_u10.nr1[nsmm_w]
print @n.xbgr.xr78_u10.nr1[nsmm_l]
print @n.xbgr.xr78_u11.nr1[nsmm_rsh]
print @n.xbgr.xr78_u11.nr1[nsmm_w]
print @n.xbgr.xr78_u11.nr1[nsmm_l]
print @n.xbgr.xr78_u12.nr1[nsmm_rsh]
print @n.xbgr.xr78_u12.nr1[nsmm_w]
print @n.xbgr.xr78_u12.nr1[nsmm_l]
print @n.xbgr.xr78_u13.nr1[nsmm_rsh]
print @n.xbgr.xr78_u13.nr1[nsmm_w]
print @n.xbgr.xr78_u13.nr1[nsmm_l]
print @n.xbgr.xr78_u14.nr1[nsmm_rsh]
print @n.xbgr.xr78_u14.nr1[nsmm_w]
print @n.xbgr.xr78_u14.nr1[nsmm_l]
print @n.xbgr.xr78_u15.nr1[nsmm_rsh]
print @n.xbgr.xr78_u15.nr1[nsmm_w]
print @n.xbgr.xr78_u15.nr1[nsmm_l]
print @n.xbgr.xr78_u16.nr1[nsmm_rsh]
print @n.xbgr.xr78_u16.nr1[nsmm_w]
print @n.xbgr.xr78_u16.nr1[nsmm_l]
print @n.xbgr.xr78_u17.nr1[nsmm_rsh]
print @n.xbgr.xr78_u17.nr1[nsmm_w]
print @n.xbgr.xr78_u17.nr1[nsmm_l]
print @n.xbgr.xr78_u18.nr1[nsmm_rsh]
print @n.xbgr.xr78_u18.nr1[nsmm_w]
print @n.xbgr.xr78_u18.nr1[nsmm_l]
print @n.xbgr.xr78_u19.nr1[nsmm_rsh]
print @n.xbgr.xr78_u19.nr1[nsmm_w]
print @n.xbgr.xr78_u19.nr1[nsmm_l]
print @n.xbgr.xr78_u20.nr1[nsmm_rsh]
print @n.xbgr.xr78_u20.nr1[nsmm_w]
print @n.xbgr.xr78_u20.nr1[nsmm_l]
print @n.xbgr.xr78_u21.nr1[nsmm_rsh]
print @n.xbgr.xr78_u21.nr1[nsmm_w]
print @n.xbgr.xr78_u21.nr1[nsmm_l]
print @n.xbgr.xr78_u22.nr1[nsmm_rsh]
print @n.xbgr.xr78_u22.nr1[nsmm_w]
print @n.xbgr.xr78_u22.nr1[nsmm_l]
print @n.xbgr.xr78_u23.nr1[nsmm_rsh]
print @n.xbgr.xr78_u23.nr1[nsmm_w]
print @n.xbgr.xr78_u23.nr1[nsmm_l]
print @n.xbgr.xr78_u24.nr1[nsmm_rsh]
print @n.xbgr.xr78_u24.nr1[nsmm_w]
print @n.xbgr.xr78_u24.nr1[nsmm_l]
print @n.xbgr.xr79_u2.nr1[nsmm_rsh]
print @n.xbgr.xr79_u2.nr1[nsmm_w]
print @n.xbgr.xr79_u2.nr1[nsmm_l]
print @n.xbgr.xr79_u3.nr1[nsmm_rsh]
print @n.xbgr.xr79_u3.nr1[nsmm_w]
print @n.xbgr.xr79_u3.nr1[nsmm_l]
print @n.xbgr.xr79_u4.nr1[nsmm_rsh]
print @n.xbgr.xr79_u4.nr1[nsmm_w]
print @n.xbgr.xr79_u4.nr1[nsmm_l]
print @n.xbgr.xr79_u5.nr1[nsmm_rsh]
print @n.xbgr.xr79_u5.nr1[nsmm_w]
print @n.xbgr.xr79_u5.nr1[nsmm_l]
print @n.xbgr.xr79_u6.nr1[nsmm_rsh]
print @n.xbgr.xr79_u6.nr1[nsmm_w]
print @n.xbgr.xr79_u6.nr1[nsmm_l]
print @n.xbgr.xr79_u7.nr1[nsmm_rsh]
print @n.xbgr.xr79_u7.nr1[nsmm_w]
print @n.xbgr.xr79_u7.nr1[nsmm_l]
print @n.xbgr.xr79_u8.nr1[nsmm_rsh]
print @n.xbgr.xr79_u8.nr1[nsmm_w]
print @n.xbgr.xr79_u8.nr1[nsmm_l]
print @n.xbgr.xr79_u9.nr1[nsmm_rsh]
print @n.xbgr.xr79_u9.nr1[nsmm_w]
print @n.xbgr.xr79_u9.nr1[nsmm_l]
print @n.xbgr.xr79_u10.nr1[nsmm_rsh]
print @n.xbgr.xr79_u10.nr1[nsmm_w]
print @n.xbgr.xr79_u10.nr1[nsmm_l]
print @n.xbgr.xr79_u11.nr1[nsmm_rsh]
print @n.xbgr.xr79_u11.nr1[nsmm_w]
print @n.xbgr.xr79_u11.nr1[nsmm_l]
print @n.xbgr.xr79_u12.nr1[nsmm_rsh]
print @n.xbgr.xr79_u12.nr1[nsmm_w]
print @n.xbgr.xr79_u12.nr1[nsmm_l]
print @n.xbgr.xr79_u13.nr1[nsmm_rsh]
print @n.xbgr.xr79_u13.nr1[nsmm_w]
print @n.xbgr.xr79_u13.nr1[nsmm_l]
print @n.xbgr.xr79_u14.nr1[nsmm_rsh]
print @n.xbgr.xr79_u14.nr1[nsmm_w]
print @n.xbgr.xr79_u14.nr1[nsmm_l]
print @n.xbgr.xr79_u15.nr1[nsmm_rsh]
print @n.xbgr.xr79_u15.nr1[nsmm_w]
print @n.xbgr.xr79_u15.nr1[nsmm_l]
print @n.xbgr.xr79_u16.nr1[nsmm_rsh]
print @n.xbgr.xr79_u16.nr1[nsmm_w]
print @n.xbgr.xr79_u16.nr1[nsmm_l]
print @n.xbgr.xr79_u17.nr1[nsmm_rsh]
print @n.xbgr.xr79_u17.nr1[nsmm_w]
print @n.xbgr.xr79_u17.nr1[nsmm_l]
print @n.xbgr.xr79_u18.nr1[nsmm_rsh]
print @n.xbgr.xr79_u18.nr1[nsmm_w]
print @n.xbgr.xr79_u18.nr1[nsmm_l]
print @n.xbgr.xr79_u19.nr1[nsmm_rsh]
print @n.xbgr.xr79_u19.nr1[nsmm_w]
print @n.xbgr.xr79_u19.nr1[nsmm_l]
print @n.xbgr.xr79_u20.nr1[nsmm_rsh]
print @n.xbgr.xr79_u20.nr1[nsmm_w]
print @n.xbgr.xr79_u20.nr1[nsmm_l]
print @n.xbgr.xr79_u21.nr1[nsmm_rsh]
print @n.xbgr.xr79_u21.nr1[nsmm_w]
print @n.xbgr.xr79_u21.nr1[nsmm_l]
print @n.xbgr.xr79_u22.nr1[nsmm_rsh]
print @n.xbgr.xr79_u22.nr1[nsmm_w]
print @n.xbgr.xr79_u22.nr1[nsmm_l]
print @n.xbgr.xr79_u23.nr1[nsmm_rsh]
print @n.xbgr.xr79_u23.nr1[nsmm_w]
print @n.xbgr.xr79_u23.nr1[nsmm_l]
print @n.xbgr.xr79_u24.nr1[nsmm_rsh]
print @n.xbgr.xr79_u24.nr1[nsmm_w]
print @n.xbgr.xr79_u24.nr1[nsmm_l]
print @n.xbgr.xr80_u2.nr1[nsmm_rsh]
print @n.xbgr.xr80_u2.nr1[nsmm_w]
print @n.xbgr.xr80_u2.nr1[nsmm_l]
print @n.xbgr.xr80_u3.nr1[nsmm_rsh]
print @n.xbgr.xr80_u3.nr1[nsmm_w]
print @n.xbgr.xr80_u3.nr1[nsmm_l]
print @n.xbgr.xr80_u4.nr1[nsmm_rsh]
print @n.xbgr.xr80_u4.nr1[nsmm_w]
print @n.xbgr.xr80_u4.nr1[nsmm_l]
print @n.xbgr.xr80_u5.nr1[nsmm_rsh]
print @n.xbgr.xr80_u5.nr1[nsmm_w]
print @n.xbgr.xr80_u5.nr1[nsmm_l]
print @n.xbgr.xr80_u6.nr1[nsmm_rsh]
print @n.xbgr.xr80_u6.nr1[nsmm_w]
print @n.xbgr.xr80_u6.nr1[nsmm_l]
print @n.xbgr.xr80_u7.nr1[nsmm_rsh]
print @n.xbgr.xr80_u7.nr1[nsmm_w]
print @n.xbgr.xr80_u7.nr1[nsmm_l]
print @n.xbgr.xr80_u8.nr1[nsmm_rsh]
print @n.xbgr.xr80_u8.nr1[nsmm_w]
print @n.xbgr.xr80_u8.nr1[nsmm_l]
print @n.xbgr.xr80_u9.nr1[nsmm_rsh]
print @n.xbgr.xr80_u9.nr1[nsmm_w]
print @n.xbgr.xr80_u9.nr1[nsmm_l]
print @n.xbgr.xr80_u10.nr1[nsmm_rsh]
print @n.xbgr.xr80_u10.nr1[nsmm_w]
print @n.xbgr.xr80_u10.nr1[nsmm_l]
print @n.xbgr.xr80_u11.nr1[nsmm_rsh]
print @n.xbgr.xr80_u11.nr1[nsmm_w]
print @n.xbgr.xr80_u11.nr1[nsmm_l]
print @n.xbgr.xr80_u12.nr1[nsmm_rsh]
print @n.xbgr.xr80_u12.nr1[nsmm_w]
print @n.xbgr.xr80_u12.nr1[nsmm_l]
print @n.xbgr.xr80_u13.nr1[nsmm_rsh]
print @n.xbgr.xr80_u13.nr1[nsmm_w]
print @n.xbgr.xr80_u13.nr1[nsmm_l]
print @n.xbgr.xr80_u14.nr1[nsmm_rsh]
print @n.xbgr.xr80_u14.nr1[nsmm_w]
print @n.xbgr.xr80_u14.nr1[nsmm_l]
print @n.xbgr.xr80_u15.nr1[nsmm_rsh]
print @n.xbgr.xr80_u15.nr1[nsmm_w]
print @n.xbgr.xr80_u15.nr1[nsmm_l]
print @n.xbgr.xr80_u16.nr1[nsmm_rsh]
print @n.xbgr.xr80_u16.nr1[nsmm_w]
print @n.xbgr.xr80_u16.nr1[nsmm_l]
print @n.xbgr.xr80_u17.nr1[nsmm_rsh]
print @n.xbgr.xr80_u17.nr1[nsmm_w]
print @n.xbgr.xr80_u17.nr1[nsmm_l]
print @n.xbgr.xr80_u18.nr1[nsmm_rsh]
print @n.xbgr.xr80_u18.nr1[nsmm_w]
print @n.xbgr.xr80_u18.nr1[nsmm_l]
print @n.xbgr.xr80_u19.nr1[nsmm_rsh]
print @n.xbgr.xr80_u19.nr1[nsmm_w]
print @n.xbgr.xr80_u19.nr1[nsmm_l]
print @n.xbgr.xr80_u20.nr1[nsmm_rsh]
print @n.xbgr.xr80_u20.nr1[nsmm_w]
print @n.xbgr.xr80_u20.nr1[nsmm_l]
print @n.xbgr.xr80_u21.nr1[nsmm_rsh]
print @n.xbgr.xr80_u21.nr1[nsmm_w]
print @n.xbgr.xr80_u21.nr1[nsmm_l]
print @n.xbgr.xr80_u22.nr1[nsmm_rsh]
print @n.xbgr.xr80_u22.nr1[nsmm_w]
print @n.xbgr.xr80_u22.nr1[nsmm_l]
print @n.xbgr.xr80_u23.nr1[nsmm_rsh]
print @n.xbgr.xr80_u23.nr1[nsmm_w]
print @n.xbgr.xr80_u23.nr1[nsmm_l]
print @n.xbgr.xr80_u24.nr1[nsmm_rsh]
print @n.xbgr.xr80_u24.nr1[nsmm_w]
print @n.xbgr.xr80_u24.nr1[nsmm_l]
print @n.xbgr.xr81_u2.nr1[nsmm_rsh]
print @n.xbgr.xr81_u2.nr1[nsmm_w]
print @n.xbgr.xr81_u2.nr1[nsmm_l]
print @n.xbgr.xr81_u3.nr1[nsmm_rsh]
print @n.xbgr.xr81_u3.nr1[nsmm_w]
print @n.xbgr.xr81_u3.nr1[nsmm_l]
print @n.xbgr.xr81_u4.nr1[nsmm_rsh]
print @n.xbgr.xr81_u4.nr1[nsmm_w]
print @n.xbgr.xr81_u4.nr1[nsmm_l]
print @n.xbgr.xr81_u5.nr1[nsmm_rsh]
print @n.xbgr.xr81_u5.nr1[nsmm_w]
print @n.xbgr.xr81_u5.nr1[nsmm_l]
print @n.xbgr.xr81_u6.nr1[nsmm_rsh]
print @n.xbgr.xr81_u6.nr1[nsmm_w]
print @n.xbgr.xr81_u6.nr1[nsmm_l]
print @n.xbgr.xr81_u7.nr1[nsmm_rsh]
print @n.xbgr.xr81_u7.nr1[nsmm_w]
print @n.xbgr.xr81_u7.nr1[nsmm_l]
print @n.xbgr.xr81_u8.nr1[nsmm_rsh]
print @n.xbgr.xr81_u8.nr1[nsmm_w]
print @n.xbgr.xr81_u8.nr1[nsmm_l]
print @n.xbgr.xr81_u9.nr1[nsmm_rsh]
print @n.xbgr.xr81_u9.nr1[nsmm_w]
print @n.xbgr.xr81_u9.nr1[nsmm_l]
print @n.xbgr.xr81_u10.nr1[nsmm_rsh]
print @n.xbgr.xr81_u10.nr1[nsmm_w]
print @n.xbgr.xr81_u10.nr1[nsmm_l]
print @n.xbgr.xr81_u11.nr1[nsmm_rsh]
print @n.xbgr.xr81_u11.nr1[nsmm_w]
print @n.xbgr.xr81_u11.nr1[nsmm_l]
print @n.xbgr.xr81_u12.nr1[nsmm_rsh]
print @n.xbgr.xr81_u12.nr1[nsmm_w]
print @n.xbgr.xr81_u12.nr1[nsmm_l]
print @n.xbgr.xr81_u13.nr1[nsmm_rsh]
print @n.xbgr.xr81_u13.nr1[nsmm_w]
print @n.xbgr.xr81_u13.nr1[nsmm_l]
print @n.xbgr.xr81_u14.nr1[nsmm_rsh]
print @n.xbgr.xr81_u14.nr1[nsmm_w]
print @n.xbgr.xr81_u14.nr1[nsmm_l]
print @n.xbgr.xr81_u15.nr1[nsmm_rsh]
print @n.xbgr.xr81_u15.nr1[nsmm_w]
print @n.xbgr.xr81_u15.nr1[nsmm_l]
print @n.xbgr.xr81_u16.nr1[nsmm_rsh]
print @n.xbgr.xr81_u16.nr1[nsmm_w]
print @n.xbgr.xr81_u16.nr1[nsmm_l]
print @n.xbgr.xr81_u17.nr1[nsmm_rsh]
print @n.xbgr.xr81_u17.nr1[nsmm_w]
print @n.xbgr.xr81_u17.nr1[nsmm_l]
print @n.xbgr.xr81_u18.nr1[nsmm_rsh]
print @n.xbgr.xr81_u18.nr1[nsmm_w]
print @n.xbgr.xr81_u18.nr1[nsmm_l]
print @n.xbgr.xr81_u19.nr1[nsmm_rsh]
print @n.xbgr.xr81_u19.nr1[nsmm_w]
print @n.xbgr.xr81_u19.nr1[nsmm_l]
print @n.xbgr.xr81_u20.nr1[nsmm_rsh]
print @n.xbgr.xr81_u20.nr1[nsmm_w]
print @n.xbgr.xr81_u20.nr1[nsmm_l]
print @n.xbgr.xr81_u21.nr1[nsmm_rsh]
print @n.xbgr.xr81_u21.nr1[nsmm_w]
print @n.xbgr.xr81_u21.nr1[nsmm_l]
print @n.xbgr.xr81_u22.nr1[nsmm_rsh]
print @n.xbgr.xr81_u22.nr1[nsmm_w]
print @n.xbgr.xr81_u22.nr1[nsmm_l]
print @n.xbgr.xr81_u23.nr1[nsmm_rsh]
print @n.xbgr.xr81_u23.nr1[nsmm_w]
print @n.xbgr.xr81_u23.nr1[nsmm_l]
print @n.xbgr.xr81_u24.nr1[nsmm_rsh]
print @n.xbgr.xr81_u24.nr1[nsmm_w]
print @n.xbgr.xr81_u24.nr1[nsmm_l]
print @n.xbgr.xr82_u2.nr1[nsmm_rsh]
print @n.xbgr.xr82_u2.nr1[nsmm_w]
print @n.xbgr.xr82_u2.nr1[nsmm_l]
print @n.xbgr.xr82_u3.nr1[nsmm_rsh]
print @n.xbgr.xr82_u3.nr1[nsmm_w]
print @n.xbgr.xr82_u3.nr1[nsmm_l]
print @n.xbgr.xr82_u4.nr1[nsmm_rsh]
print @n.xbgr.xr82_u4.nr1[nsmm_w]
print @n.xbgr.xr82_u4.nr1[nsmm_l]
print @n.xbgr.xr82_u5.nr1[nsmm_rsh]
print @n.xbgr.xr82_u5.nr1[nsmm_w]
print @n.xbgr.xr82_u5.nr1[nsmm_l]
print @n.xbgr.xr82_u6.nr1[nsmm_rsh]
print @n.xbgr.xr82_u6.nr1[nsmm_w]
print @n.xbgr.xr82_u6.nr1[nsmm_l]
print @n.xbgr.xr82_u7.nr1[nsmm_rsh]
print @n.xbgr.xr82_u7.nr1[nsmm_w]
print @n.xbgr.xr82_u7.nr1[nsmm_l]
print @n.xbgr.xr82_u8.nr1[nsmm_rsh]
print @n.xbgr.xr82_u8.nr1[nsmm_w]
print @n.xbgr.xr82_u8.nr1[nsmm_l]
print @n.xbgr.xr82_u9.nr1[nsmm_rsh]
print @n.xbgr.xr82_u9.nr1[nsmm_w]
print @n.xbgr.xr82_u9.nr1[nsmm_l]
print @n.xbgr.xr82_u10.nr1[nsmm_rsh]
print @n.xbgr.xr82_u10.nr1[nsmm_w]
print @n.xbgr.xr82_u10.nr1[nsmm_l]
print @n.xbgr.xr82_u11.nr1[nsmm_rsh]
print @n.xbgr.xr82_u11.nr1[nsmm_w]
print @n.xbgr.xr82_u11.nr1[nsmm_l]
print @n.xbgr.xr82_u12.nr1[nsmm_rsh]
print @n.xbgr.xr82_u12.nr1[nsmm_w]
print @n.xbgr.xr82_u12.nr1[nsmm_l]
print @n.xbgr.xr82_u13.nr1[nsmm_rsh]
print @n.xbgr.xr82_u13.nr1[nsmm_w]
print @n.xbgr.xr82_u13.nr1[nsmm_l]
print @n.xbgr.xr82_u14.nr1[nsmm_rsh]
print @n.xbgr.xr82_u14.nr1[nsmm_w]
print @n.xbgr.xr82_u14.nr1[nsmm_l]
print @n.xbgr.xr82_u15.nr1[nsmm_rsh]
print @n.xbgr.xr82_u15.nr1[nsmm_w]
print @n.xbgr.xr82_u15.nr1[nsmm_l]
print @n.xbgr.xr82_u16.nr1[nsmm_rsh]
print @n.xbgr.xr82_u16.nr1[nsmm_w]
print @n.xbgr.xr82_u16.nr1[nsmm_l]
print @n.xbgr.xr82_u17.nr1[nsmm_rsh]
print @n.xbgr.xr82_u17.nr1[nsmm_w]
print @n.xbgr.xr82_u17.nr1[nsmm_l]
print @n.xbgr.xr82_u18.nr1[nsmm_rsh]
print @n.xbgr.xr82_u18.nr1[nsmm_w]
print @n.xbgr.xr82_u18.nr1[nsmm_l]
print @n.xbgr.xr82_u19.nr1[nsmm_rsh]
print @n.xbgr.xr82_u19.nr1[nsmm_w]
print @n.xbgr.xr82_u19.nr1[nsmm_l]
print @n.xbgr.xr82_u20.nr1[nsmm_rsh]
print @n.xbgr.xr82_u20.nr1[nsmm_w]
print @n.xbgr.xr82_u20.nr1[nsmm_l]
print @n.xbgr.xr82_u21.nr1[nsmm_rsh]
print @n.xbgr.xr82_u21.nr1[nsmm_w]
print @n.xbgr.xr82_u21.nr1[nsmm_l]
print @n.xbgr.xr82_u22.nr1[nsmm_rsh]
print @n.xbgr.xr82_u22.nr1[nsmm_w]
print @n.xbgr.xr82_u22.nr1[nsmm_l]
print @n.xbgr.xr82_u23.nr1[nsmm_rsh]
print @n.xbgr.xr82_u23.nr1[nsmm_w]
print @n.xbgr.xr82_u23.nr1[nsmm_l]
print @n.xbgr.xr82_u24.nr1[nsmm_rsh]
print @n.xbgr.xr82_u24.nr1[nsmm_w]
print @n.xbgr.xr82_u24.nr1[nsmm_l]
print @n.xbgr.xr83_u2.nr1[nsmm_rsh]
print @n.xbgr.xr83_u2.nr1[nsmm_w]
print @n.xbgr.xr83_u2.nr1[nsmm_l]
print @n.xbgr.xr83_u3.nr1[nsmm_rsh]
print @n.xbgr.xr83_u3.nr1[nsmm_w]
print @n.xbgr.xr83_u3.nr1[nsmm_l]
print @n.xbgr.xr83_u4.nr1[nsmm_rsh]
print @n.xbgr.xr83_u4.nr1[nsmm_w]
print @n.xbgr.xr83_u4.nr1[nsmm_l]
print @n.xbgr.xr83_u5.nr1[nsmm_rsh]
print @n.xbgr.xr83_u5.nr1[nsmm_w]
print @n.xbgr.xr83_u5.nr1[nsmm_l]
print @n.xbgr.xr83_u6.nr1[nsmm_rsh]
print @n.xbgr.xr83_u6.nr1[nsmm_w]
print @n.xbgr.xr83_u6.nr1[nsmm_l]
print @n.xbgr.xr83_u7.nr1[nsmm_rsh]
print @n.xbgr.xr83_u7.nr1[nsmm_w]
print @n.xbgr.xr83_u7.nr1[nsmm_l]
print @n.xbgr.xr83_u8.nr1[nsmm_rsh]
print @n.xbgr.xr83_u8.nr1[nsmm_w]
print @n.xbgr.xr83_u8.nr1[nsmm_l]
print @n.xbgr.xr83_u9.nr1[nsmm_rsh]
print @n.xbgr.xr83_u9.nr1[nsmm_w]
print @n.xbgr.xr83_u9.nr1[nsmm_l]
print @n.xbgr.xr83_u10.nr1[nsmm_rsh]
print @n.xbgr.xr83_u10.nr1[nsmm_w]
print @n.xbgr.xr83_u10.nr1[nsmm_l]
print @n.xbgr.xr83_u11.nr1[nsmm_rsh]
print @n.xbgr.xr83_u11.nr1[nsmm_w]
print @n.xbgr.xr83_u11.nr1[nsmm_l]
print @n.xbgr.xr83_u12.nr1[nsmm_rsh]
print @n.xbgr.xr83_u12.nr1[nsmm_w]
print @n.xbgr.xr83_u12.nr1[nsmm_l]
print @n.xbgr.xr83_u13.nr1[nsmm_rsh]
print @n.xbgr.xr83_u13.nr1[nsmm_w]
print @n.xbgr.xr83_u13.nr1[nsmm_l]
print @n.xbgr.xr83_u14.nr1[nsmm_rsh]
print @n.xbgr.xr83_u14.nr1[nsmm_w]
print @n.xbgr.xr83_u14.nr1[nsmm_l]
print @n.xbgr.xr83_u15.nr1[nsmm_rsh]
print @n.xbgr.xr83_u15.nr1[nsmm_w]
print @n.xbgr.xr83_u15.nr1[nsmm_l]
print @n.xbgr.xr83_u16.nr1[nsmm_rsh]
print @n.xbgr.xr83_u16.nr1[nsmm_w]
print @n.xbgr.xr83_u16.nr1[nsmm_l]
print @n.xbgr.xr83_u17.nr1[nsmm_rsh]
print @n.xbgr.xr83_u17.nr1[nsmm_w]
print @n.xbgr.xr83_u17.nr1[nsmm_l]
print @n.xbgr.xr83_u18.nr1[nsmm_rsh]
print @n.xbgr.xr83_u18.nr1[nsmm_w]
print @n.xbgr.xr83_u18.nr1[nsmm_l]
print @n.xbgr.xr83_u19.nr1[nsmm_rsh]
print @n.xbgr.xr83_u19.nr1[nsmm_w]
print @n.xbgr.xr83_u19.nr1[nsmm_l]
print @n.xbgr.xr83_u20.nr1[nsmm_rsh]
print @n.xbgr.xr83_u20.nr1[nsmm_w]
print @n.xbgr.xr83_u20.nr1[nsmm_l]
print @n.xbgr.xr83_u21.nr1[nsmm_rsh]
print @n.xbgr.xr83_u21.nr1[nsmm_w]
print @n.xbgr.xr83_u21.nr1[nsmm_l]
print @n.xbgr.xr83_u22.nr1[nsmm_rsh]
print @n.xbgr.xr83_u22.nr1[nsmm_w]
print @n.xbgr.xr83_u22.nr1[nsmm_l]
print @n.xbgr.xr83_u23.nr1[nsmm_rsh]
print @n.xbgr.xr83_u23.nr1[nsmm_w]
print @n.xbgr.xr83_u23.nr1[nsmm_l]
print @n.xbgr.xr83_u24.nr1[nsmm_rsh]
print @n.xbgr.xr83_u24.nr1[nsmm_w]
print @n.xbgr.xr83_u24.nr1[nsmm_l]
print @n.xbgr.xr84_u2.nr1[nsmm_rsh]
print @n.xbgr.xr84_u2.nr1[nsmm_w]
print @n.xbgr.xr84_u2.nr1[nsmm_l]
print @n.xbgr.xr84_u3.nr1[nsmm_rsh]
print @n.xbgr.xr84_u3.nr1[nsmm_w]
print @n.xbgr.xr84_u3.nr1[nsmm_l]
print @n.xbgr.xr84_u4.nr1[nsmm_rsh]
print @n.xbgr.xr84_u4.nr1[nsmm_w]
print @n.xbgr.xr84_u4.nr1[nsmm_l]
print @n.xbgr.xr84_u5.nr1[nsmm_rsh]
print @n.xbgr.xr84_u5.nr1[nsmm_w]
print @n.xbgr.xr84_u5.nr1[nsmm_l]
print @n.xbgr.xr84_u6.nr1[nsmm_rsh]
print @n.xbgr.xr84_u6.nr1[nsmm_w]
print @n.xbgr.xr84_u6.nr1[nsmm_l]
print @n.xbgr.xr84_u7.nr1[nsmm_rsh]
print @n.xbgr.xr84_u7.nr1[nsmm_w]
print @n.xbgr.xr84_u7.nr1[nsmm_l]
print @n.xbgr.xr84_u8.nr1[nsmm_rsh]
print @n.xbgr.xr84_u8.nr1[nsmm_w]
print @n.xbgr.xr84_u8.nr1[nsmm_l]
print @n.xbgr.xr84_u9.nr1[nsmm_rsh]
print @n.xbgr.xr84_u9.nr1[nsmm_w]
print @n.xbgr.xr84_u9.nr1[nsmm_l]
print @n.xbgr.xr84_u10.nr1[nsmm_rsh]
print @n.xbgr.xr84_u10.nr1[nsmm_w]
print @n.xbgr.xr84_u10.nr1[nsmm_l]
print @n.xbgr.xr84_u11.nr1[nsmm_rsh]
print @n.xbgr.xr84_u11.nr1[nsmm_w]
print @n.xbgr.xr84_u11.nr1[nsmm_l]
print @n.xbgr.xr84_u12.nr1[nsmm_rsh]
print @n.xbgr.xr84_u12.nr1[nsmm_w]
print @n.xbgr.xr84_u12.nr1[nsmm_l]
print @n.xbgr.xr84_u13.nr1[nsmm_rsh]
print @n.xbgr.xr84_u13.nr1[nsmm_w]
print @n.xbgr.xr84_u13.nr1[nsmm_l]
print @n.xbgr.xr84_u14.nr1[nsmm_rsh]
print @n.xbgr.xr84_u14.nr1[nsmm_w]
print @n.xbgr.xr84_u14.nr1[nsmm_l]
print @n.xbgr.xr84_u15.nr1[nsmm_rsh]
print @n.xbgr.xr84_u15.nr1[nsmm_w]
print @n.xbgr.xr84_u15.nr1[nsmm_l]
print @n.xbgr.xr84_u16.nr1[nsmm_rsh]
print @n.xbgr.xr84_u16.nr1[nsmm_w]
print @n.xbgr.xr84_u16.nr1[nsmm_l]
print @n.xbgr.xr84_u17.nr1[nsmm_rsh]
print @n.xbgr.xr84_u17.nr1[nsmm_w]
print @n.xbgr.xr84_u17.nr1[nsmm_l]
print @n.xbgr.xr84_u18.nr1[nsmm_rsh]
print @n.xbgr.xr84_u18.nr1[nsmm_w]
print @n.xbgr.xr84_u18.nr1[nsmm_l]
print @n.xbgr.xr84_u19.nr1[nsmm_rsh]
print @n.xbgr.xr84_u19.nr1[nsmm_w]
print @n.xbgr.xr84_u19.nr1[nsmm_l]
print @n.xbgr.xr84_u20.nr1[nsmm_rsh]
print @n.xbgr.xr84_u20.nr1[nsmm_w]
print @n.xbgr.xr84_u20.nr1[nsmm_l]
print @n.xbgr.xr84_u21.nr1[nsmm_rsh]
print @n.xbgr.xr84_u21.nr1[nsmm_w]
print @n.xbgr.xr84_u21.nr1[nsmm_l]
print @n.xbgr.xr84_u22.nr1[nsmm_rsh]
print @n.xbgr.xr84_u22.nr1[nsmm_w]
print @n.xbgr.xr84_u22.nr1[nsmm_l]
print @n.xbgr.xr84_u23.nr1[nsmm_rsh]
print @n.xbgr.xr84_u23.nr1[nsmm_w]
print @n.xbgr.xr84_u23.nr1[nsmm_l]
print @n.xbgr.xr84_u24.nr1[nsmm_rsh]
print @n.xbgr.xr84_u24.nr1[nsmm_w]
print @n.xbgr.xr84_u24.nr1[nsmm_l]
print @n.xbgr.xr85_u2.nr1[nsmm_rsh]
print @n.xbgr.xr85_u2.nr1[nsmm_w]
print @n.xbgr.xr85_u2.nr1[nsmm_l]
print @n.xbgr.xr85_u3.nr1[nsmm_rsh]
print @n.xbgr.xr85_u3.nr1[nsmm_w]
print @n.xbgr.xr85_u3.nr1[nsmm_l]
print @n.xbgr.xr85_u4.nr1[nsmm_rsh]
print @n.xbgr.xr85_u4.nr1[nsmm_w]
print @n.xbgr.xr85_u4.nr1[nsmm_l]
print @n.xbgr.xr85_u5.nr1[nsmm_rsh]
print @n.xbgr.xr85_u5.nr1[nsmm_w]
print @n.xbgr.xr85_u5.nr1[nsmm_l]
print @n.xbgr.xr85_u6.nr1[nsmm_rsh]
print @n.xbgr.xr85_u6.nr1[nsmm_w]
print @n.xbgr.xr85_u6.nr1[nsmm_l]
print @n.xbgr.xr85_u7.nr1[nsmm_rsh]
print @n.xbgr.xr85_u7.nr1[nsmm_w]
print @n.xbgr.xr85_u7.nr1[nsmm_l]
print @n.xbgr.xr85_u8.nr1[nsmm_rsh]
print @n.xbgr.xr85_u8.nr1[nsmm_w]
print @n.xbgr.xr85_u8.nr1[nsmm_l]
print @n.xbgr.xr85_u9.nr1[nsmm_rsh]
print @n.xbgr.xr85_u9.nr1[nsmm_w]
print @n.xbgr.xr85_u9.nr1[nsmm_l]
print @n.xbgr.xr85_u10.nr1[nsmm_rsh]
print @n.xbgr.xr85_u10.nr1[nsmm_w]
print @n.xbgr.xr85_u10.nr1[nsmm_l]
print @n.xbgr.xr85_u11.nr1[nsmm_rsh]
print @n.xbgr.xr85_u11.nr1[nsmm_w]
print @n.xbgr.xr85_u11.nr1[nsmm_l]
print @n.xbgr.xr85_u12.nr1[nsmm_rsh]
print @n.xbgr.xr85_u12.nr1[nsmm_w]
print @n.xbgr.xr85_u12.nr1[nsmm_l]
print @n.xbgr.xr85_u13.nr1[nsmm_rsh]
print @n.xbgr.xr85_u13.nr1[nsmm_w]
print @n.xbgr.xr85_u13.nr1[nsmm_l]
print @n.xbgr.xr85_u14.nr1[nsmm_rsh]
print @n.xbgr.xr85_u14.nr1[nsmm_w]
print @n.xbgr.xr85_u14.nr1[nsmm_l]
print @n.xbgr.xr85_u15.nr1[nsmm_rsh]
print @n.xbgr.xr85_u15.nr1[nsmm_w]
print @n.xbgr.xr85_u15.nr1[nsmm_l]
print @n.xbgr.xr85_u16.nr1[nsmm_rsh]
print @n.xbgr.xr85_u16.nr1[nsmm_w]
print @n.xbgr.xr85_u16.nr1[nsmm_l]
print @n.xbgr.xr85_u17.nr1[nsmm_rsh]
print @n.xbgr.xr85_u17.nr1[nsmm_w]
print @n.xbgr.xr85_u17.nr1[nsmm_l]
print @n.xbgr.xr85_u18.nr1[nsmm_rsh]
print @n.xbgr.xr85_u18.nr1[nsmm_w]
print @n.xbgr.xr85_u18.nr1[nsmm_l]
print @n.xbgr.xr85_u19.nr1[nsmm_rsh]
print @n.xbgr.xr85_u19.nr1[nsmm_w]
print @n.xbgr.xr85_u19.nr1[nsmm_l]
print @n.xbgr.xr85_u20.nr1[nsmm_rsh]
print @n.xbgr.xr85_u20.nr1[nsmm_w]
print @n.xbgr.xr85_u20.nr1[nsmm_l]
print @n.xbgr.xr85_u21.nr1[nsmm_rsh]
print @n.xbgr.xr85_u21.nr1[nsmm_w]
print @n.xbgr.xr85_u21.nr1[nsmm_l]
print @n.xbgr.xr85_u22.nr1[nsmm_rsh]
print @n.xbgr.xr85_u22.nr1[nsmm_w]
print @n.xbgr.xr85_u22.nr1[nsmm_l]
print @n.xbgr.xr85_u23.nr1[nsmm_rsh]
print @n.xbgr.xr85_u23.nr1[nsmm_w]
print @n.xbgr.xr85_u23.nr1[nsmm_l]
print @n.xbgr.xr85_u24.nr1[nsmm_rsh]
print @n.xbgr.xr85_u24.nr1[nsmm_w]
print @n.xbgr.xr85_u24.nr1[nsmm_l]
print @n.xbgr.xr86_u2.nr1[nsmm_rsh]
print @n.xbgr.xr86_u2.nr1[nsmm_w]
print @n.xbgr.xr86_u2.nr1[nsmm_l]
print @n.xbgr.xr86_u3.nr1[nsmm_rsh]
print @n.xbgr.xr86_u3.nr1[nsmm_w]
print @n.xbgr.xr86_u3.nr1[nsmm_l]
print @n.xbgr.xr86_u4.nr1[nsmm_rsh]
print @n.xbgr.xr86_u4.nr1[nsmm_w]
print @n.xbgr.xr86_u4.nr1[nsmm_l]
print @n.xbgr.xr86_u5.nr1[nsmm_rsh]
print @n.xbgr.xr86_u5.nr1[nsmm_w]
print @n.xbgr.xr86_u5.nr1[nsmm_l]
print @n.xbgr.xr86_u6.nr1[nsmm_rsh]
print @n.xbgr.xr86_u6.nr1[nsmm_w]
print @n.xbgr.xr86_u6.nr1[nsmm_l]
print @n.xbgr.xr86_u7.nr1[nsmm_rsh]
print @n.xbgr.xr86_u7.nr1[nsmm_w]
print @n.xbgr.xr86_u7.nr1[nsmm_l]
print @n.xbgr.xr86_u8.nr1[nsmm_rsh]
print @n.xbgr.xr86_u8.nr1[nsmm_w]
print @n.xbgr.xr86_u8.nr1[nsmm_l]
print @n.xbgr.xr86_u9.nr1[nsmm_rsh]
print @n.xbgr.xr86_u9.nr1[nsmm_w]
print @n.xbgr.xr86_u9.nr1[nsmm_l]
print @n.xbgr.xr86_u10.nr1[nsmm_rsh]
print @n.xbgr.xr86_u10.nr1[nsmm_w]
print @n.xbgr.xr86_u10.nr1[nsmm_l]
print @n.xbgr.xr86_u11.nr1[nsmm_rsh]
print @n.xbgr.xr86_u11.nr1[nsmm_w]
print @n.xbgr.xr86_u11.nr1[nsmm_l]
print @n.xbgr.xr86_u12.nr1[nsmm_rsh]
print @n.xbgr.xr86_u12.nr1[nsmm_w]
print @n.xbgr.xr86_u12.nr1[nsmm_l]
print @n.xbgr.xr86_u13.nr1[nsmm_rsh]
print @n.xbgr.xr86_u13.nr1[nsmm_w]
print @n.xbgr.xr86_u13.nr1[nsmm_l]
print @n.xbgr.xr86_u14.nr1[nsmm_rsh]
print @n.xbgr.xr86_u14.nr1[nsmm_w]
print @n.xbgr.xr86_u14.nr1[nsmm_l]
print @n.xbgr.xr86_u15.nr1[nsmm_rsh]
print @n.xbgr.xr86_u15.nr1[nsmm_w]
print @n.xbgr.xr86_u15.nr1[nsmm_l]
print @n.xbgr.xr86_u16.nr1[nsmm_rsh]
print @n.xbgr.xr86_u16.nr1[nsmm_w]
print @n.xbgr.xr86_u16.nr1[nsmm_l]
print @n.xbgr.xr86_u17.nr1[nsmm_rsh]
print @n.xbgr.xr86_u17.nr1[nsmm_w]
print @n.xbgr.xr86_u17.nr1[nsmm_l]
print @n.xbgr.xr86_u18.nr1[nsmm_rsh]
print @n.xbgr.xr86_u18.nr1[nsmm_w]
print @n.xbgr.xr86_u18.nr1[nsmm_l]
print @n.xbgr.xr86_u19.nr1[nsmm_rsh]
print @n.xbgr.xr86_u19.nr1[nsmm_w]
print @n.xbgr.xr86_u19.nr1[nsmm_l]
print @n.xbgr.xr86_u20.nr1[nsmm_rsh]
print @n.xbgr.xr86_u20.nr1[nsmm_w]
print @n.xbgr.xr86_u20.nr1[nsmm_l]
print @n.xbgr.xr86_u21.nr1[nsmm_rsh]
print @n.xbgr.xr86_u21.nr1[nsmm_w]
print @n.xbgr.xr86_u21.nr1[nsmm_l]
print @n.xbgr.xr86_u22.nr1[nsmm_rsh]
print @n.xbgr.xr86_u22.nr1[nsmm_w]
print @n.xbgr.xr86_u22.nr1[nsmm_l]
print @n.xbgr.xr86_u23.nr1[nsmm_rsh]
print @n.xbgr.xr86_u23.nr1[nsmm_w]
print @n.xbgr.xr86_u23.nr1[nsmm_l]
print @n.xbgr.xr86_u24.nr1[nsmm_rsh]
print @n.xbgr.xr86_u24.nr1[nsmm_w]
print @n.xbgr.xr86_u24.nr1[nsmm_l]
set numdgt=17
echo METALLIC_POINT_VOLTAGES_BEGIN
print v(xbgr.mr_n77308448)
print v(xbgr.vd2)
print v(xbgr.mr_n76498816)
print v(xbgr.c2)
print v(xbgr.mr_n77597312)
print v(xbgr.mr_n77697872)
print v(xbgr.mr_n77812912)
print v(xbgr.mr_n77870832)
print v(xbgr.mr_n78047856)
print v(xbgr.mr_n78184128)
print v(xbgr.mr_n78356608)
print v(xbgr.mr_n78481344)
print v(xbgr.mr_n78247728)
print v(xbgr.mr_n78769216)
print v(xbgr.mr_n78801296)
print v(xbgr.mr_n79088128)
print v(xbgr.mr_n79176848)
print v(xbgr.mr_n79241952)
print v(xbgr.mr_n79475872)
print v(xbgr.mr_n79856400)
print v(xbgr.mr_n80026256)
print v(xbgr.mr_n80223552)
print v(xbgr.mr_n80394032)
print v(xbgr.mr_n80527856)
print v(xbgr.mr_n80737856)
print v(xbgr.mr_n80936784)
print v(xbgr.mr_n81146896)
print v(xbgr.mr_n78195744)
print v(xbgr.mr_n81233712)
print v(xbgr.mr_n81516400)
print v(xbgr.mr_n81709664)
print v(xbgr.mr_n81925856)
print v(xbgr.mr_n82107696)
print v(xbgr.mr_n82412944)
print v(xbgr.mr_n82617792)
print v(xbgr.mr_n82851536)
print v(xbgr.mr_n83185808)
print v(xbgr.mr_n77308896)
print v(xbgr.mr_n77372336)
print v(xbgr.b1b)
print v(xbgr.mr_n77461184)
print v(xbgr.mr_n77554400)
print v(xbgr.mr_n77665072)
print v(xbgr.mr_n77741568)
print v(xbgr.mr_n77872816)
print v(xbgr.mr_n77985888)
print v(xbgr.mr_n78326256)
print v(xbgr.mr_n78443744)
print v(xbgr.mr_n78575776)
print v(xbgr.mr_n78677888)
print v(xbgr.mr_n78850592)
print v(xbgr.mr_n78965776)
print v(xbgr.mr_n79118752)
print v(xbgr.mr_n79367952)
print v(xbgr.mr_n77343712)
print v(xbgr.mr_n77403552)
print v(xbgr.mr_n76744560)
print v(xbgr.mr_n77542528)
print v(xbgr.mr_n77643024)
print v(xbgr.mr_n77759248)
print v(xbgr.mr_n77815280)
print v(xbgr.mr_n77963648)
print v(xbgr.mr_n78068432)
print v(xbgr.mr_n78184464)
print v(xbgr.mr_n78356800)
print v(xbgr.mr_n78491376)
print v(xbgr.mr_n78652368)
print v(xbgr.mr_n78772624)
print v(xbgr.mr_n78974144)
print v(xbgr.mr_n79090752)
print v(xbgr.mr_n79197200)
print v(xbgr.mr_n79369920)
print v(xbgr.mr_n76575520)
print v(xbgr.mr_n76839584)
print v(xbgr.n_13)
print v(xbgr.n_24)
print v(xbgr.mr_n76573648)
print v(xbgr.mr_n76686656)
print v(xbgr.n_14)
print v(xbgr.mr_n77184576)
print v(xbgr.mr_n77302288)
print v(xbgr.mr_n77372528)
print v(xbgr.mr_n76584912)
print v(xbgr.mr_n77543232)
print v(xbgr.mr_n77599984)
print v(xbgr.mr_n77667344)
print v(xbgr.mr_n77683232)
print v(xbgr.vd1)
print v(xbgr.mr_n78048048)
print v(xbgr.mr_n78086112)
print v(xbgr.mr_n78294688)
print v(xbgr.mr_n78484208)
print v(xbgr.mr_n78652720)
print v(xbgr.mr_n78761584)
print v(xbgr.mr_n78885232)
print v(xbgr.mr_n79087952)
print v(xbgr.mr_n79178032)
print v(xbgr.mr_n79368624)
print v(xbgr.mr_n79713472)
print v(xbgr.mr_n79853872)
print v(xbgr.mr_n80030400)
print v(xbgr.mr_n80232464)
print v(xbgr.mr_n80335264)
print v(xbgr.mr_n80574256)
print v(xbgr.mr_n80776080)
print v(xbgr.mr_n80937952)
print v(xbgr.mr_n81152288)
print v(xbgr.mr_n78187664)
print v(xbgr.mr_n81239248)
print v(xbgr.mr_n81511968)
print v(xbgr.mr_n81709200)
print v(xbgr.mr_n81927120)
print v(xbgr.mr_n82114752)
print v(xbgr.mr_n82429568)
print v(xbgr.mr_n82603504)
print v(xbgr.mr_n82850960)
print v(xbgr.mr_n83188640)
print v(xbgr.mr_n77309472)
print v(xbgr.mr_n77373472)
print v(xbgr.mr_n76502400)
print v(xbgr.mr_n77483728)
print v(xbgr.mr_n77555792)
print v(xbgr.mr_n77650480)
print v(xbgr.mr_n77756208)
print v(xbgr.mr_n77927200)
print v(xbgr.mr_n77987888)
print v(xbgr.mr_n78327648)
print v(xbgr.mr_n78445136)
print v(xbgr.mr_n78577168)
print v(xbgr.mr_n78723904)
print v(xbgr.mr_n78852048)
print v(xbgr.mr_n78882560)
print v(xbgr.mr_n79116944)
print v(xbgr.mr_n79242496)
print v(xbgr.mr_n76576448)
print v(xbgr.mr_n76842336)
print v(xbgr.mr_n77070016)
print v(xbgr.n_26)
print v(xbgr.mr_n76575984)
print v(xbgr.mr_n76842992)
print v(xbgr.n_15)
print v(xbgr.mr_n77186016)
print v(xbgr.mr_n77345168)
print v(xbgr.mr_n77405856)
print v(xbgr.mr_n77228144)
print v(xbgr.mr_n77543968)
print v(xbgr.mr_n77643824)
print v(xbgr.mr_n77760016)
print v(xbgr.mr_n77801440)
print v(xbgr.mr_n77964912)
print v(xbgr.mr_n78070160)
print v(xbgr.mr_n78084832)
print v(xbgr.mr_n78373536)
print v(xbgr.mr_n78492224)
print v(xbgr.mr_n78667664)
print v(xbgr.mr_n78789472)
print v(xbgr.mr_n78965424)
print v(xbgr.mr_n79088384)
print v(xbgr.mr_n79196288)
print v(xbgr.mr_n79243040)
print v(xbgr.mr_n76486080)
print v(xbgr.mr_n76733600)
print v(xbgr.mr_n77070944)
print v(xbgr.n_27)
print v(xbgr.mr_n76576912)
print v(xbgr.mr_n76844176)
print v(xbgr.n_16)
print v(xbgr.mr_n77187456)
print v(xbgr.mr_n76485888)
print v(xbgr.mr_n76844768)
print v(xbgr.mr_n77071408)
print v(xbgr.n_21)
print v(xbgr.mr_n77309088)
print v(xbgr.mr_n77372144)
print v(xbgr.mr_n77096544)
print v(xbgr.mr_n77520704)
print v(xbgr.mr_n77500608)
print v(xbgr.mr_n77698576)
print v(xbgr.mr_n77819488)
print v(xbgr.mr_n77927456)
print v(xbgr.mr_n78051424)
print v(xbgr.mr_n78296768)
print v(xbgr.mr_n78491632)
print v(xbgr.mr_n78653536)
print v(xbgr.mr_n78789296)
print v(xbgr.mr_n78882816)
print v(xbgr.mr_n79044640)
print v(xbgr.mr_n79178624)
print v(xbgr.mr_n79239936)
print v(xbgr.mr_n76577776)
print v(xbgr.mr_n76845360)
print v(xbgr.mr_n79721200)
print v(xbgr.mr_n79833680)
print v(xbgr.mr_n80103760)
print v(xbgr.mr_n80224688)
print v(xbgr.mr_n80391808)
print v(xbgr.mr_n80562160)
print v(xbgr.mr_n80734080)
print v(xbgr.mr_n80923184)
print v(xbgr.mr_n81156944)
print v(xbgr.mr_n81515936)
print v(xbgr.mr_n81725008)
print v(xbgr.mr_n81932720)
print v(xbgr.mr_n82119840)
print v(xbgr.mr_n82426864)
print v(xbgr.mr_n82618896)
print v(xbgr.mr_n82830976)
print v(xbgr.mr_n83199856)
print v(xbgr.mr_n77315232)
print v(xbgr.mr_n77391792)
print v(xbgr.mr_n77197952)
print v(xbgr.mr_n77485120)
print v(xbgr.mr_n77557184)
print v(xbgr.mr_n77671392)
print v(xbgr.mr_n77797040)
print v(xbgr.mr_n77926944)
print v(xbgr.mr_n78001680)
print v(xbgr.mr_n78327184)
print v(xbgr.mr_n78446528)
print v(xbgr.mr_n78578560)
print v(xbgr.mr_n78725680)
print v(xbgr.mr_n78853824)
print v(xbgr.mr_n78972368)
print v(xbgr.mr_n79147136)
print v(xbgr.mr_n79370512)
print v(xbgr.mr_n76579232)
print v(xbgr.mr_n76845952)
print v(xbgr.n_8)
print v(xbgr.vbe3)
print v(xbgr.mr_n77344224)
print v(xbgr.mr_n77404560)
print v(xbgr.mr_n77410624)
print v(xbgr.mr_n77544848)
print v(xbgr.mr_n77644624)
print v(xbgr.mr_n77760416)
print v(xbgr.mr_n77809056)
print v(xbgr.mr_n77965792)
print v(xbgr.mr_n78071040)
print v(xbgr.mr_n78375344)
print v(xbgr.mr_n78494640)
print v(xbgr.mr_n78668464)
print v(xbgr.mr_n78790272)
print v(xbgr.mr_n78976880)
print v(xbgr.mr_n79027568)
print v(xbgr.mr_n79197792)
print v(xbgr.mr_n79368960)
print v(xbgr.mr_n76578704)
print v(xbgr.mr_n76839408)
print v(xbgr.mr_n76920992)
print v(xbgr.mr_n77232336)
print v(xbgr.mr_n76580160)
print v(xbgr.mr_n76848912)
print v(xbgr.mr_n76921232)
print v(xbgr.n_37)
print v(xbgr.mr_n76579696)
print v(xbgr.mr_n76847648)
print v(xbgr.mr_n76906544)
print v(xbgr.mr_n77233328)
print v(xbgr.n_6)
print v(xbgr.vb2)
print v(xbgr.n_2)
print v(xbgr.mr_n77187344)
print v(xbgr.mr_n77299488)
print v(xbgr.mr_n77392496)
print v(xbgr.mr_n77410512)
print v(xbgr.mr_n77441712)
print v(xbgr.mr_n77603664)
print v(xbgr.mr_n77724272)
print v(xbgr.mr_n77808224)
print v(xbgr.mr_n77952560)
print v(xbgr.mr_n78070864)
print v(xbgr.mr_n78297648)
print v(xbgr.mr_n78482048)
print v(xbgr.mr_n78667488)
print v(xbgr.mr_n78772512)
print v(xbgr.mr_n78952032)
print v(xbgr.mr_n79093440)
print v(xbgr.mr_n79170928)
print v(xbgr.mr_n79368288)
print v(xbgr.mr_n79262816)
print v(xbgr.mr_n79875008)
print v(xbgr.mr_n80111584)
print v(xbgr.mr_n80226768)
print v(xbgr.mr_n80407904)
print v(xbgr.mr_n80592128)
print v(xbgr.mr_n80787216)
print v(xbgr.mr_n80936896)
print v(xbgr.mr_n81162032)
print v(xbgr.mr_n81513040)
print v(xbgr.mr_n81716128)
print v(xbgr.mr_n81937584)
print v(xbgr.mr_n82124816)
print v(xbgr.mr_n82443232)
print v(xbgr.mr_n82635872)
print v(xbgr.mr_n82851344)
print v(xbgr.mr_n83187696)
print v(xbgr.mr_n76682352)
print v(xbgr.mr_n76717616)
print v(xbgr.mr_n76922352)
print v(xbgr.mr_n77234512)
print v(xbgr.mr_n77316144)
print v(xbgr.mr_n77392672)
print v(xbgr.mr_n76743312)
print v(xbgr.mr_n77486512)
print v(xbgr.mr_n77558576)
print v(xbgr.mr_n77673936)
print v(xbgr.mr_n77798192)
print v(xbgr.mr_n77873968)
print v(xbgr.mr_n78003072)
print v(xbgr.mr_n78326720)
print v(xbgr.mr_n78448240)
print v(xbgr.mr_n78580272)
print v(xbgr.mr_n78727456)
print v(xbgr.mr_n78855600)
print v(xbgr.mr_n78977472)
print v(xbgr.mr_n79148528)
print v(xbgr.mr_n79372576)
print v(xbgr.mr_n76683200)
print v(xbgr.mr_n76718208)
print v(xbgr.n_7)
print v(xbgr.n_36)
print v(xbgr.mr_n77347680)
print v(xbgr.mr_n77406656)
print v(xbgr.mr_n77414448)
print v(xbgr.mr_n77522080)
print v(xbgr.mr_n77645424)
print v(xbgr.mr_n77760816)
print v(xbgr.mr_n77817632)
print v(xbgr.mr_n77966352)
print v(xbgr.mr_n78071840)
print v(xbgr.mr_n78377152)
print v(xbgr.mr_n78497088)
print v(xbgr.mr_n78669264)
print v(xbgr.mr_n78791072)
print v(xbgr.mr_n78978304)
print v(xbgr.mr_n79093328)
print v(xbgr.mr_n79196624)
print v(xbgr.mr_n79370736)
print v(xbgr.mr_n76671456)
print v(xbgr.mr_n76718800)
print v(xbgr.mr_n76923152)
print v(xbgr.mr_n77087232)
print v(xbgr.mr_n76684672)
print v(xbgr.mr_n76719392)
print v(xbgr.mr_n76923552)
print v(xbgr.mr_n77236224)
print v(xbgr.mr_n76680736)
print v(xbgr.mr_n76719984)
print v(xbgr.mr_n76878720)
print v(xbgr.mr_n77236816)
print v(xbgr.mr_n76686144)
print v(xbgr.mr_n76720576)
print v(xbgr.mr_n76897072)
print v(xbgr.mr_n77237408)
print v(xbgr.mr_n77309280)
print v(xbgr.mr_n77393552)
print v(xbgr.mr_n77410288)
print v(xbgr.mr_n77544672)
print v(xbgr.mr_n77604992)
print v(xbgr.mr_n77725072)
print v(xbgr.mr_n77822704)
print v(xbgr.mr_n77951632)
print v(xbgr.mr_n78045344)
print v(xbgr.mr_n78359280)
print v(xbgr.mr_n78481536)
print v(xbgr.mr_n78652832)
print v(xbgr.mr_n78775504)
print v(xbgr.mr_n78953216)
print v(xbgr.mr_n79021616)
print v(xbgr.mr_n79199600)
print v(xbgr.mr_n79370624)
print v(xbgr.mr_n79721008)
print v(xbgr.mr_n79892032)
print v(xbgr.mr_n80108288)
print v(xbgr.mr_n80229760)
print v(xbgr.mr_n80390848)
print v(xbgr.mr_n80374928)
print v(xbgr.mr_n80787024)
print v(xbgr.mr_n80958496)
print v(xbgr.mr_n81174768)
print v(xbgr.mr_n81532720)
print v(xbgr.mr_n81683040)
print v(xbgr.mr_n81962256)
print v(xbgr.mr_n82129680)
print v(xbgr.mr_n82434208)
print v(xbgr.mr_n82620864)
print v(xbgr.mr_n82567344)
print v(xbgr.mr_n83199408)
print v(xbgr.mr_n77320224)
print v(xbgr.mr_n77393904)
print v(xbgr.mr_n76766416)
print v(xbgr.mr_n77487904)
print v(xbgr.mr_n77559968)
print v(xbgr.mr_n77651568)
print v(xbgr.mr_n77799584)
print v(xbgr.mr_n77953920)
print v(xbgr.mr_n78004464)
print v(xbgr.mr_n78328112)
print v(xbgr.mr_n78450016)
print v(xbgr.mr_n78582048)
print v(xbgr.mr_n78729232)
print v(xbgr.mr_n78857376)
print v(xbgr.mr_n78975360)
print v(xbgr.mr_n79150048)
print v(xbgr.mr_n79374640)
print v(xbgr.mr_n76677488)
print v(xbgr.mr_n76721168)
print v(xbgr.mr_n76913648)
print v(xbgr.mr_n77238592)
print v(xbgr.mr_n76687200)
print v(xbgr.mr_n76721760)
print v(xbgr.n_11)
print v(xbgr.mr_n77238000)
print v(xbgr.mr_n77345680)
print v(xbgr.mr_n77407056)
print v(xbgr.mr_n77416720)
print v(xbgr.mr_n77496016)
print v(xbgr.mr_n77646224)
print v(xbgr.mr_n77761216)
print v(xbgr.mr_n77825168)
print v(xbgr.mr_n77957232)
print v(xbgr.mr_n78072640)
print v(xbgr.mr_n78375856)
print v(xbgr.mr_n78498896)
print v(xbgr.mr_n78670064)
print v(xbgr.mr_n78791872)
print v(xbgr.mr_n78980448)
print v(xbgr.mr_n79091392)
print v(xbgr.mr_n79199712)
print v(xbgr.mr_n79372800)
print v(xbgr.mr_n76685408)
print v(xbgr.mr_n76722352)
print v(xbgr.mr_n77003648)
print v(xbgr.mr_n77239184)
print v(xbgr.mr_n76688752)
print v(xbgr.mr_n76696064)
print v(xbgr.mr_n76921552)
print v(xbgr.mr_n77233856)
print v(xbgr.mr_n76689024)
print v(xbgr.mr_n76723536)
print v(xbgr.mr_n76998480)
print v(xbgr.mr_n77240288)
print v(xbgr.mr_n77314480)
print v(xbgr.mr_n77394608)
print v(xbgr.mr_n77411776)
print v(xbgr.mr_n77521456)
print v(xbgr.mr_n77609808)
print v(xbgr.mr_n77725872)
print v(xbgr.mr_n77812240)
print v(xbgr.mr_n77953184)
print v(xbgr.mr_n78045168)
print v(xbgr.mr_n78357056)
print v(xbgr.mr_n78481792)
print v(xbgr.mr_n78669888)
print v(xbgr.mr_n78791696)
print v(xbgr.mr_n78954400)
print v(xbgr.mr_n79026752)
print v(xbgr.mr_n79197904)
print v(xbgr.mr_n79372688)
print v(xbgr.n_9)
print v(xbgr.mr_n76715936)
print v(xbgr.mr_n76961168)
print v(xbgr.mr_n77240960)
print v(xbgr.mr_n79725360)
print v(xbgr.mr_n79891568)
print v(xbgr.mr_n79873440)
print v(xbgr.mr_n80236080)
print v(xbgr.mr_n80391424)
print v(xbgr.mr_n80596528)
print v(xbgr.mr_n80796400)
print v(xbgr.mr_n80963024)
print v(xbgr.mr_n81171872)
print v(xbgr.mr_n81543360)
print v(xbgr.mr_n81737600)
print v(xbgr.mr_n81946992)
print v(xbgr.mr_n81903552)
print v(xbgr.mr_n82446576)
print v(xbgr.mr_n82635360)
print v(xbgr.mr_n82878864)
print v(xbgr.mr_n83098752)
print v(xbgr.mr_n77321136)
print v(xbgr.mr_n77394960)
print v(xbgr.mr_n76711968)
print v(xbgr.mr_n77489296)
print v(xbgr.mr_n77561360)
print v(xbgr.mr_n77679024)
print v(xbgr.mr_n77800976)
print v(xbgr.mr_n77954848)
print v(xbgr.mr_n78005856)
print v(xbgr.mr_n78357312)
print v(xbgr.mr_n78451792)
print v(xbgr.mr_n78583824)
print v(xbgr.mr_n78731008)
print v(xbgr.mr_n78859152)
print v(xbgr.mr_n78981456)
print v(xbgr.mr_n79151824)
print v(xbgr.mr_n79376704)
print v(xbgr.mr_n76687584)
print v(xbgr.mr_n76724656)
print v(xbgr.mr_n77004976)
print v(xbgr.mr_n77241552)
print v(xbgr.mr_n77350592)
print v(xbgr.mr_n77407456)
print v(xbgr.mr_n76512192)
print v(xbgr.mr_n76828816)
print v(xbgr.mr_n77647024)
print v(xbgr.mr_n77761616)
print v(xbgr.mr_n77822816)
print v(xbgr.mr_n77968048)
print v(xbgr.mr_n78073440)
print v(xbgr.mr_n78381280)
print v(xbgr.mr_n78500704)
print v(xbgr.mr_n78670864)
print v(xbgr.mr_n78792672)
print v(xbgr.mr_n78981968)
print v(xbgr.mr_n79091504)
print v(xbgr.mr_n79203328)
print v(xbgr.mr_n79374864)
print v(xbgr.mr_n76677952)
print v(xbgr.mr_n76725312)
print v(xbgr.mr_n77005440)
print v(xbgr.mr_n77229952)
print v(xbgr.mr_n76691200)
print v(xbgr.mr_n76725904)
print v(xbgr.mr_n77004240)
print v(xbgr.mr_n77242672)
print v(xbgr.mr_n76691744)
print v(xbgr.mr_n76726496)
print v(xbgr.mr_n77006880)
print v(xbgr.mr_n77243328)
print v(xbgr.mr_n76685296)
print v(xbgr.mr_n76727088)
print v(xbgr.mr_n77007472)
print v(xbgr.mr_n77243920)
print v(xbgr.mr_n77325216)
print v(xbgr.mr_n77395664)
print v(xbgr.mr_n76798624)
print v(xbgr.mr_n77544496)
print v(xbgr.mr_n77611136)
print v(xbgr.mr_n77726736)
print v(xbgr.mr_n77827984)
print v(xbgr.mr_n77954272)
print v(xbgr.mr_n78071664)
print v(xbgr.mr_n78379728)
print v(xbgr.mr_n78419328)
print v(xbgr.mr_n78668288)
print v(xbgr.mr_n78772096)
print v(xbgr.mr_n78955584)
print v(xbgr.mr_n79088720)
print v(xbgr.mr_n79201520)
print v(xbgr.mr_n79378992)
print v(xbgr.mr_n79729296)
print v(xbgr.mr_n79899936)
print v(xbgr.mr_n80106208)
print v(xbgr.mr_n80247488)
print v(xbgr.mr_n80390656)
print v(xbgr.mr_n80585200)
print v(xbgr.mr_n80792992)
print v(xbgr.mr_n80953008)
print v(xbgr.mr_n81184976)
print v(xbgr.mr_n81569312)
print v(xbgr.mr_n81746832)
print v(xbgr.mr_n81951888)
print v(xbgr.mr_n82139824)
print v(xbgr.mr_n82446688)
print v(xbgr.mr_n82610384)
print v(xbgr.mr_n82855552)
print v(xbgr.mr_n82762176)
print v(xbgr.mr_n76687696)
print v(xbgr.mr_n76696992)
print v(xbgr.mr_n77008064)
print v(xbgr.mr_n77244512)
print v(xbgr.mr_n77316896)
print v(xbgr.mr_n77396016)
print v(xbgr.mr_n76703520)
print v(xbgr.mr_n77490688)
print v(xbgr.mr_n77560896)
print v(xbgr.mr_n77679904)
print v(xbgr.mr_n77800512)
print v(xbgr.mr_n77956096)
print v(xbgr.mr_n78007248)
print v(xbgr.mr_n78380624)
print v(xbgr.mr_n78451200)
print v(xbgr.mr_n78583232)
print v(xbgr.mr_n78732784)
print v(xbgr.mr_n78858560)
print v(xbgr.mr_n78982560)
print v(xbgr.mr_n79153600)
print v(xbgr.mr_n79376816)
print v(xbgr.mr_n76693648)
print v(xbgr.mr_n76728272)
print v(xbgr.mr_n77008656)
print v(xbgr.mr_n77245104)
print v(xbgr.mr_n77349296)
print v(xbgr.mr_n77407856)
print v(xbgr.mr_n77410400)
print v(xbgr.mr_n76529232)
print v(xbgr.mr_n77647824)
print v(xbgr.mr_n77762016)
print v(xbgr.mr_n77830096)
print v(xbgr.mr_n77969024)
print v(xbgr.mr_n78074240)
print v(xbgr.mr_n78383344)
print v(xbgr.mr_n78502512)
print v(xbgr.mr_n78671664)
print v(xbgr.mr_n78776032)
print v(xbgr.mr_n78983792)
print v(xbgr.mr_n79095136)
print v(xbgr.mr_n79205024)
print v(xbgr.mr_n79376928)
print v(xbgr.mr_n76693920)
print v(xbgr.mr_n76699776)
print v(xbgr.n_3)
print v(xbgr.n_33)
print v(xbgr.mr_n76694464)
print v(xbgr.mr_n76729456)
print v(xbgr.mr_n76959984)
print v(xbgr.mr_n77246208)
print v(xbgr.mr_n76690112)
print v(xbgr.mr_n76730048)
print v(xbgr.mr_n77010432)
print v(xbgr.mr_n77246880)
print v(xbgr.mr_n76696528)
print v(xbgr.mr_n76730640)
print v(xbgr.mr_n77011024)
print v(xbgr.mr_n77247472)
print v(xbgr.mr_n77319472)
print v(xbgr.mr_n77403888)
print v(xbgr.mr_n77284176)
print v(xbgr.mr_n77523152)
print v(xbgr.mr_n77615952)
print v(xbgr.mr_n77727920)
print v(xbgr.mr_n77827872)
print v(xbgr.mr_n77955264)
print v(xbgr.mr_n78074064)
print v(xbgr.mr_n78241488)
print v(xbgr.mr_n78381792)
print v(xbgr.mr_n78452320)
print v(xbgr.mr_n78645552)
print v(xbgr.mr_n78776736)
print v(xbgr.mr_n78956768)
print v(xbgr.mr_n79095248)
print v(xbgr.mr_n79203216)
print v(xbgr.mr_n79378880)
print v(xbgr.mr_n79727040)
print v(xbgr.mr_n79921104)
print v(xbgr.mr_n80123488)
print v(xbgr.mr_n80254816)
print v(xbgr.mr_n80397552)
print v(xbgr.mr_n80614400)
print v(xbgr.mr_n80808128)
print v(xbgr.mr_n80972272)
print v(xbgr.mr_n81181984)
print v(xbgr.mr_n81352592)
print v(xbgr.mr_n81545616)
print v(xbgr.mr_n81724544)
print v(xbgr.mr_n81954336)
print v(xbgr.mr_n82029328)
print v(xbgr.mr_n82454112)
print v(xbgr.mr_n82617984)
print v(xbgr.mr_n82854320)
print v(xbgr.mr_n83061824)
print v(xbgr.mr_n77326128)
print v(xbgr.mr_n77371520)
print v(xbgr.mr_n76754320)
print v(xbgr.mr_n77491152)
print v(xbgr.mr_n77560432)
print v(xbgr.mr_n77578608)
print v(xbgr.mr_n77800048)
print v(xbgr.mr_n77957408)
print v(xbgr.mr_n78008640)
print v(xbgr.mr_n78241680)
print v(xbgr.mr_n78377664)
print v(xbgr.mr_n78450608)
print v(xbgr.mr_n78582640)
print v(xbgr.mr_n78734560)
print v(xbgr.mr_n78857968)
print v(xbgr.mr_n78979040)
print v(xbgr.mr_n79155376)
print v(xbgr.mr_n79374752)
print v(xbgr.mr_n76692288)
print v(xbgr.n_19)
print v(xbgr.mr_n77011616)
print v(xbgr.mr_n77248064)
print v(xbgr.mr_n77353904)
print v(xbgr.mr_n77408256)
print v(xbgr.mr_n77422144)
print v(xbgr.mr_n77181248)
print v(xbgr.mr_n77648624)
print v(xbgr.mr_n77762416)
print v(xbgr.mr_n77833088)
print v(xbgr.mr_n77970480)
print v(xbgr.mr_n78075040)
print v(xbgr.mr_n78252720)
print v(xbgr.mr_n78385408)
print v(xbgr.mr_n78504320)
print v(xbgr.mr_n78672464)
print v(xbgr.mr_n78794272)
print v(xbgr.mr_n78983296)
print v(xbgr.mr_n79096944)
print v(xbgr.mr_n79201408)
print v(xbgr.mr_n79380832)
print v(xbgr.mr_n76697920)
print v(xbgr.mr_n76731824)
print v(xbgr.mr_n77006256)
print v(xbgr.mr_n77248656)
print v(xbgr.mr_n76698848)
print v(xbgr.mr_n76732416)
print v(xbgr.mr_n77012800)
print v(xbgr.mr_n77249248)
print v(xbgr.mr_n76700240)
print v(xbgr.mr_n76733008)
print v(xbgr.mr_n76923952)
print v(xbgr.mr_n77249840)
print v(xbgr.mr_n76692832)
print v(xbgr.mr_n76722944)
print v(xbgr.mr_n77013984)
print v(xbgr.mr_n77245696)
print v(xbgr.mr_n77324160)
print v(xbgr.mr_n77395840)
print v(xbgr.mr_n77417232)
print v(xbgr.mr_n77500864)
print v(xbgr.mr_n77617280)
print v(xbgr.mr_n77729104)
print v(xbgr.mr_n77831008)
print v(xbgr.mr_n77958064)
print v(xbgr.mr_n78012544)
print v(xbgr.mr_n78211952)
print v(xbgr.mr_n78372240)
print v(xbgr.mr_n78499408)
print v(xbgr.mr_n78648960)
print v(xbgr.mr_n78775920)
print v(xbgr.mr_n78957360)
print v(xbgr.mr_n79097056)
print v(xbgr.mr_n79205136)
print v(xbgr.mr_n79380944)
print v(xbgr.mr_n76699312)
print v(xbgr.mr_n76734192)
print v(xbgr.mr_n77014576)
print v(xbgr.mr_n77251088)
print v(xbgr.mr_n79723744)
print v(xbgr.mr_n79925888)
print v(xbgr.mr_n80118656)
print v(xbgr.mr_n80269072)
print v(xbgr.mr_n80431184)
print v(xbgr.mr_n80619376)
print v(xbgr.mr_n80819840)
print v(xbgr.mr_n80962320)
print v(xbgr.mr_n81086816)
print v(xbgr.mr_n81355792)
print v(xbgr.mr_n81561584)
print v(xbgr.mr_n81764704)
print v(xbgr.mr_n81949440)
print v(xbgr.mr_n82154976)
print v(xbgr.mr_n82466480)
print v(xbgr.mr_n82602560)
print v(xbgr.mr_n82832240)
print v(xbgr.mr_n83024432)
print v(xbgr.mr_n77330208)
print v(xbgr.mr_n77371248)
print v(xbgr.mr_n76772496)
print v(xbgr.mr_n77490224)
print v(xbgr.mr_n77559504)
print v(xbgr.mr_n77596304)
print v(xbgr.mr_n77799120)
print v(xbgr.mr_n77957888)
print v(xbgr.mr_n78045680)
print v(xbgr.mr_n78251856)
print v(xbgr.mr_n78378560)
print v(xbgr.mr_n78449424)
print v(xbgr.mr_n78581456)
print v(xbgr.mr_n78736336)
print v(xbgr.mr_n78856784)
print v(xbgr.mr_n78985616)
print v(xbgr.mr_n79157152)
print v(xbgr.mr_n79378768)
print v(xbgr.mr_n76698384)
print v(xbgr.mr_n76517264)
print v(xbgr.mr_n77015168)
print v(xbgr.mr_n77251616)
print v(xbgr.mr_n77354960)
print v(xbgr.mr_n77408896)
print v(xbgr.mr_n77423872)
print v(xbgr.mr_n77541040)
print v(xbgr.mr_n77649024)
print v(xbgr.mr_n77762816)
print v(xbgr.mr_n77835344)
print v(xbgr.mr_n77971360)
print v(xbgr.mr_n78075840)
print v(xbgr.mr_n78256368)
print v(xbgr.mr_n78387472)
print v(xbgr.mr_n78506048)
print v(xbgr.mr_n78673264)
print v(xbgr.mr_n78795072)
print v(xbgr.mr_n78988000)
print v(xbgr.mr_n79098752)
print v(xbgr.mr_n79208640)
print v(xbgr.mr_n79382896)
print v(xbgr.mr_n76697456)
print v(xbgr.mr_n76544016)
print v(xbgr.mr_n77015760)
print v(xbgr.mr_n77229840)
print v(xbgr.mr_n76690656)
print v(xbgr.mr_n76557392)
print v(xbgr.n_4)
print v(xbgr.n_30)
print v(xbgr.mr_n76695600)
print v(xbgr.mr_n76619808)
print v(xbgr.mr_n77001872)
print v(xbgr.mr_n77253392)
print v(xbgr.mr_n76694736)
print v(xbgr.mr_n76538384)
print v(xbgr.mr_n77017536)
print v(xbgr.mr_n77253984)
print v(xbgr.mr_n77326880)
print v(xbgr.mr_n77396720)
print v(xbgr.mr_n77419040)
print v(xbgr.mr_n77475792)
print v(xbgr.mr_n77622096)
print v(xbgr.mr_n77730288)
print v(xbgr.mr_n77812576)
print v(xbgr.mr_n77954736)
print v(xbgr.mr_n77988256)
print v(xbgr.mr_n78242384)
print v(xbgr.mr_n78371120)
print v(xbgr.mr_n78421136)
print v(xbgr.mr_n78673088)
print v(xbgr.mr_n78792496)
print v(xbgr.mr_n78956176)
print v(xbgr.mr_n79098864)
print v(xbgr.mr_n79179216)
print v(xbgr.mr_n79381056)
print v(xbgr.mr_n75996656)
print v(xbgr.mr_n79931664)
print v(xbgr.mr_n80134624)
print v(xbgr.mr_n80263056)
print v(xbgr.mr_n80416176)
print v(xbgr.mr_n80618864)
print v(xbgr.mr_n80819328)
print v(xbgr.mr_n80927936)
print v(xbgr.mr_n81090240)
print v(xbgr.mr_n81387360)
print v(xbgr.mr_n81494912)
print v(xbgr.mr_n81715856)
print v(xbgr.mr_n81944544)
print v(xbgr.mr_n82159952)
print v(xbgr.mr_n82466592)
print v(xbgr.mr_n82639488)
print v(xbgr.mr_n82829712)
print v(xbgr.mr_n82952064)
print v(xbgr.mr_n76694192)
print v(xbgr.mr_n76559504)
print v(xbgr.mr_n77018128)
print v(xbgr.mr_n77254576)
print v(xbgr.mr_n77321888)
print v(xbgr.mr_n77370976)
print v(xbgr.mr_n77162496)
print v(xbgr.mr_n77489760)
print v(xbgr.mr_n77559040)
print v(xbgr.mr_n77683584)
print v(xbgr.mr_n77798656)
print v(xbgr.mr_n77956752)
print v(xbgr.mr_n77988944)
print v(xbgr.mr_n78091184)
print v(xbgr.mr_n78374048)
print v(xbgr.mr_n78448832)
print v(xbgr.mr_n78580864)
print v(xbgr.mr_n78738112)
print v(xbgr.mr_n78856192)
print v(xbgr.mr_n78987504)
print v(xbgr.mr_n79158928)
print v(xbgr.mr_n79384960)
print v(xbgr.mr_n76689568)
print v(xbgr.mr_n76515152)
print v(xbgr.mr_n77018720)
print v(xbgr.mr_n77255168)
print v(xbgr.mr_n77356736)
print v(xbgr.mr_n77404224)
print v(xbgr.mr_n77425760)
print v(xbgr.mr_n77473808)
print v(xbgr.mr_n77648224)
print v(xbgr.mr_n77763216)
print v(xbgr.mr_n77833728)
print v(xbgr.mr_n77959200)
print v(xbgr.mr_n78052176)
print v(xbgr.mr_n78258096)
print v(xbgr.mr_n78389456)
print v(xbgr.mr_n78507936)
print v(xbgr.mr_n78674064)
print v(xbgr.mr_n78795872)
print v(xbgr.mr_n78988960)
print v(xbgr.mr_n79100672)
print v(xbgr.mr_n79210448)
print v(xbgr.mr_n79383120)
print v(xbgr.mr_n76693104)
print v(xbgr.mr_n76548944)
print v(xbgr.mr_n77019312)
print v(xbgr.mr_n77255760)
print v(xbgr.mr_n76692560)
print v(xbgr.mr_n76727680)
print v(xbgr.mr_n77019904)
print v(xbgr.mr_n77114432)
print v(xbgr.mr_n76692016)
print v(xbgr.mr_n76539792)
print v(xbgr.mr_n76924352)
print v(xbgr.mr_n77242144)
print v(xbgr.mr_n77331872)
print v(xbgr.mr_n77408720)
print v(xbgr.mr_n77422656)
print v(xbgr.mr_n77510928)
print v(xbgr.mr_n77623424)
print v(xbgr.mr_n77731472)
print v(xbgr.mr_n77838096)
print v(xbgr.mr_n77953808)
print v(xbgr.mr_n78075664)
print v(xbgr.mr_n78253568)
print v(xbgr.mr_n78382688)
print v(xbgr.mr_n78501216)
print v(xbgr.mr_n78669088)
print v(xbgr.mr_n78793472)
print v(xbgr.mr_n78954992)
print v(xbgr.mr_n79100560)
print v(xbgr.mr_n79210560)
print v(xbgr.mr_n79385072)
print v(xbgr.mr_n76691472)
print v(xbgr.mr_n76537680)
print v(xbgr.mr_n77021088)
print v(xbgr.mr_n77257456)
print v(xbgr.mr_n79716688)
print v(xbgr.mr_n79924448)
print v(xbgr.mr_n80131104)
print v(xbgr.mr_n80280208)
print v(xbgr.mr_n80389712)
print v(xbgr.mr_n80602224)
print v(xbgr.mr_n80821584)
print v(xbgr.mr_n80971568)
print v(xbgr.mr_n78107344)
print v(xbgr.mr_n81090352)
print v(xbgr.mr_n81384464)
print v(xbgr.mr_n81530512)
print v(xbgr.mr_n81771424)
print v(xbgr.mr_n81939648)
print v(xbgr.mr_n82165184)
print v(xbgr.mr_n82474016)
print v(xbgr.mr_n82633360)
print v(xbgr.mr_n82854128)
print v(xbgr.mr_n82771184)
print v(xbgr.mr_n77335200)
print v(xbgr.mr_n77370704)
print v(xbgr.mr_n76749456)
print v(xbgr.mr_n77488832)
print v(xbgr.mr_n77558112)
print v(xbgr.mr_n77684352)
print v(xbgr.mr_n77797728)
print v(xbgr.mr_n77955440)
print v(xbgr.mr_n78083808)
print v(xbgr.mr_n78384752)
print v(xbgr.mr_n78447648)
print v(xbgr.mr_n78579680)
print v(xbgr.mr_n78733728)
print v(xbgr.mr_n78855008)
print v(xbgr.mr_n78985728)
print v(xbgr.mr_n79206944)
print v(xbgr.mr_n79389088)
print v(xbgr.mr_n76690928)
print v(xbgr.mr_n76693376)
print v(xbgr.mr_n77021680)
print v(xbgr.mr_n77258112)
print v(xbgr.mr_n77358272)
print v(xbgr.mr_n76794672)
print v(xbgr.mr_n77427568)
print v(xbgr.mr_n77467424)
print v(xbgr.mr_n77647424)
print v(xbgr.mr_n77763616)
print v(xbgr.mr_n77837872)
print v(xbgr.mr_n77971984)
print v(xbgr.mr_n78073264)
print v(xbgr.mr_n78259984)
print v(xbgr.mr_n78391600)
print v(xbgr.mr_n78509744)
print v(xbgr.mr_n78674864)
print v(xbgr.mr_n78796672)
print v(xbgr.mr_n78991344)
print v(xbgr.mr_n79105984)
print v(xbgr.mr_n79206832)
print v(xbgr.mr_n79387024)
print v(xbgr.mr_n76690384)
print v(xbgr.mr_n76555312)
print v(xbgr.mr_n77022272)
print v(xbgr.mr_n77258704)
print v(xbgr.mr_n76689840)
print v(xbgr.mr_n76480112)
print v(xbgr.mr_n77022864)
print v(xbgr.mr_n77259296)
print v(xbgr.mr_n76689296)
print v(xbgr.mr_n76728864)
print v(xbgr.n_5)
print v(xbgr.mr_n77259888)
print v(xbgr.mr_n76688480)
print v(xbgr.mr_n76569360)
print v(xbgr.mr_n77004864)
print v(xbgr.mr_n77250432)
print v(xbgr.mr_n77334256)
print v(xbgr.mr_n77409520)
print v(xbgr.mr_n77415040)
print v(xbgr.mr_n77473040)
print v(xbgr.mr_n77597760)
print v(xbgr.mr_n77732656)
print v(xbgr.mr_n77840528)
print v(xbgr.mr_n77953072)
print v(xbgr.mr_n78069216)
print v(xbgr.mr_n78256880)
print v(xbgr.mr_n78387984)
print v(xbgr.mr_n78497600)
print v(xbgr.mr_n78673888)
print v(xbgr.mr_n78794896)
print v(xbgr.mr_n78953808)
print v(xbgr.mr_n79104288)
print v(xbgr.mr_n79212368)
print v(xbgr.mr_n79387136)
print v(xbgr.mr_n79593008)
print v(xbgr.mr_n79855136)
print v(xbgr.mr_n80145760)
print v(xbgr.mr_n80263520)
print v(xbgr.mr_n80411520)
print v(xbgr.mr_n80591616)
print v(xbgr.mr_n80802688)
print v(xbgr.mr_n80980480)
print v(xbgr.mr_n78096768)
print v(xbgr.mr_n81078992)
print v(xbgr.mr_n81389440)
print v(xbgr.mr_n81526000)
print v(xbgr.mr_n81752528)
print v(xbgr.mr_n81935840)
print v(xbgr.mr_n82169904)
print v(xbgr.mr_n82486496)
print v(xbgr.mr_n82630176)
print v(xbgr.mr_n82779312)
print v(xbgr.mr_n83081216)
print v(xbgr.mr_n76688208)
print v(xbgr.mr_n76558800)
print v(xbgr.mr_n77024640)
print v(xbgr.mr_n77261072)
print v(xbgr.mr_n77334448)
print v(xbgr.mr_n77370432)
print v(xbgr.mr_n76756464)
print v(xbgr.mr_n77488368)
print v(xbgr.mr_n77557648)
print v(xbgr.mr_n77685280)
print v(xbgr.mr_n77797344)
print v(xbgr.mr_n77954384)
print v(xbgr.mr_n78067888)
print v(xbgr.mr_n78390944)
print v(xbgr.mr_n78447056)
print v(xbgr.mr_n78579088)
print v(xbgr.mr_n78741200)
print v(xbgr.mr_n78854416)
print v(xbgr.mr_n78990768)
print v(xbgr.mr_n79177440)
print v(xbgr.mr_n79383008)
print v(xbgr.mr_n76686928)
print v(xbgr.mr_n76481376)
print v(xbgr.mr_n77025232)
print v(xbgr.mr_n77261664)
print v(xbgr.mr_n77355472)
print v(xbgr.mr_n76507936)
print v(xbgr.mr_n77429376)
print v(xbgr.mr_n77468624)
print v(xbgr.mr_n77646624)
print v(xbgr.mr_n77764016)
print v(xbgr.mr_n77843200)
print v(xbgr.mr_n77974192)
print v(xbgr.mr_n78072464)
print v(xbgr.mr_n78261792)
print v(xbgr.mr_n78393664)
print v(xbgr.mr_n78511552)
print v(xbgr.mr_n78674688)
print v(xbgr.mr_n78797472)
print v(xbgr.mr_n78992304)
print v(xbgr.mr_n79107792)
print v(xbgr.mr_n79208752)
print v(xbgr.mr_n79385184)
print v(xbgr.mr_n76648256)
print v(xbgr.mr_n76855360)
print v(xbgr.mr_n77025824)
print v(xbgr.mr_n77262256)
print v(xbgr.mr_n76648720)
print v(xbgr.mr_n76851792)
print v(xbgr.mr_n77020496)
print v(xbgr.mr_n77262848)
print v(xbgr.mr_n76641968)
print v(xbgr.mr_n76856544)
print v(xbgr.mr_n77027008)
print v(xbgr.mr_n77260480)
print v(xbgr.mr_n76649648)
print v(xbgr.mr_n76857200)
print v(xbgr.mr_n76868448)
print v(xbgr.mr_n77263952)
print v(xbgr.mr_n77329152)
print v(xbgr.mr_n77404976)
print v(xbgr.mr_n77424464)
print v(xbgr.mr_n76586192)
print v(xbgr.mr_n77598016)
print v(xbgr.mr_n77733840)
print v(xbgr.mr_n77833840)
print v(xbgr.mr_n77951744)
print v(xbgr.mr_n78099808)
print v(xbgr.mr_n78214912)
print v(xbgr.mr_n78386816)
print v(xbgr.mr_n78503024)
print v(xbgr.mr_n78646016)
print v(xbgr.mr_n78793296)
print v(xbgr.mr_n78952624)
print v(xbgr.mr_n79104176)
print v(xbgr.mr_n79216096)
print v(xbgr.mr_n79391264)
print v(xbgr.mr_n75982928)
print v(xbgr.mr_n79895264)
print v(xbgr.mr_n80136944)
print v(xbgr.mr_n80266560)
print v(xbgr.mr_n80428672)
print v(xbgr.mr_n80589616)
print v(xbgr.mr_n80788960)
print v(xbgr.mr_n80984944)
print v(xbgr.mr_n78098624)
print v(xbgr.mr_n81084672)
print v(xbgr.mr_n81394416)
print v(xbgr.mr_n81530784)
print v(xbgr.mr_n81739536)
print v(xbgr.mr_n81928528)
print v(xbgr.mr_n82174880)
print v(xbgr.mr_n82469424)
print v(xbgr.mr_n82644144)
print v(xbgr.mr_n82854832)
print v(xbgr.mr_n83083008)
print v(xbgr.mr_n77329264)
print v(xbgr.mr_n77370160)
print v(xbgr.mr_n76503008)
print v(xbgr.mr_n77487440)
print v(xbgr.mr_n77556720)
print v(xbgr.mr_n77684816)
print v(xbgr.mr_n77796736)
print v(xbgr.mr_n77953296)
print v(xbgr.mr_n77638864)
print v(xbgr.mr_n78388880)
print v(xbgr.mr_n78446064)
print v(xbgr.mr_n78578096)
print v(xbgr.mr_n78741808)
print v(xbgr.mr_n78853232)
print v(xbgr.mr_n78984912)
print v(xbgr.mr_n79214176)
print v(xbgr.mr_n79389200)
print v(xbgr.mr_n76638256)
print v(xbgr.mr_n76857792)
print v(xbgr.mr_n77028192)
print v(xbgr.mr_n77264624)
print v(xbgr.mr_n76650576)
print v(xbgr.mr_n76850096)
print v(xbgr.mr_n77028784)
print v(xbgr.mr_n77265216)
print v(xbgr.mr_n77360784)
print v(xbgr.mr_n77406256)
print v(xbgr.mr_n77431104)
print v(xbgr.mr_n76583392)
print v(xbgr.mr_n77645824)
print v(xbgr.mr_n77764416)
print v(xbgr.mr_n77845456)
print v(xbgr.mr_n77974832)
print v(xbgr.mr_n78099616)
print v(xbgr.mr_n78263600)
print v(xbgr.mr_n78395728)
print v(xbgr.mr_n78513360)
print v(xbgr.mr_n78676464)
print v(xbgr.mr_n78798272)
print v(xbgr.mr_n78993888)
print v(xbgr.mr_n79109712)
print v(xbgr.mr_n79212256)
print v(xbgr.mr_n79391152)
print v(xbgr.mr_n76651040)
print v(xbgr.mr_n76858976)
print v(xbgr.mr_n77029376)
print v(xbgr.mr_n77252208)
print v(xbgr.mr_n76651504)
print v(xbgr.mr_n76859568)
print v(xbgr.mr_n77024048)
print v(xbgr.mr_n77266432)
print v(xbgr.mr_n76644752)
print v(xbgr.mr_n76567248)
print v(xbgr.mr_n77030560)
print v(xbgr.n_31)
print v(xbgr.mr_n77324272)
print v(xbgr.mr_n77397072)
print v(xbgr.mr_n77418448)
print v(xbgr.mr_n77542368)
print v(xbgr.mr_n77467696)
print v(xbgr.mr_n77735024)
print v(xbgr.mr_n77846176)
print v(xbgr.mr_n77903680)
print v(xbgr.mr_n78076400)
print v(xbgr.mr_n78241872)
print v(xbgr.mr_n78394176)
print v(xbgr.mr_n78504832)
print v(xbgr.mr_n78670688)
print v(xbgr.mr_n78798096)
print v(xbgr.mr_n78951440)
print v(xbgr.mr_n79109600)
print v(xbgr.mr_n79215872)
print v(xbgr.mr_n79393440)
print v(xbgr.mr_n76652432)
print v(xbgr.mr_n76860752)
print v(xbgr.mr_n77012208)
print v(xbgr.mr_n77267456)
print v(xbgr.mr_n79477616)
print v(xbgr.mr_n79898208)
print v(xbgr.mr_n80125808)
print v(xbgr.mr_n80256896)
print v(xbgr.mr_n80434800)
print v(xbgr.mr_n80478272)
print v(xbgr.mr_n80781776)
print v(xbgr.mr_n80969248)
print v(xbgr.mr_n78119536)
print v(xbgr.mr_n81086928)
print v(xbgr.mr_n81399392)
print v(xbgr.mr_n81546128)
print v(xbgr.mr_n81730704)
print v(xbgr.mr_n81605664)
print v(xbgr.mr_n82180112)
print v(xbgr.mr_n82471376)
print v(xbgr.mr_n82648800)
print v(xbgr.mr_n82853856)
print v(xbgr.mr_n83052624)
print v(xbgr.mr_n77324464)
print v(xbgr.mr_n77369968)
print v(xbgr.mr_n76502224)
print v(xbgr.mr_n77486976)
print v(xbgr.mr_n77556256)
print v(xbgr.mr_n77683888)
print v(xbgr.mr_n77796432)
print v(xbgr.mr_n77879552)
print v(xbgr.mr_n78160784)
print v(xbgr.mr_n78395072)
print v(xbgr.mr_n78445600)
print v(xbgr.mr_n78577632)
print v(xbgr.mr_n78741472)
print v(xbgr.mr_n78852640)
print v(xbgr.mr_n78976544)
print v(xbgr.mr_n79220224)
print v(xbgr.mr_n79393216)
print v(xbgr.mr_n76641040)
print v(xbgr.mr_n76861344)
print v(xbgr.mr_n77031744)
print v(xbgr.mr_n77256880)
print v(xbgr.mr_n77362240)
print v(xbgr.mr_n76525984)
print v(xbgr.mr_n77432912)
print v(xbgr.mr_n77476240)
print v(xbgr.mr_n77645024)
print v(xbgr.mr_n77764816)
print v(xbgr.mr_n77842304)
print v(xbgr.mr_n77975968)
print v(xbgr.mr_n78100464)
print v(xbgr.mr_n78265408)
print v(xbgr.mr_n78397792)
print v(xbgr.mr_n78515168)
print v(xbgr.mr_n78677264)
print v(xbgr.mr_n78799072)
print v(xbgr.mr_n78995712)
print v(xbgr.mr_n79107904)
print v(xbgr.mr_n79217936)
print v(xbgr.mr_n79387248)
print v(xbgr.mr_n76653360)
print v(xbgr.mr_n76861936)
print v(xbgr.mr_n77032336)
print v(xbgr.mr_n77268640)
print v(xbgr.mr_n76653824)
print v(xbgr.n_34)
print v(xbgr.mr_n77032928)
print v(xbgr.mr_n77263440)
print v(xbgr.mr_n76654288)
print v(xbgr.mr_n76860160)
print v(xbgr.mr_n77033520)
print v(xbgr.mr_n77269808)
print v(xbgr.mr_n76647328)
print v(xbgr.mr_n76863632)
print v(xbgr.mr_n77031152)
print v(xbgr.mr_n77265808)
print v(xbgr.mr_n77319168)
print v(xbgr.mr_n76584368)
print v(xbgr.mr_n77420848)
print v(xbgr.mr_n76593792)
print v(xbgr.mr_n77561824)
print v(xbgr.mr_n77736208)
print v(xbgr.mr_n77846288)
print v(xbgr.mr_n77951856)
print v(xbgr.mr_n78069648)
print v(xbgr.mr_n78258688)
print v(xbgr.mr_n78396240)
print v(xbgr.mr_n78495152)
print v(xbgr.mr_n78675664)
print v(xbgr.mr_n78790096)
print v(xbgr.mr_n78883072)
print v(xbgr.mr_n79113328)
print v(xbgr.mr_n79214064)
print v(xbgr.mr_n79391376)
print v(xbgr.mr_n79707664)
print v(xbgr.mr_n79889824)
print v(xbgr.mr_n80113840)
print v(xbgr.mr_n80259680)
print v(xbgr.mr_n80449232)
print v(xbgr.mr_n80576576)
print v(xbgr.mr_n80770640)
print v(xbgr.mr_n80997072)
print v(xbgr.mr_n78089392)
print v(xbgr.mr_n81084480)
print v(xbgr.mr_n81404368)
print v(xbgr.mr_n81528768)
print v(xbgr.mr_n81727328)
print v(xbgr.mr_n81922208)
print v(xbgr.mr_n82184832)
print v(xbgr.mr_n82426448)
print v(xbgr.mr_n82676736)
print v(xbgr.mr_n82859312)
print v(xbgr.mr_n83085440)
print v(xbgr.mr_n76655216)
print v(xbgr.mr_n76864304)
print v(xbgr.mr_n77009840)
print v(xbgr.mr_n77271136)
print v(xbgr.mr_n77319280)
print v(xbgr.mr_n77367232)
print v(xbgr.mr_n76552672)
print v(xbgr.mr_n77486048)
print v(xbgr.mr_n77555328)
print v(xbgr.mr_n77683696)
print v(xbgr.mr_n77756880)
print v(xbgr.mr_n77879248)
print v(xbgr.mr_n77751856)
print v(xbgr.mr_n78378976)
print v(xbgr.mr_n78444672)
print v(xbgr.mr_n78576704)
print v(xbgr.mr_n78740928)
print v(xbgr.mr_n78851520)
print v(xbgr.mr_n78996224)
print v(xbgr.mr_n79218048)
print v(xbgr.mr_n79389312)
print v(xbgr.mr_n76643824)
print v(xbgr.mr_n76864896)
print v(xbgr.mr_n77035296)
print v(xbgr.mr_n77256352)
print v(xbgr.mr_n77363616)
print v(xbgr.mr_n76814432)
print v(xbgr.mr_n77434720)
print v(xbgr.mr_n77510144)
print v(xbgr.mr_n77644224)
print v(xbgr.mr_n77765216)
print v(xbgr.mr_n77680608)
print v(xbgr.mr_n77976928)
print v(xbgr.mr_n78105312)
print v(xbgr.mr_n78267216)
print v(xbgr.mr_n78399856)
print v(xbgr.mr_n78516976)
print v(xbgr.mr_n78678064)
print v(xbgr.mr_n78799872)
print v(xbgr.mr_n78997312)
print v(xbgr.mr_n79113216)
print v(xbgr.mr_n79220000)
print v(xbgr.mr_n79395280)
print v(xbgr.mr_n76656144)
print v(xbgr.mr_n76865488)
print v(xbgr.mr_n77035888)
print v(xbgr.mr_n77272192)
print v(xbgr.mr_n76656608)
print v(xbgr.mr_n76866080)
print v(xbgr.mr_n77036480)
print v(xbgr.mr_n77188064)
print v(xbgr.mr_n76657072)
print v(xbgr.mr_n76843584)
print v(xbgr.mr_n77037072)
print v(xbgr.mr_n77273376)
print v(xbgr.mr_n76650112)
print v(xbgr.mr_n76858384)
print v(xbgr.n_10)
print v(xbgr.mr_n77274032)
print v(xbgr.mr_n77314176)
print v(xbgr.mr_n76800816)
print v(xbgr.mr_n77431696)
print v(xbgr.mr_n77518144)
print v(xbgr.mr_n77597504)
print v(xbgr.mr_n77737392)
print v(xbgr.mr_n77850752)
print v(xbgr.mr_n77871248)
print v(xbgr.mr_n78112528)
print v(xbgr.mr_n78260496)
print v(xbgr.mr_n78393008)
print v(xbgr.mr_n78510256)
print v(xbgr.mr_n78676288)
print v(xbgr.mr_n78799696)
print v(xbgr.mr_n78795696)
print v(xbgr.mr_n79106096)
print v(xbgr.mr_n79222064)
print v(xbgr.mr_n79395504)
print v(xbgr.mr_n76340960)
print v(xbgr.mr_n79887712)
print v(xbgr.mr_n80111392)
print v(xbgr.mr_n80218720)
print v(xbgr.mr_n80420832)
print v(xbgr.mr_n80559264)
print v(xbgr.mr_n80762048)
print v(xbgr.mr_n81002048)
print v(xbgr.mr_n78115616)
print v(xbgr.mr_n81083904)
print v(xbgr.mr_n81409344)
print v(xbgr.mr_n81530976)
print v(xbgr.mr_n81706304)
print v(xbgr.mr_n81924736)
print v(xbgr.mr_n82189808)
print v(xbgr.mr_n82320240)
print v(xbgr.mr_n82543552)
print v(xbgr.mr_n82712480)
print v(xbgr.mr_n82696032)
print v(xbgr.mr_n77314288)
print v(xbgr.mr_n77367344)
print v(xbgr.mr_n76545632)
print v(xbgr.mr_n77485584)
print v(xbgr.mr_n77554864)
print v(xbgr.mr_n77682368)
print v(xbgr.mr_n77757216)
print v(xbgr.mr_n77852976)
print v(xbgr.mr_n78157488)
print v(xbgr.mr_n78399200)
print v(xbgr.mr_n78444208)
print v(xbgr.mr_n78576240)
print v(xbgr.mr_n78735504)
print v(xbgr.mr_n78851056)
print v(xbgr.mr_n78983120)
print v(xbgr.mr_n79218160)
print v(xbgr.mr_n79398048)
print v(xbgr.mr_n76658000)
print v(xbgr.mr_n76867776)
print v(xbgr.mr_n77016352)
print v(xbgr.mr_n77274624)
print v(xbgr.mr_n76646480)
print v(xbgr.mr_n76851200)
print v(xbgr.mr_n77038848)
print v(xbgr.mr_n76556688)
print v(xbgr.mr_n77365392)
print v(xbgr.mr_n76824720)
print v(xbgr.mr_n77436608)
print v(xbgr.mr_n76591968)
print v(xbgr.mr_n77643424)
print v(xbgr.mr_n77765616)
print v(xbgr.mr_n77847984)
print v(xbgr.mr_n77977904)
print v(xbgr.mr_n78114768)
print v(xbgr.mr_n78269024)
print v(xbgr.mr_n78401840)
print v(xbgr.mr_n78518784)
print v(xbgr.mr_n78678864)
print v(xbgr.mr_n78800672)
print v(xbgr.mr_n78998656)
print v(xbgr.mr_n79111520)
print v(xbgr.mr_n79215984)
print v(xbgr.mr_n79393328)
print v(xbgr.mr_n76658928)
print v(xbgr.mr_n76869040)
print v(xbgr.mr_n77039440)
print v(xbgr.mr_n76536976)
print v(xbgr.mr_n76659392)
print v(xbgr.mr_n76529440)
print v(xbgr.mr_n77040032)
print v(xbgr.mr_n77180384)
print v(xbgr.mr_n76659856)
print v(xbgr.mr_n76834864)
print v(xbgr.mr_n77040624)
print v(xbgr.mr_n77226560)
print v(xbgr.mr_n77303088)
print v(xbgr.mr_n76823712)
print v(xbgr.mr_n77152960)
print v(xbgr.mr_n77460720)
print v(xbgr.mr_n77497152)
print v(xbgr.mr_n77738576)
print v(xbgr.mr_n77848480)
print v(xbgr.mr_n77926752)
print v(xbgr.mr_n78105120)
print v(xbgr.mr_n78244352)
print v(xbgr.mr_n78401264)
print v(xbgr.mr_n78515680)
print v(xbgr.mr_n78677088)
print v(xbgr.mr_n78797296)
print v(xbgr.mr_n78882368)
print v(xbgr.mr_n79102480)
print v(xbgr.mr_n79220112)
print v(xbgr.mr_n79402512)
print v(xbgr.mr_n76652896)
print v(xbgr.mr_n76531344)
print v(xbgr.mr_n77041216)
print v(xbgr.mr_n77231104)
print v(xbgr.mr_n79294560)
print v(xbgr.mr_n79878112)
print v(xbgr.mr_n80099344)
print v(xbgr.mr_n80229952)
print v(xbgr.mr_n80468432)
print v(xbgr.mr_n80525264)
print v(xbgr.mr_n80733136)
print v(xbgr.mr_n81007024)
print v(xbgr.mr_n78130304)
print v(xbgr.mr_n81084096)
print v(xbgr.mr_n81370048)
print v(xbgr.mr_n81493344)
print v(xbgr.mr_n81673552)
print v(xbgr.mr_n81919680)
print v(xbgr.mr_n82110944)
print v(xbgr.mr_n82318464)
print v(xbgr.mr_n81637328)
print v(xbgr.mr_n82828448)
print v(xbgr.mr_n83100928)
print v(xbgr.mr_n77310416)
print v(xbgr.mr_n77369504)
print v(xbgr.mr_n76584608)
print v(xbgr.mr_n77484656)
print v(xbgr.mr_n77468816)
print v(xbgr.mr_n77681120)
print v(xbgr.mr_n77756544)
print v(xbgr.mr_n77873504)
print v(xbgr.mr_n78217536)
print v(xbgr.mr_n78291376)
print v(xbgr.mr_n78417408)
print v(xbgr.mr_n78541200)
print v(xbgr.mr_n78739056)
print v(xbgr.mr_n78800496)
print v(xbgr.mr_n78994480)
print v(xbgr.mr_n79224128)
print v(xbgr.mr_n79395392)
print v(xbgr.mr_n76660784)
print v(xbgr.mr_n76830320)
print v(xbgr.mr_n77016944)
print v(xbgr.mr_n77182144)
print v(xbgr.mr_n77366608)
print v(xbgr.mr_n76821120)
print v(xbgr.mr_n77438416)
print v(xbgr.mr_n77543408)
print v(xbgr.mr_n77625472)
print v(xbgr.mr_n77766016)
print v(xbgr.mr_n77843840)
print v(xbgr.mr_n77978544)
print v(xbgr.mr_n78113504)
print v(xbgr.mr_n78211168)
print v(xbgr.mr_n78403728)
print v(xbgr.mr_n78520592)
print v(xbgr.mr_n78679664)
print v(xbgr.mr_n78801472)
print v(xbgr.mr_n79001520)
print v(xbgr.mr_n79102368)
print v(xbgr.mr_n79222288)
print v(xbgr.mr_n79398528)
print v(xbgr.mr_n76649184)
print v(xbgr.mr_n76866256)
print v(xbgr.mr_n77042400)
print v(xbgr.mr_n77228464)
print v(xbgr.mr_n76661712)
print v(xbgr.mr_n76854832)
print v(xbgr.mr_n77042992)
print v(xbgr.mr_n77228672)
print v(xbgr.mr_n76662176)
print v(xbgr.mr_n76779408)
print v(xbgr.mr_n77043584)
print v(xbgr.mr_n77227952)
print v(xbgr.mr_n76662640)
print v(xbgr.mr_n76518176)
print v(xbgr.mr_n77044176)
print v(xbgr.mr_n77227408)
print v(xbgr.mr_n76655680)
print v(xbgr.mr_n76850624)
print v(xbgr.mr_n77044768)
print v(xbgr.mr_n77266928)
print v(xbgr.mr_n76661248)
print v(xbgr.mr_n76838368)
print v(xbgr.mr_n77026416)
print v(xbgr.mr_n77275200)
print v(xbgr.mr_n76651968)
print v(xbgr.mr_n76869600)
print v(xbgr.mr_n77045952)
print v(xbgr.mr_n77271664)
print v(xbgr.mr_n76664496)
print v(xbgr.mr_n76869712)
print v(xbgr.mr_n77046544)
print v(xbgr.mr_n77268112)
print v(xbgr.mr_n77522432)
print v(xbgr.mr_n78995296)
print v(xbgr.mr_n79226416)
print v(xbgr.mr_n79406496)
print v(xbgr.mr_n76664960)
print v(xbgr.mr_n76870496)
print v(xbgr.mr_n77047136)
print v(xbgr.mr_n77277392)
print v(xbgr.d5)
print v(xbgr.d1)
print v(xbgr.mr_n77519792)
print v(xbgr.mr_n77853200)
print v(xbgr.mr_n77366256)
print v(xbgr.mr_n77420096)
print v(xbgr.mr_n77856000)
print v(xbgr.mr_n79000688)
print v(xbgr.n1)
print v(xbgr.mr_n79406128)
print v(xbgr.mr_n76665424)
print v(xbgr.mr_n76871040)
print v(xbgr.mr_n77047728)
print v(xbgr.mr_n77278448)
print v(xbgr.mr_n78790896)
print v(xbgr.mr_n79021392)
print v(xbgr.mr_n79241408)
print v(xbgr.mr_n77307632)
print v(xbgr.mr_n77399744)
print v(xbgr.kick)
print v(xbgr.mr_n77698064)
print v(xbgr.mr_n78999168)
print v(xbgr.mr_n79168032)
print v(xbgr.mr_n79402032)
print v(xbgr.mr_n76658464)
print v(xbgr.mr_n76867200)
print v(xbgr.mr_n77048320)
print v(xbgr.mr_n77279936)
print v(xbgr.mr_n76666352)
print v(xbgr.mr_n76872800)
print v(xbgr.mr_n77029968)
print v(xbgr.mr_n77280608)
print v(xbgr.mr_n77364208)
print v(xbgr.mr_n77438928)
print v(xbgr.mr_n77495680)
print v(xbgr.mr_n77848096)
print v(xbgr.mr_n79002112)
print v(xbgr.mr_n79224240)
print v(xbgr.mr_n79406016)
print v(xbgr.mr_n77970144)
print v(xbgr.mr_n78124128)
print v(xbgr.mr_n78193984)
print v(xbgr.mr_n78255712)
print v(xbgr.mr_n78517488)
print v(xbgr.mr_n78246576)
print v(xbgr.mr_n78764368)
print v(xbgr.mr_n77977552)
print v(xbgr.mr_n78087936)
print v(xbgr.mr_n78188512)
print v(xbgr.mr_n78267728)
print v(xbgr.mr_n78519296)
print v(xbgr.mr_n78649312)
print v(xbgr.mr_n78627008)
print v(xbgr.mr_n76654752)
print v(xbgr.mr_n76873392)
print v(xbgr.mr_n77049504)
print v(xbgr.mr_n77235632)
print v(xbgr.mr_n78999280)
print v(xbgr.mr_n79167648)
print v(xbgr.mr_n79410112)
print v(xbgr.mr_n77879936)
print v(xbgr.mr_n78010032)
print v(xbgr.mr_n78116768)
print v(xbgr.mr_n78214352)
print v(xbgr.mr_n78417760)
print v(xbgr.mr_n78543904)
print v(xbgr.mr_n78671488)
print v(xbgr.mr_n78814016)
print v(xbgr.mr_n79044176)
print v(xbgr.mr_n79245472)
print v(xbgr.mr_n76667280)
print v(xbgr.mr_n76873984)
print v(xbgr.mr_n77050096)
print v(xbgr.mr_n77281792)
print v(xbgr.mr_n79000512)
print v(xbgr.mr_n79168976)
print v(xbgr.mr_n79398160)
print v(xbgr.mr_n77491616)
print v(xbgr.mr_n77973216)
print v(xbgr.d2)
print v(xbgr.mr_n78152656)
print v(xbgr.mr_n78270752)
print v(xbgr.mr_n78513872)
print v(xbgr.mr_n78611648)
print v(xbgr.mr_n78737280)
print v(xbgr.mr_n77367456)
print v(xbgr.mr_n77439040)
print v(xbgr.mr_n77855696)
print v(xbgr.mr_n76667744)
print v(xbgr.mr_n76874576)
print v(xbgr.mr_n77050688)
print v(xbgr.mr_n77282384)
print v(xbgr.mr_n77367568)
print v(xbgr.mr_n77435312)
print v(xbgr.mr_n77856512)
print v(xbgr.mr_n79003504)
print v(xbgr.mr_n79222176)
print v(xbgr.mr_n79402144)
print v(xbgr.mr_n77520304)
print v(xbgr.mr_n76668208)
print v(xbgr.mr_n76875168)
print v(xbgr.mr_n77051280)
print v(xbgr.mr_n77283568)
print v(xbgr.mr_n77308176)
print v(xbgr.mr_n77399472)
print v(xbgr.mr_n77740832)
print v(xbgr.det)
print v(xbgr.mr_n79004304)
print v(xbgr.mr_n78959824)
print v(xbgr.mr_n79410480)
print v(xbgr.mr_n77499008)
print v(xbgr.mr_n76663568)
print v(xbgr.mr_n76875760)
print v(xbgr.mr_n77051872)
print v(xbgr.mr_n77183520)
print v(xbgr.mr_n78815792)
print v(xbgr.mr_n79043712)
print v(xbgr.mr_n79247328)
print v(xbgr.mr_n77360608)
print v(xbgr.mr_n77433504)
print v(xbgr.mr_n77850944)
print v(xbgr.mr_n79002224)
print v(xbgr.mr_n79167760)
print v(xbgr.mr_n79414688)
print v(xbgr.mr_n77979152)
print v(xbgr.mr_n78125440)
print v(xbgr.mr_n78193248)
print v(xbgr.mr_n78265920)
print v(xbgr.mr_n78492816)
print v(xbgr.mr_n78642608)
print v(xbgr.mr_n78769104)
print v(xbgr.mr_n77979264)
print v(xbgr.mr_n78124016)
print v(xbgr.mr_n78193872)
print v(xbgr.mr_n78262304)
print v(xbgr.mr_n78521328)
print v(xbgr.mr_n78650128)
print v(xbgr.mr_n78773328)
print v(xbgr.mr_n76669136)
print v(xbgr.mr_n76876352)
print v(xbgr.mr_n77027600)
print v(xbgr.mr_n77287792)
print v(xbgr.mr_n77903216)
print v(xbgr.mr_n78011952)
print v(xbgr.mr_n78090976)
print v(xbgr.mr_n78218352)
print v(xbgr.mr_n78421792)
print v(xbgr.mr_n78547936)
print v(xbgr.mr_n78680208)
print v(xbgr.mr_n79005664)
print v(xbgr.mr_n79229632)
print v(xbgr.mr_n79410000)
print v(xbgr.mr_n76657536)
print v(xbgr.mr_n76532752)
print v(xbgr.mr_n77053056)
print v(xbgr.mr_n77279424)
print v(xbgr.mr_n79003392)
print v(xbgr.mr_n79172704)
print v(xbgr.mr_n79417968)
print v(xbgr.mr_n76670064)
print v(xbgr.mr_n76877536)
print v(xbgr.mr_n77053648)
print v(xbgr.mr_n77289408)
print v(xbgr.mr_n77519600)
print v(xbgr.mr_n77978816)
print v(xbgr.mr_n78129648)
print v(xbgr.mr_n78198544)
print v(xbgr.mr_n78271568)
print v(xbgr.mr_n78521824)
print v(xbgr.mr_n78607504)
print v(xbgr.mr_n78732608)
print v(xbgr.mr_n77368192)
print v(xbgr.mr_n77440000)
print v(xbgr.mr_n77857200)
print v(xbgr.mr_n78817648)
print v(xbgr.mr_n79043248)
print v(xbgr.mr_n79249184)
print v(xbgr.mr_n77368304)
print v(xbgr.mr_n77440112)
print v(xbgr.mr_n77857824)
print v(xbgr.mr_n79005776)
print v(xbgr.mr_n79171520)
print v(xbgr.mr_n79417152)
print v(xbgr.mr_n76670528)
print v(xbgr.mr_n76878128)
print v(xbgr.mr_n77054240)
print v(xbgr.mr_n77282976)
print v(xbgr.mr_n77496352)
print v(xbgr.mr_n77307904)
print v(xbgr.mr_n77399200)
print v(xbgr.mr_n77458048)
print v(xbgr.mr_n77741104)
print v(xbgr.r4n)
print v(xbgr.mr_n76670992)
print v(xbgr.mr_n76863120)
print v(xbgr.mr_n77054832)
print v(xbgr.mr_n77289744)
print v(xbgr.mr_n79006336)
print v(xbgr.mr_n79232320)
print v(xbgr.mr_n79413072)
print v(xbgr.mr_n77367840)
print v(xbgr.mr_n77440736)
print v(xbgr.mr_n77858352)
print v(xbgr.mr_n77979888)
print v(xbgr.mr_n78132128)
print v(xbgr.mr_n78193632)
print v(xbgr.mr_n78242128)
print v(xbgr.mr_n78521712)
print v(xbgr.mr_n78645904)
print v(xbgr.mr_n78768752)
print v(xbgr.mr_n77979040)
print v(xbgr.mr_n78120688)
print v(xbgr.mr_n78189168)
print v(xbgr.mr_n78271456)
print v(xbgr.mr_n78522288)
print v(xbgr.mr_n78642144)
print v(xbgr.mr_n78765072)
print v(xbgr.mr_n76664032)
print v(xbgr.mr_n76879312)
print v(xbgr.mr_n77055424)
print v(xbgr.mr_n77289856)
print v(xbgr.mr_n79006592)
print v(xbgr.mr_n79174480)
print v(xbgr.mr_n79415584)
print v(xbgr.mr_n78819504)
print v(xbgr.mr_n79042784)
print v(xbgr.mr_n79251040)
print v(xbgr.mr_n77902752)
print v(xbgr.mr_n78011424)
print v(xbgr.mr_n78093072)
print v(xbgr.mr_n78219168)
print v(xbgr.mr_n78422608)
print v(xbgr.mr_n78548752)
print v(xbgr.mr_n78680624)
print v(xbgr.mr_n76671920)
print v(xbgr.mr_n76879904)
print v(xbgr.mr_n77034112)
print v(xbgr.mr_n77289968)
print v(xbgr.mr_n79008944)
print v(xbgr.mr_n79173296)
print v(xbgr.mr_n79418144)
print v(xbgr.mr_n76660320)
print v(xbgr.mr_n76880496)
print v(xbgr.mr_n77056608)
print v(xbgr.mr_n77270480)
print v(xbgr.mr_n77518624)
print v(xbgr.mr_n77975104)
print v(xbgr.mr_n78086656)
print v(xbgr.mr_n78183152)
print v(xbgr.mr_n78271984)
print v(xbgr.mr_n78521440)
print v(xbgr.mr_n78612240)
print v(xbgr.mr_n78728400)
print v(xbgr.mr_n79009808)
print v(xbgr.mr_n79231776)
print v(xbgr.mr_n79415408)
print v(xbgr.mr_n77368928)
print v(xbgr.mr_n77440848)
print v(xbgr.mr_n77853088)
print v(xbgr.mr_n77369168)
print v(xbgr.mr_n77441216)
print v(xbgr.mr_n77859392)
print v(xbgr.mr_n76672848)
print v(xbgr.mr_n76881088)
print v(xbgr.mr_n77057200)
print v(xbgr.mr_n77290384)
print v(xbgr.mr_n79009696)
print v(xbgr.mr_n79176256)
print v(xbgr.mr_n79419712)
print v(xbgr.mr_n77513744)
print v(xbgr.mr_n77307360)
print v(xbgr.mr_n77398928)
print v(xbgr.mr_n77740640)
print v(xbgr.mr_n77457584)
print v(xbgr.mr_n78821360)
print v(xbgr.mr_n79042320)
print v(xbgr.mr_n79252896)
print v(xbgr.mr_n76673312)
print v(xbgr.mr_n76881680)
print v(xbgr.mr_n77057792)
print v(xbgr.mr_n77289632)
print v(xbgr.mr_n77496688)
print v(xbgr.mr_n79011968)
print v(xbgr.mr_n79175072)
print v(xbgr.mr_n79422272)
print v(xbgr.mr_n77368576)
print v(xbgr.mr_n77440384)
print v(xbgr.mr_n77855808)
print v(xbgr.mr_n76673776)
print v(xbgr.mr_n76882272)
print v(xbgr.mr_n77058384)
print v(xbgr.mr_n77289520)
print v(xbgr.mr_n77981024)
print v(xbgr.mr_n78132320)
print v(xbgr.mr_n78199776)
print v(xbgr.mr_n78271792)
print v(xbgr.mr_n78522912)
print v(xbgr.mr_n78639200)
print v(xbgr.mr_n78762720)
print v(xbgr.mr_n77981920)
print v(xbgr.mr_n78131936)
print v(xbgr.mr_n78184800)
print v(xbgr.mr_n78272528)
print v(xbgr.mr_n78521216)
print v(xbgr.mr_n78646720)
print v(xbgr.mr_n78769920)
print v(xbgr.mr_n79012384)
print v(xbgr.mr_n79224352)
print v(xbgr.mr_n79413184)
print v(xbgr.mr_n76666816)
print v(xbgr.mr_n76856016)
print v(xbgr.mr_n77058976)
print v(xbgr.mr_n77227200)
print v(xbgr.mr_n77902288)
print v(xbgr.mr_n78010960)
print v(xbgr.mr_n78134960)
print v(xbgr.mr_n78219904)
print v(xbgr.mr_n78423424)
print v(xbgr.mr_n78549568)
print v(xbgr.mr_n78681440)
print v(xbgr.mr_n79013312)
print v(xbgr.mr_n79175664)
print v(xbgr.mr_n79420704)
print v(xbgr.mr_n76674704)
print v(xbgr.mr_n76883392)
print v(xbgr.mr_n77034704)
print v(xbgr.mr_n77291472)
print v(xbgr.mr_n78823216)
print v(xbgr.mr_n79041872)
print v(xbgr.mr_n79254784)
print v(xbgr.mr_n77980544)
print v(xbgr.mr_n78127184)
print v(xbgr.mr_n78199440)
print v(xbgr.mr_n78272800)
print v(xbgr.mr_n78522176)
print v(xbgr.mr_n78609872)
print v(xbgr.mr_n78736160)
print v(xbgr.mr_n79014256)
print v(xbgr.mr_n79173888)
print v(xbgr.mr_n79423264)
print v(xbgr.mr_n77360432)
print v(xbgr.mr_n77442784)
print v(xbgr.d3)
print v(xbgr.mr_n77853472)
print v(xbgr.mr_n77365056)
print v(xbgr.mr_n77439536)
print v(xbgr.mr_n77681232)
print v(xbgr.mr_n77860960)
print v(xbgr.mr_n76663104)
print v(xbgr.mr_n76884048)
print v(xbgr.mr_n77060160)
print v(xbgr.mr_n77291744)
print v(xbgr.mr_n77307088)
print v(xbgr.mr_n77398656)
print v(xbgr.mr_n77478928)
print v(xbgr.mr_n77739456)
print v(xbgr.mr_n79014784)
print v(xbgr.mr_n79236128)
print v(xbgr.mr_n79420528)
print v(xbgr.mr_n76675632)
print v(xbgr.mr_n76884640)
print v(xbgr.mr_n77060752)
print v(xbgr.mr_n77292016)
print v(xbgr.mr_n79015664)
print v(xbgr.mr_n79170016)
print v(xbgr.mr_n79424832)
print v(xbgr.mr_n76676096)
print v(xbgr.mr_n76876944)
print v(xbgr.mr_n77061344)
print v(xbgr.mr_n77292688)
print v(xbgr.mr_n77364320)
print v(xbgr.mr_n77439648)
print v(xbgr.mr_n77649936)
print v(xbgr.mr_n77861488)
print v(xbgr.mr_n77980000)
print v(xbgr.mr_n78060912)
print v(xbgr.mr_n78191536)
print v(xbgr.mr_n78264112)
print v(xbgr.mr_n78400368)
print v(xbgr.mr_n78524368)
print v(xbgr.mr_n78639904)
print v(xbgr.mr_n78763904)
print v(xbgr.mr_n77983216)
print v(xbgr.mr_n78088128)
print v(xbgr.mr_n78185536)
print v(xbgr.mr_n78271680)
print v(xbgr.mr_n78385920)
print v(xbgr.mr_n78525776)
print v(xbgr.mr_n78642496)
print v(xbgr.mr_n78764256)
print v(xbgr.mr_n78825072)
print v(xbgr.mr_n79041408)
print v(xbgr.mr_n79257152)
print v(xbgr.mr_n79010688)
print v(xbgr.mr_n79172112)
print v(xbgr.mr_n79425824)
print v(xbgr.mr_n76676560)
print v(xbgr.mr_n76885824)
print v(xbgr.mr_n77061936)
print v(xbgr.mr_n77290080)
print v(xbgr.mr_n77901824)
print v(xbgr.mr_n78010496)
print v(xbgr.mr_n78135776)
print v(xbgr.mr_n78219440)
print v(xbgr.mr_n78296080)
print v(xbgr.mr_n78424240)
print v(xbgr.mr_n78550384)
print v(xbgr.mr_n78682256)
print v(xbgr.mr_n76669600)
print v(xbgr.mr_n76886416)
print v(xbgr.mr_n77062528)
print v(xbgr.mr_n77281200)
print v(xbgr.mr_n79014896)
print v(xbgr.mr_n79237216)
print v(xbgr.mr_n79423088)
print v(xbgr.mr_n77984368)
print v(xbgr.mr_n78080096)
print v(xbgr.mr_n78187856)
print v(xbgr.mr_n78269536)
print v(xbgr.mr_n78404576)
print v(xbgr.mr_n78521104)
print v(xbgr.mr_n78611056)
print v(xbgr.mr_n78721888)
print v(xbgr.mr_n77364880)
print v(xbgr.mr_n77444352)
print v(xbgr.mr_n77675152)
print v(xbgr.mr_n77856848)
print v(xbgr.mr_n77362752)
print v(xbgr.mr_n77443472)
print v(xbgr.mr_n77681456)
print v(xbgr.mr_n77858704)
print v(xbgr.mr_n76675168)
print v(xbgr.mr_n76780368)
print v(xbgr.mr_n77038256)
print v(xbgr.mr_n77293888)
print v(xbgr.mr_n79002416)
print v(xbgr.mr_n79167536)
print v(xbgr.mr_n79430768)
print v(xbgr.mr_n78826000)
print v(xbgr.mr_n79040944)
print v(xbgr.mr_n79258336)
print v(xbgr.mr_n76665888)
print v(xbgr.mr_n76887600)
print v(xbgr.mr_n77063712)
print v(xbgr.mr_n77290192)
print v(xbgr.mr_n77306816)
print v(xbgr.mr_n77398384)
print v(xbgr.mr_n77465552)
print v(xbgr.mr_n77738272)
print v(xbgr.mr_n79018368)
print v(xbgr.mr_n79076544)
print v(xbgr.mr_n79428384)
print v(xbgr.mr_n76678416)
print v(xbgr.mr_n76888192)
print v(xbgr.mr_n77064304)
print v(xbgr.mr_n77295088)
print v(xbgr.mr_n77359216)
print v(xbgr.mr_n77439152)
print v(xbgr.mr_n77651296)
print v(xbgr.mr_n77860272)
print v(xbgr.mr_n79019216)
print v(xbgr.mr_n79240480)
print v(xbgr.mr_n79425648)
print v(xbgr.mr_n77981200)
print v(xbgr.mr_n78096880)
print v(xbgr.mr_n78185760)
print v(xbgr.mr_n78274144)
print v(xbgr.mr_n78404352)
print v(xbgr.mr_n78526656)
print v(xbgr.mr_n78635792)
print v(xbgr.mr_n78754880)
print v(xbgr.mr_n77981552)
print v(xbgr.mr_n78118576)
print v(xbgr.mr_n78193056)
print v(xbgr.mr_n78271344)
print v(xbgr.mr_n78405536)
print v(xbgr.mr_n78523024)
print v(xbgr.mr_n78643312)
print v(xbgr.mr_n78761696)
print v(xbgr.mr_n76678880)
print v(xbgr.mr_n76866672)
print v(xbgr.mr_n77064896)
print v(xbgr.mr_n77291200)
print v(xbgr.mr_n79020032)
print v(xbgr.mr_n79167424)
print v(xbgr.mr_n79429952)
print v(xbgr.mr_n77901360)
print v(xbgr.mr_n78009568)
print v(xbgr.mr_n78136784)
print v(xbgr.mr_n78218896)
print v(xbgr.mr_n78298544)
print v(xbgr.mr_n78425056)
print v(xbgr.mr_n78551200)
print v(xbgr.mr_n78683072)
print v(xbgr.mr_n78825536)
print v(xbgr.mr_n79040480)
print v(xbgr.mr_n79257744)
print v(xbgr.mr_n76679344)
print v(xbgr.mr_n76889376)
print v(xbgr.mr_n77059568)
print v(xbgr.mr_n77290656)
print v(xbgr.mr_n79018192)
print v(xbgr.mr_n79164608)
print v(xbgr.mr_n79432512)
print v(xbgr.mr_n77983712)
print v(xbgr.mr_n78116992)
print v(xbgr.mr_n78186880)
print v(xbgr.mr_n78274576)
print v(xbgr.mr_n78402432)
print v(xbgr.mr_n78529440)
print v(xbgr.mr_n78610464)
print v(xbgr.mr_n78734384)
print v(xbgr.mr_n76672384)
print v(xbgr.mr_n76889968)
print v(xbgr.mr_n77066080)
print v(xbgr.mr_n77296208)
print v(xbgr.mr_n77363184)
print v(xbgr.mr_n77445920)
print v(xbgr.mr_n77600768)
print v(xbgr.mr_n77862528)
print v(xbgr.mr_n77361904)
print v(xbgr.mr_n77446608)
print v(xbgr.mr_n77673392)
print v(xbgr.mr_n77864096)
print v(xbgr.mr_n79021504)
print v(xbgr.mr_n79240864)
print v(xbgr.mr_n79430944)
print v(xbgr.mr_n76680272)
print v(xbgr.mr_n76890560)
print v(xbgr.mr_n77041808)
print v(xbgr.mr_n77297088)
print v(xbgr.mr_n77306544)
print v(xbgr.mr_n77398112)
print v(xbgr.mr_n77181504)
print v(xbgr.mr_n77737088)
print v(xbgr.mr_n79019776)
print v(xbgr.mr_n79078416)
print v(xbgr.mr_n79428208)
print v(xbgr.mr_n76668672)
print v(xbgr.mr_n76891152)
print v(xbgr.mr_n77067264)
print v(xbgr.mr_n77290928)
print v(xbgr.mr_n78824608)
print v(xbgr.mr_n79040016)
print v(xbgr.mr_n79256560)
print v(xbgr.mr_n77361728)
print v(xbgr.mr_n77442432)
print v(xbgr.mr_n77651024)
print v(xbgr.mr_n77864624)
print v(xbgr.mr_n77982720)
print v(xbgr.mr_n78071392)
print v(xbgr.mr_n78185984)
print v(xbgr.mr_n78275264)
print v(xbgr.mr_n78405424)
print v(xbgr.mr_n78527776)
print v(xbgr.mr_n78638672)
print v(xbgr.mr_n78758288)
print v(xbgr.mr_n79020976)
print v(xbgr.mr_n79165200)
print v(xbgr.mr_n79433504)
print v(xbgr.mr_n77986384)
print v(xbgr.mr_n78083584)
print v(xbgr.mr_n78185424)
print v(xbgr.mr_n78273152)
print v(xbgr.mr_n78406448)
print v(xbgr.mr_n78525088)
print v(xbgr.mr_n78639088)
print v(xbgr.mr_n78763072)
print v(xbgr.mr_n76681200)
print v(xbgr.mr_n76891744)
print v(xbgr.mr_n77067856)
print v(xbgr.mr_n77293488)
print v(xbgr.mr_n77900896)
print v(xbgr.mr_n78009104)
print v(xbgr.mr_n78137248)
print v(xbgr.mr_n78218624)
print v(xbgr.mr_n78299360)
print v(xbgr.mr_n78425872)
print v(xbgr.mr_n78552016)
print v(xbgr.mr_n78683888)
print v(xbgr.mr_n76647792)
print v(xbgr.mr_n76892336)
print v(xbgr.mr_n77068448)
print v(xbgr.mr_n77298288)
print v(xbgr.mr_n79023536)
print v(xbgr.mr_n79235584)
print v(xbgr.mr_n79369616)
print v(xbgr.mr_n79022384)
print v(xbgr.mr_n79082976)
print v(xbgr.mr_n79427392)
print v(xbgr.mr_n76635472)
print v(xbgr.mr_n76892928)
print v(xbgr.mr_n77002464)
print v(xbgr.mr_n77295888)
print v(xbgr.mr_n77987536)
print v(xbgr.mr_n77998352)
print v(xbgr.mr_n78186416)
print v(xbgr.mr_n78277968)
print v(xbgr.mr_n78405968)
print v(xbgr.mr_n78528320)
print v(xbgr.mr_n78606320)
print v(xbgr.mr_n78731952)
print v(xbgr.mr_n77361296)
print v(xbgr.mr_n77447488)
print v(xbgr.mr_n77678544)
print v(xbgr.mr_n77859920)
print v(xbgr.mr_n77359392)
print v(xbgr.mr_n77443936)
print v(xbgr.mr_n77637136)
print v(xbgr.mr_n77861840)
print v(xbgr.mr_n78824144)
print v(xbgr.mr_n79039552)
print v(xbgr.mr_n79255968)
print v(xbgr.mr_n79025408)
print v(xbgr.mr_n78960176)
print v(xbgr.mr_n79369376)
print v(xbgr.mr_n76646928)
print v(xbgr.mr_n76893520)
print v(xbgr.mr_n76924752)
print v(xbgr.mr_n77294688)
print v(xbgr.mr_n77306272)
print v(xbgr.mr_n77397840)
print v(xbgr.mr_n76536720)
print v(xbgr.mr_n77735904)
print v(xbgr.mr_n76639184)
print v(xbgr.mr_n76894112)
print v(xbgr.mr_n77001280)
print v(xbgr.mr_n77299888)
print v(xbgr.mr_n79025824)
print v(xbgr.mr_n79239392)
print v(xbgr.mr_n79436064)
print v(xbgr.mr_n77358784)
print v(xbgr.mr_n77445504)
print v(xbgr.mr_n77650752)
print v(xbgr.mr_n77863408)
print v(xbgr.mr_n77985424)
print v(xbgr.mr_n78128560)
print v(xbgr.mr_n78202384)
print v(xbgr.mr_n78276928)
print v(xbgr.mr_n78408032)
print v(xbgr.mr_n78527088)
print v(xbgr.mr_n78632384)
print v(xbgr.mr_n78664768)
print v(xbgr.mr_n76646080)
print v(xbgr.mr_n76894704)
print v(xbgr.mr_n77000688)
print v(xbgr.mr_n77300288)
print v(xbgr.mr_n77984720)
print v(xbgr.mr_n78088880)
print v(xbgr.mr_n78185872)
print v(xbgr.mr_n78279968)
print v(xbgr.mr_n78406624)
print v(xbgr.mr_n78532480)
print v(xbgr.mr_n78635680)
print v(xbgr.mr_n78761968)
print v(xbgr.mr_n79025936)
print v(xbgr.mr_n79166976)
print v(xbgr.mr_n79437632)
print v(xbgr.mr_n78823680)
print v(xbgr.mr_n79039088)
print v(xbgr.mr_n79255376)
print v(xbgr.mr_n76645616)
print v(xbgr.mr_n76895296)
print v(xbgr.mr_n77000096)
print v(xbgr.mr_n77300688)
print v(xbgr.mr_n77900432)
print v(xbgr.mr_n78008176)
print v(xbgr.mr_n78136320)
print v(xbgr.mr_n78218080)
print v(xbgr.mr_n78300176)
print v(xbgr.mr_n78425600)
print v(xbgr.mr_n78551744)
print v(xbgr.mr_n78683616)
print v(xbgr.mr_n79024464)
print v(xbgr.mr_n79085008)
print v(xbgr.mr_n79352384)
print v(xbgr.mr_n76645216)
print v(xbgr.mr_n76895888)
print v(xbgr.mr_n76999504)
print v(xbgr.mr_n77301088)
print v(xbgr.mr_n77985776)
print v(xbgr.mr_n78115728)
print v(xbgr.mr_n78204528)
print v(xbgr.mr_n78281632)
print v(xbgr.mr_n78409792)
print v(xbgr.mr_n78534080)
print v(xbgr.mr_n78609280)
print v(xbgr.mr_n78730832)
print v(xbgr.mr_n77359568)
print v(xbgr.mr_n77449056)
print v(xbgr.mr_n77680064)
print v(xbgr.mr_n77862992)
print v(xbgr.mr_n79024208)
print v(xbgr.mr_n79238848)
print v(xbgr.mr_n79433328)
print v(xbgr.mr_n77355584)
print v(xbgr.mr_n77448176)
print v(xbgr.mr_n77638672)
print v(xbgr.mr_n77865664)
print v(xbgr.mr_n76632688)
print v(xbgr.mr_n76896480)
print v(xbgr.mr_n76997600)
print v(xbgr.mr_n77297488)
print v(xbgr.mr_n79026496)
print v(xbgr.mr_n79164016)
print v(xbgr.mr_n79364336)
print v(xbgr.mr_n77306000)
print v(xbgr.mr_n77397648)
print v(xbgr.mr_n77465808)
print v(xbgr.mr_n77734720)
print v(xbgr.mr_n76644288)
print v(xbgr.mr_n76882864)
print v(xbgr.mr_n77073392)
print v(xbgr.mr_n77138704)
print v(xbgr.mr_n78822752)
print v(xbgr.mr_n79038624)
print v(xbgr.mr_n79254288)
print v(xbgr.mr_n79022720)
print v(xbgr.mr_n78958480)
print v(xbgr.mr_n79357856)
print v(xbgr.mr_n77357328)
print v(xbgr.mr_n77448640)
print v(xbgr.mr_n77607040)
print v(xbgr.mr_n77867696)
print v(xbgr.mr_n76636400)
print v(xbgr.mr_n76897600)
print v(xbgr.mr_n77074832)
print v(xbgr.mr_n77138112)
print v(xbgr.mr_n77985088)
print v(xbgr.mr_n78085344)
print v(xbgr.mr_n78187232)
print v(xbgr.mr_n78277280)
print v(xbgr.mr_n78406976)
print v(xbgr.mr_n78531792)
print v(xbgr.mr_n78636496)
print v(xbgr.mr_n78761168)
print v(xbgr.mr_n77987360)
print v(xbgr.mr_n78115392)
print v(xbgr.mr_n78205312)
print v(xbgr.mr_n78282672)
print v(xbgr.mr_n78410512)
print v(xbgr.mr_n78533648)
print v(xbgr.mr_n78635264)
print v(xbgr.mr_n78752176)
print v(xbgr.mr_n79023648)
print v(xbgr.mr_n79237760)
print v(xbgr.mr_n79435888)
print v(xbgr.mr_n76643360)
print v(xbgr.mr_n76898256)
print v(xbgr.mr_n77056016)
print v(xbgr.mr_n77137520)
print v(xbgr.mr_n77899968)
print v(xbgr.mr_n78007712)
print v(xbgr.mr_n78136048)
print v(xbgr.mr_n78217808)
print v(xbgr.mr_n78300992)
print v(xbgr.mr_n78425328)
print v(xbgr.mr_n78551472)
print v(xbgr.mr_n78683344)
print v(xbgr.mr_n79017760)
print v(xbgr.mr_n79166384)
print v(xbgr.mr_n79353696)
print v(xbgr.mr_n76642896)
print v(xbgr.mr_n76898848)
print v(xbgr.mr_n77076432)
print v(xbgr.mr_n77136928)
print v(xbgr.mr_n78822288)
print v(xbgr.mr_n79038160)
print v(xbgr.mr_n79253824)
print v(xbgr.mr_n77982608)
print v(xbgr.mr_n78095008)
print v(xbgr.mr_n78203680)
print v(xbgr.mr_n78278848)
print v(xbgr.mr_n78409056)
print v(xbgr.mr_n78533168)
print v(xbgr.mr_n78608688)
print v(xbgr.mr_n78730176)
print v(xbgr.mr_n77351216)
print v(xbgr.mr_n77450624)
print v(xbgr.mr_n77679456)
print v(xbgr.mr_n77866128)
print v(xbgr.mr_n79016000)
print v(xbgr.mr_n79165792)
print v(xbgr.mr_n79316112)
print v(xbgr.mr_n77356144)
print v(xbgr.mr_n77449744)
print v(xbgr.mr_n77680240)
print v(xbgr.mr_n77867232)
print v(xbgr.mr_n76642432)
print v(xbgr.mr_n76899440)
print v(xbgr.mr_n77077232)
print v(xbgr.mr_n77136336)
print v(xbgr.mr_n77305728)
print v(xbgr.mr_n77396896)
print v(xbgr.mr_n77464592)
print v(xbgr.mr_n77733536)
print v(xbgr.mr_n76629904)
print v(xbgr.mr_n76900032)
print v(xbgr.mr_n77077632)
print v(xbgr.mr_n77135744)
print v(xbgr.mr_n79019104)
print v(xbgr.mr_n79356736)
print v(xbgr.mr_n76641504)
print v(xbgr.mr_n76900624)
print v(xbgr.mr_n77078832)
print v(xbgr.mr_n77135152)
print v(xbgr.mr_n79017008)
print v(xbgr.mr_n79357264)
print v(xbgr.mr_n77357936)
print v(xbgr.mr_n77450208)
print v(xbgr.mr_n77649632)
print v(xbgr.mr_n77869264)
print v(xbgr.mr_n77973040)
print v(xbgr.mr_n77959712)
print v(xbgr.mr_n78203120)
print v(xbgr.mr_n78273392)
print v(xbgr.mr_n78408640)
print v(xbgr.mr_n78529792)
print v(xbgr.mr_n78629152)
print v(xbgr.mr_n78758176)
print v(xbgr.mr_n77984192)
print v(xbgr.mr_n78104256)
print v(xbgr.mr_n78206864)
print v(xbgr.mr_n78284656)
print v(xbgr.mr_n78411808)
print v(xbgr.mr_n78537184)
print v(xbgr.mr_n78632272)
print v(xbgr.mr_n78751472)
print v(xbgr.mr_n78821824)
print v(xbgr.mr_n79253360)
print v(xbgr.mr_n76635936)
print v(xbgr.mr_n76901216)
print v(xbgr.mr_n77071296)
print v(xbgr.mr_n77134560)
print v(xbgr.mr_n79017184)
print v(xbgr.mr_n79359904)
print v(xbgr.mr_n77899504)
print v(xbgr.mr_n78006784)
print v(xbgr.mr_n78135504)
print v(xbgr.mr_n78217264)
print v(xbgr.mr_n78301536)
print v(xbgr.mr_n78424784)
print v(xbgr.mr_n78550928)
print v(xbgr.mr_n78682800)
print v(xbgr.mr_n76640576)
print v(xbgr.mr_n76885232)
print v(xbgr.mr_n77080432)
print v(xbgr.mr_n77133968)
print v(xbgr.mr_n79011024)
print v(xbgr.mr_n79356352)
print v(xbgr.mr_n77982256)
print v(xbgr.mr_n77951056)
print v(xbgr.mr_n78208208)
print v(xbgr.mr_n78286320)
print v(xbgr.mr_n78410144)
print v(xbgr.mr_n78538784)
print v(xbgr.mr_n78608096)
print v(xbgr.mr_n78727280)
print v(xbgr.mr_n77354784)
print v(xbgr.mr_n77452192)
print v(xbgr.mr_n77677520)
print v(xbgr.mr_n77864976)
print v(xbgr.mr_n76640112)
print v(xbgr.mr_n76902400)
print v(xbgr.mr_n77081232)
print v(xbgr.mr_n77133376)
print v(xbgr.mr_n77357760)
print v(xbgr.mr_n77451312)
print v(xbgr.mr_n77675936)
print v(xbgr.mr_n77868800)
print v(xbgr.mr_n79014672)
print v(xbgr.mr_n79339856)
print v(xbgr.mr_n78820896)
print v(xbgr.mr_n79252432)
print v(xbgr.mr_n76639648)
print v(xbgr.mr_n76902992)
print v(xbgr.mr_n77081632)
print v(xbgr.mr_n77132720)
print v(xbgr.mr_n77305456)
print v(xbgr.mr_n77394784)
print v(xbgr.mr_n77481488)
print v(xbgr.mr_n77732352)
print v(xbgr.mr_n79013056)
print v(xbgr.mr_n79336992)
print v(xbgr.mr_n76627120)
print v(xbgr.mr_n76871920)
print v(xbgr.mr_n77075232)
print v(xbgr.mr_n77086432)
print v(xbgr.mr_n77356320)
print v(xbgr.mr_n77451696)
print v(xbgr.mr_n77649520)
print v(xbgr.mr_n77868112)
print v(xbgr.mr_n77980112)
print v(xbgr.mr_n78091808)
print v(xbgr.mr_n78206560)
print v(xbgr.mr_n78281984)
print v(xbgr.mr_n78412784)
print v(xbgr.mr_n78539888)
print v(xbgr.mr_n78631856)
print v(xbgr.mr_n78757760)
print v(xbgr.mr_n79012496)
print v(xbgr.mr_n79356960)
print v(xbgr.mr_n77975536)
print v(xbgr.mr_n78083072)
print v(xbgr.mr_n78207840)
print v(xbgr.mr_n78287360)
print v(xbgr.mr_n78413744)
print v(xbgr.mr_n78538352)
print v(xbgr.mr_n78612832)
print v(xbgr.mr_n78739888)
print v(xbgr.mr_n76638720)
print v(xbgr.mr_n76904176)
print v(xbgr.mr_n77076032)
print v(xbgr.mr_n77131600)
print v(xbgr.mr_n79007408)
print v(xbgr.mr_n79363504)
print v(xbgr.mr_n77899040)
print v(xbgr.mr_n78006320)
print v(xbgr.mr_n78135232)
print v(xbgr.mr_n78216992)
print v(xbgr.mr_n78301264)
print v(xbgr.mr_n78424512)
print v(xbgr.mr_n78550656)
print v(xbgr.mr_n78682528)
print v(xbgr.mr_n76630832)
print v(xbgr.mr_n76904768)
print v(xbgr.mr_n77084432)
print v(xbgr.mr_n77115616)
print v(xbgr.mr_n78820432)
print v(xbgr.mr_n79251968)
print v(xbgr.mr_n79008016)
print v(xbgr.mr_n79435072)
print v(xbgr.mr_n76637792)
print v(xbgr.mr_n76905360)
print v(xbgr.mr_n77084832)
print v(xbgr.mr_n77130416)
print v(xbgr.mr_n77979536)
print v(xbgr.mr_n78076880)
print v(xbgr.mr_n78209056)
print v(xbgr.mr_n78285344)
print v(xbgr.mr_n78412304)
print v(xbgr.mr_n78536064)
print v(xbgr.mr_n78605728)
print v(xbgr.mr_n78724848)
print v(xbgr.mr_n77352960)
print v(xbgr.mr_n77453760)
print v(xbgr.mr_n77676976)
print v(xbgr.mr_n77870368)
print v(xbgr.mr_n77348864)
print v(xbgr.mr_n77454448)
print v(xbgr.mr_n77677696)
print v(xbgr.mr_n77871936)
print v(xbgr.mr_n79009920)
print v(xbgr.mr_n79236672)
print v(xbgr.mr_n79355536)
print v(xbgr.mr_n76637328)
print v(xbgr.mr_n76905952)
print v(xbgr.mr_n77085632)
print v(xbgr.mr_n77129824)
print v(xbgr.mr_n77305184)
print v(xbgr.mr_n77393728)
print v(xbgr.mr_n77146880)
print v(xbgr.mr_n77731168)
print v(xbgr.mr_n79009120)
print v(xbgr.mr_n79163424)
print v(xbgr.mr_n79355360)
print v(xbgr.mr_n76636864)
print v(xbgr.mr_n76887008)
print v(xbgr.mr_n77086832)
print v(xbgr.mr_n77129232)
print v(xbgr.mr_n78819968)
print v(xbgr.mr_n79037696)
print v(xbgr.mr_n79251504)
print v(xbgr.mr_n77353568)
print v(xbgr.mr_n77453344)
print v(xbgr.mr_n77649744)
print v(xbgr.mr_n77872464)
print v(xbgr.mr_n77976752)
print v(xbgr.mr_n78085536)
print v(xbgr.mr_n78209872)
print v(xbgr.mr_n78288240)
print v(xbgr.mr_n78411312)
print v(xbgr.mr_n78540768)
print v(xbgr.mr_n78631424)
print v(xbgr.mr_n78754768)
print v(xbgr.mr_n79007840)
print v(xbgr.mr_n79162832)
print v(xbgr.mr_n79440560)
print v(xbgr.mr_n77978928)
print v(xbgr.mr_n78118272)
print v(xbgr.mr_n78204880)
print v(xbgr.mr_n78283184)
print v(xbgr.mr_n78415744)
print v(xbgr.mr_n78536496)
print v(xbgr.mr_n78633088)
print v(xbgr.mr_n78758992)
print v(xbgr.mr_n76486352)
print v(xbgr.mr_n76907072)
print v(xbgr.mr_n77082032)
print v(xbgr.mr_n77128640)
print v(xbgr.mr_n77898576)
print v(xbgr.mr_n78005392)
print v(xbgr.mr_n78134688)
print v(xbgr.mr_n78216720)
print v(xbgr.mr_n78300720)
print v(xbgr.mr_n78423968)
print v(xbgr.mr_n78550112)
print v(xbgr.mr_n78681984)
print v(xbgr.mr_n76633616)
print v(xbgr.mr_n76903584)
print v(xbgr.mr_n77088432)
print v(xbgr.mr_n77127984)
print v(xbgr.mr_n79003968)
print v(xbgr.mr_n79233952)
print v(xbgr.mr_n79438800)
print v(xbgr.mr_n76628048)
print v(xbgr.mr_n76908256)
print v(xbgr.mr_n77089088)
print v(xbgr.mr_n77048912)
print v(xbgr.mr_n79005248)
print v(xbgr.mr_n79162240)
print v(xbgr.mr_n79438576)
print v(xbgr.mr_n77977728)
print v(xbgr.mr_n78102256)
print v(xbgr.mr_n78208624)
print v(xbgr.mr_n78286672)
print v(xbgr.mr_n78415056)
print v(xbgr.mr_n78543552)
print v(xbgr.mr_n78602256)
print v(xbgr.mr_n78729056)
print v(xbgr.mr_n77348304)
print v(xbgr.mr_n77455328)
print v(xbgr.mr_n77674976)
print v(xbgr.mr_n77866544)
print v(xbgr.mr_n77354608)
print v(xbgr.mr_n77456016)
print v(xbgr.mr_n77676480)
print v(xbgr.mr_n77869680)
print v(xbgr.mr_n78819040)
print v(xbgr.mr_n79037232)
print v(xbgr.mr_n79250576)
print v(xbgr.mr_n76635008)
print v(xbgr.mr_n76908912)
print v(xbgr.mr_n77090864)
print v(xbgr.mr_n77126864)
print v(xbgr.mr_n78997824)
print v(xbgr.mr_n79161648)
print v(xbgr.mr_n79443984)
print v(xbgr.mr_n77304912)
print v(xbgr.mr_n77367120)
print v(xbgr.mr_n77516320)
print v(xbgr.mr_n77729984)
print v(xbgr.mr_n76634544)
print v(xbgr.mr_n76909504)
print v(xbgr.mr_n77092048)
print v(xbgr.mr_n77126272)
print v(xbgr.mr_n79003616)
print v(xbgr.mr_n79235040)
print v(xbgr.mr_n79438688)
print v(xbgr.mr_n77351104)
print v(xbgr.mr_n77447136)
print v(xbgr.mr_n77649296)
print v(xbgr.mr_n77843952)
print v(xbgr.mr_n76634080)
print v(xbgr.mr_n76910096)
print v(xbgr.mr_n77083232)
print v(xbgr.mr_n77125680)
print v(xbgr.mr_n77975712)
print v(xbgr.mr_n78122784)
print v(xbgr.mr_n78211584)
print v(xbgr.mr_n78292064)
print v(xbgr.mr_n78413312)
print v(xbgr.mr_n78539200)
print v(xbgr.mr_n78627504)
print v(xbgr.mr_n78755584)
print v(xbgr.mr_n77969968)
print v(xbgr.mr_n78121968)
print v(xbgr.mr_n78212800)
print v(xbgr.mr_n78290528)
print v(xbgr.mr_n78418448)
print v(xbgr.mr_n78544592)
print v(xbgr.mr_n78627392)
print v(xbgr.mr_n78754416)
print v(xbgr.mr_n79002880)
print v(xbgr.mr_n79160704)
print v(xbgr.mr_n79441296)
print v(xbgr.mr_n78818576)
print v(xbgr.mr_n79036768)
print v(xbgr.mr_n79250112)
print v(xbgr.mr_n76624352)
print v(xbgr.mr_n76910688)
print v(xbgr.mr_n77084032)
print v(xbgr.mr_n77125088)
print v(xbgr.mr_n77898112)
print v(xbgr.mr_n78004928)
print v(xbgr.mr_n78134416)
print v(xbgr.mr_n78216448)
print v(xbgr.mr_n78300448)
print v(xbgr.mr_n78423696)
print v(xbgr.mr_n78549840)
print v(xbgr.mr_n78681712)
print v(xbgr.mr_n79002768)
print v(xbgr.mr_n79159872)
print v(xbgr.mr_n79446896)
print v(xbgr.mr_n76633152)
print v(xbgr.mr_n76911280)
print v(xbgr.mr_n77094352)
print v(xbgr.mr_n77124496)
print v(xbgr.mr_n77971184)
print v(xbgr.mr_n78077200)
print v(xbgr.mr_n78207488)
print v(xbgr.mr_n78289984)
print v(xbgr.mr_n78416432)
print v(xbgr.mr_n78537872)
print v(xbgr.mr_n78584416)
print v(xbgr.mr_n78726624)
print v(xbgr.mr_n77352208)
print v(xbgr.mr_n77456896)
print v(xbgr.mr_n77670912)
print v(xbgr.mr_n77848208)
print v(xbgr.mr_n77353392)
print v(xbgr.mr_n77452880)
print v(xbgr.mr_n77674368)
print v(xbgr.mr_n77850640)
print v(xbgr.mr_n79000944)
print v(xbgr.mr_n79234496)
print v(xbgr.mr_n79441184)
print v(xbgr.mr_n76577376)
print v(xbgr.mr_n76911872)
print v(xbgr.mr_n77079632)
print v(xbgr.mr_n77123904)
print v(xbgr.mr_n78999392)
print v(xbgr.mr_n79149872)
print v(xbgr.mr_n79445328)
print v(xbgr.mr_n77304640)
print v(xbgr.mr_n77392848)
print v(xbgr.mr_n77539952)
print v(xbgr.mr_n77728800)
print v(xbgr.mr_n76632224)
print v(xbgr.mr_n76912464)
print v(xbgr.mr_n77091456)
print v(xbgr.mr_n77123248)
print v(xbgr.mr_n78818112)
print v(xbgr.mr_n79036304)
print v(xbgr.mr_n79249648)
print v(xbgr.mr_n78998320)
print v(xbgr.mr_n79158096)
print v(xbgr.mr_n79449456)
print v(xbgr.mr_n76631760)
print v(xbgr.mr_n76913056)
print v(xbgr.mr_n77090272)
print v(xbgr.mr_n77093824)
print v(xbgr.mr_n77351952)
print v(xbgr.mr_n77454976)
print v(xbgr.mr_n77634384)
print v(xbgr.mr_n77840832)
print v(xbgr.mr_n77973840)
print v(xbgr.mr_n78062576)
print v(xbgr.mr_n78213616)
print v(xbgr.mr_n78292944)
print v(xbgr.mr_n78420448)
print v(xbgr.mr_n78541888)
print v(xbgr.mr_n78625504)
print v(xbgr.mr_n78742816)
print v(xbgr.mr_n77972336)
print v(xbgr.mr_n78105792)
print v(xbgr.mr_n78210304)
print v(xbgr.mr_n78288672)
print v(xbgr.mr_n78414272)
print v(xbgr.mr_n78546592)
print v(xbgr.mr_n78627616)
print v(xbgr.mr_n78748064)
print v(xbgr.mr_n76631296)
print v(xbgr.mr_n76901808)
print v(xbgr.mr_n77089680)
print v(xbgr.mr_n77122128)
print v(xbgr.mr_n78996720)
print v(xbgr.mr_n79233408)
print v(xbgr.mr_n79447888)
print v(xbgr.mr_n77897648)
print v(xbgr.mr_n78004000)
print v(xbgr.mr_n78092800)
print v(xbgr.mr_n78216176)
print v(xbgr.mr_n78299904)
print v(xbgr.mr_n78423152)
print v(xbgr.mr_n78549296)
print v(xbgr.mr_n78681168)
print v(xbgr.mr_n78993296)
print v(xbgr.mr_n79152768)
print v(xbgr.mr_n79452832)
print v(xbgr.mr_n76485440)
print v(xbgr.mr_n76914240)
print v(xbgr.mr_n77082432)
print v(xbgr.mr_n77121536)
print v(xbgr.mr_n78817184)
print v(xbgr.mr_n79035840)
print v(xbgr.mr_n79248720)
print v(xbgr.mr_n77974016)
print v(xbgr.mr_n78081920)
print v(xbgr.mr_n78213264)
print v(xbgr.mr_n78295664)
print v(xbgr.mr_n78418976)
print v(xbgr.mr_n78545120)
print v(xbgr.mr_n78602768)
print v(xbgr.mr_n78649424)
print v(xbgr.mr_n77347504)
print v(xbgr.mr_n77458464)
print v(xbgr.mr_n77672608)
print v(xbgr.mr_n77836176)
print v(xbgr.mr_n77351776)
print v(xbgr.mr_n77459152)
print v(xbgr.mr_n77672432)
print v(xbgr.mr_n77838368)
print v(xbgr.mr_n78992128)
print v(xbgr.mr_n79160528)
print v(xbgr.mr_n79452016)
print v(xbgr.mr_n76630368)
print v(xbgr.mr_n76914832)
print v(xbgr.mr_n77087632)
print v(xbgr.mr_n77120944)
print v(xbgr.mr_n77304368)
print v(xbgr.mr_n77391616)
print v(xbgr.mr_n65462464)
print v(xbgr.mr_n77727616)
print v(xbgr.mr_n76485552)
print v(xbgr.mr_n76915424)
print v(xbgr.mr_n77079232)
print v(xbgr.mr_n77120352)
print v(xbgr.mr_n78996896)
print v(xbgr.mr_n79232864)
print v(xbgr.mr_n79447712)
print v(xbgr.mr_n76629440)
print v(xbgr.mr_n76916016)
print v(xbgr.mr_n77086032)
print v(xbgr.mr_n77119760)
print v(xbgr.mr_n78993472)
print v(xbgr.mr_n79118640)
print v(xbgr.mr_n79450448)
print v(xbgr.mr_n77350416)
print v(xbgr.mr_n77445040)
print v(xbgr.mr_n77649408)
print v(xbgr.mr_n77840640)
print v(xbgr.mr_n77968848)
print v(xbgr.mr_n78130576)
print v(xbgr.mr_n78210608)
print v(xbgr.mr_n78293376)
print v(xbgr.mr_n78411200)
print v(xbgr.mr_n78543056)
print v(xbgr.mr_n78625152)
print v(xbgr.mr_n78750944)
print v(xbgr.mr_n77972160)
print v(xbgr.mr_n78064848)
print v(xbgr.mr_n78206128)
print v(xbgr.mr_n78295232)
print v(xbgr.mr_n78416912)
print v(xbgr.mr_n78534496)
print v(xbgr.mr_n78625616)
print v(xbgr.mr_n78751360)
print v(xbgr.mr_n78816720)
print v(xbgr.mr_n79035376)
print v(xbgr.mr_n79248256)
print v(xbgr.mr_n76628976)
print v(xbgr.mr_n76916608)
print v(xbgr.mr_n77085232)
print v(xbgr.mr_n77119168)
print v(xbgr.mr_n78994592)
print v(xbgr.mr_n79158752)
print v(xbgr.mr_n79453008)
print v(xbgr.mr_n77897184)
print v(xbgr.mr_n78003536)
print v(xbgr.mr_n78092368)
print v(xbgr.mr_n78215904)
print v(xbgr.mr_n78299632)
print v(xbgr.mr_n78422880)
print v(xbgr.mr_n78549024)
print v(xbgr.mr_n78680896)
print v(xbgr.mr_n76628512)
print v(xbgr.mr_n76917200)
print v(xbgr.mr_n77074432)
print v(xbgr.mr_n77118576)
print v(xbgr.mr_n78992736)
print v(xbgr.mr_n79230688)
print v(xbgr.mr_n79450272)
print v(xbgr.mr_n77963072)
print v(xbgr.mr_n78097360)
print v(xbgr.mr_n78209456)
print v(xbgr.mr_n78283536)
print v(xbgr.mr_n78412960)
print v(xbgr.mr_n78540416)
print v(xbgr.mr_n78605136)
print v(xbgr.mr_n78678688)
print v(xbgr.mr_n76491520)
print v(xbgr.mr_n76917792)
print v(xbgr.mr_n77083632)
print v(xbgr.mr_n77117984)
print v(xbgr.mr_n77350240)
print v(xbgr.mr_n77460032)
print v(xbgr.mr_n77652576)
print v(xbgr.mr_n77828256)
print v(xbgr.mr_n77349040)
print v(xbgr.mr_n77456544)
print v(xbgr.mr_n77671824)
print v(xbgr.mr_n77836064)
print v(xbgr.mr_n78990336)
print v(xbgr.mr_n79156320)
print v(xbgr.mr_n79457952)
print v(xbgr.mr_n76627584)
print v(xbgr.mr_n76907728)
print v(xbgr.mr_n77082832)
print v(xbgr.mr_n77117392)
print v(xbgr.mr_n78816256)
print v(xbgr.mr_n79034912)
print v(xbgr.mr_n79247792)
print v(xbgr.mr_n77304096)
print v(xbgr.mr_n77372720)
print v(xbgr.mr_n77285856)
print v(xbgr.mr_n77726432)
print v(xbgr.mr_n78989392)
print v(xbgr.mr_n79156976)
print v(xbgr.mr_n79457136)
print v(xbgr.mr_n76492448)
print v(xbgr.mr_n76918976)
print v(xbgr.mr_n77080032)
print v(xbgr.mr_n77116800)
print v(xbgr.mr_n77347328)
print v(xbgr.mr_n77459680)
print v(xbgr.mr_n77631616)
print v(xbgr.mr_n77837984)
print v(xbgr.mr_n77969536)
print v(xbgr.mr_n78065136)
print v(xbgr.mr_n78202816)
print v(xbgr.mr_n78294064)
print v(xbgr.mr_n78408144)
print v(xbgr.mr_n78535648)
print v(xbgr.mr_n78240400)
print v(xbgr.mr_n78743200)
print v(xbgr.mr_n77964560)
print v(xbgr.mr_n78081776)
print v(xbgr.mr_n78201696)
print v(xbgr.mr_n78292592)
print v(xbgr.mr_n78407344)
print v(xbgr.mr_n78535184)
print v(xbgr.mr_n78614608)
print v(xbgr.mr_n78747952)
print v(xbgr.mr_n78990512)
print v(xbgr.mr_n79231232)
print v(xbgr.mr_n79455568)
print v(xbgr.mr_n76626656)
print v(xbgr.mr_n76919568)
print v(xbgr.mr_n77080832)
print v(xbgr.mr_n77116144)
print v(xbgr.mr_n78989504)
print v(xbgr.mr_n79154544)
print v(xbgr.mr_n79445152)
print v(xbgr.mr_n77896720)
print v(xbgr.mr_n78002608)
print v(xbgr.mr_n78090704)
print v(xbgr.mr_n78215632)
print v(xbgr.mr_n78299088)
print v(xbgr.mr_n78422336)
print v(xbgr.mr_n78548480)
print v(xbgr.mr_n78680432)
print v(xbgr.mr_n76624544)
print v(xbgr.mr_n76888784)
print v(xbgr.mr_n77070832)
print v(xbgr.mr_n77092640)
print v(xbgr.mr_n78815328)
print v(xbgr.mr_n79034448)
print v(xbgr.mr_n79246864)
print v(xbgr.mr_n78796496)
print v(xbgr.mr_n79155200)
print v(xbgr.mr_n79459696)
print v(xbgr.mr_n76493376)
print v(xbgr.mr_n76847136)
print v(xbgr.mr_n77073056)
print v(xbgr.mr_n77114960)
print v(xbgr.mr_n77968672)
print v(xbgr.mr_n78086464)
print v(xbgr.mr_n78205776)
print v(xbgr.mr_n78290960)
print v(xbgr.mr_n78410848)
print v(xbgr.mr_n78531360)
print v(xbgr.mr_n78604544)
print v(xbgr.mr_n78725504)
print v(xbgr.mr_n77346464)
print v(xbgr.mr_n77439264)
print v(xbgr.mr_n77669888)
print v(xbgr.mr_n77826064)
print v(xbgr.mr_n77348192)
print v(xbgr.mr_n77442192)
print v(xbgr.mr_n77668368)
print v(xbgr.mr_n77832384)
print v(xbgr.mr_n76492848)
print v(xbgr.mr_n76854240)
print v(xbgr.mr_n77078432)
print v(xbgr.mr_n77088032)
print v(xbgr.mr_n78985840)
print v(xbgr.mr_n79230144)
print v(xbgr.mr_n79458128)
print v(xbgr.mr_n77303824)
print v(xbgr.mr_n77369856)
print v(xbgr.mr_n77097120)
print v(xbgr.mr_n77725568)
print v(xbgr.mr_n76485664)
print v(xbgr.mr_n76853648)
print v(xbgr.mr_n77078032)
print v(xbgr.mr_n77113840)
print v(xbgr.mr_n78988784)
print v(xbgr.mr_n79115136)
print v(xbgr.mr_n79455392)
print v(xbgr.mr_n78814864)
print v(xbgr.mr_n79033984)
print v(xbgr.mr_n79246400)
print v(xbgr.mr_n77344832)
print v(xbgr.mr_n77437120)
print v(xbgr.mr_n77628240)
print v(xbgr.mr_n77822928)
print v(xbgr.mr_n77955920)
print v(xbgr.mr_n78084448)
print v(xbgr.mr_n78201968)
print v(xbgr.mr_n78289360)
print v(xbgr.mr_n78405312)
print v(xbgr.mr_n78523888)
print v(xbgr.mr_n78626320)
print v(xbgr.mr_n78747536)
print v(xbgr.mr_n76491920)
print v(xbgr.mr_n76853056)
print v(xbgr.mr_n77076832)
print v(xbgr.mr_n77113248)
print v(xbgr.mr_n77966816)
print v(xbgr.mr_n78046752)
print v(xbgr.mr_n78204096)
print v(xbgr.mr_n78287888)
print v(xbgr.mr_n78409616)
print v(xbgr.mr_n78530480)
print v(xbgr.mr_n78624176)
print v(xbgr.mr_n78742624)
print v(xbgr.mr_n78987328)
print v(xbgr.mr_n79153424)
print v(xbgr.mr_n79462256)
print v(xbgr.mr_n76485776)
print v(xbgr.mr_n76852464)
print v(xbgr.mr_n77072800)
print v(xbgr.mr_n77112656)
print v(xbgr.mr_n77896256)
print v(xbgr.mr_n78002144)
print v(xbgr.mr_n78090512)
print v(xbgr.mr_n78215440)
print v(xbgr.mr_n78298816)
print v(xbgr.mr_n78422064)
print v(xbgr.mr_n78548208)
print v(xbgr.mr_n78680320)
print v(xbgr.mr_n78985504)
print v(xbgr.mr_n79228256)
print v(xbgr.mr_n79454576)
print v(xbgr.mr_n76491056)
print v(xbgr.mr_n76787456)
print v(xbgr.mr_n77075632)
print v(xbgr.mr_n77112064)
print v(xbgr.mr_n78984736)
print v(xbgr.mr_n79150992)
print v(xbgr.mr_n79460688)
print v(xbgr.mr_n77967872)
print v(xbgr.mr_n78104592)
print v(xbgr.mr_n78185312)
print v(xbgr.d4)
print v(xbgr.mr_n78407680)
print v(xbgr.mr_n78530944)
print v(xbgr.mr_n78547280)
print v(xbgr.mr_n78721376)
print v(xbgr.mr_n77336864)
print v(xbgr.mr_n77429888)
print v(xbgr.mr_n77669344)
print v(xbgr.mr_n77823200)
print v(xbgr.mr_n77346288)
print v(xbgr.mr_n77428080)
print v(xbgr.mr_n77670064)
print v(xbgr.mr_n77831120)
print v(xbgr.mr_n78814400)
print v(xbgr.mr_n79033520)
print v(xbgr.mr_n79245936)
print v(xbgr.mr_n76490592)
print v(xbgr.mr_n76839232)
print v(xbgr.mr_n77045360)
print v(xbgr.mr_n77111472)
print v(xbgr.mr_n78978928)
print v(xbgr.mr_n79151648)
print v(xbgr.mr_n79464816)
print v(xbgr.mr_n77301888)
print v(xbgr.mr_n77366432)
print v(xbgr.mr_n76740944)
print v(xbgr.mr_n77724768)
print v(xbgr.mr_n76490128)
print v(xbgr.mr_n76841808)
print v(xbgr.mr_n77074032)
print v(xbgr.mr_n77109792)
print v(xbgr.mr_n78984560)
print v(xbgr.mr_n78958896)
print v(xbgr.mr_n79463248)
print v(xbgr.mr_n77339440)
print v(xbgr.mr_n76506832)
print v(xbgr.mr_n77619328)
print v(xbgr.mr_n77827760)
print v(xbgr.mr_n76489664)
print v(xbgr.mr_n76849504)
print v(xbgr.mr_n76960576)
print v(xbgr.mr_n77297888)
print v(xbgr.mr_n77967168)
print v(xbgr.mr_n78062192)
print v(xbgr.mr_n78186768)
print v(xbgr.mr_n78280656)
print v(xbgr.mr_n78390048)
print v(xbgr.mr_n78524672)
print v(xbgr.mr_n78615200)
print v(xbgr.mr_n78743008)
print v(xbgr.mr_n77966992)
print v(xbgr.mr_n78066000)
print v(xbgr.mr_n78188048)
print v(xbgr.mr_n78285824)
print v(xbgr.mr_n78404848)
print v(xbgr.mr_n78528944)
print v(xbgr.mr_n78606912)
print v(xbgr.mr_n78748768)
print v(xbgr.mr_n78980960)
print v(xbgr.mr_n79149344)
print v(xbgr.mr_n79460512)
print v(xbgr.mr_n76489200)
print v(xbgr.mr_n76848256)
print v(xbgr.mr_n76918384)
print v(xbgr.mr_n77294288)
print v(xbgr.mr_n78813712)
print v(xbgr.mr_n79033056)
print v(xbgr.mr_n79245008)
print v(xbgr.mr_n77895792)
print v(xbgr.mr_n78001216)
print v(xbgr.mr_n78084640)
print v(xbgr.mr_n78215328)
print v(xbgr.mr_n78298272)
print v(xbgr.mr_n78421600)
print v(xbgr.mr_n78547744)
print v(xbgr.mr_n78680096)
print v(xbgr.mr_n78981632)
print v(xbgr.mr_n79111408)
print v(xbgr.mr_n79465808)
print v(xbgr.mr_n76488736)
print v(xbgr.mr_n76786736)
print v(xbgr.mr_n76959392)
print v(xbgr.mr_n77302688)
print v(xbgr.mr_n77962736)
print v(xbgr.mr_n78089584)
print v(xbgr.mr_n78185648)
print v(xbgr.mr_n78279280)
print v(xbgr.mr_n78404960)
print v(xbgr.mr_n78526304)
print v(xbgr.mr_n78545472)
print v(xbgr.mr_n78723728)
print v(xbgr.mr_n77344656)
print v(xbgr.mr_n77650208)
print v(xbgr.mr_n77807568)
print v(xbgr.mr_n77346112)
print v(xbgr.mr_n77668848)
print v(xbgr.mr_n77825952)
print v(xbgr.mr_n78980032)
print v(xbgr.mr_n79226192)
print v(xbgr.mr_n79463072)
print v(xbgr.mr_n76486624)
print v(xbgr.mr_n76846544)
print v(xbgr.mr_n76920160)
print v(xbgr.mr_n77293088)
print v(xbgr.mr_n76525808)
print v(xbgr.mr_n76822704)
print v(xbgr.mr_n78972704)
print v(xbgr.mr_n79147952)
print v(xbgr.mr_n79467376)
print v(xbgr.mr_n77298688)
print v(xbgr.mr_n77400016)
print v(xbgr.mr_n77501072)
print v(xbgr.mr_n77698320)
print v(xbgr.mr_n76684560)
print v(xbgr.n_23)
print v(xbgr.mr_n76958208)
print v(xbgr.mr_n77301488)
print v(xbgr.mr_n77409696)
print v(xbgr.mr_n78813408)
print v(xbgr.mr_n79032512)
print v(xbgr.mr_n79244624)
print v(xbgr.mr_n78978816)
print v(xbgr.mr_n79148416)
print v(xbgr.mr_n79469936)
print v(xbgr.n_12)
print v(xbgr.n_25)
print v(xbgr.mr_n76958800)
print v(xbgr.mr_n77295488)
print v(xbgr.mr_n77339136)
print v(xbgr.mr_n77629568)
print v(xbgr.mr_n77806080)
print v(xbgr.mr_n77965616)
print v(xbgr.mr_n78113392)
print v(xbgr.mr_n78188624)
print v(xbgr.mr_n78275888)
print v(xbgr.mr_n78398304)
print v(xbgr.mr_n78523392)
print v(xbgr.mr_n78613424)
print v(xbgr.mr_n78743952)
print v(xbgr.mr_n77958720)
print v(xbgr.mr_n78131056)
print v(xbgr.mr_n78200800)
print v(xbgr.mr_n78281136)
print v(xbgr.mr_n78404464)
print v(xbgr.mr_n78414624)
print v(xbgr.mr_n78624656)
print v(xbgr.mr_n78737936)
print v(xbgr.mr_n76683824)
print v(xbgr.mr_n76786128)
print v(xbgr.mr_n76957024)
print v(xbgr.mr_n77296688)
print v(xbgr.mr_n78975872)
print v(xbgr.mr_n79228368)
print v(xbgr.mr_n79465632)
print v(xbgr.mr_n77895328)
print v(xbgr.mr_n78000832)
print v(xbgr.mr_n78099920)
print v(xbgr.mr_n78212368)
print v(xbgr.mr_n78298080)
print v(xbgr.mr_n78421488)
print v(xbgr.mr_n78547632)
print v(xbgr.mr_n78672288)
print v(xbgr.n_17)
print v(xbgr.n_22)
print v(xbgr.mr_n76957616)
print v(xbgr.mr_n77275088)
print v(xbgr.mr_n78976368)
print v(xbgr.mr_n79146560)
print v(xbgr.mr_n79468368)
print v(xbgr.mr_n78813104)
print v(xbgr.mr_n78961856)
print v(xbgr.mr_n79244320)
print v(xbgr.mr_n77964736)
print v(xbgr.mr_n78121696)
print v(xbgr.mr_n78183792)
print v(xbgr.mr_n78278432)
print v(xbgr.mr_n78404240)
print v(xbgr.mr_n78522560)
print v(xbgr.mr_n78602432)
print v(xbgr.mr_n78721552)
print v(xbgr.mr_n77334144)
print v(xbgr.mr_n77666736)
print v(xbgr.mr_n77817968)
print v(xbgr.n_18)
print v(xbgr.mr_n76784688)
print v(xbgr.mr_n76955840)
print v(xbgr.mr_n77292288)
print v(xbgr.mr_n77339248)
print v(xbgr.mr_n77667520)
print v(xbgr.mr_n77685744)
print v(xbgr.mr_n78977968)
print v(xbgr.mr_n79147024)
print v(xbgr.mr_n79472496)
print v(xbgr.mr_n76501248)
print v(xbgr.mr_n76510304)
print v(xbgr.mr_n76681776)
print v(xbgr.mr_n76783968)
print v(xbgr.mr_n76956432)
print v(xbgr.mr_n77277072)
print v(xbgr.mr_n77303488)
print v(xbgr.mr_n76826736)
print v(xbgr.mr_n77222128)
print v(xbgr.mr_n77700544)
print v(xbgr.mr_n78975184)
print v(xbgr.mr_n79226304)
print v(xbgr.mr_n79470928)
print v(xbgr.mr_n76594336)
print v(xbgr.mr_n76674240)
print v(xbgr.mr_n76783248)
print v(xbgr.mr_n76955248)
print v(xbgr.mr_n77276544)
print v(xbgr.mr_n77331120)
print v(xbgr.mr_n77613184)
print v(xbgr.mr_n77806640)
print v(xbgr.mr_n78957952)
print v(xbgr.mr_n79120560)
print v(xbgr.mr_n79468192)
print v(xbgr.mr_n77958544)
print v(xbgr.mr_n78047744)
print v(xbgr.mr_n78200048)
print v(xbgr.mr_n78276432)
print v(xbgr.mr_n78383856)
print v(xbgr.mr_n78508448)
print v(xbgr.mr_n78614016)
print v(xbgr.mr_n78739712)
print v(xbgr.mr_n77959376)
print v(xbgr.mr_n78048800)
print v(xbgr.mr_n78194096)
print v(xbgr.mr_n78273728)
print v(xbgr.mr_n78397136)
print v(xbgr.mr_n78512064)
print v(xbgr.mr_n78622448)
print v(xbgr.mr_n78742272)
print v(xbgr.mr_n78794096)
print v(xbgr.mr_n79028176)
print v(xbgr.mr_n79238304)
print v(xbgr.mr_n76677024)
print v(xbgr.mr_n76782528)
print v(xbgr.mr_n76953344)
print v(xbgr.mr_n77272848)
print v(xbgr.mr_n78967568)
print v(xbgr.mr_n79120448)
print v(xbgr.mr_n79473488)
print v(xbgr.mr_n77894864)
print v(xbgr.mr_n77988592)
print v(xbgr.mr_n78121472)
print v(xbgr.mr_n78214048)
print v(xbgr.mr_n78297232)
print v(xbgr.mr_n78419760)
print v(xbgr.mr_n78545904)
print v(xbgr.mr_n78679488)
print v(xbgr.mr_n78972032)
print v(xbgr.mr_n79228480)
print v(xbgr.mr_n79470752)
print v(xbgr.mr_n76818992)
print v(xbgr.mr_n77956576)
print v(xbgr.mr_n77986880)
print v(xbgr.mr_n78185136)
print v(xbgr.mr_n78272416)
print v(xbgr.mr_n78392112)
print v(xbgr.mr_n78506640)
print v(xbgr.mr_n78542512)
print v(xbgr.mr_n78675488)
print v(xbgr.mr_n77329456)
print v(xbgr.mr_n77652176)
print v(xbgr.mr_n77806336)
print v(xbgr.mr_n77340192)
print v(xbgr.mr_n77651840)
print v(xbgr.mr_n77813248)
print v(xbgr.mr_n78965600)
print v(xbgr.mr_n79116832)
print v(xbgr.mr_n79475056)
print v(xbgr.mr_n76596464)
print v(xbgr.mr_n78798896)
print v(xbgr.mr_n79028000)
print v(xbgr.mr_n79243584)
print v(xbgr.mr_n77299088)
print v(xbgr.mr_n76827744)
print v(xbgr.mr_n77468064)
print v(xbgr.mr_n77681344)
print v(xbgr.mr_n76528736)
print v(xbgr.mr_n78859744)
print v(xbgr.mr_n79115024)
print v(xbgr.mr_n79476048)
print v(xbgr.mr_n77336112)
print v(xbgr.mr_n77635712)
print v(xbgr.mr_n77739760)
print v(dvbe)
print v(iptat)
print v(pbias)
print v(pcasc)
print v(r4)
print v(vbe)
print v(vdd)
print v(vref)
print v(vdd)-v(vdd)
echo METALLIC_POINT_VOLTAGES_END
echo METALLIC_ALL_NODE_VOLTAGES_BEGIN
print v(xbgr.b1b)
print v(xbgr.c2)
print v(xbgr.d1)
print v(xbgr.d2)
print v(xbgr.d3)
print v(xbgr.d4)
print v(xbgr.d5)
print v(xbgr.det)
print v(dvbe)
print v(iptat)
print v(xbgr.kick)
print v(xbgr.mr_n63358432)
print v(xbgr.mr_n63404048)
print v(xbgr.mr_n65462464)
print v(xbgr.mr_n65871232)
print v(xbgr.mr_n65883056)
print v(xbgr.mr_n66765904)
print v(xbgr.mr_n66766016)
print v(xbgr.mr_n66768752)
print v(xbgr.mr_n66768864)
print v(xbgr.mr_n66769280)
print v(xbgr.mr_n66769392)
print v(xbgr.mr_n66769712)
print v(xbgr.mr_n66769824)
print v(xbgr.mr_n66770256)
print v(xbgr.mr_n66770496)
print v(xbgr.mr_n66770608)
print v(xbgr.mr_n66770960)
print v(xbgr.mr_n66771280)
print v(xbgr.mr_n66771392)
print v(xbgr.mr_n66771824)
print v(xbgr.mr_n66772144)
print v(xbgr.mr_n66772256)
print v(xbgr.mr_n66772688)
print v(xbgr.mr_n66773008)
print v(xbgr.mr_n66773120)
print v(xbgr.mr_n66773552)
print v(xbgr.mr_n66773872)
print v(xbgr.mr_n66773984)
print v(xbgr.mr_n66774416)
print v(xbgr.mr_n66774736)
print v(xbgr.mr_n66774848)
print v(xbgr.mr_n66775280)
print v(xbgr.mr_n66775600)
print v(xbgr.mr_n66775712)
print v(xbgr.mr_n66776144)
print v(xbgr.mr_n66776464)
print v(xbgr.mr_n66776576)
print v(xbgr.mr_n66777008)
print v(xbgr.mr_n66777328)
print v(xbgr.mr_n66777440)
print v(xbgr.mr_n66777872)
print v(xbgr.mr_n66778192)
print v(xbgr.mr_n66778304)
print v(xbgr.mr_n66778736)
print v(xbgr.mr_n66779056)
print v(xbgr.mr_n66779168)
print v(xbgr.mr_n66779600)
print v(xbgr.mr_n66779920)
print v(xbgr.mr_n66780032)
print v(xbgr.mr_n66780464)
print v(xbgr.mr_n66780784)
print v(xbgr.mr_n66780896)
print v(xbgr.mr_n66781328)
print v(xbgr.mr_n66781648)
print v(xbgr.mr_n66781760)
print v(xbgr.mr_n66782192)
print v(xbgr.mr_n66782512)
print v(xbgr.mr_n66782624)
print v(xbgr.mr_n66783056)
print v(xbgr.mr_n66783376)
print v(xbgr.mr_n66783488)
print v(xbgr.mr_n66783920)
print v(xbgr.mr_n66784240)
print v(xbgr.mr_n66784352)
print v(xbgr.mr_n66784672)
print v(xbgr.mr_n66784784)
print v(xbgr.mr_n66785104)
print v(xbgr.mr_n66785216)
print v(xbgr.mr_n66785536)
print v(xbgr.mr_n66785648)
print v(xbgr.mr_n66785968)
print v(xbgr.mr_n66786080)
print v(xbgr.mr_n66786400)
print v(xbgr.mr_n66786512)
print v(xbgr.mr_n66786832)
print v(xbgr.mr_n66786944)
print v(xbgr.mr_n66787264)
print v(xbgr.mr_n66787376)
print v(xbgr.mr_n66787696)
print v(xbgr.mr_n66787808)
print v(xbgr.mr_n66788128)
print v(xbgr.mr_n66788240)
print v(xbgr.mr_n66788560)
print v(xbgr.mr_n66788672)
print v(xbgr.mr_n66788992)
print v(xbgr.mr_n66789104)
print v(xbgr.mr_n66789424)
print v(xbgr.mr_n66789536)
print v(xbgr.mr_n66789856)
print v(xbgr.mr_n66789968)
print v(xbgr.mr_n66790288)
print v(xbgr.mr_n66790400)
print v(xbgr.mr_n66790720)
print v(xbgr.mr_n66790832)
print v(xbgr.mr_n66791152)
print v(xbgr.mr_n66791264)
print v(xbgr.mr_n66791584)
print v(xbgr.mr_n66791696)
print v(xbgr.mr_n66792016)
print v(xbgr.mr_n66792128)
print v(xbgr.mr_n66792448)
print v(xbgr.mr_n66792560)
print v(xbgr.mr_n66792880)
print v(xbgr.mr_n66792992)
print v(xbgr.mr_n66793312)
print v(xbgr.mr_n66793424)
print v(xbgr.mr_n66793744)
print v(xbgr.mr_n66793856)
print v(xbgr.mr_n66794176)
print v(xbgr.mr_n66794288)
print v(xbgr.mr_n66794608)
print v(xbgr.mr_n66794720)
print v(xbgr.mr_n66795040)
print v(xbgr.mr_n66795152)
print v(xbgr.mr_n66795472)
print v(xbgr.mr_n66795584)
print v(xbgr.mr_n66795904)
print v(xbgr.mr_n66796016)
print v(xbgr.mr_n66796336)
print v(xbgr.mr_n66796448)
print v(xbgr.mr_n66796768)
print v(xbgr.mr_n66796880)
print v(xbgr.mr_n66797200)
print v(xbgr.mr_n66797312)
print v(xbgr.mr_n66797632)
print v(xbgr.mr_n66797744)
print v(xbgr.mr_n66798064)
print v(xbgr.mr_n66798176)
print v(xbgr.mr_n66798496)
print v(xbgr.mr_n66798608)
print v(xbgr.mr_n66798928)
print v(xbgr.mr_n66799040)
print v(xbgr.mr_n66799360)
print v(xbgr.mr_n66799472)
print v(xbgr.mr_n66799792)
print v(xbgr.mr_n66799904)
print v(xbgr.mr_n66800032)
print v(xbgr.mr_n66800144)
print v(xbgr.mr_n66800464)
print v(xbgr.mr_n66800576)
print v(xbgr.mr_n66800896)
print v(xbgr.mr_n66801008)
print v(xbgr.mr_n66801328)
print v(xbgr.mr_n66801440)
print v(xbgr.mr_n66801760)
print v(xbgr.mr_n66801872)
print v(xbgr.mr_n66802192)
print v(xbgr.mr_n66802304)
print v(xbgr.mr_n66802624)
print v(xbgr.mr_n66802736)
print v(xbgr.mr_n66803056)
print v(xbgr.mr_n66803168)
print v(xbgr.mr_n66803488)
print v(xbgr.mr_n66803600)
print v(xbgr.mr_n66803920)
print v(xbgr.mr_n66804032)
print v(xbgr.mr_n66804352)
print v(xbgr.mr_n66804464)
print v(xbgr.mr_n66804784)
print v(xbgr.mr_n66804896)
print v(xbgr.mr_n66805216)
print v(xbgr.mr_n66805328)
print v(xbgr.mr_n66805648)
print v(xbgr.mr_n66805760)
print v(xbgr.mr_n66806080)
print v(xbgr.mr_n66806192)
print v(xbgr.mr_n66806512)
print v(xbgr.mr_n66806624)
print v(xbgr.mr_n66806944)
print v(xbgr.mr_n66807056)
print v(xbgr.mr_n66807376)
print v(xbgr.mr_n66807488)
print v(xbgr.mr_n66807808)
print v(xbgr.mr_n66807920)
print v(xbgr.mr_n66808240)
print v(xbgr.mr_n66808352)
print v(xbgr.mr_n66808672)
print v(xbgr.mr_n66808784)
print v(xbgr.mr_n66809104)
print v(xbgr.mr_n66809216)
print v(xbgr.mr_n66809536)
print v(xbgr.mr_n66809648)
print v(xbgr.mr_n66809968)
print v(xbgr.mr_n66810080)
print v(xbgr.mr_n66810400)
print v(xbgr.mr_n66810512)
print v(xbgr.mr_n66810832)
print v(xbgr.mr_n66810944)
print v(xbgr.mr_n66811264)
print v(xbgr.mr_n66811376)
print v(xbgr.mr_n66811696)
print v(xbgr.mr_n66811808)
print v(xbgr.mr_n66812128)
print v(xbgr.mr_n66812240)
print v(xbgr.mr_n66812560)
print v(xbgr.mr_n66812672)
print v(xbgr.mr_n66812992)
print v(xbgr.mr_n66813104)
print v(xbgr.mr_n66813424)
print v(xbgr.mr_n66813536)
print v(xbgr.mr_n66813856)
print v(xbgr.mr_n66813968)
print v(xbgr.mr_n66814288)
print v(xbgr.mr_n66814400)
print v(xbgr.mr_n66814720)
print v(xbgr.mr_n66814832)
print v(xbgr.mr_n66815152)
print v(xbgr.mr_n66815264)
print v(xbgr.mr_n66815584)
print v(xbgr.mr_n66815696)
print v(xbgr.mr_n66816016)
print v(xbgr.mr_n66816128)
print v(xbgr.mr_n66816448)
print v(xbgr.mr_n66816560)
print v(xbgr.mr_n66816880)
print v(xbgr.mr_n66816992)
print v(xbgr.mr_n66817312)
print v(xbgr.mr_n66817424)
print v(xbgr.mr_n66817744)
print v(xbgr.mr_n66817856)
print v(xbgr.mr_n66818176)
print v(xbgr.mr_n66818288)
print v(xbgr.mr_n66818608)
print v(xbgr.mr_n66818720)
print v(xbgr.mr_n66819040)
print v(xbgr.mr_n66819152)
print v(xbgr.mr_n66819472)
print v(xbgr.mr_n66819584)
print v(xbgr.mr_n66819904)
print v(xbgr.mr_n66820016)
print v(xbgr.mr_n66820336)
print v(xbgr.mr_n66820448)
print v(xbgr.mr_n66820768)
print v(xbgr.mr_n66820880)
print v(xbgr.mr_n66821200)
print v(xbgr.mr_n66821312)
print v(xbgr.mr_n66821632)
print v(xbgr.mr_n66821744)
print v(xbgr.mr_n66822064)
print v(xbgr.mr_n66822176)
print v(xbgr.mr_n66822496)
print v(xbgr.mr_n66822608)
print v(xbgr.mr_n66822928)
print v(xbgr.mr_n66823040)
print v(xbgr.mr_n66823360)
print v(xbgr.mr_n66823472)
print v(xbgr.mr_n66823792)
print v(xbgr.mr_n66823904)
print v(xbgr.mr_n66824224)
print v(xbgr.mr_n66824336)
print v(xbgr.mr_n66824656)
print v(xbgr.mr_n66824768)
print v(xbgr.mr_n66825088)
print v(xbgr.mr_n66825200)
print v(xbgr.mr_n66825520)
print v(xbgr.mr_n66825632)
print v(xbgr.mr_n66825952)
print v(xbgr.mr_n66826064)
print v(xbgr.mr_n66826384)
print v(xbgr.mr_n66826496)
print v(xbgr.mr_n66826816)
print v(xbgr.mr_n66826928)
print v(xbgr.mr_n66827248)
print v(xbgr.mr_n66827360)
print v(xbgr.mr_n66827680)
print v(xbgr.mr_n66827792)
print v(xbgr.mr_n66828112)
print v(xbgr.mr_n66828224)
print v(xbgr.mr_n66828544)
print v(xbgr.mr_n66828656)
print v(xbgr.mr_n66828976)
print v(xbgr.mr_n66829088)
print v(xbgr.mr_n66829408)
print v(xbgr.mr_n66829520)
print v(xbgr.mr_n66829840)
print v(xbgr.mr_n66829952)
print v(xbgr.mr_n66830272)
print v(xbgr.mr_n66830384)
print v(xbgr.mr_n66830704)
print v(xbgr.mr_n66830816)
print v(xbgr.mr_n66831136)
print v(xbgr.mr_n66831248)
print v(xbgr.mr_n66831568)
print v(xbgr.mr_n66831680)
print v(xbgr.mr_n66832000)
print v(xbgr.mr_n66832112)
print v(xbgr.mr_n66832432)
print v(xbgr.mr_n66832544)
print v(xbgr.mr_n66832864)
print v(xbgr.mr_n66832976)
print v(xbgr.mr_n66833296)
print v(xbgr.mr_n66833408)
print v(xbgr.mr_n66833728)
print v(xbgr.mr_n66833840)
print v(xbgr.mr_n66834160)
print v(xbgr.mr_n66834272)
print v(xbgr.mr_n66834592)
print v(xbgr.mr_n66834704)
print v(xbgr.mr_n66835024)
print v(xbgr.mr_n66835136)
print v(xbgr.mr_n66835456)
print v(xbgr.mr_n66835568)
print v(xbgr.mr_n66836112)
print v(xbgr.mr_n66836224)
print v(xbgr.mr_n66836544)
print v(xbgr.mr_n66836656)
print v(xbgr.mr_n66836976)
print v(xbgr.mr_n66837088)
print v(xbgr.mr_n66837408)
print v(xbgr.mr_n66837520)
print v(xbgr.mr_n66837840)
print v(xbgr.mr_n66837952)
print v(xbgr.mr_n66838272)
print v(xbgr.mr_n66838384)
print v(xbgr.mr_n66838704)
print v(xbgr.mr_n66838816)
print v(xbgr.mr_n66839136)
print v(xbgr.mr_n66839248)
print v(xbgr.mr_n66839568)
print v(xbgr.mr_n66839680)
print v(xbgr.mr_n66840000)
print v(xbgr.mr_n66840112)
print v(xbgr.mr_n66840432)
print v(xbgr.mr_n66840544)
print v(xbgr.mr_n66840864)
print v(xbgr.mr_n66840976)
print v(xbgr.mr_n66841296)
print v(xbgr.mr_n66841408)
print v(xbgr.mr_n66841728)
print v(xbgr.mr_n66841840)
print v(xbgr.mr_n66842160)
print v(xbgr.mr_n66842272)
print v(xbgr.mr_n66842592)
print v(xbgr.mr_n66842704)
print v(xbgr.mr_n66843024)
print v(xbgr.mr_n66843136)
print v(xbgr.mr_n66843456)
print v(xbgr.mr_n66843568)
print v(xbgr.mr_n66843888)
print v(xbgr.mr_n66844000)
print v(xbgr.mr_n66844320)
print v(xbgr.mr_n66844432)
print v(xbgr.mr_n66844752)
print v(xbgr.mr_n66844864)
print v(xbgr.mr_n66845184)
print v(xbgr.mr_n66845296)
print v(xbgr.mr_n66845616)
print v(xbgr.mr_n66845728)
print v(xbgr.mr_n66846048)
print v(xbgr.mr_n66846160)
print v(xbgr.mr_n66846480)
print v(xbgr.mr_n66846592)
print v(xbgr.mr_n66846912)
print v(xbgr.mr_n66847024)
print v(xbgr.mr_n66847344)
print v(xbgr.mr_n66847456)
print v(xbgr.mr_n66847776)
print v(xbgr.mr_n66847888)
print v(xbgr.mr_n66848208)
print v(xbgr.mr_n66848320)
print v(xbgr.mr_n66848640)
print v(xbgr.mr_n66848752)
print v(xbgr.mr_n66849072)
print v(xbgr.mr_n66849184)
print v(xbgr.mr_n66849504)
print v(xbgr.mr_n66849616)
print v(xbgr.mr_n66849936)
print v(xbgr.mr_n66850048)
print v(xbgr.mr_n66850368)
print v(xbgr.mr_n66850480)
print v(xbgr.mr_n66850800)
print v(xbgr.mr_n66850912)
print v(xbgr.mr_n66851232)
print v(xbgr.mr_n66851344)
print v(xbgr.mr_n66851664)
print v(xbgr.mr_n66851776)
print v(xbgr.mr_n66852096)
print v(xbgr.mr_n66852208)
print v(xbgr.mr_n66852528)
print v(xbgr.mr_n66852640)
print v(xbgr.mr_n66852960)
print v(xbgr.mr_n66853072)
print v(xbgr.mr_n66853392)
print v(xbgr.mr_n66853504)
print v(xbgr.mr_n66853824)
print v(xbgr.mr_n66853936)
print v(xbgr.mr_n66854256)
print v(xbgr.mr_n66854368)
print v(xbgr.mr_n66854688)
print v(xbgr.mr_n66854800)
print v(xbgr.mr_n66855120)
print v(xbgr.mr_n66855232)
print v(xbgr.mr_n66855552)
print v(xbgr.mr_n66855664)
print v(xbgr.mr_n66855984)
print v(xbgr.mr_n66856096)
print v(xbgr.mr_n66856416)
print v(xbgr.mr_n66856528)
print v(xbgr.mr_n66856848)
print v(xbgr.mr_n66856960)
print v(xbgr.mr_n66857280)
print v(xbgr.mr_n66857392)
print v(xbgr.mr_n66857712)
print v(xbgr.mr_n66857824)
print v(xbgr.mr_n66858144)
print v(xbgr.mr_n66858256)
print v(xbgr.mr_n66858576)
print v(xbgr.mr_n66858688)
print v(xbgr.mr_n66859008)
print v(xbgr.mr_n66859120)
print v(xbgr.mr_n66859440)
print v(xbgr.mr_n66859552)
print v(xbgr.mr_n66859872)
print v(xbgr.mr_n66859984)
print v(xbgr.mr_n66860304)
print v(xbgr.mr_n66860416)
print v(xbgr.mr_n66860736)
print v(xbgr.mr_n66860848)
print v(xbgr.mr_n66861168)
print v(xbgr.mr_n66861280)
print v(xbgr.mr_n66861600)
print v(xbgr.mr_n66861712)
print v(xbgr.mr_n66862032)
print v(xbgr.mr_n66862144)
print v(xbgr.mr_n66862464)
print v(xbgr.mr_n66862576)
print v(xbgr.mr_n66862896)
print v(xbgr.mr_n66863008)
print v(xbgr.mr_n66863328)
print v(xbgr.mr_n66863440)
print v(xbgr.mr_n66863760)
print v(xbgr.mr_n66863872)
print v(xbgr.mr_n66864192)
print v(xbgr.mr_n66864304)
print v(xbgr.mr_n66864624)
print v(xbgr.mr_n66864736)
print v(xbgr.mr_n66865056)
print v(xbgr.mr_n66865168)
print v(xbgr.mr_n66865488)
print v(xbgr.mr_n66865600)
print v(xbgr.mr_n66865920)
print v(xbgr.mr_n66866032)
print v(xbgr.mr_n66866352)
print v(xbgr.mr_n66866464)
print v(xbgr.mr_n66866784)
print v(xbgr.mr_n66866896)
print v(xbgr.mr_n66867216)
print v(xbgr.mr_n66867328)
print v(xbgr.mr_n66867648)
print v(xbgr.mr_n66867760)
print v(xbgr.mr_n66868080)
print v(xbgr.mr_n66868192)
print v(xbgr.mr_n66868512)
print v(xbgr.mr_n66868624)
print v(xbgr.mr_n66868944)
print v(xbgr.mr_n66869056)
print v(xbgr.mr_n66869376)
print v(xbgr.mr_n66869488)
print v(xbgr.mr_n66869808)
print v(xbgr.mr_n66869920)
print v(xbgr.mr_n66870240)
print v(xbgr.mr_n66870352)
print v(xbgr.mr_n66870672)
print v(xbgr.mr_n66870784)
print v(xbgr.mr_n66871104)
print v(xbgr.mr_n66871216)
print v(xbgr.mr_n66871536)
print v(xbgr.mr_n66871648)
print v(xbgr.mr_n66871968)
print v(xbgr.mr_n66872080)
print v(xbgr.mr_n66872400)
print v(xbgr.mr_n66872512)
print v(xbgr.mr_n66872832)
print v(xbgr.mr_n66872944)
print v(xbgr.mr_n66873264)
print v(xbgr.mr_n66873376)
print v(xbgr.mr_n66873696)
print v(xbgr.mr_n66873808)
print v(xbgr.mr_n66874128)
print v(xbgr.mr_n66874240)
print v(xbgr.mr_n66874560)
print v(xbgr.mr_n66874672)
print v(xbgr.mr_n66874992)
print v(xbgr.mr_n66875104)
print v(xbgr.mr_n66875424)
print v(xbgr.mr_n66875536)
print v(xbgr.mr_n66875856)
print v(xbgr.mr_n66875968)
print v(xbgr.mr_n66876288)
print v(xbgr.mr_n66876400)
print v(xbgr.mr_n66876720)
print v(xbgr.mr_n66876832)
print v(xbgr.mr_n66877152)
print v(xbgr.mr_n66877264)
print v(xbgr.mr_n66877584)
print v(xbgr.mr_n66877696)
print v(xbgr.mr_n66878016)
print v(xbgr.mr_n66878128)
print v(xbgr.mr_n66878448)
print v(xbgr.mr_n66878560)
print v(xbgr.mr_n66878880)
print v(xbgr.mr_n66878992)
print v(xbgr.mr_n66879312)
print v(xbgr.mr_n66879424)
print v(xbgr.mr_n66879744)
print v(xbgr.mr_n66879856)
print v(xbgr.mr_n66880176)
print v(xbgr.mr_n66880288)
print v(xbgr.mr_n66880608)
print v(xbgr.mr_n66880720)
print v(xbgr.mr_n66881040)
print v(xbgr.mr_n66881152)
print v(xbgr.mr_n66881472)
print v(xbgr.mr_n66881584)
print v(xbgr.mr_n66881904)
print v(xbgr.mr_n66882016)
print v(xbgr.mr_n66882336)
print v(xbgr.mr_n66882448)
print v(xbgr.mr_n66882768)
print v(xbgr.mr_n66882880)
print v(xbgr.mr_n66883200)
print v(xbgr.mr_n66883312)
print v(xbgr.mr_n66883632)
print v(xbgr.mr_n66883744)
print v(xbgr.mr_n66884064)
print v(xbgr.mr_n66884176)
print v(xbgr.mr_n66884496)
print v(xbgr.mr_n66884608)
print v(xbgr.mr_n66884928)
print v(xbgr.mr_n66885040)
print v(xbgr.mr_n66885360)
print v(xbgr.mr_n66885472)
print v(xbgr.mr_n66885792)
print v(xbgr.mr_n66885904)
print v(xbgr.mr_n66886224)
print v(xbgr.mr_n66886336)
print v(xbgr.mr_n66886656)
print v(xbgr.mr_n66886768)
print v(xbgr.mr_n66887088)
print v(xbgr.mr_n66887200)
print v(xbgr.mr_n66887520)
print v(xbgr.mr_n66887632)
print v(xbgr.mr_n66887952)
print v(xbgr.mr_n66888064)
print v(xbgr.mr_n66888384)
print v(xbgr.mr_n66888496)
print v(xbgr.mr_n66888816)
print v(xbgr.mr_n66888928)
print v(xbgr.mr_n66889248)
print v(xbgr.mr_n66889360)
print v(xbgr.mr_n66889680)
print v(xbgr.mr_n66889792)
print v(xbgr.mr_n66890112)
print v(xbgr.mr_n66890224)
print v(xbgr.mr_n66890544)
print v(xbgr.mr_n66890656)
print v(xbgr.mr_n66890976)
print v(xbgr.mr_n66891088)
print v(xbgr.mr_n66891408)
print v(xbgr.mr_n66891520)
print v(xbgr.mr_n66891840)
print v(xbgr.mr_n66891952)
print v(xbgr.mr_n66892272)
print v(xbgr.mr_n66892384)
print v(xbgr.mr_n66892704)
print v(xbgr.mr_n66892816)
print v(xbgr.mr_n66893136)
print v(xbgr.mr_n66893248)
print v(xbgr.mr_n66893568)
print v(xbgr.mr_n66893680)
print v(xbgr.mr_n66894000)
print v(xbgr.mr_n66894112)
print v(xbgr.mr_n66894432)
print v(xbgr.mr_n66894544)
print v(xbgr.mr_n66894864)
print v(xbgr.mr_n66894976)
print v(xbgr.mr_n66895296)
print v(xbgr.mr_n66895408)
print v(xbgr.mr_n66895728)
print v(xbgr.mr_n66895840)
print v(xbgr.mr_n66896160)
print v(xbgr.mr_n66896272)
print v(xbgr.mr_n66896592)
print v(xbgr.mr_n66896704)
print v(xbgr.mr_n66897024)
print v(xbgr.mr_n66897136)
print v(xbgr.mr_n66897456)
print v(xbgr.mr_n66897568)
print v(xbgr.mr_n66897888)
print v(xbgr.mr_n66898000)
print v(xbgr.mr_n66898320)
print v(xbgr.mr_n66898432)
print v(xbgr.mr_n66898752)
print v(xbgr.mr_n66898864)
print v(xbgr.mr_n66899184)
print v(xbgr.mr_n66899296)
print v(xbgr.mr_n66899616)
print v(xbgr.mr_n66899728)
print v(xbgr.mr_n66900048)
print v(xbgr.mr_n66900160)
print v(xbgr.mr_n66900480)
print v(xbgr.mr_n66900592)
print v(xbgr.mr_n66900912)
print v(xbgr.mr_n66901024)
print v(xbgr.mr_n66901344)
print v(xbgr.mr_n66901456)
print v(xbgr.mr_n66901776)
print v(xbgr.mr_n66901888)
print v(xbgr.mr_n66902208)
print v(xbgr.mr_n66902320)
print v(xbgr.mr_n66902640)
print v(xbgr.mr_n66902752)
print v(xbgr.mr_n66903072)
print v(xbgr.mr_n66903184)
print v(xbgr.mr_n66903504)
print v(xbgr.mr_n66903616)
print v(xbgr.mr_n66903936)
print v(xbgr.mr_n66904048)
print v(xbgr.mr_n66904368)
print v(xbgr.mr_n66904480)
print v(xbgr.mr_n66904800)
print v(xbgr.mr_n66904912)
print v(xbgr.mr_n66905232)
print v(xbgr.mr_n66905344)
print v(xbgr.mr_n66905664)
print v(xbgr.mr_n66905776)
print v(xbgr.mr_n66906096)
print v(xbgr.mr_n66906208)
print v(xbgr.mr_n66906528)
print v(xbgr.mr_n66906640)
print v(xbgr.mr_n66906960)
print v(xbgr.mr_n66907072)
print v(xbgr.mr_n66907392)
print v(xbgr.mr_n66907504)
print v(xbgr.mr_n66907824)
print v(xbgr.mr_n66907936)
print v(xbgr.mr_n66908256)
print v(xbgr.mr_n66908368)
print v(xbgr.mr_n66908688)
print v(xbgr.mr_n66908800)
print v(xbgr.mr_n66909120)
print v(xbgr.mr_n66909232)
print v(xbgr.mr_n66909552)
print v(xbgr.mr_n66909664)
print v(xbgr.mr_n66909984)
print v(xbgr.mr_n66910096)
print v(xbgr.mr_n66910416)
print v(xbgr.mr_n66910528)
print v(xbgr.mr_n66910848)
print v(xbgr.mr_n66910960)
print v(xbgr.mr_n66911280)
print v(xbgr.mr_n66911392)
print v(xbgr.mr_n66911712)
print v(xbgr.mr_n66911824)
print v(xbgr.mr_n66912144)
print v(xbgr.mr_n66912256)
print v(xbgr.mr_n66912576)
print v(xbgr.mr_n66912688)
print v(xbgr.mr_n66913008)
print v(xbgr.mr_n66913120)
print v(xbgr.mr_n66913440)
print v(xbgr.mr_n66913552)
print v(xbgr.mr_n66913872)
print v(xbgr.mr_n66913984)
print v(xbgr.mr_n66914304)
print v(xbgr.mr_n66914416)
print v(xbgr.mr_n66914736)
print v(xbgr.mr_n66914848)
print v(xbgr.mr_n66915168)
print v(xbgr.mr_n66915280)
print v(xbgr.mr_n66915600)
print v(xbgr.mr_n66915712)
print v(xbgr.mr_n66916032)
print v(xbgr.mr_n66916144)
print v(xbgr.mr_n66916464)
print v(xbgr.mr_n66916576)
print v(xbgr.mr_n66916896)
print v(xbgr.mr_n66917008)
print v(xbgr.mr_n66917328)
print v(xbgr.mr_n66917440)
print v(xbgr.mr_n66917760)
print v(xbgr.mr_n66917872)
print v(xbgr.mr_n66918192)
print v(xbgr.mr_n66918304)
print v(xbgr.mr_n66918624)
print v(xbgr.mr_n66918736)
print v(xbgr.mr_n66919056)
print v(xbgr.mr_n66919168)
print v(xbgr.mr_n66919488)
print v(xbgr.mr_n66919600)
print v(xbgr.mr_n66919920)
print v(xbgr.mr_n66920032)
print v(xbgr.mr_n66920352)
print v(xbgr.mr_n66920464)
print v(xbgr.mr_n66920784)
print v(xbgr.mr_n66920896)
print v(xbgr.mr_n66921216)
print v(xbgr.mr_n66921328)
print v(xbgr.mr_n66921648)
print v(xbgr.mr_n66921760)
print v(xbgr.mr_n66922080)
print v(xbgr.mr_n66922192)
print v(xbgr.mr_n66922512)
print v(xbgr.mr_n66922624)
print v(xbgr.mr_n66922944)
print v(xbgr.mr_n66923056)
print v(xbgr.mr_n66923376)
print v(xbgr.mr_n66923488)
print v(xbgr.mr_n66923808)
print v(xbgr.mr_n66923920)
print v(xbgr.mr_n66924240)
print v(xbgr.mr_n66924352)
print v(xbgr.mr_n66924672)
print v(xbgr.mr_n66924784)
print v(xbgr.mr_n66925104)
print v(xbgr.mr_n66925216)
print v(xbgr.mr_n66925536)
print v(xbgr.mr_n66925648)
print v(xbgr.mr_n66925968)
print v(xbgr.mr_n66926080)
print v(xbgr.mr_n66926400)
print v(xbgr.mr_n66926512)
print v(xbgr.mr_n66926832)
print v(xbgr.mr_n66926944)
print v(xbgr.mr_n66927264)
print v(xbgr.mr_n66927376)
print v(xbgr.mr_n66927696)
print v(xbgr.mr_n66927808)
print v(xbgr.mr_n66928128)
print v(xbgr.mr_n66928240)
print v(xbgr.mr_n66928560)
print v(xbgr.mr_n66928672)
print v(xbgr.mr_n66928992)
print v(xbgr.mr_n66929104)
print v(xbgr.mr_n66929424)
print v(xbgr.mr_n66929536)
print v(xbgr.mr_n66929856)
print v(xbgr.mr_n66929968)
print v(xbgr.mr_n66930288)
print v(xbgr.mr_n66930400)
print v(xbgr.mr_n66930720)
print v(xbgr.mr_n66930832)
print v(xbgr.mr_n66931152)
print v(xbgr.mr_n66931264)
print v(xbgr.mr_n66931584)
print v(xbgr.mr_n66931696)
print v(xbgr.mr_n66932016)
print v(xbgr.mr_n66932128)
print v(xbgr.mr_n66932448)
print v(xbgr.mr_n66932560)
print v(xbgr.mr_n66932880)
print v(xbgr.mr_n67937392)
print v(xbgr.mr_n67937568)
print v(xbgr.mr_n67937680)
print v(xbgr.mr_n67937936)
print v(xbgr.mr_n67938048)
print v(xbgr.mr_n67938304)
print v(xbgr.mr_n67938416)
print v(xbgr.mr_n67938672)
print v(xbgr.mr_n67938784)
print v(xbgr.mr_n67939040)
print v(xbgr.mr_n67939152)
print v(xbgr.mr_n67939408)
print v(xbgr.mr_n67939520)
print v(xbgr.mr_n67939776)
print v(xbgr.mr_n67939888)
print v(xbgr.mr_n67940176)
print v(xbgr.mr_n67940288)
print v(xbgr.mr_n67940608)
print v(xbgr.mr_n67940720)
print v(xbgr.mr_n67941040)
print v(xbgr.mr_n67941152)
print v(xbgr.mr_n67941472)
print v(xbgr.mr_n67941584)
print v(xbgr.mr_n67941904)
print v(xbgr.mr_n67942016)
print v(xbgr.mr_n67942336)
print v(xbgr.mr_n67942448)
print v(xbgr.mr_n67942768)
print v(xbgr.mr_n67942880)
print v(xbgr.mr_n67943200)
print v(xbgr.mr_n67943312)
print v(xbgr.mr_n67943632)
print v(xbgr.mr_n67943744)
print v(xbgr.mr_n67944064)
print v(xbgr.mr_n67944176)
print v(xbgr.mr_n67944496)
print v(xbgr.mr_n67944608)
print v(xbgr.mr_n67944928)
print v(xbgr.mr_n67945040)
print v(xbgr.mr_n67945360)
print v(xbgr.mr_n67945472)
print v(xbgr.mr_n67945792)
print v(xbgr.mr_n67945904)
print v(xbgr.mr_n67946224)
print v(xbgr.mr_n67946336)
print v(xbgr.mr_n67946656)
print v(xbgr.mr_n67946768)
print v(xbgr.mr_n67947088)
print v(xbgr.mr_n67947200)
print v(xbgr.mr_n67947520)
print v(xbgr.mr_n67947632)
print v(xbgr.mr_n67947952)
print v(xbgr.mr_n67948064)
print v(xbgr.mr_n67948384)
print v(xbgr.mr_n67948496)
print v(xbgr.mr_n67948816)
print v(xbgr.mr_n67948928)
print v(xbgr.mr_n67949248)
print v(xbgr.mr_n67949360)
print v(xbgr.mr_n67949680)
print v(xbgr.mr_n67949792)
print v(xbgr.mr_n67950112)
print v(xbgr.mr_n67950224)
print v(xbgr.mr_n67950544)
print v(xbgr.mr_n67950656)
print v(xbgr.mr_n67950976)
print v(xbgr.mr_n67951088)
print v(xbgr.mr_n67951408)
print v(xbgr.mr_n67951520)
print v(xbgr.mr_n67951840)
print v(xbgr.mr_n67951952)
print v(xbgr.mr_n67952272)
print v(xbgr.mr_n67952384)
print v(xbgr.mr_n67952704)
print v(xbgr.mr_n67952816)
print v(xbgr.mr_n67953136)
print v(xbgr.mr_n67953248)
print v(xbgr.mr_n67953568)
print v(xbgr.mr_n67953680)
print v(xbgr.mr_n67954000)
print v(xbgr.mr_n67954112)
print v(xbgr.mr_n67954432)
print v(xbgr.mr_n67954544)
print v(xbgr.mr_n67954864)
print v(xbgr.mr_n67954976)
print v(xbgr.mr_n67955296)
print v(xbgr.mr_n67955408)
print v(xbgr.mr_n67955728)
print v(xbgr.mr_n67955840)
print v(xbgr.mr_n67956160)
print v(xbgr.mr_n67956272)
print v(xbgr.mr_n67956592)
print v(xbgr.mr_n67956704)
print v(xbgr.mr_n67957024)
print v(xbgr.mr_n67957136)
print v(xbgr.mr_n67957456)
print v(xbgr.mr_n67957568)
print v(xbgr.mr_n67957888)
print v(xbgr.mr_n67958000)
print v(xbgr.mr_n67958320)
print v(xbgr.mr_n67958432)
print v(xbgr.mr_n67958752)
print v(xbgr.mr_n67958864)
print v(xbgr.mr_n67959184)
print v(xbgr.mr_n67959296)
print v(xbgr.mr_n67959616)
print v(xbgr.mr_n67959728)
print v(xbgr.mr_n67960048)
print v(xbgr.mr_n67960160)
print v(xbgr.mr_n67960480)
print v(xbgr.mr_n67960592)
print v(xbgr.mr_n67960912)
print v(xbgr.mr_n67961024)
print v(xbgr.mr_n67961344)
print v(xbgr.mr_n67961456)
print v(xbgr.mr_n67961776)
print v(xbgr.mr_n67961888)
print v(xbgr.mr_n67962208)
print v(xbgr.mr_n67962320)
print v(xbgr.mr_n67962640)
print v(xbgr.mr_n67962752)
print v(xbgr.mr_n67963072)
print v(xbgr.mr_n67963184)
print v(xbgr.mr_n67963504)
print v(xbgr.mr_n67963616)
print v(xbgr.mr_n67963936)
print v(xbgr.mr_n67964048)
print v(xbgr.mr_n67964368)
print v(xbgr.mr_n67964480)
print v(xbgr.mr_n67964800)
print v(xbgr.mr_n67964912)
print v(xbgr.mr_n67965232)
print v(xbgr.mr_n67965344)
print v(xbgr.mr_n67965664)
print v(xbgr.mr_n67965776)
print v(xbgr.mr_n67966096)
print v(xbgr.mr_n67966208)
print v(xbgr.mr_n67966528)
print v(xbgr.mr_n67966640)
print v(xbgr.mr_n67966960)
print v(xbgr.mr_n67967072)
print v(xbgr.mr_n67967392)
print v(xbgr.mr_n67967504)
print v(xbgr.mr_n67967824)
print v(xbgr.mr_n67967936)
print v(xbgr.mr_n67968256)
print v(xbgr.mr_n67968368)
print v(xbgr.mr_n67968688)
print v(xbgr.mr_n67968800)
print v(xbgr.mr_n67969120)
print v(xbgr.mr_n67969232)
print v(xbgr.mr_n67969552)
print v(xbgr.mr_n67969664)
print v(xbgr.mr_n67969984)
print v(xbgr.mr_n67970096)
print v(xbgr.mr_n67970416)
print v(xbgr.mr_n67970528)
print v(xbgr.mr_n67970848)
print v(xbgr.mr_n67970960)
print v(xbgr.mr_n67971280)
print v(xbgr.mr_n67971392)
print v(xbgr.mr_n67971712)
print v(xbgr.mr_n67971824)
print v(xbgr.mr_n67972144)
print v(xbgr.mr_n67972256)
print v(xbgr.mr_n67972576)
print v(xbgr.mr_n67972688)
print v(xbgr.mr_n67973008)
print v(xbgr.mr_n67973120)
print v(xbgr.mr_n67973440)
print v(xbgr.mr_n67973552)
print v(xbgr.mr_n67973872)
print v(xbgr.mr_n67973984)
print v(xbgr.mr_n67974304)
print v(xbgr.mr_n67974416)
print v(xbgr.mr_n67974736)
print v(xbgr.mr_n67974848)
print v(xbgr.mr_n67975168)
print v(xbgr.mr_n67975280)
print v(xbgr.mr_n67975600)
print v(xbgr.mr_n67975712)
print v(xbgr.mr_n67976032)
print v(xbgr.mr_n67976144)
print v(xbgr.mr_n67976464)
print v(xbgr.mr_n67976576)
print v(xbgr.mr_n67976896)
print v(xbgr.mr_n67977008)
print v(xbgr.mr_n67977328)
print v(xbgr.mr_n67977440)
print v(xbgr.mr_n67977760)
print v(xbgr.mr_n67977872)
print v(xbgr.mr_n67978192)
print v(xbgr.mr_n67978304)
print v(xbgr.mr_n67978624)
print v(xbgr.mr_n67978736)
print v(xbgr.mr_n67979056)
print v(xbgr.mr_n67979168)
print v(xbgr.mr_n67979488)
print v(xbgr.mr_n67979600)
print v(xbgr.mr_n67979920)
print v(xbgr.mr_n67980032)
print v(xbgr.mr_n67980352)
print v(xbgr.mr_n67980464)
print v(xbgr.mr_n67980784)
print v(xbgr.mr_n67980896)
print v(xbgr.mr_n67981216)
print v(xbgr.mr_n67981328)
print v(xbgr.mr_n67981648)
print v(xbgr.mr_n67981760)
print v(xbgr.mr_n67982080)
print v(xbgr.mr_n67982192)
print v(xbgr.mr_n67982512)
print v(xbgr.mr_n67982624)
print v(xbgr.mr_n67982944)
print v(xbgr.mr_n67983056)
print v(xbgr.mr_n67983376)
print v(xbgr.mr_n67983488)
print v(xbgr.mr_n67983808)
print v(xbgr.mr_n67983920)
print v(xbgr.mr_n67984240)
print v(xbgr.mr_n67984352)
print v(xbgr.mr_n67984672)
print v(xbgr.mr_n67984784)
print v(xbgr.mr_n67985104)
print v(xbgr.mr_n67985216)
print v(xbgr.mr_n67985536)
print v(xbgr.mr_n67985648)
print v(xbgr.mr_n67985968)
print v(xbgr.mr_n67986080)
print v(xbgr.mr_n67986400)
print v(xbgr.mr_n67986512)
print v(xbgr.mr_n67986832)
print v(xbgr.mr_n67986944)
print v(xbgr.mr_n67987264)
print v(xbgr.mr_n67987376)
print v(xbgr.mr_n67987696)
print v(xbgr.mr_n67987808)
print v(xbgr.mr_n67988128)
print v(xbgr.mr_n67988240)
print v(xbgr.mr_n67988560)
print v(xbgr.mr_n67988672)
print v(xbgr.mr_n67988992)
print v(xbgr.mr_n67989104)
print v(xbgr.mr_n67989424)
print v(xbgr.mr_n67989536)
print v(xbgr.mr_n67989856)
print v(xbgr.mr_n67989968)
print v(xbgr.mr_n67990288)
print v(xbgr.mr_n67990400)
print v(xbgr.mr_n67990720)
print v(xbgr.mr_n67990832)
print v(xbgr.mr_n67991152)
print v(xbgr.mr_n67991264)
print v(xbgr.mr_n67991584)
print v(xbgr.mr_n67991696)
print v(xbgr.mr_n67992016)
print v(xbgr.mr_n67992128)
print v(xbgr.mr_n67992448)
print v(xbgr.mr_n67992560)
print v(xbgr.mr_n67992880)
print v(xbgr.mr_n67992992)
print v(xbgr.mr_n67993312)
print v(xbgr.mr_n67993424)
print v(xbgr.mr_n67993744)
print v(xbgr.mr_n67993856)
print v(xbgr.mr_n67994176)
print v(xbgr.mr_n67994288)
print v(xbgr.mr_n67994608)
print v(xbgr.mr_n67994720)
print v(xbgr.mr_n67995040)
print v(xbgr.mr_n67995152)
print v(xbgr.mr_n67995472)
print v(xbgr.mr_n67995584)
print v(xbgr.mr_n67995904)
print v(xbgr.mr_n67996016)
print v(xbgr.mr_n67996336)
print v(xbgr.mr_n67996448)
print v(xbgr.mr_n67996768)
print v(xbgr.mr_n67996880)
print v(xbgr.mr_n67997200)
print v(xbgr.mr_n67997312)
print v(xbgr.mr_n67997632)
print v(xbgr.mr_n67997744)
print v(xbgr.mr_n67998064)
print v(xbgr.mr_n67998176)
print v(xbgr.mr_n67998496)
print v(xbgr.mr_n67998608)
print v(xbgr.mr_n67998928)
print v(xbgr.mr_n67999040)
print v(xbgr.mr_n67999360)
print v(xbgr.mr_n67999472)
print v(xbgr.mr_n67999792)
print v(xbgr.mr_n67999904)
print v(xbgr.mr_n68000224)
print v(xbgr.mr_n68000336)
print v(xbgr.mr_n68000656)
print v(xbgr.mr_n68000768)
print v(xbgr.mr_n68001088)
print v(xbgr.mr_n68001200)
print v(xbgr.mr_n68001520)
print v(xbgr.mr_n68001632)
print v(xbgr.mr_n68001952)
print v(xbgr.mr_n68002064)
print v(xbgr.mr_n68002384)
print v(xbgr.mr_n68002496)
print v(xbgr.mr_n68002816)
print v(xbgr.mr_n68002928)
print v(xbgr.mr_n68003248)
print v(xbgr.mr_n68003360)
print v(xbgr.mr_n68003680)
print v(xbgr.mr_n68003792)
print v(xbgr.mr_n68004112)
print v(xbgr.mr_n68004224)
print v(xbgr.mr_n68004544)
print v(xbgr.mr_n68004656)
print v(xbgr.mr_n68004976)
print v(xbgr.mr_n68005088)
print v(xbgr.mr_n68005408)
print v(xbgr.mr_n68005520)
print v(xbgr.mr_n68005840)
print v(xbgr.mr_n68005952)
print v(xbgr.mr_n68006272)
print v(xbgr.mr_n68006384)
print v(xbgr.mr_n68006704)
print v(xbgr.mr_n68006816)
print v(xbgr.mr_n68007136)
print v(xbgr.mr_n68007248)
print v(xbgr.mr_n68007568)
print v(xbgr.mr_n68007680)
print v(xbgr.mr_n68008000)
print v(xbgr.mr_n68008112)
print v(xbgr.mr_n68008432)
print v(xbgr.mr_n68008544)
print v(xbgr.mr_n68008864)
print v(xbgr.mr_n68008976)
print v(xbgr.mr_n68009296)
print v(xbgr.mr_n68009408)
print v(xbgr.mr_n68009728)
print v(xbgr.mr_n68009840)
print v(xbgr.mr_n68010160)
print v(xbgr.mr_n68010272)
print v(xbgr.mr_n68010592)
print v(xbgr.mr_n68010704)
print v(xbgr.mr_n68011024)
print v(xbgr.mr_n68011136)
print v(xbgr.mr_n68011456)
print v(xbgr.mr_n68011568)
print v(xbgr.mr_n68011888)
print v(xbgr.mr_n68012000)
print v(xbgr.mr_n68012320)
print v(xbgr.mr_n68012432)
print v(xbgr.mr_n68012752)
print v(xbgr.mr_n68012864)
print v(xbgr.mr_n68013184)
print v(xbgr.mr_n68013296)
print v(xbgr.mr_n68013616)
print v(xbgr.mr_n68013728)
print v(xbgr.mr_n68014048)
print v(xbgr.mr_n68014160)
print v(xbgr.mr_n68014480)
print v(xbgr.mr_n68014592)
print v(xbgr.mr_n68014912)
print v(xbgr.mr_n68015024)
print v(xbgr.mr_n68015344)
print v(xbgr.mr_n68015456)
print v(xbgr.mr_n68015776)
print v(xbgr.mr_n68015888)
print v(xbgr.mr_n68016208)
print v(xbgr.mr_n68016320)
print v(xbgr.mr_n68016640)
print v(xbgr.mr_n68016752)
print v(xbgr.mr_n68017072)
print v(xbgr.mr_n68017184)
print v(xbgr.mr_n68017504)
print v(xbgr.mr_n68017616)
print v(xbgr.mr_n68017936)
print v(xbgr.mr_n68018048)
print v(xbgr.mr_n68018368)
print v(xbgr.mr_n68018480)
print v(xbgr.mr_n68018800)
print v(xbgr.mr_n68018912)
print v(xbgr.mr_n68019232)
print v(xbgr.mr_n68019344)
print v(xbgr.mr_n68019664)
print v(xbgr.mr_n68019776)
print v(xbgr.mr_n68020096)
print v(xbgr.mr_n68020208)
print v(xbgr.mr_n68020528)
print v(xbgr.mr_n68020640)
print v(xbgr.mr_n68020960)
print v(xbgr.mr_n68021072)
print v(xbgr.mr_n68021392)
print v(xbgr.mr_n68021504)
print v(xbgr.mr_n68021824)
print v(xbgr.mr_n68021936)
print v(xbgr.mr_n68022256)
print v(xbgr.mr_n68022368)
print v(xbgr.mr_n68022688)
print v(xbgr.mr_n68022800)
print v(xbgr.mr_n68023120)
print v(xbgr.mr_n68023232)
print v(xbgr.mr_n68023552)
print v(xbgr.mr_n68023664)
print v(xbgr.mr_n68023984)
print v(xbgr.mr_n68024096)
print v(xbgr.mr_n68024416)
print v(xbgr.mr_n68024528)
print v(xbgr.mr_n68024848)
print v(xbgr.mr_n68024960)
print v(xbgr.mr_n68025280)
print v(xbgr.mr_n68025392)
print v(xbgr.mr_n68025712)
print v(xbgr.mr_n68025824)
print v(xbgr.mr_n68026144)
print v(xbgr.mr_n68026256)
print v(xbgr.mr_n68026576)
print v(xbgr.mr_n68026688)
print v(xbgr.mr_n68027008)
print v(xbgr.mr_n68027120)
print v(xbgr.mr_n68027440)
print v(xbgr.mr_n68027552)
print v(xbgr.mr_n68027872)
print v(xbgr.mr_n68027984)
print v(xbgr.mr_n68028304)
print v(xbgr.mr_n68028416)
print v(xbgr.mr_n68028736)
print v(xbgr.mr_n68028848)
print v(xbgr.mr_n68029168)
print v(xbgr.mr_n68029280)
print v(xbgr.mr_n68029600)
print v(xbgr.mr_n68029712)
print v(xbgr.mr_n68030032)
print v(xbgr.mr_n68030144)
print v(xbgr.mr_n68030464)
print v(xbgr.mr_n68030576)
print v(xbgr.mr_n68030896)
print v(xbgr.mr_n68031008)
print v(xbgr.mr_n68031328)
print v(xbgr.mr_n68031440)
print v(xbgr.mr_n68031760)
print v(xbgr.mr_n68031872)
print v(xbgr.mr_n68032192)
print v(xbgr.mr_n68032304)
print v(xbgr.mr_n68032624)
print v(xbgr.mr_n68032736)
print v(xbgr.mr_n68033056)
print v(xbgr.mr_n68033168)
print v(xbgr.mr_n68033488)
print v(xbgr.mr_n68033600)
print v(xbgr.mr_n68033920)
print v(xbgr.mr_n68034032)
print v(xbgr.mr_n68034352)
print v(xbgr.mr_n68034464)
print v(xbgr.mr_n68034784)
print v(xbgr.mr_n68034896)
print v(xbgr.mr_n68035216)
print v(xbgr.mr_n68035328)
print v(xbgr.mr_n68035648)
print v(xbgr.mr_n68035760)
print v(xbgr.mr_n68036080)
print v(xbgr.mr_n68036192)
print v(xbgr.mr_n68036512)
print v(xbgr.mr_n68036624)
print v(xbgr.mr_n68036944)
print v(xbgr.mr_n68037056)
print v(xbgr.mr_n68037376)
print v(xbgr.mr_n68037488)
print v(xbgr.mr_n68037808)
print v(xbgr.mr_n68037920)
print v(xbgr.mr_n68038240)
print v(xbgr.mr_n68038352)
print v(xbgr.mr_n68038672)
print v(xbgr.mr_n68038784)
print v(xbgr.mr_n68039104)
print v(xbgr.mr_n68039216)
print v(xbgr.mr_n68039536)
print v(xbgr.mr_n68039648)
print v(xbgr.mr_n68039968)
print v(xbgr.mr_n68040080)
print v(xbgr.mr_n68040400)
print v(xbgr.mr_n68040512)
print v(xbgr.mr_n68040832)
print v(xbgr.mr_n68040944)
print v(xbgr.mr_n68041264)
print v(xbgr.mr_n68041376)
print v(xbgr.mr_n68041696)
print v(xbgr.mr_n68041808)
print v(xbgr.mr_n68042128)
print v(xbgr.mr_n68042240)
print v(xbgr.mr_n68042528)
print v(xbgr.mr_n68042640)
print v(xbgr.mr_n68042960)
print v(xbgr.mr_n68043072)
print v(xbgr.mr_n68043392)
print v(xbgr.mr_n68043504)
print v(xbgr.mr_n68043824)
print v(xbgr.mr_n68043936)
print v(xbgr.mr_n68044256)
print v(xbgr.mr_n68044368)
print v(xbgr.mr_n68044688)
print v(xbgr.mr_n68044800)
print v(xbgr.mr_n68045120)
print v(xbgr.mr_n68045232)
print v(xbgr.mr_n68045552)
print v(xbgr.mr_n68045664)
print v(xbgr.mr_n68045984)
print v(xbgr.mr_n68046096)
print v(xbgr.mr_n68046416)
print v(xbgr.mr_n68046528)
print v(xbgr.mr_n68046848)
print v(xbgr.mr_n68046960)
print v(xbgr.mr_n68047280)
print v(xbgr.mr_n68047392)
print v(xbgr.mr_n68047712)
print v(xbgr.mr_n68047824)
print v(xbgr.mr_n68048144)
print v(xbgr.mr_n68048256)
print v(xbgr.mr_n68048576)
print v(xbgr.mr_n68048688)
print v(xbgr.mr_n68049008)
print v(xbgr.mr_n68049120)
print v(xbgr.mr_n68049440)
print v(xbgr.mr_n68049552)
print v(xbgr.mr_n68049872)
print v(xbgr.mr_n68049984)
print v(xbgr.mr_n68050304)
print v(xbgr.mr_n68050416)
print v(xbgr.mr_n68050736)
print v(xbgr.mr_n68050848)
print v(xbgr.mr_n68051168)
print v(xbgr.mr_n68051280)
print v(xbgr.mr_n68051600)
print v(xbgr.mr_n68051712)
print v(xbgr.mr_n68052032)
print v(xbgr.mr_n68052144)
print v(xbgr.mr_n68052464)
print v(xbgr.mr_n68052576)
print v(xbgr.mr_n68052896)
print v(xbgr.mr_n68053008)
print v(xbgr.mr_n68053328)
print v(xbgr.mr_n68053440)
print v(xbgr.mr_n68053760)
print v(xbgr.mr_n68053872)
print v(xbgr.mr_n68054192)
print v(xbgr.mr_n68054304)
print v(xbgr.mr_n68054624)
print v(xbgr.mr_n68054736)
print v(xbgr.mr_n68055056)
print v(xbgr.mr_n68055168)
print v(xbgr.mr_n68055488)
print v(xbgr.mr_n68055600)
print v(xbgr.mr_n68055920)
print v(xbgr.mr_n68056032)
print v(xbgr.mr_n68056352)
print v(xbgr.mr_n68056464)
print v(xbgr.mr_n68056784)
print v(xbgr.mr_n68056896)
print v(xbgr.mr_n68057216)
print v(xbgr.mr_n68057328)
print v(xbgr.mr_n68057648)
print v(xbgr.mr_n68057760)
print v(xbgr.mr_n68058080)
print v(xbgr.mr_n68058192)
print v(xbgr.mr_n68058512)
print v(xbgr.mr_n68058624)
print v(xbgr.mr_n68058944)
print v(xbgr.mr_n68059056)
print v(xbgr.mr_n68059376)
print v(xbgr.mr_n68059488)
print v(xbgr.mr_n68059808)
print v(xbgr.mr_n68059920)
print v(xbgr.mr_n68060240)
print v(xbgr.mr_n68060352)
print v(xbgr.mr_n68060672)
print v(xbgr.mr_n68060784)
print v(xbgr.mr_n68061104)
print v(xbgr.mr_n68061216)
print v(xbgr.mr_n68061536)
print v(xbgr.mr_n68061648)
print v(xbgr.mr_n68061968)
print v(xbgr.mr_n68062080)
print v(xbgr.mr_n68062400)
print v(xbgr.mr_n68062512)
print v(xbgr.mr_n68062832)
print v(xbgr.mr_n68062944)
print v(xbgr.mr_n68063264)
print v(xbgr.mr_n68063376)
print v(xbgr.mr_n68063696)
print v(xbgr.mr_n68063808)
print v(xbgr.mr_n68064128)
print v(xbgr.mr_n68064240)
print v(xbgr.mr_n68064560)
print v(xbgr.mr_n68064672)
print v(xbgr.mr_n68064992)
print v(xbgr.mr_n68065104)
print v(xbgr.mr_n68065424)
print v(xbgr.mr_n68065536)
print v(xbgr.mr_n68065856)
print v(xbgr.mr_n68065968)
print v(xbgr.mr_n68066288)
print v(xbgr.mr_n68066400)
print v(xbgr.mr_n68066720)
print v(xbgr.mr_n68066832)
print v(xbgr.mr_n68067152)
print v(xbgr.mr_n68067264)
print v(xbgr.mr_n68067584)
print v(xbgr.mr_n68067696)
print v(xbgr.mr_n68068016)
print v(xbgr.mr_n68068128)
print v(xbgr.mr_n68068448)
print v(xbgr.mr_n68068560)
print v(xbgr.mr_n68068880)
print v(xbgr.mr_n68068992)
print v(xbgr.mr_n68069312)
print v(xbgr.mr_n68069424)
print v(xbgr.mr_n68069744)
print v(xbgr.mr_n68069856)
print v(xbgr.mr_n68070176)
print v(xbgr.mr_n68070288)
print v(xbgr.mr_n68070608)
print v(xbgr.mr_n68070720)
print v(xbgr.mr_n68071040)
print v(xbgr.mr_n68071152)
print v(xbgr.mr_n68071472)
print v(xbgr.mr_n68071584)
print v(xbgr.mr_n68071904)
print v(xbgr.mr_n68072016)
print v(xbgr.mr_n68072336)
print v(xbgr.mr_n68072448)
print v(xbgr.mr_n68072768)
print v(xbgr.mr_n68072880)
print v(xbgr.mr_n68073200)
print v(xbgr.mr_n68073312)
print v(xbgr.mr_n68073632)
print v(xbgr.mr_n68073744)
print v(xbgr.mr_n68074064)
print v(xbgr.mr_n68074176)
print v(xbgr.mr_n68074496)
print v(xbgr.mr_n68074608)
print v(xbgr.mr_n68074928)
print v(xbgr.mr_n68075040)
print v(xbgr.mr_n68075360)
print v(xbgr.mr_n68075472)
print v(xbgr.mr_n68075792)
print v(xbgr.mr_n68075904)
print v(xbgr.mr_n68076224)
print v(xbgr.mr_n68076336)
print v(xbgr.mr_n68076656)
print v(xbgr.mr_n68076768)
print v(xbgr.mr_n68077088)
print v(xbgr.mr_n68077200)
print v(xbgr.mr_n68077520)
print v(xbgr.mr_n68077632)
print v(xbgr.mr_n68077952)
print v(xbgr.mr_n68078064)
print v(xbgr.mr_n68078384)
print v(xbgr.mr_n68078496)
print v(xbgr.mr_n68078816)
print v(xbgr.mr_n68078928)
print v(xbgr.mr_n68079248)
print v(xbgr.mr_n68079360)
print v(xbgr.mr_n68079680)
print v(xbgr.mr_n68079792)
print v(xbgr.mr_n68080112)
print v(xbgr.mr_n68080224)
print v(xbgr.mr_n68080544)
print v(xbgr.mr_n68080656)
print v(xbgr.mr_n68080976)
print v(xbgr.mr_n68081088)
print v(xbgr.mr_n68081408)
print v(xbgr.mr_n68081520)
print v(xbgr.mr_n68081840)
print v(xbgr.mr_n68081952)
print v(xbgr.mr_n68082272)
print v(xbgr.mr_n68082384)
print v(xbgr.mr_n68082704)
print v(xbgr.mr_n68082816)
print v(xbgr.mr_n68083136)
print v(xbgr.mr_n68083248)
print v(xbgr.mr_n68083568)
print v(xbgr.mr_n68083680)
print v(xbgr.mr_n68084000)
print v(xbgr.mr_n68084112)
print v(xbgr.mr_n68084432)
print v(xbgr.mr_n68084544)
print v(xbgr.mr_n68084864)
print v(xbgr.mr_n68084976)
print v(xbgr.mr_n68085296)
print v(xbgr.mr_n68085408)
print v(xbgr.mr_n68085728)
print v(xbgr.mr_n68085840)
print v(xbgr.mr_n68086160)
print v(xbgr.mr_n68086272)
print v(xbgr.mr_n68086592)
print v(xbgr.mr_n68086704)
print v(xbgr.mr_n68087024)
print v(xbgr.mr_n68087136)
print v(xbgr.mr_n68087456)
print v(xbgr.mr_n68087568)
print v(xbgr.mr_n68087888)
print v(xbgr.mr_n68088000)
print v(xbgr.mr_n68088320)
print v(xbgr.mr_n68088432)
print v(xbgr.mr_n68088752)
print v(xbgr.mr_n68088864)
print v(xbgr.mr_n68089184)
print v(xbgr.mr_n68089296)
print v(xbgr.mr_n68089616)
print v(xbgr.mr_n68089728)
print v(xbgr.mr_n68090048)
print v(xbgr.mr_n68090160)
print v(xbgr.mr_n68090480)
print v(xbgr.mr_n68090592)
print v(xbgr.mr_n68090912)
print v(xbgr.mr_n68091024)
print v(xbgr.mr_n68091344)
print v(xbgr.mr_n68091456)
print v(xbgr.mr_n68091776)
print v(xbgr.mr_n68091888)
print v(xbgr.mr_n68092208)
print v(xbgr.mr_n68092320)
print v(xbgr.mr_n68092640)
print v(xbgr.mr_n68092752)
print v(xbgr.mr_n68093072)
print v(xbgr.mr_n68093184)
print v(xbgr.mr_n68093504)
print v(xbgr.mr_n68093616)
print v(xbgr.mr_n68093936)
print v(xbgr.mr_n68094048)
print v(xbgr.mr_n68094368)
print v(xbgr.mr_n68094480)
print v(xbgr.mr_n68094800)
print v(xbgr.mr_n68094912)
print v(xbgr.mr_n68095232)
print v(xbgr.mr_n68095344)
print v(xbgr.mr_n68095664)
print v(xbgr.mr_n68095776)
print v(xbgr.mr_n68096096)
print v(xbgr.mr_n68096208)
print v(xbgr.mr_n68096528)
print v(xbgr.mr_n68096640)
print v(xbgr.mr_n68096960)
print v(xbgr.mr_n68097072)
print v(xbgr.mr_n68097392)
print v(xbgr.mr_n68097504)
print v(xbgr.mr_n68097824)
print v(xbgr.mr_n68097936)
print v(xbgr.mr_n68098256)
print v(xbgr.mr_n68098368)
print v(xbgr.mr_n68098688)
print v(xbgr.mr_n68098800)
print v(xbgr.mr_n68099120)
print v(xbgr.mr_n68099232)
print v(xbgr.mr_n68099552)
print v(xbgr.mr_n68099664)
print v(xbgr.mr_n68099984)
print v(xbgr.mr_n68100096)
print v(xbgr.mr_n68100416)
print v(xbgr.mr_n68100528)
print v(xbgr.mr_n68100848)
print v(xbgr.mr_n68100960)
print v(xbgr.mr_n68101280)
print v(xbgr.mr_n68101392)
print v(xbgr.mr_n68101712)
print v(xbgr.mr_n68101824)
print v(xbgr.mr_n68102144)
print v(xbgr.mr_n68102256)
print v(xbgr.mr_n68102576)
print v(xbgr.mr_n68102688)
print v(xbgr.mr_n68103008)
print v(xbgr.mr_n68103120)
print v(xbgr.mr_n68103440)
print v(xbgr.mr_n68103552)
print v(xbgr.mr_n68103872)
print v(xbgr.mr_n68103984)
print v(xbgr.mr_n68104304)
print v(xbgr.mr_n68104416)
print v(xbgr.mr_n68104736)
print v(xbgr.mr_n68104848)
print v(xbgr.mr_n68105168)
print v(xbgr.mr_n68105280)
print v(xbgr.mr_n68105600)
print v(xbgr.mr_n68105712)
print v(xbgr.mr_n68106032)
print v(xbgr.mr_n68106144)
print v(xbgr.mr_n68106464)
print v(xbgr.mr_n68106576)
print v(xbgr.mr_n68106896)
print v(xbgr.mr_n68107008)
print v(xbgr.mr_n68107328)
print v(xbgr.mr_n68107440)
print v(xbgr.mr_n68107760)
print v(xbgr.mr_n68107872)
print v(xbgr.mr_n68108192)
print v(xbgr.mr_n68108304)
print v(xbgr.mr_n68108624)
print v(xbgr.mr_n68108736)
print v(xbgr.mr_n68109056)
print v(xbgr.mr_n68109168)
print v(xbgr.mr_n68109488)
print v(xbgr.mr_n68109600)
print v(xbgr.mr_n68109920)
print v(xbgr.mr_n68110032)
print v(xbgr.mr_n68110352)
print v(xbgr.mr_n68110464)
print v(xbgr.mr_n68110784)
print v(xbgr.mr_n68110896)
print v(xbgr.mr_n68111216)
print v(xbgr.mr_n68111328)
print v(xbgr.mr_n68111648)
print v(xbgr.mr_n68111760)
print v(xbgr.mr_n68112080)
print v(xbgr.mr_n68112192)
print v(xbgr.mr_n68112512)
print v(xbgr.mr_n68112624)
print v(xbgr.mr_n68112944)
print v(xbgr.mr_n68113056)
print v(xbgr.mr_n68113376)
print v(xbgr.mr_n68113488)
print v(xbgr.mr_n68113808)
print v(xbgr.mr_n68113920)
print v(xbgr.mr_n68114240)
print v(xbgr.mr_n68114352)
print v(xbgr.mr_n68114672)
print v(xbgr.mr_n68114784)
print v(xbgr.mr_n68115104)
print v(xbgr.mr_n68115216)
print v(xbgr.mr_n68115536)
print v(xbgr.mr_n68115648)
print v(xbgr.mr_n68115968)
print v(xbgr.mr_n68116080)
print v(xbgr.mr_n68116400)
print v(xbgr.mr_n68116512)
print v(xbgr.mr_n68116832)
print v(xbgr.mr_n68116944)
print v(xbgr.mr_n68117264)
print v(xbgr.mr_n68117376)
print v(xbgr.mr_n68117696)
print v(xbgr.mr_n68117808)
print v(xbgr.mr_n68118128)
print v(xbgr.mr_n68118240)
print v(xbgr.mr_n68118560)
print v(xbgr.mr_n68118672)
print v(xbgr.mr_n68118992)
print v(xbgr.mr_n68119104)
print v(xbgr.mr_n68119424)
print v(xbgr.mr_n68119536)
print v(xbgr.mr_n68119856)
print v(xbgr.mr_n68119968)
print v(xbgr.mr_n68120288)
print v(xbgr.mr_n68120400)
print v(xbgr.mr_n68120720)
print v(xbgr.mr_n68120832)
print v(xbgr.mr_n68121152)
print v(xbgr.mr_n68121264)
print v(xbgr.mr_n68121584)
print v(xbgr.mr_n68121696)
print v(xbgr.mr_n68122016)
print v(xbgr.mr_n68122128)
print v(xbgr.mr_n68122448)
print v(xbgr.mr_n68122560)
print v(xbgr.mr_n68122880)
print v(xbgr.mr_n68122992)
print v(xbgr.mr_n68123312)
print v(xbgr.mr_n68123424)
print v(xbgr.mr_n68123744)
print v(xbgr.mr_n68123856)
print v(xbgr.mr_n68124176)
print v(xbgr.mr_n68124288)
print v(xbgr.mr_n68124608)
print v(xbgr.mr_n68124720)
print v(xbgr.mr_n68125040)
print v(xbgr.mr_n68125152)
print v(xbgr.mr_n68125472)
print v(xbgr.mr_n68125584)
print v(xbgr.mr_n68125904)
print v(xbgr.mr_n68126016)
print v(xbgr.mr_n68126336)
print v(xbgr.mr_n68126448)
print v(xbgr.mr_n68126768)
print v(xbgr.mr_n68126880)
print v(xbgr.mr_n68127200)
print v(xbgr.mr_n68127312)
print v(xbgr.mr_n68127632)
print v(xbgr.mr_n68127744)
print v(xbgr.mr_n68128064)
print v(xbgr.mr_n68128176)
print v(xbgr.mr_n68128496)
print v(xbgr.mr_n68128608)
print v(xbgr.mr_n68128928)
print v(xbgr.mr_n68129040)
print v(xbgr.mr_n68129360)
print v(xbgr.mr_n68129472)
print v(xbgr.mr_n68129792)
print v(xbgr.mr_n68129904)
print v(xbgr.mr_n68130224)
print v(xbgr.mr_n68130336)
print v(xbgr.mr_n68130656)
print v(xbgr.mr_n68130768)
print v(xbgr.mr_n68131088)
print v(xbgr.mr_n68131200)
print v(xbgr.mr_n68131520)
print v(xbgr.mr_n68131632)
print v(xbgr.mr_n68131952)
print v(xbgr.mr_n68132064)
print v(xbgr.mr_n68132384)
print v(xbgr.mr_n68132496)
print v(xbgr.mr_n68132816)
print v(xbgr.mr_n68132928)
print v(xbgr.mr_n68133248)
print v(xbgr.mr_n68133360)
print v(xbgr.mr_n68133680)
print v(xbgr.mr_n68133792)
print v(xbgr.mr_n68134112)
print v(xbgr.mr_n68134224)
print v(xbgr.mr_n68134544)
print v(xbgr.mr_n68134656)
print v(xbgr.mr_n68134976)
print v(xbgr.mr_n68135088)
print v(xbgr.mr_n68135408)
print v(xbgr.mr_n68135520)
print v(xbgr.mr_n68135840)
print v(xbgr.mr_n68135952)
print v(xbgr.mr_n68136272)
print v(xbgr.mr_n68136384)
print v(xbgr.mr_n68136704)
print v(xbgr.mr_n68136816)
print v(xbgr.mr_n68137136)
print v(xbgr.mr_n68137248)
print v(xbgr.mr_n68137568)
print v(xbgr.mr_n68137680)
print v(xbgr.mr_n68138000)
print v(xbgr.mr_n68138112)
print v(xbgr.mr_n68138432)
print v(xbgr.mr_n68138544)
print v(xbgr.mr_n68138864)
print v(xbgr.mr_n68138976)
print v(xbgr.mr_n68139296)
print v(xbgr.mr_n68139408)
print v(xbgr.mr_n68139728)
print v(xbgr.mr_n68139840)
print v(xbgr.mr_n68140160)
print v(xbgr.mr_n68140272)
print v(xbgr.mr_n68140592)
print v(xbgr.mr_n68140704)
print v(xbgr.mr_n68141024)
print v(xbgr.mr_n68141136)
print v(xbgr.mr_n68141456)
print v(xbgr.mr_n68141568)
print v(xbgr.mr_n68141888)
print v(xbgr.mr_n68142000)
print v(xbgr.mr_n68142320)
print v(xbgr.mr_n68142432)
print v(xbgr.mr_n68142752)
print v(xbgr.mr_n68142864)
print v(xbgr.mr_n68143184)
print v(xbgr.mr_n68143296)
print v(xbgr.mr_n68143616)
print v(xbgr.mr_n68143728)
print v(xbgr.mr_n68144048)
print v(xbgr.mr_n68144160)
print v(xbgr.mr_n68144480)
print v(xbgr.mr_n68144592)
print v(xbgr.mr_n68144912)
print v(xbgr.mr_n68145024)
print v(xbgr.mr_n68145344)
print v(xbgr.mr_n68145456)
print v(xbgr.mr_n68145776)
print v(xbgr.mr_n68145888)
print v(xbgr.mr_n68146208)
print v(xbgr.mr_n68146320)
print v(xbgr.mr_n68146640)
print v(xbgr.mr_n68146752)
print v(xbgr.mr_n68147072)
print v(xbgr.mr_n68147184)
print v(xbgr.mr_n68147504)
print v(xbgr.mr_n68147616)
print v(xbgr.mr_n68147936)
print v(xbgr.mr_n68148048)
print v(xbgr.mr_n68148368)
print v(xbgr.mr_n68148480)
print v(xbgr.mr_n68148800)
print v(xbgr.mr_n68148912)
print v(xbgr.mr_n68149232)
print v(xbgr.mr_n68149344)
print v(xbgr.mr_n68149664)
print v(xbgr.mr_n68149776)
print v(xbgr.mr_n68150096)
print v(xbgr.mr_n68150208)
print v(xbgr.mr_n68150528)
print v(xbgr.mr_n68150640)
print v(xbgr.mr_n68150960)
print v(xbgr.mr_n68151072)
print v(xbgr.mr_n68151392)
print v(xbgr.mr_n68151504)
print v(xbgr.mr_n68151824)
print v(xbgr.mr_n68151936)
print v(xbgr.mr_n68152256)
print v(xbgr.mr_n68152368)
print v(xbgr.mr_n68152688)
print v(xbgr.mr_n68152800)
print v(xbgr.mr_n68153120)
print v(xbgr.mr_n68153232)
print v(xbgr.mr_n68153552)
print v(xbgr.mr_n68153664)
print v(xbgr.mr_n68153984)
print v(xbgr.mr_n68154096)
print v(xbgr.mr_n68154416)
print v(xbgr.mr_n68154528)
print v(xbgr.mr_n68154848)
print v(xbgr.mr_n68154960)
print v(xbgr.mr_n68155280)
print v(xbgr.mr_n68155392)
print v(xbgr.mr_n68155712)
print v(xbgr.mr_n68155824)
print v(xbgr.mr_n68156144)
print v(xbgr.mr_n68156256)
print v(xbgr.mr_n68156576)
print v(xbgr.mr_n68156688)
print v(xbgr.mr_n68157008)
print v(xbgr.mr_n68157120)
print v(xbgr.mr_n68157440)
print v(xbgr.mr_n68157552)
print v(xbgr.mr_n68157872)
print v(xbgr.mr_n68157984)
print v(xbgr.mr_n68158304)
print v(xbgr.mr_n68158416)
print v(xbgr.mr_n68158736)
print v(xbgr.mr_n68158848)
print v(xbgr.mr_n68159168)
print v(xbgr.mr_n68159280)
print v(xbgr.mr_n68159600)
print v(xbgr.mr_n68159712)
print v(xbgr.mr_n68160032)
print v(xbgr.mr_n68160144)
print v(xbgr.mr_n68160464)
print v(xbgr.mr_n68160576)
print v(xbgr.mr_n68160896)
print v(xbgr.mr_n68161008)
print v(xbgr.mr_n68161328)
print v(xbgr.mr_n68161440)
print v(xbgr.mr_n68161760)
print v(xbgr.mr_n68161872)
print v(xbgr.mr_n68162192)
print v(xbgr.mr_n68162304)
print v(xbgr.mr_n68162624)
print v(xbgr.mr_n68162736)
print v(xbgr.mr_n68163056)
print v(xbgr.mr_n68163168)
print v(xbgr.mr_n68163488)
print v(xbgr.mr_n68163600)
print v(xbgr.mr_n68163920)
print v(xbgr.mr_n68164032)
print v(xbgr.mr_n68164352)
print v(xbgr.mr_n68164464)
print v(xbgr.mr_n68164784)
print v(xbgr.mr_n68164896)
print v(xbgr.mr_n68165216)
print v(xbgr.mr_n68165328)
print v(xbgr.mr_n68165648)
print v(xbgr.mr_n68165760)
print v(xbgr.mr_n68166080)
print v(xbgr.mr_n68166192)
print v(xbgr.mr_n68166512)
print v(xbgr.mr_n68166624)
print v(xbgr.mr_n68166944)
print v(xbgr.mr_n68167056)
print v(xbgr.mr_n68167376)
print v(xbgr.mr_n68167488)
print v(xbgr.mr_n68167808)
print v(xbgr.mr_n68167920)
print v(xbgr.mr_n68168240)
print v(xbgr.mr_n68168352)
print v(xbgr.mr_n68168672)
print v(xbgr.mr_n68168784)
print v(xbgr.mr_n68169104)
print v(xbgr.mr_n68169216)
print v(xbgr.mr_n68169536)
print v(xbgr.mr_n68169648)
print v(xbgr.mr_n68169968)
print v(xbgr.mr_n68170080)
print v(xbgr.mr_n68170400)
print v(xbgr.mr_n68170512)
print v(xbgr.mr_n68170832)
print v(xbgr.mr_n68170944)
print v(xbgr.mr_n68171264)
print v(xbgr.mr_n68171376)
print v(xbgr.mr_n68171696)
print v(xbgr.mr_n68171808)
print v(xbgr.mr_n68172128)
print v(xbgr.mr_n68172240)
print v(xbgr.mr_n68172560)
print v(xbgr.mr_n68172672)
print v(xbgr.mr_n68172992)
print v(xbgr.mr_n68173104)
print v(xbgr.mr_n68173424)
print v(xbgr.mr_n68173536)
print v(xbgr.mr_n68173856)
print v(xbgr.mr_n68173968)
print v(xbgr.mr_n68174288)
print v(xbgr.mr_n68174400)
print v(xbgr.mr_n68174720)
print v(xbgr.mr_n68174832)
print v(xbgr.mr_n68175152)
print v(xbgr.mr_n68175264)
print v(xbgr.mr_n68175584)
print v(xbgr.mr_n68175696)
print v(xbgr.mr_n68176016)
print v(xbgr.mr_n68176128)
print v(xbgr.mr_n68176448)
print v(xbgr.mr_n68176560)
print v(xbgr.mr_n68176880)
print v(xbgr.mr_n68176992)
print v(xbgr.mr_n68177312)
print v(xbgr.mr_n68177424)
print v(xbgr.mr_n68177744)
print v(xbgr.mr_n68177856)
print v(xbgr.mr_n68178176)
print v(xbgr.mr_n68178288)
print v(xbgr.mr_n68178608)
print v(xbgr.mr_n68178720)
print v(xbgr.mr_n68179040)
print v(xbgr.mr_n68179152)
print v(xbgr.mr_n68179472)
print v(xbgr.mr_n68179584)
print v(xbgr.mr_n68179904)
print v(xbgr.mr_n68180016)
print v(xbgr.mr_n68180336)
print v(xbgr.mr_n68180448)
print v(xbgr.mr_n68180768)
print v(xbgr.mr_n68180880)
print v(xbgr.mr_n68181200)
print v(xbgr.mr_n68181312)
print v(xbgr.mr_n68181632)
print v(xbgr.mr_n68181744)
print v(xbgr.mr_n68182064)
print v(xbgr.mr_n68182176)
print v(xbgr.mr_n68182496)
print v(xbgr.mr_n68182608)
print v(xbgr.mr_n68182928)
print v(xbgr.mr_n68183040)
print v(xbgr.mr_n68183360)
print v(xbgr.mr_n68183472)
print v(xbgr.mr_n68183792)
print v(xbgr.mr_n68183904)
print v(xbgr.mr_n68184224)
print v(xbgr.mr_n68184336)
print v(xbgr.mr_n68184656)
print v(xbgr.mr_n68184768)
print v(xbgr.mr_n68185088)
print v(xbgr.mr_n68185200)
print v(xbgr.mr_n68185520)
print v(xbgr.mr_n68185632)
print v(xbgr.mr_n68185952)
print v(xbgr.mr_n68186064)
print v(xbgr.mr_n68186384)
print v(xbgr.mr_n68186496)
print v(xbgr.mr_n68186816)
print v(xbgr.mr_n68186928)
print v(xbgr.mr_n68187248)
print v(xbgr.mr_n68187360)
print v(xbgr.mr_n68187680)
print v(xbgr.mr_n68187792)
print v(xbgr.mr_n68188112)
print v(xbgr.mr_n68188224)
print v(xbgr.mr_n68188544)
print v(xbgr.mr_n68188656)
print v(xbgr.mr_n68188976)
print v(xbgr.mr_n68189088)
print v(xbgr.mr_n68189408)
print v(xbgr.mr_n68189520)
print v(xbgr.mr_n68189840)
print v(xbgr.mr_n68189952)
print v(xbgr.mr_n68190272)
print v(xbgr.mr_n68190384)
print v(xbgr.mr_n68190704)
print v(xbgr.mr_n68190816)
print v(xbgr.mr_n68191136)
print v(xbgr.mr_n68191248)
print v(xbgr.mr_n68191568)
print v(xbgr.mr_n68191680)
print v(xbgr.mr_n68192000)
print v(xbgr.mr_n68192112)
print v(xbgr.mr_n68192432)
print v(xbgr.mr_n68192544)
print v(xbgr.mr_n68192864)
print v(xbgr.mr_n68192976)
print v(xbgr.mr_n68193296)
print v(xbgr.mr_n68193408)
print v(xbgr.mr_n68193728)
print v(xbgr.mr_n68193840)
print v(xbgr.mr_n68194160)
print v(xbgr.mr_n68194272)
print v(xbgr.mr_n68194592)
print v(xbgr.mr_n68194704)
print v(xbgr.mr_n68195024)
print v(xbgr.mr_n68195136)
print v(xbgr.mr_n68195456)
print v(xbgr.mr_n68195568)
print v(xbgr.mr_n68195888)
print v(xbgr.mr_n68196000)
print v(xbgr.mr_n68196320)
print v(xbgr.mr_n68196432)
print v(xbgr.mr_n68196752)
print v(xbgr.mr_n68196864)
print v(xbgr.mr_n68197184)
print v(xbgr.mr_n68197296)
print v(xbgr.mr_n68197616)
print v(xbgr.mr_n68197728)
print v(xbgr.mr_n68198048)
print v(xbgr.mr_n68198160)
print v(xbgr.mr_n68198480)
print v(xbgr.mr_n68198592)
print v(xbgr.mr_n68198912)
print v(xbgr.mr_n68199024)
print v(xbgr.mr_n68199344)
print v(xbgr.mr_n68199456)
print v(xbgr.mr_n68199776)
print v(xbgr.mr_n68199888)
print v(xbgr.mr_n68200208)
print v(xbgr.mr_n68200320)
print v(xbgr.mr_n68200640)
print v(xbgr.mr_n68200752)
print v(xbgr.mr_n68201072)
print v(xbgr.mr_n68201184)
print v(xbgr.mr_n68201504)
print v(xbgr.mr_n68201616)
print v(xbgr.mr_n68201936)
print v(xbgr.mr_n68202048)
print v(xbgr.mr_n68202368)
print v(xbgr.mr_n68202480)
print v(xbgr.mr_n68202800)
print v(xbgr.mr_n68202912)
print v(xbgr.mr_n68203232)
print v(xbgr.mr_n68203344)
print v(xbgr.mr_n68203664)
print v(xbgr.mr_n68203776)
print v(xbgr.mr_n68204096)
print v(xbgr.mr_n68204208)
print v(xbgr.mr_n68204528)
print v(xbgr.mr_n68204640)
print v(xbgr.mr_n68204960)
print v(xbgr.mr_n68205072)
print v(xbgr.mr_n68205392)
print v(xbgr.mr_n68205504)
print v(xbgr.mr_n68205824)
print v(xbgr.mr_n68205936)
print v(xbgr.mr_n68206256)
print v(xbgr.mr_n68206368)
print v(xbgr.mr_n68206688)
print v(xbgr.mr_n68206800)
print v(xbgr.mr_n68207120)
print v(xbgr.mr_n68207232)
print v(xbgr.mr_n68207552)
print v(xbgr.mr_n68207664)
print v(xbgr.mr_n68207984)
print v(xbgr.mr_n68208096)
print v(xbgr.mr_n68208416)
print v(xbgr.mr_n68208528)
print v(xbgr.mr_n68208848)
print v(xbgr.mr_n68208960)
print v(xbgr.mr_n68209280)
print v(xbgr.mr_n68209392)
print v(xbgr.mr_n68209712)
print v(xbgr.mr_n68209824)
print v(xbgr.mr_n68210144)
print v(xbgr.mr_n68210256)
print v(xbgr.mr_n68210576)
print v(xbgr.mr_n68210688)
print v(xbgr.mr_n68211008)
print v(xbgr.mr_n68211120)
print v(xbgr.mr_n68211440)
print v(xbgr.mr_n68211552)
print v(xbgr.mr_n68211872)
print v(xbgr.mr_n68211984)
print v(xbgr.mr_n68212304)
print v(xbgr.mr_n68212416)
print v(xbgr.mr_n68212736)
print v(xbgr.mr_n68212848)
print v(xbgr.mr_n68213168)
print v(xbgr.mr_n68213280)
print v(xbgr.mr_n68213600)
print v(xbgr.mr_n68213712)
print v(xbgr.mr_n68214032)
print v(xbgr.mr_n68214144)
print v(xbgr.mr_n68214464)
print v(xbgr.mr_n68214576)
print v(xbgr.mr_n68214896)
print v(xbgr.mr_n68215008)
print v(xbgr.mr_n68215328)
print v(xbgr.mr_n68215440)
print v(xbgr.mr_n68215760)
print v(xbgr.mr_n68215872)
print v(xbgr.mr_n68216192)
print v(xbgr.mr_n68216304)
print v(xbgr.mr_n68216624)
print v(xbgr.mr_n68216736)
print v(xbgr.mr_n68217056)
print v(xbgr.mr_n68217168)
print v(xbgr.mr_n68217488)
print v(xbgr.mr_n68217600)
print v(xbgr.mr_n68217920)
print v(xbgr.mr_n68218032)
print v(xbgr.mr_n68218352)
print v(xbgr.mr_n68218464)
print v(xbgr.mr_n68218784)
print v(xbgr.mr_n68218896)
print v(xbgr.mr_n68219216)
print v(xbgr.mr_n68219328)
print v(xbgr.mr_n68219648)
print v(xbgr.mr_n68219760)
print v(xbgr.mr_n68220080)
print v(xbgr.mr_n68220192)
print v(xbgr.mr_n68220512)
print v(xbgr.mr_n68220624)
print v(xbgr.mr_n68220944)
print v(xbgr.mr_n68221056)
print v(xbgr.mr_n68221376)
print v(xbgr.mr_n68221488)
print v(xbgr.mr_n68221808)
print v(xbgr.mr_n68221920)
print v(xbgr.mr_n68222240)
print v(xbgr.mr_n68222352)
print v(xbgr.mr_n68222672)
print v(xbgr.mr_n68222784)
print v(xbgr.mr_n68223104)
print v(xbgr.mr_n68223216)
print v(xbgr.mr_n68223536)
print v(xbgr.mr_n68223648)
print v(xbgr.mr_n68223968)
print v(xbgr.mr_n68224080)
print v(xbgr.mr_n68224400)
print v(xbgr.mr_n68224512)
print v(xbgr.mr_n68224832)
print v(xbgr.mr_n68224944)
print v(xbgr.mr_n68225264)
print v(xbgr.mr_n68225376)
print v(xbgr.mr_n68225696)
print v(xbgr.mr_n68225808)
print v(xbgr.mr_n68226128)
print v(xbgr.mr_n68226240)
print v(xbgr.mr_n68226560)
print v(xbgr.mr_n68226672)
print v(xbgr.mr_n68226992)
print v(xbgr.mr_n68227104)
print v(xbgr.mr_n68227424)
print v(xbgr.mr_n68227536)
print v(xbgr.mr_n68227856)
print v(xbgr.mr_n68227968)
print v(xbgr.mr_n68228288)
print v(xbgr.mr_n68228400)
print v(xbgr.mr_n68228720)
print v(xbgr.mr_n68228832)
print v(xbgr.mr_n68229152)
print v(xbgr.mr_n68229264)
print v(xbgr.mr_n68229584)
print v(xbgr.mr_n68229696)
print v(xbgr.mr_n68230016)
print v(xbgr.mr_n68230128)
print v(xbgr.mr_n68230448)
print v(xbgr.mr_n68230560)
print v(xbgr.mr_n68230880)
print v(xbgr.mr_n68230992)
print v(xbgr.mr_n68231312)
print v(xbgr.mr_n68231424)
print v(xbgr.mr_n68231744)
print v(xbgr.mr_n68231856)
print v(xbgr.mr_n68232176)
print v(xbgr.mr_n68232288)
print v(xbgr.mr_n68232608)
print v(xbgr.mr_n68232720)
print v(xbgr.mr_n68233040)
print v(xbgr.mr_n68233152)
print v(xbgr.mr_n68233472)
print v(xbgr.mr_n68233584)
print v(xbgr.mr_n68233904)
print v(xbgr.mr_n68234016)
print v(xbgr.mr_n68234336)
print v(xbgr.mr_n68234448)
print v(xbgr.mr_n68234768)
print v(xbgr.mr_n68234880)
print v(xbgr.mr_n68235200)
print v(xbgr.mr_n68235312)
print v(xbgr.mr_n68235632)
print v(xbgr.mr_n68235744)
print v(xbgr.mr_n68236064)
print v(xbgr.mr_n68236176)
print v(xbgr.mr_n68236496)
print v(xbgr.mr_n68236608)
print v(xbgr.mr_n68236928)
print v(xbgr.mr_n68237040)
print v(xbgr.mr_n68237360)
print v(xbgr.mr_n68237472)
print v(xbgr.mr_n68237792)
print v(xbgr.mr_n68237904)
print v(xbgr.mr_n68238224)
print v(xbgr.mr_n68238336)
print v(xbgr.mr_n68238656)
print v(xbgr.mr_n68238768)
print v(xbgr.mr_n68239088)
print v(xbgr.mr_n68239200)
print v(xbgr.mr_n68239520)
print v(xbgr.mr_n68239632)
print v(xbgr.mr_n68239952)
print v(xbgr.mr_n68240064)
print v(xbgr.mr_n68240384)
print v(xbgr.mr_n68240496)
print v(xbgr.mr_n68240816)
print v(xbgr.mr_n68240928)
print v(xbgr.mr_n68241248)
print v(xbgr.mr_n68241360)
print v(xbgr.mr_n68241680)
print v(xbgr.mr_n68241792)
print v(xbgr.mr_n68242112)
print v(xbgr.mr_n68242224)
print v(xbgr.mr_n68242544)
print v(xbgr.mr_n68242656)
print v(xbgr.mr_n68242976)
print v(xbgr.mr_n68243088)
print v(xbgr.mr_n68243408)
print v(xbgr.mr_n68243520)
print v(xbgr.mr_n68243840)
print v(xbgr.mr_n68243952)
print v(xbgr.mr_n68244272)
print v(xbgr.mr_n68244384)
print v(xbgr.mr_n68244704)
print v(xbgr.mr_n68244816)
print v(xbgr.mr_n68245136)
print v(xbgr.mr_n68245248)
print v(xbgr.mr_n68245568)
print v(xbgr.mr_n68245680)
print v(xbgr.mr_n68246000)
print v(xbgr.mr_n68246112)
print v(xbgr.mr_n68246432)
print v(xbgr.mr_n68246544)
print v(xbgr.mr_n68246864)
print v(xbgr.mr_n68246976)
print v(xbgr.mr_n68247296)
print v(xbgr.mr_n68247408)
print v(xbgr.mr_n68247840)
print v(xbgr.mr_n68248160)
print v(xbgr.mr_n68248272)
print v(xbgr.mr_n68248704)
print v(xbgr.mr_n68249024)
print v(xbgr.mr_n68249136)
print v(xbgr.mr_n68249568)
print v(xbgr.mr_n68249888)
print v(xbgr.mr_n68250752)
print v(xbgr.mr_n68251616)
print v(xbgr.mr_n68252480)
print v(xbgr.mr_n68253344)
print v(xbgr.mr_n68254208)
print v(xbgr.mr_n68255072)
print v(xbgr.mr_n68255184)
print v(xbgr.mr_n68255504)
print v(xbgr.mr_n68255616)
print v(xbgr.mr_n68255936)
print v(xbgr.mr_n68256048)
print v(xbgr.mr_n68256368)
print v(xbgr.mr_n68256480)
print v(xbgr.mr_n68256800)
print v(xbgr.mr_n68257664)
print v(xbgr.mr_n68258528)
print v(xbgr.mr_n68259392)
print v(xbgr.mr_n68259504)
print v(xbgr.mr_n68259824)
print v(xbgr.mr_n68259936)
print v(xbgr.mr_n68260256)
print v(xbgr.mr_n68260368)
print v(xbgr.mr_n68260800)
print v(xbgr.mr_n68261232)
print v(xbgr.mr_n68261664)
print v(xbgr.mr_n68261984)
print v(xbgr.mr_n68262096)
print v(xbgr.mr_n68262416)
print v(xbgr.mr_n68262528)
print v(xbgr.mr_n68262848)
print v(xbgr.mr_n68262960)
print v(xbgr.mr_n68263280)
print v(xbgr.mr_n68263392)
print v(xbgr.mr_n68263712)
print v(xbgr.mr_n68263824)
print v(xbgr.mr_n68264144)
print v(xbgr.mr_n68264256)
print v(xbgr.mr_n68264576)
print v(xbgr.mr_n68264688)
print v(xbgr.mr_n68265008)
print v(xbgr.mr_n68265120)
print v(xbgr.mr_n68265440)
print v(xbgr.mr_n68265552)
print v(xbgr.mr_n68265872)
print v(xbgr.mr_n68265984)
print v(xbgr.mr_n68266304)
print v(xbgr.mr_n68266416)
print v(xbgr.mr_n68266736)
print v(xbgr.mr_n68266848)
print v(xbgr.mr_n68267168)
print v(xbgr.mr_n68267280)
print v(xbgr.mr_n68267600)
print v(xbgr.mr_n68267712)
print v(xbgr.mr_n68268032)
print v(xbgr.mr_n68268144)
print v(xbgr.mr_n68268464)
print v(xbgr.mr_n68268576)
print v(xbgr.mr_n68268896)
print v(xbgr.mr_n68269008)
print v(xbgr.mr_n68269328)
print v(xbgr.mr_n68269440)
print v(xbgr.mr_n68269760)
print v(xbgr.mr_n68269872)
print v(xbgr.mr_n68270192)
print v(xbgr.mr_n68270304)
print v(xbgr.mr_n68270624)
print v(xbgr.mr_n68270736)
print v(xbgr.mr_n68271056)
print v(xbgr.mr_n68271168)
print v(xbgr.mr_n68271488)
print v(xbgr.mr_n68271600)
print v(xbgr.mr_n68271920)
print v(xbgr.mr_n68272032)
print v(xbgr.mr_n68272352)
print v(xbgr.mr_n68272464)
print v(xbgr.mr_n68272784)
print v(xbgr.mr_n68272896)
print v(xbgr.mr_n68273216)
print v(xbgr.mr_n68273328)
print v(xbgr.mr_n68273648)
print v(xbgr.mr_n68273760)
print v(xbgr.mr_n68274080)
print v(xbgr.mr_n68274192)
print v(xbgr.mr_n68274512)
print v(xbgr.mr_n68274624)
print v(xbgr.mr_n68274944)
print v(xbgr.mr_n68275056)
print v(xbgr.mr_n68275488)
print v(xbgr.mr_n68275808)
print v(xbgr.mr_n68275920)
print v(xbgr.mr_n68276352)
print v(xbgr.mr_n68276672)
print v(xbgr.mr_n68277536)
print v(xbgr.mr_n68278400)
print v(xbgr.mr_n68279264)
print v(xbgr.mr_n68280128)
print v(xbgr.mr_n68280240)
print v(xbgr.mr_n68280560)
print v(xbgr.mr_n68280672)
print v(xbgr.mr_n68280992)
print v(xbgr.mr_n68281104)
print v(xbgr.mr_n68281424)
print v(xbgr.mr_n68281536)
print v(xbgr.mr_n68281856)
print v(xbgr.mr_n68282720)
print v(xbgr.mr_n68283584)
print v(xbgr.mr_n68283696)
print v(xbgr.mr_n68284016)
print v(xbgr.mr_n68284128)
print v(xbgr.mr_n68284448)
print v(xbgr.mr_n68284560)
print v(xbgr.mr_n68284880)
print v(xbgr.mr_n68284992)
print v(xbgr.mr_n68285312)
print v(xbgr.mr_n68285424)
print v(xbgr.mr_n68285856)
print v(xbgr.mr_n68286176)
print v(xbgr.mr_n68286288)
print v(xbgr.mr_n68286720)
print v(xbgr.mr_n68287040)
print v(xbgr.mr_n68287904)
print v(xbgr.mr_n68288768)
print v(xbgr.mr_n68289632)
print v(xbgr.mr_n68290496)
print v(xbgr.mr_n68290608)
print v(xbgr.mr_n68290928)
print v(xbgr.mr_n68291040)
print v(xbgr.mr_n68291360)
print v(xbgr.mr_n68291472)
print v(xbgr.mr_n68291792)
print v(xbgr.mr_n68291904)
print v(xbgr.mr_n68292224)
print v(xbgr.mr_n68293088)
print v(xbgr.mr_n68293952)
print v(xbgr.mr_n68294064)
print v(xbgr.mr_n68294496)
print v(xbgr.mr_n68294816)
print v(xbgr.mr_n68294928)
print v(xbgr.mr_n68295248)
print v(xbgr.mr_n68295360)
print v(xbgr.mr_n68295680)
print v(xbgr.mr_n68295792)
print v(xbgr.mr_n68296112)
print v(xbgr.mr_n68296224)
print v(xbgr.mr_n68296544)
print v(xbgr.mr_n68296656)
print v(xbgr.mr_n68297088)
print v(xbgr.mr_n68297408)
print v(xbgr.mr_n68298272)
print v(xbgr.mr_n68298384)
print v(xbgr.mr_n68298816)
print v(xbgr.mr_n68299136)
print v(xbgr.mr_n68299248)
print v(xbgr.mr_n68299680)
print v(xbgr.mr_n68300000)
print v(xbgr.mr_n68300112)
print v(xbgr.mr_n68300432)
print v(xbgr.mr_n68300544)
print v(xbgr.mr_n68300864)
print v(xbgr.mr_n68300976)
print v(xbgr.mr_n68301296)
print v(xbgr.mr_n68301408)
print v(xbgr.mr_n68301728)
print v(xbgr.mr_n68302592)
print v(xbgr.mr_n68303456)
print v(xbgr.mr_n68303568)
print v(xbgr.mr_n68303888)
print v(xbgr.mr_n68304000)
print v(xbgr.mr_n68304320)
print v(xbgr.mr_n68304432)
print v(xbgr.mr_n68304752)
print v(xbgr.mr_n68304864)
print v(xbgr.mr_n68305184)
print v(xbgr.mr_n68306048)
print v(xbgr.mr_n68306912)
print v(xbgr.mr_n68307024)
print v(xbgr.mr_n68307344)
print v(xbgr.mr_n68307456)
print v(xbgr.mr_n68307776)
print v(xbgr.mr_n68308640)
print v(xbgr.mr_n68308752)
print v(xbgr.mr_n68309072)
print v(xbgr.mr_n68309184)
print v(xbgr.mr_n68309504)
print v(xbgr.mr_n68309616)
print v(xbgr.mr_n68309936)
print v(xbgr.mr_n68310048)
print v(xbgr.mr_n68310368)
print v(xbgr.mr_n68310480)
print v(xbgr.mr_n68310800)
print v(xbgr.mr_n68310912)
print v(xbgr.mr_n68311232)
print v(xbgr.mr_n68312096)
print v(xbgr.mr_n68312896)
print v(xbgr.mr_n68313008)
print v(xbgr.mr_n68313328)
print v(xbgr.mr_n68313440)
print v(xbgr.mr_n68313760)
print v(xbgr.mr_n68313872)
print v(xbgr.mr_n68314192)
print v(xbgr.mr_n68314304)
print v(xbgr.mr_n68314624)
print v(xbgr.mr_n68314736)
print v(xbgr.mr_n68315056)
print v(xbgr.mr_n68315168)
print v(xbgr.mr_n68315488)
print v(xbgr.mr_n68315600)
print v(xbgr.mr_n68315920)
print v(xbgr.mr_n68316032)
print v(xbgr.mr_n68316352)
print v(xbgr.mr_n68316464)
print v(xbgr.mr_n68316784)
print v(xbgr.mr_n68316896)
print v(xbgr.mr_n68317216)
print v(xbgr.mr_n68317328)
print v(xbgr.mr_n68317648)
print v(xbgr.mr_n68317760)
print v(xbgr.mr_n68318080)
print v(xbgr.mr_n68318192)
print v(xbgr.mr_n68318512)
print v(xbgr.mr_n68318624)
print v(xbgr.mr_n68318944)
print v(xbgr.mr_n68319056)
print v(xbgr.mr_n68319376)
print v(xbgr.mr_n68319488)
print v(xbgr.mr_n68319808)
print v(xbgr.mr_n68319920)
print v(xbgr.mr_n68320240)
print v(xbgr.mr_n68320352)
print v(xbgr.mr_n68320672)
print v(xbgr.mr_n68320784)
print v(xbgr.mr_n68321104)
print v(xbgr.mr_n68321216)
print v(xbgr.mr_n68321536)
print v(xbgr.mr_n68321648)
print v(xbgr.mr_n68321968)
print v(xbgr.mr_n68322080)
print v(xbgr.mr_n68322400)
print v(xbgr.mr_n68322512)
print v(xbgr.mr_n68322832)
print v(xbgr.mr_n68322944)
print v(xbgr.mr_n68323264)
print v(xbgr.mr_n68323376)
print v(xbgr.mr_n68323696)
print v(xbgr.mr_n68323808)
print v(xbgr.mr_n68324128)
print v(xbgr.mr_n68324240)
print v(xbgr.mr_n68324560)
print v(xbgr.mr_n68324672)
print v(xbgr.mr_n68324992)
print v(xbgr.mr_n68325104)
print v(xbgr.mr_n68325424)
print v(xbgr.mr_n68325536)
print v(xbgr.mr_n68325856)
print v(xbgr.mr_n68325968)
print v(xbgr.mr_n68326288)
print v(xbgr.mr_n68326400)
print v(xbgr.mr_n68326720)
print v(xbgr.mr_n68326832)
print v(xbgr.mr_n68327152)
print v(xbgr.mr_n68327264)
print v(xbgr.mr_n68327584)
print v(xbgr.mr_n68327696)
print v(xbgr.mr_n68328016)
print v(xbgr.mr_n68328128)
print v(xbgr.mr_n68328448)
print v(xbgr.mr_n68328560)
print v(xbgr.mr_n68328880)
print v(xbgr.mr_n68328992)
print v(xbgr.mr_n68329312)
print v(xbgr.mr_n68329424)
print v(xbgr.mr_n68329744)
print v(xbgr.mr_n68329856)
print v(xbgr.mr_n68330176)
print v(xbgr.mr_n68330288)
print v(xbgr.mr_n68330608)
print v(xbgr.mr_n68330720)
print v(xbgr.mr_n68331040)
print v(xbgr.mr_n68331152)
print v(xbgr.mr_n68331472)
print v(xbgr.mr_n68331584)
print v(xbgr.mr_n68331904)
print v(xbgr.mr_n68332016)
print v(xbgr.mr_n68332336)
print v(xbgr.mr_n68332448)
print v(xbgr.mr_n68332768)
print v(xbgr.mr_n68332880)
print v(xbgr.mr_n68333200)
print v(xbgr.mr_n68333312)
print v(xbgr.mr_n68333632)
print v(xbgr.mr_n68333744)
print v(xbgr.mr_n68334064)
print v(xbgr.mr_n68334176)
print v(xbgr.mr_n68334496)
print v(xbgr.mr_n68334608)
print v(xbgr.mr_n68334928)
print v(xbgr.mr_n68335040)
print v(xbgr.mr_n68335360)
print v(xbgr.mr_n68335472)
print v(xbgr.mr_n68335792)
print v(xbgr.mr_n68335904)
print v(xbgr.mr_n68336224)
print v(xbgr.mr_n68336336)
print v(xbgr.mr_n68336656)
print v(xbgr.mr_n68336768)
print v(xbgr.mr_n68337088)
print v(xbgr.mr_n68337200)
print v(xbgr.mr_n68337520)
print v(xbgr.mr_n68337632)
print v(xbgr.mr_n68337952)
print v(xbgr.mr_n68338064)
print v(xbgr.mr_n68338384)
print v(xbgr.mr_n68338496)
print v(xbgr.mr_n68338816)
print v(xbgr.mr_n68338928)
print v(xbgr.mr_n68339248)
print v(xbgr.mr_n68339360)
print v(xbgr.mr_n68339680)
print v(xbgr.mr_n68339792)
print v(xbgr.mr_n68340112)
print v(xbgr.mr_n68340224)
print v(xbgr.mr_n68340544)
print v(xbgr.mr_n68340656)
print v(xbgr.mr_n68340976)
print v(xbgr.mr_n68341088)
print v(xbgr.mr_n68341408)
print v(xbgr.mr_n68341520)
print v(xbgr.mr_n68341840)
print v(xbgr.mr_n68341952)
print v(xbgr.mr_n68342272)
print v(xbgr.mr_n68342384)
print v(xbgr.mr_n68342704)
print v(xbgr.mr_n68342816)
print v(xbgr.mr_n68343136)
print v(xbgr.mr_n68343248)
print v(xbgr.mr_n68343568)
print v(xbgr.mr_n68343680)
print v(xbgr.mr_n68344000)
print v(xbgr.mr_n68344112)
print v(xbgr.mr_n68344432)
print v(xbgr.mr_n68344544)
print v(xbgr.mr_n68344864)
print v(xbgr.mr_n68344976)
print v(xbgr.mr_n68345296)
print v(xbgr.mr_n68345408)
print v(xbgr.mr_n68345728)
print v(xbgr.mr_n68345840)
print v(xbgr.mr_n68346160)
print v(xbgr.mr_n68346272)
print v(xbgr.mr_n68346592)
print v(xbgr.mr_n68346704)
print v(xbgr.mr_n68347024)
print v(xbgr.mr_n68347136)
print v(xbgr.mr_n68347456)
print v(xbgr.mr_n68347568)
print v(xbgr.mr_n68347888)
print v(xbgr.mr_n68348000)
print v(xbgr.mr_n68348320)
print v(xbgr.mr_n68348432)
print v(xbgr.mr_n68348752)
print v(xbgr.mr_n68348864)
print v(xbgr.mr_n68349184)
print v(xbgr.mr_n68349296)
print v(xbgr.mr_n68349616)
print v(xbgr.mr_n68349728)
print v(xbgr.mr_n68350048)
print v(xbgr.mr_n68350160)
print v(xbgr.mr_n68350480)
print v(xbgr.mr_n68350592)
print v(xbgr.mr_n68350912)
print v(xbgr.mr_n68351024)
print v(xbgr.mr_n68351344)
print v(xbgr.mr_n68351456)
print v(xbgr.mr_n68351776)
print v(xbgr.mr_n68351888)
print v(xbgr.mr_n68352208)
print v(xbgr.mr_n68352320)
print v(xbgr.mr_n68352640)
print v(xbgr.mr_n68352752)
print v(xbgr.mr_n68353072)
print v(xbgr.mr_n68353184)
print v(xbgr.mr_n68353504)
print v(xbgr.mr_n68353616)
print v(xbgr.mr_n68353936)
print v(xbgr.mr_n68354048)
print v(xbgr.mr_n68354368)
print v(xbgr.mr_n68354480)
print v(xbgr.mr_n68354800)
print v(xbgr.mr_n68354912)
print v(xbgr.mr_n68355232)
print v(xbgr.mr_n68355344)
print v(xbgr.mr_n68355664)
print v(xbgr.mr_n68355776)
print v(xbgr.mr_n68356096)
print v(xbgr.mr_n68356208)
print v(xbgr.mr_n68356528)
print v(xbgr.mr_n68356640)
print v(xbgr.mr_n68356960)
print v(xbgr.mr_n68357072)
print v(xbgr.mr_n68357392)
print v(xbgr.mr_n68357504)
print v(xbgr.mr_n68357824)
print v(xbgr.mr_n68357936)
print v(xbgr.mr_n68358256)
print v(xbgr.mr_n68358368)
print v(xbgr.mr_n68358688)
print v(xbgr.mr_n68358800)
print v(xbgr.mr_n68359120)
print v(xbgr.mr_n68359232)
print v(xbgr.mr_n68359552)
print v(xbgr.mr_n68359664)
print v(xbgr.mr_n68359984)
print v(xbgr.mr_n68360096)
print v(xbgr.mr_n68360416)
print v(xbgr.mr_n68360528)
print v(xbgr.mr_n68360848)
print v(xbgr.mr_n68360960)
print v(xbgr.mr_n68361280)
print v(xbgr.mr_n68361392)
print v(xbgr.mr_n68361712)
print v(xbgr.mr_n68361824)
print v(xbgr.mr_n68362144)
print v(xbgr.mr_n68362256)
print v(xbgr.mr_n68362576)
print v(xbgr.mr_n68362688)
print v(xbgr.mr_n68363008)
print v(xbgr.mr_n68363120)
print v(xbgr.mr_n68363440)
print v(xbgr.mr_n68363552)
print v(xbgr.mr_n68363872)
print v(xbgr.mr_n68363984)
print v(xbgr.mr_n68364304)
print v(xbgr.mr_n68364416)
print v(xbgr.mr_n68364736)
print v(xbgr.mr_n68364848)
print v(xbgr.mr_n68365168)
print v(xbgr.mr_n68365280)
print v(xbgr.mr_n68365600)
print v(xbgr.mr_n68365712)
print v(xbgr.mr_n68366032)
print v(xbgr.mr_n68366144)
print v(xbgr.mr_n68366464)
print v(xbgr.mr_n68366576)
print v(xbgr.mr_n68366896)
print v(xbgr.mr_n68367008)
print v(xbgr.mr_n68367328)
print v(xbgr.mr_n68367440)
print v(xbgr.mr_n68367760)
print v(xbgr.mr_n68367872)
print v(xbgr.mr_n68368192)
print v(xbgr.mr_n68368304)
print v(xbgr.mr_n68368624)
print v(xbgr.mr_n68368736)
print v(xbgr.mr_n68369056)
print v(xbgr.mr_n68369168)
print v(xbgr.mr_n68369488)
print v(xbgr.mr_n68369600)
print v(xbgr.mr_n68369920)
print v(xbgr.mr_n68370032)
print v(xbgr.mr_n68370352)
print v(xbgr.mr_n68370464)
print v(xbgr.mr_n68370784)
print v(xbgr.mr_n68370896)
print v(xbgr.mr_n68371216)
print v(xbgr.mr_n68371328)
print v(xbgr.mr_n68371648)
print v(xbgr.mr_n68371760)
print v(xbgr.mr_n68372080)
print v(xbgr.mr_n68372192)
print v(xbgr.mr_n68372512)
print v(xbgr.mr_n68372624)
print v(xbgr.mr_n68372944)
print v(xbgr.mr_n68373056)
print v(xbgr.mr_n68373376)
print v(xbgr.mr_n68373488)
print v(xbgr.mr_n68373808)
print v(xbgr.mr_n68373920)
print v(xbgr.mr_n68374240)
print v(xbgr.mr_n68374352)
print v(xbgr.mr_n68374672)
print v(xbgr.mr_n68374784)
print v(xbgr.mr_n68375104)
print v(xbgr.mr_n68375216)
print v(xbgr.mr_n68375536)
print v(xbgr.mr_n68375648)
print v(xbgr.mr_n68375968)
print v(xbgr.mr_n68376080)
print v(xbgr.mr_n68376400)
print v(xbgr.mr_n68376512)
print v(xbgr.mr_n68376832)
print v(xbgr.mr_n68376944)
print v(xbgr.mr_n68377264)
print v(xbgr.mr_n68377376)
print v(xbgr.mr_n68377696)
print v(xbgr.mr_n68377808)
print v(xbgr.mr_n68378128)
print v(xbgr.mr_n68378240)
print v(xbgr.mr_n68378560)
print v(xbgr.mr_n68378672)
print v(xbgr.mr_n68378992)
print v(xbgr.mr_n68379104)
print v(xbgr.mr_n68379424)
print v(xbgr.mr_n68379536)
print v(xbgr.mr_n68379856)
print v(xbgr.mr_n68379968)
print v(xbgr.mr_n68380288)
print v(xbgr.mr_n68380400)
print v(xbgr.mr_n68380720)
print v(xbgr.mr_n68380832)
print v(xbgr.mr_n68381152)
print v(xbgr.mr_n68381264)
print v(xbgr.mr_n68381584)
print v(xbgr.mr_n68381696)
print v(xbgr.mr_n68382016)
print v(xbgr.mr_n68382128)
print v(xbgr.mr_n68382448)
print v(xbgr.mr_n68382560)
print v(xbgr.mr_n68382880)
print v(xbgr.mr_n68382992)
print v(xbgr.mr_n68383312)
print v(xbgr.mr_n68383424)
print v(xbgr.mr_n68383744)
print v(xbgr.mr_n68383856)
print v(xbgr.mr_n68384176)
print v(xbgr.mr_n68384288)
print v(xbgr.mr_n68384608)
print v(xbgr.mr_n68384720)
print v(xbgr.mr_n68385040)
print v(xbgr.mr_n68385152)
print v(xbgr.mr_n68385472)
print v(xbgr.mr_n68385584)
print v(xbgr.mr_n68385904)
print v(xbgr.mr_n68386016)
print v(xbgr.mr_n68386336)
print v(xbgr.mr_n68386448)
print v(xbgr.mr_n68386768)
print v(xbgr.mr_n68386880)
print v(xbgr.mr_n68387200)
print v(xbgr.mr_n68387312)
print v(xbgr.mr_n68387632)
print v(xbgr.mr_n68387744)
print v(xbgr.mr_n68388064)
print v(xbgr.mr_n68388176)
print v(xbgr.mr_n68388496)
print v(xbgr.mr_n68388608)
print v(xbgr.mr_n68388928)
print v(xbgr.mr_n68389040)
print v(xbgr.mr_n68389360)
print v(xbgr.mr_n68389472)
print v(xbgr.mr_n68389792)
print v(xbgr.mr_n68389904)
print v(xbgr.mr_n68390224)
print v(xbgr.mr_n68390336)
print v(xbgr.mr_n68390656)
print v(xbgr.mr_n68390768)
print v(xbgr.mr_n68391088)
print v(xbgr.mr_n68391200)
print v(xbgr.mr_n68391520)
print v(xbgr.mr_n68391632)
print v(xbgr.mr_n68391952)
print v(xbgr.mr_n68392064)
print v(xbgr.mr_n68392384)
print v(xbgr.mr_n68392496)
print v(xbgr.mr_n68392816)
print v(xbgr.mr_n68392928)
print v(xbgr.mr_n68393248)
print v(xbgr.mr_n68393360)
print v(xbgr.mr_n68393680)
print v(xbgr.mr_n68393792)
print v(xbgr.mr_n68394112)
print v(xbgr.mr_n68394224)
print v(xbgr.mr_n68394544)
print v(xbgr.mr_n68394656)
print v(xbgr.mr_n68394976)
print v(xbgr.mr_n68395088)
print v(xbgr.mr_n68395408)
print v(xbgr.mr_n68395520)
print v(xbgr.mr_n68395840)
print v(xbgr.mr_n68395952)
print v(xbgr.mr_n68396272)
print v(xbgr.mr_n68396384)
print v(xbgr.mr_n68396704)
print v(xbgr.mr_n68396816)
print v(xbgr.mr_n68397136)
print v(xbgr.mr_n68397248)
print v(xbgr.mr_n68397568)
print v(xbgr.mr_n68397680)
print v(xbgr.mr_n68398000)
print v(xbgr.mr_n68398112)
print v(xbgr.mr_n68398432)
print v(xbgr.mr_n68398544)
print v(xbgr.mr_n68398864)
print v(xbgr.mr_n68398976)
print v(xbgr.mr_n68399296)
print v(xbgr.mr_n68399408)
print v(xbgr.mr_n68399728)
print v(xbgr.mr_n68399840)
print v(xbgr.mr_n68400160)
print v(xbgr.mr_n68400272)
print v(xbgr.mr_n68400592)
print v(xbgr.mr_n68400704)
print v(xbgr.mr_n68401024)
print v(xbgr.mr_n68401136)
print v(xbgr.mr_n68401456)
print v(xbgr.mr_n68401568)
print v(xbgr.mr_n68401888)
print v(xbgr.mr_n68402000)
print v(xbgr.mr_n68402320)
print v(xbgr.mr_n68402432)
print v(xbgr.mr_n68402752)
print v(xbgr.mr_n68402864)
print v(xbgr.mr_n68403184)
print v(xbgr.mr_n68403296)
print v(xbgr.mr_n68403616)
print v(xbgr.mr_n68403728)
print v(xbgr.mr_n68404048)
print v(xbgr.mr_n68404160)
print v(xbgr.mr_n68404480)
print v(xbgr.mr_n68404592)
print v(xbgr.mr_n68404912)
print v(xbgr.mr_n68405024)
print v(xbgr.mr_n68405344)
print v(xbgr.mr_n68405456)
print v(xbgr.mr_n68405776)
print v(xbgr.mr_n68405888)
print v(xbgr.mr_n68406208)
print v(xbgr.mr_n68406320)
print v(xbgr.mr_n68406640)
print v(xbgr.mr_n68406752)
print v(xbgr.mr_n68407072)
print v(xbgr.mr_n68407184)
print v(xbgr.mr_n68407504)
print v(xbgr.mr_n68407616)
print v(xbgr.mr_n68407936)
print v(xbgr.mr_n68408048)
print v(xbgr.mr_n68408368)
print v(xbgr.mr_n68408480)
print v(xbgr.mr_n68408800)
print v(xbgr.mr_n68408912)
print v(xbgr.mr_n68409232)
print v(xbgr.mr_n68409344)
print v(xbgr.mr_n68409664)
print v(xbgr.mr_n68409776)
print v(xbgr.mr_n68410096)
print v(xbgr.mr_n68410208)
print v(xbgr.mr_n68410528)
print v(xbgr.mr_n68410640)
print v(xbgr.mr_n68410960)
print v(xbgr.mr_n68411072)
print v(xbgr.mr_n68411392)
print v(xbgr.mr_n68411504)
print v(xbgr.mr_n68411824)
print v(xbgr.mr_n68411936)
print v(xbgr.mr_n68412256)
print v(xbgr.mr_n68412368)
print v(xbgr.mr_n68412688)
print v(xbgr.mr_n68412800)
print v(xbgr.mr_n68413120)
print v(xbgr.mr_n68413232)
print v(xbgr.mr_n68413552)
print v(xbgr.mr_n68413664)
print v(xbgr.mr_n68413984)
print v(xbgr.mr_n68414096)
print v(xbgr.mr_n68414416)
print v(xbgr.mr_n68414528)
print v(xbgr.mr_n68414848)
print v(xbgr.mr_n68414960)
print v(xbgr.mr_n68415280)
print v(xbgr.mr_n68415392)
print v(xbgr.mr_n68415712)
print v(xbgr.mr_n68415824)
print v(xbgr.mr_n68416144)
print v(xbgr.mr_n68416256)
print v(xbgr.mr_n68416576)
print v(xbgr.mr_n68416688)
print v(xbgr.mr_n68417008)
print v(xbgr.mr_n68417120)
print v(xbgr.mr_n68417440)
print v(xbgr.mr_n68417552)
print v(xbgr.mr_n68417872)
print v(xbgr.mr_n68417984)
print v(xbgr.mr_n68418304)
print v(xbgr.mr_n68418416)
print v(xbgr.mr_n68418736)
print v(xbgr.mr_n68418848)
print v(xbgr.mr_n68419168)
print v(xbgr.mr_n68419280)
print v(xbgr.mr_n68419600)
print v(xbgr.mr_n68419712)
print v(xbgr.mr_n68420032)
print v(xbgr.mr_n68420144)
print v(xbgr.mr_n68420464)
print v(xbgr.mr_n68420576)
print v(xbgr.mr_n68420896)
print v(xbgr.mr_n68421008)
print v(xbgr.mr_n68421328)
print v(xbgr.mr_n68421440)
print v(xbgr.mr_n68421760)
print v(xbgr.mr_n68421872)
print v(xbgr.mr_n68422192)
print v(xbgr.mr_n68422304)
print v(xbgr.mr_n68422624)
print v(xbgr.mr_n68422736)
print v(xbgr.mr_n68423056)
print v(xbgr.mr_n68423168)
print v(xbgr.mr_n68423488)
print v(xbgr.mr_n68423600)
print v(xbgr.mr_n68423920)
print v(xbgr.mr_n68424032)
print v(xbgr.mr_n68424352)
print v(xbgr.mr_n68424464)
print v(xbgr.mr_n68424784)
print v(xbgr.mr_n68424896)
print v(xbgr.mr_n68425216)
print v(xbgr.mr_n68425328)
print v(xbgr.mr_n68425648)
print v(xbgr.mr_n68425760)
print v(xbgr.mr_n68426080)
print v(xbgr.mr_n68426192)
print v(xbgr.mr_n68426512)
print v(xbgr.mr_n68426624)
print v(xbgr.mr_n68426944)
print v(xbgr.mr_n68427056)
print v(xbgr.mr_n68427376)
print v(xbgr.mr_n68427488)
print v(xbgr.mr_n68427808)
print v(xbgr.mr_n68427920)
print v(xbgr.mr_n68428240)
print v(xbgr.mr_n68428352)
print v(xbgr.mr_n68428672)
print v(xbgr.mr_n68428784)
print v(xbgr.mr_n68429104)
print v(xbgr.mr_n68429216)
print v(xbgr.mr_n68429536)
print v(xbgr.mr_n68429648)
print v(xbgr.mr_n68429968)
print v(xbgr.mr_n68430080)
print v(xbgr.mr_n68430400)
print v(xbgr.mr_n68430512)
print v(xbgr.mr_n68430832)
print v(xbgr.mr_n68430944)
print v(xbgr.mr_n68431264)
print v(xbgr.mr_n68431376)
print v(xbgr.mr_n68431696)
print v(xbgr.mr_n68431808)
print v(xbgr.mr_n68432128)
print v(xbgr.mr_n68432240)
print v(xbgr.mr_n68432560)
print v(xbgr.mr_n68432672)
print v(xbgr.mr_n68432992)
print v(xbgr.mr_n68433104)
print v(xbgr.mr_n68433424)
print v(xbgr.mr_n68433536)
print v(xbgr.mr_n68433856)
print v(xbgr.mr_n68433968)
print v(xbgr.mr_n68434288)
print v(xbgr.mr_n68434400)
print v(xbgr.mr_n68434720)
print v(xbgr.mr_n68434832)
print v(xbgr.mr_n68435152)
print v(xbgr.mr_n68435264)
print v(xbgr.mr_n68435584)
print v(xbgr.mr_n68435696)
print v(xbgr.mr_n68436016)
print v(xbgr.mr_n68436128)
print v(xbgr.mr_n68436448)
print v(xbgr.mr_n68436560)
print v(xbgr.mr_n68436880)
print v(xbgr.mr_n68436992)
print v(xbgr.mr_n68437312)
print v(xbgr.mr_n68437424)
print v(xbgr.mr_n68437744)
print v(xbgr.mr_n68437856)
print v(xbgr.mr_n68438176)
print v(xbgr.mr_n68438288)
print v(xbgr.mr_n68438608)
print v(xbgr.mr_n68438720)
print v(xbgr.mr_n68439040)
print v(xbgr.mr_n68439152)
print v(xbgr.mr_n68439472)
print v(xbgr.mr_n68439584)
print v(xbgr.mr_n68439904)
print v(xbgr.mr_n68440016)
print v(xbgr.mr_n68440336)
print v(xbgr.mr_n68440448)
print v(xbgr.mr_n68440768)
print v(xbgr.mr_n68440880)
print v(xbgr.mr_n68441200)
print v(xbgr.mr_n68441312)
print v(xbgr.mr_n68441632)
print v(xbgr.mr_n68441744)
print v(xbgr.mr_n68442064)
print v(xbgr.mr_n68442176)
print v(xbgr.mr_n68442496)
print v(xbgr.mr_n68442608)
print v(xbgr.mr_n68442928)
print v(xbgr.mr_n68443040)
print v(xbgr.mr_n68443360)
print v(xbgr.mr_n68443472)
print v(xbgr.mr_n68443792)
print v(xbgr.mr_n68443904)
print v(xbgr.mr_n68444224)
print v(xbgr.mr_n68444336)
print v(xbgr.mr_n68444656)
print v(xbgr.mr_n68444768)
print v(xbgr.mr_n68445088)
print v(xbgr.mr_n68445200)
print v(xbgr.mr_n68445520)
print v(xbgr.mr_n68445632)
print v(xbgr.mr_n68445952)
print v(xbgr.mr_n68446064)
print v(xbgr.mr_n68446384)
print v(xbgr.mr_n68446496)
print v(xbgr.mr_n68446816)
print v(xbgr.mr_n68446928)
print v(xbgr.mr_n68447248)
print v(xbgr.mr_n68447360)
print v(xbgr.mr_n68447680)
print v(xbgr.mr_n68447792)
print v(xbgr.mr_n68448112)
print v(xbgr.mr_n68448224)
print v(xbgr.mr_n68448544)
print v(xbgr.mr_n68448656)
print v(xbgr.mr_n68448976)
print v(xbgr.mr_n68449088)
print v(xbgr.mr_n68449408)
print v(xbgr.mr_n68449520)
print v(xbgr.mr_n68449840)
print v(xbgr.mr_n68449952)
print v(xbgr.mr_n68450272)
print v(xbgr.mr_n68450384)
print v(xbgr.mr_n68450704)
print v(xbgr.mr_n68450816)
print v(xbgr.mr_n68451136)
print v(xbgr.mr_n68451248)
print v(xbgr.mr_n68451568)
print v(xbgr.mr_n68451680)
print v(xbgr.mr_n68452000)
print v(xbgr.mr_n68452112)
print v(xbgr.mr_n68452432)
print v(xbgr.mr_n68452544)
print v(xbgr.mr_n68452864)
print v(xbgr.mr_n68452976)
print v(xbgr.mr_n68453296)
print v(xbgr.mr_n68453408)
print v(xbgr.mr_n68453728)
print v(xbgr.mr_n68453840)
print v(xbgr.mr_n68454160)
print v(xbgr.mr_n68454272)
print v(xbgr.mr_n68454592)
print v(xbgr.mr_n68454704)
print v(xbgr.mr_n68455024)
print v(xbgr.mr_n68455136)
print v(xbgr.mr_n68455456)
print v(xbgr.mr_n68455568)
print v(xbgr.mr_n68455888)
print v(xbgr.mr_n68456000)
print v(xbgr.mr_n68456320)
print v(xbgr.mr_n68456432)
print v(xbgr.mr_n68456752)
print v(xbgr.mr_n68456864)
print v(xbgr.mr_n68457184)
print v(xbgr.mr_n68457296)
print v(xbgr.mr_n68457616)
print v(xbgr.mr_n68457728)
print v(xbgr.mr_n68458048)
print v(xbgr.mr_n68458160)
print v(xbgr.mr_n68458480)
print v(xbgr.mr_n68458592)
print v(xbgr.mr_n68458912)
print v(xbgr.mr_n68459024)
print v(xbgr.mr_n68459344)
print v(xbgr.mr_n68459456)
print v(xbgr.mr_n68459776)
print v(xbgr.mr_n68459888)
print v(xbgr.mr_n68460208)
print v(xbgr.mr_n68460320)
print v(xbgr.mr_n68460640)
print v(xbgr.mr_n68460752)
print v(xbgr.mr_n68461072)
print v(xbgr.mr_n68461184)
print v(xbgr.mr_n68461504)
print v(xbgr.mr_n68461616)
print v(xbgr.mr_n68461936)
print v(xbgr.mr_n68462048)
print v(xbgr.mr_n68462368)
print v(xbgr.mr_n68462480)
print v(xbgr.mr_n68462800)
print v(xbgr.mr_n68462912)
print v(xbgr.mr_n68463232)
print v(xbgr.mr_n68463344)
print v(xbgr.mr_n68463664)
print v(xbgr.mr_n68463776)
print v(xbgr.mr_n68464096)
print v(xbgr.mr_n68464208)
print v(xbgr.mr_n68464528)
print v(xbgr.mr_n68464640)
print v(xbgr.mr_n68464960)
print v(xbgr.mr_n68465072)
print v(xbgr.mr_n68465392)
print v(xbgr.mr_n68465504)
print v(xbgr.mr_n68465824)
print v(xbgr.mr_n68465936)
print v(xbgr.mr_n68466256)
print v(xbgr.mr_n68466368)
print v(xbgr.mr_n68466688)
print v(xbgr.mr_n68466800)
print v(xbgr.mr_n68467120)
print v(xbgr.mr_n68467232)
print v(xbgr.mr_n68467552)
print v(xbgr.mr_n68467664)
print v(xbgr.mr_n68467984)
print v(xbgr.mr_n68468096)
print v(xbgr.mr_n68468416)
print v(xbgr.mr_n68468528)
print v(xbgr.mr_n68468848)
print v(xbgr.mr_n68468960)
print v(xbgr.mr_n68469280)
print v(xbgr.mr_n68469392)
print v(xbgr.mr_n68469712)
print v(xbgr.mr_n68469824)
print v(xbgr.mr_n68470144)
print v(xbgr.mr_n68470256)
print v(xbgr.mr_n68470576)
print v(xbgr.mr_n68470688)
print v(xbgr.mr_n68471008)
print v(xbgr.mr_n68471120)
print v(xbgr.mr_n68471440)
print v(xbgr.mr_n68471552)
print v(xbgr.mr_n68471872)
print v(xbgr.mr_n68471984)
print v(xbgr.mr_n68472304)
print v(xbgr.mr_n68472416)
print v(xbgr.mr_n68472736)
print v(xbgr.mr_n68472848)
print v(xbgr.mr_n68473168)
print v(xbgr.mr_n68473280)
print v(xbgr.mr_n68473600)
print v(xbgr.mr_n68473712)
print v(xbgr.mr_n68474032)
print v(xbgr.mr_n68474464)
print v(xbgr.mr_n68474576)
print v(xbgr.mr_n68474896)
print v(xbgr.mr_n68475328)
print v(xbgr.mr_n68475440)
print v(xbgr.mr_n68475760)
print v(xbgr.mr_n68475872)
print v(xbgr.mr_n68476192)
print v(xbgr.mr_n68476304)
print v(xbgr.mr_n68476624)
print v(xbgr.mr_n68476736)
print v(xbgr.mr_n68477056)
print v(xbgr.mr_n68477168)
print v(xbgr.mr_n68477488)
print v(xbgr.mr_n68477600)
print v(xbgr.mr_n68477920)
print v(xbgr.mr_n68478032)
print v(xbgr.mr_n68478352)
print v(xbgr.mr_n68478464)
print v(xbgr.mr_n68478784)
print v(xbgr.mr_n68478896)
print v(xbgr.mr_n68479216)
print v(xbgr.mr_n68479328)
print v(xbgr.mr_n68479648)
print v(xbgr.mr_n68479760)
print v(xbgr.mr_n68480080)
print v(xbgr.mr_n68480192)
print v(xbgr.mr_n68480512)
print v(xbgr.mr_n68480624)
print v(xbgr.mr_n68480944)
print v(xbgr.mr_n68481056)
print v(xbgr.mr_n68481376)
print v(xbgr.mr_n68481488)
print v(xbgr.mr_n68481808)
print v(xbgr.mr_n68481920)
print v(xbgr.mr_n68482240)
print v(xbgr.mr_n68482352)
print v(xbgr.mr_n68482672)
print v(xbgr.mr_n68482784)
print v(xbgr.mr_n68483104)
print v(xbgr.mr_n68483216)
print v(xbgr.mr_n68483536)
print v(xbgr.mr_n68483648)
print v(xbgr.mr_n68483968)
print v(xbgr.mr_n68484080)
print v(xbgr.mr_n68484400)
print v(xbgr.mr_n68484512)
print v(xbgr.mr_n68484832)
print v(xbgr.mr_n68485264)
print v(xbgr.mr_n68485376)
print v(xbgr.mr_n68485696)
print v(xbgr.mr_n68486128)
print v(xbgr.mr_n68486240)
print v(xbgr.mr_n68486560)
print v(xbgr.mr_n68486992)
print v(xbgr.mr_n68487104)
print v(xbgr.mr_n68487424)
print v(xbgr.mr_n68487856)
print v(xbgr.mr_n68487968)
print v(xbgr.mr_n68488288)
print v(xbgr.mr_n68488720)
print v(xbgr.mr_n68488832)
print v(xbgr.mr_n68489152)
print v(xbgr.mr_n68489264)
print v(xbgr.mr_n68489584)
print v(xbgr.mr_n68489696)
print v(xbgr.mr_n68490016)
print v(xbgr.mr_n68490128)
print v(xbgr.mr_n68490448)
print v(xbgr.mr_n68490560)
print v(xbgr.mr_n68490880)
print v(xbgr.mr_n68490992)
print v(xbgr.mr_n68491312)
print v(xbgr.mr_n68491424)
print v(xbgr.mr_n68491744)
print v(xbgr.mr_n68491856)
print v(xbgr.mr_n68492176)
print v(xbgr.mr_n68492288)
print v(xbgr.mr_n68492608)
print v(xbgr.mr_n68492720)
print v(xbgr.mr_n68493040)
print v(xbgr.mr_n68493152)
print v(xbgr.mr_n68493472)
print v(xbgr.mr_n68493584)
print v(xbgr.mr_n68493904)
print v(xbgr.mr_n68494016)
print v(xbgr.mr_n68494336)
print v(xbgr.mr_n68494448)
print v(xbgr.mr_n68494768)
print v(xbgr.mr_n68494880)
print v(xbgr.mr_n68495200)
print v(xbgr.mr_n68495312)
print v(xbgr.mr_n68495632)
print v(xbgr.mr_n68495744)
print v(xbgr.mr_n68496064)
print v(xbgr.mr_n68496176)
print v(xbgr.mr_n68496496)
print v(xbgr.mr_n68496608)
print v(xbgr.mr_n68496928)
print v(xbgr.mr_n68497040)
print v(xbgr.mr_n68497360)
print v(xbgr.mr_n68497472)
print v(xbgr.mr_n68497792)
print v(xbgr.mr_n68497904)
print v(xbgr.mr_n68498224)
print v(xbgr.mr_n68498336)
print v(xbgr.mr_n68498656)
print v(xbgr.mr_n68498768)
print v(xbgr.mr_n68499088)
print v(xbgr.mr_n68499200)
print v(xbgr.mr_n68499520)
print v(xbgr.mr_n68499632)
print v(xbgr.mr_n68499952)
print v(xbgr.mr_n68500064)
print v(xbgr.mr_n68500384)
print v(xbgr.mr_n68500496)
print v(xbgr.mr_n68500816)
print v(xbgr.mr_n68500928)
print v(xbgr.mr_n68501248)
print v(xbgr.mr_n68501360)
print v(xbgr.mr_n68501680)
print v(xbgr.mr_n68501792)
print v(xbgr.mr_n68502112)
print v(xbgr.mr_n68502224)
print v(xbgr.mr_n68502544)
print v(xbgr.mr_n68502656)
print v(xbgr.mr_n68502976)
print v(xbgr.mr_n68503088)
print v(xbgr.mr_n68503408)
print v(xbgr.mr_n68503520)
print v(xbgr.mr_n68503840)
print v(xbgr.mr_n68503952)
print v(xbgr.mr_n68504272)
print v(xbgr.mr_n68504384)
print v(xbgr.mr_n68504704)
print v(xbgr.mr_n68504816)
print v(xbgr.mr_n68505136)
print v(xbgr.mr_n68505248)
print v(xbgr.mr_n68505568)
print v(xbgr.mr_n68505680)
print v(xbgr.mr_n68506000)
print v(xbgr.mr_n68506112)
print v(xbgr.mr_n68506432)
print v(xbgr.mr_n68506544)
print v(xbgr.mr_n68506864)
print v(xbgr.mr_n68506976)
print v(xbgr.mr_n68507296)
print v(xbgr.mr_n68507408)
print v(xbgr.mr_n68507728)
print v(xbgr.mr_n68507840)
print v(xbgr.mr_n68508160)
print v(xbgr.mr_n68508272)
print v(xbgr.mr_n68508592)
print v(xbgr.mr_n68509024)
print v(xbgr.mr_n68509136)
print v(xbgr.mr_n68509456)
print v(xbgr.mr_n68509888)
print v(xbgr.mr_n68510000)
print v(xbgr.mr_n68510320)
print v(xbgr.mr_n68510752)
print v(xbgr.mr_n68510864)
print v(xbgr.mr_n68511184)
print v(xbgr.mr_n68511296)
print v(xbgr.mr_n68511616)
print v(xbgr.mr_n68511728)
print v(xbgr.mr_n68512048)
print v(xbgr.mr_n68512160)
print v(xbgr.mr_n68512480)
print v(xbgr.mr_n68512592)
print v(xbgr.mr_n68512912)
print v(xbgr.mr_n68513024)
print v(xbgr.mr_n68513344)
print v(xbgr.mr_n68513456)
print v(xbgr.mr_n68513776)
print v(xbgr.mr_n68513888)
print v(xbgr.mr_n68514208)
print v(xbgr.mr_n68514320)
print v(xbgr.mr_n68514640)
print v(xbgr.mr_n68514752)
print v(xbgr.mr_n68515072)
print v(xbgr.mr_n68515184)
print v(xbgr.mr_n68515504)
print v(xbgr.mr_n68515616)
print v(xbgr.mr_n68515936)
print v(xbgr.mr_n68516048)
print v(xbgr.mr_n68516368)
print v(xbgr.mr_n68516480)
print v(xbgr.mr_n68516800)
print v(xbgr.mr_n68516912)
print v(xbgr.mr_n68517232)
print v(xbgr.mr_n68517344)
print v(xbgr.mr_n68517664)
print v(xbgr.mr_n68517776)
print v(xbgr.mr_n68518096)
print v(xbgr.mr_n68518208)
print v(xbgr.mr_n68518528)
print v(xbgr.mr_n68518640)
print v(xbgr.mr_n68518960)
print v(xbgr.mr_n68519072)
print v(xbgr.mr_n68519392)
print v(xbgr.mr_n68519504)
print v(xbgr.mr_n68519824)
print v(xbgr.mr_n68519936)
print v(xbgr.mr_n68520256)
print v(xbgr.mr_n68520368)
print v(xbgr.mr_n68520688)
print v(xbgr.mr_n68520800)
print v(xbgr.mr_n68521120)
print v(xbgr.mr_n68521232)
print v(xbgr.mr_n68521552)
print v(xbgr.mr_n68521664)
print v(xbgr.mr_n68521984)
print v(xbgr.mr_n68522096)
print v(xbgr.mr_n68522416)
print v(xbgr.mr_n68522528)
print v(xbgr.mr_n68522848)
print v(xbgr.mr_n68522960)
print v(xbgr.mr_n68523280)
print v(xbgr.mr_n68523392)
print v(xbgr.mr_n68523712)
print v(xbgr.mr_n68523824)
print v(xbgr.mr_n68524144)
print v(xbgr.mr_n68524256)
print v(xbgr.mr_n68524576)
print v(xbgr.mr_n68524688)
print v(xbgr.mr_n68525008)
print v(xbgr.mr_n68525120)
print v(xbgr.mr_n68525440)
print v(xbgr.mr_n68525552)
print v(xbgr.mr_n68525872)
print v(xbgr.mr_n68525984)
print v(xbgr.mr_n68526304)
print v(xbgr.mr_n68526416)
print v(xbgr.mr_n68526736)
print v(xbgr.mr_n68526848)
print v(xbgr.mr_n68527168)
print v(xbgr.mr_n68527280)
print v(xbgr.mr_n68527600)
print v(xbgr.mr_n68527712)
print v(xbgr.mr_n68528032)
print v(xbgr.mr_n68528144)
print v(xbgr.mr_n68528464)
print v(xbgr.mr_n68528576)
print v(xbgr.mr_n68528896)
print v(xbgr.mr_n68529008)
print v(xbgr.mr_n68529328)
print v(xbgr.mr_n68529440)
print v(xbgr.mr_n68529760)
print v(xbgr.mr_n68529872)
print v(xbgr.mr_n68530192)
print v(xbgr.mr_n68530304)
print v(xbgr.mr_n68530624)
print v(xbgr.mr_n68530736)
print v(xbgr.mr_n68531056)
print v(xbgr.mr_n68531168)
print v(xbgr.mr_n68531488)
print v(xbgr.mr_n68531600)
print v(xbgr.mr_n68531920)
print v(xbgr.mr_n68532032)
print v(xbgr.mr_n68532352)
print v(xbgr.mr_n68532464)
print v(xbgr.mr_n68532784)
print v(xbgr.mr_n68532896)
print v(xbgr.mr_n68533216)
print v(xbgr.mr_n68533328)
print v(xbgr.mr_n68533648)
print v(xbgr.mr_n68533760)
print v(xbgr.mr_n68534080)
print v(xbgr.mr_n68534192)
print v(xbgr.mr_n68534512)
print v(xbgr.mr_n68534624)
print v(xbgr.mr_n68534944)
print v(xbgr.mr_n68535056)
print v(xbgr.mr_n68535376)
print v(xbgr.mr_n68535488)
print v(xbgr.mr_n68535808)
print v(xbgr.mr_n68535920)
print v(xbgr.mr_n68536240)
print v(xbgr.mr_n68536352)
print v(xbgr.mr_n68536672)
print v(xbgr.mr_n68536784)
print v(xbgr.mr_n68537104)
print v(xbgr.mr_n68537216)
print v(xbgr.mr_n68537536)
print v(xbgr.mr_n68537648)
print v(xbgr.mr_n68537968)
print v(xbgr.mr_n68538080)
print v(xbgr.mr_n68538400)
print v(xbgr.mr_n68538512)
print v(xbgr.mr_n68538832)
print v(xbgr.mr_n68538944)
print v(xbgr.mr_n68539264)
print v(xbgr.mr_n68539376)
print v(xbgr.mr_n68539696)
print v(xbgr.mr_n68539808)
print v(xbgr.mr_n68540128)
print v(xbgr.mr_n68540240)
print v(xbgr.mr_n68540560)
print v(xbgr.mr_n68540672)
print v(xbgr.mr_n68540992)
print v(xbgr.mr_n68541104)
print v(xbgr.mr_n68541424)
print v(xbgr.mr_n68541536)
print v(xbgr.mr_n68541856)
print v(xbgr.mr_n68541968)
print v(xbgr.mr_n68542288)
print v(xbgr.mr_n68542400)
print v(xbgr.mr_n68542720)
print v(xbgr.mr_n68542832)
print v(xbgr.mr_n68543152)
print v(xbgr.mr_n68543264)
print v(xbgr.mr_n68543584)
print v(xbgr.mr_n68543696)
print v(xbgr.mr_n68544016)
print v(xbgr.mr_n68544128)
print v(xbgr.mr_n68544448)
print v(xbgr.mr_n68544560)
print v(xbgr.mr_n68544880)
print v(xbgr.mr_n68544992)
print v(xbgr.mr_n68545312)
print v(xbgr.mr_n68545424)
print v(xbgr.mr_n68545744)
print v(xbgr.mr_n68545856)
print v(xbgr.mr_n68546176)
print v(xbgr.mr_n68546288)
print v(xbgr.mr_n68546608)
print v(xbgr.mr_n68546720)
print v(xbgr.mr_n68547040)
print v(xbgr.mr_n68547152)
print v(xbgr.mr_n68547472)
print v(xbgr.mr_n68547584)
print v(xbgr.mr_n68547904)
print v(xbgr.mr_n68548016)
print v(xbgr.mr_n68548336)
print v(xbgr.mr_n68548448)
print v(xbgr.mr_n68548768)
print v(xbgr.mr_n68548880)
print v(xbgr.mr_n68549200)
print v(xbgr.mr_n68549312)
print v(xbgr.mr_n68549632)
print v(xbgr.mr_n68549744)
print v(xbgr.mr_n68550064)
print v(xbgr.mr_n68550176)
print v(xbgr.mr_n68550496)
print v(xbgr.mr_n68550608)
print v(xbgr.mr_n68550928)
print v(xbgr.mr_n68551040)
print v(xbgr.mr_n68551360)
print v(xbgr.mr_n68551472)
print v(xbgr.mr_n68551792)
print v(xbgr.mr_n68551904)
print v(xbgr.mr_n68552224)
print v(xbgr.mr_n68552336)
print v(xbgr.mr_n68552656)
print v(xbgr.mr_n68552768)
print v(xbgr.mr_n68553088)
print v(xbgr.mr_n68553200)
print v(xbgr.mr_n68553520)
print v(xbgr.mr_n68553632)
print v(xbgr.mr_n68553952)
print v(xbgr.mr_n68554064)
print v(xbgr.mr_n68554384)
print v(xbgr.mr_n68554496)
print v(xbgr.mr_n68554816)
print v(xbgr.mr_n68554928)
print v(xbgr.mr_n68555248)
print v(xbgr.mr_n68555360)
print v(xbgr.mr_n68555680)
print v(xbgr.mr_n68555792)
print v(xbgr.mr_n68556112)
print v(xbgr.mr_n68556224)
print v(xbgr.mr_n68556544)
print v(xbgr.mr_n68556656)
print v(xbgr.mr_n68556976)
print v(xbgr.mr_n68557088)
print v(xbgr.mr_n68557408)
print v(xbgr.mr_n68557520)
print v(xbgr.mr_n68557840)
print v(xbgr.mr_n68557952)
print v(xbgr.mr_n68558272)
print v(xbgr.mr_n68558384)
print v(xbgr.mr_n68558704)
print v(xbgr.mr_n68558816)
print v(xbgr.mr_n68559136)
print v(xbgr.mr_n68559248)
print v(xbgr.mr_n68559568)
print v(xbgr.mr_n68559680)
print v(xbgr.mr_n68560000)
print v(xbgr.mr_n68560112)
print v(xbgr.mr_n68560432)
print v(xbgr.mr_n68560544)
print v(xbgr.mr_n68560864)
print v(xbgr.mr_n68560976)
print v(xbgr.mr_n68561296)
print v(xbgr.mr_n68561408)
print v(xbgr.mr_n68561728)
print v(xbgr.mr_n68561840)
print v(xbgr.mr_n68562160)
print v(xbgr.mr_n68562272)
print v(xbgr.mr_n68562592)
print v(xbgr.mr_n68562704)
print v(xbgr.mr_n68563024)
print v(xbgr.mr_n68563136)
print v(xbgr.mr_n68563456)
print v(xbgr.mr_n68563568)
print v(xbgr.mr_n68563888)
print v(xbgr.mr_n68564000)
print v(xbgr.mr_n68564320)
print v(xbgr.mr_n68564432)
print v(xbgr.mr_n68564752)
print v(xbgr.mr_n68564864)
print v(xbgr.mr_n68565184)
print v(xbgr.mr_n68565296)
print v(xbgr.mr_n68565616)
print v(xbgr.mr_n68565728)
print v(xbgr.mr_n68566048)
print v(xbgr.mr_n68566160)
print v(xbgr.mr_n68566480)
print v(xbgr.mr_n68566592)
print v(xbgr.mr_n68566912)
print v(xbgr.mr_n68567024)
print v(xbgr.mr_n68567344)
print v(xbgr.mr_n68567456)
print v(xbgr.mr_n68567776)
print v(xbgr.mr_n68567888)
print v(xbgr.mr_n68568208)
print v(xbgr.mr_n68568320)
print v(xbgr.mr_n68568640)
print v(xbgr.mr_n68568752)
print v(xbgr.mr_n68569072)
print v(xbgr.mr_n68569184)
print v(xbgr.mr_n68569504)
print v(xbgr.mr_n68569616)
print v(xbgr.mr_n68569936)
print v(xbgr.mr_n68570048)
print v(xbgr.mr_n68570368)
print v(xbgr.mr_n68570480)
print v(xbgr.mr_n68570800)
print v(xbgr.mr_n68570912)
print v(xbgr.mr_n68571232)
print v(xbgr.mr_n68571344)
print v(xbgr.mr_n68571664)
print v(xbgr.mr_n68571776)
print v(xbgr.mr_n68572096)
print v(xbgr.mr_n68572208)
print v(xbgr.mr_n68572528)
print v(xbgr.mr_n68572640)
print v(xbgr.mr_n68572960)
print v(xbgr.mr_n68573072)
print v(xbgr.mr_n68573392)
print v(xbgr.mr_n68573504)
print v(xbgr.mr_n68573824)
print v(xbgr.mr_n68573936)
print v(xbgr.mr_n68574256)
print v(xbgr.mr_n68574368)
print v(xbgr.mr_n68574688)
print v(xbgr.mr_n68574800)
print v(xbgr.mr_n68575120)
print v(xbgr.mr_n68575232)
print v(xbgr.mr_n68575552)
print v(xbgr.mr_n68575664)
print v(xbgr.mr_n68575984)
print v(xbgr.mr_n68576096)
print v(xbgr.mr_n68576416)
print v(xbgr.mr_n68576528)
print v(xbgr.mr_n68576848)
print v(xbgr.mr_n68576960)
print v(xbgr.mr_n68577280)
print v(xbgr.mr_n68577392)
print v(xbgr.mr_n68577712)
print v(xbgr.mr_n68577824)
print v(xbgr.mr_n68578144)
print v(xbgr.mr_n68578256)
print v(xbgr.mr_n68578576)
print v(xbgr.mr_n68578688)
print v(xbgr.mr_n68579008)
print v(xbgr.mr_n68579120)
print v(xbgr.mr_n68579440)
print v(xbgr.mr_n68579552)
print v(xbgr.mr_n68579872)
print v(xbgr.mr_n68579984)
print v(xbgr.mr_n68580304)
print v(xbgr.mr_n68580416)
print v(xbgr.mr_n68580736)
print v(xbgr.mr_n68580848)
print v(xbgr.mr_n68581168)
print v(xbgr.mr_n68581280)
print v(xbgr.mr_n68581600)
print v(xbgr.mr_n68581712)
print v(xbgr.mr_n68582032)
print v(xbgr.mr_n68582144)
print v(xbgr.mr_n68582464)
print v(xbgr.mr_n68582576)
print v(xbgr.mr_n68582896)
print v(xbgr.mr_n68583008)
print v(xbgr.mr_n68583328)
print v(xbgr.mr_n68583440)
print v(xbgr.mr_n68583760)
print v(xbgr.mr_n68583872)
print v(xbgr.mr_n68584192)
print v(xbgr.mr_n68584304)
print v(xbgr.mr_n68584624)
print v(xbgr.mr_n68584736)
print v(xbgr.mr_n68585056)
print v(xbgr.mr_n68585168)
print v(xbgr.mr_n68585488)
print v(xbgr.mr_n68585600)
print v(xbgr.mr_n68585920)
print v(xbgr.mr_n68586032)
print v(xbgr.mr_n68586352)
print v(xbgr.mr_n68586464)
print v(xbgr.mr_n68586784)
print v(xbgr.mr_n68586896)
print v(xbgr.mr_n68587216)
print v(xbgr.mr_n68587328)
print v(xbgr.mr_n68587648)
print v(xbgr.mr_n68587760)
print v(xbgr.mr_n68588080)
print v(xbgr.mr_n68588192)
print v(xbgr.mr_n68588512)
print v(xbgr.mr_n68588624)
print v(xbgr.mr_n68588944)
print v(xbgr.mr_n68589056)
print v(xbgr.mr_n68589376)
print v(xbgr.mr_n68589488)
print v(xbgr.mr_n68589808)
print v(xbgr.mr_n68589920)
print v(xbgr.mr_n68590240)
print v(xbgr.mr_n68590352)
print v(xbgr.mr_n68590672)
print v(xbgr.mr_n68590784)
print v(xbgr.mr_n68591104)
print v(xbgr.mr_n68591216)
print v(xbgr.mr_n68591536)
print v(xbgr.mr_n68591648)
print v(xbgr.mr_n68591968)
print v(xbgr.mr_n68592080)
print v(xbgr.mr_n68592400)
print v(xbgr.mr_n68592512)
print v(xbgr.mr_n68592832)
print v(xbgr.mr_n68592944)
print v(xbgr.mr_n68593264)
print v(xbgr.mr_n68593376)
print v(xbgr.mr_n68593696)
print v(xbgr.mr_n68593808)
print v(xbgr.mr_n68594128)
print v(xbgr.mr_n68594240)
print v(xbgr.mr_n68594560)
print v(xbgr.mr_n68594672)
print v(xbgr.mr_n68594992)
print v(xbgr.mr_n68595104)
print v(xbgr.mr_n68595424)
print v(xbgr.mr_n68595536)
print v(xbgr.mr_n68595856)
print v(xbgr.mr_n68595968)
print v(xbgr.mr_n68596288)
print v(xbgr.mr_n68596400)
print v(xbgr.mr_n68596720)
print v(xbgr.mr_n68596832)
print v(xbgr.mr_n68597152)
print v(xbgr.mr_n68597264)
print v(xbgr.mr_n68597584)
print v(xbgr.mr_n68597696)
print v(xbgr.mr_n68598016)
print v(xbgr.mr_n68598128)
print v(xbgr.mr_n68598448)
print v(xbgr.mr_n68598560)
print v(xbgr.mr_n68598880)
print v(xbgr.mr_n68598992)
print v(xbgr.mr_n68599312)
print v(xbgr.mr_n68599424)
print v(xbgr.mr_n68599744)
print v(xbgr.mr_n68599856)
print v(xbgr.mr_n68600176)
print v(xbgr.mr_n68600288)
print v(xbgr.mr_n68600608)
print v(xbgr.mr_n68600720)
print v(xbgr.mr_n68601040)
print v(xbgr.mr_n68601152)
print v(xbgr.mr_n68601472)
print v(xbgr.mr_n68601584)
print v(xbgr.mr_n68601904)
print v(xbgr.mr_n68602016)
print v(xbgr.mr_n68602336)
print v(xbgr.mr_n68602448)
print v(xbgr.mr_n68602768)
print v(xbgr.mr_n68602880)
print v(xbgr.mr_n68603200)
print v(xbgr.mr_n68603312)
print v(xbgr.mr_n68603632)
print v(xbgr.mr_n68603744)
print v(xbgr.mr_n68604064)
print v(xbgr.mr_n68604176)
print v(xbgr.mr_n68604496)
print v(xbgr.mr_n68604608)
print v(xbgr.mr_n68604928)
print v(xbgr.mr_n68605040)
print v(xbgr.mr_n68605360)
print v(xbgr.mr_n68605472)
print v(xbgr.mr_n68605792)
print v(xbgr.mr_n68605904)
print v(xbgr.mr_n68606224)
print v(xbgr.mr_n68606336)
print v(xbgr.mr_n68606656)
print v(xbgr.mr_n68606768)
print v(xbgr.mr_n68607088)
print v(xbgr.mr_n68607200)
print v(xbgr.mr_n68607520)
print v(xbgr.mr_n68607632)
print v(xbgr.mr_n68607952)
print v(xbgr.mr_n68608064)
print v(xbgr.mr_n68608384)
print v(xbgr.mr_n68608496)
print v(xbgr.mr_n68608816)
print v(xbgr.mr_n68608928)
print v(xbgr.mr_n68609248)
print v(xbgr.mr_n68609360)
print v(xbgr.mr_n68609680)
print v(xbgr.mr_n68609792)
print v(xbgr.mr_n68610112)
print v(xbgr.mr_n68610224)
print v(xbgr.mr_n68610544)
print v(xbgr.mr_n68610656)
print v(xbgr.mr_n68610976)
print v(xbgr.mr_n68611088)
print v(xbgr.mr_n68611408)
print v(xbgr.mr_n68611520)
print v(xbgr.mr_n68611840)
print v(xbgr.mr_n68611952)
print v(xbgr.mr_n68612272)
print v(xbgr.mr_n68612384)
print v(xbgr.mr_n68612704)
print v(xbgr.mr_n68612816)
print v(xbgr.mr_n68613136)
print v(xbgr.mr_n68613248)
print v(xbgr.mr_n68613568)
print v(xbgr.mr_n68613680)
print v(xbgr.mr_n68614000)
print v(xbgr.mr_n68614112)
print v(xbgr.mr_n68614432)
print v(xbgr.mr_n68614544)
print v(xbgr.mr_n68614864)
print v(xbgr.mr_n68614976)
print v(xbgr.mr_n68615296)
print v(xbgr.mr_n68615408)
print v(xbgr.mr_n68615728)
print v(xbgr.mr_n68615840)
print v(xbgr.mr_n68616160)
print v(xbgr.mr_n68616272)
print v(xbgr.mr_n68616592)
print v(xbgr.mr_n68616704)
print v(xbgr.mr_n68617024)
print v(xbgr.mr_n68617136)
print v(xbgr.mr_n68617456)
print v(xbgr.mr_n68617568)
print v(xbgr.mr_n68617888)
print v(xbgr.mr_n68618000)
print v(xbgr.mr_n68618320)
print v(xbgr.mr_n68618432)
print v(xbgr.mr_n68618752)
print v(xbgr.mr_n68618864)
print v(xbgr.mr_n68619184)
print v(xbgr.mr_n68619296)
print v(xbgr.mr_n68619616)
print v(xbgr.mr_n68619728)
print v(xbgr.mr_n68620048)
print v(xbgr.mr_n68620160)
print v(xbgr.mr_n68620480)
print v(xbgr.mr_n68620592)
print v(xbgr.mr_n68620912)
print v(xbgr.mr_n68621024)
print v(xbgr.mr_n68621344)
print v(xbgr.mr_n68621456)
print v(xbgr.mr_n68621776)
print v(xbgr.mr_n68621888)
print v(xbgr.mr_n68622208)
print v(xbgr.mr_n68622320)
print v(xbgr.mr_n68622640)
print v(xbgr.mr_n68622752)
print v(xbgr.mr_n68623072)
print v(xbgr.mr_n68623184)
print v(xbgr.mr_n68623504)
print v(xbgr.mr_n68623616)
print v(xbgr.mr_n68623936)
print v(xbgr.mr_n68624048)
print v(xbgr.mr_n68624368)
print v(xbgr.mr_n68624480)
print v(xbgr.mr_n68624800)
print v(xbgr.mr_n68624912)
print v(xbgr.mr_n68625232)
print v(xbgr.mr_n68625344)
print v(xbgr.mr_n68625664)
print v(xbgr.mr_n68625776)
print v(xbgr.mr_n68626096)
print v(xbgr.mr_n68626208)
print v(xbgr.mr_n68626528)
print v(xbgr.mr_n68626640)
print v(xbgr.mr_n68626960)
print v(xbgr.mr_n68627072)
print v(xbgr.mr_n68627392)
print v(xbgr.mr_n68627504)
print v(xbgr.mr_n68627824)
print v(xbgr.mr_n68627936)
print v(xbgr.mr_n68628256)
print v(xbgr.mr_n68628368)
print v(xbgr.mr_n68628688)
print v(xbgr.mr_n68628800)
print v(xbgr.mr_n68629120)
print v(xbgr.mr_n68629232)
print v(xbgr.mr_n68629552)
print v(xbgr.mr_n68629664)
print v(xbgr.mr_n68629984)
print v(xbgr.mr_n68630096)
print v(xbgr.mr_n68630416)
print v(xbgr.mr_n68630528)
print v(xbgr.mr_n68630848)
print v(xbgr.mr_n68630960)
print v(xbgr.mr_n68631280)
print v(xbgr.mr_n68631392)
print v(xbgr.mr_n68631712)
print v(xbgr.mr_n68631824)
print v(xbgr.mr_n68632144)
print v(xbgr.mr_n68632256)
print v(xbgr.mr_n68632576)
print v(xbgr.mr_n68632688)
print v(xbgr.mr_n68633008)
print v(xbgr.mr_n68633120)
print v(xbgr.mr_n68633440)
print v(xbgr.mr_n68633552)
print v(xbgr.mr_n68633872)
print v(xbgr.mr_n68633984)
print v(xbgr.mr_n68634304)
print v(xbgr.mr_n68634416)
print v(xbgr.mr_n68634736)
print v(xbgr.mr_n68634848)
print v(xbgr.mr_n68635168)
print v(xbgr.mr_n68635280)
print v(xbgr.mr_n68635600)
print v(xbgr.mr_n68635712)
print v(xbgr.mr_n68636032)
print v(xbgr.mr_n68636144)
print v(xbgr.mr_n68636464)
print v(xbgr.mr_n68636576)
print v(xbgr.mr_n68636896)
print v(xbgr.mr_n68637008)
print v(xbgr.mr_n68637328)
print v(xbgr.mr_n68637440)
print v(xbgr.mr_n68637760)
print v(xbgr.mr_n68637872)
print v(xbgr.mr_n68638192)
print v(xbgr.mr_n68638304)
print v(xbgr.mr_n68638624)
print v(xbgr.mr_n68638736)
print v(xbgr.mr_n68639056)
print v(xbgr.mr_n68639168)
print v(xbgr.mr_n68639488)
print v(xbgr.mr_n68639600)
print v(xbgr.mr_n68639920)
print v(xbgr.mr_n68640032)
print v(xbgr.mr_n68640352)
print v(xbgr.mr_n68640464)
print v(xbgr.mr_n68640784)
print v(xbgr.mr_n68640896)
print v(xbgr.mr_n68641216)
print v(xbgr.mr_n68641328)
print v(xbgr.mr_n68641648)
print v(xbgr.mr_n68641760)
print v(xbgr.mr_n68642080)
print v(xbgr.mr_n68642192)
print v(xbgr.mr_n68642512)
print v(xbgr.mr_n68642624)
print v(xbgr.mr_n68642944)
print v(xbgr.mr_n68643056)
print v(xbgr.mr_n68643376)
print v(xbgr.mr_n68643488)
print v(xbgr.mr_n68643808)
print v(xbgr.mr_n68643920)
print v(xbgr.mr_n68644240)
print v(xbgr.mr_n68644352)
print v(xbgr.mr_n68644672)
print v(xbgr.mr_n68644784)
print v(xbgr.mr_n68645104)
print v(xbgr.mr_n68645216)
print v(xbgr.mr_n68645536)
print v(xbgr.mr_n68645648)
print v(xbgr.mr_n68645968)
print v(xbgr.mr_n68646080)
print v(xbgr.mr_n68646400)
print v(xbgr.mr_n68646512)
print v(xbgr.mr_n68646832)
print v(xbgr.mr_n68646944)
print v(xbgr.mr_n68647264)
print v(xbgr.mr_n68647376)
print v(xbgr.mr_n68647696)
print v(xbgr.mr_n68647808)
print v(xbgr.mr_n68648128)
print v(xbgr.mr_n68648240)
print v(xbgr.mr_n68648560)
print v(xbgr.mr_n68648672)
print v(xbgr.mr_n68648992)
print v(xbgr.mr_n68649104)
print v(xbgr.mr_n68649424)
print v(xbgr.mr_n68649536)
print v(xbgr.mr_n68649856)
print v(xbgr.mr_n68649968)
print v(xbgr.mr_n68650288)
print v(xbgr.mr_n68650400)
print v(xbgr.mr_n68650720)
print v(xbgr.mr_n68650832)
print v(xbgr.mr_n68651152)
print v(xbgr.mr_n68651264)
print v(xbgr.mr_n68651584)
print v(xbgr.mr_n68651696)
print v(xbgr.mr_n68652016)
print v(xbgr.mr_n68652128)
print v(xbgr.mr_n68652448)
print v(xbgr.mr_n68652560)
print v(xbgr.mr_n68652880)
print v(xbgr.mr_n68652992)
print v(xbgr.mr_n68653312)
print v(xbgr.mr_n68653424)
print v(xbgr.mr_n68653744)
print v(xbgr.mr_n68653856)
print v(xbgr.mr_n68654176)
print v(xbgr.mr_n68654288)
print v(xbgr.mr_n68654608)
print v(xbgr.mr_n68654720)
print v(xbgr.mr_n68655040)
print v(xbgr.mr_n68655152)
print v(xbgr.mr_n68655472)
print v(xbgr.mr_n68655584)
print v(xbgr.mr_n68655904)
print v(xbgr.mr_n68656016)
print v(xbgr.mr_n68656336)
print v(xbgr.mr_n68656448)
print v(xbgr.mr_n68656768)
print v(xbgr.mr_n68656880)
print v(xbgr.mr_n68657200)
print v(xbgr.mr_n68657312)
print v(xbgr.mr_n68657632)
print v(xbgr.mr_n68657744)
print v(xbgr.mr_n68658064)
print v(xbgr.mr_n68658176)
print v(xbgr.mr_n68658496)
print v(xbgr.mr_n68658608)
print v(xbgr.mr_n68658928)
print v(xbgr.mr_n68659040)
print v(xbgr.mr_n68659360)
print v(xbgr.mr_n68659472)
print v(xbgr.mr_n68659792)
print v(xbgr.mr_n68659904)
print v(xbgr.mr_n68660224)
print v(xbgr.mr_n68660336)
print v(xbgr.mr_n68660656)
print v(xbgr.mr_n68660768)
print v(xbgr.mr_n68661088)
print v(xbgr.mr_n68661200)
print v(xbgr.mr_n68661520)
print v(xbgr.mr_n68661632)
print v(xbgr.mr_n68661952)
print v(xbgr.mr_n68662064)
print v(xbgr.mr_n68662384)
print v(xbgr.mr_n68662496)
print v(xbgr.mr_n68662816)
print v(xbgr.mr_n68662928)
print v(xbgr.mr_n68663248)
print v(xbgr.mr_n68663360)
print v(xbgr.mr_n68663680)
print v(xbgr.mr_n68663792)
print v(xbgr.mr_n68664112)
print v(xbgr.mr_n68664224)
print v(xbgr.mr_n68664544)
print v(xbgr.mr_n68664656)
print v(xbgr.mr_n68664976)
print v(xbgr.mr_n68665088)
print v(xbgr.mr_n68665408)
print v(xbgr.mr_n68665520)
print v(xbgr.mr_n68665840)
print v(xbgr.mr_n68665952)
print v(xbgr.mr_n68666272)
print v(xbgr.mr_n68666384)
print v(xbgr.mr_n68666704)
print v(xbgr.mr_n68666816)
print v(xbgr.mr_n68667136)
print v(xbgr.mr_n68667248)
print v(xbgr.mr_n68667568)
print v(xbgr.mr_n68667680)
print v(xbgr.mr_n68668000)
print v(xbgr.mr_n68668112)
print v(xbgr.mr_n68668432)
print v(xbgr.mr_n68668544)
print v(xbgr.mr_n68668864)
print v(xbgr.mr_n68668976)
print v(xbgr.mr_n68669296)
print v(xbgr.mr_n68669408)
print v(xbgr.mr_n68669728)
print v(xbgr.mr_n68669840)
print v(xbgr.mr_n68670160)
print v(xbgr.mr_n68670272)
print v(xbgr.mr_n68670592)
print v(xbgr.mr_n68670704)
print v(xbgr.mr_n68671024)
print v(xbgr.mr_n68671136)
print v(xbgr.mr_n68671456)
print v(xbgr.mr_n68671568)
print v(xbgr.mr_n68671888)
print v(xbgr.mr_n68672000)
print v(xbgr.mr_n68672320)
print v(xbgr.mr_n68672432)
print v(xbgr.mr_n68672752)
print v(xbgr.mr_n68672864)
print v(xbgr.mr_n68673184)
print v(xbgr.mr_n68673296)
print v(xbgr.mr_n68673616)
print v(xbgr.mr_n68673728)
print v(xbgr.mr_n68674048)
print v(xbgr.mr_n68674160)
print v(xbgr.mr_n68674480)
print v(xbgr.mr_n68674592)
print v(xbgr.mr_n68674912)
print v(xbgr.mr_n68675024)
print v(xbgr.mr_n68675344)
print v(xbgr.mr_n68675456)
print v(xbgr.mr_n68675776)
print v(xbgr.mr_n68675888)
print v(xbgr.mr_n68676320)
print v(xbgr.mr_n68676640)
print v(xbgr.mr_n68676752)
print v(xbgr.mr_n68677184)
print v(xbgr.mr_n68677504)
print v(xbgr.mr_n68677616)
print v(xbgr.mr_n68678048)
print v(xbgr.mr_n68678368)
print v(xbgr.mr_n68679232)
print v(xbgr.mr_n68680096)
print v(xbgr.mr_n68680208)
print v(xbgr.mr_n68680528)
print v(xbgr.mr_n68680640)
print v(xbgr.mr_n68680960)
print v(xbgr.mr_n68681072)
print v(xbgr.mr_n68681392)
print v(xbgr.mr_n68681504)
print v(xbgr.mr_n68681824)
print v(xbgr.mr_n68681936)
print v(xbgr.mr_n68682256)
print v(xbgr.mr_n68682368)
print v(xbgr.mr_n68682688)
print v(xbgr.mr_n68683552)
print v(xbgr.mr_n68684416)
print v(xbgr.mr_n68685280)
print v(xbgr.mr_n68685392)
print v(xbgr.mr_n68685712)
print v(xbgr.mr_n68685824)
print v(xbgr.mr_n68686144)
print v(xbgr.mr_n68686256)
print v(xbgr.mr_n68686576)
print v(xbgr.mr_n68686688)
print v(xbgr.mr_n68687008)
print v(xbgr.mr_n68687872)
print v(xbgr.mr_n68688736)
print v(xbgr.mr_n68688848)
print v(xbgr.mr_n68689168)
print v(xbgr.mr_n68689280)
print v(xbgr.mr_n68689600)
print v(xbgr.mr_n68689712)
print v(xbgr.mr_n68690032)
print v(xbgr.mr_n68690144)
print v(xbgr.mr_n68690464)
print v(xbgr.mr_n68690576)
print v(xbgr.mr_n68690896)
print v(xbgr.mr_n68691008)
print v(xbgr.mr_n68691328)
print v(xbgr.mr_n68692192)
print v(xbgr.mr_n68692304)
print v(xbgr.mr_n68692736)
print v(xbgr.mr_n68693056)
print v(xbgr.mr_n68693168)
print v(xbgr.mr_n68693600)
print v(xbgr.mr_n68693920)
print v(xbgr.mr_n68694032)
print v(xbgr.mr_n68694464)
print v(xbgr.mr_n68694784)
print v(xbgr.mr_n68695648)
print v(xbgr.mr_n68696512)
print v(xbgr.mr_n68697376)
print v(xbgr.mr_n68698240)
print v(xbgr.mr_n68699104)
print v(xbgr.mr_n68699968)
print v(xbgr.mr_n68700080)
print v(xbgr.mr_n68700400)
print v(xbgr.mr_n68700512)
print v(xbgr.mr_n68700832)
print v(xbgr.mr_n68700944)
print v(xbgr.mr_n68701264)
print v(xbgr.mr_n68701376)
print v(xbgr.mr_n68701696)
print v(xbgr.mr_n68702560)
print v(xbgr.mr_n68703424)
print v(xbgr.mr_n68704288)
print v(xbgr.mr_n68705152)
print v(xbgr.mr_n68705264)
print v(xbgr.mr_n68705696)
print v(xbgr.mr_n68706016)
print v(xbgr.mr_n68706128)
print v(xbgr.mr_n68706560)
print v(xbgr.mr_n68706880)
print v(xbgr.mr_n68706992)
print v(xbgr.mr_n68707424)
print v(xbgr.mr_n68707744)
print v(xbgr.mr_n68708608)
print v(xbgr.mr_n68709472)
print v(xbgr.mr_n68710336)
print v(xbgr.mr_n68711200)
print v(xbgr.mr_n68712064)
print v(xbgr.mr_n68712928)
print v(xbgr.mr_n68713040)
print v(xbgr.mr_n68713360)
print v(xbgr.mr_n68713472)
print v(xbgr.mr_n68713792)
print v(xbgr.mr_n68713904)
print v(xbgr.mr_n68714224)
print v(xbgr.mr_n68714336)
print v(xbgr.mr_n68714656)
print v(xbgr.mr_n68715520)
print v(xbgr.mr_n68716384)
print v(xbgr.mr_n68717248)
print v(xbgr.mr_n68717360)
print v(xbgr.mr_n68717680)
print v(xbgr.mr_n68717792)
print v(xbgr.mr_n68718112)
print v(xbgr.mr_n68718224)
print v(xbgr.mr_n68718656)
print v(xbgr.mr_n68719088)
print v(xbgr.mr_n68719520)
print v(xbgr.mr_n68719840)
print v(xbgr.mr_n68719952)
print v(xbgr.mr_n68720272)
print v(xbgr.mr_n68720384)
print v(xbgr.mr_n68720704)
print v(xbgr.mr_n68720816)
print v(xbgr.mr_n68721136)
print v(xbgr.mr_n68721248)
print v(xbgr.mr_n68721568)
print v(xbgr.mr_n68721680)
print v(xbgr.mr_n68722000)
print v(xbgr.mr_n68722112)
print v(xbgr.mr_n68722432)
print v(xbgr.mr_n68722544)
print v(xbgr.mr_n68722976)
print v(xbgr.mr_n68723296)
print v(xbgr.mr_n68723728)
print v(xbgr.mr_n68723840)
print v(xbgr.mr_n68724160)
print v(xbgr.mr_n68724272)
print v(xbgr.mr_n68724592)
print v(xbgr.mr_n68724704)
print v(xbgr.mr_n68725024)
print v(xbgr.mr_n68725136)
print v(xbgr.mr_n68725456)
print v(xbgr.mr_n68725568)
print v(xbgr.mr_n68725888)
print v(xbgr.mr_n68726000)
print v(xbgr.mr_n68726320)
print v(xbgr.mr_n68726432)
print v(xbgr.mr_n68726864)
print v(xbgr.mr_n68727184)
print v(xbgr.mr_n68727296)
print v(xbgr.mr_n68727728)
print v(xbgr.mr_n68728048)
print v(xbgr.mr_n68728160)
print v(xbgr.mr_n68728480)
print v(xbgr.mr_n68728592)
print v(xbgr.mr_n68728912)
print v(xbgr.mr_n68729024)
print v(xbgr.mr_n68729456)
print v(xbgr.mr_n68729888)
print v(xbgr.mr_n68730208)
print v(xbgr.mr_n68730320)
print v(xbgr.mr_n68730640)
print v(xbgr.mr_n68730752)
print v(xbgr.mr_n68731072)
print v(xbgr.mr_n68731184)
print v(xbgr.mr_n68731504)
print v(xbgr.mr_n68731616)
print v(xbgr.mr_n68731936)
print v(xbgr.mr_n68732048)
print v(xbgr.mr_n68732368)
print v(xbgr.mr_n68732480)
print v(xbgr.mr_n68732800)
print v(xbgr.mr_n68732912)
print v(xbgr.mr_n68733232)
print v(xbgr.mr_n68733344)
print v(xbgr.mr_n68733664)
print v(xbgr.mr_n68733776)
print v(xbgr.mr_n68734096)
print v(xbgr.mr_n68734208)
print v(xbgr.mr_n68734528)
print v(xbgr.mr_n68734640)
print v(xbgr.mr_n68734960)
print v(xbgr.mr_n68735824)
print v(xbgr.mr_n68736688)
print v(xbgr.mr_n68736800)
print v(xbgr.mr_n68737232)
print v(xbgr.mr_n68737552)
print v(xbgr.mr_n68737664)
print v(xbgr.mr_n68738416)
print v(xbgr.mr_n68738848)
print v(xbgr.mr_n68738960)
print v(xbgr.mr_n68739280)
print v(xbgr.mr_n68739392)
print v(xbgr.mr_n68739712)
print v(xbgr.mr_n68739824)
print v(xbgr.mr_n68740144)
print v(xbgr.mr_n68740256)
print v(xbgr.mr_n68740576)
print v(xbgr.mr_n68741440)
print v(xbgr.mr_n68741872)
print v(xbgr.mr_n68741984)
print v(xbgr.mr_n68742304)
print v(xbgr.mr_n68742416)
print v(xbgr.mr_n68742736)
print v(xbgr.mr_n68743600)
print v(xbgr.mr_n68744896)
print v(xbgr.mr_n68745760)
print v(xbgr.mr_n68746624)
print v(xbgr.mr_n68746736)
print v(xbgr.mr_n68747488)
print v(xbgr.mr_n68747600)
print v(xbgr.mr_n68748032)
print v(xbgr.mr_n68748464)
print v(xbgr.mr_n68749216)
print v(xbgr.mr_n68750080)
print v(xbgr.mr_n68750944)
print v(xbgr.mr_n68751056)
print v(xbgr.mr_n68751376)
print v(xbgr.mr_n68751488)
print v(xbgr.mr_n68751920)
print v(xbgr.mr_n68752240)
print v(xbgr.mr_n68752352)
print v(xbgr.mr_n68752784)
print v(xbgr.mr_n68753104)
print v(xbgr.mr_n68753216)
print v(xbgr.mr_n68753536)
print v(xbgr.mr_n68753648)
print v(xbgr.mr_n68753968)
print v(xbgr.mr_n68754832)
print v(xbgr.mr_n68754944)
print v(xbgr.mr_n68755376)
print v(xbgr.mr_n68755696)
print v(xbgr.mr_n68756672)
print v(xbgr.mr_n68756992)
print v(xbgr.mr_n68757104)
print v(xbgr.mr_n68757536)
print v(xbgr.mr_n68757856)
print v(xbgr.mr_n68758288)
print v(xbgr.mr_n68758400)
print v(xbgr.mr_n68758720)
print v(xbgr.mr_n68758832)
print v(xbgr.mr_n68759152)
print v(xbgr.mr_n68759584)
print v(xbgr.mr_n68759696)
print v(xbgr.mr_n68760016)
print v(xbgr.mr_n68760128)
print v(xbgr.mr_n68760448)
print v(xbgr.mr_n68760560)
print v(xbgr.mr_n68760880)
print v(xbgr.mr_n68760992)
print v(xbgr.mr_n68761312)
print v(xbgr.mr_n68761424)
print v(xbgr.mr_n68761856)
print v(xbgr.mr_n68762176)
print v(xbgr.mr_n68762288)
print v(xbgr.mr_n68762608)
print v(xbgr.mr_n68762720)
print v(xbgr.mr_n68763040)
print v(xbgr.mr_n68763584)
print v(xbgr.mr_n68764336)
print v(xbgr.mr_n68765632)
print v(xbgr.mr_n68765744)
print v(xbgr.mr_n68766064)
print v(xbgr.mr_n68766176)
print v(xbgr.mr_n68766496)
print v(xbgr.mr_n68767360)
print v(xbgr.mr_n68768224)
print v(xbgr.mr_n68769088)
print v(xbgr.mr_n68769200)
print v(xbgr.mr_n68769520)
print v(xbgr.mr_n68769632)
print v(xbgr.mr_n68769952)
print v(xbgr.mr_n68770064)
print v(xbgr.mr_n68770384)
print v(xbgr.mr_n68770496)
print v(xbgr.mr_n68770816)
print v(xbgr.mr_n68770928)
print v(xbgr.mr_n68771248)
print v(xbgr.mr_n68772112)
print v(xbgr.mr_n68772976)
print v(xbgr.mr_n68773840)
print v(xbgr.mr_n68773952)
print v(xbgr.mr_n68774272)
print v(xbgr.mr_n68774384)
print v(xbgr.mr_n68774704)
print v(xbgr.mr_n68774816)
print v(xbgr.mr_n68775136)
print v(xbgr.mr_n68775248)
print v(xbgr.mr_n68775680)
print v(xbgr.mr_n68776000)
print v(xbgr.mr_n68776112)
print v(xbgr.mr_n68776432)
print v(xbgr.mr_n68776544)
print v(xbgr.mr_n68776864)
print v(xbgr.mr_n68776976)
print v(xbgr.mr_n68777296)
print v(xbgr.mr_n68777408)
print v(xbgr.mr_n68778160)
print v(xbgr.mr_n68778704)
print v(xbgr.mr_n68779136)
print v(xbgr.mr_n68779568)
print v(xbgr.mr_n68780000)
print v(xbgr.mr_n68780320)
print v(xbgr.mr_n68780432)
print v(xbgr.mr_n68781184)
print v(xbgr.mr_n68782048)
print v(xbgr.mr_n68782912)
print v(xbgr.mr_n68783776)
print v(xbgr.mr_n68784640)
print v(xbgr.mr_n68785504)
print v(xbgr.mr_n68786368)
print v(xbgr.mr_n68786480)
print v(xbgr.mr_n68786800)
print v(xbgr.mr_n68786912)
print v(xbgr.mr_n68787344)
print v(xbgr.mr_n68787664)
print v(xbgr.mr_n68787776)
print v(xbgr.mr_n68788208)
print v(xbgr.mr_n68788528)
print v(xbgr.mr_n68788640)
print v(xbgr.mr_n68788960)
print v(xbgr.mr_n68789072)
print v(xbgr.mr_n68789392)
print v(xbgr.mr_n68789504)
print v(xbgr.mr_n68789824)
print v(xbgr.mr_n68789936)
print v(xbgr.mr_n68790256)
print v(xbgr.mr_n68790368)
print v(xbgr.mr_n68790688)
print v(xbgr.mr_n68790800)
print v(xbgr.mr_n68791120)
print v(xbgr.mr_n68791984)
print v(xbgr.mr_n68792416)
print v(xbgr.mr_n68793392)
print v(xbgr.mr_n68793824)
print v(xbgr.mr_n68794256)
print v(xbgr.mr_n68794688)
print v(xbgr.mr_n68795008)
print v(xbgr.mr_n68795872)
print v(xbgr.mr_n68796736)
print v(xbgr.mr_n68797600)
print v(xbgr.mr_n68798464)
print v(xbgr.mr_n68799328)
print v(xbgr.mr_n68800192)
print v(xbgr.mr_n68801488)
print v(xbgr.mr_n68801920)
print v(xbgr.mr_n68803216)
print v(xbgr.mr_n68803328)
print v(xbgr.mr_n68803648)
print v(xbgr.mr_n68803760)
print v(xbgr.mr_n68804080)
print v(xbgr.mr_n68804192)
print v(xbgr.mr_n68804624)
print v(xbgr.mr_n68805056)
print v(xbgr.mr_n68805376)
print v(xbgr.mr_n68805488)
print v(xbgr.mr_n68805808)
print v(xbgr.mr_n68805920)
print v(xbgr.mr_n68806240)
print v(xbgr.mr_n68806352)
print v(xbgr.mr_n68806672)
print v(xbgr.mr_n68806784)
print v(xbgr.mr_n68807216)
print v(xbgr.mr_n68807536)
print v(xbgr.mr_n68808400)
print v(xbgr.mr_n68808512)
print v(xbgr.mr_n68808832)
print v(xbgr.mr_n68808944)
print v(xbgr.mr_n68809264)
print v(xbgr.mr_n68809376)
print v(xbgr.mr_n68809696)
print v(xbgr.mr_n68809808)
print v(xbgr.mr_n68810128)
print v(xbgr.mr_n68810992)
print v(xbgr.mr_n68811424)
print v(xbgr.mr_n68812720)
print v(xbgr.mr_n68812832)
print v(xbgr.mr_n68813152)
print v(xbgr.mr_n68813264)
print v(xbgr.mr_n68813584)
print v(xbgr.mr_n68813696)
print v(xbgr.mr_n68814016)
print v(xbgr.mr_n68814880)
print v(xbgr.mr_n68814992)
print v(xbgr.mr_n68815424)
print v(xbgr.mr_n68815744)
print v(xbgr.mr_n68815856)
print v(xbgr.mr_n68816176)
print v(xbgr.mr_n68816288)
print v(xbgr.mr_n68816608)
print v(xbgr.mr_n68816720)
print v(xbgr.mr_n68817040)
print v(xbgr.mr_n68817152)
print v(xbgr.mr_n68817584)
print v(xbgr.mr_n68817904)
print v(xbgr.mr_n68818768)
print v(xbgr.mr_n68818880)
print v(xbgr.mr_n68819200)
print v(xbgr.mr_n68820064)
print v(xbgr.mr_n68820176)
print v(xbgr.mr_n68820496)
print v(xbgr.mr_n68820608)
print v(xbgr.mr_n68820928)
print v(xbgr.mr_n68821472)
print v(xbgr.mr_n68821904)
print v(xbgr.mr_n68822224)
print v(xbgr.mr_n68822656)
print v(xbgr.mr_n68822768)
print v(xbgr.mr_n68823088)
print v(xbgr.mr_n68823200)
print v(xbgr.mr_n68823520)
print v(xbgr.mr_n68823632)
print v(xbgr.mr_n68823952)
print v(xbgr.mr_n68824064)
print v(xbgr.mr_n68824384)
print v(xbgr.mr_n68824496)
print v(xbgr.mr_n68825248)
print v(xbgr.mr_n68825360)
print v(xbgr.mr_n68825680)
print v(xbgr.mr_n68825792)
print v(xbgr.mr_n68826112)
print v(xbgr.mr_n68827408)
print v(xbgr.mr_n68827520)
print v(xbgr.mr_n68827840)
print v(xbgr.mr_n68827952)
print v(xbgr.mr_n68828272)
print v(xbgr.mr_n68829248)
print v(xbgr.mr_n68829568)
print v(xbgr.mr_n68830432)
print v(xbgr.mr_n68830864)
print v(xbgr.mr_n68830976)
print v(xbgr.mr_n68831296)
print v(xbgr.mr_n68831408)
print v(xbgr.mr_n68831728)
print v(xbgr.mr_n68831840)
print v(xbgr.mr_n68832160)
print v(xbgr.mr_n68833024)
print v(xbgr.mr_n68834320)
print v(xbgr.mr_n68835184)
print v(xbgr.mr_n68836160)
print v(xbgr.mr_n68836480)
print v(xbgr.mr_n68836592)
print v(xbgr.mr_n68837024)
print v(xbgr.mr_n68837344)
print v(xbgr.mr_n68837456)
print v(xbgr.mr_n68837776)
print v(xbgr.mr_n68837888)
print v(xbgr.mr_n68838208)
print v(xbgr.mr_n68838320)
print v(xbgr.mr_n68838640)
print v(xbgr.mr_n68838752)
print v(xbgr.mr_n68839072)
print v(xbgr.mr_n68839184)
print v(xbgr.mr_n68839504)
print v(xbgr.mr_n68839616)
print v(xbgr.mr_n68839936)
print v(xbgr.mr_n68840048)
print v(xbgr.mr_n68840368)
print v(xbgr.mr_n68840480)
print v(xbgr.mr_n68840912)
print v(xbgr.mr_n68841232)
print v(xbgr.mr_n68841344)
print v(xbgr.mr_n68841776)
print v(xbgr.mr_n68842096)
print v(xbgr.mr_n68842960)
print v(xbgr.mr_n68843824)
print v(xbgr.mr_n68844688)
print v(xbgr.mr_n68844800)
print v(xbgr.mr_n68845120)
print v(xbgr.mr_n68845232)
print v(xbgr.mr_n68845552)
print v(xbgr.mr_n68845664)
print v(xbgr.mr_n68845984)
print v(xbgr.mr_n68846096)
print v(xbgr.mr_n68846528)
print v(xbgr.mr_n68846960)
print v(xbgr.mr_n68847392)
print v(xbgr.mr_n68847824)
print v(xbgr.mr_n68848144)
print v(xbgr.mr_n68848256)
print v(xbgr.mr_n68848576)
print v(xbgr.mr_n68848688)
print v(xbgr.mr_n68849008)
print v(xbgr.mr_n68849120)
print v(xbgr.mr_n68849440)
print v(xbgr.mr_n68849552)
print v(xbgr.mr_n68849872)
print v(xbgr.mr_n68849984)
print v(xbgr.mr_n68850304)
print v(xbgr.mr_n68850416)
print v(xbgr.mr_n68850736)
print v(xbgr.mr_n68850848)
print v(xbgr.mr_n68851280)
print v(xbgr.mr_n68851600)
print v(xbgr.mr_n68851712)
print v(xbgr.mr_n68852032)
print v(xbgr.mr_n68852896)
print v(xbgr.mr_n68853632)
print v(xbgr.mr_n68854496)
print v(xbgr.mr_n68855360)
print v(xbgr.mr_n68856224)
print v(xbgr.mr_n68857088)
print v(xbgr.mr_n68857200)
print v(xbgr.mr_n68857632)
print v(xbgr.mr_n68857952)
print v(xbgr.mr_n68858064)
print v(xbgr.mr_n68858496)
print v(xbgr.mr_n68858816)
print v(xbgr.mr_n68858928)
print v(xbgr.mr_n68859248)
print v(xbgr.mr_n68859360)
print v(xbgr.mr_n68859680)
print v(xbgr.mr_n68859792)
print v(xbgr.mr_n68860224)
print v(xbgr.mr_n68860544)
print v(xbgr.mr_n68861408)
print v(xbgr.mr_n68861520)
print v(xbgr.mr_n68861840)
print v(xbgr.mr_n68861952)
print v(xbgr.mr_n68862272)
print v(xbgr.mr_n68862384)
print v(xbgr.mr_n68862704)
print v(xbgr.mr_n68862816)
print v(xbgr.mr_n68863136)
print v(xbgr.mr_n68863248)
print v(xbgr.mr_n68863568)
print v(xbgr.mr_n68863680)
print v(xbgr.mr_n68864000)
print v(xbgr.mr_n68864112)
print v(xbgr.mr_n68864432)
print v(xbgr.mr_n68864864)
print v(xbgr.mr_n68864976)
print v(xbgr.mr_n68865296)
print v(xbgr.mr_n68865408)
print v(xbgr.mr_n68865728)
print v(xbgr.mr_n68865840)
print v(xbgr.mr_n68866160)
print v(xbgr.mr_n68866272)
print v(xbgr.mr_n68866592)
print v(xbgr.mr_n68867888)
print v(xbgr.mr_n68868752)
print v(xbgr.mr_n68869296)
print v(xbgr.mr_n68869728)
print v(xbgr.mr_n68870048)
print v(xbgr.mr_n68870160)
print v(xbgr.mr_n68870480)
print v(xbgr.mr_n68870592)
print v(xbgr.mr_n68870912)
print v(xbgr.mr_n68871024)
print v(xbgr.mr_n68871344)
print v(xbgr.mr_n68871456)
print v(xbgr.mr_n68871776)
print v(xbgr.mr_n68871888)
print v(xbgr.mr_n68872208)
print v(xbgr.mr_n68872320)
print v(xbgr.mr_n68872640)
print v(xbgr.mr_n68872752)
print v(xbgr.mr_n68873072)
print v(xbgr.mr_n68873184)
print v(xbgr.mr_n68873504)
print v(xbgr.mr_n68873616)
print v(xbgr.mr_n68873936)
print v(xbgr.mr_n68874800)
print v(xbgr.mr_n68875664)
print v(xbgr.mr_n68875776)
print v(xbgr.mr_n68876208)
print v(xbgr.mr_n68876960)
print v(xbgr.mr_n68877824)
print v(xbgr.mr_n68878688)
print v(xbgr.mr_n68879664)
print v(xbgr.mr_n68880096)
print v(xbgr.mr_n68880416)
print v(xbgr.mr_n68880528)
print v(xbgr.mr_n68880848)
print v(xbgr.mr_n68880960)
print v(xbgr.mr_n68881280)
print v(xbgr.mr_n68882144)
print v(xbgr.mr_n68883008)
print v(xbgr.mr_n68883120)
print v(xbgr.mr_n68883440)
print v(xbgr.mr_n68883552)
print v(xbgr.mr_n68883872)
print v(xbgr.mr_n68883984)
print v(xbgr.mr_n68884304)
print v(xbgr.mr_n68884416)
print v(xbgr.mr_n68884736)
print v(xbgr.mr_n68884848)
print v(xbgr.mr_n68885168)
print v(xbgr.mr_n68885280)
print v(xbgr.mr_n68885600)
print v(xbgr.mr_n68885712)
print v(xbgr.mr_n68886032)
print v(xbgr.mr_n68886144)
print v(xbgr.mr_n68886464)
print v(xbgr.mr_n68886576)
print v(xbgr.mr_n68887008)
print v(xbgr.mr_n68887328)
print v(xbgr.mr_n68887760)
print v(xbgr.mr_n68887872)
print v(xbgr.mr_n68888624)
print v(xbgr.mr_n68888736)
print v(xbgr.mr_n68889168)
print v(xbgr.mr_n68889920)
print v(xbgr.mr_n68890032)
print v(xbgr.mr_n68890352)
print v(xbgr.mr_n68890464)
print v(xbgr.mr_n68890896)
print v(xbgr.mr_n68891328)
print v(xbgr.mr_n68891760)
print v(xbgr.mr_n68892080)
print v(xbgr.mr_n68892192)
print v(xbgr.mr_n68892512)
print v(xbgr.mr_n68892624)
print v(xbgr.mr_n68893056)
print v(xbgr.mr_n68893376)
print v(xbgr.mr_n68894240)
print v(xbgr.mr_n68894352)
print v(xbgr.mr_n68894672)
print v(xbgr.mr_n68894784)
print v(xbgr.mr_n68895104)
print v(xbgr.mr_n68895216)
print v(xbgr.mr_n68895536)
print v(xbgr.mr_n68895648)
print v(xbgr.mr_n68895968)
print v(xbgr.mr_n68896080)
print v(xbgr.mr_n68896400)
print v(xbgr.mr_n68896512)
print v(xbgr.mr_n68896832)
print v(xbgr.mr_n68897696)
print v(xbgr.mr_n68898560)
print v(xbgr.mr_n68898672)
print v(xbgr.mr_n68898992)
print v(xbgr.mr_n68899104)
print v(xbgr.mr_n68899424)
print v(xbgr.mr_n68899536)
print v(xbgr.mr_n68899856)
print v(xbgr.mr_n68899968)
print v(xbgr.mr_n68900288)
print v(xbgr.mr_n68901152)
print v(xbgr.mr_n68902016)
print v(xbgr.mr_n68902880)
print v(xbgr.mr_n68903744)
print v(xbgr.mr_n68905152)
print v(xbgr.mr_n68905472)
print v(xbgr.mr_n68906336)
print v(xbgr.mr_n68907200)
print v(xbgr.mr_n68907312)
print v(xbgr.mr_n68907744)
print v(xbgr.mr_n68908064)
print v(xbgr.mr_n68908176)
print v(xbgr.mr_n68908608)
print v(xbgr.mr_n68908928)
print v(xbgr.mr_n68909792)
print v(xbgr.mr_n68910656)
print v(xbgr.mr_n68911520)
print v(xbgr.mr_n68912384)
print v(xbgr.mr_n68912496)
print v(xbgr.mr_n68912816)
print v(xbgr.mr_n68912928)
print v(xbgr.mr_n68913248)
print v(xbgr.mr_n68913360)
print v(xbgr.mr_n68913680)
print v(xbgr.mr_n68913792)
print v(xbgr.mr_n68914112)
print v(xbgr.mr_n68914976)
print v(xbgr.mr_n68915840)
print v(xbgr.mr_n68915952)
print v(xbgr.mr_n68916272)
print v(xbgr.mr_n68916384)
print v(xbgr.mr_n68916816)
print v(xbgr.mr_n68917248)
print v(xbgr.mr_n68917568)
print v(xbgr.mr_n68917680)
print v(xbgr.mr_n68918000)
print v(xbgr.mr_n68918112)
print v(xbgr.mr_n68918432)
print v(xbgr.mr_n68918544)
print v(xbgr.mr_n68918864)
print v(xbgr.mr_n68918976)
print v(xbgr.mr_n68919296)
print v(xbgr.mr_n68919408)
print v(xbgr.mr_n68919840)
print v(xbgr.mr_n68920160)
print v(xbgr.mr_n68920272)
print v(xbgr.mr_n68920704)
print v(xbgr.mr_n68921024)
print v(xbgr.mr_n68921888)
print v(xbgr.mr_n68922752)
print v(xbgr.mr_n68923616)
print v(xbgr.mr_n68924480)
print v(xbgr.mr_n68924592)
print v(xbgr.mr_n68924912)
print v(xbgr.mr_n68925024)
print v(xbgr.mr_n68925344)
print v(xbgr.mr_n68925456)
print v(xbgr.mr_n68925776)
print v(xbgr.mr_n68925888)
print v(xbgr.mr_n68926208)
print v(xbgr.mr_n68927072)
print v(xbgr.mr_n68927936)
print v(xbgr.mr_n68928048)
print v(xbgr.mr_n68928368)
print v(xbgr.mr_n68928480)
print v(xbgr.mr_n68928912)
print v(xbgr.mr_n68929344)
print v(xbgr.mr_n68929664)
print v(xbgr.mr_n68929776)
print v(xbgr.mr_n68930096)
print v(xbgr.mr_n68930208)
print v(xbgr.mr_n68930528)
print v(xbgr.mr_n68930640)
print v(xbgr.mr_n68930960)
print v(xbgr.mr_n68931072)
print v(xbgr.mr_n68931392)
print v(xbgr.mr_n68931504)
print v(xbgr.mr_n68931936)
print v(xbgr.mr_n68932256)
print v(xbgr.mr_n68932368)
print v(xbgr.mr_n68932800)
print v(xbgr.mr_n68933120)
print v(xbgr.mr_n68933232)
print v(xbgr.mr_n68933664)
print v(xbgr.mr_n68933984)
print v(xbgr.mr_n68934096)
print v(xbgr.mr_n68934528)
print v(xbgr.mr_n68934848)
print v(xbgr.mr_n68935712)
print v(xbgr.mr_n68936576)
print v(xbgr.mr_n68937440)
print v(xbgr.mr_n68938304)
print v(xbgr.mr_n68939168)
print v(xbgr.mr_n68940032)
print v(xbgr.mr_n68940144)
print v(xbgr.mr_n68940464)
print v(xbgr.mr_n68940576)
print v(xbgr.mr_n68940896)
print v(xbgr.mr_n68941008)
print v(xbgr.mr_n68941328)
print v(xbgr.mr_n68941440)
print v(xbgr.mr_n68941760)
print v(xbgr.mr_n68941872)
print v(xbgr.mr_n68942192)
print v(xbgr.mr_n68942304)
print v(xbgr.mr_n68942624)
print v(xbgr.mr_n68942736)
print v(xbgr.mr_n68943056)
print v(xbgr.mr_n68943168)
print v(xbgr.mr_n68943488)
print v(xbgr.mr_n68943600)
print v(xbgr.mr_n68943920)
print v(xbgr.mr_n68944032)
print v(xbgr.mr_n68944464)
print v(xbgr.mr_n68944896)
print v(xbgr.mr_n68945216)
print v(xbgr.mr_n68946080)
print v(xbgr.mr_n68946944)
print v(xbgr.mr_n68947056)
print v(xbgr.mr_n68947376)
print v(xbgr.mr_n68947488)
print v(xbgr.mr_n68947808)
print v(xbgr.mr_n68947920)
print v(xbgr.mr_n68948240)
print v(xbgr.mr_n68948352)
print v(xbgr.mr_n68948672)
print v(xbgr.mr_n68948784)
print v(xbgr.mr_n68949104)
print v(xbgr.mr_n68949216)
print v(xbgr.mr_n68949536)
print v(xbgr.mr_n68949648)
print v(xbgr.mr_n68949968)
print v(xbgr.mr_n68950080)
print v(xbgr.mr_n68950512)
print v(xbgr.mr_n68950944)
print v(xbgr.mr_n68951264)
print v(xbgr.mr_n68951376)
print v(xbgr.mr_n68951696)
print v(xbgr.mr_n68951808)
print v(xbgr.mr_n68952128)
print v(xbgr.mr_n68952240)
print v(xbgr.mr_n68952560)
print v(xbgr.mr_n68952672)
print v(xbgr.mr_n68952992)
print v(xbgr.mr_n68953104)
print v(xbgr.mr_n68953424)
print v(xbgr.mr_n68953536)
print v(xbgr.mr_n68953856)
print v(xbgr.mr_n68954720)
print v(xbgr.mr_n68955584)
print v(xbgr.mr_n68956448)
print v(xbgr.mr_n68957312)
print v(xbgr.mr_n68957424)
print v(xbgr.mr_n68957856)
print v(xbgr.mr_n68958176)
print v(xbgr.mr_n68958288)
print v(xbgr.mr_n68958608)
print v(xbgr.mr_n68958720)
print v(xbgr.mr_n68959040)
print v(xbgr.mr_n68959152)
print v(xbgr.mr_n68959472)
print v(xbgr.mr_n68959584)
print v(xbgr.mr_n68959904)
print v(xbgr.mr_n68960016)
print v(xbgr.mr_n68960336)
print v(xbgr.mr_n68960448)
print v(xbgr.mr_n68960768)
print v(xbgr.mr_n68960880)
print v(xbgr.mr_n68961312)
print v(xbgr.mr_n68961632)
print v(xbgr.mr_n68962496)
print v(xbgr.mr_n68962608)
print v(xbgr.mr_n68962928)
print v(xbgr.mr_n68963040)
print v(xbgr.mr_n68963360)
print v(xbgr.mr_n68963472)
print v(xbgr.mr_n68963792)
print v(xbgr.mr_n68963904)
print v(xbgr.mr_n68964224)
print v(xbgr.mr_n68964336)
print v(xbgr.mr_n68964768)
print v(xbgr.mr_n68965088)
print v(xbgr.mr_n68965200)
print v(xbgr.mr_n68965632)
print v(xbgr.mr_n68965952)
print v(xbgr.mr_n68966816)
print v(xbgr.mr_n68967680)
print v(xbgr.mr_n68968544)
print v(xbgr.mr_n68969408)
print v(xbgr.mr_n68969520)
print v(xbgr.mr_n68969840)
print v(xbgr.mr_n68969952)
print v(xbgr.mr_n68970272)
print v(xbgr.mr_n68970384)
print v(xbgr.mr_n68970704)
print v(xbgr.mr_n68970816)
print v(xbgr.mr_n68971136)
print v(xbgr.mr_n68971248)
print v(xbgr.mr_n68971568)
print v(xbgr.mr_n68971680)
print v(xbgr.mr_n68972000)
print v(xbgr.mr_n68972864)
print v(xbgr.mr_n68973728)
print v(xbgr.mr_n68973840)
print v(xbgr.mr_n68974160)
print v(xbgr.mr_n68974272)
print v(xbgr.mr_n68974704)
print v(xbgr.mr_n68975136)
print v(xbgr.mr_n68975456)
print v(xbgr.mr_n68975568)
print v(xbgr.mr_n68975888)
print v(xbgr.mr_n68976000)
print v(xbgr.mr_n68976320)
print v(xbgr.mr_n68976432)
print v(xbgr.mr_n68976752)
print v(xbgr.mr_n68976864)
print v(xbgr.mr_n68977184)
print v(xbgr.mr_n68978048)
print v(xbgr.mr_n68978912)
print v(xbgr.mr_n68979776)
print v(xbgr.mr_n68980640)
print v(xbgr.mr_n68981504)
print v(xbgr.mr_n68981616)
print v(xbgr.mr_n68981936)
print v(xbgr.mr_n68982048)
print v(xbgr.mr_n68982368)
print v(xbgr.mr_n68982480)
print v(xbgr.mr_n68982800)
print v(xbgr.mr_n68982912)
print v(xbgr.mr_n68983232)
print v(xbgr.mr_n68983344)
print v(xbgr.mr_n68983776)
print v(xbgr.mr_n68984096)
print v(xbgr.mr_n68984208)
print v(xbgr.mr_n68984640)
print v(xbgr.mr_n68984960)
print v(xbgr.mr_n68985072)
print v(xbgr.mr_n68985504)
print v(xbgr.mr_n68985824)
print v(xbgr.mr_n68985936)
print v(xbgr.mr_n68986368)
print v(xbgr.mr_n68986688)
print v(xbgr.mr_n68987552)
print v(xbgr.mr_n68987664)
print v(xbgr.mr_n68987984)
print v(xbgr.mr_n68988096)
print v(xbgr.mr_n68988416)
print v(xbgr.mr_n68988528)
print v(xbgr.mr_n68988848)
print v(xbgr.mr_n68988960)
print v(xbgr.mr_n68989280)
print v(xbgr.mr_n68990144)
print v(xbgr.mr_n68991008)
print v(xbgr.mr_n68991872)
print v(xbgr.mr_n68992736)
print v(xbgr.mr_n68993600)
print v(xbgr.mr_n68993712)
print v(xbgr.mr_n68994032)
print v(xbgr.mr_n68994144)
print v(xbgr.mr_n68994464)
print v(xbgr.mr_n68994576)
print v(xbgr.mr_n68994896)
print v(xbgr.mr_n68995008)
print v(xbgr.mr_n68995440)
print v(xbgr.mr_n68995872)
print v(xbgr.mr_n68996192)
print v(xbgr.mr_n68996304)
print v(xbgr.mr_n68996624)
print v(xbgr.mr_n68996736)
print v(xbgr.mr_n68997056)
print v(xbgr.mr_n68997920)
print v(xbgr.mr_n68998032)
print v(xbgr.mr_n68998352)
print v(xbgr.mr_n68998464)
print v(xbgr.mr_n68998784)
print v(xbgr.mr_n68999648)
print v(xbgr.mr_n69000512)
print v(xbgr.mr_n69000624)
print v(xbgr.mr_n69000944)
print v(xbgr.mr_n69001056)
print v(xbgr.mr_n69001376)
print v(xbgr.mr_n69002240)
print v(xbgr.mr_n69003104)
print v(xbgr.mr_n69003968)
print v(xbgr.mr_n69004080)
print v(xbgr.mr_n69004400)
print v(xbgr.mr_n69004512)
print v(xbgr.mr_n69004832)
print v(xbgr.mr_n69004944)
print v(xbgr.mr_n69005264)
print v(xbgr.mr_n69005376)
print v(xbgr.mr_n69005696)
print v(xbgr.mr_n69005808)
print v(xbgr.mr_n69006128)
print v(xbgr.mr_n69006240)
print v(xbgr.mr_n69006560)
print v(xbgr.mr_n69006672)
print v(xbgr.mr_n69006992)
print v(xbgr.mr_n69007104)
print v(xbgr.mr_n69007424)
print v(xbgr.mr_n69007536)
print v(xbgr.mr_n69007856)
print v(xbgr.mr_n69007968)
print v(xbgr.mr_n69008288)
print v(xbgr.mr_n69008400)
print v(xbgr.mr_n69008720)
print v(xbgr.mr_n69008832)
print v(xbgr.mr_n69009264)
print v(xbgr.mr_n69009584)
print v(xbgr.mr_n69009696)
print v(xbgr.mr_n69010128)
print v(xbgr.mr_n69010448)
print v(xbgr.mr_n69010560)
print v(xbgr.mr_n69010992)
print v(xbgr.mr_n69011312)
print v(xbgr.mr_n69012176)
print v(xbgr.mr_n69013040)
print v(xbgr.mr_n69013904)
print v(xbgr.mr_n69014016)
print v(xbgr.mr_n69014336)
print v(xbgr.mr_n69014448)
print v(xbgr.mr_n69014768)
print v(xbgr.mr_n69015632)
print v(xbgr.mr_n69016496)
print v(xbgr.mr_n69017360)
print v(xbgr.mr_n69017472)
print v(xbgr.mr_n69017792)
print v(xbgr.mr_n69017904)
print v(xbgr.mr_n69018224)
print v(xbgr.mr_n69018336)
print v(xbgr.mr_n69018656)
print v(xbgr.mr_n69018768)
print v(xbgr.mr_n69019088)
print v(xbgr.mr_n69019200)
print v(xbgr.mr_n69019520)
print v(xbgr.mr_n69019632)
print v(xbgr.mr_n69019952)
print v(xbgr.mr_n69020064)
print v(xbgr.mr_n69020384)
print v(xbgr.mr_n69020496)
print v(xbgr.mr_n69020816)
print v(xbgr.mr_n69020928)
print v(xbgr.mr_n69021248)
print v(xbgr.mr_n69021360)
print v(xbgr.mr_n69021680)
print v(xbgr.mr_n69021792)
print v(xbgr.mr_n69022112)
print v(xbgr.mr_n69022224)
print v(xbgr.mr_n69022544)
print v(xbgr.mr_n69022656)
print v(xbgr.mr_n69023088)
print v(xbgr.mr_n69023408)
print v(xbgr.mr_n69024272)
print v(xbgr.mr_n69025136)
print v(xbgr.mr_n69026000)
print v(xbgr.mr_n69026112)
print v(xbgr.mr_n69026544)
print v(xbgr.mr_n69026864)
print v(xbgr.mr_n69026976)
print v(xbgr.mr_n69027408)
print v(xbgr.mr_n69027728)
print v(xbgr.mr_n69027840)
print v(xbgr.mr_n69028160)
print v(xbgr.mr_n69028272)
print v(xbgr.mr_n69028592)
print v(xbgr.mr_n69028704)
print v(xbgr.mr_n69029136)
print v(xbgr.mr_n69029568)
print v(xbgr.mr_n69030000)
print v(xbgr.mr_n69030320)
print v(xbgr.mr_n69031184)
print v(xbgr.mr_n69032048)
print v(xbgr.mr_n69032912)
print v(xbgr.mr_n69033776)
print v(xbgr.mr_n69034640)
print v(xbgr.mr_n69035504)
print v(xbgr.mr_n69035616)
print v(xbgr.mr_n69035936)
print v(xbgr.mr_n69036048)
print v(xbgr.mr_n69036368)
print v(xbgr.mr_n69036480)
print v(xbgr.mr_n69036800)
print v(xbgr.mr_n69036912)
print v(xbgr.mr_n69037232)
print v(xbgr.mr_n69037344)
print v(xbgr.mr_n69037664)
print v(xbgr.mr_n69037776)
print v(xbgr.mr_n69038096)
print v(xbgr.mr_n69038960)
print v(xbgr.mr_n69039824)
print v(xbgr.mr_n69040800)
print v(xbgr.mr_n69041232)
print v(xbgr.mr_n69041664)
print v(xbgr.mr_n69041984)
print v(xbgr.mr_n69042096)
print v(xbgr.mr_n69042416)
print v(xbgr.mr_n69042528)
print v(xbgr.mr_n69042848)
print v(xbgr.mr_n69042960)
print v(xbgr.mr_n69043392)
print v(xbgr.mr_n69043712)
print v(xbgr.mr_n69043824)
print v(xbgr.mr_n69044144)
print v(xbgr.mr_n69044256)
print v(xbgr.mr_n69044688)
print v(xbgr.mr_n69045008)
print v(xbgr.mr_n69045120)
print v(xbgr.mr_n69045552)
print v(xbgr.mr_n69045872)
print v(xbgr.mr_n69045984)
print v(xbgr.mr_n69046416)
print v(xbgr.mr_n69046736)
print v(xbgr.mr_n69047600)
print v(xbgr.mr_n69048464)
print v(xbgr.mr_n69048576)
print v(xbgr.mr_n69048896)
print v(xbgr.mr_n69049008)
print v(xbgr.mr_n69049328)
print v(xbgr.mr_n69049440)
print v(xbgr.mr_n69049760)
print v(xbgr.mr_n69049872)
print v(xbgr.mr_n69050304)
print v(xbgr.mr_n69050624)
print v(xbgr.mr_n69051488)
print v(xbgr.mr_n69051600)
print v(xbgr.mr_n69051920)
print v(xbgr.mr_n69052032)
print v(xbgr.mr_n69052352)
print v(xbgr.mr_n69052464)
print v(xbgr.mr_n69052784)
print v(xbgr.mr_n69053648)
print v(xbgr.mr_n69054080)
print v(xbgr.mr_n69054944)
print v(xbgr.mr_n69055056)
print v(xbgr.mr_n69055376)
print v(xbgr.mr_n69055488)
print v(xbgr.mr_n69055808)
print v(xbgr.mr_n69055920)
print v(xbgr.mr_n69056240)
print v(xbgr.mr_n69056352)
print v(xbgr.mr_n69056672)
print v(xbgr.mr_n69056784)
print v(xbgr.mr_n69057216)
print v(xbgr.mr_n69057968)
print v(xbgr.mr_n69058832)
print v(xbgr.mr_n69059264)
print v(xbgr.mr_n69059376)
print v(xbgr.mr_n69059696)
print v(xbgr.mr_n69060128)
print v(xbgr.mr_n69060992)
print v(xbgr.mr_n69061856)
print v(xbgr.mr_n69062720)
print v(xbgr.mr_n69063584)
print v(xbgr.mr_n69064880)
print v(xbgr.mr_n69065744)
print v(xbgr.mr_n69066720)
print v(xbgr.mr_n69067040)
print v(xbgr.mr_n69067152)
print v(xbgr.mr_n69067584)
print v(xbgr.mr_n69067904)
print v(xbgr.mr_n69068768)
print v(xbgr.mr_n69068880)
print v(xbgr.mr_n69069200)
print v(xbgr.mr_n69069312)
print v(xbgr.mr_n69069744)
print v(xbgr.mr_n69070064)
print v(xbgr.mr_n69070176)
print v(xbgr.mr_n69070496)
print v(xbgr.mr_n69070608)
print v(xbgr.mr_n69070928)
print v(xbgr.mr_n69071040)
print v(xbgr.mr_n69071360)
print v(xbgr.mr_n69071472)
print v(xbgr.mr_n69071904)
print v(xbgr.mr_n69072224)
print v(xbgr.mr_n69072336)
print v(xbgr.mr_n69072656)
print v(xbgr.mr_n69072768)
print v(xbgr.mr_n69073088)
print v(xbgr.mr_n69073952)
print v(xbgr.mr_n69074064)
print v(xbgr.mr_n69074816)
print v(xbgr.mr_n69074928)
print v(xbgr.mr_n69075248)
print v(xbgr.mr_n69075360)
print v(xbgr.mr_n69075680)
print v(xbgr.mr_n69075792)
print v(xbgr.mr_n69076112)
print v(xbgr.mr_n69076224)
print v(xbgr.mr_n69076544)
print v(xbgr.mr_n69076656)
print v(xbgr.mr_n69076976)
print v(xbgr.mr_n69077088)
print v(xbgr.mr_n69077408)
print v(xbgr.mr_n69077520)
print v(xbgr.mr_n69077840)
print v(xbgr.mr_n69077952)
print v(xbgr.mr_n69078272)
print v(xbgr.mr_n69078384)
print v(xbgr.mr_n69078704)
print v(xbgr.mr_n69078816)
print v(xbgr.mr_n69079136)
print v(xbgr.mr_n69079248)
print v(xbgr.mr_n69079568)
print v(xbgr.mr_n69079680)
print v(xbgr.mr_n69080000)
print v(xbgr.mr_n69080112)
print v(xbgr.mr_n69080544)
print v(xbgr.mr_n69080864)
print v(xbgr.mr_n69080976)
print v(xbgr.mr_n69081408)
print v(xbgr.mr_n69081728)
print v(xbgr.mr_n69081840)
print v(xbgr.mr_n69082272)
print v(xbgr.mr_n69082592)
print v(xbgr.mr_n69083456)
print v(xbgr.mr_n69084320)
print v(xbgr.mr_n69085184)
print v(xbgr.mr_n69086048)
print v(xbgr.mr_n69086912)
print v(xbgr.mr_n69087776)
print v(xbgr.mr_n69087888)
print v(xbgr.mr_n69088208)
print v(xbgr.mr_n69088320)
print v(xbgr.mr_n69088640)
print v(xbgr.mr_n69088752)
print v(xbgr.mr_n69089072)
print v(xbgr.mr_n69089184)
print v(xbgr.mr_n69089504)
print v(xbgr.mr_n69090368)
print v(xbgr.mr_n69091232)
print v(xbgr.mr_n69092096)
print v(xbgr.mr_n69092208)
print v(xbgr.mr_n69092528)
print v(xbgr.mr_n69092640)
print v(xbgr.mr_n69092960)
print v(xbgr.mr_n69093072)
print v(xbgr.mr_n69093504)
print v(xbgr.mr_n69093936)
print v(xbgr.mr_n69094368)
print v(xbgr.mr_n69094688)
print v(xbgr.mr_n69094800)
print v(xbgr.mr_n69095120)
print v(xbgr.mr_n69095232)
print v(xbgr.mr_n69095552)
print v(xbgr.mr_n69095664)
print v(xbgr.mr_n69095984)
print v(xbgr.mr_n69096096)
print v(xbgr.mr_n69096416)
print v(xbgr.mr_n69096528)
print v(xbgr.mr_n69096848)
print v(xbgr.mr_n69096960)
print v(xbgr.mr_n69097280)
print v(xbgr.mr_n69097392)
print v(xbgr.mr_n69097824)
print v(xbgr.mr_n69098144)
print v(xbgr.mr_n69098256)
print v(xbgr.mr_n69098688)
print v(xbgr.mr_n69099008)
print v(xbgr.mr_n69099120)
print v(xbgr.mr_n69099552)
print v(xbgr.mr_n69099872)
print v(xbgr.mr_n69100736)
print v(xbgr.mr_n69101600)
print v(xbgr.mr_n69102464)
print v(xbgr.mr_n69103328)
print v(xbgr.mr_n69104192)
print v(xbgr.mr_n69105056)
print v(xbgr.mr_n69105168)
print v(xbgr.mr_n69105488)
print v(xbgr.mr_n69105600)
print v(xbgr.mr_n69105920)
print v(xbgr.mr_n69106032)
print v(xbgr.mr_n69106352)
print v(xbgr.mr_n69106464)
print v(xbgr.mr_n69106784)
print v(xbgr.mr_n69107648)
print v(xbgr.mr_n69108512)
print v(xbgr.mr_n69109376)
print v(xbgr.mr_n69109488)
print v(xbgr.mr_n69109808)
print v(xbgr.mr_n69109920)
print v(xbgr.mr_n69110240)
print v(xbgr.mr_n69110352)
print v(xbgr.mr_n69110784)
print v(xbgr.mr_n69111104)
print v(xbgr.mr_n69111216)
print v(xbgr.mr_n69111648)
print v(xbgr.mr_n69111968)
print v(xbgr.mr_n69112080)
print v(xbgr.mr_n69112512)
print v(xbgr.mr_n69112832)
print v(xbgr.mr_n69112944)
print v(xbgr.mr_n69113264)
print v(xbgr.mr_n69113376)
print v(xbgr.mr_n69113696)
print v(xbgr.mr_n69113808)
print v(xbgr.mr_n69114240)
print v(xbgr.mr_n69114560)
print v(xbgr.mr_n69115424)
print v(xbgr.mr_n69116288)
print v(xbgr.mr_n69117152)
print v(xbgr.mr_n69117264)
print v(xbgr.mr_n69117584)
print v(xbgr.mr_n69117696)
print v(xbgr.mr_n69118016)
print v(xbgr.mr_n69118880)
print v(xbgr.mr_n69119744)
print v(xbgr.mr_n69120608)
print v(xbgr.mr_n69121472)
print v(xbgr.mr_n69121584)
print v(xbgr.mr_n69121904)
print v(xbgr.mr_n69122016)
print v(xbgr.mr_n69122336)
print v(xbgr.mr_n69123200)
print v(xbgr.mr_n69123744)
print v(xbgr.mr_n69124064)
print v(xbgr.mr_n69124176)
print v(xbgr.mr_n69124496)
print v(xbgr.mr_n69124608)
print v(xbgr.mr_n69124928)
print v(xbgr.mr_n69125040)
print v(xbgr.mr_n69125360)
print v(xbgr.mr_n69125472)
print v(xbgr.mr_n69125904)
print v(xbgr.mr_n69126656)
print v(xbgr.mr_n69127520)
print v(xbgr.mr_n69128384)
print v(xbgr.mr_n69129248)
print v(xbgr.mr_n69129360)
print v(xbgr.mr_n69129680)
print v(xbgr.mr_n69129792)
print v(xbgr.mr_n69130112)
print v(xbgr.mr_n69130224)
print v(xbgr.mr_n69130544)
print v(xbgr.mr_n69130656)
print v(xbgr.mr_n69130976)
print v(xbgr.mr_n69131088)
print v(xbgr.mr_n69131408)
print v(xbgr.mr_n69131520)
print v(xbgr.mr_n69131840)
print v(xbgr.mr_n69131952)
print v(xbgr.mr_n69132384)
print v(xbgr.mr_n69132704)
print v(xbgr.mr_n69132816)
print v(xbgr.mr_n69133136)
print v(xbgr.mr_n69133248)
print v(xbgr.mr_n69133568)
print v(xbgr.mr_n69133680)
print v(xbgr.mr_n69134000)
print v(xbgr.mr_n69134112)
print v(xbgr.mr_n69134432)
print v(xbgr.mr_n69134544)
print v(xbgr.mr_n69134976)
print v(xbgr.mr_n69135296)
print v(xbgr.mr_n69136160)
print v(xbgr.mr_n69136272)
print v(xbgr.mr_n69136592)
print v(xbgr.mr_n69136704)
print v(xbgr.mr_n69137136)
print v(xbgr.mr_n69137568)
print v(xbgr.mr_n69137888)
print v(xbgr.mr_n69138000)
print v(xbgr.mr_n69138320)
print v(xbgr.mr_n69138432)
print v(xbgr.mr_n69138752)
print v(xbgr.mr_n69138864)
print v(xbgr.mr_n69139184)
print v(xbgr.mr_n69139296)
print v(xbgr.mr_n69139616)
print v(xbgr.mr_n69139728)
print v(xbgr.mr_n69140160)
print v(xbgr.mr_n69140480)
print v(xbgr.mr_n69140592)
print v(xbgr.mr_n69141024)
print v(xbgr.mr_n69141344)
print v(xbgr.mr_n69142208)
print v(xbgr.mr_n69143072)
print v(xbgr.mr_n69143936)
print v(xbgr.mr_n69144800)
print v(xbgr.mr_n69144912)
print v(xbgr.mr_n69145232)
print v(xbgr.mr_n69145344)
print v(xbgr.mr_n69145664)
print v(xbgr.mr_n69145776)
print v(xbgr.mr_n69146096)
print v(xbgr.mr_n69146208)
print v(xbgr.mr_n69146528)
print v(xbgr.mr_n69147392)
print v(xbgr.mr_n69148256)
print v(xbgr.mr_n69148368)
print v(xbgr.mr_n69148688)
print v(xbgr.mr_n69148800)
print v(xbgr.mr_n69149232)
print v(xbgr.mr_n69149664)
print v(xbgr.mr_n69149984)
print v(xbgr.mr_n69150096)
print v(xbgr.mr_n69150416)
print v(xbgr.mr_n69150528)
print v(xbgr.mr_n69150848)
print v(xbgr.mr_n69150960)
print v(xbgr.mr_n69151280)
print v(xbgr.mr_n69151392)
print v(xbgr.mr_n69151712)
print v(xbgr.mr_n69152576)
print v(xbgr.mr_n69153440)
print v(xbgr.mr_n69154304)
print v(xbgr.mr_n69155168)
print v(xbgr.mr_n69156032)
print v(xbgr.mr_n69156144)
print v(xbgr.mr_n69156576)
print v(xbgr.mr_n69156896)
print v(xbgr.mr_n69157008)
print v(xbgr.mr_n69157440)
print v(xbgr.mr_n69157760)
print v(xbgr.mr_n69157872)
print v(xbgr.mr_n69158304)
print v(xbgr.mr_n69158624)
print v(xbgr.mr_n69158736)
print v(xbgr.mr_n69159056)
print v(xbgr.mr_n69159168)
print v(xbgr.mr_n69159488)
print v(xbgr.mr_n69159600)
print v(xbgr.mr_n69159920)
print v(xbgr.mr_n69160032)
print v(xbgr.mr_n69160352)
print v(xbgr.mr_n69160464)
print v(xbgr.mr_n69160784)
print v(xbgr.mr_n69160896)
print v(xbgr.mr_n69161216)
print v(xbgr.mr_n69161328)
print v(xbgr.mr_n69161648)
print v(xbgr.mr_n69161760)
print v(xbgr.mr_n69162080)
print v(xbgr.mr_n69162192)
print v(xbgr.mr_n69162512)
print v(xbgr.mr_n69162624)
print v(xbgr.mr_n69162944)
print v(xbgr.mr_n69163056)
print v(xbgr.mr_n69163376)
print v(xbgr.mr_n69163488)
print v(xbgr.mr_n69163808)
print v(xbgr.mr_n69164672)
print v(xbgr.mr_n69165536)
print v(xbgr.mr_n69166400)
print v(xbgr.mr_n69166512)
print v(xbgr.mr_n69166944)
print v(xbgr.mr_n69167264)
print v(xbgr.mr_n69167376)
print v(xbgr.mr_n69167696)
print v(xbgr.mr_n69167808)
print v(xbgr.mr_n69168128)
print v(xbgr.mr_n69168240)
print v(xbgr.mr_n69168560)
print v(xbgr.mr_n69168672)
print v(xbgr.mr_n69169104)
print v(xbgr.mr_n69169536)
print v(xbgr.mr_n69169968)
print v(xbgr.mr_n69170400)
print v(xbgr.mr_n69170720)
print v(xbgr.mr_n69170832)
print v(xbgr.mr_n69171264)
print v(xbgr.mr_n69171584)
print v(xbgr.mr_n69172448)
print v(xbgr.mr_n69172560)
print v(xbgr.mr_n69172880)
print v(xbgr.mr_n69172992)
print v(xbgr.mr_n69173312)
print v(xbgr.mr_n69173424)
print v(xbgr.mr_n69173744)
print v(xbgr.mr_n69174720)
print v(xbgr.mr_n69175152)
print v(xbgr.mr_n69175584)
print v(xbgr.mr_n69175904)
print v(xbgr.mr_n69176768)
print v(xbgr.mr_n69176880)
print v(xbgr.mr_n69177200)
print v(xbgr.mr_n69177312)
print v(xbgr.mr_n69177632)
print v(xbgr.mr_n69177744)
print v(xbgr.mr_n69178064)
print v(xbgr.mr_n69178176)
print v(xbgr.mr_n69178496)
print v(xbgr.mr_n69178608)
print v(xbgr.mr_n69178928)
print v(xbgr.mr_n69179040)
print v(xbgr.mr_n69179360)
print v(xbgr.mr_n69179472)
print v(xbgr.mr_n69179792)
print v(xbgr.mr_n69179904)
print v(xbgr.mr_n69180224)
print v(xbgr.mr_n69181088)
print v(xbgr.mr_n69181952)
print v(xbgr.mr_n69182816)
print v(xbgr.mr_n69183680)
print v(xbgr.mr_n69184544)
print v(xbgr.mr_n69185408)
print v(xbgr.mr_n69186272)
print v(xbgr.mr_n69187136)
print v(xbgr.mr_n69188000)
print v(xbgr.mr_n69188864)
print v(xbgr.mr_n69189728)
print v(xbgr.mr_n69190592)
print v(xbgr.mr_n69190704)
print v(xbgr.mr_n69191024)
print v(xbgr.mr_n69191136)
print v(xbgr.mr_n69191456)
print v(xbgr.mr_n69191568)
print v(xbgr.mr_n69191888)
print v(xbgr.mr_n69192000)
print v(xbgr.mr_n69192320)
print v(xbgr.mr_n69192432)
print v(xbgr.mr_n69192864)
print v(xbgr.mr_n69193184)
print v(xbgr.mr_n69193296)
print v(xbgr.mr_n69193728)
print v(xbgr.mr_n69194048)
print v(xbgr.mr_n69194912)
print v(xbgr.mr_n69195776)
print v(xbgr.mr_n69196640)
print v(xbgr.mr_n69197504)
print v(xbgr.mr_n69197616)
print v(xbgr.mr_n69197936)
print v(xbgr.mr_n69198048)
print v(xbgr.mr_n69198368)
print v(xbgr.mr_n69198480)
print v(xbgr.mr_n69198800)
print v(xbgr.mr_n69198912)
print v(xbgr.mr_n69199232)
print v(xbgr.mr_n69199344)
print v(xbgr.mr_n69199664)
print v(xbgr.mr_n69199776)
print v(xbgr.mr_n69200096)
print v(xbgr.mr_n69200208)
print v(xbgr.mr_n69200528)
print v(xbgr.mr_n69201392)
print v(xbgr.mr_n69202256)
print v(xbgr.mr_n69202368)
print v(xbgr.mr_n69202688)
print v(xbgr.mr_n69202800)
print v(xbgr.mr_n69203232)
print v(xbgr.mr_n69203664)
print v(xbgr.mr_n69203984)
print v(xbgr.mr_n69204096)
print v(xbgr.mr_n69204416)
print v(xbgr.mr_n69204528)
print v(xbgr.mr_n69204848)
print v(xbgr.mr_n69204960)
print v(xbgr.mr_n69205280)
print v(xbgr.mr_n69205392)
print v(xbgr.mr_n69205712)
print v(xbgr.mr_n69205824)
print v(xbgr.mr_n69206256)
print v(xbgr.mr_n69206576)
print v(xbgr.mr_n69206688)
print v(xbgr.mr_n69207120)
print v(xbgr.mr_n69207440)
print v(xbgr.mr_n69207552)
print v(xbgr.mr_n69207872)
print v(xbgr.mr_n69208736)
print v(xbgr.mr_n69209600)
print v(xbgr.mr_n69210464)
print v(xbgr.mr_n69211328)
print v(xbgr.mr_n69211440)
print v(xbgr.mr_n69211760)
print v(xbgr.mr_n69211872)
print v(xbgr.mr_n69212192)
print v(xbgr.mr_n69212304)
print v(xbgr.mr_n69212624)
print v(xbgr.mr_n69212736)
print v(xbgr.mr_n69213056)
print v(xbgr.mr_n69213168)
print v(xbgr.mr_n69213488)
print v(xbgr.mr_n69213600)
print v(xbgr.mr_n69213920)
print v(xbgr.mr_n69214784)
print v(xbgr.mr_n69215648)
print v(xbgr.mr_n69215760)
print v(xbgr.mr_n69216192)
print v(xbgr.mr_n69216512)
print v(xbgr.mr_n69216624)
print v(xbgr.mr_n69216944)
print v(xbgr.mr_n69217056)
print v(xbgr.mr_n69217376)
print v(xbgr.mr_n69217488)
print v(xbgr.mr_n69217808)
print v(xbgr.mr_n69217920)
print v(xbgr.mr_n69218240)
print v(xbgr.mr_n69218352)
print v(xbgr.mr_n69218672)
print v(xbgr.mr_n69218784)
print v(xbgr.mr_n69219216)
print v(xbgr.mr_n69219648)
print v(xbgr.mr_n69220080)
print v(xbgr.mr_n69220512)
print v(xbgr.mr_n69220832)
print v(xbgr.mr_n69221264)
print v(xbgr.mr_n69221376)
print v(xbgr.mr_n69221696)
print v(xbgr.mr_n69221808)
print v(xbgr.mr_n69222128)
print v(xbgr.mr_n69222240)
print v(xbgr.mr_n69222560)
print v(xbgr.mr_n69222672)
print v(xbgr.mr_n69222992)
print v(xbgr.mr_n69223104)
print v(xbgr.mr_n69223424)
print v(xbgr.mr_n69223536)
print v(xbgr.mr_n69224288)
print v(xbgr.mr_n69224400)
print v(xbgr.mr_n69224832)
print v(xbgr.mr_n69225152)
print v(xbgr.mr_n69225584)
print v(xbgr.mr_n69225696)
print v(xbgr.mr_n69226128)
print v(xbgr.mr_n69226448)
print v(xbgr.mr_n69226560)
print v(xbgr.mr_n69226992)
print v(xbgr.mr_n69227312)
print v(xbgr.mr_n69227424)
print v(xbgr.mr_n69227856)
print v(xbgr.mr_n69228608)
print v(xbgr.mr_n69229472)
print v(xbgr.mr_n69230336)
print v(xbgr.mr_n69231200)
print v(xbgr.mr_n69232064)
print v(xbgr.mr_n69232928)
print v(xbgr.mr_n69233040)
print v(xbgr.mr_n69233360)
print v(xbgr.mr_n69233472)
print v(xbgr.mr_n69233792)
print v(xbgr.mr_n69233904)
print v(xbgr.mr_n69234224)
print v(xbgr.mr_n69234336)
print v(xbgr.mr_n69234656)
print v(xbgr.mr_n69235520)
print v(xbgr.mr_n69236384)
print v(xbgr.mr_n69237248)
print v(xbgr.mr_n69237360)
print v(xbgr.mr_n69237680)
print v(xbgr.mr_n69237792)
print v(xbgr.mr_n69238112)
print v(xbgr.mr_n69238224)
print v(xbgr.mr_n69238544)
print v(xbgr.mr_n69238656)
print v(xbgr.mr_n69238976)
print v(xbgr.mr_n69239088)
print v(xbgr.mr_n69239408)
print v(xbgr.mr_n69239520)
print v(xbgr.mr_n69239840)
print v(xbgr.mr_n69239952)
print v(xbgr.mr_n69240272)
print v(xbgr.mr_n69240384)
print v(xbgr.mr_n69240704)
print v(xbgr.mr_n69241568)
print v(xbgr.mr_n69242000)
print v(xbgr.mr_n69242864)
print v(xbgr.mr_n69243296)
print v(xbgr.mr_n69244160)
print v(xbgr.mr_n69245024)
print v(xbgr.mr_n69246320)
print v(xbgr.mr_n69247616)
print v(xbgr.mr_n69247728)
print v(xbgr.mr_n69248048)
print v(xbgr.mr_n69248160)
print v(xbgr.mr_n69248592)
print v(xbgr.mr_n69248912)
print v(xbgr.mr_n69249024)
print v(xbgr.mr_n69249456)
print v(xbgr.mr_n69249776)
print v(xbgr.mr_n69249888)
print v(xbgr.mr_n69250208)
print v(xbgr.mr_n69250320)
print v(xbgr.mr_n69250640)
print v(xbgr.mr_n69250752)
print v(xbgr.mr_n69251184)
print v(xbgr.mr_n69251504)
print v(xbgr.mr_n69251616)
print v(xbgr.mr_n69252048)
print v(xbgr.mr_n69252368)
print v(xbgr.mr_n69252480)
print v(xbgr.mr_n69252912)
print v(xbgr.mr_n69253232)
print v(xbgr.mr_n69253344)
print v(xbgr.mr_n69253664)
print v(xbgr.mr_n69254096)
print v(xbgr.mr_n69254208)
print v(xbgr.mr_n69254528)
print v(xbgr.mr_n69254640)
print v(xbgr.mr_n69254960)
print v(xbgr.mr_n69255072)
print v(xbgr.mr_n69255392)
print v(xbgr.mr_n69255504)
print v(xbgr.mr_n69256256)
print v(xbgr.mr_n69257120)
print v(xbgr.mr_n69257984)
print v(xbgr.mr_n69258096)
print v(xbgr.mr_n69258416)
print v(xbgr.mr_n69258528)
print v(xbgr.mr_n69258848)
print v(xbgr.mr_n69258960)
print v(xbgr.mr_n69259280)
print v(xbgr.mr_n69259392)
print v(xbgr.mr_n69260144)
print v(xbgr.mr_n69260576)
print v(xbgr.mr_n69261440)
print v(xbgr.mr_n69262736)
print v(xbgr.mr_n69263168)
print v(xbgr.mr_n69264032)
print v(xbgr.mr_n69264144)
print v(xbgr.mr_n69264464)
print v(xbgr.mr_n69264576)
print v(xbgr.mr_n69264896)
print v(xbgr.mr_n69265760)
print v(xbgr.mr_n69266192)
print v(xbgr.mr_n69266304)
print v(xbgr.mr_n69266624)
print v(xbgr.mr_n69267488)
print v(xbgr.mr_n69268352)
print v(xbgr.mr_n69269216)
print v(xbgr.mr_n69270080)
print v(xbgr.mr_n69270192)
print v(xbgr.mr_n69270512)
print v(xbgr.mr_n69270624)
print v(xbgr.mr_n69270944)
print v(xbgr.mr_n69271056)
print v(xbgr.mr_n69271376)
print v(xbgr.mr_n69271488)
print v(xbgr.mr_n69272240)
print v(xbgr.mr_n69273104)
print v(xbgr.mr_n69273968)
print v(xbgr.mr_n69274080)
print v(xbgr.mr_n69274512)
print v(xbgr.mr_n69274944)
print v(xbgr.mr_n69275376)
print v(xbgr.mr_n69275696)
print v(xbgr.mr_n69275808)
print v(xbgr.mr_n69276128)
print v(xbgr.mr_n69276240)
print v(xbgr.mr_n69276560)
print v(xbgr.mr_n69276672)
print v(xbgr.mr_n69276992)
print v(xbgr.mr_n69277104)
print v(xbgr.mr_n69277424)
print v(xbgr.mr_n69277536)
print v(xbgr.mr_n69277856)
print v(xbgr.mr_n69277968)
print v(xbgr.mr_n69278288)
print v(xbgr.mr_n69278400)
print v(xbgr.mr_n69278720)
print v(xbgr.mr_n69278832)
print v(xbgr.mr_n69280016)
print v(xbgr.mr_n69280560)
print v(xbgr.mr_n69280992)
print v(xbgr.mr_n69281424)
print v(xbgr.mr_n69282176)
print v(xbgr.mr_n69282288)
print v(xbgr.mr_n69282608)
print v(xbgr.mr_n69282720)
print v(xbgr.mr_n69283040)
print v(xbgr.mr_n69283152)
print v(xbgr.mr_n69283472)
print v(xbgr.mr_n69283584)
print v(xbgr.mr_n69283904)
print v(xbgr.mr_n69284016)
print v(xbgr.mr_n69284336)
print v(xbgr.mr_n69284448)
print v(xbgr.mr_n69284880)
print v(xbgr.mr_n69285200)
print v(xbgr.mr_n69285312)
print v(xbgr.mr_n69285632)
print v(xbgr.mr_n69285744)
print v(xbgr.mr_n69286176)
print v(xbgr.mr_n69286496)
print v(xbgr.mr_n69286608)
print v(xbgr.mr_n69286928)
print v(xbgr.mr_n69287040)
print v(xbgr.mr_n69287360)
print v(xbgr.mr_n69287472)
print v(xbgr.mr_n69287792)
print v(xbgr.mr_n69287904)
print v(xbgr.mr_n69288224)
print v(xbgr.mr_n69288336)
print v(xbgr.mr_n69288656)
print v(xbgr.mr_n69288768)
print v(xbgr.mr_n69289088)
print v(xbgr.mr_n69289952)
print v(xbgr.mr_n69290496)
print v(xbgr.mr_n69290816)
print v(xbgr.mr_n69290928)
print v(xbgr.mr_n69291360)
print v(xbgr.mr_n69291680)
print v(xbgr.mr_n69291792)
print v(xbgr.mr_n69292544)
print v(xbgr.mr_n69293408)
print v(xbgr.mr_n69293520)
print v(xbgr.mr_n69293840)
print v(xbgr.mr_n69293952)
print v(xbgr.mr_n69294272)
print v(xbgr.mr_n69294384)
print v(xbgr.mr_n69294704)
print v(xbgr.mr_n69295136)
print v(xbgr.mr_n69296000)
print v(xbgr.mr_n69297296)
print v(xbgr.mr_n69298272)
print v(xbgr.mr_n69298592)
print v(xbgr.mr_n69298704)
print v(xbgr.mr_n69299024)
print v(xbgr.mr_n69299136)
print v(xbgr.mr_n69299456)
print v(xbgr.mr_n69300320)
print v(xbgr.mr_n69300432)
print v(xbgr.mr_n69300752)
print v(xbgr.mr_n69300864)
print v(xbgr.mr_n69301184)
print v(xbgr.mr_n69301296)
print v(xbgr.mr_n69301616)
print v(xbgr.mr_n69301728)
print v(xbgr.mr_n69302048)
print v(xbgr.mr_n69302160)
print v(xbgr.mr_n69302480)
print v(xbgr.mr_n69303024)
print v(xbgr.mr_n69303344)
print v(xbgr.mr_n69304640)
print v(xbgr.mr_n69305504)
print v(xbgr.mr_n69306048)
print v(xbgr.mr_n69306480)
print v(xbgr.mr_n69307232)
print v(xbgr.mr_n69307344)
print v(xbgr.mr_n69307664)
print v(xbgr.mr_n69307776)
print v(xbgr.mr_n69308096)
print v(xbgr.mr_n69308208)
print v(xbgr.mr_n69308528)
print v(xbgr.mr_n69308640)
print v(xbgr.mr_n69308960)
print v(xbgr.mr_n69309072)
print v(xbgr.mr_n69309392)
print v(xbgr.mr_n69309504)
print v(xbgr.mr_n69309936)
print v(xbgr.mr_n69310256)
print v(xbgr.mr_n69310368)
print v(xbgr.mr_n69310688)
print v(xbgr.mr_n69310800)
print v(xbgr.mr_n69311120)
print v(xbgr.mr_n69311232)
print v(xbgr.mr_n69311552)
print v(xbgr.mr_n69311664)
print v(xbgr.mr_n69311984)
print v(xbgr.mr_n69312096)
print v(xbgr.mr_n69312416)
print v(xbgr.mr_n69312528)
print v(xbgr.mr_n69312848)
print v(xbgr.mr_n69312960)
print v(xbgr.mr_n69313280)
print v(xbgr.mr_n69313392)
print v(xbgr.mr_n69313824)
print v(xbgr.mr_n69314256)
print v(xbgr.mr_n69314688)
print v(xbgr.mr_n69315008)
print v(xbgr.mr_n69315120)
print v(xbgr.mr_n69315440)
print v(xbgr.mr_n69315552)
print v(xbgr.mr_n69315872)
print v(xbgr.mr_n69315984)
print v(xbgr.mr_n69316304)
print v(xbgr.mr_n69316416)
print v(xbgr.mr_n69316736)
print v(xbgr.mr_n69316848)
print v(xbgr.mr_n69317280)
print v(xbgr.mr_n69317600)
print v(xbgr.mr_n69318464)
print v(xbgr.mr_n69319328)
print v(xbgr.mr_n69319440)
print v(xbgr.mr_n69319760)
print v(xbgr.mr_n69319872)
print v(xbgr.mr_n69320192)
print v(xbgr.mr_n69320304)
print v(xbgr.mr_n69320624)
print v(xbgr.mr_n69320736)
print v(xbgr.mr_n69321056)
print v(xbgr.mr_n69322032)
print v(xbgr.mr_n69322352)
print v(xbgr.mr_n69322464)
print v(xbgr.mr_n69322784)
print v(xbgr.mr_n69322896)
print v(xbgr.mr_n69323216)
print v(xbgr.mr_n69323328)
print v(xbgr.mr_n69323648)
print v(xbgr.mr_n69323760)
print v(xbgr.mr_n69324080)
print v(xbgr.mr_n69324192)
print v(xbgr.mr_n69324512)
print v(xbgr.mr_n69325376)
print v(xbgr.mr_n69326240)
print v(xbgr.mr_n69327104)
print v(xbgr.mr_n69327968)
print v(xbgr.mr_n69328080)
print v(xbgr.mr_n69328400)
print v(xbgr.mr_n69328512)
print v(xbgr.mr_n69328832)
print v(xbgr.mr_n69329808)
print v(xbgr.mr_n69330240)
print v(xbgr.mr_n69330560)
print v(xbgr.mr_n69331424)
print v(xbgr.mr_n69332288)
print v(xbgr.mr_n69333152)
print v(xbgr.mr_n69334016)
print v(xbgr.mr_n69334128)
print v(xbgr.mr_n69334560)
print v(xbgr.mr_n69334880)
print v(xbgr.mr_n69334992)
print v(xbgr.mr_n69335312)
print v(xbgr.mr_n69335424)
print v(xbgr.mr_n69335744)
print v(xbgr.mr_n69335856)
print v(xbgr.mr_n69336288)
print v(xbgr.mr_n69336608)
print v(xbgr.mr_n69336720)
print v(xbgr.mr_n69337152)
print v(xbgr.mr_n69337472)
print v(xbgr.mr_n69337584)
print v(xbgr.mr_n69337904)
print v(xbgr.mr_n69338016)
print v(xbgr.mr_n69338336)
print v(xbgr.mr_n69338448)
print v(xbgr.mr_n69338768)
print v(xbgr.mr_n69338880)
print v(xbgr.mr_n69339200)
print v(xbgr.mr_n69339312)
print v(xbgr.mr_n69339632)
print v(xbgr.mr_n69339744)
print v(xbgr.mr_n69340176)
print v(xbgr.mr_n69340496)
print v(xbgr.mr_n69341360)
print v(xbgr.mr_n69341904)
print v(xbgr.mr_n69342224)
print v(xbgr.mr_n69342336)
print v(xbgr.mr_n69342656)
print v(xbgr.mr_n69342768)
print v(xbgr.mr_n69343088)
print v(xbgr.mr_n69343200)
print v(xbgr.mr_n69343520)
print v(xbgr.mr_n69343632)
print v(xbgr.mr_n69343952)
print v(xbgr.mr_n69344064)
print v(xbgr.mr_n69344384)
print v(xbgr.mr_n69344496)
print v(xbgr.mr_n69344928)
print v(xbgr.mr_n69345248)
print v(xbgr.mr_n69346112)
print v(xbgr.mr_n69346544)
print v(xbgr.mr_n69347408)
print v(xbgr.mr_n69348272)
print v(xbgr.mr_n69349680)
print v(xbgr.mr_n69350544)
print v(xbgr.mr_n69350976)
print v(xbgr.mr_n69351296)
print v(xbgr.mr_n69352160)
print v(xbgr.mr_n69352272)
print v(xbgr.mr_n69352592)
print v(xbgr.mr_n69352704)
print v(xbgr.mr_n69353024)
print v(xbgr.mr_n69353136)
print v(xbgr.mr_n69353456)
print v(xbgr.mr_n69353568)
print v(xbgr.mr_n69353888)
print v(xbgr.mr_n69354000)
print v(xbgr.mr_n69354320)
print v(xbgr.mr_n69354432)
print v(xbgr.mr_n69354752)
print v(xbgr.mr_n69354864)
print v(xbgr.mr_n69355184)
print v(xbgr.mr_n69356048)
print v(xbgr.mr_n69357024)
print v(xbgr.mr_n69357456)
print v(xbgr.mr_n69357888)
print v(xbgr.mr_n69358208)
print v(xbgr.mr_n69358320)
print v(xbgr.mr_n69358640)
print v(xbgr.mr_n69358752)
print v(xbgr.mr_n69359072)
print v(xbgr.mr_n69359936)
print v(xbgr.mr_n69360800)
print v(xbgr.mr_n69361664)
print v(xbgr.mr_n69361776)
print v(xbgr.mr_n69362096)
print v(xbgr.mr_n69362208)
print v(xbgr.mr_n69362528)
print v(xbgr.mr_n69363392)
print v(xbgr.mr_n69364256)
print v(xbgr.mr_n69365120)
print v(xbgr.mr_n69365232)
print v(xbgr.mr_n69365552)
print v(xbgr.mr_n69365664)
print v(xbgr.mr_n69365984)
print v(xbgr.mr_n69366096)
print v(xbgr.mr_n69366416)
print v(xbgr.mr_n69366528)
print v(xbgr.mr_n69366848)
print v(xbgr.mr_n69367712)
print v(xbgr.mr_n69368576)
print v(xbgr.mr_n69368688)
print v(xbgr.mr_n69369008)
print v(xbgr.mr_n69369120)
print v(xbgr.mr_n69369440)
print v(xbgr.mr_n69369552)
print v(xbgr.mr_n69369872)
print v(xbgr.mr_n69369984)
print v(xbgr.mr_n69370304)
print v(xbgr.mr_n69370416)
print v(xbgr.mr_n69370848)
print v(xbgr.mr_n69371168)
print v(xbgr.mr_n69371280)
print v(xbgr.mr_n69371600)
print v(xbgr.mr_n69371712)
print v(xbgr.mr_n69372032)
print v(xbgr.mr_n69372144)
print v(xbgr.mr_n69372464)
print v(xbgr.mr_n69372576)
print v(xbgr.mr_n69372896)
print v(xbgr.mr_n69373760)
print v(xbgr.mr_n69373872)
print v(xbgr.mr_n69374304)
print v(xbgr.mr_n69374624)
print v(xbgr.mr_n69374736)
print v(xbgr.mr_n69375056)
print v(xbgr.mr_n69375168)
print v(xbgr.mr_n69375488)
print v(xbgr.mr_n69375600)
print v(xbgr.mr_n69375920)
print v(xbgr.mr_n69376032)
print v(xbgr.mr_n69376352)
print v(xbgr.mr_n69376464)
print v(xbgr.mr_n69376784)
print v(xbgr.mr_n69376896)
print v(xbgr.mr_n69377216)
print v(xbgr.mr_n69377648)
print v(xbgr.mr_n69377760)
print v(xbgr.mr_n69378080)
print v(xbgr.mr_n69378624)
print v(xbgr.mr_n69378944)
print v(xbgr.mr_n69379056)
print v(xbgr.mr_n69379488)
print v(xbgr.mr_n69379920)
print v(xbgr.mr_n69380352)
print v(xbgr.mr_n69380784)
print v(xbgr.mr_n69381216)
print v(xbgr.mr_n69381536)
print v(xbgr.mr_n69381648)
print v(xbgr.mr_n69382080)
print v(xbgr.mr_n69382400)
print v(xbgr.mr_n69382512)
print v(xbgr.mr_n69382944)
print v(xbgr.mr_n69383264)
print v(xbgr.mr_n69384128)
print v(xbgr.mr_n69385424)
print v(xbgr.mr_n69385968)
print v(xbgr.mr_n69386288)
print v(xbgr.mr_n69386832)
print v(xbgr.mr_n69387152)
print v(xbgr.mr_n69387264)
print v(xbgr.mr_n69388016)
print v(xbgr.mr_n69388448)
print v(xbgr.mr_n69389312)
print v(xbgr.mr_n69390176)
print v(xbgr.mr_n69391472)
print v(xbgr.mr_n69392336)
print v(xbgr.mr_n69392768)
print v(xbgr.mr_n69392880)
print v(xbgr.mr_n69393632)
print v(xbgr.mr_n69393744)
print v(xbgr.mr_n69394064)
print v(xbgr.mr_n69394176)
print v(xbgr.mr_n69394496)
print v(xbgr.mr_n69394608)
print v(xbgr.mr_n69395360)
print v(xbgr.mr_n69396656)
print v(xbgr.mr_n69397520)
print v(xbgr.mr_n69398384)
print v(xbgr.mr_n69398816)
print v(xbgr.mr_n69398928)
print v(xbgr.mr_n69399248)
print v(xbgr.mr_n69399360)
print v(xbgr.mr_n69399680)
print v(xbgr.mr_n69399792)
print v(xbgr.mr_n69400112)
print v(xbgr.mr_n69400224)
print v(xbgr.mr_n69400976)
print v(xbgr.mr_n69401088)
print v(xbgr.mr_n69401408)
print v(xbgr.mr_n69401520)
print v(xbgr.mr_n69401840)
print v(xbgr.mr_n69401952)
print v(xbgr.mr_n69402272)
print v(xbgr.mr_n69403136)
print v(xbgr.mr_n69403248)
print v(xbgr.mr_n69403568)
print v(xbgr.mr_n69403680)
print v(xbgr.mr_n69404112)
print v(xbgr.mr_n69404432)
print v(xbgr.mr_n69404544)
print v(xbgr.mr_n69404864)
print v(xbgr.mr_n69404976)
print v(xbgr.mr_n69405296)
print v(xbgr.mr_n69405408)
print v(xbgr.mr_n69405840)
print v(xbgr.mr_n69406272)
print v(xbgr.mr_n69406592)
print v(xbgr.mr_n69406704)
print v(xbgr.mr_n69407024)
print v(xbgr.mr_n69407136)
print v(xbgr.mr_n69407456)
print v(xbgr.mr_n69407568)
print v(xbgr.mr_n69408000)
print v(xbgr.mr_n69408320)
print v(xbgr.mr_n69408432)
print v(xbgr.mr_n69408864)
print v(xbgr.mr_n69409184)
print v(xbgr.mr_n69409296)
print v(xbgr.mr_n69409616)
print v(xbgr.mr_n69409728)
print v(xbgr.mr_n69410048)
print v(xbgr.mr_n69410160)
print v(xbgr.mr_n69410480)
print v(xbgr.mr_n69410592)
print v(xbgr.mr_n69410912)
print v(xbgr.mr_n69411776)
print v(xbgr.mr_n69412640)
print v(xbgr.mr_n69412752)
print v(xbgr.mr_n69413072)
print v(xbgr.mr_n69413616)
print v(xbgr.mr_n69413936)
print v(xbgr.mr_n69414368)
print v(xbgr.mr_n69415664)
print v(xbgr.mr_n69416960)
print v(xbgr.mr_n69417072)
print v(xbgr.mr_n69417392)
print v(xbgr.mr_n69417504)
print v(xbgr.mr_n69417824)
print v(xbgr.mr_n69417936)
print v(xbgr.mr_n69418256)
print v(xbgr.mr_n69418368)
print v(xbgr.mr_n69418688)
print v(xbgr.mr_n69418800)
print v(xbgr.mr_n69419120)
print v(xbgr.mr_n69419232)
print v(xbgr.mr_n69419552)
print v(xbgr.mr_n69419664)
print v(xbgr.mr_n69420096)
print v(xbgr.mr_n69420416)
print v(xbgr.mr_n69421280)
print v(xbgr.mr_n69421392)
print v(xbgr.mr_n69421712)
print v(xbgr.mr_n69421824)
print v(xbgr.mr_n69422144)
print v(xbgr.mr_n69422256)
print v(xbgr.mr_n69422576)
print v(xbgr.mr_n69422688)
print v(xbgr.mr_n69423008)
print v(xbgr.mr_n69423872)
print v(xbgr.mr_n69424736)
print v(xbgr.mr_n69425600)
print v(xbgr.mr_n69426464)
print v(xbgr.mr_n69427328)
print v(xbgr.mr_n69427440)
print v(xbgr.mr_n69427760)
print v(xbgr.mr_n69427872)
print v(xbgr.mr_n69428192)
print v(xbgr.mr_n69428304)
print v(xbgr.mr_n69428624)
print v(xbgr.mr_n69428736)
print v(xbgr.mr_n69429056)
print v(xbgr.mr_n69429168)
print v(xbgr.mr_n69429488)
print v(xbgr.mr_n69429600)
print v(xbgr.mr_n69429920)
print v(xbgr.mr_n69430032)
print v(xbgr.mr_n69430352)
print v(xbgr.mr_n69430464)
print v(xbgr.mr_n69430784)
print v(xbgr.mr_n69430896)
print v(xbgr.mr_n69431216)
print v(xbgr.mr_n69431328)
print v(xbgr.mr_n69431760)
print v(xbgr.mr_n69432080)
print v(xbgr.mr_n69432192)
print v(xbgr.mr_n69432512)
print v(xbgr.mr_n69432624)
print v(xbgr.mr_n69433056)
print v(xbgr.mr_n69433376)
print v(xbgr.mr_n69433488)
print v(xbgr.mr_n69433920)
print v(xbgr.mr_n69434240)
print v(xbgr.mr_n69434352)
print v(xbgr.mr_n69434784)
print v(xbgr.mr_n69435216)
print v(xbgr.mr_n69435536)
print v(xbgr.mr_n69435648)
print v(xbgr.mr_n69436080)
print v(xbgr.mr_n69436400)
print v(xbgr.mr_n69436512)
print v(xbgr.mr_n69436832)
print v(xbgr.mr_n69436944)
print v(xbgr.mr_n69437264)
print v(xbgr.mr_n69437376)
print v(xbgr.mr_n69437696)
print v(xbgr.mr_n69437808)
print v(xbgr.mr_n69438128)
print v(xbgr.mr_n69438240)
print v(xbgr.mr_n69438560)
print v(xbgr.mr_n69438672)
print v(xbgr.mr_n69438992)
print v(xbgr.mr_n69439104)
print v(xbgr.mr_n69439424)
print v(xbgr.mr_n69439536)
print v(xbgr.mr_n69439856)
print v(xbgr.mr_n69440720)
print v(xbgr.mr_n69440832)
print v(xbgr.mr_n69441152)
print v(xbgr.mr_n69441264)
print v(xbgr.mr_n69441584)
print v(xbgr.mr_n69442448)
print v(xbgr.mr_n69443312)
print v(xbgr.mr_n69444176)
print v(xbgr.mr_n69445040)
print v(xbgr.mr_n69445904)
print v(xbgr.mr_n69446016)
print v(xbgr.mr_n69446336)
print v(xbgr.mr_n69446448)
print v(xbgr.mr_n69446768)
print v(xbgr.mr_n69446880)
print v(xbgr.mr_n69447200)
print v(xbgr.mr_n69448064)
print v(xbgr.mr_n69448928)
print v(xbgr.mr_n69449792)
print v(xbgr.mr_n69450656)
print v(xbgr.mr_n69451520)
print v(xbgr.mr_n69452384)
print v(xbgr.mr_n69453248)
print v(xbgr.mr_n69453360)
print v(xbgr.mr_n69453680)
print v(xbgr.mr_n69453792)
print v(xbgr.mr_n69454224)
print v(xbgr.mr_n69454544)
print v(xbgr.mr_n69455408)
print v(xbgr.mr_n69455952)
print v(xbgr.mr_n69456384)
print v(xbgr.mr_n69456816)
print v(xbgr.mr_n69457568)
print v(xbgr.mr_n69458432)
print v(xbgr.mr_n69459296)
print v(xbgr.mr_n69459408)
print v(xbgr.mr_n69459728)
print v(xbgr.mr_n69459840)
print v(xbgr.mr_n69460272)
print v(xbgr.mr_n69460704)
print v(xbgr.mr_n69461024)
print v(xbgr.mr_n69461888)
print v(xbgr.mr_n69462000)
print v(xbgr.mr_n69462432)
print v(xbgr.mr_n69462752)
print v(xbgr.mr_n69462864)
print v(xbgr.mr_n69463296)
print v(xbgr.mr_n69463616)
print v(xbgr.mr_n69464480)
print v(xbgr.mr_n69464592)
print v(xbgr.mr_n69464912)
print v(xbgr.mr_n69465776)
print v(xbgr.mr_n69466640)
print v(xbgr.mr_n69466752)
print v(xbgr.mr_n69467072)
print v(xbgr.mr_n69467184)
print v(xbgr.mr_n69467504)
print v(xbgr.mr_n69468368)
print v(xbgr.mr_n69468800)
print v(xbgr.mr_n69468912)
print v(xbgr.mr_n69469344)
print v(xbgr.mr_n69469664)
print v(xbgr.mr_n69469776)
print v(xbgr.mr_n69470208)
print v(xbgr.mr_n69470960)
print v(xbgr.mr_n69471072)
print v(xbgr.mr_n69471392)
print v(xbgr.mr_n69471504)
print v(xbgr.mr_n69471824)
print v(xbgr.mr_n69471936)
print v(xbgr.mr_n69472256)
print v(xbgr.mr_n69472688)
print v(xbgr.mr_n69472800)
print v(xbgr.mr_n69473552)
print v(xbgr.mr_n69473984)
print v(xbgr.mr_n69474096)
print v(xbgr.mr_n69474960)
print v(xbgr.mr_n69475280)
print v(xbgr.mr_n69475392)
print v(xbgr.mr_n69475712)
print v(xbgr.mr_n69476576)
print v(xbgr.mr_n69477440)
print v(xbgr.mr_n69478304)
print v(xbgr.mr_n69479168)
print v(xbgr.mr_n69479280)
print v(xbgr.mr_n69479600)
print v(xbgr.mr_n69479712)
print v(xbgr.mr_n69480032)
print v(xbgr.mr_n69480144)
print v(xbgr.mr_n69480464)
print v(xbgr.mr_n69480576)
print v(xbgr.mr_n69480896)
print v(xbgr.mr_n69481008)
print v(xbgr.mr_n69481328)
print v(xbgr.mr_n69481440)
print v(xbgr.mr_n69481760)
print v(xbgr.mr_n69481872)
print v(xbgr.mr_n69482192)
print v(xbgr.mr_n69482304)
print v(xbgr.mr_n69482624)
print v(xbgr.mr_n69482736)
print v(xbgr.mr_n69483056)
print v(xbgr.mr_n69483168)
print v(xbgr.mr_n69483600)
print v(xbgr.mr_n69484032)
print v(xbgr.mr_n69484464)
print v(xbgr.mr_n69484784)
print v(xbgr.mr_n69484896)
print v(xbgr.mr_n69485216)
print v(xbgr.mr_n69486080)
print v(xbgr.mr_n69486192)
print v(xbgr.mr_n69486512)
print v(xbgr.mr_n69486624)
print v(xbgr.mr_n69486944)
print v(xbgr.mr_n69487056)
print v(xbgr.mr_n69487488)
print v(xbgr.mr_n69487808)
print v(xbgr.mr_n69487920)
print v(xbgr.mr_n69488240)
print v(xbgr.mr_n69488352)
print v(xbgr.mr_n69488784)
print v(xbgr.mr_n69489104)
print v(xbgr.mr_n69489536)
print v(xbgr.mr_n69489648)
print v(xbgr.mr_n69489968)
print v(xbgr.mr_n69490080)
print v(xbgr.mr_n69490400)
print v(xbgr.mr_n69490512)
print v(xbgr.mr_n69490832)
print v(xbgr.mr_n69490944)
print v(xbgr.mr_n69491376)
print v(xbgr.mr_n69491696)
print v(xbgr.mr_n69491808)
print v(xbgr.mr_n69492128)
print v(xbgr.mr_n69492240)
print v(xbgr.mr_n69492560)
print v(xbgr.mr_n69492672)
print v(xbgr.mr_n69492992)
print v(xbgr.mr_n69493104)
print v(xbgr.mr_n69493424)
print v(xbgr.mr_n69493536)
print v(xbgr.mr_n69493856)
print v(xbgr.mr_n69493968)
print v(xbgr.mr_n69494288)
print v(xbgr.mr_n69494400)
print v(xbgr.mr_n69495152)
print v(xbgr.mr_n69495584)
print v(xbgr.mr_n69496448)
print v(xbgr.mr_n69496560)
print v(xbgr.mr_n69496880)
print v(xbgr.mr_n69497424)
print v(xbgr.mr_n69497856)
print v(xbgr.mr_n69498288)
print v(xbgr.mr_n69498608)
print v(xbgr.mr_n69499040)
print v(xbgr.mr_n69499904)
print v(xbgr.mr_n69502064)
print v(xbgr.mr_n69502928)
print v(xbgr.mr_n69503040)
print v(xbgr.mr_n69503360)
print v(xbgr.mr_n69504224)
print v(xbgr.mr_n69505088)
print v(xbgr.mr_n69505200)
print v(xbgr.mr_n69505520)
print v(xbgr.mr_n69505632)
print v(xbgr.mr_n69505952)
print v(xbgr.mr_n69506064)
print v(xbgr.mr_n69506384)
print v(xbgr.mr_n69506496)
print v(xbgr.mr_n69506816)
print v(xbgr.mr_n69507680)
print v(xbgr.mr_n69508544)
print v(xbgr.mr_n69508656)
print v(xbgr.mr_n69508976)
print v(xbgr.mr_n69509088)
print v(xbgr.mr_n69509408)
print v(xbgr.mr_n69509520)
print v(xbgr.mr_n69509840)
print v(xbgr.mr_n69509952)
print v(xbgr.mr_n69510272)
print v(xbgr.mr_n69510384)
print v(xbgr.mr_n69510704)
print v(xbgr.mr_n69510816)
print v(xbgr.mr_n69511136)
print v(xbgr.mr_n69511248)
print v(xbgr.mr_n69511680)
print v(xbgr.mr_n69512000)
print v(xbgr.mr_n69512112)
print v(xbgr.mr_n69512544)
print v(xbgr.mr_n69512864)
print v(xbgr.mr_n69513408)
print v(xbgr.mr_n69514272)
print v(xbgr.mr_n69514592)
print v(xbgr.mr_n69514704)
print v(xbgr.mr_n69515888)
print v(xbgr.mr_n69516000)
print v(xbgr.mr_n69516320)
print v(xbgr.mr_n69516432)
print v(xbgr.mr_n69516752)
print v(xbgr.mr_n69516864)
print v(xbgr.mr_n69517184)
print v(xbgr.mr_n69517296)
print v(xbgr.mr_n69517616)
print v(xbgr.mr_n69518480)
print v(xbgr.mr_n69519344)
print v(xbgr.mr_n69519456)
print v(xbgr.mr_n69519888)
print v(xbgr.mr_n69520320)
print v(xbgr.mr_n69520752)
print v(xbgr.mr_n69521072)
print v(xbgr.mr_n69521184)
print v(xbgr.mr_n69521504)
print v(xbgr.mr_n69521616)
print v(xbgr.mr_n69521936)
print v(xbgr.mr_n69522048)
print v(xbgr.mr_n69522368)
print v(xbgr.mr_n69522480)
print v(xbgr.mr_n69522800)
print v(xbgr.mr_n69522912)
print v(xbgr.mr_n69523232)
print v(xbgr.mr_n69523344)
print v(xbgr.mr_n69523664)
print v(xbgr.mr_n69524528)
print v(xbgr.mr_n69524640)
print v(xbgr.mr_n69524960)
print v(xbgr.mr_n69525072)
print v(xbgr.mr_n69525392)
print v(xbgr.mr_n69525504)
print v(xbgr.mr_n69525824)
print v(xbgr.mr_n69525936)
print v(xbgr.mr_n69526256)
print v(xbgr.mr_n69526800)
print v(xbgr.mr_n69527552)
print v(xbgr.mr_n69528416)
print v(xbgr.mr_n69529280)
print v(xbgr.mr_n69530144)
print v(xbgr.mr_n69531008)
print v(xbgr.mr_n69531872)
print v(xbgr.mr_n69531984)
print v(xbgr.mr_n69532304)
print v(xbgr.mr_n69532416)
print v(xbgr.mr_n69532736)
print v(xbgr.mr_n69532848)
print v(xbgr.mr_n69533168)
print v(xbgr.mr_n69533280)
print v(xbgr.mr_n69533600)
print v(xbgr.mr_n69533712)
print v(xbgr.mr_n69534032)
print v(xbgr.mr_n69534144)
print v(xbgr.mr_n69534464)
print v(xbgr.mr_n69535328)
print v(xbgr.mr_n69536192)
print v(xbgr.mr_n69537056)
print v(xbgr.mr_n69537920)
print v(xbgr.mr_n69538784)
print v(xbgr.mr_n69539648)
print v(xbgr.mr_n69540512)
print v(xbgr.mr_n69540624)
print v(xbgr.mr_n69540944)
print v(xbgr.mr_n69541056)
print v(xbgr.mr_n69541376)
print v(xbgr.mr_n69541488)
print v(xbgr.mr_n69541808)
print v(xbgr.mr_n69541920)
print v(xbgr.mr_n69542240)
print v(xbgr.mr_n69542352)
print v(xbgr.mr_n69542672)
print v(xbgr.mr_n69542784)
print v(xbgr.mr_n69543104)
print v(xbgr.mr_n69543216)
print v(xbgr.mr_n69543648)
print v(xbgr.mr_n69543968)
print v(xbgr.mr_n69544080)
print v(xbgr.mr_n69544512)
print v(xbgr.mr_n69544832)
print v(xbgr.mr_n69544944)
print v(xbgr.mr_n69545376)
print v(xbgr.mr_n69545696)
print v(xbgr.mr_n69546560)
print v(xbgr.mr_n69547424)
print v(xbgr.mr_n69548288)
print v(xbgr.mr_n69549152)
print v(xbgr.mr_n69550016)
print v(xbgr.mr_n69550880)
print v(xbgr.mr_n69550992)
print v(xbgr.mr_n69551312)
print v(xbgr.mr_n69551424)
print v(xbgr.mr_n69551744)
print v(xbgr.mr_n69551856)
print v(xbgr.mr_n69552176)
print v(xbgr.mr_n69552288)
print v(xbgr.mr_n69552608)
print v(xbgr.mr_n69553472)
print v(xbgr.mr_n69554336)
print v(xbgr.mr_n69555200)
print v(xbgr.mr_n69555312)
print v(xbgr.mr_n69555744)
print v(xbgr.mr_n69556064)
print v(xbgr.mr_n69556176)
print v(xbgr.mr_n69556496)
print v(xbgr.mr_n69556608)
print v(xbgr.mr_n69556928)
print v(xbgr.mr_n69557040)
print v(xbgr.mr_n69557360)
print v(xbgr.mr_n69557472)
print v(xbgr.mr_n69557792)
print v(xbgr.mr_n69557904)
print v(xbgr.mr_n69558336)
print v(xbgr.mr_n69558656)
print v(xbgr.mr_n69558768)
print v(xbgr.mr_n69559200)
print v(xbgr.mr_n69559520)
print v(xbgr.mr_n69559632)
print v(xbgr.mr_n69559952)
print v(xbgr.mr_n69560064)
print v(xbgr.mr_n69560496)
print v(xbgr.mr_n69560928)
print v(xbgr.mr_n69561248)
print v(xbgr.mr_n69561360)
print v(xbgr.mr_n69561792)
print v(xbgr.mr_n69562112)
print v(xbgr.mr_n69562224)
print v(xbgr.mr_n69562656)
print v(xbgr.mr_n69562976)
print v(xbgr.mr_n69563840)
print v(xbgr.mr_n69564704)
print v(xbgr.mr_n69565568)
print v(xbgr.mr_n69566432)
print v(xbgr.mr_n69566544)
print v(xbgr.mr_n69566864)
print v(xbgr.mr_n69566976)
print v(xbgr.mr_n69567296)
print v(xbgr.mr_n69567408)
print v(xbgr.mr_n69567728)
print v(xbgr.mr_n69567840)
print v(xbgr.mr_n69568160)
print v(xbgr.mr_n69569024)
print v(xbgr.mr_n69569888)
print v(xbgr.mr_n69570752)
print v(xbgr.mr_n69571616)
print v(xbgr.mr_n69572480)
print v(xbgr.mr_n69573344)
print v(xbgr.mr_n69574208)
print v(xbgr.mr_n69575072)
print v(xbgr.mr_n69575184)
print v(xbgr.mr_n69575504)
print v(xbgr.mr_n69575616)
print v(xbgr.mr_n69575936)
print v(xbgr.mr_n69576048)
print v(xbgr.mr_n69576368)
print v(xbgr.mr_n69576480)
print v(xbgr.mr_n69576800)
print v(xbgr.mr_n69576912)
print v(xbgr.mr_n69577232)
print v(xbgr.mr_n69577344)
print v(xbgr.mr_n69577664)
print v(xbgr.mr_n69577776)
print v(xbgr.mr_n69578096)
print v(xbgr.mr_n69578208)
print v(xbgr.mr_n69578528)
print v(xbgr.mr_n69578640)
print v(xbgr.mr_n69578960)
print v(xbgr.mr_n69579072)
print v(xbgr.mr_n69579504)
print v(xbgr.mr_n69579824)
print v(xbgr.mr_n69579936)
print v(xbgr.mr_n69580256)
print v(xbgr.mr_n69580368)
print v(xbgr.mr_n69580688)
print v(xbgr.mr_n69580800)
print v(xbgr.mr_n69581120)
print v(xbgr.mr_n69581232)
print v(xbgr.mr_n69581552)
print v(xbgr.mr_n69581664)
print v(xbgr.mr_n69582096)
print v(xbgr.mr_n69582416)
print v(xbgr.mr_n69582528)
print v(xbgr.mr_n69582960)
print v(xbgr.mr_n69583280)
print v(xbgr.mr_n69583392)
print v(xbgr.mr_n69583712)
print v(xbgr.mr_n69584576)
print v(xbgr.mr_n69585440)
print v(xbgr.mr_n69585984)
print v(xbgr.mr_n69586736)
print v(xbgr.mr_n69587168)
print v(xbgr.mr_n69587280)
print v(xbgr.mr_n69588032)
print v(xbgr.mr_n69588144)
print v(xbgr.mr_n69588576)
print v(xbgr.mr_n69589008)
print v(xbgr.mr_n69589328)
print v(xbgr.mr_n69590192)
print v(xbgr.mr_n69590624)
print v(xbgr.mr_n69591488)
print v(xbgr.mr_n69591600)
print v(xbgr.mr_n69592352)
print v(xbgr.mr_n69593648)
print v(xbgr.mr_n69594512)
print v(xbgr.mr_n69594624)
print v(xbgr.mr_n69594944)
print v(xbgr.mr_n69595056)
print v(xbgr.mr_n69595376)
print v(xbgr.mr_n69595488)
print v(xbgr.mr_n69595808)
print v(xbgr.mr_n69595920)
print v(xbgr.mr_n69596240)
print v(xbgr.mr_n69597104)
print v(xbgr.mr_n69597968)
print v(xbgr.mr_n69598832)
print v(xbgr.mr_n69598944)
print v(xbgr.mr_n69599264)
print v(xbgr.mr_n69599376)
print v(xbgr.mr_n69599696)
print v(xbgr.mr_n69600560)
print v(xbgr.mr_n69600672)
print v(xbgr.mr_n69600992)
print v(xbgr.mr_n69601104)
print v(xbgr.mr_n69601424)
print v(xbgr.mr_n69601536)
print v(xbgr.mr_n69601856)
print v(xbgr.mr_n69601968)
print v(xbgr.mr_n69602288)
print v(xbgr.mr_n69603152)
print v(xbgr.mr_n69604016)
print v(xbgr.mr_n69604128)
print v(xbgr.mr_n69604448)
print v(xbgr.mr_n69604560)
print v(xbgr.mr_n69604880)
print v(xbgr.mr_n69604992)
print v(xbgr.mr_n69605312)
print v(xbgr.mr_n69605424)
print v(xbgr.mr_n69605744)
print v(xbgr.mr_n69605856)
print v(xbgr.mr_n69606176)
print v(xbgr.mr_n69606288)
print v(xbgr.mr_n69607040)
print v(xbgr.mr_n69607904)
print v(xbgr.mr_n69608768)
print v(xbgr.mr_n69608880)
print v(xbgr.mr_n69609200)
print v(xbgr.mr_n69609312)
print v(xbgr.mr_n69609632)
print v(xbgr.mr_n69609744)
print v(xbgr.mr_n69610064)
print v(xbgr.mr_n69610176)
print v(xbgr.mr_n69610608)
print v(xbgr.mr_n69610928)
print v(xbgr.mr_n69611040)
print v(xbgr.mr_n69611792)
print v(xbgr.mr_n69612656)
print v(xbgr.mr_n69613520)
print v(xbgr.mr_n69614384)
print v(xbgr.mr_n69614496)
print v(xbgr.mr_n69614816)
print v(xbgr.mr_n69614928)
print v(xbgr.mr_n69615248)
print v(xbgr.mr_n69615360)
print v(xbgr.mr_n69615680)
print v(xbgr.mr_n69615792)
print v(xbgr.mr_n69616112)
print v(xbgr.mr_n69616976)
print v(xbgr.mr_n69618272)
print v(xbgr.mr_n69618384)
print v(xbgr.mr_n69618704)
print v(xbgr.mr_n69618816)
print v(xbgr.mr_n69619248)
print v(xbgr.mr_n69619568)
print v(xbgr.mr_n69619680)
print v(xbgr.mr_n69620112)
print v(xbgr.mr_n69620432)
print v(xbgr.mr_n69620864)
print v(xbgr.mr_n69621728)
print v(xbgr.mr_n69622592)
print v(xbgr.mr_n69622704)
print v(xbgr.mr_n69623024)
print v(xbgr.mr_n69623136)
print v(xbgr.mr_n69623568)
print v(xbgr.mr_n69623888)
print v(xbgr.mr_n69624000)
print v(xbgr.mr_n69624320)
print v(xbgr.mr_n69624432)
print v(xbgr.mr_n69624752)
print v(xbgr.mr_n69624864)
print v(xbgr.mr_n69625184)
print v(xbgr.mr_n69625296)
print v(xbgr.mr_n69625728)
print v(xbgr.mr_n69626160)
print v(xbgr.mr_n69626592)
print v(xbgr.mr_n69627024)
print v(xbgr.mr_n69627344)
print v(xbgr.mr_n69627456)
print v(xbgr.mr_n69627888)
print v(xbgr.mr_n69628208)
print v(xbgr.mr_n69629072)
print v(xbgr.mr_n69629936)
print v(xbgr.mr_n69630368)
print v(xbgr.mr_n69631232)
print v(xbgr.mr_n69631664)
print v(xbgr.mr_n69631776)
print v(xbgr.mr_n69632528)
print v(xbgr.mr_n69633392)
print v(xbgr.mr_n69634256)
print v(xbgr.mr_n69634368)
print v(xbgr.mr_n69634800)
print v(xbgr.mr_n69635120)
print v(xbgr.mr_n69635984)
print v(xbgr.mr_n69636096)
print v(xbgr.mr_n69636416)
print v(xbgr.mr_n69636528)
print v(xbgr.mr_n69636848)
print v(xbgr.mr_n69636960)
print v(xbgr.mr_n69637280)
print v(xbgr.mr_n69637392)
print v(xbgr.mr_n69637712)
print v(xbgr.mr_n69637824)
print v(xbgr.mr_n69638144)
print v(xbgr.mr_n69638256)
print v(xbgr.mr_n69638576)
print v(xbgr.mr_n69638688)
print v(xbgr.mr_n69639008)
print v(xbgr.mr_n69639120)
print v(xbgr.mr_n69639440)
print v(xbgr.mr_n69639552)
print v(xbgr.mr_n69639872)
print v(xbgr.mr_n69639984)
print v(xbgr.mr_n69640736)
print v(xbgr.mr_n69642032)
print v(xbgr.mr_n69642896)
print v(xbgr.mr_n69644192)
print v(xbgr.mr_n69644304)
print v(xbgr.mr_n69644624)
print v(xbgr.mr_n69644736)
print v(xbgr.mr_n69645056)
print v(xbgr.mr_n69645168)
print v(xbgr.mr_n69645488)
print v(xbgr.mr_n69645600)
print v(xbgr.mr_n69646352)
print v(xbgr.mr_n69647216)
print v(xbgr.mr_n69648080)
print v(xbgr.mr_n69648944)
print v(xbgr.mr_n69649056)
print v(xbgr.mr_n69649376)
print v(xbgr.mr_n69649488)
print v(xbgr.mr_n69649808)
print v(xbgr.mr_n69649920)
print v(xbgr.mr_n69650240)
print v(xbgr.mr_n69650352)
print v(xbgr.mr_n69650672)
print v(xbgr.mr_n69650784)
print v(xbgr.mr_n69651104)
print v(xbgr.mr_n69651648)
print v(xbgr.mr_n69652400)
print v(xbgr.mr_n69653264)
print v(xbgr.mr_n69653376)
print v(xbgr.mr_n69653696)
print v(xbgr.mr_n69653808)
print v(xbgr.mr_n69654240)
print v(xbgr.mr_n69654560)
print v(xbgr.mr_n69654672)
print v(xbgr.mr_n69654992)
print v(xbgr.mr_n69655104)
print v(xbgr.mr_n69655424)
print v(xbgr.mr_n69655536)
print v(xbgr.mr_n69655856)
print v(xbgr.mr_n69655968)
print v(xbgr.mr_n69656288)
print v(xbgr.mr_n69656720)
print v(xbgr.mr_n69656832)
print v(xbgr.mr_n69657152)
print v(xbgr.mr_n69657264)
print v(xbgr.mr_n69658016)
print v(xbgr.mr_n69658128)
print v(xbgr.mr_n69658448)
print v(xbgr.mr_n69658560)
print v(xbgr.mr_n69659312)
print v(xbgr.mr_n69660176)
print v(xbgr.mr_n69660288)
print v(xbgr.mr_n69660608)
print v(xbgr.mr_n69661472)
print v(xbgr.mr_n69662016)
print v(xbgr.mr_n69662336)
print v(xbgr.mr_n69662880)
print v(xbgr.mr_n69663312)
print v(xbgr.mr_n69663632)
print v(xbgr.mr_n69663744)
print v(xbgr.mr_n69664496)
print v(xbgr.mr_n69664608)
print v(xbgr.mr_n69664928)
print v(xbgr.mr_n69665040)
print v(xbgr.mr_n69665360)
print v(xbgr.mr_n69666224)
print v(xbgr.mr_n69666656)
print v(xbgr.mr_n69666768)
print v(xbgr.mr_n69667088)
print v(xbgr.mr_n69667200)
print v(xbgr.mr_n69667520)
print v(xbgr.mr_n69667632)
print v(xbgr.mr_n69667952)
print v(xbgr.mr_n69668064)
print v(xbgr.mr_n69668384)
print v(xbgr.mr_n69668496)
print v(xbgr.mr_n69669680)
print v(xbgr.mr_n69669792)
print v(xbgr.mr_n69670112)
print v(xbgr.mr_n69670224)
print v(xbgr.mr_n69670544)
print v(xbgr.mr_n69670656)
print v(xbgr.mr_n69670976)
print v(xbgr.mr_n69671408)
print v(xbgr.mr_n69803792)
print v(xbgr.mr_n69803904)
print v(xbgr.mr_n69804224)
print v(xbgr.mr_n69804336)
print v(xbgr.mr_n69804656)
print v(xbgr.mr_n69804768)
print v(xbgr.mr_n69805088)
print v(xbgr.mr_n69805200)
print v(xbgr.mr_n69805520)
print v(xbgr.mr_n69805632)
print v(xbgr.mr_n69805952)
print v(xbgr.mr_n69806064)
print v(xbgr.mr_n69806384)
print v(xbgr.mr_n69806496)
print v(xbgr.mr_n69806816)
print v(xbgr.mr_n69806928)
print v(xbgr.mr_n69807248)
print v(xbgr.mr_n69807360)
print v(xbgr.mr_n69807680)
print v(xbgr.mr_n69807792)
print v(xbgr.mr_n69808112)
print v(xbgr.mr_n69808224)
print v(xbgr.mr_n69808544)
print v(xbgr.mr_n69808656)
print v(xbgr.mr_n69808976)
print v(xbgr.mr_n69809088)
print v(xbgr.mr_n69809408)
print v(xbgr.mr_n69809520)
print v(xbgr.mr_n69809840)
print v(xbgr.mr_n69809952)
print v(xbgr.mr_n69810272)
print v(xbgr.mr_n69810384)
print v(xbgr.mr_n69810704)
print v(xbgr.mr_n69810816)
print v(xbgr.mr_n69811136)
print v(xbgr.mr_n69811248)
print v(xbgr.mr_n69811568)
print v(xbgr.mr_n69811680)
print v(xbgr.mr_n69812000)
print v(xbgr.mr_n69812112)
print v(xbgr.mr_n69812432)
print v(xbgr.mr_n69812544)
print v(xbgr.mr_n69812864)
print v(xbgr.mr_n69812976)
print v(xbgr.mr_n69813296)
print v(xbgr.mr_n69813408)
print v(xbgr.mr_n69813728)
print v(xbgr.mr_n69813840)
print v(xbgr.mr_n69814160)
print v(xbgr.mr_n69814272)
print v(xbgr.mr_n69814592)
print v(xbgr.mr_n69814704)
print v(xbgr.mr_n69815024)
print v(xbgr.mr_n69815136)
print v(xbgr.mr_n69815456)
print v(xbgr.mr_n69815568)
print v(xbgr.mr_n69815888)
print v(xbgr.mr_n69816000)
print v(xbgr.mr_n69816320)
print v(xbgr.mr_n69816432)
print v(xbgr.mr_n69816752)
print v(xbgr.mr_n69816864)
print v(xbgr.mr_n69817184)
print v(xbgr.mr_n69817296)
print v(xbgr.mr_n69817616)
print v(xbgr.mr_n69817728)
print v(xbgr.mr_n69818048)
print v(xbgr.mr_n69818160)
print v(xbgr.mr_n69818480)
print v(xbgr.mr_n69818592)
print v(xbgr.mr_n69818912)
print v(xbgr.mr_n69819024)
print v(xbgr.mr_n69819344)
print v(xbgr.mr_n69819456)
print v(xbgr.mr_n69819776)
print v(xbgr.mr_n69819888)
print v(xbgr.mr_n69820208)
print v(xbgr.mr_n69820320)
print v(xbgr.mr_n69820640)
print v(xbgr.mr_n69820752)
print v(xbgr.mr_n69821072)
print v(xbgr.mr_n69821184)
print v(xbgr.mr_n69821504)
print v(xbgr.mr_n69821616)
print v(xbgr.mr_n69821936)
print v(xbgr.mr_n69822048)
print v(xbgr.mr_n69822368)
print v(xbgr.mr_n69822480)
print v(xbgr.mr_n69822800)
print v(xbgr.mr_n69822912)
print v(xbgr.mr_n69823232)
print v(xbgr.mr_n69823344)
print v(xbgr.mr_n69823664)
print v(xbgr.mr_n69823776)
print v(xbgr.mr_n69824096)
print v(xbgr.mr_n69824208)
print v(xbgr.mr_n69824528)
print v(xbgr.mr_n69824640)
print v(xbgr.mr_n69824960)
print v(xbgr.mr_n69825072)
print v(xbgr.mr_n69825392)
print v(xbgr.mr_n69825504)
print v(xbgr.mr_n69825824)
print v(xbgr.mr_n69825936)
print v(xbgr.mr_n69826256)
print v(xbgr.mr_n69826368)
print v(xbgr.mr_n69826688)
print v(xbgr.mr_n69826800)
print v(xbgr.mr_n69827120)
print v(xbgr.mr_n69827232)
print v(xbgr.mr_n69827552)
print v(xbgr.mr_n69827664)
print v(xbgr.mr_n69827984)
print v(xbgr.mr_n69828096)
print v(xbgr.mr_n69828416)
print v(xbgr.mr_n69828528)
print v(xbgr.mr_n69828848)
print v(xbgr.mr_n69828960)
print v(xbgr.mr_n69829280)
print v(xbgr.mr_n69829392)
print v(xbgr.mr_n69829712)
print v(xbgr.mr_n69829824)
print v(xbgr.mr_n69830144)
print v(xbgr.mr_n69830256)
print v(xbgr.mr_n69830576)
print v(xbgr.mr_n69830688)
print v(xbgr.mr_n69831008)
print v(xbgr.mr_n69831120)
print v(xbgr.mr_n69831440)
print v(xbgr.mr_n69831552)
print v(xbgr.mr_n69831872)
print v(xbgr.mr_n69831984)
print v(xbgr.mr_n69832304)
print v(xbgr.mr_n69832416)
print v(xbgr.mr_n69832736)
print v(xbgr.mr_n69832848)
print v(xbgr.mr_n69833168)
print v(xbgr.mr_n69833280)
print v(xbgr.mr_n69833600)
print v(xbgr.mr_n69833712)
print v(xbgr.mr_n69834032)
print v(xbgr.mr_n69834144)
print v(xbgr.mr_n69834464)
print v(xbgr.mr_n69834576)
print v(xbgr.mr_n69834896)
print v(xbgr.mr_n69835008)
print v(xbgr.mr_n69835328)
print v(xbgr.mr_n69835440)
print v(xbgr.mr_n69835760)
print v(xbgr.mr_n69835872)
print v(xbgr.mr_n69836192)
print v(xbgr.mr_n69836304)
print v(xbgr.mr_n69836624)
print v(xbgr.mr_n69836736)
print v(xbgr.mr_n69837056)
print v(xbgr.mr_n69837168)
print v(xbgr.mr_n69837488)
print v(xbgr.mr_n69837600)
print v(xbgr.mr_n69837920)
print v(xbgr.mr_n69838032)
print v(xbgr.mr_n69838352)
print v(xbgr.mr_n69838464)
print v(xbgr.mr_n69838784)
print v(xbgr.mr_n69838896)
print v(xbgr.mr_n69839216)
print v(xbgr.mr_n69839328)
print v(xbgr.mr_n69839648)
print v(xbgr.mr_n69839760)
print v(xbgr.mr_n69840080)
print v(xbgr.mr_n69840192)
print v(xbgr.mr_n69840512)
print v(xbgr.mr_n69840624)
print v(xbgr.mr_n69840944)
print v(xbgr.mr_n69841056)
print v(xbgr.mr_n69841376)
print v(xbgr.mr_n69841488)
print v(xbgr.mr_n69841808)
print v(xbgr.mr_n69841920)
print v(xbgr.mr_n69842240)
print v(xbgr.mr_n69842352)
print v(xbgr.mr_n69842672)
print v(xbgr.mr_n69842784)
print v(xbgr.mr_n69843104)
print v(xbgr.mr_n69843216)
print v(xbgr.mr_n69843536)
print v(xbgr.mr_n69843648)
print v(xbgr.mr_n69843968)
print v(xbgr.mr_n69844080)
print v(xbgr.mr_n69844400)
print v(xbgr.mr_n69844512)
print v(xbgr.mr_n69844832)
print v(xbgr.mr_n69844944)
print v(xbgr.mr_n69845264)
print v(xbgr.mr_n69845376)
print v(xbgr.mr_n69845696)
print v(xbgr.mr_n69845808)
print v(xbgr.mr_n69846128)
print v(xbgr.mr_n69846240)
print v(xbgr.mr_n69846560)
print v(xbgr.mr_n69846672)
print v(xbgr.mr_n69846992)
print v(xbgr.mr_n69847104)
print v(xbgr.mr_n69847424)
print v(xbgr.mr_n69847536)
print v(xbgr.mr_n69847856)
print v(xbgr.mr_n69847968)
print v(xbgr.mr_n69848288)
print v(xbgr.mr_n69848400)
print v(xbgr.mr_n69848720)
print v(xbgr.mr_n69848832)
print v(xbgr.mr_n69849152)
print v(xbgr.mr_n69849264)
print v(xbgr.mr_n69849584)
print v(xbgr.mr_n69849696)
print v(xbgr.mr_n69850016)
print v(xbgr.mr_n69850128)
print v(xbgr.mr_n69850448)
print v(xbgr.mr_n69850560)
print v(xbgr.mr_n69850880)
print v(xbgr.mr_n69850992)
print v(xbgr.mr_n69851312)
print v(xbgr.mr_n69851424)
print v(xbgr.mr_n69851744)
print v(xbgr.mr_n69851856)
print v(xbgr.mr_n69852176)
print v(xbgr.mr_n69852288)
print v(xbgr.mr_n69852608)
print v(xbgr.mr_n69852720)
print v(xbgr.mr_n69853040)
print v(xbgr.mr_n69853152)
print v(xbgr.mr_n69853472)
print v(xbgr.mr_n69853584)
print v(xbgr.mr_n69853904)
print v(xbgr.mr_n69854016)
print v(xbgr.mr_n69854336)
print v(xbgr.mr_n69854448)
print v(xbgr.mr_n69854768)
print v(xbgr.mr_n69854880)
print v(xbgr.mr_n69855200)
print v(xbgr.mr_n69855312)
print v(xbgr.mr_n69855632)
print v(xbgr.mr_n69855744)
print v(xbgr.mr_n69856064)
print v(xbgr.mr_n69856176)
print v(xbgr.mr_n69856496)
print v(xbgr.mr_n69856608)
print v(xbgr.mr_n69856928)
print v(xbgr.mr_n69857040)
print v(xbgr.mr_n69857360)
print v(xbgr.mr_n69857472)
print v(xbgr.mr_n69857792)
print v(xbgr.mr_n69857904)
print v(xbgr.mr_n69858224)
print v(xbgr.mr_n69858336)
print v(xbgr.mr_n69858656)
print v(xbgr.mr_n69858768)
print v(xbgr.mr_n69859088)
print v(xbgr.mr_n69859200)
print v(xbgr.mr_n69859520)
print v(xbgr.mr_n69859632)
print v(xbgr.mr_n69859952)
print v(xbgr.mr_n69860064)
print v(xbgr.mr_n69860384)
print v(xbgr.mr_n69860496)
print v(xbgr.mr_n69860816)
print v(xbgr.mr_n69860928)
print v(xbgr.mr_n69861248)
print v(xbgr.mr_n69861360)
print v(xbgr.mr_n69861680)
print v(xbgr.mr_n69861792)
print v(xbgr.mr_n69862112)
print v(xbgr.mr_n69862224)
print v(xbgr.mr_n69862544)
print v(xbgr.mr_n69862656)
print v(xbgr.mr_n69862976)
print v(xbgr.mr_n69863088)
print v(xbgr.mr_n69863408)
print v(xbgr.mr_n69863520)
print v(xbgr.mr_n69863840)
print v(xbgr.mr_n69863952)
print v(xbgr.mr_n69864272)
print v(xbgr.mr_n69864384)
print v(xbgr.mr_n69864704)
print v(xbgr.mr_n69864816)
print v(xbgr.mr_n69865136)
print v(xbgr.mr_n69865248)
print v(xbgr.mr_n69865568)
print v(xbgr.mr_n69865680)
print v(xbgr.mr_n69866000)
print v(xbgr.mr_n69866112)
print v(xbgr.mr_n69866432)
print v(xbgr.mr_n69866544)
print v(xbgr.mr_n69866864)
print v(xbgr.mr_n69866976)
print v(xbgr.mr_n69867296)
print v(xbgr.mr_n69867408)
print v(xbgr.mr_n69867728)
print v(xbgr.mr_n69867840)
print v(xbgr.mr_n69868160)
print v(xbgr.mr_n69868272)
print v(xbgr.mr_n69868592)
print v(xbgr.mr_n69868704)
print v(xbgr.mr_n69869024)
print v(xbgr.mr_n69869136)
print v(xbgr.mr_n69869456)
print v(xbgr.mr_n69869568)
print v(xbgr.mr_n69869888)
print v(xbgr.mr_n69870000)
print v(xbgr.mr_n69870320)
print v(xbgr.mr_n69870432)
print v(xbgr.mr_n69870752)
print v(xbgr.mr_n69870864)
print v(xbgr.mr_n69871184)
print v(xbgr.mr_n69871296)
print v(xbgr.mr_n69871616)
print v(xbgr.mr_n69871728)
print v(xbgr.mr_n69872048)
print v(xbgr.mr_n69872160)
print v(xbgr.mr_n69872480)
print v(xbgr.mr_n69872592)
print v(xbgr.mr_n69872912)
print v(xbgr.mr_n69873024)
print v(xbgr.mr_n69873344)
print v(xbgr.mr_n69873456)
print v(xbgr.mr_n69873776)
print v(xbgr.mr_n69873888)
print v(xbgr.mr_n69874208)
print v(xbgr.mr_n69874320)
print v(xbgr.mr_n69874640)
print v(xbgr.mr_n69874752)
print v(xbgr.mr_n69875072)
print v(xbgr.mr_n69875184)
print v(xbgr.mr_n69875504)
print v(xbgr.mr_n69875616)
print v(xbgr.mr_n69875936)
print v(xbgr.mr_n69876048)
print v(xbgr.mr_n69876368)
print v(xbgr.mr_n69876480)
print v(xbgr.mr_n69876800)
print v(xbgr.mr_n69876912)
print v(xbgr.mr_n69877232)
print v(xbgr.mr_n69877344)
print v(xbgr.mr_n69877664)
print v(xbgr.mr_n69877776)
print v(xbgr.mr_n69878096)
print v(xbgr.mr_n69878208)
print v(xbgr.mr_n69878528)
print v(xbgr.mr_n69878640)
print v(xbgr.mr_n69878960)
print v(xbgr.mr_n69879072)
print v(xbgr.mr_n69879392)
print v(xbgr.mr_n69879504)
print v(xbgr.mr_n69879824)
print v(xbgr.mr_n69879936)
print v(xbgr.mr_n69880256)
print v(xbgr.mr_n69880368)
print v(xbgr.mr_n69880688)
print v(xbgr.mr_n69880800)
print v(xbgr.mr_n69881120)
print v(xbgr.mr_n69881232)
print v(xbgr.mr_n69881552)
print v(xbgr.mr_n69881664)
print v(xbgr.mr_n69881984)
print v(xbgr.mr_n69882096)
print v(xbgr.mr_n69882416)
print v(xbgr.mr_n69882528)
print v(xbgr.mr_n69882848)
print v(xbgr.mr_n69882960)
print v(xbgr.mr_n69883280)
print v(xbgr.mr_n69883392)
print v(xbgr.mr_n69883712)
print v(xbgr.mr_n69883824)
print v(xbgr.mr_n69884144)
print v(xbgr.mr_n69884256)
print v(xbgr.mr_n69884576)
print v(xbgr.mr_n69884688)
print v(xbgr.mr_n69885008)
print v(xbgr.mr_n69885120)
print v(xbgr.mr_n69885440)
print v(xbgr.mr_n69885552)
print v(xbgr.mr_n69885872)
print v(xbgr.mr_n69885984)
print v(xbgr.mr_n69886304)
print v(xbgr.mr_n69886416)
print v(xbgr.mr_n69886720)
print v(xbgr.mr_n69886832)
print v(xbgr.mr_n69887152)
print v(xbgr.mr_n69887264)
print v(xbgr.mr_n69887584)
print v(xbgr.mr_n69887696)
print v(xbgr.mr_n69888016)
print v(xbgr.mr_n69888128)
print v(xbgr.mr_n69888448)
print v(xbgr.mr_n69888560)
print v(xbgr.mr_n69888880)
print v(xbgr.mr_n69888992)
print v(xbgr.mr_n69889312)
print v(xbgr.mr_n69889424)
print v(xbgr.mr_n69889744)
print v(xbgr.mr_n69889856)
print v(xbgr.mr_n69890176)
print v(xbgr.mr_n69890288)
print v(xbgr.mr_n69890608)
print v(xbgr.mr_n69890720)
print v(xbgr.mr_n69891040)
print v(xbgr.mr_n69891152)
print v(xbgr.mr_n69891472)
print v(xbgr.mr_n69891584)
print v(xbgr.mr_n69891904)
print v(xbgr.mr_n69892016)
print v(xbgr.mr_n69892336)
print v(xbgr.mr_n69892448)
print v(xbgr.mr_n69892768)
print v(xbgr.mr_n69892880)
print v(xbgr.mr_n69893200)
print v(xbgr.mr_n69893312)
print v(xbgr.mr_n69893632)
print v(xbgr.mr_n69893744)
print v(xbgr.mr_n69894064)
print v(xbgr.mr_n69894176)
print v(xbgr.mr_n69894496)
print v(xbgr.mr_n69894608)
print v(xbgr.mr_n69894928)
print v(xbgr.mr_n69895040)
print v(xbgr.mr_n69895360)
print v(xbgr.mr_n69895472)
print v(xbgr.mr_n69895792)
print v(xbgr.mr_n69895904)
print v(xbgr.mr_n69896224)
print v(xbgr.mr_n69896336)
print v(xbgr.mr_n69896656)
print v(xbgr.mr_n69896768)
print v(xbgr.mr_n69897088)
print v(xbgr.mr_n69897200)
print v(xbgr.mr_n69897520)
print v(xbgr.mr_n69897632)
print v(xbgr.mr_n69897952)
print v(xbgr.mr_n69898064)
print v(xbgr.mr_n69898384)
print v(xbgr.mr_n69898496)
print v(xbgr.mr_n69898816)
print v(xbgr.mr_n69898928)
print v(xbgr.mr_n69899248)
print v(xbgr.mr_n69899360)
print v(xbgr.mr_n69899680)
print v(xbgr.mr_n69899792)
print v(xbgr.mr_n69900112)
print v(xbgr.mr_n69900224)
print v(xbgr.mr_n69900544)
print v(xbgr.mr_n69900656)
print v(xbgr.mr_n69900976)
print v(xbgr.mr_n69901088)
print v(xbgr.mr_n69901408)
print v(xbgr.mr_n69901520)
print v(xbgr.mr_n69901840)
print v(xbgr.mr_n69901952)
print v(xbgr.mr_n69902272)
print v(xbgr.mr_n69902384)
print v(xbgr.mr_n69902704)
print v(xbgr.mr_n69902816)
print v(xbgr.mr_n69903136)
print v(xbgr.mr_n69903248)
print v(xbgr.mr_n69903568)
print v(xbgr.mr_n69903680)
print v(xbgr.mr_n69904000)
print v(xbgr.mr_n69904112)
print v(xbgr.mr_n69904432)
print v(xbgr.mr_n69904544)
print v(xbgr.mr_n69904864)
print v(xbgr.mr_n69904976)
print v(xbgr.mr_n69905296)
print v(xbgr.mr_n69905408)
print v(xbgr.mr_n69905728)
print v(xbgr.mr_n69905840)
print v(xbgr.mr_n69906160)
print v(xbgr.mr_n69906272)
print v(xbgr.mr_n69906592)
print v(xbgr.mr_n69906704)
print v(xbgr.mr_n69907024)
print v(xbgr.mr_n69907136)
print v(xbgr.mr_n69907456)
print v(xbgr.mr_n69907568)
print v(xbgr.mr_n69907888)
print v(xbgr.mr_n69908000)
print v(xbgr.mr_n69908320)
print v(xbgr.mr_n69908432)
print v(xbgr.mr_n69908752)
print v(xbgr.mr_n69908864)
print v(xbgr.mr_n69909184)
print v(xbgr.mr_n69909296)
print v(xbgr.mr_n69909616)
print v(xbgr.mr_n69909728)
print v(xbgr.mr_n69910048)
print v(xbgr.mr_n69910160)
print v(xbgr.mr_n69910480)
print v(xbgr.mr_n69910592)
print v(xbgr.mr_n69910912)
print v(xbgr.mr_n69911024)
print v(xbgr.mr_n69911344)
print v(xbgr.mr_n69911456)
print v(xbgr.mr_n69911776)
print v(xbgr.mr_n69911888)
print v(xbgr.mr_n69912208)
print v(xbgr.mr_n69912320)
print v(xbgr.mr_n69912640)
print v(xbgr.mr_n69912752)
print v(xbgr.mr_n69913072)
print v(xbgr.mr_n69913184)
print v(xbgr.mr_n69913504)
print v(xbgr.mr_n69913616)
print v(xbgr.mr_n69913936)
print v(xbgr.mr_n69914048)
print v(xbgr.mr_n69914368)
print v(xbgr.mr_n69914480)
print v(xbgr.mr_n69914800)
print v(xbgr.mr_n69914912)
print v(xbgr.mr_n69915232)
print v(xbgr.mr_n69915344)
print v(xbgr.mr_n69915664)
print v(xbgr.mr_n69915776)
print v(xbgr.mr_n69916096)
print v(xbgr.mr_n69916208)
print v(xbgr.mr_n69916528)
print v(xbgr.mr_n69916640)
print v(xbgr.mr_n69916960)
print v(xbgr.mr_n69917072)
print v(xbgr.mr_n69917392)
print v(xbgr.mr_n69917504)
print v(xbgr.mr_n69917824)
print v(xbgr.mr_n69917936)
print v(xbgr.mr_n69918256)
print v(xbgr.mr_n69918368)
print v(xbgr.mr_n69918688)
print v(xbgr.mr_n69918800)
print v(xbgr.mr_n69919120)
print v(xbgr.mr_n69919232)
print v(xbgr.mr_n69919552)
print v(xbgr.mr_n69919664)
print v(xbgr.mr_n69919984)
print v(xbgr.mr_n69920096)
print v(xbgr.mr_n69920416)
print v(xbgr.mr_n69920528)
print v(xbgr.mr_n69920848)
print v(xbgr.mr_n69920960)
print v(xbgr.mr_n69921280)
print v(xbgr.mr_n69921392)
print v(xbgr.mr_n69921712)
print v(xbgr.mr_n69921824)
print v(xbgr.mr_n69922144)
print v(xbgr.mr_n69922256)
print v(xbgr.mr_n69922576)
print v(xbgr.mr_n69922688)
print v(xbgr.mr_n69923008)
print v(xbgr.mr_n69923120)
print v(xbgr.mr_n69923440)
print v(xbgr.mr_n69923552)
print v(xbgr.mr_n69923872)
print v(xbgr.mr_n69923984)
print v(xbgr.mr_n69924304)
print v(xbgr.mr_n69924416)
print v(xbgr.mr_n69924736)
print v(xbgr.mr_n69924848)
print v(xbgr.mr_n69925168)
print v(xbgr.mr_n69925280)
print v(xbgr.mr_n69925600)
print v(xbgr.mr_n69925712)
print v(xbgr.mr_n69926032)
print v(xbgr.mr_n69926144)
print v(xbgr.mr_n69926464)
print v(xbgr.mr_n69926576)
print v(xbgr.mr_n69926896)
print v(xbgr.mr_n69927008)
print v(xbgr.mr_n69927328)
print v(xbgr.mr_n69927440)
print v(xbgr.mr_n69927760)
print v(xbgr.mr_n69927872)
print v(xbgr.mr_n69928192)
print v(xbgr.mr_n69928304)
print v(xbgr.mr_n69928624)
print v(xbgr.mr_n69928736)
print v(xbgr.mr_n69929056)
print v(xbgr.mr_n69929168)
print v(xbgr.mr_n69929488)
print v(xbgr.mr_n69929600)
print v(xbgr.mr_n69929920)
print v(xbgr.mr_n69930032)
print v(xbgr.mr_n69930352)
print v(xbgr.mr_n69930464)
print v(xbgr.mr_n69930784)
print v(xbgr.mr_n69930896)
print v(xbgr.mr_n69931216)
print v(xbgr.mr_n69931328)
print v(xbgr.mr_n69931648)
print v(xbgr.mr_n69931760)
print v(xbgr.mr_n69932080)
print v(xbgr.mr_n69932192)
print v(xbgr.mr_n69932512)
print v(xbgr.mr_n69932624)
print v(xbgr.mr_n69932944)
print v(xbgr.mr_n69933056)
print v(xbgr.mr_n69933376)
print v(xbgr.mr_n69933488)
print v(xbgr.mr_n69933808)
print v(xbgr.mr_n69933920)
print v(xbgr.mr_n69934240)
print v(xbgr.mr_n69934352)
print v(xbgr.mr_n69934672)
print v(xbgr.mr_n69934880)
print v(xbgr.mr_n69935120)
print v(xbgr.mr_n69935984)
print v(xbgr.mr_n69936096)
print v(xbgr.mr_n69936416)
print v(xbgr.mr_n69936528)
print v(xbgr.mr_n69936848)
print v(xbgr.mr_n69936960)
print v(xbgr.mr_n69937280)
print v(xbgr.mr_n69937392)
print v(xbgr.mr_n69937712)
print v(xbgr.mr_n69937824)
print v(xbgr.mr_n69938144)
print v(xbgr.mr_n69938256)
print v(xbgr.mr_n69938576)
print v(xbgr.mr_n69939440)
print v(xbgr.mr_n69940304)
print v(xbgr.mr_n69941168)
print v(xbgr.mr_n69941280)
print v(xbgr.mr_n69942032)
print v(xbgr.mr_n69942144)
print v(xbgr.mr_n69942464)
print v(xbgr.mr_n69943328)
print v(xbgr.mr_n69944192)
print v(xbgr.mr_n69945056)
print v(xbgr.mr_n69945920)
print v(xbgr.mr_n69946464)
print v(xbgr.mr_n69947216)
print v(xbgr.mr_n69947760)
print v(xbgr.mr_n69948192)
print v(xbgr.mr_n69948944)
print v(xbgr.mr_n69949056)
print v(xbgr.mr_n69949376)
print v(xbgr.mr_n69949488)
print v(xbgr.mr_n69949808)
print v(xbgr.mr_n69950672)
print v(xbgr.mr_n69951536)
print v(xbgr.mr_n69952400)
print v(xbgr.mr_n69952512)
print v(xbgr.mr_n69952832)
print v(xbgr.mr_n69952944)
print v(xbgr.mr_n69953376)
print v(xbgr.mr_n69953696)
print v(xbgr.mr_n69953808)
print v(xbgr.mr_n69954128)
print v(xbgr.mr_n69954992)
print v(xbgr.mr_n69955104)
print v(xbgr.mr_n69955536)
print v(xbgr.mr_n69955856)
print v(xbgr.mr_n69955968)
print v(xbgr.mr_n69956288)
print v(xbgr.mr_n69956400)
print v(xbgr.mr_n69956720)
print v(xbgr.mr_n69956832)
print v(xbgr.mr_n69957152)
print v(xbgr.mr_n69957264)
print v(xbgr.mr_n69957584)
print v(xbgr.mr_n69958560)
print v(xbgr.mr_n69958880)
print v(xbgr.mr_n69958992)
print v(xbgr.mr_n69959312)
print v(xbgr.mr_n69959424)
print v(xbgr.mr_n69959744)
print v(xbgr.mr_n69959856)
print v(xbgr.mr_n69960176)
print v(xbgr.mr_n69960288)
print v(xbgr.mr_n69960608)
print v(xbgr.mr_n69961040)
print v(xbgr.mr_n69962016)
print v(xbgr.mr_n69962336)
print v(xbgr.mr_n69963200)
print v(xbgr.mr_n69964064)
print v(xbgr.mr_n69964176)
print v(xbgr.mr_n69964928)
print v(xbgr.mr_n69965792)
print v(xbgr.mr_n69965904)
print v(xbgr.mr_n69966224)
print v(xbgr.mr_n69967088)
print v(xbgr.mr_n69967200)
print v(xbgr.mr_n69967520)
print v(xbgr.mr_n69967632)
print v(xbgr.mr_n69967952)
print v(xbgr.mr_n69968816)
print v(xbgr.mr_n69968928)
print v(xbgr.mr_n69969248)
print v(xbgr.mr_n69969360)
print v(xbgr.mr_n69969680)
print v(xbgr.mr_n69969792)
print v(xbgr.mr_n69970112)
print v(xbgr.mr_n69970224)
print v(xbgr.mr_n69970544)
print v(xbgr.mr_n69971520)
print v(xbgr.mr_n69971952)
print v(xbgr.mr_n69972272)
print v(xbgr.mr_n69973136)
print v(xbgr.mr_n69974000)
print v(xbgr.mr_n69974112)
print v(xbgr.mr_n69974432)
print v(xbgr.mr_n69974544)
print v(xbgr.mr_n69974864)
print v(xbgr.mr_n69974976)
print v(xbgr.mr_n69975296)
print v(xbgr.mr_n69975408)
print v(xbgr.mr_n69975840)
print v(xbgr.mr_n69976272)
print v(xbgr.mr_n69976592)
print v(xbgr.mr_n69976704)
print v(xbgr.mr_n69977024)
print v(xbgr.mr_n69977136)
print v(xbgr.mr_n69977456)
print v(xbgr.mr_n69977568)
print v(xbgr.mr_n69977888)
print v(xbgr.mr_n69978000)
print v(xbgr.mr_n69978320)
print v(xbgr.mr_n69979184)
print v(xbgr.mr_n69980048)
print v(xbgr.mr_n69980160)
print v(xbgr.mr_n69980480)
print v(xbgr.mr_n69981344)
print v(xbgr.mr_n69982208)
print v(xbgr.mr_n69982320)
print v(xbgr.mr_n69982640)
print v(xbgr.mr_n69982752)
print v(xbgr.mr_n69983184)
print v(xbgr.mr_n69983504)
print v(xbgr.mr_n69983616)
print v(xbgr.mr_n69984048)
print v(xbgr.mr_n69984368)
print v(xbgr.mr_n69984800)
print v(xbgr.mr_n69984912)
print v(xbgr.mr_n69985232)
print v(xbgr.mr_n69985344)
print v(xbgr.mr_n69985664)
print v(xbgr.mr_n69986096)
print v(xbgr.mr_n69986208)
print v(xbgr.mr_n69986960)
print v(xbgr.mr_n69987072)
print v(xbgr.mr_n69987392)
print v(xbgr.mr_n69987504)
print v(xbgr.mr_n69987824)
print v(xbgr.mr_n69988256)
print v(xbgr.mr_n69988368)
print v(xbgr.mr_n69988688)
print v(xbgr.mr_n69989120)
print v(xbgr.mr_n69989984)
print v(xbgr.mr_n69991712)
print v(xbgr.mr_n69991824)
print v(xbgr.mr_n69992144)
print v(xbgr.mr_n69992256)
print v(xbgr.mr_n69992576)
print v(xbgr.mr_n69992688)
print v(xbgr.mr_n69993120)
print v(xbgr.mr_n69993552)
print v(xbgr.mr_n69993872)
print v(xbgr.mr_n69993984)
print v(xbgr.mr_n69994304)
print v(xbgr.mr_n69995712)
print v(xbgr.mr_n69996032)
print v(xbgr.mr_n69997008)
print v(xbgr.mr_n69997328)
print v(xbgr.mr_n69997440)
print v(xbgr.mr_n69997760)
print v(xbgr.mr_n69997872)
print v(xbgr.mr_n69998304)
print v(xbgr.mr_n69998624)
print v(xbgr.mr_n69998736)
print v(xbgr.mr_n69999168)
print v(xbgr.mr_n69999488)
print v(xbgr.mr_n69999600)
print v(xbgr.mr_n69999920)
print v(xbgr.mr_n70000032)
print v(xbgr.mr_n70000352)
print v(xbgr.mr_n70001216)
print v(xbgr.mr_n70001648)
print v(xbgr.mr_n70002512)
print v(xbgr.mr_n70002624)
print v(xbgr.mr_n70002944)
print v(xbgr.mr_n70003056)
print v(xbgr.mr_n70003376)
print v(xbgr.mr_n70003488)
print v(xbgr.mr_n70004240)
print v(xbgr.mr_n70004672)
print v(xbgr.mr_n70004784)
print v(xbgr.mr_n70005104)
print v(xbgr.mr_n70005536)
print v(xbgr.mr_n70005648)
print v(xbgr.mr_n70005968)
print v(xbgr.mr_n70006080)
print v(xbgr.mr_n70006400)
print v(xbgr.mr_n70006512)
print v(xbgr.mr_n70006832)
print v(xbgr.mr_n70006944)
print v(xbgr.mr_n70007264)
print v(xbgr.mr_n70007376)
print v(xbgr.mr_n70007696)
print v(xbgr.mr_n70009104)
print v(xbgr.mr_n70009424)
print v(xbgr.mr_n70009536)
print v(xbgr.mr_n70009968)
print v(xbgr.mr_n70010288)
print v(xbgr.mr_n70010400)
print v(xbgr.mr_n70010720)
print v(xbgr.mr_n70011152)
print v(xbgr.mr_n70012016)
print v(xbgr.mr_n70012880)
print v(xbgr.mr_n70013744)
print v(xbgr.mr_n70014608)
print v(xbgr.mr_n70015472)
print v(xbgr.mr_n70016768)
print v(xbgr.mr_n70017200)
print v(xbgr.mr_n70017312)
print v(xbgr.mr_n70017632)
print v(xbgr.mr_n70018064)
print v(xbgr.mr_n70018176)
print v(xbgr.mr_n70018496)
print v(xbgr.mr_n70019360)
print v(xbgr.mr_n70019472)
print v(xbgr.mr_n70019792)
print v(xbgr.mr_n70019904)
print v(xbgr.mr_n70020224)
print v(xbgr.mr_n70021088)
print v(xbgr.mr_n70021200)
print v(xbgr.mr_n70022064)
print v(xbgr.mr_n70022496)
print v(xbgr.mr_n70022928)
print v(xbgr.mr_n70023680)
print v(xbgr.mr_n70023792)
print v(xbgr.mr_n70024224)
print v(xbgr.mr_n70024976)
print v(xbgr.mr_n70025408)
print v(xbgr.mr_n70025520)
print v(xbgr.mr_n70025952)
print v(xbgr.mr_n70026704)
print v(xbgr.mr_n70026816)
print v(xbgr.mr_n70027136)
print v(xbgr.mr_n70027248)
print v(xbgr.mr_n70027568)
print v(xbgr.mr_n70027680)
print v(xbgr.mr_n70028000)
print v(xbgr.mr_n70028112)
print v(xbgr.mr_n70028432)
print v(xbgr.mr_n70028544)
print v(xbgr.mr_n70028864)
print v(xbgr.mr_n70028976)
print v(xbgr.mr_n70029296)
print v(xbgr.mr_n70029408)
print v(xbgr.mr_n70029728)
print v(xbgr.mr_n70029840)
print v(xbgr.mr_n70030160)
print v(xbgr.mr_n70030272)
print v(xbgr.mr_n70030592)
print v(xbgr.mr_n70030704)
print v(xbgr.mr_n70031024)
print v(xbgr.mr_n70031136)
print v(xbgr.mr_n70031456)
print v(xbgr.mr_n70031568)
print v(xbgr.mr_n70031888)
print v(xbgr.mr_n70032000)
print v(xbgr.mr_n70032320)
print v(xbgr.mr_n70032432)
print v(xbgr.mr_n70032864)
print v(xbgr.mr_n70033184)
print v(xbgr.mr_n70033296)
print v(xbgr.mr_n70033728)
print v(xbgr.mr_n70034048)
print v(xbgr.mr_n70034160)
print v(xbgr.mr_n70034912)
print v(xbgr.mr_n70035344)
print v(xbgr.mr_n70036208)
print v(xbgr.mr_n70037072)
print v(xbgr.mr_n70037936)
print v(xbgr.mr_n70038048)
print v(xbgr.mr_n70038368)
print v(xbgr.mr_n70038480)
print v(xbgr.mr_n70038800)
print v(xbgr.mr_n70038912)
print v(xbgr.mr_n70039232)
print v(xbgr.mr_n70039344)
print v(xbgr.mr_n70040096)
print v(xbgr.mr_n70040960)
print v(xbgr.mr_n70041824)
print v(xbgr.mr_n70042688)
print v(xbgr.mr_n70043984)
print v(xbgr.mr_n70044096)
print v(xbgr.mr_n70044416)
print v(xbgr.mr_n70044528)
print v(xbgr.mr_n70044848)
print v(xbgr.mr_n70044960)
print v(xbgr.mr_n70045392)
print v(xbgr.mr_n70045824)
print v(xbgr.mr_n70046256)
print v(xbgr.mr_n70046576)
print v(xbgr.mr_n70046688)
print v(xbgr.mr_n70047120)
print v(xbgr.mr_n70047440)
print v(xbgr.mr_n70047552)
print v(xbgr.mr_n70047872)
print v(xbgr.mr_n70047984)
print v(xbgr.mr_n70048304)
print v(xbgr.mr_n70048416)
print v(xbgr.mr_n70048736)
print v(xbgr.mr_n70048848)
print v(xbgr.mr_n70049168)
print v(xbgr.mr_n70049280)
print v(xbgr.mr_n70049712)
print v(xbgr.mr_n70050032)
print v(xbgr.mr_n70050144)
print v(xbgr.mr_n70050576)
print v(xbgr.mr_n70050896)
print v(xbgr.mr_n70051328)
print v(xbgr.mr_n70051440)
print v(xbgr.mr_n70051872)
print v(xbgr.mr_n70052192)
print v(xbgr.mr_n70052304)
print v(xbgr.mr_n70052736)
print v(xbgr.mr_n70053056)
print v(xbgr.mr_n70053168)
print v(xbgr.mr_n70053600)
print v(xbgr.mr_n70053920)
print v(xbgr.mr_n70054032)
print v(xbgr.mr_n70054352)
print v(xbgr.mr_n70054464)
print v(xbgr.mr_n70054784)
print v(xbgr.mr_n70055648)
print v(xbgr.mr_n70056512)
print v(xbgr.mr_n70057376)
print v(xbgr.mr_n70058240)
print v(xbgr.mr_n70059104)
print v(xbgr.mr_n70059968)
print v(xbgr.mr_n70060080)
print v(xbgr.mr_n70060832)
print v(xbgr.mr_n70061696)
print v(xbgr.mr_n70062560)
print v(xbgr.mr_n70063424)
print v(xbgr.mr_n70064288)
print v(xbgr.mr_n70065152)
print v(xbgr.mr_n70065264)
print v(xbgr.mr_n70065584)
print v(xbgr.mr_n70065696)
print v(xbgr.mr_n70066016)
print v(xbgr.mr_n70066128)
print v(xbgr.mr_n70066448)
print v(xbgr.mr_n70066560)
print v(xbgr.mr_n70066880)
print v(xbgr.mr_n70067744)
print v(xbgr.mr_n70068608)
print v(xbgr.mr_n70069472)
print v(xbgr.mr_n70069584)
print v(xbgr.mr_n70069904)
print v(xbgr.mr_n70070016)
print v(xbgr.mr_n70070336)
print v(xbgr.mr_n70070448)
print v(xbgr.mr_n70070768)
print v(xbgr.mr_n70071632)
print v(xbgr.mr_n70072496)
print v(xbgr.mr_n70073360)
print v(xbgr.mr_n70073472)
print v(xbgr.mr_n70073792)
print v(xbgr.mr_n70073904)
print v(xbgr.mr_n70074224)
print v(xbgr.mr_n70074336)
print v(xbgr.mr_n70074768)
print v(xbgr.mr_n70075200)
print v(xbgr.mr_n70075632)
print v(xbgr.mr_n70075952)
print v(xbgr.mr_n70076064)
print v(xbgr.mr_n70076384)
print v(xbgr.mr_n70076496)
print v(xbgr.mr_n70076816)
print v(xbgr.mr_n70076928)
print v(xbgr.mr_n70077248)
print v(xbgr.mr_n70077360)
print v(xbgr.mr_n70077680)
print v(xbgr.mr_n70077792)
print v(xbgr.mr_n70078112)
print v(xbgr.mr_n70078224)
print v(xbgr.mr_n70078544)
print v(xbgr.mr_n70078656)
print v(xbgr.mr_n70078976)
print v(xbgr.mr_n70079088)
print v(xbgr.mr_n70079408)
print v(xbgr.mr_n70079520)
print v(xbgr.mr_n70079952)
print v(xbgr.mr_n70080272)
print v(xbgr.mr_n70080384)
print v(xbgr.mr_n70080704)
print v(xbgr.mr_n70081136)
print v(xbgr.mr_n70081248)
print v(xbgr.mr_n70081568)
print v(xbgr.mr_n70081680)
print v(xbgr.mr_n70082000)
print v(xbgr.mr_n70082112)
print v(xbgr.mr_n70082432)
print v(xbgr.mr_n70082544)
print v(xbgr.mr_n70083296)
print v(xbgr.mr_n70083408)
print v(xbgr.mr_n70084160)
print v(xbgr.mr_n70085024)
print v(xbgr.mr_n70085136)
print v(xbgr.mr_n70085456)
print v(xbgr.mr_n70085568)
print v(xbgr.mr_n70085888)
print v(xbgr.mr_n70086000)
print v(xbgr.mr_n70086320)
print v(xbgr.mr_n70086432)
print v(xbgr.mr_n70086864)
print v(xbgr.mr_n70087296)
print v(xbgr.mr_n70087616)
print v(xbgr.mr_n70087728)
print v(xbgr.mr_n70088048)
print v(xbgr.mr_n70088160)
print v(xbgr.mr_n70088480)
print v(xbgr.mr_n70089344)
print v(xbgr.mr_n70090640)
print v(xbgr.mr_n70091504)
print v(xbgr.mr_n70091616)
print v(xbgr.mr_n70091936)
print v(xbgr.mr_n70092048)
print v(xbgr.mr_n70092368)
print v(xbgr.mr_n70092480)
print v(xbgr.mr_n70092800)
print v(xbgr.mr_n70092912)
print v(xbgr.mr_n70093344)
print v(xbgr.mr_n70093664)
print v(xbgr.mr_n70093776)
print v(xbgr.mr_n70094096)
print v(xbgr.mr_n70094208)
print v(xbgr.mr_n70094528)
print v(xbgr.mr_n70094640)
print v(xbgr.mr_n70095072)
print v(xbgr.mr_n70095392)
print v(xbgr.mr_n70095504)
print v(xbgr.mr_n70095824)
print v(xbgr.mr_n70095936)
print v(xbgr.mr_n70096256)
print v(xbgr.mr_n70097120)
print v(xbgr.mr_n70097984)
print v(xbgr.mr_n70098848)
print v(xbgr.mr_n70099712)
print v(xbgr.mr_n70099824)
print v(xbgr.mr_n70100144)
print v(xbgr.mr_n70100256)
print v(xbgr.mr_n70100688)
print v(xbgr.mr_n70101120)
print v(xbgr.mr_n70101440)
print v(xbgr.mr_n70101552)
print v(xbgr.mr_n70101872)
print v(xbgr.mr_n70102736)
print v(xbgr.mr_n70103600)
print v(xbgr.mr_n70103712)
print v(xbgr.mr_n70104032)
print v(xbgr.mr_n70104144)
print v(xbgr.mr_n70104464)
print v(xbgr.mr_n70104576)
print v(xbgr.mr_n70104896)
print v(xbgr.mr_n70105008)
print v(xbgr.mr_n70105328)
print v(xbgr.mr_n70105440)
print v(xbgr.mr_n70105872)
print v(xbgr.mr_n70106192)
print v(xbgr.mr_n70106304)
print v(xbgr.mr_n70107056)
print v(xbgr.mr_n70107920)
print v(xbgr.mr_n70108032)
print v(xbgr.mr_n70108352)
print v(xbgr.mr_n70108464)
print v(xbgr.mr_n70108896)
print v(xbgr.mr_n70109216)
print v(xbgr.mr_n70109328)
print v(xbgr.mr_n70109648)
print v(xbgr.mr_n70109760)
print v(xbgr.mr_n70110080)
print v(xbgr.mr_n70110192)
print v(xbgr.mr_n70110512)
print v(xbgr.mr_n70110624)
print v(xbgr.mr_n70110944)
print v(xbgr.mr_n70111056)
print v(xbgr.mr_n70111376)
print v(xbgr.mr_n70112240)
print v(xbgr.mr_n70113216)
print v(xbgr.mr_n70113536)
print v(xbgr.mr_n70114400)
print v(xbgr.mr_n70115264)
print v(xbgr.mr_n70116128)
print v(xbgr.mr_n70116560)
print v(xbgr.mr_n70116992)
print v(xbgr.mr_n70117104)
print v(xbgr.mr_n70117424)
print v(xbgr.mr_n70117536)
print v(xbgr.mr_n70117856)
print v(xbgr.mr_n70117968)
print v(xbgr.mr_n70118288)
print v(xbgr.mr_n70118400)
print v(xbgr.mr_n70118720)
print v(xbgr.mr_n70118832)
print v(xbgr.mr_n70119152)
print v(xbgr.mr_n70119264)
print v(xbgr.mr_n70119584)
print v(xbgr.mr_n70120448)
print v(xbgr.mr_n70121312)
print v(xbgr.mr_n70121424)
print v(xbgr.mr_n70121744)
print v(xbgr.mr_n70121856)
print v(xbgr.mr_n70122176)
print v(xbgr.mr_n70122288)
print v(xbgr.mr_n70122608)
print v(xbgr.mr_n70122720)
print v(xbgr.mr_n70124336)
print v(xbgr.mr_n70125200)
print v(xbgr.mr_n70125312)
print v(xbgr.mr_n70125632)
print v(xbgr.mr_n70125744)
print v(xbgr.mr_n70126064)
print v(xbgr.mr_n70126496)
print v(xbgr.mr_n70126608)
print v(xbgr.mr_n70126928)
print v(xbgr.mr_n70127040)
print v(xbgr.mr_n70127360)
print v(xbgr.mr_n70127472)
print v(xbgr.mr_n70127904)
print v(xbgr.mr_n70128224)
print v(xbgr.mr_n70128336)
print v(xbgr.mr_n70128768)
print v(xbgr.mr_n70129520)
print v(xbgr.mr_n70130384)
print v(xbgr.mr_n70131680)
print v(xbgr.mr_n70131792)
print v(xbgr.mr_n70132224)
print v(xbgr.mr_n70132544)
print v(xbgr.mr_n70133408)
print v(xbgr.mr_n70134272)
print v(xbgr.mr_n70134704)
print v(xbgr.mr_n70136000)
print v(xbgr.mr_n70136864)
print v(xbgr.mr_n70137296)
print v(xbgr.mr_n70138160)
print v(xbgr.mr_n70139456)
print v(xbgr.mr_n70139568)
print v(xbgr.mr_n70139888)
print v(xbgr.mr_n70140000)
print v(xbgr.mr_n70140320)
print v(xbgr.mr_n70140432)
print v(xbgr.mr_n70140752)
print v(xbgr.mr_n70140864)
print v(xbgr.mr_n70141184)
print v(xbgr.mr_n70141296)
print v(xbgr.mr_n70141616)
print v(xbgr.mr_n70141728)
print v(xbgr.mr_n70142048)
print v(xbgr.mr_n70142160)
print v(xbgr.mr_n70142912)
print v(xbgr.mr_n70143024)
print v(xbgr.mr_n70143456)
print v(xbgr.mr_n70143776)
print v(xbgr.mr_n70143888)
print v(xbgr.mr_n70144208)
print v(xbgr.mr_n70144320)
print v(xbgr.mr_n70144640)
print v(xbgr.mr_n70144752)
print v(xbgr.mr_n70145072)
print v(xbgr.mr_n70145184)
print v(xbgr.mr_n70145504)
print v(xbgr.mr_n70145616)
print v(xbgr.mr_n70146048)
print v(xbgr.mr_n70146368)
print v(xbgr.mr_n70146912)
print v(xbgr.mr_n70147232)
print v(xbgr.mr_n70147344)
print v(xbgr.mr_n70147776)
print v(xbgr.mr_n70148096)
print v(xbgr.mr_n70148208)
print v(xbgr.mr_n70148640)
print v(xbgr.mr_n70148960)
print v(xbgr.mr_n70149072)
print v(xbgr.mr_n70149392)
print v(xbgr.mr_n70149504)
print v(xbgr.mr_n70149824)
print v(xbgr.mr_n70149936)
print v(xbgr.mr_n70150256)
print v(xbgr.mr_n70150368)
print v(xbgr.mr_n70150688)
print v(xbgr.mr_n70150800)
print v(xbgr.mr_n70151120)
print v(xbgr.mr_n70151232)
print v(xbgr.mr_n70151552)
print v(xbgr.mr_n70151664)
print v(xbgr.mr_n70151984)
print v(xbgr.mr_n70152096)
print v(xbgr.mr_n70152416)
print v(xbgr.mr_n70153280)
print v(xbgr.mr_n70153392)
print v(xbgr.mr_n70153712)
print v(xbgr.mr_n70153824)
print v(xbgr.mr_n70154144)
print v(xbgr.mr_n70154256)
print v(xbgr.mr_n70154576)
print v(xbgr.mr_n70154688)
print v(xbgr.mr_n70155008)
print v(xbgr.mr_n70155872)
print v(xbgr.mr_n70156736)
print v(xbgr.mr_n70157600)
print v(xbgr.mr_n70158144)
print v(xbgr.mr_n70158576)
print v(xbgr.mr_n70158896)
print v(xbgr.mr_n70159008)
print v(xbgr.mr_n70159328)
print v(xbgr.mr_n70159440)
print v(xbgr.mr_n70159760)
print v(xbgr.mr_n70159872)
print v(xbgr.mr_n70160192)
print v(xbgr.mr_n70160304)
print v(xbgr.mr_n70160624)
print v(xbgr.mr_n70161920)
print v(xbgr.mr_n70162784)
print v(xbgr.mr_n70163760)
print v(xbgr.mr_n70164192)
print v(xbgr.mr_n70164512)
print v(xbgr.mr_n70164944)
print v(xbgr.mr_n70165808)
print v(xbgr.mr_n70166672)
print v(xbgr.mr_n70166784)
print v(xbgr.mr_n70167104)
print v(xbgr.mr_n70167216)
print v(xbgr.mr_n70167536)
print v(xbgr.mr_n70167648)
print v(xbgr.mr_n70167968)
print v(xbgr.mr_n70168080)
print v(xbgr.mr_n70169264)
print v(xbgr.mr_n70169376)
print v(xbgr.mr_n70169696)
print v(xbgr.mr_n70169808)
print v(xbgr.mr_n70170128)
print v(xbgr.mr_n70170240)
print v(xbgr.mr_n70170672)
print v(xbgr.mr_n70170992)
print v(xbgr.mr_n70171424)
print v(xbgr.mr_n70171536)
print v(xbgr.mr_n70171968)
print v(xbgr.mr_n70172288)
print v(xbgr.mr_n70173152)
print v(xbgr.mr_n70173264)
print v(xbgr.mr_n70173696)
print v(xbgr.mr_n70174016)
print v(xbgr.mr_n70174128)
print v(xbgr.mr_n70174880)
print v(xbgr.mr_n70175424)
print v(xbgr.mr_n70175744)
print v(xbgr.mr_n70175856)
print v(xbgr.mr_n70176176)
print v(xbgr.mr_n70176288)
print v(xbgr.mr_n70176608)
print v(xbgr.mr_n70176720)
print v(xbgr.mr_n70177040)
print v(xbgr.mr_n70177472)
print v(xbgr.mr_n70177584)
print v(xbgr.mr_n70177904)
print v(xbgr.mr_n70178016)
print v(xbgr.mr_n70178336)
print v(xbgr.mr_n70178448)
print v(xbgr.mr_n70179200)
print v(xbgr.mr_n70179312)
print v(xbgr.mr_n70179744)
print v(xbgr.mr_n70180064)
print v(xbgr.mr_n70180176)
print v(xbgr.mr_n70180496)
print v(xbgr.mr_n70180608)
print v(xbgr.mr_n70180928)
print v(xbgr.mr_n70181040)
print v(xbgr.mr_n70181360)
print v(xbgr.mr_n70182224)
print v(xbgr.mr_n70182656)
print v(xbgr.mr_n70183088)
print v(xbgr.mr_n70183200)
print v(xbgr.mr_n70183520)
print v(xbgr.mr_n70183632)
print v(xbgr.mr_n70184384)
print v(xbgr.mr_n70184496)
print v(xbgr.mr_n70184816)
print v(xbgr.mr_n70184928)
print v(xbgr.mr_n70185680)
print v(xbgr.mr_n70186544)
print v(xbgr.mr_n70186656)
print v(xbgr.mr_n70186976)
print v(xbgr.mr_n70187840)
print v(xbgr.mr_n70187952)
print v(xbgr.mr_n70188272)
print v(xbgr.mr_n70188384)
print v(xbgr.mr_n70188704)
print v(xbgr.mr_n70188816)
print v(xbgr.mr_n70189136)
print v(xbgr.mr_n70189248)
print v(xbgr.mr_n70189568)
print v(xbgr.mr_n70189680)
print v(xbgr.mr_n70190000)
print v(xbgr.mr_n70190112)
print v(xbgr.mr_n70190432)
print v(xbgr.mr_n70190544)
print v(xbgr.mr_n70190976)
print v(xbgr.mr_n70191408)
print v(xbgr.mr_n70191728)
print v(xbgr.mr_n70192160)
print v(xbgr.mr_n70192272)
print v(xbgr.mr_n70193456)
print v(xbgr.mr_n70195184)
print v(xbgr.mr_n70195296)
print v(xbgr.mr_n70195728)
print v(xbgr.mr_n70196048)
print v(xbgr.mr_n70196160)
print v(xbgr.mr_n70196480)
print v(xbgr.mr_n70196592)
print v(xbgr.mr_n70197024)
print v(xbgr.mr_n70197344)
print v(xbgr.mr_n70197456)
print v(xbgr.mr_n70197776)
print v(xbgr.mr_n70198208)
print v(xbgr.mr_n70198320)
print v(xbgr.mr_n70199072)
print v(xbgr.mr_n70199184)
print v(xbgr.mr_n70199504)
print v(xbgr.mr_n70199616)
print v(xbgr.mr_n70199936)
print v(xbgr.mr_n70200048)
print v(xbgr.mr_n70200368)
print v(xbgr.mr_n70200480)
print v(xbgr.mr_n70200800)
print v(xbgr.mr_n70200912)
print v(xbgr.mr_n70201232)
print v(xbgr.mr_n70202096)
print v(xbgr.mr_n70202960)
print v(xbgr.mr_n70203824)
print v(xbgr.mr_n70203936)
print v(xbgr.mr_n70204256)
print v(xbgr.mr_n70204688)
print v(xbgr.mr_n70204800)
print v(xbgr.mr_n70205120)
print v(xbgr.mr_n70205232)
print v(xbgr.mr_n70205552)
print v(xbgr.mr_n70205664)
print v(xbgr.mr_n70205984)
print v(xbgr.mr_n70206848)
print v(xbgr.mr_n70207824)
print v(xbgr.mr_n70208144)
print v(xbgr.mr_n70208256)
print v(xbgr.mr_n70208576)
print v(xbgr.mr_n70208688)
print v(xbgr.mr_n70209008)
print v(xbgr.mr_n70209120)
print v(xbgr.mr_n70209440)
print v(xbgr.mr_n70209552)
print v(xbgr.mr_n70209872)
print v(xbgr.mr_n70210416)
print v(xbgr.mr_n70210848)
print v(xbgr.mr_n70211280)
print v(xbgr.mr_n70212464)
print v(xbgr.mr_n70212576)
print v(xbgr.mr_n70212896)
print v(xbgr.mr_n70213008)
print v(xbgr.mr_n70213328)
print v(xbgr.mr_n70214192)
print v(xbgr.mr_n70214304)
print v(xbgr.mr_n70214624)
print v(xbgr.mr_n70214736)
print v(xbgr.mr_n70215056)
print v(xbgr.mr_n70215488)
print v(xbgr.mr_n70216352)
print v(xbgr.mr_n70217648)
print v(xbgr.mr_n70217760)
print v(xbgr.mr_n70218080)
print v(xbgr.mr_n70218192)
print v(xbgr.mr_n70218512)
print v(xbgr.mr_n70218944)
print v(xbgr.mr_n70219808)
print v(xbgr.mr_n70220240)
print v(xbgr.mr_n70220352)
print v(xbgr.mr_n70220672)
print v(xbgr.mr_n70220784)
print v(xbgr.mr_n70221104)
print v(xbgr.mr_n70221216)
print v(xbgr.mr_n70221536)
print v(xbgr.mr_n70221648)
print v(xbgr.mr_n70222400)
print v(xbgr.mr_n70222512)
print v(xbgr.mr_n70223264)
print v(xbgr.mr_n70224240)
print v(xbgr.mr_n70224560)
print v(xbgr.mr_n70224672)
print v(xbgr.mr_n70224992)
print v(xbgr.mr_n70225104)
print v(xbgr.mr_n70225424)
print v(xbgr.mr_n70225856)
print v(xbgr.mr_n70226720)
print v(xbgr.mr_n70226832)
print v(xbgr.mr_n70227152)
print v(xbgr.mr_n70227264)
print v(xbgr.mr_n70227584)
print v(xbgr.mr_n70227696)
print v(xbgr.mr_n70228016)
print v(xbgr.mr_n70228128)
print v(xbgr.mr_n70228448)
print v(xbgr.mr_n70228560)
print v(xbgr.mr_n70228992)
print v(xbgr.mr_n70229744)
print v(xbgr.mr_n70230720)
print v(xbgr.mr_n70231152)
print v(xbgr.mr_n70231472)
print v(xbgr.mr_n70231904)
print v(xbgr.mr_n70232880)
print v(xbgr.mr_n70233312)
print v(xbgr.mr_n70233632)
print v(xbgr.mr_n70234064)
print v(xbgr.mr_n70234176)
print v(xbgr.mr_n70234496)
print v(xbgr.mr_n70234608)
print v(xbgr.mr_n70234928)
print v(xbgr.mr_n70235040)
print v(xbgr.mr_n70235360)
print v(xbgr.mr_n70235472)
print v(xbgr.mr_n70236224)
print v(xbgr.mr_n70237088)
print v(xbgr.mr_n70238384)
print v(xbgr.mr_n70238496)
print v(xbgr.mr_n70238816)
print v(xbgr.mr_n70238928)
print v(xbgr.mr_n70239248)
print v(xbgr.mr_n70239360)
print v(xbgr.mr_n70239680)
print v(xbgr.mr_n70239792)
print v(xbgr.mr_n70240112)
print v(xbgr.mr_n70240224)
print v(xbgr.mr_n70240544)
print v(xbgr.mr_n70240976)
print v(xbgr.mr_n70241088)
print v(xbgr.mr_n70241408)
print v(xbgr.mr_n70241520)
print v(xbgr.mr_n70241840)
print v(xbgr.mr_n70241952)
print v(xbgr.mr_n70242272)
print v(xbgr.mr_n70242384)
print v(xbgr.mr_n70242704)
print v(xbgr.mr_n70242816)
print v(xbgr.mr_n70243136)
print v(xbgr.mr_n70243248)
print v(xbgr.mr_n70243568)
print v(xbgr.mr_n70243680)
print v(xbgr.mr_n70244000)
print v(xbgr.mr_n70244112)
print v(xbgr.mr_n70244432)
print v(xbgr.mr_n70244544)
print v(xbgr.mr_n70244976)
print v(xbgr.mr_n70245296)
print v(xbgr.mr_n70245408)
print v(xbgr.mr_n70245840)
print v(xbgr.mr_n70246272)
print v(xbgr.mr_n70246592)
print v(xbgr.mr_n70246704)
print v(xbgr.mr_n70247024)
print v(xbgr.mr_n70247136)
print v(xbgr.mr_n70247456)
print v(xbgr.mr_n70247568)
print v(xbgr.mr_n70247888)
print v(xbgr.mr_n70248000)
print v(xbgr.mr_n70248752)
print v(xbgr.mr_n70248864)
print v(xbgr.mr_n70249296)
print v(xbgr.mr_n70249616)
print v(xbgr.mr_n70250160)
print v(xbgr.mr_n70250480)
print v(xbgr.mr_n70251344)
print v(xbgr.mr_n70251456)
print v(xbgr.mr_n70251776)
print v(xbgr.mr_n70252208)
print v(xbgr.mr_n70252640)
print v(xbgr.mr_n70253072)
print v(xbgr.mr_n70253184)
print v(xbgr.mr_n70253936)
print v(xbgr.mr_n70254048)
print v(xbgr.mr_n70254368)
print v(xbgr.mr_n70254480)
print v(xbgr.mr_n70254800)
print v(xbgr.mr_n70255232)
print v(xbgr.mr_n70255344)
print v(xbgr.mr_n70255664)
print v(xbgr.mr_n70255776)
print v(xbgr.mr_n70256096)
print v(xbgr.mr_n70256208)
print v(xbgr.mr_n70256528)
print v(xbgr.mr_n70256960)
print v(xbgr.mr_n70257824)
print v(xbgr.mr_n70258688)
print v(xbgr.mr_n70259984)
print v(xbgr.mr_n70260848)
print v(xbgr.mr_n70261712)
print v(xbgr.mr_n70262576)
print v(xbgr.mr_n70262688)
print v(xbgr.mr_n70263008)
print v(xbgr.mr_n70263872)
print v(xbgr.mr_n70264736)
print v(xbgr.mr_n70265600)
print v(xbgr.mr_n70265712)
print v(xbgr.mr_n70266032)
print v(xbgr.mr_n70266144)
print v(xbgr.mr_n70266464)
print v(xbgr.mr_n70266576)
print v(xbgr.mr_n70266896)
print v(xbgr.mr_n70267008)
print v(xbgr.mr_n70267328)
print v(xbgr.mr_n70267440)
print v(xbgr.mr_n70267760)
print v(xbgr.mr_n70267872)
print v(xbgr.mr_n70269488)
print v(xbgr.mr_n70270464)
print v(xbgr.mr_n70270896)
print v(xbgr.mr_n70271328)
print v(xbgr.mr_n70271648)
print v(xbgr.mr_n70271760)
print v(xbgr.mr_n70272080)
print v(xbgr.mr_n70272192)
print v(xbgr.mr_n70272512)
print v(xbgr.mr_n70272624)
print v(xbgr.mr_n70272944)
print v(xbgr.mr_n70273056)
print v(xbgr.mr_n70273376)
print v(xbgr.mr_n70273488)
print v(xbgr.mr_n70273808)
print v(xbgr.mr_n70273920)
print v(xbgr.mr_n70274240)
print v(xbgr.mr_n70274352)
print v(xbgr.mr_n70274784)
print v(xbgr.mr_n70275104)
print v(xbgr.mr_n70275216)
print v(xbgr.mr_n70275648)
print v(xbgr.mr_n70276080)
print v(xbgr.mr_n70277264)
print v(xbgr.mr_n70277376)
print v(xbgr.mr_n70277696)
print v(xbgr.mr_n70277808)
print v(xbgr.mr_n70278128)
print v(xbgr.mr_n70278240)
print v(xbgr.mr_n70278560)
print v(xbgr.mr_n70278672)
print v(xbgr.mr_n70278992)
print v(xbgr.mr_n70279104)
print v(xbgr.mr_n70279424)
print v(xbgr.mr_n70279856)
print v(xbgr.mr_n70279968)
print v(xbgr.mr_n70280288)
print v(xbgr.mr_n70280400)
print v(xbgr.mr_n70280720)
print v(xbgr.mr_n70280832)
print v(xbgr.mr_n70281152)
print v(xbgr.mr_n70281264)
print v(xbgr.mr_n70281696)
print v(xbgr.mr_n70282016)
print v(xbgr.mr_n70282448)
print v(xbgr.mr_n70283312)
print v(xbgr.mr_n70283424)
print v(xbgr.mr_n70283744)
print v(xbgr.mr_n70284176)
print v(xbgr.mr_n70284608)
print v(xbgr.mr_n70285152)
print v(xbgr.mr_n70285472)
print v(xbgr.mr_n70286336)
print v(xbgr.mr_n70286448)
print v(xbgr.mr_n70286768)
print v(xbgr.mr_n70286880)
print v(xbgr.mr_n70287312)
print v(xbgr.mr_n70288064)
print v(xbgr.mr_n70288496)
print v(xbgr.mr_n70288928)
print v(xbgr.mr_n70289360)
print v(xbgr.mr_n70289472)
print v(xbgr.mr_n70290656)
print v(xbgr.mr_n70291520)
print v(xbgr.mr_n70292496)
print v(xbgr.mr_n70292816)
print v(xbgr.mr_n70292928)
print v(xbgr.mr_n70293360)
print v(xbgr.mr_n70293680)
print v(xbgr.mr_n70293792)
print v(xbgr.mr_n70294112)
print v(xbgr.mr_n70294224)
print v(xbgr.mr_n70294544)
print v(xbgr.mr_n70294656)
print v(xbgr.mr_n70294976)
print v(xbgr.mr_n70295088)
print v(xbgr.mr_n70295408)
print v(xbgr.mr_n70295520)
print v(xbgr.mr_n70295840)
print v(xbgr.mr_n70295952)
print v(xbgr.mr_n70296384)
print v(xbgr.mr_n70296816)
print v(xbgr.mr_n70297248)
print v(xbgr.mr_n70298000)
print v(xbgr.mr_n70298432)
print v(xbgr.mr_n70299296)
print v(xbgr.mr_n70300160)
print v(xbgr.mr_n70301888)
print v(xbgr.mr_n70302752)
print v(xbgr.mr_n70302864)
print v(xbgr.mr_n70303616)
print v(xbgr.mr_n70303728)
print v(xbgr.mr_n70304048)
print v(xbgr.mr_n70304160)
print v(xbgr.mr_n70304480)
print v(xbgr.mr_n70304592)
print v(xbgr.mr_n70306640)
print v(xbgr.mr_n70306752)
print v(xbgr.mr_n70307072)
print v(xbgr.mr_n70307184)
print v(xbgr.mr_n70307504)
print v(xbgr.mr_n70307616)
print v(xbgr.mr_n70307936)
print v(xbgr.mr_n70308048)
print v(xbgr.mr_n70308368)
print v(xbgr.mr_n70308480)
print v(xbgr.mr_n70308800)
print v(xbgr.mr_n70308912)
print v(xbgr.mr_n70309232)
print v(xbgr.mr_n70309344)
print v(xbgr.mr_n70309776)
print v(xbgr.mr_n70310096)
print v(xbgr.mr_n70310208)
print v(xbgr.mr_n70310640)
print v(xbgr.mr_n70310960)
print v(xbgr.mr_n70311072)
print v(xbgr.mr_n70311504)
print v(xbgr.mr_n70311824)
print v(xbgr.mr_n70311936)
print v(xbgr.mr_n70312256)
print v(xbgr.mr_n70312368)
print v(xbgr.mr_n70312688)
print v(xbgr.mr_n70312800)
print v(xbgr.mr_n70313120)
print v(xbgr.mr_n70313232)
print v(xbgr.mr_n70313552)
print v(xbgr.mr_n70313664)
print v(xbgr.mr_n70313984)
print v(xbgr.mr_n70314096)
print v(xbgr.mr_n70314416)
print v(xbgr.mr_n70314528)
print v(xbgr.mr_n70314848)
print v(xbgr.mr_n70314960)
print v(xbgr.mr_n70315280)
print v(xbgr.mr_n70315392)
print v(xbgr.mr_n70315712)
print v(xbgr.mr_n70315824)
print v(xbgr.mr_n70316144)
print v(xbgr.mr_n70316256)
print v(xbgr.mr_n70316576)
print v(xbgr.mr_n70316688)
print v(xbgr.mr_n70317008)
print v(xbgr.mr_n70317120)
print v(xbgr.mr_n70317440)
print v(xbgr.mr_n70317552)
print v(xbgr.mr_n70317872)
print v(xbgr.mr_n70317984)
print v(xbgr.mr_n70318304)
print v(xbgr.mr_n70318416)
print v(xbgr.mr_n70318736)
print v(xbgr.mr_n70318848)
print v(xbgr.mr_n70319168)
print v(xbgr.mr_n70319280)
print v(xbgr.mr_n70319712)
print v(xbgr.mr_n70320032)
print v(xbgr.mr_n70320144)
print v(xbgr.mr_n70320576)
print v(xbgr.mr_n70320896)
print v(xbgr.mr_n70321008)
print v(xbgr.mr_n70321440)
print v(xbgr.mr_n70321760)
print v(xbgr.mr_n70322624)
print v(xbgr.mr_n70323488)
print v(xbgr.mr_n70324352)
print v(xbgr.mr_n70325216)
print v(xbgr.mr_n70326080)
print v(xbgr.mr_n70326944)
print v(xbgr.mr_n70327056)
print v(xbgr.mr_n70327376)
print v(xbgr.mr_n70327488)
print v(xbgr.mr_n70327808)
print v(xbgr.mr_n70327920)
print v(xbgr.mr_n70328240)
print v(xbgr.mr_n70328352)
print v(xbgr.mr_n70328672)
print v(xbgr.mr_n70328784)
print v(xbgr.mr_n70329104)
print v(xbgr.mr_n70329216)
print v(xbgr.mr_n70329536)
print v(xbgr.mr_n70330400)
print v(xbgr.mr_n70331264)
print v(xbgr.mr_n70332128)
print v(xbgr.mr_n70332240)
print v(xbgr.mr_n70332560)
print v(xbgr.mr_n70332672)
print v(xbgr.mr_n70332992)
print v(xbgr.mr_n70333104)
print v(xbgr.mr_n70333536)
print v(xbgr.mr_n70333968)
print v(xbgr.mr_n70334400)
print v(xbgr.mr_n70334720)
print v(xbgr.mr_n70334832)
print v(xbgr.mr_n70335264)
print v(xbgr.mr_n70335584)
print v(xbgr.mr_n70335696)
print v(xbgr.mr_n70336016)
print v(xbgr.mr_n70336128)
print v(xbgr.mr_n70336448)
print v(xbgr.mr_n70336560)
print v(xbgr.mr_n70336880)
print v(xbgr.mr_n70336992)
print v(xbgr.mr_n70337312)
print v(xbgr.mr_n70337424)
print v(xbgr.mr_n70337744)
print v(xbgr.mr_n70337856)
print v(xbgr.mr_n70338288)
print v(xbgr.mr_n70338720)
print v(xbgr.mr_n70339040)
print v(xbgr.mr_n70339152)
print v(xbgr.mr_n70339584)
print v(xbgr.mr_n70339904)
print v(xbgr.mr_n70340016)
print v(xbgr.mr_n70340448)
print v(xbgr.mr_n70340768)
print v(xbgr.mr_n70340880)
print v(xbgr.mr_n70341312)
print v(xbgr.mr_n70341632)
print v(xbgr.mr_n70342496)
print v(xbgr.mr_n70343360)
print v(xbgr.mr_n70344224)
print v(xbgr.mr_n70345088)
print v(xbgr.mr_n70345952)
print v(xbgr.mr_n70346064)
print v(xbgr.mr_n70346384)
print v(xbgr.mr_n70346496)
print v(xbgr.mr_n70346816)
print v(xbgr.mr_n70346928)
print v(xbgr.mr_n70347248)
print v(xbgr.mr_n70347360)
print v(xbgr.mr_n70347680)
print v(xbgr.mr_n70348544)
print v(xbgr.mr_n70349408)
print v(xbgr.mr_n70350272)
print v(xbgr.mr_n70350384)
print v(xbgr.mr_n70350704)
print v(xbgr.mr_n70350816)
print v(xbgr.mr_n70351136)
print v(xbgr.mr_n70351248)
print v(xbgr.mr_n70351568)
print v(xbgr.mr_n70351680)
print v(xbgr.mr_n70352000)
print v(xbgr.mr_n70352112)
print v(xbgr.mr_n70352432)
print v(xbgr.mr_n70352544)
print v(xbgr.mr_n70352864)
print v(xbgr.mr_n70353728)
print v(xbgr.mr_n70354592)
print v(xbgr.mr_n70355456)
print v(xbgr.mr_n70356320)
print v(xbgr.mr_n70357184)
print v(xbgr.mr_n70358048)
print v(xbgr.mr_n70358912)
print v(xbgr.mr_n70359776)
print v(xbgr.mr_n70360640)
print v(xbgr.mr_n70360752)
print v(xbgr.mr_n70361072)
print v(xbgr.mr_n70361184)
print v(xbgr.mr_n70361504)
print v(xbgr.mr_n70361616)
print v(xbgr.mr_n70361936)
print v(xbgr.mr_n70362048)
print v(xbgr.mr_n70362368)
print v(xbgr.mr_n70362480)
print v(xbgr.mr_n70362800)
print v(xbgr.mr_n70362912)
print v(xbgr.mr_n70363232)
print v(xbgr.mr_n70363344)
print v(xbgr.mr_n70363664)
print v(xbgr.mr_n70363776)
print v(xbgr.mr_n70364096)
print v(xbgr.mr_n70364208)
print v(xbgr.mr_n70364528)
print v(xbgr.mr_n70364640)
print v(xbgr.mr_n70364960)
print v(xbgr.mr_n70365824)
print v(xbgr.mr_n70365936)
print v(xbgr.mr_n70366256)
print v(xbgr.mr_n70366368)
print v(xbgr.mr_n70366688)
print v(xbgr.mr_n70366800)
print v(xbgr.mr_n70367120)
print v(xbgr.mr_n70367232)
print v(xbgr.mr_n70367552)
print v(xbgr.mr_n70367664)
print v(xbgr.mr_n70367984)
print v(xbgr.mr_n70368096)
print v(xbgr.mr_n70368416)
print v(xbgr.mr_n70368528)
print v(xbgr.mr_n70368848)
print v(xbgr.mr_n70368960)
print v(xbgr.mr_n70369280)
print v(xbgr.mr_n70369392)
print v(xbgr.mr_n70369712)
print v(xbgr.mr_n70369824)
print v(xbgr.mr_n70370144)
print v(xbgr.mr_n70370256)
print v(xbgr.mr_n70370688)
print v(xbgr.mr_n70371008)
print v(xbgr.mr_n70371120)
print v(xbgr.mr_n70371552)
print v(xbgr.mr_n70371872)
print v(xbgr.mr_n70371984)
print v(xbgr.mr_n70372416)
print v(xbgr.mr_n70372736)
print v(xbgr.mr_n70372848)
print v(xbgr.mr_n70373280)
print v(xbgr.mr_n70373600)
print v(xbgr.mr_n70373712)
print v(xbgr.mr_n70374032)
print v(xbgr.mr_n70374144)
print v(xbgr.mr_n70374576)
print v(xbgr.mr_n70375008)
print v(xbgr.mr_n70375328)
print v(xbgr.mr_n70375440)
print v(xbgr.mr_n70375760)
print v(xbgr.mr_n70375872)
print v(xbgr.mr_n70376192)
print v(xbgr.mr_n70376304)
print v(xbgr.mr_n70376624)
print v(xbgr.mr_n70376736)
print v(xbgr.mr_n70377056)
print v(xbgr.mr_n70377168)
print v(xbgr.mr_n70377600)
print v(xbgr.mr_n70377920)
print v(xbgr.mr_n70378032)
print v(xbgr.mr_n70378464)
print v(xbgr.mr_n70378784)
print v(xbgr.mr_n70379648)
print v(xbgr.mr_n70380512)
print v(xbgr.mr_n70381376)
print v(xbgr.mr_n70382240)
print v(xbgr.mr_n70382352)
print v(xbgr.mr_n70382672)
print v(xbgr.mr_n70382784)
print v(xbgr.mr_n70383104)
print v(xbgr.mr_n70383216)
print v(xbgr.mr_n70383536)
print v(xbgr.mr_n70383648)
print v(xbgr.mr_n70383968)
print v(xbgr.mr_n70384832)
print v(xbgr.mr_n70385696)
print v(xbgr.mr_n70385808)
print v(xbgr.mr_n70386128)
print v(xbgr.mr_n70386240)
print v(xbgr.mr_n70386672)
print v(xbgr.mr_n70387104)
print v(xbgr.mr_n70387424)
print v(xbgr.mr_n70387536)
print v(xbgr.mr_n70387856)
print v(xbgr.mr_n70387968)
print v(xbgr.mr_n70388288)
print v(xbgr.mr_n70388400)
print v(xbgr.mr_n70388720)
print v(xbgr.mr_n70388832)
print v(xbgr.mr_n70389152)
print v(xbgr.mr_n70389264)
print v(xbgr.mr_n70389696)
print v(xbgr.mr_n70390016)
print v(xbgr.mr_n70390128)
print v(xbgr.mr_n70390560)
print v(xbgr.mr_n70390880)
print v(xbgr.mr_n70390992)
print v(xbgr.mr_n70391312)
print v(xbgr.mr_n70391424)
print v(xbgr.mr_n70391744)
print v(xbgr.mr_n70391856)
print v(xbgr.mr_n70392176)
print v(xbgr.mr_n70392288)
print v(xbgr.mr_n70392608)
print v(xbgr.mr_n70392720)
print v(xbgr.mr_n70393040)
print v(xbgr.mr_n70393152)
print v(xbgr.mr_n70393472)
print v(xbgr.mr_n70393584)
print v(xbgr.mr_n70393904)
print v(xbgr.mr_n70394016)
print v(xbgr.mr_n70394336)
print v(xbgr.mr_n70394448)
print v(xbgr.mr_n70394768)
print v(xbgr.mr_n70394880)
print v(xbgr.mr_n70395200)
print v(xbgr.mr_n70396064)
print v(xbgr.mr_n70396928)
print v(xbgr.mr_n70397792)
print v(xbgr.mr_n70398656)
print v(xbgr.mr_n70398768)
print v(xbgr.mr_n70399088)
print v(xbgr.mr_n70399200)
print v(xbgr.mr_n70399520)
print v(xbgr.mr_n70399632)
print v(xbgr.mr_n70399952)
print v(xbgr.mr_n70400064)
print v(xbgr.mr_n70400496)
print v(xbgr.mr_n70400928)
print v(xbgr.mr_n70401360)
print v(xbgr.mr_n70401792)
print v(xbgr.mr_n70402112)
print v(xbgr.mr_n70402224)
print v(xbgr.mr_n70402544)
print v(xbgr.mr_n70402656)
print v(xbgr.mr_n70402976)
print v(xbgr.mr_n70403088)
print v(xbgr.mr_n70403408)
print v(xbgr.mr_n70403520)
print v(xbgr.mr_n70403840)
print v(xbgr.mr_n70404704)
print v(xbgr.mr_n70405568)
print v(xbgr.mr_n70405680)
print v(xbgr.mr_n70406112)
print v(xbgr.mr_n70406432)
print v(xbgr.mr_n70407296)
print v(xbgr.mr_n70407408)
print v(xbgr.mr_n70407728)
print v(xbgr.mr_n70407840)
print v(xbgr.mr_n70408160)
print v(xbgr.mr_n70408272)
print v(xbgr.mr_n70408592)
print v(xbgr.mr_n70408704)
print v(xbgr.mr_n70409024)
print v(xbgr.mr_n70409888)
print v(xbgr.mr_n70410000)
print v(xbgr.mr_n70410432)
print v(xbgr.mr_n70410752)
print v(xbgr.mr_n70410864)
print v(xbgr.mr_n70411184)
print v(xbgr.mr_n70411296)
print v(xbgr.mr_n70411616)
print v(xbgr.mr_n70411728)
print v(xbgr.mr_n70412048)
print v(xbgr.mr_n70412160)
print v(xbgr.mr_n70412480)
print v(xbgr.mr_n70413344)
print v(xbgr.mr_n70413776)
print v(xbgr.mr_n70413888)
print v(xbgr.mr_n70414208)
print v(xbgr.mr_n70414320)
print v(xbgr.mr_n70414640)
print v(xbgr.mr_n70415072)
print v(xbgr.mr_n70415936)
print v(xbgr.mr_n70416800)
print v(xbgr.mr_n70416912)
print v(xbgr.mr_n70417664)
print v(xbgr.mr_n70417776)
print v(xbgr.mr_n70418096)
print v(xbgr.mr_n70418208)
print v(xbgr.mr_n70418528)
print v(xbgr.mr_n70419392)
print v(xbgr.mr_n70420256)
print v(xbgr.mr_n70420368)
print v(xbgr.mr_n70420688)
print v(xbgr.mr_n70420800)
print v(xbgr.mr_n70421120)
print v(xbgr.mr_n70421984)
print v(xbgr.mr_n70422096)
print v(xbgr.mr_n70422416)
print v(xbgr.mr_n70422528)
print v(xbgr.mr_n70422848)
print v(xbgr.mr_n70422960)
print v(xbgr.mr_n70423280)
print v(xbgr.mr_n70423392)
print v(xbgr.mr_n70423712)
print v(xbgr.mr_n70423824)
print v(xbgr.mr_n70424576)
print v(xbgr.mr_n70425440)
print v(xbgr.mr_n70426304)
print v(xbgr.mr_n70426416)
print v(xbgr.mr_n70426736)
print v(xbgr.mr_n70426848)
print v(xbgr.mr_n70427168)
print v(xbgr.mr_n70427280)
print v(xbgr.mr_n70427600)
print v(xbgr.mr_n70427712)
print v(xbgr.mr_n70428032)
print v(xbgr.mr_n70428144)
print v(xbgr.mr_n70428464)
print v(xbgr.mr_n70428576)
print v(xbgr.mr_n70428896)
print v(xbgr.mr_n70429008)
print v(xbgr.mr_n70429440)
print v(xbgr.mr_n70429760)
print v(xbgr.mr_n70429872)
print v(xbgr.mr_n70430192)
print v(xbgr.mr_n70430304)
print v(xbgr.mr_n70430624)
print v(xbgr.mr_n70431488)
print v(xbgr.mr_n70432352)
print v(xbgr.mr_n70433216)
print v(xbgr.mr_n70434080)
print v(xbgr.mr_n70434512)
print v(xbgr.mr_n70434624)
print v(xbgr.mr_n70434944)
print v(xbgr.mr_n70435056)
print v(xbgr.mr_n70435376)
print v(xbgr.mr_n70435488)
print v(xbgr.mr_n70435920)
print v(xbgr.mr_n70436672)
print v(xbgr.mr_n70436784)
print v(xbgr.mr_n70437104)
print v(xbgr.mr_n70437216)
print v(xbgr.mr_n70437536)
print v(xbgr.mr_n70438400)
print v(xbgr.mr_n70439264)
print v(xbgr.mr_n70439376)
print v(xbgr.mr_n70439696)
print v(xbgr.mr_n70439808)
print v(xbgr.mr_n70440128)
print v(xbgr.mr_n70440992)
print v(xbgr.mr_n70441856)
print v(xbgr.mr_n70442720)
print v(xbgr.mr_n70442832)
print v(xbgr.mr_n70443152)
print v(xbgr.mr_n70443264)
print v(xbgr.mr_n70443584)
print v(xbgr.mr_n70444448)
print v(xbgr.mr_n70445312)
print v(xbgr.mr_n70445424)
print v(xbgr.mr_n70445744)
print v(xbgr.mr_n70445856)
print v(xbgr.mr_n70446176)
print v(xbgr.mr_n70446288)
print v(xbgr.mr_n70446608)
print v(xbgr.mr_n70446720)
print v(xbgr.mr_n70447040)
print v(xbgr.mr_n70447152)
print v(xbgr.mr_n70447472)
print v(xbgr.mr_n70447584)
print v(xbgr.mr_n70447904)
print v(xbgr.mr_n70448016)
print v(xbgr.mr_n70448336)
print v(xbgr.mr_n70448448)
print v(xbgr.mr_n70448768)
print v(xbgr.mr_n70448880)
print v(xbgr.mr_n70449200)
print v(xbgr.mr_n70449312)
print v(xbgr.mr_n70449632)
print v(xbgr.mr_n70449744)
print v(xbgr.mr_n70450064)
print v(xbgr.mr_n70450176)
print v(xbgr.mr_n70450496)
print v(xbgr.mr_n70450608)
print v(xbgr.mr_n70450928)
print v(xbgr.mr_n70451040)
print v(xbgr.mr_n70451360)
print v(xbgr.mr_n70451472)
print v(xbgr.mr_n70451792)
print v(xbgr.mr_n70451904)
print v(xbgr.mr_n70452224)
print v(xbgr.mr_n70452336)
print v(xbgr.mr_n70452656)
print v(xbgr.mr_n70452768)
print v(xbgr.mr_n70453088)
print v(xbgr.mr_n70453200)
print v(xbgr.mr_n70453520)
print v(xbgr.mr_n70453632)
print v(xbgr.mr_n70453952)
print v(xbgr.mr_n70454064)
print v(xbgr.mr_n70454384)
print v(xbgr.mr_n70454496)
print v(xbgr.mr_n70454816)
print v(xbgr.mr_n70454928)
print v(xbgr.mr_n70455248)
print v(xbgr.mr_n70455360)
print v(xbgr.mr_n70455680)
print v(xbgr.mr_n70455792)
print v(xbgr.mr_n70456112)
print v(xbgr.mr_n70456224)
print v(xbgr.mr_n70456656)
print v(xbgr.mr_n70457088)
print v(xbgr.mr_n70457520)
print v(xbgr.mr_n70457952)
print v(xbgr.mr_n70458384)
print v(xbgr.mr_n70458816)
print v(xbgr.mr_n70459248)
print v(xbgr.mr_n70459680)
print v(xbgr.mr_n70460112)
print v(xbgr.mr_n70460544)
print v(xbgr.mr_n70460976)
print v(xbgr.mr_n70461408)
print v(xbgr.mr_n70461840)
print v(xbgr.mr_n70462272)
print v(xbgr.mr_n70462704)
print v(xbgr.mr_n70463136)
print v(xbgr.mr_n70463568)
print v(xbgr.mr_n70464000)
print v(xbgr.mr_n70464432)
print v(xbgr.mr_n70464864)
print v(xbgr.mr_n70465296)
print v(xbgr.mr_n70465728)
print v(xbgr.mr_n70466160)
print v(xbgr.mr_n70466592)
print v(xbgr.mr_n70467024)
print v(xbgr.mr_n70467456)
print v(xbgr.mr_n70467776)
print v(xbgr.mr_n70467888)
print v(xbgr.mr_n70468208)
print v(xbgr.mr_n70468320)
print v(xbgr.mr_n70468640)
print v(xbgr.mr_n70468752)
print v(xbgr.mr_n70469072)
print v(xbgr.mr_n70469184)
print v(xbgr.mr_n70469504)
print v(xbgr.mr_n70469616)
print v(xbgr.mr_n70469936)
print v(xbgr.mr_n70470048)
print v(xbgr.mr_n70470368)
print v(xbgr.mr_n70470480)
print v(xbgr.mr_n70470800)
print v(xbgr.mr_n70470912)
print v(xbgr.mr_n70471232)
print v(xbgr.mr_n70471344)
print v(xbgr.mr_n70471664)
print v(xbgr.mr_n70471776)
print v(xbgr.mr_n70472096)
print v(xbgr.mr_n70472208)
print v(xbgr.mr_n70472528)
print v(xbgr.mr_n70472640)
print v(xbgr.mr_n70472960)
print v(xbgr.mr_n70473072)
print v(xbgr.mr_n70473392)
print v(xbgr.mr_n70473504)
print v(xbgr.mr_n70473824)
print v(xbgr.mr_n70473936)
print v(xbgr.mr_n70474256)
print v(xbgr.mr_n70474368)
print v(xbgr.mr_n70474688)
print v(xbgr.mr_n70474800)
print v(xbgr.mr_n70475120)
print v(xbgr.mr_n70475232)
print v(xbgr.mr_n70475552)
print v(xbgr.mr_n70475664)
print v(xbgr.mr_n70475984)
print v(xbgr.mr_n70476096)
print v(xbgr.mr_n70476416)
print v(xbgr.mr_n70476528)
print v(xbgr.mr_n70476848)
print v(xbgr.mr_n70476960)
print v(xbgr.mr_n70477280)
print v(xbgr.mr_n70477392)
print v(xbgr.mr_n70477712)
print v(xbgr.mr_n70477824)
print v(xbgr.mr_n70478256)
print v(xbgr.mr_n70478688)
print v(xbgr.mr_n70479120)
print v(xbgr.mr_n70479552)
print v(xbgr.mr_n70479872)
print v(xbgr.mr_n70479984)
print v(xbgr.mr_n70480304)
print v(xbgr.mr_n70480416)
print v(xbgr.mr_n70480848)
print v(xbgr.mr_n70481280)
print v(xbgr.mr_n70481712)
print v(xbgr.mr_n70482144)
print v(xbgr.mr_n70482576)
print v(xbgr.mr_n70483008)
print v(xbgr.mr_n70483440)
print v(xbgr.mr_n70483872)
print v(xbgr.mr_n70484304)
print v(xbgr.mr_n70484736)
print v(xbgr.mr_n70485168)
print v(xbgr.mr_n70485600)
print v(xbgr.mr_n70486032)
print v(xbgr.mr_n70486464)
print v(xbgr.mr_n70486896)
print v(xbgr.mr_n70487328)
print v(xbgr.mr_n70487760)
print v(xbgr.mr_n70488192)
print v(xbgr.mr_n70488624)
print v(xbgr.mr_n70489056)
print v(xbgr.mr_n70489488)
print v(xbgr.mr_n70489920)
print v(xbgr.mr_n70490240)
print v(xbgr.mr_n70490352)
print v(xbgr.mr_n70490784)
print v(xbgr.mr_n70491104)
print v(xbgr.mr_n70491216)
print v(xbgr.mr_n70491648)
print v(xbgr.mr_n70491968)
print v(xbgr.mr_n70492080)
print v(xbgr.mr_n70492512)
print v(xbgr.mr_n70492832)
print v(xbgr.mr_n70492944)
print v(xbgr.mr_n70493376)
print v(xbgr.mr_n70493696)
print v(xbgr.mr_n70493808)
print v(xbgr.mr_n70494240)
print v(xbgr.mr_n70494560)
print v(xbgr.mr_n70494672)
print v(xbgr.mr_n70494992)
print v(xbgr.mr_n70495104)
print v(xbgr.mr_n70495424)
print v(xbgr.mr_n70495536)
print v(xbgr.mr_n70495968)
print v(xbgr.mr_n70496400)
print v(xbgr.mr_n70496832)
print v(xbgr.mr_n70497152)
print v(xbgr.mr_n70497264)
print v(xbgr.mr_n70497584)
print v(xbgr.mr_n70497696)
print v(xbgr.mr_n70498016)
print v(xbgr.mr_n70498128)
print v(xbgr.mr_n70498448)
print v(xbgr.mr_n70498560)
print v(xbgr.mr_n70498880)
print v(xbgr.mr_n70498992)
print v(xbgr.mr_n70499312)
print v(xbgr.mr_n70499424)
print v(xbgr.mr_n70499744)
print v(xbgr.mr_n70499856)
print v(xbgr.mr_n70500288)
print v(xbgr.mr_n70500608)
print v(xbgr.mr_n70500720)
print v(xbgr.mr_n70501152)
print v(xbgr.mr_n70501472)
print v(xbgr.mr_n70501584)
print v(xbgr.mr_n70502016)
print v(xbgr.mr_n70502336)
print v(xbgr.mr_n70503200)
print v(xbgr.mr_n70504064)
print v(xbgr.mr_n70504928)
print v(xbgr.mr_n70505792)
print v(xbgr.mr_n70506656)
print v(xbgr.mr_n70507520)
print v(xbgr.mr_n70507632)
print v(xbgr.mr_n70507952)
print v(xbgr.mr_n70508064)
print v(xbgr.mr_n70508384)
print v(xbgr.mr_n70508496)
print v(xbgr.mr_n70508816)
print v(xbgr.mr_n70508928)
print v(xbgr.mr_n70509248)
print v(xbgr.mr_n70510112)
print v(xbgr.mr_n70510976)
print v(xbgr.mr_n70511840)
print v(xbgr.mr_n70511952)
print v(xbgr.mr_n70512272)
print v(xbgr.mr_n70512384)
print v(xbgr.mr_n70512704)
print v(xbgr.mr_n70512816)
print v(xbgr.mr_n70513248)
print v(xbgr.mr_n70513680)
print v(xbgr.mr_n70514112)
print v(xbgr.mr_n70514432)
print v(xbgr.mr_n70514544)
print v(xbgr.mr_n70514864)
print v(xbgr.mr_n70514976)
print v(xbgr.mr_n70515296)
print v(xbgr.mr_n70515408)
print v(xbgr.mr_n70515728)
print v(xbgr.mr_n70515840)
print v(xbgr.mr_n70516160)
print v(xbgr.mr_n70516272)
print v(xbgr.mr_n70516592)
print v(xbgr.mr_n70516704)
print v(xbgr.mr_n70517024)
print v(xbgr.mr_n70517136)
print v(xbgr.mr_n70517456)
print v(xbgr.mr_n70517568)
print v(xbgr.mr_n70517888)
print v(xbgr.mr_n70518000)
print v(xbgr.mr_n70518432)
print v(xbgr.mr_n70518752)
print v(xbgr.mr_n70518864)
print v(xbgr.mr_n70519296)
print v(xbgr.mr_n70519616)
print v(xbgr.mr_n70519728)
print v(xbgr.mr_n70520048)
print v(xbgr.mr_n70520160)
print v(xbgr.mr_n70520480)
print v(xbgr.mr_n70521344)
print v(xbgr.mr_n70522208)
print v(xbgr.mr_n70522320)
print v(xbgr.mr_n70522640)
print v(xbgr.mr_n70522752)
print v(xbgr.mr_n70523072)
print v(xbgr.mr_n70523936)
print v(xbgr.mr_n70524480)
print v(xbgr.mr_n70524912)
print v(xbgr.mr_n70525664)
print v(xbgr.mr_n70526528)
print v(xbgr.mr_n70526640)
print v(xbgr.mr_n70526960)
print v(xbgr.mr_n70527072)
print v(xbgr.mr_n70527392)
print v(xbgr.mr_n70527504)
print v(xbgr.mr_n70527824)
print v(xbgr.mr_n70527936)
print v(xbgr.mr_n70528256)
print v(xbgr.mr_n70528368)
print v(xbgr.mr_n70528688)
print v(xbgr.mr_n70528800)
print v(xbgr.mr_n70529120)
print v(xbgr.mr_n70529232)
print v(xbgr.mr_n70529552)
print v(xbgr.mr_n70529664)
print v(xbgr.mr_n70529984)
print v(xbgr.mr_n70530848)
print v(xbgr.mr_n70530960)
print v(xbgr.mr_n70531280)
print v(xbgr.mr_n70531392)
print v(xbgr.mr_n70531712)
print v(xbgr.mr_n70532576)
print v(xbgr.mr_n70533440)
print v(xbgr.mr_n70533552)
print v(xbgr.mr_n70533872)
print v(xbgr.mr_n70533984)
print v(xbgr.mr_n70534304)
print v(xbgr.mr_n70534416)
print v(xbgr.mr_n70534848)
print v(xbgr.mr_n70535168)
print v(xbgr.mr_n70535600)
print v(xbgr.mr_n70536896)
print v(xbgr.mr_n70537008)
print v(xbgr.mr_n70537328)
print v(xbgr.mr_n70537440)
print v(xbgr.mr_n70537760)
print v(xbgr.mr_n70537872)
print v(xbgr.mr_n70538192)
print v(xbgr.mr_n70538304)
print v(xbgr.mr_n70538624)
print v(xbgr.mr_n70538736)
print v(xbgr.mr_n70539168)
print v(xbgr.mr_n70539488)
print v(xbgr.mr_n70539600)
print v(xbgr.mr_n70539920)
print v(xbgr.mr_n70540032)
print v(xbgr.mr_n70540352)
print v(xbgr.mr_n70540464)
print v(xbgr.mr_n70540784)
print v(xbgr.mr_n70540896)
print v(xbgr.mr_n70541216)
print v(xbgr.mr_n70542080)
print v(xbgr.mr_n70542944)
print v(xbgr.mr_n70543808)
print v(xbgr.mr_n70544672)
print v(xbgr.mr_n70544784)
print v(xbgr.mr_n70545104)
print v(xbgr.mr_n70545216)
print v(xbgr.mr_n70545536)
print v(xbgr.mr_n70545648)
print v(xbgr.mr_n70545968)
print v(xbgr.mr_n70546080)
print v(xbgr.mr_n70546400)
print v(xbgr.mr_n70547264)
print v(xbgr.mr_n70548128)
print v(xbgr.mr_n70548992)
print v(xbgr.mr_n70549856)
print v(xbgr.mr_n70550288)
print v(xbgr.mr_n70550400)
print v(xbgr.mr_n70550720)
print v(xbgr.mr_n70550832)
print v(xbgr.mr_n70551152)
print v(xbgr.mr_n70551264)
print v(xbgr.mr_n70551584)
print v(xbgr.mr_n70551696)
print v(xbgr.mr_n70552016)
print v(xbgr.mr_n70552128)
print v(xbgr.mr_n70552448)
print v(xbgr.mr_n70552560)
print v(xbgr.mr_n70552880)
print v(xbgr.mr_n70552992)
print v(xbgr.mr_n70553312)
print v(xbgr.mr_n70553424)
print v(xbgr.mr_n70553856)
print v(xbgr.mr_n70554176)
print v(xbgr.mr_n70554288)
print v(xbgr.mr_n70554720)
print v(xbgr.mr_n70555040)
print v(xbgr.mr_n70555152)
print v(xbgr.mr_n70555584)
print v(xbgr.mr_n70555904)
print v(xbgr.mr_n70556016)
print v(xbgr.mr_n70556336)
print v(xbgr.mr_n70556448)
print v(xbgr.mr_n70556768)
print v(xbgr.mr_n70557632)
print v(xbgr.mr_n70558496)
print v(xbgr.mr_n70559360)
print v(xbgr.mr_n70560224)
print v(xbgr.mr_n70561088)
print v(xbgr.mr_n70561952)
print v(xbgr.mr_n70562816)
print v(xbgr.mr_n70563680)
print v(xbgr.mr_n70564544)
print v(xbgr.mr_n70564656)
print v(xbgr.mr_n70564976)
print v(xbgr.mr_n70565088)
print v(xbgr.mr_n70565408)
print v(xbgr.mr_n70566272)
print v(xbgr.mr_n70566384)
print v(xbgr.mr_n70566704)
print v(xbgr.mr_n70566816)
print v(xbgr.mr_n70567136)
print v(xbgr.mr_n70567248)
print v(xbgr.mr_n70567568)
print v(xbgr.mr_n70567680)
print v(xbgr.mr_n70568000)
print v(xbgr.mr_n70568112)
print v(xbgr.mr_n70568432)
print v(xbgr.mr_n70568544)
print v(xbgr.mr_n70568864)
print v(xbgr.mr_n70568976)
print v(xbgr.mr_n70569296)
print v(xbgr.mr_n70569408)
print v(xbgr.mr_n70569728)
print v(xbgr.mr_n70570592)
print v(xbgr.mr_n70571456)
print v(xbgr.mr_n70572320)
print v(xbgr.mr_n70572432)
print v(xbgr.mr_n70572752)
print v(xbgr.mr_n70574048)
print v(xbgr.mr_n70574912)
print v(xbgr.mr_n70575776)
print v(xbgr.mr_n70576640)
print v(xbgr.mr_n70576752)
print v(xbgr.mr_n70577072)
print v(xbgr.mr_n70577184)
print v(xbgr.mr_n70577616)
print v(xbgr.mr_n70577936)
print v(xbgr.mr_n70578048)
print v(xbgr.mr_n70578480)
print v(xbgr.mr_n70578800)
print v(xbgr.mr_n70578912)
print v(xbgr.mr_n70579344)
print v(xbgr.mr_n70579664)
print v(xbgr.mr_n70579776)
print v(xbgr.mr_n70580208)
print v(xbgr.mr_n70580528)
print v(xbgr.mr_n70580640)
print v(xbgr.mr_n70581072)
print v(xbgr.mr_n70581392)
print v(xbgr.mr_n70581504)
print v(xbgr.mr_n70581824)
print v(xbgr.mr_n70581936)
print v(xbgr.mr_n70582256)
print v(xbgr.mr_n70582368)
print v(xbgr.mr_n70582800)
print v(xbgr.mr_n70583120)
print v(xbgr.mr_n70583232)
print v(xbgr.mr_n70583552)
print v(xbgr.mr_n70583664)
print v(xbgr.mr_n70583984)
print v(xbgr.mr_n70584096)
print v(xbgr.mr_n70584416)
print v(xbgr.mr_n70584528)
print v(xbgr.mr_n70584848)
print v(xbgr.mr_n70584960)
print v(xbgr.mr_n70585280)
print v(xbgr.mr_n70585392)
print v(xbgr.mr_n70585712)
print v(xbgr.mr_n70585824)
print v(xbgr.mr_n70586144)
print v(xbgr.mr_n70586256)
print v(xbgr.mr_n70586688)
print v(xbgr.mr_n70587008)
print v(xbgr.mr_n70587984)
print v(xbgr.mr_n70588416)
print v(xbgr.mr_n70588736)
print v(xbgr.mr_n70589600)
print v(xbgr.mr_n70589712)
print v(xbgr.mr_n70590032)
print v(xbgr.mr_n70590144)
print v(xbgr.mr_n70590464)
print v(xbgr.mr_n70590576)
print v(xbgr.mr_n70590896)
print v(xbgr.mr_n70591008)
print v(xbgr.mr_n70591328)
print v(xbgr.mr_n70592192)
print v(xbgr.mr_n70592624)
print v(xbgr.mr_n70593488)
print v(xbgr.mr_n70594352)
print v(xbgr.mr_n70594464)
print v(xbgr.mr_n70594784)
print v(xbgr.mr_n70594896)
print v(xbgr.mr_n70595216)
print v(xbgr.mr_n70595328)
print v(xbgr.mr_n70595648)
print v(xbgr.mr_n70595760)
print v(xbgr.mr_n70596512)
print v(xbgr.mr_n70596624)
print v(xbgr.mr_n70596944)
print v(xbgr.mr_n70597056)
print v(xbgr.mr_n70597376)
print v(xbgr.mr_n70597488)
print v(xbgr.mr_n70597808)
print v(xbgr.mr_n70597920)
print v(xbgr.mr_n70598240)
print v(xbgr.mr_n70598784)
print v(xbgr.mr_n70599104)
print v(xbgr.mr_n70599216)
print v(xbgr.mr_n70599648)
print v(xbgr.mr_n70599968)
print v(xbgr.mr_n70600080)
print v(xbgr.mr_n70601264)
print v(xbgr.mr_n70601696)
print v(xbgr.mr_n70601808)
print v(xbgr.mr_n70602128)
print v(xbgr.mr_n70602240)
print v(xbgr.mr_n70602560)
print v(xbgr.mr_n70602672)
print v(xbgr.mr_n70602992)
print v(xbgr.mr_n70603104)
print v(xbgr.mr_n70603424)
print v(xbgr.mr_n70603536)
print v(xbgr.mr_n70603856)
print v(xbgr.mr_n70603968)
print v(xbgr.mr_n70604720)
print v(xbgr.mr_n70605584)
print v(xbgr.mr_n70605696)
print v(xbgr.mr_n70606016)
print v(xbgr.mr_n70606128)
print v(xbgr.mr_n70606448)
print v(xbgr.mr_n70606560)
print v(xbgr.mr_n70606880)
print v(xbgr.mr_n70606992)
print v(xbgr.mr_n70607312)
print v(xbgr.mr_n70607424)
print v(xbgr.mr_n70607744)
print v(xbgr.mr_n70607856)
print v(xbgr.mr_n70608176)
print v(xbgr.mr_n70608288)
print v(xbgr.mr_n70608608)
print v(xbgr.mr_n70608720)
print v(xbgr.mr_n70609040)
print v(xbgr.mr_n70609904)
print v(xbgr.mr_n70610768)
print v(xbgr.mr_n70611632)
print v(xbgr.mr_n70611744)
print v(xbgr.mr_n70612176)
print v(xbgr.mr_n70612608)
print v(xbgr.mr_n70612928)
print v(xbgr.mr_n70613360)
print v(xbgr.mr_n70613472)
print v(xbgr.mr_n70613792)
print v(xbgr.mr_n70613904)
print v(xbgr.mr_n70614656)
print v(xbgr.mr_n70616064)
print v(xbgr.mr_n70616384)
print v(xbgr.mr_n70616496)
print v(xbgr.mr_n70616816)
print v(xbgr.mr_n70616928)
print v(xbgr.mr_n70617248)
print v(xbgr.mr_n70617360)
print v(xbgr.mr_n70617792)
print v(xbgr.mr_n70618112)
print v(xbgr.mr_n70618224)
print v(xbgr.mr_n70618656)
print v(xbgr.mr_n70618976)
print v(xbgr.mr_n70619408)
print v(xbgr.mr_n70619840)
print v(xbgr.mr_n70619952)
print v(xbgr.mr_n70620272)
print v(xbgr.mr_n70620384)
print v(xbgr.mr_n70620704)
print v(xbgr.mr_n70620816)
print v(xbgr.mr_n70621568)
print v(xbgr.mr_n70622432)
print v(xbgr.mr_n70622544)
print v(xbgr.mr_n70622976)
print v(xbgr.mr_n70623296)
print v(xbgr.mr_n70624160)
print v(xbgr.mr_n70625024)
print v(xbgr.mr_n70626320)
print v(xbgr.mr_n70626752)
print v(xbgr.mr_n70626864)
print v(xbgr.mr_n70627184)
print v(xbgr.mr_n70627296)
print v(xbgr.mr_n70627616)
print v(xbgr.mr_n70627728)
print v(xbgr.mr_n70628048)
print v(xbgr.mr_n70628160)
print v(xbgr.mr_n70628480)
print v(xbgr.mr_n70628592)
print v(xbgr.mr_n70628912)
print v(xbgr.mr_n70629024)
print v(xbgr.mr_n70629344)
print v(xbgr.mr_n70629456)
print v(xbgr.mr_n70629776)
print v(xbgr.mr_n70629888)
print v(xbgr.mr_n70630640)
print v(xbgr.mr_n70631504)
print v(xbgr.mr_n70632368)
print v(xbgr.mr_n70632480)
print v(xbgr.mr_n70632800)
print v(xbgr.mr_n70632912)
print v(xbgr.mr_n70633232)
print v(xbgr.mr_n70633344)
print v(xbgr.mr_n70633664)
print v(xbgr.mr_n70634528)
print v(xbgr.mr_n70635392)
print v(xbgr.mr_n70636256)
print v(xbgr.mr_n70637120)
print v(xbgr.mr_n70637984)
print v(xbgr.mr_n70638848)
print v(xbgr.mr_n70638960)
print v(xbgr.mr_n70639280)
print v(xbgr.mr_n70640144)
print v(xbgr.mr_n70640256)
print v(xbgr.mr_n70640576)
print v(xbgr.mr_n70640688)
print v(xbgr.mr_n70641008)
print v(xbgr.mr_n70641872)
print v(xbgr.mr_n70642304)
print v(xbgr.mr_n70642416)
print v(xbgr.mr_n70643168)
print v(xbgr.mr_n70643280)
print v(xbgr.mr_n70643600)
print v(xbgr.mr_n70643712)
print v(xbgr.mr_n70644032)
print v(xbgr.mr_n70644144)
print v(xbgr.mr_n70644464)
print v(xbgr.mr_n70644576)
print v(xbgr.mr_n70644896)
print v(xbgr.mr_n70645008)
print v(xbgr.mr_n70645328)
print v(xbgr.mr_n70645440)
print v(xbgr.mr_n70645760)
print v(xbgr.mr_n70645872)
print v(xbgr.mr_n70646192)
print v(xbgr.mr_n70646304)
print v(xbgr.mr_n70646624)
print v(xbgr.mr_n70646736)
print v(xbgr.mr_n70647056)
print v(xbgr.mr_n70647600)
print v(xbgr.mr_n70648352)
print v(xbgr.mr_n70649216)
print v(xbgr.mr_n70650080)
print v(xbgr.mr_n70650192)
print v(xbgr.mr_n70650624)
print v(xbgr.mr_n70650944)
print v(xbgr.mr_n70651808)
print v(xbgr.mr_n70652672)
print v(xbgr.mr_n70653536)
print v(xbgr.mr_n70654400)
print v(xbgr.mr_n70655264)
print v(xbgr.mr_n70656128)
print v(xbgr.mr_n70656240)
print v(xbgr.mr_n70656560)
print v(xbgr.mr_n70656672)
print v(xbgr.mr_n70656992)
print v(xbgr.mr_n70657856)
print v(xbgr.mr_n70658720)
print v(xbgr.mr_n70658832)
print v(xbgr.mr_n70659152)
print v(xbgr.mr_n70659264)
print v(xbgr.mr_n70659584)
print v(xbgr.mr_n70659696)
print v(xbgr.mr_n70660016)
print v(xbgr.mr_n70660128)
print v(xbgr.mr_n70660448)
print v(xbgr.mr_n70660560)
print v(xbgr.mr_n70660880)
print v(xbgr.mr_n70660992)
print v(xbgr.mr_n70661312)
print v(xbgr.mr_n70661424)
print v(xbgr.mr_n70661744)
print v(xbgr.mr_n70662608)
print v(xbgr.mr_n70662720)
print v(xbgr.mr_n70663040)
print v(xbgr.mr_n70663152)
print v(xbgr.mr_n70663472)
print v(xbgr.mr_n70663584)
print v(xbgr.mr_n70663904)
print v(xbgr.mr_n70664016)
print v(xbgr.mr_n70664336)
print v(xbgr.mr_n70664448)
print v(xbgr.mr_n70664768)
print v(xbgr.mr_n70664880)
print v(xbgr.mr_n70665200)
print v(xbgr.mr_n70665312)
print v(xbgr.mr_n70665632)
print v(xbgr.mr_n70665744)
print v(xbgr.mr_n70666176)
print v(xbgr.mr_n70666608)
print v(xbgr.mr_n70667040)
print v(xbgr.mr_n70667360)
print v(xbgr.mr_n70667472)
print v(xbgr.mr_n70667792)
print v(xbgr.mr_n70667904)
print v(xbgr.mr_n70668224)
print v(xbgr.mr_n70668336)
print v(xbgr.mr_n70668656)
print v(xbgr.mr_n70668768)
print v(xbgr.mr_n70669088)
print v(xbgr.mr_n70669200)
print v(xbgr.mr_n70669520)
print v(xbgr.mr_n70669632)
print v(xbgr.mr_n70669952)
print v(xbgr.mr_n70670064)
print v(xbgr.mr_n70670384)
print v(xbgr.mr_n70670496)
print v(xbgr.mr_n70670816)
print v(xbgr.mr_n70670928)
print v(xbgr.mr_n70671248)
print v(xbgr.mr_n70671360)
print v(xbgr.mr_n70671680)
print v(xbgr.mr_n70671792)
print v(xbgr.mr_n70672112)
print v(xbgr.mr_n70672224)
print v(xbgr.mr_n70672544)
print v(xbgr.mr_n70672656)
print v(xbgr.mr_n70672976)
print v(xbgr.mr_n70673088)
print v(xbgr.mr_n70673408)
print v(xbgr.mr_n70673520)
print v(xbgr.mr_n70673840)
print v(xbgr.mr_n70673952)
print v(xbgr.mr_n70674384)
print v(xbgr.mr_n70674704)
print v(xbgr.mr_n70674816)
print v(xbgr.mr_n70675248)
print v(xbgr.mr_n70675680)
print v(xbgr.mr_n70676000)
print v(xbgr.mr_n70676112)
print v(xbgr.mr_n70676432)
print v(xbgr.mr_n70676544)
print v(xbgr.mr_n70676864)
print v(xbgr.mr_n70676976)
print v(xbgr.mr_n70677296)
print v(xbgr.mr_n70677408)
print v(xbgr.mr_n70677840)
print v(xbgr.mr_n70678272)
print v(xbgr.mr_n70678704)
print v(xbgr.mr_n70679136)
print v(xbgr.mr_n70679568)
print v(xbgr.mr_n70680000)
print v(xbgr.mr_n70680432)
print v(xbgr.mr_n70680864)
print v(xbgr.mr_n70681184)
print v(xbgr.mr_n70681296)
print v(xbgr.mr_n70681616)
print v(xbgr.mr_n70681728)
print v(xbgr.mr_n70682048)
print v(xbgr.mr_n70682160)
print v(xbgr.mr_n70682480)
print v(xbgr.mr_n70682592)
print v(xbgr.mr_n70682912)
print v(xbgr.mr_n70683024)
print v(xbgr.mr_n70683344)
print v(xbgr.mr_n70683456)
print v(xbgr.mr_n70683776)
print v(xbgr.mr_n70683888)
print v(xbgr.mr_n70684208)
print v(xbgr.mr_n70684320)
print v(xbgr.mr_n70684640)
print v(xbgr.mr_n70684752)
print v(xbgr.mr_n70685072)
print v(xbgr.mr_n70685184)
print v(xbgr.mr_n70685504)
print v(xbgr.mr_n70685616)
print v(xbgr.mr_n70685936)
print v(xbgr.mr_n70686048)
print v(xbgr.mr_n70686368)
print v(xbgr.mr_n70686480)
print v(xbgr.mr_n70686800)
print v(xbgr.mr_n70686912)
print v(xbgr.mr_n70687232)
print v(xbgr.mr_n70687344)
print v(xbgr.mr_n70687664)
print v(xbgr.mr_n70687776)
print v(xbgr.mr_n70688096)
print v(xbgr.mr_n70688208)
print v(xbgr.mr_n70688528)
print v(xbgr.mr_n70688640)
print v(xbgr.mr_n70688960)
print v(xbgr.mr_n70689072)
print v(xbgr.mr_n70689392)
print v(xbgr.mr_n70689504)
print v(xbgr.mr_n70689824)
print v(xbgr.mr_n70689936)
print v(xbgr.mr_n70690256)
print v(xbgr.mr_n70690368)
print v(xbgr.mr_n70690688)
print v(xbgr.mr_n70690800)
print v(xbgr.mr_n70691120)
print v(xbgr.mr_n70691232)
print v(xbgr.mr_n70691664)
print v(xbgr.mr_n70692096)
print v(xbgr.mr_n70692416)
print v(xbgr.mr_n70692528)
print v(xbgr.mr_n70692848)
print v(xbgr.mr_n70692960)
print v(xbgr.mr_n70693392)
print v(xbgr.mr_n70693824)
print v(xbgr.mr_n70694256)
print v(xbgr.mr_n70694688)
print v(xbgr.mr_n70695120)
print v(xbgr.mr_n70695552)
print v(xbgr.mr_n70695984)
print v(xbgr.mr_n70696416)
print v(xbgr.mr_n70696848)
print v(xbgr.mr_n70697280)
print v(xbgr.mr_n70697712)
print v(xbgr.mr_n70698144)
print v(xbgr.mr_n70698576)
print v(xbgr.mr_n70699008)
print v(xbgr.mr_n70699440)
print v(xbgr.mr_n70699872)
print v(xbgr.mr_n70700304)
print v(xbgr.mr_n70700736)
print v(xbgr.mr_n70701168)
print v(xbgr.mr_n70701600)
print v(xbgr.mr_n70702032)
print v(xbgr.mr_n70702464)
print v(xbgr.mr_n70702896)
print v(xbgr.mr_n70703328)
print v(xbgr.mr_n70703648)
print v(xbgr.mr_n70703760)
print v(xbgr.mr_n70704080)
print v(xbgr.mr_n70704192)
print v(xbgr.mr_n70704512)
print v(xbgr.mr_n70704624)
print v(xbgr.mr_n70704944)
print v(xbgr.mr_n70705056)
print v(xbgr.mr_n70705376)
print v(xbgr.mr_n70705488)
print v(xbgr.mr_n70705808)
print v(xbgr.mr_n70705920)
print v(xbgr.mr_n70706240)
print v(xbgr.mr_n70706352)
print v(xbgr.mr_n70706672)
print v(xbgr.mr_n70706784)
print v(xbgr.mr_n70707104)
print v(xbgr.mr_n70707216)
print v(xbgr.mr_n70707536)
print v(xbgr.mr_n70707648)
print v(xbgr.mr_n70707968)
print v(xbgr.mr_n70708080)
print v(xbgr.mr_n70708400)
print v(xbgr.mr_n70708512)
print v(xbgr.mr_n70708832)
print v(xbgr.mr_n70708944)
print v(xbgr.mr_n70709376)
print v(xbgr.mr_n70709808)
print v(xbgr.mr_n70710240)
print v(xbgr.mr_n70710672)
print v(xbgr.mr_n70711104)
print v(xbgr.mr_n70711536)
print v(xbgr.mr_n70711968)
print v(xbgr.mr_n70712400)
print v(xbgr.mr_n70712832)
print v(xbgr.mr_n70713264)
print v(xbgr.mr_n70713696)
print v(xbgr.mr_n70714128)
print v(xbgr.mr_n70714560)
print v(xbgr.mr_n70714880)
print v(xbgr.mr_n70714992)
print v(xbgr.mr_n70715312)
print v(xbgr.mr_n70715424)
print v(xbgr.mr_n70715744)
print v(xbgr.mr_n70715856)
print v(xbgr.mr_n70716176)
print v(xbgr.mr_n70716288)
print v(xbgr.mr_n70716608)
print v(xbgr.mr_n70716720)
print v(xbgr.mr_n70717040)
print v(xbgr.mr_n70717152)
print v(xbgr.mr_n70717472)
print v(xbgr.mr_n70717584)
print v(xbgr.mr_n70717904)
print v(xbgr.mr_n70718016)
print v(xbgr.mr_n70718336)
print v(xbgr.mr_n70718448)
print v(xbgr.mr_n70718768)
print v(xbgr.mr_n70718880)
print v(xbgr.mr_n70719200)
print v(xbgr.mr_n70719312)
print v(xbgr.mr_n70719632)
print v(xbgr.mr_n70719744)
print v(xbgr.mr_n70720064)
print v(xbgr.mr_n70720176)
print v(xbgr.mr_n70720608)
print v(xbgr.mr_n70721040)
print v(xbgr.mr_n70721472)
print v(xbgr.mr_n70721904)
print v(xbgr.mr_n70722336)
print v(xbgr.mr_n70722768)
print v(xbgr.mr_n70723200)
print v(xbgr.mr_n70723632)
print v(xbgr.mr_n70724064)
print v(xbgr.mr_n70724496)
print v(xbgr.mr_n70724928)
print v(xbgr.mr_n70725360)
print v(xbgr.mr_n70725792)
print v(xbgr.mr_n70726112)
print v(xbgr.mr_n70726224)
print v(xbgr.mr_n70726544)
print v(xbgr.mr_n70726656)
print v(xbgr.mr_n70726976)
print v(xbgr.mr_n70727088)
print v(xbgr.mr_n70727408)
print v(xbgr.mr_n70727520)
print v(xbgr.mr_n70727840)
print v(xbgr.mr_n70727952)
print v(xbgr.mr_n70728272)
print v(xbgr.mr_n70728384)
print v(xbgr.mr_n70728704)
print v(xbgr.mr_n70728816)
print v(xbgr.mr_n70729136)
print v(xbgr.mr_n70729248)
print v(xbgr.mr_n70729568)
print v(xbgr.mr_n70729680)
print v(xbgr.mr_n70730000)
print v(xbgr.mr_n70730112)
print v(xbgr.mr_n70730432)
print v(xbgr.mr_n70730544)
print v(xbgr.mr_n70730864)
print v(xbgr.mr_n70730976)
print v(xbgr.mr_n70731296)
print v(xbgr.mr_n70731408)
print v(xbgr.mr_n70731840)
print v(xbgr.mr_n70732272)
print v(xbgr.mr_n70732704)
print v(xbgr.mr_n70733136)
print v(xbgr.mr_n70733568)
print v(xbgr.mr_n70734000)
print v(xbgr.mr_n70734432)
print v(xbgr.mr_n70734864)
print v(xbgr.mr_n70735296)
print v(xbgr.mr_n70735728)
print v(xbgr.mr_n70736160)
print v(xbgr.mr_n70736592)
print v(xbgr.mr_n70737024)
print v(xbgr.mr_n70737344)
print v(xbgr.mr_n70737456)
print v(xbgr.mr_n70737776)
print v(xbgr.mr_n70737888)
print v(xbgr.mr_n70738208)
print v(xbgr.mr_n70738320)
print v(xbgr.mr_n70738640)
print v(xbgr.mr_n70738752)
print v(xbgr.mr_n70739072)
print v(xbgr.mr_n70739184)
print v(xbgr.mr_n70739504)
print v(xbgr.mr_n70739616)
print v(xbgr.mr_n70739936)
print v(xbgr.mr_n70740048)
print v(xbgr.mr_n70740480)
print v(xbgr.mr_n70740912)
print v(xbgr.mr_n70741344)
print v(xbgr.mr_n70741776)
print v(xbgr.mr_n70742096)
print v(xbgr.mr_n70742208)
print v(xbgr.mr_n70742528)
print v(xbgr.mr_n70742640)
print v(xbgr.mr_n70742960)
print v(xbgr.mr_n70743072)
print v(xbgr.mr_n70743392)
print v(xbgr.mr_n70743504)
print v(xbgr.mr_n70743824)
print v(xbgr.mr_n70743936)
print v(xbgr.mr_n70744256)
print v(xbgr.mr_n70744368)
print v(xbgr.mr_n70744800)
print v(xbgr.mr_n70745232)
print v(xbgr.mr_n70745664)
print v(xbgr.mr_n70746096)
print v(xbgr.mr_n70746528)
print v(xbgr.mr_n70746960)
print v(xbgr.mr_n70747392)
print v(xbgr.mr_n70747824)
print v(xbgr.mr_n70748256)
print v(xbgr.mr_n70748576)
print v(xbgr.mr_n70748688)
print v(xbgr.mr_n70749008)
print v(xbgr.mr_n70749120)
print v(xbgr.mr_n70749440)
print v(xbgr.mr_n70749552)
print v(xbgr.mr_n70749872)
print v(xbgr.mr_n70749984)
print v(xbgr.mr_n70750304)
print v(xbgr.mr_n70750416)
print v(xbgr.mr_n70750736)
print v(xbgr.mr_n70750848)
print v(xbgr.mr_n70751168)
print v(xbgr.mr_n70751280)
print v(xbgr.mr_n70751600)
print v(xbgr.mr_n70751712)
print v(xbgr.mr_n70752032)
print v(xbgr.mr_n70752144)
print v(xbgr.mr_n70752464)
print v(xbgr.mr_n70752576)
print v(xbgr.mr_n70752896)
print v(xbgr.mr_n70753008)
print v(xbgr.mr_n70753328)
print v(xbgr.mr_n70753440)
print v(xbgr.mr_n70753760)
print v(xbgr.mr_n70753872)
print v(xbgr.mr_n70754192)
print v(xbgr.mr_n70754304)
print v(xbgr.mr_n70754736)
print v(xbgr.mr_n70755168)
print v(xbgr.mr_n70755600)
print v(xbgr.mr_n70756032)
print v(xbgr.mr_n70756352)
print v(xbgr.mr_n70756464)
print v(xbgr.mr_n70756784)
print v(xbgr.mr_n70756896)
print v(xbgr.mr_n70757328)
print v(xbgr.mr_n70757760)
print v(xbgr.mr_n70758192)
print v(xbgr.mr_n70758624)
print v(xbgr.mr_n70759056)
print v(xbgr.mr_n70759488)
print v(xbgr.mr_n70759920)
print v(xbgr.mr_n70760352)
print v(xbgr.mr_n70760672)
print v(xbgr.mr_n70760784)
print v(xbgr.mr_n70761104)
print v(xbgr.mr_n70761216)
print v(xbgr.mr_n70761536)
print v(xbgr.mr_n70761648)
print v(xbgr.mr_n70761968)
print v(xbgr.mr_n70762080)
print v(xbgr.mr_n70762400)
print v(xbgr.mr_n70762512)
print v(xbgr.mr_n70762832)
print v(xbgr.mr_n70762944)
print v(xbgr.mr_n70763264)
print v(xbgr.mr_n70763376)
print v(xbgr.mr_n70763696)
print v(xbgr.mr_n70763808)
print v(xbgr.mr_n70764128)
print v(xbgr.mr_n70764240)
print v(xbgr.mr_n70764560)
print v(xbgr.mr_n70764672)
print v(xbgr.mr_n70764992)
print v(xbgr.mr_n70765104)
print v(xbgr.mr_n70765424)
print v(xbgr.mr_n70765536)
print v(xbgr.mr_n70765968)
print v(xbgr.mr_n70766400)
print v(xbgr.mr_n70766832)
print v(xbgr.mr_n70767264)
print v(xbgr.mr_n70767696)
print v(xbgr.mr_n70768128)
print v(xbgr.mr_n70768448)
print v(xbgr.mr_n70768560)
print v(xbgr.mr_n70768880)
print v(xbgr.mr_n70768992)
print v(xbgr.mr_n70769312)
print v(xbgr.mr_n70769424)
print v(xbgr.mr_n70769744)
print v(xbgr.mr_n70769856)
print v(xbgr.mr_n70770176)
print v(xbgr.mr_n70770288)
print v(xbgr.mr_n70770608)
print v(xbgr.mr_n70770720)
print v(xbgr.mr_n70771040)
print v(xbgr.mr_n70771152)
print v(xbgr.mr_n70771472)
print v(xbgr.mr_n70771584)
print v(xbgr.mr_n70771904)
print v(xbgr.mr_n70772016)
print v(xbgr.mr_n70772336)
print v(xbgr.mr_n70772448)
print v(xbgr.mr_n70772768)
print v(xbgr.mr_n70772880)
print v(xbgr.mr_n70773200)
print v(xbgr.mr_n70773312)
print v(xbgr.mr_n70773632)
print v(xbgr.mr_n70773744)
print v(xbgr.mr_n70774064)
print v(xbgr.mr_n70774176)
print v(xbgr.mr_n70774496)
print v(xbgr.mr_n70774608)
print v(xbgr.mr_n70774928)
print v(xbgr.mr_n70775040)
print v(xbgr.mr_n70775360)
print v(xbgr.mr_n70775472)
print v(xbgr.mr_n70775792)
print v(xbgr.mr_n70775904)
print v(xbgr.mr_n70776336)
print v(xbgr.mr_n70776768)
print v(xbgr.mr_n70777088)
print v(xbgr.mr_n70777200)
print v(xbgr.mr_n70777520)
print v(xbgr.mr_n70777632)
print v(xbgr.mr_n70777952)
print v(xbgr.mr_n70778064)
print v(xbgr.mr_n70778384)
print v(xbgr.mr_n70778496)
print v(xbgr.mr_n70778928)
print v(xbgr.mr_n70779360)
print v(xbgr.mr_n70779792)
print v(xbgr.mr_n70780224)
print v(xbgr.mr_n70780656)
print v(xbgr.mr_n70781088)
print v(xbgr.mr_n70781520)
print v(xbgr.mr_n70781952)
print v(xbgr.mr_n70782384)
print v(xbgr.mr_n70782816)
print v(xbgr.mr_n70783248)
print v(xbgr.mr_n70783680)
print v(xbgr.mr_n70784112)
print v(xbgr.mr_n70784544)
print v(xbgr.mr_n70784976)
print v(xbgr.mr_n70785408)
print v(xbgr.mr_n70785728)
print v(xbgr.mr_n70785840)
print v(xbgr.mr_n70786160)
print v(xbgr.mr_n70786272)
print v(xbgr.mr_n70786592)
print v(xbgr.mr_n70786704)
print v(xbgr.mr_n70787024)
print v(xbgr.mr_n70787136)
print v(xbgr.mr_n70787456)
print v(xbgr.mr_n70787568)
print v(xbgr.mr_n70787888)
print v(xbgr.mr_n70788000)
print v(xbgr.mr_n70788320)
print v(xbgr.mr_n70788432)
print v(xbgr.mr_n70788752)
print v(xbgr.mr_n70788864)
print v(xbgr.mr_n70789184)
print v(xbgr.mr_n70789296)
print v(xbgr.mr_n70789616)
print v(xbgr.mr_n70789728)
print v(xbgr.mr_n70790160)
print v(xbgr.mr_n70790592)
print v(xbgr.mr_n70791024)
print v(xbgr.mr_n70791456)
print v(xbgr.mr_n70791888)
print v(xbgr.mr_n70792320)
print v(xbgr.mr_n70792752)
print v(xbgr.mr_n70793184)
print v(xbgr.mr_n70793504)
print v(xbgr.mr_n70793616)
print v(xbgr.mr_n70793936)
print v(xbgr.mr_n70794048)
print v(xbgr.mr_n70794368)
print v(xbgr.mr_n70794480)
print v(xbgr.mr_n70794800)
print v(xbgr.mr_n70794912)
print v(xbgr.mr_n70795232)
print v(xbgr.mr_n70795344)
print v(xbgr.mr_n70795664)
print v(xbgr.mr_n70795776)
print v(xbgr.mr_n70796096)
print v(xbgr.mr_n70796208)
print v(xbgr.mr_n70796528)
print v(xbgr.mr_n70796640)
print v(xbgr.mr_n70796960)
print v(xbgr.mr_n70797072)
print v(xbgr.mr_n70797392)
print v(xbgr.mr_n70797504)
print v(xbgr.mr_n70797824)
print v(xbgr.mr_n70797936)
print v(xbgr.mr_n70798256)
print v(xbgr.mr_n70798368)
print v(xbgr.mr_n70798688)
print v(xbgr.mr_n70798800)
print v(xbgr.mr_n70799120)
print v(xbgr.mr_n70799232)
print v(xbgr.mr_n70799664)
print v(xbgr.mr_n70800096)
print v(xbgr.mr_n70800528)
print v(xbgr.mr_n70800960)
print v(xbgr.mr_n70801392)
print v(xbgr.mr_n70801824)
print v(xbgr.mr_n70802256)
print v(xbgr.mr_n70802688)
print v(xbgr.mr_n70803120)
print v(xbgr.mr_n70803552)
print v(xbgr.mr_n70803984)
print v(xbgr.mr_n70804416)
print v(xbgr.mr_n70804848)
print v(xbgr.mr_n70805280)
print v(xbgr.mr_n70805600)
print v(xbgr.mr_n70805712)
print v(xbgr.mr_n70806032)
print v(xbgr.mr_n70806144)
print v(xbgr.mr_n70806464)
print v(xbgr.mr_n70806576)
print v(xbgr.mr_n70806896)
print v(xbgr.mr_n70807008)
print v(xbgr.mr_n70807328)
print v(xbgr.mr_n70807440)
print v(xbgr.mr_n70807760)
print v(xbgr.mr_n70807872)
print v(xbgr.mr_n70808192)
print v(xbgr.mr_n70808304)
print v(xbgr.mr_n70808624)
print v(xbgr.mr_n70808736)
print v(xbgr.mr_n70809056)
print v(xbgr.mr_n70809168)
print v(xbgr.mr_n70809488)
print v(xbgr.mr_n70809600)
print v(xbgr.mr_n70809920)
print v(xbgr.mr_n70810032)
print v(xbgr.mr_n70810352)
print v(xbgr.mr_n70810464)
print v(xbgr.mr_n70810784)
print v(xbgr.mr_n70810896)
print v(xbgr.mr_n70811216)
print v(xbgr.mr_n70811328)
print v(xbgr.mr_n70811648)
print v(xbgr.mr_n70811760)
print v(xbgr.mr_n70812080)
print v(xbgr.mr_n70812192)
print v(xbgr.mr_n70812512)
print v(xbgr.mr_n70812624)
print v(xbgr.mr_n70812944)
print v(xbgr.mr_n70813056)
print v(xbgr.mr_n70813376)
print v(xbgr.mr_n70813488)
print v(xbgr.mr_n70813808)
print v(xbgr.mr_n70813920)
print v(xbgr.mr_n70814240)
print v(xbgr.mr_n70814352)
print v(xbgr.mr_n70814672)
print v(xbgr.mr_n70814784)
print v(xbgr.mr_n70815104)
print v(xbgr.mr_n70815216)
print v(xbgr.mr_n70815536)
print v(xbgr.mr_n70815648)
print v(xbgr.mr_n70816080)
print v(xbgr.mr_n70816512)
print v(xbgr.mr_n70816944)
print v(xbgr.mr_n70817376)
print v(xbgr.mr_n70817808)
print v(xbgr.mr_n70818240)
print v(xbgr.mr_n70818672)
print v(xbgr.mr_n70819104)
print v(xbgr.mr_n70819536)
print v(xbgr.mr_n70819968)
print v(xbgr.mr_n70820400)
print v(xbgr.mr_n70820832)
print v(xbgr.mr_n70821264)
print v(xbgr.mr_n70821696)
print v(xbgr.mr_n70822128)
print v(xbgr.mr_n70822560)
print v(xbgr.mr_n70822880)
print v(xbgr.mr_n70822992)
print v(xbgr.mr_n70823312)
print v(xbgr.mr_n70823424)
print v(xbgr.mr_n70823856)
print v(xbgr.mr_n70824288)
print v(xbgr.mr_n70824720)
print v(xbgr.mr_n70825152)
print v(xbgr.mr_n70825584)
print v(xbgr.mr_n70826016)
print v(xbgr.mr_n70826448)
print v(xbgr.mr_n70826880)
print v(xbgr.mr_n70827312)
print v(xbgr.mr_n70827744)
print v(xbgr.mr_n70828064)
print v(xbgr.mr_n70828176)
print v(xbgr.mr_n70828496)
print v(xbgr.mr_n70828608)
print v(xbgr.mr_n70828928)
print v(xbgr.mr_n70829040)
print v(xbgr.mr_n70829360)
print v(xbgr.mr_n70829472)
print v(xbgr.mr_n70829792)
print v(xbgr.mr_n70829904)
print v(xbgr.mr_n70830224)
print v(xbgr.mr_n70830336)
print v(xbgr.mr_n70830656)
print v(xbgr.mr_n70830768)
print v(xbgr.mr_n70831088)
print v(xbgr.mr_n70831200)
print v(xbgr.mr_n70831520)
print v(xbgr.mr_n70831632)
print v(xbgr.mr_n70831952)
print v(xbgr.mr_n70832064)
print v(xbgr.mr_n70832384)
print v(xbgr.mr_n70832496)
print v(xbgr.mr_n70832816)
print v(xbgr.mr_n70832928)
print v(xbgr.mr_n70833248)
print v(xbgr.mr_n70833360)
print v(xbgr.mr_n70833792)
print v(xbgr.mr_n70834224)
print v(xbgr.mr_n70834656)
print v(xbgr.mr_n70835088)
print v(xbgr.mr_n70835520)
print v(xbgr.mr_n70835952)
print v(xbgr.mr_n70836384)
print v(xbgr.mr_n70836816)
print v(xbgr.mr_n70837248)
print v(xbgr.mr_n70837680)
print v(xbgr.mr_n70838112)
print v(xbgr.mr_n70838544)
print v(xbgr.mr_n70838976)
print v(xbgr.mr_n70839296)
print v(xbgr.mr_n70839408)
print v(xbgr.mr_n70839728)
print v(xbgr.mr_n70839840)
print v(xbgr.mr_n70840160)
print v(xbgr.mr_n70840272)
print v(xbgr.mr_n70840592)
print v(xbgr.mr_n70840704)
print v(xbgr.mr_n70841024)
print v(xbgr.mr_n70841136)
print v(xbgr.mr_n70841456)
print v(xbgr.mr_n70841568)
print v(xbgr.mr_n70841888)
print v(xbgr.mr_n70842000)
print v(xbgr.mr_n70842320)
print v(xbgr.mr_n70842432)
print v(xbgr.mr_n70842752)
print v(xbgr.mr_n70842864)
print v(xbgr.mr_n70843184)
print v(xbgr.mr_n70843296)
print v(xbgr.mr_n70843616)
print v(xbgr.mr_n70843728)
print v(xbgr.mr_n70844048)
print v(xbgr.mr_n70844160)
print v(xbgr.mr_n70844480)
print v(xbgr.mr_n70844592)
print v(xbgr.mr_n70845024)
print v(xbgr.mr_n70845456)
print v(xbgr.mr_n70845888)
print v(xbgr.mr_n70846320)
print v(xbgr.mr_n70846752)
print v(xbgr.mr_n70847184)
print v(xbgr.mr_n70847616)
print v(xbgr.mr_n70848048)
print v(xbgr.mr_n70848480)
print v(xbgr.mr_n70848912)
print v(xbgr.mr_n70849344)
print v(xbgr.mr_n70849776)
print v(xbgr.mr_n70850208)
print v(xbgr.mr_n70850528)
print v(xbgr.mr_n70850640)
print v(xbgr.mr_n70850960)
print v(xbgr.mr_n70851072)
print v(xbgr.mr_n70851392)
print v(xbgr.mr_n70851504)
print v(xbgr.mr_n70851824)
print v(xbgr.mr_n70851936)
print v(xbgr.mr_n70852256)
print v(xbgr.mr_n70852368)
print v(xbgr.mr_n70852688)
print v(xbgr.mr_n70852800)
print v(xbgr.mr_n70853120)
print v(xbgr.mr_n70853232)
print v(xbgr.mr_n70853552)
print v(xbgr.mr_n70853664)
print v(xbgr.mr_n70853984)
print v(xbgr.mr_n70854096)
print v(xbgr.mr_n70854416)
print v(xbgr.mr_n70854528)
print v(xbgr.mr_n70854848)
print v(xbgr.mr_n70854960)
print v(xbgr.mr_n70855280)
print v(xbgr.mr_n70855392)
print v(xbgr.mr_n70855712)
print v(xbgr.mr_n70855824)
print v(xbgr.mr_n70856256)
print v(xbgr.mr_n70856688)
print v(xbgr.mr_n70857120)
print v(xbgr.mr_n70857552)
print v(xbgr.mr_n70857984)
print v(xbgr.mr_n70858416)
print v(xbgr.mr_n70858848)
print v(xbgr.mr_n70859280)
print v(xbgr.mr_n70859712)
print v(xbgr.mr_n70860144)
print v(xbgr.mr_n70860576)
print v(xbgr.mr_n70861008)
print v(xbgr.mr_n70861440)
print v(xbgr.mr_n70861760)
print v(xbgr.mr_n70861872)
print v(xbgr.mr_n70862192)
print v(xbgr.mr_n70862304)
print v(xbgr.mr_n70862624)
print v(xbgr.mr_n70862736)
print v(xbgr.mr_n70863056)
print v(xbgr.mr_n70863168)
print v(xbgr.mr_n70863488)
print v(xbgr.mr_n70863600)
print v(xbgr.mr_n70863920)
print v(xbgr.mr_n70864032)
print v(xbgr.mr_n70864352)
print v(xbgr.mr_n70864464)
print v(xbgr.mr_n70864784)
print v(xbgr.mr_n70864896)
print v(xbgr.mr_n70865216)
print v(xbgr.mr_n70865328)
print v(xbgr.mr_n70865648)
print v(xbgr.mr_n70865760)
print v(xbgr.mr_n70866080)
print v(xbgr.mr_n70866192)
print v(xbgr.mr_n70866512)
print v(xbgr.mr_n70866624)
print v(xbgr.mr_n70866944)
print v(xbgr.mr_n70867056)
print v(xbgr.mr_n70867488)
print v(xbgr.mr_n70867920)
print v(xbgr.mr_n70868352)
print v(xbgr.mr_n70868784)
print v(xbgr.mr_n70869216)
print v(xbgr.mr_n70869648)
print v(xbgr.mr_n70870080)
print v(xbgr.mr_n70870512)
print v(xbgr.mr_n70870944)
print v(xbgr.mr_n70871376)
print v(xbgr.mr_n70871808)
print v(xbgr.mr_n70872240)
print v(xbgr.mr_n70872672)
print v(xbgr.mr_n70872992)
print v(xbgr.mr_n70873104)
print v(xbgr.mr_n70873424)
print v(xbgr.mr_n70873536)
print v(xbgr.mr_n70873856)
print v(xbgr.mr_n70873968)
print v(xbgr.mr_n70874288)
print v(xbgr.mr_n70874400)
print v(xbgr.mr_n70874720)
print v(xbgr.mr_n70874832)
print v(xbgr.mr_n70875264)
print v(xbgr.mr_n70875696)
print v(xbgr.mr_n70876128)
print v(xbgr.mr_n70876560)
print v(xbgr.mr_n70876992)
print v(xbgr.mr_n70877312)
print v(xbgr.mr_n70877424)
print v(xbgr.mr_n70877744)
print v(xbgr.mr_n70877856)
print v(xbgr.mr_n70878176)
print v(xbgr.mr_n70878288)
print v(xbgr.mr_n70878608)
print v(xbgr.mr_n70878720)
print v(xbgr.mr_n70879040)
print v(xbgr.mr_n70879152)
print v(xbgr.mr_n70879472)
print v(xbgr.mr_n70879584)
print v(xbgr.mr_n70879904)
print v(xbgr.mr_n70880016)
print v(xbgr.mr_n70880336)
print v(xbgr.mr_n70880448)
print v(xbgr.mr_n70880880)
print v(xbgr.mr_n70881312)
print v(xbgr.mr_n70881744)
print v(xbgr.mr_n70882176)
print v(xbgr.mr_n70882608)
print v(xbgr.mr_n70883040)
print v(xbgr.mr_n70883472)
print v(xbgr.mr_n70883904)
print v(xbgr.mr_n70884224)
print v(xbgr.mr_n70884336)
print v(xbgr.mr_n70884656)
print v(xbgr.mr_n70884768)
print v(xbgr.mr_n70885088)
print v(xbgr.mr_n70885200)
print v(xbgr.mr_n70885520)
print v(xbgr.mr_n70885632)
print v(xbgr.mr_n70885952)
print v(xbgr.mr_n70886064)
print v(xbgr.mr_n70886384)
print v(xbgr.mr_n70886496)
print v(xbgr.mr_n70886816)
print v(xbgr.mr_n70886928)
print v(xbgr.mr_n70887248)
print v(xbgr.mr_n70887360)
print v(xbgr.mr_n70887792)
print v(xbgr.mr_n70888224)
print v(xbgr.mr_n70888656)
print v(xbgr.mr_n70889088)
print v(xbgr.mr_n70889520)
print v(xbgr.mr_n70889840)
print v(xbgr.mr_n70889952)
print v(xbgr.mr_n70890272)
print v(xbgr.mr_n70890384)
print v(xbgr.mr_n70890704)
print v(xbgr.mr_n70890816)
print v(xbgr.mr_n70891136)
print v(xbgr.mr_n70891248)
print v(xbgr.mr_n70891568)
print v(xbgr.mr_n70891680)
print v(xbgr.mr_n70892112)
print v(xbgr.mr_n70892544)
print v(xbgr.mr_n70892976)
print v(xbgr.mr_n70893408)
print v(xbgr.mr_n70893840)
print v(xbgr.mr_n70894272)
print v(xbgr.mr_n70894704)
print v(xbgr.mr_n70895136)
print v(xbgr.mr_n70895456)
print v(xbgr.mr_n70895568)
print v(xbgr.mr_n70895888)
print v(xbgr.mr_n70896000)
print v(xbgr.mr_n70896320)
print v(xbgr.mr_n70896432)
print v(xbgr.mr_n70896752)
print v(xbgr.mr_n70896864)
print v(xbgr.mr_n70897184)
print v(xbgr.mr_n70897296)
print v(xbgr.mr_n70897616)
print v(xbgr.mr_n70897728)
print v(xbgr.mr_n70898048)
print v(xbgr.mr_n70898160)
print v(xbgr.mr_n70898592)
print v(xbgr.mr_n70899024)
print v(xbgr.mr_n70899456)
print v(xbgr.mr_n70899888)
print v(xbgr.mr_n70900208)
print v(xbgr.mr_n70900320)
print v(xbgr.mr_n70900752)
print v(xbgr.mr_n70901184)
print v(xbgr.mr_n70901504)
print v(xbgr.mr_n70901616)
print v(xbgr.mr_n70901936)
print v(xbgr.mr_n70902048)
print v(xbgr.mr_n70902368)
print v(xbgr.mr_n70902480)
print v(xbgr.mr_n70902800)
print v(xbgr.mr_n70902912)
print v(xbgr.mr_n70903232)
print v(xbgr.mr_n70903344)
print v(xbgr.mr_n70903776)
print v(xbgr.mr_n70904208)
print v(xbgr.mr_n70904640)
print v(xbgr.mr_n70905072)
print v(xbgr.mr_n70905504)
print v(xbgr.mr_n70905936)
print v(xbgr.mr_n70906368)
print v(xbgr.mr_n70906688)
print v(xbgr.mr_n70906800)
print v(xbgr.mr_n70907120)
print v(xbgr.mr_n70907232)
print v(xbgr.mr_n70907552)
print v(xbgr.mr_n70907664)
print v(xbgr.mr_n70907984)
print v(xbgr.mr_n70908096)
print v(xbgr.mr_n70908416)
print v(xbgr.mr_n70908528)
print v(xbgr.mr_n70908848)
print v(xbgr.mr_n70908960)
print v(xbgr.mr_n70909280)
print v(xbgr.mr_n70909392)
print v(xbgr.mr_n70909712)
print v(xbgr.mr_n70909824)
print v(xbgr.mr_n70910144)
print v(xbgr.mr_n70910256)
print v(xbgr.mr_n70910576)
print v(xbgr.mr_n70910688)
print v(xbgr.mr_n70911008)
print v(xbgr.mr_n70911120)
print v(xbgr.mr_n70911440)
print v(xbgr.mr_n70911552)
print v(xbgr.mr_n70911872)
print v(xbgr.mr_n70911984)
print v(xbgr.mr_n70912416)
print v(xbgr.mr_n70912848)
print v(xbgr.mr_n70913280)
print v(xbgr.mr_n70913712)
print v(xbgr.mr_n70914144)
print v(xbgr.mr_n70914576)
print v(xbgr.mr_n70915008)
print v(xbgr.mr_n70915440)
print v(xbgr.mr_n70915872)
print v(xbgr.mr_n70916304)
print v(xbgr.mr_n70916736)
print v(xbgr.mr_n70917168)
print v(xbgr.mr_n70917600)
print v(xbgr.mr_n70917920)
print v(xbgr.mr_n70918032)
print v(xbgr.mr_n70918352)
print v(xbgr.mr_n70918464)
print v(xbgr.mr_n70918784)
print v(xbgr.mr_n70918896)
print v(xbgr.mr_n70919216)
print v(xbgr.mr_n70919328)
print v(xbgr.mr_n70919648)
print v(xbgr.mr_n70919760)
print v(xbgr.mr_n70920080)
print v(xbgr.mr_n70920192)
print v(xbgr.mr_n70920512)
print v(xbgr.mr_n70920624)
print v(xbgr.mr_n70920944)
print v(xbgr.mr_n70921056)
print v(xbgr.mr_n70921376)
print v(xbgr.mr_n70921488)
print v(xbgr.mr_n70921808)
print v(xbgr.mr_n70921920)
print v(xbgr.mr_n70922240)
print v(xbgr.mr_n70922352)
print v(xbgr.mr_n70922672)
print v(xbgr.mr_n70922784)
print v(xbgr.mr_n70923104)
print v(xbgr.mr_n70923216)
print v(xbgr.mr_n70923536)
print v(xbgr.mr_n70923648)
print v(xbgr.mr_n70923968)
print v(xbgr.mr_n70924080)
print v(xbgr.mr_n70924400)
print v(xbgr.mr_n70924512)
print v(xbgr.mr_n70924944)
print v(xbgr.mr_n70925376)
print v(xbgr.mr_n70925808)
print v(xbgr.mr_n70926240)
print v(xbgr.mr_n70926672)
print v(xbgr.mr_n70927104)
print v(xbgr.mr_n70927424)
print v(xbgr.mr_n70927536)
print v(xbgr.mr_n70927856)
print v(xbgr.mr_n70927968)
print v(xbgr.mr_n70928288)
print v(xbgr.mr_n70928400)
print v(xbgr.mr_n70928720)
print v(xbgr.mr_n70928832)
print v(xbgr.mr_n70929152)
print v(xbgr.mr_n70929264)
print v(xbgr.mr_n70929584)
print v(xbgr.mr_n70929696)
print v(xbgr.mr_n70930016)
print v(xbgr.mr_n70930128)
print v(xbgr.mr_n70930448)
print v(xbgr.mr_n70930560)
print v(xbgr.mr_n70930880)
print v(xbgr.mr_n70930992)
print v(xbgr.mr_n70931312)
print v(xbgr.mr_n70931424)
print v(xbgr.mr_n70931856)
print v(xbgr.mr_n70932288)
print v(xbgr.mr_n70932720)
print v(xbgr.mr_n70933152)
print v(xbgr.mr_n70933584)
print v(xbgr.mr_n70934016)
print v(xbgr.mr_n70934448)
print v(xbgr.mr_n70934880)
print v(xbgr.mr_n70935312)
print v(xbgr.mr_n70935744)
print v(xbgr.mr_n70936176)
print v(xbgr.mr_n70936608)
print v(xbgr.mr_n70937040)
print v(xbgr.mr_n70937472)
print v(xbgr.mr_n70937904)
print v(xbgr.mr_n70938336)
print v(xbgr.mr_n70938768)
print v(xbgr.mr_n70939200)
print v(xbgr.mr_n70939632)
print v(xbgr.mr_n70940064)
print v(xbgr.mr_n70940384)
print v(xbgr.mr_n70940496)
print v(xbgr.mr_n70940816)
print v(xbgr.mr_n70940928)
print v(xbgr.mr_n70941248)
print v(xbgr.mr_n70941360)
print v(xbgr.mr_n70941680)
print v(xbgr.mr_n70941792)
print v(xbgr.mr_n70942112)
print v(xbgr.mr_n70942224)
print v(xbgr.mr_n70942544)
print v(xbgr.mr_n70942656)
print v(xbgr.mr_n70942976)
print v(xbgr.mr_n70943088)
print v(xbgr.mr_n70943408)
print v(xbgr.mr_n70943520)
print v(xbgr.mr_n70943840)
print v(xbgr.mr_n70943952)
print v(xbgr.mr_n70944272)
print v(xbgr.mr_n70944384)
print v(xbgr.mr_n70944704)
print v(xbgr.mr_n70944816)
print v(xbgr.mr_n70945136)
print v(xbgr.mr_n70945248)
print v(xbgr.mr_n70945568)
print v(xbgr.mr_n70945680)
print v(xbgr.mr_n70946000)
print v(xbgr.mr_n70946112)
print v(xbgr.mr_n70946544)
print v(xbgr.mr_n70946976)
print v(xbgr.mr_n70947408)
print v(xbgr.mr_n70947840)
print v(xbgr.mr_n70948160)
print v(xbgr.mr_n70948272)
print v(xbgr.mr_n70948592)
print v(xbgr.mr_n70948704)
print v(xbgr.mr_n70949024)
print v(xbgr.mr_n70949136)
print v(xbgr.mr_n70949456)
print v(xbgr.mr_n70949568)
print v(xbgr.mr_n70949888)
print v(xbgr.mr_n70950000)
print v(xbgr.mr_n70950320)
print v(xbgr.mr_n70950432)
print v(xbgr.mr_n70950864)
print v(xbgr.mr_n70951296)
print v(xbgr.mr_n70951728)
print v(xbgr.mr_n70952160)
print v(xbgr.mr_n70952592)
print v(xbgr.mr_n70953024)
print v(xbgr.mr_n70953456)
print v(xbgr.mr_n70953888)
print v(xbgr.mr_n70954320)
print v(xbgr.mr_n70954752)
print v(xbgr.mr_n70955072)
print v(xbgr.mr_n70955184)
print v(xbgr.mr_n70955504)
print v(xbgr.mr_n70955616)
print v(xbgr.mr_n70956048)
print v(xbgr.mr_n70956480)
print v(xbgr.mr_n70956800)
print v(xbgr.mr_n70956912)
print v(xbgr.mr_n70957232)
print v(xbgr.mr_n70957344)
print v(xbgr.mr_n70957664)
print v(xbgr.mr_n70957776)
print v(xbgr.mr_n70958096)
print v(xbgr.mr_n70958208)
print v(xbgr.mr_n70958640)
print v(xbgr.mr_n70959072)
print v(xbgr.mr_n70959504)
print v(xbgr.mr_n70959936)
print v(xbgr.mr_n70960368)
print v(xbgr.mr_n70960800)
print v(xbgr.mr_n70961232)
print v(xbgr.mr_n70961664)
print v(xbgr.mr_n70962096)
print v(xbgr.mr_n70962528)
print v(xbgr.mr_n70962848)
print v(xbgr.mr_n70962960)
print v(xbgr.mr_n70963280)
print v(xbgr.mr_n70963392)
print v(xbgr.mr_n70963712)
print v(xbgr.mr_n70963824)
print v(xbgr.mr_n70964144)
print v(xbgr.mr_n70964256)
print v(xbgr.mr_n70964576)
print v(xbgr.mr_n70964688)
print v(xbgr.mr_n70965008)
print v(xbgr.mr_n70965120)
print v(xbgr.mr_n70965440)
print v(xbgr.mr_n70965552)
print v(xbgr.mr_n70965872)
print v(xbgr.mr_n70965984)
print v(xbgr.mr_n70966304)
print v(xbgr.mr_n70966416)
print v(xbgr.mr_n70966736)
print v(xbgr.mr_n70966848)
print v(xbgr.mr_n70967168)
print v(xbgr.mr_n70967280)
print v(xbgr.mr_n70967600)
print v(xbgr.mr_n70967712)
print v(xbgr.mr_n70968032)
print v(xbgr.mr_n70968144)
print v(xbgr.mr_n70968464)
print v(xbgr.mr_n70968576)
print v(xbgr.mr_n70968896)
print v(xbgr.mr_n70969008)
print v(xbgr.mr_n70969328)
print v(xbgr.mr_n70969440)
print v(xbgr.mr_n70969760)
print v(xbgr.mr_n70969872)
print v(xbgr.mr_n70970192)
print v(xbgr.mr_n70970304)
print v(xbgr.mr_n70970624)
print v(xbgr.mr_n70970736)
print v(xbgr.mr_n70971056)
print v(xbgr.mr_n70971168)
print v(xbgr.mr_n70971488)
print v(xbgr.mr_n70971600)
print v(xbgr.mr_n70971920)
print v(xbgr.mr_n70972352)
print v(xbgr.mr_n70972464)
print v(xbgr.mr_n70972784)
print v(xbgr.mr_n70973216)
print v(xbgr.mr_n70973328)
print v(xbgr.mr_n70973648)
print v(xbgr.mr_n70974080)
print v(xbgr.mr_n70974192)
print v(xbgr.mr_n70974512)
print v(xbgr.mr_n70974944)
print v(xbgr.mr_n70975056)
print v(xbgr.mr_n70975376)
print v(xbgr.mr_n70975808)
print v(xbgr.mr_n70975920)
print v(xbgr.mr_n70976240)
print v(xbgr.mr_n70976352)
print v(xbgr.mr_n70976672)
print v(xbgr.mr_n70976784)
print v(xbgr.mr_n70977104)
print v(xbgr.mr_n70977216)
print v(xbgr.mr_n70977536)
print v(xbgr.mr_n70977648)
print v(xbgr.mr_n70977968)
print v(xbgr.mr_n70978080)
print v(xbgr.mr_n70978400)
print v(xbgr.mr_n70978512)
print v(xbgr.mr_n70978832)
print v(xbgr.mr_n70978944)
print v(xbgr.mr_n70979264)
print v(xbgr.mr_n70979376)
print v(xbgr.mr_n70979696)
print v(xbgr.mr_n70979808)
print v(xbgr.mr_n70980128)
print v(xbgr.mr_n70980240)
print v(xbgr.mr_n70980560)
print v(xbgr.mr_n70980672)
print v(xbgr.mr_n70980992)
print v(xbgr.mr_n70981104)
print v(xbgr.mr_n70981424)
print v(xbgr.mr_n70981536)
print v(xbgr.mr_n70981856)
print v(xbgr.mr_n70981968)
print v(xbgr.mr_n70982288)
print v(xbgr.mr_n70982400)
print v(xbgr.mr_n70982720)
print v(xbgr.mr_n70982832)
print v(xbgr.mr_n70983152)
print v(xbgr.mr_n70983264)
print v(xbgr.mr_n70983584)
print v(xbgr.mr_n70983696)
print v(xbgr.mr_n70984016)
print v(xbgr.mr_n70984128)
print v(xbgr.mr_n70984448)
print v(xbgr.mr_n70984560)
print v(xbgr.mr_n70984880)
print v(xbgr.mr_n70984992)
print v(xbgr.mr_n70985312)
print v(xbgr.mr_n70985424)
print v(xbgr.mr_n70985744)
print v(xbgr.mr_n70985856)
print v(xbgr.mr_n70986176)
print v(xbgr.mr_n70986288)
print v(xbgr.mr_n70986608)
print v(xbgr.mr_n70986720)
print v(xbgr.mr_n70987040)
print v(xbgr.mr_n70987152)
print v(xbgr.mr_n70987472)
print v(xbgr.mr_n70987584)
print v(xbgr.mr_n70987904)
print v(xbgr.mr_n70988016)
print v(xbgr.mr_n70988336)
print v(xbgr.mr_n70988448)
print v(xbgr.mr_n70988768)
print v(xbgr.mr_n70988880)
print v(xbgr.mr_n70989200)
print v(xbgr.mr_n70989312)
print v(xbgr.mr_n70989632)
print v(xbgr.mr_n70989744)
print v(xbgr.mr_n70990064)
print v(xbgr.mr_n70990176)
print v(xbgr.mr_n70990496)
print v(xbgr.mr_n70990608)
print v(xbgr.mr_n70990928)
print v(xbgr.mr_n70991040)
print v(xbgr.mr_n70991360)
print v(xbgr.mr_n70991472)
print v(xbgr.mr_n70991792)
print v(xbgr.mr_n70991904)
print v(xbgr.mr_n70992224)
print v(xbgr.mr_n70992336)
print v(xbgr.mr_n70992656)
print v(xbgr.mr_n70992768)
print v(xbgr.mr_n70993088)
print v(xbgr.mr_n70993200)
print v(xbgr.mr_n70993520)
print v(xbgr.mr_n70993632)
print v(xbgr.mr_n70993952)
print v(xbgr.mr_n70994064)
print v(xbgr.mr_n70994384)
print v(xbgr.mr_n70994496)
print v(xbgr.mr_n70994816)
print v(xbgr.mr_n70994928)
print v(xbgr.mr_n70995248)
print v(xbgr.mr_n70995360)
print v(xbgr.mr_n70995680)
print v(xbgr.mr_n70995792)
print v(xbgr.mr_n70996112)
print v(xbgr.mr_n70996224)
print v(xbgr.mr_n70996544)
print v(xbgr.mr_n70996656)
print v(xbgr.mr_n70996976)
print v(xbgr.mr_n70997088)
print v(xbgr.mr_n70997408)
print v(xbgr.mr_n70997520)
print v(xbgr.mr_n70997840)
print v(xbgr.mr_n70997952)
print v(xbgr.mr_n70998272)
print v(xbgr.mr_n70998384)
print v(xbgr.mr_n70998704)
print v(xbgr.mr_n70998816)
print v(xbgr.mr_n70999136)
print v(xbgr.mr_n70999248)
print v(xbgr.mr_n70999568)
print v(xbgr.mr_n70999680)
print v(xbgr.mr_n71000000)
print v(xbgr.mr_n71000112)
print v(xbgr.mr_n71000432)
print v(xbgr.mr_n71000544)
print v(xbgr.mr_n71000864)
print v(xbgr.mr_n71000976)
print v(xbgr.mr_n71001296)
print v(xbgr.mr_n71001408)
print v(xbgr.mr_n71001728)
print v(xbgr.mr_n71001840)
print v(xbgr.mr_n71002160)
print v(xbgr.mr_n71002272)
print v(xbgr.mr_n71002592)
print v(xbgr.mr_n71002704)
print v(xbgr.mr_n71003024)
print v(xbgr.mr_n71003136)
print v(xbgr.mr_n71003456)
print v(xbgr.mr_n71003568)
print v(xbgr.mr_n71003888)
print v(xbgr.mr_n71004000)
print v(xbgr.mr_n71004320)
print v(xbgr.mr_n71004432)
print v(xbgr.mr_n71004752)
print v(xbgr.mr_n71004864)
print v(xbgr.mr_n71005184)
print v(xbgr.mr_n71005296)
print v(xbgr.mr_n71005616)
print v(xbgr.mr_n71005728)
print v(xbgr.mr_n71006048)
print v(xbgr.mr_n71006160)
print v(xbgr.mr_n71006480)
print v(xbgr.mr_n71006592)
print v(xbgr.mr_n71006912)
print v(xbgr.mr_n71007344)
print v(xbgr.mr_n71007456)
print v(xbgr.mr_n71007776)
print v(xbgr.mr_n71008208)
print v(xbgr.mr_n71008320)
print v(xbgr.mr_n71008640)
print v(xbgr.mr_n71009072)
print v(xbgr.mr_n71009184)
print v(xbgr.mr_n71009504)
print v(xbgr.mr_n71009936)
print v(xbgr.mr_n71010048)
print v(xbgr.mr_n71010368)
print v(xbgr.mr_n71010480)
print v(xbgr.mr_n71010800)
print v(xbgr.mr_n71010912)
print v(xbgr.mr_n71011232)
print v(xbgr.mr_n71011344)
print v(xbgr.mr_n71011664)
print v(xbgr.mr_n71012096)
print v(xbgr.mr_n71012208)
print v(xbgr.mr_n71012528)
print v(xbgr.mr_n71012960)
print v(xbgr.mr_n71013072)
print v(xbgr.mr_n71013392)
print v(xbgr.mr_n71013824)
print v(xbgr.mr_n71013936)
print v(xbgr.mr_n71014256)
print v(xbgr.mr_n71014688)
print v(xbgr.mr_n71014800)
print v(xbgr.mr_n71015120)
print v(xbgr.mr_n71015232)
print v(xbgr.mr_n71015552)
print v(xbgr.mr_n71015664)
print v(xbgr.mr_n71015984)
print v(xbgr.mr_n71016096)
print v(xbgr.mr_n71016416)
print v(xbgr.mr_n71016528)
print v(xbgr.mr_n71016848)
print v(xbgr.mr_n71016960)
print v(xbgr.mr_n71017280)
print v(xbgr.mr_n71017392)
print v(xbgr.mr_n71017712)
print v(xbgr.mr_n71017824)
print v(xbgr.mr_n71018144)
print v(xbgr.mr_n71018256)
print v(xbgr.mr_n71018576)
print v(xbgr.mr_n71018688)
print v(xbgr.mr_n71019008)
print v(xbgr.mr_n71019120)
print v(xbgr.mr_n71019440)
print v(xbgr.mr_n71019552)
print v(xbgr.mr_n71019872)
print v(xbgr.mr_n71019984)
print v(xbgr.mr_n71020304)
print v(xbgr.mr_n71020416)
print v(xbgr.mr_n71020736)
print v(xbgr.mr_n71020848)
print v(xbgr.mr_n71021168)
print v(xbgr.mr_n71021280)
print v(xbgr.mr_n71021600)
print v(xbgr.mr_n71021712)
print v(xbgr.mr_n71022032)
print v(xbgr.mr_n71022144)
print v(xbgr.mr_n71022464)
print v(xbgr.mr_n71022576)
print v(xbgr.mr_n71022896)
print v(xbgr.mr_n71023008)
print v(xbgr.mr_n71023328)
print v(xbgr.mr_n71023440)
print v(xbgr.mr_n71023760)
print v(xbgr.mr_n71023872)
print v(xbgr.mr_n71024192)
print v(xbgr.mr_n71024304)
print v(xbgr.mr_n71024624)
print v(xbgr.mr_n71024736)
print v(xbgr.mr_n71025056)
print v(xbgr.mr_n71025168)
print v(xbgr.mr_n71025488)
print v(xbgr.mr_n71025600)
print v(xbgr.mr_n71025920)
print v(xbgr.mr_n71026032)
print v(xbgr.mr_n71026352)
print v(xbgr.mr_n71026464)
print v(xbgr.mr_n71026896)
print v(xbgr.mr_n71027328)
print v(xbgr.mr_n71027760)
print v(xbgr.mr_n71028192)
print v(xbgr.mr_n71028624)
print v(xbgr.mr_n71029056)
print v(xbgr.mr_n71029488)
print v(xbgr.mr_n71029920)
print v(xbgr.mr_n71030352)
print v(xbgr.mr_n71030784)
print v(xbgr.mr_n71031216)
print v(xbgr.mr_n71031648)
print v(xbgr.mr_n71032080)
print v(xbgr.mr_n71032512)
print v(xbgr.mr_n71032944)
print v(xbgr.mr_n71033376)
print v(xbgr.mr_n71033808)
print v(xbgr.mr_n71034240)
print v(xbgr.mr_n71034672)
print v(xbgr.mr_n71035104)
print v(xbgr.mr_n71035536)
print v(xbgr.mr_n71035968)
print v(xbgr.mr_n71036400)
print v(xbgr.mr_n71036832)
print v(xbgr.mr_n71037264)
print v(xbgr.mr_n71037696)
print v(xbgr.mr_n71038016)
print v(xbgr.mr_n71038128)
print v(xbgr.mr_n71038448)
print v(xbgr.mr_n71038560)
print v(xbgr.mr_n71038880)
print v(xbgr.mr_n71038992)
print v(xbgr.mr_n71039312)
print v(xbgr.mr_n71039424)
print v(xbgr.mr_n71039744)
print v(xbgr.mr_n71039856)
print v(xbgr.mr_n71040176)
print v(xbgr.mr_n71040288)
print v(xbgr.mr_n71040608)
print v(xbgr.mr_n71040720)
print v(xbgr.mr_n71041040)
print v(xbgr.mr_n71041152)
print v(xbgr.mr_n71041472)
print v(xbgr.mr_n71041584)
print v(xbgr.mr_n71041904)
print v(xbgr.mr_n71042016)
print v(xbgr.mr_n71042336)
print v(xbgr.mr_n71042448)
print v(xbgr.mr_n71042768)
print v(xbgr.mr_n71042880)
print v(xbgr.mr_n71043200)
print v(xbgr.mr_n71043312)
print v(xbgr.mr_n71043632)
print v(xbgr.mr_n71043744)
print v(xbgr.mr_n71044064)
print v(xbgr.mr_n71044176)
print v(xbgr.mr_n71044496)
print v(xbgr.mr_n71044608)
print v(xbgr.mr_n71044928)
print v(xbgr.mr_n71045040)
print v(xbgr.mr_n71045360)
print v(xbgr.mr_n71045472)
print v(xbgr.mr_n71045792)
print v(xbgr.mr_n71045904)
print v(xbgr.mr_n71046224)
print v(xbgr.mr_n71046336)
print v(xbgr.mr_n71046768)
print v(xbgr.mr_n71047200)
print v(xbgr.mr_n71047632)
print v(xbgr.mr_n71048064)
print v(xbgr.mr_n71048496)
print v(xbgr.mr_n71048928)
print v(xbgr.mr_n71049360)
print v(xbgr.mr_n71049792)
print v(xbgr.mr_n71050224)
print v(xbgr.mr_n71050656)
print v(xbgr.mr_n71051088)
print v(xbgr.mr_n71051520)
print v(xbgr.mr_n71051840)
print v(xbgr.mr_n71051952)
print v(xbgr.mr_n71052272)
print v(xbgr.mr_n71052384)
print v(xbgr.mr_n71052816)
print v(xbgr.mr_n71053248)
print v(xbgr.mr_n71053680)
print v(xbgr.mr_n71054112)
print v(xbgr.mr_n71054544)
print v(xbgr.mr_n71054976)
print v(xbgr.mr_n71055408)
print v(xbgr.mr_n71055840)
print v(xbgr.mr_n71056272)
print v(xbgr.mr_n71056704)
print v(xbgr.mr_n71057024)
print v(xbgr.mr_n71057136)
print v(xbgr.mr_n71057456)
print v(xbgr.mr_n71057568)
print v(xbgr.mr_n71057888)
print v(xbgr.mr_n71058000)
print v(xbgr.mr_n71058320)
print v(xbgr.mr_n71058432)
print v(xbgr.mr_n71058752)
print v(xbgr.mr_n71058864)
print v(xbgr.mr_n71059184)
print v(xbgr.mr_n71059296)
print v(xbgr.mr_n71059616)
print v(xbgr.mr_n71059728)
print v(xbgr.mr_n71060048)
print v(xbgr.mr_n71060160)
print v(xbgr.mr_n71060480)
print v(xbgr.mr_n71060592)
print v(xbgr.mr_n71060912)
print v(xbgr.mr_n71061024)
print v(xbgr.mr_n71061344)
print v(xbgr.mr_n71061456)
print v(xbgr.mr_n71061776)
print v(xbgr.mr_n71061888)
print v(xbgr.mr_n71062208)
print v(xbgr.mr_n71062320)
print v(xbgr.mr_n71062640)
print v(xbgr.mr_n71062752)
print v(xbgr.mr_n71063072)
print v(xbgr.mr_n71063184)
print v(xbgr.mr_n71063504)
print v(xbgr.mr_n71063616)
print v(xbgr.mr_n71063936)
print v(xbgr.mr_n71064048)
print v(xbgr.mr_n71064368)
print v(xbgr.mr_n71064480)
print v(xbgr.mr_n71064800)
print v(xbgr.mr_n71064912)
print v(xbgr.mr_n71065232)
print v(xbgr.mr_n71065344)
print v(xbgr.mr_n71065664)
print v(xbgr.mr_n71065776)
print v(xbgr.mr_n71066096)
print v(xbgr.mr_n71066208)
print v(xbgr.mr_n71066528)
print v(xbgr.mr_n71066640)
print v(xbgr.mr_n71066960)
print v(xbgr.mr_n71067072)
print v(xbgr.mr_n71067392)
print v(xbgr.mr_n71067504)
print v(xbgr.mr_n71067824)
print v(xbgr.mr_n71067936)
print v(xbgr.mr_n71068256)
print v(xbgr.mr_n71068688)
print v(xbgr.mr_n71068800)
print v(xbgr.mr_n71069120)
print v(xbgr.mr_n71069552)
print v(xbgr.mr_n71069664)
print v(xbgr.mr_n71069984)
print v(xbgr.mr_n71070416)
print v(xbgr.mr_n71070528)
print v(xbgr.mr_n71070848)
print v(xbgr.mr_n71071280)
print v(xbgr.mr_n71071392)
print v(xbgr.mr_n71071712)
print v(xbgr.mr_n71072144)
print v(xbgr.mr_n71072256)
print v(xbgr.mr_n71072576)
print v(xbgr.mr_n71072688)
print v(xbgr.mr_n71073008)
print v(xbgr.mr_n71073120)
print v(xbgr.mr_n71073440)
print v(xbgr.mr_n71073552)
print v(xbgr.mr_n71073872)
print v(xbgr.mr_n71073984)
print v(xbgr.mr_n71074304)
print v(xbgr.mr_n71074416)
print v(xbgr.mr_n71074736)
print v(xbgr.mr_n71074848)
print v(xbgr.mr_n71075168)
print v(xbgr.mr_n71075280)
print v(xbgr.mr_n71075600)
print v(xbgr.mr_n71075712)
print v(xbgr.mr_n71076032)
print v(xbgr.mr_n71076144)
print v(xbgr.mr_n71076464)
print v(xbgr.mr_n71076576)
print v(xbgr.mr_n71076896)
print v(xbgr.mr_n71077008)
print v(xbgr.mr_n71077328)
print v(xbgr.mr_n71077440)
print v(xbgr.mr_n71077760)
print v(xbgr.mr_n71077872)
print v(xbgr.mr_n71078192)
print v(xbgr.mr_n71078304)
print v(xbgr.mr_n71078624)
print v(xbgr.mr_n71078736)
print v(xbgr.mr_n71079056)
print v(xbgr.mr_n71079168)
print v(xbgr.mr_n71079488)
print v(xbgr.mr_n71079600)
print v(xbgr.mr_n71079920)
print v(xbgr.mr_n71080032)
print v(xbgr.mr_n71080352)
print v(xbgr.mr_n71080464)
print v(xbgr.mr_n71080784)
print v(xbgr.mr_n71080896)
print v(xbgr.mr_n71081216)
print v(xbgr.mr_n71081328)
print v(xbgr.mr_n71081648)
print v(xbgr.mr_n71081760)
print v(xbgr.mr_n71082080)
print v(xbgr.mr_n71082192)
print v(xbgr.mr_n71082512)
print v(xbgr.mr_n71082624)
print v(xbgr.mr_n71082944)
print v(xbgr.mr_n71083056)
print v(xbgr.mr_n71083376)
print v(xbgr.mr_n71083488)
print v(xbgr.mr_n71083808)
print v(xbgr.mr_n71083920)
print v(xbgr.mr_n71084240)
print v(xbgr.mr_n71084352)
print v(xbgr.mr_n71084672)
print v(xbgr.mr_n71084784)
print v(xbgr.mr_n71085104)
print v(xbgr.mr_n71085216)
print v(xbgr.mr_n71085536)
print v(xbgr.mr_n71085648)
print v(xbgr.mr_n71085968)
print v(xbgr.mr_n71086080)
print v(xbgr.mr_n71086400)
print v(xbgr.mr_n71086512)
print v(xbgr.mr_n71086832)
print v(xbgr.mr_n71086944)
print v(xbgr.mr_n71087264)
print v(xbgr.mr_n71087376)
print v(xbgr.mr_n71087696)
print v(xbgr.mr_n71087808)
print v(xbgr.mr_n71088128)
print v(xbgr.mr_n71088240)
print v(xbgr.mr_n71088560)
print v(xbgr.mr_n71088672)
print v(xbgr.mr_n71088992)
print v(xbgr.mr_n71089104)
print v(xbgr.mr_n71089424)
print v(xbgr.mr_n71089536)
print v(xbgr.mr_n71089856)
print v(xbgr.mr_n71089968)
print v(xbgr.mr_n71090288)
print v(xbgr.mr_n71090400)
print v(xbgr.mr_n71090720)
print v(xbgr.mr_n71091152)
print v(xbgr.mr_n71091264)
print v(xbgr.mr_n71091584)
print v(xbgr.mr_n71091696)
print v(xbgr.mr_n71092016)
print v(xbgr.mr_n71092128)
print v(xbgr.mr_n71092448)
print v(xbgr.mr_n71092880)
print v(xbgr.mr_n71092992)
print v(xbgr.mr_n71093312)
print v(xbgr.mr_n71093744)
print v(xbgr.mr_n71093856)
print v(xbgr.mr_n71094176)
print v(xbgr.mr_n71094288)
print v(xbgr.mr_n71094608)
print v(xbgr.mr_n71094720)
print v(xbgr.mr_n71095040)
print v(xbgr.mr_n71095152)
print v(xbgr.mr_n71095472)
print v(xbgr.mr_n71095584)
print v(xbgr.mr_n71095904)
print v(xbgr.mr_n71096016)
print v(xbgr.mr_n71096336)
print v(xbgr.mr_n71096448)
print v(xbgr.mr_n71096768)
print v(xbgr.mr_n71096880)
print v(xbgr.mr_n71097200)
print v(xbgr.mr_n71097312)
print v(xbgr.mr_n71097632)
print v(xbgr.mr_n71097744)
print v(xbgr.mr_n71098064)
print v(xbgr.mr_n71098176)
print v(xbgr.mr_n71098496)
print v(xbgr.mr_n71098608)
print v(xbgr.mr_n71098928)
print v(xbgr.mr_n71099040)
print v(xbgr.mr_n71099360)
print v(xbgr.mr_n71099792)
print v(xbgr.mr_n71099904)
print v(xbgr.mr_n71100224)
print v(xbgr.mr_n71100336)
print v(xbgr.mr_n71100656)
print v(xbgr.mr_n71100768)
print v(xbgr.mr_n71101088)
print v(xbgr.mr_n71101200)
print v(xbgr.mr_n71101520)
print v(xbgr.mr_n71101632)
print v(xbgr.mr_n71101952)
print v(xbgr.mr_n71102064)
print v(xbgr.mr_n71102384)
print v(xbgr.mr_n71102496)
print v(xbgr.mr_n71102816)
print v(xbgr.mr_n71102928)
print v(xbgr.mr_n71103248)
print v(xbgr.mr_n71103360)
print v(xbgr.mr_n71103680)
print v(xbgr.mr_n71103792)
print v(xbgr.mr_n71104112)
print v(xbgr.mr_n71104224)
print v(xbgr.mr_n71104544)
print v(xbgr.mr_n71104656)
print v(xbgr.mr_n71104976)
print v(xbgr.mr_n71105088)
print v(xbgr.mr_n71105408)
print v(xbgr.mr_n71105520)
print v(xbgr.mr_n71105840)
print v(xbgr.mr_n71105952)
print v(xbgr.mr_n71106272)
print v(xbgr.mr_n71106384)
print v(xbgr.mr_n71106704)
print v(xbgr.mr_n71106816)
print v(xbgr.mr_n71107136)
print v(xbgr.mr_n71107248)
print v(xbgr.mr_n71107568)
print v(xbgr.mr_n71107680)
print v(xbgr.mr_n71108000)
print v(xbgr.mr_n71108112)
print v(xbgr.mr_n71108432)
print v(xbgr.mr_n71108544)
print v(xbgr.mr_n71108864)
print v(xbgr.mr_n71108976)
print v(xbgr.mr_n71109296)
print v(xbgr.mr_n71109408)
print v(xbgr.mr_n71109728)
print v(xbgr.mr_n71109840)
print v(xbgr.mr_n71110160)
print v(xbgr.mr_n71110272)
print v(xbgr.mr_n71110592)
print v(xbgr.mr_n71110704)
print v(xbgr.mr_n71111024)
print v(xbgr.mr_n71111136)
print v(xbgr.mr_n71111456)
print v(xbgr.mr_n71111568)
print v(xbgr.mr_n71111888)
print v(xbgr.mr_n71112000)
print v(xbgr.mr_n71112320)
print v(xbgr.mr_n71112432)
print v(xbgr.mr_n71112752)
print v(xbgr.mr_n71112864)
print v(xbgr.mr_n71113184)
print v(xbgr.mr_n71113296)
print v(xbgr.mr_n71113616)
print v(xbgr.mr_n71113728)
print v(xbgr.mr_n71114048)
print v(xbgr.mr_n71114160)
print v(xbgr.mr_n71114480)
print v(xbgr.mr_n71114592)
print v(xbgr.mr_n71114912)
print v(xbgr.mr_n71115024)
print v(xbgr.mr_n71115344)
print v(xbgr.mr_n71115456)
print v(xbgr.mr_n71115776)
print v(xbgr.mr_n71115888)
print v(xbgr.mr_n71116208)
print v(xbgr.mr_n71116320)
print v(xbgr.mr_n71116640)
print v(xbgr.mr_n71116752)
print v(xbgr.mr_n71117072)
print v(xbgr.mr_n71117184)
print v(xbgr.mr_n71117504)
print v(xbgr.mr_n71117616)
print v(xbgr.mr_n71117936)
print v(xbgr.mr_n71118048)
print v(xbgr.mr_n71118368)
print v(xbgr.mr_n71118480)
print v(xbgr.mr_n71118800)
print v(xbgr.mr_n71118912)
print v(xbgr.mr_n71119232)
print v(xbgr.mr_n71119344)
print v(xbgr.mr_n71119664)
print v(xbgr.mr_n71119776)
print v(xbgr.mr_n71120096)
print v(xbgr.mr_n71120208)
print v(xbgr.mr_n71120528)
print v(xbgr.mr_n71120640)
print v(xbgr.mr_n71120960)
print v(xbgr.mr_n71121072)
print v(xbgr.mr_n71121504)
print v(xbgr.mr_n71121936)
print v(xbgr.mr_n71122368)
print v(xbgr.mr_n71122800)
print v(xbgr.mr_n71123232)
print v(xbgr.mr_n71123664)
print v(xbgr.mr_n71124096)
print v(xbgr.mr_n71124528)
print v(xbgr.mr_n71124848)
print v(xbgr.mr_n71124960)
print v(xbgr.mr_n71125280)
print v(xbgr.mr_n71125392)
print v(xbgr.mr_n71125712)
print v(xbgr.mr_n71125824)
print v(xbgr.mr_n71126144)
print v(xbgr.mr_n71126256)
print v(xbgr.mr_n71126576)
print v(xbgr.mr_n71126688)
print v(xbgr.mr_n71127008)
print v(xbgr.mr_n71127120)
print v(xbgr.mr_n71127440)
print v(xbgr.mr_n71127552)
print v(xbgr.mr_n71127872)
print v(xbgr.mr_n71127984)
print v(xbgr.mr_n71128416)
print v(xbgr.mr_n71128848)
print v(xbgr.mr_n71129280)
print v(xbgr.mr_n71129712)
print v(xbgr.mr_n71130144)
print v(xbgr.mr_n71130576)
print v(xbgr.mr_n71130896)
print v(xbgr.mr_n71131008)
print v(xbgr.mr_n71131440)
print v(xbgr.mr_n71131872)
print v(xbgr.mr_n71132304)
print v(xbgr.mr_n71132736)
print v(xbgr.mr_n71133168)
print v(xbgr.mr_n71133600)
print v(xbgr.mr_n71134032)
print v(xbgr.mr_n71134464)
print v(xbgr.mr_n71134896)
print v(xbgr.mr_n71135328)
print v(xbgr.mr_n71135760)
print v(xbgr.mr_n71136192)
print v(xbgr.mr_n71136512)
print v(xbgr.mr_n71136624)
print v(xbgr.mr_n71136944)
print v(xbgr.mr_n71137056)
print v(xbgr.mr_n71137376)
print v(xbgr.mr_n71137488)
print v(xbgr.mr_n71137808)
print v(xbgr.mr_n71137920)
print v(xbgr.mr_n71138240)
print v(xbgr.mr_n71138352)
print v(xbgr.mr_n71138672)
print v(xbgr.mr_n71138784)
print v(xbgr.mr_n71139104)
print v(xbgr.mr_n71139216)
print v(xbgr.mr_n71139536)
print v(xbgr.mr_n71139648)
print v(xbgr.mr_n71139968)
print v(xbgr.mr_n71140080)
print v(xbgr.mr_n71140400)
print v(xbgr.mr_n71140512)
print v(xbgr.mr_n71140832)
print v(xbgr.mr_n71140944)
print v(xbgr.mr_n71141264)
print v(xbgr.mr_n71141376)
print v(xbgr.mr_n71141696)
print v(xbgr.mr_n71141808)
print v(xbgr.mr_n71142128)
print v(xbgr.mr_n71142240)
print v(xbgr.mr_n71142560)
print v(xbgr.mr_n71142672)
print v(xbgr.mr_n71142992)
print v(xbgr.mr_n71143104)
print v(xbgr.mr_n71143424)
print v(xbgr.mr_n71143536)
print v(xbgr.mr_n71143856)
print v(xbgr.mr_n71143968)
print v(xbgr.mr_n71144288)
print v(xbgr.mr_n71144400)
print v(xbgr.mr_n71144720)
print v(xbgr.mr_n71144832)
print v(xbgr.mr_n71145152)
print v(xbgr.mr_n71145264)
print v(xbgr.mr_n71145696)
print v(xbgr.mr_n71146128)
print v(xbgr.mr_n71146560)
print v(xbgr.mr_n71146992)
print v(xbgr.mr_n71147424)
print v(xbgr.mr_n71147856)
print v(xbgr.mr_n71148288)
print v(xbgr.mr_n71148720)
print v(xbgr.mr_n71149152)
print v(xbgr.mr_n71149584)
print v(xbgr.mr_n71150016)
print v(xbgr.mr_n71150448)
print v(xbgr.mr_n71150880)
print v(xbgr.mr_n71151312)
print v(xbgr.mr_n71151744)
print v(xbgr.mr_n71152176)
print v(xbgr.mr_n71152608)
print v(xbgr.mr_n71153040)
print v(xbgr.mr_n71153472)
print v(xbgr.mr_n71153792)
print v(xbgr.mr_n71153904)
print v(xbgr.mr_n71154224)
print v(xbgr.mr_n71154336)
print v(xbgr.mr_n71154656)
print v(xbgr.mr_n71154768)
print v(xbgr.mr_n71155088)
print v(xbgr.mr_n71155200)
print v(xbgr.mr_n71155520)
print v(xbgr.mr_n71155632)
print v(xbgr.mr_n71156064)
print v(xbgr.mr_n71156496)
print v(xbgr.mr_n71156928)
print v(xbgr.mr_n71157360)
print v(xbgr.mr_n71157792)
print v(xbgr.mr_n71158224)
print v(xbgr.mr_n71158656)
print v(xbgr.mr_n71158976)
print v(xbgr.mr_n71159088)
print v(xbgr.mr_n71159408)
print v(xbgr.mr_n71159520)
print v(xbgr.mr_n71159840)
print v(xbgr.mr_n71159952)
print v(xbgr.mr_n71160272)
print v(xbgr.mr_n71160384)
print v(xbgr.mr_n71160704)
print v(xbgr.mr_n71160816)
print v(xbgr.mr_n71161136)
print v(xbgr.mr_n71161248)
print v(xbgr.mr_n71161568)
print v(xbgr.mr_n71161680)
print v(xbgr.mr_n71162000)
print v(xbgr.mr_n71162112)
print v(xbgr.mr_n71162432)
print v(xbgr.mr_n71162544)
print v(xbgr.mr_n71162864)
print v(xbgr.mr_n71162976)
print v(xbgr.mr_n71163296)
print v(xbgr.mr_n71163408)
print v(xbgr.mr_n71163728)
print v(xbgr.mr_n71163840)
print v(xbgr.mr_n71164160)
print v(xbgr.mr_n71164272)
print v(xbgr.mr_n71164704)
print v(xbgr.mr_n71165136)
print v(xbgr.mr_n71165568)
print v(xbgr.mr_n71166000)
print v(xbgr.mr_n71166432)
print v(xbgr.mr_n71166864)
print v(xbgr.mr_n71167296)
print v(xbgr.mr_n71167728)
print v(xbgr.mr_n71168160)
print v(xbgr.mr_n71168592)
print v(xbgr.mr_n71169024)
print v(xbgr.mr_n71169456)
print v(xbgr.mr_n71169888)
print v(xbgr.mr_n71170208)
print v(xbgr.mr_n71170320)
print v(xbgr.mr_n71170640)
print v(xbgr.mr_n71170752)
print v(xbgr.mr_n71171072)
print v(xbgr.mr_n71171184)
print v(xbgr.mr_n71171504)
print v(xbgr.mr_n71171616)
print v(xbgr.mr_n71171936)
print v(xbgr.mr_n71172048)
print v(xbgr.mr_n71172368)
print v(xbgr.mr_n71172480)
print v(xbgr.mr_n71172800)
print v(xbgr.mr_n71172912)
print v(xbgr.mr_n71173232)
print v(xbgr.mr_n71173344)
print v(xbgr.mr_n71173664)
print v(xbgr.mr_n71173776)
print v(xbgr.mr_n71174096)
print v(xbgr.mr_n71174208)
print v(xbgr.mr_n71174528)
print v(xbgr.mr_n71174640)
print v(xbgr.mr_n71174960)
print v(xbgr.mr_n71175072)
print v(xbgr.mr_n71175504)
print v(xbgr.mr_n71175936)
print v(xbgr.mr_n71176368)
print v(xbgr.mr_n71176800)
print v(xbgr.mr_n71177232)
print v(xbgr.mr_n71177664)
print v(xbgr.mr_n71178096)
print v(xbgr.mr_n71178528)
print v(xbgr.mr_n71178960)
print v(xbgr.mr_n71179392)
print v(xbgr.mr_n71179824)
print v(xbgr.mr_n71180256)
print v(xbgr.mr_n71180576)
print v(xbgr.mr_n71180688)
print v(xbgr.mr_n71181120)
print v(xbgr.mr_n71181440)
print v(xbgr.mr_n71181552)
print v(xbgr.mr_n71181872)
print v(xbgr.mr_n71181984)
print v(xbgr.mr_n71182304)
print v(xbgr.mr_n71182416)
print v(xbgr.mr_n71182736)
print v(xbgr.mr_n71182848)
print v(xbgr.mr_n71183168)
print v(xbgr.mr_n71183280)
print v(xbgr.mr_n71183712)
print v(xbgr.mr_n71184144)
print v(xbgr.mr_n71184464)
print v(xbgr.mr_n71184576)
print v(xbgr.mr_n71184896)
print v(xbgr.mr_n71185008)
print v(xbgr.mr_n71185328)
print v(xbgr.mr_n71185440)
print v(xbgr.mr_n71185760)
print v(xbgr.mr_n71185872)
print v(xbgr.mr_n71186192)
print v(xbgr.mr_n71186304)
print v(xbgr.mr_n71186624)
print v(xbgr.mr_n71186736)
print v(xbgr.mr_n71187056)
print v(xbgr.mr_n71187168)
print v(xbgr.mr_n71187488)
print v(xbgr.mr_n71187600)
print v(xbgr.mr_n71188032)
print v(xbgr.mr_n71188464)
print v(xbgr.mr_n71188896)
print v(xbgr.mr_n71189328)
print v(xbgr.mr_n71189760)
print v(xbgr.mr_n71190192)
print v(xbgr.mr_n71190624)
print v(xbgr.mr_n71191056)
print v(xbgr.mr_n71191488)
print v(xbgr.mr_n71191920)
print v(xbgr.mr_n71192352)
print v(xbgr.mr_n71192672)
print v(xbgr.mr_n71192784)
print v(xbgr.mr_n71193104)
print v(xbgr.mr_n71193216)
print v(xbgr.mr_n71193536)
print v(xbgr.mr_n71193648)
print v(xbgr.mr_n71194080)
print v(xbgr.mr_n71194512)
print v(xbgr.mr_n71194832)
print v(xbgr.mr_n71194944)
print v(xbgr.mr_n71195264)
print v(xbgr.mr_n71195376)
print v(xbgr.mr_n71195696)
print v(xbgr.mr_n71195808)
print v(xbgr.mr_n71196128)
print v(xbgr.mr_n71196240)
print v(xbgr.mr_n71196672)
print v(xbgr.mr_n71196992)
print v(xbgr.mr_n71197104)
print v(xbgr.mr_n71197424)
print v(xbgr.mr_n71197536)
print v(xbgr.mr_n71197856)
print v(xbgr.mr_n71197968)
print v(xbgr.mr_n71198288)
print v(xbgr.mr_n71198400)
print v(xbgr.mr_n71198720)
print v(xbgr.mr_n71198832)
print v(xbgr.mr_n71199152)
print v(xbgr.mr_n71199264)
print v(xbgr.mr_n71199696)
print v(xbgr.mr_n71200128)
print v(xbgr.mr_n71200560)
print v(xbgr.mr_n71200992)
print v(xbgr.mr_n71201424)
print v(xbgr.mr_n71201856)
print v(xbgr.mr_n71202288)
print v(xbgr.mr_n71202720)
print v(xbgr.mr_n71203152)
print v(xbgr.mr_n71203584)
print v(xbgr.mr_n71203904)
print v(xbgr.mr_n71204016)
print v(xbgr.mr_n71204336)
print v(xbgr.mr_n71204448)
print v(xbgr.mr_n71204768)
print v(xbgr.mr_n71204880)
print v(xbgr.mr_n71205200)
print v(xbgr.mr_n71205312)
print v(xbgr.mr_n71205632)
print v(xbgr.mr_n71205744)
print v(xbgr.mr_n71206064)
print v(xbgr.mr_n71206176)
print v(xbgr.mr_n71206496)
print v(xbgr.mr_n71206608)
print v(xbgr.mr_n71206928)
print v(xbgr.mr_n71207040)
print v(xbgr.mr_n71207360)
print v(xbgr.mr_n71207472)
print v(xbgr.mr_n71207792)
print v(xbgr.mr_n71207904)
print v(xbgr.mr_n71208224)
print v(xbgr.mr_n71208336)
print v(xbgr.mr_n71208656)
print v(xbgr.mr_n71208768)
print v(xbgr.mr_n71209088)
print v(xbgr.mr_n71209200)
print v(xbgr.mr_n71209632)
print v(xbgr.mr_n71210064)
print v(xbgr.mr_n71210496)
print v(xbgr.mr_n71210928)
print v(xbgr.mr_n71211360)
print v(xbgr.mr_n71211792)
print v(xbgr.mr_n71212224)
print v(xbgr.mr_n71212656)
print v(xbgr.mr_n71213088)
print v(xbgr.mr_n71213520)
print v(xbgr.mr_n71213952)
print v(xbgr.mr_n71214384)
print v(xbgr.mr_n71214816)
print v(xbgr.mr_n71215136)
print v(xbgr.mr_n71215248)
print v(xbgr.mr_n71215568)
print v(xbgr.mr_n71215680)
print v(xbgr.mr_n71216000)
print v(xbgr.mr_n71216112)
print v(xbgr.mr_n71216432)
print v(xbgr.mr_n71216544)
print v(xbgr.mr_n71216864)
print v(xbgr.mr_n71216976)
print v(xbgr.mr_n71217296)
print v(xbgr.mr_n71217408)
print v(xbgr.mr_n71217728)
print v(xbgr.mr_n71217840)
print v(xbgr.mr_n71218160)
print v(xbgr.mr_n71218272)
print v(xbgr.mr_n71218592)
print v(xbgr.mr_n71218704)
print v(xbgr.mr_n71219024)
print v(xbgr.mr_n71219136)
print v(xbgr.mr_n71219456)
print v(xbgr.mr_n71219568)
print v(xbgr.mr_n71219888)
print v(xbgr.mr_n71220000)
print v(xbgr.mr_n71220320)
print v(xbgr.mr_n71220432)
print v(xbgr.mr_n71220864)
print v(xbgr.mr_n71221296)
print v(xbgr.mr_n71221728)
print v(xbgr.mr_n71222160)
print v(xbgr.mr_n71222592)
print v(xbgr.mr_n71223024)
print v(xbgr.mr_n71223456)
print v(xbgr.mr_n71223888)
print v(xbgr.mr_n71224320)
print v(xbgr.mr_n71224752)
print v(xbgr.mr_n71225184)
print v(xbgr.mr_n71225616)
print v(xbgr.mr_n71226048)
print v(xbgr.mr_n71226368)
print v(xbgr.mr_n71226480)
print v(xbgr.mr_n71226800)
print v(xbgr.mr_n71226912)
print v(xbgr.mr_n71227232)
print v(xbgr.mr_n71227344)
print v(xbgr.mr_n71227664)
print v(xbgr.mr_n71227776)
print v(xbgr.mr_n71228096)
print v(xbgr.mr_n71228208)
print v(xbgr.mr_n71228528)
print v(xbgr.mr_n71228640)
print v(xbgr.mr_n71228960)
print v(xbgr.mr_n71229072)
print v(xbgr.mr_n71229392)
print v(xbgr.mr_n71229504)
print v(xbgr.mr_n71229824)
print v(xbgr.mr_n71229936)
print v(xbgr.mr_n71230256)
print v(xbgr.mr_n71230368)
print v(xbgr.mr_n71230688)
print v(xbgr.mr_n71230800)
print v(xbgr.mr_n71231120)
print v(xbgr.mr_n71231232)
print v(xbgr.mr_n71231552)
print v(xbgr.mr_n71231664)
print v(xbgr.mr_n71232096)
print v(xbgr.mr_n71232528)
print v(xbgr.mr_n71232960)
print v(xbgr.mr_n71233392)
print v(xbgr.mr_n71233824)
print v(xbgr.mr_n71234256)
print v(xbgr.mr_n71234688)
print v(xbgr.mr_n71235120)
print v(xbgr.mr_n71235552)
print v(xbgr.mr_n71235984)
print v(xbgr.mr_n71236416)
print v(xbgr.mr_n71236848)
print v(xbgr.mr_n71237280)
print v(xbgr.mr_n71237600)
print v(xbgr.mr_n71237712)
print v(xbgr.mr_n71238032)
print v(xbgr.mr_n71238144)
print v(xbgr.mr_n71238576)
print v(xbgr.mr_n71238896)
print v(xbgr.mr_n71239008)
print v(xbgr.mr_n71239328)
print v(xbgr.mr_n71239440)
print v(xbgr.mr_n71239760)
print v(xbgr.mr_n71239872)
print v(xbgr.mr_n71240192)
print v(xbgr.mr_n71240304)
print v(xbgr.mr_n71240736)
print v(xbgr.mr_n71241168)
print v(xbgr.mr_n71241600)
print v(xbgr.mr_n71242032)
print v(xbgr.mr_n71242352)
print v(xbgr.mr_n71242464)
print v(xbgr.mr_n71242784)
print v(xbgr.mr_n71242896)
print v(xbgr.mr_n71243328)
print v(xbgr.mr_n71243760)
print v(xbgr.mr_n71244080)
print v(xbgr.mr_n71244192)
print v(xbgr.mr_n71244512)
print v(xbgr.mr_n71244624)
print v(xbgr.mr_n71244944)
print v(xbgr.mr_n71245056)
print v(xbgr.mr_n71245376)
print v(xbgr.mr_n71245488)
print v(xbgr.mr_n71245808)
print v(xbgr.mr_n71245920)
print v(xbgr.mr_n71246352)
print v(xbgr.mr_n71246784)
print v(xbgr.mr_n71247216)
print v(xbgr.mr_n71247648)
print v(xbgr.mr_n71248080)
print v(xbgr.mr_n71248512)
print v(xbgr.mr_n71248832)
print v(xbgr.mr_n71248944)
print v(xbgr.mr_n71249264)
print v(xbgr.mr_n71249376)
print v(xbgr.mr_n71249696)
print v(xbgr.mr_n71249808)
print v(xbgr.mr_n71250128)
print v(xbgr.mr_n71250240)
print v(xbgr.mr_n71250560)
print v(xbgr.mr_n71250672)
print v(xbgr.mr_n71250992)
print v(xbgr.mr_n71251104)
print v(xbgr.mr_n71251424)
print v(xbgr.mr_n71251536)
print v(xbgr.mr_n71251856)
print v(xbgr.mr_n71251968)
print v(xbgr.mr_n71252288)
print v(xbgr.mr_n71252400)
print v(xbgr.mr_n71252720)
print v(xbgr.mr_n71252832)
print v(xbgr.mr_n71253152)
print v(xbgr.mr_n71253264)
print v(xbgr.mr_n71253584)
print v(xbgr.mr_n71253696)
print v(xbgr.mr_n71254128)
print v(xbgr.mr_n71254560)
print v(xbgr.mr_n71254992)
print v(xbgr.mr_n71255424)
print v(xbgr.mr_n71255856)
print v(xbgr.mr_n71256288)
print v(xbgr.mr_n71256720)
print v(xbgr.mr_n71257152)
print v(xbgr.mr_n71257472)
print v(xbgr.mr_n71257584)
print v(xbgr.mr_n71257904)
print v(xbgr.mr_n71258016)
print v(xbgr.mr_n71258336)
print v(xbgr.mr_n71258448)
print v(xbgr.mr_n71258768)
print v(xbgr.mr_n71258880)
print v(xbgr.mr_n71259200)
print v(xbgr.mr_n71259312)
print v(xbgr.mr_n71259632)
print v(xbgr.mr_n71259744)
print v(xbgr.mr_n71260064)
print v(xbgr.mr_n71260176)
print v(xbgr.mr_n71260496)
print v(xbgr.mr_n71260608)
print v(xbgr.mr_n71261040)
print v(xbgr.mr_n71261472)
print v(xbgr.mr_n71261792)
print v(xbgr.mr_n71261904)
print v(xbgr.mr_n71262224)
print v(xbgr.mr_n71262336)
print v(xbgr.mr_n71262656)
print v(xbgr.mr_n71262768)
print v(xbgr.mr_n71263088)
print v(xbgr.mr_n71263200)
print v(xbgr.mr_n71263520)
print v(xbgr.mr_n71263632)
print v(xbgr.mr_n71263952)
print v(xbgr.mr_n71264064)
print v(xbgr.mr_n71264496)
print v(xbgr.mr_n71264928)
print v(xbgr.mr_n71265360)
print v(xbgr.mr_n71265792)
print v(xbgr.mr_n71266224)
print v(xbgr.mr_n71266656)
print v(xbgr.mr_n71267088)
print v(xbgr.mr_n71267520)
print v(xbgr.mr_n71267952)
print v(xbgr.mr_n71268384)
print v(xbgr.mr_n71268816)
print v(xbgr.mr_n71269248)
print v(xbgr.mr_n71269680)
print v(xbgr.mr_n71270112)
print v(xbgr.mr_n71270544)
print v(xbgr.mr_n71270976)
print v(xbgr.mr_n71271296)
print v(xbgr.mr_n71271408)
print v(xbgr.mr_n71271728)
print v(xbgr.mr_n71271840)
print v(xbgr.mr_n71272160)
print v(xbgr.mr_n71272272)
print v(xbgr.mr_n71272592)
print v(xbgr.mr_n71272704)
print v(xbgr.mr_n71273024)
print v(xbgr.mr_n71273136)
print v(xbgr.mr_n71273456)
print v(xbgr.mr_n71273568)
print v(xbgr.mr_n71273888)
print v(xbgr.mr_n71274000)
print v(xbgr.mr_n71274320)
print v(xbgr.mr_n71274432)
print v(xbgr.mr_n71274752)
print v(xbgr.mr_n71274864)
print v(xbgr.mr_n71275184)
print v(xbgr.mr_n71275296)
print v(xbgr.mr_n71275616)
print v(xbgr.mr_n71275728)
print v(xbgr.mr_n71276048)
print v(xbgr.mr_n71276160)
print v(xbgr.mr_n71276480)
print v(xbgr.mr_n71276592)
print v(xbgr.mr_n71276912)
print v(xbgr.mr_n71277024)
print v(xbgr.mr_n71277344)
print v(xbgr.mr_n71277456)
print v(xbgr.mr_n71277776)
print v(xbgr.mr_n71277888)
print v(xbgr.mr_n71278208)
print v(xbgr.mr_n71278320)
print v(xbgr.mr_n71278640)
print v(xbgr.mr_n71278752)
print v(xbgr.mr_n71279072)
print v(xbgr.mr_n71279184)
print v(xbgr.mr_n71279504)
print v(xbgr.mr_n71279616)
print v(xbgr.mr_n71280048)
print v(xbgr.mr_n71280480)
print v(xbgr.mr_n71280912)
print v(xbgr.mr_n71281344)
print v(xbgr.mr_n71281776)
print v(xbgr.mr_n71282208)
print v(xbgr.mr_n71282528)
print v(xbgr.mr_n71282640)
print v(xbgr.mr_n71282960)
print v(xbgr.mr_n71283072)
print v(xbgr.mr_n71283392)
print v(xbgr.mr_n71283504)
print v(xbgr.mr_n71283824)
print v(xbgr.mr_n71283936)
print v(xbgr.mr_n71284256)
print v(xbgr.mr_n71284368)
print v(xbgr.mr_n71284688)
print v(xbgr.mr_n71284800)
print v(xbgr.mr_n71285232)
print v(xbgr.mr_n71285664)
print v(xbgr.mr_n71286096)
print v(xbgr.mr_n71286528)
print v(xbgr.mr_n71286960)
print v(xbgr.mr_n71287392)
print v(xbgr.mr_n71287824)
print v(xbgr.mr_n71288256)
print v(xbgr.mr_n71288688)
print v(xbgr.mr_n71289120)
print v(xbgr.mr_n71289552)
print v(xbgr.mr_n71289984)
print v(xbgr.mr_n71290416)
print v(xbgr.mr_n71290848)
print v(xbgr.mr_n71291280)
print v(xbgr.mr_n71291712)
print v(xbgr.mr_n71292144)
print v(xbgr.mr_n71292576)
print v(xbgr.mr_n71293008)
print v(xbgr.mr_n71293440)
print v(xbgr.mr_n71293760)
print v(xbgr.mr_n71293872)
print v(xbgr.mr_n71294192)
print v(xbgr.mr_n71294304)
print v(xbgr.mr_n71294624)
print v(xbgr.mr_n71294736)
print v(xbgr.mr_n71295056)
print v(xbgr.mr_n71295168)
print v(xbgr.mr_n71295488)
print v(xbgr.mr_n71295600)
print v(xbgr.mr_n71295920)
print v(xbgr.mr_n71296032)
print v(xbgr.mr_n71296352)
print v(xbgr.mr_n71296464)
print v(xbgr.mr_n71296784)
print v(xbgr.mr_n71296896)
print v(xbgr.mr_n71297216)
print v(xbgr.mr_n71297328)
print v(xbgr.mr_n71297648)
print v(xbgr.mr_n71297760)
print v(xbgr.mr_n71298080)
print v(xbgr.mr_n71298192)
print v(xbgr.mr_n71298512)
print v(xbgr.mr_n71298624)
print v(xbgr.mr_n71298944)
print v(xbgr.mr_n71299056)
print v(xbgr.mr_n71299376)
print v(xbgr.mr_n71299488)
print v(xbgr.mr_n71299808)
print v(xbgr.mr_n71299920)
print v(xbgr.mr_n71300240)
print v(xbgr.mr_n71300352)
print v(xbgr.mr_n71300672)
print v(xbgr.mr_n71300784)
print v(xbgr.mr_n71301104)
print v(xbgr.mr_n71301216)
print v(xbgr.mr_n71301536)
print v(xbgr.mr_n71301648)
print v(xbgr.mr_n71301968)
print v(xbgr.mr_n71302080)
print v(xbgr.mr_n71302400)
print v(xbgr.mr_n71302512)
print v(xbgr.mr_n71302832)
print v(xbgr.mr_n71302944)
print v(xbgr.mr_n71303264)
print v(xbgr.mr_n71303376)
print v(xbgr.mr_n71303696)
print v(xbgr.mr_n71303808)
print v(xbgr.mr_n71304128)
print v(xbgr.mr_n71304240)
print v(xbgr.mr_n71304560)
print v(xbgr.mr_n71304672)
print v(xbgr.mr_n71304992)
print v(xbgr.mr_n71305104)
print v(xbgr.mr_n71305424)
print v(xbgr.mr_n71305536)
print v(xbgr.mr_n71305856)
print v(xbgr.mr_n71305968)
print v(xbgr.mr_n71306288)
print v(xbgr.mr_n71306400)
print v(xbgr.mr_n71306720)
print v(xbgr.mr_n71306832)
print v(xbgr.mr_n71307152)
print v(xbgr.mr_n71307264)
print v(xbgr.mr_n71307696)
print v(xbgr.mr_n71308128)
print v(xbgr.mr_n71308448)
print v(xbgr.mr_n71308560)
print v(xbgr.mr_n71308880)
print v(xbgr.mr_n71308992)
print v(xbgr.mr_n71309312)
print v(xbgr.mr_n71309424)
print v(xbgr.mr_n71309744)
print v(xbgr.mr_n71309856)
print v(xbgr.mr_n71310176)
print v(xbgr.mr_n71310288)
print v(xbgr.mr_n71310608)
print v(xbgr.mr_n71310720)
print v(xbgr.mr_n71311040)
print v(xbgr.mr_n71311152)
print v(xbgr.mr_n71311472)
print v(xbgr.mr_n71311584)
print v(xbgr.mr_n71311904)
print v(xbgr.mr_n71312016)
print v(xbgr.mr_n71312336)
print v(xbgr.mr_n71312448)
print v(xbgr.mr_n71312880)
print v(xbgr.mr_n71313312)
print v(xbgr.mr_n71313744)
print v(xbgr.mr_n71314064)
print v(xbgr.mr_n71314176)
print v(xbgr.mr_n71314496)
print v(xbgr.mr_n71314608)
print v(xbgr.mr_n71315040)
print v(xbgr.mr_n71315472)
print v(xbgr.mr_n71315904)
print v(xbgr.mr_n71316336)
print v(xbgr.mr_n71316768)
print v(xbgr.mr_n71317200)
print v(xbgr.mr_n71317632)
print v(xbgr.mr_n71318064)
print v(xbgr.mr_n71318496)
print v(xbgr.mr_n71318928)
print v(xbgr.mr_n71319360)
print v(xbgr.mr_n71319680)
print v(xbgr.mr_n71319792)
print v(xbgr.mr_n71320112)
print v(xbgr.mr_n71320224)
print v(xbgr.mr_n71320544)
print v(xbgr.mr_n71320656)
print v(xbgr.mr_n71320976)
print v(xbgr.mr_n71321088)
print v(xbgr.mr_n71321408)
print v(xbgr.mr_n71321520)
print v(xbgr.mr_n71321840)
print v(xbgr.mr_n71321952)
print v(xbgr.mr_n71322272)
print v(xbgr.mr_n71322384)
print v(xbgr.mr_n71322704)
print v(xbgr.mr_n71322816)
print v(xbgr.mr_n71323248)
print v(xbgr.mr_n71323680)
print v(xbgr.mr_n71324112)
print v(xbgr.mr_n71324544)
print v(xbgr.mr_n71324976)
print v(xbgr.mr_n71325408)
print v(xbgr.mr_n71325840)
print v(xbgr.mr_n71326272)
print v(xbgr.mr_n71326704)
print v(xbgr.mr_n71327136)
print v(xbgr.mr_n71327568)
print v(xbgr.mr_n71328000)
print v(xbgr.mr_n71328432)
print v(xbgr.mr_n71328864)
print v(xbgr.mr_n71329296)
print v(xbgr.mr_n71329728)
print v(xbgr.mr_n71330160)
print v(xbgr.mr_n71330592)
print v(xbgr.mr_n71331024)
print v(xbgr.mr_n71331456)
print v(xbgr.mr_n71331776)
print v(xbgr.mr_n71331888)
print v(xbgr.mr_n71332208)
print v(xbgr.mr_n71332320)
print v(xbgr.mr_n71332640)
print v(xbgr.mr_n71332752)
print v(xbgr.mr_n71333072)
print v(xbgr.mr_n71333184)
print v(xbgr.mr_n71333504)
print v(xbgr.mr_n71333616)
print v(xbgr.mr_n71333936)
print v(xbgr.mr_n71334048)
print v(xbgr.mr_n71334368)
print v(xbgr.mr_n71334480)
print v(xbgr.mr_n71334800)
print v(xbgr.mr_n71334912)
print v(xbgr.mr_n71335232)
print v(xbgr.mr_n71335344)
print v(xbgr.mr_n71335664)
print v(xbgr.mr_n71335776)
print v(xbgr.mr_n71336096)
print v(xbgr.mr_n71336208)
print v(xbgr.mr_n71336528)
print v(xbgr.mr_n71336640)
print v(xbgr.mr_n71336960)
print v(xbgr.mr_n71337072)
print v(xbgr.mr_n71337504)
print v(xbgr.mr_n71337936)
print v(xbgr.mr_n71338368)
print v(xbgr.mr_n71338800)
print v(xbgr.mr_n71339232)
print v(xbgr.mr_n71339664)
print v(xbgr.mr_n71340096)
print v(xbgr.mr_n71340528)
print v(xbgr.mr_n71340960)
print v(xbgr.mr_n71341392)
print v(xbgr.mr_n71341824)
print v(xbgr.mr_n71342256)
print v(xbgr.mr_n71342688)
print v(xbgr.mr_n71343008)
print v(xbgr.mr_n71343120)
print v(xbgr.mr_n71343440)
print v(xbgr.mr_n71343552)
print v(xbgr.mr_n71343872)
print v(xbgr.mr_n71343984)
print v(xbgr.mr_n71344304)
print v(xbgr.mr_n71344416)
print v(xbgr.mr_n71344736)
print v(xbgr.mr_n71344848)
print v(xbgr.mr_n71345168)
print v(xbgr.mr_n71345280)
print v(xbgr.mr_n71345600)
print v(xbgr.mr_n71345712)
print v(xbgr.mr_n71346032)
print v(xbgr.mr_n71346144)
print v(xbgr.mr_n71346464)
print v(xbgr.mr_n71346576)
print v(xbgr.mr_n71346896)
print v(xbgr.mr_n71347008)
print v(xbgr.mr_n71347328)
print v(xbgr.mr_n71347440)
print v(xbgr.mr_n71347760)
print v(xbgr.mr_n71347872)
print v(xbgr.mr_n71348304)
print v(xbgr.mr_n71348624)
print v(xbgr.mr_n71348736)
print v(xbgr.mr_n71349168)
print v(xbgr.mr_n71349600)
print v(xbgr.mr_n71350032)
print v(xbgr.mr_n71350464)
print v(xbgr.mr_n71350896)
print v(xbgr.mr_n71351328)
print v(xbgr.mr_n71351760)
print v(xbgr.mr_n71352192)
print v(xbgr.mr_n71352624)
print v(xbgr.mr_n71353056)
print v(xbgr.mr_n71353488)
print v(xbgr.mr_n71353920)
print v(xbgr.mr_n71354240)
print v(xbgr.mr_n71354352)
print v(xbgr.mr_n71354672)
print v(xbgr.mr_n71354784)
print v(xbgr.mr_n71355104)
print v(xbgr.mr_n71355216)
print v(xbgr.mr_n71355536)
print v(xbgr.mr_n71355648)
print v(xbgr.mr_n71355968)
print v(xbgr.mr_n71356080)
print v(xbgr.mr_n71356400)
print v(xbgr.mr_n71356512)
print v(xbgr.mr_n71356832)
print v(xbgr.mr_n71356944)
print v(xbgr.mr_n71357264)
print v(xbgr.mr_n71357376)
print v(xbgr.mr_n71357696)
print v(xbgr.mr_n71357808)
print v(xbgr.mr_n71358128)
print v(xbgr.mr_n71358240)
print v(xbgr.mr_n71358560)
print v(xbgr.mr_n71358672)
print v(xbgr.mr_n71359104)
print v(xbgr.mr_n71359536)
print v(xbgr.mr_n71359968)
print v(xbgr.mr_n71360288)
print v(xbgr.mr_n71360400)
print v(xbgr.mr_n71360720)
print v(xbgr.mr_n71360832)
print v(xbgr.mr_n71361264)
print v(xbgr.mr_n71361696)
print v(xbgr.mr_n71362128)
print v(xbgr.mr_n71362560)
print v(xbgr.mr_n71362992)
print v(xbgr.mr_n71363424)
print v(xbgr.mr_n71363856)
print v(xbgr.mr_n71364288)
print v(xbgr.mr_n71364720)
print v(xbgr.mr_n71365152)
print v(xbgr.mr_n71365472)
print v(xbgr.mr_n71365584)
print v(xbgr.mr_n71365904)
print v(xbgr.mr_n71366016)
print v(xbgr.mr_n71366336)
print v(xbgr.mr_n71366448)
print v(xbgr.mr_n71366768)
print v(xbgr.mr_n71366880)
print v(xbgr.mr_n71367200)
print v(xbgr.mr_n71367312)
print v(xbgr.mr_n71367632)
print v(xbgr.mr_n71367744)
print v(xbgr.mr_n71368064)
print v(xbgr.mr_n71368176)
print v(xbgr.mr_n71368496)
print v(xbgr.mr_n71368608)
print v(xbgr.mr_n71368928)
print v(xbgr.mr_n71369040)
print v(xbgr.mr_n71369360)
print v(xbgr.mr_n71369472)
print v(xbgr.mr_n71369792)
print v(xbgr.mr_n71369904)
print v(xbgr.mr_n71370224)
print v(xbgr.mr_n71370336)
print v(xbgr.mr_n71370768)
print v(xbgr.mr_n71371200)
print v(xbgr.mr_n71371632)
print v(xbgr.mr_n71372064)
print v(xbgr.mr_n71372496)
print v(xbgr.mr_n71372928)
print v(xbgr.mr_n71373360)
print v(xbgr.mr_n71373680)
print v(xbgr.mr_n71373792)
print v(xbgr.mr_n71374224)
print v(xbgr.mr_n71374656)
print v(xbgr.mr_n71375088)
print v(xbgr.mr_n71375520)
print v(xbgr.mr_n71375952)
print v(xbgr.mr_n71376384)
print v(xbgr.mr_n71376704)
print v(xbgr.mr_n71376816)
print v(xbgr.mr_n71377136)
print v(xbgr.mr_n71377248)
print v(xbgr.mr_n71377568)
print v(xbgr.mr_n71377680)
print v(xbgr.mr_n71378000)
print v(xbgr.mr_n71378112)
print v(xbgr.mr_n71378432)
print v(xbgr.mr_n71378544)
print v(xbgr.mr_n71378864)
print v(xbgr.mr_n71378976)
print v(xbgr.mr_n71379296)
print v(xbgr.mr_n71379408)
print v(xbgr.mr_n71379728)
print v(xbgr.mr_n71379840)
print v(xbgr.mr_n71380160)
print v(xbgr.mr_n71380272)
print v(xbgr.mr_n71380592)
print v(xbgr.mr_n71380704)
print v(xbgr.mr_n71381024)
print v(xbgr.mr_n71381136)
print v(xbgr.mr_n71381456)
print v(xbgr.mr_n71381568)
print v(xbgr.mr_n71381888)
print v(xbgr.mr_n71382000)
print v(xbgr.mr_n71382320)
print v(xbgr.mr_n71382432)
print v(xbgr.mr_n71382752)
print v(xbgr.mr_n71382864)
print v(xbgr.mr_n71383184)
print v(xbgr.mr_n71383296)
print v(xbgr.mr_n71383616)
print v(xbgr.mr_n71383728)
print v(xbgr.mr_n71384048)
print v(xbgr.mr_n71384160)
print v(xbgr.mr_n71384480)
print v(xbgr.mr_n71384592)
print v(xbgr.mr_n71384912)
print v(xbgr.mr_n71385024)
print v(xbgr.mr_n71385344)
print v(xbgr.mr_n71385456)
print v(xbgr.mr_n71385776)
print v(xbgr.mr_n71385888)
print v(xbgr.mr_n71386208)
print v(xbgr.mr_n71386320)
print v(xbgr.mr_n71386640)
print v(xbgr.mr_n71386752)
print v(xbgr.mr_n71387184)
print v(xbgr.mr_n71387616)
print v(xbgr.mr_n71388048)
print v(xbgr.mr_n71388368)
print v(xbgr.mr_n71388480)
print v(xbgr.mr_n71388800)
print v(xbgr.mr_n71388912)
print v(xbgr.mr_n71389344)
print v(xbgr.mr_n71389776)
print v(xbgr.mr_n71390208)
print v(xbgr.mr_n71390640)
print v(xbgr.mr_n71391072)
print v(xbgr.mr_n71391504)
print v(xbgr.mr_n71391936)
print v(xbgr.mr_n71392368)
print v(xbgr.mr_n71392800)
print v(xbgr.mr_n71393232)
print v(xbgr.mr_n71393664)
print v(xbgr.mr_n71394096)
print v(xbgr.mr_n71394528)
print v(xbgr.mr_n71394960)
print v(xbgr.mr_n71395392)
print v(xbgr.mr_n71395824)
print v(xbgr.mr_n71396256)
print v(xbgr.mr_n71396688)
print v(xbgr.mr_n71397120)
print v(xbgr.mr_n71397552)
print v(xbgr.mr_n71397984)
print v(xbgr.mr_n71398416)
print v(xbgr.mr_n71398848)
print v(xbgr.mr_n71399168)
print v(xbgr.mr_n71399280)
print v(xbgr.mr_n71399600)
print v(xbgr.mr_n71399712)
print v(xbgr.mr_n71400032)
print v(xbgr.mr_n71400144)
print v(xbgr.mr_n71400464)
print v(xbgr.mr_n71400576)
print v(xbgr.mr_n71400896)
print v(xbgr.mr_n71401008)
print v(xbgr.mr_n71401328)
print v(xbgr.mr_n71401440)
print v(xbgr.mr_n71401760)
print v(xbgr.mr_n71401872)
print v(xbgr.mr_n71402192)
print v(xbgr.mr_n71402304)
print v(xbgr.mr_n71402624)
print v(xbgr.mr_n71402736)
print v(xbgr.mr_n71403056)
print v(xbgr.mr_n71403168)
print v(xbgr.mr_n71403488)
print v(xbgr.mr_n71403600)
print v(xbgr.mr_n71403920)
print v(xbgr.mr_n71404032)
print v(xbgr.mr_n71404352)
print v(xbgr.mr_n71404464)
print v(xbgr.mr_n71404784)
print v(xbgr.mr_n71404896)
print v(xbgr.mr_n71405328)
print v(xbgr.mr_n71405760)
print v(xbgr.mr_n71406080)
print v(xbgr.mr_n71406192)
print v(xbgr.mr_n71406512)
print v(xbgr.mr_n71406624)
print v(xbgr.mr_n71406944)
print v(xbgr.mr_n71407056)
print v(xbgr.mr_n71407376)
print v(xbgr.mr_n71407488)
print v(xbgr.mr_n71407920)
print v(xbgr.mr_n71408352)
print v(xbgr.mr_n71408672)
print v(xbgr.mr_n71408784)
print v(xbgr.mr_n71409104)
print v(xbgr.mr_n71409216)
print v(xbgr.mr_n71409536)
print v(xbgr.mr_n71409648)
print v(xbgr.mr_n71409968)
print v(xbgr.mr_n71410080)
print v(xbgr.mr_n71410400)
print v(xbgr.mr_n71410512)
print v(xbgr.mr_n71410832)
print v(xbgr.mr_n71410944)
print v(xbgr.mr_n71411264)
print v(xbgr.mr_n71411376)
print v(xbgr.mr_n71411696)
print v(xbgr.mr_n71411808)
print v(xbgr.mr_n71412240)
print v(xbgr.mr_n71412672)
print v(xbgr.mr_n71413104)
print v(xbgr.mr_n71413536)
print v(xbgr.mr_n71413968)
print v(xbgr.mr_n71414400)
print v(xbgr.mr_n71414832)
print v(xbgr.mr_n71415264)
print v(xbgr.mr_n71415696)
print v(xbgr.mr_n71416128)
print v(xbgr.mr_n71416448)
print v(xbgr.mr_n71416560)
print v(xbgr.mr_n71416880)
print v(xbgr.mr_n71416992)
print v(xbgr.mr_n71417312)
print v(xbgr.mr_n71417424)
print v(xbgr.mr_n71417744)
print v(xbgr.mr_n71417856)
print v(xbgr.mr_n71422912)
print v(xbgr.mr_n71423024)
print v(xbgr.mr_n71423360)
print v(xbgr.mr_n71423472)
print v(xbgr.mr_n71423792)
print v(xbgr.mr_n71423904)
print v(xbgr.mr_n71424272)
print v(xbgr.mr_n71424384)
print v(xbgr.mr_n71424704)
print v(xbgr.mr_n71424816)
print v(xbgr.mr_n71425136)
print v(xbgr.mr_n71425248)
print v(xbgr.mr_n71425488)
print v(xbgr.mr_n71425600)
print v(xbgr.mr_n71425920)
print v(xbgr.mr_n71426032)
print v(xbgr.mr_n71426352)
print v(xbgr.mr_n71426464)
print v(xbgr.mr_n71426784)
print v(xbgr.mr_n71426896)
print v(xbgr.mr_n71427216)
print v(xbgr.mr_n71427328)
print v(xbgr.mr_n71427648)
print v(xbgr.mr_n71427760)
print v(xbgr.mr_n71428080)
print v(xbgr.mr_n71428192)
print v(xbgr.mr_n71428512)
print v(xbgr.mr_n71428624)
print v(xbgr.mr_n71428944)
print v(xbgr.mr_n71429056)
print v(xbgr.mr_n71429376)
print v(xbgr.mr_n71429488)
print v(xbgr.mr_n71429808)
print v(xbgr.mr_n71429920)
print v(xbgr.mr_n71430240)
print v(xbgr.mr_n71430352)
print v(xbgr.mr_n71430672)
print v(xbgr.mr_n71430784)
print v(xbgr.mr_n71431104)
print v(xbgr.mr_n71431216)
print v(xbgr.mr_n71431536)
print v(xbgr.mr_n71431648)
print v(xbgr.mr_n71431968)
print v(xbgr.mr_n71432080)
print v(xbgr.mr_n71432400)
print v(xbgr.mr_n71432512)
print v(xbgr.mr_n71432832)
print v(xbgr.mr_n71432944)
print v(xbgr.mr_n71433264)
print v(xbgr.mr_n71433376)
print v(xbgr.mr_n71433696)
print v(xbgr.mr_n71433808)
print v(xbgr.mr_n71434128)
print v(xbgr.mr_n71434240)
print v(xbgr.mr_n71434560)
print v(xbgr.mr_n71434672)
print v(xbgr.mr_n71434992)
print v(xbgr.mr_n71435104)
print v(xbgr.mr_n71435424)
print v(xbgr.mr_n71435536)
print v(xbgr.mr_n71435856)
print v(xbgr.mr_n71435968)
print v(xbgr.mr_n71436288)
print v(xbgr.mr_n71436400)
print v(xbgr.mr_n71436720)
print v(xbgr.mr_n71436832)
print v(xbgr.mr_n71437152)
print v(xbgr.mr_n71437264)
print v(xbgr.mr_n71437584)
print v(xbgr.mr_n71437696)
print v(xbgr.mr_n71438016)
print v(xbgr.mr_n71438128)
print v(xbgr.mr_n71438448)
print v(xbgr.mr_n71438560)
print v(xbgr.mr_n71438880)
print v(xbgr.mr_n71438992)
print v(xbgr.mr_n71439312)
print v(xbgr.mr_n71439424)
print v(xbgr.mr_n71439744)
print v(xbgr.mr_n71439856)
print v(xbgr.mr_n71440176)
print v(xbgr.mr_n71440288)
print v(xbgr.mr_n71440608)
print v(xbgr.mr_n71440720)
print v(xbgr.mr_n71441040)
print v(xbgr.mr_n71441152)
print v(xbgr.mr_n71441472)
print v(xbgr.mr_n71441584)
print v(xbgr.mr_n71441904)
print v(xbgr.mr_n71442016)
print v(xbgr.mr_n71442336)
print v(xbgr.mr_n71442448)
print v(xbgr.mr_n71442768)
print v(xbgr.mr_n71442880)
print v(xbgr.mr_n71443200)
print v(xbgr.mr_n71443312)
print v(xbgr.mr_n71443632)
print v(xbgr.mr_n71443744)
print v(xbgr.mr_n71444064)
print v(xbgr.mr_n71444176)
print v(xbgr.mr_n71444496)
print v(xbgr.mr_n71444608)
print v(xbgr.mr_n71444928)
print v(xbgr.mr_n71445040)
print v(xbgr.mr_n71445360)
print v(xbgr.mr_n71445472)
print v(xbgr.mr_n71445792)
print v(xbgr.mr_n71445904)
print v(xbgr.mr_n71446224)
print v(xbgr.mr_n71446336)
print v(xbgr.mr_n71446656)
print v(xbgr.mr_n71446768)
print v(xbgr.mr_n71447088)
print v(xbgr.mr_n71447200)
print v(xbgr.mr_n71447520)
print v(xbgr.mr_n71447632)
print v(xbgr.mr_n71447952)
print v(xbgr.mr_n71448064)
print v(xbgr.mr_n71448384)
print v(xbgr.mr_n71448496)
print v(xbgr.mr_n71448816)
print v(xbgr.mr_n71448928)
print v(xbgr.mr_n71449248)
print v(xbgr.mr_n71449360)
print v(xbgr.mr_n71449680)
print v(xbgr.mr_n71449792)
print v(xbgr.mr_n71450112)
print v(xbgr.mr_n71450224)
print v(xbgr.mr_n71450544)
print v(xbgr.mr_n71450656)
print v(xbgr.mr_n71450976)
print v(xbgr.mr_n71451088)
print v(xbgr.mr_n71451408)
print v(xbgr.mr_n71451520)
print v(xbgr.mr_n71451840)
print v(xbgr.mr_n71451952)
print v(xbgr.mr_n71452272)
print v(xbgr.mr_n71452384)
print v(xbgr.mr_n71452704)
print v(xbgr.mr_n71452816)
print v(xbgr.mr_n71453040)
print v(xbgr.mr_n71453152)
print v(xbgr.mr_n71453408)
print v(xbgr.mr_n71453520)
print v(xbgr.mr_n71453776)
print v(xbgr.mr_n71453888)
print v(xbgr.mr_n71454144)
print v(xbgr.mr_n71454256)
print v(xbgr.mr_n71454512)
print v(xbgr.mr_n71454624)
print v(xbgr.mr_n71454880)
print v(xbgr.mr_n71454992)
print v(xbgr.mr_n71455248)
print v(xbgr.mr_n71455360)
print v(xbgr.mr_n71455616)
print v(xbgr.mr_n71455728)
print v(xbgr.mr_n71455984)
print v(xbgr.mr_n71456096)
print v(xbgr.mr_n71456352)
print v(xbgr.mr_n71456464)
print v(xbgr.mr_n71456784)
print v(xbgr.mr_n71456896)
print v(xbgr.mr_n71457216)
print v(xbgr.mr_n71457328)
print v(xbgr.mr_n71457648)
print v(xbgr.mr_n71457760)
print v(xbgr.mr_n71458080)
print v(xbgr.mr_n71458192)
print v(xbgr.mr_n71458512)
print v(xbgr.mr_n71458624)
print v(xbgr.mr_n71458944)
print v(xbgr.mr_n71459056)
print v(xbgr.mr_n71459376)
print v(xbgr.mr_n71459488)
print v(xbgr.mr_n71459808)
print v(xbgr.mr_n71459920)
print v(xbgr.mr_n71460240)
print v(xbgr.mr_n71460352)
print v(xbgr.mr_n71460672)
print v(xbgr.mr_n71460784)
print v(xbgr.mr_n71461104)
print v(xbgr.mr_n71461216)
print v(xbgr.mr_n71461536)
print v(xbgr.mr_n71461648)
print v(xbgr.mr_n71461968)
print v(xbgr.mr_n71462080)
print v(xbgr.mr_n71462400)
print v(xbgr.mr_n71462512)
print v(xbgr.mr_n71462832)
print v(xbgr.mr_n71462944)
print v(xbgr.mr_n71463264)
print v(xbgr.mr_n71463376)
print v(xbgr.mr_n71463696)
print v(xbgr.mr_n71463808)
print v(xbgr.mr_n71464128)
print v(xbgr.mr_n71464240)
print v(xbgr.mr_n71464560)
print v(xbgr.mr_n71464672)
print v(xbgr.mr_n71464992)
print v(xbgr.mr_n71465104)
print v(xbgr.mr_n71465424)
print v(xbgr.mr_n71465536)
print v(xbgr.mr_n71465856)
print v(xbgr.mr_n71465968)
print v(xbgr.mr_n71466288)
print v(xbgr.mr_n71466400)
print v(xbgr.mr_n71466720)
print v(xbgr.mr_n71466832)
print v(xbgr.mr_n71467152)
print v(xbgr.mr_n71467264)
print v(xbgr.mr_n71467584)
print v(xbgr.mr_n71467696)
print v(xbgr.mr_n71468016)
print v(xbgr.mr_n71468128)
print v(xbgr.mr_n71468448)
print v(xbgr.mr_n71468560)
print v(xbgr.mr_n71468880)
print v(xbgr.mr_n71468992)
print v(xbgr.mr_n71469312)
print v(xbgr.mr_n71469424)
print v(xbgr.mr_n71469744)
print v(xbgr.mr_n71469856)
print v(xbgr.mr_n71470176)
print v(xbgr.mr_n71470288)
print v(xbgr.mr_n71470608)
print v(xbgr.mr_n71470720)
print v(xbgr.mr_n71471040)
print v(xbgr.mr_n71471152)
print v(xbgr.mr_n71471472)
print v(xbgr.mr_n71471584)
print v(xbgr.mr_n71471904)
print v(xbgr.mr_n71472016)
print v(xbgr.mr_n71472336)
print v(xbgr.mr_n71472448)
print v(xbgr.mr_n71472768)
print v(xbgr.mr_n71472880)
print v(xbgr.mr_n71473200)
print v(xbgr.mr_n71473312)
print v(xbgr.mr_n71473632)
print v(xbgr.mr_n71473744)
print v(xbgr.mr_n71474064)
print v(xbgr.mr_n71474176)
print v(xbgr.mr_n71474496)
print v(xbgr.mr_n71474608)
print v(xbgr.mr_n71474928)
print v(xbgr.mr_n71475040)
print v(xbgr.mr_n71475360)
print v(xbgr.mr_n71475472)
print v(xbgr.mr_n71475792)
print v(xbgr.mr_n71475904)
print v(xbgr.mr_n71476224)
print v(xbgr.mr_n71476336)
print v(xbgr.mr_n71476656)
print v(xbgr.mr_n71476768)
print v(xbgr.mr_n71477088)
print v(xbgr.mr_n71477200)
print v(xbgr.mr_n71477520)
print v(xbgr.mr_n71477632)
print v(xbgr.mr_n71477952)
print v(xbgr.mr_n71478064)
print v(xbgr.mr_n71478384)
print v(xbgr.mr_n71478496)
print v(xbgr.mr_n71478816)
print v(xbgr.mr_n71478928)
print v(xbgr.mr_n71479248)
print v(xbgr.mr_n71479360)
print v(xbgr.mr_n71479680)
print v(xbgr.mr_n71479792)
print v(xbgr.mr_n71480112)
print v(xbgr.mr_n71480224)
print v(xbgr.mr_n71480544)
print v(xbgr.mr_n71480656)
print v(xbgr.mr_n71480976)
print v(xbgr.mr_n71481088)
print v(xbgr.mr_n71481408)
print v(xbgr.mr_n71481520)
print v(xbgr.mr_n71481840)
print v(xbgr.mr_n71481952)
print v(xbgr.mr_n71482272)
print v(xbgr.mr_n71482384)
print v(xbgr.mr_n71482704)
print v(xbgr.mr_n71482816)
print v(xbgr.mr_n71483136)
print v(xbgr.mr_n71483248)
print v(xbgr.mr_n71483568)
print v(xbgr.mr_n71483680)
print v(xbgr.mr_n71484000)
print v(xbgr.mr_n71484112)
print v(xbgr.mr_n71484320)
print v(xbgr.mr_n71484432)
print v(xbgr.mr_n71484752)
print v(xbgr.mr_n71484864)
print v(xbgr.mr_n71485184)
print v(xbgr.mr_n71485296)
print v(xbgr.mr_n71485616)
print v(xbgr.mr_n71485728)
print v(xbgr.mr_n71486048)
print v(xbgr.mr_n71486160)
print v(xbgr.mr_n71486480)
print v(xbgr.mr_n71486592)
print v(xbgr.mr_n71486912)
print v(xbgr.mr_n71487024)
print v(xbgr.mr_n71487344)
print v(xbgr.mr_n71487456)
print v(xbgr.mr_n71487776)
print v(xbgr.mr_n71487888)
print v(xbgr.mr_n71488208)
print v(xbgr.mr_n71488320)
print v(xbgr.mr_n71488640)
print v(xbgr.mr_n71488752)
print v(xbgr.mr_n71489072)
print v(xbgr.mr_n71489184)
print v(xbgr.mr_n71489504)
print v(xbgr.mr_n71489616)
print v(xbgr.mr_n71489936)
print v(xbgr.mr_n71490048)
print v(xbgr.mr_n71490368)
print v(xbgr.mr_n71490480)
print v(xbgr.mr_n71490800)
print v(xbgr.mr_n71490912)
print v(xbgr.mr_n71491232)
print v(xbgr.mr_n71491344)
print v(xbgr.mr_n71491664)
print v(xbgr.mr_n71491776)
print v(xbgr.mr_n71492096)
print v(xbgr.mr_n71492208)
print v(xbgr.mr_n71492528)
print v(xbgr.mr_n71492640)
print v(xbgr.mr_n71492960)
print v(xbgr.mr_n71493072)
print v(xbgr.mr_n71493392)
print v(xbgr.mr_n71493504)
print v(xbgr.mr_n71493824)
print v(xbgr.mr_n71493936)
print v(xbgr.mr_n71494256)
print v(xbgr.mr_n71494368)
print v(xbgr.mr_n71494688)
print v(xbgr.mr_n71494800)
print v(xbgr.mr_n71495120)
print v(xbgr.mr_n71495232)
print v(xbgr.mr_n71495552)
print v(xbgr.mr_n71495664)
print v(xbgr.mr_n71495984)
print v(xbgr.mr_n71496096)
print v(xbgr.mr_n71496416)
print v(xbgr.mr_n71496528)
print v(xbgr.mr_n71496848)
print v(xbgr.mr_n71496960)
print v(xbgr.mr_n71497280)
print v(xbgr.mr_n71497392)
print v(xbgr.mr_n71497712)
print v(xbgr.mr_n71497824)
print v(xbgr.mr_n71498144)
print v(xbgr.mr_n71498256)
print v(xbgr.mr_n71498576)
print v(xbgr.mr_n71498688)
print v(xbgr.mr_n71499008)
print v(xbgr.mr_n71499120)
print v(xbgr.mr_n71499440)
print v(xbgr.mr_n71499552)
print v(xbgr.mr_n71499872)
print v(xbgr.mr_n71499984)
print v(xbgr.mr_n71500304)
print v(xbgr.mr_n71500416)
print v(xbgr.mr_n71500736)
print v(xbgr.mr_n71500848)
print v(xbgr.mr_n71501168)
print v(xbgr.mr_n71501280)
print v(xbgr.mr_n71501600)
print v(xbgr.mr_n71501712)
print v(xbgr.mr_n71502032)
print v(xbgr.mr_n71502144)
print v(xbgr.mr_n71502464)
print v(xbgr.mr_n71502576)
print v(xbgr.mr_n71502896)
print v(xbgr.mr_n71503008)
print v(xbgr.mr_n71503328)
print v(xbgr.mr_n71503440)
print v(xbgr.mr_n71503760)
print v(xbgr.mr_n71503872)
print v(xbgr.mr_n71504192)
print v(xbgr.mr_n71504304)
print v(xbgr.mr_n71504624)
print v(xbgr.mr_n71504736)
print v(xbgr.mr_n71505056)
print v(xbgr.mr_n71505168)
print v(xbgr.mr_n71505488)
print v(xbgr.mr_n71505600)
print v(xbgr.mr_n71505920)
print v(xbgr.mr_n71506032)
print v(xbgr.mr_n71506352)
print v(xbgr.mr_n71506464)
print v(xbgr.mr_n71506784)
print v(xbgr.mr_n71506896)
print v(xbgr.mr_n71507216)
print v(xbgr.mr_n71507328)
print v(xbgr.mr_n71507648)
print v(xbgr.mr_n71507760)
print v(xbgr.mr_n71508080)
print v(xbgr.mr_n71508192)
print v(xbgr.mr_n71508512)
print v(xbgr.mr_n71508624)
print v(xbgr.mr_n71508944)
print v(xbgr.mr_n71509056)
print v(xbgr.mr_n71509376)
print v(xbgr.mr_n71509488)
print v(xbgr.mr_n71509808)
print v(xbgr.mr_n71509920)
print v(xbgr.mr_n71510240)
print v(xbgr.mr_n71510352)
print v(xbgr.mr_n71510672)
print v(xbgr.mr_n71510784)
print v(xbgr.mr_n71511104)
print v(xbgr.mr_n71511216)
print v(xbgr.mr_n71511536)
print v(xbgr.mr_n71511648)
print v(xbgr.mr_n71511968)
print v(xbgr.mr_n71512080)
print v(xbgr.mr_n71512400)
print v(xbgr.mr_n71512512)
print v(xbgr.mr_n71512832)
print v(xbgr.mr_n71512944)
print v(xbgr.mr_n71513264)
print v(xbgr.mr_n71513376)
print v(xbgr.mr_n71513696)
print v(xbgr.mr_n71513808)
print v(xbgr.mr_n71514128)
print v(xbgr.mr_n71514240)
print v(xbgr.mr_n71514560)
print v(xbgr.mr_n71514672)
print v(xbgr.mr_n71514992)
print v(xbgr.mr_n71515104)
print v(xbgr.mr_n71515424)
print v(xbgr.mr_n71515536)
print v(xbgr.mr_n71515856)
print v(xbgr.mr_n71515968)
print v(xbgr.mr_n71516288)
print v(xbgr.mr_n71516400)
print v(xbgr.mr_n71516720)
print v(xbgr.mr_n71516832)
print v(xbgr.mr_n71517152)
print v(xbgr.mr_n71517264)
print v(xbgr.mr_n71517584)
print v(xbgr.mr_n71517696)
print v(xbgr.mr_n71518016)
print v(xbgr.mr_n71518128)
print v(xbgr.mr_n71518448)
print v(xbgr.mr_n71518560)
print v(xbgr.mr_n71518880)
print v(xbgr.mr_n71518992)
print v(xbgr.mr_n71519312)
print v(xbgr.mr_n71519424)
print v(xbgr.mr_n71519744)
print v(xbgr.mr_n71519856)
print v(xbgr.mr_n71520176)
print v(xbgr.mr_n71520288)
print v(xbgr.mr_n71520608)
print v(xbgr.mr_n71520720)
print v(xbgr.mr_n71521040)
print v(xbgr.mr_n71521152)
print v(xbgr.mr_n71521472)
print v(xbgr.mr_n71521584)
print v(xbgr.mr_n71521904)
print v(xbgr.mr_n71522016)
print v(xbgr.mr_n71522336)
print v(xbgr.mr_n71522448)
print v(xbgr.mr_n71522768)
print v(xbgr.mr_n71522880)
print v(xbgr.mr_n71523200)
print v(xbgr.mr_n71523312)
print v(xbgr.mr_n71523632)
print v(xbgr.mr_n71523744)
print v(xbgr.mr_n71524064)
print v(xbgr.mr_n71524176)
print v(xbgr.mr_n71524496)
print v(xbgr.mr_n71524608)
print v(xbgr.mr_n71524928)
print v(xbgr.mr_n71525040)
print v(xbgr.mr_n71525360)
print v(xbgr.mr_n71525472)
print v(xbgr.mr_n71525792)
print v(xbgr.mr_n71525904)
print v(xbgr.mr_n71526224)
print v(xbgr.mr_n71526336)
print v(xbgr.mr_n71526656)
print v(xbgr.mr_n71526768)
print v(xbgr.mr_n71527088)
print v(xbgr.mr_n71527200)
print v(xbgr.mr_n71527520)
print v(xbgr.mr_n71527632)
print v(xbgr.mr_n71527952)
print v(xbgr.mr_n71528064)
print v(xbgr.mr_n71528384)
print v(xbgr.mr_n71528496)
print v(xbgr.mr_n71528816)
print v(xbgr.mr_n71528928)
print v(xbgr.mr_n71529248)
print v(xbgr.mr_n71529360)
print v(xbgr.mr_n71529680)
print v(xbgr.mr_n71529792)
print v(xbgr.mr_n71530112)
print v(xbgr.mr_n71530224)
print v(xbgr.mr_n71530544)
print v(xbgr.mr_n71530656)
print v(xbgr.mr_n71530976)
print v(xbgr.mr_n71531088)
print v(xbgr.mr_n71531408)
print v(xbgr.mr_n71531520)
print v(xbgr.mr_n71531840)
print v(xbgr.mr_n71531952)
print v(xbgr.mr_n71532272)
print v(xbgr.mr_n71532384)
print v(xbgr.mr_n71532704)
print v(xbgr.mr_n71532816)
print v(xbgr.mr_n71533136)
print v(xbgr.mr_n71533248)
print v(xbgr.mr_n71533568)
print v(xbgr.mr_n71533680)
print v(xbgr.mr_n71534000)
print v(xbgr.mr_n71534112)
print v(xbgr.mr_n71534432)
print v(xbgr.mr_n71534544)
print v(xbgr.mr_n71534864)
print v(xbgr.mr_n71534976)
print v(xbgr.mr_n71535296)
print v(xbgr.mr_n71535408)
print v(xbgr.mr_n71535728)
print v(xbgr.mr_n71535840)
print v(xbgr.mr_n71536160)
print v(xbgr.mr_n71536272)
print v(xbgr.mr_n71536592)
print v(xbgr.mr_n71536704)
print v(xbgr.mr_n71537024)
print v(xbgr.mr_n71537136)
print v(xbgr.mr_n71537456)
print v(xbgr.mr_n71537568)
print v(xbgr.mr_n71537888)
print v(xbgr.mr_n71538000)
print v(xbgr.mr_n71538320)
print v(xbgr.mr_n71538432)
print v(xbgr.mr_n71538752)
print v(xbgr.mr_n71538864)
print v(xbgr.mr_n71539184)
print v(xbgr.mr_n71539296)
print v(xbgr.mr_n71539616)
print v(xbgr.mr_n71539728)
print v(xbgr.mr_n71540048)
print v(xbgr.mr_n71540160)
print v(xbgr.mr_n71540480)
print v(xbgr.mr_n71540592)
print v(xbgr.mr_n71540912)
print v(xbgr.mr_n71541024)
print v(xbgr.mr_n71541344)
print v(xbgr.mr_n71541456)
print v(xbgr.mr_n71541776)
print v(xbgr.mr_n71541888)
print v(xbgr.mr_n71542208)
print v(xbgr.mr_n71542320)
print v(xbgr.mr_n71542640)
print v(xbgr.mr_n71542752)
print v(xbgr.mr_n71543072)
print v(xbgr.mr_n71543184)
print v(xbgr.mr_n71543504)
print v(xbgr.mr_n71543616)
print v(xbgr.mr_n71543936)
print v(xbgr.mr_n71544048)
print v(xbgr.mr_n71544368)
print v(xbgr.mr_n71544480)
print v(xbgr.mr_n71544800)
print v(xbgr.mr_n71544912)
print v(xbgr.mr_n71545232)
print v(xbgr.mr_n71545344)
print v(xbgr.mr_n71545872)
print v(xbgr.mr_n71545984)
print v(xbgr.mr_n71546304)
print v(xbgr.mr_n71546416)
print v(xbgr.mr_n71546736)
print v(xbgr.mr_n71546848)
print v(xbgr.mr_n71547168)
print v(xbgr.mr_n71547280)
print v(xbgr.mr_n71547600)
print v(xbgr.mr_n71547712)
print v(xbgr.mr_n71548032)
print v(xbgr.mr_n71548144)
print v(xbgr.mr_n71548464)
print v(xbgr.mr_n71548576)
print v(xbgr.mr_n71548896)
print v(xbgr.mr_n71549008)
print v(xbgr.mr_n71549328)
print v(xbgr.mr_n71549440)
print v(xbgr.mr_n71549760)
print v(xbgr.mr_n71549872)
print v(xbgr.mr_n71550192)
print v(xbgr.mr_n71550304)
print v(xbgr.mr_n71550624)
print v(xbgr.mr_n71550736)
print v(xbgr.mr_n71551056)
print v(xbgr.mr_n71551168)
print v(xbgr.mr_n71551488)
print v(xbgr.mr_n71551600)
print v(xbgr.mr_n71551920)
print v(xbgr.mr_n71552032)
print v(xbgr.mr_n71552352)
print v(xbgr.mr_n71552464)
print v(xbgr.mr_n71552784)
print v(xbgr.mr_n71552896)
print v(xbgr.mr_n71553216)
print v(xbgr.mr_n71553328)
print v(xbgr.mr_n71553648)
print v(xbgr.mr_n71553760)
print v(xbgr.mr_n71554080)
print v(xbgr.mr_n71554192)
print v(xbgr.mr_n71554512)
print v(xbgr.mr_n71554624)
print v(xbgr.mr_n71554944)
print v(xbgr.mr_n71555056)
print v(xbgr.mr_n71555376)
print v(xbgr.mr_n71555488)
print v(xbgr.mr_n71555808)
print v(xbgr.mr_n71555920)
print v(xbgr.mr_n71556240)
print v(xbgr.mr_n71556352)
print v(xbgr.mr_n71556672)
print v(xbgr.mr_n71556784)
print v(xbgr.mr_n71557104)
print v(xbgr.mr_n71557216)
print v(xbgr.mr_n71557536)
print v(xbgr.mr_n71557648)
print v(xbgr.mr_n71557968)
print v(xbgr.mr_n71558080)
print v(xbgr.mr_n71558400)
print v(xbgr.mr_n71558512)
print v(xbgr.mr_n71558832)
print v(xbgr.mr_n71558944)
print v(xbgr.mr_n71559264)
print v(xbgr.mr_n71559376)
print v(xbgr.mr_n71559696)
print v(xbgr.mr_n71559808)
print v(xbgr.mr_n71560128)
print v(xbgr.mr_n71560240)
print v(xbgr.mr_n71560560)
print v(xbgr.mr_n71560672)
print v(xbgr.mr_n71560992)
print v(xbgr.mr_n71561104)
print v(xbgr.mr_n71561424)
print v(xbgr.mr_n71561536)
print v(xbgr.mr_n71561856)
print v(xbgr.mr_n71561968)
print v(xbgr.mr_n71562288)
print v(xbgr.mr_n71562400)
print v(xbgr.mr_n71562720)
print v(xbgr.mr_n71562832)
print v(xbgr.mr_n71563152)
print v(xbgr.mr_n71563264)
print v(xbgr.mr_n71563584)
print v(xbgr.mr_n71563696)
print v(xbgr.mr_n71564016)
print v(xbgr.mr_n71564128)
print v(xbgr.mr_n71564448)
print v(xbgr.mr_n71564560)
print v(xbgr.mr_n71564880)
print v(xbgr.mr_n71564992)
print v(xbgr.mr_n71565312)
print v(xbgr.mr_n71565424)
print v(xbgr.mr_n71565744)
print v(xbgr.mr_n71565856)
print v(xbgr.mr_n71566176)
print v(xbgr.mr_n71566288)
print v(xbgr.mr_n71566608)
print v(xbgr.mr_n71566720)
print v(xbgr.mr_n71567040)
print v(xbgr.mr_n71567152)
print v(xbgr.mr_n71567472)
print v(xbgr.mr_n71567584)
print v(xbgr.mr_n71567904)
print v(xbgr.mr_n71568016)
print v(xbgr.mr_n71568336)
print v(xbgr.mr_n71568448)
print v(xbgr.mr_n71568768)
print v(xbgr.mr_n71568880)
print v(xbgr.mr_n71569200)
print v(xbgr.mr_n71569312)
print v(xbgr.mr_n71569632)
print v(xbgr.mr_n71569744)
print v(xbgr.mr_n71570064)
print v(xbgr.mr_n71570176)
print v(xbgr.mr_n71570496)
print v(xbgr.mr_n71570608)
print v(xbgr.mr_n71570928)
print v(xbgr.mr_n71571040)
print v(xbgr.mr_n71571360)
print v(xbgr.mr_n71571472)
print v(xbgr.mr_n71571792)
print v(xbgr.mr_n71571904)
print v(xbgr.mr_n71572224)
print v(xbgr.mr_n71572336)
print v(xbgr.mr_n71572656)
print v(xbgr.mr_n71572768)
print v(xbgr.mr_n71573088)
print v(xbgr.mr_n71573200)
print v(xbgr.mr_n71573520)
print v(xbgr.mr_n71573632)
print v(xbgr.mr_n71573952)
print v(xbgr.mr_n71574064)
print v(xbgr.mr_n71574384)
print v(xbgr.mr_n71574496)
print v(xbgr.mr_n71574816)
print v(xbgr.mr_n71574928)
print v(xbgr.mr_n71575248)
print v(xbgr.mr_n71575360)
print v(xbgr.mr_n71575680)
print v(xbgr.mr_n71575792)
print v(xbgr.mr_n71576112)
print v(xbgr.mr_n71576224)
print v(xbgr.mr_n71576544)
print v(xbgr.mr_n71576656)
print v(xbgr.mr_n71576976)
print v(xbgr.mr_n71577088)
print v(xbgr.mr_n71577408)
print v(xbgr.mr_n71577520)
print v(xbgr.mr_n71577840)
print v(xbgr.mr_n71577952)
print v(xbgr.mr_n71578272)
print v(xbgr.mr_n71578384)
print v(xbgr.mr_n71578704)
print v(xbgr.mr_n71578816)
print v(xbgr.mr_n71579136)
print v(xbgr.mr_n71579248)
print v(xbgr.mr_n71579568)
print v(xbgr.mr_n71579680)
print v(xbgr.mr_n71580000)
print v(xbgr.mr_n71580112)
print v(xbgr.mr_n71580432)
print v(xbgr.mr_n71580544)
print v(xbgr.mr_n71580864)
print v(xbgr.mr_n71580976)
print v(xbgr.mr_n71581296)
print v(xbgr.mr_n71581408)
print v(xbgr.mr_n71581728)
print v(xbgr.mr_n71581840)
print v(xbgr.mr_n71582160)
print v(xbgr.mr_n71582272)
print v(xbgr.mr_n71582592)
print v(xbgr.mr_n71582704)
print v(xbgr.mr_n71583024)
print v(xbgr.mr_n71583136)
print v(xbgr.mr_n71583456)
print v(xbgr.mr_n71583568)
print v(xbgr.mr_n71583888)
print v(xbgr.mr_n71584000)
print v(xbgr.mr_n71584320)
print v(xbgr.mr_n71584432)
print v(xbgr.mr_n71584752)
print v(xbgr.mr_n71584864)
print v(xbgr.mr_n71585184)
print v(xbgr.mr_n71585296)
print v(xbgr.mr_n71847776)
print v(xbgr.mr_n71848016)
print v(xbgr.mr_n71848128)
print v(xbgr.mr_n71848448)
print v(xbgr.mr_n71848560)
print v(xbgr.mr_n71848880)
print v(xbgr.mr_n71848992)
print v(xbgr.mr_n71849312)
print v(xbgr.mr_n71849424)
print v(xbgr.mr_n71849744)
print v(xbgr.mr_n71849856)
print v(xbgr.mr_n71850176)
print v(xbgr.mr_n71850288)
print v(xbgr.mr_n71850608)
print v(xbgr.mr_n71850720)
print v(xbgr.mr_n71851040)
print v(xbgr.mr_n71851152)
print v(xbgr.mr_n71851472)
print v(xbgr.mr_n71851584)
print v(xbgr.mr_n71851904)
print v(xbgr.mr_n71852016)
print v(xbgr.mr_n71852336)
print v(xbgr.mr_n71852448)
print v(xbgr.mr_n71852768)
print v(xbgr.mr_n71852880)
print v(xbgr.mr_n71853200)
print v(xbgr.mr_n71853312)
print v(xbgr.mr_n71853632)
print v(xbgr.mr_n71853744)
print v(xbgr.mr_n71854064)
print v(xbgr.mr_n71854176)
print v(xbgr.mr_n71854496)
print v(xbgr.mr_n71854608)
print v(xbgr.mr_n71854928)
print v(xbgr.mr_n71855040)
print v(xbgr.mr_n71855360)
print v(xbgr.mr_n71855472)
print v(xbgr.mr_n71855792)
print v(xbgr.mr_n71855904)
print v(xbgr.mr_n71856224)
print v(xbgr.mr_n71856336)
print v(xbgr.mr_n71856656)
print v(xbgr.mr_n71856768)
print v(xbgr.mr_n71857088)
print v(xbgr.mr_n71857200)
print v(xbgr.mr_n71857520)
print v(xbgr.mr_n71857632)
print v(xbgr.mr_n71857952)
print v(xbgr.mr_n71858064)
print v(xbgr.mr_n71858384)
print v(xbgr.mr_n71858496)
print v(xbgr.mr_n71858816)
print v(xbgr.mr_n71858928)
print v(xbgr.mr_n71859248)
print v(xbgr.mr_n71859360)
print v(xbgr.mr_n71859680)
print v(xbgr.mr_n71859792)
print v(xbgr.mr_n71860112)
print v(xbgr.mr_n71860224)
print v(xbgr.mr_n71860544)
print v(xbgr.mr_n71860656)
print v(xbgr.mr_n71860976)
print v(xbgr.mr_n71861088)
print v(xbgr.mr_n71861408)
print v(xbgr.mr_n71861520)
print v(xbgr.mr_n71861840)
print v(xbgr.mr_n71861952)
print v(xbgr.mr_n71862272)
print v(xbgr.mr_n71862384)
print v(xbgr.mr_n71862704)
print v(xbgr.mr_n71862816)
print v(xbgr.mr_n71863136)
print v(xbgr.mr_n71863248)
print v(xbgr.mr_n71863568)
print v(xbgr.mr_n71863680)
print v(xbgr.mr_n71864000)
print v(xbgr.mr_n71864112)
print v(xbgr.mr_n71864432)
print v(xbgr.mr_n71864544)
print v(xbgr.mr_n71864864)
print v(xbgr.mr_n71864976)
print v(xbgr.mr_n71865296)
print v(xbgr.mr_n71865408)
print v(xbgr.mr_n71865728)
print v(xbgr.mr_n71865840)
print v(xbgr.mr_n71866160)
print v(xbgr.mr_n71866272)
print v(xbgr.mr_n71866592)
print v(xbgr.mr_n71866704)
print v(xbgr.mr_n71867024)
print v(xbgr.mr_n71867136)
print v(xbgr.mr_n71867456)
print v(xbgr.mr_n71867568)
print v(xbgr.mr_n71867888)
print v(xbgr.mr_n71868000)
print v(xbgr.mr_n71868320)
print v(xbgr.mr_n71868432)
print v(xbgr.mr_n71868752)
print v(xbgr.mr_n71868864)
print v(xbgr.mr_n71869184)
print v(xbgr.mr_n71869296)
print v(xbgr.mr_n71869616)
print v(xbgr.mr_n71869728)
print v(xbgr.mr_n71870048)
print v(xbgr.mr_n71870160)
print v(xbgr.mr_n71870480)
print v(xbgr.mr_n71870592)
print v(xbgr.mr_n71870912)
print v(xbgr.mr_n71871024)
print v(xbgr.mr_n71871344)
print v(xbgr.mr_n71871456)
print v(xbgr.mr_n71871776)
print v(xbgr.mr_n71871888)
print v(xbgr.mr_n71872208)
print v(xbgr.mr_n71872320)
print v(xbgr.mr_n71872640)
print v(xbgr.mr_n71872752)
print v(xbgr.mr_n71873072)
print v(xbgr.mr_n71873184)
print v(xbgr.mr_n71873504)
print v(xbgr.mr_n71873616)
print v(xbgr.mr_n71873936)
print v(xbgr.mr_n71874048)
print v(xbgr.mr_n71874368)
print v(xbgr.mr_n71874480)
print v(xbgr.mr_n71874800)
print v(xbgr.mr_n71874912)
print v(xbgr.mr_n71875232)
print v(xbgr.mr_n71875344)
print v(xbgr.mr_n71875664)
print v(xbgr.mr_n71875776)
print v(xbgr.mr_n71876096)
print v(xbgr.mr_n71876208)
print v(xbgr.mr_n71876528)
print v(xbgr.mr_n71876640)
print v(xbgr.mr_n71876960)
print v(xbgr.mr_n71877072)
print v(xbgr.mr_n71877392)
print v(xbgr.mr_n71877504)
print v(xbgr.mr_n71877824)
print v(xbgr.mr_n71877936)
print v(xbgr.mr_n71878256)
print v(xbgr.mr_n71878368)
print v(xbgr.mr_n71878688)
print v(xbgr.mr_n71878800)
print v(xbgr.mr_n71879120)
print v(xbgr.mr_n71879232)
print v(xbgr.mr_n71879552)
print v(xbgr.mr_n71879664)
print v(xbgr.mr_n71879984)
print v(xbgr.mr_n71880096)
print v(xbgr.mr_n71880416)
print v(xbgr.mr_n71880528)
print v(xbgr.mr_n71880848)
print v(xbgr.mr_n71880960)
print v(xbgr.mr_n71881280)
print v(xbgr.mr_n71881392)
print v(xbgr.mr_n71881712)
print v(xbgr.mr_n71881824)
print v(xbgr.mr_n71882144)
print v(xbgr.mr_n71882256)
print v(xbgr.mr_n71882576)
print v(xbgr.mr_n71882688)
print v(xbgr.mr_n71883008)
print v(xbgr.mr_n71883120)
print v(xbgr.mr_n71883440)
print v(xbgr.mr_n71883552)
print v(xbgr.mr_n71883872)
print v(xbgr.mr_n71883984)
print v(xbgr.mr_n71884304)
print v(xbgr.mr_n71884416)
print v(xbgr.mr_n71884736)
print v(xbgr.mr_n71884848)
print v(xbgr.mr_n71885168)
print v(xbgr.mr_n71885280)
print v(xbgr.mr_n71885600)
print v(xbgr.mr_n71885712)
print v(xbgr.mr_n71886032)
print v(xbgr.mr_n71886144)
print v(xbgr.mr_n71886464)
print v(xbgr.mr_n71886576)
print v(xbgr.mr_n71886896)
print v(xbgr.mr_n71887008)
print v(xbgr.mr_n71887328)
print v(xbgr.mr_n71887440)
print v(xbgr.mr_n71887760)
print v(xbgr.mr_n71887872)
print v(xbgr.mr_n71888192)
print v(xbgr.mr_n71888304)
print v(xbgr.mr_n71888624)
print v(xbgr.mr_n71888736)
print v(xbgr.mr_n71889056)
print v(xbgr.mr_n71889168)
print v(xbgr.mr_n71889488)
print v(xbgr.mr_n71889600)
print v(xbgr.mr_n71889920)
print v(xbgr.mr_n71890032)
print v(xbgr.mr_n71890352)
print v(xbgr.mr_n71890464)
print v(xbgr.mr_n71890784)
print v(xbgr.mr_n71890896)
print v(xbgr.mr_n71891216)
print v(xbgr.mr_n71891328)
print v(xbgr.mr_n71891648)
print v(xbgr.mr_n71891760)
print v(xbgr.mr_n71892080)
print v(xbgr.mr_n71892192)
print v(xbgr.mr_n71892512)
print v(xbgr.mr_n71892624)
print v(xbgr.mr_n71892944)
print v(xbgr.mr_n71893056)
print v(xbgr.mr_n71893376)
print v(xbgr.mr_n71893488)
print v(xbgr.mr_n71893808)
print v(xbgr.mr_n71893920)
print v(xbgr.mr_n71894240)
print v(xbgr.mr_n71894352)
print v(xbgr.mr_n71894672)
print v(xbgr.mr_n71894784)
print v(xbgr.mr_n71895104)
print v(xbgr.mr_n71895216)
print v(xbgr.mr_n71895536)
print v(xbgr.mr_n71895648)
print v(xbgr.mr_n71895968)
print v(xbgr.mr_n71896080)
print v(xbgr.mr_n71896400)
print v(xbgr.mr_n71896512)
print v(xbgr.mr_n71896832)
print v(xbgr.mr_n71896944)
print v(xbgr.mr_n71897264)
print v(xbgr.mr_n71897376)
print v(xbgr.mr_n71897696)
print v(xbgr.mr_n71897808)
print v(xbgr.mr_n71898128)
print v(xbgr.mr_n71898240)
print v(xbgr.mr_n71898560)
print v(xbgr.mr_n71898672)
print v(xbgr.mr_n71898992)
print v(xbgr.mr_n71899104)
print v(xbgr.mr_n71899424)
print v(xbgr.mr_n71899536)
print v(xbgr.mr_n71899856)
print v(xbgr.mr_n71899968)
print v(xbgr.mr_n71900288)
print v(xbgr.mr_n71900400)
print v(xbgr.mr_n71900720)
print v(xbgr.mr_n71900832)
print v(xbgr.mr_n71901152)
print v(xbgr.mr_n71901264)
print v(xbgr.mr_n71901584)
print v(xbgr.mr_n71901696)
print v(xbgr.mr_n71902016)
print v(xbgr.mr_n71902128)
print v(xbgr.mr_n71902448)
print v(xbgr.mr_n71902560)
print v(xbgr.mr_n71902880)
print v(xbgr.mr_n71902992)
print v(xbgr.mr_n71903312)
print v(xbgr.mr_n71903424)
print v(xbgr.mr_n71903744)
print v(xbgr.mr_n71903856)
print v(xbgr.mr_n71904176)
print v(xbgr.mr_n71904288)
print v(xbgr.mr_n71904608)
print v(xbgr.mr_n71904720)
print v(xbgr.mr_n71905040)
print v(xbgr.mr_n71905152)
print v(xbgr.mr_n71905472)
print v(xbgr.mr_n71905584)
print v(xbgr.mr_n71905904)
print v(xbgr.mr_n71906016)
print v(xbgr.mr_n71906336)
print v(xbgr.mr_n71906448)
print v(xbgr.mr_n71906768)
print v(xbgr.mr_n71906880)
print v(xbgr.mr_n71907200)
print v(xbgr.mr_n71907312)
print v(xbgr.mr_n71907632)
print v(xbgr.mr_n71907744)
print v(xbgr.mr_n71908064)
print v(xbgr.mr_n71908176)
print v(xbgr.mr_n71908496)
print v(xbgr.mr_n71908608)
print v(xbgr.mr_n71908928)
print v(xbgr.mr_n71909040)
print v(xbgr.mr_n71909360)
print v(xbgr.mr_n71909472)
print v(xbgr.mr_n71909792)
print v(xbgr.mr_n71909904)
print v(xbgr.mr_n71910224)
print v(xbgr.mr_n71910336)
print v(xbgr.mr_n71910656)
print v(xbgr.mr_n71910768)
print v(xbgr.mr_n71911088)
print v(xbgr.mr_n71911200)
print v(xbgr.mr_n71911520)
print v(xbgr.mr_n71911632)
print v(xbgr.mr_n71911952)
print v(xbgr.mr_n71912064)
print v(xbgr.mr_n71912384)
print v(xbgr.mr_n71912496)
print v(xbgr.mr_n71912816)
print v(xbgr.mr_n71912928)
print v(xbgr.mr_n71913248)
print v(xbgr.mr_n71913360)
print v(xbgr.mr_n71913680)
print v(xbgr.mr_n71913792)
print v(xbgr.mr_n71914112)
print v(xbgr.mr_n71914224)
print v(xbgr.mr_n71914544)
print v(xbgr.mr_n71914656)
print v(xbgr.mr_n71914976)
print v(xbgr.mr_n71915088)
print v(xbgr.mr_n71915408)
print v(xbgr.mr_n71915520)
print v(xbgr.mr_n71915840)
print v(xbgr.mr_n71915952)
print v(xbgr.mr_n71916272)
print v(xbgr.mr_n71916384)
print v(xbgr.mr_n71916704)
print v(xbgr.mr_n71916816)
print v(xbgr.mr_n71917136)
print v(xbgr.mr_n71917248)
print v(xbgr.mr_n71917568)
print v(xbgr.mr_n71917680)
print v(xbgr.mr_n71918000)
print v(xbgr.mr_n71918112)
print v(xbgr.mr_n71918432)
print v(xbgr.mr_n71918544)
print v(xbgr.mr_n71918864)
print v(xbgr.mr_n71918976)
print v(xbgr.mr_n71919296)
print v(xbgr.mr_n71919408)
print v(xbgr.mr_n71919728)
print v(xbgr.mr_n71919840)
print v(xbgr.mr_n71920160)
print v(xbgr.mr_n71920272)
print v(xbgr.mr_n71920592)
print v(xbgr.mr_n71920704)
print v(xbgr.mr_n71921024)
print v(xbgr.mr_n71921136)
print v(xbgr.mr_n71921456)
print v(xbgr.mr_n71921568)
print v(xbgr.mr_n71921888)
print v(xbgr.mr_n71922000)
print v(xbgr.mr_n71922320)
print v(xbgr.mr_n71922432)
print v(xbgr.mr_n71922752)
print v(xbgr.mr_n71922864)
print v(xbgr.mr_n71923184)
print v(xbgr.mr_n71923296)
print v(xbgr.mr_n71923616)
print v(xbgr.mr_n71923728)
print v(xbgr.mr_n71924048)
print v(xbgr.mr_n71924160)
print v(xbgr.mr_n71924480)
print v(xbgr.mr_n71924592)
print v(xbgr.mr_n71924912)
print v(xbgr.mr_n71925024)
print v(xbgr.mr_n71925344)
print v(xbgr.mr_n71925456)
print v(xbgr.mr_n71925776)
print v(xbgr.mr_n71925888)
print v(xbgr.mr_n71926208)
print v(xbgr.mr_n71926320)
print v(xbgr.mr_n71926640)
print v(xbgr.mr_n71926752)
print v(xbgr.mr_n71927072)
print v(xbgr.mr_n71927184)
print v(xbgr.mr_n71927504)
print v(xbgr.mr_n71927616)
print v(xbgr.mr_n71927936)
print v(xbgr.mr_n71928048)
print v(xbgr.mr_n71928368)
print v(xbgr.mr_n71928480)
print v(xbgr.mr_n71928800)
print v(xbgr.mr_n71928912)
print v(xbgr.mr_n71929232)
print v(xbgr.mr_n71929344)
print v(xbgr.mr_n71929664)
print v(xbgr.mr_n71929776)
print v(xbgr.mr_n71930096)
print v(xbgr.mr_n71930208)
print v(xbgr.mr_n71930528)
print v(xbgr.mr_n71930640)
print v(xbgr.mr_n71930960)
print v(xbgr.mr_n71931072)
print v(xbgr.mr_n71931392)
print v(xbgr.mr_n71931504)
print v(xbgr.mr_n71931824)
print v(xbgr.mr_n71931936)
print v(xbgr.mr_n71932256)
print v(xbgr.mr_n71932368)
print v(xbgr.mr_n71932688)
print v(xbgr.mr_n71932800)
print v(xbgr.mr_n71933120)
print v(xbgr.mr_n71933232)
print v(xbgr.mr_n71933552)
print v(xbgr.mr_n71933664)
print v(xbgr.mr_n71933984)
print v(xbgr.mr_n71934096)
print v(xbgr.mr_n71934416)
print v(xbgr.mr_n71934528)
print v(xbgr.mr_n71934848)
print v(xbgr.mr_n71934960)
print v(xbgr.mr_n71935280)
print v(xbgr.mr_n71935392)
print v(xbgr.mr_n71935712)
print v(xbgr.mr_n71935824)
print v(xbgr.mr_n71936144)
print v(xbgr.mr_n71936256)
print v(xbgr.mr_n71936576)
print v(xbgr.mr_n71936688)
print v(xbgr.mr_n71937008)
print v(xbgr.mr_n71937120)
print v(xbgr.mr_n71937440)
print v(xbgr.mr_n71937552)
print v(xbgr.mr_n71937872)
print v(xbgr.mr_n71937984)
print v(xbgr.mr_n71938304)
print v(xbgr.mr_n71938416)
print v(xbgr.mr_n71938736)
print v(xbgr.mr_n71938848)
print v(xbgr.mr_n71939168)
print v(xbgr.mr_n71939280)
print v(xbgr.mr_n71939600)
print v(xbgr.mr_n71939712)
print v(xbgr.mr_n71940032)
print v(xbgr.mr_n71940144)
print v(xbgr.mr_n71940464)
print v(xbgr.mr_n71940576)
print v(xbgr.mr_n71940896)
print v(xbgr.mr_n71941008)
print v(xbgr.mr_n71941328)
print v(xbgr.mr_n71941440)
print v(xbgr.mr_n71941760)
print v(xbgr.mr_n71941872)
print v(xbgr.mr_n71942192)
print v(xbgr.mr_n71942304)
print v(xbgr.mr_n71942624)
print v(xbgr.mr_n71942736)
print v(xbgr.mr_n71943056)
print v(xbgr.mr_n71943168)
print v(xbgr.mr_n71943488)
print v(xbgr.mr_n71943600)
print v(xbgr.mr_n71943920)
print v(xbgr.mr_n71944032)
print v(xbgr.mr_n71944352)
print v(xbgr.mr_n71944464)
print v(xbgr.mr_n71944784)
print v(xbgr.mr_n71944896)
print v(xbgr.mr_n71945216)
print v(xbgr.mr_n71945328)
print v(xbgr.mr_n71945648)
print v(xbgr.mr_n71945760)
print v(xbgr.mr_n71946080)
print v(xbgr.mr_n71946192)
print v(xbgr.mr_n71946512)
print v(xbgr.mr_n71946624)
print v(xbgr.mr_n71946944)
print v(xbgr.mr_n71947056)
print v(xbgr.mr_n71947376)
print v(xbgr.mr_n71947488)
print v(xbgr.mr_n71947808)
print v(xbgr.mr_n71947920)
print v(xbgr.mr_n71948240)
print v(xbgr.mr_n71948352)
print v(xbgr.mr_n71948672)
print v(xbgr.mr_n71948784)
print v(xbgr.mr_n71949104)
print v(xbgr.mr_n71949216)
print v(xbgr.mr_n71949536)
print v(xbgr.mr_n71949648)
print v(xbgr.mr_n71949968)
print v(xbgr.mr_n71950080)
print v(xbgr.mr_n71950400)
print v(xbgr.mr_n71950512)
print v(xbgr.mr_n71950832)
print v(xbgr.mr_n71950944)
print v(xbgr.mr_n71951264)
print v(xbgr.mr_n71951376)
print v(xbgr.mr_n71951696)
print v(xbgr.mr_n71951808)
print v(xbgr.mr_n71952128)
print v(xbgr.mr_n71952240)
print v(xbgr.mr_n71952560)
print v(xbgr.mr_n71952672)
print v(xbgr.mr_n71952992)
print v(xbgr.mr_n71953104)
print v(xbgr.mr_n71953424)
print v(xbgr.mr_n71953536)
print v(xbgr.mr_n71953856)
print v(xbgr.mr_n71953968)
print v(xbgr.mr_n71954288)
print v(xbgr.mr_n71954400)
print v(xbgr.mr_n71954720)
print v(xbgr.mr_n71954832)
print v(xbgr.mr_n71955152)
print v(xbgr.mr_n71955264)
print v(xbgr.mr_n71955584)
print v(xbgr.mr_n71955696)
print v(xbgr.mr_n71956016)
print v(xbgr.mr_n71956128)
print v(xbgr.mr_n71956448)
print v(xbgr.mr_n71956560)
print v(xbgr.mr_n71956880)
print v(xbgr.mr_n71956992)
print v(xbgr.mr_n71957312)
print v(xbgr.mr_n71957424)
print v(xbgr.mr_n71957744)
print v(xbgr.mr_n71957856)
print v(xbgr.mr_n71958176)
print v(xbgr.mr_n71958288)
print v(xbgr.mr_n71958608)
print v(xbgr.mr_n71958720)
print v(xbgr.mr_n71959040)
print v(xbgr.mr_n71959152)
print v(xbgr.mr_n71959472)
print v(xbgr.mr_n71959584)
print v(xbgr.mr_n71959904)
print v(xbgr.mr_n71960016)
print v(xbgr.mr_n71960336)
print v(xbgr.mr_n71960448)
print v(xbgr.mr_n71960768)
print v(xbgr.mr_n71960880)
print v(xbgr.mr_n71961200)
print v(xbgr.mr_n71961312)
print v(xbgr.mr_n71961632)
print v(xbgr.mr_n71961744)
print v(xbgr.mr_n71962064)
print v(xbgr.mr_n71962176)
print v(xbgr.mr_n71962496)
print v(xbgr.mr_n71962608)
print v(xbgr.mr_n71962928)
print v(xbgr.mr_n71963040)
print v(xbgr.mr_n71963360)
print v(xbgr.mr_n71963472)
print v(xbgr.mr_n71963792)
print v(xbgr.mr_n71963904)
print v(xbgr.mr_n71964224)
print v(xbgr.mr_n71964336)
print v(xbgr.mr_n71964656)
print v(xbgr.mr_n71964768)
print v(xbgr.mr_n71965088)
print v(xbgr.mr_n71965200)
print v(xbgr.mr_n71965520)
print v(xbgr.mr_n71965632)
print v(xbgr.mr_n71965952)
print v(xbgr.mr_n71966064)
print v(xbgr.mr_n71966384)
print v(xbgr.mr_n71966496)
print v(xbgr.mr_n71966816)
print v(xbgr.mr_n71966928)
print v(xbgr.mr_n71967248)
print v(xbgr.mr_n71967360)
print v(xbgr.mr_n71967680)
print v(xbgr.mr_n71967792)
print v(xbgr.mr_n71968112)
print v(xbgr.mr_n71968224)
print v(xbgr.mr_n71968544)
print v(xbgr.mr_n71968656)
print v(xbgr.mr_n71968976)
print v(xbgr.mr_n71969088)
print v(xbgr.mr_n71969408)
print v(xbgr.mr_n71969520)
print v(xbgr.mr_n71969840)
print v(xbgr.mr_n71969952)
print v(xbgr.mr_n71970272)
print v(xbgr.mr_n71970384)
print v(xbgr.mr_n71970704)
print v(xbgr.mr_n71970816)
print v(xbgr.mr_n71971136)
print v(xbgr.mr_n71971248)
print v(xbgr.mr_n71971568)
print v(xbgr.mr_n71971680)
print v(xbgr.mr_n71972000)
print v(xbgr.mr_n71972112)
print v(xbgr.mr_n71972432)
print v(xbgr.mr_n71972544)
print v(xbgr.mr_n71972864)
print v(xbgr.mr_n71972976)
print v(xbgr.mr_n71973296)
print v(xbgr.mr_n71973408)
print v(xbgr.mr_n71973728)
print v(xbgr.mr_n71973840)
print v(xbgr.mr_n71974160)
print v(xbgr.mr_n71974272)
print v(xbgr.mr_n71974592)
print v(xbgr.mr_n71974704)
print v(xbgr.mr_n71975024)
print v(xbgr.mr_n71975136)
print v(xbgr.mr_n71975456)
print v(xbgr.mr_n71975568)
print v(xbgr.mr_n71975888)
print v(xbgr.mr_n71976000)
print v(xbgr.mr_n71976320)
print v(xbgr.mr_n71976432)
print v(xbgr.mr_n71976752)
print v(xbgr.mr_n71976864)
print v(xbgr.mr_n71977184)
print v(xbgr.mr_n71977296)
print v(xbgr.mr_n71977616)
print v(xbgr.mr_n71977728)
print v(xbgr.mr_n71978048)
print v(xbgr.mr_n71978160)
print v(xbgr.mr_n71978480)
print v(xbgr.mr_n71978592)
print v(xbgr.mr_n71978912)
print v(xbgr.mr_n71979024)
print v(xbgr.mr_n71979344)
print v(xbgr.mr_n71979456)
print v(xbgr.mr_n71979776)
print v(xbgr.mr_n71979888)
print v(xbgr.mr_n71980208)
print v(xbgr.mr_n71980320)
print v(xbgr.mr_n71980640)
print v(xbgr.mr_n71980752)
print v(xbgr.mr_n71981072)
print v(xbgr.mr_n71981184)
print v(xbgr.mr_n71981504)
print v(xbgr.mr_n71981616)
print v(xbgr.mr_n71981936)
print v(xbgr.mr_n71982048)
print v(xbgr.mr_n71982368)
print v(xbgr.mr_n71982480)
print v(xbgr.mr_n71982800)
print v(xbgr.mr_n71982912)
print v(xbgr.mr_n71983232)
print v(xbgr.mr_n71983344)
print v(xbgr.mr_n71983664)
print v(xbgr.mr_n71983776)
print v(xbgr.mr_n71984096)
print v(xbgr.mr_n71984208)
print v(xbgr.mr_n71984528)
print v(xbgr.mr_n71984640)
print v(xbgr.mr_n71984960)
print v(xbgr.mr_n71985072)
print v(xbgr.mr_n71985392)
print v(xbgr.mr_n71985504)
print v(xbgr.mr_n71985824)
print v(xbgr.mr_n71985936)
print v(xbgr.mr_n71986256)
print v(xbgr.mr_n71986368)
print v(xbgr.mr_n71986688)
print v(xbgr.mr_n71986800)
print v(xbgr.mr_n71987120)
print v(xbgr.mr_n71987232)
print v(xbgr.mr_n71987552)
print v(xbgr.mr_n71987664)
print v(xbgr.mr_n71987984)
print v(xbgr.mr_n71988096)
print v(xbgr.mr_n71988416)
print v(xbgr.mr_n71988528)
print v(xbgr.mr_n71988848)
print v(xbgr.mr_n71988960)
print v(xbgr.mr_n71989280)
print v(xbgr.mr_n71989392)
print v(xbgr.mr_n71989712)
print v(xbgr.mr_n71989824)
print v(xbgr.mr_n71990144)
print v(xbgr.mr_n71990256)
print v(xbgr.mr_n71990576)
print v(xbgr.mr_n71990688)
print v(xbgr.mr_n71991008)
print v(xbgr.mr_n71991120)
print v(xbgr.mr_n71991440)
print v(xbgr.mr_n71991552)
print v(xbgr.mr_n71991872)
print v(xbgr.mr_n71991984)
print v(xbgr.mr_n71992304)
print v(xbgr.mr_n71992416)
print v(xbgr.mr_n71992736)
print v(xbgr.mr_n71992848)
print v(xbgr.mr_n71993168)
print v(xbgr.mr_n71993280)
print v(xbgr.mr_n71993600)
print v(xbgr.mr_n71993712)
print v(xbgr.mr_n71994032)
print v(xbgr.mr_n71994144)
print v(xbgr.mr_n71994464)
print v(xbgr.mr_n71994576)
print v(xbgr.mr_n71994896)
print v(xbgr.mr_n71995008)
print v(xbgr.mr_n71995328)
print v(xbgr.mr_n71995440)
print v(xbgr.mr_n71995760)
print v(xbgr.mr_n71995872)
print v(xbgr.mr_n71996192)
print v(xbgr.mr_n71996304)
print v(xbgr.mr_n71996624)
print v(xbgr.mr_n71996736)
print v(xbgr.mr_n71997056)
print v(xbgr.mr_n71997168)
print v(xbgr.mr_n71997488)
print v(xbgr.mr_n71997600)
print v(xbgr.mr_n71997920)
print v(xbgr.mr_n71998032)
print v(xbgr.mr_n71998352)
print v(xbgr.mr_n71998464)
print v(xbgr.mr_n71998784)
print v(xbgr.mr_n71998896)
print v(xbgr.mr_n71999216)
print v(xbgr.mr_n71999328)
print v(xbgr.mr_n71999648)
print v(xbgr.mr_n71999760)
print v(xbgr.mr_n72000080)
print v(xbgr.mr_n72000192)
print v(xbgr.mr_n72000512)
print v(xbgr.mr_n72000624)
print v(xbgr.mr_n72000944)
print v(xbgr.mr_n72001056)
print v(xbgr.mr_n72001376)
print v(xbgr.mr_n72001488)
print v(xbgr.mr_n72001808)
print v(xbgr.mr_n72001920)
print v(xbgr.mr_n72002240)
print v(xbgr.mr_n72002352)
print v(xbgr.mr_n72002672)
print v(xbgr.mr_n72002784)
print v(xbgr.mr_n72003104)
print v(xbgr.mr_n72003216)
print v(xbgr.mr_n72003536)
print v(xbgr.mr_n72003648)
print v(xbgr.mr_n72003968)
print v(xbgr.mr_n72004080)
print v(xbgr.mr_n72004400)
print v(xbgr.mr_n72004512)
print v(xbgr.mr_n72004832)
print v(xbgr.mr_n72004944)
print v(xbgr.mr_n72005264)
print v(xbgr.mr_n72005376)
print v(xbgr.mr_n72005696)
print v(xbgr.mr_n72005808)
print v(xbgr.mr_n72006128)
print v(xbgr.mr_n72006240)
print v(xbgr.mr_n72006560)
print v(xbgr.mr_n72006672)
print v(xbgr.mr_n72006992)
print v(xbgr.mr_n72007104)
print v(xbgr.mr_n72007424)
print v(xbgr.mr_n72007536)
print v(xbgr.mr_n72007856)
print v(xbgr.mr_n72007968)
print v(xbgr.mr_n72008288)
print v(xbgr.mr_n72008400)
print v(xbgr.mr_n72008720)
print v(xbgr.mr_n72008832)
print v(xbgr.mr_n72009152)
print v(xbgr.mr_n72009264)
print v(xbgr.mr_n72009584)
print v(xbgr.mr_n72009696)
print v(xbgr.mr_n72010016)
print v(xbgr.mr_n72010128)
print v(xbgr.mr_n72010448)
print v(xbgr.mr_n72010560)
print v(xbgr.mr_n72010880)
print v(xbgr.mr_n72010992)
print v(xbgr.mr_n72011312)
print v(xbgr.mr_n72011424)
print v(xbgr.mr_n72011744)
print v(xbgr.mr_n72011856)
print v(xbgr.mr_n72012176)
print v(xbgr.mr_n72012288)
print v(xbgr.mr_n72012608)
print v(xbgr.mr_n72012720)
print v(xbgr.mr_n72013040)
print v(xbgr.mr_n72013152)
print v(xbgr.mr_n72013472)
print v(xbgr.mr_n72013584)
print v(xbgr.mr_n72013904)
print v(xbgr.mr_n72014016)
print v(xbgr.mr_n72014336)
print v(xbgr.mr_n72014448)
print v(xbgr.mr_n72014768)
print v(xbgr.mr_n72014880)
print v(xbgr.mr_n72015200)
print v(xbgr.mr_n72015312)
print v(xbgr.mr_n72015632)
print v(xbgr.mr_n72015744)
print v(xbgr.mr_n72016064)
print v(xbgr.mr_n72016176)
print v(xbgr.mr_n72016496)
print v(xbgr.mr_n72016608)
print v(xbgr.mr_n72016928)
print v(xbgr.mr_n72017040)
print v(xbgr.mr_n72017360)
print v(xbgr.mr_n72017472)
print v(xbgr.mr_n72017792)
print v(xbgr.mr_n72017904)
print v(xbgr.mr_n72018224)
print v(xbgr.mr_n72018336)
print v(xbgr.mr_n72018656)
print v(xbgr.mr_n72018768)
print v(xbgr.mr_n72019088)
print v(xbgr.mr_n72019200)
print v(xbgr.mr_n72019520)
print v(xbgr.mr_n72019632)
print v(xbgr.mr_n72019952)
print v(xbgr.mr_n72020064)
print v(xbgr.mr_n72020384)
print v(xbgr.mr_n72020496)
print v(xbgr.mr_n72020816)
print v(xbgr.mr_n72020928)
print v(xbgr.mr_n72021248)
print v(xbgr.mr_n72021360)
print v(xbgr.mr_n72021680)
print v(xbgr.mr_n72021792)
print v(xbgr.mr_n72022112)
print v(xbgr.mr_n72022224)
print v(xbgr.mr_n72022544)
print v(xbgr.mr_n72022656)
print v(xbgr.mr_n72022976)
print v(xbgr.mr_n72023088)
print v(xbgr.mr_n72023408)
print v(xbgr.mr_n72023520)
print v(xbgr.mr_n72023840)
print v(xbgr.mr_n72023952)
print v(xbgr.mr_n72024272)
print v(xbgr.mr_n72024384)
print v(xbgr.mr_n72024704)
print v(xbgr.mr_n72024816)
print v(xbgr.mr_n72025136)
print v(xbgr.mr_n72025248)
print v(xbgr.mr_n72025568)
print v(xbgr.mr_n72025680)
print v(xbgr.mr_n72026000)
print v(xbgr.mr_n72026112)
print v(xbgr.mr_n72026432)
print v(xbgr.mr_n72026544)
print v(xbgr.mr_n72026864)
print v(xbgr.mr_n72026976)
print v(xbgr.mr_n72027296)
print v(xbgr.mr_n72027408)
print v(xbgr.mr_n72027728)
print v(xbgr.mr_n72027840)
print v(xbgr.mr_n72028160)
print v(xbgr.mr_n72028272)
print v(xbgr.mr_n72028592)
print v(xbgr.mr_n72028704)
print v(xbgr.mr_n72029024)
print v(xbgr.mr_n72029136)
print v(xbgr.mr_n72029456)
print v(xbgr.mr_n72029568)
print v(xbgr.mr_n72029888)
print v(xbgr.mr_n72030000)
print v(xbgr.mr_n72030320)
print v(xbgr.mr_n72030432)
print v(xbgr.mr_n72030752)
print v(xbgr.mr_n72030864)
print v(xbgr.mr_n72031184)
print v(xbgr.mr_n72031296)
print v(xbgr.mr_n72031616)
print v(xbgr.mr_n72031728)
print v(xbgr.mr_n72032048)
print v(xbgr.mr_n72032160)
print v(xbgr.mr_n72032480)
print v(xbgr.mr_n72032592)
print v(xbgr.mr_n72032912)
print v(xbgr.mr_n72033024)
print v(xbgr.mr_n72033344)
print v(xbgr.mr_n72033456)
print v(xbgr.mr_n72033776)
print v(xbgr.mr_n72033888)
print v(xbgr.mr_n72034208)
print v(xbgr.mr_n72034320)
print v(xbgr.mr_n72034640)
print v(xbgr.mr_n72034752)
print v(xbgr.mr_n72035072)
print v(xbgr.mr_n72035184)
print v(xbgr.mr_n72035504)
print v(xbgr.mr_n72035616)
print v(xbgr.mr_n72035936)
print v(xbgr.mr_n72036048)
print v(xbgr.mr_n72036368)
print v(xbgr.mr_n72036480)
print v(xbgr.mr_n72036800)
print v(xbgr.mr_n72036912)
print v(xbgr.mr_n72037232)
print v(xbgr.mr_n72037344)
print v(xbgr.mr_n72037664)
print v(xbgr.mr_n72037776)
print v(xbgr.mr_n72038096)
print v(xbgr.mr_n72038208)
print v(xbgr.mr_n72038528)
print v(xbgr.mr_n72038640)
print v(xbgr.mr_n72038960)
print v(xbgr.mr_n72039072)
print v(xbgr.mr_n72039392)
print v(xbgr.mr_n72039504)
print v(xbgr.mr_n72039824)
print v(xbgr.mr_n72039936)
print v(xbgr.mr_n72040256)
print v(xbgr.mr_n72040368)
print v(xbgr.mr_n72040688)
print v(xbgr.mr_n72040800)
print v(xbgr.mr_n72041120)
print v(xbgr.mr_n72041232)
print v(xbgr.mr_n72041552)
print v(xbgr.mr_n72041664)
print v(xbgr.mr_n72041984)
print v(xbgr.mr_n72042096)
print v(xbgr.mr_n72042416)
print v(xbgr.mr_n72042528)
print v(xbgr.mr_n72042848)
print v(xbgr.mr_n72042960)
print v(xbgr.mr_n72043280)
print v(xbgr.mr_n72043392)
print v(xbgr.mr_n72043712)
print v(xbgr.mr_n72043824)
print v(xbgr.mr_n72044144)
print v(xbgr.mr_n72044256)
print v(xbgr.mr_n72044576)
print v(xbgr.mr_n72044688)
print v(xbgr.mr_n72045008)
print v(xbgr.mr_n72045120)
print v(xbgr.mr_n72045424)
print v(xbgr.mr_n72045536)
print v(xbgr.mr_n72045856)
print v(xbgr.mr_n72045968)
print v(xbgr.mr_n72046288)
print v(xbgr.mr_n72046400)
print v(xbgr.mr_n72046720)
print v(xbgr.mr_n72046832)
print v(xbgr.mr_n72047152)
print v(xbgr.mr_n72047264)
print v(xbgr.mr_n72047584)
print v(xbgr.mr_n72047696)
print v(xbgr.mr_n72048016)
print v(xbgr.mr_n72048128)
print v(xbgr.mr_n72048448)
print v(xbgr.mr_n72048560)
print v(xbgr.mr_n72048880)
print v(xbgr.mr_n72048992)
print v(xbgr.mr_n72049312)
print v(xbgr.mr_n72049424)
print v(xbgr.mr_n72049744)
print v(xbgr.mr_n72049856)
print v(xbgr.mr_n72050176)
print v(xbgr.mr_n72050288)
print v(xbgr.mr_n72050608)
print v(xbgr.mr_n72050720)
print v(xbgr.mr_n72051040)
print v(xbgr.mr_n72051152)
print v(xbgr.mr_n72051472)
print v(xbgr.mr_n72051584)
print v(xbgr.mr_n72051904)
print v(xbgr.mr_n72052016)
print v(xbgr.mr_n72052336)
print v(xbgr.mr_n72052448)
print v(xbgr.mr_n72052768)
print v(xbgr.mr_n72052880)
print v(xbgr.mr_n72053200)
print v(xbgr.mr_n72053312)
print v(xbgr.mr_n72053632)
print v(xbgr.mr_n72053744)
print v(xbgr.mr_n72054064)
print v(xbgr.mr_n72054176)
print v(xbgr.mr_n72054496)
print v(xbgr.mr_n72054608)
print v(xbgr.mr_n72054928)
print v(xbgr.mr_n72055040)
print v(xbgr.mr_n72055360)
print v(xbgr.mr_n72055472)
print v(xbgr.mr_n72055792)
print v(xbgr.mr_n72055904)
print v(xbgr.mr_n72056224)
print v(xbgr.mr_n72056336)
print v(xbgr.mr_n72056656)
print v(xbgr.mr_n72056768)
print v(xbgr.mr_n72057088)
print v(xbgr.mr_n72057200)
print v(xbgr.mr_n72057520)
print v(xbgr.mr_n72057632)
print v(xbgr.mr_n72057952)
print v(xbgr.mr_n72058064)
print v(xbgr.mr_n72058384)
print v(xbgr.mr_n72058496)
print v(xbgr.mr_n72058816)
print v(xbgr.mr_n72058928)
print v(xbgr.mr_n72059248)
print v(xbgr.mr_n72059360)
print v(xbgr.mr_n72059680)
print v(xbgr.mr_n72059792)
print v(xbgr.mr_n72060112)
print v(xbgr.mr_n72060224)
print v(xbgr.mr_n72060544)
print v(xbgr.mr_n72060656)
print v(xbgr.mr_n72060976)
print v(xbgr.mr_n72061088)
print v(xbgr.mr_n72061408)
print v(xbgr.mr_n72061520)
print v(xbgr.mr_n72061840)
print v(xbgr.mr_n72061952)
print v(xbgr.mr_n72062272)
print v(xbgr.mr_n72062384)
print v(xbgr.mr_n72062704)
print v(xbgr.mr_n72062816)
print v(xbgr.mr_n72063136)
print v(xbgr.mr_n72063248)
print v(xbgr.mr_n72063568)
print v(xbgr.mr_n72063680)
print v(xbgr.mr_n72064000)
print v(xbgr.mr_n72064112)
print v(xbgr.mr_n72064432)
print v(xbgr.mr_n72064544)
print v(xbgr.mr_n72064864)
print v(xbgr.mr_n72064976)
print v(xbgr.mr_n72065296)
print v(xbgr.mr_n72065408)
print v(xbgr.mr_n72065728)
print v(xbgr.mr_n72065840)
print v(xbgr.mr_n72066160)
print v(xbgr.mr_n72066272)
print v(xbgr.mr_n72066592)
print v(xbgr.mr_n72066704)
print v(xbgr.mr_n72067024)
print v(xbgr.mr_n72067136)
print v(xbgr.mr_n72067456)
print v(xbgr.mr_n72067568)
print v(xbgr.mr_n72067888)
print v(xbgr.mr_n72068000)
print v(xbgr.mr_n72068320)
print v(xbgr.mr_n72068432)
print v(xbgr.mr_n72068752)
print v(xbgr.mr_n72068864)
print v(xbgr.mr_n72069184)
print v(xbgr.mr_n72069296)
print v(xbgr.mr_n72069616)
print v(xbgr.mr_n72069728)
print v(xbgr.mr_n72070048)
print v(xbgr.mr_n72070160)
print v(xbgr.mr_n72070480)
print v(xbgr.mr_n72070592)
print v(xbgr.mr_n72070912)
print v(xbgr.mr_n72071024)
print v(xbgr.mr_n72071344)
print v(xbgr.mr_n72071456)
print v(xbgr.mr_n72071776)
print v(xbgr.mr_n72071888)
print v(xbgr.mr_n72072208)
print v(xbgr.mr_n72072320)
print v(xbgr.mr_n72072640)
print v(xbgr.mr_n72072752)
print v(xbgr.mr_n72073072)
print v(xbgr.mr_n72073184)
print v(xbgr.mr_n72073504)
print v(xbgr.mr_n72073616)
print v(xbgr.mr_n72073936)
print v(xbgr.mr_n72074048)
print v(xbgr.mr_n72074368)
print v(xbgr.mr_n72074480)
print v(xbgr.mr_n72074800)
print v(xbgr.mr_n72074912)
print v(xbgr.mr_n72075232)
print v(xbgr.mr_n72075344)
print v(xbgr.mr_n72075664)
print v(xbgr.mr_n72075776)
print v(xbgr.mr_n72076096)
print v(xbgr.mr_n72076208)
print v(xbgr.mr_n72076528)
print v(xbgr.mr_n72076640)
print v(xbgr.mr_n72076960)
print v(xbgr.mr_n72077072)
print v(xbgr.mr_n72077392)
print v(xbgr.mr_n72077504)
print v(xbgr.mr_n72077824)
print v(xbgr.mr_n72077936)
print v(xbgr.mr_n72078256)
print v(xbgr.mr_n72078368)
print v(xbgr.mr_n72078688)
print v(xbgr.mr_n72078800)
print v(xbgr.mr_n72079120)
print v(xbgr.mr_n72079232)
print v(xbgr.mr_n72079552)
print v(xbgr.mr_n72079664)
print v(xbgr.mr_n72079984)
print v(xbgr.mr_n72080096)
print v(xbgr.mr_n72080416)
print v(xbgr.mr_n72080528)
print v(xbgr.mr_n72080848)
print v(xbgr.mr_n72080960)
print v(xbgr.mr_n72081280)
print v(xbgr.mr_n72081392)
print v(xbgr.mr_n72081712)
print v(xbgr.mr_n72081824)
print v(xbgr.mr_n72082144)
print v(xbgr.mr_n72082256)
print v(xbgr.mr_n72082576)
print v(xbgr.mr_n72082688)
print v(xbgr.mr_n72083008)
print v(xbgr.mr_n72083120)
print v(xbgr.mr_n72083440)
print v(xbgr.mr_n72083552)
print v(xbgr.mr_n72083872)
print v(xbgr.mr_n72083984)
print v(xbgr.mr_n72084304)
print v(xbgr.mr_n72084416)
print v(xbgr.mr_n72084736)
print v(xbgr.mr_n72084848)
print v(xbgr.mr_n72085168)
print v(xbgr.mr_n72085280)
print v(xbgr.mr_n72085600)
print v(xbgr.mr_n72085712)
print v(xbgr.mr_n72086032)
print v(xbgr.mr_n72086144)
print v(xbgr.mr_n72086464)
print v(xbgr.mr_n72086576)
print v(xbgr.mr_n72086896)
print v(xbgr.mr_n72087008)
print v(xbgr.mr_n72087328)
print v(xbgr.mr_n72087440)
print v(xbgr.mr_n72087760)
print v(xbgr.mr_n72087872)
print v(xbgr.mr_n72088192)
print v(xbgr.mr_n72088304)
print v(xbgr.mr_n72088624)
print v(xbgr.mr_n72088736)
print v(xbgr.mr_n72089056)
print v(xbgr.mr_n72089168)
print v(xbgr.mr_n72089488)
print v(xbgr.mr_n72089600)
print v(xbgr.mr_n72089920)
print v(xbgr.mr_n72090032)
print v(xbgr.mr_n72090352)
print v(xbgr.mr_n72090464)
print v(xbgr.mr_n72090784)
print v(xbgr.mr_n72090896)
print v(xbgr.mr_n72091216)
print v(xbgr.mr_n72091328)
print v(xbgr.mr_n72091648)
print v(xbgr.mr_n72091760)
print v(xbgr.mr_n72092080)
print v(xbgr.mr_n72092192)
print v(xbgr.mr_n72092512)
print v(xbgr.mr_n72092624)
print v(xbgr.mr_n72092944)
print v(xbgr.mr_n72093056)
print v(xbgr.mr_n72093376)
print v(xbgr.mr_n72093488)
print v(xbgr.mr_n72093808)
print v(xbgr.mr_n72093920)
print v(xbgr.mr_n72094240)
print v(xbgr.mr_n72094352)
print v(xbgr.mr_n72094672)
print v(xbgr.mr_n72094784)
print v(xbgr.mr_n72095104)
print v(xbgr.mr_n72095216)
print v(xbgr.mr_n72095536)
print v(xbgr.mr_n72095648)
print v(xbgr.mr_n72095968)
print v(xbgr.mr_n72096080)
print v(xbgr.mr_n72096400)
print v(xbgr.mr_n72096512)
print v(xbgr.mr_n72096832)
print v(xbgr.mr_n72096944)
print v(xbgr.mr_n72097264)
print v(xbgr.mr_n72097376)
print v(xbgr.mr_n72097696)
print v(xbgr.mr_n72097808)
print v(xbgr.mr_n72098128)
print v(xbgr.mr_n72098240)
print v(xbgr.mr_n72098560)
print v(xbgr.mr_n72098672)
print v(xbgr.mr_n72098992)
print v(xbgr.mr_n72099104)
print v(xbgr.mr_n72099424)
print v(xbgr.mr_n72099536)
print v(xbgr.mr_n72099856)
print v(xbgr.mr_n72099968)
print v(xbgr.mr_n72100288)
print v(xbgr.mr_n72100400)
print v(xbgr.mr_n72100720)
print v(xbgr.mr_n72100832)
print v(xbgr.mr_n72101152)
print v(xbgr.mr_n72101264)
print v(xbgr.mr_n72101584)
print v(xbgr.mr_n72101696)
print v(xbgr.mr_n72102016)
print v(xbgr.mr_n72102128)
print v(xbgr.mr_n72102448)
print v(xbgr.mr_n72102560)
print v(xbgr.mr_n72102880)
print v(xbgr.mr_n72102992)
print v(xbgr.mr_n72103312)
print v(xbgr.mr_n72103424)
print v(xbgr.mr_n72103744)
print v(xbgr.mr_n72103856)
print v(xbgr.mr_n72104176)
print v(xbgr.mr_n72104288)
print v(xbgr.mr_n72104608)
print v(xbgr.mr_n72104720)
print v(xbgr.mr_n72105040)
print v(xbgr.mr_n72105152)
print v(xbgr.mr_n72105472)
print v(xbgr.mr_n72105584)
print v(xbgr.mr_n72105904)
print v(xbgr.mr_n72106016)
print v(xbgr.mr_n72106336)
print v(xbgr.mr_n72106448)
print v(xbgr.mr_n72106768)
print v(xbgr.mr_n72106880)
print v(xbgr.mr_n72107200)
print v(xbgr.mr_n72107312)
print v(xbgr.mr_n72107632)
print v(xbgr.mr_n72107744)
print v(xbgr.mr_n72108064)
print v(xbgr.mr_n72108176)
print v(xbgr.mr_n72108496)
print v(xbgr.mr_n72108608)
print v(xbgr.mr_n72108928)
print v(xbgr.mr_n72109040)
print v(xbgr.mr_n72109360)
print v(xbgr.mr_n72109472)
print v(xbgr.mr_n72109792)
print v(xbgr.mr_n72109904)
print v(xbgr.mr_n72110224)
print v(xbgr.mr_n72110336)
print v(xbgr.mr_n72110656)
print v(xbgr.mr_n72110768)
print v(xbgr.mr_n72111088)
print v(xbgr.mr_n72111200)
print v(xbgr.mr_n72111520)
print v(xbgr.mr_n72111632)
print v(xbgr.mr_n72111952)
print v(xbgr.mr_n72112064)
print v(xbgr.mr_n72112384)
print v(xbgr.mr_n72112496)
print v(xbgr.mr_n72112816)
print v(xbgr.mr_n72112928)
print v(xbgr.mr_n72113248)
print v(xbgr.mr_n72113360)
print v(xbgr.mr_n72113680)
print v(xbgr.mr_n72113792)
print v(xbgr.mr_n72114112)
print v(xbgr.mr_n72114224)
print v(xbgr.mr_n72114544)
print v(xbgr.mr_n72114656)
print v(xbgr.mr_n72114976)
print v(xbgr.mr_n72115088)
print v(xbgr.mr_n72115408)
print v(xbgr.mr_n72115520)
print v(xbgr.mr_n72115840)
print v(xbgr.mr_n72115952)
print v(xbgr.mr_n72116272)
print v(xbgr.mr_n72116384)
print v(xbgr.mr_n72116704)
print v(xbgr.mr_n72116816)
print v(xbgr.mr_n72117136)
print v(xbgr.mr_n72117248)
print v(xbgr.mr_n72117568)
print v(xbgr.mr_n72117680)
print v(xbgr.mr_n72118000)
print v(xbgr.mr_n72118112)
print v(xbgr.mr_n72118432)
print v(xbgr.mr_n72118544)
print v(xbgr.mr_n72118864)
print v(xbgr.mr_n72118976)
print v(xbgr.mr_n72119296)
print v(xbgr.mr_n72119408)
print v(xbgr.mr_n72119728)
print v(xbgr.mr_n72119840)
print v(xbgr.mr_n72120160)
print v(xbgr.mr_n72120272)
print v(xbgr.mr_n72120592)
print v(xbgr.mr_n72120704)
print v(xbgr.mr_n72121024)
print v(xbgr.mr_n72121136)
print v(xbgr.mr_n72121456)
print v(xbgr.mr_n72121568)
print v(xbgr.mr_n72121888)
print v(xbgr.mr_n72122000)
print v(xbgr.mr_n72122320)
print v(xbgr.mr_n72122432)
print v(xbgr.mr_n72122752)
print v(xbgr.mr_n72122864)
print v(xbgr.mr_n72123184)
print v(xbgr.mr_n72123296)
print v(xbgr.mr_n72123616)
print v(xbgr.mr_n72123728)
print v(xbgr.mr_n72124048)
print v(xbgr.mr_n72124160)
print v(xbgr.mr_n72124480)
print v(xbgr.mr_n72124592)
print v(xbgr.mr_n72124912)
print v(xbgr.mr_n72125024)
print v(xbgr.mr_n72125344)
print v(xbgr.mr_n72125456)
print v(xbgr.mr_n72125776)
print v(xbgr.mr_n72125888)
print v(xbgr.mr_n72126208)
print v(xbgr.mr_n72126320)
print v(xbgr.mr_n72126640)
print v(xbgr.mr_n72126752)
print v(xbgr.mr_n72127072)
print v(xbgr.mr_n72127184)
print v(xbgr.mr_n72127504)
print v(xbgr.mr_n72127616)
print v(xbgr.mr_n72127936)
print v(xbgr.mr_n72128048)
print v(xbgr.mr_n72128368)
print v(xbgr.mr_n72128480)
print v(xbgr.mr_n72128800)
print v(xbgr.mr_n72128912)
print v(xbgr.mr_n72129232)
print v(xbgr.mr_n72129344)
print v(xbgr.mr_n72129664)
print v(xbgr.mr_n72129776)
print v(xbgr.mr_n72130096)
print v(xbgr.mr_n72130208)
print v(xbgr.mr_n72130528)
print v(xbgr.mr_n72130640)
print v(xbgr.mr_n72130960)
print v(xbgr.mr_n72131072)
print v(xbgr.mr_n72131392)
print v(xbgr.mr_n72131504)
print v(xbgr.mr_n72131824)
print v(xbgr.mr_n72131936)
print v(xbgr.mr_n72132256)
print v(xbgr.mr_n72132368)
print v(xbgr.mr_n72132688)
print v(xbgr.mr_n72132800)
print v(xbgr.mr_n72133120)
print v(xbgr.mr_n72133232)
print v(xbgr.mr_n72133552)
print v(xbgr.mr_n72133664)
print v(xbgr.mr_n72133984)
print v(xbgr.mr_n72134096)
print v(xbgr.mr_n72134416)
print v(xbgr.mr_n72134528)
print v(xbgr.mr_n72134848)
print v(xbgr.mr_n72134960)
print v(xbgr.mr_n72135280)
print v(xbgr.mr_n72135392)
print v(xbgr.mr_n72135712)
print v(xbgr.mr_n72135824)
print v(xbgr.mr_n72136144)
print v(xbgr.mr_n72136256)
print v(xbgr.mr_n72136576)
print v(xbgr.mr_n72136688)
print v(xbgr.mr_n72137008)
print v(xbgr.mr_n72137120)
print v(xbgr.mr_n72137440)
print v(xbgr.mr_n72137552)
print v(xbgr.mr_n72137872)
print v(xbgr.mr_n72137984)
print v(xbgr.mr_n72138304)
print v(xbgr.mr_n72138416)
print v(xbgr.mr_n72138736)
print v(xbgr.mr_n72138848)
print v(xbgr.mr_n72139168)
print v(xbgr.mr_n72139280)
print v(xbgr.mr_n72139600)
print v(xbgr.mr_n72139712)
print v(xbgr.mr_n72140032)
print v(xbgr.mr_n72140144)
print v(xbgr.mr_n72140464)
print v(xbgr.mr_n72140576)
print v(xbgr.mr_n72140896)
print v(xbgr.mr_n72141008)
print v(xbgr.mr_n72141328)
print v(xbgr.mr_n72141440)
print v(xbgr.mr_n72141760)
print v(xbgr.mr_n72141872)
print v(xbgr.mr_n72142192)
print v(xbgr.mr_n72142304)
print v(xbgr.mr_n72142624)
print v(xbgr.mr_n72142736)
print v(xbgr.mr_n72143056)
print v(xbgr.mr_n72143168)
print v(xbgr.mr_n72143488)
print v(xbgr.mr_n72143600)
print v(xbgr.mr_n72143920)
print v(xbgr.mr_n72144032)
print v(xbgr.mr_n72144352)
print v(xbgr.mr_n72144464)
print v(xbgr.mr_n72144784)
print v(xbgr.mr_n72144896)
print v(xbgr.mr_n72145216)
print v(xbgr.mr_n72145328)
print v(xbgr.mr_n72145648)
print v(xbgr.mr_n72145760)
print v(xbgr.mr_n72146080)
print v(xbgr.mr_n72146192)
print v(xbgr.mr_n72146512)
print v(xbgr.mr_n72146624)
print v(xbgr.mr_n72146944)
print v(xbgr.mr_n72147056)
print v(xbgr.mr_n72147376)
print v(xbgr.mr_n72147488)
print v(xbgr.mr_n72147808)
print v(xbgr.mr_n72147920)
print v(xbgr.mr_n72148240)
print v(xbgr.mr_n72148352)
print v(xbgr.mr_n72148672)
print v(xbgr.mr_n72148784)
print v(xbgr.mr_n72149104)
print v(xbgr.mr_n72149216)
print v(xbgr.mr_n72149536)
print v(xbgr.mr_n72149648)
print v(xbgr.mr_n72149968)
print v(xbgr.mr_n72150080)
print v(xbgr.mr_n72150400)
print v(xbgr.mr_n72150512)
print v(xbgr.mr_n72150832)
print v(xbgr.mr_n72150944)
print v(xbgr.mr_n72151264)
print v(xbgr.mr_n72151376)
print v(xbgr.mr_n72151696)
print v(xbgr.mr_n72151808)
print v(xbgr.mr_n72152128)
print v(xbgr.mr_n72152240)
print v(xbgr.mr_n72152560)
print v(xbgr.mr_n72152672)
print v(xbgr.mr_n72152992)
print v(xbgr.mr_n72153104)
print v(xbgr.mr_n72153424)
print v(xbgr.mr_n72153536)
print v(xbgr.mr_n72153856)
print v(xbgr.mr_n72153968)
print v(xbgr.mr_n72154288)
print v(xbgr.mr_n72154400)
print v(xbgr.mr_n72154720)
print v(xbgr.mr_n72154832)
print v(xbgr.mr_n72155152)
print v(xbgr.mr_n72155264)
print v(xbgr.mr_n72155584)
print v(xbgr.mr_n72155696)
print v(xbgr.mr_n72156016)
print v(xbgr.mr_n72156128)
print v(xbgr.mr_n72156448)
print v(xbgr.mr_n72156560)
print v(xbgr.mr_n72156880)
print v(xbgr.mr_n72156992)
print v(xbgr.mr_n72157312)
print v(xbgr.mr_n72157424)
print v(xbgr.mr_n72157744)
print v(xbgr.mr_n72157856)
print v(xbgr.mr_n72158176)
print v(xbgr.mr_n72158288)
print v(xbgr.mr_n72158608)
print v(xbgr.mr_n72158720)
print v(xbgr.mr_n72159040)
print v(xbgr.mr_n72159152)
print v(xbgr.mr_n72159472)
print v(xbgr.mr_n72159584)
print v(xbgr.mr_n72159904)
print v(xbgr.mr_n72160016)
print v(xbgr.mr_n72160336)
print v(xbgr.mr_n72160448)
print v(xbgr.mr_n72160768)
print v(xbgr.mr_n72160880)
print v(xbgr.mr_n72161200)
print v(xbgr.mr_n72161312)
print v(xbgr.mr_n72161632)
print v(xbgr.mr_n72161744)
print v(xbgr.mr_n72162064)
print v(xbgr.mr_n72162176)
print v(xbgr.mr_n72162496)
print v(xbgr.mr_n72162608)
print v(xbgr.mr_n72162928)
print v(xbgr.mr_n72163040)
print v(xbgr.mr_n72163360)
print v(xbgr.mr_n72163472)
print v(xbgr.mr_n72163792)
print v(xbgr.mr_n72163904)
print v(xbgr.mr_n72164224)
print v(xbgr.mr_n72164336)
print v(xbgr.mr_n72164656)
print v(xbgr.mr_n72164768)
print v(xbgr.mr_n72165088)
print v(xbgr.mr_n72165200)
print v(xbgr.mr_n72165520)
print v(xbgr.mr_n72165632)
print v(xbgr.mr_n72165952)
print v(xbgr.mr_n72166064)
print v(xbgr.mr_n72166384)
print v(xbgr.mr_n72166496)
print v(xbgr.mr_n72166816)
print v(xbgr.mr_n72166928)
print v(xbgr.mr_n72167248)
print v(xbgr.mr_n72167360)
print v(xbgr.mr_n72167680)
print v(xbgr.mr_n72167792)
print v(xbgr.mr_n72168112)
print v(xbgr.mr_n72168224)
print v(xbgr.mr_n72168544)
print v(xbgr.mr_n72168656)
print v(xbgr.mr_n72168976)
print v(xbgr.mr_n72169088)
print v(xbgr.mr_n72169408)
print v(xbgr.mr_n72169520)
print v(xbgr.mr_n72169840)
print v(xbgr.mr_n72169952)
print v(xbgr.mr_n72170272)
print v(xbgr.mr_n72170384)
print v(xbgr.mr_n72170704)
print v(xbgr.mr_n72170816)
print v(xbgr.mr_n72171136)
print v(xbgr.mr_n72171248)
print v(xbgr.mr_n72171568)
print v(xbgr.mr_n72171680)
print v(xbgr.mr_n72172000)
print v(xbgr.mr_n72172112)
print v(xbgr.mr_n72172432)
print v(xbgr.mr_n72172544)
print v(xbgr.mr_n72172864)
print v(xbgr.mr_n72172976)
print v(xbgr.mr_n72173296)
print v(xbgr.mr_n72173408)
print v(xbgr.mr_n72173728)
print v(xbgr.mr_n72173840)
print v(xbgr.mr_n72174160)
print v(xbgr.mr_n72174272)
print v(xbgr.mr_n72174592)
print v(xbgr.mr_n72174704)
print v(xbgr.mr_n72175024)
print v(xbgr.mr_n72175136)
print v(xbgr.mr_n72175456)
print v(xbgr.mr_n72175568)
print v(xbgr.mr_n72175888)
print v(xbgr.mr_n72176000)
print v(xbgr.mr_n72176320)
print v(xbgr.mr_n72176432)
print v(xbgr.mr_n72176752)
print v(xbgr.mr_n72176864)
print v(xbgr.mr_n72177184)
print v(xbgr.mr_n72177296)
print v(xbgr.mr_n72177616)
print v(xbgr.mr_n72177728)
print v(xbgr.mr_n72178048)
print v(xbgr.mr_n72178160)
print v(xbgr.mr_n72178480)
print v(xbgr.mr_n72178592)
print v(xbgr.mr_n72178912)
print v(xbgr.mr_n72179024)
print v(xbgr.mr_n72179344)
print v(xbgr.mr_n72179456)
print v(xbgr.mr_n72179776)
print v(xbgr.mr_n72179888)
print v(xbgr.mr_n72180208)
print v(xbgr.mr_n72180320)
print v(xbgr.mr_n72180640)
print v(xbgr.mr_n72180752)
print v(xbgr.mr_n72181072)
print v(xbgr.mr_n72181184)
print v(xbgr.mr_n72181504)
print v(xbgr.mr_n72181616)
print v(xbgr.mr_n72181936)
print v(xbgr.mr_n72182048)
print v(xbgr.mr_n72182368)
print v(xbgr.mr_n72182480)
print v(xbgr.mr_n72182800)
print v(xbgr.mr_n72182912)
print v(xbgr.mr_n72183232)
print v(xbgr.mr_n72183344)
print v(xbgr.mr_n72183664)
print v(xbgr.mr_n72183776)
print v(xbgr.mr_n72184096)
print v(xbgr.mr_n72184208)
print v(xbgr.mr_n72184528)
print v(xbgr.mr_n72184640)
print v(xbgr.mr_n72184960)
print v(xbgr.mr_n72185072)
print v(xbgr.mr_n72185392)
print v(xbgr.mr_n72185504)
print v(xbgr.mr_n72185824)
print v(xbgr.mr_n72185936)
print v(xbgr.mr_n72186256)
print v(xbgr.mr_n72186368)
print v(xbgr.mr_n72186688)
print v(xbgr.mr_n72186800)
print v(xbgr.mr_n72187120)
print v(xbgr.mr_n72187232)
print v(xbgr.mr_n72187552)
print v(xbgr.mr_n72187664)
print v(xbgr.mr_n72187984)
print v(xbgr.mr_n72188096)
print v(xbgr.mr_n72188416)
print v(xbgr.mr_n72188528)
print v(xbgr.mr_n72188848)
print v(xbgr.mr_n72188960)
print v(xbgr.mr_n72189280)
print v(xbgr.mr_n72189392)
print v(xbgr.mr_n72189712)
print v(xbgr.mr_n72189824)
print v(xbgr.mr_n72190144)
print v(xbgr.mr_n72190256)
print v(xbgr.mr_n72190576)
print v(xbgr.mr_n72190688)
print v(xbgr.mr_n72191008)
print v(xbgr.mr_n72191120)
print v(xbgr.mr_n72191440)
print v(xbgr.mr_n72191552)
print v(xbgr.mr_n72191872)
print v(xbgr.mr_n72191984)
print v(xbgr.mr_n72192304)
print v(xbgr.mr_n72192416)
print v(xbgr.mr_n72192736)
print v(xbgr.mr_n72192848)
print v(xbgr.mr_n72193168)
print v(xbgr.mr_n72193280)
print v(xbgr.mr_n72193600)
print v(xbgr.mr_n72193712)
print v(xbgr.mr_n72194032)
print v(xbgr.mr_n72194144)
print v(xbgr.mr_n72194464)
print v(xbgr.mr_n72194576)
print v(xbgr.mr_n72194896)
print v(xbgr.mr_n72195008)
print v(xbgr.mr_n72195328)
print v(xbgr.mr_n72195440)
print v(xbgr.mr_n72195760)
print v(xbgr.mr_n72195872)
print v(xbgr.mr_n72196192)
print v(xbgr.mr_n72196304)
print v(xbgr.mr_n72196624)
print v(xbgr.mr_n72196736)
print v(xbgr.mr_n72197056)
print v(xbgr.mr_n72197168)
print v(xbgr.mr_n72197488)
print v(xbgr.mr_n72197600)
print v(xbgr.mr_n72197920)
print v(xbgr.mr_n72198032)
print v(xbgr.mr_n72198352)
print v(xbgr.mr_n72198464)
print v(xbgr.mr_n72198784)
print v(xbgr.mr_n72198896)
print v(xbgr.mr_n72199216)
print v(xbgr.mr_n72199328)
print v(xbgr.mr_n72199648)
print v(xbgr.mr_n72199760)
print v(xbgr.mr_n72200080)
print v(xbgr.mr_n72200192)
print v(xbgr.mr_n72200512)
print v(xbgr.mr_n72200624)
print v(xbgr.mr_n72200944)
print v(xbgr.mr_n72201056)
print v(xbgr.mr_n72201376)
print v(xbgr.mr_n72201488)
print v(xbgr.mr_n72201808)
print v(xbgr.mr_n72201920)
print v(xbgr.mr_n72202240)
print v(xbgr.mr_n72202352)
print v(xbgr.mr_n72202672)
print v(xbgr.mr_n72202784)
print v(xbgr.mr_n72203104)
print v(xbgr.mr_n72203216)
print v(xbgr.mr_n72203536)
print v(xbgr.mr_n72203648)
print v(xbgr.mr_n72203968)
print v(xbgr.mr_n72204080)
print v(xbgr.mr_n72204400)
print v(xbgr.mr_n72204512)
print v(xbgr.mr_n72204832)
print v(xbgr.mr_n72204944)
print v(xbgr.mr_n72205264)
print v(xbgr.mr_n72205376)
print v(xbgr.mr_n72205696)
print v(xbgr.mr_n72205808)
print v(xbgr.mr_n72206128)
print v(xbgr.mr_n72206240)
print v(xbgr.mr_n72206560)
print v(xbgr.mr_n72206672)
print v(xbgr.mr_n72206992)
print v(xbgr.mr_n72207104)
print v(xbgr.mr_n72207424)
print v(xbgr.mr_n72207536)
print v(xbgr.mr_n72207856)
print v(xbgr.mr_n72207968)
print v(xbgr.mr_n72208288)
print v(xbgr.mr_n72208400)
print v(xbgr.mr_n72208720)
print v(xbgr.mr_n72208832)
print v(xbgr.mr_n72209152)
print v(xbgr.mr_n72209264)
print v(xbgr.mr_n72209584)
print v(xbgr.mr_n72209696)
print v(xbgr.mr_n72210016)
print v(xbgr.mr_n72210128)
print v(xbgr.mr_n72210448)
print v(xbgr.mr_n72210560)
print v(xbgr.mr_n72210880)
print v(xbgr.mr_n72210992)
print v(xbgr.mr_n72211312)
print v(xbgr.mr_n72211424)
print v(xbgr.mr_n72211744)
print v(xbgr.mr_n72211856)
print v(xbgr.mr_n72212176)
print v(xbgr.mr_n72212288)
print v(xbgr.mr_n72212608)
print v(xbgr.mr_n72212720)
print v(xbgr.mr_n72213040)
print v(xbgr.mr_n72213152)
print v(xbgr.mr_n72213472)
print v(xbgr.mr_n72213584)
print v(xbgr.mr_n72213904)
print v(xbgr.mr_n72214016)
print v(xbgr.mr_n72214336)
print v(xbgr.mr_n72214448)
print v(xbgr.mr_n72214768)
print v(xbgr.mr_n72214880)
print v(xbgr.mr_n72215200)
print v(xbgr.mr_n72215312)
print v(xbgr.mr_n72215632)
print v(xbgr.mr_n72215744)
print v(xbgr.mr_n72216064)
print v(xbgr.mr_n72216176)
print v(xbgr.mr_n72216496)
print v(xbgr.mr_n72216608)
print v(xbgr.mr_n72216928)
print v(xbgr.mr_n72217040)
print v(xbgr.mr_n72217360)
print v(xbgr.mr_n72217472)
print v(xbgr.mr_n72217792)
print v(xbgr.mr_n72217904)
print v(xbgr.mr_n72218224)
print v(xbgr.mr_n72218336)
print v(xbgr.mr_n72218656)
print v(xbgr.mr_n72218768)
print v(xbgr.mr_n72219088)
print v(xbgr.mr_n72219200)
print v(xbgr.mr_n72219520)
print v(xbgr.mr_n72219632)
print v(xbgr.mr_n72219952)
print v(xbgr.mr_n72220064)
print v(xbgr.mr_n72220384)
print v(xbgr.mr_n72220496)
print v(xbgr.mr_n72220816)
print v(xbgr.mr_n72220928)
print v(xbgr.mr_n72221248)
print v(xbgr.mr_n72221360)
print v(xbgr.mr_n72221680)
print v(xbgr.mr_n72221792)
print v(xbgr.mr_n72222112)
print v(xbgr.mr_n72222224)
print v(xbgr.mr_n72222544)
print v(xbgr.mr_n72222656)
print v(xbgr.mr_n72222976)
print v(xbgr.mr_n72223088)
print v(xbgr.mr_n72223408)
print v(xbgr.mr_n72223520)
print v(xbgr.mr_n72223840)
print v(xbgr.mr_n72223952)
print v(xbgr.mr_n72224272)
print v(xbgr.mr_n72224384)
print v(xbgr.mr_n72224704)
print v(xbgr.mr_n72224816)
print v(xbgr.mr_n72225136)
print v(xbgr.mr_n72225248)
print v(xbgr.mr_n72225568)
print v(xbgr.mr_n72225680)
print v(xbgr.mr_n72226000)
print v(xbgr.mr_n72226112)
print v(xbgr.mr_n72226432)
print v(xbgr.mr_n72226544)
print v(xbgr.mr_n72226864)
print v(xbgr.mr_n72226976)
print v(xbgr.mr_n72227296)
print v(xbgr.mr_n72227408)
print v(xbgr.mr_n72227728)
print v(xbgr.mr_n72227840)
print v(xbgr.mr_n72228160)
print v(xbgr.mr_n72228272)
print v(xbgr.mr_n72228592)
print v(xbgr.mr_n72228704)
print v(xbgr.mr_n72229024)
print v(xbgr.mr_n72229136)
print v(xbgr.mr_n72229456)
print v(xbgr.mr_n72229568)
print v(xbgr.mr_n72229888)
print v(xbgr.mr_n72230000)
print v(xbgr.mr_n72230320)
print v(xbgr.mr_n72230432)
print v(xbgr.mr_n72230752)
print v(xbgr.mr_n72230864)
print v(xbgr.mr_n72231184)
print v(xbgr.mr_n72231296)
print v(xbgr.mr_n72231616)
print v(xbgr.mr_n72231728)
print v(xbgr.mr_n72232048)
print v(xbgr.mr_n72232160)
print v(xbgr.mr_n72232480)
print v(xbgr.mr_n72232592)
print v(xbgr.mr_n72232912)
print v(xbgr.mr_n72233024)
print v(xbgr.mr_n72233344)
print v(xbgr.mr_n72233456)
print v(xbgr.mr_n72233776)
print v(xbgr.mr_n72233888)
print v(xbgr.mr_n72234208)
print v(xbgr.mr_n72234320)
print v(xbgr.mr_n72234640)
print v(xbgr.mr_n72234752)
print v(xbgr.mr_n72235072)
print v(xbgr.mr_n72235184)
print v(xbgr.mr_n72235504)
print v(xbgr.mr_n72235616)
print v(xbgr.mr_n72235936)
print v(xbgr.mr_n72236048)
print v(xbgr.mr_n72236368)
print v(xbgr.mr_n72236480)
print v(xbgr.mr_n72236800)
print v(xbgr.mr_n72236912)
print v(xbgr.mr_n72237232)
print v(xbgr.mr_n72237344)
print v(xbgr.mr_n72237664)
print v(xbgr.mr_n72237776)
print v(xbgr.mr_n72238096)
print v(xbgr.mr_n72238208)
print v(xbgr.mr_n72238528)
print v(xbgr.mr_n72238640)
print v(xbgr.mr_n72238960)
print v(xbgr.mr_n72239072)
print v(xbgr.mr_n72239392)
print v(xbgr.mr_n72239504)
print v(xbgr.mr_n72239824)
print v(xbgr.mr_n72239936)
print v(xbgr.mr_n72240256)
print v(xbgr.mr_n72240368)
print v(xbgr.mr_n72240688)
print v(xbgr.mr_n72240800)
print v(xbgr.mr_n72241120)
print v(xbgr.mr_n72241232)
print v(xbgr.mr_n72241552)
print v(xbgr.mr_n72241664)
print v(xbgr.mr_n72241984)
print v(xbgr.mr_n72242096)
print v(xbgr.mr_n72242416)
print v(xbgr.mr_n72242528)
print v(xbgr.mr_n72242848)
print v(xbgr.mr_n72242960)
print v(xbgr.mr_n72243280)
print v(xbgr.mr_n72243392)
print v(xbgr.mr_n72243712)
print v(xbgr.mr_n72243824)
print v(xbgr.mr_n72244144)
print v(xbgr.mr_n72244256)
print v(xbgr.mr_n72244576)
print v(xbgr.mr_n72244688)
print v(xbgr.mr_n72245008)
print v(xbgr.mr_n72245120)
print v(xbgr.mr_n72245440)
print v(xbgr.mr_n72245552)
print v(xbgr.mr_n72245872)
print v(xbgr.mr_n72245984)
print v(xbgr.mr_n72246304)
print v(xbgr.mr_n72246416)
print v(xbgr.mr_n72246736)
print v(xbgr.mr_n72246848)
print v(xbgr.mr_n72247168)
print v(xbgr.mr_n72247280)
print v(xbgr.mr_n72247600)
print v(xbgr.mr_n72247712)
print v(xbgr.mr_n72248032)
print v(xbgr.mr_n72248144)
print v(xbgr.mr_n72248464)
print v(xbgr.mr_n72248576)
print v(xbgr.mr_n72248896)
print v(xbgr.mr_n72249008)
print v(xbgr.mr_n72249328)
print v(xbgr.mr_n72249440)
print v(xbgr.mr_n72249760)
print v(xbgr.mr_n72249872)
print v(xbgr.mr_n72250192)
print v(xbgr.mr_n72250304)
print v(xbgr.mr_n72250624)
print v(xbgr.mr_n72250736)
print v(xbgr.mr_n72251056)
print v(xbgr.mr_n72251168)
print v(xbgr.mr_n72251488)
print v(xbgr.mr_n72251600)
print v(xbgr.mr_n72251920)
print v(xbgr.mr_n72252032)
print v(xbgr.mr_n72252352)
print v(xbgr.mr_n72252464)
print v(xbgr.mr_n72252784)
print v(xbgr.mr_n72252896)
print v(xbgr.mr_n72253216)
print v(xbgr.mr_n72253328)
print v(xbgr.mr_n72253648)
print v(xbgr.mr_n72253760)
print v(xbgr.mr_n72254080)
print v(xbgr.mr_n72254192)
print v(xbgr.mr_n72254512)
print v(xbgr.mr_n72254624)
print v(xbgr.mr_n72254944)
print v(xbgr.mr_n72255056)
print v(xbgr.mr_n72255376)
print v(xbgr.mr_n72255488)
print v(xbgr.mr_n72255808)
print v(xbgr.mr_n72255920)
print v(xbgr.mr_n72256240)
print v(xbgr.mr_n72256352)
print v(xbgr.mr_n72256672)
print v(xbgr.mr_n72256784)
print v(xbgr.mr_n72257104)
print v(xbgr.mr_n72257216)
print v(xbgr.mr_n72257536)
print v(xbgr.mr_n72257648)
print v(xbgr.mr_n72257968)
print v(xbgr.mr_n72258080)
print v(xbgr.mr_n72258400)
print v(xbgr.mr_n72258512)
print v(xbgr.mr_n72258832)
print v(xbgr.mr_n72258944)
print v(xbgr.mr_n72259264)
print v(xbgr.mr_n72259376)
print v(xbgr.mr_n72259696)
print v(xbgr.mr_n72259808)
print v(xbgr.mr_n72260128)
print v(xbgr.mr_n72260240)
print v(xbgr.mr_n72260560)
print v(xbgr.mr_n72260672)
print v(xbgr.mr_n72260992)
print v(xbgr.mr_n72261104)
print v(xbgr.mr_n72261424)
print v(xbgr.mr_n72261536)
print v(xbgr.mr_n72261856)
print v(xbgr.mr_n72261968)
print v(xbgr.mr_n72262288)
print v(xbgr.mr_n72262400)
print v(xbgr.mr_n72262720)
print v(xbgr.mr_n72262832)
print v(xbgr.mr_n72263152)
print v(xbgr.mr_n72263264)
print v(xbgr.mr_n72263584)
print v(xbgr.mr_n72263696)
print v(xbgr.mr_n72264016)
print v(xbgr.mr_n72264128)
print v(xbgr.mr_n72264448)
print v(xbgr.mr_n72264560)
print v(xbgr.mr_n72264880)
print v(xbgr.mr_n72264992)
print v(xbgr.mr_n72265312)
print v(xbgr.mr_n72265424)
print v(xbgr.mr_n72265744)
print v(xbgr.mr_n72265856)
print v(xbgr.mr_n72266176)
print v(xbgr.mr_n72266288)
print v(xbgr.mr_n72266608)
print v(xbgr.mr_n72266720)
print v(xbgr.mr_n72267040)
print v(xbgr.mr_n72267152)
print v(xbgr.mr_n72267472)
print v(xbgr.mr_n72267584)
print v(xbgr.mr_n72267904)
print v(xbgr.mr_n72268016)
print v(xbgr.mr_n72268336)
print v(xbgr.mr_n72268448)
print v(xbgr.mr_n72268768)
print v(xbgr.mr_n72268880)
print v(xbgr.mr_n72269200)
print v(xbgr.mr_n72269312)
print v(xbgr.mr_n72269632)
print v(xbgr.mr_n72269744)
print v(xbgr.mr_n72270064)
print v(xbgr.mr_n72270176)
print v(xbgr.mr_n72270496)
print v(xbgr.mr_n72270608)
print v(xbgr.mr_n72270928)
print v(xbgr.mr_n72271040)
print v(xbgr.mr_n72271360)
print v(xbgr.mr_n72271472)
print v(xbgr.mr_n72271792)
print v(xbgr.mr_n72271904)
print v(xbgr.mr_n72272224)
print v(xbgr.mr_n72272336)
print v(xbgr.mr_n72272656)
print v(xbgr.mr_n72272768)
print v(xbgr.mr_n72273088)
print v(xbgr.mr_n72273200)
print v(xbgr.mr_n72273520)
print v(xbgr.mr_n72273632)
print v(xbgr.mr_n72273952)
print v(xbgr.mr_n72274064)
print v(xbgr.mr_n72274384)
print v(xbgr.mr_n72274496)
print v(xbgr.mr_n72274816)
print v(xbgr.mr_n72274928)
print v(xbgr.mr_n72275248)
print v(xbgr.mr_n72275360)
print v(xbgr.mr_n72275680)
print v(xbgr.mr_n72275792)
print v(xbgr.mr_n72276112)
print v(xbgr.mr_n72276224)
print v(xbgr.mr_n72276544)
print v(xbgr.mr_n72276656)
print v(xbgr.mr_n72276976)
print v(xbgr.mr_n72277088)
print v(xbgr.mr_n72277408)
print v(xbgr.mr_n72277520)
print v(xbgr.mr_n72277840)
print v(xbgr.mr_n72277952)
print v(xbgr.mr_n72278272)
print v(xbgr.mr_n72278384)
print v(xbgr.mr_n72278704)
print v(xbgr.mr_n72278816)
print v(xbgr.mr_n72279136)
print v(xbgr.mr_n72279248)
print v(xbgr.mr_n72279568)
print v(xbgr.mr_n72279680)
print v(xbgr.mr_n72280000)
print v(xbgr.mr_n72280112)
print v(xbgr.mr_n72280432)
print v(xbgr.mr_n72280544)
print v(xbgr.mr_n72280864)
print v(xbgr.mr_n72280976)
print v(xbgr.mr_n72281296)
print v(xbgr.mr_n72281408)
print v(xbgr.mr_n72281728)
print v(xbgr.mr_n72281840)
print v(xbgr.mr_n72282160)
print v(xbgr.mr_n72282272)
print v(xbgr.mr_n72282592)
print v(xbgr.mr_n72282704)
print v(xbgr.mr_n72283024)
print v(xbgr.mr_n72283136)
print v(xbgr.mr_n72283456)
print v(xbgr.mr_n72283568)
print v(xbgr.mr_n72283888)
print v(xbgr.mr_n72284000)
print v(xbgr.mr_n72284320)
print v(xbgr.mr_n72284432)
print v(xbgr.mr_n72284752)
print v(xbgr.mr_n72284864)
print v(xbgr.mr_n72285184)
print v(xbgr.mr_n72285296)
print v(xbgr.mr_n72285616)
print v(xbgr.mr_n72285728)
print v(xbgr.mr_n72286048)
print v(xbgr.mr_n72286160)
print v(xbgr.mr_n72286480)
print v(xbgr.mr_n72286592)
print v(xbgr.mr_n72286912)
print v(xbgr.mr_n72287024)
print v(xbgr.mr_n72287344)
print v(xbgr.mr_n72287456)
print v(xbgr.mr_n72287776)
print v(xbgr.mr_n72287888)
print v(xbgr.mr_n72288208)
print v(xbgr.mr_n72288320)
print v(xbgr.mr_n72288640)
print v(xbgr.mr_n72288752)
print v(xbgr.mr_n72289072)
print v(xbgr.mr_n72289184)
print v(xbgr.mr_n72289504)
print v(xbgr.mr_n72289616)
print v(xbgr.mr_n72289936)
print v(xbgr.mr_n72290048)
print v(xbgr.mr_n72290368)
print v(xbgr.mr_n72290480)
print v(xbgr.mr_n72290800)
print v(xbgr.mr_n72290912)
print v(xbgr.mr_n72291232)
print v(xbgr.mr_n72291344)
print v(xbgr.mr_n72291664)
print v(xbgr.mr_n72291776)
print v(xbgr.mr_n72292096)
print v(xbgr.mr_n72292208)
print v(xbgr.mr_n72292528)
print v(xbgr.mr_n72292640)
print v(xbgr.mr_n72292960)
print v(xbgr.mr_n72293072)
print v(xbgr.mr_n72293392)
print v(xbgr.mr_n72293504)
print v(xbgr.mr_n72293824)
print v(xbgr.mr_n72293936)
print v(xbgr.mr_n72294256)
print v(xbgr.mr_n72294368)
print v(xbgr.mr_n72294688)
print v(xbgr.mr_n72294800)
print v(xbgr.mr_n72295120)
print v(xbgr.mr_n72295232)
print v(xbgr.mr_n72295552)
print v(xbgr.mr_n72295664)
print v(xbgr.mr_n72295984)
print v(xbgr.mr_n72296096)
print v(xbgr.mr_n72296416)
print v(xbgr.mr_n72296528)
print v(xbgr.mr_n72296848)
print v(xbgr.mr_n72296960)
print v(xbgr.mr_n72297280)
print v(xbgr.mr_n72297392)
print v(xbgr.mr_n72297712)
print v(xbgr.mr_n72297824)
print v(xbgr.mr_n72298144)
print v(xbgr.mr_n72298256)
print v(xbgr.mr_n72298576)
print v(xbgr.mr_n72298688)
print v(xbgr.mr_n72299008)
print v(xbgr.mr_n72299120)
print v(xbgr.mr_n72299440)
print v(xbgr.mr_n72299552)
print v(xbgr.mr_n72299872)
print v(xbgr.mr_n72299984)
print v(xbgr.mr_n72300304)
print v(xbgr.mr_n72300416)
print v(xbgr.mr_n72300736)
print v(xbgr.mr_n72300848)
print v(xbgr.mr_n72301168)
print v(xbgr.mr_n72301280)
print v(xbgr.mr_n72301600)
print v(xbgr.mr_n72301712)
print v(xbgr.mr_n72302032)
print v(xbgr.mr_n72302144)
print v(xbgr.mr_n72302464)
print v(xbgr.mr_n72302576)
print v(xbgr.mr_n72302896)
print v(xbgr.mr_n72303008)
print v(xbgr.mr_n72303328)
print v(xbgr.mr_n72303440)
print v(xbgr.mr_n72303760)
print v(xbgr.mr_n72303872)
print v(xbgr.mr_n72304192)
print v(xbgr.mr_n72304304)
print v(xbgr.mr_n72304624)
print v(xbgr.mr_n72304736)
print v(xbgr.mr_n72305056)
print v(xbgr.mr_n72305168)
print v(xbgr.mr_n72305488)
print v(xbgr.mr_n72305600)
print v(xbgr.mr_n72305920)
print v(xbgr.mr_n72306032)
print v(xbgr.mr_n72306352)
print v(xbgr.mr_n72306464)
print v(xbgr.mr_n72306784)
print v(xbgr.mr_n72306896)
print v(xbgr.mr_n72307216)
print v(xbgr.mr_n72307328)
print v(xbgr.mr_n72307648)
print v(xbgr.mr_n72307760)
print v(xbgr.mr_n72308080)
print v(xbgr.mr_n72308192)
print v(xbgr.mr_n72308512)
print v(xbgr.mr_n72308624)
print v(xbgr.mr_n72308944)
print v(xbgr.mr_n72309056)
print v(xbgr.mr_n72309376)
print v(xbgr.mr_n72309488)
print v(xbgr.mr_n72309808)
print v(xbgr.mr_n72309920)
print v(xbgr.mr_n72310240)
print v(xbgr.mr_n72310352)
print v(xbgr.mr_n72310672)
print v(xbgr.mr_n72310784)
print v(xbgr.mr_n72311104)
print v(xbgr.mr_n72311216)
print v(xbgr.mr_n72311536)
print v(xbgr.mr_n72311648)
print v(xbgr.mr_n72311968)
print v(xbgr.mr_n72312080)
print v(xbgr.mr_n72312400)
print v(xbgr.mr_n72312512)
print v(xbgr.mr_n72312832)
print v(xbgr.mr_n72312944)
print v(xbgr.mr_n72313264)
print v(xbgr.mr_n72313376)
print v(xbgr.mr_n72313696)
print v(xbgr.mr_n72313808)
print v(xbgr.mr_n72314128)
print v(xbgr.mr_n72314240)
print v(xbgr.mr_n72314560)
print v(xbgr.mr_n72314672)
print v(xbgr.mr_n72314992)
print v(xbgr.mr_n72315104)
print v(xbgr.mr_n72315424)
print v(xbgr.mr_n72315536)
print v(xbgr.mr_n72315856)
print v(xbgr.mr_n72315968)
print v(xbgr.mr_n72316288)
print v(xbgr.mr_n72316400)
print v(xbgr.mr_n72316720)
print v(xbgr.mr_n72316832)
print v(xbgr.mr_n72317152)
print v(xbgr.mr_n72317264)
print v(xbgr.mr_n72317584)
print v(xbgr.mr_n72317696)
print v(xbgr.mr_n72318016)
print v(xbgr.mr_n72318128)
print v(xbgr.mr_n72318448)
print v(xbgr.mr_n72318560)
print v(xbgr.mr_n72318880)
print v(xbgr.mr_n72318992)
print v(xbgr.mr_n72319312)
print v(xbgr.mr_n72319424)
print v(xbgr.mr_n72319744)
print v(xbgr.mr_n72319856)
print v(xbgr.mr_n72320176)
print v(xbgr.mr_n72320288)
print v(xbgr.mr_n72320608)
print v(xbgr.mr_n72320720)
print v(xbgr.mr_n72321040)
print v(xbgr.mr_n72321152)
print v(xbgr.mr_n72321472)
print v(xbgr.mr_n72321584)
print v(xbgr.mr_n72321904)
print v(xbgr.mr_n72322016)
print v(xbgr.mr_n72322336)
print v(xbgr.mr_n72322448)
print v(xbgr.mr_n72322768)
print v(xbgr.mr_n72322880)
print v(xbgr.mr_n72323200)
print v(xbgr.mr_n72323312)
print v(xbgr.mr_n72323632)
print v(xbgr.mr_n72323744)
print v(xbgr.mr_n72324064)
print v(xbgr.mr_n72324176)
print v(xbgr.mr_n72324496)
print v(xbgr.mr_n72324608)
print v(xbgr.mr_n72324928)
print v(xbgr.mr_n72325040)
print v(xbgr.mr_n72325360)
print v(xbgr.mr_n72325472)
print v(xbgr.mr_n72325792)
print v(xbgr.mr_n72325904)
print v(xbgr.mr_n72326224)
print v(xbgr.mr_n72326336)
print v(xbgr.mr_n72326656)
print v(xbgr.mr_n72326768)
print v(xbgr.mr_n72327088)
print v(xbgr.mr_n72327200)
print v(xbgr.mr_n72327520)
print v(xbgr.mr_n72327632)
print v(xbgr.mr_n72327952)
print v(xbgr.mr_n72328064)
print v(xbgr.mr_n72328384)
print v(xbgr.mr_n72328496)
print v(xbgr.mr_n72328816)
print v(xbgr.mr_n72328928)
print v(xbgr.mr_n72329248)
print v(xbgr.mr_n72329360)
print v(xbgr.mr_n72329680)
print v(xbgr.mr_n72329792)
print v(xbgr.mr_n72330112)
print v(xbgr.mr_n72330224)
print v(xbgr.mr_n72330544)
print v(xbgr.mr_n72330656)
print v(xbgr.mr_n72330976)
print v(xbgr.mr_n72331088)
print v(xbgr.mr_n72331408)
print v(xbgr.mr_n72331520)
print v(xbgr.mr_n72331840)
print v(xbgr.mr_n72331952)
print v(xbgr.mr_n72332272)
print v(xbgr.mr_n72332384)
print v(xbgr.mr_n72332704)
print v(xbgr.mr_n72332816)
print v(xbgr.mr_n72333136)
print v(xbgr.mr_n72333248)
print v(xbgr.mr_n72333568)
print v(xbgr.mr_n72333680)
print v(xbgr.mr_n72334000)
print v(xbgr.mr_n72334112)
print v(xbgr.mr_n72334432)
print v(xbgr.mr_n72334544)
print v(xbgr.mr_n72334864)
print v(xbgr.mr_n72334976)
print v(xbgr.mr_n72335296)
print v(xbgr.mr_n72335408)
print v(xbgr.mr_n72335728)
print v(xbgr.mr_n72335840)
print v(xbgr.mr_n72336160)
print v(xbgr.mr_n72336272)
print v(xbgr.mr_n72336592)
print v(xbgr.mr_n72336704)
print v(xbgr.mr_n72337024)
print v(xbgr.mr_n72337136)
print v(xbgr.mr_n72337456)
print v(xbgr.mr_n72337568)
print v(xbgr.mr_n72337888)
print v(xbgr.mr_n72338000)
print v(xbgr.mr_n72338320)
print v(xbgr.mr_n72338432)
print v(xbgr.mr_n72338752)
print v(xbgr.mr_n72338864)
print v(xbgr.mr_n72339184)
print v(xbgr.mr_n72339296)
print v(xbgr.mr_n72339616)
print v(xbgr.mr_n72339728)
print v(xbgr.mr_n72340048)
print v(xbgr.mr_n72340160)
print v(xbgr.mr_n72340480)
print v(xbgr.mr_n72340592)
print v(xbgr.mr_n72340912)
print v(xbgr.mr_n72341024)
print v(xbgr.mr_n72341344)
print v(xbgr.mr_n72341456)
print v(xbgr.mr_n72341776)
print v(xbgr.mr_n72341888)
print v(xbgr.mr_n72342208)
print v(xbgr.mr_n72342320)
print v(xbgr.mr_n72342640)
print v(xbgr.mr_n72342752)
print v(xbgr.mr_n72343072)
print v(xbgr.mr_n72343184)
print v(xbgr.mr_n72343504)
print v(xbgr.mr_n72343616)
print v(xbgr.mr_n72343936)
print v(xbgr.mr_n72344048)
print v(xbgr.mr_n72344368)
print v(xbgr.mr_n72344480)
print v(xbgr.mr_n72344800)
print v(xbgr.mr_n72344912)
print v(xbgr.mr_n72345232)
print v(xbgr.mr_n72345344)
print v(xbgr.mr_n72345664)
print v(xbgr.mr_n72345776)
print v(xbgr.mr_n72346096)
print v(xbgr.mr_n72346208)
print v(xbgr.mr_n72346528)
print v(xbgr.mr_n72346640)
print v(xbgr.mr_n72346960)
print v(xbgr.mr_n72347072)
print v(xbgr.mr_n72347392)
print v(xbgr.mr_n72347504)
print v(xbgr.mr_n72347824)
print v(xbgr.mr_n72347936)
print v(xbgr.mr_n72348256)
print v(xbgr.mr_n72348368)
print v(xbgr.mr_n72348688)
print v(xbgr.mr_n72348800)
print v(xbgr.mr_n72349120)
print v(xbgr.mr_n72349232)
print v(xbgr.mr_n72349552)
print v(xbgr.mr_n72349664)
print v(xbgr.mr_n72349984)
print v(xbgr.mr_n72350096)
print v(xbgr.mr_n72350416)
print v(xbgr.mr_n72350528)
print v(xbgr.mr_n72350848)
print v(xbgr.mr_n72350960)
print v(xbgr.mr_n72351280)
print v(xbgr.mr_n72351392)
print v(xbgr.mr_n72351712)
print v(xbgr.mr_n72351824)
print v(xbgr.mr_n72352144)
print v(xbgr.mr_n72352256)
print v(xbgr.mr_n72352576)
print v(xbgr.mr_n72352688)
print v(xbgr.mr_n72353008)
print v(xbgr.mr_n72353120)
print v(xbgr.mr_n72353440)
print v(xbgr.mr_n72353552)
print v(xbgr.mr_n72353872)
print v(xbgr.mr_n72353984)
print v(xbgr.mr_n72354304)
print v(xbgr.mr_n72354416)
print v(xbgr.mr_n72354736)
print v(xbgr.mr_n72354848)
print v(xbgr.mr_n72355168)
print v(xbgr.mr_n72355280)
print v(xbgr.mr_n72355600)
print v(xbgr.mr_n72355712)
print v(xbgr.mr_n72356032)
print v(xbgr.mr_n72356144)
print v(xbgr.mr_n72356464)
print v(xbgr.mr_n72356576)
print v(xbgr.mr_n72356896)
print v(xbgr.mr_n72357008)
print v(xbgr.mr_n72357328)
print v(xbgr.mr_n72357440)
print v(xbgr.mr_n72357760)
print v(xbgr.mr_n72357872)
print v(xbgr.mr_n72358192)
print v(xbgr.mr_n72358304)
print v(xbgr.mr_n72358624)
print v(xbgr.mr_n72358736)
print v(xbgr.mr_n72359056)
print v(xbgr.mr_n72359168)
print v(xbgr.mr_n72359488)
print v(xbgr.mr_n72359600)
print v(xbgr.mr_n72359920)
print v(xbgr.mr_n72360032)
print v(xbgr.mr_n72360352)
print v(xbgr.mr_n72360464)
print v(xbgr.mr_n72360784)
print v(xbgr.mr_n72360896)
print v(xbgr.mr_n72361216)
print v(xbgr.mr_n72361328)
print v(xbgr.mr_n72361648)
print v(xbgr.mr_n72361760)
print v(xbgr.mr_n72362080)
print v(xbgr.mr_n72362192)
print v(xbgr.mr_n72362512)
print v(xbgr.mr_n72362624)
print v(xbgr.mr_n72362944)
print v(xbgr.mr_n72363056)
print v(xbgr.mr_n72363376)
print v(xbgr.mr_n72363488)
print v(xbgr.mr_n72363808)
print v(xbgr.mr_n72363920)
print v(xbgr.mr_n72364240)
print v(xbgr.mr_n72364352)
print v(xbgr.mr_n72364672)
print v(xbgr.mr_n72364784)
print v(xbgr.mr_n72365104)
print v(xbgr.mr_n72365216)
print v(xbgr.mr_n72365536)
print v(xbgr.mr_n72365648)
print v(xbgr.mr_n72365968)
print v(xbgr.mr_n72366080)
print v(xbgr.mr_n72366400)
print v(xbgr.mr_n72366512)
print v(xbgr.mr_n72366832)
print v(xbgr.mr_n72366944)
print v(xbgr.mr_n72367264)
print v(xbgr.mr_n72367376)
print v(xbgr.mr_n72367696)
print v(xbgr.mr_n72367808)
print v(xbgr.mr_n72368128)
print v(xbgr.mr_n72368240)
print v(xbgr.mr_n72368560)
print v(xbgr.mr_n72368672)
print v(xbgr.mr_n72368992)
print v(xbgr.mr_n72369104)
print v(xbgr.mr_n72369424)
print v(xbgr.mr_n72369536)
print v(xbgr.mr_n72369856)
print v(xbgr.mr_n72369968)
print v(xbgr.mr_n72370288)
print v(xbgr.mr_n72370400)
print v(xbgr.mr_n72370720)
print v(xbgr.mr_n72370832)
print v(xbgr.mr_n72371152)
print v(xbgr.mr_n72371264)
print v(xbgr.mr_n72371584)
print v(xbgr.mr_n72371696)
print v(xbgr.mr_n72372016)
print v(xbgr.mr_n72372128)
print v(xbgr.mr_n72372448)
print v(xbgr.mr_n72372560)
print v(xbgr.mr_n72372880)
print v(xbgr.mr_n72372992)
print v(xbgr.mr_n72373312)
print v(xbgr.mr_n72373424)
print v(xbgr.mr_n72373744)
print v(xbgr.mr_n72373856)
print v(xbgr.mr_n72374176)
print v(xbgr.mr_n72374288)
print v(xbgr.mr_n72374608)
print v(xbgr.mr_n72374720)
print v(xbgr.mr_n72375040)
print v(xbgr.mr_n72375152)
print v(xbgr.mr_n72375472)
print v(xbgr.mr_n72375584)
print v(xbgr.mr_n72375904)
print v(xbgr.mr_n72376016)
print v(xbgr.mr_n72376336)
print v(xbgr.mr_n72376448)
print v(xbgr.mr_n72376768)
print v(xbgr.mr_n72376880)
print v(xbgr.mr_n72377200)
print v(xbgr.mr_n72377312)
print v(xbgr.mr_n72377632)
print v(xbgr.mr_n72377744)
print v(xbgr.mr_n72378064)
print v(xbgr.mr_n72378176)
print v(xbgr.mr_n72378496)
print v(xbgr.mr_n72378608)
print v(xbgr.mr_n72378928)
print v(xbgr.mr_n72379040)
print v(xbgr.mr_n72379360)
print v(xbgr.mr_n72379472)
print v(xbgr.mr_n72379792)
print v(xbgr.mr_n72379904)
print v(xbgr.mr_n72380224)
print v(xbgr.mr_n72380336)
print v(xbgr.mr_n72380656)
print v(xbgr.mr_n72380768)
print v(xbgr.mr_n72381088)
print v(xbgr.mr_n72381200)
print v(xbgr.mr_n72381520)
print v(xbgr.mr_n72381632)
print v(xbgr.mr_n72381952)
print v(xbgr.mr_n72382064)
print v(xbgr.mr_n72382384)
print v(xbgr.mr_n72382496)
print v(xbgr.mr_n72382816)
print v(xbgr.mr_n72382928)
print v(xbgr.mr_n72383248)
print v(xbgr.mr_n72383360)
print v(xbgr.mr_n72383680)
print v(xbgr.mr_n72383792)
print v(xbgr.mr_n72384112)
print v(xbgr.mr_n72384224)
print v(xbgr.mr_n72384544)
print v(xbgr.mr_n72384656)
print v(xbgr.mr_n72384976)
print v(xbgr.mr_n72385088)
print v(xbgr.mr_n72385408)
print v(xbgr.mr_n72385520)
print v(xbgr.mr_n72385840)
print v(xbgr.mr_n72385952)
print v(xbgr.mr_n72386272)
print v(xbgr.mr_n72386384)
print v(xbgr.mr_n72386704)
print v(xbgr.mr_n72386816)
print v(xbgr.mr_n72387136)
print v(xbgr.mr_n72387248)
print v(xbgr.mr_n72387568)
print v(xbgr.mr_n72387680)
print v(xbgr.mr_n72388000)
print v(xbgr.mr_n72388112)
print v(xbgr.mr_n72388432)
print v(xbgr.mr_n72388544)
print v(xbgr.mr_n72388864)
print v(xbgr.mr_n72388976)
print v(xbgr.mr_n72389296)
print v(xbgr.mr_n72389408)
print v(xbgr.mr_n72389728)
print v(xbgr.mr_n72389840)
print v(xbgr.mr_n72390160)
print v(xbgr.mr_n72390272)
print v(xbgr.mr_n72390592)
print v(xbgr.mr_n72390704)
print v(xbgr.mr_n72391024)
print v(xbgr.mr_n72391136)
print v(xbgr.mr_n72391456)
print v(xbgr.mr_n72391568)
print v(xbgr.mr_n72391888)
print v(xbgr.mr_n72392000)
print v(xbgr.mr_n72392320)
print v(xbgr.mr_n72392432)
print v(xbgr.mr_n72392752)
print v(xbgr.mr_n72392864)
print v(xbgr.mr_n72393184)
print v(xbgr.mr_n72393296)
print v(xbgr.mr_n72393616)
print v(xbgr.mr_n72393728)
print v(xbgr.mr_n72394048)
print v(xbgr.mr_n72394160)
print v(xbgr.mr_n72394480)
print v(xbgr.mr_n72394592)
print v(xbgr.mr_n72394912)
print v(xbgr.mr_n72395024)
print v(xbgr.mr_n72395344)
print v(xbgr.mr_n72395456)
print v(xbgr.mr_n72395776)
print v(xbgr.mr_n72395888)
print v(xbgr.mr_n72396208)
print v(xbgr.mr_n72396320)
print v(xbgr.mr_n72396640)
print v(xbgr.mr_n72396752)
print v(xbgr.mr_n72397072)
print v(xbgr.mr_n72397184)
print v(xbgr.mr_n72397504)
print v(xbgr.mr_n72397616)
print v(xbgr.mr_n72397936)
print v(xbgr.mr_n72398048)
print v(xbgr.mr_n72398368)
print v(xbgr.mr_n72398480)
print v(xbgr.mr_n72398800)
print v(xbgr.mr_n72398912)
print v(xbgr.mr_n72399232)
print v(xbgr.mr_n72399344)
print v(xbgr.mr_n72399664)
print v(xbgr.mr_n72399776)
print v(xbgr.mr_n72400096)
print v(xbgr.mr_n72400208)
print v(xbgr.mr_n72400528)
print v(xbgr.mr_n72400640)
print v(xbgr.mr_n72400960)
print v(xbgr.mr_n72401072)
print v(xbgr.mr_n72401392)
print v(xbgr.mr_n72401504)
print v(xbgr.mr_n72401824)
print v(xbgr.mr_n72401936)
print v(xbgr.mr_n72402256)
print v(xbgr.mr_n72402368)
print v(xbgr.mr_n72402688)
print v(xbgr.mr_n72402800)
print v(xbgr.mr_n72403120)
print v(xbgr.mr_n72403232)
print v(xbgr.mr_n72403552)
print v(xbgr.mr_n72403664)
print v(xbgr.mr_n72403984)
print v(xbgr.mr_n72404096)
print v(xbgr.mr_n72404416)
print v(xbgr.mr_n72404528)
print v(xbgr.mr_n72404848)
print v(xbgr.mr_n72404960)
print v(xbgr.mr_n72405280)
print v(xbgr.mr_n72405392)
print v(xbgr.mr_n72405712)
print v(xbgr.mr_n72405824)
print v(xbgr.mr_n72406144)
print v(xbgr.mr_n72406256)
print v(xbgr.mr_n72406576)
print v(xbgr.mr_n72406688)
print v(xbgr.mr_n72407008)
print v(xbgr.mr_n72407120)
print v(xbgr.mr_n72407440)
print v(xbgr.mr_n72407552)
print v(xbgr.mr_n72407872)
print v(xbgr.mr_n72407984)
print v(xbgr.mr_n72408304)
print v(xbgr.mr_n72408416)
print v(xbgr.mr_n72408736)
print v(xbgr.mr_n72408848)
print v(xbgr.mr_n72409168)
print v(xbgr.mr_n72409280)
print v(xbgr.mr_n72409600)
print v(xbgr.mr_n72409712)
print v(xbgr.mr_n72410032)
print v(xbgr.mr_n72410144)
print v(xbgr.mr_n72410464)
print v(xbgr.mr_n72410576)
print v(xbgr.mr_n72410896)
print v(xbgr.mr_n72411008)
print v(xbgr.mr_n72411328)
print v(xbgr.mr_n72411440)
print v(xbgr.mr_n72411760)
print v(xbgr.mr_n72411872)
print v(xbgr.mr_n72412192)
print v(xbgr.mr_n72412304)
print v(xbgr.mr_n72412624)
print v(xbgr.mr_n72412736)
print v(xbgr.mr_n72413056)
print v(xbgr.mr_n72413168)
print v(xbgr.mr_n72413488)
print v(xbgr.mr_n72413600)
print v(xbgr.mr_n72413920)
print v(xbgr.mr_n72414032)
print v(xbgr.mr_n72414352)
print v(xbgr.mr_n72414464)
print v(xbgr.mr_n72414784)
print v(xbgr.mr_n72414896)
print v(xbgr.mr_n72415216)
print v(xbgr.mr_n72415328)
print v(xbgr.mr_n72415648)
print v(xbgr.mr_n72415760)
print v(xbgr.mr_n72416080)
print v(xbgr.mr_n72416192)
print v(xbgr.mr_n72416512)
print v(xbgr.mr_n72416624)
print v(xbgr.mr_n72416944)
print v(xbgr.mr_n72417056)
print v(xbgr.mr_n72417376)
print v(xbgr.mr_n72417488)
print v(xbgr.mr_n72417808)
print v(xbgr.mr_n72417920)
print v(xbgr.mr_n72418240)
print v(xbgr.mr_n72418352)
print v(xbgr.mr_n72418672)
print v(xbgr.mr_n72418784)
print v(xbgr.mr_n72419104)
print v(xbgr.mr_n72419216)
print v(xbgr.mr_n72419536)
print v(xbgr.mr_n72419648)
print v(xbgr.mr_n72419968)
print v(xbgr.mr_n72420080)
print v(xbgr.mr_n72420400)
print v(xbgr.mr_n72420512)
print v(xbgr.mr_n72420832)
print v(xbgr.mr_n72420944)
print v(xbgr.mr_n72421264)
print v(xbgr.mr_n72421376)
print v(xbgr.mr_n72421696)
print v(xbgr.mr_n72421808)
print v(xbgr.mr_n72422128)
print v(xbgr.mr_n72422240)
print v(xbgr.mr_n72422560)
print v(xbgr.mr_n72422672)
print v(xbgr.mr_n72423104)
print v(xbgr.mr_n72423424)
print v(xbgr.mr_n72423536)
print v(xbgr.mr_n72423856)
print v(xbgr.mr_n72423968)
print v(xbgr.mr_n72424288)
print v(xbgr.mr_n72424400)
print v(xbgr.mr_n72424720)
print v(xbgr.mr_n72424832)
print v(xbgr.mr_n72425152)
print v(xbgr.mr_n72425264)
print v(xbgr.mr_n72425584)
print v(xbgr.mr_n72425696)
print v(xbgr.mr_n72426016)
print v(xbgr.mr_n72426128)
print v(xbgr.mr_n72426448)
print v(xbgr.mr_n72426560)
print v(xbgr.mr_n72426880)
print v(xbgr.mr_n72426992)
print v(xbgr.mr_n72427312)
print v(xbgr.mr_n72427424)
print v(xbgr.mr_n72427744)
print v(xbgr.mr_n72427856)
print v(xbgr.mr_n72428176)
print v(xbgr.mr_n72428288)
print v(xbgr.mr_n72428608)
print v(xbgr.mr_n72428720)
print v(xbgr.mr_n72429152)
print v(xbgr.mr_n72429472)
print v(xbgr.mr_n72429584)
print v(xbgr.mr_n72429904)
print v(xbgr.mr_n72430016)
print v(xbgr.mr_n72430336)
print v(xbgr.mr_n72430448)
print v(xbgr.mr_n72430768)
print v(xbgr.mr_n72430880)
print v(xbgr.mr_n72431200)
print v(xbgr.mr_n72431312)
print v(xbgr.mr_n72431632)
print v(xbgr.mr_n72431744)
print v(xbgr.mr_n72432064)
print v(xbgr.mr_n72432176)
print v(xbgr.mr_n72432496)
print v(xbgr.mr_n72432608)
print v(xbgr.mr_n72432928)
print v(xbgr.mr_n72433040)
print v(xbgr.mr_n72433360)
print v(xbgr.mr_n72433472)
print v(xbgr.mr_n72433792)
print v(xbgr.mr_n72433904)
print v(xbgr.mr_n72434224)
print v(xbgr.mr_n72434336)
print v(xbgr.mr_n72434656)
print v(xbgr.mr_n72434768)
print v(xbgr.mr_n72435088)
print v(xbgr.mr_n72435200)
print v(xbgr.mr_n72435520)
print v(xbgr.mr_n72435632)
print v(xbgr.mr_n72435952)
print v(xbgr.mr_n72436064)
print v(xbgr.mr_n72436384)
print v(xbgr.mr_n72436496)
print v(xbgr.mr_n72436816)
print v(xbgr.mr_n72436928)
print v(xbgr.mr_n72437248)
print v(xbgr.mr_n72437360)
print v(xbgr.mr_n72437680)
print v(xbgr.mr_n72437792)
print v(xbgr.mr_n72438112)
print v(xbgr.mr_n72438224)
print v(xbgr.mr_n72438544)
print v(xbgr.mr_n72438656)
print v(xbgr.mr_n72438976)
print v(xbgr.mr_n72439088)
print v(xbgr.mr_n72439408)
print v(xbgr.mr_n72439520)
print v(xbgr.mr_n72439840)
print v(xbgr.mr_n72439952)
print v(xbgr.mr_n72440272)
print v(xbgr.mr_n72440384)
print v(xbgr.mr_n72440704)
print v(xbgr.mr_n72440816)
print v(xbgr.mr_n72441136)
print v(xbgr.mr_n72441248)
print v(xbgr.mr_n72441568)
print v(xbgr.mr_n72441680)
print v(xbgr.mr_n72442000)
print v(xbgr.mr_n72442112)
print v(xbgr.mr_n72442432)
print v(xbgr.mr_n72442544)
print v(xbgr.mr_n72442864)
print v(xbgr.mr_n72442976)
print v(xbgr.mr_n72443296)
print v(xbgr.mr_n72443408)
print v(xbgr.mr_n72443728)
print v(xbgr.mr_n72443840)
print v(xbgr.mr_n72444160)
print v(xbgr.mr_n72444272)
print v(xbgr.mr_n72444592)
print v(xbgr.mr_n72444704)
print v(xbgr.mr_n72445024)
print v(xbgr.mr_n72445136)
print v(xbgr.mr_n72445456)
print v(xbgr.mr_n72445568)
print v(xbgr.mr_n72445888)
print v(xbgr.mr_n72446000)
print v(xbgr.mr_n72446320)
print v(xbgr.mr_n72446432)
print v(xbgr.mr_n72446752)
print v(xbgr.mr_n72446864)
print v(xbgr.mr_n72447184)
print v(xbgr.mr_n72447296)
print v(xbgr.mr_n72447616)
print v(xbgr.mr_n72447728)
print v(xbgr.mr_n72448048)
print v(xbgr.mr_n72448160)
print v(xbgr.mr_n72448480)
print v(xbgr.mr_n72448592)
print v(xbgr.mr_n72448912)
print v(xbgr.mr_n72449024)
print v(xbgr.mr_n72449344)
print v(xbgr.mr_n72449456)
print v(xbgr.mr_n72449776)
print v(xbgr.mr_n72449888)
print v(xbgr.mr_n72450208)
print v(xbgr.mr_n72450320)
print v(xbgr.mr_n72450640)
print v(xbgr.mr_n72450752)
print v(xbgr.mr_n72451072)
print v(xbgr.mr_n72451184)
print v(xbgr.mr_n72451504)
print v(xbgr.mr_n72451616)
print v(xbgr.mr_n72451936)
print v(xbgr.mr_n72452048)
print v(xbgr.mr_n72452368)
print v(xbgr.mr_n72452480)
print v(xbgr.mr_n72452800)
print v(xbgr.mr_n72452912)
print v(xbgr.mr_n72453232)
print v(xbgr.mr_n72453344)
print v(xbgr.mr_n72453664)
print v(xbgr.mr_n72453776)
print v(xbgr.mr_n72454096)
print v(xbgr.mr_n72454208)
print v(xbgr.mr_n72454528)
print v(xbgr.mr_n72454640)
print v(xbgr.mr_n72454960)
print v(xbgr.mr_n72455072)
print v(xbgr.mr_n72455392)
print v(xbgr.mr_n72455504)
print v(xbgr.mr_n72455824)
print v(xbgr.mr_n72455936)
print v(xbgr.mr_n72456256)
print v(xbgr.mr_n72456368)
print v(xbgr.mr_n72456688)
print v(xbgr.mr_n72456800)
print v(xbgr.mr_n72457120)
print v(xbgr.mr_n72457232)
print v(xbgr.mr_n72457552)
print v(xbgr.mr_n72457664)
print v(xbgr.mr_n72457984)
print v(xbgr.mr_n72458096)
print v(xbgr.mr_n72458416)
print v(xbgr.mr_n72458528)
print v(xbgr.mr_n72458848)
print v(xbgr.mr_n72458960)
print v(xbgr.mr_n72459280)
print v(xbgr.mr_n72459392)
print v(xbgr.mr_n72459712)
print v(xbgr.mr_n72459824)
print v(xbgr.mr_n72460144)
print v(xbgr.mr_n72460256)
print v(xbgr.mr_n72460576)
print v(xbgr.mr_n72460688)
print v(xbgr.mr_n72461008)
print v(xbgr.mr_n72461120)
print v(xbgr.mr_n72461440)
print v(xbgr.mr_n72461552)
print v(xbgr.mr_n72461984)
print v(xbgr.mr_n72462304)
print v(xbgr.mr_n72462416)
print v(xbgr.mr_n72462736)
print v(xbgr.mr_n72462848)
print v(xbgr.mr_n72463168)
print v(xbgr.mr_n72463280)
print v(xbgr.mr_n72463712)
print v(xbgr.mr_n72464032)
print v(xbgr.mr_n72464144)
print v(xbgr.mr_n72464464)
print v(xbgr.mr_n72464576)
print v(xbgr.mr_n72464896)
print v(xbgr.mr_n72465008)
print v(xbgr.mr_n72465440)
print v(xbgr.mr_n72465760)
print v(xbgr.mr_n72465872)
print v(xbgr.mr_n72466192)
print v(xbgr.mr_n72466304)
print v(xbgr.mr_n72466624)
print v(xbgr.mr_n72466736)
print v(xbgr.mr_n72467056)
print v(xbgr.mr_n72467168)
print v(xbgr.mr_n72467488)
print v(xbgr.mr_n72467600)
print v(xbgr.mr_n72467920)
print v(xbgr.mr_n72468032)
print v(xbgr.mr_n72468352)
print v(xbgr.mr_n72468464)
print v(xbgr.mr_n72468784)
print v(xbgr.mr_n72468896)
print v(xbgr.mr_n72469216)
print v(xbgr.mr_n72469328)
print v(xbgr.mr_n72469648)
print v(xbgr.mr_n72469760)
print v(xbgr.mr_n72470080)
print v(xbgr.mr_n72470192)
print v(xbgr.mr_n72470512)
print v(xbgr.mr_n72470624)
print v(xbgr.mr_n72470944)
print v(xbgr.mr_n72471056)
print v(xbgr.mr_n72471376)
print v(xbgr.mr_n72471488)
print v(xbgr.mr_n72471808)
print v(xbgr.mr_n72471920)
print v(xbgr.mr_n72472240)
print v(xbgr.mr_n72472352)
print v(xbgr.mr_n72472672)
print v(xbgr.mr_n72472784)
print v(xbgr.mr_n72473104)
print v(xbgr.mr_n72473216)
print v(xbgr.mr_n72473536)
print v(xbgr.mr_n72473648)
print v(xbgr.mr_n72473968)
print v(xbgr.mr_n72474080)
print v(xbgr.mr_n72474400)
print v(xbgr.mr_n72474512)
print v(xbgr.mr_n72474832)
print v(xbgr.mr_n72474944)
print v(xbgr.mr_n72475264)
print v(xbgr.mr_n72475376)
print v(xbgr.mr_n72475696)
print v(xbgr.mr_n72475808)
print v(xbgr.mr_n72476128)
print v(xbgr.mr_n72476240)
print v(xbgr.mr_n72476560)
print v(xbgr.mr_n72476672)
print v(xbgr.mr_n72476992)
print v(xbgr.mr_n72477104)
print v(xbgr.mr_n72477424)
print v(xbgr.mr_n72477536)
print v(xbgr.mr_n72477856)
print v(xbgr.mr_n72477968)
print v(xbgr.mr_n72478288)
print v(xbgr.mr_n72478400)
print v(xbgr.mr_n72478720)
print v(xbgr.mr_n72478832)
print v(xbgr.mr_n72479152)
print v(xbgr.mr_n72479264)
print v(xbgr.mr_n72479584)
print v(xbgr.mr_n72479696)
print v(xbgr.mr_n72480016)
print v(xbgr.mr_n72480128)
print v(xbgr.mr_n72480448)
print v(xbgr.mr_n72480560)
print v(xbgr.mr_n72480880)
print v(xbgr.mr_n72480992)
print v(xbgr.mr_n72481312)
print v(xbgr.mr_n72481424)
print v(xbgr.mr_n72481744)
print v(xbgr.mr_n72481856)
print v(xbgr.mr_n72482176)
print v(xbgr.mr_n72482288)
print v(xbgr.mr_n72482608)
print v(xbgr.mr_n72482720)
print v(xbgr.mr_n72483040)
print v(xbgr.mr_n72483152)
print v(xbgr.mr_n72483472)
print v(xbgr.mr_n72483584)
print v(xbgr.mr_n72483904)
print v(xbgr.mr_n72484016)
print v(xbgr.mr_n72484336)
print v(xbgr.mr_n72484448)
print v(xbgr.mr_n72484768)
print v(xbgr.mr_n72484880)
print v(xbgr.mr_n72485200)
print v(xbgr.mr_n72485312)
print v(xbgr.mr_n72485744)
print v(xbgr.mr_n72486176)
print v(xbgr.mr_n72486608)
print v(xbgr.mr_n72487040)
print v(xbgr.mr_n72487472)
print v(xbgr.mr_n72487904)
print v(xbgr.mr_n72488336)
print v(xbgr.mr_n72488768)
print v(xbgr.mr_n72489200)
print v(xbgr.mr_n72489632)
print v(xbgr.mr_n72490064)
print v(xbgr.mr_n72490496)
print v(xbgr.mr_n72490928)
print v(xbgr.mr_n72491360)
print v(xbgr.mr_n72491792)
print v(xbgr.mr_n72492224)
print v(xbgr.mr_n72492656)
print v(xbgr.mr_n72493088)
print v(xbgr.mr_n72493520)
print v(xbgr.mr_n72493952)
print v(xbgr.mr_n72494384)
print v(xbgr.mr_n72494816)
print v(xbgr.mr_n72495248)
print v(xbgr.mr_n72495680)
print v(xbgr.mr_n72496112)
print v(xbgr.mr_n72496544)
print v(xbgr.mr_n72496976)
print v(xbgr.mr_n72497408)
print v(xbgr.mr_n72497840)
print v(xbgr.mr_n72498272)
print v(xbgr.mr_n72498704)
print v(xbgr.mr_n72499136)
print v(xbgr.mr_n72499568)
print v(xbgr.mr_n72500000)
print v(xbgr.mr_n72500432)
print v(xbgr.mr_n72500864)
print v(xbgr.mr_n72501296)
print v(xbgr.mr_n72501728)
print v(xbgr.mr_n72502160)
print v(xbgr.mr_n72502592)
print v(xbgr.mr_n72503024)
print v(xbgr.mr_n72503456)
print v(xbgr.mr_n72503888)
print v(xbgr.mr_n72504320)
print v(xbgr.mr_n72504752)
print v(xbgr.mr_n72505184)
print v(xbgr.mr_n72505616)
print v(xbgr.mr_n72506048)
print v(xbgr.mr_n72506480)
print v(xbgr.mr_n72506912)
print v(xbgr.mr_n72507344)
print v(xbgr.mr_n72507776)
print v(xbgr.mr_n72508208)
print v(xbgr.mr_n72508640)
print v(xbgr.mr_n72509072)
print v(xbgr.mr_n72509504)
print v(xbgr.mr_n72509936)
print v(xbgr.mr_n72510368)
print v(xbgr.mr_n72510800)
print v(xbgr.mr_n72511232)
print v(xbgr.mr_n72511664)
print v(xbgr.mr_n72512096)
print v(xbgr.mr_n72512528)
print v(xbgr.mr_n72512960)
print v(xbgr.mr_n72513392)
print v(xbgr.mr_n72513824)
print v(xbgr.mr_n72514256)
print v(xbgr.mr_n72514688)
print v(xbgr.mr_n72515120)
print v(xbgr.mr_n72515552)
print v(xbgr.mr_n72515984)
print v(xbgr.mr_n72516416)
print v(xbgr.mr_n72516848)
print v(xbgr.mr_n72517280)
print v(xbgr.mr_n72517712)
print v(xbgr.mr_n72518144)
print v(xbgr.mr_n72518576)
print v(xbgr.mr_n72519008)
print v(xbgr.mr_n72519440)
print v(xbgr.mr_n72519872)
print v(xbgr.mr_n72520192)
print v(xbgr.mr_n72520304)
print v(xbgr.mr_n72520736)
print v(xbgr.mr_n72521056)
print v(xbgr.mr_n72521168)
print v(xbgr.mr_n72521488)
print v(xbgr.mr_n72521600)
print v(xbgr.mr_n72521920)
print v(xbgr.mr_n72522032)
print v(xbgr.mr_n72522352)
print v(xbgr.mr_n72522464)
print v(xbgr.mr_n72522784)
print v(xbgr.mr_n72522896)
print v(xbgr.mr_n72523216)
print v(xbgr.mr_n72523328)
print v(xbgr.mr_n72523648)
print v(xbgr.mr_n72523760)
print v(xbgr.mr_n72524080)
print v(xbgr.mr_n72524192)
print v(xbgr.mr_n72524512)
print v(xbgr.mr_n72524624)
print v(xbgr.mr_n72524944)
print v(xbgr.mr_n72525056)
print v(xbgr.mr_n72525488)
print v(xbgr.mr_n72525920)
print v(xbgr.mr_n72526352)
print v(xbgr.mr_n72526784)
print v(xbgr.mr_n72527216)
print v(xbgr.mr_n72527648)
print v(xbgr.mr_n72528080)
print v(xbgr.mr_n72528512)
print v(xbgr.mr_n72528944)
print v(xbgr.mr_n72529376)
print v(xbgr.mr_n72529808)
print v(xbgr.mr_n72530240)
print v(xbgr.mr_n72530672)
print v(xbgr.mr_n72531104)
print v(xbgr.mr_n72531536)
print v(xbgr.mr_n72531968)
print v(xbgr.mr_n72532400)
print v(xbgr.mr_n72532832)
print v(xbgr.mr_n72533264)
print v(xbgr.mr_n72533696)
print v(xbgr.mr_n72534128)
print v(xbgr.mr_n72534560)
print v(xbgr.mr_n72534992)
print v(xbgr.mr_n72535424)
print v(xbgr.mr_n72535856)
print v(xbgr.mr_n72536288)
print v(xbgr.mr_n72536720)
print v(xbgr.mr_n72536992)
print v(xbgr.mr_n72537104)
print v(xbgr.mr_n72537424)
print v(xbgr.mr_n72537536)
print v(xbgr.mr_n72537856)
print v(xbgr.mr_n72537968)
print v(xbgr.mr_n72538288)
print v(xbgr.mr_n72538400)
print v(xbgr.mr_n72538720)
print v(xbgr.mr_n72538832)
print v(xbgr.mr_n72539152)
print v(xbgr.mr_n72539264)
print v(xbgr.mr_n72539584)
print v(xbgr.mr_n72539696)
print v(xbgr.mr_n72540016)
print v(xbgr.mr_n72540128)
print v(xbgr.mr_n72540448)
print v(xbgr.mr_n72540560)
print v(xbgr.mr_n72540880)
print v(xbgr.mr_n72540992)
print v(xbgr.mr_n72541312)
print v(xbgr.mr_n72541424)
print v(xbgr.mr_n72541744)
print v(xbgr.mr_n72541856)
print v(xbgr.mr_n72542176)
print v(xbgr.mr_n72542288)
print v(xbgr.mr_n72542608)
print v(xbgr.mr_n72542720)
print v(xbgr.mr_n72543040)
print v(xbgr.mr_n72543152)
print v(xbgr.mr_n72543472)
print v(xbgr.mr_n72543584)
print v(xbgr.mr_n72543904)
print v(xbgr.mr_n72544016)
print v(xbgr.mr_n72544336)
print v(xbgr.mr_n72544448)
print v(xbgr.mr_n72544768)
print v(xbgr.mr_n72544880)
print v(xbgr.mr_n72545200)
print v(xbgr.mr_n72545312)
print v(xbgr.mr_n72545632)
print v(xbgr.mr_n72545744)
print v(xbgr.mr_n72546064)
print v(xbgr.mr_n72546176)
print v(xbgr.mr_n72546496)
print v(xbgr.mr_n72546608)
print v(xbgr.mr_n72546928)
print v(xbgr.mr_n72547040)
print v(xbgr.mr_n72547360)
print v(xbgr.mr_n72547472)
print v(xbgr.mr_n72547792)
print v(xbgr.mr_n72547904)
print v(xbgr.mr_n72548224)
print v(xbgr.mr_n72548336)
print v(xbgr.mr_n72548656)
print v(xbgr.mr_n72548768)
print v(xbgr.mr_n72549088)
print v(xbgr.mr_n72549200)
print v(xbgr.mr_n72549520)
print v(xbgr.mr_n72549632)
print v(xbgr.mr_n72549952)
print v(xbgr.mr_n72550064)
print v(xbgr.mr_n72550384)
print v(xbgr.mr_n72550496)
print v(xbgr.mr_n72550816)
print v(xbgr.mr_n72550928)
print v(xbgr.mr_n72551248)
print v(xbgr.mr_n72551360)
print v(xbgr.mr_n72551680)
print v(xbgr.mr_n72551792)
print v(xbgr.mr_n72552112)
print v(xbgr.mr_n72552224)
print v(xbgr.mr_n72552544)
print v(xbgr.mr_n72552656)
print v(xbgr.mr_n72552976)
print v(xbgr.mr_n72553088)
print v(xbgr.mr_n72553408)
print v(xbgr.mr_n72553520)
print v(xbgr.mr_n72553840)
print v(xbgr.mr_n72553952)
print v(xbgr.mr_n72554272)
print v(xbgr.mr_n72554384)
print v(xbgr.mr_n72554704)
print v(xbgr.mr_n72554816)
print v(xbgr.mr_n72555136)
print v(xbgr.mr_n72555248)
print v(xbgr.mr_n72555568)
print v(xbgr.mr_n72555680)
print v(xbgr.mr_n72556000)
print v(xbgr.mr_n72556112)
print v(xbgr.mr_n72556432)
print v(xbgr.mr_n72556544)
print v(xbgr.mr_n72556864)
print v(xbgr.mr_n72556976)
print v(xbgr.mr_n72557296)
print v(xbgr.mr_n72557408)
print v(xbgr.mr_n72557728)
print v(xbgr.mr_n72557840)
print v(xbgr.mr_n72558160)
print v(xbgr.mr_n72558272)
print v(xbgr.mr_n72558592)
print v(xbgr.mr_n72558704)
print v(xbgr.mr_n72559024)
print v(xbgr.mr_n72559136)
print v(xbgr.mr_n72559456)
print v(xbgr.mr_n72559568)
print v(xbgr.mr_n72559888)
print v(xbgr.mr_n72560000)
print v(xbgr.mr_n72560320)
print v(xbgr.mr_n72560432)
print v(xbgr.mr_n72560752)
print v(xbgr.mr_n72560864)
print v(xbgr.mr_n72561184)
print v(xbgr.mr_n72561296)
print v(xbgr.mr_n72561616)
print v(xbgr.mr_n72561728)
print v(xbgr.mr_n72562048)
print v(xbgr.mr_n72562160)
print v(xbgr.mr_n72562480)
print v(xbgr.mr_n72562592)
print v(xbgr.mr_n72562912)
print v(xbgr.mr_n72563024)
print v(xbgr.mr_n72563344)
print v(xbgr.mr_n72563456)
print v(xbgr.mr_n72563776)
print v(xbgr.mr_n72563888)
print v(xbgr.mr_n72564208)
print v(xbgr.mr_n72564320)
print v(xbgr.mr_n72564640)
print v(xbgr.mr_n72564752)
print v(xbgr.mr_n72565072)
print v(xbgr.mr_n72565184)
print v(xbgr.mr_n72565504)
print v(xbgr.mr_n72565616)
print v(xbgr.mr_n72565936)
print v(xbgr.mr_n72566048)
print v(xbgr.mr_n72566368)
print v(xbgr.mr_n72566480)
print v(xbgr.mr_n72566800)
print v(xbgr.mr_n72566912)
print v(xbgr.mr_n72567232)
print v(xbgr.mr_n72567344)
print v(xbgr.mr_n72567664)
print v(xbgr.mr_n72567776)
print v(xbgr.mr_n72568096)
print v(xbgr.mr_n72568208)
print v(xbgr.mr_n72568528)
print v(xbgr.mr_n72568640)
print v(xbgr.mr_n72568960)
print v(xbgr.mr_n72569072)
print v(xbgr.mr_n72569392)
print v(xbgr.mr_n72569504)
print v(xbgr.mr_n72569824)
print v(xbgr.mr_n72569936)
print v(xbgr.mr_n72570256)
print v(xbgr.mr_n72570368)
print v(xbgr.mr_n72570688)
print v(xbgr.mr_n72570800)
print v(xbgr.mr_n72571120)
print v(xbgr.mr_n72571232)
print v(xbgr.mr_n72571552)
print v(xbgr.mr_n72571664)
print v(xbgr.mr_n72571984)
print v(xbgr.mr_n72572096)
print v(xbgr.mr_n72572416)
print v(xbgr.mr_n72572528)
print v(xbgr.mr_n72572848)
print v(xbgr.mr_n72572960)
print v(xbgr.mr_n72573280)
print v(xbgr.mr_n72573392)
print v(xbgr.mr_n72573712)
print v(xbgr.mr_n72573824)
print v(xbgr.mr_n72574144)
print v(xbgr.mr_n72574256)
print v(xbgr.mr_n72574576)
print v(xbgr.mr_n72574688)
print v(xbgr.mr_n72575008)
print v(xbgr.mr_n72575120)
print v(xbgr.mr_n72575440)
print v(xbgr.mr_n72575552)
print v(xbgr.mr_n72575872)
print v(xbgr.mr_n72575984)
print v(xbgr.mr_n72576304)
print v(xbgr.mr_n72576416)
print v(xbgr.mr_n72576736)
print v(xbgr.mr_n72576848)
print v(xbgr.mr_n72577168)
print v(xbgr.mr_n72577280)
print v(xbgr.mr_n72577600)
print v(xbgr.mr_n72577712)
print v(xbgr.mr_n72578032)
print v(xbgr.mr_n72578144)
print v(xbgr.mr_n72578464)
print v(xbgr.mr_n72578576)
print v(xbgr.mr_n72578896)
print v(xbgr.mr_n72579008)
print v(xbgr.mr_n72579328)
print v(xbgr.mr_n72579440)
print v(xbgr.mr_n72579760)
print v(xbgr.mr_n72579872)
print v(xbgr.mr_n72580192)
print v(xbgr.mr_n72580304)
print v(xbgr.mr_n72580624)
print v(xbgr.mr_n72580736)
print v(xbgr.mr_n72581056)
print v(xbgr.mr_n72581168)
print v(xbgr.mr_n72581488)
print v(xbgr.mr_n72581600)
print v(xbgr.mr_n72581920)
print v(xbgr.mr_n72582032)
print v(xbgr.mr_n72582352)
print v(xbgr.mr_n72582464)
print v(xbgr.mr_n72582784)
print v(xbgr.mr_n72582896)
print v(xbgr.mr_n72583216)
print v(xbgr.mr_n72583328)
print v(xbgr.mr_n72583648)
print v(xbgr.mr_n72583760)
print v(xbgr.mr_n72584080)
print v(xbgr.mr_n72584192)
print v(xbgr.mr_n72584512)
print v(xbgr.mr_n72584624)
print v(xbgr.mr_n72584944)
print v(xbgr.mr_n72585056)
print v(xbgr.mr_n72585376)
print v(xbgr.mr_n72585488)
print v(xbgr.mr_n72585808)
print v(xbgr.mr_n72585920)
print v(xbgr.mr_n72586240)
print v(xbgr.mr_n72586352)
print v(xbgr.mr_n72586672)
print v(xbgr.mr_n72586784)
print v(xbgr.mr_n72587104)
print v(xbgr.mr_n72587216)
print v(xbgr.mr_n72587536)
print v(xbgr.mr_n72587648)
print v(xbgr.mr_n72587968)
print v(xbgr.mr_n72588080)
print v(xbgr.mr_n72588400)
print v(xbgr.mr_n72588512)
print v(xbgr.mr_n72588832)
print v(xbgr.mr_n72588944)
print v(xbgr.mr_n72589264)
print v(xbgr.mr_n72589376)
print v(xbgr.mr_n72589696)
print v(xbgr.mr_n72589808)
print v(xbgr.mr_n72590128)
print v(xbgr.mr_n72590240)
print v(xbgr.mr_n72590560)
print v(xbgr.mr_n72590672)
print v(xbgr.mr_n72590992)
print v(xbgr.mr_n72591104)
print v(xbgr.mr_n72591424)
print v(xbgr.mr_n72591536)
print v(xbgr.mr_n72591856)
print v(xbgr.mr_n72591968)
print v(xbgr.mr_n72592288)
print v(xbgr.mr_n72592400)
print v(xbgr.mr_n72592720)
print v(xbgr.mr_n72592832)
print v(xbgr.mr_n72593152)
print v(xbgr.mr_n72593264)
print v(xbgr.mr_n72593584)
print v(xbgr.mr_n72593696)
print v(xbgr.mr_n72594016)
print v(xbgr.mr_n72594128)
print v(xbgr.mr_n72594448)
print v(xbgr.mr_n72594560)
print v(xbgr.mr_n72594880)
print v(xbgr.mr_n72594992)
print v(xbgr.mr_n72595312)
print v(xbgr.mr_n72595424)
print v(xbgr.mr_n72595744)
print v(xbgr.mr_n72595856)
print v(xbgr.mr_n72596176)
print v(xbgr.mr_n72596288)
print v(xbgr.mr_n72596608)
print v(xbgr.mr_n72596720)
print v(xbgr.mr_n72597040)
print v(xbgr.mr_n72597152)
print v(xbgr.mr_n72597472)
print v(xbgr.mr_n72597584)
print v(xbgr.mr_n72597904)
print v(xbgr.mr_n72598016)
print v(xbgr.mr_n72598336)
print v(xbgr.mr_n72598448)
print v(xbgr.mr_n72598768)
print v(xbgr.mr_n72598880)
print v(xbgr.mr_n72599200)
print v(xbgr.mr_n72599312)
print v(xbgr.mr_n72599632)
print v(xbgr.mr_n72599744)
print v(xbgr.mr_n72600064)
print v(xbgr.mr_n72600176)
print v(xbgr.mr_n72600496)
print v(xbgr.mr_n72600608)
print v(xbgr.mr_n72600928)
print v(xbgr.mr_n72601040)
print v(xbgr.mr_n72601360)
print v(xbgr.mr_n72601472)
print v(xbgr.mr_n72601792)
print v(xbgr.mr_n72601904)
print v(xbgr.mr_n72602224)
print v(xbgr.mr_n72602336)
print v(xbgr.mr_n72602656)
print v(xbgr.mr_n72602768)
print v(xbgr.mr_n72603088)
print v(xbgr.mr_n72603200)
print v(xbgr.mr_n72603520)
print v(xbgr.mr_n72603632)
print v(xbgr.mr_n72603952)
print v(xbgr.mr_n72604064)
print v(xbgr.mr_n72604384)
print v(xbgr.mr_n72604496)
print v(xbgr.mr_n72604816)
print v(xbgr.mr_n72604928)
print v(xbgr.mr_n72605248)
print v(xbgr.mr_n72605360)
print v(xbgr.mr_n72605680)
print v(xbgr.mr_n72605792)
print v(xbgr.mr_n72606112)
print v(xbgr.mr_n72606224)
print v(xbgr.mr_n72606544)
print v(xbgr.mr_n72606656)
print v(xbgr.mr_n72606976)
print v(xbgr.mr_n72607088)
print v(xbgr.mr_n72607408)
print v(xbgr.mr_n72607520)
print v(xbgr.mr_n72607840)
print v(xbgr.mr_n72607952)
print v(xbgr.mr_n72608272)
print v(xbgr.mr_n72608384)
print v(xbgr.mr_n72608704)
print v(xbgr.mr_n72608816)
print v(xbgr.mr_n72609136)
print v(xbgr.mr_n72609248)
print v(xbgr.mr_n72609568)
print v(xbgr.mr_n72609680)
print v(xbgr.mr_n72610000)
print v(xbgr.mr_n72610112)
print v(xbgr.mr_n72610432)
print v(xbgr.mr_n72610544)
print v(xbgr.mr_n72610864)
print v(xbgr.mr_n72610976)
print v(xbgr.mr_n72611296)
print v(xbgr.mr_n72611408)
print v(xbgr.mr_n72611728)
print v(xbgr.mr_n72611840)
print v(xbgr.mr_n72612160)
print v(xbgr.mr_n72612272)
print v(xbgr.mr_n72612592)
print v(xbgr.mr_n72612704)
print v(xbgr.mr_n72613024)
print v(xbgr.mr_n72613136)
print v(xbgr.mr_n72613456)
print v(xbgr.mr_n72613568)
print v(xbgr.mr_n72613888)
print v(xbgr.mr_n72614000)
print v(xbgr.mr_n72614320)
print v(xbgr.mr_n72614432)
print v(xbgr.mr_n72614752)
print v(xbgr.mr_n72614864)
print v(xbgr.mr_n72615184)
print v(xbgr.mr_n72615296)
print v(xbgr.mr_n72615616)
print v(xbgr.mr_n72615728)
print v(xbgr.mr_n72616048)
print v(xbgr.mr_n72616160)
print v(xbgr.mr_n72616480)
print v(xbgr.mr_n72616592)
print v(xbgr.mr_n72616912)
print v(xbgr.mr_n72617024)
print v(xbgr.mr_n72617344)
print v(xbgr.mr_n72617456)
print v(xbgr.mr_n72617776)
print v(xbgr.mr_n72617888)
print v(xbgr.mr_n72618208)
print v(xbgr.mr_n72618320)
print v(xbgr.mr_n72618640)
print v(xbgr.mr_n72618752)
print v(xbgr.mr_n72619072)
print v(xbgr.mr_n72619184)
print v(xbgr.mr_n72619504)
print v(xbgr.mr_n72619616)
print v(xbgr.mr_n72619936)
print v(xbgr.mr_n72620048)
print v(xbgr.mr_n72620368)
print v(xbgr.mr_n72620480)
print v(xbgr.mr_n72620800)
print v(xbgr.mr_n72620912)
print v(xbgr.mr_n72621232)
print v(xbgr.mr_n72621344)
print v(xbgr.mr_n72621776)
print v(xbgr.mr_n72622096)
print v(xbgr.mr_n72622208)
print v(xbgr.mr_n72622528)
print v(xbgr.mr_n72622640)
print v(xbgr.mr_n72622960)
print v(xbgr.mr_n72623072)
print v(xbgr.mr_n72623504)
print v(xbgr.mr_n72623824)
print v(xbgr.mr_n72623936)
print v(xbgr.mr_n72624256)
print v(xbgr.mr_n72624368)
print v(xbgr.mr_n72624688)
print v(xbgr.mr_n72624800)
print v(xbgr.mr_n72625232)
print v(xbgr.mr_n72625552)
print v(xbgr.mr_n72625664)
print v(xbgr.mr_n72625984)
print v(xbgr.mr_n72626096)
print v(xbgr.mr_n72626416)
print v(xbgr.mr_n72626528)
print v(xbgr.mr_n72626960)
print v(xbgr.mr_n72627280)
print v(xbgr.mr_n72627392)
print v(xbgr.mr_n72627712)
print v(xbgr.mr_n72627824)
print v(xbgr.mr_n72628144)
print v(xbgr.mr_n72628256)
print v(xbgr.mr_n72628688)
print v(xbgr.mr_n72629008)
print v(xbgr.mr_n72629120)
print v(xbgr.mr_n72629440)
print v(xbgr.mr_n72629552)
print v(xbgr.mr_n72629872)
print v(xbgr.mr_n72629984)
print v(xbgr.mr_n72630416)
print v(xbgr.mr_n72630736)
print v(xbgr.mr_n72630848)
print v(xbgr.mr_n72631168)
print v(xbgr.mr_n72631280)
print v(xbgr.mr_n72631600)
print v(xbgr.mr_n72631712)
print v(xbgr.mr_n72632144)
print v(xbgr.mr_n72632464)
print v(xbgr.mr_n72632576)
print v(xbgr.mr_n72632896)
print v(xbgr.mr_n72633008)
print v(xbgr.mr_n72633328)
print v(xbgr.mr_n72633440)
print v(xbgr.mr_n72633872)
print v(xbgr.mr_n72634192)
print v(xbgr.mr_n72634304)
print v(xbgr.mr_n72634624)
print v(xbgr.mr_n72634736)
print v(xbgr.mr_n72635056)
print v(xbgr.mr_n72635168)
print v(xbgr.mr_n72635488)
print v(xbgr.mr_n72635600)
print v(xbgr.mr_n72635920)
print v(xbgr.mr_n72636032)
print v(xbgr.mr_n72636352)
print v(xbgr.mr_n72636464)
print v(xbgr.mr_n72636784)
print v(xbgr.mr_n72636896)
print v(xbgr.mr_n72637216)
print v(xbgr.mr_n72637328)
print v(xbgr.mr_n72637648)
print v(xbgr.mr_n72637760)
print v(xbgr.mr_n72638080)
print v(xbgr.mr_n72638192)
print v(xbgr.mr_n72638512)
print v(xbgr.mr_n72638624)
print v(xbgr.mr_n72638944)
print v(xbgr.mr_n72639056)
print v(xbgr.mr_n72639376)
print v(xbgr.mr_n72639488)
print v(xbgr.mr_n72639808)
print v(xbgr.mr_n72639920)
print v(xbgr.mr_n72640240)
print v(xbgr.mr_n72640352)
print v(xbgr.mr_n72640672)
print v(xbgr.mr_n72640784)
print v(xbgr.mr_n72641104)
print v(xbgr.mr_n72641216)
print v(xbgr.mr_n72641536)
print v(xbgr.mr_n72641648)
print v(xbgr.mr_n72641968)
print v(xbgr.mr_n72642080)
print v(xbgr.mr_n72642400)
print v(xbgr.mr_n72642512)
print v(xbgr.mr_n72642832)
print v(xbgr.mr_n72642944)
print v(xbgr.mr_n72643264)
print v(xbgr.mr_n72643376)
print v(xbgr.mr_n72643696)
print v(xbgr.mr_n72643808)
print v(xbgr.mr_n72644128)
print v(xbgr.mr_n72644240)
print v(xbgr.mr_n72644560)
print v(xbgr.mr_n72644672)
print v(xbgr.mr_n72644992)
print v(xbgr.mr_n72645104)
print v(xbgr.mr_n72645424)
print v(xbgr.mr_n72645536)
print v(xbgr.mr_n72645856)
print v(xbgr.mr_n72645968)
print v(xbgr.mr_n72646288)
print v(xbgr.mr_n72646400)
print v(xbgr.mr_n72646720)
print v(xbgr.mr_n72646832)
print v(xbgr.mr_n72647152)
print v(xbgr.mr_n72647264)
print v(xbgr.mr_n72647584)
print v(xbgr.mr_n72647696)
print v(xbgr.mr_n72648016)
print v(xbgr.mr_n72648128)
print v(xbgr.mr_n72648448)
print v(xbgr.mr_n72648560)
print v(xbgr.mr_n72648880)
print v(xbgr.mr_n72648992)
print v(xbgr.mr_n72649312)
print v(xbgr.mr_n72649424)
print v(xbgr.mr_n72649744)
print v(xbgr.mr_n72649856)
print v(xbgr.mr_n72650176)
print v(xbgr.mr_n72650288)
print v(xbgr.mr_n72650608)
print v(xbgr.mr_n72650720)
print v(xbgr.mr_n72651040)
print v(xbgr.mr_n72651152)
print v(xbgr.mr_n72651472)
print v(xbgr.mr_n72651584)
print v(xbgr.mr_n72651904)
print v(xbgr.mr_n72652016)
print v(xbgr.mr_n72652336)
print v(xbgr.mr_n72652448)
print v(xbgr.mr_n72652768)
print v(xbgr.mr_n72652880)
print v(xbgr.mr_n72653200)
print v(xbgr.mr_n72653312)
print v(xbgr.mr_n72653632)
print v(xbgr.mr_n72653744)
print v(xbgr.mr_n72654064)
print v(xbgr.mr_n72654176)
print v(xbgr.mr_n72654496)
print v(xbgr.mr_n72654608)
print v(xbgr.mr_n72654928)
print v(xbgr.mr_n72655040)
print v(xbgr.mr_n72655360)
print v(xbgr.mr_n72655472)
print v(xbgr.mr_n72655792)
print v(xbgr.mr_n72655904)
print v(xbgr.mr_n72656224)
print v(xbgr.mr_n72656336)
print v(xbgr.mr_n72656656)
print v(xbgr.mr_n72656768)
print v(xbgr.mr_n72657088)
print v(xbgr.mr_n72657200)
print v(xbgr.mr_n72657520)
print v(xbgr.mr_n72657632)
print v(xbgr.mr_n72657952)
print v(xbgr.mr_n72658064)
print v(xbgr.mr_n72658384)
print v(xbgr.mr_n72658496)
print v(xbgr.mr_n72658816)
print v(xbgr.mr_n72658928)
print v(xbgr.mr_n72659248)
print v(xbgr.mr_n72659360)
print v(xbgr.mr_n72659680)
print v(xbgr.mr_n72659792)
print v(xbgr.mr_n72660112)
print v(xbgr.mr_n72660224)
print v(xbgr.mr_n72660544)
print v(xbgr.mr_n72660656)
print v(xbgr.mr_n72660976)
print v(xbgr.mr_n72661088)
print v(xbgr.mr_n72661408)
print v(xbgr.mr_n72661520)
print v(xbgr.mr_n72661840)
print v(xbgr.mr_n72661952)
print v(xbgr.mr_n72662272)
print v(xbgr.mr_n72662384)
print v(xbgr.mr_n72662704)
print v(xbgr.mr_n72662816)
print v(xbgr.mr_n72663136)
print v(xbgr.mr_n72663248)
print v(xbgr.mr_n72663568)
print v(xbgr.mr_n72663680)
print v(xbgr.mr_n72664112)
print v(xbgr.mr_n72664432)
print v(xbgr.mr_n72664544)
print v(xbgr.mr_n72664864)
print v(xbgr.mr_n72664976)
print v(xbgr.mr_n72665296)
print v(xbgr.mr_n72665408)
print v(xbgr.mr_n72665840)
print v(xbgr.mr_n72666160)
print v(xbgr.mr_n72666272)
print v(xbgr.mr_n72666592)
print v(xbgr.mr_n72666704)
print v(xbgr.mr_n72667024)
print v(xbgr.mr_n72667136)
print v(xbgr.mr_n72667568)
print v(xbgr.mr_n72667888)
print v(xbgr.mr_n72668000)
print v(xbgr.mr_n72668320)
print v(xbgr.mr_n72668432)
print v(xbgr.mr_n72668752)
print v(xbgr.mr_n72668864)
print v(xbgr.mr_n72669184)
print v(xbgr.mr_n72669296)
print v(xbgr.mr_n72669616)
print v(xbgr.mr_n72669728)
print v(xbgr.mr_n72670048)
print v(xbgr.mr_n72670160)
print v(xbgr.mr_n72670480)
print v(xbgr.mr_n72670592)
print v(xbgr.mr_n72670912)
print v(xbgr.mr_n72671024)
print v(xbgr.mr_n72671344)
print v(xbgr.mr_n72671456)
print v(xbgr.mr_n72671888)
print v(xbgr.mr_n72672208)
print v(xbgr.mr_n72672320)
print v(xbgr.mr_n72672752)
print v(xbgr.mr_n72673072)
print v(xbgr.mr_n72673184)
print v(xbgr.mr_n72673616)
print v(xbgr.mr_n72673936)
print v(xbgr.mr_n72674048)
print v(xbgr.mr_n72674368)
print v(xbgr.mr_n72674480)
print v(xbgr.mr_n72674800)
print v(xbgr.mr_n72674912)
print v(xbgr.mr_n72675344)
print v(xbgr.mr_n72675664)
print v(xbgr.mr_n72675776)
print v(xbgr.mr_n72676096)
print v(xbgr.mr_n72676208)
print v(xbgr.mr_n72676528)
print v(xbgr.mr_n72676640)
print v(xbgr.mr_n72676960)
print v(xbgr.mr_n72677072)
print v(xbgr.mr_n72677392)
print v(xbgr.mr_n72677504)
print v(xbgr.mr_n72677936)
print v(xbgr.mr_n72678256)
print v(xbgr.mr_n72678368)
print v(xbgr.mr_n72678688)
print v(xbgr.mr_n72678800)
print v(xbgr.mr_n72679120)
print v(xbgr.mr_n72679232)
print v(xbgr.mr_n72679552)
print v(xbgr.mr_n72679664)
print v(xbgr.mr_n72679984)
print v(xbgr.mr_n72680096)
print v(xbgr.mr_n72680416)
print v(xbgr.mr_n72680528)
print v(xbgr.mr_n72680848)
print v(xbgr.mr_n72680960)
print v(xbgr.mr_n72681280)
print v(xbgr.mr_n72681392)
print v(xbgr.mr_n72681712)
print v(xbgr.mr_n72681824)
print v(xbgr.mr_n72682144)
print v(xbgr.mr_n72682256)
print v(xbgr.mr_n72682576)
print v(xbgr.mr_n72682688)
print v(xbgr.mr_n72683008)
print v(xbgr.mr_n72683120)
print v(xbgr.mr_n72683440)
print v(xbgr.mr_n72683552)
print v(xbgr.mr_n72683872)
print v(xbgr.mr_n72683984)
print v(xbgr.mr_n72684304)
print v(xbgr.mr_n72684416)
print v(xbgr.mr_n72684736)
print v(xbgr.mr_n72684848)
print v(xbgr.mr_n72685168)
print v(xbgr.mr_n72685280)
print v(xbgr.mr_n72685600)
print v(xbgr.mr_n72685712)
print v(xbgr.mr_n72686032)
print v(xbgr.mr_n72686144)
print v(xbgr.mr_n72686464)
print v(xbgr.mr_n72686576)
print v(xbgr.mr_n72686896)
print v(xbgr.mr_n72687008)
print v(xbgr.mr_n72687328)
print v(xbgr.mr_n72687440)
print v(xbgr.mr_n72687760)
print v(xbgr.mr_n72687872)
print v(xbgr.mr_n72688192)
print v(xbgr.mr_n72688304)
print v(xbgr.mr_n72688624)
print v(xbgr.mr_n72688736)
print v(xbgr.mr_n72689056)
print v(xbgr.mr_n72689168)
print v(xbgr.mr_n72689488)
print v(xbgr.mr_n72689600)
print v(xbgr.mr_n72689920)
print v(xbgr.mr_n72690032)
print v(xbgr.mr_n72690352)
print v(xbgr.mr_n72690464)
print v(xbgr.mr_n72690784)
print v(xbgr.mr_n72690896)
print v(xbgr.mr_n72691216)
print v(xbgr.mr_n72691328)
print v(xbgr.mr_n72691648)
print v(xbgr.mr_n72691760)
print v(xbgr.mr_n72692080)
print v(xbgr.mr_n72692192)
print v(xbgr.mr_n72692512)
print v(xbgr.mr_n72692624)
print v(xbgr.mr_n72692944)
print v(xbgr.mr_n72693056)
print v(xbgr.mr_n72693376)
print v(xbgr.mr_n72693488)
print v(xbgr.mr_n72693808)
print v(xbgr.mr_n72693920)
print v(xbgr.mr_n72694240)
print v(xbgr.mr_n72694352)
print v(xbgr.mr_n72694672)
print v(xbgr.mr_n72694784)
print v(xbgr.mr_n72695104)
print v(xbgr.mr_n72695216)
print v(xbgr.mr_n72695536)
print v(xbgr.mr_n72695648)
print v(xbgr.mr_n72695968)
print v(xbgr.mr_n72696080)
print v(xbgr.mr_n72696400)
print v(xbgr.mr_n72696512)
print v(xbgr.mr_n72696832)
print v(xbgr.mr_n72696944)
print v(xbgr.mr_n72697264)
print v(xbgr.mr_n72697376)
print v(xbgr.mr_n72697696)
print v(xbgr.mr_n72697808)
print v(xbgr.mr_n72698128)
print v(xbgr.mr_n72698240)
print v(xbgr.mr_n72698560)
print v(xbgr.mr_n72698672)
print v(xbgr.mr_n72698992)
print v(xbgr.mr_n72699104)
print v(xbgr.mr_n72699424)
print v(xbgr.mr_n72699536)
print v(xbgr.mr_n72699856)
print v(xbgr.mr_n72699968)
print v(xbgr.mr_n72700288)
print v(xbgr.mr_n72700400)
print v(xbgr.mr_n72700720)
print v(xbgr.mr_n72700832)
print v(xbgr.mr_n72701152)
print v(xbgr.mr_n72701264)
print v(xbgr.mr_n72701584)
print v(xbgr.mr_n72701696)
print v(xbgr.mr_n72702016)
print v(xbgr.mr_n72702128)
print v(xbgr.mr_n72702448)
print v(xbgr.mr_n72702560)
print v(xbgr.mr_n72702880)
print v(xbgr.mr_n72702992)
print v(xbgr.mr_n72703312)
print v(xbgr.mr_n72703424)
print v(xbgr.mr_n72703744)
print v(xbgr.mr_n72703856)
print v(xbgr.mr_n72704176)
print v(xbgr.mr_n72704288)
print v(xbgr.mr_n72704608)
print v(xbgr.mr_n72704720)
print v(xbgr.mr_n72705040)
print v(xbgr.mr_n72705152)
print v(xbgr.mr_n72705472)
print v(xbgr.mr_n72705584)
print v(xbgr.mr_n72705904)
print v(xbgr.mr_n72706016)
print v(xbgr.mr_n72706336)
print v(xbgr.mr_n72706448)
print v(xbgr.mr_n72706768)
print v(xbgr.mr_n72706880)
print v(xbgr.mr_n72707200)
print v(xbgr.mr_n72707312)
print v(xbgr.mr_n72707632)
print v(xbgr.mr_n72707744)
print v(xbgr.mr_n72708064)
print v(xbgr.mr_n72708176)
print v(xbgr.mr_n72708496)
print v(xbgr.mr_n72708608)
print v(xbgr.mr_n72708928)
print v(xbgr.mr_n72709040)
print v(xbgr.mr_n72709360)
print v(xbgr.mr_n72709472)
print v(xbgr.mr_n72709792)
print v(xbgr.mr_n72709904)
print v(xbgr.mr_n72710224)
print v(xbgr.mr_n72710336)
print v(xbgr.mr_n72710656)
print v(xbgr.mr_n72710768)
print v(xbgr.mr_n72711088)
print v(xbgr.mr_n72711200)
print v(xbgr.mr_n72711520)
print v(xbgr.mr_n72711632)
print v(xbgr.mr_n72711952)
print v(xbgr.mr_n72712064)
print v(xbgr.mr_n72712384)
print v(xbgr.mr_n72712496)
print v(xbgr.mr_n72712816)
print v(xbgr.mr_n72712928)
print v(xbgr.mr_n72713248)
print v(xbgr.mr_n72713360)
print v(xbgr.mr_n72713680)
print v(xbgr.mr_n72713792)
print v(xbgr.mr_n72714112)
print v(xbgr.mr_n72714224)
print v(xbgr.mr_n72714544)
print v(xbgr.mr_n72714656)
print v(xbgr.mr_n72714976)
print v(xbgr.mr_n72715088)
print v(xbgr.mr_n72715408)
print v(xbgr.mr_n72715520)
print v(xbgr.mr_n72715840)
print v(xbgr.mr_n72715952)
print v(xbgr.mr_n72716272)
print v(xbgr.mr_n72716384)
print v(xbgr.mr_n72716704)
print v(xbgr.mr_n72716816)
print v(xbgr.mr_n72717136)
print v(xbgr.mr_n72717248)
print v(xbgr.mr_n72717568)
print v(xbgr.mr_n72717680)
print v(xbgr.mr_n72718000)
print v(xbgr.mr_n72718112)
print v(xbgr.mr_n72718432)
print v(xbgr.mr_n72718544)
print v(xbgr.mr_n72718864)
print v(xbgr.mr_n72718976)
print v(xbgr.mr_n72719296)
print v(xbgr.mr_n72719408)
print v(xbgr.mr_n72719728)
print v(xbgr.mr_n72719840)
print v(xbgr.mr_n72720160)
print v(xbgr.mr_n72720272)
print v(xbgr.mr_n72720592)
print v(xbgr.mr_n72720704)
print v(xbgr.mr_n72721024)
print v(xbgr.mr_n72721136)
print v(xbgr.mr_n72721456)
print v(xbgr.mr_n72721568)
print v(xbgr.mr_n72721888)
print v(xbgr.mr_n72722000)
print v(xbgr.mr_n72722320)
print v(xbgr.mr_n72722432)
print v(xbgr.mr_n72722752)
print v(xbgr.mr_n72722864)
print v(xbgr.mr_n72723184)
print v(xbgr.mr_n72723296)
print v(xbgr.mr_n72723616)
print v(xbgr.mr_n72723728)
print v(xbgr.mr_n72724048)
print v(xbgr.mr_n72724160)
print v(xbgr.mr_n72724480)
print v(xbgr.mr_n72724592)
print v(xbgr.mr_n72724912)
print v(xbgr.mr_n72725024)
print v(xbgr.mr_n72725344)
print v(xbgr.mr_n72725456)
print v(xbgr.mr_n72725776)
print v(xbgr.mr_n72725888)
print v(xbgr.mr_n72726208)
print v(xbgr.mr_n72726320)
print v(xbgr.mr_n72726640)
print v(xbgr.mr_n72726752)
print v(xbgr.mr_n72727072)
print v(xbgr.mr_n72727184)
print v(xbgr.mr_n72727504)
print v(xbgr.mr_n72727616)
print v(xbgr.mr_n72727936)
print v(xbgr.mr_n72728048)
print v(xbgr.mr_n72728368)
print v(xbgr.mr_n72728480)
print v(xbgr.mr_n72728800)
print v(xbgr.mr_n72728912)
print v(xbgr.mr_n72729232)
print v(xbgr.mr_n72729344)
print v(xbgr.mr_n72729664)
print v(xbgr.mr_n72729776)
print v(xbgr.mr_n72730096)
print v(xbgr.mr_n72730208)
print v(xbgr.mr_n72730528)
print v(xbgr.mr_n72730640)
print v(xbgr.mr_n72730960)
print v(xbgr.mr_n72731072)
print v(xbgr.mr_n72731392)
print v(xbgr.mr_n72731504)
print v(xbgr.mr_n72731824)
print v(xbgr.mr_n72731936)
print v(xbgr.mr_n72732256)
print v(xbgr.mr_n72732368)
print v(xbgr.mr_n72732688)
print v(xbgr.mr_n72732800)
print v(xbgr.mr_n72733120)
print v(xbgr.mr_n72733232)
print v(xbgr.mr_n72733552)
print v(xbgr.mr_n72733664)
print v(xbgr.mr_n72733984)
print v(xbgr.mr_n72734096)
print v(xbgr.mr_n72734416)
print v(xbgr.mr_n72734528)
print v(xbgr.mr_n72734848)
print v(xbgr.mr_n72734960)
print v(xbgr.mr_n72735280)
print v(xbgr.mr_n72735392)
print v(xbgr.mr_n72735712)
print v(xbgr.mr_n72735824)
print v(xbgr.mr_n72736144)
print v(xbgr.mr_n72736256)
print v(xbgr.mr_n72736576)
print v(xbgr.mr_n72736688)
print v(xbgr.mr_n72737008)
print v(xbgr.mr_n72737120)
print v(xbgr.mr_n72737440)
print v(xbgr.mr_n72737552)
print v(xbgr.mr_n72737872)
print v(xbgr.mr_n72737984)
print v(xbgr.mr_n72738304)
print v(xbgr.mr_n72738416)
print v(xbgr.mr_n72738736)
print v(xbgr.mr_n72738848)
print v(xbgr.mr_n72739168)
print v(xbgr.mr_n72739280)
print v(xbgr.mr_n72739600)
print v(xbgr.mr_n72739712)
print v(xbgr.mr_n72740032)
print v(xbgr.mr_n72740144)
print v(xbgr.mr_n72740464)
print v(xbgr.mr_n72740576)
print v(xbgr.mr_n72740896)
print v(xbgr.mr_n72741008)
print v(xbgr.mr_n72741328)
print v(xbgr.mr_n72741440)
print v(xbgr.mr_n72741760)
print v(xbgr.mr_n72741872)
print v(xbgr.mr_n72742192)
print v(xbgr.mr_n72742304)
print v(xbgr.mr_n72742624)
print v(xbgr.mr_n72742736)
print v(xbgr.mr_n72743056)
print v(xbgr.mr_n72743168)
print v(xbgr.mr_n72743488)
print v(xbgr.mr_n72743600)
print v(xbgr.mr_n72743920)
print v(xbgr.mr_n72744032)
print v(xbgr.mr_n72744352)
print v(xbgr.mr_n72744464)
print v(xbgr.mr_n72744784)
print v(xbgr.mr_n72744896)
print v(xbgr.mr_n72745216)
print v(xbgr.mr_n72745328)
print v(xbgr.mr_n72745648)
print v(xbgr.mr_n72745760)
print v(xbgr.mr_n72746080)
print v(xbgr.mr_n72746192)
print v(xbgr.mr_n72746512)
print v(xbgr.mr_n72746624)
print v(xbgr.mr_n72746944)
print v(xbgr.mr_n72747056)
print v(xbgr.mr_n72747376)
print v(xbgr.mr_n72747488)
print v(xbgr.mr_n72747808)
print v(xbgr.mr_n72747920)
print v(xbgr.mr_n72748240)
print v(xbgr.mr_n72748352)
print v(xbgr.mr_n72748672)
print v(xbgr.mr_n72748784)
print v(xbgr.mr_n72749104)
print v(xbgr.mr_n72749216)
print v(xbgr.mr_n72749536)
print v(xbgr.mr_n72749648)
print v(xbgr.mr_n72749968)
print v(xbgr.mr_n72750080)
print v(xbgr.mr_n72750400)
print v(xbgr.mr_n72750512)
print v(xbgr.mr_n72750832)
print v(xbgr.mr_n72750944)
print v(xbgr.mr_n72751264)
print v(xbgr.mr_n72751376)
print v(xbgr.mr_n72751696)
print v(xbgr.mr_n72751808)
print v(xbgr.mr_n72752128)
print v(xbgr.mr_n72752240)
print v(xbgr.mr_n72752560)
print v(xbgr.mr_n72752672)
print v(xbgr.mr_n72753104)
print v(xbgr.mr_n72753424)
print v(xbgr.mr_n72753536)
print v(xbgr.mr_n72753968)
print v(xbgr.mr_n72754288)
print v(xbgr.mr_n72754400)
print v(xbgr.mr_n72754832)
print v(xbgr.mr_n72755152)
print v(xbgr.mr_n72756016)
print v(xbgr.mr_n72756128)
print v(xbgr.mr_n72756560)
print v(xbgr.mr_n72756880)
print v(xbgr.mr_n72756992)
print v(xbgr.mr_n72757312)
print v(xbgr.mr_n72757424)
print v(xbgr.mr_n72757744)
print v(xbgr.mr_n72757856)
print v(xbgr.mr_n72758176)
print v(xbgr.mr_n72758288)
print v(xbgr.mr_n72758608)
print v(xbgr.mr_n72758720)
print v(xbgr.mr_n72759040)
print v(xbgr.mr_n72759152)
print v(xbgr.mr_n72759472)
print v(xbgr.mr_n72759584)
print v(xbgr.mr_n72759904)
print v(xbgr.mr_n72760016)
print v(xbgr.mr_n72760336)
print v(xbgr.mr_n72761200)
print v(xbgr.mr_n72762064)
print v(xbgr.mr_n72762176)
print v(xbgr.mr_n72762496)
print v(xbgr.mr_n72762608)
print v(xbgr.mr_n72762928)
print v(xbgr.mr_n72763792)
print v(xbgr.mr_n72763904)
print v(xbgr.mr_n72764224)
print v(xbgr.mr_n72764336)
print v(xbgr.mr_n72764656)
print v(xbgr.mr_n72764768)
print v(xbgr.mr_n72765088)
print v(xbgr.mr_n72765200)
print v(xbgr.mr_n72765520)
print v(xbgr.mr_n72765632)
print v(xbgr.mr_n72765952)
print v(xbgr.mr_n72766064)
print v(xbgr.mr_n72766384)
print v(xbgr.mr_n72766496)
print v(xbgr.mr_n72766816)
print v(xbgr.mr_n72766928)
print v(xbgr.mr_n72767248)
print v(xbgr.mr_n72767360)
print v(xbgr.mr_n72767680)
print v(xbgr.mr_n72767792)
print v(xbgr.mr_n72768112)
print v(xbgr.mr_n72768224)
print v(xbgr.mr_n72768544)
print v(xbgr.mr_n72768656)
print v(xbgr.mr_n72768976)
print v(xbgr.mr_n72769088)
print v(xbgr.mr_n72769408)
print v(xbgr.mr_n72769520)
print v(xbgr.mr_n72769840)
print v(xbgr.mr_n72769952)
print v(xbgr.mr_n72770272)
print v(xbgr.mr_n72770384)
print v(xbgr.mr_n72770704)
print v(xbgr.mr_n72770816)
print v(xbgr.mr_n72771136)
print v(xbgr.mr_n72771248)
print v(xbgr.mr_n72771568)
print v(xbgr.mr_n72771680)
print v(xbgr.mr_n72772000)
print v(xbgr.mr_n72772112)
print v(xbgr.mr_n72772432)
print v(xbgr.mr_n72772544)
print v(xbgr.mr_n72772864)
print v(xbgr.mr_n72772976)
print v(xbgr.mr_n72773296)
print v(xbgr.mr_n72773408)
print v(xbgr.mr_n72773728)
print v(xbgr.mr_n72773840)
print v(xbgr.mr_n72774160)
print v(xbgr.mr_n72774272)
print v(xbgr.mr_n72774704)
print v(xbgr.mr_n72775024)
print v(xbgr.mr_n72775136)
print v(xbgr.mr_n72775456)
print v(xbgr.mr_n72775568)
print v(xbgr.mr_n72775888)
print v(xbgr.mr_n72776000)
print v(xbgr.mr_n72776320)
print v(xbgr.mr_n72776432)
print v(xbgr.mr_n72776752)
print v(xbgr.mr_n72776864)
print v(xbgr.mr_n72777184)
print v(xbgr.mr_n72777296)
print v(xbgr.mr_n72777616)
print v(xbgr.mr_n72777728)
print v(xbgr.mr_n72778048)
print v(xbgr.mr_n72778160)
print v(xbgr.mr_n72778480)
print v(xbgr.mr_n72778592)
print v(xbgr.mr_n72778912)
print v(xbgr.mr_n72779024)
print v(xbgr.mr_n72779344)
print v(xbgr.mr_n72779456)
print v(xbgr.mr_n72779776)
print v(xbgr.mr_n72779888)
print v(xbgr.mr_n72780208)
print v(xbgr.mr_n72780320)
print v(xbgr.mr_n72780640)
print v(xbgr.mr_n72780752)
print v(xbgr.mr_n72781072)
print v(xbgr.mr_n72781936)
print v(xbgr.mr_n72782048)
print v(xbgr.mr_n72782368)
print v(xbgr.mr_n72782480)
print v(xbgr.mr_n72782800)
print v(xbgr.mr_n72782912)
print v(xbgr.mr_n72783232)
print v(xbgr.mr_n72783344)
print v(xbgr.mr_n72783664)
print v(xbgr.mr_n72783776)
print v(xbgr.mr_n72784096)
print v(xbgr.mr_n72784208)
print v(xbgr.mr_n72784528)
print v(xbgr.mr_n72784640)
print v(xbgr.mr_n72784960)
print v(xbgr.mr_n72785072)
print v(xbgr.mr_n72785392)
print v(xbgr.mr_n72785504)
print v(xbgr.mr_n72785824)
print v(xbgr.mr_n72785936)
print v(xbgr.mr_n72786256)
print v(xbgr.mr_n72786368)
print v(xbgr.mr_n72786688)
print v(xbgr.mr_n72786800)
print v(xbgr.mr_n72787120)
print v(xbgr.mr_n72787232)
print v(xbgr.mr_n72787552)
print v(xbgr.mr_n72787664)
print v(xbgr.mr_n72787984)
print v(xbgr.mr_n72788096)
print v(xbgr.mr_n72788416)
print v(xbgr.mr_n72788528)
print v(xbgr.mr_n72788848)
print v(xbgr.mr_n72788960)
print v(xbgr.mr_n72789280)
print v(xbgr.mr_n72789392)
print v(xbgr.mr_n72789712)
print v(xbgr.mr_n72789824)
print v(xbgr.mr_n72790144)
print v(xbgr.mr_n72790256)
print v(xbgr.mr_n72790576)
print v(xbgr.mr_n72790688)
print v(xbgr.mr_n72791008)
print v(xbgr.mr_n72791120)
print v(xbgr.mr_n72791440)
print v(xbgr.mr_n72791552)
print v(xbgr.mr_n72791872)
print v(xbgr.mr_n72791984)
print v(xbgr.mr_n72792304)
print v(xbgr.mr_n72792416)
print v(xbgr.mr_n72792736)
print v(xbgr.mr_n72792848)
print v(xbgr.mr_n72793168)
print v(xbgr.mr_n72793280)
print v(xbgr.mr_n72793600)
print v(xbgr.mr_n72793712)
print v(xbgr.mr_n72794032)
print v(xbgr.mr_n72794144)
print v(xbgr.mr_n72794464)
print v(xbgr.mr_n72794576)
print v(xbgr.mr_n72794896)
print v(xbgr.mr_n72795008)
print v(xbgr.mr_n72795328)
print v(xbgr.mr_n72795440)
print v(xbgr.mr_n72795760)
print v(xbgr.mr_n72795872)
print v(xbgr.mr_n72796192)
print v(xbgr.mr_n72796304)
print v(xbgr.mr_n72796624)
print v(xbgr.mr_n72796736)
print v(xbgr.mr_n72797056)
print v(xbgr.mr_n72797168)
print v(xbgr.mr_n72797488)
print v(xbgr.mr_n72797600)
print v(xbgr.mr_n72797920)
print v(xbgr.mr_n72798032)
print v(xbgr.mr_n72798352)
print v(xbgr.mr_n72798464)
print v(xbgr.mr_n72798784)
print v(xbgr.mr_n72798896)
print v(xbgr.mr_n72799216)
print v(xbgr.mr_n72799328)
print v(xbgr.mr_n72799648)
print v(xbgr.mr_n72799760)
print v(xbgr.mr_n72800080)
print v(xbgr.mr_n72800192)
print v(xbgr.mr_n72800512)
print v(xbgr.mr_n72800624)
print v(xbgr.mr_n72800944)
print v(xbgr.mr_n72801056)
print v(xbgr.mr_n72801376)
print v(xbgr.mr_n72801488)
print v(xbgr.mr_n72801808)
print v(xbgr.mr_n72801920)
print v(xbgr.mr_n72802240)
print v(xbgr.mr_n72802352)
print v(xbgr.mr_n72802672)
print v(xbgr.mr_n72802784)
print v(xbgr.mr_n72803104)
print v(xbgr.mr_n72803216)
print v(xbgr.mr_n72803536)
print v(xbgr.mr_n72803648)
print v(xbgr.mr_n72803968)
print v(xbgr.mr_n72804080)
print v(xbgr.mr_n72804400)
print v(xbgr.mr_n72804512)
print v(xbgr.mr_n72804832)
print v(xbgr.mr_n72804944)
print v(xbgr.mr_n72805264)
print v(xbgr.mr_n72805376)
print v(xbgr.mr_n72805696)
print v(xbgr.mr_n72805808)
print v(xbgr.mr_n72806128)
print v(xbgr.mr_n72806240)
print v(xbgr.mr_n72806560)
print v(xbgr.mr_n72806672)
print v(xbgr.mr_n72806992)
print v(xbgr.mr_n72807104)
print v(xbgr.mr_n72807424)
print v(xbgr.mr_n72807536)
print v(xbgr.mr_n72807856)
print v(xbgr.mr_n72807968)
print v(xbgr.mr_n72808288)
print v(xbgr.mr_n72808400)
print v(xbgr.mr_n72808720)
print v(xbgr.mr_n72808832)
print v(xbgr.mr_n72809152)
print v(xbgr.mr_n72809264)
print v(xbgr.mr_n72809584)
print v(xbgr.mr_n72809696)
print v(xbgr.mr_n72810016)
print v(xbgr.mr_n72810128)
print v(xbgr.mr_n72810448)
print v(xbgr.mr_n72810560)
print v(xbgr.mr_n72810880)
print v(xbgr.mr_n72810992)
print v(xbgr.mr_n72811312)
print v(xbgr.mr_n72811424)
print v(xbgr.mr_n72811744)
print v(xbgr.mr_n72811856)
print v(xbgr.mr_n72812176)
print v(xbgr.mr_n72812288)
print v(xbgr.mr_n72812608)
print v(xbgr.mr_n72812720)
print v(xbgr.mr_n72813040)
print v(xbgr.mr_n72813152)
print v(xbgr.mr_n72813472)
print v(xbgr.mr_n72813584)
print v(xbgr.mr_n72813904)
print v(xbgr.mr_n72814016)
print v(xbgr.mr_n72814336)
print v(xbgr.mr_n72814448)
print v(xbgr.mr_n72814768)
print v(xbgr.mr_n72814880)
print v(xbgr.mr_n72815200)
print v(xbgr.mr_n72815312)
print v(xbgr.mr_n72815632)
print v(xbgr.mr_n72815744)
print v(xbgr.mr_n72816064)
print v(xbgr.mr_n72816176)
print v(xbgr.mr_n72816496)
print v(xbgr.mr_n72816608)
print v(xbgr.mr_n72816928)
print v(xbgr.mr_n72817040)
print v(xbgr.mr_n72817360)
print v(xbgr.mr_n72817472)
print v(xbgr.mr_n72817792)
print v(xbgr.mr_n72817904)
print v(xbgr.mr_n72818224)
print v(xbgr.mr_n72818336)
print v(xbgr.mr_n72818656)
print v(xbgr.mr_n72818768)
print v(xbgr.mr_n72819088)
print v(xbgr.mr_n72819200)
print v(xbgr.mr_n72819520)
print v(xbgr.mr_n72819632)
print v(xbgr.mr_n72819952)
print v(xbgr.mr_n72820064)
print v(xbgr.mr_n72820384)
print v(xbgr.mr_n72820496)
print v(xbgr.mr_n72820816)
print v(xbgr.mr_n72820928)
print v(xbgr.mr_n72821248)
print v(xbgr.mr_n72821360)
print v(xbgr.mr_n72821680)
print v(xbgr.mr_n72821792)
print v(xbgr.mr_n72822112)
print v(xbgr.mr_n72822224)
print v(xbgr.mr_n72822544)
print v(xbgr.mr_n72822656)
print v(xbgr.mr_n72822976)
print v(xbgr.mr_n72823088)
print v(xbgr.mr_n72823408)
print v(xbgr.mr_n72823520)
print v(xbgr.mr_n72823840)
print v(xbgr.mr_n72823952)
print v(xbgr.mr_n72824272)
print v(xbgr.mr_n72824384)
print v(xbgr.mr_n72824704)
print v(xbgr.mr_n72824816)
print v(xbgr.mr_n72825136)
print v(xbgr.mr_n72825248)
print v(xbgr.mr_n72825568)
print v(xbgr.mr_n72825680)
print v(xbgr.mr_n72826000)
print v(xbgr.mr_n72826112)
print v(xbgr.mr_n72826432)
print v(xbgr.mr_n72826544)
print v(xbgr.mr_n72826864)
print v(xbgr.mr_n72826976)
print v(xbgr.mr_n72827296)
print v(xbgr.mr_n72827408)
print v(xbgr.mr_n72827728)
print v(xbgr.mr_n72827840)
print v(xbgr.mr_n72828160)
print v(xbgr.mr_n72828272)
print v(xbgr.mr_n72828592)
print v(xbgr.mr_n72828704)
print v(xbgr.mr_n72829024)
print v(xbgr.mr_n72829136)
print v(xbgr.mr_n72829456)
print v(xbgr.mr_n72829568)
print v(xbgr.mr_n72829888)
print v(xbgr.mr_n72830000)
print v(xbgr.mr_n72830320)
print v(xbgr.mr_n72830432)
print v(xbgr.mr_n72830752)
print v(xbgr.mr_n72830864)
print v(xbgr.mr_n72831184)
print v(xbgr.mr_n72831296)
print v(xbgr.mr_n72831616)
print v(xbgr.mr_n72831728)
print v(xbgr.mr_n72832048)
print v(xbgr.mr_n72832160)
print v(xbgr.mr_n72832480)
print v(xbgr.mr_n72832592)
print v(xbgr.mr_n72832912)
print v(xbgr.mr_n72833024)
print v(xbgr.mr_n72833344)
print v(xbgr.mr_n72833456)
print v(xbgr.mr_n72833776)
print v(xbgr.mr_n72833888)
print v(xbgr.mr_n72834208)
print v(xbgr.mr_n72834320)
print v(xbgr.mr_n72834640)
print v(xbgr.mr_n72834752)
print v(xbgr.mr_n72835072)
print v(xbgr.mr_n72835184)
print v(xbgr.mr_n72835504)
print v(xbgr.mr_n72835616)
print v(xbgr.mr_n72835936)
print v(xbgr.mr_n72836048)
print v(xbgr.mr_n72836368)
print v(xbgr.mr_n72836480)
print v(xbgr.mr_n72836800)
print v(xbgr.mr_n72836912)
print v(xbgr.mr_n72837232)
print v(xbgr.mr_n72837344)
print v(xbgr.mr_n72837664)
print v(xbgr.mr_n72837776)
print v(xbgr.mr_n72838096)
print v(xbgr.mr_n72838208)
print v(xbgr.mr_n72838528)
print v(xbgr.mr_n72838640)
print v(xbgr.mr_n72838960)
print v(xbgr.mr_n72839072)
print v(xbgr.mr_n72839392)
print v(xbgr.mr_n72839504)
print v(xbgr.mr_n72839824)
print v(xbgr.mr_n72839936)
print v(xbgr.mr_n72840256)
print v(xbgr.mr_n72840368)
print v(xbgr.mr_n72840688)
print v(xbgr.mr_n72840800)
print v(xbgr.mr_n72841120)
print v(xbgr.mr_n72841232)
print v(xbgr.mr_n72841552)
print v(xbgr.mr_n72841664)
print v(xbgr.mr_n72841984)
print v(xbgr.mr_n72842096)
print v(xbgr.mr_n72842416)
print v(xbgr.mr_n72842528)
print v(xbgr.mr_n72842848)
print v(xbgr.mr_n72842960)
print v(xbgr.mr_n72843280)
print v(xbgr.mr_n72843392)
print v(xbgr.mr_n72843712)
print v(xbgr.mr_n72843824)
print v(xbgr.mr_n72844144)
print v(xbgr.mr_n72844256)
print v(xbgr.mr_n72844576)
print v(xbgr.mr_n72844688)
print v(xbgr.mr_n72845008)
print v(xbgr.mr_n72845120)
print v(xbgr.mr_n72845440)
print v(xbgr.mr_n72845552)
print v(xbgr.mr_n72845872)
print v(xbgr.mr_n72845984)
print v(xbgr.mr_n72846304)
print v(xbgr.mr_n72846416)
print v(xbgr.mr_n72846736)
print v(xbgr.mr_n72846848)
print v(xbgr.mr_n72847168)
print v(xbgr.mr_n72847280)
print v(xbgr.mr_n72847600)
print v(xbgr.mr_n72847712)
print v(xbgr.mr_n72848032)
print v(xbgr.mr_n72848144)
print v(xbgr.mr_n72848464)
print v(xbgr.mr_n72848576)
print v(xbgr.mr_n72848896)
print v(xbgr.mr_n72849008)
print v(xbgr.mr_n72849328)
print v(xbgr.mr_n72849440)
print v(xbgr.mr_n72849760)
print v(xbgr.mr_n72849872)
print v(xbgr.mr_n72850192)
print v(xbgr.mr_n72850304)
print v(xbgr.mr_n72850624)
print v(xbgr.mr_n72850736)
print v(xbgr.mr_n72851056)
print v(xbgr.mr_n72851168)
print v(xbgr.mr_n72851488)
print v(xbgr.mr_n72851600)
print v(xbgr.mr_n72851920)
print v(xbgr.mr_n72852032)
print v(xbgr.mr_n72852352)
print v(xbgr.mr_n72852464)
print v(xbgr.mr_n72852784)
print v(xbgr.mr_n72852896)
print v(xbgr.mr_n72853216)
print v(xbgr.mr_n72853328)
print v(xbgr.mr_n72853648)
print v(xbgr.mr_n72853760)
print v(xbgr.mr_n72854080)
print v(xbgr.mr_n72854192)
print v(xbgr.mr_n72854512)
print v(xbgr.mr_n72854624)
print v(xbgr.mr_n72854944)
print v(xbgr.mr_n72855056)
print v(xbgr.mr_n72855376)
print v(xbgr.mr_n72855488)
print v(xbgr.mr_n72855808)
print v(xbgr.mr_n72855920)
print v(xbgr.mr_n72856240)
print v(xbgr.mr_n72856352)
print v(xbgr.mr_n72856672)
print v(xbgr.mr_n72856784)
print v(xbgr.mr_n72857104)
print v(xbgr.mr_n72857216)
print v(xbgr.mr_n72857536)
print v(xbgr.mr_n72857648)
print v(xbgr.mr_n72857968)
print v(xbgr.mr_n72858080)
print v(xbgr.mr_n72858400)
print v(xbgr.mr_n72858512)
print v(xbgr.mr_n72858832)
print v(xbgr.mr_n72858944)
print v(xbgr.mr_n72859264)
print v(xbgr.mr_n72859376)
print v(xbgr.mr_n72859696)
print v(xbgr.mr_n72859808)
print v(xbgr.mr_n72860128)
print v(xbgr.mr_n72860240)
print v(xbgr.mr_n72860560)
print v(xbgr.mr_n72860672)
print v(xbgr.mr_n72860992)
print v(xbgr.mr_n72861104)
print v(xbgr.mr_n72861424)
print v(xbgr.mr_n72861536)
print v(xbgr.mr_n72861856)
print v(xbgr.mr_n72861968)
print v(xbgr.mr_n72862288)
print v(xbgr.mr_n72862400)
print v(xbgr.mr_n72862720)
print v(xbgr.mr_n72862832)
print v(xbgr.mr_n72863152)
print v(xbgr.mr_n72863264)
print v(xbgr.mr_n72863584)
print v(xbgr.mr_n72863696)
print v(xbgr.mr_n72864016)
print v(xbgr.mr_n72864128)
print v(xbgr.mr_n72864448)
print v(xbgr.mr_n72864560)
print v(xbgr.mr_n72864880)
print v(xbgr.mr_n72864992)
print v(xbgr.mr_n72865312)
print v(xbgr.mr_n72865424)
print v(xbgr.mr_n72865744)
print v(xbgr.mr_n72865856)
print v(xbgr.mr_n72866176)
print v(xbgr.mr_n72866288)
print v(xbgr.mr_n72866608)
print v(xbgr.mr_n72866720)
print v(xbgr.mr_n72867040)
print v(xbgr.mr_n72867152)
print v(xbgr.mr_n72867472)
print v(xbgr.mr_n72867584)
print v(xbgr.mr_n72867904)
print v(xbgr.mr_n72868016)
print v(xbgr.mr_n72868336)
print v(xbgr.mr_n72868448)
print v(xbgr.mr_n72868768)
print v(xbgr.mr_n72868880)
print v(xbgr.mr_n72869200)
print v(xbgr.mr_n72869312)
print v(xbgr.mr_n72869632)
print v(xbgr.mr_n72869744)
print v(xbgr.mr_n72870064)
print v(xbgr.mr_n72870176)
print v(xbgr.mr_n72870496)
print v(xbgr.mr_n72870608)
print v(xbgr.mr_n72870928)
print v(xbgr.mr_n72871040)
print v(xbgr.mr_n72871360)
print v(xbgr.mr_n72871472)
print v(xbgr.mr_n72871792)
print v(xbgr.mr_n72871904)
print v(xbgr.mr_n72872224)
print v(xbgr.mr_n72872336)
print v(xbgr.mr_n72872656)
print v(xbgr.mr_n72872768)
print v(xbgr.mr_n72873088)
print v(xbgr.mr_n72873200)
print v(xbgr.mr_n72873520)
print v(xbgr.mr_n72873632)
print v(xbgr.mr_n72873952)
print v(xbgr.mr_n72874064)
print v(xbgr.mr_n72874384)
print v(xbgr.mr_n72874496)
print v(xbgr.mr_n72874816)
print v(xbgr.mr_n72874928)
print v(xbgr.mr_n72875248)
print v(xbgr.mr_n72875360)
print v(xbgr.mr_n72875680)
print v(xbgr.mr_n72875792)
print v(xbgr.mr_n72876112)
print v(xbgr.mr_n72876224)
print v(xbgr.mr_n72876544)
print v(xbgr.mr_n72876656)
print v(xbgr.mr_n72876976)
print v(xbgr.mr_n72877088)
print v(xbgr.mr_n72877408)
print v(xbgr.mr_n72877520)
print v(xbgr.mr_n72877840)
print v(xbgr.mr_n72877952)
print v(xbgr.mr_n72878272)
print v(xbgr.mr_n72878384)
print v(xbgr.mr_n72878704)
print v(xbgr.mr_n72878816)
print v(xbgr.mr_n72879136)
print v(xbgr.mr_n72879248)
print v(xbgr.mr_n72879568)
print v(xbgr.mr_n72879680)
print v(xbgr.mr_n72880000)
print v(xbgr.mr_n72880112)
print v(xbgr.mr_n72880432)
print v(xbgr.mr_n72880544)
print v(xbgr.mr_n72880864)
print v(xbgr.mr_n72880976)
print v(xbgr.mr_n72881296)
print v(xbgr.mr_n72881408)
print v(xbgr.mr_n72881728)
print v(xbgr.mr_n72881840)
print v(xbgr.mr_n72882160)
print v(xbgr.mr_n72882272)
print v(xbgr.mr_n72882592)
print v(xbgr.mr_n72882704)
print v(xbgr.mr_n72883024)
print v(xbgr.mr_n72883136)
print v(xbgr.mr_n72883456)
print v(xbgr.mr_n72883568)
print v(xbgr.mr_n72883888)
print v(xbgr.mr_n72884000)
print v(xbgr.mr_n72884320)
print v(xbgr.mr_n72884432)
print v(xbgr.mr_n72884752)
print v(xbgr.mr_n72884864)
print v(xbgr.mr_n72885184)
print v(xbgr.mr_n72885296)
print v(xbgr.mr_n72885616)
print v(xbgr.mr_n72885728)
print v(xbgr.mr_n72886048)
print v(xbgr.mr_n72886160)
print v(xbgr.mr_n72886480)
print v(xbgr.mr_n72886592)
print v(xbgr.mr_n72886912)
print v(xbgr.mr_n72887024)
print v(xbgr.mr_n72887344)
print v(xbgr.mr_n72887456)
print v(xbgr.mr_n72887776)
print v(xbgr.mr_n72887888)
print v(xbgr.mr_n72888208)
print v(xbgr.mr_n72888320)
print v(xbgr.mr_n72888640)
print v(xbgr.mr_n72888752)
print v(xbgr.mr_n72889072)
print v(xbgr.mr_n72889184)
print v(xbgr.mr_n72889504)
print v(xbgr.mr_n72889616)
print v(xbgr.mr_n72889936)
print v(xbgr.mr_n72890048)
print v(xbgr.mr_n72890368)
print v(xbgr.mr_n72890480)
print v(xbgr.mr_n72890800)
print v(xbgr.mr_n72890912)
print v(xbgr.mr_n72891232)
print v(xbgr.mr_n72891344)
print v(xbgr.mr_n72891664)
print v(xbgr.mr_n72891776)
print v(xbgr.mr_n72892096)
print v(xbgr.mr_n72892208)
print v(xbgr.mr_n72892528)
print v(xbgr.mr_n72892640)
print v(xbgr.mr_n72892960)
print v(xbgr.mr_n72893072)
print v(xbgr.mr_n72893392)
print v(xbgr.mr_n72893504)
print v(xbgr.mr_n72893824)
print v(xbgr.mr_n72893936)
print v(xbgr.mr_n72894256)
print v(xbgr.mr_n72894368)
print v(xbgr.mr_n72894688)
print v(xbgr.mr_n72894800)
print v(xbgr.mr_n72895120)
print v(xbgr.mr_n72895232)
print v(xbgr.mr_n72895552)
print v(xbgr.mr_n72895664)
print v(xbgr.mr_n72895984)
print v(xbgr.mr_n72896096)
print v(xbgr.mr_n72896416)
print v(xbgr.mr_n72896528)
print v(xbgr.mr_n72896848)
print v(xbgr.mr_n72896960)
print v(xbgr.mr_n72897280)
print v(xbgr.mr_n72897392)
print v(xbgr.mr_n72897712)
print v(xbgr.mr_n72897824)
print v(xbgr.mr_n72898144)
print v(xbgr.mr_n72898256)
print v(xbgr.mr_n72898576)
print v(xbgr.mr_n72898688)
print v(xbgr.mr_n72899008)
print v(xbgr.mr_n72899120)
print v(xbgr.mr_n72899440)
print v(xbgr.mr_n72899552)
print v(xbgr.mr_n72899872)
print v(xbgr.mr_n72899984)
print v(xbgr.mr_n72900304)
print v(xbgr.mr_n72900416)
print v(xbgr.mr_n72900736)
print v(xbgr.mr_n72900848)
print v(xbgr.mr_n72901168)
print v(xbgr.mr_n72901280)
print v(xbgr.mr_n72901600)
print v(xbgr.mr_n72901712)
print v(xbgr.mr_n72902032)
print v(xbgr.mr_n72902144)
print v(xbgr.mr_n72902464)
print v(xbgr.mr_n72902576)
print v(xbgr.mr_n72902896)
print v(xbgr.mr_n72903008)
print v(xbgr.mr_n72903328)
print v(xbgr.mr_n72903440)
print v(xbgr.mr_n72903760)
print v(xbgr.mr_n72903872)
print v(xbgr.mr_n72904192)
print v(xbgr.mr_n72904304)
print v(xbgr.mr_n72904624)
print v(xbgr.mr_n72904736)
print v(xbgr.mr_n72905056)
print v(xbgr.mr_n72905168)
print v(xbgr.mr_n72905488)
print v(xbgr.mr_n72905600)
print v(xbgr.mr_n72905920)
print v(xbgr.mr_n72906032)
print v(xbgr.mr_n72906352)
print v(xbgr.mr_n72906464)
print v(xbgr.mr_n72906784)
print v(xbgr.mr_n72906896)
print v(xbgr.mr_n72907216)
print v(xbgr.mr_n72907328)
print v(xbgr.mr_n72907648)
print v(xbgr.mr_n72907760)
print v(xbgr.mr_n72908080)
print v(xbgr.mr_n72908192)
print v(xbgr.mr_n72908512)
print v(xbgr.mr_n72908624)
print v(xbgr.mr_n72908944)
print v(xbgr.mr_n72909056)
print v(xbgr.mr_n72909376)
print v(xbgr.mr_n72909488)
print v(xbgr.mr_n72909808)
print v(xbgr.mr_n72909920)
print v(xbgr.mr_n72910240)
print v(xbgr.mr_n72910352)
print v(xbgr.mr_n72910672)
print v(xbgr.mr_n72910784)
print v(xbgr.mr_n72911104)
print v(xbgr.mr_n72911216)
print v(xbgr.mr_n72911536)
print v(xbgr.mr_n72911648)
print v(xbgr.mr_n72911968)
print v(xbgr.mr_n72912080)
print v(xbgr.mr_n72912400)
print v(xbgr.mr_n72912512)
print v(xbgr.mr_n72912832)
print v(xbgr.mr_n72912944)
print v(xbgr.mr_n72913264)
print v(xbgr.mr_n72913376)
print v(xbgr.mr_n72913696)
print v(xbgr.mr_n72913808)
print v(xbgr.mr_n72914128)
print v(xbgr.mr_n72914240)
print v(xbgr.mr_n72914560)
print v(xbgr.mr_n72914672)
print v(xbgr.mr_n72914992)
print v(xbgr.mr_n72915104)
print v(xbgr.mr_n72915424)
print v(xbgr.mr_n72915536)
print v(xbgr.mr_n72915856)
print v(xbgr.mr_n72915968)
print v(xbgr.mr_n72916288)
print v(xbgr.mr_n72916400)
print v(xbgr.mr_n72916720)
print v(xbgr.mr_n72916832)
print v(xbgr.mr_n72917152)
print v(xbgr.mr_n72917264)
print v(xbgr.mr_n72917584)
print v(xbgr.mr_n72917696)
print v(xbgr.mr_n72918016)
print v(xbgr.mr_n72918128)
print v(xbgr.mr_n72918448)
print v(xbgr.mr_n72918560)
print v(xbgr.mr_n72918880)
print v(xbgr.mr_n72918992)
print v(xbgr.mr_n72919312)
print v(xbgr.mr_n72919424)
print v(xbgr.mr_n72919744)
print v(xbgr.mr_n72919856)
print v(xbgr.mr_n72920176)
print v(xbgr.mr_n72920288)
print v(xbgr.mr_n72920608)
print v(xbgr.mr_n72920720)
print v(xbgr.mr_n72921040)
print v(xbgr.mr_n72921152)
print v(xbgr.mr_n72921472)
print v(xbgr.mr_n72921584)
print v(xbgr.mr_n72921904)
print v(xbgr.mr_n72922016)
print v(xbgr.mr_n72922336)
print v(xbgr.mr_n72922448)
print v(xbgr.mr_n72922768)
print v(xbgr.mr_n72922880)
print v(xbgr.mr_n72923200)
print v(xbgr.mr_n72923312)
print v(xbgr.mr_n72923632)
print v(xbgr.mr_n72923744)
print v(xbgr.mr_n72924064)
print v(xbgr.mr_n72924176)
print v(xbgr.mr_n72924496)
print v(xbgr.mr_n72924608)
print v(xbgr.mr_n72924928)
print v(xbgr.mr_n72925040)
print v(xbgr.mr_n72925360)
print v(xbgr.mr_n72925472)
print v(xbgr.mr_n72925792)
print v(xbgr.mr_n72925904)
print v(xbgr.mr_n72926224)
print v(xbgr.mr_n72926336)
print v(xbgr.mr_n72926656)
print v(xbgr.mr_n72926768)
print v(xbgr.mr_n72927088)
print v(xbgr.mr_n72927200)
print v(xbgr.mr_n72927520)
print v(xbgr.mr_n72927632)
print v(xbgr.mr_n72927952)
print v(xbgr.mr_n72928064)
print v(xbgr.mr_n72928384)
print v(xbgr.mr_n72928496)
print v(xbgr.mr_n72928816)
print v(xbgr.mr_n72928928)
print v(xbgr.mr_n72929248)
print v(xbgr.mr_n72929360)
print v(xbgr.mr_n72929680)
print v(xbgr.mr_n72929792)
print v(xbgr.mr_n72930112)
print v(xbgr.mr_n72930224)
print v(xbgr.mr_n72930544)
print v(xbgr.mr_n72930656)
print v(xbgr.mr_n72930976)
print v(xbgr.mr_n72931088)
print v(xbgr.mr_n72931408)
print v(xbgr.mr_n72931520)
print v(xbgr.mr_n72931840)
print v(xbgr.mr_n72931952)
print v(xbgr.mr_n72932272)
print v(xbgr.mr_n72932384)
print v(xbgr.mr_n72932704)
print v(xbgr.mr_n72932816)
print v(xbgr.mr_n72933136)
print v(xbgr.mr_n72933248)
print v(xbgr.mr_n72933568)
print v(xbgr.mr_n72933680)
print v(xbgr.mr_n72934000)
print v(xbgr.mr_n72934112)
print v(xbgr.mr_n72934432)
print v(xbgr.mr_n72934544)
print v(xbgr.mr_n72934864)
print v(xbgr.mr_n72934976)
print v(xbgr.mr_n72935296)
print v(xbgr.mr_n72935408)
print v(xbgr.mr_n72935728)
print v(xbgr.mr_n72935840)
print v(xbgr.mr_n72936160)
print v(xbgr.mr_n72936272)
print v(xbgr.mr_n72936592)
print v(xbgr.mr_n72936704)
print v(xbgr.mr_n72937024)
print v(xbgr.mr_n72937136)
print v(xbgr.mr_n72937456)
print v(xbgr.mr_n72937568)
print v(xbgr.mr_n72937888)
print v(xbgr.mr_n72938000)
print v(xbgr.mr_n72938320)
print v(xbgr.mr_n72938432)
print v(xbgr.mr_n72938752)
print v(xbgr.mr_n72938864)
print v(xbgr.mr_n72939184)
print v(xbgr.mr_n72939296)
print v(xbgr.mr_n72939616)
print v(xbgr.mr_n72939728)
print v(xbgr.mr_n72940048)
print v(xbgr.mr_n72940160)
print v(xbgr.mr_n72940480)
print v(xbgr.mr_n72940592)
print v(xbgr.mr_n72940912)
print v(xbgr.mr_n72941024)
print v(xbgr.mr_n72941344)
print v(xbgr.mr_n72941456)
print v(xbgr.mr_n72941776)
print v(xbgr.mr_n72941888)
print v(xbgr.mr_n72942208)
print v(xbgr.mr_n72942320)
print v(xbgr.mr_n72942640)
print v(xbgr.mr_n72942752)
print v(xbgr.mr_n72943072)
print v(xbgr.mr_n72943184)
print v(xbgr.mr_n72943504)
print v(xbgr.mr_n72943616)
print v(xbgr.mr_n72943936)
print v(xbgr.mr_n72944048)
print v(xbgr.mr_n72944368)
print v(xbgr.mr_n72944480)
print v(xbgr.mr_n72944800)
print v(xbgr.mr_n72944912)
print v(xbgr.mr_n72945232)
print v(xbgr.mr_n72945344)
print v(xbgr.mr_n72945664)
print v(xbgr.mr_n72945776)
print v(xbgr.mr_n72946096)
print v(xbgr.mr_n72946208)
print v(xbgr.mr_n72946528)
print v(xbgr.mr_n72946640)
print v(xbgr.mr_n72946960)
print v(xbgr.mr_n72947072)
print v(xbgr.mr_n72947392)
print v(xbgr.mr_n72947504)
print v(xbgr.mr_n72947824)
print v(xbgr.mr_n72947936)
print v(xbgr.mr_n72948256)
print v(xbgr.mr_n72948368)
print v(xbgr.mr_n72948688)
print v(xbgr.mr_n72948800)
print v(xbgr.mr_n72949120)
print v(xbgr.mr_n72949232)
print v(xbgr.mr_n72949552)
print v(xbgr.mr_n72949664)
print v(xbgr.mr_n72949984)
print v(xbgr.mr_n72950096)
print v(xbgr.mr_n72950416)
print v(xbgr.mr_n72950528)
print v(xbgr.mr_n72950848)
print v(xbgr.mr_n72950960)
print v(xbgr.mr_n72951280)
print v(xbgr.mr_n72951392)
print v(xbgr.mr_n72951712)
print v(xbgr.mr_n72951824)
print v(xbgr.mr_n72952144)
print v(xbgr.mr_n72952256)
print v(xbgr.mr_n72952576)
print v(xbgr.mr_n72952688)
print v(xbgr.mr_n72953008)
print v(xbgr.mr_n72953120)
print v(xbgr.mr_n72953552)
print v(xbgr.mr_n72953872)
print v(xbgr.mr_n72953984)
print v(xbgr.mr_n72954304)
print v(xbgr.mr_n72954416)
print v(xbgr.mr_n72954736)
print v(xbgr.mr_n72954848)
print v(xbgr.mr_n72955168)
print v(xbgr.mr_n72955280)
print v(xbgr.mr_n72955600)
print v(xbgr.mr_n72956464)
print v(xbgr.mr_n72956576)
print v(xbgr.mr_n72956896)
print v(xbgr.mr_n72957008)
print v(xbgr.mr_n72957328)
print v(xbgr.mr_n72957440)
print v(xbgr.mr_n72957760)
print v(xbgr.mr_n72957872)
print v(xbgr.mr_n72958192)
print v(xbgr.mr_n72958304)
print v(xbgr.mr_n72958624)
print v(xbgr.mr_n72958736)
print v(xbgr.mr_n72959056)
print v(xbgr.mr_n72959168)
print v(xbgr.mr_n72959488)
print v(xbgr.mr_n72959600)
print v(xbgr.mr_n72959920)
print v(xbgr.mr_n72960032)
print v(xbgr.mr_n72960352)
print v(xbgr.mr_n72960464)
print v(xbgr.mr_n72960784)
print v(xbgr.mr_n72960896)
print v(xbgr.mr_n72961328)
print v(xbgr.mr_n72961648)
print v(xbgr.mr_n72961760)
print v(xbgr.mr_n72962080)
print v(xbgr.mr_n72962192)
print v(xbgr.mr_n72962512)
print v(xbgr.mr_n72962624)
print v(xbgr.mr_n72962944)
print v(xbgr.mr_n72963056)
print v(xbgr.mr_n72963376)
print v(xbgr.mr_n72963488)
print v(xbgr.mr_n72963808)
print v(xbgr.mr_n72963920)
print v(xbgr.mr_n72964240)
print v(xbgr.mr_n72964352)
print v(xbgr.mr_n72964672)
print v(xbgr.mr_n72964784)
print v(xbgr.mr_n72965104)
print v(xbgr.mr_n72965216)
print v(xbgr.mr_n72965536)
print v(xbgr.mr_n72965648)
print v(xbgr.mr_n72965968)
print v(xbgr.mr_n72966080)
print v(xbgr.mr_n72966400)
print v(xbgr.mr_n72966512)
print v(xbgr.mr_n72966832)
print v(xbgr.mr_n72966944)
print v(xbgr.mr_n72967264)
print v(xbgr.mr_n72967376)
print v(xbgr.mr_n72967696)
print v(xbgr.mr_n72967808)
print v(xbgr.mr_n72968128)
print v(xbgr.mr_n72968240)
print v(xbgr.mr_n72968560)
print v(xbgr.mr_n72968672)
print v(xbgr.mr_n72968992)
print v(xbgr.mr_n72969104)
print v(xbgr.mr_n72969424)
print v(xbgr.mr_n72969536)
print v(xbgr.mr_n72969856)
print v(xbgr.mr_n72969968)
print v(xbgr.mr_n72970288)
print v(xbgr.mr_n72970400)
print v(xbgr.mr_n72970720)
print v(xbgr.mr_n72970832)
print v(xbgr.mr_n72971152)
print v(xbgr.mr_n72971264)
print v(xbgr.mr_n72971584)
print v(xbgr.mr_n72971696)
print v(xbgr.mr_n72972016)
print v(xbgr.mr_n72972128)
print v(xbgr.mr_n72972448)
print v(xbgr.mr_n72972560)
print v(xbgr.mr_n72972880)
print v(xbgr.mr_n72972992)
print v(xbgr.mr_n72973312)
print v(xbgr.mr_n72973424)
print v(xbgr.mr_n72973744)
print v(xbgr.mr_n72973856)
print v(xbgr.mr_n72974176)
print v(xbgr.mr_n72974288)
print v(xbgr.mr_n72974608)
print v(xbgr.mr_n72974720)
print v(xbgr.mr_n72975040)
print v(xbgr.mr_n72975152)
print v(xbgr.mr_n72975472)
print v(xbgr.mr_n72975584)
print v(xbgr.mr_n72975904)
print v(xbgr.mr_n72976016)
print v(xbgr.mr_n72976336)
print v(xbgr.mr_n72976448)
print v(xbgr.mr_n72976768)
print v(xbgr.mr_n72976880)
print v(xbgr.mr_n72977200)
print v(xbgr.mr_n72977312)
print v(xbgr.mr_n72977632)
print v(xbgr.mr_n72977744)
print v(xbgr.mr_n72978064)
print v(xbgr.mr_n72978928)
print v(xbgr.mr_n72979040)
print v(xbgr.mr_n72979360)
print v(xbgr.mr_n72979472)
print v(xbgr.mr_n72979792)
print v(xbgr.mr_n72979904)
print v(xbgr.mr_n72980224)
print v(xbgr.mr_n72980336)
print v(xbgr.mr_n72980656)
print v(xbgr.mr_n72980768)
print v(xbgr.mr_n72981088)
print v(xbgr.mr_n72981200)
print v(xbgr.mr_n72981520)
print v(xbgr.mr_n72981632)
print v(xbgr.mr_n72981952)
print v(xbgr.mr_n72982064)
print v(xbgr.mr_n72982384)
print v(xbgr.mr_n72982496)
print v(xbgr.mr_n72982816)
print v(xbgr.mr_n72982928)
print v(xbgr.mr_n72983248)
print v(xbgr.mr_n72983360)
print v(xbgr.mr_n72983680)
print v(xbgr.mr_n72983792)
print v(xbgr.mr_n72984112)
print v(xbgr.mr_n72984224)
print v(xbgr.mr_n72984544)
print v(xbgr.mr_n72984656)
print v(xbgr.mr_n72984976)
print v(xbgr.mr_n72985088)
print v(xbgr.mr_n72985408)
print v(xbgr.mr_n72985520)
print v(xbgr.mr_n72985840)
print v(xbgr.mr_n72985952)
print v(xbgr.mr_n72986272)
print v(xbgr.mr_n72986384)
print v(xbgr.mr_n72986704)
print v(xbgr.mr_n72986816)
print v(xbgr.mr_n72987136)
print v(xbgr.mr_n72987248)
print v(xbgr.mr_n72987568)
print v(xbgr.mr_n72987680)
print v(xbgr.mr_n72988000)
print v(xbgr.mr_n72988112)
print v(xbgr.mr_n72988432)
print v(xbgr.mr_n72988544)
print v(xbgr.mr_n72988864)
print v(xbgr.mr_n72988976)
print v(xbgr.mr_n72989296)
print v(xbgr.mr_n72989408)
print v(xbgr.mr_n72989728)
print v(xbgr.mr_n72989840)
print v(xbgr.mr_n72990160)
print v(xbgr.mr_n72990272)
print v(xbgr.mr_n72990592)
print v(xbgr.mr_n72990704)
print v(xbgr.mr_n72991024)
print v(xbgr.mr_n72991136)
print v(xbgr.mr_n72991456)
print v(xbgr.mr_n72991568)
print v(xbgr.mr_n72991888)
print v(xbgr.mr_n72992000)
print v(xbgr.mr_n72992320)
print v(xbgr.mr_n72992432)
print v(xbgr.mr_n72992752)
print v(xbgr.mr_n72992864)
print v(xbgr.mr_n72993184)
print v(xbgr.mr_n72993296)
print v(xbgr.mr_n72993616)
print v(xbgr.mr_n72993728)
print v(xbgr.mr_n72994048)
print v(xbgr.mr_n72994160)
print v(xbgr.mr_n72994480)
print v(xbgr.mr_n72994592)
print v(xbgr.mr_n72994912)
print v(xbgr.mr_n72995024)
print v(xbgr.mr_n72995344)
print v(xbgr.mr_n72995456)
print v(xbgr.mr_n72995776)
print v(xbgr.mr_n72995888)
print v(xbgr.mr_n72996208)
print v(xbgr.mr_n72996320)
print v(xbgr.mr_n72996640)
print v(xbgr.mr_n72996752)
print v(xbgr.mr_n72997072)
print v(xbgr.mr_n72997184)
print v(xbgr.mr_n72997504)
print v(xbgr.mr_n72997616)
print v(xbgr.mr_n72997936)
print v(xbgr.mr_n72998048)
print v(xbgr.mr_n72998368)
print v(xbgr.mr_n72998480)
print v(xbgr.mr_n72998800)
print v(xbgr.mr_n72998912)
print v(xbgr.mr_n72999232)
print v(xbgr.mr_n72999344)
print v(xbgr.mr_n72999664)
print v(xbgr.mr_n72999776)
print v(xbgr.mr_n73000096)
print v(xbgr.mr_n73000208)
print v(xbgr.mr_n73000528)
print v(xbgr.mr_n73000640)
print v(xbgr.mr_n73000960)
print v(xbgr.mr_n73001072)
print v(xbgr.mr_n73001392)
print v(xbgr.mr_n73001504)
print v(xbgr.mr_n73001824)
print v(xbgr.mr_n73001936)
print v(xbgr.mr_n73002256)
print v(xbgr.mr_n73002368)
print v(xbgr.mr_n73002688)
print v(xbgr.mr_n73002800)
print v(xbgr.mr_n73003120)
print v(xbgr.mr_n73003232)
print v(xbgr.mr_n73003552)
print v(xbgr.mr_n73003664)
print v(xbgr.mr_n73003984)
print v(xbgr.mr_n73004096)
print v(xbgr.mr_n73004416)
print v(xbgr.mr_n73004528)
print v(xbgr.mr_n73004848)
print v(xbgr.mr_n73004960)
print v(xbgr.mr_n73005280)
print v(xbgr.mr_n73005392)
print v(xbgr.mr_n73005712)
print v(xbgr.mr_n73005824)
print v(xbgr.mr_n73006144)
print v(xbgr.mr_n73006256)
print v(xbgr.mr_n73006576)
print v(xbgr.mr_n73006688)
print v(xbgr.mr_n73007008)
print v(xbgr.mr_n73007120)
print v(xbgr.mr_n73007440)
print v(xbgr.mr_n73007552)
print v(xbgr.mr_n73007872)
print v(xbgr.mr_n73007984)
print v(xbgr.mr_n73008304)
print v(xbgr.mr_n73008416)
print v(xbgr.mr_n73008736)
print v(xbgr.mr_n73008848)
print v(xbgr.mr_n73009168)
print v(xbgr.mr_n73009280)
print v(xbgr.mr_n73009600)
print v(xbgr.mr_n73009712)
print v(xbgr.mr_n73010032)
print v(xbgr.mr_n73010144)
print v(xbgr.mr_n73010464)
print v(xbgr.mr_n73010576)
print v(xbgr.mr_n73010896)
print v(xbgr.mr_n73011008)
print v(xbgr.mr_n73011328)
print v(xbgr.mr_n73011440)
print v(xbgr.mr_n73011760)
print v(xbgr.mr_n73011872)
print v(xbgr.mr_n73012192)
print v(xbgr.mr_n73012304)
print v(xbgr.mr_n73012624)
print v(xbgr.mr_n73012736)
print v(xbgr.mr_n73013056)
print v(xbgr.mr_n73013168)
print v(xbgr.mr_n73013488)
print v(xbgr.mr_n73013600)
print v(xbgr.mr_n73013920)
print v(xbgr.mr_n73014032)
print v(xbgr.mr_n73014352)
print v(xbgr.mr_n73014464)
print v(xbgr.mr_n73014784)
print v(xbgr.mr_n73014896)
print v(xbgr.mr_n73015216)
print v(xbgr.mr_n73015328)
print v(xbgr.mr_n73015648)
print v(xbgr.mr_n73015760)
print v(xbgr.mr_n73016080)
print v(xbgr.mr_n73016192)
print v(xbgr.mr_n73016512)
print v(xbgr.mr_n73016624)
print v(xbgr.mr_n73016944)
print v(xbgr.mr_n73017056)
print v(xbgr.mr_n73017376)
print v(xbgr.mr_n73017488)
print v(xbgr.mr_n73017808)
print v(xbgr.mr_n73017920)
print v(xbgr.mr_n73018240)
print v(xbgr.mr_n73018352)
print v(xbgr.mr_n73018672)
print v(xbgr.mr_n73018784)
print v(xbgr.mr_n73019104)
print v(xbgr.mr_n73019216)
print v(xbgr.mr_n73019536)
print v(xbgr.mr_n73019648)
print v(xbgr.mr_n73019968)
print v(xbgr.mr_n73020080)
print v(xbgr.mr_n73020400)
print v(xbgr.mr_n73020512)
print v(xbgr.mr_n73020832)
print v(xbgr.mr_n73020944)
print v(xbgr.mr_n73021264)
print v(xbgr.mr_n73021376)
print v(xbgr.mr_n73021696)
print v(xbgr.mr_n73021808)
print v(xbgr.mr_n73022128)
print v(xbgr.mr_n73022240)
print v(xbgr.mr_n73022560)
print v(xbgr.mr_n73022672)
print v(xbgr.mr_n73022992)
print v(xbgr.mr_n73023104)
print v(xbgr.mr_n73023424)
print v(xbgr.mr_n73023536)
print v(xbgr.mr_n73023856)
print v(xbgr.mr_n73023968)
print v(xbgr.mr_n73024288)
print v(xbgr.mr_n73024400)
print v(xbgr.mr_n73024720)
print v(xbgr.mr_n73024832)
print v(xbgr.mr_n73025152)
print v(xbgr.mr_n73025264)
print v(xbgr.mr_n73025584)
print v(xbgr.mr_n73025696)
print v(xbgr.mr_n73026016)
print v(xbgr.mr_n73026128)
print v(xbgr.mr_n73026448)
print v(xbgr.mr_n73026560)
print v(xbgr.mr_n73026880)
print v(xbgr.mr_n73026992)
print v(xbgr.mr_n73027312)
print v(xbgr.mr_n73027424)
print v(xbgr.mr_n73027744)
print v(xbgr.mr_n73027856)
print v(xbgr.mr_n73028176)
print v(xbgr.mr_n73028288)
print v(xbgr.mr_n73028608)
print v(xbgr.mr_n73028720)
print v(xbgr.mr_n73029040)
print v(xbgr.mr_n73029152)
print v(xbgr.mr_n73029472)
print v(xbgr.mr_n73029584)
print v(xbgr.mr_n73029904)
print v(xbgr.mr_n73030016)
print v(xbgr.mr_n73030336)
print v(xbgr.mr_n73030448)
print v(xbgr.mr_n73030768)
print v(xbgr.mr_n73030880)
print v(xbgr.mr_n73031200)
print v(xbgr.mr_n73031312)
print v(xbgr.mr_n73031632)
print v(xbgr.mr_n73031744)
print v(xbgr.mr_n73032064)
print v(xbgr.mr_n73032176)
print v(xbgr.mr_n73032496)
print v(xbgr.mr_n73032608)
print v(xbgr.mr_n73032928)
print v(xbgr.mr_n73033040)
print v(xbgr.mr_n73033360)
print v(xbgr.mr_n73033472)
print v(xbgr.mr_n73033792)
print v(xbgr.mr_n73033904)
print v(xbgr.mr_n73034224)
print v(xbgr.mr_n73034336)
print v(xbgr.mr_n73034656)
print v(xbgr.mr_n73034768)
print v(xbgr.mr_n73035088)
print v(xbgr.mr_n73035200)
print v(xbgr.mr_n73035520)
print v(xbgr.mr_n73035632)
print v(xbgr.mr_n73035952)
print v(xbgr.mr_n73036064)
print v(xbgr.mr_n73036384)
print v(xbgr.mr_n73036496)
print v(xbgr.mr_n73036816)
print v(xbgr.mr_n73036928)
print v(xbgr.mr_n73037248)
print v(xbgr.mr_n73037360)
print v(xbgr.mr_n73037680)
print v(xbgr.mr_n73037792)
print v(xbgr.mr_n73038112)
print v(xbgr.mr_n73038224)
print v(xbgr.mr_n73038544)
print v(xbgr.mr_n73038656)
print v(xbgr.mr_n73038976)
print v(xbgr.mr_n73039088)
print v(xbgr.mr_n73039408)
print v(xbgr.mr_n73039520)
print v(xbgr.mr_n73039840)
print v(xbgr.mr_n73039952)
print v(xbgr.mr_n73040272)
print v(xbgr.mr_n73040384)
print v(xbgr.mr_n73040704)
print v(xbgr.mr_n73040816)
print v(xbgr.mr_n73041136)
print v(xbgr.mr_n73041248)
print v(xbgr.mr_n73041568)
print v(xbgr.mr_n73041680)
print v(xbgr.mr_n73042000)
print v(xbgr.mr_n73042112)
print v(xbgr.mr_n73042432)
print v(xbgr.mr_n73042544)
print v(xbgr.mr_n73042864)
print v(xbgr.mr_n73042976)
print v(xbgr.mr_n73043296)
print v(xbgr.mr_n73043408)
print v(xbgr.mr_n73043728)
print v(xbgr.mr_n73043840)
print v(xbgr.mr_n73044160)
print v(xbgr.mr_n73044272)
print v(xbgr.mr_n73044592)
print v(xbgr.mr_n73044704)
print v(xbgr.mr_n73045024)
print v(xbgr.mr_n73045136)
print v(xbgr.mr_n73045456)
print v(xbgr.mr_n73045568)
print v(xbgr.mr_n73045888)
print v(xbgr.mr_n73046000)
print v(xbgr.mr_n73046320)
print v(xbgr.mr_n73046432)
print v(xbgr.mr_n73046752)
print v(xbgr.mr_n73046864)
print v(xbgr.mr_n73047184)
print v(xbgr.mr_n73047296)
print v(xbgr.mr_n73047616)
print v(xbgr.mr_n73047728)
print v(xbgr.mr_n73048048)
print v(xbgr.mr_n73048160)
print v(xbgr.mr_n73048480)
print v(xbgr.mr_n73048592)
print v(xbgr.mr_n73048912)
print v(xbgr.mr_n73049024)
print v(xbgr.mr_n73049344)
print v(xbgr.mr_n73049456)
print v(xbgr.mr_n73049776)
print v(xbgr.mr_n73049888)
print v(xbgr.mr_n73050208)
print v(xbgr.mr_n73050320)
print v(xbgr.mr_n73050640)
print v(xbgr.mr_n73050752)
print v(xbgr.mr_n73051072)
print v(xbgr.mr_n73051184)
print v(xbgr.mr_n73051504)
print v(xbgr.mr_n73051616)
print v(xbgr.mr_n73051936)
print v(xbgr.mr_n73052048)
print v(xbgr.mr_n73052368)
print v(xbgr.mr_n73052480)
print v(xbgr.mr_n73052800)
print v(xbgr.mr_n73052912)
print v(xbgr.mr_n73053232)
print v(xbgr.mr_n73053344)
print v(xbgr.mr_n73053664)
print v(xbgr.mr_n73053776)
print v(xbgr.mr_n73054096)
print v(xbgr.mr_n73054208)
print v(xbgr.mr_n73054528)
print v(xbgr.mr_n73054640)
print v(xbgr.mr_n73054960)
print v(xbgr.mr_n73055072)
print v(xbgr.mr_n73055392)
print v(xbgr.mr_n73055504)
print v(xbgr.mr_n73055824)
print v(xbgr.mr_n73055936)
print v(xbgr.mr_n73056256)
print v(xbgr.mr_n73056368)
print v(xbgr.mr_n73056688)
print v(xbgr.mr_n73056800)
print v(xbgr.mr_n73057120)
print v(xbgr.mr_n73057232)
print v(xbgr.mr_n73057552)
print v(xbgr.mr_n73057664)
print v(xbgr.mr_n73057984)
print v(xbgr.mr_n73058096)
print v(xbgr.mr_n73058416)
print v(xbgr.mr_n73058528)
print v(xbgr.mr_n73058848)
print v(xbgr.mr_n73058960)
print v(xbgr.mr_n73059280)
print v(xbgr.mr_n73059392)
print v(xbgr.mr_n73059712)
print v(xbgr.mr_n73059824)
print v(xbgr.mr_n73060144)
print v(xbgr.mr_n73060256)
print v(xbgr.mr_n73060576)
print v(xbgr.mr_n73060688)
print v(xbgr.mr_n73061008)
print v(xbgr.mr_n73061120)
print v(xbgr.mr_n73061440)
print v(xbgr.mr_n73061552)
print v(xbgr.mr_n73061872)
print v(xbgr.mr_n73061984)
print v(xbgr.mr_n73062304)
print v(xbgr.mr_n73062416)
print v(xbgr.mr_n73062736)
print v(xbgr.mr_n73062848)
print v(xbgr.mr_n73063168)
print v(xbgr.mr_n73063280)
print v(xbgr.mr_n73063600)
print v(xbgr.mr_n73063712)
print v(xbgr.mr_n73064032)
print v(xbgr.mr_n73064144)
print v(xbgr.mr_n73064464)
print v(xbgr.mr_n73064576)
print v(xbgr.mr_n73064896)
print v(xbgr.mr_n73065008)
print v(xbgr.mr_n73065328)
print v(xbgr.mr_n73065440)
print v(xbgr.mr_n73065760)
print v(xbgr.mr_n73065872)
print v(xbgr.mr_n73066192)
print v(xbgr.mr_n73066304)
print v(xbgr.mr_n73066624)
print v(xbgr.mr_n73066736)
print v(xbgr.mr_n73067056)
print v(xbgr.mr_n73067168)
print v(xbgr.mr_n73067488)
print v(xbgr.mr_n73067600)
print v(xbgr.mr_n73067920)
print v(xbgr.mr_n73068032)
print v(xbgr.mr_n73068352)
print v(xbgr.mr_n73068464)
print v(xbgr.mr_n73068784)
print v(xbgr.mr_n73068896)
print v(xbgr.mr_n73069216)
print v(xbgr.mr_n73069328)
print v(xbgr.mr_n73069648)
print v(xbgr.mr_n73069760)
print v(xbgr.mr_n73070080)
print v(xbgr.mr_n73070192)
print v(xbgr.mr_n73070512)
print v(xbgr.mr_n73070624)
print v(xbgr.mr_n73070944)
print v(xbgr.mr_n73071056)
print v(xbgr.mr_n73071376)
print v(xbgr.mr_n73071488)
print v(xbgr.mr_n73071808)
print v(xbgr.mr_n73071920)
print v(xbgr.mr_n73072240)
print v(xbgr.mr_n73072352)
print v(xbgr.mr_n73072672)
print v(xbgr.mr_n73072784)
print v(xbgr.mr_n73073104)
print v(xbgr.mr_n73073216)
print v(xbgr.mr_n73073536)
print v(xbgr.mr_n73073648)
print v(xbgr.mr_n73073968)
print v(xbgr.mr_n73074080)
print v(xbgr.mr_n73074400)
print v(xbgr.mr_n73074512)
print v(xbgr.mr_n73074832)
print v(xbgr.mr_n73074944)
print v(xbgr.mr_n73075264)
print v(xbgr.mr_n73075376)
print v(xbgr.mr_n73075696)
print v(xbgr.mr_n73075808)
print v(xbgr.mr_n73076128)
print v(xbgr.mr_n73076240)
print v(xbgr.mr_n73076560)
print v(xbgr.mr_n73076672)
print v(xbgr.mr_n73076992)
print v(xbgr.mr_n73077104)
print v(xbgr.mr_n73077424)
print v(xbgr.mr_n73077536)
print v(xbgr.mr_n73077856)
print v(xbgr.mr_n73077968)
print v(xbgr.mr_n73078288)
print v(xbgr.mr_n73078400)
print v(xbgr.mr_n73078720)
print v(xbgr.mr_n73078832)
print v(xbgr.mr_n73079152)
print v(xbgr.mr_n73079264)
print v(xbgr.mr_n73079584)
print v(xbgr.mr_n73079696)
print v(xbgr.mr_n73080016)
print v(xbgr.mr_n73080128)
print v(xbgr.mr_n73080448)
print v(xbgr.mr_n73080560)
print v(xbgr.mr_n73080880)
print v(xbgr.mr_n73080992)
print v(xbgr.mr_n73081312)
print v(xbgr.mr_n73081424)
print v(xbgr.mr_n73081744)
print v(xbgr.mr_n73081856)
print v(xbgr.mr_n73082176)
print v(xbgr.mr_n73082288)
print v(xbgr.mr_n73082608)
print v(xbgr.mr_n73082720)
print v(xbgr.mr_n73083040)
print v(xbgr.mr_n73083152)
print v(xbgr.mr_n73083472)
print v(xbgr.mr_n73083584)
print v(xbgr.mr_n73083904)
print v(xbgr.mr_n73084016)
print v(xbgr.mr_n73084336)
print v(xbgr.mr_n73084448)
print v(xbgr.mr_n73084768)
print v(xbgr.mr_n73084880)
print v(xbgr.mr_n73085200)
print v(xbgr.mr_n73085312)
print v(xbgr.mr_n73085632)
print v(xbgr.mr_n73085744)
print v(xbgr.mr_n73086064)
print v(xbgr.mr_n73086176)
print v(xbgr.mr_n73086496)
print v(xbgr.mr_n73086608)
print v(xbgr.mr_n73086928)
print v(xbgr.mr_n73087040)
print v(xbgr.mr_n73087360)
print v(xbgr.mr_n73087472)
print v(xbgr.mr_n73087792)
print v(xbgr.mr_n73087904)
print v(xbgr.mr_n73088224)
print v(xbgr.mr_n73088336)
print v(xbgr.mr_n73088656)
print v(xbgr.mr_n73088768)
print v(xbgr.mr_n73089088)
print v(xbgr.mr_n73089200)
print v(xbgr.mr_n73089520)
print v(xbgr.mr_n73089632)
print v(xbgr.mr_n73089952)
print v(xbgr.mr_n73090064)
print v(xbgr.mr_n73090384)
print v(xbgr.mr_n73090496)
print v(xbgr.mr_n73090816)
print v(xbgr.mr_n73090928)
print v(xbgr.mr_n73091248)
print v(xbgr.mr_n73091360)
print v(xbgr.mr_n73091680)
print v(xbgr.mr_n73091792)
print v(xbgr.mr_n73092112)
print v(xbgr.mr_n73092224)
print v(xbgr.mr_n73092544)
print v(xbgr.mr_n73092656)
print v(xbgr.mr_n73092976)
print v(xbgr.mr_n73093088)
print v(xbgr.mr_n73093408)
print v(xbgr.mr_n73093520)
print v(xbgr.mr_n73093840)
print v(xbgr.mr_n73093952)
print v(xbgr.mr_n73094272)
print v(xbgr.mr_n73094384)
print v(xbgr.mr_n73094704)
print v(xbgr.mr_n73094816)
print v(xbgr.mr_n73095136)
print v(xbgr.mr_n73095248)
print v(xbgr.mr_n73095568)
print v(xbgr.mr_n73095680)
print v(xbgr.mr_n73096000)
print v(xbgr.mr_n73096112)
print v(xbgr.mr_n73096432)
print v(xbgr.mr_n73096544)
print v(xbgr.mr_n73096864)
print v(xbgr.mr_n73096976)
print v(xbgr.mr_n73097296)
print v(xbgr.mr_n73097408)
print v(xbgr.mr_n73097728)
print v(xbgr.mr_n73097840)
print v(xbgr.mr_n73098160)
print v(xbgr.mr_n73098272)
print v(xbgr.mr_n73098592)
print v(xbgr.mr_n73098704)
print v(xbgr.mr_n73099024)
print v(xbgr.mr_n73099136)
print v(xbgr.mr_n73099456)
print v(xbgr.mr_n73099568)
print v(xbgr.mr_n73099888)
print v(xbgr.mr_n73100000)
print v(xbgr.mr_n73100320)
print v(xbgr.mr_n73100432)
print v(xbgr.mr_n73100752)
print v(xbgr.mr_n73100864)
print v(xbgr.mr_n73101184)
print v(xbgr.mr_n73101296)
print v(xbgr.mr_n73101616)
print v(xbgr.mr_n73101728)
print v(xbgr.mr_n73102048)
print v(xbgr.mr_n73102160)
print v(xbgr.mr_n73102480)
print v(xbgr.mr_n73102592)
print v(xbgr.mr_n73102912)
print v(xbgr.mr_n73103024)
print v(xbgr.mr_n73103344)
print v(xbgr.mr_n73103456)
print v(xbgr.mr_n73103776)
print v(xbgr.mr_n73103888)
print v(xbgr.mr_n73104208)
print v(xbgr.mr_n73104320)
print v(xbgr.mr_n73104640)
print v(xbgr.mr_n73104752)
print v(xbgr.mr_n73105072)
print v(xbgr.mr_n73105184)
print v(xbgr.mr_n73105616)
print v(xbgr.mr_n73105936)
print v(xbgr.mr_n73106048)
print v(xbgr.mr_n73106368)
print v(xbgr.mr_n73106480)
print v(xbgr.mr_n73106800)
print v(xbgr.mr_n73106912)
print v(xbgr.mr_n73107344)
print v(xbgr.mr_n73107664)
print v(xbgr.mr_n73107776)
print v(xbgr.mr_n73108096)
print v(xbgr.mr_n73108208)
print v(xbgr.mr_n73108528)
print v(xbgr.mr_n73108640)
print v(xbgr.mr_n73108960)
print v(xbgr.mr_n73109072)
print v(xbgr.mr_n73109392)
print v(xbgr.mr_n73109504)
print v(xbgr.mr_n73109824)
print v(xbgr.mr_n73109936)
print v(xbgr.mr_n73110256)
print v(xbgr.mr_n73110368)
print v(xbgr.mr_n73110688)
print v(xbgr.mr_n73110800)
print v(xbgr.mr_n73111120)
print v(xbgr.mr_n73111232)
print v(xbgr.mr_n73111552)
print v(xbgr.mr_n73111664)
print v(xbgr.mr_n73111984)
print v(xbgr.mr_n73112096)
print v(xbgr.mr_n73112416)
print v(xbgr.mr_n73112528)
print v(xbgr.mr_n73112848)
print v(xbgr.mr_n73112960)
print v(xbgr.mr_n73113280)
print v(xbgr.mr_n73113392)
print v(xbgr.mr_n73113712)
print v(xbgr.mr_n73113824)
print v(xbgr.mr_n73114256)
print v(xbgr.mr_n73114576)
print v(xbgr.mr_n73114688)
print v(xbgr.mr_n73115008)
print v(xbgr.mr_n73115120)
print v(xbgr.mr_n73115440)
print v(xbgr.mr_n73115552)
print v(xbgr.mr_n73115872)
print v(xbgr.mr_n73115984)
print v(xbgr.mr_n73116304)
print v(xbgr.mr_n73116416)
print v(xbgr.mr_n73116736)
print v(xbgr.mr_n73116848)
print v(xbgr.mr_n73117168)
print v(xbgr.mr_n73117280)
print v(xbgr.mr_n73117712)
print v(xbgr.mr_n73118032)
print v(xbgr.mr_n73118144)
print v(xbgr.mr_n73118464)
print v(xbgr.mr_n73118576)
print v(xbgr.mr_n73118896)
print v(xbgr.mr_n73119008)
print v(xbgr.mr_n73119328)
print v(xbgr.mr_n73119440)
print v(xbgr.mr_n73119760)
print v(xbgr.mr_n73119872)
print v(xbgr.mr_n73120192)
print v(xbgr.mr_n73120304)
print v(xbgr.mr_n73120624)
print v(xbgr.mr_n73120736)
print v(xbgr.mr_n73121056)
print v(xbgr.mr_n73121168)
print v(xbgr.mr_n73121488)
print v(xbgr.mr_n73121600)
print v(xbgr.mr_n73121920)
print v(xbgr.mr_n73122032)
print v(xbgr.mr_n73122352)
print v(xbgr.mr_n73122464)
print v(xbgr.mr_n73122784)
print v(xbgr.mr_n73122896)
print v(xbgr.mr_n73123216)
print v(xbgr.mr_n73123328)
print v(xbgr.mr_n73123760)
print v(xbgr.mr_n73124080)
print v(xbgr.mr_n73124192)
print v(xbgr.mr_n73124512)
print v(xbgr.mr_n73124624)
print v(xbgr.mr_n73124944)
print v(xbgr.mr_n73125056)
print v(xbgr.mr_n73125488)
print v(xbgr.mr_n73125808)
print v(xbgr.mr_n73125920)
print v(xbgr.mr_n73126240)
print v(xbgr.mr_n73126352)
print v(xbgr.mr_n73126672)
print v(xbgr.mr_n73126784)
print v(xbgr.mr_n73127104)
print v(xbgr.mr_n73127216)
print v(xbgr.mr_n73127536)
print v(xbgr.mr_n73127648)
print v(xbgr.mr_n73128080)
print v(xbgr.mr_n73128400)
print v(xbgr.mr_n73128512)
print v(xbgr.mr_n73128832)
print v(xbgr.mr_n73128944)
print v(xbgr.mr_n73129264)
print v(xbgr.mr_n73129376)
print v(xbgr.mr_n73129696)
print v(xbgr.mr_n73129808)
print v(xbgr.mr_n73130128)
print v(xbgr.mr_n73130240)
print v(xbgr.mr_n73130560)
print v(xbgr.mr_n73130672)
print v(xbgr.mr_n73130992)
print v(xbgr.mr_n73131104)
print v(xbgr.mr_n73131424)
print v(xbgr.mr_n73131536)
print v(xbgr.mr_n73131856)
print v(xbgr.mr_n73131968)
print v(xbgr.mr_n73132288)
print v(xbgr.mr_n73132400)
print v(xbgr.mr_n73132720)
print v(xbgr.mr_n73132832)
print v(xbgr.mr_n73133152)
print v(xbgr.mr_n73133264)
print v(xbgr.mr_n73133584)
print v(xbgr.mr_n73133696)
print v(xbgr.mr_n73134128)
print v(xbgr.mr_n73134448)
print v(xbgr.mr_n73134560)
print v(xbgr.mr_n73134880)
print v(xbgr.mr_n73134992)
print v(xbgr.mr_n73135312)
print v(xbgr.mr_n73135424)
print v(xbgr.mr_n73135856)
print v(xbgr.mr_n73136176)
print v(xbgr.mr_n73136288)
print v(xbgr.mr_n73136720)
print v(xbgr.mr_n73137040)
print v(xbgr.mr_n73137152)
print v(xbgr.mr_n73137472)
print v(xbgr.mr_n73137584)
print v(xbgr.mr_n73137904)
print v(xbgr.mr_n73138016)
print v(xbgr.mr_n73138448)
print v(xbgr.mr_n73138768)
print v(xbgr.mr_n73138880)
print v(xbgr.mr_n73139200)
print v(xbgr.mr_n73139312)
print v(xbgr.mr_n73139632)
print v(xbgr.mr_n73139744)
print v(xbgr.mr_n73140064)
print v(xbgr.mr_n73140176)
print v(xbgr.mr_n73140496)
print v(xbgr.mr_n73140608)
print v(xbgr.mr_n73140928)
print v(xbgr.mr_n73141040)
print v(xbgr.mr_n73141360)
print v(xbgr.mr_n73141472)
print v(xbgr.mr_n73141792)
print v(xbgr.mr_n73141904)
print v(xbgr.mr_n73142224)
print v(xbgr.mr_n73142336)
print v(xbgr.mr_n73142768)
print v(xbgr.mr_n73143088)
print v(xbgr.mr_n73143200)
print v(xbgr.mr_n73143520)
print v(xbgr.mr_n73143632)
print v(xbgr.mr_n73143952)
print v(xbgr.mr_n73144064)
print v(xbgr.mr_n73144384)
print v(xbgr.mr_n73144496)
print v(xbgr.mr_n73144816)
print v(xbgr.mr_n73144928)
print v(xbgr.mr_n73145248)
print v(xbgr.mr_n73145360)
print v(xbgr.mr_n73145680)
print v(xbgr.mr_n73145792)
print v(xbgr.mr_n73146112)
print v(xbgr.mr_n73146224)
print v(xbgr.mr_n73146544)
print v(xbgr.mr_n73146656)
print v(xbgr.mr_n73146976)
print v(xbgr.mr_n73147088)
print v(xbgr.mr_n73147408)
print v(xbgr.mr_n73147520)
print v(xbgr.mr_n73147840)
print v(xbgr.mr_n73147952)
print v(xbgr.mr_n73148272)
print v(xbgr.mr_n73148384)
print v(xbgr.mr_n73148704)
print v(xbgr.mr_n73148816)
print v(xbgr.mr_n73149136)
print v(xbgr.mr_n73149248)
print v(xbgr.mr_n73149568)
print v(xbgr.mr_n73149680)
print v(xbgr.mr_n73150000)
print v(xbgr.mr_n73150112)
print v(xbgr.mr_n73150432)
print v(xbgr.mr_n73150544)
print v(xbgr.mr_n73150864)
print v(xbgr.mr_n73150976)
print v(xbgr.mr_n73151296)
print v(xbgr.mr_n73151408)
print v(xbgr.mr_n73151728)
print v(xbgr.mr_n73151840)
print v(xbgr.mr_n73152160)
print v(xbgr.mr_n73152272)
print v(xbgr.mr_n73152592)
print v(xbgr.mr_n73152704)
print v(xbgr.mr_n73153024)
print v(xbgr.mr_n73153136)
print v(xbgr.mr_n73153456)
print v(xbgr.mr_n73153568)
print v(xbgr.mr_n73153888)
print v(xbgr.mr_n73154000)
print v(xbgr.mr_n73154320)
print v(xbgr.mr_n73154432)
print v(xbgr.mr_n73154752)
print v(xbgr.mr_n73154864)
print v(xbgr.mr_n73155184)
print v(xbgr.mr_n73155296)
print v(xbgr.mr_n73155616)
print v(xbgr.mr_n73155728)
print v(xbgr.mr_n73156048)
print v(xbgr.mr_n73156160)
print v(xbgr.mr_n73156480)
print v(xbgr.mr_n73156592)
print v(xbgr.mr_n73156912)
print v(xbgr.mr_n73157024)
print v(xbgr.mr_n73157344)
print v(xbgr.mr_n73157456)
print v(xbgr.mr_n73157776)
print v(xbgr.mr_n73157888)
print v(xbgr.mr_n73158208)
print v(xbgr.mr_n73158320)
print v(xbgr.mr_n73158640)
print v(xbgr.mr_n73158752)
print v(xbgr.mr_n73159072)
print v(xbgr.mr_n73159184)
print v(xbgr.mr_n73159504)
print v(xbgr.mr_n73159616)
print v(xbgr.mr_n73159936)
print v(xbgr.mr_n73160048)
print v(xbgr.mr_n73160368)
print v(xbgr.mr_n73160480)
print v(xbgr.mr_n73160800)
print v(xbgr.mr_n73160912)
print v(xbgr.mr_n73161232)
print v(xbgr.mr_n73161344)
print v(xbgr.mr_n73161664)
print v(xbgr.mr_n73161776)
print v(xbgr.mr_n73162096)
print v(xbgr.mr_n73162208)
print v(xbgr.mr_n73162528)
print v(xbgr.mr_n73162640)
print v(xbgr.mr_n73162960)
print v(xbgr.mr_n73163072)
print v(xbgr.mr_n73163392)
print v(xbgr.mr_n73163504)
print v(xbgr.mr_n73163824)
print v(xbgr.mr_n73163936)
print v(xbgr.mr_n73164256)
print v(xbgr.mr_n73164368)
print v(xbgr.mr_n73164688)
print v(xbgr.mr_n73164800)
print v(xbgr.mr_n73165120)
print v(xbgr.mr_n73165232)
print v(xbgr.mr_n73165552)
print v(xbgr.mr_n73165664)
print v(xbgr.mr_n73165984)
print v(xbgr.mr_n73166096)
print v(xbgr.mr_n73166416)
print v(xbgr.mr_n73166528)
print v(xbgr.mr_n73166848)
print v(xbgr.mr_n73166960)
print v(xbgr.mr_n73167280)
print v(xbgr.mr_n73167392)
print v(xbgr.mr_n73167712)
print v(xbgr.mr_n73167824)
print v(xbgr.mr_n73168144)
print v(xbgr.mr_n73168256)
print v(xbgr.mr_n73168576)
print v(xbgr.mr_n73168688)
print v(xbgr.mr_n73169008)
print v(xbgr.mr_n73169120)
print v(xbgr.mr_n73169440)
print v(xbgr.mr_n73169552)
print v(xbgr.mr_n73169872)
print v(xbgr.mr_n73169984)
print v(xbgr.mr_n73170304)
print v(xbgr.mr_n73170416)
print v(xbgr.mr_n73170736)
print v(xbgr.mr_n73170848)
print v(xbgr.mr_n73171168)
print v(xbgr.mr_n73171280)
print v(xbgr.mr_n73171600)
print v(xbgr.mr_n73171712)
print v(xbgr.mr_n73172032)
print v(xbgr.mr_n73172144)
print v(xbgr.mr_n73172464)
print v(xbgr.mr_n73172576)
print v(xbgr.mr_n73172896)
print v(xbgr.mr_n73173008)
print v(xbgr.mr_n73173328)
print v(xbgr.mr_n73173440)
print v(xbgr.mr_n73173760)
print v(xbgr.mr_n73173872)
print v(xbgr.mr_n73174192)
print v(xbgr.mr_n73174304)
print v(xbgr.mr_n73174624)
print v(xbgr.mr_n73174736)
print v(xbgr.mr_n73175056)
print v(xbgr.mr_n73175168)
print v(xbgr.mr_n73175488)
print v(xbgr.mr_n73175600)
print v(xbgr.mr_n73175920)
print v(xbgr.mr_n73176032)
print v(xbgr.mr_n73176352)
print v(xbgr.mr_n73176464)
print v(xbgr.mr_n73176784)
print v(xbgr.mr_n73176896)
print v(xbgr.mr_n73177216)
print v(xbgr.mr_n73177328)
print v(xbgr.mr_n73177648)
print v(xbgr.mr_n73177760)
print v(xbgr.mr_n73178080)
print v(xbgr.mr_n73178192)
print v(xbgr.mr_n73178512)
print v(xbgr.mr_n73178624)
print v(xbgr.mr_n73178944)
print v(xbgr.mr_n73179056)
print v(xbgr.mr_n73179376)
print v(xbgr.mr_n73179488)
print v(xbgr.mr_n73179808)
print v(xbgr.mr_n73179920)
print v(xbgr.mr_n73180240)
print v(xbgr.mr_n73180352)
print v(xbgr.mr_n73180672)
print v(xbgr.mr_n73180784)
print v(xbgr.mr_n73181104)
print v(xbgr.mr_n73181216)
print v(xbgr.mr_n73181536)
print v(xbgr.mr_n73181648)
print v(xbgr.mr_n73181968)
print v(xbgr.mr_n73182080)
print v(xbgr.mr_n73182400)
print v(xbgr.mr_n73182512)
print v(xbgr.mr_n73182832)
print v(xbgr.mr_n73182944)
print v(xbgr.mr_n73183264)
print v(xbgr.mr_n73183376)
print v(xbgr.mr_n73183696)
print v(xbgr.mr_n73183808)
print v(xbgr.mr_n73184128)
print v(xbgr.mr_n73184240)
print v(xbgr.mr_n73184560)
print v(xbgr.mr_n73184672)
print v(xbgr.mr_n73184992)
print v(xbgr.mr_n73185104)
print v(xbgr.mr_n73185424)
print v(xbgr.mr_n73185536)
print v(xbgr.mr_n73185856)
print v(xbgr.mr_n73185968)
print v(xbgr.mr_n73186288)
print v(xbgr.mr_n73186400)
print v(xbgr.mr_n73186720)
print v(xbgr.mr_n73186832)
print v(xbgr.mr_n73187152)
print v(xbgr.mr_n73187264)
print v(xbgr.mr_n73187584)
print v(xbgr.mr_n73187696)
print v(xbgr.mr_n73188016)
print v(xbgr.mr_n73188128)
print v(xbgr.mr_n73188448)
print v(xbgr.mr_n73188560)
print v(xbgr.mr_n73188880)
print v(xbgr.mr_n73188992)
print v(xbgr.mr_n73189312)
print v(xbgr.mr_n73189424)
print v(xbgr.mr_n73189744)
print v(xbgr.mr_n73189856)
print v(xbgr.mr_n73190176)
print v(xbgr.mr_n73190288)
print v(xbgr.mr_n73190608)
print v(xbgr.mr_n73190720)
print v(xbgr.mr_n73191040)
print v(xbgr.mr_n73191152)
print v(xbgr.mr_n73191472)
print v(xbgr.mr_n73191584)
print v(xbgr.mr_n73191904)
print v(xbgr.mr_n73192016)
print v(xbgr.mr_n73192336)
print v(xbgr.mr_n73192448)
print v(xbgr.mr_n73192768)
print v(xbgr.mr_n73192880)
print v(xbgr.mr_n73193200)
print v(xbgr.mr_n73193312)
print v(xbgr.mr_n73193632)
print v(xbgr.mr_n73193744)
print v(xbgr.mr_n73194064)
print v(xbgr.mr_n73194176)
print v(xbgr.mr_n73194496)
print v(xbgr.mr_n73194608)
print v(xbgr.mr_n73194928)
print v(xbgr.mr_n73195040)
print v(xbgr.mr_n73195360)
print v(xbgr.mr_n73195472)
print v(xbgr.mr_n73195792)
print v(xbgr.mr_n73195904)
print v(xbgr.mr_n73196224)
print v(xbgr.mr_n73196336)
print v(xbgr.mr_n73196656)
print v(xbgr.mr_n73196768)
print v(xbgr.mr_n73197088)
print v(xbgr.mr_n73197200)
print v(xbgr.mr_n73197520)
print v(xbgr.mr_n73197632)
print v(xbgr.mr_n73197952)
print v(xbgr.mr_n73198064)
print v(xbgr.mr_n73198384)
print v(xbgr.mr_n73198496)
print v(xbgr.mr_n73198816)
print v(xbgr.mr_n73198928)
print v(xbgr.mr_n73199248)
print v(xbgr.mr_n73199360)
print v(xbgr.mr_n73199680)
print v(xbgr.mr_n73199792)
print v(xbgr.mr_n73200112)
print v(xbgr.mr_n73200224)
print v(xbgr.mr_n73200544)
print v(xbgr.mr_n73200656)
print v(xbgr.mr_n73200976)
print v(xbgr.mr_n73201088)
print v(xbgr.mr_n73201408)
print v(xbgr.mr_n73201520)
print v(xbgr.mr_n73201840)
print v(xbgr.mr_n73201952)
print v(xbgr.mr_n73202272)
print v(xbgr.mr_n73202384)
print v(xbgr.mr_n73202704)
print v(xbgr.mr_n73202816)
print v(xbgr.mr_n73203136)
print v(xbgr.mr_n73203248)
print v(xbgr.mr_n73203568)
print v(xbgr.mr_n73203680)
print v(xbgr.mr_n73204000)
print v(xbgr.mr_n73204112)
print v(xbgr.mr_n73204432)
print v(xbgr.mr_n73204544)
print v(xbgr.mr_n73204864)
print v(xbgr.mr_n73204976)
print v(xbgr.mr_n73205296)
print v(xbgr.mr_n73205408)
print v(xbgr.mr_n73205728)
print v(xbgr.mr_n73205840)
print v(xbgr.mr_n73206160)
print v(xbgr.mr_n73206272)
print v(xbgr.mr_n73206592)
print v(xbgr.mr_n73206704)
print v(xbgr.mr_n73207024)
print v(xbgr.mr_n73207136)
print v(xbgr.mr_n73207456)
print v(xbgr.mr_n73207568)
print v(xbgr.mr_n73207888)
print v(xbgr.mr_n73208000)
print v(xbgr.mr_n73208320)
print v(xbgr.mr_n73208432)
print v(xbgr.mr_n73208752)
print v(xbgr.mr_n73208864)
print v(xbgr.mr_n73209184)
print v(xbgr.mr_n73209296)
print v(xbgr.mr_n73209616)
print v(xbgr.mr_n73209728)
print v(xbgr.mr_n73210048)
print v(xbgr.mr_n73210160)
print v(xbgr.mr_n73210480)
print v(xbgr.mr_n73210592)
print v(xbgr.mr_n73210912)
print v(xbgr.mr_n73211024)
print v(xbgr.mr_n73211344)
print v(xbgr.mr_n73211456)
print v(xbgr.mr_n73211776)
print v(xbgr.mr_n73211888)
print v(xbgr.mr_n73212208)
print v(xbgr.mr_n73212320)
print v(xbgr.mr_n73212640)
print v(xbgr.mr_n73212752)
print v(xbgr.mr_n73213072)
print v(xbgr.mr_n73213184)
print v(xbgr.mr_n73213504)
print v(xbgr.mr_n73213616)
print v(xbgr.mr_n73213936)
print v(xbgr.mr_n73214048)
print v(xbgr.mr_n73214368)
print v(xbgr.mr_n73214480)
print v(xbgr.mr_n73214800)
print v(xbgr.mr_n73214912)
print v(xbgr.mr_n73215232)
print v(xbgr.mr_n73215344)
print v(xbgr.mr_n73215664)
print v(xbgr.mr_n73215776)
print v(xbgr.mr_n73216096)
print v(xbgr.mr_n73216208)
print v(xbgr.mr_n73216528)
print v(xbgr.mr_n73216640)
print v(xbgr.mr_n73216960)
print v(xbgr.mr_n73217072)
print v(xbgr.mr_n73217392)
print v(xbgr.mr_n73217504)
print v(xbgr.mr_n73217824)
print v(xbgr.mr_n73217936)
print v(xbgr.mr_n73218256)
print v(xbgr.mr_n73218368)
print v(xbgr.mr_n73218688)
print v(xbgr.mr_n73218800)
print v(xbgr.mr_n73219120)
print v(xbgr.mr_n73219232)
print v(xbgr.mr_n73219552)
print v(xbgr.mr_n73219664)
print v(xbgr.mr_n73219984)
print v(xbgr.mr_n73220096)
print v(xbgr.mr_n73220416)
print v(xbgr.mr_n73220528)
print v(xbgr.mr_n73220848)
print v(xbgr.mr_n73220960)
print v(xbgr.mr_n73221280)
print v(xbgr.mr_n73221392)
print v(xbgr.mr_n73221712)
print v(xbgr.mr_n73221824)
print v(xbgr.mr_n73222144)
print v(xbgr.mr_n73222256)
print v(xbgr.mr_n73222576)
print v(xbgr.mr_n73222688)
print v(xbgr.mr_n73223008)
print v(xbgr.mr_n73223120)
print v(xbgr.mr_n73223440)
print v(xbgr.mr_n73223552)
print v(xbgr.mr_n73223872)
print v(xbgr.mr_n73223984)
print v(xbgr.mr_n73224304)
print v(xbgr.mr_n73224416)
print v(xbgr.mr_n73224736)
print v(xbgr.mr_n73224848)
print v(xbgr.mr_n73225168)
print v(xbgr.mr_n73225280)
print v(xbgr.mr_n73225600)
print v(xbgr.mr_n73225712)
print v(xbgr.mr_n73226032)
print v(xbgr.mr_n73226144)
print v(xbgr.mr_n73226464)
print v(xbgr.mr_n73226576)
print v(xbgr.mr_n73226896)
print v(xbgr.mr_n73227008)
print v(xbgr.mr_n73227328)
print v(xbgr.mr_n73227440)
print v(xbgr.mr_n73227760)
print v(xbgr.mr_n73227872)
print v(xbgr.mr_n73228192)
print v(xbgr.mr_n73228304)
print v(xbgr.mr_n73228624)
print v(xbgr.mr_n73228736)
print v(xbgr.mr_n73229056)
print v(xbgr.mr_n73229168)
print v(xbgr.mr_n73229488)
print v(xbgr.mr_n73229600)
print v(xbgr.mr_n73229920)
print v(xbgr.mr_n73230032)
print v(xbgr.mr_n73230352)
print v(xbgr.mr_n73230464)
print v(xbgr.mr_n73230784)
print v(xbgr.mr_n73230896)
print v(xbgr.mr_n73231216)
print v(xbgr.mr_n73231328)
print v(xbgr.mr_n73231648)
print v(xbgr.mr_n73231760)
print v(xbgr.mr_n73232080)
print v(xbgr.mr_n73232192)
print v(xbgr.mr_n73232512)
print v(xbgr.mr_n73232624)
print v(xbgr.mr_n73232944)
print v(xbgr.mr_n73233056)
print v(xbgr.mr_n73233376)
print v(xbgr.mr_n73233488)
print v(xbgr.mr_n73233808)
print v(xbgr.mr_n73233920)
print v(xbgr.mr_n73234240)
print v(xbgr.mr_n73234352)
print v(xbgr.mr_n73234672)
print v(xbgr.mr_n73234784)
print v(xbgr.mr_n73235104)
print v(xbgr.mr_n73235216)
print v(xbgr.mr_n73235536)
print v(xbgr.mr_n73235648)
print v(xbgr.mr_n73235968)
print v(xbgr.mr_n73236080)
print v(xbgr.mr_n73236400)
print v(xbgr.mr_n73236512)
print v(xbgr.mr_n73236832)
print v(xbgr.mr_n73236944)
print v(xbgr.mr_n73237264)
print v(xbgr.mr_n73237376)
print v(xbgr.mr_n73237696)
print v(xbgr.mr_n73237808)
print v(xbgr.mr_n73238128)
print v(xbgr.mr_n73238240)
print v(xbgr.mr_n73238560)
print v(xbgr.mr_n73238672)
print v(xbgr.mr_n73238992)
print v(xbgr.mr_n73239104)
print v(xbgr.mr_n73239424)
print v(xbgr.mr_n73239536)
print v(xbgr.mr_n73239856)
print v(xbgr.mr_n73239968)
print v(xbgr.mr_n73240288)
print v(xbgr.mr_n73240400)
print v(xbgr.mr_n73240720)
print v(xbgr.mr_n73240832)
print v(xbgr.mr_n73241152)
print v(xbgr.mr_n73241264)
print v(xbgr.mr_n73241584)
print v(xbgr.mr_n73241696)
print v(xbgr.mr_n73242016)
print v(xbgr.mr_n73242128)
print v(xbgr.mr_n73242448)
print v(xbgr.mr_n73242560)
print v(xbgr.mr_n73242880)
print v(xbgr.mr_n73242992)
print v(xbgr.mr_n73243312)
print v(xbgr.mr_n73243424)
print v(xbgr.mr_n73243744)
print v(xbgr.mr_n73243856)
print v(xbgr.mr_n73244176)
print v(xbgr.mr_n73244288)
print v(xbgr.mr_n73244608)
print v(xbgr.mr_n73244720)
print v(xbgr.mr_n73245040)
print v(xbgr.mr_n73245152)
print v(xbgr.mr_n73245472)
print v(xbgr.mr_n73245584)
print v(xbgr.mr_n73245904)
print v(xbgr.mr_n73246016)
print v(xbgr.mr_n73246336)
print v(xbgr.mr_n73246448)
print v(xbgr.mr_n73246768)
print v(xbgr.mr_n73246880)
print v(xbgr.mr_n73247312)
print v(xbgr.mr_n73247632)
print v(xbgr.mr_n73247744)
print v(xbgr.mr_n73248064)
print v(xbgr.mr_n73248176)
print v(xbgr.mr_n73248496)
print v(xbgr.mr_n73248608)
print v(xbgr.mr_n73248928)
print v(xbgr.mr_n73249040)
print v(xbgr.mr_n73249360)
print v(xbgr.mr_n73249472)
print v(xbgr.mr_n73249904)
print v(xbgr.mr_n73250224)
print v(xbgr.mr_n73250336)
print v(xbgr.mr_n73250656)
print v(xbgr.mr_n73250768)
print v(xbgr.mr_n73251088)
print v(xbgr.mr_n73251200)
print v(xbgr.mr_n73251520)
print v(xbgr.mr_n73251632)
print v(xbgr.mr_n73251952)
print v(xbgr.mr_n73252064)
print v(xbgr.mr_n73252496)
print v(xbgr.mr_n73252816)
print v(xbgr.mr_n73252928)
print v(xbgr.mr_n73253248)
print v(xbgr.mr_n73253360)
print v(xbgr.mr_n73253680)
print v(xbgr.mr_n73253792)
print v(xbgr.mr_n73254112)
print v(xbgr.mr_n73254224)
print v(xbgr.mr_n73254544)
print v(xbgr.mr_n73254656)
print v(xbgr.mr_n73254976)
print v(xbgr.mr_n73255088)
print v(xbgr.mr_n73255408)
print v(xbgr.mr_n73255520)
print v(xbgr.mr_n73255952)
print v(xbgr.mr_n73256272)
print v(xbgr.mr_n73256384)
print v(xbgr.mr_n73256816)
print v(xbgr.mr_n73257136)
print v(xbgr.mr_n73257248)
print v(xbgr.mr_n73257568)
print v(xbgr.mr_n73257680)
print v(xbgr.mr_n73258000)
print v(xbgr.mr_n73258112)
print v(xbgr.mr_n73258432)
print v(xbgr.mr_n73258544)
print v(xbgr.mr_n73258864)
print v(xbgr.mr_n73258976)
print v(xbgr.mr_n73259408)
print v(xbgr.mr_n73259728)
print v(xbgr.mr_n73259840)
print v(xbgr.mr_n73260272)
print v(xbgr.mr_n73260592)
print v(xbgr.mr_n73260704)
print v(xbgr.mr_n73261024)
print v(xbgr.mr_n73261136)
print v(xbgr.mr_n73261456)
print v(xbgr.mr_n73261568)
print v(xbgr.mr_n73261888)
print v(xbgr.mr_n73262000)
print v(xbgr.mr_n73262320)
print v(xbgr.mr_n73262432)
print v(xbgr.mr_n73262752)
print v(xbgr.mr_n73262864)
print v(xbgr.mr_n73263184)
print v(xbgr.mr_n73263296)
print v(xbgr.mr_n73263616)
print v(xbgr.mr_n73263728)
print v(xbgr.mr_n73264048)
print v(xbgr.mr_n73264160)
print v(xbgr.mr_n73264480)
print v(xbgr.mr_n73264592)
print v(xbgr.mr_n73264912)
print v(xbgr.mr_n73265024)
print v(xbgr.mr_n73265344)
print v(xbgr.mr_n73265456)
print v(xbgr.mr_n73265776)
print v(xbgr.mr_n73265888)
print v(xbgr.mr_n73266208)
print v(xbgr.mr_n73266320)
print v(xbgr.mr_n73266640)
print v(xbgr.mr_n73266752)
print v(xbgr.mr_n73267072)
print v(xbgr.mr_n73267184)
print v(xbgr.mr_n73267504)
print v(xbgr.mr_n73267616)
print v(xbgr.mr_n73267936)
print v(xbgr.mr_n73268048)
print v(xbgr.mr_n73268368)
print v(xbgr.mr_n73268480)
print v(xbgr.mr_n73268800)
print v(xbgr.mr_n73268912)
print v(xbgr.mr_n73269232)
print v(xbgr.mr_n73269344)
print v(xbgr.mr_n73269664)
print v(xbgr.mr_n73269776)
print v(xbgr.mr_n73270096)
print v(xbgr.mr_n73270208)
print v(xbgr.mr_n73270528)
print v(xbgr.mr_n73270640)
print v(xbgr.mr_n73270960)
print v(xbgr.mr_n73271072)
print v(xbgr.mr_n73271392)
print v(xbgr.mr_n73271504)
print v(xbgr.mr_n73271824)
print v(xbgr.mr_n73271936)
print v(xbgr.mr_n73272256)
print v(xbgr.mr_n73272368)
print v(xbgr.mr_n73272688)
print v(xbgr.mr_n73272800)
print v(xbgr.mr_n73273120)
print v(xbgr.mr_n73273232)
print v(xbgr.mr_n73273552)
print v(xbgr.mr_n73273664)
print v(xbgr.mr_n73273984)
print v(xbgr.mr_n73274096)
print v(xbgr.mr_n73274416)
print v(xbgr.mr_n73274528)
print v(xbgr.mr_n73274848)
print v(xbgr.mr_n73274960)
print v(xbgr.mr_n73275280)
print v(xbgr.mr_n73275392)
print v(xbgr.mr_n73275712)
print v(xbgr.mr_n73275824)
print v(xbgr.mr_n73276144)
print v(xbgr.mr_n73276256)
print v(xbgr.mr_n73276576)
print v(xbgr.mr_n73276688)
print v(xbgr.mr_n73277008)
print v(xbgr.mr_n73277120)
print v(xbgr.mr_n73277440)
print v(xbgr.mr_n73277552)
print v(xbgr.mr_n73277872)
print v(xbgr.mr_n73277984)
print v(xbgr.mr_n73278304)
print v(xbgr.mr_n73278416)
print v(xbgr.mr_n73278736)
print v(xbgr.mr_n73278848)
print v(xbgr.mr_n73279168)
print v(xbgr.mr_n73279280)
print v(xbgr.mr_n73279600)
print v(xbgr.mr_n73279712)
print v(xbgr.mr_n73280032)
print v(xbgr.mr_n73280144)
print v(xbgr.mr_n73280464)
print v(xbgr.mr_n73280576)
print v(xbgr.mr_n73280896)
print v(xbgr.mr_n73281008)
print v(xbgr.mr_n73281328)
print v(xbgr.mr_n73281440)
print v(xbgr.mr_n73281760)
print v(xbgr.mr_n73281872)
print v(xbgr.mr_n73282192)
print v(xbgr.mr_n73282304)
print v(xbgr.mr_n73282624)
print v(xbgr.mr_n73282736)
print v(xbgr.mr_n73283056)
print v(xbgr.mr_n73283168)
print v(xbgr.mr_n73283488)
print v(xbgr.mr_n73283600)
print v(xbgr.mr_n73283920)
print v(xbgr.mr_n73284032)
print v(xbgr.mr_n73284352)
print v(xbgr.mr_n73284464)
print v(xbgr.mr_n73284784)
print v(xbgr.mr_n73284896)
print v(xbgr.mr_n73285216)
print v(xbgr.mr_n73285328)
print v(xbgr.mr_n73285648)
print v(xbgr.mr_n73285760)
print v(xbgr.mr_n73286080)
print v(xbgr.mr_n73286192)
print v(xbgr.mr_n73286512)
print v(xbgr.mr_n73286624)
print v(xbgr.mr_n73286944)
print v(xbgr.mr_n73287056)
print v(xbgr.mr_n73287376)
print v(xbgr.mr_n73287488)
print v(xbgr.mr_n73287808)
print v(xbgr.mr_n73287920)
print v(xbgr.mr_n73288240)
print v(xbgr.mr_n73288352)
print v(xbgr.mr_n73288672)
print v(xbgr.mr_n73288784)
print v(xbgr.mr_n73289104)
print v(xbgr.mr_n73289216)
print v(xbgr.mr_n73289536)
print v(xbgr.mr_n73289648)
print v(xbgr.mr_n73289968)
print v(xbgr.mr_n73290080)
print v(xbgr.mr_n73290400)
print v(xbgr.mr_n73290512)
print v(xbgr.mr_n73290832)
print v(xbgr.mr_n73290944)
print v(xbgr.mr_n73291264)
print v(xbgr.mr_n73291376)
print v(xbgr.mr_n73291696)
print v(xbgr.mr_n73291808)
print v(xbgr.mr_n73292128)
print v(xbgr.mr_n73292240)
print v(xbgr.mr_n73292560)
print v(xbgr.mr_n73292672)
print v(xbgr.mr_n73292992)
print v(xbgr.mr_n73293104)
print v(xbgr.mr_n73293424)
print v(xbgr.mr_n73293536)
print v(xbgr.mr_n73293968)
print v(xbgr.mr_n73294288)
print v(xbgr.mr_n73294400)
print v(xbgr.mr_n73294720)
print v(xbgr.mr_n73294832)
print v(xbgr.mr_n73295152)
print v(xbgr.mr_n73295264)
print v(xbgr.mr_n73295696)
print v(xbgr.mr_n73296016)
print v(xbgr.mr_n73296128)
print v(xbgr.mr_n73296560)
print v(xbgr.mr_n73296880)
print v(xbgr.mr_n73296992)
print v(xbgr.mr_n73297312)
print v(xbgr.mr_n73297424)
print v(xbgr.mr_n73297744)
print v(xbgr.mr_n73297856)
print v(xbgr.mr_n73298176)
print v(xbgr.mr_n73298288)
print v(xbgr.mr_n73298608)
print v(xbgr.mr_n73298720)
print v(xbgr.mr_n73299040)
print v(xbgr.mr_n73299152)
print v(xbgr.mr_n73299472)
print v(xbgr.mr_n73299584)
print v(xbgr.mr_n73299904)
print v(xbgr.mr_n73300016)
print v(xbgr.mr_n73300336)
print v(xbgr.mr_n73300448)
print v(xbgr.mr_n73300768)
print v(xbgr.mr_n73300880)
print v(xbgr.mr_n73301200)
print v(xbgr.mr_n73301312)
print v(xbgr.mr_n73301632)
print v(xbgr.mr_n73301744)
print v(xbgr.mr_n73302064)
print v(xbgr.mr_n73302176)
print v(xbgr.mr_n73302496)
print v(xbgr.mr_n73302608)
print v(xbgr.mr_n73302928)
print v(xbgr.mr_n73303040)
print v(xbgr.mr_n73303360)
print v(xbgr.mr_n73303472)
print v(xbgr.mr_n73303792)
print v(xbgr.mr_n73303904)
print v(xbgr.mr_n73304224)
print v(xbgr.mr_n73304336)
print v(xbgr.mr_n73304656)
print v(xbgr.mr_n73304768)
print v(xbgr.mr_n73305088)
print v(xbgr.mr_n73305200)
print v(xbgr.mr_n73305520)
print v(xbgr.mr_n73305632)
print v(xbgr.mr_n73305952)
print v(xbgr.mr_n73306064)
print v(xbgr.mr_n73306384)
print v(xbgr.mr_n73306496)
print v(xbgr.mr_n73306816)
print v(xbgr.mr_n73306928)
print v(xbgr.mr_n73307248)
print v(xbgr.mr_n73307360)
print v(xbgr.mr_n73307680)
print v(xbgr.mr_n73307792)
print v(xbgr.mr_n73308112)
print v(xbgr.mr_n73308224)
print v(xbgr.mr_n73308656)
print v(xbgr.mr_n73308976)
print v(xbgr.mr_n73309088)
print v(xbgr.mr_n73309408)
print v(xbgr.mr_n73309520)
print v(xbgr.mr_n73309840)
print v(xbgr.mr_n73309952)
print v(xbgr.mr_n73310272)
print v(xbgr.mr_n73310384)
print v(xbgr.mr_n73310704)
print v(xbgr.mr_n73310816)
print v(xbgr.mr_n73311136)
print v(xbgr.mr_n73311248)
print v(xbgr.mr_n73311568)
print v(xbgr.mr_n73311680)
print v(xbgr.mr_n73312000)
print v(xbgr.mr_n73312112)
print v(xbgr.mr_n73312432)
print v(xbgr.mr_n73312544)
print v(xbgr.mr_n73312976)
print v(xbgr.mr_n73313296)
print v(xbgr.mr_n73313408)
print v(xbgr.mr_n73313728)
print v(xbgr.mr_n73313840)
print v(xbgr.mr_n73314160)
print v(xbgr.mr_n73314272)
print v(xbgr.mr_n73314704)
print v(xbgr.mr_n73315024)
print v(xbgr.mr_n73315136)
print v(xbgr.mr_n73315456)
print v(xbgr.mr_n73315568)
print v(xbgr.mr_n73315888)
print v(xbgr.mr_n73316000)
print v(xbgr.mr_n73316320)
print v(xbgr.mr_n73316432)
print v(xbgr.mr_n73316752)
print v(xbgr.mr_n73316864)
print v(xbgr.mr_n73317296)
print v(xbgr.mr_n73317616)
print v(xbgr.mr_n73317728)
print v(xbgr.mr_n73318048)
print v(xbgr.mr_n73318160)
print v(xbgr.mr_n73318480)
print v(xbgr.mr_n73318592)
print v(xbgr.mr_n73318912)
print v(xbgr.mr_n73319024)
print v(xbgr.mr_n73319344)
print v(xbgr.mr_n73319456)
print v(xbgr.mr_n73319776)
print v(xbgr.mr_n73319888)
print v(xbgr.mr_n73320208)
print v(xbgr.mr_n73320320)
print v(xbgr.mr_n73320640)
print v(xbgr.mr_n73320752)
print v(xbgr.mr_n73321072)
print v(xbgr.mr_n73321184)
print v(xbgr.mr_n73321504)
print v(xbgr.mr_n73321616)
print v(xbgr.mr_n73321936)
print v(xbgr.mr_n73322048)
print v(xbgr.mr_n73322368)
print v(xbgr.mr_n73322480)
print v(xbgr.mr_n73322800)
print v(xbgr.mr_n73322912)
print v(xbgr.mr_n73323232)
print v(xbgr.mr_n73323344)
print v(xbgr.mr_n73323664)
print v(xbgr.mr_n73323776)
print v(xbgr.mr_n73324096)
print v(xbgr.mr_n73324208)
print v(xbgr.mr_n73324528)
print v(xbgr.mr_n73324640)
print v(xbgr.mr_n73324960)
print v(xbgr.mr_n73325072)
print v(xbgr.mr_n73325392)
print v(xbgr.mr_n73325504)
print v(xbgr.mr_n73325824)
print v(xbgr.mr_n73325936)
print v(xbgr.mr_n73326256)
print v(xbgr.mr_n73326368)
print v(xbgr.mr_n73326688)
print v(xbgr.mr_n73326800)
print v(xbgr.mr_n73327120)
print v(xbgr.mr_n73327232)
print v(xbgr.mr_n73327552)
print v(xbgr.mr_n73327664)
print v(xbgr.mr_n73327984)
print v(xbgr.mr_n73328096)
print v(xbgr.mr_n73328416)
print v(xbgr.mr_n73328528)
print v(xbgr.mr_n73328848)
print v(xbgr.mr_n73328960)
print v(xbgr.mr_n73329280)
print v(xbgr.mr_n73329392)
print v(xbgr.mr_n73329712)
print v(xbgr.mr_n73329824)
print v(xbgr.mr_n73330144)
print v(xbgr.mr_n73330256)
print v(xbgr.mr_n73330576)
print v(xbgr.mr_n73330688)
print v(xbgr.mr_n73331008)
print v(xbgr.mr_n73331120)
print v(xbgr.mr_n73331440)
print v(xbgr.mr_n73331552)
print v(xbgr.mr_n73331872)
print v(xbgr.mr_n73331984)
print v(xbgr.mr_n73332304)
print v(xbgr.mr_n73332416)
print v(xbgr.mr_n73332736)
print v(xbgr.mr_n73332848)
print v(xbgr.mr_n73333168)
print v(xbgr.mr_n73333280)
print v(xbgr.mr_n73333600)
print v(xbgr.mr_n73333712)
print v(xbgr.mr_n73334032)
print v(xbgr.mr_n73334144)
print v(xbgr.mr_n73334464)
print v(xbgr.mr_n73334576)
print v(xbgr.mr_n73334896)
print v(xbgr.mr_n73335008)
print v(xbgr.mr_n73335328)
print v(xbgr.mr_n73335440)
print v(xbgr.mr_n73335760)
print v(xbgr.mr_n73335872)
print v(xbgr.mr_n73336192)
print v(xbgr.mr_n73336304)
print v(xbgr.mr_n73336624)
print v(xbgr.mr_n73336736)
print v(xbgr.mr_n73337056)
print v(xbgr.mr_n73337168)
print v(xbgr.mr_n73337488)
print v(xbgr.mr_n73337600)
print v(xbgr.mr_n73337920)
print v(xbgr.mr_n73338032)
print v(xbgr.mr_n73338352)
print v(xbgr.mr_n73338464)
print v(xbgr.mr_n73338784)
print v(xbgr.mr_n73338896)
print v(xbgr.mr_n73339216)
print v(xbgr.mr_n73339328)
print v(xbgr.mr_n73339648)
print v(xbgr.mr_n73339760)
print v(xbgr.mr_n73340080)
print v(xbgr.mr_n73340192)
print v(xbgr.mr_n73340512)
print v(xbgr.mr_n73340624)
print v(xbgr.mr_n73340944)
print v(xbgr.mr_n73341056)
print v(xbgr.mr_n73341376)
print v(xbgr.mr_n73341488)
print v(xbgr.mr_n73341808)
print v(xbgr.mr_n73341920)
print v(xbgr.mr_n73342240)
print v(xbgr.mr_n73342352)
print v(xbgr.mr_n73342672)
print v(xbgr.mr_n73342784)
print v(xbgr.mr_n73343104)
print v(xbgr.mr_n73343216)
print v(xbgr.mr_n73343536)
print v(xbgr.mr_n73343648)
print v(xbgr.mr_n73343968)
print v(xbgr.mr_n73344080)
print v(xbgr.mr_n73344400)
print v(xbgr.mr_n73344512)
print v(xbgr.mr_n73344832)
print v(xbgr.mr_n73344944)
print v(xbgr.mr_n73345264)
print v(xbgr.mr_n73345376)
print v(xbgr.mr_n73345696)
print v(xbgr.mr_n73345808)
print v(xbgr.mr_n73346128)
print v(xbgr.mr_n73346240)
print v(xbgr.mr_n73346560)
print v(xbgr.mr_n73346672)
print v(xbgr.mr_n73346992)
print v(xbgr.mr_n73347104)
print v(xbgr.mr_n73347536)
print v(xbgr.mr_n73347856)
print v(xbgr.mr_n73347968)
print v(xbgr.mr_n73348288)
print v(xbgr.mr_n73348400)
print v(xbgr.mr_n73348720)
print v(xbgr.mr_n73348832)
print v(xbgr.mr_n73349264)
print v(xbgr.mr_n73349584)
print v(xbgr.mr_n73349696)
print v(xbgr.mr_n73350128)
print v(xbgr.mr_n73350448)
print v(xbgr.mr_n73350560)
print v(xbgr.mr_n73350880)
print v(xbgr.mr_n73350992)
print v(xbgr.mr_n73351312)
print v(xbgr.mr_n73351424)
print v(xbgr.mr_n73351744)
print v(xbgr.mr_n73351856)
print v(xbgr.mr_n73352176)
print v(xbgr.mr_n73352288)
print v(xbgr.mr_n73352608)
print v(xbgr.mr_n73352720)
print v(xbgr.mr_n73353040)
print v(xbgr.mr_n73353152)
print v(xbgr.mr_n73353472)
print v(xbgr.mr_n73353584)
print v(xbgr.mr_n73353904)
print v(xbgr.mr_n73354016)
print v(xbgr.mr_n73354336)
print v(xbgr.mr_n73354448)
print v(xbgr.mr_n73354768)
print v(xbgr.mr_n73354880)
print v(xbgr.mr_n73355200)
print v(xbgr.mr_n73355312)
print v(xbgr.mr_n73355632)
print v(xbgr.mr_n73355744)
print v(xbgr.mr_n73356064)
print v(xbgr.mr_n73356176)
print v(xbgr.mr_n73356496)
print v(xbgr.mr_n73356608)
print v(xbgr.mr_n73356928)
print v(xbgr.mr_n73357040)
print v(xbgr.mr_n73357360)
print v(xbgr.mr_n73357472)
print v(xbgr.mr_n73357792)
print v(xbgr.mr_n73357904)
print v(xbgr.mr_n73358224)
print v(xbgr.mr_n73358336)
print v(xbgr.mr_n73358656)
print v(xbgr.mr_n73358768)
print v(xbgr.mr_n73359088)
print v(xbgr.mr_n73359200)
print v(xbgr.mr_n73359520)
print v(xbgr.mr_n73359632)
print v(xbgr.mr_n73359952)
print v(xbgr.mr_n73360064)
print v(xbgr.mr_n73360384)
print v(xbgr.mr_n73360496)
print v(xbgr.mr_n73360816)
print v(xbgr.mr_n73360928)
print v(xbgr.mr_n73361248)
print v(xbgr.mr_n73361360)
print v(xbgr.mr_n73361680)
print v(xbgr.mr_n73361792)
print v(xbgr.mr_n73362112)
print v(xbgr.mr_n73362224)
print v(xbgr.mr_n73362544)
print v(xbgr.mr_n73362656)
print v(xbgr.mr_n73362976)
print v(xbgr.mr_n73363088)
print v(xbgr.mr_n73363408)
print v(xbgr.mr_n73363520)
print v(xbgr.mr_n73363840)
print v(xbgr.mr_n73363952)
print v(xbgr.mr_n73364272)
print v(xbgr.mr_n73364384)
print v(xbgr.mr_n73364704)
print v(xbgr.mr_n73364816)
print v(xbgr.mr_n73365136)
print v(xbgr.mr_n73365248)
print v(xbgr.mr_n73365568)
print v(xbgr.mr_n73365680)
print v(xbgr.mr_n73366000)
print v(xbgr.mr_n73366112)
print v(xbgr.mr_n73366432)
print v(xbgr.mr_n73366544)
print v(xbgr.mr_n73366864)
print v(xbgr.mr_n73366976)
print v(xbgr.mr_n73367296)
print v(xbgr.mr_n73367408)
print v(xbgr.mr_n73367728)
print v(xbgr.mr_n73367840)
print v(xbgr.mr_n73368160)
print v(xbgr.mr_n73368272)
print v(xbgr.mr_n73368592)
print v(xbgr.mr_n73368704)
print v(xbgr.mr_n73369024)
print v(xbgr.mr_n73369136)
print v(xbgr.mr_n73369456)
print v(xbgr.mr_n73369568)
print v(xbgr.mr_n73369888)
print v(xbgr.mr_n73370000)
print v(xbgr.mr_n73370320)
print v(xbgr.mr_n73370432)
print v(xbgr.mr_n73370752)
print v(xbgr.mr_n73370864)
print v(xbgr.mr_n73371184)
print v(xbgr.mr_n73371296)
print v(xbgr.mr_n73371616)
print v(xbgr.mr_n73371728)
print v(xbgr.mr_n73372048)
print v(xbgr.mr_n73372160)
print v(xbgr.mr_n73372480)
print v(xbgr.mr_n73372592)
print v(xbgr.mr_n73372912)
print v(xbgr.mr_n73373024)
print v(xbgr.mr_n73373344)
print v(xbgr.mr_n73373456)
print v(xbgr.mr_n73373776)
print v(xbgr.mr_n73373888)
print v(xbgr.mr_n73374208)
print v(xbgr.mr_n73374320)
print v(xbgr.mr_n73374640)
print v(xbgr.mr_n73374752)
print v(xbgr.mr_n73375072)
print v(xbgr.mr_n73375184)
print v(xbgr.mr_n73375504)
print v(xbgr.mr_n73375616)
print v(xbgr.mr_n73375936)
print v(xbgr.mr_n73376048)
print v(xbgr.mr_n73376368)
print v(xbgr.mr_n73376480)
print v(xbgr.mr_n73376800)
print v(xbgr.mr_n73376912)
print v(xbgr.mr_n73377232)
print v(xbgr.mr_n73377344)
print v(xbgr.mr_n73377664)
print v(xbgr.mr_n73377776)
print v(xbgr.mr_n73378096)
print v(xbgr.mr_n73378208)
print v(xbgr.mr_n73378528)
print v(xbgr.mr_n73378640)
print v(xbgr.mr_n73378960)
print v(xbgr.mr_n73379072)
print v(xbgr.mr_n73379392)
print v(xbgr.mr_n73379504)
print v(xbgr.mr_n73379824)
print v(xbgr.mr_n73379936)
print v(xbgr.mr_n73380256)
print v(xbgr.mr_n73380368)
print v(xbgr.mr_n73380688)
print v(xbgr.mr_n73380800)
print v(xbgr.mr_n73381120)
print v(xbgr.mr_n73381232)
print v(xbgr.mr_n73381552)
print v(xbgr.mr_n73381664)
print v(xbgr.mr_n73381984)
print v(xbgr.mr_n73382096)
print v(xbgr.mr_n73382416)
print v(xbgr.mr_n73382528)
print v(xbgr.mr_n73382848)
print v(xbgr.mr_n73382960)
print v(xbgr.mr_n73383280)
print v(xbgr.mr_n73383392)
print v(xbgr.mr_n73383712)
print v(xbgr.mr_n73383824)
print v(xbgr.mr_n73384144)
print v(xbgr.mr_n73384256)
print v(xbgr.mr_n73384576)
print v(xbgr.mr_n73384688)
print v(xbgr.mr_n73385008)
print v(xbgr.mr_n73385120)
print v(xbgr.mr_n73385440)
print v(xbgr.mr_n73385552)
print v(xbgr.mr_n73385872)
print v(xbgr.mr_n73385984)
print v(xbgr.mr_n73386304)
print v(xbgr.mr_n73386416)
print v(xbgr.mr_n73386736)
print v(xbgr.mr_n73386848)
print v(xbgr.mr_n73387168)
print v(xbgr.mr_n73387280)
print v(xbgr.mr_n73387600)
print v(xbgr.mr_n73387712)
print v(xbgr.mr_n73388032)
print v(xbgr.mr_n73388144)
print v(xbgr.mr_n73388464)
print v(xbgr.mr_n73388576)
print v(xbgr.mr_n73388896)
print v(xbgr.mr_n73389008)
print v(xbgr.mr_n73389328)
print v(xbgr.mr_n73389440)
print v(xbgr.mr_n73389760)
print v(xbgr.mr_n73389872)
print v(xbgr.mr_n73390192)
print v(xbgr.mr_n73390304)
print v(xbgr.mr_n73390624)
print v(xbgr.mr_n73390736)
print v(xbgr.mr_n73391056)
print v(xbgr.mr_n73391168)
print v(xbgr.mr_n73391488)
print v(xbgr.mr_n73391600)
print v(xbgr.mr_n73391920)
print v(xbgr.mr_n73392032)
print v(xbgr.mr_n73392352)
print v(xbgr.mr_n73392464)
print v(xbgr.mr_n73392784)
print v(xbgr.mr_n73392896)
print v(xbgr.mr_n73393216)
print v(xbgr.mr_n73393328)
print v(xbgr.mr_n73393648)
print v(xbgr.mr_n73393760)
print v(xbgr.mr_n73394080)
print v(xbgr.mr_n73394192)
print v(xbgr.mr_n73394512)
print v(xbgr.mr_n73394624)
print v(xbgr.mr_n73394944)
print v(xbgr.mr_n73395056)
print v(xbgr.mr_n73395376)
print v(xbgr.mr_n73395488)
print v(xbgr.mr_n73395808)
print v(xbgr.mr_n73395920)
print v(xbgr.mr_n73396240)
print v(xbgr.mr_n73396352)
print v(xbgr.mr_n73396672)
print v(xbgr.mr_n73396784)
print v(xbgr.mr_n73397104)
print v(xbgr.mr_n73397216)
print v(xbgr.mr_n73397536)
print v(xbgr.mr_n73397648)
print v(xbgr.mr_n73397968)
print v(xbgr.mr_n73398080)
print v(xbgr.mr_n73398400)
print v(xbgr.mr_n73398512)
print v(xbgr.mr_n73398832)
print v(xbgr.mr_n73398944)
print v(xbgr.mr_n73399264)
print v(xbgr.mr_n73399376)
print v(xbgr.mr_n73399696)
print v(xbgr.mr_n73399808)
print v(xbgr.mr_n73400128)
print v(xbgr.mr_n73400240)
print v(xbgr.mr_n73400560)
print v(xbgr.mr_n73400672)
print v(xbgr.mr_n73400992)
print v(xbgr.mr_n73401104)
print v(xbgr.mr_n73401424)
print v(xbgr.mr_n73401536)
print v(xbgr.mr_n73401856)
print v(xbgr.mr_n73401968)
print v(xbgr.mr_n73402288)
print v(xbgr.mr_n73402400)
print v(xbgr.mr_n73402720)
print v(xbgr.mr_n73402832)
print v(xbgr.mr_n73403152)
print v(xbgr.mr_n73403264)
print v(xbgr.mr_n73403584)
print v(xbgr.mr_n73403696)
print v(xbgr.mr_n73404016)
print v(xbgr.mr_n73404128)
print v(xbgr.mr_n73404448)
print v(xbgr.mr_n73404560)
print v(xbgr.mr_n73404880)
print v(xbgr.mr_n73404992)
print v(xbgr.mr_n73405312)
print v(xbgr.mr_n73405424)
print v(xbgr.mr_n73405744)
print v(xbgr.mr_n73405856)
print v(xbgr.mr_n73406176)
print v(xbgr.mr_n73406288)
print v(xbgr.mr_n73406608)
print v(xbgr.mr_n73406720)
print v(xbgr.mr_n73407040)
print v(xbgr.mr_n73407152)
print v(xbgr.mr_n73407472)
print v(xbgr.mr_n73407584)
print v(xbgr.mr_n73407904)
print v(xbgr.mr_n73408016)
print v(xbgr.mr_n73408336)
print v(xbgr.mr_n73408448)
print v(xbgr.mr_n73408768)
print v(xbgr.mr_n73408880)
print v(xbgr.mr_n73409200)
print v(xbgr.mr_n73409312)
print v(xbgr.mr_n73409632)
print v(xbgr.mr_n73409744)
print v(xbgr.mr_n73410064)
print v(xbgr.mr_n73410176)
print v(xbgr.mr_n73410496)
print v(xbgr.mr_n73410608)
print v(xbgr.mr_n73410928)
print v(xbgr.mr_n73411040)
print v(xbgr.mr_n73411360)
print v(xbgr.mr_n73411472)
print v(xbgr.mr_n73411792)
print v(xbgr.mr_n73411904)
print v(xbgr.mr_n73412224)
print v(xbgr.mr_n73412336)
print v(xbgr.mr_n73412656)
print v(xbgr.mr_n73412768)
print v(xbgr.mr_n73413088)
print v(xbgr.mr_n73413200)
print v(xbgr.mr_n73413520)
print v(xbgr.mr_n73413632)
print v(xbgr.mr_n73413952)
print v(xbgr.mr_n73414064)
print v(xbgr.mr_n73414384)
print v(xbgr.mr_n73414496)
print v(xbgr.mr_n73414816)
print v(xbgr.mr_n73414928)
print v(xbgr.mr_n73415248)
print v(xbgr.mr_n73415360)
print v(xbgr.mr_n73415680)
print v(xbgr.mr_n73415792)
print v(xbgr.mr_n73416112)
print v(xbgr.mr_n73416224)
print v(xbgr.mr_n73416544)
print v(xbgr.mr_n73416656)
print v(xbgr.mr_n73416976)
print v(xbgr.mr_n73417088)
print v(xbgr.mr_n73417408)
print v(xbgr.mr_n73417520)
print v(xbgr.mr_n73417840)
print v(xbgr.mr_n73417952)
print v(xbgr.mr_n73418272)
print v(xbgr.mr_n73418384)
print v(xbgr.mr_n73418704)
print v(xbgr.mr_n73418816)
print v(xbgr.mr_n73419136)
print v(xbgr.mr_n73419248)
print v(xbgr.mr_n73419568)
print v(xbgr.mr_n73419680)
print v(xbgr.mr_n73420000)
print v(xbgr.mr_n73420112)
print v(xbgr.mr_n73420432)
print v(xbgr.mr_n73420544)
print v(xbgr.mr_n73420864)
print v(xbgr.mr_n73420976)
print v(xbgr.mr_n73421296)
print v(xbgr.mr_n73421408)
print v(xbgr.mr_n73421728)
print v(xbgr.mr_n73421840)
print v(xbgr.mr_n73422160)
print v(xbgr.mr_n73422272)
print v(xbgr.mr_n73422592)
print v(xbgr.mr_n73422704)
print v(xbgr.mr_n73423024)
print v(xbgr.mr_n73423136)
print v(xbgr.mr_n73423456)
print v(xbgr.mr_n73423568)
print v(xbgr.mr_n73423888)
print v(xbgr.mr_n73424000)
print v(xbgr.mr_n73424320)
print v(xbgr.mr_n73424432)
print v(xbgr.mr_n73424752)
print v(xbgr.mr_n73424864)
print v(xbgr.mr_n73425184)
print v(xbgr.mr_n73425296)
print v(xbgr.mr_n73425616)
print v(xbgr.mr_n73425728)
print v(xbgr.mr_n73426048)
print v(xbgr.mr_n73426160)
print v(xbgr.mr_n73426480)
print v(xbgr.mr_n73426592)
print v(xbgr.mr_n73426912)
print v(xbgr.mr_n73427024)
print v(xbgr.mr_n73427344)
print v(xbgr.mr_n73427456)
print v(xbgr.mr_n73427776)
print v(xbgr.mr_n73427888)
print v(xbgr.mr_n73428208)
print v(xbgr.mr_n73428320)
print v(xbgr.mr_n73428640)
print v(xbgr.mr_n73428752)
print v(xbgr.mr_n73429072)
print v(xbgr.mr_n73429184)
print v(xbgr.mr_n73429504)
print v(xbgr.mr_n73429616)
print v(xbgr.mr_n73429936)
print v(xbgr.mr_n73430048)
print v(xbgr.mr_n73430368)
print v(xbgr.mr_n73430480)
print v(xbgr.mr_n73430800)
print v(xbgr.mr_n73430912)
print v(xbgr.mr_n73431232)
print v(xbgr.mr_n73431344)
print v(xbgr.mr_n73431664)
print v(xbgr.mr_n73431776)
print v(xbgr.mr_n73432096)
print v(xbgr.mr_n73432208)
print v(xbgr.mr_n73432528)
print v(xbgr.mr_n73432640)
print v(xbgr.mr_n73432960)
print v(xbgr.mr_n73433072)
print v(xbgr.mr_n73433392)
print v(xbgr.mr_n73433504)
print v(xbgr.mr_n73433824)
print v(xbgr.mr_n73433936)
print v(xbgr.mr_n73434256)
print v(xbgr.mr_n73434368)
print v(xbgr.mr_n73434688)
print v(xbgr.mr_n73434800)
print v(xbgr.mr_n73435120)
print v(xbgr.mr_n73435232)
print v(xbgr.mr_n73435552)
print v(xbgr.mr_n73435664)
print v(xbgr.mr_n73435984)
print v(xbgr.mr_n73436096)
print v(xbgr.mr_n73436416)
print v(xbgr.mr_n73436528)
print v(xbgr.mr_n73436848)
print v(xbgr.mr_n73436960)
print v(xbgr.mr_n73437280)
print v(xbgr.mr_n73437392)
print v(xbgr.mr_n73437712)
print v(xbgr.mr_n73437824)
print v(xbgr.mr_n73438144)
print v(xbgr.mr_n73438256)
print v(xbgr.mr_n73438576)
print v(xbgr.mr_n73438688)
print v(xbgr.mr_n73439008)
print v(xbgr.mr_n73439120)
print v(xbgr.mr_n73439440)
print v(xbgr.mr_n73439552)
print v(xbgr.mr_n73439872)
print v(xbgr.mr_n73439984)
print v(xbgr.mr_n73440304)
print v(xbgr.mr_n73440416)
print v(xbgr.mr_n73506288)
print v(xbgr.mr_n73506400)
print v(xbgr.mr_n73506720)
print v(xbgr.mr_n73506832)
print v(xbgr.mr_n73507152)
print v(xbgr.mr_n73507264)
print v(xbgr.mr_n73507696)
print v(xbgr.mr_n73508016)
print v(xbgr.mr_n73508128)
print v(xbgr.mr_n73508448)
print v(xbgr.mr_n73508560)
print v(xbgr.mr_n73508992)
print v(xbgr.mr_n73509424)
print v(xbgr.mr_n73509744)
print v(xbgr.mr_n73509856)
print v(xbgr.mr_n73510176)
print v(xbgr.mr_n73510288)
print v(xbgr.mr_n73510608)
print v(xbgr.mr_n73510720)
print v(xbgr.mr_n73511040)
print v(xbgr.mr_n73511152)
print v(xbgr.mr_n73511472)
print v(xbgr.mr_n73511584)
print v(xbgr.mr_n73511904)
print v(xbgr.mr_n73512016)
print v(xbgr.mr_n73512336)
print v(xbgr.mr_n73512448)
print v(xbgr.mr_n73512768)
print v(xbgr.mr_n73512880)
print v(xbgr.mr_n73513200)
print v(xbgr.mr_n73513312)
print v(xbgr.mr_n73513632)
print v(xbgr.mr_n73513744)
print v(xbgr.mr_n73514064)
print v(xbgr.mr_n73514176)
print v(xbgr.mr_n73514496)
print v(xbgr.mr_n73514608)
print v(xbgr.mr_n73515040)
print v(xbgr.mr_n73515360)
print v(xbgr.mr_n73515472)
print v(xbgr.mr_n73515792)
print v(xbgr.mr_n73515904)
print v(xbgr.mr_n73516224)
print v(xbgr.mr_n73516336)
print v(xbgr.mr_n73516656)
print v(xbgr.mr_n73516768)
print v(xbgr.mr_n73517088)
print v(xbgr.mr_n73517200)
print v(xbgr.mr_n73517520)
print v(xbgr.mr_n73517632)
print v(xbgr.mr_n73517952)
print v(xbgr.mr_n73518064)
print v(xbgr.mr_n73518384)
print v(xbgr.mr_n73518496)
print v(xbgr.mr_n73518816)
print v(xbgr.mr_n73518928)
print v(xbgr.mr_n73519248)
print v(xbgr.mr_n73519360)
print v(xbgr.mr_n73519792)
print v(xbgr.mr_n73520224)
print v(xbgr.mr_n73520544)
print v(xbgr.mr_n73520656)
print v(xbgr.mr_n73520976)
print v(xbgr.mr_n73521088)
print v(xbgr.mr_n73521408)
print v(xbgr.mr_n73521520)
print v(xbgr.mr_n73521840)
print v(xbgr.mr_n73521952)
print v(xbgr.mr_n73522272)
print v(xbgr.mr_n73522384)
print v(xbgr.mr_n73522704)
print v(xbgr.mr_n73522816)
print v(xbgr.mr_n73523136)
print v(xbgr.mr_n73523248)
print v(xbgr.mr_n73523568)
print v(xbgr.mr_n73523680)
print v(xbgr.mr_n73524000)
print v(xbgr.mr_n73524112)
print v(xbgr.mr_n73524432)
print v(xbgr.mr_n73524544)
print v(xbgr.mr_n73524864)
print v(xbgr.mr_n73524976)
print v(xbgr.mr_n73525296)
print v(xbgr.mr_n73525408)
print v(xbgr.mr_n73525728)
print v(xbgr.mr_n73525840)
print v(xbgr.mr_n73526160)
print v(xbgr.mr_n73526272)
print v(xbgr.mr_n73526592)
print v(xbgr.mr_n73526704)
print v(xbgr.mr_n73527024)
print v(xbgr.mr_n73527136)
print v(xbgr.mr_n73527456)
print v(xbgr.mr_n73527568)
print v(xbgr.mr_n73527888)
print v(xbgr.mr_n73528000)
print v(xbgr.mr_n73528320)
print v(xbgr.mr_n73528432)
print v(xbgr.mr_n73528752)
print v(xbgr.mr_n73528864)
print v(xbgr.mr_n73529184)
print v(xbgr.mr_n73529296)
print v(xbgr.mr_n73529616)
print v(xbgr.mr_n73529728)
print v(xbgr.mr_n73530048)
print v(xbgr.mr_n73530160)
print v(xbgr.mr_n73530480)
print v(xbgr.mr_n73530592)
print v(xbgr.mr_n73530912)
print v(xbgr.mr_n73531024)
print v(xbgr.mr_n73531344)
print v(xbgr.mr_n73531456)
print v(xbgr.mr_n73531776)
print v(xbgr.mr_n73531888)
print v(xbgr.mr_n73532208)
print v(xbgr.mr_n73532320)
print v(xbgr.mr_n73532640)
print v(xbgr.mr_n73532752)
print v(xbgr.mr_n73533072)
print v(xbgr.mr_n73533184)
print v(xbgr.mr_n73533504)
print v(xbgr.mr_n73533616)
print v(xbgr.mr_n73533936)
print v(xbgr.mr_n73534048)
print v(xbgr.mr_n73534368)
print v(xbgr.mr_n73534480)
print v(xbgr.mr_n73534800)
print v(xbgr.mr_n73534912)
print v(xbgr.mr_n73535232)
print v(xbgr.mr_n73535344)
print v(xbgr.mr_n73535664)
print v(xbgr.mr_n73535776)
print v(xbgr.mr_n73536096)
print v(xbgr.mr_n73536208)
print v(xbgr.mr_n73536528)
print v(xbgr.mr_n73536640)
print v(xbgr.mr_n73536960)
print v(xbgr.mr_n73537072)
print v(xbgr.mr_n73537392)
print v(xbgr.mr_n73537504)
print v(xbgr.mr_n73537824)
print v(xbgr.mr_n73537936)
print v(xbgr.mr_n73538256)
print v(xbgr.mr_n73538368)
print v(xbgr.mr_n73538688)
print v(xbgr.mr_n73538800)
print v(xbgr.mr_n73539120)
print v(xbgr.mr_n73539232)
print v(xbgr.mr_n73539552)
print v(xbgr.mr_n73539664)
print v(xbgr.mr_n73539984)
print v(xbgr.mr_n73540096)
print v(xbgr.mr_n73540416)
print v(xbgr.mr_n73540528)
print v(xbgr.mr_n73540848)
print v(xbgr.mr_n73540960)
print v(xbgr.mr_n73541280)
print v(xbgr.mr_n73541392)
print v(xbgr.mr_n73541712)
print v(xbgr.mr_n73541824)
print v(xbgr.mr_n73542144)
print v(xbgr.mr_n73542256)
print v(xbgr.mr_n73542576)
print v(xbgr.mr_n73542688)
print v(xbgr.mr_n73543008)
print v(xbgr.mr_n73543120)
print v(xbgr.mr_n73543440)
print v(xbgr.mr_n73543552)
print v(xbgr.mr_n73543872)
print v(xbgr.mr_n73543984)
print v(xbgr.mr_n73544304)
print v(xbgr.mr_n73544416)
print v(xbgr.mr_n73544736)
print v(xbgr.mr_n73544848)
print v(xbgr.mr_n73545168)
print v(xbgr.mr_n73545280)
print v(xbgr.mr_n73545600)
print v(xbgr.mr_n73545712)
print v(xbgr.mr_n73546032)
print v(xbgr.mr_n73546144)
print v(xbgr.mr_n73546464)
print v(xbgr.mr_n73546576)
print v(xbgr.mr_n73546896)
print v(xbgr.mr_n73547008)
print v(xbgr.mr_n73547328)
print v(xbgr.mr_n73547440)
print v(xbgr.mr_n73547760)
print v(xbgr.mr_n73547872)
print v(xbgr.mr_n73548192)
print v(xbgr.mr_n73548304)
print v(xbgr.mr_n73548624)
print v(xbgr.mr_n73548736)
print v(xbgr.mr_n73549056)
print v(xbgr.mr_n73549168)
print v(xbgr.mr_n73549488)
print v(xbgr.mr_n73549600)
print v(xbgr.mr_n73549920)
print v(xbgr.mr_n73550032)
print v(xbgr.mr_n73550352)
print v(xbgr.mr_n73550464)
print v(xbgr.mr_n73550784)
print v(xbgr.mr_n73550896)
print v(xbgr.mr_n73551216)
print v(xbgr.mr_n73551328)
print v(xbgr.mr_n73551648)
print v(xbgr.mr_n73551760)
print v(xbgr.mr_n73552080)
print v(xbgr.mr_n73552192)
print v(xbgr.mr_n73552512)
print v(xbgr.mr_n73552624)
print v(xbgr.mr_n73552944)
print v(xbgr.mr_n73553056)
print v(xbgr.mr_n73553376)
print v(xbgr.mr_n73553488)
print v(xbgr.mr_n73553808)
print v(xbgr.mr_n73553920)
print v(xbgr.mr_n73554240)
print v(xbgr.mr_n73554352)
print v(xbgr.mr_n73554672)
print v(xbgr.mr_n73554784)
print v(xbgr.mr_n73555104)
print v(xbgr.mr_n73555216)
print v(xbgr.mr_n73555536)
print v(xbgr.mr_n73555648)
print v(xbgr.mr_n73555968)
print v(xbgr.mr_n73556080)
print v(xbgr.mr_n73556400)
print v(xbgr.mr_n73556512)
print v(xbgr.mr_n73556832)
print v(xbgr.mr_n73556944)
print v(xbgr.mr_n73557264)
print v(xbgr.mr_n73557376)
print v(xbgr.mr_n73557696)
print v(xbgr.mr_n73557808)
print v(xbgr.mr_n73558128)
print v(xbgr.mr_n73558240)
print v(xbgr.mr_n73558560)
print v(xbgr.mr_n73558672)
print v(xbgr.mr_n73558992)
print v(xbgr.mr_n73559104)
print v(xbgr.mr_n73559424)
print v(xbgr.mr_n73559536)
print v(xbgr.mr_n73559856)
print v(xbgr.mr_n73559968)
print v(xbgr.mr_n73560288)
print v(xbgr.mr_n73560400)
print v(xbgr.mr_n73560720)
print v(xbgr.mr_n73560832)
print v(xbgr.mr_n73561152)
print v(xbgr.mr_n73561264)
print v(xbgr.mr_n73561584)
print v(xbgr.mr_n73561696)
print v(xbgr.mr_n73562016)
print v(xbgr.mr_n73562128)
print v(xbgr.mr_n73562448)
print v(xbgr.mr_n73562560)
print v(xbgr.mr_n73562880)
print v(xbgr.mr_n73562992)
print v(xbgr.mr_n73563312)
print v(xbgr.mr_n73563424)
print v(xbgr.mr_n73563744)
print v(xbgr.mr_n73563856)
print v(xbgr.mr_n73564176)
print v(xbgr.mr_n73564288)
print v(xbgr.mr_n73564608)
print v(xbgr.mr_n73564720)
print v(xbgr.mr_n73565040)
print v(xbgr.mr_n73565152)
print v(xbgr.mr_n73565472)
print v(xbgr.mr_n73565584)
print v(xbgr.mr_n73565904)
print v(xbgr.mr_n73566016)
print v(xbgr.mr_n73566336)
print v(xbgr.mr_n73566448)
print v(xbgr.mr_n73566768)
print v(xbgr.mr_n73566880)
print v(xbgr.mr_n73567200)
print v(xbgr.mr_n73567312)
print v(xbgr.mr_n73567632)
print v(xbgr.mr_n73567744)
print v(xbgr.mr_n73568064)
print v(xbgr.mr_n73568176)
print v(xbgr.mr_n73568496)
print v(xbgr.mr_n73568608)
print v(xbgr.mr_n73568928)
print v(xbgr.mr_n73569040)
print v(xbgr.mr_n73569360)
print v(xbgr.mr_n73569472)
print v(xbgr.mr_n73569792)
print v(xbgr.mr_n73569904)
print v(xbgr.mr_n73570224)
print v(xbgr.mr_n73570336)
print v(xbgr.mr_n73570656)
print v(xbgr.mr_n73570768)
print v(xbgr.mr_n73571088)
print v(xbgr.mr_n73571200)
print v(xbgr.mr_n73571520)
print v(xbgr.mr_n73571632)
print v(xbgr.mr_n73571952)
print v(xbgr.mr_n73572064)
print v(xbgr.mr_n73572384)
print v(xbgr.mr_n73572496)
print v(xbgr.mr_n73572816)
print v(xbgr.mr_n73572928)
print v(xbgr.mr_n73573248)
print v(xbgr.mr_n73573360)
print v(xbgr.mr_n73573680)
print v(xbgr.mr_n73573792)
print v(xbgr.mr_n73574112)
print v(xbgr.mr_n73574224)
print v(xbgr.mr_n73574544)
print v(xbgr.mr_n73574656)
print v(xbgr.mr_n73574976)
print v(xbgr.mr_n73575088)
print v(xbgr.mr_n73575408)
print v(xbgr.mr_n73575520)
print v(xbgr.mr_n73575840)
print v(xbgr.mr_n73575952)
print v(xbgr.mr_n73576272)
print v(xbgr.mr_n73576384)
print v(xbgr.mr_n73576704)
print v(xbgr.mr_n73576816)
print v(xbgr.mr_n73577136)
print v(xbgr.mr_n73577248)
print v(xbgr.mr_n73577568)
print v(xbgr.mr_n73577680)
print v(xbgr.mr_n73578000)
print v(xbgr.mr_n73578112)
print v(xbgr.mr_n73578432)
print v(xbgr.mr_n73578544)
print v(xbgr.mr_n73578864)
print v(xbgr.mr_n73578976)
print v(xbgr.mr_n73579296)
print v(xbgr.mr_n73579408)
print v(xbgr.mr_n73579728)
print v(xbgr.mr_n73579840)
print v(xbgr.mr_n73580160)
print v(xbgr.mr_n73580272)
print v(xbgr.mr_n73580592)
print v(xbgr.mr_n73580704)
print v(xbgr.mr_n73581024)
print v(xbgr.mr_n73581136)
print v(xbgr.mr_n73581456)
print v(xbgr.mr_n73581568)
print v(xbgr.mr_n73581888)
print v(xbgr.mr_n73582000)
print v(xbgr.mr_n73582320)
print v(xbgr.mr_n73582432)
print v(xbgr.mr_n73582752)
print v(xbgr.mr_n73582864)
print v(xbgr.mr_n73583184)
print v(xbgr.mr_n73583296)
print v(xbgr.mr_n73583616)
print v(xbgr.mr_n73583728)
print v(xbgr.mr_n73584048)
print v(xbgr.mr_n73584160)
print v(xbgr.mr_n73584480)
print v(xbgr.mr_n73584592)
print v(xbgr.mr_n73584912)
print v(xbgr.mr_n73585024)
print v(xbgr.mr_n73585344)
print v(xbgr.mr_n73585456)
print v(xbgr.mr_n73585776)
print v(xbgr.mr_n73585888)
print v(xbgr.mr_n73586208)
print v(xbgr.mr_n73586320)
print v(xbgr.mr_n73586640)
print v(xbgr.mr_n73586752)
print v(xbgr.mr_n73587072)
print v(xbgr.mr_n73587184)
print v(xbgr.mr_n73587504)
print v(xbgr.mr_n73587616)
print v(xbgr.mr_n73587936)
print v(xbgr.mr_n73588048)
print v(xbgr.mr_n73588480)
print v(xbgr.mr_n73588800)
print v(xbgr.mr_n73588912)
print v(xbgr.mr_n73589232)
print v(xbgr.mr_n73589344)
print v(xbgr.mr_n73589664)
print v(xbgr.mr_n73589776)
print v(xbgr.mr_n73590096)
print v(xbgr.mr_n73590208)
print v(xbgr.mr_n73590528)
print v(xbgr.mr_n73591392)
print v(xbgr.mr_n73591504)
print v(xbgr.mr_n73591824)
print v(xbgr.mr_n73591936)
print v(xbgr.mr_n73592256)
print v(xbgr.mr_n73592368)
print v(xbgr.mr_n73592688)
print v(xbgr.mr_n73592800)
print v(xbgr.mr_n73593120)
print v(xbgr.mr_n73593232)
print v(xbgr.mr_n73593664)
print v(xbgr.mr_n73593984)
print v(xbgr.mr_n73594096)
print v(xbgr.mr_n73594416)
print v(xbgr.mr_n73594528)
print v(xbgr.mr_n73594848)
print v(xbgr.mr_n73594960)
print v(xbgr.mr_n73595280)
print v(xbgr.mr_n73595392)
print v(xbgr.mr_n73595712)
print v(xbgr.mr_n73595824)
print v(xbgr.mr_n73596256)
print v(xbgr.mr_n73596576)
print v(xbgr.mr_n73597440)
print v(xbgr.mr_n73597552)
print v(xbgr.mr_n73597984)
print v(xbgr.mr_n73598304)
print v(xbgr.mr_n73599168)
print v(xbgr.mr_n73599280)
print v(xbgr.mr_n73599712)
print v(xbgr.mr_n73600032)
print v(xbgr.mr_n73600144)
print v(xbgr.mr_n73600464)
print v(xbgr.mr_n73600576)
print v(xbgr.mr_n73600896)
print v(xbgr.mr_n73601008)
print v(xbgr.mr_n73601328)
print v(xbgr.mr_n73601440)
print v(xbgr.mr_n73601760)
print v(xbgr.mr_n73601872)
print v(xbgr.mr_n73602192)
print v(xbgr.mr_n73602304)
print v(xbgr.mr_n73602624)
print v(xbgr.mr_n73603488)
print v(xbgr.mr_n73603600)
print v(xbgr.mr_n73603920)
print v(xbgr.mr_n73604032)
print v(xbgr.mr_n73604352)
print v(xbgr.mr_n73605216)
print v(xbgr.mr_n73605328)
print v(xbgr.mr_n73605648)
print v(xbgr.mr_n73605760)
print v(xbgr.mr_n73606080)
print v(xbgr.mr_n73606192)
print v(xbgr.mr_n73606512)
print v(xbgr.mr_n73606624)
print v(xbgr.mr_n73606944)
print v(xbgr.mr_n73607056)
print v(xbgr.mr_n73607376)
print v(xbgr.mr_n73607488)
print v(xbgr.mr_n73607808)
print v(xbgr.mr_n73607920)
print v(xbgr.mr_n73608240)
print v(xbgr.mr_n73608352)
print v(xbgr.mr_n73608672)
print v(xbgr.mr_n73608784)
print v(xbgr.mr_n73609104)
print v(xbgr.mr_n73609216)
print v(xbgr.mr_n73609536)
print v(xbgr.mr_n73609648)
print v(xbgr.mr_n73609968)
print v(xbgr.mr_n73610080)
print v(xbgr.mr_n73610400)
print v(xbgr.mr_n73610512)
print v(xbgr.mr_n73610832)
print v(xbgr.mr_n73610944)
print v(xbgr.mr_n73611264)
print v(xbgr.mr_n73611376)
print v(xbgr.mr_n73611696)
print v(xbgr.mr_n73611808)
print v(xbgr.mr_n73612128)
print v(xbgr.mr_n73612240)
print v(xbgr.mr_n73612560)
print v(xbgr.mr_n73612672)
print v(xbgr.mr_n73612992)
print v(xbgr.mr_n73613104)
print v(xbgr.mr_n73613424)
print v(xbgr.mr_n73613536)
print v(xbgr.mr_n73613856)
print v(xbgr.mr_n73613968)
print v(xbgr.mr_n73614288)
print v(xbgr.mr_n73614400)
print v(xbgr.mr_n73614720)
print v(xbgr.mr_n73614832)
print v(xbgr.mr_n73615152)
print v(xbgr.mr_n73615264)
print v(xbgr.mr_n73615584)
print v(xbgr.mr_n73615696)
print v(xbgr.mr_n73616016)
print v(xbgr.mr_n73616128)
print v(xbgr.mr_n73616560)
print v(xbgr.mr_n73616992)
print v(xbgr.mr_n73617424)
print v(xbgr.mr_n73617856)
print v(xbgr.mr_n73618288)
print v(xbgr.mr_n73618720)
print v(xbgr.mr_n73619152)
print v(xbgr.mr_n73619584)
print v(xbgr.mr_n73620016)
print v(xbgr.mr_n73620448)
print v(xbgr.mr_n73620880)
print v(xbgr.mr_n73621312)
print v(xbgr.mr_n73621744)
print v(xbgr.mr_n73622176)
print v(xbgr.mr_n73622608)
print v(xbgr.mr_n73623040)
print v(xbgr.mr_n73623472)
print v(xbgr.mr_n73623904)
print v(xbgr.mr_n73624336)
print v(xbgr.mr_n73624768)
print v(xbgr.mr_n73625200)
print v(xbgr.mr_n73625632)
print v(xbgr.mr_n73625952)
print v(xbgr.mr_n73626064)
print v(xbgr.mr_n73626496)
print v(xbgr.mr_n73626928)
print v(xbgr.mr_n73627360)
print v(xbgr.mr_n73627792)
print v(xbgr.mr_n73628224)
print v(xbgr.mr_n73628656)
print v(xbgr.mr_n73629088)
print v(xbgr.mr_n73629520)
print v(xbgr.mr_n73629952)
print v(xbgr.mr_n73630384)
print v(xbgr.mr_n73630816)
print v(xbgr.mr_n73631248)
print v(xbgr.mr_n73631680)
print v(xbgr.mr_n73632112)
print v(xbgr.mr_n73632544)
print v(xbgr.mr_n73632976)
print v(xbgr.mr_n73633408)
print v(xbgr.mr_n73633840)
print v(xbgr.mr_n73634272)
print v(xbgr.mr_n73634704)
print v(xbgr.mr_n73635136)
print v(xbgr.mr_n73635568)
print v(xbgr.mr_n73636000)
print v(xbgr.mr_n73636432)
print v(xbgr.mr_n73636864)
print v(xbgr.mr_n73637296)
print v(xbgr.mr_n73637728)
print v(xbgr.mr_n73638160)
print v(xbgr.mr_n73638592)
print v(xbgr.mr_n73639024)
print v(xbgr.mr_n73639456)
print v(xbgr.mr_n73639888)
print v(xbgr.mr_n73640320)
print v(xbgr.mr_n73640752)
print v(xbgr.mr_n73641184)
print v(xbgr.mr_n73641616)
print v(xbgr.mr_n73642048)
print v(xbgr.mr_n73642480)
print v(xbgr.mr_n73642912)
print v(xbgr.mr_n73643344)
print v(xbgr.mr_n73643776)
print v(xbgr.mr_n73644208)
print v(xbgr.mr_n73644640)
print v(xbgr.mr_n73645072)
print v(xbgr.mr_n73645504)
print v(xbgr.mr_n73645936)
print v(xbgr.mr_n73646368)
print v(xbgr.mr_n73646800)
print v(xbgr.mr_n73647232)
print v(xbgr.mr_n73647664)
print v(xbgr.mr_n73648096)
print v(xbgr.mr_n73648528)
print v(xbgr.mr_n73648960)
print v(xbgr.mr_n73649392)
print v(xbgr.mr_n73649824)
print v(xbgr.mr_n73650256)
print v(xbgr.mr_n73650688)
print v(xbgr.mr_n73651120)
print v(xbgr.mr_n73651552)
print v(xbgr.mr_n73651984)
print v(xbgr.mr_n73652416)
print v(xbgr.mr_n73652848)
print v(xbgr.mr_n73653280)
print v(xbgr.mr_n73653600)
print v(xbgr.mr_n73653712)
print v(xbgr.mr_n73654032)
print v(xbgr.mr_n73654144)
print v(xbgr.mr_n73654464)
print v(xbgr.mr_n73654576)
print v(xbgr.mr_n73654896)
print v(xbgr.mr_n73655008)
print v(xbgr.mr_n73655328)
print v(xbgr.mr_n73655440)
print v(xbgr.mr_n73655760)
print v(xbgr.mr_n73655872)
print v(xbgr.mr_n73656192)
print v(xbgr.mr_n73656304)
print v(xbgr.mr_n73656624)
print v(xbgr.mr_n73656736)
print v(xbgr.mr_n73657056)
print v(xbgr.mr_n73657168)
print v(xbgr.mr_n73657488)
print v(xbgr.mr_n73657600)
print v(xbgr.mr_n73657920)
print v(xbgr.mr_n73658032)
print v(xbgr.mr_n73658352)
print v(xbgr.mr_n73658464)
print v(xbgr.mr_n73658784)
print v(xbgr.mr_n73659216)
print v(xbgr.mr_n73659328)
print v(xbgr.mr_n73659648)
print v(xbgr.mr_n73659760)
print v(xbgr.mr_n73660080)
print v(xbgr.mr_n73660192)
print v(xbgr.mr_n73660512)
print v(xbgr.mr_n73660624)
print v(xbgr.mr_n73660944)
print v(xbgr.mr_n73661056)
print v(xbgr.mr_n73661376)
print v(xbgr.mr_n73661488)
print v(xbgr.mr_n73661808)
print v(xbgr.mr_n73661920)
print v(xbgr.mr_n73662240)
print v(xbgr.mr_n73662352)
print v(xbgr.mr_n73662672)
print v(xbgr.mr_n73662784)
print v(xbgr.mr_n73663104)
print v(xbgr.mr_n73663216)
print v(xbgr.mr_n73663536)
print v(xbgr.mr_n73663648)
print v(xbgr.mr_n73664080)
print v(xbgr.mr_n73664512)
print v(xbgr.mr_n73664944)
print v(xbgr.mr_n73665376)
print v(xbgr.mr_n73665808)
print v(xbgr.mr_n73666240)
print v(xbgr.mr_n73666672)
print v(xbgr.mr_n73667104)
print v(xbgr.mr_n73667536)
print v(xbgr.mr_n73667968)
print v(xbgr.mr_n73668400)
print v(xbgr.mr_n73668832)
print v(xbgr.mr_n73669264)
print v(xbgr.mr_n73669696)
print v(xbgr.mr_n73670128)
print v(xbgr.mr_n73670560)
print v(xbgr.mr_n73670992)
print v(xbgr.mr_n73671424)
print v(xbgr.mr_n73671856)
print v(xbgr.mr_n73672288)
print v(xbgr.mr_n73672720)
print v(xbgr.mr_n73673152)
print v(xbgr.mr_n73673584)
print v(xbgr.mr_n73674016)
print v(xbgr.mr_n73674448)
print v(xbgr.mr_n73674880)
print v(xbgr.mr_n73675312)
print v(xbgr.mr_n73675744)
print v(xbgr.mr_n73676176)
print v(xbgr.mr_n73676608)
print v(xbgr.mr_n73677040)
print v(xbgr.mr_n73677472)
print v(xbgr.mr_n73677904)
print v(xbgr.mr_n73678336)
print v(xbgr.mr_n73678768)
print v(xbgr.mr_n73679200)
print v(xbgr.mr_n73679632)
print v(xbgr.mr_n73680064)
print v(xbgr.mr_n73680496)
print v(xbgr.mr_n73680928)
print v(xbgr.mr_n73681360)
print v(xbgr.mr_n73681792)
print v(xbgr.mr_n73682224)
print v(xbgr.mr_n73682656)
print v(xbgr.mr_n73683088)
print v(xbgr.mr_n73683520)
print v(xbgr.mr_n73683952)
print v(xbgr.mr_n73684384)
print v(xbgr.mr_n73684816)
print v(xbgr.mr_n73685248)
print v(xbgr.mr_n73685680)
print v(xbgr.mr_n73686112)
print v(xbgr.mr_n73686544)
print v(xbgr.mr_n73686976)
print v(xbgr.mr_n73687408)
print v(xbgr.mr_n73687840)
print v(xbgr.mr_n73688272)
print v(xbgr.mr_n73688704)
print v(xbgr.mr_n73689136)
print v(xbgr.mr_n73689568)
print v(xbgr.mr_n73690000)
print v(xbgr.mr_n73690432)
print v(xbgr.mr_n73690864)
print v(xbgr.mr_n73691296)
print v(xbgr.mr_n73691728)
print v(xbgr.mr_n73692160)
print v(xbgr.mr_n73692592)
print v(xbgr.mr_n73693024)
print v(xbgr.mr_n73693456)
print v(xbgr.mr_n73693888)
print v(xbgr.mr_n73694320)
print v(xbgr.mr_n73694752)
print v(xbgr.mr_n73695184)
print v(xbgr.mr_n73695616)
print v(xbgr.mr_n73696048)
print v(xbgr.mr_n73696480)
print v(xbgr.mr_n73696912)
print v(xbgr.mr_n73697344)
print v(xbgr.mr_n73697776)
print v(xbgr.mr_n73698208)
print v(xbgr.mr_n73698640)
print v(xbgr.mr_n73699072)
print v(xbgr.mr_n73699504)
print v(xbgr.mr_n73699936)
print v(xbgr.mr_n73700368)
print v(xbgr.mr_n73700800)
print v(xbgr.mr_n73701120)
print v(xbgr.mr_n73701232)
print v(xbgr.mr_n73701552)
print v(xbgr.mr_n73701664)
print v(xbgr.mr_n73701984)
print v(xbgr.mr_n73702096)
print v(xbgr.mr_n73702416)
print v(xbgr.mr_n73702528)
print v(xbgr.mr_n73702848)
print v(xbgr.mr_n73702960)
print v(xbgr.mr_n73703280)
print v(xbgr.mr_n73703392)
print v(xbgr.mr_n73703712)
print v(xbgr.mr_n73703824)
print v(xbgr.mr_n73704144)
print v(xbgr.mr_n73704256)
print v(xbgr.mr_n73704576)
print v(xbgr.mr_n73704688)
print v(xbgr.mr_n73705008)
print v(xbgr.mr_n73705120)
print v(xbgr.mr_n73705440)
print v(xbgr.mr_n73705552)
print v(xbgr.mr_n73705872)
print v(xbgr.mr_n73705984)
print v(xbgr.mr_n73706304)
print v(xbgr.mr_n73706416)
print v(xbgr.mr_n73706736)
print v(xbgr.mr_n73706848)
print v(xbgr.mr_n73707168)
print v(xbgr.mr_n73707280)
print v(xbgr.mr_n73707600)
print v(xbgr.mr_n73707712)
print v(xbgr.mr_n73708032)
print v(xbgr.mr_n73708144)
print v(xbgr.mr_n73708464)
print v(xbgr.mr_n73708576)
print v(xbgr.mr_n73708896)
print v(xbgr.mr_n73709440)
print v(xbgr.mr_n73709760)
print v(xbgr.mr_n73710192)
print v(xbgr.mr_n73710304)
print v(xbgr.mr_n73710624)
print v(xbgr.mr_n73710736)
print v(xbgr.mr_n73711168)
print v(xbgr.mr_n73711488)
print v(xbgr.mr_n73712352)
print v(xbgr.mr_n73712464)
print v(xbgr.mr_n73712896)
print v(xbgr.mr_n73713216)
print v(xbgr.mr_n73714080)
print v(xbgr.mr_n73714192)
print v(xbgr.mr_n73714624)
print v(xbgr.mr_n73714944)
print v(xbgr.mr_n73715056)
print v(xbgr.mr_n73715488)
print v(xbgr.mr_n73715920)
print v(xbgr.mr_n73716240)
print v(xbgr.mr_n73717104)
print v(xbgr.mr_n73718080)
print v(xbgr.mr_n73718400)
print v(xbgr.mr_n73718512)
print v(xbgr.mr_n73718944)
print v(xbgr.mr_n73719264)
print v(xbgr.mr_n73719376)
print v(xbgr.mr_n73719808)
print v(xbgr.mr_n73720128)
print v(xbgr.mr_n73720240)
print v(xbgr.mr_n73720560)
print v(xbgr.mr_n73720672)
print v(xbgr.mr_n73720992)
print v(xbgr.mr_n73721104)
print v(xbgr.mr_n73721424)
print v(xbgr.mr_n73721536)
print v(xbgr.mr_n73721856)
print v(xbgr.mr_n73721968)
print v(xbgr.mr_n73722288)
print v(xbgr.mr_n73722400)
print v(xbgr.mr_n73722720)
print v(xbgr.mr_n73722832)
print v(xbgr.mr_n73723152)
print v(xbgr.mr_n73723264)
print v(xbgr.mr_n73723584)
print v(xbgr.mr_n73723696)
print v(xbgr.mr_n73724016)
print v(xbgr.mr_n73724128)
print v(xbgr.mr_n73724448)
print v(xbgr.mr_n73724560)
print v(xbgr.mr_n73724880)
print v(xbgr.mr_n73724992)
print v(xbgr.mr_n73725312)
print v(xbgr.mr_n73726176)
print v(xbgr.mr_n73727040)
print v(xbgr.mr_n73727472)
print v(xbgr.mr_n73727904)
print v(xbgr.mr_n73728336)
print v(xbgr.mr_n73728768)
print v(xbgr.mr_n73729200)
print v(xbgr.mr_n73729632)
print v(xbgr.mr_n73730064)
print v(xbgr.mr_n73730496)
print v(xbgr.mr_n73730928)
print v(xbgr.mr_n73731360)
print v(xbgr.mr_n73731792)
print v(xbgr.mr_n73732224)
print v(xbgr.mr_n73732336)
print v(xbgr.mr_n73732656)
print v(xbgr.mr_n73732768)
print v(xbgr.mr_n73733088)
print v(xbgr.mr_n73733200)
print v(xbgr.mr_n73733520)
print v(xbgr.mr_n73733632)
print v(xbgr.mr_n73733952)
print v(xbgr.mr_n73734064)
print v(xbgr.mr_n73734384)
print v(xbgr.mr_n73734496)
print v(xbgr.mr_n73734816)
print v(xbgr.mr_n73734928)
print v(xbgr.mr_n73735248)
print v(xbgr.mr_n73735360)
print v(xbgr.mr_n73735680)
print v(xbgr.mr_n73735792)
print v(xbgr.mr_n73736112)
print v(xbgr.mr_n73736224)
print v(xbgr.mr_n73736544)
print v(xbgr.mr_n73736656)
print v(xbgr.mr_n73736976)
print v(xbgr.mr_n73737088)
print v(xbgr.mr_n73737408)
print v(xbgr.mr_n73737840)
print v(xbgr.mr_n73737952)
print v(xbgr.mr_n73738272)
print v(xbgr.mr_n73738384)
print v(xbgr.mr_n73738704)
print v(xbgr.mr_n73738816)
print v(xbgr.mr_n73739136)
print v(xbgr.mr_n73739248)
print v(xbgr.mr_n73739568)
print v(xbgr.mr_n73739680)
print v(xbgr.mr_n73740000)
print v(xbgr.mr_n73740112)
print v(xbgr.mr_n73740432)
print v(xbgr.mr_n73740544)
print v(xbgr.mr_n73740864)
print v(xbgr.mr_n73740976)
print v(xbgr.mr_n73741296)
print v(xbgr.mr_n73741408)
print v(xbgr.mr_n73741728)
print v(xbgr.mr_n73741840)
print v(xbgr.mr_n73742160)
print v(xbgr.mr_n73742272)
print v(xbgr.mr_n73742592)
print v(xbgr.mr_n73742704)
print v(xbgr.mr_n73743024)
print v(xbgr.mr_n73743136)
print v(xbgr.mr_n73743456)
print v(xbgr.mr_n73743568)
print v(xbgr.mr_n73743888)
print v(xbgr.mr_n73744000)
print v(xbgr.mr_n73744320)
print v(xbgr.mr_n73744432)
print v(xbgr.mr_n73744752)
print v(xbgr.mr_n73744864)
print v(xbgr.mr_n73745184)
print v(xbgr.mr_n73745296)
print v(xbgr.mr_n73745616)
print v(xbgr.mr_n73745728)
print v(xbgr.mr_n73746048)
print v(xbgr.mr_n73746160)
print v(xbgr.mr_n73746480)
print v(xbgr.mr_n73746592)
print v(xbgr.mr_n73746912)
print v(xbgr.mr_n73747024)
print v(xbgr.mr_n73747344)
print v(xbgr.mr_n73747456)
print v(xbgr.mr_n73747776)
print v(xbgr.mr_n73747888)
print v(xbgr.mr_n73748208)
print v(xbgr.mr_n73748320)
print v(xbgr.mr_n73748640)
print v(xbgr.mr_n73748752)
print v(xbgr.mr_n73749072)
print v(xbgr.mr_n73749184)
print v(xbgr.mr_n73749504)
print v(xbgr.mr_n73749616)
print v(xbgr.mr_n73749936)
print v(xbgr.mr_n73750048)
print v(xbgr.mr_n73750368)
print v(xbgr.mr_n73750480)
print v(xbgr.mr_n73750800)
print v(xbgr.mr_n73750912)
print v(xbgr.mr_n73751232)
print v(xbgr.mr_n73751344)
print v(xbgr.mr_n73751664)
print v(xbgr.mr_n73751776)
print v(xbgr.mr_n73752096)
print v(xbgr.mr_n73752208)
print v(xbgr.mr_n73752528)
print v(xbgr.mr_n73752640)
print v(xbgr.mr_n73752960)
print v(xbgr.mr_n73753072)
print v(xbgr.mr_n73753392)
print v(xbgr.mr_n73753504)
print v(xbgr.mr_n73753824)
print v(xbgr.mr_n73753936)
print v(xbgr.mr_n73754256)
print v(xbgr.mr_n73754368)
print v(xbgr.mr_n73754688)
print v(xbgr.mr_n73754800)
print v(xbgr.mr_n73755120)
print v(xbgr.mr_n73755232)
print v(xbgr.mr_n73755552)
print v(xbgr.mr_n73755664)
print v(xbgr.mr_n73755984)
print v(xbgr.mr_n73756096)
print v(xbgr.mr_n73756416)
print v(xbgr.mr_n73756528)
print v(xbgr.mr_n73756848)
print v(xbgr.mr_n73756960)
print v(xbgr.mr_n73757280)
print v(xbgr.mr_n73757392)
print v(xbgr.mr_n73757712)
print v(xbgr.mr_n73757824)
print v(xbgr.mr_n73758144)
print v(xbgr.mr_n73758256)
print v(xbgr.mr_n73758576)
print v(xbgr.mr_n73758688)
print v(xbgr.mr_n73759008)
print v(xbgr.mr_n73759120)
print v(xbgr.mr_n73759440)
print v(xbgr.mr_n73759552)
print v(xbgr.mr_n73759872)
print v(xbgr.mr_n73759984)
print v(xbgr.mr_n73760304)
print v(xbgr.mr_n73760416)
print v(xbgr.mr_n73760736)
print v(xbgr.mr_n73760848)
print v(xbgr.mr_n73761168)
print v(xbgr.mr_n73761280)
print v(xbgr.mr_n73761600)
print v(xbgr.mr_n73761712)
print v(xbgr.mr_n73762032)
print v(xbgr.mr_n73762144)
print v(xbgr.mr_n73762464)
print v(xbgr.mr_n73762576)
print v(xbgr.mr_n73762896)
print v(xbgr.mr_n73763008)
print v(xbgr.mr_n73763328)
print v(xbgr.mr_n73763440)
print v(xbgr.mr_n73763760)
print v(xbgr.mr_n73763872)
print v(xbgr.mr_n73764192)
print v(xbgr.mr_n73764304)
print v(xbgr.mr_n73764624)
print v(xbgr.mr_n73764736)
print v(xbgr.mr_n73765056)
print v(xbgr.mr_n73765168)
print v(xbgr.mr_n73765488)
print v(xbgr.mr_n73765600)
print v(xbgr.mr_n73765920)
print v(xbgr.mr_n73766032)
print v(xbgr.mr_n73766352)
print v(xbgr.mr_n73766464)
print v(xbgr.mr_n73766784)
print v(xbgr.mr_n73766896)
print v(xbgr.mr_n73767216)
print v(xbgr.mr_n73767328)
print v(xbgr.mr_n73767648)
print v(xbgr.mr_n73767760)
print v(xbgr.mr_n73768080)
print v(xbgr.mr_n73768192)
print v(xbgr.mr_n73768512)
print v(xbgr.mr_n73768624)
print v(xbgr.mr_n73768944)
print v(xbgr.mr_n73769056)
print v(xbgr.mr_n73769376)
print v(xbgr.mr_n73769808)
print v(xbgr.mr_n73769920)
print v(xbgr.mr_n73770240)
print v(xbgr.mr_n73770352)
print v(xbgr.mr_n73770672)
print v(xbgr.mr_n73770784)
print v(xbgr.mr_n73771104)
print v(xbgr.mr_n73771216)
print v(xbgr.mr_n73771536)
print v(xbgr.mr_n73771648)
print v(xbgr.mr_n73771968)
print v(xbgr.mr_n73772080)
print v(xbgr.mr_n73772400)
print v(xbgr.mr_n73772512)
print v(xbgr.mr_n73772832)
print v(xbgr.mr_n73772944)
print v(xbgr.mr_n73773264)
print v(xbgr.mr_n73773376)
print v(xbgr.mr_n73773696)
print v(xbgr.mr_n73773808)
print v(xbgr.mr_n73774128)
print v(xbgr.mr_n73774240)
print v(xbgr.mr_n73774560)
print v(xbgr.mr_n73774672)
print v(xbgr.mr_n73774992)
print v(xbgr.mr_n73775104)
print v(xbgr.mr_n73775424)
print v(xbgr.mr_n73775536)
print v(xbgr.mr_n73775856)
print v(xbgr.mr_n73775968)
print v(xbgr.mr_n73776288)
print v(xbgr.mr_n73776400)
print v(xbgr.mr_n73776720)
print v(xbgr.mr_n73776832)
print v(xbgr.mr_n73777152)
print v(xbgr.mr_n73777264)
print v(xbgr.mr_n73777584)
print v(xbgr.mr_n73778128)
print v(xbgr.mr_n73778448)
print v(xbgr.mr_n73778560)
print v(xbgr.mr_n73778880)
print v(xbgr.mr_n73778992)
print v(xbgr.mr_n73779424)
print v(xbgr.mr_n73779856)
print v(xbgr.mr_n73780288)
print v(xbgr.mr_n73780720)
print v(xbgr.mr_n73781152)
print v(xbgr.mr_n73781584)
print v(xbgr.mr_n73782016)
print v(xbgr.mr_n73782448)
print v(xbgr.mr_n73782880)
print v(xbgr.mr_n73783312)
print v(xbgr.mr_n73783744)
print v(xbgr.mr_n73784176)
print v(xbgr.mr_n73784608)
print v(xbgr.mr_n73785040)
print v(xbgr.mr_n73785472)
print v(xbgr.mr_n73785904)
print v(xbgr.mr_n73786336)
print v(xbgr.mr_n73786768)
print v(xbgr.mr_n73787200)
print v(xbgr.mr_n73787632)
print v(xbgr.mr_n73788064)
print v(xbgr.mr_n73788496)
print v(xbgr.mr_n73788928)
print v(xbgr.mr_n73789360)
print v(xbgr.mr_n73789792)
print v(xbgr.mr_n73790224)
print v(xbgr.mr_n73790656)
print v(xbgr.mr_n73791088)
print v(xbgr.mr_n73791520)
print v(xbgr.mr_n73791952)
print v(xbgr.mr_n73792384)
print v(xbgr.mr_n73792816)
print v(xbgr.mr_n73793248)
print v(xbgr.mr_n73793680)
print v(xbgr.mr_n73794112)
print v(xbgr.mr_n73794544)
print v(xbgr.mr_n73794976)
print v(xbgr.mr_n73795408)
print v(xbgr.mr_n73795840)
print v(xbgr.mr_n73796272)
print v(xbgr.mr_n73796704)
print v(xbgr.mr_n73797136)
print v(xbgr.mr_n73797568)
print v(xbgr.mr_n73798000)
print v(xbgr.mr_n73798432)
print v(xbgr.mr_n73798864)
print v(xbgr.mr_n73799296)
print v(xbgr.mr_n73799728)
print v(xbgr.mr_n73800160)
print v(xbgr.mr_n73800592)
print v(xbgr.mr_n73801024)
print v(xbgr.mr_n73801456)
print v(xbgr.mr_n73801888)
print v(xbgr.mr_n73802320)
print v(xbgr.mr_n73802752)
print v(xbgr.mr_n73803184)
print v(xbgr.mr_n73803616)
print v(xbgr.mr_n73804048)
print v(xbgr.mr_n73804480)
print v(xbgr.mr_n73804912)
print v(xbgr.mr_n73805344)
print v(xbgr.mr_n73805776)
print v(xbgr.mr_n73806208)
print v(xbgr.mr_n73806640)
print v(xbgr.mr_n73807072)
print v(xbgr.mr_n73807504)
print v(xbgr.mr_n73807936)
print v(xbgr.mr_n73808368)
print v(xbgr.mr_n73808800)
print v(xbgr.mr_n73809232)
print v(xbgr.mr_n73809664)
print v(xbgr.mr_n73810096)
print v(xbgr.mr_n73810528)
print v(xbgr.mr_n73810960)
print v(xbgr.mr_n73811392)
print v(xbgr.mr_n73811824)
print v(xbgr.mr_n73812256)
print v(xbgr.mr_n73812688)
print v(xbgr.mr_n73813120)
print v(xbgr.mr_n73813552)
print v(xbgr.mr_n73813984)
print v(xbgr.mr_n73814416)
print v(xbgr.mr_n73814848)
print v(xbgr.mr_n73815280)
print v(xbgr.mr_n73815712)
print v(xbgr.mr_n73816144)
print v(xbgr.mr_n73816576)
print v(xbgr.mr_n73817008)
print v(xbgr.mr_n73817440)
print v(xbgr.mr_n73817872)
print v(xbgr.mr_n73818304)
print v(xbgr.mr_n73818736)
print v(xbgr.mr_n73819168)
print v(xbgr.mr_n73819600)
print v(xbgr.mr_n73820032)
print v(xbgr.mr_n73820464)
print v(xbgr.mr_n73820896)
print v(xbgr.mr_n73821328)
print v(xbgr.mr_n73821760)
print v(xbgr.mr_n73822192)
print v(xbgr.mr_n73822624)
print v(xbgr.mr_n73823056)
print v(xbgr.mr_n73823488)
print v(xbgr.mr_n73823920)
print v(xbgr.mr_n73824352)
print v(xbgr.mr_n73824672)
print v(xbgr.mr_n73824784)
print v(xbgr.mr_n73825104)
print v(xbgr.mr_n73825216)
print v(xbgr.mr_n73825536)
print v(xbgr.mr_n73825648)
print v(xbgr.mr_n73825968)
print v(xbgr.mr_n73826080)
print v(xbgr.mr_n73826400)
print v(xbgr.mr_n73826512)
print v(xbgr.mr_n73826832)
print v(xbgr.mr_n73826944)
print v(xbgr.mr_n73827264)
print v(xbgr.mr_n73827376)
print v(xbgr.mr_n73827696)
print v(xbgr.mr_n73827808)
print v(xbgr.mr_n73828128)
print v(xbgr.mr_n73828240)
print v(xbgr.mr_n73828560)
print v(xbgr.mr_n73828672)
print v(xbgr.mr_n73828992)
print v(xbgr.mr_n73829104)
print v(xbgr.mr_n73829424)
print v(xbgr.mr_n73829536)
print v(xbgr.mr_n73829856)
print v(xbgr.mr_n73829968)
print v(xbgr.mr_n73830288)
print v(xbgr.mr_n73830400)
print v(xbgr.mr_n73830720)
print v(xbgr.mr_n73830832)
print v(xbgr.mr_n73831152)
print v(xbgr.mr_n73831264)
print v(xbgr.mr_n73831584)
print v(xbgr.mr_n73831696)
print v(xbgr.mr_n73832016)
print v(xbgr.mr_n73832128)
print v(xbgr.mr_n73832448)
print v(xbgr.mr_n73832560)
print v(xbgr.mr_n73832880)
print v(xbgr.mr_n73832992)
print v(xbgr.mr_n73833312)
print v(xbgr.mr_n73833424)
print v(xbgr.mr_n73833744)
print v(xbgr.mr_n73833856)
print v(xbgr.mr_n73834176)
print v(xbgr.mr_n73834288)
print v(xbgr.mr_n73834608)
print v(xbgr.mr_n73834720)
print v(xbgr.mr_n73835040)
print v(xbgr.mr_n73835152)
print v(xbgr.mr_n73835472)
print v(xbgr.mr_n73835584)
print v(xbgr.mr_n73835904)
print v(xbgr.mr_n73836016)
print v(xbgr.mr_n73836336)
print v(xbgr.mr_n73836448)
print v(xbgr.mr_n73836768)
print v(xbgr.mr_n73836880)
print v(xbgr.mr_n73837200)
print v(xbgr.mr_n73837312)
print v(xbgr.mr_n73837632)
print v(xbgr.mr_n73837744)
print v(xbgr.mr_n73838064)
print v(xbgr.mr_n73838176)
print v(xbgr.mr_n73838496)
print v(xbgr.mr_n73838608)
print v(xbgr.mr_n73838928)
print v(xbgr.mr_n73839040)
print v(xbgr.mr_n73839360)
print v(xbgr.mr_n73839472)
print v(xbgr.mr_n73839792)
print v(xbgr.mr_n73839904)
print v(xbgr.mr_n73840224)
print v(xbgr.mr_n73840336)
print v(xbgr.mr_n73840656)
print v(xbgr.mr_n73840768)
print v(xbgr.mr_n73841088)
print v(xbgr.mr_n73841200)
print v(xbgr.mr_n73841520)
print v(xbgr.mr_n73841632)
print v(xbgr.mr_n73841952)
print v(xbgr.mr_n73842064)
print v(xbgr.mr_n73842384)
print v(xbgr.mr_n73842496)
print v(xbgr.mr_n73842816)
print v(xbgr.mr_n73843248)
print v(xbgr.mr_n73843360)
print v(xbgr.mr_n73843680)
print v(xbgr.mr_n73843792)
print v(xbgr.mr_n73844112)
print v(xbgr.mr_n73844224)
print v(xbgr.mr_n73844544)
print v(xbgr.mr_n73844656)
print v(xbgr.mr_n73844976)
print v(xbgr.mr_n73845088)
print v(xbgr.mr_n73845408)
print v(xbgr.mr_n73845520)
print v(xbgr.mr_n73845840)
print v(xbgr.mr_n73845952)
print v(xbgr.mr_n73846272)
print v(xbgr.mr_n73846384)
print v(xbgr.mr_n73846704)
print v(xbgr.mr_n73846816)
print v(xbgr.mr_n73847136)
print v(xbgr.mr_n73847248)
print v(xbgr.mr_n73847568)
print v(xbgr.mr_n73847680)
print v(xbgr.mr_n73848000)
print v(xbgr.mr_n73848112)
print v(xbgr.mr_n73848432)
print v(xbgr.mr_n73848544)
print v(xbgr.mr_n73848864)
print v(xbgr.mr_n73848976)
print v(xbgr.mr_n73849296)
print v(xbgr.mr_n73849408)
print v(xbgr.mr_n73849728)
print v(xbgr.mr_n73849840)
print v(xbgr.mr_n73850160)
print v(xbgr.mr_n73850272)
print v(xbgr.mr_n73850592)
print v(xbgr.mr_n73850704)
print v(xbgr.mr_n73851024)
print v(xbgr.mr_n73851136)
print v(xbgr.mr_n73851456)
print v(xbgr.mr_n73851568)
print v(xbgr.mr_n73851888)
print v(xbgr.mr_n73852000)
print v(xbgr.mr_n73852320)
print v(xbgr.mr_n73852432)
print v(xbgr.mr_n73852752)
print v(xbgr.mr_n73852864)
print v(xbgr.mr_n73853184)
print v(xbgr.mr_n73853296)
print v(xbgr.mr_n73853616)
print v(xbgr.mr_n73853728)
print v(xbgr.mr_n73854048)
print v(xbgr.mr_n73854160)
print v(xbgr.mr_n73854480)
print v(xbgr.mr_n73854592)
print v(xbgr.mr_n73854912)
print v(xbgr.mr_n73855024)
print v(xbgr.mr_n73855344)
print v(xbgr.mr_n73855456)
print v(xbgr.mr_n73855776)
print v(xbgr.mr_n73855888)
print v(xbgr.mr_n73856208)
print v(xbgr.mr_n73856320)
print v(xbgr.mr_n73856640)
print v(xbgr.mr_n73856752)
print v(xbgr.mr_n73857072)
print v(xbgr.mr_n73857184)
print v(xbgr.mr_n73857504)
print v(xbgr.mr_n73857616)
print v(xbgr.mr_n73857936)
print v(xbgr.mr_n73858048)
print v(xbgr.mr_n73858368)
print v(xbgr.mr_n73858480)
print v(xbgr.mr_n73858800)
print v(xbgr.mr_n73858912)
print v(xbgr.mr_n73859232)
print v(xbgr.mr_n73859344)
print v(xbgr.mr_n73859664)
print v(xbgr.mr_n73859776)
print v(xbgr.mr_n73860096)
print v(xbgr.mr_n73860208)
print v(xbgr.mr_n73860528)
print v(xbgr.mr_n73860640)
print v(xbgr.mr_n73860960)
print v(xbgr.mr_n73861072)
print v(xbgr.mr_n73861392)
print v(xbgr.mr_n73861504)
print v(xbgr.mr_n73861824)
print v(xbgr.mr_n73861936)
print v(xbgr.mr_n73862256)
print v(xbgr.mr_n73862368)
print v(xbgr.mr_n73862688)
print v(xbgr.mr_n73862800)
print v(xbgr.mr_n73863120)
print v(xbgr.mr_n73863232)
print v(xbgr.mr_n73863552)
print v(xbgr.mr_n73863664)
print v(xbgr.mr_n73863984)
print v(xbgr.mr_n73864096)
print v(xbgr.mr_n73864416)
print v(xbgr.mr_n73864528)
print v(xbgr.mr_n73864848)
print v(xbgr.mr_n73864960)
print v(xbgr.mr_n73865280)
print v(xbgr.mr_n73865392)
print v(xbgr.mr_n73865712)
print v(xbgr.mr_n73865824)
print v(xbgr.mr_n73866144)
print v(xbgr.mr_n73866256)
print v(xbgr.mr_n73866576)
print v(xbgr.mr_n73866688)
print v(xbgr.mr_n73867008)
print v(xbgr.mr_n73867120)
print v(xbgr.mr_n73867440)
print v(xbgr.mr_n73867552)
print v(xbgr.mr_n73867872)
print v(xbgr.mr_n73867984)
print v(xbgr.mr_n73868304)
print v(xbgr.mr_n73868416)
print v(xbgr.mr_n73868736)
print v(xbgr.mr_n73868848)
print v(xbgr.mr_n73869168)
print v(xbgr.mr_n73869280)
print v(xbgr.mr_n73869600)
print v(xbgr.mr_n73869712)
print v(xbgr.mr_n73870032)
print v(xbgr.mr_n73870144)
print v(xbgr.mr_n73870464)
print v(xbgr.mr_n73870576)
print v(xbgr.mr_n73870896)
print v(xbgr.mr_n73871008)
print v(xbgr.mr_n73871328)
print v(xbgr.mr_n73871440)
print v(xbgr.mr_n73871760)
print v(xbgr.mr_n73871872)
print v(xbgr.mr_n73872192)
print v(xbgr.mr_n73872304)
print v(xbgr.mr_n73872624)
print v(xbgr.mr_n73872736)
print v(xbgr.mr_n73873056)
print v(xbgr.mr_n73873168)
print v(xbgr.mr_n73873488)
print v(xbgr.mr_n73873600)
print v(xbgr.mr_n73873920)
print v(xbgr.mr_n73874032)
print v(xbgr.mr_n73874352)
print v(xbgr.mr_n73874464)
print v(xbgr.mr_n73874784)
print v(xbgr.mr_n73874896)
print v(xbgr.mr_n73875216)
print v(xbgr.mr_n73875328)
print v(xbgr.mr_n73875648)
print v(xbgr.mr_n73875760)
print v(xbgr.mr_n73876080)
print v(xbgr.mr_n73876192)
print v(xbgr.mr_n73876512)
print v(xbgr.mr_n73876624)
print v(xbgr.mr_n73876944)
print v(xbgr.mr_n73877056)
print v(xbgr.mr_n73877376)
print v(xbgr.mr_n73877488)
print v(xbgr.mr_n73877808)
print v(xbgr.mr_n73877920)
print v(xbgr.mr_n73878240)
print v(xbgr.mr_n73878352)
print v(xbgr.mr_n73878672)
print v(xbgr.mr_n73878784)
print v(xbgr.mr_n73879104)
print v(xbgr.mr_n73879216)
print v(xbgr.mr_n73879536)
print v(xbgr.mr_n73879648)
print v(xbgr.mr_n73879968)
print v(xbgr.mr_n73880080)
print v(xbgr.mr_n73880400)
print v(xbgr.mr_n73880512)
print v(xbgr.mr_n73880832)
print v(xbgr.mr_n73880944)
print v(xbgr.mr_n73881264)
print v(xbgr.mr_n73881376)
print v(xbgr.mr_n73881696)
print v(xbgr.mr_n73881808)
print v(xbgr.mr_n73882128)
print v(xbgr.mr_n73882240)
print v(xbgr.mr_n73882560)
print v(xbgr.mr_n73882672)
print v(xbgr.mr_n73882992)
print v(xbgr.mr_n73883104)
print v(xbgr.mr_n73883424)
print v(xbgr.mr_n73883536)
print v(xbgr.mr_n73883856)
print v(xbgr.mr_n73883968)
print v(xbgr.mr_n73884288)
print v(xbgr.mr_n73884400)
print v(xbgr.mr_n73884720)
print v(xbgr.mr_n73884832)
print v(xbgr.mr_n73885152)
print v(xbgr.mr_n73885264)
print v(xbgr.mr_n73885584)
print v(xbgr.mr_n73885696)
print v(xbgr.mr_n73886016)
print v(xbgr.mr_n73886128)
print v(xbgr.mr_n73886448)
print v(xbgr.mr_n73886560)
print v(xbgr.mr_n73886880)
print v(xbgr.mr_n73886992)
print v(xbgr.mr_n73887312)
print v(xbgr.mr_n73887424)
print v(xbgr.mr_n73887744)
print v(xbgr.mr_n73887856)
print v(xbgr.mr_n73888176)
print v(xbgr.mr_n73888288)
print v(xbgr.mr_n73888608)
print v(xbgr.mr_n73888720)
print v(xbgr.mr_n73889040)
print v(xbgr.mr_n73889152)
print v(xbgr.mr_n73889472)
print v(xbgr.mr_n73889584)
print v(xbgr.mr_n73889904)
print v(xbgr.mr_n73890016)
print v(xbgr.mr_n73890336)
print v(xbgr.mr_n73890448)
print v(xbgr.mr_n73890768)
print v(xbgr.mr_n73890880)
print v(xbgr.mr_n73891200)
print v(xbgr.mr_n73891312)
print v(xbgr.mr_n73891632)
print v(xbgr.mr_n73891744)
print v(xbgr.mr_n73892064)
print v(xbgr.mr_n73892176)
print v(xbgr.mr_n73892496)
print v(xbgr.mr_n73892608)
print v(xbgr.mr_n73892928)
print v(xbgr.mr_n73893360)
print v(xbgr.mr_n73893472)
print v(xbgr.mr_n73893792)
print v(xbgr.mr_n73893904)
print v(xbgr.mr_n73894224)
print v(xbgr.mr_n73894336)
print v(xbgr.mr_n73894656)
print v(xbgr.mr_n73894768)
print v(xbgr.mr_n73895088)
print v(xbgr.mr_n73895200)
print v(xbgr.mr_n73895520)
print v(xbgr.mr_n73895632)
print v(xbgr.mr_n73895952)
print v(xbgr.mr_n73896064)
print v(xbgr.mr_n73896384)
print v(xbgr.mr_n73896496)
print v(xbgr.mr_n73896816)
print v(xbgr.mr_n73896928)
print v(xbgr.mr_n73897248)
print v(xbgr.mr_n73897360)
print v(xbgr.mr_n73897680)
print v(xbgr.mr_n73897792)
print v(xbgr.mr_n73898112)
print v(xbgr.mr_n73898224)
print v(xbgr.mr_n73898544)
print v(xbgr.mr_n73898656)
print v(xbgr.mr_n73898976)
print v(xbgr.mr_n73899088)
print v(xbgr.mr_n73899408)
print v(xbgr.mr_n73899520)
print v(xbgr.mr_n73899840)
print v(xbgr.mr_n73899952)
print v(xbgr.mr_n73900272)
print v(xbgr.mr_n73900384)
print v(xbgr.mr_n73900704)
print v(xbgr.mr_n73900816)
print v(xbgr.mr_n73901136)
print v(xbgr.mr_n73901248)
print v(xbgr.mr_n73901568)
print v(xbgr.mr_n73901680)
print v(xbgr.mr_n73902000)
print v(xbgr.mr_n73902112)
print v(xbgr.mr_n73902432)
print v(xbgr.mr_n73902544)
print v(xbgr.mr_n73902864)
print v(xbgr.mr_n73902976)
print v(xbgr.mr_n73903296)
print v(xbgr.mr_n73903408)
print v(xbgr.mr_n73903728)
print v(xbgr.mr_n73903840)
print v(xbgr.mr_n73904160)
print v(xbgr.mr_n73904272)
print v(xbgr.mr_n73904592)
print v(xbgr.mr_n73904704)
print v(xbgr.mr_n73905024)
print v(xbgr.mr_n73905136)
print v(xbgr.mr_n73905456)
print v(xbgr.mr_n73905568)
print v(xbgr.mr_n73905888)
print v(xbgr.mr_n73906000)
print v(xbgr.mr_n73906320)
print v(xbgr.mr_n73906432)
print v(xbgr.mr_n73906752)
print v(xbgr.mr_n73906864)
print v(xbgr.mr_n73907184)
print v(xbgr.mr_n73907296)
print v(xbgr.mr_n73907616)
print v(xbgr.mr_n73907728)
print v(xbgr.mr_n73908048)
print v(xbgr.mr_n73908160)
print v(xbgr.mr_n73908480)
print v(xbgr.mr_n73908592)
print v(xbgr.mr_n73908912)
print v(xbgr.mr_n73909024)
print v(xbgr.mr_n73909344)
print v(xbgr.mr_n73909456)
print v(xbgr.mr_n73909776)
print v(xbgr.mr_n73909888)
print v(xbgr.mr_n73910208)
print v(xbgr.mr_n73910320)
print v(xbgr.mr_n73910640)
print v(xbgr.mr_n73910752)
print v(xbgr.mr_n73911072)
print v(xbgr.mr_n73911184)
print v(xbgr.mr_n73911504)
print v(xbgr.mr_n73911616)
print v(xbgr.mr_n73911936)
print v(xbgr.mr_n73912048)
print v(xbgr.mr_n73912368)
print v(xbgr.mr_n73912480)
print v(xbgr.mr_n73912800)
print v(xbgr.mr_n73912912)
print v(xbgr.mr_n73913232)
print v(xbgr.mr_n73913344)
print v(xbgr.mr_n73913664)
print v(xbgr.mr_n73914096)
print v(xbgr.mr_n73914208)
print v(xbgr.mr_n73914528)
print v(xbgr.mr_n73914640)
print v(xbgr.mr_n73914960)
print v(xbgr.mr_n73915072)
print v(xbgr.mr_n73915392)
print v(xbgr.mr_n73915504)
print v(xbgr.mr_n73915824)
print v(xbgr.mr_n73915936)
print v(xbgr.mr_n73916256)
print v(xbgr.mr_n73916368)
print v(xbgr.mr_n73916800)
print v(xbgr.mr_n73917232)
print v(xbgr.mr_n73917552)
print v(xbgr.mr_n73917664)
print v(xbgr.mr_n73917984)
print v(xbgr.mr_n73918096)
print v(xbgr.mr_n73918416)
print v(xbgr.mr_n73918528)
print v(xbgr.mr_n73918848)
print v(xbgr.mr_n73918960)
print v(xbgr.mr_n73919280)
print v(xbgr.mr_n73919392)
print v(xbgr.mr_n73919712)
print v(xbgr.mr_n73919824)
print v(xbgr.mr_n73920144)
print v(xbgr.mr_n73920256)
print v(xbgr.mr_n73920576)
print v(xbgr.mr_n73920688)
print v(xbgr.mr_n73921008)
print v(xbgr.mr_n73921120)
print v(xbgr.mr_n73921440)
print v(xbgr.mr_n73921552)
print v(xbgr.mr_n73921872)
print v(xbgr.mr_n73921984)
print v(xbgr.mr_n73922304)
print v(xbgr.mr_n73922416)
print v(xbgr.mr_n73922736)
print v(xbgr.mr_n73922848)
print v(xbgr.mr_n73923168)
print v(xbgr.mr_n73923280)
print v(xbgr.mr_n73923600)
print v(xbgr.mr_n73923712)
print v(xbgr.mr_n73924032)
print v(xbgr.mr_n73924144)
print v(xbgr.mr_n73924464)
print v(xbgr.mr_n73924576)
print v(xbgr.mr_n73924896)
print v(xbgr.mr_n73925008)
print v(xbgr.mr_n73925328)
print v(xbgr.mr_n73925440)
print v(xbgr.mr_n73925760)
print v(xbgr.mr_n73925872)
print v(xbgr.mr_n73926192)
print v(xbgr.mr_n73926304)
print v(xbgr.mr_n73926624)
print v(xbgr.mr_n73926736)
print v(xbgr.mr_n73927056)
print v(xbgr.mr_n73927168)
print v(xbgr.mr_n73927488)
print v(xbgr.mr_n73927600)
print v(xbgr.mr_n73927920)
print v(xbgr.mr_n73928032)
print v(xbgr.mr_n73928352)
print v(xbgr.mr_n73928464)
print v(xbgr.mr_n73928784)
print v(xbgr.mr_n73928896)
print v(xbgr.mr_n73929216)
print v(xbgr.mr_n73929328)
print v(xbgr.mr_n73929648)
print v(xbgr.mr_n73929760)
print v(xbgr.mr_n73930080)
print v(xbgr.mr_n73930192)
print v(xbgr.mr_n73930512)
print v(xbgr.mr_n73930624)
print v(xbgr.mr_n73930944)
print v(xbgr.mr_n73931056)
print v(xbgr.mr_n73931376)
print v(xbgr.mr_n73931488)
print v(xbgr.mr_n73931808)
print v(xbgr.mr_n73931920)
print v(xbgr.mr_n73932240)
print v(xbgr.mr_n73932352)
print v(xbgr.mr_n73932672)
print v(xbgr.mr_n73932784)
print v(xbgr.mr_n73933104)
print v(xbgr.mr_n73933216)
print v(xbgr.mr_n73933536)
print v(xbgr.mr_n73933648)
print v(xbgr.mr_n73933968)
print v(xbgr.mr_n73934080)
print v(xbgr.mr_n73934400)
print v(xbgr.mr_n73934512)
print v(xbgr.mr_n73934832)
print v(xbgr.mr_n73934944)
print v(xbgr.mr_n73935264)
print v(xbgr.mr_n73935376)
print v(xbgr.mr_n73935696)
print v(xbgr.mr_n73935808)
print v(xbgr.mr_n73936128)
print v(xbgr.mr_n73936240)
print v(xbgr.mr_n73936560)
print v(xbgr.mr_n73936672)
print v(xbgr.mr_n73936992)
print v(xbgr.mr_n73937104)
print v(xbgr.mr_n73937424)
print v(xbgr.mr_n73937536)
print v(xbgr.mr_n73937856)
print v(xbgr.mr_n73937968)
print v(xbgr.mr_n73938288)
print v(xbgr.mr_n73938400)
print v(xbgr.mr_n73938720)
print v(xbgr.mr_n73938832)
print v(xbgr.mr_n73939152)
print v(xbgr.mr_n73939264)
print v(xbgr.mr_n73939584)
print v(xbgr.mr_n73939696)
print v(xbgr.mr_n73940016)
print v(xbgr.mr_n73940128)
print v(xbgr.mr_n73940448)
print v(xbgr.mr_n73940560)
print v(xbgr.mr_n73940880)
print v(xbgr.mr_n73940992)
print v(xbgr.mr_n73941312)
print v(xbgr.mr_n73941424)
print v(xbgr.mr_n73941744)
print v(xbgr.mr_n73941856)
print v(xbgr.mr_n73942176)
print v(xbgr.mr_n73942288)
print v(xbgr.mr_n73942608)
print v(xbgr.mr_n73942720)
print v(xbgr.mr_n73943040)
print v(xbgr.mr_n73943152)
print v(xbgr.mr_n73943472)
print v(xbgr.mr_n73943584)
print v(xbgr.mr_n73943904)
print v(xbgr.mr_n73944016)
print v(xbgr.mr_n73944336)
print v(xbgr.mr_n73944448)
print v(xbgr.mr_n73944768)
print v(xbgr.mr_n73944880)
print v(xbgr.mr_n73945200)
print v(xbgr.mr_n73945312)
print v(xbgr.mr_n73945632)
print v(xbgr.mr_n73945744)
print v(xbgr.mr_n73946064)
print v(xbgr.mr_n73946176)
print v(xbgr.mr_n73946496)
print v(xbgr.mr_n73946608)
print v(xbgr.mr_n73946928)
print v(xbgr.mr_n73947040)
print v(xbgr.mr_n73947360)
print v(xbgr.mr_n73947472)
print v(xbgr.mr_n73947792)
print v(xbgr.mr_n73947904)
print v(xbgr.mr_n73948224)
print v(xbgr.mr_n73948336)
print v(xbgr.mr_n73948656)
print v(xbgr.mr_n73948768)
print v(xbgr.mr_n73949088)
print v(xbgr.mr_n73949200)
print v(xbgr.mr_n73949520)
print v(xbgr.mr_n73949632)
print v(xbgr.mr_n73949952)
print v(xbgr.mr_n73950064)
print v(xbgr.mr_n73950384)
print v(xbgr.mr_n73950496)
print v(xbgr.mr_n73950816)
print v(xbgr.mr_n73950928)
print v(xbgr.mr_n73951248)
print v(xbgr.mr_n73951360)
print v(xbgr.mr_n73951680)
print v(xbgr.mr_n73951792)
print v(xbgr.mr_n73952112)
print v(xbgr.mr_n73952224)
print v(xbgr.mr_n73952544)
print v(xbgr.mr_n73952656)
print v(xbgr.mr_n73952976)
print v(xbgr.mr_n73953088)
print v(xbgr.mr_n73953408)
print v(xbgr.mr_n73953520)
print v(xbgr.mr_n73953840)
print v(xbgr.mr_n73953952)
print v(xbgr.mr_n73954272)
print v(xbgr.mr_n73954384)
print v(xbgr.mr_n73954704)
print v(xbgr.mr_n73954816)
print v(xbgr.mr_n73955136)
print v(xbgr.mr_n73955248)
print v(xbgr.mr_n73955568)
print v(xbgr.mr_n73955680)
print v(xbgr.mr_n73956000)
print v(xbgr.mr_n73956112)
print v(xbgr.mr_n73956432)
print v(xbgr.mr_n73956544)
print v(xbgr.mr_n73956864)
print v(xbgr.mr_n73956976)
print v(xbgr.mr_n73957296)
print v(xbgr.mr_n73957408)
print v(xbgr.mr_n73957728)
print v(xbgr.mr_n73957840)
print v(xbgr.mr_n73958160)
print v(xbgr.mr_n73958272)
print v(xbgr.mr_n73958592)
print v(xbgr.mr_n73958704)
print v(xbgr.mr_n73959024)
print v(xbgr.mr_n73959136)
print v(xbgr.mr_n73959456)
print v(xbgr.mr_n73959568)
print v(xbgr.mr_n73959888)
print v(xbgr.mr_n73960000)
print v(xbgr.mr_n73960320)
print v(xbgr.mr_n73960432)
print v(xbgr.mr_n73960752)
print v(xbgr.mr_n73960864)
print v(xbgr.mr_n73961184)
print v(xbgr.mr_n73961296)
print v(xbgr.mr_n73961616)
print v(xbgr.mr_n73961728)
print v(xbgr.mr_n73962048)
print v(xbgr.mr_n73962160)
print v(xbgr.mr_n73962480)
print v(xbgr.mr_n73962592)
print v(xbgr.mr_n73962912)
print v(xbgr.mr_n73963024)
print v(xbgr.mr_n73963344)
print v(xbgr.mr_n73963456)
print v(xbgr.mr_n73963776)
print v(xbgr.mr_n73963888)
print v(xbgr.mr_n73964208)
print v(xbgr.mr_n73964320)
print v(xbgr.mr_n73964640)
print v(xbgr.mr_n73964752)
print v(xbgr.mr_n73965072)
print v(xbgr.mr_n73965184)
print v(xbgr.mr_n73965504)
print v(xbgr.mr_n73965616)
print v(xbgr.mr_n73965936)
print v(xbgr.mr_n73966048)
print v(xbgr.mr_n73966368)
print v(xbgr.mr_n73966480)
print v(xbgr.mr_n73966800)
print v(xbgr.mr_n73966912)
print v(xbgr.mr_n73967232)
print v(xbgr.mr_n73967344)
print v(xbgr.mr_n73967664)
print v(xbgr.mr_n73967776)
print v(xbgr.mr_n73968096)
print v(xbgr.mr_n73968208)
print v(xbgr.mr_n73968528)
print v(xbgr.mr_n73968640)
print v(xbgr.mr_n73968960)
print v(xbgr.mr_n73969072)
print v(xbgr.mr_n73969392)
print v(xbgr.mr_n73969504)
print v(xbgr.mr_n73969824)
print v(xbgr.mr_n73969936)
print v(xbgr.mr_n73970256)
print v(xbgr.mr_n73970368)
print v(xbgr.mr_n73970688)
print v(xbgr.mr_n73970800)
print v(xbgr.mr_n73971120)
print v(xbgr.mr_n73971232)
print v(xbgr.mr_n73971552)
print v(xbgr.mr_n73971664)
print v(xbgr.mr_n73971984)
print v(xbgr.mr_n73972096)
print v(xbgr.mr_n73972416)
print v(xbgr.mr_n73972528)
print v(xbgr.mr_n73972848)
print v(xbgr.mr_n73972960)
print v(xbgr.mr_n73973392)
print v(xbgr.mr_n73973824)
print v(xbgr.mr_n73974256)
print v(xbgr.mr_n73974688)
print v(xbgr.mr_n73975120)
print v(xbgr.mr_n73975552)
print v(xbgr.mr_n73975984)
print v(xbgr.mr_n73976416)
print v(xbgr.mr_n73976848)
print v(xbgr.mr_n73977280)
print v(xbgr.mr_n73977712)
print v(xbgr.mr_n73978144)
print v(xbgr.mr_n73978576)
print v(xbgr.mr_n73979008)
print v(xbgr.mr_n73979440)
print v(xbgr.mr_n73979872)
print v(xbgr.mr_n73980304)
print v(xbgr.mr_n73980736)
print v(xbgr.mr_n73981168)
print v(xbgr.mr_n73981600)
print v(xbgr.mr_n73982032)
print v(xbgr.mr_n73982464)
print v(xbgr.mr_n73982896)
print v(xbgr.mr_n73983328)
print v(xbgr.mr_n73983760)
print v(xbgr.mr_n73984192)
print v(xbgr.mr_n73984624)
print v(xbgr.mr_n73985056)
print v(xbgr.mr_n73985488)
print v(xbgr.mr_n73985920)
print v(xbgr.mr_n73986352)
print v(xbgr.mr_n73986784)
print v(xbgr.mr_n73987216)
print v(xbgr.mr_n73987648)
print v(xbgr.mr_n73988080)
print v(xbgr.mr_n73988512)
print v(xbgr.mr_n73988944)
print v(xbgr.mr_n73989376)
print v(xbgr.mr_n73989808)
print v(xbgr.mr_n73990240)
print v(xbgr.mr_n73990672)
print v(xbgr.mr_n73991104)
print v(xbgr.mr_n73991536)
print v(xbgr.mr_n73991968)
print v(xbgr.mr_n73992400)
print v(xbgr.mr_n73992832)
print v(xbgr.mr_n73993264)
print v(xbgr.mr_n73993696)
print v(xbgr.mr_n73994128)
print v(xbgr.mr_n73994560)
print v(xbgr.mr_n73994992)
print v(xbgr.mr_n73995424)
print v(xbgr.mr_n73995856)
print v(xbgr.mr_n73996288)
print v(xbgr.mr_n73996720)
print v(xbgr.mr_n73997152)
print v(xbgr.mr_n73997584)
print v(xbgr.mr_n73998016)
print v(xbgr.mr_n73998448)
print v(xbgr.mr_n73998880)
print v(xbgr.mr_n73999312)
print v(xbgr.mr_n73999744)
print v(xbgr.mr_n74000176)
print v(xbgr.mr_n74000608)
print v(xbgr.mr_n74001040)
print v(xbgr.mr_n74001472)
print v(xbgr.mr_n74001904)
print v(xbgr.mr_n74002336)
print v(xbgr.mr_n74002768)
print v(xbgr.mr_n74003200)
print v(xbgr.mr_n74003632)
print v(xbgr.mr_n74004064)
print v(xbgr.mr_n74004496)
print v(xbgr.mr_n74004928)
print v(xbgr.mr_n74005360)
print v(xbgr.mr_n74005792)
print v(xbgr.mr_n74006224)
print v(xbgr.mr_n74006656)
print v(xbgr.mr_n74007088)
print v(xbgr.mr_n74007520)
print v(xbgr.mr_n74007952)
print v(xbgr.mr_n74008384)
print v(xbgr.mr_n74008816)
print v(xbgr.mr_n74009248)
print v(xbgr.mr_n74009680)
print v(xbgr.mr_n74010112)
print v(xbgr.mr_n74010544)
print v(xbgr.mr_n74010976)
print v(xbgr.mr_n74011408)
print v(xbgr.mr_n74011840)
print v(xbgr.mr_n74012272)
print v(xbgr.mr_n74012704)
print v(xbgr.mr_n74013136)
print v(xbgr.mr_n74013568)
print v(xbgr.mr_n74014000)
print v(xbgr.mr_n74014432)
print v(xbgr.mr_n74014864)
print v(xbgr.mr_n74015296)
print v(xbgr.mr_n74015616)
print v(xbgr.mr_n74015728)
print v(xbgr.mr_n74016048)
print v(xbgr.mr_n74016160)
print v(xbgr.mr_n74016480)
print v(xbgr.mr_n74016592)
print v(xbgr.mr_n74016912)
print v(xbgr.mr_n74017024)
print v(xbgr.mr_n74017344)
print v(xbgr.mr_n74017456)
print v(xbgr.mr_n74017776)
print v(xbgr.mr_n74017888)
print v(xbgr.mr_n74018208)
print v(xbgr.mr_n74018320)
print v(xbgr.mr_n74018640)
print v(xbgr.mr_n74018752)
print v(xbgr.mr_n74019072)
print v(xbgr.mr_n74019184)
print v(xbgr.mr_n74019504)
print v(xbgr.mr_n74019616)
print v(xbgr.mr_n74019936)
print v(xbgr.mr_n74020048)
print v(xbgr.mr_n74020368)
print v(xbgr.mr_n74020480)
print v(xbgr.mr_n74020800)
print v(xbgr.mr_n74020912)
print v(xbgr.mr_n74021232)
print v(xbgr.mr_n74021344)
print v(xbgr.mr_n74021664)
print v(xbgr.mr_n74021776)
print v(xbgr.mr_n74022096)
print v(xbgr.mr_n74022208)
print v(xbgr.mr_n74022528)
print v(xbgr.mr_n74022640)
print v(xbgr.mr_n74022960)
print v(xbgr.mr_n74023072)
print v(xbgr.mr_n74023392)
print v(xbgr.mr_n74023504)
print v(xbgr.mr_n74023824)
print v(xbgr.mr_n74023936)
print v(xbgr.mr_n74024256)
print v(xbgr.mr_n74024368)
print v(xbgr.mr_n74024688)
print v(xbgr.mr_n74024800)
print v(xbgr.mr_n74025120)
print v(xbgr.mr_n74025232)
print v(xbgr.mr_n74025552)
print v(xbgr.mr_n74025664)
print v(xbgr.mr_n74025984)
print v(xbgr.mr_n74026096)
print v(xbgr.mr_n74026416)
print v(xbgr.mr_n74026528)
print v(xbgr.mr_n74026848)
print v(xbgr.mr_n74026960)
print v(xbgr.mr_n74027280)
print v(xbgr.mr_n74027392)
print v(xbgr.mr_n74027712)
print v(xbgr.mr_n74027824)
print v(xbgr.mr_n74028144)
print v(xbgr.mr_n74028256)
print v(xbgr.mr_n74028576)
print v(xbgr.mr_n74028688)
print v(xbgr.mr_n74029008)
print v(xbgr.mr_n74029120)
print v(xbgr.mr_n74029440)
print v(xbgr.mr_n74029552)
print v(xbgr.mr_n74029872)
print v(xbgr.mr_n74029984)
print v(xbgr.mr_n74030304)
print v(xbgr.mr_n74030416)
print v(xbgr.mr_n74030736)
print v(xbgr.mr_n74030848)
print v(xbgr.mr_n74031168)
print v(xbgr.mr_n74031280)
print v(xbgr.mr_n74031600)
print v(xbgr.mr_n74031712)
print v(xbgr.mr_n74032032)
print v(xbgr.mr_n74032144)
print v(xbgr.mr_n74032464)
print v(xbgr.mr_n74032576)
print v(xbgr.mr_n74032896)
print v(xbgr.mr_n74033008)
print v(xbgr.mr_n74033328)
print v(xbgr.mr_n74033440)
print v(xbgr.mr_n74033760)
print v(xbgr.mr_n74033872)
print v(xbgr.mr_n74034192)
print v(xbgr.mr_n74034304)
print v(xbgr.mr_n74034624)
print v(xbgr.mr_n74034736)
print v(xbgr.mr_n74035056)
print v(xbgr.mr_n74035168)
print v(xbgr.mr_n74035488)
print v(xbgr.mr_n74035600)
print v(xbgr.mr_n74035920)
print v(xbgr.mr_n74036032)
print v(xbgr.mr_n74036352)
print v(xbgr.mr_n74036464)
print v(xbgr.mr_n74036784)
print v(xbgr.mr_n74036896)
print v(xbgr.mr_n74037216)
print v(xbgr.mr_n74037328)
print v(xbgr.mr_n74037648)
print v(xbgr.mr_n74037760)
print v(xbgr.mr_n74038080)
print v(xbgr.mr_n74038192)
print v(xbgr.mr_n74038512)
print v(xbgr.mr_n74038624)
print v(xbgr.mr_n74038944)
print v(xbgr.mr_n74039056)
print v(xbgr.mr_n74039376)
print v(xbgr.mr_n74039488)
print v(xbgr.mr_n74039808)
print v(xbgr.mr_n74039920)
print v(xbgr.mr_n74040240)
print v(xbgr.mr_n74040352)
print v(xbgr.mr_n74040672)
print v(xbgr.mr_n74040784)
print v(xbgr.mr_n74041104)
print v(xbgr.mr_n74041216)
print v(xbgr.mr_n74041536)
print v(xbgr.mr_n74041648)
print v(xbgr.mr_n74041968)
print v(xbgr.mr_n74042080)
print v(xbgr.mr_n74042400)
print v(xbgr.mr_n74042512)
print v(xbgr.mr_n74042832)
print v(xbgr.mr_n74042944)
print v(xbgr.mr_n74043264)
print v(xbgr.mr_n74043376)
print v(xbgr.mr_n74043696)
print v(xbgr.mr_n74043808)
print v(xbgr.mr_n74044128)
print v(xbgr.mr_n74044240)
print v(xbgr.mr_n74044560)
print v(xbgr.mr_n74044672)
print v(xbgr.mr_n74044992)
print v(xbgr.mr_n74045104)
print v(xbgr.mr_n74045424)
print v(xbgr.mr_n74045536)
print v(xbgr.mr_n74045856)
print v(xbgr.mr_n74045968)
print v(xbgr.mr_n74046288)
print v(xbgr.mr_n74046400)
print v(xbgr.mr_n74046720)
print v(xbgr.mr_n74046832)
print v(xbgr.mr_n74047152)
print v(xbgr.mr_n74047264)
print v(xbgr.mr_n74047584)
print v(xbgr.mr_n74047696)
print v(xbgr.mr_n74048016)
print v(xbgr.mr_n74048128)
print v(xbgr.mr_n74048448)
print v(xbgr.mr_n74048560)
print v(xbgr.mr_n74048880)
print v(xbgr.mr_n74048992)
print v(xbgr.mr_n74049312)
print v(xbgr.mr_n74049424)
print v(xbgr.mr_n74049744)
print v(xbgr.mr_n74049856)
print v(xbgr.mr_n74050176)
print v(xbgr.mr_n74050288)
print v(xbgr.mr_n74050608)
print v(xbgr.mr_n74050720)
print v(xbgr.mr_n74051040)
print v(xbgr.mr_n74051152)
print v(xbgr.mr_n74051472)
print v(xbgr.mr_n74051584)
print v(xbgr.mr_n74051904)
print v(xbgr.mr_n74052016)
print v(xbgr.mr_n74052336)
print v(xbgr.mr_n74052448)
print v(xbgr.mr_n74052768)
print v(xbgr.mr_n74052880)
print v(xbgr.mr_n74053200)
print v(xbgr.mr_n74053312)
print v(xbgr.mr_n74053632)
print v(xbgr.mr_n74053744)
print v(xbgr.mr_n74054064)
print v(xbgr.mr_n74054176)
print v(xbgr.mr_n74054496)
print v(xbgr.mr_n74054608)
print v(xbgr.mr_n74054928)
print v(xbgr.mr_n74055040)
print v(xbgr.mr_n74055360)
print v(xbgr.mr_n74055472)
print v(xbgr.mr_n74055792)
print v(xbgr.mr_n74055904)
print v(xbgr.mr_n74056224)
print v(xbgr.mr_n74056336)
print v(xbgr.mr_n74056656)
print v(xbgr.mr_n74056768)
print v(xbgr.mr_n74057088)
print v(xbgr.mr_n74057200)
print v(xbgr.mr_n74057520)
print v(xbgr.mr_n74057632)
print v(xbgr.mr_n74057952)
print v(xbgr.mr_n74058064)
print v(xbgr.mr_n74058384)
print v(xbgr.mr_n74058496)
print v(xbgr.mr_n74058816)
print v(xbgr.mr_n74058928)
print v(xbgr.mr_n74059248)
print v(xbgr.mr_n74059360)
print v(xbgr.mr_n74059680)
print v(xbgr.mr_n74059792)
print v(xbgr.mr_n74060112)
print v(xbgr.mr_n74060224)
print v(xbgr.mr_n74060544)
print v(xbgr.mr_n74060656)
print v(xbgr.mr_n74060976)
print v(xbgr.mr_n74061088)
print v(xbgr.mr_n74061408)
print v(xbgr.mr_n74061520)
print v(xbgr.mr_n74061840)
print v(xbgr.mr_n74061952)
print v(xbgr.mr_n74062272)
print v(xbgr.mr_n74062384)
print v(xbgr.mr_n74062704)
print v(xbgr.mr_n74062816)
print v(xbgr.mr_n74063136)
print v(xbgr.mr_n74063248)
print v(xbgr.mr_n74063568)
print v(xbgr.mr_n74063680)
print v(xbgr.mr_n74064000)
print v(xbgr.mr_n74064112)
print v(xbgr.mr_n74064432)
print v(xbgr.mr_n74064544)
print v(xbgr.mr_n74064864)
print v(xbgr.mr_n74064976)
print v(xbgr.mr_n74065296)
print v(xbgr.mr_n74065408)
print v(xbgr.mr_n74065728)
print v(xbgr.mr_n74065840)
print v(xbgr.mr_n74066160)
print v(xbgr.mr_n74066272)
print v(xbgr.mr_n74066592)
print v(xbgr.mr_n74066704)
print v(xbgr.mr_n74067024)
print v(xbgr.mr_n74067136)
print v(xbgr.mr_n74067456)
print v(xbgr.mr_n74067568)
print v(xbgr.mr_n74067888)
print v(xbgr.mr_n74068000)
print v(xbgr.mr_n74068320)
print v(xbgr.mr_n74068432)
print v(xbgr.mr_n74068752)
print v(xbgr.mr_n74068864)
print v(xbgr.mr_n74069184)
print v(xbgr.mr_n74069296)
print v(xbgr.mr_n74069616)
print v(xbgr.mr_n74069728)
print v(xbgr.mr_n74070048)
print v(xbgr.mr_n74070160)
print v(xbgr.mr_n74070480)
print v(xbgr.mr_n74070592)
print v(xbgr.mr_n74070912)
print v(xbgr.mr_n74071024)
print v(xbgr.mr_n74071344)
print v(xbgr.mr_n74071456)
print v(xbgr.mr_n74071776)
print v(xbgr.mr_n74071888)
print v(xbgr.mr_n74072208)
print v(xbgr.mr_n74072320)
print v(xbgr.mr_n74072640)
print v(xbgr.mr_n74072752)
print v(xbgr.mr_n74073072)
print v(xbgr.mr_n74073184)
print v(xbgr.mr_n74073504)
print v(xbgr.mr_n74073616)
print v(xbgr.mr_n74073936)
print v(xbgr.mr_n74074048)
print v(xbgr.mr_n74074368)
print v(xbgr.mr_n74074480)
print v(xbgr.mr_n74074800)
print v(xbgr.mr_n74074912)
print v(xbgr.mr_n74075232)
print v(xbgr.mr_n74075344)
print v(xbgr.mr_n74075664)
print v(xbgr.mr_n74075776)
print v(xbgr.mr_n74076096)
print v(xbgr.mr_n74076208)
print v(xbgr.mr_n74076528)
print v(xbgr.mr_n74076640)
print v(xbgr.mr_n74076960)
print v(xbgr.mr_n74077072)
print v(xbgr.mr_n74077392)
print v(xbgr.mr_n74077504)
print v(xbgr.mr_n74077824)
print v(xbgr.mr_n74077936)
print v(xbgr.mr_n74078256)
print v(xbgr.mr_n74078368)
print v(xbgr.mr_n74078800)
print v(xbgr.mr_n74079232)
print v(xbgr.mr_n74079664)
print v(xbgr.mr_n74080096)
print v(xbgr.mr_n74080528)
print v(xbgr.mr_n74080960)
print v(xbgr.mr_n74081392)
print v(xbgr.mr_n74081824)
print v(xbgr.mr_n74082256)
print v(xbgr.mr_n74082688)
print v(xbgr.mr_n74083120)
print v(xbgr.mr_n74083552)
print v(xbgr.mr_n74083984)
print v(xbgr.mr_n74084416)
print v(xbgr.mr_n74084848)
print v(xbgr.mr_n74085280)
print v(xbgr.mr_n74085712)
print v(xbgr.mr_n74086144)
print v(xbgr.mr_n74086576)
print v(xbgr.mr_n74087008)
print v(xbgr.mr_n74087440)
print v(xbgr.mr_n74087872)
print v(xbgr.mr_n74088304)
print v(xbgr.mr_n74088736)
print v(xbgr.mr_n74089168)
print v(xbgr.mr_n74089600)
print v(xbgr.mr_n74090032)
print v(xbgr.mr_n74090464)
print v(xbgr.mr_n74090896)
print v(xbgr.mr_n74091328)
print v(xbgr.mr_n74091760)
print v(xbgr.mr_n74092192)
print v(xbgr.mr_n74092624)
print v(xbgr.mr_n74093056)
print v(xbgr.mr_n74093488)
print v(xbgr.mr_n74093920)
print v(xbgr.mr_n74094352)
print v(xbgr.mr_n74094784)
print v(xbgr.mr_n74095216)
print v(xbgr.mr_n74095648)
print v(xbgr.mr_n74096080)
print v(xbgr.mr_n74096512)
print v(xbgr.mr_n74096944)
print v(xbgr.mr_n74097376)
print v(xbgr.mr_n74097808)
print v(xbgr.mr_n74098240)
print v(xbgr.mr_n74098672)
print v(xbgr.mr_n74099104)
print v(xbgr.mr_n74099536)
print v(xbgr.mr_n74099968)
print v(xbgr.mr_n74100400)
print v(xbgr.mr_n74100832)
print v(xbgr.mr_n74101264)
print v(xbgr.mr_n74101696)
print v(xbgr.mr_n74102128)
print v(xbgr.mr_n74102560)
print v(xbgr.mr_n74102992)
print v(xbgr.mr_n74103424)
print v(xbgr.mr_n74103856)
print v(xbgr.mr_n74104288)
print v(xbgr.mr_n74104720)
print v(xbgr.mr_n74105152)
print v(xbgr.mr_n74105584)
print v(xbgr.mr_n74106016)
print v(xbgr.mr_n74106448)
print v(xbgr.mr_n74106880)
print v(xbgr.mr_n74107312)
print v(xbgr.mr_n74107744)
print v(xbgr.mr_n74108176)
print v(xbgr.mr_n74108608)
print v(xbgr.mr_n74109040)
print v(xbgr.mr_n74109472)
print v(xbgr.mr_n74109904)
print v(xbgr.mr_n74110336)
print v(xbgr.mr_n74110768)
print v(xbgr.mr_n74111200)
print v(xbgr.mr_n74111632)
print v(xbgr.mr_n74112064)
print v(xbgr.mr_n74112496)
print v(xbgr.mr_n74112928)
print v(xbgr.mr_n74113360)
print v(xbgr.mr_n74113792)
print v(xbgr.mr_n74114224)
print v(xbgr.mr_n74114656)
print v(xbgr.mr_n74115088)
print v(xbgr.mr_n74115520)
print v(xbgr.mr_n74115952)
print v(xbgr.mr_n74116384)
print v(xbgr.mr_n74116816)
print v(xbgr.mr_n74117248)
print v(xbgr.mr_n74117680)
print v(xbgr.mr_n74118112)
print v(xbgr.mr_n74118544)
print v(xbgr.mr_n74118976)
print v(xbgr.mr_n74119408)
print v(xbgr.mr_n74119840)
print v(xbgr.mr_n74120272)
print v(xbgr.mr_n74120704)
print v(xbgr.mr_n74121136)
print v(xbgr.mr_n74121568)
print v(xbgr.mr_n74122000)
print v(xbgr.mr_n74122432)
print v(xbgr.mr_n74122864)
print v(xbgr.mr_n74123296)
print v(xbgr.mr_n74123728)
print v(xbgr.mr_n74124160)
print v(xbgr.mr_n74124592)
print v(xbgr.mr_n74125024)
print v(xbgr.mr_n74125456)
print v(xbgr.mr_n74125888)
print v(xbgr.mr_n74126320)
print v(xbgr.mr_n74126752)
print v(xbgr.mr_n74127184)
print v(xbgr.mr_n74127616)
print v(xbgr.mr_n74128048)
print v(xbgr.mr_n74128480)
print v(xbgr.mr_n74128912)
print v(xbgr.mr_n74129344)
print v(xbgr.mr_n74129776)
print v(xbgr.mr_n74130208)
print v(xbgr.mr_n74130640)
print v(xbgr.mr_n74131072)
print v(xbgr.mr_n74131504)
print v(xbgr.mr_n74131936)
print v(xbgr.mr_n74132368)
print v(xbgr.mr_n74132800)
print v(xbgr.mr_n74133232)
print v(xbgr.mr_n74133664)
print v(xbgr.mr_n74134096)
print v(xbgr.mr_n74134528)
print v(xbgr.mr_n74134960)
print v(xbgr.mr_n74135392)
print v(xbgr.mr_n74135824)
print v(xbgr.mr_n74136256)
print v(xbgr.mr_n74136688)
print v(xbgr.mr_n74137120)
print v(xbgr.mr_n74137552)
print v(xbgr.mr_n74137984)
print v(xbgr.mr_n74138416)
print v(xbgr.mr_n74138848)
print v(xbgr.mr_n74139280)
print v(xbgr.mr_n74139712)
print v(xbgr.mr_n74140144)
print v(xbgr.mr_n74140576)
print v(xbgr.mr_n74141008)
print v(xbgr.mr_n74141440)
print v(xbgr.mr_n74141872)
print v(xbgr.mr_n74142304)
print v(xbgr.mr_n74142736)
print v(xbgr.mr_n74143168)
print v(xbgr.mr_n74143600)
print v(xbgr.mr_n74144032)
print v(xbgr.mr_n74144464)
print v(xbgr.mr_n74144896)
print v(xbgr.mr_n74145328)
print v(xbgr.mr_n74145760)
print v(xbgr.mr_n74146192)
print v(xbgr.mr_n74146624)
print v(xbgr.mr_n74147056)
print v(xbgr.mr_n74147488)
print v(xbgr.mr_n74147920)
print v(xbgr.mr_n74148352)
print v(xbgr.mr_n74148784)
print v(xbgr.mr_n74149216)
print v(xbgr.mr_n74149648)
print v(xbgr.mr_n74150080)
print v(xbgr.mr_n74150512)
print v(xbgr.mr_n74150944)
print v(xbgr.mr_n74151376)
print v(xbgr.mr_n74151808)
print v(xbgr.mr_n74152240)
print v(xbgr.mr_n74152672)
print v(xbgr.mr_n74153104)
print v(xbgr.mr_n74153536)
print v(xbgr.mr_n74153968)
print v(xbgr.mr_n74154400)
print v(xbgr.mr_n74154832)
print v(xbgr.mr_n74155264)
print v(xbgr.mr_n74155696)
print v(xbgr.mr_n74156128)
print v(xbgr.mr_n74156560)
print v(xbgr.mr_n74156992)
print v(xbgr.mr_n74157424)
print v(xbgr.mr_n74157856)
print v(xbgr.mr_n74158288)
print v(xbgr.mr_n74158720)
print v(xbgr.mr_n74159152)
print v(xbgr.mr_n74159584)
print v(xbgr.mr_n74160016)
print v(xbgr.mr_n74160448)
print v(xbgr.mr_n74160880)
print v(xbgr.mr_n74161312)
print v(xbgr.mr_n74161744)
print v(xbgr.mr_n74162176)
print v(xbgr.mr_n74162608)
print v(xbgr.mr_n74163040)
print v(xbgr.mr_n74163472)
print v(xbgr.mr_n74163904)
print v(xbgr.mr_n74164336)
print v(xbgr.mr_n74164768)
print v(xbgr.mr_n74165200)
print v(xbgr.mr_n74165632)
print v(xbgr.mr_n74166064)
print v(xbgr.mr_n74166496)
print v(xbgr.mr_n74166928)
print v(xbgr.mr_n74167360)
print v(xbgr.mr_n74167792)
print v(xbgr.mr_n74168224)
print v(xbgr.mr_n74168656)
print v(xbgr.mr_n74169088)
print v(xbgr.mr_n74169520)
print v(xbgr.mr_n74169952)
print v(xbgr.mr_n74170384)
print v(xbgr.mr_n74170816)
print v(xbgr.mr_n74171136)
print v(xbgr.mr_n74171248)
print v(xbgr.mr_n74171568)
print v(xbgr.mr_n74171680)
print v(xbgr.mr_n74172000)
print v(xbgr.mr_n74172112)
print v(xbgr.mr_n74172432)
print v(xbgr.mr_n74172544)
print v(xbgr.mr_n74172864)
print v(xbgr.mr_n74172976)
print v(xbgr.mr_n74173296)
print v(xbgr.mr_n74173408)
print v(xbgr.mr_n74173728)
print v(xbgr.mr_n74173840)
print v(xbgr.mr_n74174160)
print v(xbgr.mr_n74174272)
print v(xbgr.mr_n74174592)
print v(xbgr.mr_n74174704)
print v(xbgr.mr_n74175024)
print v(xbgr.mr_n74175136)
print v(xbgr.mr_n74175456)
print v(xbgr.mr_n74175568)
print v(xbgr.mr_n74175888)
print v(xbgr.mr_n74176000)
print v(xbgr.mr_n74176320)
print v(xbgr.mr_n74176432)
print v(xbgr.mr_n74176752)
print v(xbgr.mr_n74176864)
print v(xbgr.mr_n74177184)
print v(xbgr.mr_n74177296)
print v(xbgr.mr_n74177616)
print v(xbgr.mr_n74177728)
print v(xbgr.mr_n74178048)
print v(xbgr.mr_n74178160)
print v(xbgr.mr_n74178480)
print v(xbgr.mr_n74178592)
print v(xbgr.mr_n74178912)
print v(xbgr.mr_n74179024)
print v(xbgr.mr_n74179344)
print v(xbgr.mr_n74179456)
print v(xbgr.mr_n74179776)
print v(xbgr.mr_n74179888)
print v(xbgr.mr_n74180208)
print v(xbgr.mr_n74180320)
print v(xbgr.mr_n74180640)
print v(xbgr.mr_n74180752)
print v(xbgr.mr_n74181072)
print v(xbgr.mr_n74181184)
print v(xbgr.mr_n74181504)
print v(xbgr.mr_n74181616)
print v(xbgr.mr_n74181936)
print v(xbgr.mr_n74182048)
print v(xbgr.mr_n74182368)
print v(xbgr.mr_n74182480)
print v(xbgr.mr_n74182800)
print v(xbgr.mr_n74182912)
print v(xbgr.mr_n74183232)
print v(xbgr.mr_n74183344)
print v(xbgr.mr_n74183664)
print v(xbgr.mr_n74183776)
print v(xbgr.mr_n74184096)
print v(xbgr.mr_n74184208)
print v(xbgr.mr_n74184528)
print v(xbgr.mr_n74184640)
print v(xbgr.mr_n74184960)
print v(xbgr.mr_n74185072)
print v(xbgr.mr_n74185392)
print v(xbgr.mr_n74185504)
print v(xbgr.mr_n74185824)
print v(xbgr.mr_n74185936)
print v(xbgr.mr_n74186256)
print v(xbgr.mr_n74186368)
print v(xbgr.mr_n74186688)
print v(xbgr.mr_n74186800)
print v(xbgr.mr_n74187120)
print v(xbgr.mr_n74187232)
print v(xbgr.mr_n74187552)
print v(xbgr.mr_n74187664)
print v(xbgr.mr_n74187984)
print v(xbgr.mr_n74188096)
print v(xbgr.mr_n74188416)
print v(xbgr.mr_n74188528)
print v(xbgr.mr_n74188848)
print v(xbgr.mr_n74188960)
print v(xbgr.mr_n74189280)
print v(xbgr.mr_n74189392)
print v(xbgr.mr_n74189712)
print v(xbgr.mr_n74189824)
print v(xbgr.mr_n74190144)
print v(xbgr.mr_n74190256)
print v(xbgr.mr_n74190576)
print v(xbgr.mr_n74190688)
print v(xbgr.mr_n74191008)
print v(xbgr.mr_n74191120)
print v(xbgr.mr_n74191440)
print v(xbgr.mr_n74191552)
print v(xbgr.mr_n74191872)
print v(xbgr.mr_n74191984)
print v(xbgr.mr_n74192304)
print v(xbgr.mr_n74192416)
print v(xbgr.mr_n74192736)
print v(xbgr.mr_n74192848)
print v(xbgr.mr_n74193168)
print v(xbgr.mr_n74193280)
print v(xbgr.mr_n74193600)
print v(xbgr.mr_n74193712)
print v(xbgr.mr_n74194032)
print v(xbgr.mr_n74194144)
print v(xbgr.mr_n74194464)
print v(xbgr.mr_n74194576)
print v(xbgr.mr_n74194896)
print v(xbgr.mr_n74195008)
print v(xbgr.mr_n74195328)
print v(xbgr.mr_n74195440)
print v(xbgr.mr_n74195760)
print v(xbgr.mr_n74195872)
print v(xbgr.mr_n74196192)
print v(xbgr.mr_n74196304)
print v(xbgr.mr_n74196624)
print v(xbgr.mr_n74196736)
print v(xbgr.mr_n74197056)
print v(xbgr.mr_n74197168)
print v(xbgr.mr_n74197488)
print v(xbgr.mr_n74197600)
print v(xbgr.mr_n74197920)
print v(xbgr.mr_n74198032)
print v(xbgr.mr_n74198352)
print v(xbgr.mr_n74198464)
print v(xbgr.mr_n74198784)
print v(xbgr.mr_n74198896)
print v(xbgr.mr_n74199216)
print v(xbgr.mr_n74199328)
print v(xbgr.mr_n74199648)
print v(xbgr.mr_n74199760)
print v(xbgr.mr_n74200080)
print v(xbgr.mr_n74200192)
print v(xbgr.mr_n74200512)
print v(xbgr.mr_n74200624)
print v(xbgr.mr_n74200944)
print v(xbgr.mr_n74201056)
print v(xbgr.mr_n74201376)
print v(xbgr.mr_n74201488)
print v(xbgr.mr_n74201808)
print v(xbgr.mr_n74201920)
print v(xbgr.mr_n74202240)
print v(xbgr.mr_n74202352)
print v(xbgr.mr_n74202672)
print v(xbgr.mr_n74202784)
print v(xbgr.mr_n74203104)
print v(xbgr.mr_n74203216)
print v(xbgr.mr_n74203536)
print v(xbgr.mr_n74203648)
print v(xbgr.mr_n74203968)
print v(xbgr.mr_n74204080)
print v(xbgr.mr_n74204400)
print v(xbgr.mr_n74204512)
print v(xbgr.mr_n74204832)
print v(xbgr.mr_n74204944)
print v(xbgr.mr_n74205264)
print v(xbgr.mr_n74205376)
print v(xbgr.mr_n74205696)
print v(xbgr.mr_n74205808)
print v(xbgr.mr_n74206128)
print v(xbgr.mr_n74206240)
print v(xbgr.mr_n74206560)
print v(xbgr.mr_n74206672)
print v(xbgr.mr_n74206992)
print v(xbgr.mr_n74207104)
print v(xbgr.mr_n74207424)
print v(xbgr.mr_n74207536)
print v(xbgr.mr_n74207856)
print v(xbgr.mr_n74207968)
print v(xbgr.mr_n74208288)
print v(xbgr.mr_n74208400)
print v(xbgr.mr_n74208720)
print v(xbgr.mr_n74208832)
print v(xbgr.mr_n74209152)
print v(xbgr.mr_n74209264)
print v(xbgr.mr_n74209584)
print v(xbgr.mr_n74209696)
print v(xbgr.mr_n74210016)
print v(xbgr.mr_n74210128)
print v(xbgr.mr_n74210448)
print v(xbgr.mr_n74210560)
print v(xbgr.mr_n74210880)
print v(xbgr.mr_n74210992)
print v(xbgr.mr_n74211312)
print v(xbgr.mr_n74211424)
print v(xbgr.mr_n74211744)
print v(xbgr.mr_n74211856)
print v(xbgr.mr_n74212176)
print v(xbgr.mr_n74212288)
print v(xbgr.mr_n74212608)
print v(xbgr.mr_n74212720)
print v(xbgr.mr_n74213040)
print v(xbgr.mr_n74213152)
print v(xbgr.mr_n74213472)
print v(xbgr.mr_n74213584)
print v(xbgr.mr_n74213904)
print v(xbgr.mr_n74214016)
print v(xbgr.mr_n74214336)
print v(xbgr.mr_n74214448)
print v(xbgr.mr_n74214768)
print v(xbgr.mr_n74214880)
print v(xbgr.mr_n74215200)
print v(xbgr.mr_n74215312)
print v(xbgr.mr_n74215632)
print v(xbgr.mr_n74215744)
print v(xbgr.mr_n74216064)
print v(xbgr.mr_n74216176)
print v(xbgr.mr_n74216496)
print v(xbgr.mr_n74216608)
print v(xbgr.mr_n74216928)
print v(xbgr.mr_n74217040)
print v(xbgr.mr_n74217360)
print v(xbgr.mr_n74217472)
print v(xbgr.mr_n74217792)
print v(xbgr.mr_n74217904)
print v(xbgr.mr_n74218224)
print v(xbgr.mr_n74218336)
print v(xbgr.mr_n74218656)
print v(xbgr.mr_n74218768)
print v(xbgr.mr_n74219088)
print v(xbgr.mr_n74219200)
print v(xbgr.mr_n74219520)
print v(xbgr.mr_n74219632)
print v(xbgr.mr_n74219952)
print v(xbgr.mr_n74220064)
print v(xbgr.mr_n74220384)
print v(xbgr.mr_n74220496)
print v(xbgr.mr_n74220816)
print v(xbgr.mr_n74220928)
print v(xbgr.mr_n74221248)
print v(xbgr.mr_n74221360)
print v(xbgr.mr_n74221680)
print v(xbgr.mr_n74221792)
print v(xbgr.mr_n74222112)
print v(xbgr.mr_n74222224)
print v(xbgr.mr_n74222544)
print v(xbgr.mr_n74222656)
print v(xbgr.mr_n74222976)
print v(xbgr.mr_n74223088)
print v(xbgr.mr_n74223408)
print v(xbgr.mr_n74223520)
print v(xbgr.mr_n74223840)
print v(xbgr.mr_n74223952)
print v(xbgr.mr_n74224272)
print v(xbgr.mr_n74224384)
print v(xbgr.mr_n74224704)
print v(xbgr.mr_n74224816)
print v(xbgr.mr_n74225136)
print v(xbgr.mr_n74225248)
print v(xbgr.mr_n74225568)
print v(xbgr.mr_n74225680)
print v(xbgr.mr_n74226000)
print v(xbgr.mr_n74226112)
print v(xbgr.mr_n74226432)
print v(xbgr.mr_n74226544)
print v(xbgr.mr_n74226864)
print v(xbgr.mr_n74226976)
print v(xbgr.mr_n74227296)
print v(xbgr.mr_n74227408)
print v(xbgr.mr_n74227728)
print v(xbgr.mr_n74227840)
print v(xbgr.mr_n74228160)
print v(xbgr.mr_n74228272)
print v(xbgr.mr_n74228592)
print v(xbgr.mr_n74228704)
print v(xbgr.mr_n74229024)
print v(xbgr.mr_n74229136)
print v(xbgr.mr_n74229456)
print v(xbgr.mr_n74229568)
print v(xbgr.mr_n74229888)
print v(xbgr.mr_n74230000)
print v(xbgr.mr_n74230320)
print v(xbgr.mr_n74230432)
print v(xbgr.mr_n74230752)
print v(xbgr.mr_n74230864)
print v(xbgr.mr_n74231184)
print v(xbgr.mr_n74231296)
print v(xbgr.mr_n74231616)
print v(xbgr.mr_n74231728)
print v(xbgr.mr_n74232048)
print v(xbgr.mr_n74232160)
print v(xbgr.mr_n74232480)
print v(xbgr.mr_n74232592)
print v(xbgr.mr_n74232912)
print v(xbgr.mr_n74233024)
print v(xbgr.mr_n74233344)
print v(xbgr.mr_n74233456)
print v(xbgr.mr_n74233776)
print v(xbgr.mr_n74233888)
print v(xbgr.mr_n74234208)
print v(xbgr.mr_n74234320)
print v(xbgr.mr_n74234640)
print v(xbgr.mr_n74234752)
print v(xbgr.mr_n74235072)
print v(xbgr.mr_n74235184)
print v(xbgr.mr_n74235504)
print v(xbgr.mr_n74235616)
print v(xbgr.mr_n74235936)
print v(xbgr.mr_n74236048)
print v(xbgr.mr_n74236368)
print v(xbgr.mr_n74236480)
print v(xbgr.mr_n74236800)
print v(xbgr.mr_n74236912)
print v(xbgr.mr_n74237232)
print v(xbgr.mr_n74237344)
print v(xbgr.mr_n74237664)
print v(xbgr.mr_n74237776)
print v(xbgr.mr_n74238096)
print v(xbgr.mr_n74238208)
print v(xbgr.mr_n74238528)
print v(xbgr.mr_n74238640)
print v(xbgr.mr_n74238960)
print v(xbgr.mr_n74239072)
print v(xbgr.mr_n74239392)
print v(xbgr.mr_n74239504)
print v(xbgr.mr_n74239824)
print v(xbgr.mr_n74239936)
print v(xbgr.mr_n74240256)
print v(xbgr.mr_n74240368)
print v(xbgr.mr_n74240688)
print v(xbgr.mr_n74240800)
print v(xbgr.mr_n74241120)
print v(xbgr.mr_n74241232)
print v(xbgr.mr_n74241552)
print v(xbgr.mr_n74241664)
print v(xbgr.mr_n74241984)
print v(xbgr.mr_n74242096)
print v(xbgr.mr_n74242416)
print v(xbgr.mr_n74242528)
print v(xbgr.mr_n74242848)
print v(xbgr.mr_n74242960)
print v(xbgr.mr_n74243280)
print v(xbgr.mr_n74243392)
print v(xbgr.mr_n74243712)
print v(xbgr.mr_n74243824)
print v(xbgr.mr_n74244144)
print v(xbgr.mr_n74244256)
print v(xbgr.mr_n74244576)
print v(xbgr.mr_n74244688)
print v(xbgr.mr_n74245008)
print v(xbgr.mr_n74245120)
print v(xbgr.mr_n74245440)
print v(xbgr.mr_n74245552)
print v(xbgr.mr_n74245872)
print v(xbgr.mr_n74245984)
print v(xbgr.mr_n74246304)
print v(xbgr.mr_n74246416)
print v(xbgr.mr_n74246736)
print v(xbgr.mr_n74246848)
print v(xbgr.mr_n74247168)
print v(xbgr.mr_n74247280)
print v(xbgr.mr_n74247600)
print v(xbgr.mr_n74247712)
print v(xbgr.mr_n74248032)
print v(xbgr.mr_n74248144)
print v(xbgr.mr_n74248464)
print v(xbgr.mr_n74248576)
print v(xbgr.mr_n74248896)
print v(xbgr.mr_n74249008)
print v(xbgr.mr_n74249328)
print v(xbgr.mr_n74249440)
print v(xbgr.mr_n74249760)
print v(xbgr.mr_n74249872)
print v(xbgr.mr_n74250192)
print v(xbgr.mr_n74250304)
print v(xbgr.mr_n74250624)
print v(xbgr.mr_n74250736)
print v(xbgr.mr_n74251056)
print v(xbgr.mr_n74251168)
print v(xbgr.mr_n74251488)
print v(xbgr.mr_n74251600)
print v(xbgr.mr_n74251920)
print v(xbgr.mr_n74252032)
print v(xbgr.mr_n74252352)
print v(xbgr.mr_n74252464)
print v(xbgr.mr_n74252784)
print v(xbgr.mr_n74252896)
print v(xbgr.mr_n74253216)
print v(xbgr.mr_n74253328)
print v(xbgr.mr_n74253648)
print v(xbgr.mr_n74253760)
print v(xbgr.mr_n74254080)
print v(xbgr.mr_n74254192)
print v(xbgr.mr_n74254512)
print v(xbgr.mr_n74254624)
print v(xbgr.mr_n74254944)
print v(xbgr.mr_n74255056)
print v(xbgr.mr_n74255376)
print v(xbgr.mr_n74255488)
print v(xbgr.mr_n74255808)
print v(xbgr.mr_n74255920)
print v(xbgr.mr_n74256240)
print v(xbgr.mr_n74256352)
print v(xbgr.mr_n74256672)
print v(xbgr.mr_n74256784)
print v(xbgr.mr_n74257104)
print v(xbgr.mr_n74257216)
print v(xbgr.mr_n74257536)
print v(xbgr.mr_n74257648)
print v(xbgr.mr_n74257968)
print v(xbgr.mr_n74258080)
print v(xbgr.mr_n74258400)
print v(xbgr.mr_n74258512)
print v(xbgr.mr_n74258832)
print v(xbgr.mr_n74258944)
print v(xbgr.mr_n74259264)
print v(xbgr.mr_n74259376)
print v(xbgr.mr_n74259696)
print v(xbgr.mr_n74259808)
print v(xbgr.mr_n74260128)
print v(xbgr.mr_n74260240)
print v(xbgr.mr_n74260560)
print v(xbgr.mr_n74260672)
print v(xbgr.mr_n74260992)
print v(xbgr.mr_n74261104)
print v(xbgr.mr_n74261424)
print v(xbgr.mr_n74261536)
print v(xbgr.mr_n74261856)
print v(xbgr.mr_n74261968)
print v(xbgr.mr_n74262288)
print v(xbgr.mr_n74262400)
print v(xbgr.mr_n74262720)
print v(xbgr.mr_n74262832)
print v(xbgr.mr_n74263152)
print v(xbgr.mr_n74263264)
print v(xbgr.mr_n74263584)
print v(xbgr.mr_n74263696)
print v(xbgr.mr_n74264016)
print v(xbgr.mr_n74264128)
print v(xbgr.mr_n74264448)
print v(xbgr.mr_n74264560)
print v(xbgr.mr_n74264880)
print v(xbgr.mr_n74264992)
print v(xbgr.mr_n74265856)
print v(xbgr.mr_n74266288)
print v(xbgr.mr_n74266720)
print v(xbgr.mr_n74267152)
print v(xbgr.mr_n74267584)
print v(xbgr.mr_n74268016)
print v(xbgr.mr_n74268448)
print v(xbgr.mr_n74268880)
print v(xbgr.mr_n74269312)
print v(xbgr.mr_n74269744)
print v(xbgr.mr_n74270176)
print v(xbgr.mr_n74270608)
print v(xbgr.mr_n74271040)
print v(xbgr.mr_n74271472)
print v(xbgr.mr_n74271904)
print v(xbgr.mr_n74272336)
print v(xbgr.mr_n74272768)
print v(xbgr.mr_n74273200)
print v(xbgr.mr_n74273632)
print v(xbgr.mr_n74274064)
print v(xbgr.mr_n74274496)
print v(xbgr.mr_n74274928)
print v(xbgr.mr_n74275360)
print v(xbgr.mr_n74275792)
print v(xbgr.mr_n74277952)
print v(xbgr.mr_n74278384)
print v(xbgr.mr_n74278816)
print v(xbgr.mr_n74279248)
print v(xbgr.mr_n74279680)
print v(xbgr.mr_n74280112)
print v(xbgr.mr_n74280544)
print v(xbgr.mr_n74280976)
print v(xbgr.mr_n74281408)
print v(xbgr.mr_n74281840)
print v(xbgr.mr_n74282272)
print v(xbgr.mr_n74282704)
print v(xbgr.mr_n74283136)
print v(xbgr.mr_n74283568)
print v(xbgr.mr_n74284000)
print v(xbgr.mr_n74284432)
print v(xbgr.mr_n74284864)
print v(xbgr.mr_n74285296)
print v(xbgr.mr_n74285728)
print v(xbgr.mr_n74286160)
print v(xbgr.mr_n74286592)
print v(xbgr.mr_n74287024)
print v(xbgr.mr_n74287456)
print v(xbgr.mr_n74287888)
print v(xbgr.mr_n74291776)
print v(xbgr.mr_n74292208)
print v(xbgr.mr_n74292640)
print v(xbgr.mr_n74293072)
print v(xbgr.mr_n74293504)
print v(xbgr.mr_n74293936)
print v(xbgr.mr_n74294368)
print v(xbgr.mr_n74294800)
print v(xbgr.mr_n74295232)
print v(xbgr.mr_n74295664)
print v(xbgr.mr_n74296096)
print v(xbgr.mr_n74296528)
print v(xbgr.mr_n74296960)
print v(xbgr.mr_n74297392)
print v(xbgr.mr_n74297824)
print v(xbgr.mr_n74299120)
print v(xbgr.mr_n74299552)
print v(xbgr.mr_n74299984)
print v(xbgr.mr_n74300416)
print v(xbgr.mr_n74300848)
print v(xbgr.mr_n74301280)
print v(xbgr.mr_n74301712)
print v(xbgr.mr_n74302144)
print v(xbgr.mr_n74302576)
print v(xbgr.mr_n74303008)
print v(xbgr.mr_n74304304)
print v(xbgr.mr_n74304736)
print v(xbgr.mr_n74305168)
print v(xbgr.mr_n74305600)
print v(xbgr.mr_n74306032)
print v(xbgr.mr_n74306464)
print v(xbgr.mr_n74306896)
print v(xbgr.mr_n74307328)
print v(xbgr.mr_n74307648)
print v(xbgr.mr_n74307760)
print v(xbgr.mr_n74308080)
print v(xbgr.mr_n74308192)
print v(xbgr.mr_n74308512)
print v(xbgr.mr_n74308624)
print v(xbgr.mr_n74308944)
print v(xbgr.mr_n74309056)
print v(xbgr.mr_n74309376)
print v(xbgr.mr_n74309488)
print v(xbgr.mr_n74309808)
print v(xbgr.mr_n74309920)
print v(xbgr.mr_n74310240)
print v(xbgr.mr_n74310352)
print v(xbgr.mr_n74310672)
print v(xbgr.mr_n74310784)
print v(xbgr.mr_n74311104)
print v(xbgr.mr_n74311216)
print v(xbgr.mr_n74311536)
print v(xbgr.mr_n74311648)
print v(xbgr.mr_n74311968)
print v(xbgr.mr_n74312080)
print v(xbgr.mr_n74312400)
print v(xbgr.mr_n74312512)
print v(xbgr.mr_n74312832)
print v(xbgr.mr_n74312944)
print v(xbgr.mr_n74313264)
print v(xbgr.mr_n74313376)
print v(xbgr.mr_n74313696)
print v(xbgr.mr_n74313808)
print v(xbgr.mr_n74314128)
print v(xbgr.mr_n74314240)
print v(xbgr.mr_n74314560)
print v(xbgr.mr_n74314672)
print v(xbgr.mr_n74314992)
print v(xbgr.mr_n74315104)
print v(xbgr.mr_n74315424)
print v(xbgr.mr_n74315536)
print v(xbgr.mr_n74315856)
print v(xbgr.mr_n74315968)
print v(xbgr.mr_n74316288)
print v(xbgr.mr_n74316400)
print v(xbgr.mr_n74316720)
print v(xbgr.mr_n74316832)
print v(xbgr.mr_n74317152)
print v(xbgr.mr_n74317264)
print v(xbgr.mr_n74317584)
print v(xbgr.mr_n74317696)
print v(xbgr.mr_n74318016)
print v(xbgr.mr_n74318128)
print v(xbgr.mr_n74318448)
print v(xbgr.mr_n74318560)
print v(xbgr.mr_n74318880)
print v(xbgr.mr_n74318992)
print v(xbgr.mr_n74319312)
print v(xbgr.mr_n74319424)
print v(xbgr.mr_n74319744)
print v(xbgr.mr_n74319856)
print v(xbgr.mr_n74320176)
print v(xbgr.mr_n74320288)
print v(xbgr.mr_n74320608)
print v(xbgr.mr_n74320720)
print v(xbgr.mr_n74321040)
print v(xbgr.mr_n74321152)
print v(xbgr.mr_n74321472)
print v(xbgr.mr_n74321584)
print v(xbgr.mr_n74321904)
print v(xbgr.mr_n74322016)
print v(xbgr.mr_n74322336)
print v(xbgr.mr_n74322448)
print v(xbgr.mr_n74322768)
print v(xbgr.mr_n74322880)
print v(xbgr.mr_n74323200)
print v(xbgr.mr_n74323312)
print v(xbgr.mr_n74323632)
print v(xbgr.mr_n74323744)
print v(xbgr.mr_n74324064)
print v(xbgr.mr_n74324176)
print v(xbgr.mr_n74324496)
print v(xbgr.mr_n74324608)
print v(xbgr.mr_n74324928)
print v(xbgr.mr_n74325040)
print v(xbgr.mr_n74325360)
print v(xbgr.mr_n74325472)
print v(xbgr.mr_n74325792)
print v(xbgr.mr_n74325904)
print v(xbgr.mr_n74326224)
print v(xbgr.mr_n74326336)
print v(xbgr.mr_n74326656)
print v(xbgr.mr_n74326768)
print v(xbgr.mr_n74327088)
print v(xbgr.mr_n74327200)
print v(xbgr.mr_n74327520)
print v(xbgr.mr_n74327632)
print v(xbgr.mr_n74327952)
print v(xbgr.mr_n74328064)
print v(xbgr.mr_n74328384)
print v(xbgr.mr_n74328496)
print v(xbgr.mr_n74328816)
print v(xbgr.mr_n74328928)
print v(xbgr.mr_n74329248)
print v(xbgr.mr_n74329360)
print v(xbgr.mr_n74329680)
print v(xbgr.mr_n74329792)
print v(xbgr.mr_n74330112)
print v(xbgr.mr_n74330224)
print v(xbgr.mr_n74330544)
print v(xbgr.mr_n74330656)
print v(xbgr.mr_n74330976)
print v(xbgr.mr_n74331088)
print v(xbgr.mr_n74331408)
print v(xbgr.mr_n74331520)
print v(xbgr.mr_n74331840)
print v(xbgr.mr_n74331952)
print v(xbgr.mr_n74332272)
print v(xbgr.mr_n74332384)
print v(xbgr.mr_n74332704)
print v(xbgr.mr_n74332816)
print v(xbgr.mr_n74333136)
print v(xbgr.mr_n74333248)
print v(xbgr.mr_n74333568)
print v(xbgr.mr_n74333680)
print v(xbgr.mr_n74334000)
print v(xbgr.mr_n74334112)
print v(xbgr.mr_n74334432)
print v(xbgr.mr_n74334544)
print v(xbgr.mr_n74334864)
print v(xbgr.mr_n74334976)
print v(xbgr.mr_n74335296)
print v(xbgr.mr_n74335408)
print v(xbgr.mr_n74335728)
print v(xbgr.mr_n74335840)
print v(xbgr.mr_n74336160)
print v(xbgr.mr_n74336272)
print v(xbgr.mr_n74336592)
print v(xbgr.mr_n74336704)
print v(xbgr.mr_n74337024)
print v(xbgr.mr_n74337136)
print v(xbgr.mr_n74337456)
print v(xbgr.mr_n74337568)
print v(xbgr.mr_n74337888)
print v(xbgr.mr_n74338000)
print v(xbgr.mr_n74338320)
print v(xbgr.mr_n74338432)
print v(xbgr.mr_n74338752)
print v(xbgr.mr_n74338864)
print v(xbgr.mr_n74339184)
print v(xbgr.mr_n74339296)
print v(xbgr.mr_n74339616)
print v(xbgr.mr_n74339728)
print v(xbgr.mr_n74340048)
print v(xbgr.mr_n74340160)
print v(xbgr.mr_n74340480)
print v(xbgr.mr_n74340592)
print v(xbgr.mr_n74340912)
print v(xbgr.mr_n74341024)
print v(xbgr.mr_n74341344)
print v(xbgr.mr_n74341456)
print v(xbgr.mr_n74341776)
print v(xbgr.mr_n74341888)
print v(xbgr.mr_n74342208)
print v(xbgr.mr_n74342320)
print v(xbgr.mr_n74342640)
print v(xbgr.mr_n74342752)
print v(xbgr.mr_n74343072)
print v(xbgr.mr_n74343184)
print v(xbgr.mr_n74343504)
print v(xbgr.mr_n74343616)
print v(xbgr.mr_n74343936)
print v(xbgr.mr_n74344048)
print v(xbgr.mr_n74344368)
print v(xbgr.mr_n74344480)
print v(xbgr.mr_n74344800)
print v(xbgr.mr_n74344912)
print v(xbgr.mr_n74345232)
print v(xbgr.mr_n74345344)
print v(xbgr.mr_n74345664)
print v(xbgr.mr_n74345776)
print v(xbgr.mr_n74346096)
print v(xbgr.mr_n74346208)
print v(xbgr.mr_n74346528)
print v(xbgr.mr_n74346640)
print v(xbgr.mr_n74346960)
print v(xbgr.mr_n74347072)
print v(xbgr.mr_n74347392)
print v(xbgr.mr_n74347504)
print v(xbgr.mr_n74347824)
print v(xbgr.mr_n74347936)
print v(xbgr.mr_n74348256)
print v(xbgr.mr_n74348368)
print v(xbgr.mr_n74348688)
print v(xbgr.mr_n74348800)
print v(xbgr.mr_n74349120)
print v(xbgr.mr_n74349232)
print v(xbgr.mr_n74349552)
print v(xbgr.mr_n74349664)
print v(xbgr.mr_n74349984)
print v(xbgr.mr_n74350096)
print v(xbgr.mr_n74350416)
print v(xbgr.mr_n74350528)
print v(xbgr.mr_n74350848)
print v(xbgr.mr_n74350960)
print v(xbgr.mr_n74351280)
print v(xbgr.mr_n74351392)
print v(xbgr.mr_n74351712)
print v(xbgr.mr_n74351824)
print v(xbgr.mr_n74352144)
print v(xbgr.mr_n74352256)
print v(xbgr.mr_n74352576)
print v(xbgr.mr_n74352688)
print v(xbgr.mr_n74353008)
print v(xbgr.mr_n74353120)
print v(xbgr.mr_n74353440)
print v(xbgr.mr_n74353552)
print v(xbgr.mr_n74353872)
print v(xbgr.mr_n74353984)
print v(xbgr.mr_n74354304)
print v(xbgr.mr_n74354736)
print v(xbgr.mr_n74354848)
print v(xbgr.mr_n74355168)
print v(xbgr.mr_n74355280)
print v(xbgr.mr_n74355600)
print v(xbgr.mr_n74355712)
print v(xbgr.mr_n74356032)
print v(xbgr.mr_n74356144)
print v(xbgr.mr_n74356464)
print v(xbgr.mr_n74356576)
print v(xbgr.mr_n74356896)
print v(xbgr.mr_n74357008)
print v(xbgr.mr_n74357328)
print v(xbgr.mr_n74357440)
print v(xbgr.mr_n74357760)
print v(xbgr.mr_n74357872)
print v(xbgr.mr_n74358192)
print v(xbgr.mr_n74358304)
print v(xbgr.mr_n74358624)
print v(xbgr.mr_n74358736)
print v(xbgr.mr_n74359056)
print v(xbgr.mr_n74359168)
print v(xbgr.mr_n74359488)
print v(xbgr.mr_n74359600)
print v(xbgr.mr_n74359920)
print v(xbgr.mr_n74360032)
print v(xbgr.mr_n74360352)
print v(xbgr.mr_n74360464)
print v(xbgr.mr_n74360784)
print v(xbgr.mr_n74360896)
print v(xbgr.mr_n74361216)
print v(xbgr.mr_n74361328)
print v(xbgr.mr_n74361648)
print v(xbgr.mr_n74361760)
print v(xbgr.mr_n74362080)
print v(xbgr.mr_n74362192)
print v(xbgr.mr_n74362512)
print v(xbgr.mr_n74362624)
print v(xbgr.mr_n74362944)
print v(xbgr.mr_n74363056)
print v(xbgr.mr_n74363376)
print v(xbgr.mr_n74363488)
print v(xbgr.mr_n74363808)
print v(xbgr.mr_n74363920)
print v(xbgr.mr_n74364240)
print v(xbgr.mr_n74364352)
print v(xbgr.mr_n74364672)
print v(xbgr.mr_n74364784)
print v(xbgr.mr_n74365104)
print v(xbgr.mr_n74365216)
print v(xbgr.mr_n74365536)
print v(xbgr.mr_n74365648)
print v(xbgr.mr_n74365968)
print v(xbgr.mr_n74366080)
print v(xbgr.mr_n74366400)
print v(xbgr.mr_n74366512)
print v(xbgr.mr_n74366832)
print v(xbgr.mr_n74366944)
print v(xbgr.mr_n74367264)
print v(xbgr.mr_n74367376)
print v(xbgr.mr_n74367696)
print v(xbgr.mr_n74367808)
print v(xbgr.mr_n74368128)
print v(xbgr.mr_n74368240)
print v(xbgr.mr_n74368560)
print v(xbgr.mr_n74368672)
print v(xbgr.mr_n74368992)
print v(xbgr.mr_n74369104)
print v(xbgr.mr_n74369424)
print v(xbgr.mr_n74369536)
print v(xbgr.mr_n74369856)
print v(xbgr.mr_n74370288)
print v(xbgr.mr_n74370400)
print v(xbgr.mr_n74370720)
print v(xbgr.mr_n74370832)
print v(xbgr.mr_n74371152)
print v(xbgr.mr_n74371264)
print v(xbgr.mr_n74371584)
print v(xbgr.mr_n74372016)
print v(xbgr.mr_n74372128)
print v(xbgr.mr_n74372448)
print v(xbgr.mr_n74372560)
print v(xbgr.mr_n74372880)
print v(xbgr.mr_n74372992)
print v(xbgr.mr_n74373312)
print v(xbgr.mr_n74373744)
print v(xbgr.mr_n74373856)
print v(xbgr.mr_n74374176)
print v(xbgr.mr_n74374288)
print v(xbgr.mr_n74374608)
print v(xbgr.mr_n74374720)
print v(xbgr.mr_n74375040)
print v(xbgr.mr_n74375152)
print v(xbgr.mr_n74375472)
print v(xbgr.mr_n74375584)
print v(xbgr.mr_n74375904)
print v(xbgr.mr_n74376016)
print v(xbgr.mr_n74376336)
print v(xbgr.mr_n74376448)
print v(xbgr.mr_n74376768)
print v(xbgr.mr_n74376880)
print v(xbgr.mr_n74377200)
print v(xbgr.mr_n74377312)
print v(xbgr.mr_n74377632)
print v(xbgr.mr_n74377744)
print v(xbgr.mr_n74378064)
print v(xbgr.mr_n74378176)
print v(xbgr.mr_n74378496)
print v(xbgr.mr_n74378608)
print v(xbgr.mr_n74378928)
print v(xbgr.mr_n74379040)
print v(xbgr.mr_n74379360)
print v(xbgr.mr_n74379472)
print v(xbgr.mr_n74379792)
print v(xbgr.mr_n74379904)
print v(xbgr.mr_n74380224)
print v(xbgr.mr_n74380336)
print v(xbgr.mr_n74380656)
print v(xbgr.mr_n74381088)
print v(xbgr.mr_n74381200)
print v(xbgr.mr_n74381520)
print v(xbgr.mr_n74381632)
print v(xbgr.mr_n74381952)
print v(xbgr.mr_n74382064)
print v(xbgr.mr_n74382384)
print v(xbgr.mr_n74382496)
print v(xbgr.mr_n74382816)
print v(xbgr.mr_n74382928)
print v(xbgr.mr_n74383248)
print v(xbgr.mr_n74383360)
print v(xbgr.mr_n74383680)
print v(xbgr.mr_n74383792)
print v(xbgr.mr_n74384112)
print v(xbgr.mr_n74384224)
print v(xbgr.mr_n74384544)
print v(xbgr.mr_n74384656)
print v(xbgr.mr_n74384976)
print v(xbgr.mr_n74385088)
print v(xbgr.mr_n74385408)
print v(xbgr.mr_n74385840)
print v(xbgr.mr_n74385952)
print v(xbgr.mr_n74386272)
print v(xbgr.mr_n74386704)
print v(xbgr.mr_n74386816)
print v(xbgr.mr_n74387136)
print v(xbgr.mr_n74387248)
print v(xbgr.mr_n74387568)
print v(xbgr.mr_n74387680)
print v(xbgr.mr_n74388000)
print v(xbgr.mr_n74388112)
print v(xbgr.mr_n74388432)
print v(xbgr.mr_n74388544)
print v(xbgr.mr_n74388864)
print v(xbgr.mr_n74389296)
print v(xbgr.mr_n74389408)
print v(xbgr.mr_n74389728)
print v(xbgr.mr_n74389840)
print v(xbgr.mr_n74390160)
print v(xbgr.mr_n74390272)
print v(xbgr.mr_n74394848)
print v(xbgr.mr_n74394960)
print v(xbgr.mr_n74395296)
print v(xbgr.mr_n74395408)
print v(xbgr.mr_n74395728)
print v(xbgr.mr_n74395840)
print v(xbgr.mr_n74396208)
print v(xbgr.mr_n74396320)
print v(xbgr.mr_n74396640)
print v(xbgr.mr_n74396752)
print v(xbgr.mr_n74397072)
print v(xbgr.mr_n74397424)
print v(xbgr.mr_n74397536)
print v(xbgr.mr_n74397856)
print v(xbgr.mr_n74398288)
print v(xbgr.mr_n74398400)
print v(xbgr.mr_n74398720)
print v(xbgr.mr_n74398832)
print v(xbgr.mr_n74399152)
print v(xbgr.mr_n74399264)
print v(xbgr.mr_n74399584)
print v(xbgr.mr_n74399696)
print v(xbgr.mr_n74400016)
print v(xbgr.mr_n74400128)
print v(xbgr.mr_n74400448)
print v(xbgr.mr_n74400880)
print v(xbgr.mr_n74400992)
print v(xbgr.mr_n74401312)
print v(xbgr.mr_n74401744)
print v(xbgr.mr_n74401856)
print v(xbgr.mr_n74402176)
print v(xbgr.mr_n74402288)
print v(xbgr.mr_n74402608)
print v(xbgr.mr_n74402720)
print v(xbgr.mr_n74403040)
print v(xbgr.mr_n74403152)
print v(xbgr.mr_n74403472)
print v(xbgr.mr_n74403584)
print v(xbgr.mr_n74403904)
print v(xbgr.mr_n74404016)
print v(xbgr.mr_n74404336)
print v(xbgr.mr_n74404448)
print v(xbgr.mr_n74404768)
print v(xbgr.mr_n74405200)
print v(xbgr.mr_n74405312)
print v(xbgr.mr_n74405632)
print v(xbgr.mr_n74405744)
print v(xbgr.mr_n74406064)
print v(xbgr.mr_n74406176)
print v(xbgr.mr_n74406496)
print v(xbgr.mr_n74406608)
print v(xbgr.mr_n74406928)
print v(xbgr.mr_n74407040)
print v(xbgr.mr_n74407360)
print v(xbgr.mr_n74407472)
print v(xbgr.mr_n74407792)
print v(xbgr.mr_n74407904)
print v(xbgr.mr_n74408224)
print v(xbgr.mr_n74408656)
print v(xbgr.mr_n74408768)
print v(xbgr.mr_n74409088)
print v(xbgr.mr_n74409520)
print v(xbgr.mr_n74409632)
print v(xbgr.mr_n74409952)
print v(xbgr.mr_n74410064)
print v(xbgr.mr_n74410384)
print v(xbgr.mr_n74410496)
print v(xbgr.mr_n74410816)
print v(xbgr.mr_n74410928)
print v(xbgr.mr_n74411248)
print v(xbgr.mr_n74411360)
print v(xbgr.mr_n74411680)
print v(xbgr.mr_n74411792)
print v(xbgr.mr_n74412112)
print v(xbgr.mr_n74412224)
print v(xbgr.mr_n74412544)
print v(xbgr.mr_n74412976)
print v(xbgr.mr_n74413088)
print v(xbgr.mr_n74413408)
print v(xbgr.mr_n74413520)
print v(xbgr.mr_n74413840)
print v(xbgr.mr_n74413952)
print v(xbgr.mr_n74414272)
print v(xbgr.mr_n74414704)
print v(xbgr.mr_n74414816)
print v(xbgr.mr_n74415136)
print v(xbgr.mr_n74415248)
print v(xbgr.mr_n74415568)
print v(xbgr.mr_n74415680)
print v(xbgr.mr_n74416000)
print v(xbgr.mr_n74416112)
print v(xbgr.mr_n74416432)
print v(xbgr.mr_n74416544)
print v(xbgr.mr_n74416864)
print v(xbgr.mr_n74416976)
print v(xbgr.mr_n74417296)
print v(xbgr.mr_n74417408)
print v(xbgr.mr_n74417728)
print v(xbgr.mr_n74418160)
print v(xbgr.mr_n74418272)
print v(xbgr.mr_n74418592)
print v(xbgr.mr_n74418704)
print v(xbgr.mr_n74419024)
print v(xbgr.mr_n74419136)
print v(xbgr.mr_n74419456)
print v(xbgr.mr_n74419888)
print v(xbgr.mr_n74420000)
print v(xbgr.mr_n74420320)
print v(xbgr.mr_n74420432)
print v(xbgr.mr_n74420752)
print v(xbgr.mr_n74420864)
print v(xbgr.mr_n74421184)
print v(xbgr.mr_n74421296)
print v(xbgr.mr_n74421616)
print v(xbgr.mr_n74421728)
print v(xbgr.mr_n74422048)
print v(xbgr.mr_n74422160)
print v(xbgr.mr_n74422480)
print v(xbgr.mr_n74422592)
print v(xbgr.mr_n74422912)
print v(xbgr.mr_n74423024)
print v(xbgr.mr_n74423344)
print v(xbgr.mr_n74423456)
print v(xbgr.mr_n74423776)
print v(xbgr.mr_n74424208)
print v(xbgr.mr_n74424320)
print v(xbgr.mr_n74424640)
print v(xbgr.mr_n74424752)
print v(xbgr.mr_n74424976)
print v(xbgr.mr_n74425344)
print v(xbgr.mr_n74425456)
print v(xbgr.mr_n74425712)
print v(xbgr.mr_n74425824)
print v(xbgr.mr_n74426080)
print v(xbgr.mr_n74426192)
print v(xbgr.mr_n74426448)
print v(xbgr.mr_n74426560)
print v(xbgr.mr_n74426816)
print v(xbgr.mr_n74426928)
print v(xbgr.mr_n74427184)
print v(xbgr.mr_n74427552)
print v(xbgr.mr_n74427664)
print v(xbgr.mr_n74427920)
print v(xbgr.mr_n74428288)
print v(xbgr.mr_n74428400)
print v(xbgr.mr_n74428656)
print v(xbgr.mr_n74429024)
print v(xbgr.mr_n74429136)
print v(xbgr.mr_n74429392)
print v(xbgr.mr_n74429504)
print v(xbgr.mr_n74429760)
print v(xbgr.mr_n74429872)
print v(xbgr.mr_n74430128)
print v(xbgr.mr_n74430496)
print v(xbgr.mr_n74430608)
print v(xbgr.mr_n74430864)
print v(xbgr.mr_n74431232)
print v(xbgr.mr_n74431344)
print v(xbgr.mr_n74431600)
print v(xbgr.mr_n74431968)
print v(xbgr.mr_n74432080)
print v(xbgr.mr_n74432336)
print v(xbgr.mr_n74432448)
print v(xbgr.mr_n74432704)
print v(xbgr.mr_n74432816)
print v(xbgr.mr_n74433072)
print v(xbgr.mr_n74433184)
print v(xbgr.mr_n74433440)
print v(xbgr.mr_n74433552)
print v(xbgr.mr_n74433808)
print v(xbgr.mr_n74434176)
print v(xbgr.mr_n74434288)
print v(xbgr.mr_n74434544)
print v(xbgr.mr_n74434656)
print v(xbgr.mr_n74434912)
print v(xbgr.mr_n74435024)
print v(xbgr.mr_n74435280)
print v(xbgr.mr_n74435392)
print v(xbgr.mr_n74435648)
print v(xbgr.mr_n74435760)
print v(xbgr.mr_n74436016)
print v(xbgr.mr_n74436384)
print v(xbgr.mr_n74436496)
print v(xbgr.mr_n74436752)
print v(xbgr.mr_n74437120)
print v(xbgr.mr_n74437232)
print v(xbgr.mr_n74437488)
print v(xbgr.mr_n74437600)
print v(xbgr.mr_n74437856)
print v(xbgr.mr_n74437968)
print v(xbgr.mr_n74438224)
print v(xbgr.mr_n74438592)
print v(xbgr.mr_n74438704)
print v(xbgr.mr_n74438960)
print v(xbgr.mr_n74439328)
print v(xbgr.mr_n74439440)
print v(xbgr.mr_n74439696)
print v(xbgr.mr_n74439808)
print v(xbgr.mr_n74440064)
print v(xbgr.mr_n74440176)
print v(xbgr.mr_n74440432)
print v(xbgr.mr_n74440544)
print v(xbgr.mr_n74440832)
print v(xbgr.mr_n74440944)
print v(xbgr.mr_n74441264)
print v(xbgr.mr_n74441376)
print v(xbgr.mr_n74441696)
print v(xbgr.mr_n74441808)
print v(xbgr.mr_n74442128)
print v(xbgr.mr_n74442560)
print v(xbgr.mr_n74442672)
print v(xbgr.mr_n74442992)
print v(xbgr.mr_n74443104)
print v(xbgr.mr_n74443424)
print v(xbgr.mr_n74443536)
print v(xbgr.mr_n74443856)
print v(xbgr.mr_n74443968)
print v(xbgr.mr_n74444288)
print v(xbgr.mr_n74444400)
print v(xbgr.mr_n74444720)
print v(xbgr.mr_n74445152)
print v(xbgr.mr_n74445264)
print v(xbgr.mr_n74445584)
print v(xbgr.mr_n74446016)
print v(xbgr.mr_n74446128)
print v(xbgr.mr_n74446448)
print v(xbgr.mr_n74446560)
print v(xbgr.mr_n74446880)
print v(xbgr.mr_n74446992)
print v(xbgr.mr_n74447312)
print v(xbgr.mr_n74447424)
print v(xbgr.mr_n74447744)
print v(xbgr.mr_n74447856)
print v(xbgr.mr_n74448176)
print v(xbgr.mr_n74448288)
print v(xbgr.mr_n74448608)
print v(xbgr.mr_n74448720)
print v(xbgr.mr_n74449040)
print v(xbgr.mr_n74449152)
print v(xbgr.mr_n74449472)
print v(xbgr.mr_n74450016)
print v(xbgr.mr_n74450448)
print v(xbgr.mr_n74450880)
print v(xbgr.mr_n74451312)
print v(xbgr.mr_n74451744)
print v(xbgr.mr_n74452176)
print v(xbgr.mr_n74452608)
print v(xbgr.mr_n74453040)
print v(xbgr.mr_n74453472)
print v(xbgr.mr_n74453904)
print v(xbgr.mr_n74454224)
print v(xbgr.mr_n74454656)
print v(xbgr.mr_n74455088)
print v(xbgr.mr_n74455520)
print v(xbgr.mr_n74455952)
print v(xbgr.mr_n74456384)
print v(xbgr.mr_n74456816)
print v(xbgr.mr_n74457248)
print v(xbgr.mr_n74457680)
print v(xbgr.mr_n74458112)
print v(xbgr.mr_n74458544)
print v(xbgr.mr_n74458976)
print v(xbgr.mr_n74459408)
print v(xbgr.mr_n74459840)
print v(xbgr.mr_n74460272)
print v(xbgr.mr_n74460704)
print v(xbgr.mr_n74461136)
print v(xbgr.mr_n74461568)
print v(xbgr.mr_n74462000)
print v(xbgr.mr_n74462432)
print v(xbgr.mr_n74462864)
print v(xbgr.mr_n74463296)
print v(xbgr.mr_n74463728)
print v(xbgr.mr_n74464160)
print v(xbgr.mr_n74464592)
print v(xbgr.mr_n74465024)
print v(xbgr.mr_n74465456)
print v(xbgr.mr_n74465888)
print v(xbgr.mr_n74466320)
print v(xbgr.mr_n74466752)
print v(xbgr.mr_n74467184)
print v(xbgr.mr_n74467616)
print v(xbgr.mr_n74468048)
print v(xbgr.mr_n74468480)
print v(xbgr.mr_n74468912)
print v(xbgr.mr_n74469344)
print v(xbgr.mr_n74469776)
print v(xbgr.mr_n74470208)
print v(xbgr.mr_n74470640)
print v(xbgr.mr_n74471072)
print v(xbgr.mr_n74471504)
print v(xbgr.mr_n74471936)
print v(xbgr.mr_n74472368)
print v(xbgr.mr_n74472800)
print v(xbgr.mr_n74473232)
print v(xbgr.mr_n74473664)
print v(xbgr.mr_n74474096)
print v(xbgr.mr_n74474528)
print v(xbgr.mr_n74475824)
print v(xbgr.mr_n74476256)
print v(xbgr.mr_n74476688)
print v(xbgr.mr_n74477120)
print v(xbgr.mr_n74477552)
print v(xbgr.mr_n74477984)
print v(xbgr.mr_n74478416)
print v(xbgr.mr_n74478848)
print v(xbgr.mr_n74479280)
print v(xbgr.mr_n74479712)
print v(xbgr.mr_n74480144)
print v(xbgr.mr_n74480576)
print v(xbgr.mr_n74482736)
print v(xbgr.mr_n74483168)
print v(xbgr.mr_n74483600)
print v(xbgr.mr_n74484032)
print v(xbgr.mr_n74484464)
print v(xbgr.mr_n74484896)
print v(xbgr.mr_n74485328)
print v(xbgr.mr_n74485760)
print v(xbgr.mr_n74486192)
print v(xbgr.mr_n74486624)
print v(xbgr.mr_n74487920)
print v(xbgr.mr_n74488352)
print v(xbgr.mr_n74488784)
print v(xbgr.mr_n74489216)
print v(xbgr.mr_n74489648)
print v(xbgr.mr_n74490080)
print v(xbgr.mr_n74490512)
print v(xbgr.mr_n74490944)
print v(xbgr.mr_n74491376)
print v(xbgr.mr_n74491808)
print v(xbgr.mr_n74492240)
print v(xbgr.mr_n74492672)
print v(xbgr.mr_n74493968)
print v(xbgr.mr_n74494400)
print v(xbgr.mr_n74495696)
print v(xbgr.mr_n74496128)
print v(xbgr.mr_n74496560)
print v(xbgr.mr_n74496992)
print v(xbgr.mr_n74497424)
print v(xbgr.mr_n74497856)
print v(xbgr.mr_n74498288)
print v(xbgr.mr_n74498720)
print v(xbgr.mr_n74500016)
print v(xbgr.mr_n74500448)
print v(xbgr.mr_n74500768)
print v(xbgr.mr_n74500880)
print v(xbgr.mr_n74501200)
print v(xbgr.mr_n74501312)
print v(xbgr.mr_n74501632)
print v(xbgr.mr_n74501744)
print v(xbgr.mr_n74502064)
print v(xbgr.mr_n74502176)
print v(xbgr.mr_n74502496)
print v(xbgr.mr_n74502608)
print v(xbgr.mr_n74502928)
print v(xbgr.mr_n74503040)
print v(xbgr.mr_n74503360)
print v(xbgr.mr_n74503472)
print v(xbgr.mr_n74503792)
print v(xbgr.mr_n74503904)
print v(xbgr.mr_n74504336)
print v(xbgr.mr_n74504768)
print v(xbgr.mr_n74505200)
print v(xbgr.mr_n74505632)
print v(xbgr.mr_n74506064)
print v(xbgr.mr_n74506496)
print v(xbgr.mr_n74506928)
print v(xbgr.mr_n74507360)
print v(xbgr.mr_n74507792)
print v(xbgr.mr_n74508224)
print v(xbgr.mr_n74508656)
print v(xbgr.mr_n74509088)
print v(xbgr.mr_n74509520)
print v(xbgr.mr_n74509952)
print v(xbgr.mr_n74510384)
print v(xbgr.mr_n74510816)
print v(xbgr.mr_n74511248)
print v(xbgr.mr_n74511680)
print v(xbgr.mr_n74512112)
print v(xbgr.mr_n74512544)
print v(xbgr.mr_n74512976)
print v(xbgr.mr_n74513408)
print v(xbgr.mr_n74513840)
print v(xbgr.mr_n74514272)
print v(xbgr.mr_n74514704)
print v(xbgr.mr_n74515136)
print v(xbgr.mr_n74515776)
print v(xbgr.mr_n74516208)
print v(xbgr.mr_n74516640)
print v(xbgr.mr_n74517072)
print v(xbgr.mr_n74517504)
print v(xbgr.mr_n74517936)
print v(xbgr.mr_n74518368)
print v(xbgr.mr_n74518800)
print v(xbgr.mr_n74519232)
print v(xbgr.mr_n74519664)
print v(xbgr.mr_n74520096)
print v(xbgr.mr_n74520528)
print v(xbgr.mr_n74520960)
print v(xbgr.mr_n74521392)
print v(xbgr.mr_n74521824)
print v(xbgr.mr_n74522256)
print v(xbgr.mr_n74522688)
print v(xbgr.mr_n74523120)
print v(xbgr.mr_n74523552)
print v(xbgr.mr_n74523984)
print v(xbgr.mr_n74524416)
print v(xbgr.mr_n74524848)
print v(xbgr.mr_n74525280)
print v(xbgr.mr_n74525712)
print v(xbgr.mr_n74526144)
print v(xbgr.mr_n74526576)
print v(xbgr.mr_n74527008)
print v(xbgr.mr_n74527440)
print v(xbgr.mr_n74527872)
print v(xbgr.mr_n74528304)
print v(xbgr.mr_n74528736)
print v(xbgr.mr_n74529168)
print v(xbgr.mr_n74529600)
print v(xbgr.mr_n74530032)
print v(xbgr.mr_n74530464)
print v(xbgr.mr_n74530896)
print v(xbgr.mr_n74531328)
print v(xbgr.mr_n74531760)
print v(xbgr.mr_n74532192)
print v(xbgr.mr_n74532624)
print v(xbgr.mr_n74533056)
print v(xbgr.mr_n74533488)
print v(xbgr.mr_n74533920)
print v(xbgr.mr_n74534352)
print v(xbgr.mr_n74534784)
print v(xbgr.mr_n74535216)
print v(xbgr.mr_n74535648)
print v(xbgr.mr_n74536080)
print v(xbgr.mr_n74536512)
print v(xbgr.mr_n74536944)
print v(xbgr.mr_n74537376)
print v(xbgr.mr_n74537808)
print v(xbgr.mr_n74538240)
print v(xbgr.mr_n74538672)
print v(xbgr.mr_n74539104)
print v(xbgr.mr_n74539536)
print v(xbgr.mr_n74539968)
print v(xbgr.mr_n74540400)
print v(xbgr.mr_n74540832)
print v(xbgr.mr_n74541264)
print v(xbgr.mr_n74541696)
print v(xbgr.mr_n74542128)
print v(xbgr.mr_n74542560)
print v(xbgr.mr_n74542992)
print v(xbgr.mr_n74543424)
print v(xbgr.mr_n74543856)
print v(xbgr.mr_n74544288)
print v(xbgr.mr_n74544720)
print v(xbgr.mr_n74545152)
print v(xbgr.mr_n74545584)
print v(xbgr.mr_n74546016)
print v(xbgr.mr_n74546448)
print v(xbgr.mr_n74546880)
print v(xbgr.mr_n74547312)
print v(xbgr.mr_n74547744)
print v(xbgr.mr_n74548176)
print v(xbgr.mr_n74548608)
print v(xbgr.mr_n74549040)
print v(xbgr.mr_n74549472)
print v(xbgr.mr_n74549904)
print v(xbgr.mr_n74550336)
print v(xbgr.mr_n74550768)
print v(xbgr.mr_n74551200)
print v(xbgr.mr_n74551632)
print v(xbgr.mr_n74552064)
print v(xbgr.mr_n74552384)
print v(xbgr.mr_n74552496)
print v(xbgr.mr_n74552816)
print v(xbgr.mr_n74552928)
print v(xbgr.mr_n74553248)
print v(xbgr.mr_n74553360)
print v(xbgr.mr_n74553680)
print v(xbgr.mr_n74553792)
print v(xbgr.mr_n74554224)
print v(xbgr.mr_n74554656)
print v(xbgr.mr_n74555088)
print v(xbgr.mr_n74555520)
print v(xbgr.mr_n74555952)
print v(xbgr.mr_n74556384)
print v(xbgr.mr_n74556816)
print v(xbgr.mr_n74557248)
print v(xbgr.mr_n74557680)
print v(xbgr.mr_n74558112)
print v(xbgr.mr_n74558544)
print v(xbgr.mr_n74558976)
print v(xbgr.mr_n74559408)
print v(xbgr.mr_n74559840)
print v(xbgr.mr_n74560272)
print v(xbgr.mr_n74560704)
print v(xbgr.mr_n74561136)
print v(xbgr.mr_n74561568)
print v(xbgr.mr_n74562000)
print v(xbgr.mr_n74562432)
print v(xbgr.mr_n74562864)
print v(xbgr.mr_n74563296)
print v(xbgr.mr_n74563728)
print v(xbgr.mr_n74564160)
print v(xbgr.mr_n74564592)
print v(xbgr.mr_n74565024)
print v(xbgr.mr_n74565456)
print v(xbgr.mr_n74565888)
print v(xbgr.mr_n74566320)
print v(xbgr.mr_n74566752)
print v(xbgr.mr_n74567184)
print v(xbgr.mr_n74567616)
print v(xbgr.mr_n74568048)
print v(xbgr.mr_n74568480)
print v(xbgr.mr_n74568912)
print v(xbgr.mr_n74569344)
print v(xbgr.mr_n74569776)
print v(xbgr.mr_n74570208)
print v(xbgr.mr_n74570640)
print v(xbgr.mr_n74571072)
print v(xbgr.mr_n74571504)
print v(xbgr.mr_n74571936)
print v(xbgr.mr_n74572368)
print v(xbgr.mr_n74572800)
print v(xbgr.mr_n74573232)
print v(xbgr.mr_n74573664)
print v(xbgr.mr_n74574096)
print v(xbgr.mr_n74574528)
print v(xbgr.mr_n74574960)
print v(xbgr.mr_n74575392)
print v(xbgr.mr_n74575824)
print v(xbgr.mr_n74576256)
print v(xbgr.mr_n74576688)
print v(xbgr.mr_n74577120)
print v(xbgr.mr_n74577552)
print v(xbgr.mr_n74577984)
print v(xbgr.mr_n74578416)
print v(xbgr.mr_n74578848)
print v(xbgr.mr_n74579280)
print v(xbgr.mr_n74579712)
print v(xbgr.mr_n74580144)
print v(xbgr.mr_n74580576)
print v(xbgr.mr_n74581008)
print v(xbgr.mr_n74581440)
print v(xbgr.mr_n74582736)
print v(xbgr.mr_n74583168)
print v(xbgr.mr_n74584464)
print v(xbgr.mr_n74584896)
print v(xbgr.mr_n74586192)
print v(xbgr.mr_n74586624)
print v(xbgr.mr_n74587056)
print v(xbgr.mr_n74587488)
print v(xbgr.mr_n74587920)
print v(xbgr.mr_n74588352)
print v(xbgr.mr_n74588784)
print v(xbgr.mr_n74589216)
print v(xbgr.mr_n74589648)
print v(xbgr.mr_n74590080)
print v(xbgr.mr_n74590512)
print v(xbgr.mr_n74590944)
print v(xbgr.mr_n74591376)
print v(xbgr.mr_n74591808)
print v(xbgr.mr_n74592240)
print v(xbgr.mr_n74592672)
print v(xbgr.mr_n74593968)
print v(xbgr.mr_n74594400)
print v(xbgr.mr_n74594832)
print v(xbgr.mr_n74595264)
print v(xbgr.mr_n74595696)
print v(xbgr.mr_n74596128)
print v(xbgr.mr_n74597424)
print v(xbgr.mr_n74597856)
print v(xbgr.mr_n74598288)
print v(xbgr.mr_n74598720)
print v(xbgr.mr_n74599152)
print v(xbgr.mr_n74599584)
print v(xbgr.mr_n74600016)
print v(xbgr.mr_n74600448)
print v(xbgr.mr_n74600880)
print v(xbgr.mr_n74601312)
print v(xbgr.mr_n74601744)
print v(xbgr.mr_n74602176)
print v(xbgr.mr_n74602608)
print v(xbgr.mr_n74603040)
print v(xbgr.mr_n74603472)
print v(xbgr.mr_n74603904)
print v(xbgr.mr_n74604336)
print v(xbgr.mr_n74604768)
print v(xbgr.mr_n74605200)
print v(xbgr.mr_n74605632)
print v(xbgr.mr_n74606064)
print v(xbgr.mr_n74606496)
print v(xbgr.mr_n74606928)
print v(xbgr.mr_n74607360)
print v(xbgr.mr_n74607792)
print v(xbgr.mr_n74608224)
print v(xbgr.mr_n74608656)
print v(xbgr.mr_n74609088)
print v(xbgr.mr_n74609520)
print v(xbgr.mr_n74609952)
print v(xbgr.mr_n74610384)
print v(xbgr.mr_n74610816)
print v(xbgr.mr_n74611248)
print v(xbgr.mr_n74611680)
print v(xbgr.mr_n74612112)
print v(xbgr.mr_n74612544)
print v(xbgr.mr_n74612976)
print v(xbgr.mr_n74613408)
print v(xbgr.mr_n74613840)
print v(xbgr.mr_n74614272)
print v(xbgr.mr_n74614704)
print v(xbgr.mr_n74615136)
print v(xbgr.mr_n74615568)
print v(xbgr.mr_n74616000)
print v(xbgr.mr_n74616432)
print v(xbgr.mr_n74616864)
print v(xbgr.mr_n74617296)
print v(xbgr.mr_n74617728)
print v(xbgr.mr_n74618160)
print v(xbgr.mr_n74618592)
print v(xbgr.mr_n74619024)
print v(xbgr.mr_n74619456)
print v(xbgr.mr_n74619888)
print v(xbgr.mr_n74620320)
print v(xbgr.mr_n74620752)
print v(xbgr.mr_n74621184)
print v(xbgr.mr_n74621616)
print v(xbgr.mr_n74621936)
print v(xbgr.mr_n74622048)
print v(xbgr.mr_n74622368)
print v(xbgr.mr_n74622480)
print v(xbgr.mr_n74622800)
print v(xbgr.mr_n74622912)
print v(xbgr.mr_n74623232)
print v(xbgr.mr_n74623344)
print v(xbgr.mr_n74623664)
print v(xbgr.mr_n74623776)
print v(xbgr.mr_n74624096)
print v(xbgr.mr_n74624208)
print v(xbgr.mr_n74624528)
print v(xbgr.mr_n74624640)
print v(xbgr.mr_n74624960)
print v(xbgr.mr_n74625072)
print v(xbgr.mr_n74625392)
print v(xbgr.mr_n74625504)
print v(xbgr.mr_n74625824)
print v(xbgr.mr_n74625936)
print v(xbgr.mr_n74626256)
print v(xbgr.mr_n74626368)
print v(xbgr.mr_n74626688)
print v(xbgr.mr_n74626800)
print v(xbgr.mr_n74627120)
print v(xbgr.mr_n74627232)
print v(xbgr.mr_n74627552)
print v(xbgr.mr_n74627664)
print v(xbgr.mr_n74627984)
print v(xbgr.mr_n74628096)
print v(xbgr.mr_n74628416)
print v(xbgr.mr_n74628528)
print v(xbgr.mr_n74628848)
print v(xbgr.mr_n74628960)
print v(xbgr.mr_n74629280)
print v(xbgr.mr_n74629392)
print v(xbgr.mr_n74629712)
print v(xbgr.mr_n74629824)
print v(xbgr.mr_n74630144)
print v(xbgr.mr_n74630256)
print v(xbgr.mr_n74630576)
print v(xbgr.mr_n74630688)
print v(xbgr.mr_n74631008)
print v(xbgr.mr_n74631120)
print v(xbgr.mr_n74631440)
print v(xbgr.mr_n74631552)
print v(xbgr.mr_n74631872)
print v(xbgr.mr_n74631984)
print v(xbgr.mr_n74632304)
print v(xbgr.mr_n74632416)
print v(xbgr.mr_n74632736)
print v(xbgr.mr_n74632848)
print v(xbgr.mr_n74633168)
print v(xbgr.mr_n74633280)
print v(xbgr.mr_n74633600)
print v(xbgr.mr_n74633712)
print v(xbgr.mr_n74634032)
print v(xbgr.mr_n74634144)
print v(xbgr.mr_n74634464)
print v(xbgr.mr_n74634576)
print v(xbgr.mr_n74634896)
print v(xbgr.mr_n74635008)
print v(xbgr.mr_n74635328)
print v(xbgr.mr_n74635440)
print v(xbgr.mr_n74635760)
print v(xbgr.mr_n74635872)
print v(xbgr.mr_n74636192)
print v(xbgr.mr_n74636304)
print v(xbgr.mr_n74636624)
print v(xbgr.mr_n74636736)
print v(xbgr.mr_n74637056)
print v(xbgr.mr_n74637168)
print v(xbgr.mr_n74637488)
print v(xbgr.mr_n74637600)
print v(xbgr.mr_n74637920)
print v(xbgr.mr_n74638032)
print v(xbgr.mr_n74638448)
print v(xbgr.mr_n74638880)
print v(xbgr.mr_n74639312)
print v(xbgr.mr_n74639744)
print v(xbgr.mr_n74640176)
print v(xbgr.mr_n74640608)
print v(xbgr.mr_n74641040)
print v(xbgr.mr_n74641472)
print v(xbgr.mr_n74641904)
print v(xbgr.mr_n74642336)
print v(xbgr.mr_n74642768)
print v(xbgr.mr_n74643200)
print v(xbgr.mr_n74643520)
print v(xbgr.mr_n74643632)
print v(xbgr.mr_n74643952)
print v(xbgr.mr_n74644064)
print v(xbgr.mr_n74644496)
print v(xbgr.mr_n74644928)
print v(xbgr.mr_n74645360)
print v(xbgr.mr_n74645792)
print v(xbgr.mr_n74646224)
print v(xbgr.mr_n74646656)
print v(xbgr.mr_n74647088)
print v(xbgr.mr_n74647520)
print v(xbgr.mr_n74647952)
print v(xbgr.mr_n74648384)
print v(xbgr.mr_n74648816)
print v(xbgr.mr_n74649248)
print v(xbgr.mr_n74649680)
print v(xbgr.mr_n74650112)
print v(xbgr.mr_n74650544)
print v(xbgr.mr_n74650976)
print v(xbgr.mr_n74651408)
print v(xbgr.mr_n74651840)
print v(xbgr.mr_n74652272)
print v(xbgr.mr_n74652704)
print v(xbgr.mr_n74653136)
print v(xbgr.mr_n74653568)
print v(xbgr.mr_n74654000)
print v(xbgr.mr_n74654432)
print v(xbgr.mr_n74654864)
print v(xbgr.mr_n74655296)
print v(xbgr.mr_n74655728)
print v(xbgr.mr_n74656160)
print v(xbgr.mr_n74656592)
print v(xbgr.mr_n74657024)
print v(xbgr.mr_n74657456)
print v(xbgr.mr_n74657888)
print v(xbgr.mr_n74658320)
print v(xbgr.mr_n74658752)
print v(xbgr.mr_n74659184)
print v(xbgr.mr_n74659616)
print v(xbgr.mr_n74660048)
print v(xbgr.mr_n74660480)
print v(xbgr.mr_n74660912)
print v(xbgr.mr_n74661344)
print v(xbgr.mr_n74661664)
print v(xbgr.mr_n74661776)
print v(xbgr.mr_n74662096)
print v(xbgr.mr_n74662208)
print v(xbgr.mr_n74662640)
print v(xbgr.mr_n74662960)
print v(xbgr.mr_n74663072)
print v(xbgr.mr_n74663504)
print v(xbgr.mr_n74663936)
print v(xbgr.mr_n74664368)
print v(xbgr.mr_n74664800)
print v(xbgr.mr_n74665232)
print v(xbgr.mr_n74665664)
print v(xbgr.mr_n74666096)
print v(xbgr.mr_n74666528)
print v(xbgr.mr_n74666960)
print v(xbgr.mr_n74667392)
print v(xbgr.mr_n74667824)
print v(xbgr.mr_n74668256)
print v(xbgr.mr_n74668688)
print v(xbgr.mr_n74669120)
print v(xbgr.mr_n74669552)
print v(xbgr.mr_n74669984)
print v(xbgr.mr_n74670416)
print v(xbgr.mr_n74670848)
print v(xbgr.mr_n74671280)
print v(xbgr.mr_n74671712)
print v(xbgr.mr_n74672144)
print v(xbgr.mr_n74672576)
print v(xbgr.mr_n74673008)
print v(xbgr.mr_n74673440)
print v(xbgr.mr_n74673872)
print v(xbgr.mr_n74674304)
print v(xbgr.mr_n74674736)
print v(xbgr.mr_n74675168)
print v(xbgr.mr_n74675600)
print v(xbgr.mr_n74676032)
print v(xbgr.mr_n74676464)
print v(xbgr.mr_n74676896)
print v(xbgr.mr_n74677328)
print v(xbgr.mr_n74677760)
print v(xbgr.mr_n74678192)
print v(xbgr.mr_n74678624)
print v(xbgr.mr_n74679056)
print v(xbgr.mr_n74679488)
print v(xbgr.mr_n74679920)
print v(xbgr.mr_n74680352)
print v(xbgr.mr_n74680784)
print v(xbgr.mr_n74681216)
print v(xbgr.mr_n74681648)
print v(xbgr.mr_n74682080)
print v(xbgr.mr_n74682512)
print v(xbgr.mr_n74682944)
print v(xbgr.mr_n74683376)
print v(xbgr.mr_n74683696)
print v(xbgr.mr_n74683808)
print v(xbgr.mr_n74684240)
print v(xbgr.mr_n74684672)
print v(xbgr.mr_n74684992)
print v(xbgr.mr_n74685104)
print v(xbgr.mr_n74685424)
print v(xbgr.mr_n74685536)
print v(xbgr.mr_n74685856)
print v(xbgr.mr_n74685968)
print v(xbgr.mr_n74686288)
print v(xbgr.mr_n74686400)
print v(xbgr.mr_n74686720)
print v(xbgr.mr_n74686832)
print v(xbgr.mr_n74687152)
print v(xbgr.mr_n74687264)
print v(xbgr.mr_n74687696)
print v(xbgr.mr_n74688016)
print v(xbgr.mr_n74688128)
print v(xbgr.mr_n74688448)
print v(xbgr.mr_n74688560)
print v(xbgr.mr_n74688880)
print v(xbgr.mr_n74688992)
print v(xbgr.mr_n74689312)
print v(xbgr.mr_n74689424)
print v(xbgr.mr_n74689744)
print v(xbgr.mr_n74689856)
print v(xbgr.mr_n74690176)
print v(xbgr.mr_n74690288)
print v(xbgr.mr_n74690720)
print v(xbgr.mr_n74691040)
print v(xbgr.mr_n74691152)
print v(xbgr.mr_n74691472)
print v(xbgr.mr_n74691584)
print v(xbgr.mr_n74691904)
print v(xbgr.mr_n74692016)
print v(xbgr.mr_n74692336)
print v(xbgr.mr_n74692448)
print v(xbgr.mr_n74692768)
print v(xbgr.mr_n74692880)
print v(xbgr.mr_n74693200)
print v(xbgr.mr_n74693312)
print v(xbgr.mr_n74693744)
print v(xbgr.mr_n74694064)
print v(xbgr.mr_n74694176)
print v(xbgr.mr_n74694496)
print v(xbgr.mr_n74694608)
print v(xbgr.mr_n74694928)
print v(xbgr.mr_n74695040)
print v(xbgr.mr_n74695472)
print v(xbgr.mr_n74695792)
print v(xbgr.mr_n74695904)
print v(xbgr.mr_n74696336)
print v(xbgr.mr_n74696768)
print v(xbgr.mr_n74697200)
print v(xbgr.mr_n74697632)
print v(xbgr.mr_n74698928)
print v(xbgr.mr_n74699360)
print v(xbgr.mr_n74700656)
print v(xbgr.mr_n74701088)
print v(xbgr.mr_n74701408)
print v(xbgr.mr_n74701520)
print v(xbgr.mr_n74701840)
print v(xbgr.mr_n74701952)
print v(xbgr.mr_n74702272)
print v(xbgr.mr_n74702384)
print v(xbgr.mr_n74702704)
print v(xbgr.mr_n74703248)
print v(xbgr.mr_n74704000)
print v(xbgr.mr_n74704112)
print v(xbgr.mr_n74704432)
print v(xbgr.mr_n74706704)
print v(xbgr.mr_n74707568)
print v(xbgr.mr_n74708432)
print v(xbgr.mr_n74708864)
print v(xbgr.mr_n74709296)
print v(xbgr.mr_n74709728)
print v(xbgr.mr_n74711776)
print v(xbgr.mr_n74711888)
print v(xbgr.mr_n74712320)
print v(xbgr.mr_n74712640)
print v(xbgr.mr_n74712752)
print v(xbgr.mr_n74713072)
print v(xbgr.mr_n74713184)
print v(xbgr.mr_n74713616)
print v(xbgr.mr_n74713936)
print v(xbgr.mr_n74714048)
print v(xbgr.mr_n74714368)
print v(xbgr.mr_n74714480)
print v(xbgr.mr_n74714800)
print v(xbgr.mr_n74714912)
print v(xbgr.mr_n74715344)
print v(xbgr.mr_n74715664)
print v(xbgr.mr_n74715776)
print v(xbgr.mr_n74716096)
print v(xbgr.mr_n74716208)
print v(xbgr.mr_n74716528)
print v(xbgr.mr_n74716640)
print v(xbgr.mr_n74717072)
print v(xbgr.mr_n74717392)
print v(xbgr.mr_n74717504)
print v(xbgr.mr_n74717824)
print v(xbgr.mr_n74717936)
print v(xbgr.mr_n74718256)
print v(xbgr.mr_n74718368)
print v(xbgr.mr_n74718688)
print v(xbgr.mr_n74718800)
print v(xbgr.mr_n74719120)
print v(xbgr.mr_n74719232)
print v(xbgr.mr_n74719664)
print v(xbgr.mr_n74719984)
print v(xbgr.mr_n74720096)
print v(xbgr.mr_n74720416)
print v(xbgr.mr_n74720528)
print v(xbgr.mr_n74720848)
print v(xbgr.mr_n74720960)
print v(xbgr.mr_n74721280)
print v(xbgr.mr_n74721392)
print v(xbgr.mr_n74721824)
print v(xbgr.mr_n74722144)
print v(xbgr.mr_n74722256)
print v(xbgr.mr_n74722576)
print v(xbgr.mr_n74722688)
print v(xbgr.mr_n74723120)
print v(xbgr.mr_n74723440)
print v(xbgr.mr_n74723552)
print v(xbgr.mr_n74723872)
print v(xbgr.mr_n74723984)
print v(xbgr.mr_n74724304)
print v(xbgr.mr_n74724416)
print v(xbgr.mr_n74724848)
print v(xbgr.mr_n74725168)
print v(xbgr.mr_n74725280)
print v(xbgr.mr_n74725600)
print v(xbgr.mr_n74725712)
print v(xbgr.mr_n74726032)
print v(xbgr.mr_n74726144)
print v(xbgr.mr_n74726576)
print v(xbgr.mr_n74726896)
print v(xbgr.mr_n74727008)
print v(xbgr.mr_n74727328)
print v(xbgr.mr_n74727440)
print v(xbgr.mr_n74727760)
print v(xbgr.mr_n74727872)
print v(xbgr.mr_n74728192)
print v(xbgr.mr_n74728304)
print v(xbgr.mr_n74728624)
print v(xbgr.mr_n74728736)
print v(xbgr.mr_n74729056)
print v(xbgr.mr_n74729168)
print v(xbgr.mr_n74729488)
print v(xbgr.mr_n74729600)
print v(xbgr.mr_n74729920)
print v(xbgr.mr_n74730032)
print v(xbgr.mr_n74730352)
print v(xbgr.mr_n74730464)
print v(xbgr.mr_n74730784)
print v(xbgr.mr_n74730896)
print v(xbgr.mr_n74731216)
print v(xbgr.mr_n74731328)
print v(xbgr.mr_n74731648)
print v(xbgr.mr_n74731760)
print v(xbgr.mr_n74732080)
print v(xbgr.mr_n74732192)
print v(xbgr.mr_n74732624)
print v(xbgr.mr_n74732944)
print v(xbgr.mr_n74733056)
print v(xbgr.mr_n74733376)
print v(xbgr.mr_n74733488)
print v(xbgr.mr_n74733808)
print v(xbgr.mr_n74733920)
print v(xbgr.mr_n74734240)
print v(xbgr.mr_n74734352)
print v(xbgr.mr_n74734672)
print v(xbgr.mr_n74734784)
print v(xbgr.mr_n74735104)
print v(xbgr.mr_n74735216)
print v(xbgr.mr_n74735536)
print v(xbgr.mr_n74735648)
print v(xbgr.mr_n74735968)
print v(xbgr.mr_n74736080)
print v(xbgr.mr_n74736400)
print v(xbgr.mr_n74736512)
print v(xbgr.mr_n74736832)
print v(xbgr.mr_n74736944)
print v(xbgr.mr_n74737376)
print v(xbgr.mr_n74737696)
print v(xbgr.mr_n74737808)
print v(xbgr.mr_n74738128)
print v(xbgr.mr_n74738240)
print v(xbgr.mr_n74738560)
print v(xbgr.mr_n74738672)
print v(xbgr.mr_n74738992)
print v(xbgr.mr_n74739104)
print v(xbgr.mr_n74739424)
print v(xbgr.mr_n74739536)
print v(xbgr.mr_n74739856)
print v(xbgr.mr_n74739968)
print v(xbgr.mr_n74740288)
print v(xbgr.mr_n74740400)
print v(xbgr.mr_n74740720)
print v(xbgr.mr_n74740832)
print v(xbgr.mr_n74741152)
print v(xbgr.mr_n74741264)
print v(xbgr.mr_n74741584)
print v(xbgr.mr_n74741696)
print v(xbgr.mr_n74742016)
print v(xbgr.mr_n74742128)
print v(xbgr.mr_n74742448)
print v(xbgr.mr_n74742560)
print v(xbgr.mr_n74742880)
print v(xbgr.mr_n74742992)
print v(xbgr.mr_n74743312)
print v(xbgr.mr_n74743424)
print v(xbgr.mr_n74743744)
print v(xbgr.mr_n74743856)
print v(xbgr.mr_n74744176)
print v(xbgr.mr_n74744288)
print v(xbgr.mr_n74744720)
print v(xbgr.mr_n74745040)
print v(xbgr.mr_n74745152)
print v(xbgr.mr_n74745472)
print v(xbgr.mr_n74745584)
print v(xbgr.mr_n74745904)
print v(xbgr.mr_n74746016)
print v(xbgr.mr_n74746336)
print v(xbgr.mr_n74746448)
print v(xbgr.mr_n74746768)
print v(xbgr.mr_n74746880)
print v(xbgr.mr_n74747200)
print v(xbgr.mr_n74747312)
print v(xbgr.mr_n74747632)
print v(xbgr.mr_n74747744)
print v(xbgr.mr_n74748064)
print v(xbgr.mr_n74748176)
print v(xbgr.mr_n74748496)
print v(xbgr.mr_n74748608)
print v(xbgr.mr_n74748928)
print v(xbgr.mr_n74749040)
print v(xbgr.mr_n74749360)
print v(xbgr.mr_n74749472)
print v(xbgr.mr_n74749792)
print v(xbgr.mr_n74749904)
print v(xbgr.mr_n74750336)
print v(xbgr.mr_n74750656)
print v(xbgr.mr_n74750768)
print v(xbgr.mr_n74751088)
print v(xbgr.mr_n74751200)
print v(xbgr.mr_n74751520)
print v(xbgr.mr_n74751632)
print v(xbgr.mr_n74751952)
print v(xbgr.mr_n74752064)
print v(xbgr.mr_n74752384)
print v(xbgr.mr_n74752496)
print v(xbgr.mr_n74752816)
print v(xbgr.mr_n74752928)
print v(xbgr.mr_n74753248)
print v(xbgr.mr_n74753360)
print v(xbgr.mr_n74753680)
print v(xbgr.mr_n74753792)
print v(xbgr.mr_n74754112)
print v(xbgr.mr_n74754224)
print v(xbgr.mr_n74754544)
print v(xbgr.mr_n74754656)
print v(xbgr.mr_n74754976)
print v(xbgr.mr_n74755088)
print v(xbgr.mr_n74755408)
print v(xbgr.mr_n74755520)
print v(xbgr.mr_n74755840)
print v(xbgr.mr_n74755952)
print v(xbgr.mr_n74756272)
print v(xbgr.mr_n74756384)
print v(xbgr.mr_n74756704)
print v(xbgr.mr_n74756816)
print v(xbgr.mr_n74757136)
print v(xbgr.mr_n74757248)
print v(xbgr.mr_n74757568)
print v(xbgr.mr_n74757680)
print v(xbgr.mr_n74758000)
print v(xbgr.mr_n74758112)
print v(xbgr.mr_n74758432)
print v(xbgr.mr_n74758544)
print v(xbgr.mr_n74758864)
print v(xbgr.mr_n74758976)
print v(xbgr.mr_n74759408)
print v(xbgr.mr_n74759728)
print v(xbgr.mr_n74759840)
print v(xbgr.mr_n74760160)
print v(xbgr.mr_n74760272)
print v(xbgr.mr_n74760592)
print v(xbgr.mr_n74760704)
print v(xbgr.mr_n74761024)
print v(xbgr.mr_n74761136)
print v(xbgr.mr_n74761456)
print v(xbgr.mr_n74761568)
print v(xbgr.mr_n74761888)
print v(xbgr.mr_n74762000)
print v(xbgr.mr_n74762320)
print v(xbgr.mr_n74762432)
print v(xbgr.mr_n74762752)
print v(xbgr.mr_n74762864)
print v(xbgr.mr_n74763184)
print v(xbgr.mr_n74763296)
print v(xbgr.mr_n74763616)
print v(xbgr.mr_n74763728)
print v(xbgr.mr_n74764048)
print v(xbgr.mr_n74764160)
print v(xbgr.mr_n74764480)
print v(xbgr.mr_n74764592)
print v(xbgr.mr_n74764912)
print v(xbgr.mr_n74765024)
print v(xbgr.mr_n74765344)
print v(xbgr.mr_n74765456)
print v(xbgr.mr_n74765776)
print v(xbgr.mr_n74765888)
print v(xbgr.mr_n74766208)
print v(xbgr.mr_n74766320)
print v(xbgr.mr_n74766640)
print v(xbgr.mr_n74766752)
print v(xbgr.mr_n74767072)
print v(xbgr.mr_n74767184)
print v(xbgr.mr_n74767504)
print v(xbgr.mr_n74767616)
print v(xbgr.mr_n74767936)
print v(xbgr.mr_n74768048)
print v(xbgr.mr_n74768368)
print v(xbgr.mr_n74768480)
print v(xbgr.mr_n74768800)
print v(xbgr.mr_n74768912)
print v(xbgr.mr_n74769344)
print v(xbgr.mr_n74769664)
print v(xbgr.mr_n74769776)
print v(xbgr.mr_n74770096)
print v(xbgr.mr_n74770208)
print v(xbgr.mr_n74770528)
print v(xbgr.mr_n74770640)
print v(xbgr.mr_n74770960)
print v(xbgr.mr_n74771072)
print v(xbgr.mr_n74771392)
print v(xbgr.mr_n74771504)
print v(xbgr.mr_n74771824)
print v(xbgr.mr_n74771936)
print v(xbgr.mr_n74772256)
print v(xbgr.mr_n74772368)
print v(xbgr.mr_n74772688)
print v(xbgr.mr_n74772800)
print v(xbgr.mr_n74773120)
print v(xbgr.mr_n74773232)
print v(xbgr.mr_n74773552)
print v(xbgr.mr_n74773664)
print v(xbgr.mr_n74773984)
print v(xbgr.mr_n74774096)
print v(xbgr.mr_n74774416)
print v(xbgr.mr_n74774528)
print v(xbgr.mr_n74774960)
print v(xbgr.mr_n74775392)
print v(xbgr.mr_n74775824)
print v(xbgr.mr_n74776256)
print v(xbgr.mr_n74776688)
print v(xbgr.mr_n74777120)
print v(xbgr.mr_n74777552)
print v(xbgr.mr_n74777984)
print v(xbgr.mr_n74778416)
print v(xbgr.mr_n74778848)
print v(xbgr.mr_n74779280)
print v(xbgr.mr_n74779712)
print v(xbgr.mr_n74780144)
print v(xbgr.mr_n74780576)
print v(xbgr.mr_n74781008)
print v(xbgr.mr_n74781440)
print v(xbgr.mr_n74781872)
print v(xbgr.mr_n74782304)
print v(xbgr.mr_n74782736)
print v(xbgr.mr_n74783168)
print v(xbgr.mr_n74783600)
print v(xbgr.mr_n74784032)
print v(xbgr.mr_n74784464)
print v(xbgr.mr_n74784896)
print v(xbgr.mr_n74785328)
print v(xbgr.mr_n74785760)
print v(xbgr.mr_n74786192)
print v(xbgr.mr_n74786624)
print v(xbgr.mr_n74787056)
print v(xbgr.mr_n74787488)
print v(xbgr.mr_n74787920)
print v(xbgr.mr_n74788352)
print v(xbgr.mr_n74788784)
print v(xbgr.mr_n74789216)
print v(xbgr.mr_n74789648)
print v(xbgr.mr_n74790080)
print v(xbgr.mr_n74790512)
print v(xbgr.mr_n74790944)
print v(xbgr.mr_n74791376)
print v(xbgr.mr_n74791808)
print v(xbgr.mr_n74792240)
print v(xbgr.mr_n74792672)
print v(xbgr.mr_n74793104)
print v(xbgr.mr_n74793536)
print v(xbgr.mr_n74793968)
print v(xbgr.mr_n74794400)
print v(xbgr.mr_n74794832)
print v(xbgr.mr_n74795264)
print v(xbgr.mr_n74795696)
print v(xbgr.mr_n74796128)
print v(xbgr.mr_n74796560)
print v(xbgr.mr_n74796992)
print v(xbgr.mr_n74797424)
print v(xbgr.mr_n74797856)
print v(xbgr.mr_n74798288)
print v(xbgr.mr_n74798720)
print v(xbgr.mr_n74799152)
print v(xbgr.mr_n74799584)
print v(xbgr.mr_n74800016)
print v(xbgr.mr_n74800448)
print v(xbgr.mr_n74800880)
print v(xbgr.mr_n74801312)
print v(xbgr.mr_n74801744)
print v(xbgr.mr_n74802176)
print v(xbgr.mr_n74802608)
print v(xbgr.mr_n74803040)
print v(xbgr.mr_n74803472)
print v(xbgr.mr_n74803904)
print v(xbgr.mr_n74804336)
print v(xbgr.mr_n74804768)
print v(xbgr.mr_n74805200)
print v(xbgr.mr_n74805632)
print v(xbgr.mr_n74806064)
print v(xbgr.mr_n74806496)
print v(xbgr.mr_n74806928)
print v(xbgr.mr_n74807360)
print v(xbgr.mr_n74807792)
print v(xbgr.mr_n74808224)
print v(xbgr.mr_n74808656)
print v(xbgr.mr_n74809088)
print v(xbgr.mr_n74809520)
print v(xbgr.mr_n74809952)
print v(xbgr.mr_n74810384)
print v(xbgr.mr_n74810816)
print v(xbgr.mr_n74811248)
print v(xbgr.mr_n74811680)
print v(xbgr.mr_n74812112)
print v(xbgr.mr_n74812544)
print v(xbgr.mr_n74812976)
print v(xbgr.mr_n74813408)
print v(xbgr.mr_n74813840)
print v(xbgr.mr_n74814272)
print v(xbgr.mr_n74814704)
print v(xbgr.mr_n74815136)
print v(xbgr.mr_n74815568)
print v(xbgr.mr_n74816000)
print v(xbgr.mr_n74816432)
print v(xbgr.mr_n74816864)
print v(xbgr.mr_n74817296)
print v(xbgr.mr_n74817728)
print v(xbgr.mr_n74818160)
print v(xbgr.mr_n74818592)
print v(xbgr.mr_n74819024)
print v(xbgr.mr_n74819456)
print v(xbgr.mr_n74819888)
print v(xbgr.mr_n74820320)
print v(xbgr.mr_n74820752)
print v(xbgr.mr_n74821184)
print v(xbgr.mr_n74821616)
print v(xbgr.mr_n74822048)
print v(xbgr.mr_n74822368)
print v(xbgr.mr_n74822480)
print v(xbgr.mr_n74822800)
print v(xbgr.mr_n74822912)
print v(xbgr.mr_n74823232)
print v(xbgr.mr_n74823344)
print v(xbgr.mr_n74823664)
print v(xbgr.mr_n74823776)
print v(xbgr.mr_n74824096)
print v(xbgr.mr_n74824208)
print v(xbgr.mr_n74824528)
print v(xbgr.mr_n74824640)
print v(xbgr.mr_n74824960)
print v(xbgr.mr_n74825072)
print v(xbgr.mr_n74825392)
print v(xbgr.mr_n74825504)
print v(xbgr.mr_n74825824)
print v(xbgr.mr_n74825936)
print v(xbgr.mr_n74826256)
print v(xbgr.mr_n74826368)
print v(xbgr.mr_n74826688)
print v(xbgr.mr_n74826800)
print v(xbgr.mr_n74827120)
print v(xbgr.mr_n74827232)
print v(xbgr.mr_n74827552)
print v(xbgr.mr_n74827664)
print v(xbgr.mr_n74827984)
print v(xbgr.mr_n74828096)
print v(xbgr.mr_n74828416)
print v(xbgr.mr_n74828528)
print v(xbgr.mr_n74828848)
print v(xbgr.mr_n74828960)
print v(xbgr.mr_n74829280)
print v(xbgr.mr_n74829392)
print v(xbgr.mr_n74829712)
print v(xbgr.mr_n74829824)
print v(xbgr.mr_n74830144)
print v(xbgr.mr_n74830256)
print v(xbgr.mr_n74830576)
print v(xbgr.mr_n74830688)
print v(xbgr.mr_n74831008)
print v(xbgr.mr_n74831120)
print v(xbgr.mr_n74831440)
print v(xbgr.mr_n74831552)
print v(xbgr.mr_n74831872)
print v(xbgr.mr_n74831984)
print v(xbgr.mr_n74832304)
print v(xbgr.mr_n74832416)
print v(xbgr.mr_n74832736)
print v(xbgr.mr_n74832848)
print v(xbgr.mr_n74833168)
print v(xbgr.mr_n74833280)
print v(xbgr.mr_n74833600)
print v(xbgr.mr_n74833712)
print v(xbgr.mr_n74834032)
print v(xbgr.mr_n74834144)
print v(xbgr.mr_n74834464)
print v(xbgr.mr_n74834576)
print v(xbgr.mr_n74834896)
print v(xbgr.mr_n74835008)
print v(xbgr.mr_n74835328)
print v(xbgr.mr_n74835440)
print v(xbgr.mr_n74835760)
print v(xbgr.mr_n74835872)
print v(xbgr.mr_n74836192)
print v(xbgr.mr_n74836304)
print v(xbgr.mr_n74836624)
print v(xbgr.mr_n74836736)
print v(xbgr.mr_n74837056)
print v(xbgr.mr_n74837168)
print v(xbgr.mr_n74837488)
print v(xbgr.mr_n74837600)
print v(xbgr.mr_n74837920)
print v(xbgr.mr_n74838032)
print v(xbgr.mr_n74838352)
print v(xbgr.mr_n74838464)
print v(xbgr.mr_n74838784)
print v(xbgr.mr_n74838896)
print v(xbgr.mr_n74839216)
print v(xbgr.mr_n74839328)
print v(xbgr.mr_n74839648)
print v(xbgr.mr_n74839760)
print v(xbgr.mr_n74840080)
print v(xbgr.mr_n74840192)
print v(xbgr.mr_n74840512)
print v(xbgr.mr_n74840624)
print v(xbgr.mr_n74840944)
print v(xbgr.mr_n74841056)
print v(xbgr.mr_n74841376)
print v(xbgr.mr_n74841488)
print v(xbgr.mr_n74841808)
print v(xbgr.mr_n74841920)
print v(xbgr.mr_n74842240)
print v(xbgr.mr_n74842352)
print v(xbgr.mr_n74842672)
print v(xbgr.mr_n74842784)
print v(xbgr.mr_n74843104)
print v(xbgr.mr_n74843216)
print v(xbgr.mr_n74843536)
print v(xbgr.mr_n74843648)
print v(xbgr.mr_n74844080)
print v(xbgr.mr_n74844400)
print v(xbgr.mr_n74844512)
print v(xbgr.mr_n74844832)
print v(xbgr.mr_n74844944)
print v(xbgr.mr_n74845264)
print v(xbgr.mr_n74845376)
print v(xbgr.mr_n74845696)
print v(xbgr.mr_n74845808)
print v(xbgr.mr_n74846128)
print v(xbgr.mr_n74846240)
print v(xbgr.mr_n74846560)
print v(xbgr.mr_n74846672)
print v(xbgr.mr_n74846992)
print v(xbgr.mr_n74847104)
print v(xbgr.mr_n74847424)
print v(xbgr.mr_n74847536)
print v(xbgr.mr_n74847856)
print v(xbgr.mr_n74847968)
print v(xbgr.mr_n74848288)
print v(xbgr.mr_n74848400)
print v(xbgr.mr_n74848720)
print v(xbgr.mr_n74848832)
print v(xbgr.mr_n74849152)
print v(xbgr.mr_n74849264)
print v(xbgr.mr_n74849584)
print v(xbgr.mr_n74849696)
print v(xbgr.mr_n74850016)
print v(xbgr.mr_n74850128)
print v(xbgr.mr_n74850448)
print v(xbgr.mr_n74850560)
print v(xbgr.mr_n74850880)
print v(xbgr.mr_n74850992)
print v(xbgr.mr_n74851440)
print v(xbgr.mr_n74851552)
print v(xbgr.mr_n74851872)
print v(xbgr.mr_n74851984)
print v(xbgr.mr_n74852304)
print v(xbgr.mr_n74852416)
print v(xbgr.mr_n74852736)
print v(xbgr.mr_n74852848)
print v(xbgr.mr_n74853168)
print v(xbgr.mr_n74853280)
print v(xbgr.mr_n74853600)
print v(xbgr.mr_n74853712)
print v(xbgr.mr_n74854032)
print v(xbgr.mr_n74854144)
print v(xbgr.mr_n74854464)
print v(xbgr.mr_n74854576)
print v(xbgr.mr_n74854896)
print v(xbgr.mr_n74855008)
print v(xbgr.mr_n74855328)
print v(xbgr.mr_n74855440)
print v(xbgr.mr_n74855760)
print v(xbgr.mr_n74855872)
print v(xbgr.mr_n74856192)
print v(xbgr.mr_n74856304)
print v(xbgr.mr_n74856624)
print v(xbgr.mr_n74856736)
print v(xbgr.mr_n74857056)
print v(xbgr.mr_n74857168)
print v(xbgr.mr_n74857488)
print v(xbgr.mr_n74857600)
print v(xbgr.mr_n74857920)
print v(xbgr.mr_n74858032)
print v(xbgr.mr_n74858464)
print v(xbgr.mr_n74858896)
print v(xbgr.mr_n74859216)
print v(xbgr.mr_n74859328)
print v(xbgr.mr_n74859648)
print v(xbgr.mr_n74859760)
print v(xbgr.mr_n74860080)
print v(xbgr.mr_n74860192)
print v(xbgr.mr_n74860512)
print v(xbgr.mr_n74860624)
print v(xbgr.mr_n74860944)
print v(xbgr.mr_n74861056)
print v(xbgr.mr_n74861376)
print v(xbgr.mr_n74861488)
print v(xbgr.mr_n74861920)
print v(xbgr.mr_n74862240)
print v(xbgr.mr_n74862352)
print v(xbgr.mr_n74862672)
print v(xbgr.mr_n74862784)
print v(xbgr.mr_n74863104)
print v(xbgr.mr_n74863216)
print v(xbgr.mr_n74863536)
print v(xbgr.mr_n74863648)
print v(xbgr.mr_n74863968)
print v(xbgr.mr_n74864080)
print v(xbgr.mr_n74864400)
print v(xbgr.mr_n74864512)
print v(xbgr.mr_n74864832)
print v(xbgr.mr_n74864944)
print v(xbgr.mr_n74865264)
print v(xbgr.mr_n74865376)
print v(xbgr.mr_n74865696)
print v(xbgr.mr_n74865808)
print v(xbgr.mr_n74866128)
print v(xbgr.mr_n74866240)
print v(xbgr.mr_n74866560)
print v(xbgr.mr_n74866672)
print v(xbgr.mr_n74866992)
print v(xbgr.mr_n74867104)
print v(xbgr.mr_n74867536)
print v(xbgr.mr_n74867968)
print v(xbgr.mr_n74868400)
print v(xbgr.mr_n74868832)
print v(xbgr.mr_n74869360)
print v(xbgr.mr_n74869472)
print v(xbgr.mr_n74869808)
print v(xbgr.mr_n74869920)
print v(xbgr.mr_n74870240)
print v(xbgr.mr_n74870352)
print v(xbgr.mr_n74870720)
print v(xbgr.mr_n74870832)
print v(xbgr.mr_n74871152)
print v(xbgr.mr_n74871264)
print v(xbgr.mr_n74871584)
print v(xbgr.mr_n74871696)
print v(xbgr.mr_n74871936)
print v(xbgr.mr_n74872048)
print v(xbgr.mr_n74872368)
print v(xbgr.mr_n74872480)
print v(xbgr.mr_n74872800)
print v(xbgr.mr_n74872912)
print v(xbgr.mr_n74873232)
print v(xbgr.mr_n74873344)
print v(xbgr.mr_n74873664)
print v(xbgr.mr_n74873776)
print v(xbgr.mr_n74874096)
print v(xbgr.mr_n74874208)
print v(xbgr.mr_n74874528)
print v(xbgr.mr_n74874640)
print v(xbgr.mr_n74874960)
print v(xbgr.mr_n74875072)
print v(xbgr.mr_n74875392)
print v(xbgr.mr_n74875504)
print v(xbgr.mr_n74875824)
print v(xbgr.mr_n74875936)
print v(xbgr.mr_n74876256)
print v(xbgr.mr_n74876368)
print v(xbgr.mr_n74876688)
print v(xbgr.mr_n74876800)
print v(xbgr.mr_n74877120)
print v(xbgr.mr_n74877232)
print v(xbgr.mr_n74877552)
print v(xbgr.mr_n74877664)
print v(xbgr.mr_n74877984)
print v(xbgr.mr_n74878096)
print v(xbgr.mr_n74878416)
print v(xbgr.mr_n74878528)
print v(xbgr.mr_n74878848)
print v(xbgr.mr_n74878960)
print v(xbgr.mr_n74879280)
print v(xbgr.mr_n74879392)
print v(xbgr.mr_n74879712)
print v(xbgr.mr_n74879824)
print v(xbgr.mr_n74880144)
print v(xbgr.mr_n74880256)
print v(xbgr.mr_n74880576)
print v(xbgr.mr_n74880688)
print v(xbgr.mr_n74881008)
print v(xbgr.mr_n74881120)
print v(xbgr.mr_n74881440)
print v(xbgr.mr_n74881552)
print v(xbgr.mr_n74881872)
print v(xbgr.mr_n74881984)
print v(xbgr.mr_n74882304)
print v(xbgr.mr_n74882416)
print v(xbgr.mr_n74882848)
print v(xbgr.mr_n74883168)
print v(xbgr.mr_n74884128)
print v(xbgr.mr_n74884240)
print v(xbgr.mr_n74884560)
print v(xbgr.mr_n74884672)
print v(xbgr.mr_n74884992)
print v(xbgr.mr_n74885104)
print v(xbgr.mr_n74885536)
print v(xbgr.mr_n74885856)
print v(xbgr.mr_n74885968)
print v(xbgr.mr_n74886288)
print v(xbgr.mr_n74886400)
print v(xbgr.mr_n74886720)
print v(xbgr.mr_n74886832)
print v(xbgr.mr_n74887152)
print v(xbgr.mr_n74887264)
print v(xbgr.mr_n74887584)
print v(xbgr.mr_n74887696)
print v(xbgr.mr_n74888128)
print v(xbgr.mr_n74888560)
print v(xbgr.mr_n74888992)
print v(xbgr.mr_n74889424)
print v(xbgr.mr_n74889744)
print v(xbgr.mr_n74889856)
print v(xbgr.mr_n74890176)
print v(xbgr.mr_n74890288)
print v(xbgr.mr_n74890608)
print v(xbgr.mr_n74890720)
print v(xbgr.mr_n74891152)
print v(xbgr.mr_n74891584)
print v(xbgr.mr_n74891904)
print v(xbgr.mr_n74892016)
print v(xbgr.mr_n74892336)
print v(xbgr.mr_n74892448)
print v(xbgr.mr_n74892768)
print v(xbgr.mr_n74892880)
print v(xbgr.mr_n74893200)
print v(xbgr.mr_n74893312)
print v(xbgr.mr_n74893744)
print v(xbgr.mr_n74894176)
print v(xbgr.mr_n74894608)
print v(xbgr.mr_n74895040)
print v(xbgr.mr_n74895472)
print v(xbgr.mr_n74895792)
print v(xbgr.mr_n74895904)
print v(xbgr.mr_n74896224)
print v(xbgr.mr_n74896336)
print v(xbgr.mr_n74896656)
print v(xbgr.mr_n74896768)
print v(xbgr.mr_n74897088)
print v(xbgr.mr_n74897200)
print v(xbgr.mr_n74897520)
print v(xbgr.mr_n74897632)
print v(xbgr.mr_n74897952)
print v(xbgr.mr_n74898064)
print v(xbgr.mr_n74898384)
print v(xbgr.mr_n74898496)
print v(xbgr.mr_n74898816)
print v(xbgr.mr_n74898928)
print v(xbgr.mr_n74899248)
print v(xbgr.mr_n74899360)
print v(xbgr.mr_n74899680)
print v(xbgr.mr_n74899792)
print v(xbgr.mr_n74900112)
print v(xbgr.mr_n74900224)
print v(xbgr.mr_n74900544)
print v(xbgr.mr_n74900656)
print v(xbgr.mr_n74901088)
print v(xbgr.mr_n74901408)
print v(xbgr.mr_n74901520)
print v(xbgr.mr_n74901840)
print v(xbgr.mr_n74901952)
print v(xbgr.mr_n74902272)
print v(xbgr.mr_n74902384)
print v(xbgr.mr_n74902704)
print v(xbgr.mr_n74902816)
print v(xbgr.mr_n74903136)
print v(xbgr.mr_n74903248)
print v(xbgr.mr_n74903680)
print v(xbgr.mr_n74904112)
print v(xbgr.mr_n74904544)
print v(xbgr.mr_n74904976)
print v(xbgr.mr_n74905296)
print v(xbgr.mr_n74905408)
print v(xbgr.mr_n74905728)
print v(xbgr.mr_n74905840)
print v(xbgr.mr_n74906160)
print v(xbgr.mr_n74906272)
print v(xbgr.mr_n74906592)
print v(xbgr.mr_n74906704)
print v(xbgr.mr_n74907024)
print v(xbgr.mr_n74907136)
print v(xbgr.mr_n74907456)
print v(xbgr.mr_n74907568)
print v(xbgr.mr_n74907888)
print v(xbgr.mr_n74908000)
print v(xbgr.mr_n74908320)
print v(xbgr.mr_n74908432)
print v(xbgr.mr_n74908752)
print v(xbgr.mr_n74908864)
print v(xbgr.mr_n74909184)
print v(xbgr.mr_n74909296)
print v(xbgr.mr_n74909616)
print v(xbgr.mr_n74909728)
print v(xbgr.mr_n74910048)
print v(xbgr.mr_n74910160)
print v(xbgr.mr_n74910480)
print v(xbgr.mr_n74910592)
print v(xbgr.mr_n74910912)
print v(xbgr.mr_n74911024)
print v(xbgr.mr_n74911344)
print v(xbgr.mr_n74911456)
print v(xbgr.mr_n74911776)
print v(xbgr.mr_n74911888)
print v(xbgr.mr_n74912208)
print v(xbgr.mr_n74912320)
print v(xbgr.mr_n74912640)
print v(xbgr.mr_n74912752)
print v(xbgr.mr_n74913072)
print v(xbgr.mr_n74913184)
print v(xbgr.mr_n74913504)
print v(xbgr.mr_n74913616)
print v(xbgr.mr_n74913936)
print v(xbgr.mr_n74914048)
print v(xbgr.mr_n74914368)
print v(xbgr.mr_n74914480)
print v(xbgr.mr_n74914800)
print v(xbgr.mr_n74914912)
print v(xbgr.mr_n74915232)
print v(xbgr.mr_n74915344)
print v(xbgr.mr_n74915664)
print v(xbgr.mr_n74915776)
print v(xbgr.mr_n74916096)
print v(xbgr.mr_n74916208)
print v(xbgr.mr_n74916528)
print v(xbgr.mr_n74916640)
print v(xbgr.mr_n74916960)
print v(xbgr.mr_n74917072)
print v(xbgr.mr_n74917392)
print v(xbgr.mr_n74917504)
print v(xbgr.mr_n74917824)
print v(xbgr.mr_n74917936)
print v(xbgr.mr_n74918256)
print v(xbgr.mr_n74918368)
print v(xbgr.mr_n74918688)
print v(xbgr.mr_n74918800)
print v(xbgr.mr_n74919120)
print v(xbgr.mr_n74919232)
print v(xbgr.mr_n74919552)
print v(xbgr.mr_n74919664)
print v(xbgr.mr_n74919984)
print v(xbgr.mr_n74920096)
print v(xbgr.mr_n74920416)
print v(xbgr.mr_n74920528)
print v(xbgr.mr_n74920848)
print v(xbgr.mr_n74920960)
print v(xbgr.mr_n74921280)
print v(xbgr.mr_n74921392)
print v(xbgr.mr_n74921712)
print v(xbgr.mr_n74921824)
print v(xbgr.mr_n74922144)
print v(xbgr.mr_n74922256)
print v(xbgr.mr_n74922576)
print v(xbgr.mr_n74922688)
print v(xbgr.mr_n74923008)
print v(xbgr.mr_n74923120)
print v(xbgr.mr_n74923440)
print v(xbgr.mr_n74923552)
print v(xbgr.mr_n74923872)
print v(xbgr.mr_n74923984)
print v(xbgr.mr_n74924416)
print v(xbgr.mr_n74924848)
print v(xbgr.mr_n74925168)
print v(xbgr.mr_n74925280)
print v(xbgr.mr_n74925600)
print v(xbgr.mr_n74925712)
print v(xbgr.mr_n74926032)
print v(xbgr.mr_n74926144)
print v(xbgr.mr_n74926464)
print v(xbgr.mr_n74926576)
print v(xbgr.mr_n74927008)
print v(xbgr.mr_n74927440)
print v(xbgr.mr_n74927760)
print v(xbgr.mr_n74927872)
print v(xbgr.mr_n74928192)
print v(xbgr.mr_n74928304)
print v(xbgr.mr_n74928624)
print v(xbgr.mr_n74928736)
print v(xbgr.mr_n74929056)
print v(xbgr.mr_n74929168)
print v(xbgr.mr_n74929600)
print v(xbgr.mr_n74930032)
print v(xbgr.mr_n74930464)
print v(xbgr.mr_n74930896)
print v(xbgr.mr_n74931328)
print v(xbgr.mr_n74931760)
print v(xbgr.mr_n74932192)
print v(xbgr.mr_n74932624)
print v(xbgr.mr_n74933056)
print v(xbgr.mr_n74933488)
print v(xbgr.mr_n74933920)
print v(xbgr.mr_n74934352)
print v(xbgr.mr_n74934672)
print v(xbgr.mr_n74935104)
print v(xbgr.mr_n74935536)
print v(xbgr.mr_n74935968)
print v(xbgr.mr_n74936400)
print v(xbgr.mr_n74936832)
print v(xbgr.mr_n74937264)
print v(xbgr.mr_n74937696)
print v(xbgr.mr_n74938128)
print v(xbgr.mr_n74938240)
print v(xbgr.mr_n74938560)
print v(xbgr.mr_n74938672)
print v(xbgr.mr_n74938992)
print v(xbgr.mr_n74939104)
print v(xbgr.mr_n74939424)
print v(xbgr.mr_n74939536)
print v(xbgr.mr_n74939856)
print v(xbgr.mr_n74939968)
print v(xbgr.mr_n74940288)
print v(xbgr.mr_n74940400)
print v(xbgr.mr_n74940720)
print v(xbgr.mr_n74940832)
print v(xbgr.mr_n74941152)
print v(xbgr.mr_n74941264)
print v(xbgr.mr_n74941584)
print v(xbgr.mr_n74942016)
print v(xbgr.mr_n74942448)
print v(xbgr.mr_n74942880)
print v(xbgr.mr_n74943312)
print v(xbgr.mr_n74943744)
print v(xbgr.mr_n74944176)
print v(xbgr.mr_n74944608)
print v(xbgr.mr_n74945040)
print v(xbgr.mr_n74945472)
print v(xbgr.mr_n74946016)
print v(xbgr.mr_n74946448)
print v(xbgr.mr_n74946880)
print v(xbgr.mr_n74947312)
print v(xbgr.mr_n74947744)
print v(xbgr.mr_n74948176)
print v(xbgr.mr_n74948608)
print v(xbgr.mr_n74949040)
print v(xbgr.mr_n74949472)
print v(xbgr.mr_n74949904)
print v(xbgr.mr_n74950336)
print v(xbgr.mr_n74950768)
print v(xbgr.mr_n74951200)
print v(xbgr.mr_n74951632)
print v(xbgr.mr_n74952064)
print v(xbgr.mr_n74952496)
print v(xbgr.mr_n74952928)
print v(xbgr.mr_n74953360)
print v(xbgr.mr_n74953792)
print v(xbgr.mr_n74954224)
print v(xbgr.mr_n74954656)
print v(xbgr.mr_n74955088)
print v(xbgr.mr_n74955520)
print v(xbgr.mr_n74955952)
print v(xbgr.mr_n74956384)
print v(xbgr.mr_n74956816)
print v(xbgr.mr_n74957248)
print v(xbgr.mr_n74957680)
print v(xbgr.mr_n74958112)
print v(xbgr.mr_n74958544)
print v(xbgr.mr_n74958976)
print v(xbgr.mr_n74959408)
print v(xbgr.mr_n74959840)
print v(xbgr.mr_n74960272)
print v(xbgr.mr_n74960704)
print v(xbgr.mr_n74961136)
print v(xbgr.mr_n74961568)
print v(xbgr.mr_n74962000)
print v(xbgr.mr_n74962432)
print v(xbgr.mr_n74962864)
print v(xbgr.mr_n74963296)
print v(xbgr.mr_n74963728)
print v(xbgr.mr_n74964160)
print v(xbgr.mr_n74964592)
print v(xbgr.mr_n74965024)
print v(xbgr.mr_n74965456)
print v(xbgr.mr_n74965888)
print v(xbgr.mr_n74966320)
print v(xbgr.mr_n74966752)
print v(xbgr.mr_n74967184)
print v(xbgr.mr_n74967616)
print v(xbgr.mr_n74968048)
print v(xbgr.mr_n74968480)
print v(xbgr.mr_n74968912)
print v(xbgr.mr_n74969344)
print v(xbgr.mr_n74969776)
print v(xbgr.mr_n74970208)
print v(xbgr.mr_n74970640)
print v(xbgr.mr_n74971072)
print v(xbgr.mr_n74971504)
print v(xbgr.mr_n74971936)
print v(xbgr.mr_n74972368)
print v(xbgr.mr_n74972800)
print v(xbgr.mr_n74973232)
print v(xbgr.mr_n74973552)
print v(xbgr.mr_n74973984)
print v(xbgr.mr_n74974416)
print v(xbgr.mr_n74974848)
print v(xbgr.mr_n74975280)
print v(xbgr.mr_n74975712)
print v(xbgr.mr_n74976256)
print v(xbgr.mr_n74976688)
print v(xbgr.mr_n74977120)
print v(xbgr.mr_n74977552)
print v(xbgr.mr_n74977984)
print v(xbgr.mr_n74978416)
print v(xbgr.mr_n74978848)
print v(xbgr.mr_n74979280)
print v(xbgr.mr_n74979712)
print v(xbgr.mr_n74980144)
print v(xbgr.mr_n74980576)
print v(xbgr.mr_n74981008)
print v(xbgr.mr_n74981440)
print v(xbgr.mr_n74981872)
print v(xbgr.mr_n74982304)
print v(xbgr.mr_n74982736)
print v(xbgr.mr_n74983168)
print v(xbgr.mr_n74983600)
print v(xbgr.mr_n74984032)
print v(xbgr.mr_n74984464)
print v(xbgr.mr_n74984896)
print v(xbgr.mr_n74985328)
print v(xbgr.mr_n74985760)
print v(xbgr.mr_n74986192)
print v(xbgr.mr_n74986624)
print v(xbgr.mr_n74987056)
print v(xbgr.mr_n74987376)
print v(xbgr.mr_n74987488)
print v(xbgr.mr_n74987808)
print v(xbgr.mr_n74987920)
print v(xbgr.mr_n74988240)
print v(xbgr.mr_n74988352)
print v(xbgr.mr_n74988672)
print v(xbgr.mr_n74988784)
print v(xbgr.mr_n74989104)
print v(xbgr.mr_n74989216)
print v(xbgr.mr_n74989536)
print v(xbgr.mr_n74989648)
print v(xbgr.mr_n74989968)
print v(xbgr.mr_n74990080)
print v(xbgr.mr_n74990400)
print v(xbgr.mr_n74990512)
print v(xbgr.mr_n74990832)
print v(xbgr.mr_n74990944)
print v(xbgr.mr_n74991264)
print v(xbgr.mr_n74991376)
print v(xbgr.mr_n74991696)
print v(xbgr.mr_n74991808)
print v(xbgr.mr_n74992128)
print v(xbgr.mr_n74992240)
print v(xbgr.mr_n74992560)
print v(xbgr.mr_n74992672)
print v(xbgr.mr_n74992992)
print v(xbgr.mr_n74993104)
print v(xbgr.mr_n74993424)
print v(xbgr.mr_n74993536)
print v(xbgr.mr_n74993856)
print v(xbgr.mr_n74994288)
print v(xbgr.mr_n74994400)
print v(xbgr.mr_n74994720)
print v(xbgr.mr_n74995152)
print v(xbgr.mr_n74995264)
print v(xbgr.mr_n74995584)
print v(xbgr.mr_n74995696)
print v(xbgr.mr_n74996016)
print v(xbgr.mr_n74996128)
print v(xbgr.mr_n74996448)
print v(xbgr.mr_n74996560)
print v(xbgr.mr_n74996880)
print v(xbgr.mr_n74996992)
print v(xbgr.mr_n74997312)
print v(xbgr.mr_n74997424)
print v(xbgr.mr_n74997744)
print v(xbgr.mr_n74997856)
print v(xbgr.mr_n74998176)
print v(xbgr.mr_n74998608)
print v(xbgr.mr_n74998720)
print v(xbgr.mr_n74999040)
print v(xbgr.mr_n74999152)
print v(xbgr.mr_n74999472)
print v(xbgr.mr_n74999584)
print v(xbgr.mr_n74999904)
print v(xbgr.mr_n75000336)
print v(xbgr.mr_n75000448)
print v(xbgr.mr_n75000768)
print v(xbgr.mr_n75000880)
print v(xbgr.mr_n75001200)
print v(xbgr.mr_n75001312)
print v(xbgr.mr_n75001632)
print v(xbgr.mr_n75001744)
print v(xbgr.mr_n75002064)
print v(xbgr.mr_n75002176)
print v(xbgr.mr_n75002496)
print v(xbgr.mr_n75002608)
print v(xbgr.mr_n75002928)
print v(xbgr.mr_n75003040)
print v(xbgr.mr_n75003360)
print v(xbgr.mr_n75003792)
print v(xbgr.mr_n75003904)
print v(xbgr.mr_n75004224)
print v(xbgr.mr_n75004336)
print v(xbgr.mr_n75004656)
print v(xbgr.mr_n75004768)
print v(xbgr.mr_n75005088)
print v(xbgr.mr_n75005200)
print v(xbgr.mr_n75005520)
print v(xbgr.mr_n75005632)
print v(xbgr.mr_n75005952)
print v(xbgr.mr_n75006064)
print v(xbgr.mr_n75006384)
print v(xbgr.mr_n75006496)
print v(xbgr.mr_n75006816)
print v(xbgr.mr_n75006928)
print v(xbgr.mr_n75007248)
print v(xbgr.mr_n75007360)
print v(xbgr.mr_n75007680)
print v(xbgr.mr_n75007792)
print v(xbgr.mr_n75008112)
print v(xbgr.mr_n75008224)
print v(xbgr.mr_n75008544)
print v(xbgr.mr_n75008656)
print v(xbgr.mr_n75008976)
print v(xbgr.mr_n75009088)
print v(xbgr.mr_n75009408)
print v(xbgr.mr_n75009840)
print v(xbgr.mr_n75009952)
print v(xbgr.mr_n75010272)
print v(xbgr.mr_n75010384)
print v(xbgr.mr_n75010704)
print v(xbgr.mr_n75010816)
print v(xbgr.mr_n75011136)
print v(xbgr.mr_n75011248)
print v(xbgr.mr_n75011568)
print v(xbgr.mr_n75011680)
print v(xbgr.mr_n75012000)
print v(xbgr.mr_n75012112)
print v(xbgr.mr_n75012432)
print v(xbgr.mr_n75012544)
print v(xbgr.mr_n75012864)
print v(xbgr.mr_n75013296)
print v(xbgr.mr_n75013408)
print v(xbgr.mr_n75013728)
print v(xbgr.mr_n75014160)
print v(xbgr.mr_n75014272)
print v(xbgr.mr_n75014592)
print v(xbgr.mr_n75014704)
print v(xbgr.mr_n75015024)
print v(xbgr.mr_n75015136)
print v(xbgr.mr_n75015456)
print v(xbgr.mr_n75015568)
print v(xbgr.mr_n75015888)
print v(xbgr.mr_n75016000)
print v(xbgr.mr_n75016320)
print v(xbgr.mr_n75016432)
print v(xbgr.mr_n75016752)
print v(xbgr.mr_n75016864)
print v(xbgr.mr_n75017184)
print v(xbgr.mr_n75017296)
print v(xbgr.mr_n75017616)
print v(xbgr.mr_n75017728)
print v(xbgr.mr_n75018048)
print v(xbgr.mr_n75018160)
print v(xbgr.mr_n75018480)
print v(xbgr.mr_n75018592)
print v(xbgr.mr_n75018912)
print v(xbgr.mr_n75019024)
print v(xbgr.mr_n75019456)
print v(xbgr.mr_n75019888)
print v(xbgr.mr_n75020320)
print v(xbgr.mr_n75020752)
print v(xbgr.mr_n75021184)
print v(xbgr.mr_n75021616)
print v(xbgr.mr_n75022048)
print v(xbgr.mr_n75022480)
print v(xbgr.mr_n75022912)
print v(xbgr.mr_n75023344)
print v(xbgr.mr_n75023776)
print v(xbgr.mr_n75024208)
print v(xbgr.mr_n75024640)
print v(xbgr.mr_n75025072)
print v(xbgr.mr_n75025504)
print v(xbgr.mr_n75025936)
print v(xbgr.mr_n75026368)
print v(xbgr.mr_n75026800)
print v(xbgr.mr_n75027232)
print v(xbgr.mr_n75027664)
print v(xbgr.mr_n75028096)
print v(xbgr.mr_n75028528)
print v(xbgr.mr_n75028960)
print v(xbgr.mr_n75029392)
print v(xbgr.mr_n75029824)
print v(xbgr.mr_n75030256)
print v(xbgr.mr_n75030688)
print v(xbgr.mr_n75031120)
print v(xbgr.mr_n75031552)
print v(xbgr.mr_n75031984)
print v(xbgr.mr_n75032416)
print v(xbgr.mr_n75032848)
print v(xbgr.mr_n75033280)
print v(xbgr.mr_n75033712)
print v(xbgr.mr_n75034144)
print v(xbgr.mr_n75034576)
print v(xbgr.mr_n75035008)
print v(xbgr.mr_n75035440)
print v(xbgr.mr_n75035872)
print v(xbgr.mr_n75036304)
print v(xbgr.mr_n75036736)
print v(xbgr.mr_n75037168)
print v(xbgr.mr_n75037600)
print v(xbgr.mr_n75038032)
print v(xbgr.mr_n75038464)
print v(xbgr.mr_n75038896)
print v(xbgr.mr_n75039328)
print v(xbgr.mr_n75039760)
print v(xbgr.mr_n75040192)
print v(xbgr.mr_n75040624)
print v(xbgr.mr_n75041056)
print v(xbgr.mr_n75041488)
print v(xbgr.mr_n75041920)
print v(xbgr.mr_n75042352)
print v(xbgr.mr_n75042784)
print v(xbgr.mr_n75043216)
print v(xbgr.mr_n75043648)
print v(xbgr.mr_n75044080)
print v(xbgr.mr_n75044512)
print v(xbgr.mr_n75044944)
print v(xbgr.mr_n75045376)
print v(xbgr.mr_n75045808)
print v(xbgr.mr_n75046240)
print v(xbgr.mr_n75046672)
print v(xbgr.mr_n75047104)
print v(xbgr.mr_n75047536)
print v(xbgr.mr_n75047968)
print v(xbgr.mr_n75048400)
print v(xbgr.mr_n75048832)
print v(xbgr.mr_n75049264)
print v(xbgr.mr_n75049696)
print v(xbgr.mr_n75050128)
print v(xbgr.mr_n75050560)
print v(xbgr.mr_n75050992)
print v(xbgr.mr_n75051424)
print v(xbgr.mr_n75051856)
print v(xbgr.mr_n75052288)
print v(xbgr.mr_n75052720)
print v(xbgr.mr_n75053040)
print v(xbgr.mr_n75053152)
print v(xbgr.mr_n75053472)
print v(xbgr.mr_n75053584)
print v(xbgr.mr_n75054016)
print v(xbgr.mr_n75054448)
print v(xbgr.mr_n75054768)
print v(xbgr.mr_n75054880)
print v(xbgr.mr_n75055200)
print v(xbgr.mr_n75055744)
print v(xbgr.mr_n75056176)
print v(xbgr.mr_n75056496)
print v(xbgr.mr_n75056608)
print v(xbgr.mr_n75056928)
print v(xbgr.mr_n75057040)
print v(xbgr.mr_n75057360)
print v(xbgr.mr_n75057472)
print v(xbgr.mr_n75057792)
print v(xbgr.mr_n75057904)
print v(xbgr.mr_n75058224)
print v(xbgr.mr_n75058336)
print v(xbgr.mr_n75058656)
print v(xbgr.mr_n75058768)
print v(xbgr.mr_n75059088)
print v(xbgr.mr_n75059200)
print v(xbgr.mr_n75059520)
print v(xbgr.mr_n75059632)
print v(xbgr.mr_n75059952)
print v(xbgr.mr_n75060064)
print v(xbgr.mr_n75060384)
print v(xbgr.mr_n75060496)
print v(xbgr.mr_n75060816)
print v(xbgr.mr_n75060928)
print v(xbgr.mr_n75061248)
print v(xbgr.mr_n75061360)
print v(xbgr.mr_n75061792)
print v(xbgr.mr_n75062224)
print v(xbgr.mr_n75062544)
print v(xbgr.mr_n75062656)
print v(xbgr.mr_n75062976)
print v(xbgr.mr_n75063088)
print v(xbgr.mr_n75063520)
print v(xbgr.mr_n75063952)
print v(xbgr.mr_n75064384)
print v(xbgr.mr_n75064816)
print v(xbgr.mr_n75065248)
print v(xbgr.mr_n75065680)
print v(xbgr.mr_n75066112)
print v(xbgr.mr_n75066544)
print v(xbgr.mr_n75066976)
print v(xbgr.mr_n75067408)
print v(xbgr.mr_n75067840)
print v(xbgr.mr_n75068272)
print v(xbgr.mr_n75068704)
print v(xbgr.mr_n75069136)
print v(xbgr.mr_n75069568)
print v(xbgr.mr_n75070000)
print v(xbgr.mr_n75070432)
print v(xbgr.mr_n75070864)
print v(xbgr.mr_n75071296)
print v(xbgr.mr_n75071728)
print v(xbgr.mr_n75072160)
print v(xbgr.mr_n75072592)
print v(xbgr.mr_n75073024)
print v(xbgr.mr_n75073456)
print v(xbgr.mr_n75073888)
print v(xbgr.mr_n75074320)
print v(xbgr.mr_n75074752)
print v(xbgr.mr_n75075184)
print v(xbgr.mr_n75075616)
print v(xbgr.mr_n75076048)
print v(xbgr.mr_n75076480)
print v(xbgr.mr_n75076912)
print v(xbgr.mr_n75077344)
print v(xbgr.mr_n75077776)
print v(xbgr.mr_n75078208)
print v(xbgr.mr_n75078640)
print v(xbgr.mr_n75079072)
print v(xbgr.mr_n75079504)
print v(xbgr.mr_n75079936)
print v(xbgr.mr_n75080368)
print v(xbgr.mr_n75080800)
print v(xbgr.mr_n75081232)
print v(xbgr.mr_n75081664)
print v(xbgr.mr_n75082096)
print v(xbgr.mr_n75082528)
print v(xbgr.mr_n75082960)
print v(xbgr.mr_n75083392)
print v(xbgr.mr_n75083824)
print v(xbgr.mr_n75084256)
print v(xbgr.mr_n75084688)
print v(xbgr.mr_n75085120)
print v(xbgr.mr_n75085552)
print v(xbgr.mr_n75085984)
print v(xbgr.mr_n75086416)
print v(xbgr.mr_n75086848)
print v(xbgr.mr_n75087280)
print v(xbgr.mr_n75087712)
print v(xbgr.mr_n75088144)
print v(xbgr.mr_n75088576)
print v(xbgr.mr_n75089008)
print v(xbgr.mr_n75089440)
print v(xbgr.mr_n75089872)
print v(xbgr.mr_n75090304)
print v(xbgr.mr_n75090736)
print v(xbgr.mr_n75091168)
print v(xbgr.mr_n75091600)
print v(xbgr.mr_n75092032)
print v(xbgr.mr_n75092464)
print v(xbgr.mr_n75092896)
print v(xbgr.mr_n75093328)
print v(xbgr.mr_n75093760)
print v(xbgr.mr_n75094192)
print v(xbgr.mr_n75094624)
print v(xbgr.mr_n75095056)
print v(xbgr.mr_n75095488)
print v(xbgr.mr_n75095920)
print v(xbgr.mr_n75096352)
print v(xbgr.mr_n75096784)
print v(xbgr.mr_n75097216)
print v(xbgr.mr_n75097648)
print v(xbgr.mr_n75098080)
print v(xbgr.mr_n75098512)
print v(xbgr.mr_n75098944)
print v(xbgr.mr_n75099376)
print v(xbgr.mr_n75099808)
print v(xbgr.mr_n75100240)
print v(xbgr.mr_n75100672)
print v(xbgr.mr_n75101104)
print v(xbgr.mr_n75101536)
print v(xbgr.mr_n75101968)
print v(xbgr.mr_n75102400)
print v(xbgr.mr_n75102832)
print v(xbgr.mr_n75103264)
print v(xbgr.mr_n75103696)
print v(xbgr.mr_n75104128)
print v(xbgr.mr_n75104560)
print v(xbgr.mr_n75104992)
print v(xbgr.mr_n75105424)
print v(xbgr.mr_n75105856)
print v(xbgr.mr_n75106288)
print v(xbgr.mr_n75106720)
print v(xbgr.mr_n75107152)
print v(xbgr.mr_n75107584)
print v(xbgr.mr_n75108016)
print v(xbgr.mr_n75108448)
print v(xbgr.mr_n75108880)
print v(xbgr.mr_n75109312)
print v(xbgr.mr_n75109744)
print v(xbgr.mr_n75110176)
print v(xbgr.mr_n75110608)
print v(xbgr.mr_n75111040)
print v(xbgr.mr_n75111472)
print v(xbgr.mr_n75111904)
print v(xbgr.mr_n75112336)
print v(xbgr.mr_n75112768)
print v(xbgr.mr_n75113200)
print v(xbgr.mr_n75113632)
print v(xbgr.mr_n75114064)
print v(xbgr.mr_n75114496)
print v(xbgr.mr_n75114928)
print v(xbgr.mr_n75115360)
print v(xbgr.mr_n75115792)
print v(xbgr.mr_n75116224)
print v(xbgr.mr_n75116656)
print v(xbgr.mr_n75117088)
print v(xbgr.mr_n75117520)
print v(xbgr.mr_n75117952)
print v(xbgr.mr_n75118384)
print v(xbgr.mr_n75118816)
print v(xbgr.mr_n75119248)
print v(xbgr.mr_n75119680)
print v(xbgr.mr_n75120112)
print v(xbgr.mr_n75120544)
print v(xbgr.mr_n75120976)
print v(xbgr.mr_n75121408)
print v(xbgr.mr_n75121840)
print v(xbgr.mr_n75122160)
print v(xbgr.mr_n75122272)
print v(xbgr.mr_n75122592)
print v(xbgr.mr_n75122704)
print v(xbgr.mr_n75123024)
print v(xbgr.mr_n75123136)
print v(xbgr.mr_n75123456)
print v(xbgr.mr_n75123568)
print v(xbgr.mr_n75123888)
print v(xbgr.mr_n75124000)
print v(xbgr.mr_n75124320)
print v(xbgr.mr_n75124432)
print v(xbgr.mr_n75124752)
print v(xbgr.mr_n75124864)
print v(xbgr.mr_n75125184)
print v(xbgr.mr_n75125296)
print v(xbgr.mr_n75125616)
print v(xbgr.mr_n75125728)
print v(xbgr.mr_n75126048)
print v(xbgr.mr_n75126160)
print v(xbgr.mr_n75126480)
print v(xbgr.mr_n75126592)
print v(xbgr.mr_n75126912)
print v(xbgr.mr_n75127024)
print v(xbgr.mr_n75127344)
print v(xbgr.mr_n75127456)
print v(xbgr.mr_n75127776)
print v(xbgr.mr_n75127888)
print v(xbgr.mr_n75128208)
print v(xbgr.mr_n75128320)
print v(xbgr.mr_n75128640)
print v(xbgr.mr_n75128752)
print v(xbgr.mr_n75129072)
print v(xbgr.mr_n75129184)
print v(xbgr.mr_n75129504)
print v(xbgr.mr_n75129616)
print v(xbgr.mr_n75129936)
print v(xbgr.mr_n75130048)
print v(xbgr.mr_n75130368)
print v(xbgr.mr_n75130480)
print v(xbgr.mr_n75130800)
print v(xbgr.mr_n75130912)
print v(xbgr.mr_n75131232)
print v(xbgr.mr_n75131344)
print v(xbgr.mr_n75131664)
print v(xbgr.mr_n75131776)
print v(xbgr.mr_n75132096)
print v(xbgr.mr_n75132208)
print v(xbgr.mr_n75132528)
print v(xbgr.mr_n75132640)
print v(xbgr.mr_n75132960)
print v(xbgr.mr_n75133072)
print v(xbgr.mr_n75133392)
print v(xbgr.mr_n75133504)
print v(xbgr.mr_n75133824)
print v(xbgr.mr_n75133936)
print v(xbgr.mr_n75134256)
print v(xbgr.mr_n75134368)
print v(xbgr.mr_n75134688)
print v(xbgr.mr_n75134800)
print v(xbgr.mr_n75135232)
print v(xbgr.mr_n75135664)
print v(xbgr.mr_n75136096)
print v(xbgr.mr_n75136528)
print v(xbgr.mr_n75136848)
print v(xbgr.mr_n75136960)
print v(xbgr.mr_n75137280)
print v(xbgr.mr_n75137392)
print v(xbgr.mr_n75137712)
print v(xbgr.mr_n75137824)
print v(xbgr.mr_n75138144)
print v(xbgr.mr_n75138256)
print v(xbgr.mr_n75138576)
print v(xbgr.mr_n75138688)
print v(xbgr.mr_n75139008)
print v(xbgr.mr_n75139120)
print v(xbgr.mr_n75139552)
print v(xbgr.mr_n75139984)
print v(xbgr.mr_n75140416)
print v(xbgr.mr_n75140736)
print v(xbgr.mr_n75140848)
print v(xbgr.mr_n75141168)
print v(xbgr.mr_n75141280)
print v(xbgr.mr_n75141600)
print v(xbgr.mr_n75141712)
print v(xbgr.mr_n75142032)
print v(xbgr.mr_n75142144)
print v(xbgr.mr_n75142464)
print v(xbgr.mr_n75142576)
print v(xbgr.mr_n75142896)
print v(xbgr.mr_n75143008)
print v(xbgr.mr_n75143328)
print v(xbgr.mr_n75143440)
print v(xbgr.mr_n75143760)
print v(xbgr.mr_n75143872)
print v(xbgr.mr_n75144192)
print v(xbgr.mr_n75144304)
print v(xbgr.mr_n75144624)
print v(xbgr.mr_n75144736)
print v(xbgr.mr_n75145168)
print v(xbgr.mr_n75145600)
print v(xbgr.mr_n75146032)
print v(xbgr.mr_n75146464)
print v(xbgr.mr_n75146896)
print v(xbgr.mr_n75147328)
print v(xbgr.mr_n75147760)
print v(xbgr.mr_n75148192)
print v(xbgr.mr_n75148624)
print v(xbgr.mr_n75149056)
print v(xbgr.mr_n75149488)
print v(xbgr.mr_n75149920)
print v(xbgr.mr_n75150352)
print v(xbgr.mr_n75150672)
print v(xbgr.mr_n75150784)
print v(xbgr.mr_n75151104)
print v(xbgr.mr_n75151216)
print v(xbgr.mr_n75151536)
print v(xbgr.mr_n75151648)
print v(xbgr.mr_n75151968)
print v(xbgr.mr_n75152080)
print v(xbgr.mr_n75152400)
print v(xbgr.mr_n75152512)
print v(xbgr.mr_n75152944)
print v(xbgr.mr_n75153376)
print v(xbgr.mr_n75153808)
print v(xbgr.mr_n75154240)
print v(xbgr.mr_n75154672)
print v(xbgr.mr_n75155104)
print v(xbgr.mr_n75155424)
print v(xbgr.mr_n75155536)
print v(xbgr.mr_n75155856)
print v(xbgr.mr_n75155968)
print v(xbgr.mr_n75156400)
print v(xbgr.mr_n75156832)
print v(xbgr.mr_n75157152)
print v(xbgr.mr_n75157264)
print v(xbgr.mr_n75157584)
print v(xbgr.mr_n75157696)
print v(xbgr.mr_n75158016)
print v(xbgr.mr_n75158128)
print v(xbgr.mr_n75158448)
print v(xbgr.mr_n75158560)
print v(xbgr.mr_n75158880)
print v(xbgr.mr_n75158992)
print v(xbgr.mr_n75159312)
print v(xbgr.mr_n75159424)
print v(xbgr.mr_n75159744)
print v(xbgr.mr_n75159856)
print v(xbgr.mr_n75160176)
print v(xbgr.mr_n75160288)
print v(xbgr.mr_n75160608)
print v(xbgr.mr_n75160720)
print v(xbgr.mr_n75161040)
print v(xbgr.mr_n75161152)
print v(xbgr.mr_n75161472)
print v(xbgr.mr_n75161584)
print v(xbgr.mr_n75161904)
print v(xbgr.mr_n75162016)
print v(xbgr.mr_n75162336)
print v(xbgr.mr_n75162448)
print v(xbgr.mr_n75162768)
print v(xbgr.mr_n75162880)
print v(xbgr.mr_n75163312)
print v(xbgr.mr_n75163744)
print v(xbgr.mr_n75164064)
print v(xbgr.mr_n75164176)
print v(xbgr.mr_n75164496)
print v(xbgr.mr_n75164608)
print v(xbgr.mr_n75164928)
print v(xbgr.mr_n75165040)
print v(xbgr.mr_n75165360)
print v(xbgr.mr_n75165472)
print v(xbgr.mr_n75165792)
print v(xbgr.mr_n75165904)
print v(xbgr.mr_n75166224)
print v(xbgr.mr_n75166336)
print v(xbgr.mr_n75166768)
print v(xbgr.mr_n75167200)
print v(xbgr.mr_n75167520)
print v(xbgr.mr_n75167632)
print v(xbgr.mr_n75167952)
print v(xbgr.mr_n75168064)
print v(xbgr.mr_n75168384)
print v(xbgr.mr_n75168496)
print v(xbgr.mr_n75168816)
print v(xbgr.mr_n75168928)
print v(xbgr.mr_n75169248)
print v(xbgr.mr_n75169360)
print v(xbgr.mr_n75169680)
print v(xbgr.mr_n75169792)
print v(xbgr.mr_n75170112)
print v(xbgr.mr_n75170224)
print v(xbgr.mr_n75170544)
print v(xbgr.mr_n75170656)
print v(xbgr.mr_n75170976)
print v(xbgr.mr_n75171088)
print v(xbgr.mr_n75171408)
print v(xbgr.mr_n75171520)
print v(xbgr.mr_n75171840)
print v(xbgr.mr_n75171952)
print v(xbgr.mr_n75172272)
print v(xbgr.mr_n75172384)
print v(xbgr.mr_n75172704)
print v(xbgr.mr_n75172816)
print v(xbgr.mr_n75173136)
print v(xbgr.mr_n75173248)
print v(xbgr.mr_n75173568)
print v(xbgr.mr_n75173680)
print v(xbgr.mr_n75174000)
print v(xbgr.mr_n75174112)
print v(xbgr.mr_n75174432)
print v(xbgr.mr_n75174544)
print v(xbgr.mr_n75174864)
print v(xbgr.mr_n75174976)
print v(xbgr.mr_n75175296)
print v(xbgr.mr_n75175408)
print v(xbgr.mr_n75175728)
print v(xbgr.mr_n75175840)
print v(xbgr.mr_n75176160)
print v(xbgr.mr_n75176272)
print v(xbgr.mr_n75176592)
print v(xbgr.mr_n75176704)
print v(xbgr.mr_n75177024)
print v(xbgr.mr_n75177136)
print v(xbgr.mr_n75177456)
print v(xbgr.mr_n75177568)
print v(xbgr.mr_n75177888)
print v(xbgr.mr_n75178000)
print v(xbgr.mr_n75178320)
print v(xbgr.mr_n75178432)
print v(xbgr.mr_n75178752)
print v(xbgr.mr_n75178864)
print v(xbgr.mr_n75179184)
print v(xbgr.mr_n75179296)
print v(xbgr.mr_n75179616)
print v(xbgr.mr_n75179728)
print v(xbgr.mr_n75180048)
print v(xbgr.mr_n75180160)
print v(xbgr.mr_n75180480)
print v(xbgr.mr_n75180592)
print v(xbgr.mr_n75180912)
print v(xbgr.mr_n75181024)
print v(xbgr.mr_n75181344)
print v(xbgr.mr_n75181456)
print v(xbgr.mr_n75181776)
print v(xbgr.mr_n75181888)
print v(xbgr.mr_n75182208)
print v(xbgr.mr_n75182320)
print v(xbgr.mr_n75182640)
print v(xbgr.mr_n75182752)
print v(xbgr.mr_n75183072)
print v(xbgr.mr_n75183184)
print v(xbgr.mr_n75183504)
print v(xbgr.mr_n75183616)
print v(xbgr.mr_n75183936)
print v(xbgr.mr_n75184048)
print v(xbgr.mr_n75184368)
print v(xbgr.mr_n75184480)
print v(xbgr.mr_n75184800)
print v(xbgr.mr_n75184912)
print v(xbgr.mr_n75185232)
print v(xbgr.mr_n75185344)
print v(xbgr.mr_n75185664)
print v(xbgr.mr_n75185776)
print v(xbgr.mr_n75186096)
print v(xbgr.mr_n75186208)
print v(xbgr.mr_n75186528)
print v(xbgr.mr_n75186640)
print v(xbgr.mr_n75186960)
print v(xbgr.mr_n75187072)
print v(xbgr.mr_n75187392)
print v(xbgr.mr_n75187504)
print v(xbgr.mr_n75187824)
print v(xbgr.mr_n75187936)
print v(xbgr.mr_n75188256)
print v(xbgr.mr_n75188368)
print v(xbgr.mr_n75188688)
print v(xbgr.mr_n75188800)
print v(xbgr.mr_n75189120)
print v(xbgr.mr_n75189232)
print v(xbgr.mr_n75189552)
print v(xbgr.mr_n75189664)
print v(xbgr.mr_n75189984)
print v(xbgr.mr_n75190096)
print v(xbgr.mr_n75190416)
print v(xbgr.mr_n75190528)
print v(xbgr.mr_n75190848)
print v(xbgr.mr_n75190960)
print v(xbgr.mr_n75191280)
print v(xbgr.mr_n75191392)
print v(xbgr.mr_n75191712)
print v(xbgr.mr_n75191824)
print v(xbgr.mr_n75192144)
print v(xbgr.mr_n75192256)
print v(xbgr.mr_n75192576)
print v(xbgr.mr_n75192688)
print v(xbgr.mr_n75193008)
print v(xbgr.mr_n75193120)
print v(xbgr.mr_n75193440)
print v(xbgr.mr_n75193552)
print v(xbgr.mr_n75193872)
print v(xbgr.mr_n75193984)
print v(xbgr.mr_n75194304)
print v(xbgr.mr_n75194416)
print v(xbgr.mr_n75194736)
print v(xbgr.mr_n75194848)
print v(xbgr.mr_n75195168)
print v(xbgr.mr_n75195280)
print v(xbgr.mr_n75195600)
print v(xbgr.mr_n75195712)
print v(xbgr.mr_n75196032)
print v(xbgr.mr_n75196144)
print v(xbgr.mr_n75196464)
print v(xbgr.mr_n75196576)
print v(xbgr.mr_n75196896)
print v(xbgr.mr_n75197008)
print v(xbgr.mr_n75197328)
print v(xbgr.mr_n75197440)
print v(xbgr.mr_n75197760)
print v(xbgr.mr_n75197872)
print v(xbgr.mr_n75198192)
print v(xbgr.mr_n75198304)
print v(xbgr.mr_n75198624)
print v(xbgr.mr_n75198736)
print v(xbgr.mr_n75199056)
print v(xbgr.mr_n75199168)
print v(xbgr.mr_n75199488)
print v(xbgr.mr_n75199600)
print v(xbgr.mr_n75199920)
print v(xbgr.mr_n75200032)
print v(xbgr.mr_n75200352)
print v(xbgr.mr_n75200464)
print v(xbgr.mr_n75200784)
print v(xbgr.mr_n75200896)
print v(xbgr.mr_n75201216)
print v(xbgr.mr_n75201328)
print v(xbgr.mr_n75201648)
print v(xbgr.mr_n75201760)
print v(xbgr.mr_n75202080)
print v(xbgr.mr_n75202192)
print v(xbgr.mr_n75202512)
print v(xbgr.mr_n75202624)
print v(xbgr.mr_n75202944)
print v(xbgr.mr_n75203056)
print v(xbgr.mr_n75203376)
print v(xbgr.mr_n75203488)
print v(xbgr.mr_n75203808)
print v(xbgr.mr_n75203920)
print v(xbgr.mr_n75204240)
print v(xbgr.mr_n75204352)
print v(xbgr.mr_n75204672)
print v(xbgr.mr_n75204784)
print v(xbgr.mr_n75205104)
print v(xbgr.mr_n75205216)
print v(xbgr.mr_n75205536)
print v(xbgr.mr_n75205648)
print v(xbgr.mr_n75205968)
print v(xbgr.mr_n75206080)
print v(xbgr.mr_n75206400)
print v(xbgr.mr_n75206512)
print v(xbgr.mr_n75206832)
print v(xbgr.mr_n75206944)
print v(xbgr.mr_n75207264)
print v(xbgr.mr_n75207376)
print v(xbgr.mr_n75207696)
print v(xbgr.mr_n75207808)
print v(xbgr.mr_n75208128)
print v(xbgr.mr_n75208240)
print v(xbgr.mr_n75208560)
print v(xbgr.mr_n75208672)
print v(xbgr.mr_n75208992)
print v(xbgr.mr_n75209104)
print v(xbgr.mr_n75209424)
print v(xbgr.mr_n75209536)
print v(xbgr.mr_n75209856)
print v(xbgr.mr_n75209968)
print v(xbgr.mr_n75210288)
print v(xbgr.mr_n75210400)
print v(xbgr.mr_n75210720)
print v(xbgr.mr_n75210832)
print v(xbgr.mr_n75211152)
print v(xbgr.mr_n75211264)
print v(xbgr.mr_n75211584)
print v(xbgr.mr_n75211696)
print v(xbgr.mr_n75212016)
print v(xbgr.mr_n75212128)
print v(xbgr.mr_n75212448)
print v(xbgr.mr_n75212560)
print v(xbgr.mr_n75212880)
print v(xbgr.mr_n75212992)
print v(xbgr.mr_n75213312)
print v(xbgr.mr_n75213424)
print v(xbgr.mr_n75213744)
print v(xbgr.mr_n75213856)
print v(xbgr.mr_n75214176)
print v(xbgr.mr_n75214288)
print v(xbgr.mr_n75214608)
print v(xbgr.mr_n75214720)
print v(xbgr.mr_n75215040)
print v(xbgr.mr_n75215152)
print v(xbgr.mr_n75215472)
print v(xbgr.mr_n75215584)
print v(xbgr.mr_n75215904)
print v(xbgr.mr_n75216016)
print v(xbgr.mr_n75216336)
print v(xbgr.mr_n75216448)
print v(xbgr.mr_n75216768)
print v(xbgr.mr_n75216880)
print v(xbgr.mr_n75217200)
print v(xbgr.mr_n75217312)
print v(xbgr.mr_n75217632)
print v(xbgr.mr_n75217744)
print v(xbgr.mr_n75218176)
print v(xbgr.mr_n75218608)
print v(xbgr.mr_n75219040)
print v(xbgr.mr_n75219472)
print v(xbgr.mr_n75219904)
print v(xbgr.mr_n75220336)
print v(xbgr.mr_n75220768)
print v(xbgr.mr_n75221200)
print v(xbgr.mr_n75221632)
print v(xbgr.mr_n75222064)
print v(xbgr.mr_n75222496)
print v(xbgr.mr_n75222928)
print v(xbgr.mr_n75223360)
print v(xbgr.mr_n75223792)
print v(xbgr.mr_n75224224)
print v(xbgr.mr_n75224656)
print v(xbgr.mr_n75225088)
print v(xbgr.mr_n75225520)
print v(xbgr.mr_n75225952)
print v(xbgr.mr_n75226384)
print v(xbgr.mr_n75226816)
print v(xbgr.mr_n75227248)
print v(xbgr.mr_n75227680)
print v(xbgr.mr_n75228112)
print v(xbgr.mr_n75228544)
print v(xbgr.mr_n75228976)
print v(xbgr.mr_n75229408)
print v(xbgr.mr_n75229840)
print v(xbgr.mr_n75230272)
print v(xbgr.mr_n75230704)
print v(xbgr.mr_n75231136)
print v(xbgr.mr_n75231568)
print v(xbgr.mr_n75232000)
print v(xbgr.mr_n75232432)
print v(xbgr.mr_n75232752)
print v(xbgr.mr_n75232864)
print v(xbgr.mr_n75233184)
print v(xbgr.mr_n75233296)
print v(xbgr.mr_n75233728)
print v(xbgr.mr_n75234048)
print v(xbgr.mr_n75234160)
print v(xbgr.mr_n75234480)
print v(xbgr.mr_n75234592)
print v(xbgr.mr_n75234912)
print v(xbgr.mr_n75235024)
print v(xbgr.mr_n75235344)
print v(xbgr.mr_n75235456)
print v(xbgr.mr_n75235776)
print v(xbgr.mr_n75235888)
print v(xbgr.mr_n75236208)
print v(xbgr.mr_n75236320)
print v(xbgr.mr_n75236640)
print v(xbgr.mr_n75236752)
print v(xbgr.mr_n75237072)
print v(xbgr.mr_n75237184)
print v(xbgr.mr_n75237616)
print v(xbgr.mr_n75238048)
print v(xbgr.mr_n75238480)
print v(xbgr.mr_n75238912)
print v(xbgr.mr_n75239344)
print v(xbgr.mr_n75239776)
print v(xbgr.mr_n75240208)
print v(xbgr.mr_n75240640)
print v(xbgr.mr_n75241072)
print v(xbgr.mr_n75241392)
print v(xbgr.mr_n75241504)
print v(xbgr.mr_n75241824)
print v(xbgr.mr_n75241936)
print v(xbgr.mr_n75242256)
print v(xbgr.mr_n75242368)
print v(xbgr.mr_n75242688)
print v(xbgr.mr_n75242800)
print v(xbgr.mr_n75243232)
print v(xbgr.mr_n75243664)
print v(xbgr.mr_n75244096)
print v(xbgr.mr_n75244528)
print v(xbgr.mr_n75244960)
print v(xbgr.mr_n75245392)
print v(xbgr.mr_n75245824)
print v(xbgr.mr_n75246256)
print v(xbgr.mr_n75246688)
print v(xbgr.mr_n75247120)
print v(xbgr.mr_n75247552)
print v(xbgr.mr_n75247984)
print v(xbgr.mr_n75248416)
print v(xbgr.mr_n75248848)
print v(xbgr.mr_n75249280)
print v(xbgr.mr_n75249712)
print v(xbgr.mr_n75250144)
print v(xbgr.mr_n75250576)
print v(xbgr.mr_n75251008)
print v(xbgr.mr_n75251440)
print v(xbgr.mr_n75251872)
print v(xbgr.mr_n75252304)
print v(xbgr.mr_n75252736)
print v(xbgr.mr_n75253168)
print v(xbgr.mr_n75253600)
print v(xbgr.mr_n75254032)
print v(xbgr.mr_n75254464)
print v(xbgr.mr_n75254896)
print v(xbgr.mr_n75255328)
print v(xbgr.mr_n75255648)
print v(xbgr.mr_n75255760)
print v(xbgr.mr_n75256080)
print v(xbgr.mr_n75256192)
print v(xbgr.mr_n75256512)
print v(xbgr.mr_n75256624)
print v(xbgr.mr_n75256944)
print v(xbgr.mr_n75257056)
print v(xbgr.mr_n75257376)
print v(xbgr.mr_n75257488)
print v(xbgr.mr_n75257808)
print v(xbgr.mr_n75257920)
print v(xbgr.mr_n75520400)
print v(xbgr.mr_n75521200)
print v(xbgr.mr_n75522064)
print v(xbgr.mr_n75522176)
print v(xbgr.mr_n75522496)
print v(xbgr.mr_n75522928)
print v(xbgr.mr_n75523360)
print v(xbgr.mr_n75523792)
print v(xbgr.mr_n75523904)
print v(xbgr.mr_n75524224)
print v(xbgr.mr_n75524656)
print v(xbgr.mr_n75525088)
print v(xbgr.mr_n75525520)
print v(xbgr.mr_n75525632)
print v(xbgr.mr_n75525952)
print v(xbgr.mr_n75526384)
print v(xbgr.mr_n75526816)
print v(xbgr.mr_n75527248)
print v(xbgr.mr_n75527360)
print v(xbgr.mr_n75527680)
print v(xbgr.mr_n75528112)
print v(xbgr.mr_n75528544)
print v(xbgr.mr_n75528976)
print v(xbgr.mr_n75529088)
print v(xbgr.mr_n75529408)
print v(xbgr.mr_n75529520)
print v(xbgr.mr_n75529840)
print v(xbgr.mr_n75529952)
print v(xbgr.mr_n75530384)
print v(xbgr.mr_n75530816)
print v(xbgr.mr_n75531248)
print v(xbgr.mr_n75531568)
print v(xbgr.mr_n75532432)
print v(xbgr.mr_n75532544)
print v(xbgr.mr_n75532864)
print v(xbgr.mr_n75532976)
print v(xbgr.mr_n75533296)
print v(xbgr.mr_n75533408)
print v(xbgr.mr_n75535904)
print v(xbgr.mr_n75536304)
print v(xbgr.mr_n75536624)
print v(xbgr.mr_n75537600)
print v(xbgr.mr_n75537920)
print v(xbgr.mr_n75538896)
print v(xbgr.mr_n75539216)
print v(xbgr.mr_n75540192)
print v(xbgr.mr_n75540512)
print v(xbgr.mr_n75540624)
print v(xbgr.mr_n75541056)
print v(xbgr.mr_n75541488)
print v(xbgr.mr_n75541808)
print v(xbgr.mr_n75542784)
print v(xbgr.mr_n75543104)
print v(xbgr.mr_n75544080)
print v(xbgr.mr_n75544400)
print v(xbgr.mr_n75545376)
print v(xbgr.mr_n75545696)
print v(xbgr.mr_n75545808)
print v(xbgr.mr_n75546128)
print v(xbgr.mr_n75546240)
print v(xbgr.mr_n75546560)
print v(xbgr.mr_n75546992)
print v(xbgr.mr_n75547104)
print v(xbgr.mr_n75547424)
print v(xbgr.mr_n75547856)
print v(xbgr.mr_n75548288)
print v(xbgr.mr_n75549152)
print v(xbgr.mr_n75549264)
print v(xbgr.mr_n75549696)
print v(xbgr.mr_n75550016)
print v(xbgr.mr_n75550560)
print v(xbgr.mr_n75550880)
print v(xbgr.mr_n75551312)
print v(xbgr.mr_n75551744)
print v(xbgr.mr_n75552720)
print v(xbgr.mr_n75553152)
print v(xbgr.mr_n75553584)
print v(xbgr.mr_n75554016)
print v(xbgr.mr_n75554448)
print v(xbgr.mr_n75554880)
print v(xbgr.mr_n75555312)
print v(xbgr.mr_n75555744)
print v(xbgr.mr_n75556176)
print v(xbgr.mr_n75556608)
print v(xbgr.mr_n75557040)
print v(xbgr.mr_n75557472)
print v(xbgr.mr_n75557904)
print v(xbgr.mr_n75558336)
print v(xbgr.mr_n75558768)
print v(xbgr.mr_n75559200)
print v(xbgr.mr_n75559632)
print v(xbgr.mr_n75560064)
print v(xbgr.mr_n75560496)
print v(xbgr.mr_n75560928)
print v(xbgr.mr_n75561360)
print v(xbgr.mr_n75561792)
print v(xbgr.mr_n75562224)
print v(xbgr.mr_n75562656)
print v(xbgr.mr_n75621744)
print v(xbgr.mr_n75622784)
print v(xbgr.mr_n75623232)
print v(xbgr.mr_n75623680)
print v(xbgr.mr_n75624128)
print v(xbgr.mr_n75625920)
print v(xbgr.mr_n75627264)
print v(xbgr.mr_n75630256)
print v(xbgr.mr_n75634192)
print v(xbgr.mr_n75636080)
print v(xbgr.mr_n75637776)
print v(xbgr.mr_n75638880)
print v(xbgr.mr_n75643456)
print v(xbgr.mr_n75643872)
print v(xbgr.mr_n75645680)
print v(xbgr.mr_n75647536)
print v(xbgr.mr_n75647712)
print v(xbgr.mr_n75648432)
print v(xbgr.mr_n75652064)
print v(xbgr.mr_n75652576)
print v(xbgr.mr_n75653264)
print v(xbgr.mr_n75654048)
print v(xbgr.mr_n75654816)
print v(xbgr.mr_n75655328)
print v(xbgr.mr_n75655712)
print v(xbgr.mr_n75656224)
print v(xbgr.mr_n75658192)
print v(xbgr.mr_n75658464)
print v(xbgr.mr_n75658976)
print v(xbgr.mr_n75659088)
print v(xbgr.mr_n75660320)
print v(xbgr.mr_n75662880)
print v(xbgr.mr_n75757008)
print v(xbgr.mr_n75758032)
print v(xbgr.mr_n75768720)
print v(xbgr.mr_n75775680)
print v(xbgr.mr_n75776400)
print v(xbgr.mr_n75787200)
print v(xbgr.mr_n75792448)
print v(xbgr.mr_n75805456)
print v(xbgr.mr_n75808256)
print v(xbgr.mr_n75809472)
print v(xbgr.mr_n75812928)
print v(xbgr.mr_n75878336)
print v(xbgr.mr_n75879040)
print v(xbgr.mr_n75880064)
print v(xbgr.mr_n75880384)
print v(xbgr.mr_n75880624)
print v(xbgr.mr_n75882176)
print v(xbgr.mr_n75883584)
print v(xbgr.mr_n75883760)
print v(xbgr.mr_n75885200)
print v(xbgr.mr_n75886272)
print v(xbgr.mr_n75886896)
print v(xbgr.mr_n75887104)
print v(xbgr.mr_n75887552)
print v(xbgr.mr_n75887936)
print v(xbgr.mr_n75888336)
print v(xbgr.mr_n75889792)
print v(xbgr.mr_n75890928)
print v(xbgr.mr_n75892272)
print v(xbgr.mr_n75894064)
print v(xbgr.mr_n75894336)
print v(xbgr.mr_n75895680)
print v(xbgr.mr_n75897856)
print v(xbgr.mr_n75898544)
print v(xbgr.mr_n75899088)
print v(xbgr.mr_n75899648)
print v(xbgr.mr_n75902736)
print v(xbgr.mr_n75903184)
print v(xbgr.mr_n75905024)
print v(xbgr.mr_n75908160)
print v(xbgr.mr_n75908672)
print v(xbgr.mr_n75909952)
print v(xbgr.mr_n75922640)
print v(xbgr.mr_n75922928)
print v(xbgr.mr_n75923296)
print v(xbgr.mr_n75923552)
print v(xbgr.mr_n75923696)
print v(xbgr.mr_n75924352)
print v(xbgr.mr_n75925904)
print v(xbgr.mr_n75930624)
print v(xbgr.mr_n75931984)
print v(xbgr.mr_n75937952)
print v(xbgr.mr_n75938336)
print v(xbgr.mr_n75977888)
print v(xbgr.mr_n75979824)
print v(xbgr.mr_n75982928)
print v(xbgr.mr_n75984592)
print v(xbgr.mr_n75984768)
print v(xbgr.mr_n75985152)
print v(xbgr.mr_n75986112)
print v(xbgr.mr_n75987792)
print v(xbgr.mr_n75994224)
print v(xbgr.mr_n75994528)
print v(xbgr.mr_n75995264)
print v(xbgr.mr_n75996656)
print v(xbgr.mr_n76001440)
print v(xbgr.mr_n76002976)
print v(xbgr.mr_n76004320)
print v(xbgr.mr_n76004848)
print v(xbgr.mr_n76006432)
print v(xbgr.mr_n76008192)
print v(xbgr.mr_n76012384)
print v(xbgr.mr_n76041792)
print v(xbgr.mr_n76045152)
print v(xbgr.mr_n76059488)
print v(xbgr.mr_n76072848)
print v(xbgr.mr_n76074528)
print v(xbgr.mr_n76129168)
print v(xbgr.mr_n76129360)
print v(xbgr.mr_n76199008)
print v(xbgr.mr_n76255216)
print v(xbgr.mr_n76255408)
print v(xbgr.mr_n76288240)
print v(xbgr.mr_n76288432)
print v(xbgr.mr_n76336672)
print v(xbgr.mr_n76336848)
print v(xbgr.mr_n76339152)
print v(xbgr.mr_n76339840)
print v(xbgr.mr_n76340960)
print v(xbgr.mr_n76376448)
print v(xbgr.mr_n76391040)
print v(xbgr.mr_n76398992)
print v(xbgr.mr_n76403776)
print v(xbgr.mr_n76405888)
print v(xbgr.mr_n76409760)
print v(xbgr.mr_n76439296)
print v(xbgr.mr_n76439632)
print v(xbgr.mr_n76441600)
print v(xbgr.mr_n76444752)
print v(xbgr.mr_n76446544)
print v(xbgr.mr_n76450112)
print v(xbgr.mr_n76450624)
print v(xbgr.mr_n76455808)
print v(xbgr.mr_n76456576)
print v(xbgr.mr_n76458480)
print v(xbgr.mr_n76468800)
print v(xbgr.mr_n76468976)
print v(xbgr.mr_n76469504)
print v(xbgr.mr_n76474864)
print v(xbgr.mr_n76475840)
print v(xbgr.mr_n76476704)
print v(xbgr.mr_n76478768)
print v(xbgr.mr_n76480112)
print v(xbgr.mr_n76480704)
print v(xbgr.mr_n76481088)
print v(xbgr.mr_n76481376)
print v(xbgr.mr_n76482304)
print v(xbgr.mr_n76485056)
print v(xbgr.mr_n76485440)
print v(xbgr.mr_n76485552)
print v(xbgr.mr_n76485664)
print v(xbgr.mr_n76485776)
print v(xbgr.mr_n76485888)
print v(xbgr.mr_n76486080)
print v(xbgr.mr_n76486352)
print v(xbgr.mr_n76486624)
print v(xbgr.mr_n76488736)
print v(xbgr.mr_n76489200)
print v(xbgr.mr_n76489664)
print v(xbgr.mr_n76490128)
print v(xbgr.mr_n76490592)
print v(xbgr.mr_n76491056)
print v(xbgr.mr_n76491520)
print v(xbgr.mr_n76491920)
print v(xbgr.mr_n76492448)
print v(xbgr.mr_n76492848)
print v(xbgr.mr_n76493376)
print v(xbgr.mr_n76494560)
print v(xbgr.mr_n76494736)
print v(xbgr.mr_n76496864)
print v(xbgr.mr_n76498208)
print v(xbgr.mr_n76498640)
print v(xbgr.mr_n76498816)
print v(xbgr.mr_n76501248)
print v(xbgr.mr_n76502224)
print v(xbgr.mr_n76502400)
print v(xbgr.mr_n76503008)
print v(xbgr.mr_n76503616)
print v(xbgr.mr_n76505152)
print v(xbgr.mr_n76506288)
print v(xbgr.mr_n76506592)
print v(xbgr.mr_n76506832)
print v(xbgr.mr_n76507936)
print v(xbgr.mr_n76508368)
print v(xbgr.mr_n76508736)
print v(xbgr.mr_n76510304)
print v(xbgr.mr_n76510976)
print v(xbgr.mr_n76511488)
print v(xbgr.mr_n76512192)
print v(xbgr.mr_n76515152)
print v(xbgr.mr_n76517264)
print v(xbgr.mr_n76518176)
print v(xbgr.mr_n76518496)
print v(xbgr.mr_n76518944)
print v(xbgr.mr_n76519376)
print v(xbgr.mr_n76521824)
print v(xbgr.mr_n76525808)
print v(xbgr.mr_n76525984)
print v(xbgr.mr_n76527328)
print v(xbgr.mr_n76528736)
print v(xbgr.mr_n76529232)
print v(xbgr.mr_n76529440)
print v(xbgr.mr_n76530736)
print v(xbgr.mr_n76531344)
print v(xbgr.mr_n76532576)
print v(xbgr.mr_n76532752)
print v(xbgr.mr_n76534256)
print v(xbgr.mr_n76536480)
print v(xbgr.mr_n76536720)
print v(xbgr.mr_n76536976)
print v(xbgr.mr_n76537680)
print v(xbgr.mr_n76538384)
print v(xbgr.mr_n76539792)
print v(xbgr.mr_n76540640)
print v(xbgr.mr_n76544016)
print v(xbgr.mr_n76545632)
print v(xbgr.mr_n76548944)
print v(xbgr.mr_n76549744)
print v(xbgr.mr_n76550096)
print v(xbgr.mr_n76552032)
print v(xbgr.mr_n76552672)
print v(xbgr.mr_n76553488)
print v(xbgr.mr_n76555312)
print v(xbgr.mr_n76556688)
print v(xbgr.mr_n76556896)
print v(xbgr.mr_n76557392)
print v(xbgr.mr_n76558544)
print v(xbgr.mr_n76558800)
print v(xbgr.mr_n76559504)
print v(xbgr.mr_n76560304)
print v(xbgr.mr_n76562128)
print v(xbgr.mr_n76566048)
print v(xbgr.mr_n76566816)
print v(xbgr.mr_n76567248)
print v(xbgr.mr_n76569360)
print v(xbgr.mr_n76573648)
print v(xbgr.mr_n76574144)
print v(xbgr.mr_n76575520)
print v(xbgr.mr_n76575984)
print v(xbgr.mr_n76576448)
print v(xbgr.mr_n76576912)
print v(xbgr.mr_n76577376)
print v(xbgr.mr_n76577776)
print v(xbgr.mr_n76578704)
print v(xbgr.mr_n76579232)
print v(xbgr.mr_n76579696)
print v(xbgr.mr_n76580160)
print v(xbgr.mr_n76583392)
print v(xbgr.mr_n76584368)
print v(xbgr.mr_n76584608)
print v(xbgr.mr_n76584912)
print v(xbgr.mr_n76585520)
print v(xbgr.mr_n76586192)
print v(xbgr.mr_n76586432)
print v(xbgr.mr_n76589536)
print v(xbgr.mr_n76591968)
print v(xbgr.mr_n76592208)
print v(xbgr.mr_n76593792)
print v(xbgr.mr_n76594336)
print v(xbgr.mr_n76594704)
print v(xbgr.mr_n76595616)
print v(xbgr.mr_n76596464)
print v(xbgr.mr_n76596640)
print v(xbgr.mr_n76597136)
print v(xbgr.mr_n76598048)
print v(xbgr.mr_n76599504)
print v(xbgr.mr_n76600480)
print v(xbgr.mr_n76600720)
print v(xbgr.mr_n76601936)
print v(xbgr.mr_n76602240)
print v(xbgr.mr_n76604064)
print v(xbgr.mr_n76607952)
print v(xbgr.mr_n76608416)
print v(xbgr.mr_n76608736)
print v(xbgr.mr_n76611248)
print v(xbgr.mr_n76614400)
print v(xbgr.mr_n76615088)
print v(xbgr.mr_n76619808)
print v(xbgr.mr_n76624352)
print v(xbgr.mr_n76624544)
print v(xbgr.mr_n76626656)
print v(xbgr.mr_n76627120)
print v(xbgr.mr_n76627584)
print v(xbgr.mr_n76628048)
print v(xbgr.mr_n76628512)
print v(xbgr.mr_n76628976)
print v(xbgr.mr_n76629440)
print v(xbgr.mr_n76629904)
print v(xbgr.mr_n76630368)
print v(xbgr.mr_n76630832)
print v(xbgr.mr_n76631296)
print v(xbgr.mr_n76631760)
print v(xbgr.mr_n76632224)
print v(xbgr.mr_n76632688)
print v(xbgr.mr_n76633152)
print v(xbgr.mr_n76633616)
print v(xbgr.mr_n76634080)
print v(xbgr.mr_n76634544)
print v(xbgr.mr_n76635008)
print v(xbgr.mr_n76635472)
print v(xbgr.mr_n76635936)
print v(xbgr.mr_n76636400)
print v(xbgr.mr_n76636864)
print v(xbgr.mr_n76637328)
print v(xbgr.mr_n76637792)
print v(xbgr.mr_n76638256)
print v(xbgr.mr_n76638720)
print v(xbgr.mr_n76639184)
print v(xbgr.mr_n76639648)
print v(xbgr.mr_n76640112)
print v(xbgr.mr_n76640576)
print v(xbgr.mr_n76641040)
print v(xbgr.mr_n76641504)
print v(xbgr.mr_n76641968)
print v(xbgr.mr_n76642432)
print v(xbgr.mr_n76642896)
print v(xbgr.mr_n76643360)
print v(xbgr.mr_n76643824)
print v(xbgr.mr_n76644288)
print v(xbgr.mr_n76644752)
print v(xbgr.mr_n76645216)
print v(xbgr.mr_n76645616)
print v(xbgr.mr_n76646080)
print v(xbgr.mr_n76646480)
print v(xbgr.mr_n76646928)
print v(xbgr.mr_n76647328)
print v(xbgr.mr_n76647792)
print v(xbgr.mr_n76648256)
print v(xbgr.mr_n76648720)
print v(xbgr.mr_n76649184)
print v(xbgr.mr_n76649648)
print v(xbgr.mr_n76650112)
print v(xbgr.mr_n76650576)
print v(xbgr.mr_n76651040)
print v(xbgr.mr_n76651504)
print v(xbgr.mr_n76651968)
print v(xbgr.mr_n76652432)
print v(xbgr.mr_n76652896)
print v(xbgr.mr_n76653360)
print v(xbgr.mr_n76653824)
print v(xbgr.mr_n76654288)
print v(xbgr.mr_n76654752)
print v(xbgr.mr_n76655216)
print v(xbgr.mr_n76655680)
print v(xbgr.mr_n76656144)
print v(xbgr.mr_n76656608)
print v(xbgr.mr_n76657072)
print v(xbgr.mr_n76657536)
print v(xbgr.mr_n76658000)
print v(xbgr.mr_n76658464)
print v(xbgr.mr_n76658928)
print v(xbgr.mr_n76659392)
print v(xbgr.mr_n76659856)
print v(xbgr.mr_n76660320)
print v(xbgr.mr_n76660784)
print v(xbgr.mr_n76661248)
print v(xbgr.mr_n76661712)
print v(xbgr.mr_n76662176)
print v(xbgr.mr_n76662640)
print v(xbgr.mr_n76663104)
print v(xbgr.mr_n76663568)
print v(xbgr.mr_n76664032)
print v(xbgr.mr_n76664496)
print v(xbgr.mr_n76664960)
print v(xbgr.mr_n76665424)
print v(xbgr.mr_n76665888)
print v(xbgr.mr_n76666352)
print v(xbgr.mr_n76666816)
print v(xbgr.mr_n76667280)
print v(xbgr.mr_n76667744)
print v(xbgr.mr_n76668208)
print v(xbgr.mr_n76668672)
print v(xbgr.mr_n76669136)
print v(xbgr.mr_n76669600)
print v(xbgr.mr_n76670064)
print v(xbgr.mr_n76670528)
print v(xbgr.mr_n76670992)
print v(xbgr.mr_n76671456)
print v(xbgr.mr_n76671920)
print v(xbgr.mr_n76672384)
print v(xbgr.mr_n76672848)
print v(xbgr.mr_n76673312)
print v(xbgr.mr_n76673776)
print v(xbgr.mr_n76674240)
print v(xbgr.mr_n76674704)
print v(xbgr.mr_n76675168)
print v(xbgr.mr_n76675632)
print v(xbgr.mr_n76676096)
print v(xbgr.mr_n76676560)
print v(xbgr.mr_n76677024)
print v(xbgr.mr_n76677488)
print v(xbgr.mr_n76677952)
print v(xbgr.mr_n76678416)
print v(xbgr.mr_n76678880)
print v(xbgr.mr_n76679344)
print v(xbgr.mr_n76679808)
print v(xbgr.mr_n76680272)
print v(xbgr.mr_n76680736)
print v(xbgr.mr_n76681008)
print v(xbgr.mr_n76681200)
print v(xbgr.mr_n76681664)
print v(xbgr.mr_n76681776)
print v(xbgr.mr_n76682240)
print v(xbgr.mr_n76682352)
print v(xbgr.mr_n76682976)
print v(xbgr.mr_n76683200)
print v(xbgr.mr_n76683712)
print v(xbgr.mr_n76683824)
print v(xbgr.mr_n76684448)
print v(xbgr.mr_n76684560)
print v(xbgr.mr_n76684672)
print v(xbgr.mr_n76685184)
print v(xbgr.mr_n76685296)
print v(xbgr.mr_n76685408)
print v(xbgr.mr_n76686032)
print v(xbgr.mr_n76686144)
print v(xbgr.mr_n76686656)
print v(xbgr.mr_n76686928)
print v(xbgr.mr_n76687200)
print v(xbgr.mr_n76687472)
print v(xbgr.mr_n76687584)
print v(xbgr.mr_n76687696)
print v(xbgr.mr_n76688208)
print v(xbgr.mr_n76688480)
print v(xbgr.mr_n76688752)
print v(xbgr.mr_n76689024)
print v(xbgr.mr_n76689296)
print v(xbgr.mr_n76689568)
print v(xbgr.mr_n76689840)
print v(xbgr.mr_n76690112)
print v(xbgr.mr_n76690384)
print v(xbgr.mr_n76690656)
print v(xbgr.mr_n76690928)
print v(xbgr.mr_n76691200)
print v(xbgr.mr_n76691472)
print v(xbgr.mr_n76691744)
print v(xbgr.mr_n76692016)
print v(xbgr.mr_n76692288)
print v(xbgr.mr_n76692560)
print v(xbgr.mr_n76692832)
print v(xbgr.mr_n76693104)
print v(xbgr.mr_n76693376)
print v(xbgr.mr_n76693648)
print v(xbgr.mr_n76693920)
print v(xbgr.mr_n76694192)
print v(xbgr.mr_n76694464)
print v(xbgr.mr_n76694736)
print v(xbgr.mr_n76695600)
print v(xbgr.mr_n76696064)
print v(xbgr.mr_n76696528)
print v(xbgr.mr_n76696992)
print v(xbgr.mr_n76697456)
print v(xbgr.mr_n76697920)
print v(xbgr.mr_n76698192)
print v(xbgr.mr_n76698384)
print v(xbgr.mr_n76698848)
print v(xbgr.mr_n76699312)
print v(xbgr.mr_n76699776)
print v(xbgr.mr_n76700240)
print v(xbgr.mr_n76703520)
print v(xbgr.mr_n76705120)
print v(xbgr.mr_n76711024)
print v(xbgr.mr_n76711280)
print v(xbgr.mr_n76711968)
print v(xbgr.mr_n76715936)
print v(xbgr.mr_n76717616)
print v(xbgr.mr_n76718208)
print v(xbgr.mr_n76718800)
print v(xbgr.mr_n76719392)
print v(xbgr.mr_n76719984)
print v(xbgr.mr_n76720576)
print v(xbgr.mr_n76721168)
print v(xbgr.mr_n76721760)
print v(xbgr.mr_n76722352)
print v(xbgr.mr_n76722944)
print v(xbgr.mr_n76723536)
print v(xbgr.mr_n76724128)
print v(xbgr.mr_n76724656)
print v(xbgr.mr_n76725312)
print v(xbgr.mr_n76725904)
print v(xbgr.mr_n76726496)
print v(xbgr.mr_n76727088)
print v(xbgr.mr_n76727680)
print v(xbgr.mr_n76728272)
print v(xbgr.mr_n76728864)
print v(xbgr.mr_n76729456)
print v(xbgr.mr_n76730048)
print v(xbgr.mr_n76730640)
print v(xbgr.mr_n76731824)
print v(xbgr.mr_n76732416)
print v(xbgr.mr_n76733008)
print v(xbgr.mr_n76733600)
print v(xbgr.mr_n76734192)
print v(xbgr.mr_n76734736)
print v(xbgr.mr_n76736832)
print v(xbgr.mr_n76740944)
print v(xbgr.mr_n76743312)
print v(xbgr.mr_n76744560)
print v(xbgr.mr_n76749456)
print v(xbgr.mr_n76750736)
print v(xbgr.mr_n76752688)
print v(xbgr.mr_n76754320)
print v(xbgr.mr_n76756464)
print v(xbgr.mr_n76759312)
print v(xbgr.mr_n76759808)
print v(xbgr.mr_n76759984)
print v(xbgr.mr_n76761216)
print v(xbgr.mr_n76761952)
print v(xbgr.mr_n76764304)
print v(xbgr.mr_n76764688)
print v(xbgr.mr_n76766416)
print v(xbgr.mr_n76769776)
print v(xbgr.mr_n76772496)
print v(xbgr.mr_n76773648)
print v(xbgr.mr_n76779408)
print v(xbgr.mr_n76780368)
print v(xbgr.mr_n76781888)
print v(xbgr.mr_n76782528)
print v(xbgr.mr_n76783136)
print v(xbgr.mr_n76783248)
print v(xbgr.mr_n76783856)
print v(xbgr.mr_n76783968)
print v(xbgr.mr_n76784576)
print v(xbgr.mr_n76784688)
print v(xbgr.mr_n76785296)
print v(xbgr.mr_n76786016)
print v(xbgr.mr_n76786128)
print v(xbgr.mr_n76786736)
print v(xbgr.mr_n76787456)
print v(xbgr.mr_n76794672)
print v(xbgr.mr_n76797056)
print v(xbgr.mr_n76798624)
print v(xbgr.mr_n76800816)
print v(xbgr.mr_n76800928)
print v(xbgr.mr_n76802272)
print v(xbgr.mr_n76804208)
print v(xbgr.mr_n76805248)
print v(xbgr.mr_n76809872)
print v(xbgr.mr_n76811088)
print v(xbgr.mr_n76812304)
print v(xbgr.mr_n76812912)
print v(xbgr.mr_n76814432)
print v(xbgr.mr_n76814736)
print v(xbgr.mr_n76817232)
print v(xbgr.mr_n76817776)
print v(xbgr.mr_n76818144)
print v(xbgr.mr_n76818992)
print v(xbgr.mr_n76819968)
print v(xbgr.mr_n76820208)
print v(xbgr.mr_n76821008)
print v(xbgr.mr_n76821120)
print v(xbgr.mr_n76822704)
print v(xbgr.mr_n76823712)
print v(xbgr.mr_n76823824)
print v(xbgr.mr_n76824720)
print v(xbgr.mr_n76825488)
print v(xbgr.mr_n76825968)
print v(xbgr.mr_n76826736)
print v(xbgr.mr_n76827744)
print v(xbgr.mr_n76828816)
print v(xbgr.mr_n76830320)
print v(xbgr.mr_n76831840)
print v(xbgr.mr_n76834864)
print v(xbgr.mr_n76838368)
print v(xbgr.mr_n76839232)
print v(xbgr.mr_n76839408)
print v(xbgr.mr_n76839584)
print v(xbgr.mr_n76841808)
print v(xbgr.mr_n76842336)
print v(xbgr.mr_n76842992)
print v(xbgr.mr_n76843584)
print v(xbgr.mr_n76844176)
print v(xbgr.mr_n76844768)
print v(xbgr.mr_n76845360)
print v(xbgr.mr_n76845952)
print v(xbgr.mr_n76846544)
print v(xbgr.mr_n76847136)
print v(xbgr.mr_n76847648)
print v(xbgr.mr_n76848256)
print v(xbgr.mr_n76848912)
print v(xbgr.mr_n76849504)
print v(xbgr.mr_n76850096)
print v(xbgr.mr_n76850624)
print v(xbgr.mr_n76851200)
print v(xbgr.mr_n76851792)
print v(xbgr.mr_n76852464)
print v(xbgr.mr_n76853056)
print v(xbgr.mr_n76853648)
print v(xbgr.mr_n76854240)
print v(xbgr.mr_n76854832)
print v(xbgr.mr_n76855360)
print v(xbgr.mr_n76855840)
print v(xbgr.mr_n76856016)
print v(xbgr.mr_n76856544)
print v(xbgr.mr_n76857200)
print v(xbgr.mr_n76857792)
print v(xbgr.mr_n76858384)
print v(xbgr.mr_n76858976)
print v(xbgr.mr_n76859568)
print v(xbgr.mr_n76860160)
print v(xbgr.mr_n76860752)
print v(xbgr.mr_n76861344)
print v(xbgr.mr_n76861936)
print v(xbgr.mr_n76863120)
print v(xbgr.mr_n76863632)
print v(xbgr.mr_n76864304)
print v(xbgr.mr_n76864896)
print v(xbgr.mr_n76865488)
print v(xbgr.mr_n76866080)
print v(xbgr.mr_n76866256)
print v(xbgr.mr_n76866368)
print v(xbgr.mr_n76866672)
print v(xbgr.mr_n76867200)
print v(xbgr.mr_n76867776)
print v(xbgr.mr_n76868448)
print v(xbgr.mr_n76869040)
print v(xbgr.mr_n76869600)
print v(xbgr.mr_n76869712)
print v(xbgr.mr_n76870496)
print v(xbgr.mr_n76871040)
print v(xbgr.mr_n76871920)
print v(xbgr.mr_n76872800)
print v(xbgr.mr_n76873392)
print v(xbgr.mr_n76873984)
print v(xbgr.mr_n76874576)
print v(xbgr.mr_n76875168)
print v(xbgr.mr_n76875760)
print v(xbgr.mr_n76876352)
print v(xbgr.mr_n76876944)
print v(xbgr.mr_n76877536)
print v(xbgr.mr_n76878128)
print v(xbgr.mr_n76878720)
print v(xbgr.mr_n76879312)
print v(xbgr.mr_n76879904)
print v(xbgr.mr_n76880496)
print v(xbgr.mr_n76881088)
print v(xbgr.mr_n76881680)
print v(xbgr.mr_n76882272)
print v(xbgr.mr_n76882864)
print v(xbgr.mr_n76883392)
print v(xbgr.mr_n76884048)
print v(xbgr.mr_n76884640)
print v(xbgr.mr_n76885232)
print v(xbgr.mr_n76885824)
print v(xbgr.mr_n76886416)
print v(xbgr.mr_n76887008)
print v(xbgr.mr_n76887600)
print v(xbgr.mr_n76888192)
print v(xbgr.mr_n76888784)
print v(xbgr.mr_n76889376)
print v(xbgr.mr_n76889968)
print v(xbgr.mr_n76890560)
print v(xbgr.mr_n76891152)
print v(xbgr.mr_n76891744)
print v(xbgr.mr_n76892336)
print v(xbgr.mr_n76892928)
print v(xbgr.mr_n76893520)
print v(xbgr.mr_n76894112)
print v(xbgr.mr_n76894704)
print v(xbgr.mr_n76895296)
print v(xbgr.mr_n76895888)
print v(xbgr.mr_n76896480)
print v(xbgr.mr_n76897072)
print v(xbgr.mr_n76897600)
print v(xbgr.mr_n76898256)
print v(xbgr.mr_n76898848)
print v(xbgr.mr_n76899440)
print v(xbgr.mr_n76900032)
print v(xbgr.mr_n76900624)
print v(xbgr.mr_n76901216)
print v(xbgr.mr_n76901808)
print v(xbgr.mr_n76902400)
print v(xbgr.mr_n76902992)
print v(xbgr.mr_n76903584)
print v(xbgr.mr_n76904176)
print v(xbgr.mr_n76904768)
print v(xbgr.mr_n76905360)
print v(xbgr.mr_n76905952)
print v(xbgr.mr_n76906544)
print v(xbgr.mr_n76907072)
print v(xbgr.mr_n76907728)
print v(xbgr.mr_n76908256)
print v(xbgr.mr_n76908912)
print v(xbgr.mr_n76909504)
print v(xbgr.mr_n76910096)
print v(xbgr.mr_n76910688)
print v(xbgr.mr_n76911280)
print v(xbgr.mr_n76911872)
print v(xbgr.mr_n76912464)
print v(xbgr.mr_n76913056)
print v(xbgr.mr_n76913392)
print v(xbgr.mr_n76913648)
print v(xbgr.mr_n76914240)
print v(xbgr.mr_n76914832)
print v(xbgr.mr_n76915424)
print v(xbgr.mr_n76916016)
print v(xbgr.mr_n76916608)
print v(xbgr.mr_n76917200)
print v(xbgr.mr_n76917792)
print v(xbgr.mr_n76918384)
print v(xbgr.mr_n76918976)
print v(xbgr.mr_n76919312)
print v(xbgr.mr_n76919568)
print v(xbgr.mr_n76920160)
print v(xbgr.mr_n76920992)
print v(xbgr.mr_n76921232)
print v(xbgr.mr_n76921552)
print v(xbgr.mr_n76922352)
print v(xbgr.mr_n76923152)
print v(xbgr.mr_n76923552)
print v(xbgr.mr_n76923952)
print v(xbgr.mr_n76924352)
print v(xbgr.mr_n76924752)
print v(xbgr.mr_n76929824)
print v(xbgr.mr_n76934304)
print v(xbgr.mr_n76938784)
print v(xbgr.mr_n76939040)
print v(xbgr.mr_n76939152)
print v(xbgr.mr_n76942496)
print v(xbgr.mr_n76949344)
print v(xbgr.mr_n76950832)
print v(xbgr.mr_n76951872)
print v(xbgr.mr_n76953344)
print v(xbgr.mr_n76955248)
print v(xbgr.mr_n76955840)
print v(xbgr.mr_n76956432)
print v(xbgr.mr_n76957024)
print v(xbgr.mr_n76957616)
print v(xbgr.mr_n76958208)
print v(xbgr.mr_n76958800)
print v(xbgr.mr_n76959392)
print v(xbgr.mr_n76959984)
print v(xbgr.mr_n76960576)
print v(xbgr.mr_n76961168)
print v(xbgr.mr_n76961584)
print v(xbgr.mr_n76961824)
print v(xbgr.mr_n76962672)
print v(xbgr.mr_n76963120)
print v(xbgr.mr_n76966688)
print v(xbgr.mr_n76971808)
print v(xbgr.mr_n76975328)
print v(xbgr.mr_n76977968)
print v(xbgr.mr_n76978288)
print v(xbgr.mr_n76980656)
print v(xbgr.mr_n76981040)
print v(xbgr.mr_n76983456)
print v(xbgr.mr_n76987104)
print v(xbgr.mr_n76987488)
print v(xbgr.mr_n76991392)
print v(xbgr.mr_n76991808)
print v(xbgr.mr_n76996880)
print v(xbgr.mr_n76997600)
print v(xbgr.mr_n76998480)
print v(xbgr.mr_n76999504)
print v(xbgr.mr_n77000096)
print v(xbgr.mr_n77000688)
print v(xbgr.mr_n77001280)
print v(xbgr.mr_n77001872)
print v(xbgr.mr_n77002464)
print v(xbgr.mr_n77003648)
print v(xbgr.mr_n77004240)
print v(xbgr.mr_n77004864)
print v(xbgr.mr_n77004976)
print v(xbgr.mr_n77005440)
print v(xbgr.mr_n77006256)
print v(xbgr.mr_n77006880)
print v(xbgr.mr_n77007472)
print v(xbgr.mr_n77008064)
print v(xbgr.mr_n77008656)
print v(xbgr.mr_n77009840)
print v(xbgr.mr_n77010432)
print v(xbgr.mr_n77011024)
print v(xbgr.mr_n77011616)
print v(xbgr.mr_n77012208)
print v(xbgr.mr_n77012800)
print v(xbgr.mr_n77013984)
print v(xbgr.mr_n77014576)
print v(xbgr.mr_n77015168)
print v(xbgr.mr_n77015760)
print v(xbgr.mr_n77016096)
print v(xbgr.mr_n77016352)
print v(xbgr.mr_n77016944)
print v(xbgr.mr_n77017536)
print v(xbgr.mr_n77018128)
print v(xbgr.mr_n77018720)
print v(xbgr.mr_n77019312)
print v(xbgr.mr_n77019904)
print v(xbgr.mr_n77020496)
print v(xbgr.mr_n77021088)
print v(xbgr.mr_n77021680)
print v(xbgr.mr_n77022272)
print v(xbgr.mr_n77022864)
print v(xbgr.mr_n77024048)
print v(xbgr.mr_n77024640)
print v(xbgr.mr_n77025232)
print v(xbgr.mr_n77025824)
print v(xbgr.mr_n77026416)
print v(xbgr.mr_n77027008)
print v(xbgr.mr_n77027600)
print v(xbgr.mr_n77028192)
print v(xbgr.mr_n77028784)
print v(xbgr.mr_n77029376)
print v(xbgr.mr_n77029968)
print v(xbgr.mr_n77030560)
print v(xbgr.mr_n77031152)
print v(xbgr.mr_n77031744)
print v(xbgr.mr_n77032336)
print v(xbgr.mr_n77032928)
print v(xbgr.mr_n77033520)
print v(xbgr.mr_n77034112)
print v(xbgr.mr_n77034704)
print v(xbgr.mr_n77035296)
print v(xbgr.mr_n77035888)
print v(xbgr.mr_n77036480)
print v(xbgr.mr_n77037072)
print v(xbgr.mr_n77038256)
print v(xbgr.mr_n77038848)
print v(xbgr.mr_n77039440)
print v(xbgr.mr_n77039776)
print v(xbgr.mr_n77040032)
print v(xbgr.mr_n77040624)
print v(xbgr.mr_n77041216)
print v(xbgr.mr_n77041808)
print v(xbgr.mr_n77042400)
print v(xbgr.mr_n77042992)
print v(xbgr.mr_n77043584)
print v(xbgr.mr_n77044176)
print v(xbgr.mr_n77044768)
print v(xbgr.mr_n77045360)
print v(xbgr.mr_n77045952)
print v(xbgr.mr_n77046544)
print v(xbgr.mr_n77047136)
print v(xbgr.mr_n77047728)
print v(xbgr.mr_n77048320)
print v(xbgr.mr_n77048912)
print v(xbgr.mr_n77049504)
print v(xbgr.mr_n77050096)
print v(xbgr.mr_n77050512)
print v(xbgr.mr_n77050688)
print v(xbgr.mr_n77051280)
print v(xbgr.mr_n77051872)
print v(xbgr.mr_n77052464)
print v(xbgr.mr_n77053056)
print v(xbgr.mr_n77053648)
print v(xbgr.mr_n77054240)
print v(xbgr.mr_n77054832)
print v(xbgr.mr_n77055424)
print v(xbgr.mr_n77056016)
print v(xbgr.mr_n77056608)
print v(xbgr.mr_n77057200)
print v(xbgr.mr_n77057792)
print v(xbgr.mr_n77058384)
print v(xbgr.mr_n77058976)
print v(xbgr.mr_n77059568)
print v(xbgr.mr_n77060160)
print v(xbgr.mr_n77060752)
print v(xbgr.mr_n77061344)
print v(xbgr.mr_n77061936)
print v(xbgr.mr_n77062528)
print v(xbgr.mr_n77063712)
print v(xbgr.mr_n77064304)
print v(xbgr.mr_n77064896)
print v(xbgr.mr_n77065488)
print v(xbgr.mr_n77066080)
print v(xbgr.mr_n77066672)
print v(xbgr.mr_n77067264)
print v(xbgr.mr_n77067856)
print v(xbgr.mr_n77068448)
print v(xbgr.mr_n77068976)
print v(xbgr.mr_n77069440)
print v(xbgr.mr_n77069904)
print v(xbgr.mr_n77070016)
print v(xbgr.mr_n77070368)
print v(xbgr.mr_n77070832)
print v(xbgr.mr_n77070944)
print v(xbgr.mr_n77071296)
print v(xbgr.mr_n77071408)
print v(xbgr.mr_n77072800)
print v(xbgr.mr_n77073056)
print v(xbgr.mr_n77073392)
print v(xbgr.mr_n77074032)
print v(xbgr.mr_n77074432)
print v(xbgr.mr_n77074832)
print v(xbgr.mr_n77075232)
print v(xbgr.mr_n77075632)
print v(xbgr.mr_n77076032)
print v(xbgr.mr_n77076432)
print v(xbgr.mr_n77076832)
print v(xbgr.mr_n77077232)
print v(xbgr.mr_n77077632)
print v(xbgr.mr_n77078032)
print v(xbgr.mr_n77078432)
print v(xbgr.mr_n77078832)
print v(xbgr.mr_n77079232)
print v(xbgr.mr_n77079632)
print v(xbgr.mr_n77080032)
print v(xbgr.mr_n77080432)
print v(xbgr.mr_n77080832)
print v(xbgr.mr_n77081232)
print v(xbgr.mr_n77081632)
print v(xbgr.mr_n77082032)
print v(xbgr.mr_n77082432)
print v(xbgr.mr_n77082832)
print v(xbgr.mr_n77083232)
print v(xbgr.mr_n77083632)
print v(xbgr.mr_n77084032)
print v(xbgr.mr_n77084432)
print v(xbgr.mr_n77084832)
print v(xbgr.mr_n77085232)
print v(xbgr.mr_n77085632)
print v(xbgr.mr_n77086032)
print v(xbgr.mr_n77086432)
print v(xbgr.mr_n77086832)
print v(xbgr.mr_n77087232)
print v(xbgr.mr_n77087632)
print v(xbgr.mr_n77088032)
print v(xbgr.mr_n77088432)
print v(xbgr.mr_n77089088)
print v(xbgr.mr_n77089680)
print v(xbgr.mr_n77090272)
print v(xbgr.mr_n77090864)
print v(xbgr.mr_n77091456)
print v(xbgr.mr_n77092048)
print v(xbgr.mr_n77092640)
print v(xbgr.mr_n77093168)
print v(xbgr.mr_n77093824)
print v(xbgr.mr_n77094352)
print v(xbgr.mr_n77096544)
print v(xbgr.mr_n77096736)
print v(xbgr.mr_n77097120)
print v(xbgr.mr_n77098224)
print v(xbgr.mr_n77100576)
print v(xbgr.mr_n77100960)
print v(xbgr.mr_n77106608)
print v(xbgr.mr_n77108320)
print v(xbgr.mr_n77109792)
print v(xbgr.mr_n77111472)
print v(xbgr.mr_n77112064)
print v(xbgr.mr_n77112656)
print v(xbgr.mr_n77113248)
print v(xbgr.mr_n77113584)
print v(xbgr.mr_n77113840)
print v(xbgr.mr_n77114432)
print v(xbgr.mr_n77114960)
print v(xbgr.mr_n77115616)
print v(xbgr.mr_n77116144)
print v(xbgr.mr_n77116800)
print v(xbgr.mr_n77117392)
print v(xbgr.mr_n77117984)
print v(xbgr.mr_n77118576)
print v(xbgr.mr_n77119168)
print v(xbgr.mr_n77119760)
print v(xbgr.mr_n77120352)
print v(xbgr.mr_n77120944)
print v(xbgr.mr_n77121536)
print v(xbgr.mr_n77122128)
print v(xbgr.mr_n77122720)
print v(xbgr.mr_n77123248)
print v(xbgr.mr_n77123904)
print v(xbgr.mr_n77124496)
print v(xbgr.mr_n77125088)
print v(xbgr.mr_n77125680)
print v(xbgr.mr_n77126272)
print v(xbgr.mr_n77126864)
print v(xbgr.mr_n77127984)
print v(xbgr.mr_n77128640)
print v(xbgr.mr_n77129232)
print v(xbgr.mr_n77129824)
print v(xbgr.mr_n77130416)
print v(xbgr.mr_n77131008)
print v(xbgr.mr_n77131600)
print v(xbgr.mr_n77132720)
print v(xbgr.mr_n77133376)
print v(xbgr.mr_n77133968)
print v(xbgr.mr_n77134560)
print v(xbgr.mr_n77135152)
print v(xbgr.mr_n77135744)
print v(xbgr.mr_n77136336)
print v(xbgr.mr_n77136928)
print v(xbgr.mr_n77137520)
print v(xbgr.mr_n77138112)
print v(xbgr.mr_n77138704)
print v(xbgr.mr_n77140576)
print v(xbgr.mr_n77146880)
print v(xbgr.mr_n77152960)
print v(xbgr.mr_n77159392)
print v(xbgr.mr_n77162496)
print v(xbgr.mr_n77167552)
print v(xbgr.mr_n77168896)
print v(xbgr.mr_n77180384)
print v(xbgr.mr_n77181248)
print v(xbgr.mr_n77181504)
print v(xbgr.mr_n77182144)
print v(xbgr.mr_n77183520)
print v(xbgr.mr_n77184464)
print v(xbgr.mr_n77184576)
print v(xbgr.mr_n77185184)
print v(xbgr.mr_n77185904)
print v(xbgr.mr_n77186016)
print v(xbgr.mr_n77186624)
print v(xbgr.mr_n77187344)
print v(xbgr.mr_n77187456)
print v(xbgr.mr_n77188064)
print v(xbgr.mr_n77189456)
print v(xbgr.mr_n77197952)
print v(xbgr.mr_n77202048)
print v(xbgr.mr_n77204288)
print v(xbgr.mr_n77209168)
print v(xbgr.mr_n77219264)
print v(xbgr.mr_n77222128)
print v(xbgr.mr_n77225840)
print v(xbgr.mr_n77226560)
print v(xbgr.mr_n77227200)
print v(xbgr.mr_n77227408)
print v(xbgr.mr_n77227952)
print v(xbgr.mr_n77228144)
print v(xbgr.mr_n77228464)
print v(xbgr.mr_n77228672)
print v(xbgr.mr_n77229840)
print v(xbgr.mr_n77229952)
print v(xbgr.mr_n77231104)
print v(xbgr.mr_n77232336)
print v(xbgr.mr_n77233328)
print v(xbgr.mr_n77233856)
print v(xbgr.mr_n77234512)
print v(xbgr.mr_n77235632)
print v(xbgr.mr_n77236224)
print v(xbgr.mr_n77236816)
print v(xbgr.mr_n77237408)
print v(xbgr.mr_n77238000)
print v(xbgr.mr_n77238592)
print v(xbgr.mr_n77239184)
print v(xbgr.mr_n77240288)
print v(xbgr.mr_n77240960)
print v(xbgr.mr_n77241552)
print v(xbgr.mr_n77242144)
print v(xbgr.mr_n77242672)
print v(xbgr.mr_n77243328)
print v(xbgr.mr_n77243920)
print v(xbgr.mr_n77244512)
print v(xbgr.mr_n77245104)
print v(xbgr.mr_n77245696)
print v(xbgr.mr_n77246208)
print v(xbgr.mr_n77246880)
print v(xbgr.mr_n77247472)
print v(xbgr.mr_n77248064)
print v(xbgr.mr_n77248656)
print v(xbgr.mr_n77249248)
print v(xbgr.mr_n77249840)
print v(xbgr.mr_n77250432)
print v(xbgr.mr_n77251088)
print v(xbgr.mr_n77251616)
print v(xbgr.mr_n77252208)
print v(xbgr.mr_n77253392)
print v(xbgr.mr_n77253984)
print v(xbgr.mr_n77254576)
print v(xbgr.mr_n77255168)
print v(xbgr.mr_n77255760)
print v(xbgr.mr_n77256352)
print v(xbgr.mr_n77256880)
print v(xbgr.mr_n77257456)
print v(xbgr.mr_n77258112)
print v(xbgr.mr_n77258704)
print v(xbgr.mr_n77259296)
print v(xbgr.mr_n77259664)
print v(xbgr.mr_n77259888)
print v(xbgr.mr_n77260480)
print v(xbgr.mr_n77261072)
print v(xbgr.mr_n77261664)
print v(xbgr.mr_n77262256)
print v(xbgr.mr_n77262848)
print v(xbgr.mr_n77263440)
print v(xbgr.mr_n77263952)
print v(xbgr.mr_n77264624)
print v(xbgr.mr_n77265216)
print v(xbgr.mr_n77265808)
print v(xbgr.mr_n77266432)
print v(xbgr.mr_n77266928)
print v(xbgr.mr_n77267456)
print v(xbgr.mr_n77268112)
print v(xbgr.mr_n77268640)
print v(xbgr.mr_n77269808)
print v(xbgr.mr_n77270480)
print v(xbgr.mr_n77271136)
print v(xbgr.mr_n77271664)
print v(xbgr.mr_n77272192)
print v(xbgr.mr_n77272848)
print v(xbgr.mr_n77273376)
print v(xbgr.mr_n77274032)
print v(xbgr.mr_n77274624)
print v(xbgr.mr_n77275088)
print v(xbgr.mr_n77275200)
print v(xbgr.mr_n77276544)
print v(xbgr.mr_n77277072)
print v(xbgr.mr_n77277392)
print v(xbgr.mr_n77278448)
print v(xbgr.mr_n77279424)
print v(xbgr.mr_n77279936)
print v(xbgr.mr_n77280608)
print v(xbgr.mr_n77281200)
print v(xbgr.mr_n77281792)
print v(xbgr.mr_n77282384)
print v(xbgr.mr_n77282976)
print v(xbgr.mr_n77283312)
print v(xbgr.mr_n77283568)
print v(xbgr.mr_n77284176)
print v(xbgr.mr_n77285856)
print v(xbgr.mr_n77287792)
print v(xbgr.mr_n77289408)
print v(xbgr.mr_n77289520)
print v(xbgr.mr_n77289632)
print v(xbgr.mr_n77289744)
print v(xbgr.mr_n77289856)
print v(xbgr.mr_n77289968)
print v(xbgr.mr_n77290080)
print v(xbgr.mr_n77290192)
print v(xbgr.mr_n77290384)
print v(xbgr.mr_n77290656)
print v(xbgr.mr_n77290928)
print v(xbgr.mr_n77291200)
print v(xbgr.mr_n77291472)
print v(xbgr.mr_n77291744)
print v(xbgr.mr_n77292016)
print v(xbgr.mr_n77292288)
print v(xbgr.mr_n77292688)
print v(xbgr.mr_n77293088)
print v(xbgr.mr_n77293488)
print v(xbgr.mr_n77293888)
print v(xbgr.mr_n77294288)
print v(xbgr.mr_n77294688)
print v(xbgr.mr_n77295088)
print v(xbgr.mr_n77295488)
print v(xbgr.mr_n77295888)
print v(xbgr.mr_n77296208)
print v(xbgr.mr_n77296688)
print v(xbgr.mr_n77297088)
print v(xbgr.mr_n77297488)
print v(xbgr.mr_n77297888)
print v(xbgr.mr_n77298288)
print v(xbgr.mr_n77298688)
print v(xbgr.mr_n77299088)
print v(xbgr.mr_n77299488)
print v(xbgr.mr_n77299888)
print v(xbgr.mr_n77300288)
print v(xbgr.mr_n77300688)
print v(xbgr.mr_n77301088)
print v(xbgr.mr_n77301488)
print v(xbgr.mr_n77301888)
print v(xbgr.mr_n77302288)
print v(xbgr.mr_n77302688)
print v(xbgr.mr_n77303088)
print v(xbgr.mr_n77303488)
print v(xbgr.mr_n77303824)
print v(xbgr.mr_n77304096)
print v(xbgr.mr_n77304368)
print v(xbgr.mr_n77304640)
print v(xbgr.mr_n77304912)
print v(xbgr.mr_n77305184)
print v(xbgr.mr_n77305456)
print v(xbgr.mr_n77305728)
print v(xbgr.mr_n77306000)
print v(xbgr.mr_n77306272)
print v(xbgr.mr_n77306544)
print v(xbgr.mr_n77306816)
print v(xbgr.mr_n77307088)
print v(xbgr.mr_n77307360)
print v(xbgr.mr_n77307632)
print v(xbgr.mr_n77307904)
print v(xbgr.mr_n77308176)
print v(xbgr.mr_n77308448)
print v(xbgr.mr_n77308896)
print v(xbgr.mr_n77309088)
print v(xbgr.mr_n77309280)
print v(xbgr.mr_n77309472)
print v(xbgr.mr_n77310416)
print v(xbgr.mr_n77314176)
print v(xbgr.mr_n77314288)
print v(xbgr.mr_n77314480)
print v(xbgr.mr_n77315232)
print v(xbgr.mr_n77316144)
print v(xbgr.mr_n77316896)
print v(xbgr.mr_n77319168)
print v(xbgr.mr_n77319280)
print v(xbgr.mr_n77319472)
print v(xbgr.mr_n77320224)
print v(xbgr.mr_n77321136)
print v(xbgr.mr_n77321888)
print v(xbgr.mr_n77324160)
print v(xbgr.mr_n77324272)
print v(xbgr.mr_n77324464)
print v(xbgr.mr_n77325216)
print v(xbgr.mr_n77326128)
print v(xbgr.mr_n77326880)
print v(xbgr.mr_n77329152)
print v(xbgr.mr_n77329264)
print v(xbgr.mr_n77329456)
print v(xbgr.mr_n77330208)
print v(xbgr.mr_n77331120)
print v(xbgr.mr_n77331872)
print v(xbgr.mr_n77334144)
print v(xbgr.mr_n77334256)
print v(xbgr.mr_n77334448)
print v(xbgr.mr_n77335200)
print v(xbgr.mr_n77336112)
print v(xbgr.mr_n77336864)
print v(xbgr.mr_n77339136)
print v(xbgr.mr_n77339248)
print v(xbgr.mr_n77339440)
print v(xbgr.mr_n77340192)
print v(xbgr.mr_n77343712)
print v(xbgr.mr_n77344224)
print v(xbgr.mr_n77344656)
print v(xbgr.mr_n77344832)
print v(xbgr.mr_n77345168)
print v(xbgr.mr_n77345680)
print v(xbgr.mr_n77346112)
print v(xbgr.mr_n77346288)
print v(xbgr.mr_n77346464)
print v(xbgr.mr_n77347328)
print v(xbgr.mr_n77347504)
print v(xbgr.mr_n77347680)
print v(xbgr.mr_n77348192)
print v(xbgr.mr_n77348304)
print v(xbgr.mr_n77348864)
print v(xbgr.mr_n77349040)
print v(xbgr.mr_n77349296)
print v(xbgr.mr_n77350240)
print v(xbgr.mr_n77350416)
print v(xbgr.mr_n77350592)
print v(xbgr.mr_n77351104)
print v(xbgr.mr_n77351216)
print v(xbgr.mr_n77351776)
print v(xbgr.mr_n77351952)
print v(xbgr.mr_n77352208)
print v(xbgr.mr_n77352960)
print v(xbgr.mr_n77353392)
print v(xbgr.mr_n77353568)
print v(xbgr.mr_n77353904)
print v(xbgr.mr_n77354608)
print v(xbgr.mr_n77354784)
print v(xbgr.mr_n77354960)
print v(xbgr.mr_n77355472)
print v(xbgr.mr_n77355584)
print v(xbgr.mr_n77356144)
print v(xbgr.mr_n77356320)
print v(xbgr.mr_n77356736)
print v(xbgr.mr_n77357328)
print v(xbgr.mr_n77357760)
print v(xbgr.mr_n77357936)
print v(xbgr.mr_n77358272)
print v(xbgr.mr_n77358784)
print v(xbgr.mr_n77359216)
print v(xbgr.mr_n77359392)
print v(xbgr.mr_n77359568)
print v(xbgr.mr_n77360432)
print v(xbgr.mr_n77360608)
print v(xbgr.mr_n77360784)
print v(xbgr.mr_n77361296)
print v(xbgr.mr_n77361728)
print v(xbgr.mr_n77361904)
print v(xbgr.mr_n77362240)
print v(xbgr.mr_n77362752)
print v(xbgr.mr_n77363184)
print v(xbgr.mr_n77363616)
print v(xbgr.mr_n77364208)
print v(xbgr.mr_n77364320)
print v(xbgr.mr_n77364880)
print v(xbgr.mr_n77365056)
print v(xbgr.mr_n77365392)
print v(xbgr.mr_n77366256)
print v(xbgr.mr_n77366432)
print v(xbgr.mr_n77366608)
print v(xbgr.mr_n77367120)
print v(xbgr.mr_n77367232)
print v(xbgr.mr_n77367344)
print v(xbgr.mr_n77367456)
print v(xbgr.mr_n77367568)
print v(xbgr.mr_n77367840)
print v(xbgr.mr_n77368192)
print v(xbgr.mr_n77368304)
print v(xbgr.mr_n77368576)
print v(xbgr.mr_n77368928)
print v(xbgr.mr_n77369168)
print v(xbgr.mr_n77369504)
print v(xbgr.mr_n77369856)
print v(xbgr.mr_n77369968)
print v(xbgr.mr_n77370160)
print v(xbgr.mr_n77370432)
print v(xbgr.mr_n77370704)
print v(xbgr.mr_n77370976)
print v(xbgr.mr_n77371248)
print v(xbgr.mr_n77371520)
print v(xbgr.mr_n77372144)
print v(xbgr.mr_n77372336)
print v(xbgr.mr_n77372528)
print v(xbgr.mr_n77372720)
print v(xbgr.mr_n77373472)
print v(xbgr.mr_n77391616)
print v(xbgr.mr_n77391792)
print v(xbgr.mr_n77392496)
print v(xbgr.mr_n77392672)
print v(xbgr.mr_n77392848)
print v(xbgr.mr_n77393552)
print v(xbgr.mr_n77393728)
print v(xbgr.mr_n77393904)
print v(xbgr.mr_n77394608)
print v(xbgr.mr_n77394784)
print v(xbgr.mr_n77394960)
print v(xbgr.mr_n77395664)
print v(xbgr.mr_n77395840)
print v(xbgr.mr_n77396016)
print v(xbgr.mr_n77396720)
print v(xbgr.mr_n77396896)
print v(xbgr.mr_n77397072)
print v(xbgr.mr_n77397648)
print v(xbgr.mr_n77397840)
print v(xbgr.mr_n77398112)
print v(xbgr.mr_n77398384)
print v(xbgr.mr_n77398656)
print v(xbgr.mr_n77398928)
print v(xbgr.mr_n77399200)
print v(xbgr.mr_n77399472)
print v(xbgr.mr_n77399744)
print v(xbgr.mr_n77400016)
print v(xbgr.mr_n77403552)
print v(xbgr.mr_n77403888)
print v(xbgr.mr_n77404224)
print v(xbgr.mr_n77404560)
print v(xbgr.mr_n77404976)
print v(xbgr.mr_n77405856)
print v(xbgr.mr_n77406256)
print v(xbgr.mr_n77406656)
print v(xbgr.mr_n77407056)
print v(xbgr.mr_n77407456)
print v(xbgr.mr_n77407856)
print v(xbgr.mr_n77408256)
print v(xbgr.mr_n77408720)
print v(xbgr.mr_n77408896)
print v(xbgr.mr_n77409520)
print v(xbgr.mr_n77409696)
print v(xbgr.mr_n77410288)
print v(xbgr.mr_n77410400)
print v(xbgr.mr_n77410512)
print v(xbgr.mr_n77410624)
print v(xbgr.mr_n77411776)
print v(xbgr.mr_n77414448)
print v(xbgr.mr_n77415040)
print v(xbgr.mr_n77416720)
print v(xbgr.mr_n77417232)
print v(xbgr.mr_n77418448)
print v(xbgr.mr_n77419040)
print v(xbgr.mr_n77420096)
print v(xbgr.mr_n77420848)
print v(xbgr.mr_n77422144)
print v(xbgr.mr_n77422656)
print v(xbgr.mr_n77423872)
print v(xbgr.mr_n77424464)
print v(xbgr.mr_n77425760)
print v(xbgr.mr_n77427568)
print v(xbgr.mr_n77428080)
print v(xbgr.mr_n77429376)
print v(xbgr.mr_n77429888)
print v(xbgr.mr_n77431104)
print v(xbgr.mr_n77431696)
print v(xbgr.mr_n77432912)
print v(xbgr.mr_n77433504)
print v(xbgr.mr_n77434720)
print v(xbgr.mr_n77435312)
print v(xbgr.mr_n77436608)
print v(xbgr.mr_n77437120)
print v(xbgr.mr_n77438416)
print v(xbgr.mr_n77438928)
print v(xbgr.mr_n77439040)
print v(xbgr.mr_n77439152)
print v(xbgr.mr_n77439264)
print v(xbgr.mr_n77439536)
print v(xbgr.mr_n77439648)
print v(xbgr.mr_n77440000)
print v(xbgr.mr_n77440112)
print v(xbgr.mr_n77440384)
print v(xbgr.mr_n77440736)
print v(xbgr.mr_n77440848)
print v(xbgr.mr_n77441216)
print v(xbgr.mr_n77441712)
print v(xbgr.mr_n77442192)
print v(xbgr.mr_n77442432)
print v(xbgr.mr_n77442784)
print v(xbgr.mr_n77443472)
print v(xbgr.mr_n77443936)
print v(xbgr.mr_n77444352)
print v(xbgr.mr_n77445040)
print v(xbgr.mr_n77445504)
print v(xbgr.mr_n77445920)
print v(xbgr.mr_n77446608)
print v(xbgr.mr_n77447136)
print v(xbgr.mr_n77447488)
print v(xbgr.mr_n77448176)
print v(xbgr.mr_n77448640)
print v(xbgr.mr_n77449056)
print v(xbgr.mr_n77449744)
print v(xbgr.mr_n77450208)
print v(xbgr.mr_n77450624)
print v(xbgr.mr_n77450736)
print v(xbgr.mr_n77451312)
print v(xbgr.mr_n77451696)
print v(xbgr.mr_n77452192)
print v(xbgr.mr_n77452880)
print v(xbgr.mr_n77453344)
print v(xbgr.mr_n77453760)
print v(xbgr.mr_n77454448)
print v(xbgr.mr_n77454976)
print v(xbgr.mr_n77455328)
print v(xbgr.mr_n77456016)
print v(xbgr.mr_n77456544)
print v(xbgr.mr_n77456896)
print v(xbgr.mr_n77457584)
print v(xbgr.mr_n77458048)
print v(xbgr.mr_n77458464)
print v(xbgr.mr_n77459152)
print v(xbgr.mr_n77459680)
print v(xbgr.mr_n77460032)
print v(xbgr.mr_n77460224)
print v(xbgr.mr_n77460720)
print v(xbgr.mr_n77461184)
print v(xbgr.mr_n77461600)
print v(xbgr.mr_n77462944)
print v(xbgr.mr_n77464592)
print v(xbgr.mr_n77465552)
print v(xbgr.mr_n77465808)
print v(xbgr.mr_n77466784)
print v(xbgr.mr_n77467424)
print v(xbgr.mr_n77467696)
print v(xbgr.mr_n77467808)
print v(xbgr.mr_n77468064)
print v(xbgr.mr_n77468624)
print v(xbgr.mr_n77468816)
print v(xbgr.mr_n77473040)
print v(xbgr.mr_n77473808)
print v(xbgr.mr_n77475792)
print v(xbgr.mr_n77476240)
print v(xbgr.mr_n77476384)
print v(xbgr.mr_n77478928)
print v(xbgr.mr_n77481488)
print v(xbgr.mr_n77483728)
print v(xbgr.mr_n77484656)
print v(xbgr.mr_n77485120)
print v(xbgr.mr_n77485584)
print v(xbgr.mr_n77486048)
print v(xbgr.mr_n77486512)
print v(xbgr.mr_n77486976)
print v(xbgr.mr_n77487440)
print v(xbgr.mr_n77487904)
print v(xbgr.mr_n77488368)
print v(xbgr.mr_n77488832)
print v(xbgr.mr_n77489296)
print v(xbgr.mr_n77489760)
print v(xbgr.mr_n77490224)
print v(xbgr.mr_n77490688)
print v(xbgr.mr_n77491152)
print v(xbgr.mr_n77491616)
print v(xbgr.mr_n77495680)
print v(xbgr.mr_n77496016)
print v(xbgr.mr_n77496352)
print v(xbgr.mr_n77496688)
print v(xbgr.mr_n77497152)
print v(xbgr.mr_n77498640)
print v(xbgr.mr_n77499008)
print v(xbgr.mr_n77499600)
print v(xbgr.mr_n77500608)
print v(xbgr.mr_n77500864)
print v(xbgr.mr_n77501072)
print v(xbgr.mr_n77509008)
print v(xbgr.mr_n77510144)
print v(xbgr.mr_n77510928)
print v(xbgr.mr_n77513328)
print v(xbgr.mr_n77513744)
print v(xbgr.mr_n77516320)
print v(xbgr.mr_n77518144)
print v(xbgr.mr_n77518624)
print v(xbgr.mr_n77519600)
print v(xbgr.mr_n77519792)
print v(xbgr.mr_n77520304)
print v(xbgr.mr_n77520704)
print v(xbgr.mr_n77521104)
print v(xbgr.mr_n77521456)
print v(xbgr.mr_n77522080)
print v(xbgr.mr_n77522432)
print v(xbgr.mr_n77523152)
print v(xbgr.mr_n77539952)
print v(xbgr.mr_n77541040)
print v(xbgr.mr_n77542368)
print v(xbgr.mr_n77542528)
print v(xbgr.mr_n77543232)
print v(xbgr.mr_n77543408)
print v(xbgr.mr_n77543968)
print v(xbgr.mr_n77544496)
print v(xbgr.mr_n77544672)
print v(xbgr.mr_n77544848)
print v(xbgr.mr_n77554400)
print v(xbgr.mr_n77554864)
print v(xbgr.mr_n77555328)
print v(xbgr.mr_n77555792)
print v(xbgr.mr_n77556256)
print v(xbgr.mr_n77556720)
print v(xbgr.mr_n77557184)
print v(xbgr.mr_n77557648)
print v(xbgr.mr_n77558112)
print v(xbgr.mr_n77558576)
print v(xbgr.mr_n77559040)
print v(xbgr.mr_n77559504)
print v(xbgr.mr_n77559968)
print v(xbgr.mr_n77560432)
print v(xbgr.mr_n77560896)
print v(xbgr.mr_n77561360)
print v(xbgr.mr_n77561824)
print v(xbgr.mr_n77578608)
print v(xbgr.mr_n77593184)
print v(xbgr.mr_n77596304)
print v(xbgr.mr_n77597312)
print v(xbgr.mr_n77597504)
print v(xbgr.mr_n77597760)
print v(xbgr.mr_n77598016)
print v(xbgr.mr_n77598656)
print v(xbgr.mr_n77599984)
print v(xbgr.mr_n77600768)
print v(xbgr.mr_n77603664)
print v(xbgr.mr_n77604992)
print v(xbgr.mr_n77607040)
print v(xbgr.mr_n77609808)
print v(xbgr.mr_n77611136)
print v(xbgr.mr_n77613184)
print v(xbgr.mr_n77615952)
print v(xbgr.mr_n77617280)
print v(xbgr.mr_n77619328)
print v(xbgr.mr_n77622096)
print v(xbgr.mr_n77623424)
print v(xbgr.mr_n77625472)
print v(xbgr.mr_n77628240)
print v(xbgr.mr_n77629568)
print v(xbgr.mr_n77631616)
print v(xbgr.mr_n77634384)
print v(xbgr.mr_n77635712)
print v(xbgr.mr_n77637136)
print v(xbgr.mr_n77638672)
print v(xbgr.mr_n77638864)
print v(xbgr.mr_n77643024)
print v(xbgr.mr_n77643424)
print v(xbgr.mr_n77643824)
print v(xbgr.mr_n77644224)
print v(xbgr.mr_n77644624)
print v(xbgr.mr_n77645024)
print v(xbgr.mr_n77645424)
print v(xbgr.mr_n77645824)
print v(xbgr.mr_n77646224)
print v(xbgr.mr_n77646624)
print v(xbgr.mr_n77647024)
print v(xbgr.mr_n77647424)
print v(xbgr.mr_n77647824)
print v(xbgr.mr_n77648224)
print v(xbgr.mr_n77648624)
print v(xbgr.mr_n77649024)
print v(xbgr.mr_n77649296)
print v(xbgr.mr_n77649408)
print v(xbgr.mr_n77649520)
print v(xbgr.mr_n77649632)
print v(xbgr.mr_n77649744)
print v(xbgr.mr_n77649936)
print v(xbgr.mr_n77650208)
print v(xbgr.mr_n77650480)
print v(xbgr.mr_n77650752)
print v(xbgr.mr_n77651024)
print v(xbgr.mr_n77651296)
print v(xbgr.mr_n77651568)
print v(xbgr.mr_n77651840)
print v(xbgr.mr_n77652176)
print v(xbgr.mr_n77652576)
print v(xbgr.mr_n77665072)
print v(xbgr.mr_n77666736)
print v(xbgr.mr_n77667344)
print v(xbgr.mr_n77667520)
print v(xbgr.mr_n77668368)
print v(xbgr.mr_n77668848)
print v(xbgr.mr_n77669344)
print v(xbgr.mr_n77669888)
print v(xbgr.mr_n77670064)
print v(xbgr.mr_n77670912)
print v(xbgr.mr_n77671392)
print v(xbgr.mr_n77671824)
print v(xbgr.mr_n77672432)
print v(xbgr.mr_n77672608)
print v(xbgr.mr_n77673392)
print v(xbgr.mr_n77673936)
print v(xbgr.mr_n77674368)
print v(xbgr.mr_n77674976)
print v(xbgr.mr_n77675152)
print v(xbgr.mr_n77675936)
print v(xbgr.mr_n77676480)
print v(xbgr.mr_n77676976)
print v(xbgr.mr_n77677520)
print v(xbgr.mr_n77677696)
print v(xbgr.mr_n77678544)
print v(xbgr.mr_n77679024)
print v(xbgr.mr_n77679456)
print v(xbgr.mr_n77679904)
print v(xbgr.mr_n77680064)
print v(xbgr.mr_n77680240)
print v(xbgr.mr_n77680608)
print v(xbgr.mr_n77681120)
print v(xbgr.mr_n77681232)
print v(xbgr.mr_n77681344)
print v(xbgr.mr_n77681456)
print v(xbgr.mr_n77682368)
print v(xbgr.mr_n77683232)
print v(xbgr.mr_n77683584)
print v(xbgr.mr_n77683696)
print v(xbgr.mr_n77683888)
print v(xbgr.mr_n77684352)
print v(xbgr.mr_n77684816)
print v(xbgr.mr_n77685280)
print v(xbgr.mr_n77685744)
print v(xbgr.mr_n77695152)
print v(xbgr.mr_n77696672)
print v(xbgr.mr_n77696816)
print v(xbgr.mr_n77697872)
print v(xbgr.mr_n77698064)
print v(xbgr.mr_n77698320)
print v(xbgr.mr_n77698576)
print v(xbgr.mr_n77700544)
print v(xbgr.mr_n77724272)
print v(xbgr.mr_n77724768)
print v(xbgr.mr_n77725072)
print v(xbgr.mr_n77725568)
print v(xbgr.mr_n77725872)
print v(xbgr.mr_n77726432)
print v(xbgr.mr_n77726736)
print v(xbgr.mr_n77727616)
print v(xbgr.mr_n77727920)
print v(xbgr.mr_n77728800)
print v(xbgr.mr_n77729104)
print v(xbgr.mr_n77729984)
print v(xbgr.mr_n77730288)
print v(xbgr.mr_n77731168)
print v(xbgr.mr_n77731472)
print v(xbgr.mr_n77732352)
print v(xbgr.mr_n77732656)
print v(xbgr.mr_n77733536)
print v(xbgr.mr_n77733840)
print v(xbgr.mr_n77734720)
print v(xbgr.mr_n77735024)
print v(xbgr.mr_n77735904)
print v(xbgr.mr_n77736208)
print v(xbgr.mr_n77737088)
print v(xbgr.mr_n77737392)
print v(xbgr.mr_n77738272)
print v(xbgr.mr_n77738576)
print v(xbgr.mr_n77739456)
print v(xbgr.mr_n77739760)
print v(xbgr.mr_n77740640)
print v(xbgr.mr_n77740832)
print v(xbgr.mr_n77741104)
print v(xbgr.mr_n77741568)
print v(xbgr.mr_n77751856)
print v(xbgr.mr_n77756208)
print v(xbgr.mr_n77756544)
print v(xbgr.mr_n77756880)
print v(xbgr.mr_n77757216)
print v(xbgr.mr_n77759248)
print v(xbgr.mr_n77760016)
print v(xbgr.mr_n77760416)
print v(xbgr.mr_n77760816)
print v(xbgr.mr_n77761216)
print v(xbgr.mr_n77761616)
print v(xbgr.mr_n77762016)
print v(xbgr.mr_n77762416)
print v(xbgr.mr_n77762816)
print v(xbgr.mr_n77763216)
print v(xbgr.mr_n77763616)
print v(xbgr.mr_n77764016)
print v(xbgr.mr_n77764416)
print v(xbgr.mr_n77764816)
print v(xbgr.mr_n77765216)
print v(xbgr.mr_n77765616)
print v(xbgr.mr_n77766016)
print v(xbgr.mr_n77770896)
print v(xbgr.mr_n77773344)
print v(xbgr.mr_n77787152)
print v(xbgr.mr_n77788048)
print v(xbgr.mr_n77791440)
print v(xbgr.mr_n77796432)
print v(xbgr.mr_n77796736)
print v(xbgr.mr_n77797040)
print v(xbgr.mr_n77797344)
print v(xbgr.mr_n77797728)
print v(xbgr.mr_n77798192)
print v(xbgr.mr_n77798656)
print v(xbgr.mr_n77799120)
print v(xbgr.mr_n77799584)
print v(xbgr.mr_n77800048)
print v(xbgr.mr_n77800512)
print v(xbgr.mr_n77800976)
print v(xbgr.mr_n77801440)
print v(xbgr.mr_n77802384)
print v(xbgr.mr_n77803344)
print v(xbgr.mr_n77803936)
print v(xbgr.mr_n77806080)
print v(xbgr.mr_n77806336)
print v(xbgr.mr_n77806640)
print v(xbgr.mr_n77807568)
print v(xbgr.mr_n77808224)
print v(xbgr.mr_n77809056)
print v(xbgr.mr_n77812240)
print v(xbgr.mr_n77812576)
print v(xbgr.mr_n77812912)
print v(xbgr.mr_n77813248)
print v(xbgr.mr_n77815280)
print v(xbgr.mr_n77817632)
print v(xbgr.mr_n77817968)
print v(xbgr.mr_n77819488)
print v(xbgr.mr_n77822704)
print v(xbgr.mr_n77822816)
print v(xbgr.mr_n77822928)
print v(xbgr.mr_n77823200)
print v(xbgr.mr_n77825168)
print v(xbgr.mr_n77825952)
print v(xbgr.mr_n77826064)
print v(xbgr.mr_n77827760)
print v(xbgr.mr_n77827872)
print v(xbgr.mr_n77827984)
print v(xbgr.mr_n77828256)
print v(xbgr.mr_n77830096)
print v(xbgr.mr_n77831008)
print v(xbgr.mr_n77831120)
print v(xbgr.mr_n77832384)
print v(xbgr.mr_n77833088)
print v(xbgr.mr_n77833728)
print v(xbgr.mr_n77833840)
print v(xbgr.mr_n77835344)
print v(xbgr.mr_n77836064)
print v(xbgr.mr_n77836176)
print v(xbgr.mr_n77837872)
print v(xbgr.mr_n77837984)
print v(xbgr.mr_n77838096)
print v(xbgr.mr_n77838368)
print v(xbgr.mr_n77840528)
print v(xbgr.mr_n77840640)
print v(xbgr.mr_n77840832)
print v(xbgr.mr_n77842304)
print v(xbgr.mr_n77843200)
print v(xbgr.mr_n77843840)
print v(xbgr.mr_n77843952)
print v(xbgr.mr_n77845456)
print v(xbgr.mr_n77846176)
print v(xbgr.mr_n77846288)
print v(xbgr.mr_n77847984)
print v(xbgr.mr_n77848096)
print v(xbgr.mr_n77848208)
print v(xbgr.mr_n77848480)
print v(xbgr.mr_n77850640)
print v(xbgr.mr_n77850752)
print v(xbgr.mr_n77850944)
print v(xbgr.mr_n77852976)
print v(xbgr.mr_n77853088)
print v(xbgr.mr_n77853200)
print v(xbgr.mr_n77853472)
print v(xbgr.mr_n77855696)
print v(xbgr.mr_n77855808)
print v(xbgr.mr_n77856000)
print v(xbgr.mr_n77856512)
print v(xbgr.mr_n77856848)
print v(xbgr.mr_n77857200)
print v(xbgr.mr_n77857824)
print v(xbgr.mr_n77858352)
print v(xbgr.mr_n77858704)
print v(xbgr.mr_n77858880)
print v(xbgr.mr_n77859392)
print v(xbgr.mr_n77859920)
print v(xbgr.mr_n77860272)
print v(xbgr.mr_n77860960)
print v(xbgr.mr_n77861488)
print v(xbgr.mr_n77861840)
print v(xbgr.mr_n77862528)
print v(xbgr.mr_n77862992)
print v(xbgr.mr_n77863408)
print v(xbgr.mr_n77864096)
print v(xbgr.mr_n77864624)
print v(xbgr.mr_n77864976)
print v(xbgr.mr_n77865664)
print v(xbgr.mr_n77866128)
print v(xbgr.mr_n77866544)
print v(xbgr.mr_n77867232)
print v(xbgr.mr_n77867696)
print v(xbgr.mr_n77868112)
print v(xbgr.mr_n77868800)
print v(xbgr.mr_n77869264)
print v(xbgr.mr_n77869680)
print v(xbgr.mr_n77870368)
print v(xbgr.mr_n77870832)
print v(xbgr.mr_n77871248)
print v(xbgr.mr_n77871936)
print v(xbgr.mr_n77872464)
print v(xbgr.mr_n77872816)
print v(xbgr.mr_n77873504)
print v(xbgr.mr_n77873968)
print v(xbgr.mr_n77879248)
print v(xbgr.mr_n77879552)
print v(xbgr.mr_n77879936)
print v(xbgr.mr_n77890000)
print v(xbgr.mr_n77891248)
print v(xbgr.mr_n77894864)
print v(xbgr.mr_n77895328)
print v(xbgr.mr_n77895792)
print v(xbgr.mr_n77896256)
print v(xbgr.mr_n77896720)
print v(xbgr.mr_n77897184)
print v(xbgr.mr_n77897648)
print v(xbgr.mr_n77898112)
print v(xbgr.mr_n77898576)
print v(xbgr.mr_n77899040)
print v(xbgr.mr_n77899504)
print v(xbgr.mr_n77899968)
print v(xbgr.mr_n77900432)
print v(xbgr.mr_n77900896)
print v(xbgr.mr_n77901360)
print v(xbgr.mr_n77901824)
print v(xbgr.mr_n77902288)
print v(xbgr.mr_n77902752)
print v(xbgr.mr_n77903216)
print v(xbgr.mr_n77903680)
print v(xbgr.mr_n77904080)
print v(xbgr.mr_n77919552)
print v(xbgr.mr_n77926752)
print v(xbgr.mr_n77926944)
print v(xbgr.mr_n77927200)
print v(xbgr.mr_n77927456)
print v(xbgr.mr_n77951056)
print v(xbgr.mr_n77951632)
print v(xbgr.mr_n77951744)
print v(xbgr.mr_n77951856)
print v(xbgr.mr_n77952560)
print v(xbgr.mr_n77953072)
print v(xbgr.mr_n77953184)
print v(xbgr.mr_n77953296)
print v(xbgr.mr_n77953808)
print v(xbgr.mr_n77953920)
print v(xbgr.mr_n77954272)
print v(xbgr.mr_n77954384)
print v(xbgr.mr_n77954736)
print v(xbgr.mr_n77954848)
print v(xbgr.mr_n77955264)
print v(xbgr.mr_n77955440)
print v(xbgr.mr_n77955920)
print v(xbgr.mr_n77956096)
print v(xbgr.mr_n77956576)
print v(xbgr.mr_n77956752)
print v(xbgr.mr_n77957232)
print v(xbgr.mr_n77957408)
print v(xbgr.mr_n77957888)
print v(xbgr.mr_n77958064)
print v(xbgr.mr_n77958544)
print v(xbgr.mr_n77958720)
print v(xbgr.mr_n77959200)
print v(xbgr.mr_n77959376)
print v(xbgr.mr_n77959712)
print v(xbgr.mr_n77962736)
print v(xbgr.mr_n77963072)
print v(xbgr.mr_n77963648)
print v(xbgr.mr_n77964560)
print v(xbgr.mr_n77964736)
print v(xbgr.mr_n77964912)
print v(xbgr.mr_n77965616)
print v(xbgr.mr_n77965792)
print v(xbgr.mr_n77966352)
print v(xbgr.mr_n77966816)
print v(xbgr.mr_n77966992)
print v(xbgr.mr_n77967168)
print v(xbgr.mr_n77967872)
print v(xbgr.mr_n77968048)
print v(xbgr.mr_n77968672)
print v(xbgr.mr_n77968848)
print v(xbgr.mr_n77969024)
print v(xbgr.mr_n77969536)
print v(xbgr.mr_n77969968)
print v(xbgr.mr_n77970144)
print v(xbgr.mr_n77970480)
print v(xbgr.mr_n77971184)
print v(xbgr.mr_n77971360)
print v(xbgr.mr_n77971984)
print v(xbgr.mr_n77972160)
print v(xbgr.mr_n77972336)
print v(xbgr.mr_n77973040)
print v(xbgr.mr_n77973216)
print v(xbgr.mr_n77973840)
print v(xbgr.mr_n77974016)
print v(xbgr.mr_n77974192)
print v(xbgr.mr_n77974832)
print v(xbgr.mr_n77975104)
print v(xbgr.mr_n77975536)
print v(xbgr.mr_n77975712)
print v(xbgr.mr_n77975968)
print v(xbgr.mr_n77976752)
print v(xbgr.mr_n77976928)
print v(xbgr.mr_n77977552)
print v(xbgr.mr_n77977728)
print v(xbgr.mr_n77977904)
print v(xbgr.mr_n77978544)
print v(xbgr.mr_n77978816)
print v(xbgr.mr_n77978928)
print v(xbgr.mr_n77979040)
print v(xbgr.mr_n77979152)
print v(xbgr.mr_n77979264)
print v(xbgr.mr_n77979536)
print v(xbgr.mr_n77979888)
print v(xbgr.mr_n77980000)
print v(xbgr.mr_n77980112)
print v(xbgr.mr_n77980544)
print v(xbgr.mr_n77981024)
print v(xbgr.mr_n77981200)
print v(xbgr.mr_n77981552)
print v(xbgr.mr_n77981920)
print v(xbgr.mr_n77982256)
print v(xbgr.mr_n77982608)
print v(xbgr.mr_n77982720)
print v(xbgr.mr_n77983216)
print v(xbgr.mr_n77983712)
print v(xbgr.mr_n77984192)
print v(xbgr.mr_n77984368)
print v(xbgr.mr_n77984720)
print v(xbgr.mr_n77985088)
print v(xbgr.mr_n77985424)
print v(xbgr.mr_n77985776)
print v(xbgr.mr_n77985888)
print v(xbgr.mr_n77986384)
print v(xbgr.mr_n77986880)
print v(xbgr.mr_n77987360)
print v(xbgr.mr_n77987536)
print v(xbgr.mr_n77987888)
print v(xbgr.mr_n77988256)
print v(xbgr.mr_n77988592)
print v(xbgr.mr_n77988944)
print v(xbgr.mr_n77998352)
print v(xbgr.mr_n77999616)
print v(xbgr.mr_n78000832)
print v(xbgr.mr_n78001216)
print v(xbgr.mr_n78001680)
print v(xbgr.mr_n78002144)
print v(xbgr.mr_n78002608)
print v(xbgr.mr_n78003072)
print v(xbgr.mr_n78003536)
print v(xbgr.mr_n78004000)
print v(xbgr.mr_n78004464)
print v(xbgr.mr_n78004928)
print v(xbgr.mr_n78005392)
print v(xbgr.mr_n78005856)
print v(xbgr.mr_n78006320)
print v(xbgr.mr_n78006784)
print v(xbgr.mr_n78007248)
print v(xbgr.mr_n78007712)
print v(xbgr.mr_n78008176)
print v(xbgr.mr_n78008640)
print v(xbgr.mr_n78009104)
print v(xbgr.mr_n78009568)
print v(xbgr.mr_n78010032)
print v(xbgr.mr_n78010496)
print v(xbgr.mr_n78010960)
print v(xbgr.mr_n78011424)
print v(xbgr.mr_n78011952)
print v(xbgr.mr_n78012544)
print v(xbgr.mr_n78013424)
print v(xbgr.mr_n78037296)
print v(xbgr.mr_n78039616)
print v(xbgr.mr_n78045168)
print v(xbgr.mr_n78045344)
print v(xbgr.mr_n78045680)
print v(xbgr.mr_n78046640)
print v(xbgr.mr_n78046752)
print v(xbgr.mr_n78047744)
print v(xbgr.mr_n78047856)
print v(xbgr.mr_n78048048)
print v(xbgr.mr_n78048800)
print v(xbgr.mr_n78051104)
print v(xbgr.mr_n78051424)
print v(xbgr.mr_n78052176)
print v(xbgr.mr_n78060912)
print v(xbgr.mr_n78062192)
print v(xbgr.mr_n78062576)
print v(xbgr.mr_n78064848)
print v(xbgr.mr_n78065136)
print v(xbgr.mr_n78066000)
print v(xbgr.mr_n78067888)
print v(xbgr.mr_n78068432)
print v(xbgr.mr_n78069216)
print v(xbgr.mr_n78069648)
print v(xbgr.mr_n78069824)
print v(xbgr.mr_n78070160)
print v(xbgr.mr_n78070864)
print v(xbgr.mr_n78071040)
print v(xbgr.mr_n78071392)
print v(xbgr.mr_n78071664)
print v(xbgr.mr_n78071840)
print v(xbgr.mr_n78072464)
print v(xbgr.mr_n78072640)
print v(xbgr.mr_n78073264)
print v(xbgr.mr_n78073440)
print v(xbgr.mr_n78074064)
print v(xbgr.mr_n78074240)
print v(xbgr.mr_n78074864)
print v(xbgr.mr_n78075040)
print v(xbgr.mr_n78075664)
print v(xbgr.mr_n78075840)
print v(xbgr.mr_n78076400)
print v(xbgr.mr_n78076880)
print v(xbgr.mr_n78077200)
print v(xbgr.mr_n78079504)
print v(xbgr.mr_n78080096)
print v(xbgr.mr_n78080960)
print v(xbgr.mr_n78081776)
print v(xbgr.mr_n78081920)
print v(xbgr.mr_n78083072)
print v(xbgr.mr_n78083584)
print v(xbgr.mr_n78083808)
print v(xbgr.mr_n78084448)
print v(xbgr.mr_n78084640)
print v(xbgr.mr_n78084832)
print v(xbgr.mr_n78085344)
print v(xbgr.mr_n78085536)
print v(xbgr.mr_n78086112)
print v(xbgr.mr_n78086464)
print v(xbgr.mr_n78086656)
print v(xbgr.mr_n78087936)
print v(xbgr.mr_n78088128)
print v(xbgr.mr_n78088320)
print v(xbgr.mr_n78088688)
print v(xbgr.mr_n78088880)
print v(xbgr.mr_n78089040)
print v(xbgr.mr_n78089392)
print v(xbgr.mr_n78089584)
print v(xbgr.mr_n78090512)
print v(xbgr.mr_n78090704)
print v(xbgr.mr_n78090976)
print v(xbgr.mr_n78091184)
print v(xbgr.mr_n78091808)
print v(xbgr.mr_n78092256)
print v(xbgr.mr_n78092368)
print v(xbgr.mr_n78092800)
print v(xbgr.mr_n78093072)
print v(xbgr.mr_n78095008)
print v(xbgr.mr_n78096064)
print v(xbgr.mr_n78096768)
print v(xbgr.mr_n78096880)
print v(xbgr.mr_n78097104)
print v(xbgr.mr_n78097360)
print v(xbgr.mr_n78097616)
print v(xbgr.mr_n78097776)
print v(xbgr.mr_n78098064)
print v(xbgr.mr_n78098624)
print v(xbgr.mr_n78099616)
print v(xbgr.mr_n78099808)
print v(xbgr.mr_n78099920)
print v(xbgr.mr_n78100272)
print v(xbgr.mr_n78100464)
print v(xbgr.mr_n78100912)
print v(xbgr.mr_n78102256)
print v(xbgr.mr_n78102992)
print v(xbgr.mr_n78103824)
print v(xbgr.mr_n78104256)
print v(xbgr.mr_n78104592)
print v(xbgr.mr_n78105120)
print v(xbgr.mr_n78105312)
print v(xbgr.mr_n78105504)
print v(xbgr.mr_n78105792)
print v(xbgr.mr_n78107344)
print v(xbgr.mr_n78107888)
print v(xbgr.mr_n78110352)
print v(xbgr.mr_n78112528)
print v(xbgr.mr_n78113392)
print v(xbgr.mr_n78113504)
print v(xbgr.mr_n78114768)
print v(xbgr.mr_n78115392)
print v(xbgr.mr_n78115616)
print v(xbgr.mr_n78115728)
print v(xbgr.mr_n78116528)
print v(xbgr.mr_n78116768)
print v(xbgr.mr_n78116992)
print v(xbgr.mr_n78117600)
print v(xbgr.mr_n78118096)
print v(xbgr.mr_n78118272)
print v(xbgr.mr_n78118576)
print v(xbgr.mr_n78118832)
print v(xbgr.mr_n78119536)
print v(xbgr.mr_n78120688)
print v(xbgr.mr_n78121472)
print v(xbgr.mr_n78121696)
print v(xbgr.mr_n78121968)
print v(xbgr.mr_n78122784)
print v(xbgr.mr_n78124016)
print v(xbgr.mr_n78124128)
print v(xbgr.mr_n78125440)
print v(xbgr.mr_n78126352)
print v(xbgr.mr_n78127184)
print v(xbgr.mr_n78128560)
print v(xbgr.mr_n78129648)
print v(xbgr.mr_n78130304)
print v(xbgr.mr_n78130576)
print v(xbgr.mr_n78131056)
print v(xbgr.mr_n78131936)
print v(xbgr.mr_n78132128)
print v(xbgr.mr_n78132320)
print v(xbgr.mr_n78134416)
print v(xbgr.mr_n78134688)
print v(xbgr.mr_n78134960)
print v(xbgr.mr_n78135232)
print v(xbgr.mr_n78135504)
print v(xbgr.mr_n78135776)
print v(xbgr.mr_n78136048)
print v(xbgr.mr_n78136320)
print v(xbgr.mr_n78136784)
print v(xbgr.mr_n78137248)
print v(xbgr.mr_n78149584)
print v(xbgr.mr_n78152656)
print v(xbgr.mr_n78157488)
print v(xbgr.mr_n78160784)
print v(xbgr.mr_n78183152)
print v(xbgr.mr_n78183792)
print v(xbgr.mr_n78184128)
print v(xbgr.mr_n78184464)
print v(xbgr.mr_n78184800)
print v(xbgr.mr_n78185136)
print v(xbgr.mr_n78185312)
print v(xbgr.mr_n78185424)
print v(xbgr.mr_n78185536)
print v(xbgr.mr_n78185648)
print v(xbgr.mr_n78185760)
print v(xbgr.mr_n78185872)
print v(xbgr.mr_n78185984)
print v(xbgr.mr_n78186416)
print v(xbgr.mr_n78186768)
print v(xbgr.mr_n78186880)
print v(xbgr.mr_n78187232)
print v(xbgr.mr_n78187664)
print v(xbgr.mr_n78187856)
print v(xbgr.mr_n78188048)
print v(xbgr.mr_n78188400)
print v(xbgr.mr_n78188512)
print v(xbgr.mr_n78188624)
print v(xbgr.mr_n78188736)
print v(xbgr.mr_n78189168)
print v(xbgr.mr_n78191536)
print v(xbgr.mr_n78193056)
print v(xbgr.mr_n78193248)
print v(xbgr.mr_n78193440)
print v(xbgr.mr_n78193632)
print v(xbgr.mr_n78193872)
print v(xbgr.mr_n78193984)
print v(xbgr.mr_n78194096)
print v(xbgr.mr_n78195552)
print v(xbgr.mr_n78195744)
print v(xbgr.mr_n78198544)
print v(xbgr.mr_n78199440)
print v(xbgr.mr_n78199776)
print v(xbgr.mr_n78200048)
print v(xbgr.mr_n78200800)
print v(xbgr.mr_n78201696)
print v(xbgr.mr_n78201968)
print v(xbgr.mr_n78202384)
print v(xbgr.mr_n78202816)
print v(xbgr.mr_n78203120)
print v(xbgr.mr_n78203680)
print v(xbgr.mr_n78204096)
print v(xbgr.mr_n78204528)
print v(xbgr.mr_n78204880)
print v(xbgr.mr_n78205312)
print v(xbgr.mr_n78205776)
print v(xbgr.mr_n78206128)
print v(xbgr.mr_n78206560)
print v(xbgr.mr_n78206864)
print v(xbgr.mr_n78207488)
print v(xbgr.mr_n78207840)
print v(xbgr.mr_n78208208)
print v(xbgr.mr_n78208624)
print v(xbgr.mr_n78209056)
print v(xbgr.mr_n78209456)
print v(xbgr.mr_n78209872)
print v(xbgr.mr_n78210304)
print v(xbgr.mr_n78210608)
print v(xbgr.mr_n78211168)
print v(xbgr.mr_n78211584)
print v(xbgr.mr_n78211952)
print v(xbgr.mr_n78212368)
print v(xbgr.mr_n78212800)
print v(xbgr.mr_n78213264)
print v(xbgr.mr_n78213616)
print v(xbgr.mr_n78214048)
print v(xbgr.mr_n78214352)
print v(xbgr.mr_n78214912)
print v(xbgr.mr_n78215328)
print v(xbgr.mr_n78215440)
print v(xbgr.mr_n78215632)
print v(xbgr.mr_n78215904)
print v(xbgr.mr_n78216176)
print v(xbgr.mr_n78216448)
print v(xbgr.mr_n78216720)
print v(xbgr.mr_n78216992)
print v(xbgr.mr_n78217264)
print v(xbgr.mr_n78217536)
print v(xbgr.mr_n78217808)
print v(xbgr.mr_n78218080)
print v(xbgr.mr_n78218352)
print v(xbgr.mr_n78218624)
print v(xbgr.mr_n78218896)
print v(xbgr.mr_n78219168)
print v(xbgr.mr_n78219440)
print v(xbgr.mr_n78219904)
print v(xbgr.mr_n78221104)
print v(xbgr.mr_n78230288)
print v(xbgr.mr_n78238416)
print v(xbgr.mr_n78240400)
print v(xbgr.mr_n78241488)
print v(xbgr.mr_n78241680)
print v(xbgr.mr_n78241872)
print v(xbgr.mr_n78242128)
print v(xbgr.mr_n78242384)
print v(xbgr.mr_n78244352)
print v(xbgr.mr_n78246576)
print v(xbgr.mr_n78247728)
print v(xbgr.mr_n78251856)
print v(xbgr.mr_n78252720)
print v(xbgr.mr_n78253568)
print v(xbgr.mr_n78255712)
print v(xbgr.mr_n78256368)
print v(xbgr.mr_n78256880)
print v(xbgr.mr_n78258096)
print v(xbgr.mr_n78258688)
print v(xbgr.mr_n78259984)
print v(xbgr.mr_n78260496)
print v(xbgr.mr_n78261792)
print v(xbgr.mr_n78262304)
print v(xbgr.mr_n78263600)
print v(xbgr.mr_n78264112)
print v(xbgr.mr_n78265408)
print v(xbgr.mr_n78265920)
print v(xbgr.mr_n78267216)
print v(xbgr.mr_n78267728)
print v(xbgr.mr_n78269024)
print v(xbgr.mr_n78269536)
print v(xbgr.mr_n78270752)
print v(xbgr.mr_n78271344)
print v(xbgr.mr_n78271456)
print v(xbgr.mr_n78271568)
print v(xbgr.mr_n78271680)
print v(xbgr.mr_n78271792)
print v(xbgr.mr_n78271984)
print v(xbgr.mr_n78272416)
print v(xbgr.mr_n78272528)
print v(xbgr.mr_n78272800)
print v(xbgr.mr_n78273152)
print v(xbgr.mr_n78273392)
print v(xbgr.mr_n78273728)
print v(xbgr.mr_n78274144)
print v(xbgr.mr_n78274576)
print v(xbgr.mr_n78275264)
print v(xbgr.mr_n78275888)
print v(xbgr.mr_n78276432)
print v(xbgr.mr_n78276928)
print v(xbgr.mr_n78277280)
print v(xbgr.mr_n78277968)
print v(xbgr.mr_n78278432)
print v(xbgr.mr_n78278848)
print v(xbgr.mr_n78279280)
print v(xbgr.mr_n78279968)
print v(xbgr.mr_n78280656)
print v(xbgr.mr_n78281136)
print v(xbgr.mr_n78281632)
print v(xbgr.mr_n78281984)
print v(xbgr.mr_n78282672)
print v(xbgr.mr_n78283184)
print v(xbgr.mr_n78283536)
print v(xbgr.mr_n78284656)
print v(xbgr.mr_n78285344)
print v(xbgr.mr_n78285824)
print v(xbgr.mr_n78286320)
print v(xbgr.mr_n78286672)
print v(xbgr.mr_n78287360)
print v(xbgr.mr_n78287888)
print v(xbgr.mr_n78288240)
print v(xbgr.mr_n78288672)
print v(xbgr.mr_n78289360)
print v(xbgr.mr_n78289984)
print v(xbgr.mr_n78290528)
print v(xbgr.mr_n78290960)
print v(xbgr.mr_n78291376)
print v(xbgr.mr_n78292064)
print v(xbgr.mr_n78292592)
print v(xbgr.mr_n78292944)
print v(xbgr.mr_n78293376)
print v(xbgr.mr_n78294064)
print v(xbgr.mr_n78294688)
print v(xbgr.mr_n78295232)
print v(xbgr.mr_n78295664)
print v(xbgr.mr_n78296080)
print v(xbgr.mr_n78296768)
print v(xbgr.mr_n78297232)
print v(xbgr.mr_n78297648)
print v(xbgr.mr_n78297824)
print v(xbgr.mr_n78298080)
print v(xbgr.mr_n78298272)
print v(xbgr.mr_n78298544)
print v(xbgr.mr_n78298816)
print v(xbgr.mr_n78299088)
print v(xbgr.mr_n78299360)
print v(xbgr.mr_n78299632)
print v(xbgr.mr_n78299904)
print v(xbgr.mr_n78300176)
print v(xbgr.mr_n78300448)
print v(xbgr.mr_n78300720)
print v(xbgr.mr_n78300992)
print v(xbgr.mr_n78301264)
print v(xbgr.mr_n78301536)
print v(xbgr.mr_n78317904)
print v(xbgr.mr_n78326256)
print v(xbgr.mr_n78326720)
print v(xbgr.mr_n78327184)
print v(xbgr.mr_n78327648)
print v(xbgr.mr_n78328112)
print v(xbgr.mr_n78334320)
print v(xbgr.mr_n78352096)
print v(xbgr.mr_n78356608)
print v(xbgr.mr_n78356800)
print v(xbgr.mr_n78357056)
print v(xbgr.mr_n78357312)
print v(xbgr.mr_n78359280)
print v(xbgr.mr_n78371120)
print v(xbgr.mr_n78372240)
print v(xbgr.mr_n78373536)
print v(xbgr.mr_n78374048)
print v(xbgr.mr_n78375344)
print v(xbgr.mr_n78375856)
print v(xbgr.mr_n78377152)
print v(xbgr.mr_n78377664)
print v(xbgr.mr_n78378560)
print v(xbgr.mr_n78378976)
print v(xbgr.mr_n78379728)
print v(xbgr.mr_n78380624)
print v(xbgr.mr_n78381280)
print v(xbgr.mr_n78381792)
print v(xbgr.mr_n78382688)
print v(xbgr.mr_n78383344)
print v(xbgr.mr_n78383856)
print v(xbgr.mr_n78384752)
print v(xbgr.mr_n78385408)
print v(xbgr.mr_n78385920)
print v(xbgr.mr_n78386816)
print v(xbgr.mr_n78387472)
print v(xbgr.mr_n78387984)
print v(xbgr.mr_n78388880)
print v(xbgr.mr_n78389456)
print v(xbgr.mr_n78390048)
print v(xbgr.mr_n78390944)
print v(xbgr.mr_n78391600)
print v(xbgr.mr_n78392112)
print v(xbgr.mr_n78393008)
print v(xbgr.mr_n78393664)
print v(xbgr.mr_n78394176)
print v(xbgr.mr_n78395072)
print v(xbgr.mr_n78395728)
print v(xbgr.mr_n78396240)
print v(xbgr.mr_n78397136)
print v(xbgr.mr_n78397792)
print v(xbgr.mr_n78398304)
print v(xbgr.mr_n78399200)
print v(xbgr.mr_n78399856)
print v(xbgr.mr_n78400368)
print v(xbgr.mr_n78401264)
print v(xbgr.mr_n78401840)
print v(xbgr.mr_n78402432)
print v(xbgr.mr_n78403728)
print v(xbgr.mr_n78404240)
print v(xbgr.mr_n78404352)
print v(xbgr.mr_n78404464)
print v(xbgr.mr_n78404576)
print v(xbgr.mr_n78404848)
print v(xbgr.mr_n78404960)
print v(xbgr.mr_n78405312)
print v(xbgr.mr_n78405424)
print v(xbgr.mr_n78405536)
print v(xbgr.mr_n78405968)
print v(xbgr.mr_n78406448)
print v(xbgr.mr_n78406624)
print v(xbgr.mr_n78406976)
print v(xbgr.mr_n78407344)
print v(xbgr.mr_n78407680)
print v(xbgr.mr_n78408032)
print v(xbgr.mr_n78408144)
print v(xbgr.mr_n78408640)
print v(xbgr.mr_n78409056)
print v(xbgr.mr_n78409616)
print v(xbgr.mr_n78409792)
print v(xbgr.mr_n78410144)
print v(xbgr.mr_n78410512)
print v(xbgr.mr_n78410848)
print v(xbgr.mr_n78411200)
print v(xbgr.mr_n78411312)
print v(xbgr.mr_n78411808)
print v(xbgr.mr_n78412304)
print v(xbgr.mr_n78412784)
print v(xbgr.mr_n78412960)
print v(xbgr.mr_n78413312)
print v(xbgr.mr_n78413744)
print v(xbgr.mr_n78414272)
print v(xbgr.mr_n78414624)
print v(xbgr.mr_n78415056)
print v(xbgr.mr_n78415744)
print v(xbgr.mr_n78416432)
print v(xbgr.mr_n78416912)
print v(xbgr.mr_n78417408)
print v(xbgr.mr_n78417760)
print v(xbgr.mr_n78418448)
print v(xbgr.mr_n78418976)
print v(xbgr.mr_n78419328)
print v(xbgr.mr_n78419760)
print v(xbgr.mr_n78420448)
print v(xbgr.mr_n78421136)
print v(xbgr.mr_n78421488)
print v(xbgr.mr_n78421600)
print v(xbgr.mr_n78421792)
print v(xbgr.mr_n78422064)
print v(xbgr.mr_n78422336)
print v(xbgr.mr_n78422608)
print v(xbgr.mr_n78422880)
print v(xbgr.mr_n78423152)
print v(xbgr.mr_n78423424)
print v(xbgr.mr_n78423696)
print v(xbgr.mr_n78423968)
print v(xbgr.mr_n78424240)
print v(xbgr.mr_n78424512)
print v(xbgr.mr_n78424784)
print v(xbgr.mr_n78425056)
print v(xbgr.mr_n78425328)
print v(xbgr.mr_n78425600)
print v(xbgr.mr_n78425872)
print v(xbgr.mr_n78432512)
print v(xbgr.mr_n78443216)
print v(xbgr.mr_n78443744)
print v(xbgr.mr_n78444208)
print v(xbgr.mr_n78444672)
print v(xbgr.mr_n78445136)
print v(xbgr.mr_n78445600)
print v(xbgr.mr_n78446064)
print v(xbgr.mr_n78446528)
print v(xbgr.mr_n78447056)
print v(xbgr.mr_n78447648)
print v(xbgr.mr_n78448240)
print v(xbgr.mr_n78448832)
print v(xbgr.mr_n78449424)
print v(xbgr.mr_n78450016)
print v(xbgr.mr_n78450608)
print v(xbgr.mr_n78451200)
print v(xbgr.mr_n78451792)
print v(xbgr.mr_n78452320)
print v(xbgr.mr_n78461664)
print v(xbgr.mr_n78463328)
print v(xbgr.mr_n78476384)
print v(xbgr.mr_n78481344)
print v(xbgr.mr_n78481536)
print v(xbgr.mr_n78481792)
print v(xbgr.mr_n78482048)
print v(xbgr.mr_n78484208)
print v(xbgr.mr_n78491376)
print v(xbgr.mr_n78491632)
print v(xbgr.mr_n78492224)
print v(xbgr.mr_n78492816)
print v(xbgr.mr_n78494640)
print v(xbgr.mr_n78495152)
print v(xbgr.mr_n78497088)
print v(xbgr.mr_n78497600)
print v(xbgr.mr_n78498896)
print v(xbgr.mr_n78499408)
print v(xbgr.mr_n78500704)
print v(xbgr.mr_n78501216)
print v(xbgr.mr_n78502512)
print v(xbgr.mr_n78503024)
print v(xbgr.mr_n78504320)
print v(xbgr.mr_n78504832)
print v(xbgr.mr_n78506048)
print v(xbgr.mr_n78506640)
print v(xbgr.mr_n78507936)
print v(xbgr.mr_n78508448)
print v(xbgr.mr_n78509744)
print v(xbgr.mr_n78510256)
print v(xbgr.mr_n78511552)
print v(xbgr.mr_n78512064)
print v(xbgr.mr_n78513360)
print v(xbgr.mr_n78513872)
print v(xbgr.mr_n78515168)
print v(xbgr.mr_n78515680)
print v(xbgr.mr_n78516976)
print v(xbgr.mr_n78517488)
print v(xbgr.mr_n78518784)
print v(xbgr.mr_n78519296)
print v(xbgr.mr_n78520592)
print v(xbgr.mr_n78521104)
print v(xbgr.mr_n78521216)
print v(xbgr.mr_n78521328)
print v(xbgr.mr_n78521440)
print v(xbgr.mr_n78521712)
print v(xbgr.mr_n78521824)
print v(xbgr.mr_n78522176)
print v(xbgr.mr_n78522288)
print v(xbgr.mr_n78522560)
print v(xbgr.mr_n78522912)
print v(xbgr.mr_n78523024)
print v(xbgr.mr_n78523392)
print v(xbgr.mr_n78523888)
print v(xbgr.mr_n78524368)
print v(xbgr.mr_n78524672)
print v(xbgr.mr_n78525088)
print v(xbgr.mr_n78525776)
print v(xbgr.mr_n78526304)
print v(xbgr.mr_n78526656)
print v(xbgr.mr_n78527088)
print v(xbgr.mr_n78527200)
print v(xbgr.mr_n78527776)
print v(xbgr.mr_n78528320)
print v(xbgr.mr_n78528944)
print v(xbgr.mr_n78529440)
print v(xbgr.mr_n78529792)
print v(xbgr.mr_n78530480)
print v(xbgr.mr_n78530944)
print v(xbgr.mr_n78531360)
print v(xbgr.mr_n78531792)
print v(xbgr.mr_n78532480)
print v(xbgr.mr_n78533168)
print v(xbgr.mr_n78533648)
print v(xbgr.mr_n78534080)
print v(xbgr.mr_n78534496)
print v(xbgr.mr_n78535184)
print v(xbgr.mr_n78535648)
print v(xbgr.mr_n78536064)
print v(xbgr.mr_n78536496)
print v(xbgr.mr_n78537184)
print v(xbgr.mr_n78537872)
print v(xbgr.mr_n78538352)
print v(xbgr.mr_n78538784)
print v(xbgr.mr_n78539200)
print v(xbgr.mr_n78539888)
print v(xbgr.mr_n78540416)
print v(xbgr.mr_n78540768)
print v(xbgr.mr_n78541200)
print v(xbgr.mr_n78541888)
print v(xbgr.mr_n78542512)
print v(xbgr.mr_n78543056)
print v(xbgr.mr_n78543552)
print v(xbgr.mr_n78543904)
print v(xbgr.mr_n78544592)
print v(xbgr.mr_n78545120)
print v(xbgr.mr_n78545472)
print v(xbgr.mr_n78545904)
print v(xbgr.mr_n78546592)
print v(xbgr.mr_n78547280)
print v(xbgr.mr_n78547632)
print v(xbgr.mr_n78547744)
print v(xbgr.mr_n78547936)
print v(xbgr.mr_n78548208)
print v(xbgr.mr_n78548480)
print v(xbgr.mr_n78548752)
print v(xbgr.mr_n78549024)
print v(xbgr.mr_n78549296)
print v(xbgr.mr_n78549568)
print v(xbgr.mr_n78549840)
print v(xbgr.mr_n78550112)
print v(xbgr.mr_n78550384)
print v(xbgr.mr_n78550656)
print v(xbgr.mr_n78550928)
print v(xbgr.mr_n78551200)
print v(xbgr.mr_n78551472)
print v(xbgr.mr_n78551744)
print v(xbgr.mr_n78552016)
print v(xbgr.mr_n78555776)
print v(xbgr.mr_n78556992)
print v(xbgr.mr_n78562448)
print v(xbgr.mr_n78563616)
print v(xbgr.mr_n78572032)
print v(xbgr.mr_n78572288)
print v(xbgr.mr_n78573328)
print v(xbgr.mr_n78575776)
print v(xbgr.mr_n78576240)
print v(xbgr.mr_n78576704)
print v(xbgr.mr_n78577168)
print v(xbgr.mr_n78577632)
print v(xbgr.mr_n78578096)
print v(xbgr.mr_n78578560)
print v(xbgr.mr_n78579088)
print v(xbgr.mr_n78579680)
print v(xbgr.mr_n78580272)
print v(xbgr.mr_n78580864)
print v(xbgr.mr_n78581456)
print v(xbgr.mr_n78582048)
print v(xbgr.mr_n78582640)
print v(xbgr.mr_n78583232)
print v(xbgr.mr_n78583824)
print v(xbgr.mr_n78584416)
print v(xbgr.mr_n78585296)
print v(xbgr.mr_n78593904)
print v(xbgr.mr_n78602256)
print v(xbgr.mr_n78602432)
print v(xbgr.mr_n78602768)
print v(xbgr.mr_n78604544)
print v(xbgr.mr_n78605136)
print v(xbgr.mr_n78605728)
print v(xbgr.mr_n78606320)
print v(xbgr.mr_n78606912)
print v(xbgr.mr_n78607504)
print v(xbgr.mr_n78608096)
print v(xbgr.mr_n78608688)
print v(xbgr.mr_n78609280)
print v(xbgr.mr_n78609872)
print v(xbgr.mr_n78610464)
print v(xbgr.mr_n78611056)
print v(xbgr.mr_n78611648)
print v(xbgr.mr_n78612240)
print v(xbgr.mr_n78612832)
print v(xbgr.mr_n78613424)
print v(xbgr.mr_n78614016)
print v(xbgr.mr_n78614608)
print v(xbgr.mr_n78615200)
print v(xbgr.mr_n78622448)
print v(xbgr.mr_n78624176)
print v(xbgr.mr_n78624656)
print v(xbgr.mr_n78625152)
print v(xbgr.mr_n78625504)
print v(xbgr.mr_n78625616)
print v(xbgr.mr_n78626320)
print v(xbgr.mr_n78627008)
print v(xbgr.mr_n78627392)
print v(xbgr.mr_n78627504)
print v(xbgr.mr_n78627616)
print v(xbgr.mr_n78629152)
print v(xbgr.mr_n78631424)
print v(xbgr.mr_n78631856)
print v(xbgr.mr_n78632272)
print v(xbgr.mr_n78632384)
print v(xbgr.mr_n78633088)
print v(xbgr.mr_n78635264)
print v(xbgr.mr_n78635680)
print v(xbgr.mr_n78635792)
print v(xbgr.mr_n78636496)
print v(xbgr.mr_n78638672)
print v(xbgr.mr_n78639088)
print v(xbgr.mr_n78639200)
print v(xbgr.mr_n78639904)
print v(xbgr.mr_n78640976)
print v(xbgr.mr_n78642144)
print v(xbgr.mr_n78642496)
print v(xbgr.mr_n78642608)
print v(xbgr.mr_n78643312)
print v(xbgr.mr_n78645552)
print v(xbgr.mr_n78645904)
print v(xbgr.mr_n78646016)
print v(xbgr.mr_n78646720)
print v(xbgr.mr_n78648960)
print v(xbgr.mr_n78649312)
print v(xbgr.mr_n78649424)
print v(xbgr.mr_n78650128)
print v(xbgr.mr_n78652368)
print v(xbgr.mr_n78652720)
print v(xbgr.mr_n78652832)
print v(xbgr.mr_n78653536)
print v(xbgr.mr_n78664768)
print v(xbgr.mr_n78667488)
print v(xbgr.mr_n78667664)
print v(xbgr.mr_n78668288)
print v(xbgr.mr_n78668464)
print v(xbgr.mr_n78669088)
print v(xbgr.mr_n78669264)
print v(xbgr.mr_n78669888)
print v(xbgr.mr_n78670064)
print v(xbgr.mr_n78670688)
print v(xbgr.mr_n78670864)
print v(xbgr.mr_n78671488)
print v(xbgr.mr_n78671664)
print v(xbgr.mr_n78672288)
print v(xbgr.mr_n78672464)
print v(xbgr.mr_n78673088)
print v(xbgr.mr_n78673264)
print v(xbgr.mr_n78673888)
print v(xbgr.mr_n78674064)
print v(xbgr.mr_n78674688)
print v(xbgr.mr_n78674864)
print v(xbgr.mr_n78675488)
print v(xbgr.mr_n78675664)
print v(xbgr.mr_n78676288)
print v(xbgr.mr_n78676464)
print v(xbgr.mr_n78677088)
print v(xbgr.mr_n78677264)
print v(xbgr.mr_n78677888)
print v(xbgr.mr_n78678064)
print v(xbgr.mr_n78678688)
print v(xbgr.mr_n78678864)
print v(xbgr.mr_n78679488)
print v(xbgr.mr_n78679664)
print v(xbgr.mr_n78680096)
print v(xbgr.mr_n78680208)
print v(xbgr.mr_n78680320)
print v(xbgr.mr_n78680432)
print v(xbgr.mr_n78680624)
print v(xbgr.mr_n78680896)
print v(xbgr.mr_n78681168)
print v(xbgr.mr_n78681440)
print v(xbgr.mr_n78681712)
print v(xbgr.mr_n78681984)
print v(xbgr.mr_n78682256)
print v(xbgr.mr_n78682528)
print v(xbgr.mr_n78682800)
print v(xbgr.mr_n78683072)
print v(xbgr.mr_n78683344)
print v(xbgr.mr_n78683616)
print v(xbgr.mr_n78683888)
print v(xbgr.mr_n78685280)
print v(xbgr.mr_n78695904)
print v(xbgr.mr_n78696736)
print v(xbgr.mr_n78700336)
print v(xbgr.mr_n78714976)
print v(xbgr.mr_n78721376)
print v(xbgr.mr_n78721552)
print v(xbgr.mr_n78721888)
print v(xbgr.mr_n78723728)
print v(xbgr.mr_n78723904)
print v(xbgr.mr_n78724848)
print v(xbgr.mr_n78725504)
print v(xbgr.mr_n78725680)
print v(xbgr.mr_n78726624)
print v(xbgr.mr_n78727280)
print v(xbgr.mr_n78727456)
print v(xbgr.mr_n78728400)
print v(xbgr.mr_n78729056)
print v(xbgr.mr_n78729232)
print v(xbgr.mr_n78730176)
print v(xbgr.mr_n78730832)
print v(xbgr.mr_n78731008)
print v(xbgr.mr_n78731952)
print v(xbgr.mr_n78732608)
print v(xbgr.mr_n78732784)
print v(xbgr.mr_n78733728)
print v(xbgr.mr_n78734384)
print v(xbgr.mr_n78734560)
print v(xbgr.mr_n78735504)
print v(xbgr.mr_n78736160)
print v(xbgr.mr_n78736336)
print v(xbgr.mr_n78737280)
print v(xbgr.mr_n78737936)
print v(xbgr.mr_n78738112)
print v(xbgr.mr_n78739056)
print v(xbgr.mr_n78739712)
print v(xbgr.mr_n78739888)
print v(xbgr.mr_n78740928)
print v(xbgr.mr_n78741200)
print v(xbgr.mr_n78741472)
print v(xbgr.mr_n78741808)
print v(xbgr.mr_n78742272)
print v(xbgr.mr_n78742624)
print v(xbgr.mr_n78742816)
print v(xbgr.mr_n78743008)
print v(xbgr.mr_n78743200)
print v(xbgr.mr_n78743952)
print v(xbgr.mr_n78747536)
print v(xbgr.mr_n78747952)
print v(xbgr.mr_n78748064)
print v(xbgr.mr_n78748768)
print v(xbgr.mr_n78750944)
print v(xbgr.mr_n78751360)
print v(xbgr.mr_n78751472)
print v(xbgr.mr_n78752176)
print v(xbgr.mr_n78754416)
print v(xbgr.mr_n78754768)
print v(xbgr.mr_n78754880)
print v(xbgr.mr_n78755584)
print v(xbgr.mr_n78757760)
print v(xbgr.mr_n78758176)
print v(xbgr.mr_n78758288)
print v(xbgr.mr_n78758992)
print v(xbgr.mr_n78761168)
print v(xbgr.mr_n78761584)
print v(xbgr.mr_n78761696)
print v(xbgr.mr_n78761968)
print v(xbgr.mr_n78762720)
print v(xbgr.mr_n78763072)
print v(xbgr.mr_n78763904)
print v(xbgr.mr_n78764256)
print v(xbgr.mr_n78764368)
print v(xbgr.mr_n78765072)
print v(xbgr.mr_n78766400)
print v(xbgr.mr_n78768752)
print v(xbgr.mr_n78769104)
print v(xbgr.mr_n78769216)
print v(xbgr.mr_n78769920)
print v(xbgr.mr_n78772096)
print v(xbgr.mr_n78772512)
print v(xbgr.mr_n78772624)
print v(xbgr.mr_n78773328)
print v(xbgr.mr_n78775504)
print v(xbgr.mr_n78775920)
print v(xbgr.mr_n78776032)
print v(xbgr.mr_n78776736)
print v(xbgr.mr_n78789296)
print v(xbgr.mr_n78789472)
print v(xbgr.mr_n78790096)
print v(xbgr.mr_n78790272)
print v(xbgr.mr_n78790896)
print v(xbgr.mr_n78791072)
print v(xbgr.mr_n78791696)
print v(xbgr.mr_n78791872)
print v(xbgr.mr_n78792496)
print v(xbgr.mr_n78792672)
print v(xbgr.mr_n78793296)
print v(xbgr.mr_n78793472)
print v(xbgr.mr_n78794096)
print v(xbgr.mr_n78794272)
print v(xbgr.mr_n78794896)
print v(xbgr.mr_n78795072)
print v(xbgr.mr_n78795696)
print v(xbgr.mr_n78795872)
print v(xbgr.mr_n78796496)
print v(xbgr.mr_n78796672)
print v(xbgr.mr_n78797296)
print v(xbgr.mr_n78797472)
print v(xbgr.mr_n78798096)
print v(xbgr.mr_n78798272)
print v(xbgr.mr_n78798896)
print v(xbgr.mr_n78799072)
print v(xbgr.mr_n78799696)
print v(xbgr.mr_n78799872)
print v(xbgr.mr_n78800496)
print v(xbgr.mr_n78800672)
print v(xbgr.mr_n78801296)
print v(xbgr.mr_n78801472)
print v(xbgr.mr_n78809712)
print v(xbgr.mr_n78813104)
print v(xbgr.mr_n78813408)
print v(xbgr.mr_n78813712)
print v(xbgr.mr_n78814016)
print v(xbgr.mr_n78814400)
print v(xbgr.mr_n78814864)
print v(xbgr.mr_n78815328)
print v(xbgr.mr_n78815792)
print v(xbgr.mr_n78816256)
print v(xbgr.mr_n78816720)
print v(xbgr.mr_n78817184)
print v(xbgr.mr_n78817648)
print v(xbgr.mr_n78818112)
print v(xbgr.mr_n78818576)
print v(xbgr.mr_n78819040)
print v(xbgr.mr_n78819504)
print v(xbgr.mr_n78819968)
print v(xbgr.mr_n78820432)
print v(xbgr.mr_n78820896)
print v(xbgr.mr_n78821360)
print v(xbgr.mr_n78821824)
print v(xbgr.mr_n78822288)
print v(xbgr.mr_n78822752)
print v(xbgr.mr_n78823216)
print v(xbgr.mr_n78823680)
print v(xbgr.mr_n78824144)
print v(xbgr.mr_n78824608)
print v(xbgr.mr_n78825072)
print v(xbgr.mr_n78825536)
print v(xbgr.mr_n78826000)
print v(xbgr.mr_n78830800)
print v(xbgr.mr_n78832832)
print v(xbgr.mr_n78837968)
print v(xbgr.mr_n78839632)
print v(xbgr.mr_n78850064)
print v(xbgr.mr_n78850592)
print v(xbgr.mr_n78851056)
print v(xbgr.mr_n78851520)
print v(xbgr.mr_n78852048)
print v(xbgr.mr_n78852640)
print v(xbgr.mr_n78853232)
print v(xbgr.mr_n78853824)
print v(xbgr.mr_n78854416)
print v(xbgr.mr_n78855008)
print v(xbgr.mr_n78855600)
print v(xbgr.mr_n78856192)
print v(xbgr.mr_n78856784)
print v(xbgr.mr_n78857376)
print v(xbgr.mr_n78857968)
print v(xbgr.mr_n78858560)
print v(xbgr.mr_n78859152)
print v(xbgr.mr_n78859744)
print v(xbgr.mr_n78862416)
print v(xbgr.mr_n78863568)
print v(xbgr.mr_n78867152)
print v(xbgr.mr_n78870880)
print v(xbgr.mr_n78877968)
print v(xbgr.mr_n78881264)
print v(xbgr.mr_n78882064)
print v(xbgr.mr_n78882368)
print v(xbgr.mr_n78882560)
print v(xbgr.mr_n78882816)
print v(xbgr.mr_n78883072)
print v(xbgr.mr_n78885232)
print v(xbgr.mr_n78914048)
print v(xbgr.mr_n78920288)
print v(xbgr.mr_n78922432)
print v(xbgr.mr_n78926144)
print v(xbgr.mr_n78928352)
print v(xbgr.mr_n78951440)
print v(xbgr.mr_n78952032)
print v(xbgr.mr_n78952624)
print v(xbgr.mr_n78953216)
print v(xbgr.mr_n78953808)
print v(xbgr.mr_n78954400)
print v(xbgr.mr_n78954992)
print v(xbgr.mr_n78955584)
print v(xbgr.mr_n78956176)
print v(xbgr.mr_n78956768)
print v(xbgr.mr_n78957360)
print v(xbgr.mr_n78957952)
print v(xbgr.mr_n78958480)
print v(xbgr.mr_n78958896)
print v(xbgr.mr_n78959824)
print v(xbgr.mr_n78960176)
print v(xbgr.mr_n78960832)
print v(xbgr.mr_n78961856)
print v(xbgr.mr_n78965424)
print v(xbgr.mr_n78965600)
print v(xbgr.mr_n78965776)
print v(xbgr.mr_n78967568)
print v(xbgr.mr_n78970080)
print v(xbgr.mr_n78972032)
print v(xbgr.mr_n78972368)
print v(xbgr.mr_n78972704)
print v(xbgr.mr_n78974144)
print v(xbgr.mr_n78975184)
print v(xbgr.mr_n78975360)
print v(xbgr.mr_n78975872)
print v(xbgr.mr_n78976368)
print v(xbgr.mr_n78976544)
print v(xbgr.mr_n78976880)
print v(xbgr.mr_n78977472)
print v(xbgr.mr_n78977968)
print v(xbgr.mr_n78978304)
print v(xbgr.mr_n78978816)
print v(xbgr.mr_n78978928)
print v(xbgr.mr_n78979040)
print v(xbgr.mr_n78980032)
print v(xbgr.mr_n78980448)
print v(xbgr.mr_n78980960)
print v(xbgr.mr_n78981456)
print v(xbgr.mr_n78981632)
print v(xbgr.mr_n78981968)
print v(xbgr.mr_n78982560)
print v(xbgr.mr_n78983120)
print v(xbgr.mr_n78983296)
print v(xbgr.mr_n78983792)
print v(xbgr.mr_n78984560)
print v(xbgr.mr_n78984736)
print v(xbgr.mr_n78984912)
print v(xbgr.mr_n78985504)
print v(xbgr.mr_n78985616)
print v(xbgr.mr_n78985728)
print v(xbgr.mr_n78985840)
print v(xbgr.mr_n78987328)
print v(xbgr.mr_n78987504)
print v(xbgr.mr_n78988000)
print v(xbgr.mr_n78988784)
print v(xbgr.mr_n78988960)
print v(xbgr.mr_n78989392)
print v(xbgr.mr_n78989504)
print v(xbgr.mr_n78990336)
print v(xbgr.mr_n78990512)
print v(xbgr.mr_n78990768)
print v(xbgr.mr_n78991344)
print v(xbgr.mr_n78992128)
print v(xbgr.mr_n78992304)
print v(xbgr.mr_n78992736)
print v(xbgr.mr_n78993296)
print v(xbgr.mr_n78993472)
print v(xbgr.mr_n78993888)
print v(xbgr.mr_n78994480)
print v(xbgr.mr_n78994592)
print v(xbgr.mr_n78995296)
print v(xbgr.mr_n78995712)
print v(xbgr.mr_n78996224)
print v(xbgr.mr_n78996720)
print v(xbgr.mr_n78996896)
print v(xbgr.mr_n78997312)
print v(xbgr.mr_n78997824)
print v(xbgr.mr_n78998320)
print v(xbgr.mr_n78998656)
print v(xbgr.mr_n78999168)
print v(xbgr.mr_n78999280)
print v(xbgr.mr_n78999392)
print v(xbgr.mr_n79000512)
print v(xbgr.mr_n79000688)
print v(xbgr.mr_n79000944)
print v(xbgr.mr_n79001520)
print v(xbgr.mr_n79002112)
print v(xbgr.mr_n79002224)
print v(xbgr.mr_n79002416)
print v(xbgr.mr_n79002768)
print v(xbgr.mr_n79002880)
print v(xbgr.mr_n79003392)
print v(xbgr.mr_n79003504)
print v(xbgr.mr_n79003616)
print v(xbgr.mr_n79003968)
print v(xbgr.mr_n79004304)
print v(xbgr.mr_n79005248)
print v(xbgr.mr_n79005664)
print v(xbgr.mr_n79005776)
print v(xbgr.mr_n79006336)
print v(xbgr.mr_n79006592)
print v(xbgr.mr_n79007408)
print v(xbgr.mr_n79007840)
print v(xbgr.mr_n79008016)
print v(xbgr.mr_n79008944)
print v(xbgr.mr_n79009120)
print v(xbgr.mr_n79009696)
print v(xbgr.mr_n79009808)
print v(xbgr.mr_n79009920)
print v(xbgr.mr_n79010688)
print v(xbgr.mr_n79011024)
print v(xbgr.mr_n79011968)
print v(xbgr.mr_n79012384)
print v(xbgr.mr_n79012496)
print v(xbgr.mr_n79013056)
print v(xbgr.mr_n79013312)
print v(xbgr.mr_n79014256)
print v(xbgr.mr_n79014672)
print v(xbgr.mr_n79014784)
print v(xbgr.mr_n79014896)
print v(xbgr.mr_n79015664)
print v(xbgr.mr_n79016000)
print v(xbgr.mr_n79017008)
print v(xbgr.mr_n79017184)
print v(xbgr.mr_n79017760)
print v(xbgr.mr_n79018192)
print v(xbgr.mr_n79018368)
print v(xbgr.mr_n79019104)
print v(xbgr.mr_n79019216)
print v(xbgr.mr_n79019776)
print v(xbgr.mr_n79020032)
print v(xbgr.mr_n79020976)
print v(xbgr.mr_n79021392)
print v(xbgr.mr_n79021504)
print v(xbgr.mr_n79021616)
print v(xbgr.mr_n79022384)
print v(xbgr.mr_n79022720)
print v(xbgr.mr_n79023536)
print v(xbgr.mr_n79023648)
print v(xbgr.mr_n79024208)
print v(xbgr.mr_n79024464)
print v(xbgr.mr_n79025408)
print v(xbgr.mr_n79025824)
print v(xbgr.mr_n79025936)
print v(xbgr.mr_n79026496)
print v(xbgr.mr_n79026752)
print v(xbgr.mr_n79027568)
print v(xbgr.mr_n79028000)
print v(xbgr.mr_n79028176)
print v(xbgr.mr_n79030784)
print v(xbgr.mr_n79032512)
print v(xbgr.mr_n79033056)
print v(xbgr.mr_n79033520)
print v(xbgr.mr_n79033984)
print v(xbgr.mr_n79034448)
print v(xbgr.mr_n79034912)
print v(xbgr.mr_n79035376)
print v(xbgr.mr_n79035840)
print v(xbgr.mr_n79036304)
print v(xbgr.mr_n79036768)
print v(xbgr.mr_n79037232)
print v(xbgr.mr_n79037696)
print v(xbgr.mr_n79038160)
print v(xbgr.mr_n79038624)
print v(xbgr.mr_n79039088)
print v(xbgr.mr_n79039552)
print v(xbgr.mr_n79040016)
print v(xbgr.mr_n79040480)
print v(xbgr.mr_n79040944)
print v(xbgr.mr_n79041408)
print v(xbgr.mr_n79041872)
print v(xbgr.mr_n79042320)
print v(xbgr.mr_n79042784)
print v(xbgr.mr_n79043248)
print v(xbgr.mr_n79043712)
print v(xbgr.mr_n79044176)
print v(xbgr.mr_n79044640)
print v(xbgr.mr_n79049008)
print v(xbgr.mr_n79052960)
print v(xbgr.mr_n79055376)
print v(xbgr.mr_n79057120)
print v(xbgr.mr_n79062816)
print v(xbgr.mr_n79074544)
print v(xbgr.mr_n79074976)
print v(xbgr.mr_n79076544)
print v(xbgr.mr_n79076832)
print v(xbgr.mr_n79078416)
print v(xbgr.mr_n79082976)
print v(xbgr.mr_n79085008)
print v(xbgr.mr_n79086304)
print v(xbgr.mr_n79087952)
print v(xbgr.mr_n79088128)
print v(xbgr.mr_n79088384)
print v(xbgr.mr_n79088720)
print v(xbgr.mr_n79090752)
print v(xbgr.mr_n79091392)
print v(xbgr.mr_n79091504)
print v(xbgr.mr_n79093328)
print v(xbgr.mr_n79093440)
print v(xbgr.mr_n79095136)
print v(xbgr.mr_n79095248)
print v(xbgr.mr_n79096944)
print v(xbgr.mr_n79097056)
print v(xbgr.mr_n79098752)
print v(xbgr.mr_n79098864)
print v(xbgr.mr_n79100560)
print v(xbgr.mr_n79100672)
print v(xbgr.mr_n79102368)
print v(xbgr.mr_n79102480)
print v(xbgr.mr_n79104176)
print v(xbgr.mr_n79104288)
print v(xbgr.mr_n79105984)
print v(xbgr.mr_n79106096)
print v(xbgr.mr_n79107792)
print v(xbgr.mr_n79107904)
print v(xbgr.mr_n79109600)
print v(xbgr.mr_n79109712)
print v(xbgr.mr_n79111408)
print v(xbgr.mr_n79111520)
print v(xbgr.mr_n79113216)
print v(xbgr.mr_n79113328)
print v(xbgr.mr_n79115024)
print v(xbgr.mr_n79115136)
print v(xbgr.mr_n79116832)
print v(xbgr.mr_n79116944)
print v(xbgr.mr_n79118640)
print v(xbgr.mr_n79118752)
print v(xbgr.mr_n79120448)
print v(xbgr.mr_n79120560)
print v(xbgr.mr_n79124128)
print v(xbgr.mr_n79125536)
print v(xbgr.mr_n79127856)
print v(xbgr.mr_n79131376)
print v(xbgr.mr_n79132656)
print v(xbgr.mr_n79137440)
print v(xbgr.mr_n79138016)
print v(xbgr.mr_n79143392)
print v(xbgr.mr_n79146560)
print v(xbgr.mr_n79147024)
print v(xbgr.mr_n79147136)
print v(xbgr.mr_n79147952)
print v(xbgr.mr_n79148416)
print v(xbgr.mr_n79148528)
print v(xbgr.mr_n79149344)
print v(xbgr.mr_n79149872)
print v(xbgr.mr_n79150048)
print v(xbgr.mr_n79150992)
print v(xbgr.mr_n79151648)
print v(xbgr.mr_n79151824)
print v(xbgr.mr_n79152768)
print v(xbgr.mr_n79153424)
print v(xbgr.mr_n79153600)
print v(xbgr.mr_n79154544)
print v(xbgr.mr_n79155200)
print v(xbgr.mr_n79155376)
print v(xbgr.mr_n79156320)
print v(xbgr.mr_n79156976)
print v(xbgr.mr_n79157152)
print v(xbgr.mr_n79158096)
print v(xbgr.mr_n79158752)
print v(xbgr.mr_n79158928)
print v(xbgr.mr_n79159872)
print v(xbgr.mr_n79160528)
print v(xbgr.mr_n79160704)
print v(xbgr.mr_n79161648)
print v(xbgr.mr_n79162240)
print v(xbgr.mr_n79162832)
print v(xbgr.mr_n79163424)
print v(xbgr.mr_n79164016)
print v(xbgr.mr_n79164608)
print v(xbgr.mr_n79165200)
print v(xbgr.mr_n79165792)
print v(xbgr.mr_n79166384)
print v(xbgr.mr_n79166976)
print v(xbgr.mr_n79167424)
print v(xbgr.mr_n79167536)
print v(xbgr.mr_n79167648)
print v(xbgr.mr_n79167760)
print v(xbgr.mr_n79168032)
print v(xbgr.mr_n79168976)
print v(xbgr.mr_n79170016)
print v(xbgr.mr_n79170928)
print v(xbgr.mr_n79171520)
print v(xbgr.mr_n79172112)
print v(xbgr.mr_n79172704)
print v(xbgr.mr_n79173296)
print v(xbgr.mr_n79173888)
print v(xbgr.mr_n79174480)
print v(xbgr.mr_n79175072)
print v(xbgr.mr_n79175664)
print v(xbgr.mr_n79176256)
print v(xbgr.mr_n79176848)
print v(xbgr.mr_n79177440)
print v(xbgr.mr_n79178032)
print v(xbgr.mr_n79178624)
print v(xbgr.mr_n79179216)
print v(xbgr.mr_n79182496)
print v(xbgr.mr_n79189280)
print v(xbgr.mr_n79193456)
print v(xbgr.mr_n79196288)
print v(xbgr.mr_n79196624)
print v(xbgr.mr_n79197200)
print v(xbgr.mr_n79197792)
print v(xbgr.mr_n79197904)
print v(xbgr.mr_n79199600)
print v(xbgr.mr_n79199712)
print v(xbgr.mr_n79201408)
print v(xbgr.mr_n79201520)
print v(xbgr.mr_n79203216)
print v(xbgr.mr_n79203328)
print v(xbgr.mr_n79205024)
print v(xbgr.mr_n79205136)
print v(xbgr.mr_n79206832)
print v(xbgr.mr_n79206944)
print v(xbgr.mr_n79208640)
print v(xbgr.mr_n79208752)
print v(xbgr.mr_n79210448)
print v(xbgr.mr_n79210560)
print v(xbgr.mr_n79212256)
print v(xbgr.mr_n79212368)
print v(xbgr.mr_n79214064)
print v(xbgr.mr_n79214176)
print v(xbgr.mr_n79215872)
print v(xbgr.mr_n79215984)
print v(xbgr.mr_n79216096)
print v(xbgr.mr_n79217936)
print v(xbgr.mr_n79218048)
print v(xbgr.mr_n79218160)
print v(xbgr.mr_n79220000)
print v(xbgr.mr_n79220112)
print v(xbgr.mr_n79220224)
print v(xbgr.mr_n79222064)
print v(xbgr.mr_n79222176)
print v(xbgr.mr_n79222288)
print v(xbgr.mr_n79224128)
print v(xbgr.mr_n79224240)
print v(xbgr.mr_n79224352)
print v(xbgr.mr_n79226192)
print v(xbgr.mr_n79226304)
print v(xbgr.mr_n79226416)
print v(xbgr.mr_n79228256)
print v(xbgr.mr_n79228368)
print v(xbgr.mr_n79228480)
print v(xbgr.mr_n79229632)
print v(xbgr.mr_n79230144)
print v(xbgr.mr_n79230688)
print v(xbgr.mr_n79231232)
print v(xbgr.mr_n79231776)
print v(xbgr.mr_n79232320)
print v(xbgr.mr_n79232864)
print v(xbgr.mr_n79233408)
print v(xbgr.mr_n79233952)
print v(xbgr.mr_n79234496)
print v(xbgr.mr_n79235040)
print v(xbgr.mr_n79235584)
print v(xbgr.mr_n79236128)
print v(xbgr.mr_n79236672)
print v(xbgr.mr_n79237216)
print v(xbgr.mr_n79237760)
print v(xbgr.mr_n79238304)
print v(xbgr.mr_n79238848)
print v(xbgr.mr_n79239392)
print v(xbgr.mr_n79239936)
print v(xbgr.mr_n79240480)
print v(xbgr.mr_n79240864)
print v(xbgr.mr_n79241408)
print v(xbgr.mr_n79241952)
print v(xbgr.mr_n79242496)
print v(xbgr.mr_n79243040)
print v(xbgr.mr_n79243584)
print v(xbgr.mr_n79244320)
print v(xbgr.mr_n79244624)
print v(xbgr.mr_n79245008)
print v(xbgr.mr_n79245472)
print v(xbgr.mr_n79245936)
print v(xbgr.mr_n79246400)
print v(xbgr.mr_n79246864)
print v(xbgr.mr_n79247328)
print v(xbgr.mr_n79247792)
print v(xbgr.mr_n79248256)
print v(xbgr.mr_n79248720)
print v(xbgr.mr_n79249184)
print v(xbgr.mr_n79249648)
print v(xbgr.mr_n79250112)
print v(xbgr.mr_n79250576)
print v(xbgr.mr_n79251040)
print v(xbgr.mr_n79251504)
print v(xbgr.mr_n79251968)
print v(xbgr.mr_n79252432)
print v(xbgr.mr_n79252896)
print v(xbgr.mr_n79253360)
print v(xbgr.mr_n79253824)
print v(xbgr.mr_n79254288)
print v(xbgr.mr_n79254784)
print v(xbgr.mr_n79255376)
print v(xbgr.mr_n79255968)
print v(xbgr.mr_n79256560)
print v(xbgr.mr_n79257152)
print v(xbgr.mr_n79257744)
print v(xbgr.mr_n79258336)
print v(xbgr.mr_n79260496)
print v(xbgr.mr_n79260752)
print v(xbgr.mr_n79261056)
print v(xbgr.mr_n79261728)
print v(xbgr.mr_n79262048)
print v(xbgr.mr_n79262816)
print v(xbgr.mr_n79263520)
print v(xbgr.mr_n79263696)
print v(xbgr.mr_n79264592)
print v(xbgr.mr_n79280592)
print v(xbgr.mr_n79293600)
print v(xbgr.mr_n79293744)
print v(xbgr.mr_n79293888)
print v(xbgr.mr_n79294560)
print v(xbgr.mr_n79294896)
print v(xbgr.mr_n79295456)
print v(xbgr.mr_n79297952)
print v(xbgr.mr_n79309392)
print v(xbgr.mr_n79315072)
print v(xbgr.mr_n79316112)
print v(xbgr.mr_n79317600)
print v(xbgr.mr_n79319248)
print v(xbgr.mr_n79320032)
print v(xbgr.mr_n79320560)
print v(xbgr.mr_n79320736)
print v(xbgr.mr_n79321248)
print v(xbgr.mr_n79322848)
print v(xbgr.mr_n79329392)
print v(xbgr.mr_n79330128)
print v(xbgr.mr_n79330304)
print v(xbgr.mr_n79331648)
print v(xbgr.mr_n79336992)
print v(xbgr.mr_n79337264)
print v(xbgr.mr_n79338080)
print v(xbgr.mr_n79338304)
print v(xbgr.mr_n79338656)
print v(xbgr.mr_n79339856)
print v(xbgr.mr_n79341440)
print v(xbgr.mr_n79342656)
print v(xbgr.mr_n79345920)
print v(xbgr.mr_n79348656)
print v(xbgr.mr_n79348832)
print v(xbgr.mr_n79352384)
print v(xbgr.mr_n79353008)
print v(xbgr.mr_n79353696)
print v(xbgr.mr_n79355360)
print v(xbgr.mr_n79355536)
print v(xbgr.mr_n79356352)
print v(xbgr.mr_n79356464)
print v(xbgr.mr_n79356736)
print v(xbgr.mr_n79356960)
print v(xbgr.mr_n79357264)
print v(xbgr.mr_n79357856)
print v(xbgr.mr_n79359488)
print v(xbgr.mr_n79359904)
print v(xbgr.mr_n79363504)
print v(xbgr.mr_n79364336)
print v(xbgr.mr_n79365344)
print v(xbgr.mr_n79367952)
print v(xbgr.mr_n79368288)
print v(xbgr.mr_n79368624)
print v(xbgr.mr_n79368960)
print v(xbgr.mr_n79369376)
print v(xbgr.mr_n79369616)
print v(xbgr.mr_n79369920)
print v(xbgr.mr_n79370512)
print v(xbgr.mr_n79370624)
print v(xbgr.mr_n79370736)
print v(xbgr.mr_n79372576)
print v(xbgr.mr_n79372688)
print v(xbgr.mr_n79372800)
print v(xbgr.mr_n79374640)
print v(xbgr.mr_n79374752)
print v(xbgr.mr_n79374864)
print v(xbgr.mr_n79376704)
print v(xbgr.mr_n79376816)
print v(xbgr.mr_n79376928)
print v(xbgr.mr_n79378768)
print v(xbgr.mr_n79378880)
print v(xbgr.mr_n79378992)
print v(xbgr.mr_n79380832)
print v(xbgr.mr_n79380944)
print v(xbgr.mr_n79381056)
print v(xbgr.mr_n79382896)
print v(xbgr.mr_n79383008)
print v(xbgr.mr_n79383120)
print v(xbgr.mr_n79384960)
print v(xbgr.mr_n79385072)
print v(xbgr.mr_n79385184)
print v(xbgr.mr_n79387024)
print v(xbgr.mr_n79387136)
print v(xbgr.mr_n79387248)
print v(xbgr.mr_n79389088)
print v(xbgr.mr_n79389200)
print v(xbgr.mr_n79389312)
print v(xbgr.mr_n79391152)
print v(xbgr.mr_n79391264)
print v(xbgr.mr_n79391376)
print v(xbgr.mr_n79393216)
print v(xbgr.mr_n79393328)
print v(xbgr.mr_n79393440)
print v(xbgr.mr_n79395280)
print v(xbgr.mr_n79395392)
print v(xbgr.mr_n79395504)
print v(xbgr.mr_n79398048)
print v(xbgr.mr_n79398160)
print v(xbgr.mr_n79398528)
print v(xbgr.mr_n79402032)
print v(xbgr.mr_n79402144)
print v(xbgr.mr_n79402512)
print v(xbgr.mr_n79404016)
print v(xbgr.mr_n79406016)
print v(xbgr.mr_n79406128)
print v(xbgr.mr_n79406496)
print v(xbgr.mr_n79408048)
print v(xbgr.mr_n79410000)
print v(xbgr.mr_n79410112)
print v(xbgr.mr_n79410480)
print v(xbgr.mr_n79413072)
print v(xbgr.mr_n79413184)
print v(xbgr.mr_n79414688)
print v(xbgr.mr_n79415408)
print v(xbgr.mr_n79415584)
print v(xbgr.mr_n79417152)
print v(xbgr.mr_n79417968)
print v(xbgr.mr_n79418144)
print v(xbgr.mr_n79419712)
print v(xbgr.mr_n79420528)
print v(xbgr.mr_n79420704)
print v(xbgr.mr_n79422272)
print v(xbgr.mr_n79423088)
print v(xbgr.mr_n79423264)
print v(xbgr.mr_n79424832)
print v(xbgr.mr_n79425648)
print v(xbgr.mr_n79425824)
print v(xbgr.mr_n79427392)
print v(xbgr.mr_n79428208)
print v(xbgr.mr_n79428384)
print v(xbgr.mr_n79429952)
print v(xbgr.mr_n79430768)
print v(xbgr.mr_n79430944)
print v(xbgr.mr_n79432512)
print v(xbgr.mr_n79433328)
print v(xbgr.mr_n79433504)
print v(xbgr.mr_n79435072)
print v(xbgr.mr_n79435888)
print v(xbgr.mr_n79436064)
print v(xbgr.mr_n79437632)
print v(xbgr.mr_n79438576)
print v(xbgr.mr_n79438688)
print v(xbgr.mr_n79438800)
print v(xbgr.mr_n79440560)
print v(xbgr.mr_n79441072)
print v(xbgr.mr_n79441184)
print v(xbgr.mr_n79441296)
print v(xbgr.mr_n79443984)
print v(xbgr.mr_n79445152)
print v(xbgr.mr_n79445328)
print v(xbgr.mr_n79446896)
print v(xbgr.mr_n79447712)
print v(xbgr.mr_n79447888)
print v(xbgr.mr_n79449456)
print v(xbgr.mr_n79450272)
print v(xbgr.mr_n79450448)
print v(xbgr.mr_n79452016)
print v(xbgr.mr_n79452832)
print v(xbgr.mr_n79453008)
print v(xbgr.mr_n79454576)
print v(xbgr.mr_n79455392)
print v(xbgr.mr_n79455568)
print v(xbgr.mr_n79457136)
print v(xbgr.mr_n79457952)
print v(xbgr.mr_n79458128)
print v(xbgr.mr_n79459696)
print v(xbgr.mr_n79460512)
print v(xbgr.mr_n79460688)
print v(xbgr.mr_n79462256)
print v(xbgr.mr_n79463072)
print v(xbgr.mr_n79463248)
print v(xbgr.mr_n79464816)
print v(xbgr.mr_n79465136)
print v(xbgr.mr_n79465632)
print v(xbgr.mr_n79465808)
print v(xbgr.mr_n79467376)
print v(xbgr.mr_n79468192)
print v(xbgr.mr_n79468368)
print v(xbgr.mr_n79469936)
print v(xbgr.mr_n79470256)
print v(xbgr.mr_n79470752)
print v(xbgr.mr_n79470928)
print v(xbgr.mr_n79472496)
print v(xbgr.mr_n79473312)
print v(xbgr.mr_n79473488)
print v(xbgr.mr_n79475056)
print v(xbgr.mr_n79475872)
print v(xbgr.mr_n79476048)
print v(xbgr.mr_n79477616)
print v(xbgr.mr_n79478432)
print v(xbgr.mr_n79478608)
print v(xbgr.mr_n79478848)
print v(xbgr.mr_n79480176)
print v(xbgr.mr_n79520944)
print v(xbgr.mr_n79552560)
print v(xbgr.mr_n79554656)
print v(xbgr.mr_n79556416)
print v(xbgr.mr_n79570096)
print v(xbgr.mr_n79571552)
print v(xbgr.mr_n79573568)
print v(xbgr.mr_n79577248)
print v(xbgr.mr_n79582272)
print v(xbgr.mr_n79589520)
print v(xbgr.mr_n79589696)
print v(xbgr.mr_n79591120)
print v(xbgr.mr_n79591920)
print v(xbgr.mr_n79592896)
print v(xbgr.mr_n79593008)
print v(xbgr.mr_n79594048)
print v(xbgr.mr_n79594320)
print v(xbgr.mr_n79597072)
print v(xbgr.mr_n79597696)
print v(xbgr.mr_n79597808)
print v(xbgr.mr_n79599088)
print v(xbgr.mr_n79697744)
print v(xbgr.mr_n79697856)
print v(xbgr.mr_n79698288)
print v(xbgr.mr_n79698400)
print v(xbgr.mr_n79698832)
print v(xbgr.mr_n79698944)
print v(xbgr.mr_n79699376)
print v(xbgr.mr_n79699488)
print v(xbgr.mr_n79699920)
print v(xbgr.mr_n79700032)
print v(xbgr.mr_n79700464)
print v(xbgr.mr_n79700576)
print v(xbgr.mr_n79701008)
print v(xbgr.mr_n79701120)
print v(xbgr.mr_n79701552)
print v(xbgr.mr_n79701664)
print v(xbgr.mr_n79702096)
print v(xbgr.mr_n79702208)
print v(xbgr.mr_n79702640)
print v(xbgr.mr_n79702752)
print v(xbgr.mr_n79703184)
print v(xbgr.mr_n79703296)
print v(xbgr.mr_n79703888)
print v(xbgr.mr_n79704000)
print v(xbgr.mr_n79704832)
print v(xbgr.mr_n79704944)
print v(xbgr.mr_n79705776)
print v(xbgr.mr_n79705888)
print v(xbgr.mr_n79706720)
print v(xbgr.mr_n79706832)
print v(xbgr.mr_n79707664)
print v(xbgr.mr_n79707776)
print v(xbgr.mr_n79709632)
print v(xbgr.mr_n79710128)
print v(xbgr.mr_n79711216)
print v(xbgr.mr_n79712368)
print v(xbgr.mr_n79713472)
print v(xbgr.mr_n79715584)
print v(xbgr.mr_n79716688)
print v(xbgr.mr_n79719664)
print v(xbgr.mr_n79721008)
print v(xbgr.mr_n79721200)
print v(xbgr.mr_n79723744)
print v(xbgr.mr_n79725360)
print v(xbgr.mr_n79727040)
print v(xbgr.mr_n79729296)
print v(xbgr.mr_n79731552)
print v(xbgr.mr_n79733808)
print v(xbgr.mr_n79736064)
print v(xbgr.mr_n79738320)
print v(xbgr.mr_n79740576)
print v(xbgr.mr_n79742832)
print v(xbgr.mr_n79749296)
print v(xbgr.mr_n79756832)
print v(xbgr.mr_n79760800)
print v(xbgr.mr_n79767760)
print v(xbgr.mr_n79768880)
print v(xbgr.mr_n79768992)
print v(xbgr.mr_n79769616)
print v(xbgr.mr_n79771152)
print v(xbgr.mr_n79772016)
print v(xbgr.mr_n79772976)
print v(xbgr.mr_n79773088)
print v(xbgr.mr_n79774032)
print v(xbgr.mr_n79775152)
print v(xbgr.mr_n79775264)
print v(xbgr.mr_n79775888)
print v(xbgr.mr_n79777424)
print v(xbgr.mr_n79778288)
print v(xbgr.mr_n79779248)
print v(xbgr.mr_n79779360)
print v(xbgr.mr_n79780304)
print v(xbgr.mr_n79781360)
print v(xbgr.mr_n79781472)
print v(xbgr.mr_n79782096)
print v(xbgr.mr_n79783696)
print v(xbgr.mr_n79784560)
print v(xbgr.mr_n79785520)
print v(xbgr.mr_n79785632)
print v(xbgr.mr_n79786576)
print v(xbgr.mr_n79787696)
print v(xbgr.mr_n79787808)
print v(xbgr.mr_n79788432)
print v(xbgr.mr_n79789968)
print v(xbgr.mr_n79790832)
print v(xbgr.mr_n79791792)
print v(xbgr.mr_n79791904)
print v(xbgr.mr_n79792848)
print v(xbgr.mr_n79793968)
print v(xbgr.mr_n79794080)
print v(xbgr.mr_n79794704)
print v(xbgr.mr_n79796240)
print v(xbgr.mr_n79797104)
print v(xbgr.mr_n79798064)
print v(xbgr.mr_n79798176)
print v(xbgr.mr_n79799120)
print v(xbgr.mr_n79800240)
print v(xbgr.mr_n79800352)
print v(xbgr.mr_n79800976)
print v(xbgr.mr_n79803152)
print v(xbgr.mr_n79803328)
print v(xbgr.mr_n79805216)
print v(xbgr.mr_n79805904)
print v(xbgr.mr_n79806592)
print v(xbgr.mr_n79807344)
print v(xbgr.mr_n79808288)
print v(xbgr.mr_n79809232)
print v(xbgr.mr_n79810176)
print v(xbgr.mr_n79811120)
print v(xbgr.mr_n79812064)
print v(xbgr.mr_n79813008)
print v(xbgr.mr_n79813952)
print v(xbgr.mr_n79814896)
print v(xbgr.mr_n79815840)
print v(xbgr.mr_n79816784)
print v(xbgr.mr_n79817728)
print v(xbgr.mr_n79818672)
print v(xbgr.mr_n79819616)
print v(xbgr.mr_n79820560)
print v(xbgr.mr_n79821504)
print v(xbgr.mr_n79822448)
print v(xbgr.mr_n79823392)
print v(xbgr.mr_n79824336)
print v(xbgr.mr_n79825280)
print v(xbgr.mr_n79826224)
print v(xbgr.mr_n79827136)
print v(xbgr.mr_n79828080)
print v(xbgr.mr_n79829024)
print v(xbgr.mr_n79829936)
print v(xbgr.mr_n79830880)
print v(xbgr.mr_n79831824)
print v(xbgr.mr_n79832736)
print v(xbgr.mr_n79833680)
print v(xbgr.mr_n79834624)
print v(xbgr.mr_n79835536)
print v(xbgr.mr_n79836480)
print v(xbgr.mr_n79837424)
print v(xbgr.mr_n79841568)
print v(xbgr.mr_n79842816)
print v(xbgr.mr_n79843312)
print v(xbgr.mr_n79844144)
print v(xbgr.mr_n79845344)
print v(xbgr.mr_n79845456)
print v(xbgr.mr_n79847920)
print v(xbgr.mr_n79848032)
print v(xbgr.mr_n79850080)
print v(xbgr.mr_n79850192)
print v(xbgr.mr_n79851344)
print v(xbgr.mr_n79851456)
print v(xbgr.mr_n79852608)
print v(xbgr.mr_n79852720)
print v(xbgr.mr_n79853872)
print v(xbgr.mr_n79853984)
print v(xbgr.mr_n79855136)
print v(xbgr.mr_n79855248)
print v(xbgr.mr_n79856400)
print v(xbgr.mr_n79856512)
print v(xbgr.mr_n79857664)
print v(xbgr.mr_n79857776)
print v(xbgr.mr_n79865184)
print v(xbgr.mr_n79870768)
print v(xbgr.mr_n79873440)
print v(xbgr.mr_n79874752)
print v(xbgr.mr_n79875008)
print v(xbgr.mr_n79875264)
print v(xbgr.mr_n79875520)
print v(xbgr.mr_n79878112)
print v(xbgr.mr_n79878224)
print v(xbgr.mr_n79881984)
print v(xbgr.mr_n79883776)
print v(xbgr.mr_n79886464)
print v(xbgr.mr_n79887712)
print v(xbgr.mr_n79887824)
print v(xbgr.mr_n79889824)
print v(xbgr.mr_n79890080)
print v(xbgr.mr_n79891568)
print v(xbgr.mr_n79891840)
print v(xbgr.mr_n79892032)
print v(xbgr.mr_n79895264)
print v(xbgr.mr_n79895456)
print v(xbgr.mr_n79898208)
print v(xbgr.mr_n79899936)
print v(xbgr.mr_n79900128)
print v(xbgr.mr_n79903296)
print v(xbgr.mr_n79903488)
print v(xbgr.mr_n79907632)
print v(xbgr.mr_n79907904)
print v(xbgr.mr_n79908096)
print v(xbgr.mr_n79911392)
print v(xbgr.mr_n79911584)
print v(xbgr.mr_n79915664)
print v(xbgr.mr_n79915936)
print v(xbgr.mr_n79916128)
print v(xbgr.mr_n79919856)
print v(xbgr.mr_n79921104)
print v(xbgr.mr_n79921216)
print v(xbgr.mr_n79924256)
print v(xbgr.mr_n79924448)
print v(xbgr.mr_n79924640)
print v(xbgr.mr_n79925888)
print v(xbgr.mr_n79926000)
print v(xbgr.mr_n79927616)
print v(xbgr.mr_n79930416)
print v(xbgr.mr_n79931664)
print v(xbgr.mr_n79931776)
print v(xbgr.mr_n79934864)
print v(xbgr.mr_n79937760)
print v(xbgr.mr_n79943712)
print v(xbgr.mr_n79944544)
print v(xbgr.mr_n79944656)
print v(xbgr.mr_n79945488)
print v(xbgr.mr_n79945600)
print v(xbgr.mr_n79946432)
print v(xbgr.mr_n79946544)
print v(xbgr.mr_n79947632)
print v(xbgr.mr_n79947744)
print v(xbgr.mr_n79948896)
print v(xbgr.mr_n79949008)
print v(xbgr.mr_n79950096)
print v(xbgr.mr_n79950208)
print v(xbgr.mr_n79951424)
print v(xbgr.mr_n79951536)
print v(xbgr.mr_n79952688)
print v(xbgr.mr_n79952800)
print v(xbgr.mr_n79953952)
print v(xbgr.mr_n79954064)
print v(xbgr.mr_n79955216)
print v(xbgr.mr_n79955328)
print v(xbgr.mr_n79956416)
print v(xbgr.mr_n79956528)
print v(xbgr.mr_n79957744)
print v(xbgr.mr_n79957856)
print v(xbgr.mr_n79959008)
print v(xbgr.mr_n79959120)
print v(xbgr.mr_n79960272)
print v(xbgr.mr_n79960384)
print v(xbgr.mr_n79961536)
print v(xbgr.mr_n79961648)
print v(xbgr.mr_n79962288)
print v(xbgr.mr_n79967648)
print v(xbgr.mr_n79969056)
print v(xbgr.mr_n79969744)
print v(xbgr.mr_n79970432)
print v(xbgr.mr_n79971152)
print v(xbgr.mr_n79972768)
print v(xbgr.mr_n79973216)
print v(xbgr.mr_n79974160)
print v(xbgr.mr_n79975104)
print v(xbgr.mr_n79975424)
print v(xbgr.mr_n79976048)
print v(xbgr.mr_n79976256)
print v(xbgr.mr_n79976368)
print v(xbgr.mr_n79976992)
print v(xbgr.mr_n79977168)
print v(xbgr.mr_n79978736)
print v(xbgr.mr_n79978912)
print v(xbgr.mr_n79979968)
print v(xbgr.mr_n79980464)
print v(xbgr.mr_n79982928)
print v(xbgr.mr_n79983472)
print v(xbgr.mr_n79984816)
print v(xbgr.mr_n79985360)
print v(xbgr.mr_n79986704)
print v(xbgr.mr_n79987248)
print v(xbgr.mr_n79988592)
print v(xbgr.mr_n79989136)
print v(xbgr.mr_n79990480)
print v(xbgr.mr_n79991024)
print v(xbgr.mr_n79992368)
print v(xbgr.mr_n79992912)
print v(xbgr.mr_n79994256)
print v(xbgr.mr_n79994800)
print v(xbgr.mr_n79996144)
print v(xbgr.mr_n79996688)
print v(xbgr.mr_n79998032)
print v(xbgr.mr_n79998896)
print v(xbgr.mr_n79999856)
print v(xbgr.mr_n79999968)
print v(xbgr.mr_n80000912)
print v(xbgr.mr_n80002064)
print v(xbgr.mr_n80002176)
print v(xbgr.mr_n80003120)
print v(xbgr.mr_n80004272)
print v(xbgr.mr_n80004384)
print v(xbgr.mr_n80005008)
print v(xbgr.mr_n80011568)
print v(xbgr.mr_n80012496)
print v(xbgr.mr_n80015264)
print v(xbgr.mr_n80016288)
print v(xbgr.mr_n80020112)
print v(xbgr.mr_n80020800)
print v(xbgr.mr_n80021488)
print v(xbgr.mr_n80022208)
print v(xbgr.mr_n80023152)
print v(xbgr.mr_n80023344)
print v(xbgr.mr_n80023536)
print v(xbgr.mr_n80023728)
print v(xbgr.mr_n80023920)
print v(xbgr.mr_n80024112)
print v(xbgr.mr_n80026256)
print v(xbgr.mr_n80026368)
print v(xbgr.mr_n80028384)
print v(xbgr.mr_n80030400)
print v(xbgr.mr_n80030512)
print v(xbgr.mr_n80036160)
print v(xbgr.mr_n80037104)
print v(xbgr.mr_n80040800)
print v(xbgr.mr_n80044784)
print v(xbgr.mr_n80052128)
print v(xbgr.mr_n80053072)
print v(xbgr.mr_n80054016)
print v(xbgr.mr_n80054960)
print v(xbgr.mr_n80055904)
print v(xbgr.mr_n80056848)
print v(xbgr.mr_n80057792)
print v(xbgr.mr_n80058736)
print v(xbgr.mr_n80060352)
print v(xbgr.mr_n80064288)
print v(xbgr.mr_n80064480)
print v(xbgr.mr_n80065312)
print v(xbgr.mr_n80065824)
print v(xbgr.mr_n80067440)
print v(xbgr.mr_n80067632)
print v(xbgr.mr_n80068464)
print v(xbgr.mr_n80068976)
print v(xbgr.mr_n80070736)
print v(xbgr.mr_n80070928)
print v(xbgr.mr_n80071616)
print v(xbgr.mr_n80072128)
print v(xbgr.mr_n80073744)
print v(xbgr.mr_n80073936)
print v(xbgr.mr_n80074768)
print v(xbgr.mr_n80075280)
print v(xbgr.mr_n80077040)
print v(xbgr.mr_n80077232)
print v(xbgr.mr_n80077920)
print v(xbgr.mr_n80078432)
print v(xbgr.mr_n80080192)
print v(xbgr.mr_n80080384)
print v(xbgr.mr_n80081072)
print v(xbgr.mr_n80081584)
print v(xbgr.mr_n80083344)
print v(xbgr.mr_n80083536)
print v(xbgr.mr_n80084224)
print v(xbgr.mr_n80084736)
print v(xbgr.mr_n80086352)
print v(xbgr.mr_n80086544)
print v(xbgr.mr_n80087376)
print v(xbgr.mr_n80087952)
print v(xbgr.mr_n80088640)
print v(xbgr.mr_n80089344)
print v(xbgr.mr_n80089904)
print v(xbgr.mr_n80090480)
print v(xbgr.mr_n80091168)
print v(xbgr.mr_n80091744)
print v(xbgr.mr_n80092432)
print v(xbgr.mr_n80093008)
print v(xbgr.mr_n80093696)
print v(xbgr.mr_n80094128)
print v(xbgr.mr_n80094960)
print v(xbgr.mr_n80095536)
print v(xbgr.mr_n80096224)
print v(xbgr.mr_n80098656)
print v(xbgr.mr_n80099344)
print v(xbgr.mr_n80100032)
print v(xbgr.mr_n80101648)
print v(xbgr.mr_n80102688)
print v(xbgr.mr_n80102880)
print v(xbgr.mr_n80103568)
print v(xbgr.mr_n80103760)
print v(xbgr.mr_n80104336)
print v(xbgr.mr_n80104448)
print v(xbgr.mr_n80106208)
print v(xbgr.mr_n80107040)
print v(xbgr.mr_n80107312)
print v(xbgr.mr_n80107424)
print v(xbgr.mr_n80108064)
print v(xbgr.mr_n80108176)
print v(xbgr.mr_n80108288)
print v(xbgr.mr_n80108480)
print v(xbgr.mr_n80108672)
print v(xbgr.mr_n80108864)
print v(xbgr.mr_n80111120)
print v(xbgr.mr_n80111392)
print v(xbgr.mr_n80111584)
print v(xbgr.mr_n80112096)
print v(xbgr.mr_n80113840)
print v(xbgr.mr_n80113952)
print v(xbgr.mr_n80116208)
print v(xbgr.mr_n80116480)
print v(xbgr.mr_n80116672)
print v(xbgr.mr_n80117184)
print v(xbgr.mr_n80118656)
print v(xbgr.mr_n80119168)
print v(xbgr.mr_n80123216)
print v(xbgr.mr_n80123488)
print v(xbgr.mr_n80123680)
print v(xbgr.mr_n80124192)
print v(xbgr.mr_n80125808)
print v(xbgr.mr_n80126000)
print v(xbgr.mr_n80128192)
print v(xbgr.mr_n80128384)
print v(xbgr.mr_n80128576)
print v(xbgr.mr_n80129168)
print v(xbgr.mr_n80131104)
print v(xbgr.mr_n80131616)
print v(xbgr.mr_n80134352)
print v(xbgr.mr_n80134624)
print v(xbgr.mr_n80134816)
print v(xbgr.mr_n80135328)
print v(xbgr.mr_n80136944)
print v(xbgr.mr_n80137136)
print v(xbgr.mr_n80139328)
print v(xbgr.mr_n80139600)
print v(xbgr.mr_n80139792)
print v(xbgr.mr_n80140304)
print v(xbgr.mr_n80142240)
print v(xbgr.mr_n80142752)
print v(xbgr.mr_n80145488)
print v(xbgr.mr_n80145760)
print v(xbgr.mr_n80145952)
print v(xbgr.mr_n80146464)
print v(xbgr.mr_n80148080)
print v(xbgr.mr_n80148272)
print v(xbgr.mr_n80150464)
print v(xbgr.mr_n80150736)
print v(xbgr.mr_n80150928)
print v(xbgr.mr_n80151440)
print v(xbgr.mr_n80152336)
print v(xbgr.mr_n80153376)
print v(xbgr.mr_n80153888)
print v(xbgr.mr_n80156624)
print v(xbgr.mr_n80156816)
print v(xbgr.mr_n80157008)
print v(xbgr.mr_n80157600)
print v(xbgr.mr_n80161312)
print v(xbgr.mr_n80162464)
print v(xbgr.mr_n80162576)
print v(xbgr.mr_n80163728)
print v(xbgr.mr_n80163840)
print v(xbgr.mr_n80164992)
print v(xbgr.mr_n80165104)
print v(xbgr.mr_n80166256)
print v(xbgr.mr_n80166368)
print v(xbgr.mr_n80167456)
print v(xbgr.mr_n80167568)
print v(xbgr.mr_n80168784)
print v(xbgr.mr_n80168896)
print v(xbgr.mr_n80170048)
print v(xbgr.mr_n80170160)
print v(xbgr.mr_n80171312)
print v(xbgr.mr_n80171424)
print v(xbgr.mr_n80172576)
print v(xbgr.mr_n80172688)
print v(xbgr.mr_n80173840)
print v(xbgr.mr_n80173952)
print v(xbgr.mr_n80175040)
print v(xbgr.mr_n80175152)
print v(xbgr.mr_n80176368)
print v(xbgr.mr_n80176480)
print v(xbgr.mr_n80177632)
print v(xbgr.mr_n80177744)
print v(xbgr.mr_n80178896)
print v(xbgr.mr_n80179008)
print v(xbgr.mr_n80180160)
print v(xbgr.mr_n80180272)
print v(xbgr.mr_n80180976)
print v(xbgr.mr_n80183344)
print v(xbgr.mr_n80188032)
print v(xbgr.mr_n80188368)
print v(xbgr.mr_n80193072)
print v(xbgr.mr_n80197040)
print v(xbgr.mr_n80197488)
print v(xbgr.mr_n80200000)
print v(xbgr.mr_n80202480)
print v(xbgr.mr_n80204976)
print v(xbgr.mr_n80208992)
print v(xbgr.mr_n80210656)
print v(xbgr.mr_n80211056)
print v(xbgr.mr_n80214240)
print v(xbgr.mr_n80214928)
print v(xbgr.mr_n80215680)
print v(xbgr.mr_n80216624)
print v(xbgr.mr_n80218720)
print v(xbgr.mr_n80220672)
print v(xbgr.mr_n80223552)
print v(xbgr.mr_n80223744)
print v(xbgr.mr_n80224576)
print v(xbgr.mr_n80224688)
print v(xbgr.mr_n80224800)
print v(xbgr.mr_n80224912)
print v(xbgr.mr_n80225024)
print v(xbgr.mr_n80226768)
print v(xbgr.mr_n80227040)
print v(xbgr.mr_n80227232)
print v(xbgr.mr_n80227744)
print v(xbgr.mr_n80229760)
print v(xbgr.mr_n80229952)
print v(xbgr.mr_n80231760)
print v(xbgr.mr_n80231952)
print v(xbgr.mr_n80232464)
print v(xbgr.mr_n80234336)
print v(xbgr.mr_n80236080)
print v(xbgr.mr_n80236352)
print v(xbgr.mr_n80236544)
print v(xbgr.mr_n80237056)
print v(xbgr.mr_n80238288)
print v(xbgr.mr_n80238800)
print v(xbgr.mr_n80239616)
print v(xbgr.mr_n80242240)
print v(xbgr.mr_n80242512)
print v(xbgr.mr_n80242704)
print v(xbgr.mr_n80243216)
print v(xbgr.mr_n80245360)
print v(xbgr.mr_n80245472)
print v(xbgr.mr_n80247216)
print v(xbgr.mr_n80247488)
print v(xbgr.mr_n80247680)
print v(xbgr.mr_n80248192)
print v(xbgr.mr_n80250688)
print v(xbgr.mr_n80254816)
print v(xbgr.mr_n80254928)
print v(xbgr.mr_n80255040)
print v(xbgr.mr_n80255152)
print v(xbgr.mr_n80256896)
print v(xbgr.mr_n80257168)
print v(xbgr.mr_n80257360)
print v(xbgr.mr_n80257872)
print v(xbgr.mr_n80259168)
print v(xbgr.mr_n80259680)
print v(xbgr.mr_n80263056)
print v(xbgr.mr_n80263328)
print v(xbgr.mr_n80263520)
print v(xbgr.mr_n80264032)
print v(xbgr.mr_n80266176)
print v(xbgr.mr_n80266368)
print v(xbgr.mr_n80266560)
print v(xbgr.mr_n80268368)
print v(xbgr.mr_n80268560)
print v(xbgr.mr_n80269072)
print v(xbgr.mr_n80270240)
print v(xbgr.mr_n80270752)
print v(xbgr.mr_n80274192)
print v(xbgr.mr_n80274464)
print v(xbgr.mr_n80274656)
print v(xbgr.mr_n80275168)
print v(xbgr.mr_n80277312)
print v(xbgr.mr_n80277504)
print v(xbgr.mr_n80277696)
print v(xbgr.mr_n80278096)
print v(xbgr.mr_n80279504)
print v(xbgr.mr_n80279696)
print v(xbgr.mr_n80280208)
print v(xbgr.mr_n80281376)
print v(xbgr.mr_n80281888)
print v(xbgr.mr_n80283936)
print v(xbgr.mr_n80285328)
print v(xbgr.mr_n80285600)
print v(xbgr.mr_n80285792)
print v(xbgr.mr_n80286304)
print v(xbgr.mr_n80288368)
print v(xbgr.mr_n80288480)
print v(xbgr.mr_n80288992)
print v(xbgr.mr_n80289104)
print v(xbgr.mr_n80289616)
print v(xbgr.mr_n80289728)
print v(xbgr.mr_n80290496)
print v(xbgr.mr_n80290608)
print v(xbgr.mr_n80291440)
print v(xbgr.mr_n80291552)
print v(xbgr.mr_n80292384)
print v(xbgr.mr_n80292496)
print v(xbgr.mr_n80293328)
print v(xbgr.mr_n80293440)
print v(xbgr.mr_n80294272)
print v(xbgr.mr_n80294384)
print v(xbgr.mr_n80295280)
print v(xbgr.mr_n80295392)
print v(xbgr.mr_n80296544)
print v(xbgr.mr_n80296656)
print v(xbgr.mr_n80297808)
print v(xbgr.mr_n80297920)
print v(xbgr.mr_n80299072)
print v(xbgr.mr_n80299184)
print v(xbgr.mr_n80300336)
print v(xbgr.mr_n80300448)
print v(xbgr.mr_n80301600)
print v(xbgr.mr_n80301712)
print v(xbgr.mr_n80302864)
print v(xbgr.mr_n80302976)
print v(xbgr.mr_n80305328)
print v(xbgr.mr_n80308800)
print v(xbgr.mr_n80309504)
print v(xbgr.mr_n80310976)
print v(xbgr.mr_n80315040)
print v(xbgr.mr_n80315152)
print v(xbgr.mr_n80316304)
print v(xbgr.mr_n80316416)
print v(xbgr.mr_n80317568)
print v(xbgr.mr_n80317680)
print v(xbgr.mr_n80318832)
print v(xbgr.mr_n80318944)
print v(xbgr.mr_n80320096)
print v(xbgr.mr_n80320208)
print v(xbgr.mr_n80321360)
print v(xbgr.mr_n80321472)
print v(xbgr.mr_n80322624)
print v(xbgr.mr_n80322736)
print v(xbgr.mr_n80323888)
print v(xbgr.mr_n80324000)
print v(xbgr.mr_n80325152)
print v(xbgr.mr_n80325264)
print v(xbgr.mr_n80326416)
print v(xbgr.mr_n80326528)
print v(xbgr.mr_n80327680)
print v(xbgr.mr_n80327792)
print v(xbgr.mr_n80328944)
print v(xbgr.mr_n80329056)
print v(xbgr.mr_n80330208)
print v(xbgr.mr_n80330320)
print v(xbgr.mr_n80331472)
print v(xbgr.mr_n80331584)
print v(xbgr.mr_n80332736)
print v(xbgr.mr_n80332848)
print v(xbgr.mr_n80334000)
print v(xbgr.mr_n80334112)
print v(xbgr.mr_n80335264)
print v(xbgr.mr_n80335376)
print v(xbgr.mr_n80349056)
print v(xbgr.mr_n80350576)
print v(xbgr.mr_n80351584)
print v(xbgr.mr_n80352752)
print v(xbgr.mr_n80353424)
print v(xbgr.mr_n80357328)
print v(xbgr.mr_n80358208)
print v(xbgr.mr_n80358624)
print v(xbgr.mr_n80358800)
print v(xbgr.mr_n80359088)
print v(xbgr.mr_n80359328)
print v(xbgr.mr_n80359440)
print v(xbgr.mr_n80360144)
print v(xbgr.mr_n80361200)
print v(xbgr.mr_n80362432)
print v(xbgr.mr_n80362608)
print v(xbgr.mr_n80362848)
print v(xbgr.mr_n80363024)
print v(xbgr.mr_n80363840)
print v(xbgr.mr_n80367248)
print v(xbgr.mr_n80367424)
print v(xbgr.mr_n80368480)
print v(xbgr.mr_n80368768)
print v(xbgr.mr_n80369184)
print v(xbgr.mr_n80369712)
print v(xbgr.mr_n80370352)
print v(xbgr.mr_n80370528)
print v(xbgr.mr_n80371120)
print v(xbgr.mr_n80372000)
print v(xbgr.mr_n80372992)
print v(xbgr.mr_n80374928)
print v(xbgr.mr_n80376096)
print v(xbgr.mr_n80376688)
print v(xbgr.mr_n80376928)
print v(xbgr.mr_n80377104)
print v(xbgr.mr_n80377280)
print v(xbgr.mr_n80378256)
print v(xbgr.mr_n80378816)
print v(xbgr.mr_n80379216)
print v(xbgr.mr_n80379328)
print v(xbgr.mr_n80379808)
print v(xbgr.mr_n80382448)
print v(xbgr.mr_n80383136)
print v(xbgr.mr_n80383824)
print v(xbgr.mr_n80384768)
print v(xbgr.mr_n80386576)
print v(xbgr.mr_n80389520)
print v(xbgr.mr_n80389712)
print v(xbgr.mr_n80390544)
print v(xbgr.mr_n80390656)
print v(xbgr.mr_n80390848)
print v(xbgr.mr_n80391040)
print v(xbgr.mr_n80391232)
print v(xbgr.mr_n80391424)
print v(xbgr.mr_n80391616)
print v(xbgr.mr_n80391808)
print v(xbgr.mr_n80394032)
print v(xbgr.mr_n80395808)
print v(xbgr.mr_n80397552)
print v(xbgr.mr_n80397824)
print v(xbgr.mr_n80398016)
print v(xbgr.mr_n80398528)
print v(xbgr.mr_n80400464)
print v(xbgr.mr_n80402208)
print v(xbgr.mr_n80402480)
print v(xbgr.mr_n80402672)
print v(xbgr.mr_n80403184)
print v(xbgr.mr_n80405200)
print v(xbgr.mr_n80405392)
print v(xbgr.mr_n80407200)
print v(xbgr.mr_n80407392)
print v(xbgr.mr_n80407904)
print v(xbgr.mr_n80409776)
print v(xbgr.mr_n80411520)
print v(xbgr.mr_n80411792)
print v(xbgr.mr_n80411984)
print v(xbgr.mr_n80412496)
print v(xbgr.mr_n80414432)
print v(xbgr.mr_n80416176)
print v(xbgr.mr_n80416448)
print v(xbgr.mr_n80416640)
print v(xbgr.mr_n80417152)
print v(xbgr.mr_n80419088)
print v(xbgr.mr_n80420832)
print v(xbgr.mr_n80421024)
print v(xbgr.mr_n80421216)
print v(xbgr.mr_n80421808)
print v(xbgr.mr_n80423744)
print v(xbgr.mr_n80425488)
print v(xbgr.mr_n80425760)
print v(xbgr.mr_n80425952)
print v(xbgr.mr_n80426464)
print v(xbgr.mr_n80428480)
print v(xbgr.mr_n80428672)
print v(xbgr.mr_n80430480)
print v(xbgr.mr_n80430672)
print v(xbgr.mr_n80431184)
print v(xbgr.mr_n80433056)
print v(xbgr.mr_n80434800)
print v(xbgr.mr_n80435072)
print v(xbgr.mr_n80435264)
print v(xbgr.mr_n80435776)
print v(xbgr.mr_n80437712)
print v(xbgr.mr_n80439456)
print v(xbgr.mr_n80439728)
print v(xbgr.mr_n80439920)
print v(xbgr.mr_n80440432)
print v(xbgr.mr_n80442368)
print v(xbgr.mr_n80444112)
print v(xbgr.mr_n80444384)
print v(xbgr.mr_n80444576)
print v(xbgr.mr_n80445088)
print v(xbgr.mr_n80447024)
print v(xbgr.mr_n80448768)
print v(xbgr.mr_n80449040)
print v(xbgr.mr_n80449232)
print v(xbgr.mr_n80449744)
print v(xbgr.mr_n80451680)
print v(xbgr.mr_n80453424)
print v(xbgr.mr_n80453696)
print v(xbgr.mr_n80453888)
print v(xbgr.mr_n80454400)
print v(xbgr.mr_n80456336)
print v(xbgr.mr_n80458080)
print v(xbgr.mr_n80458352)
print v(xbgr.mr_n80458544)
print v(xbgr.mr_n80459056)
print v(xbgr.mr_n80460992)
print v(xbgr.mr_n80462736)
print v(xbgr.mr_n80463008)
print v(xbgr.mr_n80463200)
print v(xbgr.mr_n80463712)
print v(xbgr.mr_n80465728)
print v(xbgr.mr_n80465920)
print v(xbgr.mr_n80467728)
print v(xbgr.mr_n80467920)
print v(xbgr.mr_n80468432)
print v(xbgr.mr_n80471200)
print v(xbgr.mr_n80471984)
print v(xbgr.mr_n80473632)
print v(xbgr.mr_n80473968)
print v(xbgr.mr_n80475536)
print v(xbgr.mr_n80476176)
print v(xbgr.mr_n80477840)
print v(xbgr.mr_n80478272)
print v(xbgr.mr_n80478704)
print v(xbgr.mr_n80480128)
print v(xbgr.mr_n80480704)
print v(xbgr.mr_n80480816)
print v(xbgr.mr_n80481760)
print v(xbgr.mr_n80482592)
print v(xbgr.mr_n80482704)
print v(xbgr.mr_n80483648)
print v(xbgr.mr_n80484800)
print v(xbgr.mr_n80484912)
print v(xbgr.mr_n80485856)
print v(xbgr.mr_n80487008)
print v(xbgr.mr_n80487120)
print v(xbgr.mr_n80488064)
print v(xbgr.mr_n80489216)
print v(xbgr.mr_n80489328)
print v(xbgr.mr_n80490272)
print v(xbgr.mr_n80491424)
print v(xbgr.mr_n80491536)
print v(xbgr.mr_n80492480)
print v(xbgr.mr_n80493632)
print v(xbgr.mr_n80493744)
print v(xbgr.mr_n80494688)
print v(xbgr.mr_n80495840)
print v(xbgr.mr_n80495952)
print v(xbgr.mr_n80496896)
print v(xbgr.mr_n80497216)
print v(xbgr.mr_n80498048)
print v(xbgr.mr_n80498160)
print v(xbgr.mr_n80499104)
print v(xbgr.mr_n80500256)
print v(xbgr.mr_n80500368)
print v(xbgr.mr_n80501312)
print v(xbgr.mr_n80502464)
print v(xbgr.mr_n80502576)
print v(xbgr.mr_n80503520)
print v(xbgr.mr_n80504672)
print v(xbgr.mr_n80504784)
print v(xbgr.mr_n80505728)
print v(xbgr.mr_n80506880)
print v(xbgr.mr_n80506992)
print v(xbgr.mr_n80507936)
print v(xbgr.mr_n80509088)
print v(xbgr.mr_n80509200)
print v(xbgr.mr_n80510144)
print v(xbgr.mr_n80510320)
print v(xbgr.mr_n80511296)
print v(xbgr.mr_n80511408)
print v(xbgr.mr_n80512496)
print v(xbgr.mr_n80512608)
print v(xbgr.mr_n80513824)
print v(xbgr.mr_n80513936)
print v(xbgr.mr_n80515600)
print v(xbgr.mr_n80516240)
print v(xbgr.mr_n80518864)
print v(xbgr.mr_n80518976)
print v(xbgr.mr_n80520000)
print v(xbgr.mr_n80520112)
print v(xbgr.mr_n80520944)
print v(xbgr.mr_n80521056)
print v(xbgr.mr_n80522592)
print v(xbgr.mr_n80522704)
print v(xbgr.mr_n80525264)
print v(xbgr.mr_n80525376)
print v(xbgr.mr_n80526592)
print v(xbgr.mr_n80526704)
print v(xbgr.mr_n80527856)
print v(xbgr.mr_n80527968)
print v(xbgr.mr_n80529120)
print v(xbgr.mr_n80529232)
print v(xbgr.mr_n80531648)
print v(xbgr.mr_n80532048)
print v(xbgr.mr_n80534288)
print v(xbgr.mr_n80545200)
print v(xbgr.mr_n80559264)
print v(xbgr.mr_n80559456)
print v(xbgr.mr_n80559648)
print v(xbgr.mr_n80559840)
print v(xbgr.mr_n80560544)
print v(xbgr.mr_n80562160)
print v(xbgr.mr_n80562432)
print v(xbgr.mr_n80562624)
print v(xbgr.mr_n80563136)
print v(xbgr.mr_n80568816)
print v(xbgr.mr_n80569088)
print v(xbgr.mr_n80569280)
print v(xbgr.mr_n80569792)
print v(xbgr.mr_n80571936)
print v(xbgr.mr_n80572048)
print v(xbgr.mr_n80573792)
print v(xbgr.mr_n80574064)
print v(xbgr.mr_n80574256)
print v(xbgr.mr_n80574768)
print v(xbgr.mr_n80576064)
print v(xbgr.mr_n80576576)
print v(xbgr.mr_n80579952)
print v(xbgr.mr_n80580224)
print v(xbgr.mr_n80580416)
print v(xbgr.mr_n80580928)
print v(xbgr.mr_n80583072)
print v(xbgr.mr_n80583184)
print v(xbgr.mr_n80584928)
print v(xbgr.mr_n80585200)
print v(xbgr.mr_n80585392)
print v(xbgr.mr_n80585904)
print v(xbgr.mr_n80586016)
print v(xbgr.mr_n80587136)
print v(xbgr.mr_n80587648)
print v(xbgr.mr_n80589616)
print v(xbgr.mr_n80591424)
print v(xbgr.mr_n80591616)
print v(xbgr.mr_n80592128)
print v(xbgr.mr_n80594208)
print v(xbgr.mr_n80594320)
print v(xbgr.mr_n80596064)
print v(xbgr.mr_n80596336)
print v(xbgr.mr_n80596528)
print v(xbgr.mr_n80597040)
print v(xbgr.mr_n80598272)
print v(xbgr.mr_n80598784)
print v(xbgr.mr_n80602224)
print v(xbgr.mr_n80602496)
print v(xbgr.mr_n80602688)
print v(xbgr.mr_n80603200)
print v(xbgr.mr_n80605344)
print v(xbgr.mr_n80605456)
print v(xbgr.mr_n80607200)
print v(xbgr.mr_n80607472)
print v(xbgr.mr_n80607664)
print v(xbgr.mr_n80608176)
print v(xbgr.mr_n80609408)
print v(xbgr.mr_n80609920)
print v(xbgr.mr_n80611888)
print v(xbgr.mr_n80613696)
print v(xbgr.mr_n80613888)
print v(xbgr.mr_n80614400)
print v(xbgr.mr_n80616480)
print v(xbgr.mr_n80616672)
print v(xbgr.mr_n80616864)
print v(xbgr.mr_n80618672)
print v(xbgr.mr_n80618864)
print v(xbgr.mr_n80619376)
print v(xbgr.mr_n80620544)
print v(xbgr.mr_n80621056)
print v(xbgr.mr_n80624496)
print v(xbgr.mr_n80624768)
print v(xbgr.mr_n80624960)
print v(xbgr.mr_n80625472)
print v(xbgr.mr_n80627888)
print v(xbgr.mr_n80630672)
print v(xbgr.mr_n80630784)
print v(xbgr.mr_n80631616)
print v(xbgr.mr_n80631728)
print v(xbgr.mr_n80632560)
print v(xbgr.mr_n80632672)
print v(xbgr.mr_n80633760)
print v(xbgr.mr_n80633872)
print v(xbgr.mr_n80635024)
print v(xbgr.mr_n80635136)
print v(xbgr.mr_n80636288)
print v(xbgr.mr_n80636400)
print v(xbgr.mr_n80637552)
print v(xbgr.mr_n80637664)
print v(xbgr.mr_n80638816)
print v(xbgr.mr_n80638928)
print v(xbgr.mr_n80640080)
print v(xbgr.mr_n80640192)
print v(xbgr.mr_n80641344)
print v(xbgr.mr_n80641456)
print v(xbgr.mr_n80642608)
print v(xbgr.mr_n80642720)
print v(xbgr.mr_n80643872)
print v(xbgr.mr_n80643984)
print v(xbgr.mr_n80645136)
print v(xbgr.mr_n80645248)
print v(xbgr.mr_n80646400)
print v(xbgr.mr_n80646512)
print v(xbgr.mr_n80647664)
print v(xbgr.mr_n80647776)
print v(xbgr.mr_n80649504)
print v(xbgr.mr_n80652512)
print v(xbgr.mr_n80653200)
print v(xbgr.mr_n80656624)
print v(xbgr.mr_n80657968)
print v(xbgr.mr_n80658656)
print v(xbgr.mr_n80659344)
print v(xbgr.mr_n80660032)
print v(xbgr.mr_n80661136)
print v(xbgr.mr_n80662688)
print v(xbgr.mr_n80663632)
print v(xbgr.mr_n80664576)
print v(xbgr.mr_n80665520)
print v(xbgr.mr_n80666464)
print v(xbgr.mr_n80667408)
print v(xbgr.mr_n80669824)
print v(xbgr.mr_n80670160)
print v(xbgr.mr_n80672368)
print v(xbgr.mr_n80673872)
print v(xbgr.mr_n80675504)
print v(xbgr.mr_n80677072)
print v(xbgr.mr_n80678640)
print v(xbgr.mr_n80680208)
print v(xbgr.mr_n80681776)
print v(xbgr.mr_n80683344)
print v(xbgr.mr_n80687824)
print v(xbgr.mr_n80688512)
print v(xbgr.mr_n80689200)
print v(xbgr.mr_n80689936)
print v(xbgr.mr_n80691552)
print v(xbgr.mr_n80692832)
print v(xbgr.mr_n80692944)
print v(xbgr.mr_n80693888)
print v(xbgr.mr_n80695040)
print v(xbgr.mr_n80695152)
print v(xbgr.mr_n80696096)
print v(xbgr.mr_n80697248)
print v(xbgr.mr_n80697360)
print v(xbgr.mr_n80698304)
print v(xbgr.mr_n80699456)
print v(xbgr.mr_n80699568)
print v(xbgr.mr_n80700512)
print v(xbgr.mr_n80701664)
print v(xbgr.mr_n80701776)
print v(xbgr.mr_n80702720)
print v(xbgr.mr_n80703872)
print v(xbgr.mr_n80703984)
print v(xbgr.mr_n80704928)
print v(xbgr.mr_n80706080)
print v(xbgr.mr_n80706192)
print v(xbgr.mr_n80707136)
print v(xbgr.mr_n80708224)
print v(xbgr.mr_n80708336)
print v(xbgr.mr_n80709280)
print v(xbgr.mr_n80710496)
print v(xbgr.mr_n80710608)
print v(xbgr.mr_n80711552)
print v(xbgr.mr_n80712704)
print v(xbgr.mr_n80712816)
print v(xbgr.mr_n80713760)
print v(xbgr.mr_n80714912)
print v(xbgr.mr_n80715024)
print v(xbgr.mr_n80715968)
print v(xbgr.mr_n80717120)
print v(xbgr.mr_n80717232)
print v(xbgr.mr_n80718176)
print v(xbgr.mr_n80719328)
print v(xbgr.mr_n80719440)
print v(xbgr.mr_n80720384)
print v(xbgr.mr_n80721536)
print v(xbgr.mr_n80721648)
print v(xbgr.mr_n80722592)
print v(xbgr.mr_n80723744)
print v(xbgr.mr_n80723856)
print v(xbgr.mr_n80724800)
print v(xbgr.mr_n80725952)
print v(xbgr.mr_n80726064)
print v(xbgr.mr_n80727008)
print v(xbgr.mr_n80728160)
print v(xbgr.mr_n80728272)
print v(xbgr.mr_n80729152)
print v(xbgr.mr_n80729840)
print v(xbgr.mr_n80730528)
print v(xbgr.mr_n80731248)
print v(xbgr.mr_n80732192)
print v(xbgr.mr_n80733136)
print v(xbgr.mr_n80734080)
print v(xbgr.mr_n80735024)
print v(xbgr.mr_n80735968)
print v(xbgr.mr_n80737856)
print v(xbgr.mr_n80737968)
print v(xbgr.mr_n80738560)
print v(xbgr.mr_n80739888)
print v(xbgr.mr_n80748528)
print v(xbgr.mr_n80760976)
print v(xbgr.mr_n80762048)
print v(xbgr.mr_n80762240)
print v(xbgr.mr_n80762432)
print v(xbgr.mr_n80762624)
print v(xbgr.mr_n80762816)
print v(xbgr.mr_n80764944)
print v(xbgr.mr_n80765216)
print v(xbgr.mr_n80765408)
print v(xbgr.mr_n80765920)
print v(xbgr.mr_n80768272)
print v(xbgr.mr_n80770640)
print v(xbgr.mr_n80770912)
print v(xbgr.mr_n80771616)
print v(xbgr.mr_n80773760)
print v(xbgr.mr_n80773872)
print v(xbgr.mr_n80775888)
print v(xbgr.mr_n80776080)
print v(xbgr.mr_n80776592)
print v(xbgr.mr_n80777824)
print v(xbgr.mr_n80778336)
print v(xbgr.mr_n80778640)
print v(xbgr.mr_n80781776)
print v(xbgr.mr_n80782048)
print v(xbgr.mr_n80782240)
print v(xbgr.mr_n80782752)
print v(xbgr.mr_n80784896)
print v(xbgr.mr_n80785008)
print v(xbgr.mr_n80786752)
print v(xbgr.mr_n80787024)
print v(xbgr.mr_n80787216)
print v(xbgr.mr_n80787728)
print v(xbgr.mr_n80788960)
print v(xbgr.mr_n80789760)
print v(xbgr.mr_n80790320)
print v(xbgr.mr_n80792992)
print v(xbgr.mr_n80793824)
print v(xbgr.mr_n80793936)
print v(xbgr.mr_n80794048)
print v(xbgr.mr_n80794160)
print v(xbgr.mr_n80794272)
print v(xbgr.mr_n80794464)
print v(xbgr.mr_n80796016)
print v(xbgr.mr_n80796208)
print v(xbgr.mr_n80796400)
print v(xbgr.mr_n80796992)
print v(xbgr.mr_n80798352)
print v(xbgr.mr_n80798864)
print v(xbgr.mr_n80802688)
print v(xbgr.mr_n80802880)
print v(xbgr.mr_n80803072)
print v(xbgr.mr_n80803664)
print v(xbgr.mr_n80805808)
print v(xbgr.mr_n80805920)
print v(xbgr.mr_n80807664)
print v(xbgr.mr_n80807936)
print v(xbgr.mr_n80808128)
print v(xbgr.mr_n80808640)
print v(xbgr.mr_n80809872)
print v(xbgr.mr_n80810384)
print v(xbgr.mr_n80813824)
print v(xbgr.mr_n80814096)
print v(xbgr.mr_n80814288)
print v(xbgr.mr_n80814800)
print v(xbgr.mr_n80816944)
print v(xbgr.mr_n80817136)
print v(xbgr.mr_n80817328)
print v(xbgr.mr_n80819136)
print v(xbgr.mr_n80819328)
print v(xbgr.mr_n80819840)
print v(xbgr.mr_n80821072)
print v(xbgr.mr_n80821584)
print v(xbgr.mr_n80824960)
print v(xbgr.mr_n80825232)
print v(xbgr.mr_n80825424)
print v(xbgr.mr_n80825936)
print v(xbgr.mr_n80830880)
print v(xbgr.mr_n80830992)
print v(xbgr.mr_n80831824)
print v(xbgr.mr_n80831936)
print v(xbgr.mr_n80832768)
print v(xbgr.mr_n80832880)
print v(xbgr.mr_n80833968)
print v(xbgr.mr_n80834080)
print v(xbgr.mr_n80835232)
print v(xbgr.mr_n80835344)
print v(xbgr.mr_n80836496)
print v(xbgr.mr_n80836608)
print v(xbgr.mr_n80837760)
print v(xbgr.mr_n80837872)
print v(xbgr.mr_n80839024)
print v(xbgr.mr_n80839136)
print v(xbgr.mr_n80840288)
print v(xbgr.mr_n80840400)
print v(xbgr.mr_n80841552)
print v(xbgr.mr_n80841664)
print v(xbgr.mr_n80842816)
print v(xbgr.mr_n80842928)
print v(xbgr.mr_n80844080)
print v(xbgr.mr_n80844192)
print v(xbgr.mr_n80845344)
print v(xbgr.mr_n80845456)
print v(xbgr.mr_n80846608)
print v(xbgr.mr_n80846720)
print v(xbgr.mr_n80847872)
print v(xbgr.mr_n80847984)
print v(xbgr.mr_n80849520)
print v(xbgr.mr_n80849632)
print v(xbgr.mr_n80850784)
print v(xbgr.mr_n80850896)
print v(xbgr.mr_n80852048)
print v(xbgr.mr_n80852160)
print v(xbgr.mr_n80853312)
print v(xbgr.mr_n80853424)
print v(xbgr.mr_n80854576)
print v(xbgr.mr_n80854688)
print v(xbgr.mr_n80855840)
print v(xbgr.mr_n80855952)
print v(xbgr.mr_n80857104)
print v(xbgr.mr_n80857216)
print v(xbgr.mr_n80858368)
print v(xbgr.mr_n80858480)
print v(xbgr.mr_n80859632)
print v(xbgr.mr_n80859744)
print v(xbgr.mr_n80860896)
print v(xbgr.mr_n80861008)
print v(xbgr.mr_n80862160)
print v(xbgr.mr_n80862272)
print v(xbgr.mr_n80863424)
print v(xbgr.mr_n80863536)
print v(xbgr.mr_n80864688)
print v(xbgr.mr_n80864800)
print v(xbgr.mr_n80865952)
print v(xbgr.mr_n80866064)
print v(xbgr.mr_n80867216)
print v(xbgr.mr_n80867328)
print v(xbgr.mr_n80868480)
print v(xbgr.mr_n80868592)
print v(xbgr.mr_n80869744)
print v(xbgr.mr_n80869856)
print v(xbgr.mr_n80874656)
print v(xbgr.mr_n80874960)
print v(xbgr.mr_n80877744)
print v(xbgr.mr_n80878944)
print v(xbgr.mr_n80881808)
print v(xbgr.mr_n80883552)
print v(xbgr.mr_n80887008)
print v(xbgr.mr_n80893072)
print v(xbgr.mr_n80900064)
print v(xbgr.mr_n80901520)
print v(xbgr.mr_n80905328)
print v(xbgr.mr_n80906928)
print v(xbgr.mr_n80907616)
print v(xbgr.mr_n80908304)
print v(xbgr.mr_n80909024)
print v(xbgr.mr_n80909968)
print v(xbgr.mr_n80910912)
print v(xbgr.mr_n80911856)
print v(xbgr.mr_n80912800)
print v(xbgr.mr_n80913744)
print v(xbgr.mr_n80914688)
print v(xbgr.mr_n80915632)
print v(xbgr.mr_n80916576)
print v(xbgr.mr_n80917520)
print v(xbgr.mr_n80918464)
print v(xbgr.mr_n80919408)
print v(xbgr.mr_n80920352)
print v(xbgr.mr_n80921296)
print v(xbgr.mr_n80922240)
print v(xbgr.mr_n80923184)
print v(xbgr.mr_n80925728)
print v(xbgr.mr_n80927936)
print v(xbgr.mr_n80932720)
print v(xbgr.mr_n80936784)
print v(xbgr.mr_n80936896)
print v(xbgr.mr_n80937728)
print v(xbgr.mr_n80937840)
print v(xbgr.mr_n80937952)
print v(xbgr.mr_n80938064)
print v(xbgr.mr_n80938176)
print v(xbgr.mr_n80939920)
print v(xbgr.mr_n80940192)
print v(xbgr.mr_n80940384)
print v(xbgr.mr_n80940896)
print v(xbgr.mr_n80941360)
print v(xbgr.mr_n80943488)
print v(xbgr.mr_n80943760)
print v(xbgr.mr_n80943952)
print v(xbgr.mr_n80944464)
print v(xbgr.mr_n80947952)
print v(xbgr.mr_n80948224)
print v(xbgr.mr_n80948416)
print v(xbgr.mr_n80948928)
print v(xbgr.mr_n80950480)
print v(xbgr.mr_n80950672)
print v(xbgr.mr_n80952736)
print v(xbgr.mr_n80953008)
print v(xbgr.mr_n80953200)
print v(xbgr.mr_n80953712)
print v(xbgr.mr_n80955440)
print v(xbgr.mr_n80955696)
print v(xbgr.mr_n80955952)
print v(xbgr.mr_n80956544)
print v(xbgr.mr_n80956880)
print v(xbgr.mr_n80958496)
print v(xbgr.mr_n80960128)
print v(xbgr.mr_n80960320)
print v(xbgr.mr_n80960512)
print v(xbgr.mr_n80962320)
print v(xbgr.mr_n80962512)
print v(xbgr.mr_n80963024)
print v(xbgr.mr_n80966448)
print v(xbgr.mr_n80966720)
print v(xbgr.mr_n80966912)
print v(xbgr.mr_n80967424)
print v(xbgr.mr_n80969056)
print v(xbgr.mr_n80969248)
print v(xbgr.mr_n80971568)
print v(xbgr.mr_n80971760)
print v(xbgr.mr_n80972272)
print v(xbgr.mr_n80973840)
print v(xbgr.mr_n80975696)
print v(xbgr.mr_n80975968)
print v(xbgr.mr_n80976160)
print v(xbgr.mr_n80976672)
print v(xbgr.mr_n80978224)
print v(xbgr.mr_n80980480)
print v(xbgr.mr_n80980752)
print v(xbgr.mr_n80980944)
print v(xbgr.mr_n80981456)
print v(xbgr.mr_n80984944)
print v(xbgr.mr_n80985136)
print v(xbgr.mr_n80985328)
print v(xbgr.mr_n80985920)
print v(xbgr.mr_n80987376)
print v(xbgr.mr_n80988784)
print v(xbgr.mr_n80989056)
print v(xbgr.mr_n80989248)
print v(xbgr.mr_n80989760)
print v(xbgr.mr_n80992624)
print v(xbgr.mr_n80992896)
print v(xbgr.mr_n80993088)
print v(xbgr.mr_n80993600)
print v(xbgr.mr_n80996960)
print v(xbgr.mr_n80997072)
print v(xbgr.mr_n80998816)
print v(xbgr.mr_n80999088)
print v(xbgr.mr_n80999280)
print v(xbgr.mr_n80999792)
print v(xbgr.mr_n81001936)
print v(xbgr.mr_n81002048)
print v(xbgr.mr_n81003792)
print v(xbgr.mr_n81004064)
print v(xbgr.mr_n81004256)
print v(xbgr.mr_n81004768)
print v(xbgr.mr_n81006912)
print v(xbgr.mr_n81007024)
print v(xbgr.mr_n81008768)
print v(xbgr.mr_n81009040)
print v(xbgr.mr_n81009232)
print v(xbgr.mr_n81009744)
print v(xbgr.mr_n81011888)
print v(xbgr.mr_n81012000)
print v(xbgr.mr_n81013744)
print v(xbgr.mr_n81014016)
print v(xbgr.mr_n81014208)
print v(xbgr.mr_n81014720)
print v(xbgr.mr_n81019888)
print v(xbgr.mr_n81022080)
print v(xbgr.mr_n81023648)
print v(xbgr.mr_n81024592)
print v(xbgr.mr_n81026784)
print v(xbgr.mr_n81028352)
print v(xbgr.mr_n81029296)
print v(xbgr.mr_n81031488)
print v(xbgr.mr_n81033104)
print v(xbgr.mr_n81033680)
print v(xbgr.mr_n81033792)
print v(xbgr.mr_n81034624)
print v(xbgr.mr_n81034736)
print v(xbgr.mr_n81035568)
print v(xbgr.mr_n81035680)
print v(xbgr.mr_n81036512)
print v(xbgr.mr_n81036624)
print v(xbgr.mr_n81037456)
print v(xbgr.mr_n81037568)
print v(xbgr.mr_n81038400)
print v(xbgr.mr_n81038512)
print v(xbgr.mr_n81039344)
print v(xbgr.mr_n81039456)
print v(xbgr.mr_n81040288)
print v(xbgr.mr_n81040400)
print v(xbgr.mr_n81041232)
print v(xbgr.mr_n81041344)
print v(xbgr.mr_n81042304)
print v(xbgr.mr_n81042416)
print v(xbgr.mr_n81050976)
print v(xbgr.mr_n81057152)
print v(xbgr.mr_n81063104)
print v(xbgr.mr_n81065568)
print v(xbgr.mr_n81066912)
print v(xbgr.mr_n81067600)
print v(xbgr.mr_n81068288)
print v(xbgr.mr_n81068976)
print v(xbgr.mr_n81069984)
print v(xbgr.mr_n81071440)
print v(xbgr.mr_n81072384)
print v(xbgr.mr_n81073328)
print v(xbgr.mr_n81074272)
print v(xbgr.mr_n81075216)
print v(xbgr.mr_n81076160)
print v(xbgr.mr_n81077104)
print v(xbgr.mr_n81078048)
print v(xbgr.mr_n81078992)
print v(xbgr.mr_n81079936)
print v(xbgr.mr_n81080880)
print v(xbgr.mr_n81081824)
print v(xbgr.mr_n81082768)
print v(xbgr.mr_n81083712)
print v(xbgr.mr_n81083904)
print v(xbgr.mr_n81084096)
print v(xbgr.mr_n81084288)
print v(xbgr.mr_n81084480)
print v(xbgr.mr_n81084672)
print v(xbgr.mr_n81086816)
print v(xbgr.mr_n81086928)
print v(xbgr.mr_n81090240)
print v(xbgr.mr_n81090352)
print v(xbgr.mr_n81095232)
print v(xbgr.mr_n81097072)
print v(xbgr.mr_n81098912)
print v(xbgr.mr_n81100752)
print v(xbgr.mr_n81105488)
print v(xbgr.mr_n81107728)
print v(xbgr.mr_n81117920)
print v(xbgr.mr_n81119488)
print v(xbgr.mr_n81121056)
print v(xbgr.mr_n81122608)
print v(xbgr.mr_n81124176)
print v(xbgr.mr_n81125744)
print v(xbgr.mr_n81127312)
print v(xbgr.mr_n81128880)
print v(xbgr.mr_n81130448)
print v(xbgr.mr_n81132016)
print v(xbgr.mr_n81133584)
print v(xbgr.mr_n81135152)
print v(xbgr.mr_n81136720)
print v(xbgr.mr_n81138288)
print v(xbgr.mr_n81139856)
print v(xbgr.mr_n81141424)
print v(xbgr.mr_n81144672)
print v(xbgr.mr_n81145008)
print v(xbgr.mr_n81145120)
print v(xbgr.mr_n81145952)
print v(xbgr.mr_n81146064)
print v(xbgr.mr_n81146896)
print v(xbgr.mr_n81147008)
print v(xbgr.mr_n81147840)
print v(xbgr.mr_n81147952)
print v(xbgr.mr_n81151520)
print v(xbgr.mr_n81151952)
print v(xbgr.mr_n81152064)
print v(xbgr.mr_n81152176)
print v(xbgr.mr_n81152288)
print v(xbgr.mr_n81152400)
print v(xbgr.mr_n81153824)
print v(xbgr.mr_n81154096)
print v(xbgr.mr_n81154288)
print v(xbgr.mr_n81154800)
print v(xbgr.mr_n81156944)
print v(xbgr.mr_n81157056)
print v(xbgr.mr_n81158800)
print v(xbgr.mr_n81159072)
print v(xbgr.mr_n81159264)
print v(xbgr.mr_n81159776)
print v(xbgr.mr_n81161920)
print v(xbgr.mr_n81162032)
print v(xbgr.mr_n81163776)
print v(xbgr.mr_n81164048)
print v(xbgr.mr_n81164240)
print v(xbgr.mr_n81164752)
print v(xbgr.mr_n81166896)
print v(xbgr.mr_n81167008)
print v(xbgr.mr_n81168752)
print v(xbgr.mr_n81169024)
print v(xbgr.mr_n81169216)
print v(xbgr.mr_n81169728)
print v(xbgr.mr_n81171872)
print v(xbgr.mr_n81172064)
print v(xbgr.mr_n81172256)
print v(xbgr.mr_n81174064)
print v(xbgr.mr_n81174256)
print v(xbgr.mr_n81174768)
print v(xbgr.mr_n81176848)
print v(xbgr.mr_n81176960)
print v(xbgr.mr_n81178704)
print v(xbgr.mr_n81178976)
print v(xbgr.mr_n81179168)
print v(xbgr.mr_n81179680)
print v(xbgr.mr_n81181984)
print v(xbgr.mr_n81182176)
print v(xbgr.mr_n81182368)
print v(xbgr.mr_n81182560)
print v(xbgr.mr_n81182752)
print v(xbgr.mr_n81184976)
print v(xbgr.mr_n81186800)
print v(xbgr.mr_n81186912)
print v(xbgr.mr_n81188656)
print v(xbgr.mr_n81188928)
print v(xbgr.mr_n81189120)
print v(xbgr.mr_n81189632)
print v(xbgr.mr_n81190528)
print v(xbgr.mr_n81191440)
print v(xbgr.mr_n81191552)
print v(xbgr.mr_n81192704)
print v(xbgr.mr_n81192816)
print v(xbgr.mr_n81193968)
print v(xbgr.mr_n81194080)
print v(xbgr.mr_n81195392)
print v(xbgr.mr_n81196208)
print v(xbgr.mr_n81196896)
print v(xbgr.mr_n81197584)
print v(xbgr.mr_n81198272)
print v(xbgr.mr_n81198960)
print v(xbgr.mr_n81199648)
print v(xbgr.mr_n81200336)
print v(xbgr.mr_n81201024)
print v(xbgr.mr_n81201712)
print v(xbgr.mr_n81203648)
print v(xbgr.mr_n81204784)
print v(xbgr.mr_n81205728)
print v(xbgr.mr_n81206672)
print v(xbgr.mr_n81207616)
print v(xbgr.mr_n81208560)
print v(xbgr.mr_n81209504)
print v(xbgr.mr_n81210448)
print v(xbgr.mr_n81211392)
print v(xbgr.mr_n81212336)
print v(xbgr.mr_n81214128)
print v(xbgr.mr_n81215104)
print v(xbgr.mr_n81222048)
print v(xbgr.mr_n81225584)
print v(xbgr.mr_n81227168)
print v(xbgr.mr_n81229280)
print v(xbgr.mr_n81230848)
print v(xbgr.mr_n81231888)
print v(xbgr.mr_n81232000)
print v(xbgr.mr_n81232112)
print v(xbgr.mr_n81233712)
print v(xbgr.mr_n81233824)
print v(xbgr.mr_n81235024)
print v(xbgr.mr_n81235568)
print v(xbgr.mr_n81238032)
print v(xbgr.mr_n81239248)
print v(xbgr.mr_n81239360)
print v(xbgr.mr_n81243104)
print v(xbgr.mr_n81244576)
print v(xbgr.mr_n81246144)
print v(xbgr.mr_n81247712)
print v(xbgr.mr_n81249280)
print v(xbgr.mr_n81255360)
print v(xbgr.mr_n81255632)
print v(xbgr.mr_n81257856)
print v(xbgr.mr_n81258128)
print v(xbgr.mr_n81258320)
print v(xbgr.mr_n81259424)
print v(xbgr.mr_n81259536)
print v(xbgr.mr_n81261776)
print v(xbgr.mr_n81262560)
print v(xbgr.mr_n81263328)
print v(xbgr.mr_n81264448)
print v(xbgr.mr_n81265136)
print v(xbgr.mr_n81266496)
print v(xbgr.mr_n81268032)
print v(xbgr.mr_n81269600)
print v(xbgr.mr_n81270544)
print v(xbgr.mr_n81272608)
print v(xbgr.mr_n81277696)
print v(xbgr.mr_n81279312)
print v(xbgr.mr_n81279424)
print v(xbgr.mr_n81280576)
print v(xbgr.mr_n81280688)
print v(xbgr.mr_n81281840)
print v(xbgr.mr_n81281952)
print v(xbgr.mr_n81283104)
print v(xbgr.mr_n81283216)
print v(xbgr.mr_n81284304)
print v(xbgr.mr_n81284416)
print v(xbgr.mr_n81285632)
print v(xbgr.mr_n81285744)
print v(xbgr.mr_n81286896)
print v(xbgr.mr_n81287008)
print v(xbgr.mr_n81288096)
print v(xbgr.mr_n81288208)
print v(xbgr.mr_n81289424)
print v(xbgr.mr_n81289536)
print v(xbgr.mr_n81290624)
print v(xbgr.mr_n81290736)
print v(xbgr.mr_n81292208)
print v(xbgr.mr_n81294368)
print v(xbgr.mr_n81296096)
print v(xbgr.mr_n81305120)
print v(xbgr.mr_n81309520)
print v(xbgr.mr_n81310304)
print v(xbgr.mr_n81310416)
print v(xbgr.mr_n81310608)
print v(xbgr.mr_n81310800)
print v(xbgr.mr_n81310992)
print v(xbgr.mr_n81313408)
print v(xbgr.mr_n81319248)
print v(xbgr.mr_n81320192)
print v(xbgr.mr_n81321136)
print v(xbgr.mr_n81322080)
print v(xbgr.mr_n81323024)
print v(xbgr.mr_n81323968)
print v(xbgr.mr_n81324912)
print v(xbgr.mr_n81325856)
print v(xbgr.mr_n81326800)
print v(xbgr.mr_n81327744)
print v(xbgr.mr_n81328688)
print v(xbgr.mr_n81329632)
print v(xbgr.mr_n81330656)
print v(xbgr.mr_n81331008)
print v(xbgr.mr_n81331280)
print v(xbgr.mr_n81331888)
print v(xbgr.mr_n81332992)
print v(xbgr.mr_n81335344)
print v(xbgr.mr_n81336288)
print v(xbgr.mr_n81337232)
print v(xbgr.mr_n81338176)
print v(xbgr.mr_n81339120)
print v(xbgr.mr_n81340064)
print v(xbgr.mr_n81341008)
print v(xbgr.mr_n81341952)
print v(xbgr.mr_n81342896)
print v(xbgr.mr_n81343840)
print v(xbgr.mr_n81347600)
print v(xbgr.mr_n81348544)
print v(xbgr.mr_n81349488)
print v(xbgr.mr_n81349680)
print v(xbgr.mr_n81349872)
print v(xbgr.mr_n81350064)
print v(xbgr.mr_n81350256)
print v(xbgr.mr_n81350448)
print v(xbgr.mr_n81352592)
print v(xbgr.mr_n81352704)
print v(xbgr.mr_n81355792)
print v(xbgr.mr_n81355904)
print v(xbgr.mr_n81361552)
print v(xbgr.mr_n81362496)
print v(xbgr.mr_n81363440)
print v(xbgr.mr_n81364384)
print v(xbgr.mr_n81365328)
print v(xbgr.mr_n81366272)
print v(xbgr.mr_n81367216)
print v(xbgr.mr_n81368160)
print v(xbgr.mr_n81369104)
print v(xbgr.mr_n81370048)
print v(xbgr.mr_n81370928)
print v(xbgr.mr_n81372432)
print v(xbgr.mr_n81373120)
print v(xbgr.mr_n81373392)
print v(xbgr.mr_n81374064)
print v(xbgr.mr_n81374256)
print v(xbgr.mr_n81374448)
print v(xbgr.mr_n81374640)
print v(xbgr.mr_n81376832)
print v(xbgr.mr_n81377104)
print v(xbgr.mr_n81377296)
print v(xbgr.mr_n81377808)
print v(xbgr.mr_n81378848)
print v(xbgr.mr_n81383296)
print v(xbgr.mr_n81384128)
print v(xbgr.mr_n81384240)
print v(xbgr.mr_n81384352)
print v(xbgr.mr_n81384464)
print v(xbgr.mr_n81384656)
print v(xbgr.mr_n81384848)
print v(xbgr.mr_n81386656)
print v(xbgr.mr_n81386848)
print v(xbgr.mr_n81387360)
print v(xbgr.mr_n81389440)
print v(xbgr.mr_n81389552)
print v(xbgr.mr_n81391296)
print v(xbgr.mr_n81391568)
print v(xbgr.mr_n81391760)
print v(xbgr.mr_n81392272)
print v(xbgr.mr_n81394416)
print v(xbgr.mr_n81394528)
print v(xbgr.mr_n81396272)
print v(xbgr.mr_n81396544)
print v(xbgr.mr_n81396736)
print v(xbgr.mr_n81397248)
print v(xbgr.mr_n81399392)
print v(xbgr.mr_n81399504)
print v(xbgr.mr_n81401248)
print v(xbgr.mr_n81401520)
print v(xbgr.mr_n81401712)
print v(xbgr.mr_n81402224)
print v(xbgr.mr_n81404368)
print v(xbgr.mr_n81404480)
print v(xbgr.mr_n81406224)
print v(xbgr.mr_n81406496)
print v(xbgr.mr_n81406688)
print v(xbgr.mr_n81407200)
print v(xbgr.mr_n81409344)
print v(xbgr.mr_n81411200)
print v(xbgr.mr_n81411472)
print v(xbgr.mr_n81412176)
print v(xbgr.mr_n81414320)
print v(xbgr.mr_n81414432)
print v(xbgr.mr_n81416176)
print v(xbgr.mr_n81416448)
print v(xbgr.mr_n81416640)
print v(xbgr.mr_n81417152)
print v(xbgr.mr_n81421936)
print v(xbgr.mr_n81425488)
print v(xbgr.mr_n81426912)
print v(xbgr.mr_n81427584)
print v(xbgr.mr_n81427776)
print v(xbgr.mr_n81428816)
print v(xbgr.mr_n81428928)
print v(xbgr.mr_n81431744)
print v(xbgr.mr_n81435328)
print v(xbgr.mr_n81436016)
print v(xbgr.mr_n81436704)
print v(xbgr.mr_n81437392)
print v(xbgr.mr_n81438080)
print v(xbgr.mr_n81438768)
print v(xbgr.mr_n81439456)
print v(xbgr.mr_n81440144)
print v(xbgr.mr_n81440832)
print v(xbgr.mr_n81441520)
print v(xbgr.mr_n81442208)
print v(xbgr.mr_n81442896)
print v(xbgr.mr_n81445776)
print v(xbgr.mr_n81449040)
print v(xbgr.mr_n81451664)
print v(xbgr.mr_n81454176)
print v(xbgr.mr_n81456032)
print v(xbgr.mr_n81456144)
print v(xbgr.mr_n81458128)
print v(xbgr.mr_n81458240)
print v(xbgr.mr_n81459392)
print v(xbgr.mr_n81459504)
print v(xbgr.mr_n81460656)
print v(xbgr.mr_n81460768)
print v(xbgr.mr_n81461920)
print v(xbgr.mr_n81462032)
print v(xbgr.mr_n81463184)
print v(xbgr.mr_n81463296)
print v(xbgr.mr_n81464448)
print v(xbgr.mr_n81464560)
print v(xbgr.mr_n81465424)
print v(xbgr.mr_n81465536)
print v(xbgr.mr_n81465648)
print v(xbgr.mr_n81466256)
print v(xbgr.mr_n81466368)
print v(xbgr.mr_n81467664)
print v(xbgr.mr_n81467776)
print v(xbgr.mr_n81469760)
print v(xbgr.mr_n81469872)
print v(xbgr.mr_n81471824)
print v(xbgr.mr_n81471936)
print v(xbgr.mr_n81473088)
print v(xbgr.mr_n81473200)
print v(xbgr.mr_n81474352)
print v(xbgr.mr_n81474464)
print v(xbgr.mr_n81476304)
print v(xbgr.mr_n81478208)
print v(xbgr.mr_n81479328)
print v(xbgr.mr_n81480800)
print v(xbgr.mr_n81482368)
print v(xbgr.mr_n81483936)
print v(xbgr.mr_n81485504)
print v(xbgr.mr_n81487072)
print v(xbgr.mr_n81488640)
print v(xbgr.mr_n81490208)
print v(xbgr.mr_n81491776)
print v(xbgr.mr_n81493344)
print v(xbgr.mr_n81494912)
print v(xbgr.mr_n81497104)
print v(xbgr.mr_n81498672)
print v(xbgr.mr_n81500240)
print v(xbgr.mr_n81502976)
print v(xbgr.mr_n81504400)
print v(xbgr.mr_n81511968)
print v(xbgr.mr_n81513040)
print v(xbgr.mr_n81513232)
print v(xbgr.mr_n81513424)
print v(xbgr.mr_n81513616)
print v(xbgr.mr_n81513872)
print v(xbgr.mr_n81515936)
print v(xbgr.mr_n81516208)
print v(xbgr.mr_n81516400)
print v(xbgr.mr_n81516912)
print v(xbgr.mr_n81520304)
print v(xbgr.mr_n81521824)
print v(xbgr.mr_n81522096)
print v(xbgr.mr_n81522288)
print v(xbgr.mr_n81522800)
print v(xbgr.mr_n81525536)
print v(xbgr.mr_n81525808)
print v(xbgr.mr_n81526000)
print v(xbgr.mr_n81526512)
print v(xbgr.mr_n81528656)
print v(xbgr.mr_n81528768)
print v(xbgr.mr_n81530512)
print v(xbgr.mr_n81530784)
print v(xbgr.mr_n81530976)
print v(xbgr.mr_n81531488)
print v(xbgr.mr_n81532720)
print v(xbgr.mr_n81533232)
print v(xbgr.mr_n81541024)
print v(xbgr.mr_n81541296)
print v(xbgr.mr_n81541488)
print v(xbgr.mr_n81542000)
print v(xbgr.mr_n81543360)
print v(xbgr.mr_n81543872)
print v(xbgr.mr_n81545616)
print v(xbgr.mr_n81546128)
print v(xbgr.mr_n81548128)
print v(xbgr.mr_n81548640)
print v(xbgr.mr_n81550704)
print v(xbgr.mr_n81551216)
print v(xbgr.mr_n81553280)
print v(xbgr.mr_n81553792)
print v(xbgr.mr_n81555856)
print v(xbgr.mr_n81556368)
print v(xbgr.mr_n81557184)
print v(xbgr.mr_n81558432)
print v(xbgr.mr_n81558944)
print v(xbgr.mr_n81561072)
print v(xbgr.mr_n81561584)
print v(xbgr.mr_n81563584)
print v(xbgr.mr_n81564096)
print v(xbgr.mr_n81566160)
print v(xbgr.mr_n81566672)
print v(xbgr.mr_n81568800)
print v(xbgr.mr_n81569312)
print v(xbgr.mr_n81577584)
print v(xbgr.mr_n81577696)
print v(xbgr.mr_n81578848)
print v(xbgr.mr_n81578960)
print v(xbgr.mr_n81580112)
print v(xbgr.mr_n81580224)
print v(xbgr.mr_n81581376)
print v(xbgr.mr_n81581488)
print v(xbgr.mr_n81582640)
print v(xbgr.mr_n81582752)
print v(xbgr.mr_n81583904)
print v(xbgr.mr_n81584016)
print v(xbgr.mr_n81585168)
print v(xbgr.mr_n81585280)
print v(xbgr.mr_n81586368)
print v(xbgr.mr_n81586480)
print v(xbgr.mr_n81587696)
print v(xbgr.mr_n81587808)
print v(xbgr.mr_n81588960)
print v(xbgr.mr_n81589072)
print v(xbgr.mr_n81590224)
print v(xbgr.mr_n81590336)
print v(xbgr.mr_n81591488)
print v(xbgr.mr_n81591600)
print v(xbgr.mr_n81592752)
print v(xbgr.mr_n81592864)
print v(xbgr.mr_n81594016)
print v(xbgr.mr_n81594128)
print v(xbgr.mr_n81599744)
print v(xbgr.mr_n81600752)
print v(xbgr.mr_n81605664)
print v(xbgr.mr_n81605920)
print v(xbgr.mr_n81606464)
print v(xbgr.mr_n81606960)
print v(xbgr.mr_n81609440)
print v(xbgr.mr_n81610128)
print v(xbgr.mr_n81611168)
print v(xbgr.mr_n81612752)
print v(xbgr.mr_n81613696)
print v(xbgr.mr_n81614640)
print v(xbgr.mr_n81615584)
print v(xbgr.mr_n81616528)
print v(xbgr.mr_n81617472)
print v(xbgr.mr_n81618416)
print v(xbgr.mr_n81619360)
print v(xbgr.mr_n81620304)
print v(xbgr.mr_n81621248)
print v(xbgr.mr_n81622192)
print v(xbgr.mr_n81623136)
print v(xbgr.mr_n81624080)
print v(xbgr.mr_n81625024)
print v(xbgr.mr_n81625968)
print v(xbgr.mr_n81626912)
print v(xbgr.mr_n81628496)
print v(xbgr.mr_n81633216)
print v(xbgr.mr_n81634784)
print v(xbgr.mr_n81637328)
print v(xbgr.mr_n81638128)
print v(xbgr.mr_n81639360)
print v(xbgr.mr_n81639472)
print v(xbgr.mr_n81640416)
print v(xbgr.mr_n81641504)
print v(xbgr.mr_n81641616)
print v(xbgr.mr_n81643456)
print v(xbgr.mr_n81643568)
print v(xbgr.mr_n81644512)
print v(xbgr.mr_n81645664)
print v(xbgr.mr_n81645776)
print v(xbgr.mr_n81647024)
print v(xbgr.mr_n81647552)
print v(xbgr.mr_n81647664)
print v(xbgr.mr_n81648608)
print v(xbgr.mr_n81649760)
print v(xbgr.mr_n81649872)
print v(xbgr.mr_n81651648)
print v(xbgr.mr_n81651760)
print v(xbgr.mr_n81652704)
print v(xbgr.mr_n81653856)
print v(xbgr.mr_n81653968)
print v(xbgr.mr_n81655680)
print v(xbgr.mr_n81655792)
print v(xbgr.mr_n81656736)
print v(xbgr.mr_n81657952)
print v(xbgr.mr_n81658064)
print v(xbgr.mr_n81659840)
print v(xbgr.mr_n81659952)
print v(xbgr.mr_n81660896)
print v(xbgr.mr_n81662048)
print v(xbgr.mr_n81662160)
print v(xbgr.mr_n81663936)
print v(xbgr.mr_n81664048)
print v(xbgr.mr_n81664992)
print v(xbgr.mr_n81666144)
print v(xbgr.mr_n81666256)
print v(xbgr.mr_n81667360)
print v(xbgr.mr_n81667968)
print v(xbgr.mr_n81668080)
print v(xbgr.mr_n81669024)
print v(xbgr.mr_n81670240)
print v(xbgr.mr_n81670352)
print v(xbgr.mr_n81672128)
print v(xbgr.mr_n81672240)
print v(xbgr.mr_n81673552)
print v(xbgr.mr_n81674672)
print v(xbgr.mr_n81676768)
print v(xbgr.mr_n81678336)
print v(xbgr.mr_n81679904)
print v(xbgr.mr_n81681472)
print v(xbgr.mr_n81683040)
print v(xbgr.mr_n81684608)
print v(xbgr.mr_n81686176)
print v(xbgr.mr_n81699040)
print v(xbgr.mr_n81704176)
print v(xbgr.mr_n81705040)
print v(xbgr.mr_n81706304)
print v(xbgr.mr_n81706496)
print v(xbgr.mr_n81706688)
print v(xbgr.mr_n81706880)
print v(xbgr.mr_n81709200)
print v(xbgr.mr_n81709472)
print v(xbgr.mr_n81709664)
print v(xbgr.mr_n81710176)
print v(xbgr.mr_n81712752)
print v(xbgr.mr_n81714256)
print v(xbgr.mr_n81715856)
print v(xbgr.mr_n81716128)
print v(xbgr.mr_n81716320)
print v(xbgr.mr_n81716832)
print v(xbgr.mr_n81719568)
print v(xbgr.mr_n81719840)
print v(xbgr.mr_n81720032)
print v(xbgr.mr_n81720544)
print v(xbgr.mr_n81722688)
print v(xbgr.mr_n81722800)
print v(xbgr.mr_n81724544)
print v(xbgr.mr_n81724816)
print v(xbgr.mr_n81725008)
print v(xbgr.mr_n81725520)
print v(xbgr.mr_n81726816)
print v(xbgr.mr_n81727328)
print v(xbgr.mr_n81727888)
print v(xbgr.mr_n81730704)
print v(xbgr.mr_n81730976)
print v(xbgr.mr_n81731168)
print v(xbgr.mr_n81731680)
print v(xbgr.mr_n81733824)
print v(xbgr.mr_n81733936)
print v(xbgr.mr_n81735696)
print v(xbgr.mr_n81737408)
print v(xbgr.mr_n81737600)
print v(xbgr.mr_n81737792)
print v(xbgr.mr_n81739536)
print v(xbgr.mr_n81739808)
print v(xbgr.mr_n81740000)
print v(xbgr.mr_n81740512)
print v(xbgr.mr_n81744512)
print v(xbgr.mr_n81744624)
print v(xbgr.mr_n81746368)
print v(xbgr.mr_n81746640)
print v(xbgr.mr_n81746832)
print v(xbgr.mr_n81747344)
print v(xbgr.mr_n81748576)
print v(xbgr.mr_n81749088)
print v(xbgr.mr_n81752528)
print v(xbgr.mr_n81752720)
print v(xbgr.mr_n81752912)
print v(xbgr.mr_n81753504)
print v(xbgr.mr_n81755648)
print v(xbgr.mr_n81755760)
print v(xbgr.mr_n81757504)
print v(xbgr.mr_n81757776)
print v(xbgr.mr_n81757968)
print v(xbgr.mr_n81758480)
print v(xbgr.mr_n81759712)
print v(xbgr.mr_n81760224)
print v(xbgr.mr_n81762192)
print v(xbgr.mr_n81764000)
print v(xbgr.mr_n81764192)
print v(xbgr.mr_n81764704)
print v(xbgr.mr_n81766784)
print v(xbgr.mr_n81766896)
print v(xbgr.mr_n81768640)
print v(xbgr.mr_n81768912)
print v(xbgr.mr_n81769104)
print v(xbgr.mr_n81769616)
print v(xbgr.mr_n81770000)
print v(xbgr.mr_n81770912)
print v(xbgr.mr_n81771424)
print v(xbgr.mr_n81775952)
print v(xbgr.mr_n81778416)
print v(xbgr.mr_n81778528)
print v(xbgr.mr_n81779296)
print v(xbgr.mr_n81779408)
print v(xbgr.mr_n81780304)
print v(xbgr.mr_n81780416)
print v(xbgr.mr_n81781440)
print v(xbgr.mr_n81781552)
print v(xbgr.mr_n81782768)
print v(xbgr.mr_n81782880)
print v(xbgr.mr_n81783968)
print v(xbgr.mr_n81784080)
print v(xbgr.mr_n81785296)
print v(xbgr.mr_n81785408)
print v(xbgr.mr_n81786560)
print v(xbgr.mr_n81786672)
print v(xbgr.mr_n81787824)
print v(xbgr.mr_n81787936)
print v(xbgr.mr_n81789088)
print v(xbgr.mr_n81789200)
print v(xbgr.mr_n81790352)
print v(xbgr.mr_n81790464)
print v(xbgr.mr_n81791552)
print v(xbgr.mr_n81791664)
print v(xbgr.mr_n81792880)
print v(xbgr.mr_n81792992)
print v(xbgr.mr_n81794080)
print v(xbgr.mr_n81794192)
print v(xbgr.mr_n81795408)
print v(xbgr.mr_n81795520)
print v(xbgr.mr_n81795712)
print v(xbgr.mr_n81797888)
print v(xbgr.mr_n81799536)
print v(xbgr.mr_n81802032)
print v(xbgr.mr_n81802720)
print v(xbgr.mr_n81803408)
print v(xbgr.mr_n81804128)
print v(xbgr.mr_n81805072)
print v(xbgr.mr_n81806016)
print v(xbgr.mr_n81806960)
print v(xbgr.mr_n81807904)
print v(xbgr.mr_n81808848)
print v(xbgr.mr_n81809792)
print v(xbgr.mr_n81810736)
print v(xbgr.mr_n81811680)
print v(xbgr.mr_n81812624)
print v(xbgr.mr_n81813568)
print v(xbgr.mr_n81814512)
print v(xbgr.mr_n81815456)
print v(xbgr.mr_n81816400)
print v(xbgr.mr_n81817344)
print v(xbgr.mr_n81818288)
print v(xbgr.mr_n81819632)
print v(xbgr.mr_n81820208)
print v(xbgr.mr_n81823456)
print v(xbgr.mr_n81826528)
print v(xbgr.mr_n81831280)
print v(xbgr.mr_n81831776)
print v(xbgr.mr_n81833824)
print v(xbgr.mr_n81835392)
print v(xbgr.mr_n81837872)
print v(xbgr.mr_n81838912)
print v(xbgr.mr_n81839024)
print v(xbgr.mr_n81839968)
print v(xbgr.mr_n81841120)
print v(xbgr.mr_n81841232)
print v(xbgr.mr_n81843008)
print v(xbgr.mr_n81843120)
print v(xbgr.mr_n81844064)
print v(xbgr.mr_n81845216)
print v(xbgr.mr_n81845328)
print v(xbgr.mr_n81846576)
print v(xbgr.mr_n81847104)
print v(xbgr.mr_n81847216)
print v(xbgr.mr_n81848160)
print v(xbgr.mr_n81849312)
print v(xbgr.mr_n81849424)
print v(xbgr.mr_n81851200)
print v(xbgr.mr_n81851312)
print v(xbgr.mr_n81852256)
print v(xbgr.mr_n81853408)
print v(xbgr.mr_n81853520)
print v(xbgr.mr_n81855296)
print v(xbgr.mr_n81855408)
print v(xbgr.mr_n81856352)
print v(xbgr.mr_n81857504)
print v(xbgr.mr_n81857616)
print v(xbgr.mr_n81859392)
print v(xbgr.mr_n81859504)
print v(xbgr.mr_n81860448)
print v(xbgr.mr_n81861600)
print v(xbgr.mr_n81861712)
print v(xbgr.mr_n81863488)
print v(xbgr.mr_n81863600)
print v(xbgr.mr_n81864544)
print v(xbgr.mr_n81865696)
print v(xbgr.mr_n81865808)
print v(xbgr.mr_n81867584)
print v(xbgr.mr_n81867696)
print v(xbgr.mr_n81868640)
print v(xbgr.mr_n81869792)
print v(xbgr.mr_n81869904)
print v(xbgr.mr_n81871152)
print v(xbgr.mr_n81872400)
print v(xbgr.mr_n81873904)
print v(xbgr.mr_n81876656)
print v(xbgr.mr_n81878224)
print v(xbgr.mr_n81879792)
print v(xbgr.mr_n81882864)
print v(xbgr.mr_n81885232)
print v(xbgr.mr_n81887392)
print v(xbgr.mr_n81887968)
print v(xbgr.mr_n81896704)
print v(xbgr.mr_n81897296)
print v(xbgr.mr_n81898800)
print v(xbgr.mr_n81903552)
print v(xbgr.mr_n81907968)
print v(xbgr.mr_n81908160)
print v(xbgr.mr_n81908992)
print v(xbgr.mr_n81909568)
print v(xbgr.mr_n81910256)
print v(xbgr.mr_n81910688)
print v(xbgr.mr_n81911520)
print v(xbgr.mr_n81911952)
print v(xbgr.mr_n81912784)
print v(xbgr.mr_n81913360)
print v(xbgr.mr_n81914048)
print v(xbgr.mr_n81914624)
print v(xbgr.mr_n81915312)
print v(xbgr.mr_n81915888)
print v(xbgr.mr_n81916576)
print v(xbgr.mr_n81917152)
print v(xbgr.mr_n81917840)
print v(xbgr.mr_n81918416)
print v(xbgr.mr_n81919104)
print v(xbgr.mr_n81919680)
print v(xbgr.mr_n81920368)
print v(xbgr.mr_n81920944)
print v(xbgr.mr_n81921632)
print v(xbgr.mr_n81922208)
print v(xbgr.mr_n81922896)
print v(xbgr.mr_n81923472)
print v(xbgr.mr_n81924160)
print v(xbgr.mr_n81924736)
print v(xbgr.mr_n81925424)
print v(xbgr.mr_n81925856)
print v(xbgr.mr_n81926688)
print v(xbgr.mr_n81927120)
print v(xbgr.mr_n81927952)
print v(xbgr.mr_n81928528)
print v(xbgr.mr_n81929216)
print v(xbgr.mr_n81932720)
print v(xbgr.mr_n81932832)
print v(xbgr.mr_n81932944)
print v(xbgr.mr_n81933056)
print v(xbgr.mr_n81935376)
print v(xbgr.mr_n81935648)
print v(xbgr.mr_n81935840)
print v(xbgr.mr_n81936352)
print v(xbgr.mr_n81936752)
print v(xbgr.mr_n81937584)
print v(xbgr.mr_n81938096)
print v(xbgr.mr_n81939648)
print v(xbgr.mr_n81940160)
print v(xbgr.mr_n81942096)
print v(xbgr.mr_n81942608)
print v(xbgr.mr_n81944544)
print v(xbgr.mr_n81945056)
print v(xbgr.mr_n81946992)
print v(xbgr.mr_n81947504)
print v(xbgr.mr_n81949440)
print v(xbgr.mr_n81949952)
print v(xbgr.mr_n81951888)
print v(xbgr.mr_n81952400)
print v(xbgr.mr_n81954336)
print v(xbgr.mr_n81954848)
print v(xbgr.mr_n81956784)
print v(xbgr.mr_n81957296)
print v(xbgr.mr_n81959232)
print v(xbgr.mr_n81959744)
print v(xbgr.mr_n81961744)
print v(xbgr.mr_n81962256)
print v(xbgr.mr_n81964128)
print v(xbgr.mr_n81964640)
print v(xbgr.mr_n81966576)
print v(xbgr.mr_n81967088)
print v(xbgr.mr_n81969024)
print v(xbgr.mr_n81969536)
print v(xbgr.mr_n81971472)
print v(xbgr.mr_n81971984)
print v(xbgr.mr_n81973920)
print v(xbgr.mr_n81974432)
print v(xbgr.mr_n81974544)
print v(xbgr.mr_n81982352)
print v(xbgr.mr_n81983504)
print v(xbgr.mr_n81983616)
print v(xbgr.mr_n81984768)
print v(xbgr.mr_n81984880)
print v(xbgr.mr_n81986032)
print v(xbgr.mr_n81986144)
print v(xbgr.mr_n81987296)
print v(xbgr.mr_n81987408)
print v(xbgr.mr_n81988560)
print v(xbgr.mr_n81988672)
print v(xbgr.mr_n81989824)
print v(xbgr.mr_n81989936)
print v(xbgr.mr_n81991088)
print v(xbgr.mr_n81991200)
print v(xbgr.mr_n81992352)
print v(xbgr.mr_n81992464)
print v(xbgr.mr_n81993616)
print v(xbgr.mr_n81993728)
print v(xbgr.mr_n81994880)
print v(xbgr.mr_n81994992)
print v(xbgr.mr_n81996144)
print v(xbgr.mr_n81996256)
print v(xbgr.mr_n81997408)
print v(xbgr.mr_n81997520)
print v(xbgr.mr_n81998672)
print v(xbgr.mr_n81998784)
print v(xbgr.mr_n81999936)
print v(xbgr.mr_n82000048)
print v(xbgr.mr_n82001200)
print v(xbgr.mr_n82001312)
print v(xbgr.mr_n82002192)
print v(xbgr.mr_n82002880)
print v(xbgr.mr_n82003568)
print v(xbgr.mr_n82004288)
print v(xbgr.mr_n82005232)
print v(xbgr.mr_n82005968)
print v(xbgr.mr_n82006080)
print v(xbgr.mr_n82006192)
print v(xbgr.mr_n82006304)
print v(xbgr.mr_n82006480)
print v(xbgr.mr_n82007648)
print v(xbgr.mr_n82014992)
print v(xbgr.mr_n82016096)
print v(xbgr.mr_n82026896)
print v(xbgr.mr_n82028896)
print v(xbgr.mr_n82029328)
print v(xbgr.mr_n82031216)
print v(xbgr.mr_n82031984)
print v(xbgr.mr_n82035120)
print v(xbgr.mr_n82038112)
print v(xbgr.mr_n82039344)
print v(xbgr.mr_n82039456)
print v(xbgr.mr_n82040400)
print v(xbgr.mr_n82041552)
print v(xbgr.mr_n82041664)
print v(xbgr.mr_n82043440)
print v(xbgr.mr_n82043552)
print v(xbgr.mr_n82044496)
print v(xbgr.mr_n82045648)
print v(xbgr.mr_n82045760)
print v(xbgr.mr_n82047536)
print v(xbgr.mr_n82047648)
print v(xbgr.mr_n82048592)
print v(xbgr.mr_n82049744)
print v(xbgr.mr_n82049856)
print v(xbgr.mr_n82051104)
print v(xbgr.mr_n82051632)
print v(xbgr.mr_n82051744)
print v(xbgr.mr_n82052688)
print v(xbgr.mr_n82053840)
print v(xbgr.mr_n82053952)
print v(xbgr.mr_n82055728)
print v(xbgr.mr_n82055840)
print v(xbgr.mr_n82056784)
print v(xbgr.mr_n82057936)
print v(xbgr.mr_n82058048)
print v(xbgr.mr_n82059824)
print v(xbgr.mr_n82059936)
print v(xbgr.mr_n82060880)
print v(xbgr.mr_n82062032)
print v(xbgr.mr_n82062144)
print v(xbgr.mr_n82063920)
print v(xbgr.mr_n82064032)
print v(xbgr.mr_n82064976)
print v(xbgr.mr_n82066128)
print v(xbgr.mr_n82066240)
print v(xbgr.mr_n82068016)
print v(xbgr.mr_n82068128)
print v(xbgr.mr_n82069072)
print v(xbgr.mr_n82070224)
print v(xbgr.mr_n82070336)
print v(xbgr.mr_n82071584)
print v(xbgr.mr_n82072112)
print v(xbgr.mr_n82072224)
print v(xbgr.mr_n82073536)
print v(xbgr.mr_n82074656)
print v(xbgr.mr_n82076752)
print v(xbgr.mr_n82078320)
print v(xbgr.mr_n82079888)
print v(xbgr.mr_n82081456)
print v(xbgr.mr_n82083024)
print v(xbgr.mr_n82084592)
print v(xbgr.mr_n82086160)
print v(xbgr.mr_n82096016)
print v(xbgr.mr_n82098704)
print v(xbgr.mr_n82103904)
print v(xbgr.mr_n82105760)
print v(xbgr.mr_n82105872)
print v(xbgr.mr_n82107120)
print v(xbgr.mr_n82107312)
print v(xbgr.mr_n82107504)
print v(xbgr.mr_n82107696)
print v(xbgr.mr_n82107888)
print v(xbgr.mr_n82108144)
print v(xbgr.mr_n82108400)
print v(xbgr.mr_n82110944)
print v(xbgr.mr_n82114752)
print v(xbgr.mr_n82114864)
print v(xbgr.mr_n82116608)
print v(xbgr.mr_n82116880)
print v(xbgr.mr_n82117072)
print v(xbgr.mr_n82117584)
print v(xbgr.mr_n82119728)
print v(xbgr.mr_n82119840)
print v(xbgr.mr_n82121584)
print v(xbgr.mr_n82121856)
print v(xbgr.mr_n82122048)
print v(xbgr.mr_n82122560)
print v(xbgr.mr_n82124704)
print v(xbgr.mr_n82124816)
print v(xbgr.mr_n82125008)
print v(xbgr.mr_n82126560)
print v(xbgr.mr_n82126832)
print v(xbgr.mr_n82127024)
print v(xbgr.mr_n82127536)
print v(xbgr.mr_n82129680)
print v(xbgr.mr_n82129792)
print v(xbgr.mr_n82131536)
print v(xbgr.mr_n82131808)
print v(xbgr.mr_n82132000)
print v(xbgr.mr_n82132512)
print v(xbgr.mr_n82134656)
print v(xbgr.mr_n82134768)
print v(xbgr.mr_n82136512)
print v(xbgr.mr_n82136784)
print v(xbgr.mr_n82136976)
print v(xbgr.mr_n82137488)
print v(xbgr.mr_n82139632)
print v(xbgr.mr_n82139824)
print v(xbgr.mr_n82140016)
print v(xbgr.mr_n82141312)
print v(xbgr.mr_n82142688)
print v(xbgr.mr_n82143376)
print v(xbgr.mr_n82145728)
print v(xbgr.mr_n82145840)
print v(xbgr.mr_n82145952)
print v(xbgr.mr_n82146064)
print v(xbgr.mr_n82146256)
print v(xbgr.mr_n82147808)
print v(xbgr.mr_n82148080)
print v(xbgr.mr_n82148272)
print v(xbgr.mr_n82148784)
print v(xbgr.mr_n82152080)
print v(xbgr.mr_n82152272)
print v(xbgr.mr_n82152464)
print v(xbgr.mr_n82154272)
print v(xbgr.mr_n82154464)
print v(xbgr.mr_n82154976)
print v(xbgr.mr_n82157056)
print v(xbgr.mr_n82157248)
print v(xbgr.mr_n82157440)
print v(xbgr.mr_n82159248)
print v(xbgr.mr_n82159440)
print v(xbgr.mr_n82159952)
print v(xbgr.mr_n82162192)
print v(xbgr.mr_n82162384)
print v(xbgr.mr_n82162576)
print v(xbgr.mr_n82162768)
print v(xbgr.mr_n82162960)
print v(xbgr.mr_n82163536)
print v(xbgr.mr_n82165184)
print v(xbgr.mr_n82167008)
print v(xbgr.mr_n82167200)
print v(xbgr.mr_n82167392)
print v(xbgr.mr_n82169200)
print v(xbgr.mr_n82169392)
print v(xbgr.mr_n82169904)
print v(xbgr.mr_n82171984)
print v(xbgr.mr_n82172176)
print v(xbgr.mr_n82172368)
print v(xbgr.mr_n82174176)
print v(xbgr.mr_n82174368)
print v(xbgr.mr_n82174880)
print v(xbgr.mr_n82177120)
print v(xbgr.mr_n82177312)
print v(xbgr.mr_n82177504)
print v(xbgr.mr_n82177696)
print v(xbgr.mr_n82177888)
print v(xbgr.mr_n82180112)
print v(xbgr.mr_n82181936)
print v(xbgr.mr_n82182128)
print v(xbgr.mr_n82182320)
print v(xbgr.mr_n82184128)
print v(xbgr.mr_n82184320)
print v(xbgr.mr_n82184832)
print v(xbgr.mr_n82186912)
print v(xbgr.mr_n82187104)
print v(xbgr.mr_n82187296)
print v(xbgr.mr_n82187696)
print v(xbgr.mr_n82189104)
print v(xbgr.mr_n82189296)
print v(xbgr.mr_n82189808)
print v(xbgr.mr_n82198880)
print v(xbgr.mr_n82202624)
print v(xbgr.mr_n82204880)
print v(xbgr.mr_n82206352)
print v(xbgr.mr_n82207632)
print v(xbgr.mr_n82210768)
print v(xbgr.mr_n82213024)
print v(xbgr.mr_n82215136)
print v(xbgr.mr_n82222128)
print v(xbgr.mr_n82222624)
print v(xbgr.mr_n82223968)
print v(xbgr.mr_n82224400)
print v(xbgr.mr_n82227808)
print v(xbgr.mr_n82227920)
print v(xbgr.mr_n82229072)
print v(xbgr.mr_n82229184)
print v(xbgr.mr_n82230336)
print v(xbgr.mr_n82230448)
print v(xbgr.mr_n82231600)
print v(xbgr.mr_n82231712)
print v(xbgr.mr_n82232864)
print v(xbgr.mr_n82232976)
print v(xbgr.mr_n82234064)
print v(xbgr.mr_n82234176)
print v(xbgr.mr_n82235392)
print v(xbgr.mr_n82235504)
print v(xbgr.mr_n82236656)
print v(xbgr.mr_n82236768)
print v(xbgr.mr_n82237920)
print v(xbgr.mr_n82238032)
print v(xbgr.mr_n82239184)
print v(xbgr.mr_n82239296)
print v(xbgr.mr_n82240448)
print v(xbgr.mr_n82240560)
print v(xbgr.mr_n82241712)
print v(xbgr.mr_n82241824)
print v(xbgr.mr_n82242976)
print v(xbgr.mr_n82243088)
print v(xbgr.mr_n82244240)
print v(xbgr.mr_n82244352)
print v(xbgr.mr_n82245504)
print v(xbgr.mr_n82245616)
print v(xbgr.mr_n82248304)
print v(xbgr.mr_n82251232)
print v(xbgr.mr_n82251376)
print v(xbgr.mr_n82253216)
print v(xbgr.mr_n82255776)
print v(xbgr.mr_n82256464)
print v(xbgr.mr_n82257152)
print v(xbgr.mr_n82257872)
print v(xbgr.mr_n82258816)
print v(xbgr.mr_n82259760)
print v(xbgr.mr_n82260704)
print v(xbgr.mr_n82261648)
print v(xbgr.mr_n82262592)
print v(xbgr.mr_n82263536)
print v(xbgr.mr_n82264480)
print v(xbgr.mr_n82265424)
print v(xbgr.mr_n82266368)
print v(xbgr.mr_n82267312)
print v(xbgr.mr_n82268256)
print v(xbgr.mr_n82269200)
print v(xbgr.mr_n82270144)
print v(xbgr.mr_n82271088)
print v(xbgr.mr_n82272032)
print v(xbgr.mr_n82272976)
print v(xbgr.mr_n82273920)
print v(xbgr.mr_n82274864)
print v(xbgr.mr_n82275808)
print v(xbgr.mr_n82276336)
print v(xbgr.mr_n82276448)
print v(xbgr.mr_n82277056)
print v(xbgr.mr_n82279472)
print v(xbgr.mr_n82281904)
print v(xbgr.mr_n82289840)
print v(xbgr.mr_n82290928)
print v(xbgr.mr_n82291168)
print v(xbgr.mr_n82292832)
print v(xbgr.mr_n82293888)
print v(xbgr.mr_n82294944)
print v(xbgr.mr_n82295568)
print v(xbgr.mr_n82296288)
print v(xbgr.mr_n82297936)
print v(xbgr.mr_n82300096)
print v(xbgr.mr_n82301280)
print v(xbgr.mr_n82301568)
print v(xbgr.mr_n82303040)
print v(xbgr.mr_n82303568)
print v(xbgr.mr_n82304272)
print v(xbgr.mr_n82304864)
print v(xbgr.mr_n82304976)
print v(xbgr.mr_n82306032)
print v(xbgr.mr_n82306320)
print v(xbgr.mr_n82308144)
print v(xbgr.mr_n82308672)
print v(xbgr.mr_n82314944)
print v(xbgr.mr_n82316176)
print v(xbgr.mr_n82317024)
print v(xbgr.mr_n82318000)
print v(xbgr.mr_n82318288)
print v(xbgr.mr_n82318464)
print v(xbgr.mr_n82318640)
print v(xbgr.mr_n82318880)
print v(xbgr.mr_n82319168)
print v(xbgr.mr_n82319408)
print v(xbgr.mr_n82320240)
print v(xbgr.mr_n82320672)
print v(xbgr.mr_n82323072)
print v(xbgr.mr_n82324544)
print v(xbgr.mr_n82325312)
print v(xbgr.mr_n82326256)
print v(xbgr.mr_n82327200)
print v(xbgr.mr_n82328144)
print v(xbgr.mr_n82329088)
print v(xbgr.mr_n82330032)
print v(xbgr.mr_n82330976)
print v(xbgr.mr_n82331920)
print v(xbgr.mr_n82332864)
print v(xbgr.mr_n82333808)
print v(xbgr.mr_n82334752)
print v(xbgr.mr_n82335696)
print v(xbgr.mr_n82336640)
print v(xbgr.mr_n82337584)
print v(xbgr.mr_n82338528)
print v(xbgr.mr_n82339472)
print v(xbgr.mr_n82340416)
print v(xbgr.mr_n82341360)
print v(xbgr.mr_n82342304)
print v(xbgr.mr_n82343248)
print v(xbgr.mr_n82344192)
print v(xbgr.mr_n82345136)
print v(xbgr.mr_n82346080)
print v(xbgr.mr_n82347024)
print v(xbgr.mr_n82347968)
print v(xbgr.mr_n82348912)
print v(xbgr.mr_n82349856)
print v(xbgr.mr_n82350800)
print v(xbgr.mr_n82351744)
print v(xbgr.mr_n82352688)
print v(xbgr.mr_n82353632)
print v(xbgr.mr_n82354576)
print v(xbgr.mr_n82355520)
print v(xbgr.mr_n82356464)
print v(xbgr.mr_n82357408)
print v(xbgr.mr_n82358352)
print v(xbgr.mr_n82359296)
print v(xbgr.mr_n82360240)
print v(xbgr.mr_n82361184)
print v(xbgr.mr_n82362128)
print v(xbgr.mr_n82363072)
print v(xbgr.mr_n82364016)
print v(xbgr.mr_n82364960)
print v(xbgr.mr_n82365904)
print v(xbgr.mr_n82366848)
print v(xbgr.mr_n82367792)
print v(xbgr.mr_n82368736)
print v(xbgr.mr_n82369680)
print v(xbgr.mr_n82370624)
print v(xbgr.mr_n82371568)
print v(xbgr.mr_n82372512)
print v(xbgr.mr_n82373456)
print v(xbgr.mr_n82374400)
print v(xbgr.mr_n82375344)
print v(xbgr.mr_n82376288)
print v(xbgr.mr_n82377232)
print v(xbgr.mr_n82378176)
print v(xbgr.mr_n82379120)
print v(xbgr.mr_n82380064)
print v(xbgr.mr_n82381008)
print v(xbgr.mr_n82381952)
print v(xbgr.mr_n82382896)
print v(xbgr.mr_n82383840)
print v(xbgr.mr_n82384784)
print v(xbgr.mr_n82385728)
print v(xbgr.mr_n82386672)
print v(xbgr.mr_n82387616)
print v(xbgr.mr_n82388560)
print v(xbgr.mr_n82389504)
print v(xbgr.mr_n82390448)
print v(xbgr.mr_n82391392)
print v(xbgr.mr_n82392336)
print v(xbgr.mr_n82393280)
print v(xbgr.mr_n82394224)
print v(xbgr.mr_n82395168)
print v(xbgr.mr_n82396112)
print v(xbgr.mr_n82397056)
print v(xbgr.mr_n82398000)
print v(xbgr.mr_n82398944)
print v(xbgr.mr_n82399888)
print v(xbgr.mr_n82400832)
print v(xbgr.mr_n82401776)
print v(xbgr.mr_n82402720)
print v(xbgr.mr_n82403664)
print v(xbgr.mr_n82404608)
print v(xbgr.mr_n82405552)
print v(xbgr.mr_n82406496)
print v(xbgr.mr_n82407440)
print v(xbgr.mr_n82408384)
print v(xbgr.mr_n82409328)
print v(xbgr.mr_n82410272)
print v(xbgr.mr_n82411216)
print v(xbgr.mr_n82412240)
print v(xbgr.mr_n82412752)
print v(xbgr.mr_n82412944)
print v(xbgr.mr_n82413856)
print v(xbgr.mr_n82414128)
print v(xbgr.mr_n82414320)
print v(xbgr.mr_n82414832)
print v(xbgr.mr_n82420432)
print v(xbgr.mr_n82420544)
print v(xbgr.mr_n82422288)
print v(xbgr.mr_n82422560)
print v(xbgr.mr_n82422752)
print v(xbgr.mr_n82423264)
print v(xbgr.mr_n82426448)
print v(xbgr.mr_n82426560)
print v(xbgr.mr_n82426672)
print v(xbgr.mr_n82426864)
print v(xbgr.mr_n82427056)
print v(xbgr.mr_n82428864)
print v(xbgr.mr_n82429056)
print v(xbgr.mr_n82429568)
print v(xbgr.mr_n82430736)
print v(xbgr.mr_n82431248)
print v(xbgr.mr_n82434096)
print v(xbgr.mr_n82434208)
print v(xbgr.mr_n82435952)
print v(xbgr.mr_n82436224)
print v(xbgr.mr_n82436416)
print v(xbgr.mr_n82436928)
print v(xbgr.mr_n82440112)
print v(xbgr.mr_n82440224)
print v(xbgr.mr_n82440336)
print v(xbgr.mr_n82440528)
print v(xbgr.mr_n82440720)
print v(xbgr.mr_n82442528)
print v(xbgr.mr_n82442720)
print v(xbgr.mr_n82443232)
print v(xbgr.mr_n82446352)
print v(xbgr.mr_n82446464)
print v(xbgr.mr_n82446576)
print v(xbgr.mr_n82446688)
print v(xbgr.mr_n82446880)
print v(xbgr.mr_n82448432)
print v(xbgr.mr_n82448704)
print v(xbgr.mr_n82448896)
print v(xbgr.mr_n82449408)
print v(xbgr.mr_n82450640)
print v(xbgr.mr_n82451152)
print v(xbgr.mr_n82454000)
print v(xbgr.mr_n82454112)
print v(xbgr.mr_n82455856)
print v(xbgr.mr_n82456128)
print v(xbgr.mr_n82456320)
print v(xbgr.mr_n82456832)
print v(xbgr.mr_n82460016)
print v(xbgr.mr_n82460128)
print v(xbgr.mr_n82460240)
print v(xbgr.mr_n82460352)
print v(xbgr.mr_n82462096)
print v(xbgr.mr_n82462288)
print v(xbgr.mr_n82462480)
print v(xbgr.mr_n82463072)
print v(xbgr.mr_n82466256)
print v(xbgr.mr_n82466368)
print v(xbgr.mr_n82466480)
print v(xbgr.mr_n82466592)
print v(xbgr.mr_n82468336)
print v(xbgr.mr_n82468608)
print v(xbgr.mr_n82468800)
print v(xbgr.mr_n82469312)
print v(xbgr.mr_n82469424)
print v(xbgr.mr_n82471376)
print v(xbgr.mr_n82473904)
print v(xbgr.mr_n82474016)
print v(xbgr.mr_n82475760)
print v(xbgr.mr_n82476032)
print v(xbgr.mr_n82476224)
print v(xbgr.mr_n82476736)
print v(xbgr.mr_n82479920)
print v(xbgr.mr_n82480032)
print v(xbgr.mr_n82480144)
print v(xbgr.mr_n82480256)
print v(xbgr.mr_n82482000)
print v(xbgr.mr_n82482272)
print v(xbgr.mr_n82482464)
print v(xbgr.mr_n82482976)
print v(xbgr.mr_n82486160)
print v(xbgr.mr_n82486272)
print v(xbgr.mr_n82486384)
print v(xbgr.mr_n82486496)
print v(xbgr.mr_n82488240)
print v(xbgr.mr_n82488512)
print v(xbgr.mr_n82488704)
print v(xbgr.mr_n82489216)
print v(xbgr.mr_n82490368)
print v(xbgr.mr_n82490960)
print v(xbgr.mr_n82493808)
print v(xbgr.mr_n82493920)
print v(xbgr.mr_n82495664)
print v(xbgr.mr_n82495936)
print v(xbgr.mr_n82496128)
print v(xbgr.mr_n82496640)
print v(xbgr.mr_n82498704)
print v(xbgr.mr_n82498816)
print v(xbgr.mr_n82499328)
print v(xbgr.mr_n82499440)
print v(xbgr.mr_n82499952)
print v(xbgr.mr_n82500064)
print v(xbgr.mr_n82500832)
print v(xbgr.mr_n82500944)
print v(xbgr.mr_n82501776)
print v(xbgr.mr_n82501888)
print v(xbgr.mr_n82502976)
print v(xbgr.mr_n82503088)
print v(xbgr.mr_n82504240)
print v(xbgr.mr_n82504352)
print v(xbgr.mr_n82505504)
print v(xbgr.mr_n82505616)
print v(xbgr.mr_n82506768)
print v(xbgr.mr_n82506880)
print v(xbgr.mr_n82508032)
print v(xbgr.mr_n82508144)
print v(xbgr.mr_n82509296)
print v(xbgr.mr_n82509408)
print v(xbgr.mr_n82510560)
print v(xbgr.mr_n82510672)
print v(xbgr.mr_n82511824)
print v(xbgr.mr_n82511936)
print v(xbgr.mr_n82513088)
print v(xbgr.mr_n82513200)
print v(xbgr.mr_n82514352)
print v(xbgr.mr_n82514464)
print v(xbgr.mr_n82515616)
print v(xbgr.mr_n82515728)
print v(xbgr.mr_n82517120)
print v(xbgr.mr_n82525008)
print v(xbgr.mr_n82525440)
print v(xbgr.mr_n82529408)
print v(xbgr.mr_n82535360)
print v(xbgr.mr_n82536272)
print v(xbgr.mr_n82536528)
print v(xbgr.mr_n82536896)
print v(xbgr.mr_n82538112)
print v(xbgr.mr_n82542112)
print v(xbgr.mr_n82543552)
print v(xbgr.mr_n82544128)
print v(xbgr.mr_n82544384)
print v(xbgr.mr_n82544640)
print v(xbgr.mr_n82544896)
print v(xbgr.mr_n82553712)
print v(xbgr.mr_n82555216)
print v(xbgr.mr_n82560048)
print v(xbgr.mr_n82563312)
print v(xbgr.mr_n82564912)
print v(xbgr.mr_n82565408)
print v(xbgr.mr_n82567344)
print v(xbgr.mr_n82567456)
print v(xbgr.mr_n82571344)
print v(xbgr.mr_n82573040)
print v(xbgr.mr_n82573392)
print v(xbgr.mr_n82580848)
print v(xbgr.mr_n82581792)
print v(xbgr.mr_n82582736)
print v(xbgr.mr_n82583680)
print v(xbgr.mr_n82584624)
print v(xbgr.mr_n82585568)
print v(xbgr.mr_n82586512)
print v(xbgr.mr_n82587456)
print v(xbgr.mr_n82588400)
print v(xbgr.mr_n82589344)
print v(xbgr.mr_n82590288)
print v(xbgr.mr_n82591232)
print v(xbgr.mr_n82592176)
print v(xbgr.mr_n82593120)
print v(xbgr.mr_n82594064)
print v(xbgr.mr_n82595008)
print v(xbgr.mr_n82595952)
print v(xbgr.mr_n82596896)
print v(xbgr.mr_n82597840)
print v(xbgr.mr_n82598784)
print v(xbgr.mr_n82599728)
print v(xbgr.mr_n82600672)
print v(xbgr.mr_n82601616)
print v(xbgr.mr_n82602560)
print v(xbgr.mr_n82603504)
print v(xbgr.mr_n82605600)
print v(xbgr.mr_n82609440)
print v(xbgr.mr_n82610384)
print v(xbgr.mr_n82611328)
print v(xbgr.mr_n82612464)
print v(xbgr.mr_n82617792)
print v(xbgr.mr_n82617984)
print v(xbgr.mr_n82618672)
print v(xbgr.mr_n82618784)
print v(xbgr.mr_n82618896)
print v(xbgr.mr_n82619008)
print v(xbgr.mr_n82619120)
print v(xbgr.mr_n82620864)
print v(xbgr.mr_n82621136)
print v(xbgr.mr_n82621328)
print v(xbgr.mr_n82621840)
print v(xbgr.mr_n82623776)
print v(xbgr.mr_n82625520)
print v(xbgr.mr_n82625792)
print v(xbgr.mr_n82625984)
print v(xbgr.mr_n82626496)
print v(xbgr.mr_n82628432)
print v(xbgr.mr_n82630176)
print v(xbgr.mr_n82630448)
print v(xbgr.mr_n82630640)
print v(xbgr.mr_n82631152)
print v(xbgr.mr_n82633168)
print v(xbgr.mr_n82633360)
print v(xbgr.mr_n82635168)
print v(xbgr.mr_n82635360)
print v(xbgr.mr_n82635872)
print v(xbgr.mr_n82637744)
print v(xbgr.mr_n82639488)
print v(xbgr.mr_n82639760)
print v(xbgr.mr_n82639952)
print v(xbgr.mr_n82640464)
print v(xbgr.mr_n82642400)
print v(xbgr.mr_n82644144)
print v(xbgr.mr_n82644416)
print v(xbgr.mr_n82644608)
print v(xbgr.mr_n82645120)
print v(xbgr.mr_n82647056)
print v(xbgr.mr_n82648800)
print v(xbgr.mr_n82649072)
print v(xbgr.mr_n82649264)
print v(xbgr.mr_n82649776)
print v(xbgr.mr_n82651712)
print v(xbgr.mr_n82653456)
print v(xbgr.mr_n82653728)
print v(xbgr.mr_n82653920)
print v(xbgr.mr_n82654432)
print v(xbgr.mr_n82656368)
print v(xbgr.mr_n82658112)
print v(xbgr.mr_n82658384)
print v(xbgr.mr_n82658576)
print v(xbgr.mr_n82659088)
print v(xbgr.mr_n82661024)
print v(xbgr.mr_n82662768)
print v(xbgr.mr_n82663040)
print v(xbgr.mr_n82663232)
print v(xbgr.mr_n82663744)
print v(xbgr.mr_n82665680)
print v(xbgr.mr_n82667424)
print v(xbgr.mr_n82667696)
print v(xbgr.mr_n82667888)
print v(xbgr.mr_n82668400)
print v(xbgr.mr_n82670336)
print v(xbgr.mr_n82672080)
print v(xbgr.mr_n82672352)
print v(xbgr.mr_n82672544)
print v(xbgr.mr_n82673056)
print v(xbgr.mr_n82674992)
print v(xbgr.mr_n82676736)
print v(xbgr.mr_n82677008)
print v(xbgr.mr_n82677200)
print v(xbgr.mr_n82677712)
print v(xbgr.mr_n82679648)
print v(xbgr.mr_n82681392)
print v(xbgr.mr_n82681920)
print v(xbgr.mr_n82685568)
print v(xbgr.mr_n82685760)
print v(xbgr.mr_n82686448)
print v(xbgr.mr_n82686960)
print v(xbgr.mr_n82690768)
print v(xbgr.mr_n82693616)
print v(xbgr.mr_n82693856)
print v(xbgr.mr_n82694000)
print v(xbgr.mr_n82695120)
print v(xbgr.mr_n82695888)
print v(xbgr.mr_n82696032)
print v(xbgr.mr_n82696192)
print v(xbgr.mr_n82697584)
print v(xbgr.mr_n82699152)
print v(xbgr.mr_n82699376)
print v(xbgr.mr_n82700800)
print v(xbgr.mr_n82701488)
print v(xbgr.mr_n82703472)
print v(xbgr.mr_n82704832)
print v(xbgr.mr_n82705408)
print v(xbgr.mr_n82708768)
print v(xbgr.mr_n82709120)
print v(xbgr.mr_n82709472)
print v(xbgr.mr_n82711232)
print v(xbgr.mr_n82712480)
print v(xbgr.mr_n82712928)
print v(xbgr.mr_n82714208)
print v(xbgr.mr_n82714464)
print v(xbgr.mr_n82716960)
print v(xbgr.mr_n82717232)
print v(xbgr.mr_n82717344)
print v(xbgr.mr_n82718480)
print v(xbgr.mr_n82725792)
print v(xbgr.mr_n82726912)
print v(xbgr.mr_n82727696)
print v(xbgr.mr_n82730960)
print v(xbgr.mr_n82731296)
print v(xbgr.mr_n82734304)
print v(xbgr.mr_n82735024)
print v(xbgr.mr_n82735536)
print v(xbgr.mr_n82735984)
print v(xbgr.mr_n82738000)
print v(xbgr.mr_n82738768)
print v(xbgr.mr_n82742016)
print v(xbgr.mr_n82743024)
print v(xbgr.mr_n82743328)
print v(xbgr.mr_n82743584)
print v(xbgr.mr_n82746256)
print v(xbgr.mr_n82747824)
print v(xbgr.mr_n82749008)
print v(xbgr.mr_n82749552)
print v(xbgr.mr_n82751024)
print v(xbgr.mr_n82751824)
print v(xbgr.mr_n82752864)
print v(xbgr.mr_n82754608)
print v(xbgr.mr_n82755120)
print v(xbgr.mr_n82755232)
print v(xbgr.mr_n82755664)
print v(xbgr.mr_n82756176)
print v(xbgr.mr_n82756288)
print v(xbgr.mr_n82756720)
print v(xbgr.mr_n82757232)
print v(xbgr.mr_n82757344)
print v(xbgr.mr_n82760304)
print v(xbgr.mr_n82760912)
print v(xbgr.mr_n82761024)
print v(xbgr.mr_n82761680)
print v(xbgr.mr_n82761904)
print v(xbgr.mr_n82762176)
print v(xbgr.mr_n82762304)
print v(xbgr.mr_n82762640)
print v(xbgr.mr_n82763040)
print v(xbgr.mr_n82763504)
print v(xbgr.mr_n82763856)
print v(xbgr.mr_n82769024)
print v(xbgr.mr_n82769376)
print v(xbgr.mr_n82769568)
print v(xbgr.mr_n82770864)
print v(xbgr.mr_n82771184)
print v(xbgr.mr_n82771296)
print v(xbgr.mr_n82771968)
print v(xbgr.mr_n82774496)
print v(xbgr.mr_n82775456)
print v(xbgr.mr_n82775920)
print v(xbgr.mr_n82777024)
print v(xbgr.mr_n82778128)
print v(xbgr.mr_n82779312)
print v(xbgr.mr_n82780912)
print v(xbgr.mr_n82784112)
print v(xbgr.mr_n82784304)
print v(xbgr.mr_n82784496)
print v(xbgr.mr_n82786208)
print v(xbgr.mr_n82786320)
print v(xbgr.mr_n82786896)
print v(xbgr.mr_n82787360)
print v(xbgr.mr_n82787824)
print v(xbgr.mr_n82788016)
print v(xbgr.mr_n82788816)
print v(xbgr.mr_n82789216)
print v(xbgr.mr_n82790432)
print v(xbgr.mr_n82790768)
print v(xbgr.mr_n82791232)
print v(xbgr.mr_n82791696)
print v(xbgr.mr_n82792496)
print v(xbgr.mr_n82793280)
print v(xbgr.mr_n82793904)
print v(xbgr.mr_n82794656)
print v(xbgr.mr_n82795072)
print v(xbgr.mr_n82795472)
print v(xbgr.mr_n82795936)
print v(xbgr.mr_n82799792)
print v(xbgr.mr_n82802912)
print v(xbgr.mr_n82803488)
print v(xbgr.mr_n82803600)
print v(xbgr.mr_n82804480)
print v(xbgr.mr_n82805168)
print v(xbgr.mr_n82805856)
print v(xbgr.mr_n82806544)
print v(xbgr.mr_n82807232)
print v(xbgr.mr_n82807920)
print v(xbgr.mr_n82808608)
print v(xbgr.mr_n82809296)
print v(xbgr.mr_n82809984)
print v(xbgr.mr_n82810672)
print v(xbgr.mr_n82811360)
print v(xbgr.mr_n82812048)
print v(xbgr.mr_n82812736)
print v(xbgr.mr_n82813424)
print v(xbgr.mr_n82814112)
print v(xbgr.mr_n82814800)
print v(xbgr.mr_n82815488)
print v(xbgr.mr_n82816176)
print v(xbgr.mr_n82816864)
print v(xbgr.mr_n82817488)
print v(xbgr.mr_n82818160)
print v(xbgr.mr_n82818272)
print v(xbgr.mr_n82818784)
print v(xbgr.mr_n82818896)
print v(xbgr.mr_n82819408)
print v(xbgr.mr_n82819520)
print v(xbgr.mr_n82820032)
print v(xbgr.mr_n82820144)
print v(xbgr.mr_n82820656)
print v(xbgr.mr_n82820768)
print v(xbgr.mr_n82821984)
print v(xbgr.mr_n82822096)
print v(xbgr.mr_n82823728)
print v(xbgr.mr_n82823840)
print v(xbgr.mr_n82824672)
print v(xbgr.mr_n82824784)
print v(xbgr.mr_n82825616)
print v(xbgr.mr_n82825728)
print v(xbgr.mr_n82826560)
print v(xbgr.mr_n82826672)
print v(xbgr.mr_n82827504)
print v(xbgr.mr_n82827616)
print v(xbgr.mr_n82828448)
print v(xbgr.mr_n82828560)
print v(xbgr.mr_n82829712)
print v(xbgr.mr_n82829824)
print v(xbgr.mr_n82830976)
print v(xbgr.mr_n82831088)
print v(xbgr.mr_n82832240)
print v(xbgr.mr_n82832352)
print v(xbgr.mr_n82832784)
print v(xbgr.mr_n82834128)
print v(xbgr.mr_n82837728)
print v(xbgr.mr_n82841568)
print v(xbgr.mr_n82845264)
print v(xbgr.mr_n82847648)
print v(xbgr.mr_n82850960)
print v(xbgr.mr_n82851152)
print v(xbgr.mr_n82851344)
print v(xbgr.mr_n82851536)
print v(xbgr.mr_n82853856)
print v(xbgr.mr_n82854128)
print v(xbgr.mr_n82854320)
print v(xbgr.mr_n82854832)
print v(xbgr.mr_n82854944)
print v(xbgr.mr_n82855056)
print v(xbgr.mr_n82855168)
print v(xbgr.mr_n82855360)
print v(xbgr.mr_n82855552)
print v(xbgr.mr_n82855744)
print v(xbgr.mr_n82859312)
print v(xbgr.mr_n82875408)
print v(xbgr.mr_n82878864)
print v(xbgr.mr_n82880480)
print v(xbgr.mr_n82882160)
print v(xbgr.mr_n82884416)
print v(xbgr.mr_n82886672)
print v(xbgr.mr_n82888928)
print v(xbgr.mr_n82891184)
print v(xbgr.mr_n82894624)
print v(xbgr.mr_n82895008)
print v(xbgr.mr_n82896752)
print v(xbgr.mr_n82912480)
print v(xbgr.mr_n82912912)
print v(xbgr.mr_n82913744)
print v(xbgr.mr_n82914176)
print v(xbgr.mr_n82915008)
print v(xbgr.mr_n82915584)
print v(xbgr.mr_n82916272)
print v(xbgr.mr_n82916848)
print v(xbgr.mr_n82917536)
print v(xbgr.mr_n82917968)
print v(xbgr.mr_n82918800)
print v(xbgr.mr_n82918912)
print v(xbgr.mr_n82919376)
print v(xbgr.mr_n82920064)
print v(xbgr.mr_n82920640)
print v(xbgr.mr_n82921328)
print v(xbgr.mr_n82925088)
print v(xbgr.mr_n82927392)
print v(xbgr.mr_n82928544)
print v(xbgr.mr_n82931104)
print v(xbgr.mr_n82934384)
print v(xbgr.mr_n82935840)
print v(xbgr.mr_n82937968)
print v(xbgr.mr_n82939552)
print v(xbgr.mr_n82943984)
print v(xbgr.mr_n82946224)
print v(xbgr.mr_n82947696)
print v(xbgr.mr_n82951680)
print v(xbgr.mr_n82952064)
print v(xbgr.mr_n82952720)
print v(xbgr.mr_n82952832)
print v(xbgr.mr_n82953632)
print v(xbgr.mr_n82954256)
print v(xbgr.mr_n82954720)
print v(xbgr.mr_n82955120)
print v(xbgr.mr_n82955840)
print v(xbgr.mr_n82956592)
print v(xbgr.mr_n82956704)
print v(xbgr.mr_n82956816)
print v(xbgr.mr_n82956928)
print v(xbgr.mr_n82957040)
print v(xbgr.mr_n82957152)
print v(xbgr.mr_n82957264)
print v(xbgr.mr_n82957376)
print v(xbgr.mr_n82957648)
print v(xbgr.mr_n82957760)
print v(xbgr.mr_n82958640)
print v(xbgr.mr_n82958832)
print v(xbgr.mr_n82959024)
print v(xbgr.mr_n82959984)
print v(xbgr.mr_n82961344)
print v(xbgr.mr_n82961616)
print v(xbgr.mr_n82962016)
print v(xbgr.mr_n82962416)
print v(xbgr.mr_n82962816)
print v(xbgr.mr_n82963008)
print v(xbgr.mr_n82963200)
print v(xbgr.mr_n82964384)
print v(xbgr.mr_n82966928)
print v(xbgr.mr_n82967040)
print v(xbgr.mr_n82967552)
print v(xbgr.mr_n82967664)
print v(xbgr.mr_n82968176)
print v(xbgr.mr_n82968288)
print v(xbgr.mr_n82968800)
print v(xbgr.mr_n82968912)
print v(xbgr.mr_n82969424)
print v(xbgr.mr_n82969536)
print v(xbgr.mr_n82970048)
print v(xbgr.mr_n82970160)
print v(xbgr.mr_n82970672)
print v(xbgr.mr_n82970784)
print v(xbgr.mr_n82971296)
print v(xbgr.mr_n82971408)
print v(xbgr.mr_n82972048)
print v(xbgr.mr_n82972432)
print v(xbgr.mr_n82977728)
print v(xbgr.mr_n82982240)
print v(xbgr.mr_n82984960)
print v(xbgr.mr_n82985648)
print v(xbgr.mr_n82986336)
print v(xbgr.mr_n82987024)
print v(xbgr.mr_n82987712)
print v(xbgr.mr_n82988400)
print v(xbgr.mr_n82989088)
print v(xbgr.mr_n82989776)
print v(xbgr.mr_n82990656)
print v(xbgr.mr_n82992624)
print v(xbgr.mr_n82993568)
print v(xbgr.mr_n82994512)
print v(xbgr.mr_n82995456)
print v(xbgr.mr_n82996400)
print v(xbgr.mr_n82997344)
print v(xbgr.mr_n82998288)
print v(xbgr.mr_n82999232)
print v(xbgr.mr_n82999568)
print v(xbgr.mr_n83000176)
print v(xbgr.mr_n83007616)
print v(xbgr.mr_n83008384)
print v(xbgr.mr_n83009152)
print v(xbgr.mr_n83009616)
print v(xbgr.mr_n83011072)
print v(xbgr.mr_n83011456)
print v(xbgr.mr_n83011840)
print v(xbgr.mr_n83012224)
print v(xbgr.mr_n83012688)
print v(xbgr.mr_n83013072)
print v(xbgr.mr_n83013760)
print v(xbgr.mr_n83014144)
print v(xbgr.mr_n83014912)
print v(xbgr.mr_n83016064)
print v(xbgr.mr_n83016448)
print v(xbgr.mr_n83017216)
print v(xbgr.mr_n83020448)
print v(xbgr.mr_n83021248)
print v(xbgr.mr_n83021568)
print v(xbgr.mr_n83022144)
print v(xbgr.mr_n83022400)
print v(xbgr.mr_n83023664)
print v(xbgr.mr_n83024432)
print v(xbgr.mr_n83025088)
print v(xbgr.mr_n83025472)
print v(xbgr.mr_n83026080)
print v(xbgr.mr_n83027424)
print v(xbgr.mr_n83028768)
print v(xbgr.mr_n83029296)
print v(xbgr.mr_n83031904)
print v(xbgr.mr_n83032128)
print v(xbgr.mr_n83032384)
print v(xbgr.mr_n83034784)
print v(xbgr.mr_n83043904)
print v(xbgr.mr_n83044448)
print v(xbgr.mr_n83045552)
print v(xbgr.mr_n83048960)
print v(xbgr.mr_n83050576)
print v(xbgr.mr_n83051824)
print v(xbgr.mr_n83052624)
print v(xbgr.mr_n83054320)
print v(xbgr.mr_n83055136)
print v(xbgr.mr_n83056368)
print v(xbgr.mr_n83056880)
print v(xbgr.mr_n83056992)
print v(xbgr.mr_n83057424)
print v(xbgr.mr_n83057936)
print v(xbgr.mr_n83058048)
print v(xbgr.mr_n83058480)
print v(xbgr.mr_n83058992)
print v(xbgr.mr_n83059104)
print v(xbgr.mr_n83059536)
print v(xbgr.mr_n83060048)
print v(xbgr.mr_n83061824)
print v(xbgr.mr_n83062016)
print v(xbgr.mr_n83062880)
print v(xbgr.mr_n83065776)
print v(xbgr.mr_n83066128)
print v(xbgr.mr_n83066592)
print v(xbgr.mr_n83067808)
print v(xbgr.mr_n83068112)
print v(xbgr.mr_n83069792)
print v(xbgr.mr_n83070496)
print v(xbgr.mr_n83072144)
print v(xbgr.mr_n83072816)
print v(xbgr.mr_n83073904)
print v(xbgr.mr_n83077712)
print v(xbgr.mr_n83080416)
print v(xbgr.mr_n83081216)
print v(xbgr.mr_n83081328)
print v(xbgr.mr_n83081472)
print v(xbgr.mr_n83083008)
print v(xbgr.mr_n83085440)
print v(xbgr.mr_n83086112)
print v(xbgr.mr_n83086880)
print v(xbgr.mr_n83087872)
print v(xbgr.mr_n83088320)
print v(xbgr.mr_n83094112)
print v(xbgr.mr_n83094688)
print v(xbgr.mr_n83095200)
print v(xbgr.mr_n83097184)
print v(xbgr.mr_n83098752)
print v(xbgr.mr_n83099424)
print v(xbgr.mr_n83100928)
print v(xbgr.mr_n83101760)
print v(xbgr.mr_n83103712)
print v(xbgr.mr_n83104576)
print v(xbgr.mr_n83109536)
print v(xbgr.mr_n83109920)
print v(xbgr.mr_n83110384)
print v(xbgr.mr_n83110576)
print v(xbgr.mr_n83110768)
print v(xbgr.mr_n83111712)
print v(xbgr.mr_n83111968)
print v(xbgr.mr_n83112160)
print v(xbgr.mr_n83112640)
print v(xbgr.mr_n83112976)
print v(xbgr.mr_n83113376)
print v(xbgr.mr_n83113840)
print v(xbgr.mr_n83114304)
print v(xbgr.mr_n83114496)
print v(xbgr.mr_n83114960)
print v(xbgr.mr_n83115904)
print v(xbgr.mr_n83116720)
print v(xbgr.mr_n83116912)
print v(xbgr.mr_n83117728)
print v(xbgr.mr_n83118064)
print v(xbgr.mr_n83118528)
print v(xbgr.mr_n83119472)
print v(xbgr.mr_n83120016)
print v(xbgr.mr_n83120480)
print v(xbgr.mr_n83120944)
print v(xbgr.mr_n83121408)
print v(xbgr.mr_n83121808)
print v(xbgr.mr_n83122816)
print v(xbgr.mr_n83123312)
print v(xbgr.mr_n83126208)
print v(xbgr.mr_n83128848)
print v(xbgr.mr_n83129312)
print v(xbgr.mr_n83129504)
print v(xbgr.mr_n83129968)
print v(xbgr.mr_n83130432)
print v(xbgr.mr_n83130624)
print v(xbgr.mr_n83130992)
print v(xbgr.mr_n83132096)
print v(xbgr.mr_n83132768)
print v(xbgr.mr_n83139056)
print v(xbgr.mr_n83141152)
print v(xbgr.mr_n83141584)
print v(xbgr.mr_n83142096)
print v(xbgr.mr_n83142208)
print v(xbgr.mr_n83142640)
print v(xbgr.mr_n83143152)
print v(xbgr.mr_n83143264)
print v(xbgr.mr_n83143696)
print v(xbgr.mr_n83144208)
print v(xbgr.mr_n83144320)
print v(xbgr.mr_n83144752)
print v(xbgr.mr_n83145264)
print v(xbgr.mr_n83145376)
print v(xbgr.mr_n83145808)
print v(xbgr.mr_n83146320)
print v(xbgr.mr_n83146432)
print v(xbgr.mr_n83146864)
print v(xbgr.mr_n83147376)
print v(xbgr.mr_n83147488)
print v(xbgr.mr_n83147920)
print v(xbgr.mr_n83148432)
print v(xbgr.mr_n83148544)
print v(xbgr.mr_n83148976)
print v(xbgr.mr_n83149488)
print v(xbgr.mr_n83149600)
print v(xbgr.mr_n83150032)
print v(xbgr.mr_n83151120)
print v(xbgr.mr_n83151232)
print v(xbgr.mr_n83152112)
print v(xbgr.mr_n83152800)
print v(xbgr.mr_n83153488)
print v(xbgr.mr_n83154176)
print v(xbgr.mr_n83154864)
print v(xbgr.mr_n83155552)
print v(xbgr.mr_n83156240)
print v(xbgr.mr_n83156928)
print v(xbgr.mr_n83157616)
print v(xbgr.mr_n83158304)
print v(xbgr.mr_n83158992)
print v(xbgr.mr_n83159680)
print v(xbgr.mr_n83160368)
print v(xbgr.mr_n83161056)
print v(xbgr.mr_n83161744)
print v(xbgr.mr_n83162432)
print v(xbgr.mr_n83163120)
print v(xbgr.mr_n83163808)
print v(xbgr.mr_n83164496)
print v(xbgr.mr_n83165824)
print v(xbgr.mr_n83166928)
print v(xbgr.mr_n83167872)
print v(xbgr.mr_n83168816)
print v(xbgr.mr_n83169760)
print v(xbgr.mr_n83170704)
print v(xbgr.mr_n83171648)
print v(xbgr.mr_n83172592)
print v(xbgr.mr_n83173536)
print v(xbgr.mr_n83174480)
print v(xbgr.mr_n83175424)
print v(xbgr.mr_n83176368)
print v(xbgr.mr_n83177312)
print v(xbgr.mr_n83178256)
print v(xbgr.mr_n83179200)
print v(xbgr.mr_n83180144)
print v(xbgr.mr_n83181088)
print v(xbgr.mr_n83182032)
print v(xbgr.mr_n83182976)
print v(xbgr.mr_n83183920)
print v(xbgr.mr_n83184864)
print v(xbgr.mr_n83185808)
print v(xbgr.mr_n83186752)
print v(xbgr.mr_n83187696)
print v(xbgr.mr_n83188640)
print v(xbgr.mr_n83189584)
print v(xbgr.mr_n83190528)
print v(xbgr.mr_n83194736)
print v(xbgr.mr_n83195328)
print v(xbgr.mr_n83195584)
print v(xbgr.mr_n83195840)
print v(xbgr.mr_n83196096)
print v(xbgr.mr_n83196352)
print v(xbgr.mr_n83196608)
print v(xbgr.mr_n83199408)
print v(xbgr.mr_n83199856)
print v(xbgr.mr_n83200048)
print v(xbgr.mr_n83200240)
print v(xbgr.mr_n83200432)
print v(xbgr.mr_n83200624)
print v(xbgr.mr_n83200816)
print v(xbgr.mr_n83201072)
print v(xbgr.mr_n83206080)
print v(xbgr.mr_n83217536)
print v(xbgr.mr_n83221760)
print v(xbgr.mr_n83239392)
print v(xbgr.mr_n83239792)
print v(xbgr.mr_n83239984)
print v(xbgr.mr_n83242400)
print v(xbgr.mr_n83242656)
print v(xbgr.mr_n83243040)
print v(xbgr.mr_n83244720)
print v(xbgr.mr_n83245312)
print v(xbgr.mr_n83246144)
print v(xbgr.mr_n83246944)
print v(xbgr.mr_n83248128)
print v(xbgr.mr_n83248240)
print v(xbgr.mr_n83249312)
print v(xbgr.mr_n83249696)
print v(xbgr.mr_n83249888)
print v(xbgr.mr_n83250080)
print v(xbgr.mr_n83542976)
print v(xbgr.mr_n83543232)
print v(xbgr.mr_n83613280)
print v(xbgr.mr_n83613472)
print v(xbgr.mr_n83648832)
print v(xbgr.mr_n83650224)
print v(xbgr.mr_n83677856)
print v(xbgr.mr_n83677968)
print v(xbgr.mr_n83693296)
print v(xbgr.mr_n83694064)
print v(xbgr.mr_n83721792)
print v(xbgr.mr_n83764528)
print v(xbgr.mr_n83764768)
print v(xbgr.mr_n83796144)
print v(xbgr.mr_n83797024)
print v(xbgr.mr_n83812192)
print v(xbgr.mr_n83812384)
print v(xbgr.mr_n83812576)
print v(xbgr.mr_n83812768)
print v(xbgr.mr_n83812960)
print v(xbgr.mr_n83839296)
print v(xbgr.mr_n83865152)
print v(xbgr.mr_n83865632)
print v(xbgr.mr_n83879456)
print v(xbgr.mr_n83927856)
print v(xbgr.mr_n83928224)
print v(xbgr.mr_n83928640)
print v(xbgr.mr_n83928752)
print v(xbgr.mr_n83929104)
print v(xbgr.mr_n83929216)
print v(xbgr.mr_n83965840)
print v(xbgr.mr_n84013104)
print v(xbgr.mr_n84025472)
print v(xbgr.mr_n84025664)
print v(xbgr.mr_n84025936)
print v(xbgr.mr_n84026128)
print v(xbgr.mr_n84026480)
print v(xbgr.mr_n84026832)
print v(xbgr.mr_n84055376)
print v(xbgr.mr_n84087920)
print v(xbgr.mr_n84088240)
print v(xbgr.mr_n84089536)
print v(xbgr.mr_n84114272)
print v(xbgr.mr_n84115440)
print v(xbgr.mr_n84131824)
print v(xbgr.mr_n84132336)
print v(xbgr.mr_n84132592)
print v(xbgr.mr_n84149456)
print v(xbgr.mr_n84167088)
print v(xbgr.mr_n84176368)
print v(xbgr.mr_n84176784)
print v(xbgr.mr_n84201472)
print v(xbgr.mr_n84207616)
print v(xbgr.mr_n84207968)
print v(xbgr.mr_n84251200)
print v(xbgr.mr_n84263008)
print v(xbgr.mr_n84266992)
print v(xbgr.mr_n84267184)
print v(xbgr.mr_n84284272)
print v(xbgr.mr_n84298736)
print v(xbgr.mr_n84299056)
print v(xbgr.mr_n84304288)
print v(xbgr.mr_n84304544)
print v(xbgr.mr_n84347904)
print v(xbgr.mr_n84348352)
print v(xbgr.mr_n84348992)
print v(xbgr.mr_n84349408)
print v(xbgr.n1)
print v(xbgr.n_10)
print v(xbgr.n_11)
print v(xbgr.n_12)
print v(xbgr.n_13)
print v(xbgr.n_14)
print v(xbgr.n_15)
print v(xbgr.n_16)
print v(xbgr.n_17)
print v(xbgr.n_18)
print v(xbgr.n_19)
print v(xbgr.n_2)
print v(xbgr.n_21)
print v(xbgr.n_22)
print v(xbgr.n_23)
print v(xbgr.n_24)
print v(xbgr.n_25)
print v(xbgr.n_26)
print v(xbgr.n_27)
print v(xbgr.n_3)
print v(xbgr.n_30)
print v(xbgr.n_31)
print v(xbgr.n_33)
print v(xbgr.n_34)
print v(xbgr.n_36)
print v(xbgr.n_37)
print v(xbgr.n_4)
print v(xbgr.n_5)
print v(xbgr.n_6)
print v(xbgr.n_7)
print v(xbgr.n_8)
print v(xbgr.n_9)
print v(pbias)
print v(pcasc)
print v(r4)
print v(xbgr.r4n)
print v(xbgr.vb2)
print v(vbe)
print v(xbgr.vbe3)
print v(xbgr.vd1)
print v(xbgr.vd2)
print v(vdd)
print v(vref)
print v(vdd)-v(vdd)
echo METALLIC_ALL_NODE_VOLTAGES_END
quit
.endc
.end
