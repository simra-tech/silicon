* G1_BGR standalone capacitance-PEX qualification
.lib /foss/pdks/ihp-sg13g2/libs.tech/ngspice/models/cornerHBT.lib hbt_typ
.lib /foss/pdks/ihp-sg13g2/libs.tech/ngspice/models/cornerMOShv.lib mos_tt
.lib /foss/pdks/ihp-sg13g2/libs.tech/ngspice/models/cornerRES.lib res_typ
.include conditional_metal.spice
.option seed=44001 gmin=1e-15 abstol=1e-14 reltol=1e-5 vntol=1e-7
.global sub!
Vsub sub! 0 0
Vdd vdd 0 3.3
Vr4 r4 0 0
Xbgr vdd 0 r4 vref iptat pbias pcasc vbe dvbe g1_bgr
Vload iptat 0 1
Cload vref 0 1e-12
.control
set num_threads=1
set numdgt=15
set wr_singlescale
set wr_vecnames
op
echo RAW_CURRENT_LEDGER_BEGIN
print @n.xbgr.xr1.nr1[ibody]
print @n.xbgr.xr2.nr1[ibody]
print @n.xbgr.xr3.nr1[ibody]
print @n.xbgr.xr4.nr1[ibody]
print @n.xbgr.xr5.nr1[ibody]
print @n.xbgr.xr6.nr1[ibody]
print @n.xbgr.xr7.nr1[ibody]
print @n.xbgr.xr8.nr1[ibody]
print @n.xbgr.xr9.nr1[ibody]
print @n.xbgr.xr10.nr1[ibody]
print @n.xbgr.xr11.nr1[ibody]
print @n.xbgr.xr12.nr1[ibody]
print @n.xbgr.xr13.nr1[ibody]
print @n.xbgr.xr14.nr1[ibody]
print @n.xbgr.xr15.nr1[ibody]
print @n.xbgr.xr16.nr1[ibody]
print @n.xbgr.xr17.nr1[ibody]
print @n.xbgr.xr18.nr1[ibody]
print @n.xbgr.xr19.nr1[ibody]
print @n.xbgr.xr20.nr1[ibody]
print @n.xbgr.xr21.nr1[ibody]
print @n.xbgr.xr22.nr1[ibody]
print @n.xbgr.xr23.nr1[ibody]
print @n.xbgr.xr24.nr1[ibody]
print @n.xbgr.xr25.nr1[ibody]
print @n.xbgr.xr26.nr1[ibody]
print @n.xbgr.xm27.nsg13_hv_pmos[ide]
print @n.xbgr.xm27.nsg13_hv_pmos[ige]
print @n.xbgr.xm27.nsg13_hv_pmos[ise]
print @n.xbgr.xm27.nsg13_hv_pmos[ibe]
print @n.xbgr.xm27.nsg13_hv_pmos[ctype]
print @n.xbgr.xm28.nsg13_hv_pmos[ide]
print @n.xbgr.xm28.nsg13_hv_pmos[ige]
print @n.xbgr.xm28.nsg13_hv_pmos[ise]
print @n.xbgr.xm28.nsg13_hv_pmos[ibe]
print @n.xbgr.xm28.nsg13_hv_pmos[ctype]
print @n.xbgr.xm29.nsg13_hv_nmos[ide]
print @n.xbgr.xm29.nsg13_hv_nmos[ige]
print @n.xbgr.xm29.nsg13_hv_nmos[ise]
print @n.xbgr.xm29.nsg13_hv_nmos[ibe]
print @n.xbgr.xm29.nsg13_hv_nmos[ctype]
print @n.xbgr.xm30.nsg13_hv_nmos[ide]
print @n.xbgr.xm30.nsg13_hv_nmos[ige]
print @n.xbgr.xm30.nsg13_hv_nmos[ise]
print @n.xbgr.xm30.nsg13_hv_nmos[ibe]
print @n.xbgr.xm30.nsg13_hv_nmos[ctype]
print @n.xbgr.xm31.nsg13_hv_nmos[ide]
print @n.xbgr.xm31.nsg13_hv_nmos[ige]
print @n.xbgr.xm31.nsg13_hv_nmos[ise]
print @n.xbgr.xm31.nsg13_hv_nmos[ibe]
print @n.xbgr.xm31.nsg13_hv_nmos[ctype]
print @n.xbgr.xm32.nsg13_hv_nmos[ide]
print @n.xbgr.xm32.nsg13_hv_nmos[ige]
print @n.xbgr.xm32.nsg13_hv_nmos[ise]
print @n.xbgr.xm32.nsg13_hv_nmos[ibe]
print @n.xbgr.xm32.nsg13_hv_nmos[ctype]
print @n.xbgr.xm33.nsg13_hv_nmos[ide]
print @n.xbgr.xm33.nsg13_hv_nmos[ige]
print @n.xbgr.xm33.nsg13_hv_nmos[ise]
print @n.xbgr.xm33.nsg13_hv_nmos[ibe]
print @n.xbgr.xm33.nsg13_hv_nmos[ctype]
print @n.xbgr.xm34.nsg13_hv_nmos[ide]
print @n.xbgr.xm34.nsg13_hv_nmos[ige]
print @n.xbgr.xm34.nsg13_hv_nmos[ise]
print @n.xbgr.xm34.nsg13_hv_nmos[ibe]
print @n.xbgr.xm34.nsg13_hv_nmos[ctype]
print @n.xbgr.xm35.nsg13_hv_nmos[ide]
print @n.xbgr.xm35.nsg13_hv_nmos[ige]
print @n.xbgr.xm35.nsg13_hv_nmos[ise]
print @n.xbgr.xm35.nsg13_hv_nmos[ibe]
print @n.xbgr.xm35.nsg13_hv_nmos[ctype]
print @n.xbgr.xm36.nsg13_hv_nmos[ide]
print @n.xbgr.xm36.nsg13_hv_nmos[ige]
print @n.xbgr.xm36.nsg13_hv_nmos[ise]
print @n.xbgr.xm36.nsg13_hv_nmos[ibe]
print @n.xbgr.xm36.nsg13_hv_nmos[ctype]
print @n.xbgr.xm37.nsg13_hv_nmos[ide]
print @n.xbgr.xm37.nsg13_hv_nmos[ige]
print @n.xbgr.xm37.nsg13_hv_nmos[ise]
print @n.xbgr.xm37.nsg13_hv_nmos[ibe]
print @n.xbgr.xm37.nsg13_hv_nmos[ctype]
print @n.xbgr.xm38.nsg13_hv_pmos[ide]
print @n.xbgr.xm38.nsg13_hv_pmos[ige]
print @n.xbgr.xm38.nsg13_hv_pmos[ise]
print @n.xbgr.xm38.nsg13_hv_pmos[ibe]
print @n.xbgr.xm38.nsg13_hv_pmos[ctype]
print @n.xbgr.xm39.nsg13_hv_pmos[ide]
print @n.xbgr.xm39.nsg13_hv_pmos[ige]
print @n.xbgr.xm39.nsg13_hv_pmos[ise]
print @n.xbgr.xm39.nsg13_hv_pmos[ibe]
print @n.xbgr.xm39.nsg13_hv_pmos[ctype]
print @n.xbgr.xm40.nsg13_hv_pmos[ide]
print @n.xbgr.xm40.nsg13_hv_pmos[ige]
print @n.xbgr.xm40.nsg13_hv_pmos[ise]
print @n.xbgr.xm40.nsg13_hv_pmos[ibe]
print @n.xbgr.xm40.nsg13_hv_pmos[ctype]
print @n.xbgr.xm41.nsg13_hv_pmos[ide]
print @n.xbgr.xm41.nsg13_hv_pmos[ige]
print @n.xbgr.xm41.nsg13_hv_pmos[ise]
print @n.xbgr.xm41.nsg13_hv_pmos[ibe]
print @n.xbgr.xm41.nsg13_hv_pmos[ctype]
print @n.xbgr.xm42.nsg13_hv_pmos[ide]
print @n.xbgr.xm42.nsg13_hv_pmos[ige]
print @n.xbgr.xm42.nsg13_hv_pmos[ise]
print @n.xbgr.xm42.nsg13_hv_pmos[ibe]
print @n.xbgr.xm42.nsg13_hv_pmos[ctype]
print @n.xbgr.xm43.nsg13_hv_pmos[ide]
print @n.xbgr.xm43.nsg13_hv_pmos[ige]
print @n.xbgr.xm43.nsg13_hv_pmos[ise]
print @n.xbgr.xm43.nsg13_hv_pmos[ibe]
print @n.xbgr.xm43.nsg13_hv_pmos[ctype]
print @n.xbgr.xm44.nsg13_hv_pmos[ide]
print @n.xbgr.xm44.nsg13_hv_pmos[ige]
print @n.xbgr.xm44.nsg13_hv_pmos[ise]
print @n.xbgr.xm44.nsg13_hv_pmos[ibe]
print @n.xbgr.xm44.nsg13_hv_pmos[ctype]
print @n.xbgr.xm45.nsg13_hv_pmos[ide]
print @n.xbgr.xm45.nsg13_hv_pmos[ige]
print @n.xbgr.xm45.nsg13_hv_pmos[ise]
print @n.xbgr.xm45.nsg13_hv_pmos[ibe]
print @n.xbgr.xm45.nsg13_hv_pmos[ctype]
print @n.xbgr.xm46.nsg13_hv_pmos[ide]
print @n.xbgr.xm46.nsg13_hv_pmos[ige]
print @n.xbgr.xm46.nsg13_hv_pmos[ise]
print @n.xbgr.xm46.nsg13_hv_pmos[ibe]
print @n.xbgr.xm46.nsg13_hv_pmos[ctype]
print @n.xbgr.xm47.nsg13_hv_pmos[ide]
print @n.xbgr.xm47.nsg13_hv_pmos[ige]
print @n.xbgr.xm47.nsg13_hv_pmos[ise]
print @n.xbgr.xm47.nsg13_hv_pmos[ibe]
print @n.xbgr.xm47.nsg13_hv_pmos[ctype]
print @n.xbgr.xm48.nsg13_hv_pmos[ide]
print @n.xbgr.xm48.nsg13_hv_pmos[ige]
print @n.xbgr.xm48.nsg13_hv_pmos[ise]
print @n.xbgr.xm48.nsg13_hv_pmos[ibe]
print @n.xbgr.xm48.nsg13_hv_pmos[ctype]
print @n.xbgr.xm49.nsg13_hv_pmos[ide]
print @n.xbgr.xm49.nsg13_hv_pmos[ige]
print @n.xbgr.xm49.nsg13_hv_pmos[ise]
print @n.xbgr.xm49.nsg13_hv_pmos[ibe]
print @n.xbgr.xm49.nsg13_hv_pmos[ctype]
print @n.xbgr.xm50.nsg13_hv_pmos[ide]
print @n.xbgr.xm50.nsg13_hv_pmos[ige]
print @n.xbgr.xm50.nsg13_hv_pmos[ise]
print @n.xbgr.xm50.nsg13_hv_pmos[ibe]
print @n.xbgr.xm50.nsg13_hv_pmos[ctype]
print @n.xbgr.xm51.nsg13_hv_pmos[ide]
print @n.xbgr.xm51.nsg13_hv_pmos[ige]
print @n.xbgr.xm51.nsg13_hv_pmos[ise]
print @n.xbgr.xm51.nsg13_hv_pmos[ibe]
print @n.xbgr.xm51.nsg13_hv_pmos[ctype]
print @n.xbgr.xm52.nsg13_hv_pmos[ide]
print @n.xbgr.xm52.nsg13_hv_pmos[ige]
print @n.xbgr.xm52.nsg13_hv_pmos[ise]
print @n.xbgr.xm52.nsg13_hv_pmos[ibe]
print @n.xbgr.xm52.nsg13_hv_pmos[ctype]
print @n.xbgr.xm53.nsg13_hv_pmos[ide]
print @n.xbgr.xm53.nsg13_hv_pmos[ige]
print @n.xbgr.xm53.nsg13_hv_pmos[ise]
print @n.xbgr.xm53.nsg13_hv_pmos[ibe]
print @n.xbgr.xm53.nsg13_hv_pmos[ctype]
print @n.xbgr.xm54.nsg13_hv_pmos[ide]
print @n.xbgr.xm54.nsg13_hv_pmos[ige]
print @n.xbgr.xm54.nsg13_hv_pmos[ise]
print @n.xbgr.xm54.nsg13_hv_pmos[ibe]
print @n.xbgr.xm54.nsg13_hv_pmos[ctype]
print @q.xbgr.xq55.qnpn13g2[ic]
print @q.xbgr.xq55.qnpn13g2[ib]
print @q.xbgr.xq55.qnpn13g2[ie]
print @q.xbgr.xq55.qnpn13g2[is]
print @r.xbgr.xq55.rsub[i]
print @c.xbgr.xq55.csub[i]
print @q.xbgr.xq56.qnpn13g2[ic]
print @q.xbgr.xq56.qnpn13g2[ib]
print @q.xbgr.xq56.qnpn13g2[ie]
print @q.xbgr.xq56.qnpn13g2[is]
print @r.xbgr.xq56.rsub[i]
print @c.xbgr.xq56.csub[i]
print @q.xbgr.xq57.qnpn13g2[ic]
print @q.xbgr.xq57.qnpn13g2[ib]
print @q.xbgr.xq57.qnpn13g2[ie]
print @q.xbgr.xq57.qnpn13g2[is]
print @r.xbgr.xq57.rsub[i]
print @c.xbgr.xq57.csub[i]
print @q.xbgr.xq58.qnpn13g2[ic]
print @q.xbgr.xq58.qnpn13g2[ib]
print @q.xbgr.xq58.qnpn13g2[ie]
print @q.xbgr.xq58.qnpn13g2[is]
print @r.xbgr.xq58.rsub[i]
print @c.xbgr.xq58.csub[i]
print @q.xbgr.xq59.qnpn13g2[ic]
print @q.xbgr.xq59.qnpn13g2[ib]
print @q.xbgr.xq59.qnpn13g2[ie]
print @q.xbgr.xq59.qnpn13g2[is]
print @r.xbgr.xq59.rsub[i]
print @c.xbgr.xq59.csub[i]
print @q.xbgr.xq60.qnpn13g2[ic]
print @q.xbgr.xq60.qnpn13g2[ib]
print @q.xbgr.xq60.qnpn13g2[ie]
print @q.xbgr.xq60.qnpn13g2[is]
print @r.xbgr.xq60.rsub[i]
print @c.xbgr.xq60.csub[i]
print @q.xbgr.xq61.qnpn13g2[ic]
print @q.xbgr.xq61.qnpn13g2[ib]
print @q.xbgr.xq61.qnpn13g2[ie]
print @q.xbgr.xq61.qnpn13g2[is]
print @r.xbgr.xq61.rsub[i]
print @c.xbgr.xq61.csub[i]
print @q.xbgr.xq62.qnpn13g2[ic]
print @q.xbgr.xq62.qnpn13g2[ib]
print @q.xbgr.xq62.qnpn13g2[ie]
print @q.xbgr.xq62.qnpn13g2[is]
print @r.xbgr.xq62.rsub[i]
print @c.xbgr.xq62.csub[i]
print @q.xbgr.xq63.qnpn13g2[ic]
print @q.xbgr.xq63.qnpn13g2[ib]
print @q.xbgr.xq63.qnpn13g2[ie]
print @q.xbgr.xq63.qnpn13g2[is]
print @r.xbgr.xq63.rsub[i]
print @c.xbgr.xq63.csub[i]
print @q.xbgr.xq64.qnpn13g2[ic]
print @q.xbgr.xq64.qnpn13g2[ib]
print @q.xbgr.xq64.qnpn13g2[ie]
print @q.xbgr.xq64.qnpn13g2[is]
print @r.xbgr.xq64.rsub[i]
print @c.xbgr.xq64.csub[i]
print @q.xbgr.xq65.qnpn13g2[ic]
print @q.xbgr.xq65.qnpn13g2[ib]
print @q.xbgr.xq65.qnpn13g2[ie]
print @q.xbgr.xq65.qnpn13g2[is]
print @r.xbgr.xq65.rsub[i]
print @c.xbgr.xq65.csub[i]
print @q.xbgr.xq66.qnpn13g2[ic]
print @q.xbgr.xq66.qnpn13g2[ib]
print @q.xbgr.xq66.qnpn13g2[ie]
print @q.xbgr.xq66.qnpn13g2[is]
print @r.xbgr.xq66.rsub[i]
print @c.xbgr.xq66.csub[i]
print @q.xbgr.xq67.qnpn13g2[ic]
print @q.xbgr.xq67.qnpn13g2[ib]
print @q.xbgr.xq67.qnpn13g2[ie]
print @q.xbgr.xq67.qnpn13g2[is]
print @r.xbgr.xq67.rsub[i]
print @c.xbgr.xq67.csub[i]
print @q.xbgr.xq68.qnpn13g2[ic]
print @q.xbgr.xq68.qnpn13g2[ib]
print @q.xbgr.xq68.qnpn13g2[ie]
print @q.xbgr.xq68.qnpn13g2[is]
print @r.xbgr.xq68.rsub[i]
print @c.xbgr.xq68.csub[i]
print @q.xbgr.xq69.qnpn13g2[ic]
print @q.xbgr.xq69.qnpn13g2[ib]
print @q.xbgr.xq69.qnpn13g2[ie]
print @q.xbgr.xq69.qnpn13g2[is]
print @r.xbgr.xq69.rsub[i]
print @c.xbgr.xq69.csub[i]
print @q.xbgr.xq70.qnpn13g2[ic]
print @q.xbgr.xq70.qnpn13g2[ib]
print @q.xbgr.xq70.qnpn13g2[ie]
print @q.xbgr.xq70.qnpn13g2[is]
print @r.xbgr.xq70.rsub[i]
print @c.xbgr.xq70.csub[i]
print @q.xbgr.xq71.qnpn13g2[ic]
print @q.xbgr.xq71.qnpn13g2[ib]
print @q.xbgr.xq71.qnpn13g2[ie]
print @q.xbgr.xq71.qnpn13g2[is]
print @r.xbgr.xq71.rsub[i]
print @c.xbgr.xq71.csub[i]
print @q.xbgr.xq72.qnpn13g2[ic]
print @q.xbgr.xq72.qnpn13g2[ib]
print @q.xbgr.xq72.qnpn13g2[ie]
print @q.xbgr.xq72.qnpn13g2[is]
print @r.xbgr.xq72.rsub[i]
print @c.xbgr.xq72.csub[i]
print @q.xbgr.xq73.qnpn13g2[ic]
print @q.xbgr.xq73.qnpn13g2[ib]
print @q.xbgr.xq73.qnpn13g2[ie]
print @q.xbgr.xq73.qnpn13g2[is]
print @r.xbgr.xq73.rsub[i]
print @c.xbgr.xq73.csub[i]
print @q.xbgr.xq74.qnpn13g2[ic]
print @q.xbgr.xq74.qnpn13g2[ib]
print @q.xbgr.xq74.qnpn13g2[ie]
print @q.xbgr.xq74.qnpn13g2[is]
print @r.xbgr.xq74.rsub[i]
print @c.xbgr.xq74.csub[i]
print @q.xbgr.xq75.qnpn13g2[ic]
print @q.xbgr.xq75.qnpn13g2[ib]
print @q.xbgr.xq75.qnpn13g2[ie]
print @q.xbgr.xq75.qnpn13g2[is]
print @r.xbgr.xq75.rsub[i]
print @c.xbgr.xq75.csub[i]
print @q.xbgr.xq76.qnpn13g2[ic]
print @q.xbgr.xq76.qnpn13g2[ib]
print @q.xbgr.xq76.qnpn13g2[ie]
print @q.xbgr.xq76.qnpn13g2[is]
print @r.xbgr.xq76.rsub[i]
print @c.xbgr.xq76.csub[i]
print @n.xbgr.xr77.nr1[ibody]
print @n.xbgr.xr78.nr1[ibody]
print @n.xbgr.xr79.nr1[ibody]
print @n.xbgr.xr80.nr1[ibody]
print @n.xbgr.xr81.nr1[ibody]
print @n.xbgr.xr82.nr1[ibody]
print @n.xbgr.xr83.nr1[ibody]
print @n.xbgr.xr84.nr1[ibody]
print @n.xbgr.xr85.nr1[ibody]
print @n.xbgr.xr86.nr1[ibody]
print @n.xbgr.xr16_u2.nr1[ibody]
print @n.xbgr.xr16_u3.nr1[ibody]
print @n.xbgr.xr16_u4.nr1[ibody]
print @n.xbgr.xr16_u5.nr1[ibody]
print @n.xbgr.xr16_u6.nr1[ibody]
print @n.xbgr.xr16_u7.nr1[ibody]
print @n.xbgr.xr16_u8.nr1[ibody]
print @n.xbgr.xr16_u9.nr1[ibody]
print @n.xbgr.xr16_u10.nr1[ibody]
print @n.xbgr.xr16_u11.nr1[ibody]
print @n.xbgr.xr16_u12.nr1[ibody]
print @n.xbgr.xr16_u13.nr1[ibody]
print @n.xbgr.xr16_u14.nr1[ibody]
print @n.xbgr.xr16_u15.nr1[ibody]
print @n.xbgr.xr16_u16.nr1[ibody]
print @n.xbgr.xr16_u17.nr1[ibody]
print @n.xbgr.xr16_u18.nr1[ibody]
print @n.xbgr.xr16_u19.nr1[ibody]
print @n.xbgr.xr16_u20.nr1[ibody]
print @n.xbgr.xr16_u21.nr1[ibody]
print @n.xbgr.xr16_u22.nr1[ibody]
print @n.xbgr.xr16_u23.nr1[ibody]
print @n.xbgr.xr16_u24.nr1[ibody]
print @n.xbgr.xr17_u2.nr1[ibody]
print @n.xbgr.xr17_u3.nr1[ibody]
print @n.xbgr.xr17_u4.nr1[ibody]
print @n.xbgr.xr18_u2.nr1[ibody]
print @n.xbgr.xr18_u3.nr1[ibody]
print @n.xbgr.xr18_u4.nr1[ibody]
print @n.xbgr.xr19_u2.nr1[ibody]
print @n.xbgr.xr19_u3.nr1[ibody]
print @n.xbgr.xr19_u4.nr1[ibody]
print @n.xbgr.xr20_u2.nr1[ibody]
print @n.xbgr.xr20_u3.nr1[ibody]
print @n.xbgr.xr20_u4.nr1[ibody]
print @n.xbgr.xr21_u2.nr1[ibody]
print @n.xbgr.xr21_u3.nr1[ibody]
print @n.xbgr.xr21_u4.nr1[ibody]
print @n.xbgr.xr22_u2.nr1[ibody]
print @n.xbgr.xr22_u3.nr1[ibody]
print @n.xbgr.xr22_u4.nr1[ibody]
print @n.xbgr.xr23_u2.nr1[ibody]
print @n.xbgr.xr23_u3.nr1[ibody]
print @n.xbgr.xr23_u4.nr1[ibody]
print @n.xbgr.xr23_u5.nr1[ibody]
print @n.xbgr.xr23_u6.nr1[ibody]
print @n.xbgr.xr23_u7.nr1[ibody]
print @n.xbgr.xr23_u8.nr1[ibody]
print @n.xbgr.xr23_u9.nr1[ibody]
print @n.xbgr.xr23_u10.nr1[ibody]
print @n.xbgr.xr23_u11.nr1[ibody]
print @n.xbgr.xr23_u12.nr1[ibody]
print @n.xbgr.xr23_u13.nr1[ibody]
print @n.xbgr.xr23_u14.nr1[ibody]
print @n.xbgr.xr23_u15.nr1[ibody]
print @n.xbgr.xr23_u16.nr1[ibody]
print @n.xbgr.xr23_u17.nr1[ibody]
print @n.xbgr.xr23_u18.nr1[ibody]
print @n.xbgr.xr23_u19.nr1[ibody]
print @n.xbgr.xr23_u20.nr1[ibody]
print @n.xbgr.xr23_u21.nr1[ibody]
print @n.xbgr.xr23_u22.nr1[ibody]
print @n.xbgr.xr23_u23.nr1[ibody]
print @n.xbgr.xr23_u24.nr1[ibody]
print @n.xbgr.xr24_u2.nr1[ibody]
print @n.xbgr.xr24_u3.nr1[ibody]
print @n.xbgr.xr24_u4.nr1[ibody]
print @n.xbgr.xr24_u5.nr1[ibody]
print @n.xbgr.xr24_u6.nr1[ibody]
print @n.xbgr.xr24_u7.nr1[ibody]
print @n.xbgr.xr24_u8.nr1[ibody]
print @n.xbgr.xr24_u9.nr1[ibody]
print @n.xbgr.xr24_u10.nr1[ibody]
print @n.xbgr.xr24_u11.nr1[ibody]
print @n.xbgr.xr24_u12.nr1[ibody]
print @n.xbgr.xr24_u13.nr1[ibody]
print @n.xbgr.xr24_u14.nr1[ibody]
print @n.xbgr.xr24_u15.nr1[ibody]
print @n.xbgr.xr24_u16.nr1[ibody]
print @n.xbgr.xr24_u17.nr1[ibody]
print @n.xbgr.xr24_u18.nr1[ibody]
print @n.xbgr.xr24_u19.nr1[ibody]
print @n.xbgr.xr24_u20.nr1[ibody]
print @n.xbgr.xr24_u21.nr1[ibody]
print @n.xbgr.xr24_u22.nr1[ibody]
print @n.xbgr.xr24_u23.nr1[ibody]
print @n.xbgr.xr24_u24.nr1[ibody]
print @n.xbgr.xr25_u2.nr1[ibody]
print @n.xbgr.xr25_u3.nr1[ibody]
print @n.xbgr.xr25_u4.nr1[ibody]
print @n.xbgr.xr25_u5.nr1[ibody]
print @n.xbgr.xr25_u6.nr1[ibody]
print @n.xbgr.xr25_u7.nr1[ibody]
print @n.xbgr.xr25_u8.nr1[ibody]
print @n.xbgr.xr25_u9.nr1[ibody]
print @n.xbgr.xr25_u10.nr1[ibody]
print @n.xbgr.xr25_u11.nr1[ibody]
print @n.xbgr.xr25_u12.nr1[ibody]
print @n.xbgr.xr25_u13.nr1[ibody]
print @n.xbgr.xr25_u14.nr1[ibody]
print @n.xbgr.xr25_u15.nr1[ibody]
print @n.xbgr.xr25_u16.nr1[ibody]
print @n.xbgr.xr25_u17.nr1[ibody]
print @n.xbgr.xr25_u18.nr1[ibody]
print @n.xbgr.xr25_u19.nr1[ibody]
print @n.xbgr.xr25_u20.nr1[ibody]
print @n.xbgr.xr25_u21.nr1[ibody]
print @n.xbgr.xr25_u22.nr1[ibody]
print @n.xbgr.xr25_u23.nr1[ibody]
print @n.xbgr.xr25_u24.nr1[ibody]
print @n.xbgr.xr26_u2.nr1[ibody]
print @n.xbgr.xr26_u3.nr1[ibody]
print @n.xbgr.xr26_u4.nr1[ibody]
print @n.xbgr.xr26_u5.nr1[ibody]
print @n.xbgr.xr26_u6.nr1[ibody]
print @n.xbgr.xr26_u7.nr1[ibody]
print @n.xbgr.xr26_u8.nr1[ibody]
print @n.xbgr.xr26_u9.nr1[ibody]
print @n.xbgr.xr26_u10.nr1[ibody]
print @n.xbgr.xr26_u11.nr1[ibody]
print @n.xbgr.xr26_u12.nr1[ibody]
print @n.xbgr.xr26_u13.nr1[ibody]
print @n.xbgr.xr26_u14.nr1[ibody]
print @n.xbgr.xr26_u15.nr1[ibody]
print @n.xbgr.xr26_u16.nr1[ibody]
print @n.xbgr.xr26_u17.nr1[ibody]
print @n.xbgr.xr26_u18.nr1[ibody]
print @n.xbgr.xr26_u19.nr1[ibody]
print @n.xbgr.xr26_u20.nr1[ibody]
print @n.xbgr.xr26_u21.nr1[ibody]
print @n.xbgr.xr26_u22.nr1[ibody]
print @n.xbgr.xr26_u23.nr1[ibody]
print @n.xbgr.xr26_u24.nr1[ibody]
print @n.xbgr.xm34_u2.nsg13_hv_nmos[ide]
print @n.xbgr.xm34_u2.nsg13_hv_nmos[ige]
print @n.xbgr.xm34_u2.nsg13_hv_nmos[ise]
print @n.xbgr.xm34_u2.nsg13_hv_nmos[ibe]
print @n.xbgr.xm34_u2.nsg13_hv_nmos[ctype]
print @n.xbgr.xm34_u3.nsg13_hv_nmos[ide]
print @n.xbgr.xm34_u3.nsg13_hv_nmos[ige]
print @n.xbgr.xm34_u3.nsg13_hv_nmos[ise]
print @n.xbgr.xm34_u3.nsg13_hv_nmos[ibe]
print @n.xbgr.xm34_u3.nsg13_hv_nmos[ctype]
print @n.xbgr.xm34_u4.nsg13_hv_nmos[ide]
print @n.xbgr.xm34_u4.nsg13_hv_nmos[ige]
print @n.xbgr.xm34_u4.nsg13_hv_nmos[ise]
print @n.xbgr.xm34_u4.nsg13_hv_nmos[ibe]
print @n.xbgr.xm34_u4.nsg13_hv_nmos[ctype]
print @n.xbgr.xm34_u5.nsg13_hv_nmos[ide]
print @n.xbgr.xm34_u5.nsg13_hv_nmos[ige]
print @n.xbgr.xm34_u5.nsg13_hv_nmos[ise]
print @n.xbgr.xm34_u5.nsg13_hv_nmos[ibe]
print @n.xbgr.xm34_u5.nsg13_hv_nmos[ctype]
print @n.xbgr.xm34_u6.nsg13_hv_nmos[ide]
print @n.xbgr.xm34_u6.nsg13_hv_nmos[ige]
print @n.xbgr.xm34_u6.nsg13_hv_nmos[ise]
print @n.xbgr.xm34_u6.nsg13_hv_nmos[ibe]
print @n.xbgr.xm34_u6.nsg13_hv_nmos[ctype]
print @n.xbgr.xm34_u7.nsg13_hv_nmos[ide]
print @n.xbgr.xm34_u7.nsg13_hv_nmos[ige]
print @n.xbgr.xm34_u7.nsg13_hv_nmos[ise]
print @n.xbgr.xm34_u7.nsg13_hv_nmos[ibe]
print @n.xbgr.xm34_u7.nsg13_hv_nmos[ctype]
print @n.xbgr.xm34_u8.nsg13_hv_nmos[ide]
print @n.xbgr.xm34_u8.nsg13_hv_nmos[ige]
print @n.xbgr.xm34_u8.nsg13_hv_nmos[ise]
print @n.xbgr.xm34_u8.nsg13_hv_nmos[ibe]
print @n.xbgr.xm34_u8.nsg13_hv_nmos[ctype]
print @n.xbgr.xm34_u9.nsg13_hv_nmos[ide]
print @n.xbgr.xm34_u9.nsg13_hv_nmos[ige]
print @n.xbgr.xm34_u9.nsg13_hv_nmos[ise]
print @n.xbgr.xm34_u9.nsg13_hv_nmos[ibe]
print @n.xbgr.xm34_u9.nsg13_hv_nmos[ctype]
print @n.xbgr.xm34_u10.nsg13_hv_nmos[ide]
print @n.xbgr.xm34_u10.nsg13_hv_nmos[ige]
print @n.xbgr.xm34_u10.nsg13_hv_nmos[ise]
print @n.xbgr.xm34_u10.nsg13_hv_nmos[ibe]
print @n.xbgr.xm34_u10.nsg13_hv_nmos[ctype]
print @n.xbgr.xm34_u11.nsg13_hv_nmos[ide]
print @n.xbgr.xm34_u11.nsg13_hv_nmos[ige]
print @n.xbgr.xm34_u11.nsg13_hv_nmos[ise]
print @n.xbgr.xm34_u11.nsg13_hv_nmos[ibe]
print @n.xbgr.xm34_u11.nsg13_hv_nmos[ctype]
print @n.xbgr.xm34_u12.nsg13_hv_nmos[ide]
print @n.xbgr.xm34_u12.nsg13_hv_nmos[ige]
print @n.xbgr.xm34_u12.nsg13_hv_nmos[ise]
print @n.xbgr.xm34_u12.nsg13_hv_nmos[ibe]
print @n.xbgr.xm34_u12.nsg13_hv_nmos[ctype]
print @n.xbgr.xm34_u13.nsg13_hv_nmos[ide]
print @n.xbgr.xm34_u13.nsg13_hv_nmos[ige]
print @n.xbgr.xm34_u13.nsg13_hv_nmos[ise]
print @n.xbgr.xm34_u13.nsg13_hv_nmos[ibe]
print @n.xbgr.xm34_u13.nsg13_hv_nmos[ctype]
print @n.xbgr.xm34_u14.nsg13_hv_nmos[ide]
print @n.xbgr.xm34_u14.nsg13_hv_nmos[ige]
print @n.xbgr.xm34_u14.nsg13_hv_nmos[ise]
print @n.xbgr.xm34_u14.nsg13_hv_nmos[ibe]
print @n.xbgr.xm34_u14.nsg13_hv_nmos[ctype]
print @n.xbgr.xm34_u15.nsg13_hv_nmos[ide]
print @n.xbgr.xm34_u15.nsg13_hv_nmos[ige]
print @n.xbgr.xm34_u15.nsg13_hv_nmos[ise]
print @n.xbgr.xm34_u15.nsg13_hv_nmos[ibe]
print @n.xbgr.xm34_u15.nsg13_hv_nmos[ctype]
print @n.xbgr.xm34_u16.nsg13_hv_nmos[ide]
print @n.xbgr.xm34_u16.nsg13_hv_nmos[ige]
print @n.xbgr.xm34_u16.nsg13_hv_nmos[ise]
print @n.xbgr.xm34_u16.nsg13_hv_nmos[ibe]
print @n.xbgr.xm34_u16.nsg13_hv_nmos[ctype]
print @n.xbgr.xm34_u17.nsg13_hv_nmos[ide]
print @n.xbgr.xm34_u17.nsg13_hv_nmos[ige]
print @n.xbgr.xm34_u17.nsg13_hv_nmos[ise]
print @n.xbgr.xm34_u17.nsg13_hv_nmos[ibe]
print @n.xbgr.xm34_u17.nsg13_hv_nmos[ctype]
print @n.xbgr.xm34_u18.nsg13_hv_nmos[ide]
print @n.xbgr.xm34_u18.nsg13_hv_nmos[ige]
print @n.xbgr.xm34_u18.nsg13_hv_nmos[ise]
print @n.xbgr.xm34_u18.nsg13_hv_nmos[ibe]
print @n.xbgr.xm34_u18.nsg13_hv_nmos[ctype]
print @n.xbgr.xm34_u19.nsg13_hv_nmos[ide]
print @n.xbgr.xm34_u19.nsg13_hv_nmos[ige]
print @n.xbgr.xm34_u19.nsg13_hv_nmos[ise]
print @n.xbgr.xm34_u19.nsg13_hv_nmos[ibe]
print @n.xbgr.xm34_u19.nsg13_hv_nmos[ctype]
print @n.xbgr.xm34_u20.nsg13_hv_nmos[ide]
print @n.xbgr.xm34_u20.nsg13_hv_nmos[ige]
print @n.xbgr.xm34_u20.nsg13_hv_nmos[ise]
print @n.xbgr.xm34_u20.nsg13_hv_nmos[ibe]
print @n.xbgr.xm34_u20.nsg13_hv_nmos[ctype]
print @n.xbgr.xm34_u21.nsg13_hv_nmos[ide]
print @n.xbgr.xm34_u21.nsg13_hv_nmos[ige]
print @n.xbgr.xm34_u21.nsg13_hv_nmos[ise]
print @n.xbgr.xm34_u21.nsg13_hv_nmos[ibe]
print @n.xbgr.xm34_u21.nsg13_hv_nmos[ctype]
print @n.xbgr.xm34_u22.nsg13_hv_nmos[ide]
print @n.xbgr.xm34_u22.nsg13_hv_nmos[ige]
print @n.xbgr.xm34_u22.nsg13_hv_nmos[ise]
print @n.xbgr.xm34_u22.nsg13_hv_nmos[ibe]
print @n.xbgr.xm34_u22.nsg13_hv_nmos[ctype]
print @n.xbgr.xm34_u23.nsg13_hv_nmos[ide]
print @n.xbgr.xm34_u23.nsg13_hv_nmos[ige]
print @n.xbgr.xm34_u23.nsg13_hv_nmos[ise]
print @n.xbgr.xm34_u23.nsg13_hv_nmos[ibe]
print @n.xbgr.xm34_u23.nsg13_hv_nmos[ctype]
print @n.xbgr.xm34_u24.nsg13_hv_nmos[ide]
print @n.xbgr.xm34_u24.nsg13_hv_nmos[ige]
print @n.xbgr.xm34_u24.nsg13_hv_nmos[ise]
print @n.xbgr.xm34_u24.nsg13_hv_nmos[ibe]
print @n.xbgr.xm34_u24.nsg13_hv_nmos[ctype]
print @n.xbgr.xm35_u2.nsg13_hv_nmos[ide]
print @n.xbgr.xm35_u2.nsg13_hv_nmos[ige]
print @n.xbgr.xm35_u2.nsg13_hv_nmos[ise]
print @n.xbgr.xm35_u2.nsg13_hv_nmos[ibe]
print @n.xbgr.xm35_u2.nsg13_hv_nmos[ctype]
print @n.xbgr.xm35_u3.nsg13_hv_nmos[ide]
print @n.xbgr.xm35_u3.nsg13_hv_nmos[ige]
print @n.xbgr.xm35_u3.nsg13_hv_nmos[ise]
print @n.xbgr.xm35_u3.nsg13_hv_nmos[ibe]
print @n.xbgr.xm35_u3.nsg13_hv_nmos[ctype]
print @n.xbgr.xm35_u4.nsg13_hv_nmos[ide]
print @n.xbgr.xm35_u4.nsg13_hv_nmos[ige]
print @n.xbgr.xm35_u4.nsg13_hv_nmos[ise]
print @n.xbgr.xm35_u4.nsg13_hv_nmos[ibe]
print @n.xbgr.xm35_u4.nsg13_hv_nmos[ctype]
print @n.xbgr.xm35_u5.nsg13_hv_nmos[ide]
print @n.xbgr.xm35_u5.nsg13_hv_nmos[ige]
print @n.xbgr.xm35_u5.nsg13_hv_nmos[ise]
print @n.xbgr.xm35_u5.nsg13_hv_nmos[ibe]
print @n.xbgr.xm35_u5.nsg13_hv_nmos[ctype]
print @n.xbgr.xm35_u6.nsg13_hv_nmos[ide]
print @n.xbgr.xm35_u6.nsg13_hv_nmos[ige]
print @n.xbgr.xm35_u6.nsg13_hv_nmos[ise]
print @n.xbgr.xm35_u6.nsg13_hv_nmos[ibe]
print @n.xbgr.xm35_u6.nsg13_hv_nmos[ctype]
print @n.xbgr.xm35_u7.nsg13_hv_nmos[ide]
print @n.xbgr.xm35_u7.nsg13_hv_nmos[ige]
print @n.xbgr.xm35_u7.nsg13_hv_nmos[ise]
print @n.xbgr.xm35_u7.nsg13_hv_nmos[ibe]
print @n.xbgr.xm35_u7.nsg13_hv_nmos[ctype]
print @n.xbgr.xm35_u8.nsg13_hv_nmos[ide]
print @n.xbgr.xm35_u8.nsg13_hv_nmos[ige]
print @n.xbgr.xm35_u8.nsg13_hv_nmos[ise]
print @n.xbgr.xm35_u8.nsg13_hv_nmos[ibe]
print @n.xbgr.xm35_u8.nsg13_hv_nmos[ctype]
print @n.xbgr.xm35_u9.nsg13_hv_nmos[ide]
print @n.xbgr.xm35_u9.nsg13_hv_nmos[ige]
print @n.xbgr.xm35_u9.nsg13_hv_nmos[ise]
print @n.xbgr.xm35_u9.nsg13_hv_nmos[ibe]
print @n.xbgr.xm35_u9.nsg13_hv_nmos[ctype]
print @n.xbgr.xm35_u10.nsg13_hv_nmos[ide]
print @n.xbgr.xm35_u10.nsg13_hv_nmos[ige]
print @n.xbgr.xm35_u10.nsg13_hv_nmos[ise]
print @n.xbgr.xm35_u10.nsg13_hv_nmos[ibe]
print @n.xbgr.xm35_u10.nsg13_hv_nmos[ctype]
print @n.xbgr.xm35_u11.nsg13_hv_nmos[ide]
print @n.xbgr.xm35_u11.nsg13_hv_nmos[ige]
print @n.xbgr.xm35_u11.nsg13_hv_nmos[ise]
print @n.xbgr.xm35_u11.nsg13_hv_nmos[ibe]
print @n.xbgr.xm35_u11.nsg13_hv_nmos[ctype]
print @n.xbgr.xm35_u12.nsg13_hv_nmos[ide]
print @n.xbgr.xm35_u12.nsg13_hv_nmos[ige]
print @n.xbgr.xm35_u12.nsg13_hv_nmos[ise]
print @n.xbgr.xm35_u12.nsg13_hv_nmos[ibe]
print @n.xbgr.xm35_u12.nsg13_hv_nmos[ctype]
print @n.xbgr.xm35_u13.nsg13_hv_nmos[ide]
print @n.xbgr.xm35_u13.nsg13_hv_nmos[ige]
print @n.xbgr.xm35_u13.nsg13_hv_nmos[ise]
print @n.xbgr.xm35_u13.nsg13_hv_nmos[ibe]
print @n.xbgr.xm35_u13.nsg13_hv_nmos[ctype]
print @n.xbgr.xm35_u14.nsg13_hv_nmos[ide]
print @n.xbgr.xm35_u14.nsg13_hv_nmos[ige]
print @n.xbgr.xm35_u14.nsg13_hv_nmos[ise]
print @n.xbgr.xm35_u14.nsg13_hv_nmos[ibe]
print @n.xbgr.xm35_u14.nsg13_hv_nmos[ctype]
print @n.xbgr.xm35_u15.nsg13_hv_nmos[ide]
print @n.xbgr.xm35_u15.nsg13_hv_nmos[ige]
print @n.xbgr.xm35_u15.nsg13_hv_nmos[ise]
print @n.xbgr.xm35_u15.nsg13_hv_nmos[ibe]
print @n.xbgr.xm35_u15.nsg13_hv_nmos[ctype]
print @n.xbgr.xm35_u16.nsg13_hv_nmos[ide]
print @n.xbgr.xm35_u16.nsg13_hv_nmos[ige]
print @n.xbgr.xm35_u16.nsg13_hv_nmos[ise]
print @n.xbgr.xm35_u16.nsg13_hv_nmos[ibe]
print @n.xbgr.xm35_u16.nsg13_hv_nmos[ctype]
print @n.xbgr.xm35_u17.nsg13_hv_nmos[ide]
print @n.xbgr.xm35_u17.nsg13_hv_nmos[ige]
print @n.xbgr.xm35_u17.nsg13_hv_nmos[ise]
print @n.xbgr.xm35_u17.nsg13_hv_nmos[ibe]
print @n.xbgr.xm35_u17.nsg13_hv_nmos[ctype]
print @n.xbgr.xm35_u18.nsg13_hv_nmos[ide]
print @n.xbgr.xm35_u18.nsg13_hv_nmos[ige]
print @n.xbgr.xm35_u18.nsg13_hv_nmos[ise]
print @n.xbgr.xm35_u18.nsg13_hv_nmos[ibe]
print @n.xbgr.xm35_u18.nsg13_hv_nmos[ctype]
print @n.xbgr.xm35_u19.nsg13_hv_nmos[ide]
print @n.xbgr.xm35_u19.nsg13_hv_nmos[ige]
print @n.xbgr.xm35_u19.nsg13_hv_nmos[ise]
print @n.xbgr.xm35_u19.nsg13_hv_nmos[ibe]
print @n.xbgr.xm35_u19.nsg13_hv_nmos[ctype]
print @n.xbgr.xm35_u20.nsg13_hv_nmos[ide]
print @n.xbgr.xm35_u20.nsg13_hv_nmos[ige]
print @n.xbgr.xm35_u20.nsg13_hv_nmos[ise]
print @n.xbgr.xm35_u20.nsg13_hv_nmos[ibe]
print @n.xbgr.xm35_u20.nsg13_hv_nmos[ctype]
print @n.xbgr.xm35_u21.nsg13_hv_nmos[ide]
print @n.xbgr.xm35_u21.nsg13_hv_nmos[ige]
print @n.xbgr.xm35_u21.nsg13_hv_nmos[ise]
print @n.xbgr.xm35_u21.nsg13_hv_nmos[ibe]
print @n.xbgr.xm35_u21.nsg13_hv_nmos[ctype]
print @n.xbgr.xm35_u22.nsg13_hv_nmos[ide]
print @n.xbgr.xm35_u22.nsg13_hv_nmos[ige]
print @n.xbgr.xm35_u22.nsg13_hv_nmos[ise]
print @n.xbgr.xm35_u22.nsg13_hv_nmos[ibe]
print @n.xbgr.xm35_u22.nsg13_hv_nmos[ctype]
print @n.xbgr.xm35_u23.nsg13_hv_nmos[ide]
print @n.xbgr.xm35_u23.nsg13_hv_nmos[ige]
print @n.xbgr.xm35_u23.nsg13_hv_nmos[ise]
print @n.xbgr.xm35_u23.nsg13_hv_nmos[ibe]
print @n.xbgr.xm35_u23.nsg13_hv_nmos[ctype]
print @n.xbgr.xm35_u24.nsg13_hv_nmos[ide]
print @n.xbgr.xm35_u24.nsg13_hv_nmos[ige]
print @n.xbgr.xm35_u24.nsg13_hv_nmos[ise]
print @n.xbgr.xm35_u24.nsg13_hv_nmos[ibe]
print @n.xbgr.xm35_u24.nsg13_hv_nmos[ctype]
print @n.xbgr.xm36_u2.nsg13_hv_nmos[ide]
print @n.xbgr.xm36_u2.nsg13_hv_nmos[ige]
print @n.xbgr.xm36_u2.nsg13_hv_nmos[ise]
print @n.xbgr.xm36_u2.nsg13_hv_nmos[ibe]
print @n.xbgr.xm36_u2.nsg13_hv_nmos[ctype]
print @n.xbgr.xm36_u3.nsg13_hv_nmos[ide]
print @n.xbgr.xm36_u3.nsg13_hv_nmos[ige]
print @n.xbgr.xm36_u3.nsg13_hv_nmos[ise]
print @n.xbgr.xm36_u3.nsg13_hv_nmos[ibe]
print @n.xbgr.xm36_u3.nsg13_hv_nmos[ctype]
print @n.xbgr.xm36_u4.nsg13_hv_nmos[ide]
print @n.xbgr.xm36_u4.nsg13_hv_nmos[ige]
print @n.xbgr.xm36_u4.nsg13_hv_nmos[ise]
print @n.xbgr.xm36_u4.nsg13_hv_nmos[ibe]
print @n.xbgr.xm36_u4.nsg13_hv_nmos[ctype]
print @n.xbgr.xm36_u5.nsg13_hv_nmos[ide]
print @n.xbgr.xm36_u5.nsg13_hv_nmos[ige]
print @n.xbgr.xm36_u5.nsg13_hv_nmos[ise]
print @n.xbgr.xm36_u5.nsg13_hv_nmos[ibe]
print @n.xbgr.xm36_u5.nsg13_hv_nmos[ctype]
print @n.xbgr.xm36_u6.nsg13_hv_nmos[ide]
print @n.xbgr.xm36_u6.nsg13_hv_nmos[ige]
print @n.xbgr.xm36_u6.nsg13_hv_nmos[ise]
print @n.xbgr.xm36_u6.nsg13_hv_nmos[ibe]
print @n.xbgr.xm36_u6.nsg13_hv_nmos[ctype]
print @n.xbgr.xm36_u7.nsg13_hv_nmos[ide]
print @n.xbgr.xm36_u7.nsg13_hv_nmos[ige]
print @n.xbgr.xm36_u7.nsg13_hv_nmos[ise]
print @n.xbgr.xm36_u7.nsg13_hv_nmos[ibe]
print @n.xbgr.xm36_u7.nsg13_hv_nmos[ctype]
print @n.xbgr.xm36_u8.nsg13_hv_nmos[ide]
print @n.xbgr.xm36_u8.nsg13_hv_nmos[ige]
print @n.xbgr.xm36_u8.nsg13_hv_nmos[ise]
print @n.xbgr.xm36_u8.nsg13_hv_nmos[ibe]
print @n.xbgr.xm36_u8.nsg13_hv_nmos[ctype]
print @n.xbgr.xm36_u9.nsg13_hv_nmos[ide]
print @n.xbgr.xm36_u9.nsg13_hv_nmos[ige]
print @n.xbgr.xm36_u9.nsg13_hv_nmos[ise]
print @n.xbgr.xm36_u9.nsg13_hv_nmos[ibe]
print @n.xbgr.xm36_u9.nsg13_hv_nmos[ctype]
print @n.xbgr.xm36_u10.nsg13_hv_nmos[ide]
print @n.xbgr.xm36_u10.nsg13_hv_nmos[ige]
print @n.xbgr.xm36_u10.nsg13_hv_nmos[ise]
print @n.xbgr.xm36_u10.nsg13_hv_nmos[ibe]
print @n.xbgr.xm36_u10.nsg13_hv_nmos[ctype]
print @n.xbgr.xm36_u11.nsg13_hv_nmos[ide]
print @n.xbgr.xm36_u11.nsg13_hv_nmos[ige]
print @n.xbgr.xm36_u11.nsg13_hv_nmos[ise]
print @n.xbgr.xm36_u11.nsg13_hv_nmos[ibe]
print @n.xbgr.xm36_u11.nsg13_hv_nmos[ctype]
print @n.xbgr.xm36_u12.nsg13_hv_nmos[ide]
print @n.xbgr.xm36_u12.nsg13_hv_nmos[ige]
print @n.xbgr.xm36_u12.nsg13_hv_nmos[ise]
print @n.xbgr.xm36_u12.nsg13_hv_nmos[ibe]
print @n.xbgr.xm36_u12.nsg13_hv_nmos[ctype]
print @n.xbgr.xm36_u13.nsg13_hv_nmos[ide]
print @n.xbgr.xm36_u13.nsg13_hv_nmos[ige]
print @n.xbgr.xm36_u13.nsg13_hv_nmos[ise]
print @n.xbgr.xm36_u13.nsg13_hv_nmos[ibe]
print @n.xbgr.xm36_u13.nsg13_hv_nmos[ctype]
print @n.xbgr.xm36_u14.nsg13_hv_nmos[ide]
print @n.xbgr.xm36_u14.nsg13_hv_nmos[ige]
print @n.xbgr.xm36_u14.nsg13_hv_nmos[ise]
print @n.xbgr.xm36_u14.nsg13_hv_nmos[ibe]
print @n.xbgr.xm36_u14.nsg13_hv_nmos[ctype]
print @n.xbgr.xm36_u15.nsg13_hv_nmos[ide]
print @n.xbgr.xm36_u15.nsg13_hv_nmos[ige]
print @n.xbgr.xm36_u15.nsg13_hv_nmos[ise]
print @n.xbgr.xm36_u15.nsg13_hv_nmos[ibe]
print @n.xbgr.xm36_u15.nsg13_hv_nmos[ctype]
print @n.xbgr.xm36_u16.nsg13_hv_nmos[ide]
print @n.xbgr.xm36_u16.nsg13_hv_nmos[ige]
print @n.xbgr.xm36_u16.nsg13_hv_nmos[ise]
print @n.xbgr.xm36_u16.nsg13_hv_nmos[ibe]
print @n.xbgr.xm36_u16.nsg13_hv_nmos[ctype]
print @n.xbgr.xm36_u17.nsg13_hv_nmos[ide]
print @n.xbgr.xm36_u17.nsg13_hv_nmos[ige]
print @n.xbgr.xm36_u17.nsg13_hv_nmos[ise]
print @n.xbgr.xm36_u17.nsg13_hv_nmos[ibe]
print @n.xbgr.xm36_u17.nsg13_hv_nmos[ctype]
print @n.xbgr.xm36_u18.nsg13_hv_nmos[ide]
print @n.xbgr.xm36_u18.nsg13_hv_nmos[ige]
print @n.xbgr.xm36_u18.nsg13_hv_nmos[ise]
print @n.xbgr.xm36_u18.nsg13_hv_nmos[ibe]
print @n.xbgr.xm36_u18.nsg13_hv_nmos[ctype]
print @n.xbgr.xm36_u19.nsg13_hv_nmos[ide]
print @n.xbgr.xm36_u19.nsg13_hv_nmos[ige]
print @n.xbgr.xm36_u19.nsg13_hv_nmos[ise]
print @n.xbgr.xm36_u19.nsg13_hv_nmos[ibe]
print @n.xbgr.xm36_u19.nsg13_hv_nmos[ctype]
print @n.xbgr.xm36_u20.nsg13_hv_nmos[ide]
print @n.xbgr.xm36_u20.nsg13_hv_nmos[ige]
print @n.xbgr.xm36_u20.nsg13_hv_nmos[ise]
print @n.xbgr.xm36_u20.nsg13_hv_nmos[ibe]
print @n.xbgr.xm36_u20.nsg13_hv_nmos[ctype]
print @n.xbgr.xm36_u21.nsg13_hv_nmos[ide]
print @n.xbgr.xm36_u21.nsg13_hv_nmos[ige]
print @n.xbgr.xm36_u21.nsg13_hv_nmos[ise]
print @n.xbgr.xm36_u21.nsg13_hv_nmos[ibe]
print @n.xbgr.xm36_u21.nsg13_hv_nmos[ctype]
print @n.xbgr.xm36_u22.nsg13_hv_nmos[ide]
print @n.xbgr.xm36_u22.nsg13_hv_nmos[ige]
print @n.xbgr.xm36_u22.nsg13_hv_nmos[ise]
print @n.xbgr.xm36_u22.nsg13_hv_nmos[ibe]
print @n.xbgr.xm36_u22.nsg13_hv_nmos[ctype]
print @n.xbgr.xm36_u23.nsg13_hv_nmos[ide]
print @n.xbgr.xm36_u23.nsg13_hv_nmos[ige]
print @n.xbgr.xm36_u23.nsg13_hv_nmos[ise]
print @n.xbgr.xm36_u23.nsg13_hv_nmos[ibe]
print @n.xbgr.xm36_u23.nsg13_hv_nmos[ctype]
print @n.xbgr.xm36_u24.nsg13_hv_nmos[ide]
print @n.xbgr.xm36_u24.nsg13_hv_nmos[ige]
print @n.xbgr.xm36_u24.nsg13_hv_nmos[ise]
print @n.xbgr.xm36_u24.nsg13_hv_nmos[ibe]
print @n.xbgr.xm36_u24.nsg13_hv_nmos[ctype]
print @n.xbgr.xm37_u2.nsg13_hv_nmos[ide]
print @n.xbgr.xm37_u2.nsg13_hv_nmos[ige]
print @n.xbgr.xm37_u2.nsg13_hv_nmos[ise]
print @n.xbgr.xm37_u2.nsg13_hv_nmos[ibe]
print @n.xbgr.xm37_u2.nsg13_hv_nmos[ctype]
print @n.xbgr.xm37_u3.nsg13_hv_nmos[ide]
print @n.xbgr.xm37_u3.nsg13_hv_nmos[ige]
print @n.xbgr.xm37_u3.nsg13_hv_nmos[ise]
print @n.xbgr.xm37_u3.nsg13_hv_nmos[ibe]
print @n.xbgr.xm37_u3.nsg13_hv_nmos[ctype]
print @n.xbgr.xm37_u4.nsg13_hv_nmos[ide]
print @n.xbgr.xm37_u4.nsg13_hv_nmos[ige]
print @n.xbgr.xm37_u4.nsg13_hv_nmos[ise]
print @n.xbgr.xm37_u4.nsg13_hv_nmos[ibe]
print @n.xbgr.xm37_u4.nsg13_hv_nmos[ctype]
print @n.xbgr.xm37_u5.nsg13_hv_nmos[ide]
print @n.xbgr.xm37_u5.nsg13_hv_nmos[ige]
print @n.xbgr.xm37_u5.nsg13_hv_nmos[ise]
print @n.xbgr.xm37_u5.nsg13_hv_nmos[ibe]
print @n.xbgr.xm37_u5.nsg13_hv_nmos[ctype]
print @n.xbgr.xm37_u6.nsg13_hv_nmos[ide]
print @n.xbgr.xm37_u6.nsg13_hv_nmos[ige]
print @n.xbgr.xm37_u6.nsg13_hv_nmos[ise]
print @n.xbgr.xm37_u6.nsg13_hv_nmos[ibe]
print @n.xbgr.xm37_u6.nsg13_hv_nmos[ctype]
print @n.xbgr.xm37_u7.nsg13_hv_nmos[ide]
print @n.xbgr.xm37_u7.nsg13_hv_nmos[ige]
print @n.xbgr.xm37_u7.nsg13_hv_nmos[ise]
print @n.xbgr.xm37_u7.nsg13_hv_nmos[ibe]
print @n.xbgr.xm37_u7.nsg13_hv_nmos[ctype]
print @n.xbgr.xm37_u8.nsg13_hv_nmos[ide]
print @n.xbgr.xm37_u8.nsg13_hv_nmos[ige]
print @n.xbgr.xm37_u8.nsg13_hv_nmos[ise]
print @n.xbgr.xm37_u8.nsg13_hv_nmos[ibe]
print @n.xbgr.xm37_u8.nsg13_hv_nmos[ctype]
print @n.xbgr.xm37_u9.nsg13_hv_nmos[ide]
print @n.xbgr.xm37_u9.nsg13_hv_nmos[ige]
print @n.xbgr.xm37_u9.nsg13_hv_nmos[ise]
print @n.xbgr.xm37_u9.nsg13_hv_nmos[ibe]
print @n.xbgr.xm37_u9.nsg13_hv_nmos[ctype]
print @n.xbgr.xm37_u10.nsg13_hv_nmos[ide]
print @n.xbgr.xm37_u10.nsg13_hv_nmos[ige]
print @n.xbgr.xm37_u10.nsg13_hv_nmos[ise]
print @n.xbgr.xm37_u10.nsg13_hv_nmos[ibe]
print @n.xbgr.xm37_u10.nsg13_hv_nmos[ctype]
print @n.xbgr.xm37_u11.nsg13_hv_nmos[ide]
print @n.xbgr.xm37_u11.nsg13_hv_nmos[ige]
print @n.xbgr.xm37_u11.nsg13_hv_nmos[ise]
print @n.xbgr.xm37_u11.nsg13_hv_nmos[ibe]
print @n.xbgr.xm37_u11.nsg13_hv_nmos[ctype]
print @n.xbgr.xm37_u12.nsg13_hv_nmos[ide]
print @n.xbgr.xm37_u12.nsg13_hv_nmos[ige]
print @n.xbgr.xm37_u12.nsg13_hv_nmos[ise]
print @n.xbgr.xm37_u12.nsg13_hv_nmos[ibe]
print @n.xbgr.xm37_u12.nsg13_hv_nmos[ctype]
print @n.xbgr.xm37_u13.nsg13_hv_nmos[ide]
print @n.xbgr.xm37_u13.nsg13_hv_nmos[ige]
print @n.xbgr.xm37_u13.nsg13_hv_nmos[ise]
print @n.xbgr.xm37_u13.nsg13_hv_nmos[ibe]
print @n.xbgr.xm37_u13.nsg13_hv_nmos[ctype]
print @n.xbgr.xm37_u14.nsg13_hv_nmos[ide]
print @n.xbgr.xm37_u14.nsg13_hv_nmos[ige]
print @n.xbgr.xm37_u14.nsg13_hv_nmos[ise]
print @n.xbgr.xm37_u14.nsg13_hv_nmos[ibe]
print @n.xbgr.xm37_u14.nsg13_hv_nmos[ctype]
print @n.xbgr.xm37_u15.nsg13_hv_nmos[ide]
print @n.xbgr.xm37_u15.nsg13_hv_nmos[ige]
print @n.xbgr.xm37_u15.nsg13_hv_nmos[ise]
print @n.xbgr.xm37_u15.nsg13_hv_nmos[ibe]
print @n.xbgr.xm37_u15.nsg13_hv_nmos[ctype]
print @n.xbgr.xm37_u16.nsg13_hv_nmos[ide]
print @n.xbgr.xm37_u16.nsg13_hv_nmos[ige]
print @n.xbgr.xm37_u16.nsg13_hv_nmos[ise]
print @n.xbgr.xm37_u16.nsg13_hv_nmos[ibe]
print @n.xbgr.xm37_u16.nsg13_hv_nmos[ctype]
print @n.xbgr.xm37_u17.nsg13_hv_nmos[ide]
print @n.xbgr.xm37_u17.nsg13_hv_nmos[ige]
print @n.xbgr.xm37_u17.nsg13_hv_nmos[ise]
print @n.xbgr.xm37_u17.nsg13_hv_nmos[ibe]
print @n.xbgr.xm37_u17.nsg13_hv_nmos[ctype]
print @n.xbgr.xm37_u18.nsg13_hv_nmos[ide]
print @n.xbgr.xm37_u18.nsg13_hv_nmos[ige]
print @n.xbgr.xm37_u18.nsg13_hv_nmos[ise]
print @n.xbgr.xm37_u18.nsg13_hv_nmos[ibe]
print @n.xbgr.xm37_u18.nsg13_hv_nmos[ctype]
print @n.xbgr.xm37_u19.nsg13_hv_nmos[ide]
print @n.xbgr.xm37_u19.nsg13_hv_nmos[ige]
print @n.xbgr.xm37_u19.nsg13_hv_nmos[ise]
print @n.xbgr.xm37_u19.nsg13_hv_nmos[ibe]
print @n.xbgr.xm37_u19.nsg13_hv_nmos[ctype]
print @n.xbgr.xm37_u20.nsg13_hv_nmos[ide]
print @n.xbgr.xm37_u20.nsg13_hv_nmos[ige]
print @n.xbgr.xm37_u20.nsg13_hv_nmos[ise]
print @n.xbgr.xm37_u20.nsg13_hv_nmos[ibe]
print @n.xbgr.xm37_u20.nsg13_hv_nmos[ctype]
print @n.xbgr.xm37_u21.nsg13_hv_nmos[ide]
print @n.xbgr.xm37_u21.nsg13_hv_nmos[ige]
print @n.xbgr.xm37_u21.nsg13_hv_nmos[ise]
print @n.xbgr.xm37_u21.nsg13_hv_nmos[ibe]
print @n.xbgr.xm37_u21.nsg13_hv_nmos[ctype]
print @n.xbgr.xm37_u22.nsg13_hv_nmos[ide]
print @n.xbgr.xm37_u22.nsg13_hv_nmos[ige]
print @n.xbgr.xm37_u22.nsg13_hv_nmos[ise]
print @n.xbgr.xm37_u22.nsg13_hv_nmos[ibe]
print @n.xbgr.xm37_u22.nsg13_hv_nmos[ctype]
print @n.xbgr.xm37_u23.nsg13_hv_nmos[ide]
print @n.xbgr.xm37_u23.nsg13_hv_nmos[ige]
print @n.xbgr.xm37_u23.nsg13_hv_nmos[ise]
print @n.xbgr.xm37_u23.nsg13_hv_nmos[ibe]
print @n.xbgr.xm37_u23.nsg13_hv_nmos[ctype]
print @n.xbgr.xm37_u24.nsg13_hv_nmos[ide]
print @n.xbgr.xm37_u24.nsg13_hv_nmos[ige]
print @n.xbgr.xm37_u24.nsg13_hv_nmos[ise]
print @n.xbgr.xm37_u24.nsg13_hv_nmos[ibe]
print @n.xbgr.xm37_u24.nsg13_hv_nmos[ctype]
print @n.xbgr.xm38_u2.nsg13_hv_pmos[ide]
print @n.xbgr.xm38_u2.nsg13_hv_pmos[ige]
print @n.xbgr.xm38_u2.nsg13_hv_pmos[ise]
print @n.xbgr.xm38_u2.nsg13_hv_pmos[ibe]
print @n.xbgr.xm38_u2.nsg13_hv_pmos[ctype]
print @n.xbgr.xm38_u3.nsg13_hv_pmos[ide]
print @n.xbgr.xm38_u3.nsg13_hv_pmos[ige]
print @n.xbgr.xm38_u3.nsg13_hv_pmos[ise]
print @n.xbgr.xm38_u3.nsg13_hv_pmos[ibe]
print @n.xbgr.xm38_u3.nsg13_hv_pmos[ctype]
print @n.xbgr.xm38_u4.nsg13_hv_pmos[ide]
print @n.xbgr.xm38_u4.nsg13_hv_pmos[ige]
print @n.xbgr.xm38_u4.nsg13_hv_pmos[ise]
print @n.xbgr.xm38_u4.nsg13_hv_pmos[ibe]
print @n.xbgr.xm38_u4.nsg13_hv_pmos[ctype]
print @n.xbgr.xm38_u5.nsg13_hv_pmos[ide]
print @n.xbgr.xm38_u5.nsg13_hv_pmos[ige]
print @n.xbgr.xm38_u5.nsg13_hv_pmos[ise]
print @n.xbgr.xm38_u5.nsg13_hv_pmos[ibe]
print @n.xbgr.xm38_u5.nsg13_hv_pmos[ctype]
print @n.xbgr.xm38_u6.nsg13_hv_pmos[ide]
print @n.xbgr.xm38_u6.nsg13_hv_pmos[ige]
print @n.xbgr.xm38_u6.nsg13_hv_pmos[ise]
print @n.xbgr.xm38_u6.nsg13_hv_pmos[ibe]
print @n.xbgr.xm38_u6.nsg13_hv_pmos[ctype]
print @n.xbgr.xm38_u7.nsg13_hv_pmos[ide]
print @n.xbgr.xm38_u7.nsg13_hv_pmos[ige]
print @n.xbgr.xm38_u7.nsg13_hv_pmos[ise]
print @n.xbgr.xm38_u7.nsg13_hv_pmos[ibe]
print @n.xbgr.xm38_u7.nsg13_hv_pmos[ctype]
print @n.xbgr.xm38_u8.nsg13_hv_pmos[ide]
print @n.xbgr.xm38_u8.nsg13_hv_pmos[ige]
print @n.xbgr.xm38_u8.nsg13_hv_pmos[ise]
print @n.xbgr.xm38_u8.nsg13_hv_pmos[ibe]
print @n.xbgr.xm38_u8.nsg13_hv_pmos[ctype]
print @n.xbgr.xm38_u9.nsg13_hv_pmos[ide]
print @n.xbgr.xm38_u9.nsg13_hv_pmos[ige]
print @n.xbgr.xm38_u9.nsg13_hv_pmos[ise]
print @n.xbgr.xm38_u9.nsg13_hv_pmos[ibe]
print @n.xbgr.xm38_u9.nsg13_hv_pmos[ctype]
print @n.xbgr.xm38_u10.nsg13_hv_pmos[ide]
print @n.xbgr.xm38_u10.nsg13_hv_pmos[ige]
print @n.xbgr.xm38_u10.nsg13_hv_pmos[ise]
print @n.xbgr.xm38_u10.nsg13_hv_pmos[ibe]
print @n.xbgr.xm38_u10.nsg13_hv_pmos[ctype]
print @n.xbgr.xm38_u11.nsg13_hv_pmos[ide]
print @n.xbgr.xm38_u11.nsg13_hv_pmos[ige]
print @n.xbgr.xm38_u11.nsg13_hv_pmos[ise]
print @n.xbgr.xm38_u11.nsg13_hv_pmos[ibe]
print @n.xbgr.xm38_u11.nsg13_hv_pmos[ctype]
print @n.xbgr.xm38_u12.nsg13_hv_pmos[ide]
print @n.xbgr.xm38_u12.nsg13_hv_pmos[ige]
print @n.xbgr.xm38_u12.nsg13_hv_pmos[ise]
print @n.xbgr.xm38_u12.nsg13_hv_pmos[ibe]
print @n.xbgr.xm38_u12.nsg13_hv_pmos[ctype]
print @n.xbgr.xm38_u13.nsg13_hv_pmos[ide]
print @n.xbgr.xm38_u13.nsg13_hv_pmos[ige]
print @n.xbgr.xm38_u13.nsg13_hv_pmos[ise]
print @n.xbgr.xm38_u13.nsg13_hv_pmos[ibe]
print @n.xbgr.xm38_u13.nsg13_hv_pmos[ctype]
print @n.xbgr.xm38_u14.nsg13_hv_pmos[ide]
print @n.xbgr.xm38_u14.nsg13_hv_pmos[ige]
print @n.xbgr.xm38_u14.nsg13_hv_pmos[ise]
print @n.xbgr.xm38_u14.nsg13_hv_pmos[ibe]
print @n.xbgr.xm38_u14.nsg13_hv_pmos[ctype]
print @n.xbgr.xm38_u15.nsg13_hv_pmos[ide]
print @n.xbgr.xm38_u15.nsg13_hv_pmos[ige]
print @n.xbgr.xm38_u15.nsg13_hv_pmos[ise]
print @n.xbgr.xm38_u15.nsg13_hv_pmos[ibe]
print @n.xbgr.xm38_u15.nsg13_hv_pmos[ctype]
print @n.xbgr.xm38_u16.nsg13_hv_pmos[ide]
print @n.xbgr.xm38_u16.nsg13_hv_pmos[ige]
print @n.xbgr.xm38_u16.nsg13_hv_pmos[ise]
print @n.xbgr.xm38_u16.nsg13_hv_pmos[ibe]
print @n.xbgr.xm38_u16.nsg13_hv_pmos[ctype]
print @n.xbgr.xm38_u17.nsg13_hv_pmos[ide]
print @n.xbgr.xm38_u17.nsg13_hv_pmos[ige]
print @n.xbgr.xm38_u17.nsg13_hv_pmos[ise]
print @n.xbgr.xm38_u17.nsg13_hv_pmos[ibe]
print @n.xbgr.xm38_u17.nsg13_hv_pmos[ctype]
print @n.xbgr.xm38_u18.nsg13_hv_pmos[ide]
print @n.xbgr.xm38_u18.nsg13_hv_pmos[ige]
print @n.xbgr.xm38_u18.nsg13_hv_pmos[ise]
print @n.xbgr.xm38_u18.nsg13_hv_pmos[ibe]
print @n.xbgr.xm38_u18.nsg13_hv_pmos[ctype]
print @n.xbgr.xm38_u19.nsg13_hv_pmos[ide]
print @n.xbgr.xm38_u19.nsg13_hv_pmos[ige]
print @n.xbgr.xm38_u19.nsg13_hv_pmos[ise]
print @n.xbgr.xm38_u19.nsg13_hv_pmos[ibe]
print @n.xbgr.xm38_u19.nsg13_hv_pmos[ctype]
print @n.xbgr.xm38_u20.nsg13_hv_pmos[ide]
print @n.xbgr.xm38_u20.nsg13_hv_pmos[ige]
print @n.xbgr.xm38_u20.nsg13_hv_pmos[ise]
print @n.xbgr.xm38_u20.nsg13_hv_pmos[ibe]
print @n.xbgr.xm38_u20.nsg13_hv_pmos[ctype]
print @n.xbgr.xm38_u21.nsg13_hv_pmos[ide]
print @n.xbgr.xm38_u21.nsg13_hv_pmos[ige]
print @n.xbgr.xm38_u21.nsg13_hv_pmos[ise]
print @n.xbgr.xm38_u21.nsg13_hv_pmos[ibe]
print @n.xbgr.xm38_u21.nsg13_hv_pmos[ctype]
print @n.xbgr.xm38_u22.nsg13_hv_pmos[ide]
print @n.xbgr.xm38_u22.nsg13_hv_pmos[ige]
print @n.xbgr.xm38_u22.nsg13_hv_pmos[ise]
print @n.xbgr.xm38_u22.nsg13_hv_pmos[ibe]
print @n.xbgr.xm38_u22.nsg13_hv_pmos[ctype]
print @n.xbgr.xm38_u23.nsg13_hv_pmos[ide]
print @n.xbgr.xm38_u23.nsg13_hv_pmos[ige]
print @n.xbgr.xm38_u23.nsg13_hv_pmos[ise]
print @n.xbgr.xm38_u23.nsg13_hv_pmos[ibe]
print @n.xbgr.xm38_u23.nsg13_hv_pmos[ctype]
print @n.xbgr.xm38_u24.nsg13_hv_pmos[ide]
print @n.xbgr.xm38_u24.nsg13_hv_pmos[ige]
print @n.xbgr.xm38_u24.nsg13_hv_pmos[ise]
print @n.xbgr.xm38_u24.nsg13_hv_pmos[ibe]
print @n.xbgr.xm38_u24.nsg13_hv_pmos[ctype]
print @n.xbgr.xm39_u2.nsg13_hv_pmos[ide]
print @n.xbgr.xm39_u2.nsg13_hv_pmos[ige]
print @n.xbgr.xm39_u2.nsg13_hv_pmos[ise]
print @n.xbgr.xm39_u2.nsg13_hv_pmos[ibe]
print @n.xbgr.xm39_u2.nsg13_hv_pmos[ctype]
print @n.xbgr.xm39_u3.nsg13_hv_pmos[ide]
print @n.xbgr.xm39_u3.nsg13_hv_pmos[ige]
print @n.xbgr.xm39_u3.nsg13_hv_pmos[ise]
print @n.xbgr.xm39_u3.nsg13_hv_pmos[ibe]
print @n.xbgr.xm39_u3.nsg13_hv_pmos[ctype]
print @n.xbgr.xm39_u4.nsg13_hv_pmos[ide]
print @n.xbgr.xm39_u4.nsg13_hv_pmos[ige]
print @n.xbgr.xm39_u4.nsg13_hv_pmos[ise]
print @n.xbgr.xm39_u4.nsg13_hv_pmos[ibe]
print @n.xbgr.xm39_u4.nsg13_hv_pmos[ctype]
print @n.xbgr.xm39_u5.nsg13_hv_pmos[ide]
print @n.xbgr.xm39_u5.nsg13_hv_pmos[ige]
print @n.xbgr.xm39_u5.nsg13_hv_pmos[ise]
print @n.xbgr.xm39_u5.nsg13_hv_pmos[ibe]
print @n.xbgr.xm39_u5.nsg13_hv_pmos[ctype]
print @n.xbgr.xm39_u6.nsg13_hv_pmos[ide]
print @n.xbgr.xm39_u6.nsg13_hv_pmos[ige]
print @n.xbgr.xm39_u6.nsg13_hv_pmos[ise]
print @n.xbgr.xm39_u6.nsg13_hv_pmos[ibe]
print @n.xbgr.xm39_u6.nsg13_hv_pmos[ctype]
print @n.xbgr.xm39_u7.nsg13_hv_pmos[ide]
print @n.xbgr.xm39_u7.nsg13_hv_pmos[ige]
print @n.xbgr.xm39_u7.nsg13_hv_pmos[ise]
print @n.xbgr.xm39_u7.nsg13_hv_pmos[ibe]
print @n.xbgr.xm39_u7.nsg13_hv_pmos[ctype]
print @n.xbgr.xm39_u8.nsg13_hv_pmos[ide]
print @n.xbgr.xm39_u8.nsg13_hv_pmos[ige]
print @n.xbgr.xm39_u8.nsg13_hv_pmos[ise]
print @n.xbgr.xm39_u8.nsg13_hv_pmos[ibe]
print @n.xbgr.xm39_u8.nsg13_hv_pmos[ctype]
print @n.xbgr.xm39_u9.nsg13_hv_pmos[ide]
print @n.xbgr.xm39_u9.nsg13_hv_pmos[ige]
print @n.xbgr.xm39_u9.nsg13_hv_pmos[ise]
print @n.xbgr.xm39_u9.nsg13_hv_pmos[ibe]
print @n.xbgr.xm39_u9.nsg13_hv_pmos[ctype]
print @n.xbgr.xm39_u10.nsg13_hv_pmos[ide]
print @n.xbgr.xm39_u10.nsg13_hv_pmos[ige]
print @n.xbgr.xm39_u10.nsg13_hv_pmos[ise]
print @n.xbgr.xm39_u10.nsg13_hv_pmos[ibe]
print @n.xbgr.xm39_u10.nsg13_hv_pmos[ctype]
print @n.xbgr.xm39_u11.nsg13_hv_pmos[ide]
print @n.xbgr.xm39_u11.nsg13_hv_pmos[ige]
print @n.xbgr.xm39_u11.nsg13_hv_pmos[ise]
print @n.xbgr.xm39_u11.nsg13_hv_pmos[ibe]
print @n.xbgr.xm39_u11.nsg13_hv_pmos[ctype]
print @n.xbgr.xm39_u12.nsg13_hv_pmos[ide]
print @n.xbgr.xm39_u12.nsg13_hv_pmos[ige]
print @n.xbgr.xm39_u12.nsg13_hv_pmos[ise]
print @n.xbgr.xm39_u12.nsg13_hv_pmos[ibe]
print @n.xbgr.xm39_u12.nsg13_hv_pmos[ctype]
print @n.xbgr.xm39_u13.nsg13_hv_pmos[ide]
print @n.xbgr.xm39_u13.nsg13_hv_pmos[ige]
print @n.xbgr.xm39_u13.nsg13_hv_pmos[ise]
print @n.xbgr.xm39_u13.nsg13_hv_pmos[ibe]
print @n.xbgr.xm39_u13.nsg13_hv_pmos[ctype]
print @n.xbgr.xm39_u14.nsg13_hv_pmos[ide]
print @n.xbgr.xm39_u14.nsg13_hv_pmos[ige]
print @n.xbgr.xm39_u14.nsg13_hv_pmos[ise]
print @n.xbgr.xm39_u14.nsg13_hv_pmos[ibe]
print @n.xbgr.xm39_u14.nsg13_hv_pmos[ctype]
print @n.xbgr.xm39_u15.nsg13_hv_pmos[ide]
print @n.xbgr.xm39_u15.nsg13_hv_pmos[ige]
print @n.xbgr.xm39_u15.nsg13_hv_pmos[ise]
print @n.xbgr.xm39_u15.nsg13_hv_pmos[ibe]
print @n.xbgr.xm39_u15.nsg13_hv_pmos[ctype]
print @n.xbgr.xm39_u16.nsg13_hv_pmos[ide]
print @n.xbgr.xm39_u16.nsg13_hv_pmos[ige]
print @n.xbgr.xm39_u16.nsg13_hv_pmos[ise]
print @n.xbgr.xm39_u16.nsg13_hv_pmos[ibe]
print @n.xbgr.xm39_u16.nsg13_hv_pmos[ctype]
print @n.xbgr.xm39_u17.nsg13_hv_pmos[ide]
print @n.xbgr.xm39_u17.nsg13_hv_pmos[ige]
print @n.xbgr.xm39_u17.nsg13_hv_pmos[ise]
print @n.xbgr.xm39_u17.nsg13_hv_pmos[ibe]
print @n.xbgr.xm39_u17.nsg13_hv_pmos[ctype]
print @n.xbgr.xm39_u18.nsg13_hv_pmos[ide]
print @n.xbgr.xm39_u18.nsg13_hv_pmos[ige]
print @n.xbgr.xm39_u18.nsg13_hv_pmos[ise]
print @n.xbgr.xm39_u18.nsg13_hv_pmos[ibe]
print @n.xbgr.xm39_u18.nsg13_hv_pmos[ctype]
print @n.xbgr.xm39_u19.nsg13_hv_pmos[ide]
print @n.xbgr.xm39_u19.nsg13_hv_pmos[ige]
print @n.xbgr.xm39_u19.nsg13_hv_pmos[ise]
print @n.xbgr.xm39_u19.nsg13_hv_pmos[ibe]
print @n.xbgr.xm39_u19.nsg13_hv_pmos[ctype]
print @n.xbgr.xm39_u20.nsg13_hv_pmos[ide]
print @n.xbgr.xm39_u20.nsg13_hv_pmos[ige]
print @n.xbgr.xm39_u20.nsg13_hv_pmos[ise]
print @n.xbgr.xm39_u20.nsg13_hv_pmos[ibe]
print @n.xbgr.xm39_u20.nsg13_hv_pmos[ctype]
print @n.xbgr.xm39_u21.nsg13_hv_pmos[ide]
print @n.xbgr.xm39_u21.nsg13_hv_pmos[ige]
print @n.xbgr.xm39_u21.nsg13_hv_pmos[ise]
print @n.xbgr.xm39_u21.nsg13_hv_pmos[ibe]
print @n.xbgr.xm39_u21.nsg13_hv_pmos[ctype]
print @n.xbgr.xm39_u22.nsg13_hv_pmos[ide]
print @n.xbgr.xm39_u22.nsg13_hv_pmos[ige]
print @n.xbgr.xm39_u22.nsg13_hv_pmos[ise]
print @n.xbgr.xm39_u22.nsg13_hv_pmos[ibe]
print @n.xbgr.xm39_u22.nsg13_hv_pmos[ctype]
print @n.xbgr.xm39_u23.nsg13_hv_pmos[ide]
print @n.xbgr.xm39_u23.nsg13_hv_pmos[ige]
print @n.xbgr.xm39_u23.nsg13_hv_pmos[ise]
print @n.xbgr.xm39_u23.nsg13_hv_pmos[ibe]
print @n.xbgr.xm39_u23.nsg13_hv_pmos[ctype]
print @n.xbgr.xm39_u24.nsg13_hv_pmos[ide]
print @n.xbgr.xm39_u24.nsg13_hv_pmos[ige]
print @n.xbgr.xm39_u24.nsg13_hv_pmos[ise]
print @n.xbgr.xm39_u24.nsg13_hv_pmos[ibe]
print @n.xbgr.xm39_u24.nsg13_hv_pmos[ctype]
print @n.xbgr.xm41_u2.nsg13_hv_pmos[ide]
print @n.xbgr.xm41_u2.nsg13_hv_pmos[ige]
print @n.xbgr.xm41_u2.nsg13_hv_pmos[ise]
print @n.xbgr.xm41_u2.nsg13_hv_pmos[ibe]
print @n.xbgr.xm41_u2.nsg13_hv_pmos[ctype]
print @n.xbgr.xm41_u3.nsg13_hv_pmos[ide]
print @n.xbgr.xm41_u3.nsg13_hv_pmos[ige]
print @n.xbgr.xm41_u3.nsg13_hv_pmos[ise]
print @n.xbgr.xm41_u3.nsg13_hv_pmos[ibe]
print @n.xbgr.xm41_u3.nsg13_hv_pmos[ctype]
print @n.xbgr.xm41_u4.nsg13_hv_pmos[ide]
print @n.xbgr.xm41_u4.nsg13_hv_pmos[ige]
print @n.xbgr.xm41_u4.nsg13_hv_pmos[ise]
print @n.xbgr.xm41_u4.nsg13_hv_pmos[ibe]
print @n.xbgr.xm41_u4.nsg13_hv_pmos[ctype]
print @n.xbgr.xm41_u5.nsg13_hv_pmos[ide]
print @n.xbgr.xm41_u5.nsg13_hv_pmos[ige]
print @n.xbgr.xm41_u5.nsg13_hv_pmos[ise]
print @n.xbgr.xm41_u5.nsg13_hv_pmos[ibe]
print @n.xbgr.xm41_u5.nsg13_hv_pmos[ctype]
print @n.xbgr.xm41_u6.nsg13_hv_pmos[ide]
print @n.xbgr.xm41_u6.nsg13_hv_pmos[ige]
print @n.xbgr.xm41_u6.nsg13_hv_pmos[ise]
print @n.xbgr.xm41_u6.nsg13_hv_pmos[ibe]
print @n.xbgr.xm41_u6.nsg13_hv_pmos[ctype]
print @n.xbgr.xm41_u7.nsg13_hv_pmos[ide]
print @n.xbgr.xm41_u7.nsg13_hv_pmos[ige]
print @n.xbgr.xm41_u7.nsg13_hv_pmos[ise]
print @n.xbgr.xm41_u7.nsg13_hv_pmos[ibe]
print @n.xbgr.xm41_u7.nsg13_hv_pmos[ctype]
print @n.xbgr.xm41_u8.nsg13_hv_pmos[ide]
print @n.xbgr.xm41_u8.nsg13_hv_pmos[ige]
print @n.xbgr.xm41_u8.nsg13_hv_pmos[ise]
print @n.xbgr.xm41_u8.nsg13_hv_pmos[ibe]
print @n.xbgr.xm41_u8.nsg13_hv_pmos[ctype]
print @n.xbgr.xm41_u9.nsg13_hv_pmos[ide]
print @n.xbgr.xm41_u9.nsg13_hv_pmos[ige]
print @n.xbgr.xm41_u9.nsg13_hv_pmos[ise]
print @n.xbgr.xm41_u9.nsg13_hv_pmos[ibe]
print @n.xbgr.xm41_u9.nsg13_hv_pmos[ctype]
print @n.xbgr.xm41_u10.nsg13_hv_pmos[ide]
print @n.xbgr.xm41_u10.nsg13_hv_pmos[ige]
print @n.xbgr.xm41_u10.nsg13_hv_pmos[ise]
print @n.xbgr.xm41_u10.nsg13_hv_pmos[ibe]
print @n.xbgr.xm41_u10.nsg13_hv_pmos[ctype]
print @n.xbgr.xm41_u11.nsg13_hv_pmos[ide]
print @n.xbgr.xm41_u11.nsg13_hv_pmos[ige]
print @n.xbgr.xm41_u11.nsg13_hv_pmos[ise]
print @n.xbgr.xm41_u11.nsg13_hv_pmos[ibe]
print @n.xbgr.xm41_u11.nsg13_hv_pmos[ctype]
print @n.xbgr.xm41_u12.nsg13_hv_pmos[ide]
print @n.xbgr.xm41_u12.nsg13_hv_pmos[ige]
print @n.xbgr.xm41_u12.nsg13_hv_pmos[ise]
print @n.xbgr.xm41_u12.nsg13_hv_pmos[ibe]
print @n.xbgr.xm41_u12.nsg13_hv_pmos[ctype]
print @n.xbgr.xm41_u13.nsg13_hv_pmos[ide]
print @n.xbgr.xm41_u13.nsg13_hv_pmos[ige]
print @n.xbgr.xm41_u13.nsg13_hv_pmos[ise]
print @n.xbgr.xm41_u13.nsg13_hv_pmos[ibe]
print @n.xbgr.xm41_u13.nsg13_hv_pmos[ctype]
print @n.xbgr.xm41_u14.nsg13_hv_pmos[ide]
print @n.xbgr.xm41_u14.nsg13_hv_pmos[ige]
print @n.xbgr.xm41_u14.nsg13_hv_pmos[ise]
print @n.xbgr.xm41_u14.nsg13_hv_pmos[ibe]
print @n.xbgr.xm41_u14.nsg13_hv_pmos[ctype]
print @n.xbgr.xm41_u15.nsg13_hv_pmos[ide]
print @n.xbgr.xm41_u15.nsg13_hv_pmos[ige]
print @n.xbgr.xm41_u15.nsg13_hv_pmos[ise]
print @n.xbgr.xm41_u15.nsg13_hv_pmos[ibe]
print @n.xbgr.xm41_u15.nsg13_hv_pmos[ctype]
print @n.xbgr.xm41_u16.nsg13_hv_pmos[ide]
print @n.xbgr.xm41_u16.nsg13_hv_pmos[ige]
print @n.xbgr.xm41_u16.nsg13_hv_pmos[ise]
print @n.xbgr.xm41_u16.nsg13_hv_pmos[ibe]
print @n.xbgr.xm41_u16.nsg13_hv_pmos[ctype]
print @n.xbgr.xm41_u17.nsg13_hv_pmos[ide]
print @n.xbgr.xm41_u17.nsg13_hv_pmos[ige]
print @n.xbgr.xm41_u17.nsg13_hv_pmos[ise]
print @n.xbgr.xm41_u17.nsg13_hv_pmos[ibe]
print @n.xbgr.xm41_u17.nsg13_hv_pmos[ctype]
print @n.xbgr.xm41_u18.nsg13_hv_pmos[ide]
print @n.xbgr.xm41_u18.nsg13_hv_pmos[ige]
print @n.xbgr.xm41_u18.nsg13_hv_pmos[ise]
print @n.xbgr.xm41_u18.nsg13_hv_pmos[ibe]
print @n.xbgr.xm41_u18.nsg13_hv_pmos[ctype]
print @n.xbgr.xm41_u19.nsg13_hv_pmos[ide]
print @n.xbgr.xm41_u19.nsg13_hv_pmos[ige]
print @n.xbgr.xm41_u19.nsg13_hv_pmos[ise]
print @n.xbgr.xm41_u19.nsg13_hv_pmos[ibe]
print @n.xbgr.xm41_u19.nsg13_hv_pmos[ctype]
print @n.xbgr.xm41_u20.nsg13_hv_pmos[ide]
print @n.xbgr.xm41_u20.nsg13_hv_pmos[ige]
print @n.xbgr.xm41_u20.nsg13_hv_pmos[ise]
print @n.xbgr.xm41_u20.nsg13_hv_pmos[ibe]
print @n.xbgr.xm41_u20.nsg13_hv_pmos[ctype]
print @n.xbgr.xm41_u21.nsg13_hv_pmos[ide]
print @n.xbgr.xm41_u21.nsg13_hv_pmos[ige]
print @n.xbgr.xm41_u21.nsg13_hv_pmos[ise]
print @n.xbgr.xm41_u21.nsg13_hv_pmos[ibe]
print @n.xbgr.xm41_u21.nsg13_hv_pmos[ctype]
print @n.xbgr.xm41_u22.nsg13_hv_pmos[ide]
print @n.xbgr.xm41_u22.nsg13_hv_pmos[ige]
print @n.xbgr.xm41_u22.nsg13_hv_pmos[ise]
print @n.xbgr.xm41_u22.nsg13_hv_pmos[ibe]
print @n.xbgr.xm41_u22.nsg13_hv_pmos[ctype]
print @n.xbgr.xm41_u23.nsg13_hv_pmos[ide]
print @n.xbgr.xm41_u23.nsg13_hv_pmos[ige]
print @n.xbgr.xm41_u23.nsg13_hv_pmos[ise]
print @n.xbgr.xm41_u23.nsg13_hv_pmos[ibe]
print @n.xbgr.xm41_u23.nsg13_hv_pmos[ctype]
print @n.xbgr.xm41_u24.nsg13_hv_pmos[ide]
print @n.xbgr.xm41_u24.nsg13_hv_pmos[ige]
print @n.xbgr.xm41_u24.nsg13_hv_pmos[ise]
print @n.xbgr.xm41_u24.nsg13_hv_pmos[ibe]
print @n.xbgr.xm41_u24.nsg13_hv_pmos[ctype]
print @n.xbgr.xm43_u2.nsg13_hv_pmos[ide]
print @n.xbgr.xm43_u2.nsg13_hv_pmos[ige]
print @n.xbgr.xm43_u2.nsg13_hv_pmos[ise]
print @n.xbgr.xm43_u2.nsg13_hv_pmos[ibe]
print @n.xbgr.xm43_u2.nsg13_hv_pmos[ctype]
print @n.xbgr.xm43_u3.nsg13_hv_pmos[ide]
print @n.xbgr.xm43_u3.nsg13_hv_pmos[ige]
print @n.xbgr.xm43_u3.nsg13_hv_pmos[ise]
print @n.xbgr.xm43_u3.nsg13_hv_pmos[ibe]
print @n.xbgr.xm43_u3.nsg13_hv_pmos[ctype]
print @n.xbgr.xm43_u4.nsg13_hv_pmos[ide]
print @n.xbgr.xm43_u4.nsg13_hv_pmos[ige]
print @n.xbgr.xm43_u4.nsg13_hv_pmos[ise]
print @n.xbgr.xm43_u4.nsg13_hv_pmos[ibe]
print @n.xbgr.xm43_u4.nsg13_hv_pmos[ctype]
print @n.xbgr.xm44_u2.nsg13_hv_pmos[ide]
print @n.xbgr.xm44_u2.nsg13_hv_pmos[ige]
print @n.xbgr.xm44_u2.nsg13_hv_pmos[ise]
print @n.xbgr.xm44_u2.nsg13_hv_pmos[ibe]
print @n.xbgr.xm44_u2.nsg13_hv_pmos[ctype]
print @n.xbgr.xm44_u3.nsg13_hv_pmos[ide]
print @n.xbgr.xm44_u3.nsg13_hv_pmos[ige]
print @n.xbgr.xm44_u3.nsg13_hv_pmos[ise]
print @n.xbgr.xm44_u3.nsg13_hv_pmos[ibe]
print @n.xbgr.xm44_u3.nsg13_hv_pmos[ctype]
print @n.xbgr.xm44_u4.nsg13_hv_pmos[ide]
print @n.xbgr.xm44_u4.nsg13_hv_pmos[ige]
print @n.xbgr.xm44_u4.nsg13_hv_pmos[ise]
print @n.xbgr.xm44_u4.nsg13_hv_pmos[ibe]
print @n.xbgr.xm44_u4.nsg13_hv_pmos[ctype]
print @n.xbgr.xm45_u2.nsg13_hv_pmos[ide]
print @n.xbgr.xm45_u2.nsg13_hv_pmos[ige]
print @n.xbgr.xm45_u2.nsg13_hv_pmos[ise]
print @n.xbgr.xm45_u2.nsg13_hv_pmos[ibe]
print @n.xbgr.xm45_u2.nsg13_hv_pmos[ctype]
print @n.xbgr.xm45_u3.nsg13_hv_pmos[ide]
print @n.xbgr.xm45_u3.nsg13_hv_pmos[ige]
print @n.xbgr.xm45_u3.nsg13_hv_pmos[ise]
print @n.xbgr.xm45_u3.nsg13_hv_pmos[ibe]
print @n.xbgr.xm45_u3.nsg13_hv_pmos[ctype]
print @n.xbgr.xm45_u4.nsg13_hv_pmos[ide]
print @n.xbgr.xm45_u4.nsg13_hv_pmos[ige]
print @n.xbgr.xm45_u4.nsg13_hv_pmos[ise]
print @n.xbgr.xm45_u4.nsg13_hv_pmos[ibe]
print @n.xbgr.xm45_u4.nsg13_hv_pmos[ctype]
print @n.xbgr.xm45_u5.nsg13_hv_pmos[ide]
print @n.xbgr.xm45_u5.nsg13_hv_pmos[ige]
print @n.xbgr.xm45_u5.nsg13_hv_pmos[ise]
print @n.xbgr.xm45_u5.nsg13_hv_pmos[ibe]
print @n.xbgr.xm45_u5.nsg13_hv_pmos[ctype]
print @n.xbgr.xm45_u6.nsg13_hv_pmos[ide]
print @n.xbgr.xm45_u6.nsg13_hv_pmos[ige]
print @n.xbgr.xm45_u6.nsg13_hv_pmos[ise]
print @n.xbgr.xm45_u6.nsg13_hv_pmos[ibe]
print @n.xbgr.xm45_u6.nsg13_hv_pmos[ctype]
print @n.xbgr.xm45_u7.nsg13_hv_pmos[ide]
print @n.xbgr.xm45_u7.nsg13_hv_pmos[ige]
print @n.xbgr.xm45_u7.nsg13_hv_pmos[ise]
print @n.xbgr.xm45_u7.nsg13_hv_pmos[ibe]
print @n.xbgr.xm45_u7.nsg13_hv_pmos[ctype]
print @n.xbgr.xm45_u8.nsg13_hv_pmos[ide]
print @n.xbgr.xm45_u8.nsg13_hv_pmos[ige]
print @n.xbgr.xm45_u8.nsg13_hv_pmos[ise]
print @n.xbgr.xm45_u8.nsg13_hv_pmos[ibe]
print @n.xbgr.xm45_u8.nsg13_hv_pmos[ctype]
print @n.xbgr.xm45_u9.nsg13_hv_pmos[ide]
print @n.xbgr.xm45_u9.nsg13_hv_pmos[ige]
print @n.xbgr.xm45_u9.nsg13_hv_pmos[ise]
print @n.xbgr.xm45_u9.nsg13_hv_pmos[ibe]
print @n.xbgr.xm45_u9.nsg13_hv_pmos[ctype]
print @n.xbgr.xm45_u10.nsg13_hv_pmos[ide]
print @n.xbgr.xm45_u10.nsg13_hv_pmos[ige]
print @n.xbgr.xm45_u10.nsg13_hv_pmos[ise]
print @n.xbgr.xm45_u10.nsg13_hv_pmos[ibe]
print @n.xbgr.xm45_u10.nsg13_hv_pmos[ctype]
print @n.xbgr.xm45_u11.nsg13_hv_pmos[ide]
print @n.xbgr.xm45_u11.nsg13_hv_pmos[ige]
print @n.xbgr.xm45_u11.nsg13_hv_pmos[ise]
print @n.xbgr.xm45_u11.nsg13_hv_pmos[ibe]
print @n.xbgr.xm45_u11.nsg13_hv_pmos[ctype]
print @n.xbgr.xm45_u12.nsg13_hv_pmos[ide]
print @n.xbgr.xm45_u12.nsg13_hv_pmos[ige]
print @n.xbgr.xm45_u12.nsg13_hv_pmos[ise]
print @n.xbgr.xm45_u12.nsg13_hv_pmos[ibe]
print @n.xbgr.xm45_u12.nsg13_hv_pmos[ctype]
print @n.xbgr.xm45_u13.nsg13_hv_pmos[ide]
print @n.xbgr.xm45_u13.nsg13_hv_pmos[ige]
print @n.xbgr.xm45_u13.nsg13_hv_pmos[ise]
print @n.xbgr.xm45_u13.nsg13_hv_pmos[ibe]
print @n.xbgr.xm45_u13.nsg13_hv_pmos[ctype]
print @n.xbgr.xm45_u14.nsg13_hv_pmos[ide]
print @n.xbgr.xm45_u14.nsg13_hv_pmos[ige]
print @n.xbgr.xm45_u14.nsg13_hv_pmos[ise]
print @n.xbgr.xm45_u14.nsg13_hv_pmos[ibe]
print @n.xbgr.xm45_u14.nsg13_hv_pmos[ctype]
print @n.xbgr.xm45_u15.nsg13_hv_pmos[ide]
print @n.xbgr.xm45_u15.nsg13_hv_pmos[ige]
print @n.xbgr.xm45_u15.nsg13_hv_pmos[ise]
print @n.xbgr.xm45_u15.nsg13_hv_pmos[ibe]
print @n.xbgr.xm45_u15.nsg13_hv_pmos[ctype]
print @n.xbgr.xm45_u16.nsg13_hv_pmos[ide]
print @n.xbgr.xm45_u16.nsg13_hv_pmos[ige]
print @n.xbgr.xm45_u16.nsg13_hv_pmos[ise]
print @n.xbgr.xm45_u16.nsg13_hv_pmos[ibe]
print @n.xbgr.xm45_u16.nsg13_hv_pmos[ctype]
print @n.xbgr.xm45_u17.nsg13_hv_pmos[ide]
print @n.xbgr.xm45_u17.nsg13_hv_pmos[ige]
print @n.xbgr.xm45_u17.nsg13_hv_pmos[ise]
print @n.xbgr.xm45_u17.nsg13_hv_pmos[ibe]
print @n.xbgr.xm45_u17.nsg13_hv_pmos[ctype]
print @n.xbgr.xm45_u18.nsg13_hv_pmos[ide]
print @n.xbgr.xm45_u18.nsg13_hv_pmos[ige]
print @n.xbgr.xm45_u18.nsg13_hv_pmos[ise]
print @n.xbgr.xm45_u18.nsg13_hv_pmos[ibe]
print @n.xbgr.xm45_u18.nsg13_hv_pmos[ctype]
print @n.xbgr.xm45_u19.nsg13_hv_pmos[ide]
print @n.xbgr.xm45_u19.nsg13_hv_pmos[ige]
print @n.xbgr.xm45_u19.nsg13_hv_pmos[ise]
print @n.xbgr.xm45_u19.nsg13_hv_pmos[ibe]
print @n.xbgr.xm45_u19.nsg13_hv_pmos[ctype]
print @n.xbgr.xm45_u20.nsg13_hv_pmos[ide]
print @n.xbgr.xm45_u20.nsg13_hv_pmos[ige]
print @n.xbgr.xm45_u20.nsg13_hv_pmos[ise]
print @n.xbgr.xm45_u20.nsg13_hv_pmos[ibe]
print @n.xbgr.xm45_u20.nsg13_hv_pmos[ctype]
print @n.xbgr.xm45_u21.nsg13_hv_pmos[ide]
print @n.xbgr.xm45_u21.nsg13_hv_pmos[ige]
print @n.xbgr.xm45_u21.nsg13_hv_pmos[ise]
print @n.xbgr.xm45_u21.nsg13_hv_pmos[ibe]
print @n.xbgr.xm45_u21.nsg13_hv_pmos[ctype]
print @n.xbgr.xm45_u22.nsg13_hv_pmos[ide]
print @n.xbgr.xm45_u22.nsg13_hv_pmos[ige]
print @n.xbgr.xm45_u22.nsg13_hv_pmos[ise]
print @n.xbgr.xm45_u22.nsg13_hv_pmos[ibe]
print @n.xbgr.xm45_u22.nsg13_hv_pmos[ctype]
print @n.xbgr.xm45_u23.nsg13_hv_pmos[ide]
print @n.xbgr.xm45_u23.nsg13_hv_pmos[ige]
print @n.xbgr.xm45_u23.nsg13_hv_pmos[ise]
print @n.xbgr.xm45_u23.nsg13_hv_pmos[ibe]
print @n.xbgr.xm45_u23.nsg13_hv_pmos[ctype]
print @n.xbgr.xm45_u24.nsg13_hv_pmos[ide]
print @n.xbgr.xm45_u24.nsg13_hv_pmos[ige]
print @n.xbgr.xm45_u24.nsg13_hv_pmos[ise]
print @n.xbgr.xm45_u24.nsg13_hv_pmos[ibe]
print @n.xbgr.xm45_u24.nsg13_hv_pmos[ctype]
print @n.xbgr.xm47_u2.nsg13_hv_pmos[ide]
print @n.xbgr.xm47_u2.nsg13_hv_pmos[ige]
print @n.xbgr.xm47_u2.nsg13_hv_pmos[ise]
print @n.xbgr.xm47_u2.nsg13_hv_pmos[ibe]
print @n.xbgr.xm47_u2.nsg13_hv_pmos[ctype]
print @n.xbgr.xm47_u3.nsg13_hv_pmos[ide]
print @n.xbgr.xm47_u3.nsg13_hv_pmos[ige]
print @n.xbgr.xm47_u3.nsg13_hv_pmos[ise]
print @n.xbgr.xm47_u3.nsg13_hv_pmos[ibe]
print @n.xbgr.xm47_u3.nsg13_hv_pmos[ctype]
print @n.xbgr.xm47_u4.nsg13_hv_pmos[ide]
print @n.xbgr.xm47_u4.nsg13_hv_pmos[ige]
print @n.xbgr.xm47_u4.nsg13_hv_pmos[ise]
print @n.xbgr.xm47_u4.nsg13_hv_pmos[ibe]
print @n.xbgr.xm47_u4.nsg13_hv_pmos[ctype]
print @n.xbgr.xm47_u5.nsg13_hv_pmos[ide]
print @n.xbgr.xm47_u5.nsg13_hv_pmos[ige]
print @n.xbgr.xm47_u5.nsg13_hv_pmos[ise]
print @n.xbgr.xm47_u5.nsg13_hv_pmos[ibe]
print @n.xbgr.xm47_u5.nsg13_hv_pmos[ctype]
print @n.xbgr.xm47_u6.nsg13_hv_pmos[ide]
print @n.xbgr.xm47_u6.nsg13_hv_pmos[ige]
print @n.xbgr.xm47_u6.nsg13_hv_pmos[ise]
print @n.xbgr.xm47_u6.nsg13_hv_pmos[ibe]
print @n.xbgr.xm47_u6.nsg13_hv_pmos[ctype]
print @n.xbgr.xm47_u7.nsg13_hv_pmos[ide]
print @n.xbgr.xm47_u7.nsg13_hv_pmos[ige]
print @n.xbgr.xm47_u7.nsg13_hv_pmos[ise]
print @n.xbgr.xm47_u7.nsg13_hv_pmos[ibe]
print @n.xbgr.xm47_u7.nsg13_hv_pmos[ctype]
print @n.xbgr.xm47_u8.nsg13_hv_pmos[ide]
print @n.xbgr.xm47_u8.nsg13_hv_pmos[ige]
print @n.xbgr.xm47_u8.nsg13_hv_pmos[ise]
print @n.xbgr.xm47_u8.nsg13_hv_pmos[ibe]
print @n.xbgr.xm47_u8.nsg13_hv_pmos[ctype]
print @n.xbgr.xm47_u9.nsg13_hv_pmos[ide]
print @n.xbgr.xm47_u9.nsg13_hv_pmos[ige]
print @n.xbgr.xm47_u9.nsg13_hv_pmos[ise]
print @n.xbgr.xm47_u9.nsg13_hv_pmos[ibe]
print @n.xbgr.xm47_u9.nsg13_hv_pmos[ctype]
print @n.xbgr.xm47_u10.nsg13_hv_pmos[ide]
print @n.xbgr.xm47_u10.nsg13_hv_pmos[ige]
print @n.xbgr.xm47_u10.nsg13_hv_pmos[ise]
print @n.xbgr.xm47_u10.nsg13_hv_pmos[ibe]
print @n.xbgr.xm47_u10.nsg13_hv_pmos[ctype]
print @n.xbgr.xm47_u11.nsg13_hv_pmos[ide]
print @n.xbgr.xm47_u11.nsg13_hv_pmos[ige]
print @n.xbgr.xm47_u11.nsg13_hv_pmos[ise]
print @n.xbgr.xm47_u11.nsg13_hv_pmos[ibe]
print @n.xbgr.xm47_u11.nsg13_hv_pmos[ctype]
print @n.xbgr.xm47_u12.nsg13_hv_pmos[ide]
print @n.xbgr.xm47_u12.nsg13_hv_pmos[ige]
print @n.xbgr.xm47_u12.nsg13_hv_pmos[ise]
print @n.xbgr.xm47_u12.nsg13_hv_pmos[ibe]
print @n.xbgr.xm47_u12.nsg13_hv_pmos[ctype]
print @n.xbgr.xm47_u13.nsg13_hv_pmos[ide]
print @n.xbgr.xm47_u13.nsg13_hv_pmos[ige]
print @n.xbgr.xm47_u13.nsg13_hv_pmos[ise]
print @n.xbgr.xm47_u13.nsg13_hv_pmos[ibe]
print @n.xbgr.xm47_u13.nsg13_hv_pmos[ctype]
print @n.xbgr.xm47_u14.nsg13_hv_pmos[ide]
print @n.xbgr.xm47_u14.nsg13_hv_pmos[ige]
print @n.xbgr.xm47_u14.nsg13_hv_pmos[ise]
print @n.xbgr.xm47_u14.nsg13_hv_pmos[ibe]
print @n.xbgr.xm47_u14.nsg13_hv_pmos[ctype]
print @n.xbgr.xm47_u15.nsg13_hv_pmos[ide]
print @n.xbgr.xm47_u15.nsg13_hv_pmos[ige]
print @n.xbgr.xm47_u15.nsg13_hv_pmos[ise]
print @n.xbgr.xm47_u15.nsg13_hv_pmos[ibe]
print @n.xbgr.xm47_u15.nsg13_hv_pmos[ctype]
print @n.xbgr.xm47_u16.nsg13_hv_pmos[ide]
print @n.xbgr.xm47_u16.nsg13_hv_pmos[ige]
print @n.xbgr.xm47_u16.nsg13_hv_pmos[ise]
print @n.xbgr.xm47_u16.nsg13_hv_pmos[ibe]
print @n.xbgr.xm47_u16.nsg13_hv_pmos[ctype]
print @n.xbgr.xm47_u17.nsg13_hv_pmos[ide]
print @n.xbgr.xm47_u17.nsg13_hv_pmos[ige]
print @n.xbgr.xm47_u17.nsg13_hv_pmos[ise]
print @n.xbgr.xm47_u17.nsg13_hv_pmos[ibe]
print @n.xbgr.xm47_u17.nsg13_hv_pmos[ctype]
print @n.xbgr.xm47_u18.nsg13_hv_pmos[ide]
print @n.xbgr.xm47_u18.nsg13_hv_pmos[ige]
print @n.xbgr.xm47_u18.nsg13_hv_pmos[ise]
print @n.xbgr.xm47_u18.nsg13_hv_pmos[ibe]
print @n.xbgr.xm47_u18.nsg13_hv_pmos[ctype]
print @n.xbgr.xm47_u19.nsg13_hv_pmos[ide]
print @n.xbgr.xm47_u19.nsg13_hv_pmos[ige]
print @n.xbgr.xm47_u19.nsg13_hv_pmos[ise]
print @n.xbgr.xm47_u19.nsg13_hv_pmos[ibe]
print @n.xbgr.xm47_u19.nsg13_hv_pmos[ctype]
print @n.xbgr.xm47_u20.nsg13_hv_pmos[ide]
print @n.xbgr.xm47_u20.nsg13_hv_pmos[ige]
print @n.xbgr.xm47_u20.nsg13_hv_pmos[ise]
print @n.xbgr.xm47_u20.nsg13_hv_pmos[ibe]
print @n.xbgr.xm47_u20.nsg13_hv_pmos[ctype]
print @n.xbgr.xm47_u21.nsg13_hv_pmos[ide]
print @n.xbgr.xm47_u21.nsg13_hv_pmos[ige]
print @n.xbgr.xm47_u21.nsg13_hv_pmos[ise]
print @n.xbgr.xm47_u21.nsg13_hv_pmos[ibe]
print @n.xbgr.xm47_u21.nsg13_hv_pmos[ctype]
print @n.xbgr.xm47_u22.nsg13_hv_pmos[ide]
print @n.xbgr.xm47_u22.nsg13_hv_pmos[ige]
print @n.xbgr.xm47_u22.nsg13_hv_pmos[ise]
print @n.xbgr.xm47_u22.nsg13_hv_pmos[ibe]
print @n.xbgr.xm47_u22.nsg13_hv_pmos[ctype]
print @n.xbgr.xm47_u23.nsg13_hv_pmos[ide]
print @n.xbgr.xm47_u23.nsg13_hv_pmos[ige]
print @n.xbgr.xm47_u23.nsg13_hv_pmos[ise]
print @n.xbgr.xm47_u23.nsg13_hv_pmos[ibe]
print @n.xbgr.xm47_u23.nsg13_hv_pmos[ctype]
print @n.xbgr.xm47_u24.nsg13_hv_pmos[ide]
print @n.xbgr.xm47_u24.nsg13_hv_pmos[ige]
print @n.xbgr.xm47_u24.nsg13_hv_pmos[ise]
print @n.xbgr.xm47_u24.nsg13_hv_pmos[ibe]
print @n.xbgr.xm47_u24.nsg13_hv_pmos[ctype]
print @n.xbgr.xm48_u2.nsg13_hv_pmos[ide]
print @n.xbgr.xm48_u2.nsg13_hv_pmos[ige]
print @n.xbgr.xm48_u2.nsg13_hv_pmos[ise]
print @n.xbgr.xm48_u2.nsg13_hv_pmos[ibe]
print @n.xbgr.xm48_u2.nsg13_hv_pmos[ctype]
print @n.xbgr.xm48_u3.nsg13_hv_pmos[ide]
print @n.xbgr.xm48_u3.nsg13_hv_pmos[ige]
print @n.xbgr.xm48_u3.nsg13_hv_pmos[ise]
print @n.xbgr.xm48_u3.nsg13_hv_pmos[ibe]
print @n.xbgr.xm48_u3.nsg13_hv_pmos[ctype]
print @n.xbgr.xm48_u4.nsg13_hv_pmos[ide]
print @n.xbgr.xm48_u4.nsg13_hv_pmos[ige]
print @n.xbgr.xm48_u4.nsg13_hv_pmos[ise]
print @n.xbgr.xm48_u4.nsg13_hv_pmos[ibe]
print @n.xbgr.xm48_u4.nsg13_hv_pmos[ctype]
print @n.xbgr.xm48_u5.nsg13_hv_pmos[ide]
print @n.xbgr.xm48_u5.nsg13_hv_pmos[ige]
print @n.xbgr.xm48_u5.nsg13_hv_pmos[ise]
print @n.xbgr.xm48_u5.nsg13_hv_pmos[ibe]
print @n.xbgr.xm48_u5.nsg13_hv_pmos[ctype]
print @n.xbgr.xm48_u6.nsg13_hv_pmos[ide]
print @n.xbgr.xm48_u6.nsg13_hv_pmos[ige]
print @n.xbgr.xm48_u6.nsg13_hv_pmos[ise]
print @n.xbgr.xm48_u6.nsg13_hv_pmos[ibe]
print @n.xbgr.xm48_u6.nsg13_hv_pmos[ctype]
print @n.xbgr.xm48_u7.nsg13_hv_pmos[ide]
print @n.xbgr.xm48_u7.nsg13_hv_pmos[ige]
print @n.xbgr.xm48_u7.nsg13_hv_pmos[ise]
print @n.xbgr.xm48_u7.nsg13_hv_pmos[ibe]
print @n.xbgr.xm48_u7.nsg13_hv_pmos[ctype]
print @n.xbgr.xm48_u8.nsg13_hv_pmos[ide]
print @n.xbgr.xm48_u8.nsg13_hv_pmos[ige]
print @n.xbgr.xm48_u8.nsg13_hv_pmos[ise]
print @n.xbgr.xm48_u8.nsg13_hv_pmos[ibe]
print @n.xbgr.xm48_u8.nsg13_hv_pmos[ctype]
print @n.xbgr.xm48_u9.nsg13_hv_pmos[ide]
print @n.xbgr.xm48_u9.nsg13_hv_pmos[ige]
print @n.xbgr.xm48_u9.nsg13_hv_pmos[ise]
print @n.xbgr.xm48_u9.nsg13_hv_pmos[ibe]
print @n.xbgr.xm48_u9.nsg13_hv_pmos[ctype]
print @n.xbgr.xm48_u10.nsg13_hv_pmos[ide]
print @n.xbgr.xm48_u10.nsg13_hv_pmos[ige]
print @n.xbgr.xm48_u10.nsg13_hv_pmos[ise]
print @n.xbgr.xm48_u10.nsg13_hv_pmos[ibe]
print @n.xbgr.xm48_u10.nsg13_hv_pmos[ctype]
print @n.xbgr.xm48_u11.nsg13_hv_pmos[ide]
print @n.xbgr.xm48_u11.nsg13_hv_pmos[ige]
print @n.xbgr.xm48_u11.nsg13_hv_pmos[ise]
print @n.xbgr.xm48_u11.nsg13_hv_pmos[ibe]
print @n.xbgr.xm48_u11.nsg13_hv_pmos[ctype]
print @n.xbgr.xm48_u12.nsg13_hv_pmos[ide]
print @n.xbgr.xm48_u12.nsg13_hv_pmos[ige]
print @n.xbgr.xm48_u12.nsg13_hv_pmos[ise]
print @n.xbgr.xm48_u12.nsg13_hv_pmos[ibe]
print @n.xbgr.xm48_u12.nsg13_hv_pmos[ctype]
print @n.xbgr.xm48_u13.nsg13_hv_pmos[ide]
print @n.xbgr.xm48_u13.nsg13_hv_pmos[ige]
print @n.xbgr.xm48_u13.nsg13_hv_pmos[ise]
print @n.xbgr.xm48_u13.nsg13_hv_pmos[ibe]
print @n.xbgr.xm48_u13.nsg13_hv_pmos[ctype]
print @n.xbgr.xm48_u14.nsg13_hv_pmos[ide]
print @n.xbgr.xm48_u14.nsg13_hv_pmos[ige]
print @n.xbgr.xm48_u14.nsg13_hv_pmos[ise]
print @n.xbgr.xm48_u14.nsg13_hv_pmos[ibe]
print @n.xbgr.xm48_u14.nsg13_hv_pmos[ctype]
print @n.xbgr.xm48_u15.nsg13_hv_pmos[ide]
print @n.xbgr.xm48_u15.nsg13_hv_pmos[ige]
print @n.xbgr.xm48_u15.nsg13_hv_pmos[ise]
print @n.xbgr.xm48_u15.nsg13_hv_pmos[ibe]
print @n.xbgr.xm48_u15.nsg13_hv_pmos[ctype]
print @n.xbgr.xm48_u16.nsg13_hv_pmos[ide]
print @n.xbgr.xm48_u16.nsg13_hv_pmos[ige]
print @n.xbgr.xm48_u16.nsg13_hv_pmos[ise]
print @n.xbgr.xm48_u16.nsg13_hv_pmos[ibe]
print @n.xbgr.xm48_u16.nsg13_hv_pmos[ctype]
print @n.xbgr.xm48_u17.nsg13_hv_pmos[ide]
print @n.xbgr.xm48_u17.nsg13_hv_pmos[ige]
print @n.xbgr.xm48_u17.nsg13_hv_pmos[ise]
print @n.xbgr.xm48_u17.nsg13_hv_pmos[ibe]
print @n.xbgr.xm48_u17.nsg13_hv_pmos[ctype]
print @n.xbgr.xm48_u18.nsg13_hv_pmos[ide]
print @n.xbgr.xm48_u18.nsg13_hv_pmos[ige]
print @n.xbgr.xm48_u18.nsg13_hv_pmos[ise]
print @n.xbgr.xm48_u18.nsg13_hv_pmos[ibe]
print @n.xbgr.xm48_u18.nsg13_hv_pmos[ctype]
print @n.xbgr.xm48_u19.nsg13_hv_pmos[ide]
print @n.xbgr.xm48_u19.nsg13_hv_pmos[ige]
print @n.xbgr.xm48_u19.nsg13_hv_pmos[ise]
print @n.xbgr.xm48_u19.nsg13_hv_pmos[ibe]
print @n.xbgr.xm48_u19.nsg13_hv_pmos[ctype]
print @n.xbgr.xm48_u20.nsg13_hv_pmos[ide]
print @n.xbgr.xm48_u20.nsg13_hv_pmos[ige]
print @n.xbgr.xm48_u20.nsg13_hv_pmos[ise]
print @n.xbgr.xm48_u20.nsg13_hv_pmos[ibe]
print @n.xbgr.xm48_u20.nsg13_hv_pmos[ctype]
print @n.xbgr.xm48_u21.nsg13_hv_pmos[ide]
print @n.xbgr.xm48_u21.nsg13_hv_pmos[ige]
print @n.xbgr.xm48_u21.nsg13_hv_pmos[ise]
print @n.xbgr.xm48_u21.nsg13_hv_pmos[ibe]
print @n.xbgr.xm48_u21.nsg13_hv_pmos[ctype]
print @n.xbgr.xm48_u22.nsg13_hv_pmos[ide]
print @n.xbgr.xm48_u22.nsg13_hv_pmos[ige]
print @n.xbgr.xm48_u22.nsg13_hv_pmos[ise]
print @n.xbgr.xm48_u22.nsg13_hv_pmos[ibe]
print @n.xbgr.xm48_u22.nsg13_hv_pmos[ctype]
print @n.xbgr.xm48_u23.nsg13_hv_pmos[ide]
print @n.xbgr.xm48_u23.nsg13_hv_pmos[ige]
print @n.xbgr.xm48_u23.nsg13_hv_pmos[ise]
print @n.xbgr.xm48_u23.nsg13_hv_pmos[ibe]
print @n.xbgr.xm48_u23.nsg13_hv_pmos[ctype]
print @n.xbgr.xm48_u24.nsg13_hv_pmos[ide]
print @n.xbgr.xm48_u24.nsg13_hv_pmos[ige]
print @n.xbgr.xm48_u24.nsg13_hv_pmos[ise]
print @n.xbgr.xm48_u24.nsg13_hv_pmos[ibe]
print @n.xbgr.xm48_u24.nsg13_hv_pmos[ctype]
print @n.xbgr.xm50_u2.nsg13_hv_pmos[ide]
print @n.xbgr.xm50_u2.nsg13_hv_pmos[ige]
print @n.xbgr.xm50_u2.nsg13_hv_pmos[ise]
print @n.xbgr.xm50_u2.nsg13_hv_pmos[ibe]
print @n.xbgr.xm50_u2.nsg13_hv_pmos[ctype]
print @n.xbgr.xm50_u3.nsg13_hv_pmos[ide]
print @n.xbgr.xm50_u3.nsg13_hv_pmos[ige]
print @n.xbgr.xm50_u3.nsg13_hv_pmos[ise]
print @n.xbgr.xm50_u3.nsg13_hv_pmos[ibe]
print @n.xbgr.xm50_u3.nsg13_hv_pmos[ctype]
print @n.xbgr.xm50_u4.nsg13_hv_pmos[ide]
print @n.xbgr.xm50_u4.nsg13_hv_pmos[ige]
print @n.xbgr.xm50_u4.nsg13_hv_pmos[ise]
print @n.xbgr.xm50_u4.nsg13_hv_pmos[ibe]
print @n.xbgr.xm50_u4.nsg13_hv_pmos[ctype]
print @n.xbgr.xm50_u5.nsg13_hv_pmos[ide]
print @n.xbgr.xm50_u5.nsg13_hv_pmos[ige]
print @n.xbgr.xm50_u5.nsg13_hv_pmos[ise]
print @n.xbgr.xm50_u5.nsg13_hv_pmos[ibe]
print @n.xbgr.xm50_u5.nsg13_hv_pmos[ctype]
print @n.xbgr.xm50_u6.nsg13_hv_pmos[ide]
print @n.xbgr.xm50_u6.nsg13_hv_pmos[ige]
print @n.xbgr.xm50_u6.nsg13_hv_pmos[ise]
print @n.xbgr.xm50_u6.nsg13_hv_pmos[ibe]
print @n.xbgr.xm50_u6.nsg13_hv_pmos[ctype]
print @n.xbgr.xm50_u7.nsg13_hv_pmos[ide]
print @n.xbgr.xm50_u7.nsg13_hv_pmos[ige]
print @n.xbgr.xm50_u7.nsg13_hv_pmos[ise]
print @n.xbgr.xm50_u7.nsg13_hv_pmos[ibe]
print @n.xbgr.xm50_u7.nsg13_hv_pmos[ctype]
print @n.xbgr.xm50_u8.nsg13_hv_pmos[ide]
print @n.xbgr.xm50_u8.nsg13_hv_pmos[ige]
print @n.xbgr.xm50_u8.nsg13_hv_pmos[ise]
print @n.xbgr.xm50_u8.nsg13_hv_pmos[ibe]
print @n.xbgr.xm50_u8.nsg13_hv_pmos[ctype]
print @n.xbgr.xm50_u9.nsg13_hv_pmos[ide]
print @n.xbgr.xm50_u9.nsg13_hv_pmos[ige]
print @n.xbgr.xm50_u9.nsg13_hv_pmos[ise]
print @n.xbgr.xm50_u9.nsg13_hv_pmos[ibe]
print @n.xbgr.xm50_u9.nsg13_hv_pmos[ctype]
print @n.xbgr.xm50_u10.nsg13_hv_pmos[ide]
print @n.xbgr.xm50_u10.nsg13_hv_pmos[ige]
print @n.xbgr.xm50_u10.nsg13_hv_pmos[ise]
print @n.xbgr.xm50_u10.nsg13_hv_pmos[ibe]
print @n.xbgr.xm50_u10.nsg13_hv_pmos[ctype]
print @n.xbgr.xm50_u11.nsg13_hv_pmos[ide]
print @n.xbgr.xm50_u11.nsg13_hv_pmos[ige]
print @n.xbgr.xm50_u11.nsg13_hv_pmos[ise]
print @n.xbgr.xm50_u11.nsg13_hv_pmos[ibe]
print @n.xbgr.xm50_u11.nsg13_hv_pmos[ctype]
print @n.xbgr.xm50_u12.nsg13_hv_pmos[ide]
print @n.xbgr.xm50_u12.nsg13_hv_pmos[ige]
print @n.xbgr.xm50_u12.nsg13_hv_pmos[ise]
print @n.xbgr.xm50_u12.nsg13_hv_pmos[ibe]
print @n.xbgr.xm50_u12.nsg13_hv_pmos[ctype]
print @n.xbgr.xm50_u13.nsg13_hv_pmos[ide]
print @n.xbgr.xm50_u13.nsg13_hv_pmos[ige]
print @n.xbgr.xm50_u13.nsg13_hv_pmos[ise]
print @n.xbgr.xm50_u13.nsg13_hv_pmos[ibe]
print @n.xbgr.xm50_u13.nsg13_hv_pmos[ctype]
print @n.xbgr.xm50_u14.nsg13_hv_pmos[ide]
print @n.xbgr.xm50_u14.nsg13_hv_pmos[ige]
print @n.xbgr.xm50_u14.nsg13_hv_pmos[ise]
print @n.xbgr.xm50_u14.nsg13_hv_pmos[ibe]
print @n.xbgr.xm50_u14.nsg13_hv_pmos[ctype]
print @n.xbgr.xm50_u15.nsg13_hv_pmos[ide]
print @n.xbgr.xm50_u15.nsg13_hv_pmos[ige]
print @n.xbgr.xm50_u15.nsg13_hv_pmos[ise]
print @n.xbgr.xm50_u15.nsg13_hv_pmos[ibe]
print @n.xbgr.xm50_u15.nsg13_hv_pmos[ctype]
print @n.xbgr.xm50_u16.nsg13_hv_pmos[ide]
print @n.xbgr.xm50_u16.nsg13_hv_pmos[ige]
print @n.xbgr.xm50_u16.nsg13_hv_pmos[ise]
print @n.xbgr.xm50_u16.nsg13_hv_pmos[ibe]
print @n.xbgr.xm50_u16.nsg13_hv_pmos[ctype]
print @n.xbgr.xm50_u17.nsg13_hv_pmos[ide]
print @n.xbgr.xm50_u17.nsg13_hv_pmos[ige]
print @n.xbgr.xm50_u17.nsg13_hv_pmos[ise]
print @n.xbgr.xm50_u17.nsg13_hv_pmos[ibe]
print @n.xbgr.xm50_u17.nsg13_hv_pmos[ctype]
print @n.xbgr.xm50_u18.nsg13_hv_pmos[ide]
print @n.xbgr.xm50_u18.nsg13_hv_pmos[ige]
print @n.xbgr.xm50_u18.nsg13_hv_pmos[ise]
print @n.xbgr.xm50_u18.nsg13_hv_pmos[ibe]
print @n.xbgr.xm50_u18.nsg13_hv_pmos[ctype]
print @n.xbgr.xm50_u19.nsg13_hv_pmos[ide]
print @n.xbgr.xm50_u19.nsg13_hv_pmos[ige]
print @n.xbgr.xm50_u19.nsg13_hv_pmos[ise]
print @n.xbgr.xm50_u19.nsg13_hv_pmos[ibe]
print @n.xbgr.xm50_u19.nsg13_hv_pmos[ctype]
print @n.xbgr.xm50_u20.nsg13_hv_pmos[ide]
print @n.xbgr.xm50_u20.nsg13_hv_pmos[ige]
print @n.xbgr.xm50_u20.nsg13_hv_pmos[ise]
print @n.xbgr.xm50_u20.nsg13_hv_pmos[ibe]
print @n.xbgr.xm50_u20.nsg13_hv_pmos[ctype]
print @n.xbgr.xm50_u21.nsg13_hv_pmos[ide]
print @n.xbgr.xm50_u21.nsg13_hv_pmos[ige]
print @n.xbgr.xm50_u21.nsg13_hv_pmos[ise]
print @n.xbgr.xm50_u21.nsg13_hv_pmos[ibe]
print @n.xbgr.xm50_u21.nsg13_hv_pmos[ctype]
print @n.xbgr.xm50_u22.nsg13_hv_pmos[ide]
print @n.xbgr.xm50_u22.nsg13_hv_pmos[ige]
print @n.xbgr.xm50_u22.nsg13_hv_pmos[ise]
print @n.xbgr.xm50_u22.nsg13_hv_pmos[ibe]
print @n.xbgr.xm50_u22.nsg13_hv_pmos[ctype]
print @n.xbgr.xm50_u23.nsg13_hv_pmos[ide]
print @n.xbgr.xm50_u23.nsg13_hv_pmos[ige]
print @n.xbgr.xm50_u23.nsg13_hv_pmos[ise]
print @n.xbgr.xm50_u23.nsg13_hv_pmos[ibe]
print @n.xbgr.xm50_u23.nsg13_hv_pmos[ctype]
print @n.xbgr.xm50_u24.nsg13_hv_pmos[ide]
print @n.xbgr.xm50_u24.nsg13_hv_pmos[ige]
print @n.xbgr.xm50_u24.nsg13_hv_pmos[ise]
print @n.xbgr.xm50_u24.nsg13_hv_pmos[ibe]
print @n.xbgr.xm50_u24.nsg13_hv_pmos[ctype]
print @n.xbgr.xm51_u2.nsg13_hv_pmos[ide]
print @n.xbgr.xm51_u2.nsg13_hv_pmos[ige]
print @n.xbgr.xm51_u2.nsg13_hv_pmos[ise]
print @n.xbgr.xm51_u2.nsg13_hv_pmos[ibe]
print @n.xbgr.xm51_u2.nsg13_hv_pmos[ctype]
print @n.xbgr.xm51_u3.nsg13_hv_pmos[ide]
print @n.xbgr.xm51_u3.nsg13_hv_pmos[ige]
print @n.xbgr.xm51_u3.nsg13_hv_pmos[ise]
print @n.xbgr.xm51_u3.nsg13_hv_pmos[ibe]
print @n.xbgr.xm51_u3.nsg13_hv_pmos[ctype]
print @n.xbgr.xm51_u4.nsg13_hv_pmos[ide]
print @n.xbgr.xm51_u4.nsg13_hv_pmos[ige]
print @n.xbgr.xm51_u4.nsg13_hv_pmos[ise]
print @n.xbgr.xm51_u4.nsg13_hv_pmos[ibe]
print @n.xbgr.xm51_u4.nsg13_hv_pmos[ctype]
print @n.xbgr.xm52_u2.nsg13_hv_pmos[ide]
print @n.xbgr.xm52_u2.nsg13_hv_pmos[ige]
print @n.xbgr.xm52_u2.nsg13_hv_pmos[ise]
print @n.xbgr.xm52_u2.nsg13_hv_pmos[ibe]
print @n.xbgr.xm52_u2.nsg13_hv_pmos[ctype]
print @n.xbgr.xm52_u3.nsg13_hv_pmos[ide]
print @n.xbgr.xm52_u3.nsg13_hv_pmos[ige]
print @n.xbgr.xm52_u3.nsg13_hv_pmos[ise]
print @n.xbgr.xm52_u3.nsg13_hv_pmos[ibe]
print @n.xbgr.xm52_u3.nsg13_hv_pmos[ctype]
print @n.xbgr.xm52_u4.nsg13_hv_pmos[ide]
print @n.xbgr.xm52_u4.nsg13_hv_pmos[ige]
print @n.xbgr.xm52_u4.nsg13_hv_pmos[ise]
print @n.xbgr.xm52_u4.nsg13_hv_pmos[ibe]
print @n.xbgr.xm52_u4.nsg13_hv_pmos[ctype]
print @n.xbgr.xm52_u5.nsg13_hv_pmos[ide]
print @n.xbgr.xm52_u5.nsg13_hv_pmos[ige]
print @n.xbgr.xm52_u5.nsg13_hv_pmos[ise]
print @n.xbgr.xm52_u5.nsg13_hv_pmos[ibe]
print @n.xbgr.xm52_u5.nsg13_hv_pmos[ctype]
print @n.xbgr.xm52_u6.nsg13_hv_pmos[ide]
print @n.xbgr.xm52_u6.nsg13_hv_pmos[ige]
print @n.xbgr.xm52_u6.nsg13_hv_pmos[ise]
print @n.xbgr.xm52_u6.nsg13_hv_pmos[ibe]
print @n.xbgr.xm52_u6.nsg13_hv_pmos[ctype]
print @n.xbgr.xm52_u7.nsg13_hv_pmos[ide]
print @n.xbgr.xm52_u7.nsg13_hv_pmos[ige]
print @n.xbgr.xm52_u7.nsg13_hv_pmos[ise]
print @n.xbgr.xm52_u7.nsg13_hv_pmos[ibe]
print @n.xbgr.xm52_u7.nsg13_hv_pmos[ctype]
print @n.xbgr.xm52_u8.nsg13_hv_pmos[ide]
print @n.xbgr.xm52_u8.nsg13_hv_pmos[ige]
print @n.xbgr.xm52_u8.nsg13_hv_pmos[ise]
print @n.xbgr.xm52_u8.nsg13_hv_pmos[ibe]
print @n.xbgr.xm52_u8.nsg13_hv_pmos[ctype]
print @n.xbgr.xm52_u9.nsg13_hv_pmos[ide]
print @n.xbgr.xm52_u9.nsg13_hv_pmos[ige]
print @n.xbgr.xm52_u9.nsg13_hv_pmos[ise]
print @n.xbgr.xm52_u9.nsg13_hv_pmos[ibe]
print @n.xbgr.xm52_u9.nsg13_hv_pmos[ctype]
print @n.xbgr.xm52_u10.nsg13_hv_pmos[ide]
print @n.xbgr.xm52_u10.nsg13_hv_pmos[ige]
print @n.xbgr.xm52_u10.nsg13_hv_pmos[ise]
print @n.xbgr.xm52_u10.nsg13_hv_pmos[ibe]
print @n.xbgr.xm52_u10.nsg13_hv_pmos[ctype]
print @n.xbgr.xm52_u11.nsg13_hv_pmos[ide]
print @n.xbgr.xm52_u11.nsg13_hv_pmos[ige]
print @n.xbgr.xm52_u11.nsg13_hv_pmos[ise]
print @n.xbgr.xm52_u11.nsg13_hv_pmos[ibe]
print @n.xbgr.xm52_u11.nsg13_hv_pmos[ctype]
print @n.xbgr.xm52_u12.nsg13_hv_pmos[ide]
print @n.xbgr.xm52_u12.nsg13_hv_pmos[ige]
print @n.xbgr.xm52_u12.nsg13_hv_pmos[ise]
print @n.xbgr.xm52_u12.nsg13_hv_pmos[ibe]
print @n.xbgr.xm52_u12.nsg13_hv_pmos[ctype]
print @n.xbgr.xm52_u13.nsg13_hv_pmos[ide]
print @n.xbgr.xm52_u13.nsg13_hv_pmos[ige]
print @n.xbgr.xm52_u13.nsg13_hv_pmos[ise]
print @n.xbgr.xm52_u13.nsg13_hv_pmos[ibe]
print @n.xbgr.xm52_u13.nsg13_hv_pmos[ctype]
print @n.xbgr.xm52_u14.nsg13_hv_pmos[ide]
print @n.xbgr.xm52_u14.nsg13_hv_pmos[ige]
print @n.xbgr.xm52_u14.nsg13_hv_pmos[ise]
print @n.xbgr.xm52_u14.nsg13_hv_pmos[ibe]
print @n.xbgr.xm52_u14.nsg13_hv_pmos[ctype]
print @n.xbgr.xm52_u15.nsg13_hv_pmos[ide]
print @n.xbgr.xm52_u15.nsg13_hv_pmos[ige]
print @n.xbgr.xm52_u15.nsg13_hv_pmos[ise]
print @n.xbgr.xm52_u15.nsg13_hv_pmos[ibe]
print @n.xbgr.xm52_u15.nsg13_hv_pmos[ctype]
print @n.xbgr.xm52_u16.nsg13_hv_pmos[ide]
print @n.xbgr.xm52_u16.nsg13_hv_pmos[ige]
print @n.xbgr.xm52_u16.nsg13_hv_pmos[ise]
print @n.xbgr.xm52_u16.nsg13_hv_pmos[ibe]
print @n.xbgr.xm52_u16.nsg13_hv_pmos[ctype]
print @n.xbgr.xm52_u17.nsg13_hv_pmos[ide]
print @n.xbgr.xm52_u17.nsg13_hv_pmos[ige]
print @n.xbgr.xm52_u17.nsg13_hv_pmos[ise]
print @n.xbgr.xm52_u17.nsg13_hv_pmos[ibe]
print @n.xbgr.xm52_u17.nsg13_hv_pmos[ctype]
print @n.xbgr.xm52_u18.nsg13_hv_pmos[ide]
print @n.xbgr.xm52_u18.nsg13_hv_pmos[ige]
print @n.xbgr.xm52_u18.nsg13_hv_pmos[ise]
print @n.xbgr.xm52_u18.nsg13_hv_pmos[ibe]
print @n.xbgr.xm52_u18.nsg13_hv_pmos[ctype]
print @n.xbgr.xm52_u19.nsg13_hv_pmos[ide]
print @n.xbgr.xm52_u19.nsg13_hv_pmos[ige]
print @n.xbgr.xm52_u19.nsg13_hv_pmos[ise]
print @n.xbgr.xm52_u19.nsg13_hv_pmos[ibe]
print @n.xbgr.xm52_u19.nsg13_hv_pmos[ctype]
print @n.xbgr.xm52_u20.nsg13_hv_pmos[ide]
print @n.xbgr.xm52_u20.nsg13_hv_pmos[ige]
print @n.xbgr.xm52_u20.nsg13_hv_pmos[ise]
print @n.xbgr.xm52_u20.nsg13_hv_pmos[ibe]
print @n.xbgr.xm52_u20.nsg13_hv_pmos[ctype]
print @n.xbgr.xm52_u21.nsg13_hv_pmos[ide]
print @n.xbgr.xm52_u21.nsg13_hv_pmos[ige]
print @n.xbgr.xm52_u21.nsg13_hv_pmos[ise]
print @n.xbgr.xm52_u21.nsg13_hv_pmos[ibe]
print @n.xbgr.xm52_u21.nsg13_hv_pmos[ctype]
print @n.xbgr.xm52_u22.nsg13_hv_pmos[ide]
print @n.xbgr.xm52_u22.nsg13_hv_pmos[ige]
print @n.xbgr.xm52_u22.nsg13_hv_pmos[ise]
print @n.xbgr.xm52_u22.nsg13_hv_pmos[ibe]
print @n.xbgr.xm52_u22.nsg13_hv_pmos[ctype]
print @n.xbgr.xm52_u23.nsg13_hv_pmos[ide]
print @n.xbgr.xm52_u23.nsg13_hv_pmos[ige]
print @n.xbgr.xm52_u23.nsg13_hv_pmos[ise]
print @n.xbgr.xm52_u23.nsg13_hv_pmos[ibe]
print @n.xbgr.xm52_u23.nsg13_hv_pmos[ctype]
print @n.xbgr.xm52_u24.nsg13_hv_pmos[ide]
print @n.xbgr.xm52_u24.nsg13_hv_pmos[ige]
print @n.xbgr.xm52_u24.nsg13_hv_pmos[ise]
print @n.xbgr.xm52_u24.nsg13_hv_pmos[ibe]
print @n.xbgr.xm52_u24.nsg13_hv_pmos[ctype]
print @n.xbgr.xm54_u2.nsg13_hv_pmos[ide]
print @n.xbgr.xm54_u2.nsg13_hv_pmos[ige]
print @n.xbgr.xm54_u2.nsg13_hv_pmos[ise]
print @n.xbgr.xm54_u2.nsg13_hv_pmos[ibe]
print @n.xbgr.xm54_u2.nsg13_hv_pmos[ctype]
print @n.xbgr.xm54_u3.nsg13_hv_pmos[ide]
print @n.xbgr.xm54_u3.nsg13_hv_pmos[ige]
print @n.xbgr.xm54_u3.nsg13_hv_pmos[ise]
print @n.xbgr.xm54_u3.nsg13_hv_pmos[ibe]
print @n.xbgr.xm54_u3.nsg13_hv_pmos[ctype]
print @n.xbgr.xm54_u4.nsg13_hv_pmos[ide]
print @n.xbgr.xm54_u4.nsg13_hv_pmos[ige]
print @n.xbgr.xm54_u4.nsg13_hv_pmos[ise]
print @n.xbgr.xm54_u4.nsg13_hv_pmos[ibe]
print @n.xbgr.xm54_u4.nsg13_hv_pmos[ctype]
print @n.xbgr.xm54_u5.nsg13_hv_pmos[ide]
print @n.xbgr.xm54_u5.nsg13_hv_pmos[ige]
print @n.xbgr.xm54_u5.nsg13_hv_pmos[ise]
print @n.xbgr.xm54_u5.nsg13_hv_pmos[ibe]
print @n.xbgr.xm54_u5.nsg13_hv_pmos[ctype]
print @n.xbgr.xm54_u6.nsg13_hv_pmos[ide]
print @n.xbgr.xm54_u6.nsg13_hv_pmos[ige]
print @n.xbgr.xm54_u6.nsg13_hv_pmos[ise]
print @n.xbgr.xm54_u6.nsg13_hv_pmos[ibe]
print @n.xbgr.xm54_u6.nsg13_hv_pmos[ctype]
print @n.xbgr.xm54_u7.nsg13_hv_pmos[ide]
print @n.xbgr.xm54_u7.nsg13_hv_pmos[ige]
print @n.xbgr.xm54_u7.nsg13_hv_pmos[ise]
print @n.xbgr.xm54_u7.nsg13_hv_pmos[ibe]
print @n.xbgr.xm54_u7.nsg13_hv_pmos[ctype]
print @n.xbgr.xm54_u8.nsg13_hv_pmos[ide]
print @n.xbgr.xm54_u8.nsg13_hv_pmos[ige]
print @n.xbgr.xm54_u8.nsg13_hv_pmos[ise]
print @n.xbgr.xm54_u8.nsg13_hv_pmos[ibe]
print @n.xbgr.xm54_u8.nsg13_hv_pmos[ctype]
print @n.xbgr.xm54_u9.nsg13_hv_pmos[ide]
print @n.xbgr.xm54_u9.nsg13_hv_pmos[ige]
print @n.xbgr.xm54_u9.nsg13_hv_pmos[ise]
print @n.xbgr.xm54_u9.nsg13_hv_pmos[ibe]
print @n.xbgr.xm54_u9.nsg13_hv_pmos[ctype]
print @n.xbgr.xm54_u10.nsg13_hv_pmos[ide]
print @n.xbgr.xm54_u10.nsg13_hv_pmos[ige]
print @n.xbgr.xm54_u10.nsg13_hv_pmos[ise]
print @n.xbgr.xm54_u10.nsg13_hv_pmos[ibe]
print @n.xbgr.xm54_u10.nsg13_hv_pmos[ctype]
print @n.xbgr.xm54_u11.nsg13_hv_pmos[ide]
print @n.xbgr.xm54_u11.nsg13_hv_pmos[ige]
print @n.xbgr.xm54_u11.nsg13_hv_pmos[ise]
print @n.xbgr.xm54_u11.nsg13_hv_pmos[ibe]
print @n.xbgr.xm54_u11.nsg13_hv_pmos[ctype]
print @n.xbgr.xm54_u12.nsg13_hv_pmos[ide]
print @n.xbgr.xm54_u12.nsg13_hv_pmos[ige]
print @n.xbgr.xm54_u12.nsg13_hv_pmos[ise]
print @n.xbgr.xm54_u12.nsg13_hv_pmos[ibe]
print @n.xbgr.xm54_u12.nsg13_hv_pmos[ctype]
print @n.xbgr.xm54_u13.nsg13_hv_pmos[ide]
print @n.xbgr.xm54_u13.nsg13_hv_pmos[ige]
print @n.xbgr.xm54_u13.nsg13_hv_pmos[ise]
print @n.xbgr.xm54_u13.nsg13_hv_pmos[ibe]
print @n.xbgr.xm54_u13.nsg13_hv_pmos[ctype]
print @n.xbgr.xm54_u14.nsg13_hv_pmos[ide]
print @n.xbgr.xm54_u14.nsg13_hv_pmos[ige]
print @n.xbgr.xm54_u14.nsg13_hv_pmos[ise]
print @n.xbgr.xm54_u14.nsg13_hv_pmos[ibe]
print @n.xbgr.xm54_u14.nsg13_hv_pmos[ctype]
print @n.xbgr.xm54_u15.nsg13_hv_pmos[ide]
print @n.xbgr.xm54_u15.nsg13_hv_pmos[ige]
print @n.xbgr.xm54_u15.nsg13_hv_pmos[ise]
print @n.xbgr.xm54_u15.nsg13_hv_pmos[ibe]
print @n.xbgr.xm54_u15.nsg13_hv_pmos[ctype]
print @n.xbgr.xm54_u16.nsg13_hv_pmos[ide]
print @n.xbgr.xm54_u16.nsg13_hv_pmos[ige]
print @n.xbgr.xm54_u16.nsg13_hv_pmos[ise]
print @n.xbgr.xm54_u16.nsg13_hv_pmos[ibe]
print @n.xbgr.xm54_u16.nsg13_hv_pmos[ctype]
print @n.xbgr.xm54_u17.nsg13_hv_pmos[ide]
print @n.xbgr.xm54_u17.nsg13_hv_pmos[ige]
print @n.xbgr.xm54_u17.nsg13_hv_pmos[ise]
print @n.xbgr.xm54_u17.nsg13_hv_pmos[ibe]
print @n.xbgr.xm54_u17.nsg13_hv_pmos[ctype]
print @n.xbgr.xm54_u18.nsg13_hv_pmos[ide]
print @n.xbgr.xm54_u18.nsg13_hv_pmos[ige]
print @n.xbgr.xm54_u18.nsg13_hv_pmos[ise]
print @n.xbgr.xm54_u18.nsg13_hv_pmos[ibe]
print @n.xbgr.xm54_u18.nsg13_hv_pmos[ctype]
print @n.xbgr.xm54_u19.nsg13_hv_pmos[ide]
print @n.xbgr.xm54_u19.nsg13_hv_pmos[ige]
print @n.xbgr.xm54_u19.nsg13_hv_pmos[ise]
print @n.xbgr.xm54_u19.nsg13_hv_pmos[ibe]
print @n.xbgr.xm54_u19.nsg13_hv_pmos[ctype]
print @n.xbgr.xm54_u20.nsg13_hv_pmos[ide]
print @n.xbgr.xm54_u20.nsg13_hv_pmos[ige]
print @n.xbgr.xm54_u20.nsg13_hv_pmos[ise]
print @n.xbgr.xm54_u20.nsg13_hv_pmos[ibe]
print @n.xbgr.xm54_u20.nsg13_hv_pmos[ctype]
print @n.xbgr.xm54_u21.nsg13_hv_pmos[ide]
print @n.xbgr.xm54_u21.nsg13_hv_pmos[ige]
print @n.xbgr.xm54_u21.nsg13_hv_pmos[ise]
print @n.xbgr.xm54_u21.nsg13_hv_pmos[ibe]
print @n.xbgr.xm54_u21.nsg13_hv_pmos[ctype]
print @n.xbgr.xm54_u22.nsg13_hv_pmos[ide]
print @n.xbgr.xm54_u22.nsg13_hv_pmos[ige]
print @n.xbgr.xm54_u22.nsg13_hv_pmos[ise]
print @n.xbgr.xm54_u22.nsg13_hv_pmos[ibe]
print @n.xbgr.xm54_u22.nsg13_hv_pmos[ctype]
print @n.xbgr.xm54_u23.nsg13_hv_pmos[ide]
print @n.xbgr.xm54_u23.nsg13_hv_pmos[ige]
print @n.xbgr.xm54_u23.nsg13_hv_pmos[ise]
print @n.xbgr.xm54_u23.nsg13_hv_pmos[ibe]
print @n.xbgr.xm54_u23.nsg13_hv_pmos[ctype]
print @n.xbgr.xm54_u24.nsg13_hv_pmos[ide]
print @n.xbgr.xm54_u24.nsg13_hv_pmos[ige]
print @n.xbgr.xm54_u24.nsg13_hv_pmos[ise]
print @n.xbgr.xm54_u24.nsg13_hv_pmos[ibe]
print @n.xbgr.xm54_u24.nsg13_hv_pmos[ctype]
print @q.xbgr.xq56_u2.qnpn13g2[ic]
print @q.xbgr.xq56_u2.qnpn13g2[ib]
print @q.xbgr.xq56_u2.qnpn13g2[ie]
print @q.xbgr.xq56_u2.qnpn13g2[is]
print @r.xbgr.xq56_u2.rsub[i]
print @c.xbgr.xq56_u2.csub[i]
print @q.xbgr.xq56_u3.qnpn13g2[ic]
print @q.xbgr.xq56_u3.qnpn13g2[ib]
print @q.xbgr.xq56_u3.qnpn13g2[ie]
print @q.xbgr.xq56_u3.qnpn13g2[is]
print @r.xbgr.xq56_u3.rsub[i]
print @c.xbgr.xq56_u3.csub[i]
print @q.xbgr.xq56_u4.qnpn13g2[ic]
print @q.xbgr.xq56_u4.qnpn13g2[ib]
print @q.xbgr.xq56_u4.qnpn13g2[ie]
print @q.xbgr.xq56_u4.qnpn13g2[is]
print @r.xbgr.xq56_u4.rsub[i]
print @c.xbgr.xq56_u4.csub[i]
print @q.xbgr.xq56_u5.qnpn13g2[ic]
print @q.xbgr.xq56_u5.qnpn13g2[ib]
print @q.xbgr.xq56_u5.qnpn13g2[ie]
print @q.xbgr.xq56_u5.qnpn13g2[is]
print @r.xbgr.xq56_u5.rsub[i]
print @c.xbgr.xq56_u5.csub[i]
print @q.xbgr.xq56_u6.qnpn13g2[ic]
print @q.xbgr.xq56_u6.qnpn13g2[ib]
print @q.xbgr.xq56_u6.qnpn13g2[ie]
print @q.xbgr.xq56_u6.qnpn13g2[is]
print @r.xbgr.xq56_u6.rsub[i]
print @c.xbgr.xq56_u6.csub[i]
print @q.xbgr.xq56_u7.qnpn13g2[ic]
print @q.xbgr.xq56_u7.qnpn13g2[ib]
print @q.xbgr.xq56_u7.qnpn13g2[ie]
print @q.xbgr.xq56_u7.qnpn13g2[is]
print @r.xbgr.xq56_u7.rsub[i]
print @c.xbgr.xq56_u7.csub[i]
print @q.xbgr.xq56_u8.qnpn13g2[ic]
print @q.xbgr.xq56_u8.qnpn13g2[ib]
print @q.xbgr.xq56_u8.qnpn13g2[ie]
print @q.xbgr.xq56_u8.qnpn13g2[is]
print @r.xbgr.xq56_u8.rsub[i]
print @c.xbgr.xq56_u8.csub[i]
print @q.xbgr.xq56_u9.qnpn13g2[ic]
print @q.xbgr.xq56_u9.qnpn13g2[ib]
print @q.xbgr.xq56_u9.qnpn13g2[ie]
print @q.xbgr.xq56_u9.qnpn13g2[is]
print @r.xbgr.xq56_u9.rsub[i]
print @c.xbgr.xq56_u9.csub[i]
print @q.xbgr.xq56_u10.qnpn13g2[ic]
print @q.xbgr.xq56_u10.qnpn13g2[ib]
print @q.xbgr.xq56_u10.qnpn13g2[ie]
print @q.xbgr.xq56_u10.qnpn13g2[is]
print @r.xbgr.xq56_u10.rsub[i]
print @c.xbgr.xq56_u10.csub[i]
print @q.xbgr.xq56_u11.qnpn13g2[ic]
print @q.xbgr.xq56_u11.qnpn13g2[ib]
print @q.xbgr.xq56_u11.qnpn13g2[ie]
print @q.xbgr.xq56_u11.qnpn13g2[is]
print @r.xbgr.xq56_u11.rsub[i]
print @c.xbgr.xq56_u11.csub[i]
print @q.xbgr.xq56_u12.qnpn13g2[ic]
print @q.xbgr.xq56_u12.qnpn13g2[ib]
print @q.xbgr.xq56_u12.qnpn13g2[ie]
print @q.xbgr.xq56_u12.qnpn13g2[is]
print @r.xbgr.xq56_u12.rsub[i]
print @c.xbgr.xq56_u12.csub[i]
print @q.xbgr.xq56_u13.qnpn13g2[ic]
print @q.xbgr.xq56_u13.qnpn13g2[ib]
print @q.xbgr.xq56_u13.qnpn13g2[ie]
print @q.xbgr.xq56_u13.qnpn13g2[is]
print @r.xbgr.xq56_u13.rsub[i]
print @c.xbgr.xq56_u13.csub[i]
print @q.xbgr.xq56_u14.qnpn13g2[ic]
print @q.xbgr.xq56_u14.qnpn13g2[ib]
print @q.xbgr.xq56_u14.qnpn13g2[ie]
print @q.xbgr.xq56_u14.qnpn13g2[is]
print @r.xbgr.xq56_u14.rsub[i]
print @c.xbgr.xq56_u14.csub[i]
print @q.xbgr.xq56_u15.qnpn13g2[ic]
print @q.xbgr.xq56_u15.qnpn13g2[ib]
print @q.xbgr.xq56_u15.qnpn13g2[ie]
print @q.xbgr.xq56_u15.qnpn13g2[is]
print @r.xbgr.xq56_u15.rsub[i]
print @c.xbgr.xq56_u15.csub[i]
print @q.xbgr.xq56_u16.qnpn13g2[ic]
print @q.xbgr.xq56_u16.qnpn13g2[ib]
print @q.xbgr.xq56_u16.qnpn13g2[ie]
print @q.xbgr.xq56_u16.qnpn13g2[is]
print @r.xbgr.xq56_u16.rsub[i]
print @c.xbgr.xq56_u16.csub[i]
print @q.xbgr.xq56_u17.qnpn13g2[ic]
print @q.xbgr.xq56_u17.qnpn13g2[ib]
print @q.xbgr.xq56_u17.qnpn13g2[ie]
print @q.xbgr.xq56_u17.qnpn13g2[is]
print @r.xbgr.xq56_u17.rsub[i]
print @c.xbgr.xq56_u17.csub[i]
print @q.xbgr.xq56_u18.qnpn13g2[ic]
print @q.xbgr.xq56_u18.qnpn13g2[ib]
print @q.xbgr.xq56_u18.qnpn13g2[ie]
print @q.xbgr.xq56_u18.qnpn13g2[is]
print @r.xbgr.xq56_u18.rsub[i]
print @c.xbgr.xq56_u18.csub[i]
print @q.xbgr.xq56_u19.qnpn13g2[ic]
print @q.xbgr.xq56_u19.qnpn13g2[ib]
print @q.xbgr.xq56_u19.qnpn13g2[ie]
print @q.xbgr.xq56_u19.qnpn13g2[is]
print @r.xbgr.xq56_u19.rsub[i]
print @c.xbgr.xq56_u19.csub[i]
print @q.xbgr.xq56_u20.qnpn13g2[ic]
print @q.xbgr.xq56_u20.qnpn13g2[ib]
print @q.xbgr.xq56_u20.qnpn13g2[ie]
print @q.xbgr.xq56_u20.qnpn13g2[is]
print @r.xbgr.xq56_u20.rsub[i]
print @c.xbgr.xq56_u20.csub[i]
print @q.xbgr.xq56_u21.qnpn13g2[ic]
print @q.xbgr.xq56_u21.qnpn13g2[ib]
print @q.xbgr.xq56_u21.qnpn13g2[ie]
print @q.xbgr.xq56_u21.qnpn13g2[is]
print @r.xbgr.xq56_u21.rsub[i]
print @c.xbgr.xq56_u21.csub[i]
print @q.xbgr.xq56_u22.qnpn13g2[ic]
print @q.xbgr.xq56_u22.qnpn13g2[ib]
print @q.xbgr.xq56_u22.qnpn13g2[ie]
print @q.xbgr.xq56_u22.qnpn13g2[is]
print @r.xbgr.xq56_u22.rsub[i]
print @c.xbgr.xq56_u22.csub[i]
print @q.xbgr.xq56_u23.qnpn13g2[ic]
print @q.xbgr.xq56_u23.qnpn13g2[ib]
print @q.xbgr.xq56_u23.qnpn13g2[ie]
print @q.xbgr.xq56_u23.qnpn13g2[is]
print @r.xbgr.xq56_u23.rsub[i]
print @c.xbgr.xq56_u23.csub[i]
print @q.xbgr.xq56_u24.qnpn13g2[ic]
print @q.xbgr.xq56_u24.qnpn13g2[ib]
print @q.xbgr.xq56_u24.qnpn13g2[ie]
print @q.xbgr.xq56_u24.qnpn13g2[is]
print @r.xbgr.xq56_u24.rsub[i]
print @c.xbgr.xq56_u24.csub[i]
print @q.xbgr.xq60_u2.qnpn13g2[ic]
print @q.xbgr.xq60_u2.qnpn13g2[ib]
print @q.xbgr.xq60_u2.qnpn13g2[ie]
print @q.xbgr.xq60_u2.qnpn13g2[is]
print @r.xbgr.xq60_u2.rsub[i]
print @c.xbgr.xq60_u2.csub[i]
print @q.xbgr.xq60_u3.qnpn13g2[ic]
print @q.xbgr.xq60_u3.qnpn13g2[ib]
print @q.xbgr.xq60_u3.qnpn13g2[ie]
print @q.xbgr.xq60_u3.qnpn13g2[is]
print @r.xbgr.xq60_u3.rsub[i]
print @c.xbgr.xq60_u3.csub[i]
print @q.xbgr.xq60_u4.qnpn13g2[ic]
print @q.xbgr.xq60_u4.qnpn13g2[ib]
print @q.xbgr.xq60_u4.qnpn13g2[ie]
print @q.xbgr.xq60_u4.qnpn13g2[is]
print @r.xbgr.xq60_u4.rsub[i]
print @c.xbgr.xq60_u4.csub[i]
print @q.xbgr.xq62_u2.qnpn13g2[ic]
print @q.xbgr.xq62_u2.qnpn13g2[ib]
print @q.xbgr.xq62_u2.qnpn13g2[ie]
print @q.xbgr.xq62_u2.qnpn13g2[is]
print @r.xbgr.xq62_u2.rsub[i]
print @c.xbgr.xq62_u2.csub[i]
print @q.xbgr.xq62_u3.qnpn13g2[ic]
print @q.xbgr.xq62_u3.qnpn13g2[ib]
print @q.xbgr.xq62_u3.qnpn13g2[ie]
print @q.xbgr.xq62_u3.qnpn13g2[is]
print @r.xbgr.xq62_u3.rsub[i]
print @c.xbgr.xq62_u3.csub[i]
print @q.xbgr.xq62_u4.qnpn13g2[ic]
print @q.xbgr.xq62_u4.qnpn13g2[ib]
print @q.xbgr.xq62_u4.qnpn13g2[ie]
print @q.xbgr.xq62_u4.qnpn13g2[is]
print @r.xbgr.xq62_u4.rsub[i]
print @c.xbgr.xq62_u4.csub[i]
print @q.xbgr.xq62_u5.qnpn13g2[ic]
print @q.xbgr.xq62_u5.qnpn13g2[ib]
print @q.xbgr.xq62_u5.qnpn13g2[ie]
print @q.xbgr.xq62_u5.qnpn13g2[is]
print @r.xbgr.xq62_u5.rsub[i]
print @c.xbgr.xq62_u5.csub[i]
print @q.xbgr.xq62_u6.qnpn13g2[ic]
print @q.xbgr.xq62_u6.qnpn13g2[ib]
print @q.xbgr.xq62_u6.qnpn13g2[ie]
print @q.xbgr.xq62_u6.qnpn13g2[is]
print @r.xbgr.xq62_u6.rsub[i]
print @c.xbgr.xq62_u6.csub[i]
print @q.xbgr.xq62_u7.qnpn13g2[ic]
print @q.xbgr.xq62_u7.qnpn13g2[ib]
print @q.xbgr.xq62_u7.qnpn13g2[ie]
print @q.xbgr.xq62_u7.qnpn13g2[is]
print @r.xbgr.xq62_u7.rsub[i]
print @c.xbgr.xq62_u7.csub[i]
print @q.xbgr.xq62_u8.qnpn13g2[ic]
print @q.xbgr.xq62_u8.qnpn13g2[ib]
print @q.xbgr.xq62_u8.qnpn13g2[ie]
print @q.xbgr.xq62_u8.qnpn13g2[is]
print @r.xbgr.xq62_u8.rsub[i]
print @c.xbgr.xq62_u8.csub[i]
print @q.xbgr.xq62_u9.qnpn13g2[ic]
print @q.xbgr.xq62_u9.qnpn13g2[ib]
print @q.xbgr.xq62_u9.qnpn13g2[ie]
print @q.xbgr.xq62_u9.qnpn13g2[is]
print @r.xbgr.xq62_u9.rsub[i]
print @c.xbgr.xq62_u9.csub[i]
print @q.xbgr.xq62_u10.qnpn13g2[ic]
print @q.xbgr.xq62_u10.qnpn13g2[ib]
print @q.xbgr.xq62_u10.qnpn13g2[ie]
print @q.xbgr.xq62_u10.qnpn13g2[is]
print @r.xbgr.xq62_u10.rsub[i]
print @c.xbgr.xq62_u10.csub[i]
print @q.xbgr.xq62_u11.qnpn13g2[ic]
print @q.xbgr.xq62_u11.qnpn13g2[ib]
print @q.xbgr.xq62_u11.qnpn13g2[ie]
print @q.xbgr.xq62_u11.qnpn13g2[is]
print @r.xbgr.xq62_u11.rsub[i]
print @c.xbgr.xq62_u11.csub[i]
print @q.xbgr.xq62_u12.qnpn13g2[ic]
print @q.xbgr.xq62_u12.qnpn13g2[ib]
print @q.xbgr.xq62_u12.qnpn13g2[ie]
print @q.xbgr.xq62_u12.qnpn13g2[is]
print @r.xbgr.xq62_u12.rsub[i]
print @c.xbgr.xq62_u12.csub[i]
print @q.xbgr.xq62_u13.qnpn13g2[ic]
print @q.xbgr.xq62_u13.qnpn13g2[ib]
print @q.xbgr.xq62_u13.qnpn13g2[ie]
print @q.xbgr.xq62_u13.qnpn13g2[is]
print @r.xbgr.xq62_u13.rsub[i]
print @c.xbgr.xq62_u13.csub[i]
print @q.xbgr.xq62_u14.qnpn13g2[ic]
print @q.xbgr.xq62_u14.qnpn13g2[ib]
print @q.xbgr.xq62_u14.qnpn13g2[ie]
print @q.xbgr.xq62_u14.qnpn13g2[is]
print @r.xbgr.xq62_u14.rsub[i]
print @c.xbgr.xq62_u14.csub[i]
print @q.xbgr.xq62_u15.qnpn13g2[ic]
print @q.xbgr.xq62_u15.qnpn13g2[ib]
print @q.xbgr.xq62_u15.qnpn13g2[ie]
print @q.xbgr.xq62_u15.qnpn13g2[is]
print @r.xbgr.xq62_u15.rsub[i]
print @c.xbgr.xq62_u15.csub[i]
print @q.xbgr.xq62_u16.qnpn13g2[ic]
print @q.xbgr.xq62_u16.qnpn13g2[ib]
print @q.xbgr.xq62_u16.qnpn13g2[ie]
print @q.xbgr.xq62_u16.qnpn13g2[is]
print @r.xbgr.xq62_u16.rsub[i]
print @c.xbgr.xq62_u16.csub[i]
print @q.xbgr.xq62_u17.qnpn13g2[ic]
print @q.xbgr.xq62_u17.qnpn13g2[ib]
print @q.xbgr.xq62_u17.qnpn13g2[ie]
print @q.xbgr.xq62_u17.qnpn13g2[is]
print @r.xbgr.xq62_u17.rsub[i]
print @c.xbgr.xq62_u17.csub[i]
print @q.xbgr.xq62_u18.qnpn13g2[ic]
print @q.xbgr.xq62_u18.qnpn13g2[ib]
print @q.xbgr.xq62_u18.qnpn13g2[ie]
print @q.xbgr.xq62_u18.qnpn13g2[is]
print @r.xbgr.xq62_u18.rsub[i]
print @c.xbgr.xq62_u18.csub[i]
print @q.xbgr.xq62_u19.qnpn13g2[ic]
print @q.xbgr.xq62_u19.qnpn13g2[ib]
print @q.xbgr.xq62_u19.qnpn13g2[ie]
print @q.xbgr.xq62_u19.qnpn13g2[is]
print @r.xbgr.xq62_u19.rsub[i]
print @c.xbgr.xq62_u19.csub[i]
print @q.xbgr.xq62_u20.qnpn13g2[ic]
print @q.xbgr.xq62_u20.qnpn13g2[ib]
print @q.xbgr.xq62_u20.qnpn13g2[ie]
print @q.xbgr.xq62_u20.qnpn13g2[is]
print @r.xbgr.xq62_u20.rsub[i]
print @c.xbgr.xq62_u20.csub[i]
print @q.xbgr.xq62_u21.qnpn13g2[ic]
print @q.xbgr.xq62_u21.qnpn13g2[ib]
print @q.xbgr.xq62_u21.qnpn13g2[ie]
print @q.xbgr.xq62_u21.qnpn13g2[is]
print @r.xbgr.xq62_u21.rsub[i]
print @c.xbgr.xq62_u21.csub[i]
print @q.xbgr.xq62_u22.qnpn13g2[ic]
print @q.xbgr.xq62_u22.qnpn13g2[ib]
print @q.xbgr.xq62_u22.qnpn13g2[ie]
print @q.xbgr.xq62_u22.qnpn13g2[is]
print @r.xbgr.xq62_u22.rsub[i]
print @c.xbgr.xq62_u22.csub[i]
print @q.xbgr.xq62_u23.qnpn13g2[ic]
print @q.xbgr.xq62_u23.qnpn13g2[ib]
print @q.xbgr.xq62_u23.qnpn13g2[ie]
print @q.xbgr.xq62_u23.qnpn13g2[is]
print @r.xbgr.xq62_u23.rsub[i]
print @c.xbgr.xq62_u23.csub[i]
print @q.xbgr.xq62_u24.qnpn13g2[ic]
print @q.xbgr.xq62_u24.qnpn13g2[ib]
print @q.xbgr.xq62_u24.qnpn13g2[ie]
print @q.xbgr.xq62_u24.qnpn13g2[is]
print @r.xbgr.xq62_u24.rsub[i]
print @c.xbgr.xq62_u24.csub[i]
print @q.xbgr.xq67_u2.qnpn13g2[ic]
print @q.xbgr.xq67_u2.qnpn13g2[ib]
print @q.xbgr.xq67_u2.qnpn13g2[ie]
print @q.xbgr.xq67_u2.qnpn13g2[is]
print @r.xbgr.xq67_u2.rsub[i]
print @c.xbgr.xq67_u2.csub[i]
print @q.xbgr.xq67_u3.qnpn13g2[ic]
print @q.xbgr.xq67_u3.qnpn13g2[ib]
print @q.xbgr.xq67_u3.qnpn13g2[ie]
print @q.xbgr.xq67_u3.qnpn13g2[is]
print @r.xbgr.xq67_u3.rsub[i]
print @c.xbgr.xq67_u3.csub[i]
print @q.xbgr.xq67_u4.qnpn13g2[ic]
print @q.xbgr.xq67_u4.qnpn13g2[ib]
print @q.xbgr.xq67_u4.qnpn13g2[ie]
print @q.xbgr.xq67_u4.qnpn13g2[is]
print @r.xbgr.xq67_u4.rsub[i]
print @c.xbgr.xq67_u4.csub[i]
print @q.xbgr.xq67_u5.qnpn13g2[ic]
print @q.xbgr.xq67_u5.qnpn13g2[ib]
print @q.xbgr.xq67_u5.qnpn13g2[ie]
print @q.xbgr.xq67_u5.qnpn13g2[is]
print @r.xbgr.xq67_u5.rsub[i]
print @c.xbgr.xq67_u5.csub[i]
print @q.xbgr.xq67_u6.qnpn13g2[ic]
print @q.xbgr.xq67_u6.qnpn13g2[ib]
print @q.xbgr.xq67_u6.qnpn13g2[ie]
print @q.xbgr.xq67_u6.qnpn13g2[is]
print @r.xbgr.xq67_u6.rsub[i]
print @c.xbgr.xq67_u6.csub[i]
print @q.xbgr.xq67_u7.qnpn13g2[ic]
print @q.xbgr.xq67_u7.qnpn13g2[ib]
print @q.xbgr.xq67_u7.qnpn13g2[ie]
print @q.xbgr.xq67_u7.qnpn13g2[is]
print @r.xbgr.xq67_u7.rsub[i]
print @c.xbgr.xq67_u7.csub[i]
print @q.xbgr.xq67_u8.qnpn13g2[ic]
print @q.xbgr.xq67_u8.qnpn13g2[ib]
print @q.xbgr.xq67_u8.qnpn13g2[ie]
print @q.xbgr.xq67_u8.qnpn13g2[is]
print @r.xbgr.xq67_u8.rsub[i]
print @c.xbgr.xq67_u8.csub[i]
print @q.xbgr.xq67_u9.qnpn13g2[ic]
print @q.xbgr.xq67_u9.qnpn13g2[ib]
print @q.xbgr.xq67_u9.qnpn13g2[ie]
print @q.xbgr.xq67_u9.qnpn13g2[is]
print @r.xbgr.xq67_u9.rsub[i]
print @c.xbgr.xq67_u9.csub[i]
print @q.xbgr.xq67_u10.qnpn13g2[ic]
print @q.xbgr.xq67_u10.qnpn13g2[ib]
print @q.xbgr.xq67_u10.qnpn13g2[ie]
print @q.xbgr.xq67_u10.qnpn13g2[is]
print @r.xbgr.xq67_u10.rsub[i]
print @c.xbgr.xq67_u10.csub[i]
print @q.xbgr.xq67_u11.qnpn13g2[ic]
print @q.xbgr.xq67_u11.qnpn13g2[ib]
print @q.xbgr.xq67_u11.qnpn13g2[ie]
print @q.xbgr.xq67_u11.qnpn13g2[is]
print @r.xbgr.xq67_u11.rsub[i]
print @c.xbgr.xq67_u11.csub[i]
print @q.xbgr.xq67_u12.qnpn13g2[ic]
print @q.xbgr.xq67_u12.qnpn13g2[ib]
print @q.xbgr.xq67_u12.qnpn13g2[ie]
print @q.xbgr.xq67_u12.qnpn13g2[is]
print @r.xbgr.xq67_u12.rsub[i]
print @c.xbgr.xq67_u12.csub[i]
print @q.xbgr.xq67_u13.qnpn13g2[ic]
print @q.xbgr.xq67_u13.qnpn13g2[ib]
print @q.xbgr.xq67_u13.qnpn13g2[ie]
print @q.xbgr.xq67_u13.qnpn13g2[is]
print @r.xbgr.xq67_u13.rsub[i]
print @c.xbgr.xq67_u13.csub[i]
print @q.xbgr.xq67_u14.qnpn13g2[ic]
print @q.xbgr.xq67_u14.qnpn13g2[ib]
print @q.xbgr.xq67_u14.qnpn13g2[ie]
print @q.xbgr.xq67_u14.qnpn13g2[is]
print @r.xbgr.xq67_u14.rsub[i]
print @c.xbgr.xq67_u14.csub[i]
print @q.xbgr.xq67_u15.qnpn13g2[ic]
print @q.xbgr.xq67_u15.qnpn13g2[ib]
print @q.xbgr.xq67_u15.qnpn13g2[ie]
print @q.xbgr.xq67_u15.qnpn13g2[is]
print @r.xbgr.xq67_u15.rsub[i]
print @c.xbgr.xq67_u15.csub[i]
print @q.xbgr.xq67_u16.qnpn13g2[ic]
print @q.xbgr.xq67_u16.qnpn13g2[ib]
print @q.xbgr.xq67_u16.qnpn13g2[ie]
print @q.xbgr.xq67_u16.qnpn13g2[is]
print @r.xbgr.xq67_u16.rsub[i]
print @c.xbgr.xq67_u16.csub[i]
print @q.xbgr.xq67_u17.qnpn13g2[ic]
print @q.xbgr.xq67_u17.qnpn13g2[ib]
print @q.xbgr.xq67_u17.qnpn13g2[ie]
print @q.xbgr.xq67_u17.qnpn13g2[is]
print @r.xbgr.xq67_u17.rsub[i]
print @c.xbgr.xq67_u17.csub[i]
print @q.xbgr.xq67_u18.qnpn13g2[ic]
print @q.xbgr.xq67_u18.qnpn13g2[ib]
print @q.xbgr.xq67_u18.qnpn13g2[ie]
print @q.xbgr.xq67_u18.qnpn13g2[is]
print @r.xbgr.xq67_u18.rsub[i]
print @c.xbgr.xq67_u18.csub[i]
print @q.xbgr.xq67_u19.qnpn13g2[ic]
print @q.xbgr.xq67_u19.qnpn13g2[ib]
print @q.xbgr.xq67_u19.qnpn13g2[ie]
print @q.xbgr.xq67_u19.qnpn13g2[is]
print @r.xbgr.xq67_u19.rsub[i]
print @c.xbgr.xq67_u19.csub[i]
print @q.xbgr.xq67_u20.qnpn13g2[ic]
print @q.xbgr.xq67_u20.qnpn13g2[ib]
print @q.xbgr.xq67_u20.qnpn13g2[ie]
print @q.xbgr.xq67_u20.qnpn13g2[is]
print @r.xbgr.xq67_u20.rsub[i]
print @c.xbgr.xq67_u20.csub[i]
print @q.xbgr.xq67_u21.qnpn13g2[ic]
print @q.xbgr.xq67_u21.qnpn13g2[ib]
print @q.xbgr.xq67_u21.qnpn13g2[ie]
print @q.xbgr.xq67_u21.qnpn13g2[is]
print @r.xbgr.xq67_u21.rsub[i]
print @c.xbgr.xq67_u21.csub[i]
print @q.xbgr.xq67_u22.qnpn13g2[ic]
print @q.xbgr.xq67_u22.qnpn13g2[ib]
print @q.xbgr.xq67_u22.qnpn13g2[ie]
print @q.xbgr.xq67_u22.qnpn13g2[is]
print @r.xbgr.xq67_u22.rsub[i]
print @c.xbgr.xq67_u22.csub[i]
print @q.xbgr.xq67_u23.qnpn13g2[ic]
print @q.xbgr.xq67_u23.qnpn13g2[ib]
print @q.xbgr.xq67_u23.qnpn13g2[ie]
print @q.xbgr.xq67_u23.qnpn13g2[is]
print @r.xbgr.xq67_u23.rsub[i]
print @c.xbgr.xq67_u23.csub[i]
print @q.xbgr.xq67_u24.qnpn13g2[ic]
print @q.xbgr.xq67_u24.qnpn13g2[ib]
print @q.xbgr.xq67_u24.qnpn13g2[ie]
print @q.xbgr.xq67_u24.qnpn13g2[is]
print @r.xbgr.xq67_u24.rsub[i]
print @c.xbgr.xq67_u24.csub[i]
print @q.xbgr.xq68_u2.qnpn13g2[ic]
print @q.xbgr.xq68_u2.qnpn13g2[ib]
print @q.xbgr.xq68_u2.qnpn13g2[ie]
print @q.xbgr.xq68_u2.qnpn13g2[is]
print @r.xbgr.xq68_u2.rsub[i]
print @c.xbgr.xq68_u2.csub[i]
print @q.xbgr.xq68_u3.qnpn13g2[ic]
print @q.xbgr.xq68_u3.qnpn13g2[ib]
print @q.xbgr.xq68_u3.qnpn13g2[ie]
print @q.xbgr.xq68_u3.qnpn13g2[is]
print @r.xbgr.xq68_u3.rsub[i]
print @c.xbgr.xq68_u3.csub[i]
print @q.xbgr.xq68_u4.qnpn13g2[ic]
print @q.xbgr.xq68_u4.qnpn13g2[ib]
print @q.xbgr.xq68_u4.qnpn13g2[ie]
print @q.xbgr.xq68_u4.qnpn13g2[is]
print @r.xbgr.xq68_u4.rsub[i]
print @c.xbgr.xq68_u4.csub[i]
print @q.xbgr.xq68_u5.qnpn13g2[ic]
print @q.xbgr.xq68_u5.qnpn13g2[ib]
print @q.xbgr.xq68_u5.qnpn13g2[ie]
print @q.xbgr.xq68_u5.qnpn13g2[is]
print @r.xbgr.xq68_u5.rsub[i]
print @c.xbgr.xq68_u5.csub[i]
print @q.xbgr.xq68_u6.qnpn13g2[ic]
print @q.xbgr.xq68_u6.qnpn13g2[ib]
print @q.xbgr.xq68_u6.qnpn13g2[ie]
print @q.xbgr.xq68_u6.qnpn13g2[is]
print @r.xbgr.xq68_u6.rsub[i]
print @c.xbgr.xq68_u6.csub[i]
print @q.xbgr.xq68_u7.qnpn13g2[ic]
print @q.xbgr.xq68_u7.qnpn13g2[ib]
print @q.xbgr.xq68_u7.qnpn13g2[ie]
print @q.xbgr.xq68_u7.qnpn13g2[is]
print @r.xbgr.xq68_u7.rsub[i]
print @c.xbgr.xq68_u7.csub[i]
print @q.xbgr.xq68_u8.qnpn13g2[ic]
print @q.xbgr.xq68_u8.qnpn13g2[ib]
print @q.xbgr.xq68_u8.qnpn13g2[ie]
print @q.xbgr.xq68_u8.qnpn13g2[is]
print @r.xbgr.xq68_u8.rsub[i]
print @c.xbgr.xq68_u8.csub[i]
print @q.xbgr.xq68_u9.qnpn13g2[ic]
print @q.xbgr.xq68_u9.qnpn13g2[ib]
print @q.xbgr.xq68_u9.qnpn13g2[ie]
print @q.xbgr.xq68_u9.qnpn13g2[is]
print @r.xbgr.xq68_u9.rsub[i]
print @c.xbgr.xq68_u9.csub[i]
print @q.xbgr.xq68_u10.qnpn13g2[ic]
print @q.xbgr.xq68_u10.qnpn13g2[ib]
print @q.xbgr.xq68_u10.qnpn13g2[ie]
print @q.xbgr.xq68_u10.qnpn13g2[is]
print @r.xbgr.xq68_u10.rsub[i]
print @c.xbgr.xq68_u10.csub[i]
print @q.xbgr.xq68_u11.qnpn13g2[ic]
print @q.xbgr.xq68_u11.qnpn13g2[ib]
print @q.xbgr.xq68_u11.qnpn13g2[ie]
print @q.xbgr.xq68_u11.qnpn13g2[is]
print @r.xbgr.xq68_u11.rsub[i]
print @c.xbgr.xq68_u11.csub[i]
print @q.xbgr.xq68_u12.qnpn13g2[ic]
print @q.xbgr.xq68_u12.qnpn13g2[ib]
print @q.xbgr.xq68_u12.qnpn13g2[ie]
print @q.xbgr.xq68_u12.qnpn13g2[is]
print @r.xbgr.xq68_u12.rsub[i]
print @c.xbgr.xq68_u12.csub[i]
print @q.xbgr.xq68_u13.qnpn13g2[ic]
print @q.xbgr.xq68_u13.qnpn13g2[ib]
print @q.xbgr.xq68_u13.qnpn13g2[ie]
print @q.xbgr.xq68_u13.qnpn13g2[is]
print @r.xbgr.xq68_u13.rsub[i]
print @c.xbgr.xq68_u13.csub[i]
print @q.xbgr.xq68_u14.qnpn13g2[ic]
print @q.xbgr.xq68_u14.qnpn13g2[ib]
print @q.xbgr.xq68_u14.qnpn13g2[ie]
print @q.xbgr.xq68_u14.qnpn13g2[is]
print @r.xbgr.xq68_u14.rsub[i]
print @c.xbgr.xq68_u14.csub[i]
print @q.xbgr.xq68_u15.qnpn13g2[ic]
print @q.xbgr.xq68_u15.qnpn13g2[ib]
print @q.xbgr.xq68_u15.qnpn13g2[ie]
print @q.xbgr.xq68_u15.qnpn13g2[is]
print @r.xbgr.xq68_u15.rsub[i]
print @c.xbgr.xq68_u15.csub[i]
print @q.xbgr.xq68_u16.qnpn13g2[ic]
print @q.xbgr.xq68_u16.qnpn13g2[ib]
print @q.xbgr.xq68_u16.qnpn13g2[ie]
print @q.xbgr.xq68_u16.qnpn13g2[is]
print @r.xbgr.xq68_u16.rsub[i]
print @c.xbgr.xq68_u16.csub[i]
print @q.xbgr.xq68_u17.qnpn13g2[ic]
print @q.xbgr.xq68_u17.qnpn13g2[ib]
print @q.xbgr.xq68_u17.qnpn13g2[ie]
print @q.xbgr.xq68_u17.qnpn13g2[is]
print @r.xbgr.xq68_u17.rsub[i]
print @c.xbgr.xq68_u17.csub[i]
print @q.xbgr.xq68_u18.qnpn13g2[ic]
print @q.xbgr.xq68_u18.qnpn13g2[ib]
print @q.xbgr.xq68_u18.qnpn13g2[ie]
print @q.xbgr.xq68_u18.qnpn13g2[is]
print @r.xbgr.xq68_u18.rsub[i]
print @c.xbgr.xq68_u18.csub[i]
print @q.xbgr.xq68_u19.qnpn13g2[ic]
print @q.xbgr.xq68_u19.qnpn13g2[ib]
print @q.xbgr.xq68_u19.qnpn13g2[ie]
print @q.xbgr.xq68_u19.qnpn13g2[is]
print @r.xbgr.xq68_u19.rsub[i]
print @c.xbgr.xq68_u19.csub[i]
print @q.xbgr.xq68_u20.qnpn13g2[ic]
print @q.xbgr.xq68_u20.qnpn13g2[ib]
print @q.xbgr.xq68_u20.qnpn13g2[ie]
print @q.xbgr.xq68_u20.qnpn13g2[is]
print @r.xbgr.xq68_u20.rsub[i]
print @c.xbgr.xq68_u20.csub[i]
print @q.xbgr.xq68_u21.qnpn13g2[ic]
print @q.xbgr.xq68_u21.qnpn13g2[ib]
print @q.xbgr.xq68_u21.qnpn13g2[ie]
print @q.xbgr.xq68_u21.qnpn13g2[is]
print @r.xbgr.xq68_u21.rsub[i]
print @c.xbgr.xq68_u21.csub[i]
print @q.xbgr.xq68_u22.qnpn13g2[ic]
print @q.xbgr.xq68_u22.qnpn13g2[ib]
print @q.xbgr.xq68_u22.qnpn13g2[ie]
print @q.xbgr.xq68_u22.qnpn13g2[is]
print @r.xbgr.xq68_u22.rsub[i]
print @c.xbgr.xq68_u22.csub[i]
print @q.xbgr.xq68_u23.qnpn13g2[ic]
print @q.xbgr.xq68_u23.qnpn13g2[ib]
print @q.xbgr.xq68_u23.qnpn13g2[ie]
print @q.xbgr.xq68_u23.qnpn13g2[is]
print @r.xbgr.xq68_u23.rsub[i]
print @c.xbgr.xq68_u23.csub[i]
print @q.xbgr.xq68_u24.qnpn13g2[ic]
print @q.xbgr.xq68_u24.qnpn13g2[ib]
print @q.xbgr.xq68_u24.qnpn13g2[ie]
print @q.xbgr.xq68_u24.qnpn13g2[is]
print @r.xbgr.xq68_u24.rsub[i]
print @c.xbgr.xq68_u24.csub[i]
print @q.xbgr.xq69_u2.qnpn13g2[ic]
print @q.xbgr.xq69_u2.qnpn13g2[ib]
print @q.xbgr.xq69_u2.qnpn13g2[ie]
print @q.xbgr.xq69_u2.qnpn13g2[is]
print @r.xbgr.xq69_u2.rsub[i]
print @c.xbgr.xq69_u2.csub[i]
print @q.xbgr.xq69_u3.qnpn13g2[ic]
print @q.xbgr.xq69_u3.qnpn13g2[ib]
print @q.xbgr.xq69_u3.qnpn13g2[ie]
print @q.xbgr.xq69_u3.qnpn13g2[is]
print @r.xbgr.xq69_u3.rsub[i]
print @c.xbgr.xq69_u3.csub[i]
print @q.xbgr.xq69_u4.qnpn13g2[ic]
print @q.xbgr.xq69_u4.qnpn13g2[ib]
print @q.xbgr.xq69_u4.qnpn13g2[ie]
print @q.xbgr.xq69_u4.qnpn13g2[is]
print @r.xbgr.xq69_u4.rsub[i]
print @c.xbgr.xq69_u4.csub[i]
print @q.xbgr.xq69_u5.qnpn13g2[ic]
print @q.xbgr.xq69_u5.qnpn13g2[ib]
print @q.xbgr.xq69_u5.qnpn13g2[ie]
print @q.xbgr.xq69_u5.qnpn13g2[is]
print @r.xbgr.xq69_u5.rsub[i]
print @c.xbgr.xq69_u5.csub[i]
print @q.xbgr.xq69_u6.qnpn13g2[ic]
print @q.xbgr.xq69_u6.qnpn13g2[ib]
print @q.xbgr.xq69_u6.qnpn13g2[ie]
print @q.xbgr.xq69_u6.qnpn13g2[is]
print @r.xbgr.xq69_u6.rsub[i]
print @c.xbgr.xq69_u6.csub[i]
print @q.xbgr.xq69_u7.qnpn13g2[ic]
print @q.xbgr.xq69_u7.qnpn13g2[ib]
print @q.xbgr.xq69_u7.qnpn13g2[ie]
print @q.xbgr.xq69_u7.qnpn13g2[is]
print @r.xbgr.xq69_u7.rsub[i]
print @c.xbgr.xq69_u7.csub[i]
print @q.xbgr.xq69_u8.qnpn13g2[ic]
print @q.xbgr.xq69_u8.qnpn13g2[ib]
print @q.xbgr.xq69_u8.qnpn13g2[ie]
print @q.xbgr.xq69_u8.qnpn13g2[is]
print @r.xbgr.xq69_u8.rsub[i]
print @c.xbgr.xq69_u8.csub[i]
print @q.xbgr.xq69_u9.qnpn13g2[ic]
print @q.xbgr.xq69_u9.qnpn13g2[ib]
print @q.xbgr.xq69_u9.qnpn13g2[ie]
print @q.xbgr.xq69_u9.qnpn13g2[is]
print @r.xbgr.xq69_u9.rsub[i]
print @c.xbgr.xq69_u9.csub[i]
print @q.xbgr.xq69_u10.qnpn13g2[ic]
print @q.xbgr.xq69_u10.qnpn13g2[ib]
print @q.xbgr.xq69_u10.qnpn13g2[ie]
print @q.xbgr.xq69_u10.qnpn13g2[is]
print @r.xbgr.xq69_u10.rsub[i]
print @c.xbgr.xq69_u10.csub[i]
print @q.xbgr.xq69_u11.qnpn13g2[ic]
print @q.xbgr.xq69_u11.qnpn13g2[ib]
print @q.xbgr.xq69_u11.qnpn13g2[ie]
print @q.xbgr.xq69_u11.qnpn13g2[is]
print @r.xbgr.xq69_u11.rsub[i]
print @c.xbgr.xq69_u11.csub[i]
print @q.xbgr.xq69_u12.qnpn13g2[ic]
print @q.xbgr.xq69_u12.qnpn13g2[ib]
print @q.xbgr.xq69_u12.qnpn13g2[ie]
print @q.xbgr.xq69_u12.qnpn13g2[is]
print @r.xbgr.xq69_u12.rsub[i]
print @c.xbgr.xq69_u12.csub[i]
print @q.xbgr.xq69_u13.qnpn13g2[ic]
print @q.xbgr.xq69_u13.qnpn13g2[ib]
print @q.xbgr.xq69_u13.qnpn13g2[ie]
print @q.xbgr.xq69_u13.qnpn13g2[is]
print @r.xbgr.xq69_u13.rsub[i]
print @c.xbgr.xq69_u13.csub[i]
print @q.xbgr.xq69_u14.qnpn13g2[ic]
print @q.xbgr.xq69_u14.qnpn13g2[ib]
print @q.xbgr.xq69_u14.qnpn13g2[ie]
print @q.xbgr.xq69_u14.qnpn13g2[is]
print @r.xbgr.xq69_u14.rsub[i]
print @c.xbgr.xq69_u14.csub[i]
print @q.xbgr.xq69_u15.qnpn13g2[ic]
print @q.xbgr.xq69_u15.qnpn13g2[ib]
print @q.xbgr.xq69_u15.qnpn13g2[ie]
print @q.xbgr.xq69_u15.qnpn13g2[is]
print @r.xbgr.xq69_u15.rsub[i]
print @c.xbgr.xq69_u15.csub[i]
print @q.xbgr.xq69_u16.qnpn13g2[ic]
print @q.xbgr.xq69_u16.qnpn13g2[ib]
print @q.xbgr.xq69_u16.qnpn13g2[ie]
print @q.xbgr.xq69_u16.qnpn13g2[is]
print @r.xbgr.xq69_u16.rsub[i]
print @c.xbgr.xq69_u16.csub[i]
print @q.xbgr.xq69_u17.qnpn13g2[ic]
print @q.xbgr.xq69_u17.qnpn13g2[ib]
print @q.xbgr.xq69_u17.qnpn13g2[ie]
print @q.xbgr.xq69_u17.qnpn13g2[is]
print @r.xbgr.xq69_u17.rsub[i]
print @c.xbgr.xq69_u17.csub[i]
print @q.xbgr.xq69_u18.qnpn13g2[ic]
print @q.xbgr.xq69_u18.qnpn13g2[ib]
print @q.xbgr.xq69_u18.qnpn13g2[ie]
print @q.xbgr.xq69_u18.qnpn13g2[is]
print @r.xbgr.xq69_u18.rsub[i]
print @c.xbgr.xq69_u18.csub[i]
print @q.xbgr.xq69_u19.qnpn13g2[ic]
print @q.xbgr.xq69_u19.qnpn13g2[ib]
print @q.xbgr.xq69_u19.qnpn13g2[ie]
print @q.xbgr.xq69_u19.qnpn13g2[is]
print @r.xbgr.xq69_u19.rsub[i]
print @c.xbgr.xq69_u19.csub[i]
print @q.xbgr.xq69_u20.qnpn13g2[ic]
print @q.xbgr.xq69_u20.qnpn13g2[ib]
print @q.xbgr.xq69_u20.qnpn13g2[ie]
print @q.xbgr.xq69_u20.qnpn13g2[is]
print @r.xbgr.xq69_u20.rsub[i]
print @c.xbgr.xq69_u20.csub[i]
print @q.xbgr.xq69_u21.qnpn13g2[ic]
print @q.xbgr.xq69_u21.qnpn13g2[ib]
print @q.xbgr.xq69_u21.qnpn13g2[ie]
print @q.xbgr.xq69_u21.qnpn13g2[is]
print @r.xbgr.xq69_u21.rsub[i]
print @c.xbgr.xq69_u21.csub[i]
print @q.xbgr.xq69_u22.qnpn13g2[ic]
print @q.xbgr.xq69_u22.qnpn13g2[ib]
print @q.xbgr.xq69_u22.qnpn13g2[ie]
print @q.xbgr.xq69_u22.qnpn13g2[is]
print @r.xbgr.xq69_u22.rsub[i]
print @c.xbgr.xq69_u22.csub[i]
print @q.xbgr.xq69_u23.qnpn13g2[ic]
print @q.xbgr.xq69_u23.qnpn13g2[ib]
print @q.xbgr.xq69_u23.qnpn13g2[ie]
print @q.xbgr.xq69_u23.qnpn13g2[is]
print @r.xbgr.xq69_u23.rsub[i]
print @c.xbgr.xq69_u23.csub[i]
print @q.xbgr.xq69_u24.qnpn13g2[ic]
print @q.xbgr.xq69_u24.qnpn13g2[ib]
print @q.xbgr.xq69_u24.qnpn13g2[ie]
print @q.xbgr.xq69_u24.qnpn13g2[is]
print @r.xbgr.xq69_u24.rsub[i]
print @c.xbgr.xq69_u24.csub[i]
print @q.xbgr.xq70_u2.qnpn13g2[ic]
print @q.xbgr.xq70_u2.qnpn13g2[ib]
print @q.xbgr.xq70_u2.qnpn13g2[ie]
print @q.xbgr.xq70_u2.qnpn13g2[is]
print @r.xbgr.xq70_u2.rsub[i]
print @c.xbgr.xq70_u2.csub[i]
print @q.xbgr.xq70_u3.qnpn13g2[ic]
print @q.xbgr.xq70_u3.qnpn13g2[ib]
print @q.xbgr.xq70_u3.qnpn13g2[ie]
print @q.xbgr.xq70_u3.qnpn13g2[is]
print @r.xbgr.xq70_u3.rsub[i]
print @c.xbgr.xq70_u3.csub[i]
print @q.xbgr.xq70_u4.qnpn13g2[ic]
print @q.xbgr.xq70_u4.qnpn13g2[ib]
print @q.xbgr.xq70_u4.qnpn13g2[ie]
print @q.xbgr.xq70_u4.qnpn13g2[is]
print @r.xbgr.xq70_u4.rsub[i]
print @c.xbgr.xq70_u4.csub[i]
print @q.xbgr.xq70_u5.qnpn13g2[ic]
print @q.xbgr.xq70_u5.qnpn13g2[ib]
print @q.xbgr.xq70_u5.qnpn13g2[ie]
print @q.xbgr.xq70_u5.qnpn13g2[is]
print @r.xbgr.xq70_u5.rsub[i]
print @c.xbgr.xq70_u5.csub[i]
print @q.xbgr.xq70_u6.qnpn13g2[ic]
print @q.xbgr.xq70_u6.qnpn13g2[ib]
print @q.xbgr.xq70_u6.qnpn13g2[ie]
print @q.xbgr.xq70_u6.qnpn13g2[is]
print @r.xbgr.xq70_u6.rsub[i]
print @c.xbgr.xq70_u6.csub[i]
print @q.xbgr.xq70_u7.qnpn13g2[ic]
print @q.xbgr.xq70_u7.qnpn13g2[ib]
print @q.xbgr.xq70_u7.qnpn13g2[ie]
print @q.xbgr.xq70_u7.qnpn13g2[is]
print @r.xbgr.xq70_u7.rsub[i]
print @c.xbgr.xq70_u7.csub[i]
print @q.xbgr.xq70_u8.qnpn13g2[ic]
print @q.xbgr.xq70_u8.qnpn13g2[ib]
print @q.xbgr.xq70_u8.qnpn13g2[ie]
print @q.xbgr.xq70_u8.qnpn13g2[is]
print @r.xbgr.xq70_u8.rsub[i]
print @c.xbgr.xq70_u8.csub[i]
print @q.xbgr.xq70_u9.qnpn13g2[ic]
print @q.xbgr.xq70_u9.qnpn13g2[ib]
print @q.xbgr.xq70_u9.qnpn13g2[ie]
print @q.xbgr.xq70_u9.qnpn13g2[is]
print @r.xbgr.xq70_u9.rsub[i]
print @c.xbgr.xq70_u9.csub[i]
print @q.xbgr.xq70_u10.qnpn13g2[ic]
print @q.xbgr.xq70_u10.qnpn13g2[ib]
print @q.xbgr.xq70_u10.qnpn13g2[ie]
print @q.xbgr.xq70_u10.qnpn13g2[is]
print @r.xbgr.xq70_u10.rsub[i]
print @c.xbgr.xq70_u10.csub[i]
print @q.xbgr.xq70_u11.qnpn13g2[ic]
print @q.xbgr.xq70_u11.qnpn13g2[ib]
print @q.xbgr.xq70_u11.qnpn13g2[ie]
print @q.xbgr.xq70_u11.qnpn13g2[is]
print @r.xbgr.xq70_u11.rsub[i]
print @c.xbgr.xq70_u11.csub[i]
print @q.xbgr.xq70_u12.qnpn13g2[ic]
print @q.xbgr.xq70_u12.qnpn13g2[ib]
print @q.xbgr.xq70_u12.qnpn13g2[ie]
print @q.xbgr.xq70_u12.qnpn13g2[is]
print @r.xbgr.xq70_u12.rsub[i]
print @c.xbgr.xq70_u12.csub[i]
print @q.xbgr.xq70_u13.qnpn13g2[ic]
print @q.xbgr.xq70_u13.qnpn13g2[ib]
print @q.xbgr.xq70_u13.qnpn13g2[ie]
print @q.xbgr.xq70_u13.qnpn13g2[is]
print @r.xbgr.xq70_u13.rsub[i]
print @c.xbgr.xq70_u13.csub[i]
print @q.xbgr.xq70_u14.qnpn13g2[ic]
print @q.xbgr.xq70_u14.qnpn13g2[ib]
print @q.xbgr.xq70_u14.qnpn13g2[ie]
print @q.xbgr.xq70_u14.qnpn13g2[is]
print @r.xbgr.xq70_u14.rsub[i]
print @c.xbgr.xq70_u14.csub[i]
print @q.xbgr.xq70_u15.qnpn13g2[ic]
print @q.xbgr.xq70_u15.qnpn13g2[ib]
print @q.xbgr.xq70_u15.qnpn13g2[ie]
print @q.xbgr.xq70_u15.qnpn13g2[is]
print @r.xbgr.xq70_u15.rsub[i]
print @c.xbgr.xq70_u15.csub[i]
print @q.xbgr.xq70_u16.qnpn13g2[ic]
print @q.xbgr.xq70_u16.qnpn13g2[ib]
print @q.xbgr.xq70_u16.qnpn13g2[ie]
print @q.xbgr.xq70_u16.qnpn13g2[is]
print @r.xbgr.xq70_u16.rsub[i]
print @c.xbgr.xq70_u16.csub[i]
print @q.xbgr.xq70_u17.qnpn13g2[ic]
print @q.xbgr.xq70_u17.qnpn13g2[ib]
print @q.xbgr.xq70_u17.qnpn13g2[ie]
print @q.xbgr.xq70_u17.qnpn13g2[is]
print @r.xbgr.xq70_u17.rsub[i]
print @c.xbgr.xq70_u17.csub[i]
print @q.xbgr.xq70_u18.qnpn13g2[ic]
print @q.xbgr.xq70_u18.qnpn13g2[ib]
print @q.xbgr.xq70_u18.qnpn13g2[ie]
print @q.xbgr.xq70_u18.qnpn13g2[is]
print @r.xbgr.xq70_u18.rsub[i]
print @c.xbgr.xq70_u18.csub[i]
print @q.xbgr.xq70_u19.qnpn13g2[ic]
print @q.xbgr.xq70_u19.qnpn13g2[ib]
print @q.xbgr.xq70_u19.qnpn13g2[ie]
print @q.xbgr.xq70_u19.qnpn13g2[is]
print @r.xbgr.xq70_u19.rsub[i]
print @c.xbgr.xq70_u19.csub[i]
print @q.xbgr.xq70_u20.qnpn13g2[ic]
print @q.xbgr.xq70_u20.qnpn13g2[ib]
print @q.xbgr.xq70_u20.qnpn13g2[ie]
print @q.xbgr.xq70_u20.qnpn13g2[is]
print @r.xbgr.xq70_u20.rsub[i]
print @c.xbgr.xq70_u20.csub[i]
print @q.xbgr.xq70_u21.qnpn13g2[ic]
print @q.xbgr.xq70_u21.qnpn13g2[ib]
print @q.xbgr.xq70_u21.qnpn13g2[ie]
print @q.xbgr.xq70_u21.qnpn13g2[is]
print @r.xbgr.xq70_u21.rsub[i]
print @c.xbgr.xq70_u21.csub[i]
print @q.xbgr.xq70_u22.qnpn13g2[ic]
print @q.xbgr.xq70_u22.qnpn13g2[ib]
print @q.xbgr.xq70_u22.qnpn13g2[ie]
print @q.xbgr.xq70_u22.qnpn13g2[is]
print @r.xbgr.xq70_u22.rsub[i]
print @c.xbgr.xq70_u22.csub[i]
print @q.xbgr.xq70_u23.qnpn13g2[ic]
print @q.xbgr.xq70_u23.qnpn13g2[ib]
print @q.xbgr.xq70_u23.qnpn13g2[ie]
print @q.xbgr.xq70_u23.qnpn13g2[is]
print @r.xbgr.xq70_u23.rsub[i]
print @c.xbgr.xq70_u23.csub[i]
print @q.xbgr.xq70_u24.qnpn13g2[ic]
print @q.xbgr.xq70_u24.qnpn13g2[ib]
print @q.xbgr.xq70_u24.qnpn13g2[ie]
print @q.xbgr.xq70_u24.qnpn13g2[is]
print @r.xbgr.xq70_u24.rsub[i]
print @c.xbgr.xq70_u24.csub[i]
print @q.xbgr.xq71_u2.qnpn13g2[ic]
print @q.xbgr.xq71_u2.qnpn13g2[ib]
print @q.xbgr.xq71_u2.qnpn13g2[ie]
print @q.xbgr.xq71_u2.qnpn13g2[is]
print @r.xbgr.xq71_u2.rsub[i]
print @c.xbgr.xq71_u2.csub[i]
print @q.xbgr.xq71_u3.qnpn13g2[ic]
print @q.xbgr.xq71_u3.qnpn13g2[ib]
print @q.xbgr.xq71_u3.qnpn13g2[ie]
print @q.xbgr.xq71_u3.qnpn13g2[is]
print @r.xbgr.xq71_u3.rsub[i]
print @c.xbgr.xq71_u3.csub[i]
print @q.xbgr.xq71_u4.qnpn13g2[ic]
print @q.xbgr.xq71_u4.qnpn13g2[ib]
print @q.xbgr.xq71_u4.qnpn13g2[ie]
print @q.xbgr.xq71_u4.qnpn13g2[is]
print @r.xbgr.xq71_u4.rsub[i]
print @c.xbgr.xq71_u4.csub[i]
print @q.xbgr.xq71_u5.qnpn13g2[ic]
print @q.xbgr.xq71_u5.qnpn13g2[ib]
print @q.xbgr.xq71_u5.qnpn13g2[ie]
print @q.xbgr.xq71_u5.qnpn13g2[is]
print @r.xbgr.xq71_u5.rsub[i]
print @c.xbgr.xq71_u5.csub[i]
print @q.xbgr.xq71_u6.qnpn13g2[ic]
print @q.xbgr.xq71_u6.qnpn13g2[ib]
print @q.xbgr.xq71_u6.qnpn13g2[ie]
print @q.xbgr.xq71_u6.qnpn13g2[is]
print @r.xbgr.xq71_u6.rsub[i]
print @c.xbgr.xq71_u6.csub[i]
print @q.xbgr.xq71_u7.qnpn13g2[ic]
print @q.xbgr.xq71_u7.qnpn13g2[ib]
print @q.xbgr.xq71_u7.qnpn13g2[ie]
print @q.xbgr.xq71_u7.qnpn13g2[is]
print @r.xbgr.xq71_u7.rsub[i]
print @c.xbgr.xq71_u7.csub[i]
print @q.xbgr.xq71_u8.qnpn13g2[ic]
print @q.xbgr.xq71_u8.qnpn13g2[ib]
print @q.xbgr.xq71_u8.qnpn13g2[ie]
print @q.xbgr.xq71_u8.qnpn13g2[is]
print @r.xbgr.xq71_u8.rsub[i]
print @c.xbgr.xq71_u8.csub[i]
print @q.xbgr.xq71_u9.qnpn13g2[ic]
print @q.xbgr.xq71_u9.qnpn13g2[ib]
print @q.xbgr.xq71_u9.qnpn13g2[ie]
print @q.xbgr.xq71_u9.qnpn13g2[is]
print @r.xbgr.xq71_u9.rsub[i]
print @c.xbgr.xq71_u9.csub[i]
print @q.xbgr.xq71_u10.qnpn13g2[ic]
print @q.xbgr.xq71_u10.qnpn13g2[ib]
print @q.xbgr.xq71_u10.qnpn13g2[ie]
print @q.xbgr.xq71_u10.qnpn13g2[is]
print @r.xbgr.xq71_u10.rsub[i]
print @c.xbgr.xq71_u10.csub[i]
print @q.xbgr.xq71_u11.qnpn13g2[ic]
print @q.xbgr.xq71_u11.qnpn13g2[ib]
print @q.xbgr.xq71_u11.qnpn13g2[ie]
print @q.xbgr.xq71_u11.qnpn13g2[is]
print @r.xbgr.xq71_u11.rsub[i]
print @c.xbgr.xq71_u11.csub[i]
print @q.xbgr.xq71_u12.qnpn13g2[ic]
print @q.xbgr.xq71_u12.qnpn13g2[ib]
print @q.xbgr.xq71_u12.qnpn13g2[ie]
print @q.xbgr.xq71_u12.qnpn13g2[is]
print @r.xbgr.xq71_u12.rsub[i]
print @c.xbgr.xq71_u12.csub[i]
print @q.xbgr.xq71_u13.qnpn13g2[ic]
print @q.xbgr.xq71_u13.qnpn13g2[ib]
print @q.xbgr.xq71_u13.qnpn13g2[ie]
print @q.xbgr.xq71_u13.qnpn13g2[is]
print @r.xbgr.xq71_u13.rsub[i]
print @c.xbgr.xq71_u13.csub[i]
print @q.xbgr.xq71_u14.qnpn13g2[ic]
print @q.xbgr.xq71_u14.qnpn13g2[ib]
print @q.xbgr.xq71_u14.qnpn13g2[ie]
print @q.xbgr.xq71_u14.qnpn13g2[is]
print @r.xbgr.xq71_u14.rsub[i]
print @c.xbgr.xq71_u14.csub[i]
print @q.xbgr.xq71_u15.qnpn13g2[ic]
print @q.xbgr.xq71_u15.qnpn13g2[ib]
print @q.xbgr.xq71_u15.qnpn13g2[ie]
print @q.xbgr.xq71_u15.qnpn13g2[is]
print @r.xbgr.xq71_u15.rsub[i]
print @c.xbgr.xq71_u15.csub[i]
print @q.xbgr.xq71_u16.qnpn13g2[ic]
print @q.xbgr.xq71_u16.qnpn13g2[ib]
print @q.xbgr.xq71_u16.qnpn13g2[ie]
print @q.xbgr.xq71_u16.qnpn13g2[is]
print @r.xbgr.xq71_u16.rsub[i]
print @c.xbgr.xq71_u16.csub[i]
print @q.xbgr.xq71_u17.qnpn13g2[ic]
print @q.xbgr.xq71_u17.qnpn13g2[ib]
print @q.xbgr.xq71_u17.qnpn13g2[ie]
print @q.xbgr.xq71_u17.qnpn13g2[is]
print @r.xbgr.xq71_u17.rsub[i]
print @c.xbgr.xq71_u17.csub[i]
print @q.xbgr.xq71_u18.qnpn13g2[ic]
print @q.xbgr.xq71_u18.qnpn13g2[ib]
print @q.xbgr.xq71_u18.qnpn13g2[ie]
print @q.xbgr.xq71_u18.qnpn13g2[is]
print @r.xbgr.xq71_u18.rsub[i]
print @c.xbgr.xq71_u18.csub[i]
print @q.xbgr.xq71_u19.qnpn13g2[ic]
print @q.xbgr.xq71_u19.qnpn13g2[ib]
print @q.xbgr.xq71_u19.qnpn13g2[ie]
print @q.xbgr.xq71_u19.qnpn13g2[is]
print @r.xbgr.xq71_u19.rsub[i]
print @c.xbgr.xq71_u19.csub[i]
print @q.xbgr.xq71_u20.qnpn13g2[ic]
print @q.xbgr.xq71_u20.qnpn13g2[ib]
print @q.xbgr.xq71_u20.qnpn13g2[ie]
print @q.xbgr.xq71_u20.qnpn13g2[is]
print @r.xbgr.xq71_u20.rsub[i]
print @c.xbgr.xq71_u20.csub[i]
print @q.xbgr.xq71_u21.qnpn13g2[ic]
print @q.xbgr.xq71_u21.qnpn13g2[ib]
print @q.xbgr.xq71_u21.qnpn13g2[ie]
print @q.xbgr.xq71_u21.qnpn13g2[is]
print @r.xbgr.xq71_u21.rsub[i]
print @c.xbgr.xq71_u21.csub[i]
print @q.xbgr.xq71_u22.qnpn13g2[ic]
print @q.xbgr.xq71_u22.qnpn13g2[ib]
print @q.xbgr.xq71_u22.qnpn13g2[ie]
print @q.xbgr.xq71_u22.qnpn13g2[is]
print @r.xbgr.xq71_u22.rsub[i]
print @c.xbgr.xq71_u22.csub[i]
print @q.xbgr.xq71_u23.qnpn13g2[ic]
print @q.xbgr.xq71_u23.qnpn13g2[ib]
print @q.xbgr.xq71_u23.qnpn13g2[ie]
print @q.xbgr.xq71_u23.qnpn13g2[is]
print @r.xbgr.xq71_u23.rsub[i]
print @c.xbgr.xq71_u23.csub[i]
print @q.xbgr.xq71_u24.qnpn13g2[ic]
print @q.xbgr.xq71_u24.qnpn13g2[ib]
print @q.xbgr.xq71_u24.qnpn13g2[ie]
print @q.xbgr.xq71_u24.qnpn13g2[is]
print @r.xbgr.xq71_u24.rsub[i]
print @c.xbgr.xq71_u24.csub[i]
print @q.xbgr.xq72_u2.qnpn13g2[ic]
print @q.xbgr.xq72_u2.qnpn13g2[ib]
print @q.xbgr.xq72_u2.qnpn13g2[ie]
print @q.xbgr.xq72_u2.qnpn13g2[is]
print @r.xbgr.xq72_u2.rsub[i]
print @c.xbgr.xq72_u2.csub[i]
print @q.xbgr.xq72_u3.qnpn13g2[ic]
print @q.xbgr.xq72_u3.qnpn13g2[ib]
print @q.xbgr.xq72_u3.qnpn13g2[ie]
print @q.xbgr.xq72_u3.qnpn13g2[is]
print @r.xbgr.xq72_u3.rsub[i]
print @c.xbgr.xq72_u3.csub[i]
print @q.xbgr.xq72_u4.qnpn13g2[ic]
print @q.xbgr.xq72_u4.qnpn13g2[ib]
print @q.xbgr.xq72_u4.qnpn13g2[ie]
print @q.xbgr.xq72_u4.qnpn13g2[is]
print @r.xbgr.xq72_u4.rsub[i]
print @c.xbgr.xq72_u4.csub[i]
print @q.xbgr.xq72_u5.qnpn13g2[ic]
print @q.xbgr.xq72_u5.qnpn13g2[ib]
print @q.xbgr.xq72_u5.qnpn13g2[ie]
print @q.xbgr.xq72_u5.qnpn13g2[is]
print @r.xbgr.xq72_u5.rsub[i]
print @c.xbgr.xq72_u5.csub[i]
print @q.xbgr.xq72_u6.qnpn13g2[ic]
print @q.xbgr.xq72_u6.qnpn13g2[ib]
print @q.xbgr.xq72_u6.qnpn13g2[ie]
print @q.xbgr.xq72_u6.qnpn13g2[is]
print @r.xbgr.xq72_u6.rsub[i]
print @c.xbgr.xq72_u6.csub[i]
print @q.xbgr.xq72_u7.qnpn13g2[ic]
print @q.xbgr.xq72_u7.qnpn13g2[ib]
print @q.xbgr.xq72_u7.qnpn13g2[ie]
print @q.xbgr.xq72_u7.qnpn13g2[is]
print @r.xbgr.xq72_u7.rsub[i]
print @c.xbgr.xq72_u7.csub[i]
print @q.xbgr.xq72_u8.qnpn13g2[ic]
print @q.xbgr.xq72_u8.qnpn13g2[ib]
print @q.xbgr.xq72_u8.qnpn13g2[ie]
print @q.xbgr.xq72_u8.qnpn13g2[is]
print @r.xbgr.xq72_u8.rsub[i]
print @c.xbgr.xq72_u8.csub[i]
print @q.xbgr.xq72_u9.qnpn13g2[ic]
print @q.xbgr.xq72_u9.qnpn13g2[ib]
print @q.xbgr.xq72_u9.qnpn13g2[ie]
print @q.xbgr.xq72_u9.qnpn13g2[is]
print @r.xbgr.xq72_u9.rsub[i]
print @c.xbgr.xq72_u9.csub[i]
print @q.xbgr.xq72_u10.qnpn13g2[ic]
print @q.xbgr.xq72_u10.qnpn13g2[ib]
print @q.xbgr.xq72_u10.qnpn13g2[ie]
print @q.xbgr.xq72_u10.qnpn13g2[is]
print @r.xbgr.xq72_u10.rsub[i]
print @c.xbgr.xq72_u10.csub[i]
print @q.xbgr.xq72_u11.qnpn13g2[ic]
print @q.xbgr.xq72_u11.qnpn13g2[ib]
print @q.xbgr.xq72_u11.qnpn13g2[ie]
print @q.xbgr.xq72_u11.qnpn13g2[is]
print @r.xbgr.xq72_u11.rsub[i]
print @c.xbgr.xq72_u11.csub[i]
print @q.xbgr.xq72_u12.qnpn13g2[ic]
print @q.xbgr.xq72_u12.qnpn13g2[ib]
print @q.xbgr.xq72_u12.qnpn13g2[ie]
print @q.xbgr.xq72_u12.qnpn13g2[is]
print @r.xbgr.xq72_u12.rsub[i]
print @c.xbgr.xq72_u12.csub[i]
print @q.xbgr.xq72_u13.qnpn13g2[ic]
print @q.xbgr.xq72_u13.qnpn13g2[ib]
print @q.xbgr.xq72_u13.qnpn13g2[ie]
print @q.xbgr.xq72_u13.qnpn13g2[is]
print @r.xbgr.xq72_u13.rsub[i]
print @c.xbgr.xq72_u13.csub[i]
print @q.xbgr.xq72_u14.qnpn13g2[ic]
print @q.xbgr.xq72_u14.qnpn13g2[ib]
print @q.xbgr.xq72_u14.qnpn13g2[ie]
print @q.xbgr.xq72_u14.qnpn13g2[is]
print @r.xbgr.xq72_u14.rsub[i]
print @c.xbgr.xq72_u14.csub[i]
print @q.xbgr.xq72_u15.qnpn13g2[ic]
print @q.xbgr.xq72_u15.qnpn13g2[ib]
print @q.xbgr.xq72_u15.qnpn13g2[ie]
print @q.xbgr.xq72_u15.qnpn13g2[is]
print @r.xbgr.xq72_u15.rsub[i]
print @c.xbgr.xq72_u15.csub[i]
print @q.xbgr.xq72_u16.qnpn13g2[ic]
print @q.xbgr.xq72_u16.qnpn13g2[ib]
print @q.xbgr.xq72_u16.qnpn13g2[ie]
print @q.xbgr.xq72_u16.qnpn13g2[is]
print @r.xbgr.xq72_u16.rsub[i]
print @c.xbgr.xq72_u16.csub[i]
print @q.xbgr.xq72_u17.qnpn13g2[ic]
print @q.xbgr.xq72_u17.qnpn13g2[ib]
print @q.xbgr.xq72_u17.qnpn13g2[ie]
print @q.xbgr.xq72_u17.qnpn13g2[is]
print @r.xbgr.xq72_u17.rsub[i]
print @c.xbgr.xq72_u17.csub[i]
print @q.xbgr.xq72_u18.qnpn13g2[ic]
print @q.xbgr.xq72_u18.qnpn13g2[ib]
print @q.xbgr.xq72_u18.qnpn13g2[ie]
print @q.xbgr.xq72_u18.qnpn13g2[is]
print @r.xbgr.xq72_u18.rsub[i]
print @c.xbgr.xq72_u18.csub[i]
print @q.xbgr.xq72_u19.qnpn13g2[ic]
print @q.xbgr.xq72_u19.qnpn13g2[ib]
print @q.xbgr.xq72_u19.qnpn13g2[ie]
print @q.xbgr.xq72_u19.qnpn13g2[is]
print @r.xbgr.xq72_u19.rsub[i]
print @c.xbgr.xq72_u19.csub[i]
print @q.xbgr.xq72_u20.qnpn13g2[ic]
print @q.xbgr.xq72_u20.qnpn13g2[ib]
print @q.xbgr.xq72_u20.qnpn13g2[ie]
print @q.xbgr.xq72_u20.qnpn13g2[is]
print @r.xbgr.xq72_u20.rsub[i]
print @c.xbgr.xq72_u20.csub[i]
print @q.xbgr.xq72_u21.qnpn13g2[ic]
print @q.xbgr.xq72_u21.qnpn13g2[ib]
print @q.xbgr.xq72_u21.qnpn13g2[ie]
print @q.xbgr.xq72_u21.qnpn13g2[is]
print @r.xbgr.xq72_u21.rsub[i]
print @c.xbgr.xq72_u21.csub[i]
print @q.xbgr.xq72_u22.qnpn13g2[ic]
print @q.xbgr.xq72_u22.qnpn13g2[ib]
print @q.xbgr.xq72_u22.qnpn13g2[ie]
print @q.xbgr.xq72_u22.qnpn13g2[is]
print @r.xbgr.xq72_u22.rsub[i]
print @c.xbgr.xq72_u22.csub[i]
print @q.xbgr.xq72_u23.qnpn13g2[ic]
print @q.xbgr.xq72_u23.qnpn13g2[ib]
print @q.xbgr.xq72_u23.qnpn13g2[ie]
print @q.xbgr.xq72_u23.qnpn13g2[is]
print @r.xbgr.xq72_u23.rsub[i]
print @c.xbgr.xq72_u23.csub[i]
print @q.xbgr.xq72_u24.qnpn13g2[ic]
print @q.xbgr.xq72_u24.qnpn13g2[ib]
print @q.xbgr.xq72_u24.qnpn13g2[ie]
print @q.xbgr.xq72_u24.qnpn13g2[is]
print @r.xbgr.xq72_u24.rsub[i]
print @c.xbgr.xq72_u24.csub[i]
print @q.xbgr.xq73_u2.qnpn13g2[ic]
print @q.xbgr.xq73_u2.qnpn13g2[ib]
print @q.xbgr.xq73_u2.qnpn13g2[ie]
print @q.xbgr.xq73_u2.qnpn13g2[is]
print @r.xbgr.xq73_u2.rsub[i]
print @c.xbgr.xq73_u2.csub[i]
print @q.xbgr.xq73_u3.qnpn13g2[ic]
print @q.xbgr.xq73_u3.qnpn13g2[ib]
print @q.xbgr.xq73_u3.qnpn13g2[ie]
print @q.xbgr.xq73_u3.qnpn13g2[is]
print @r.xbgr.xq73_u3.rsub[i]
print @c.xbgr.xq73_u3.csub[i]
print @q.xbgr.xq73_u4.qnpn13g2[ic]
print @q.xbgr.xq73_u4.qnpn13g2[ib]
print @q.xbgr.xq73_u4.qnpn13g2[ie]
print @q.xbgr.xq73_u4.qnpn13g2[is]
print @r.xbgr.xq73_u4.rsub[i]
print @c.xbgr.xq73_u4.csub[i]
print @q.xbgr.xq73_u5.qnpn13g2[ic]
print @q.xbgr.xq73_u5.qnpn13g2[ib]
print @q.xbgr.xq73_u5.qnpn13g2[ie]
print @q.xbgr.xq73_u5.qnpn13g2[is]
print @r.xbgr.xq73_u5.rsub[i]
print @c.xbgr.xq73_u5.csub[i]
print @q.xbgr.xq73_u6.qnpn13g2[ic]
print @q.xbgr.xq73_u6.qnpn13g2[ib]
print @q.xbgr.xq73_u6.qnpn13g2[ie]
print @q.xbgr.xq73_u6.qnpn13g2[is]
print @r.xbgr.xq73_u6.rsub[i]
print @c.xbgr.xq73_u6.csub[i]
print @q.xbgr.xq73_u7.qnpn13g2[ic]
print @q.xbgr.xq73_u7.qnpn13g2[ib]
print @q.xbgr.xq73_u7.qnpn13g2[ie]
print @q.xbgr.xq73_u7.qnpn13g2[is]
print @r.xbgr.xq73_u7.rsub[i]
print @c.xbgr.xq73_u7.csub[i]
print @q.xbgr.xq73_u8.qnpn13g2[ic]
print @q.xbgr.xq73_u8.qnpn13g2[ib]
print @q.xbgr.xq73_u8.qnpn13g2[ie]
print @q.xbgr.xq73_u8.qnpn13g2[is]
print @r.xbgr.xq73_u8.rsub[i]
print @c.xbgr.xq73_u8.csub[i]
print @q.xbgr.xq73_u9.qnpn13g2[ic]
print @q.xbgr.xq73_u9.qnpn13g2[ib]
print @q.xbgr.xq73_u9.qnpn13g2[ie]
print @q.xbgr.xq73_u9.qnpn13g2[is]
print @r.xbgr.xq73_u9.rsub[i]
print @c.xbgr.xq73_u9.csub[i]
print @q.xbgr.xq73_u10.qnpn13g2[ic]
print @q.xbgr.xq73_u10.qnpn13g2[ib]
print @q.xbgr.xq73_u10.qnpn13g2[ie]
print @q.xbgr.xq73_u10.qnpn13g2[is]
print @r.xbgr.xq73_u10.rsub[i]
print @c.xbgr.xq73_u10.csub[i]
print @q.xbgr.xq73_u11.qnpn13g2[ic]
print @q.xbgr.xq73_u11.qnpn13g2[ib]
print @q.xbgr.xq73_u11.qnpn13g2[ie]
print @q.xbgr.xq73_u11.qnpn13g2[is]
print @r.xbgr.xq73_u11.rsub[i]
print @c.xbgr.xq73_u11.csub[i]
print @q.xbgr.xq73_u12.qnpn13g2[ic]
print @q.xbgr.xq73_u12.qnpn13g2[ib]
print @q.xbgr.xq73_u12.qnpn13g2[ie]
print @q.xbgr.xq73_u12.qnpn13g2[is]
print @r.xbgr.xq73_u12.rsub[i]
print @c.xbgr.xq73_u12.csub[i]
print @q.xbgr.xq73_u13.qnpn13g2[ic]
print @q.xbgr.xq73_u13.qnpn13g2[ib]
print @q.xbgr.xq73_u13.qnpn13g2[ie]
print @q.xbgr.xq73_u13.qnpn13g2[is]
print @r.xbgr.xq73_u13.rsub[i]
print @c.xbgr.xq73_u13.csub[i]
print @q.xbgr.xq73_u14.qnpn13g2[ic]
print @q.xbgr.xq73_u14.qnpn13g2[ib]
print @q.xbgr.xq73_u14.qnpn13g2[ie]
print @q.xbgr.xq73_u14.qnpn13g2[is]
print @r.xbgr.xq73_u14.rsub[i]
print @c.xbgr.xq73_u14.csub[i]
print @q.xbgr.xq73_u15.qnpn13g2[ic]
print @q.xbgr.xq73_u15.qnpn13g2[ib]
print @q.xbgr.xq73_u15.qnpn13g2[ie]
print @q.xbgr.xq73_u15.qnpn13g2[is]
print @r.xbgr.xq73_u15.rsub[i]
print @c.xbgr.xq73_u15.csub[i]
print @q.xbgr.xq73_u16.qnpn13g2[ic]
print @q.xbgr.xq73_u16.qnpn13g2[ib]
print @q.xbgr.xq73_u16.qnpn13g2[ie]
print @q.xbgr.xq73_u16.qnpn13g2[is]
print @r.xbgr.xq73_u16.rsub[i]
print @c.xbgr.xq73_u16.csub[i]
print @q.xbgr.xq73_u17.qnpn13g2[ic]
print @q.xbgr.xq73_u17.qnpn13g2[ib]
print @q.xbgr.xq73_u17.qnpn13g2[ie]
print @q.xbgr.xq73_u17.qnpn13g2[is]
print @r.xbgr.xq73_u17.rsub[i]
print @c.xbgr.xq73_u17.csub[i]
print @q.xbgr.xq73_u18.qnpn13g2[ic]
print @q.xbgr.xq73_u18.qnpn13g2[ib]
print @q.xbgr.xq73_u18.qnpn13g2[ie]
print @q.xbgr.xq73_u18.qnpn13g2[is]
print @r.xbgr.xq73_u18.rsub[i]
print @c.xbgr.xq73_u18.csub[i]
print @q.xbgr.xq73_u19.qnpn13g2[ic]
print @q.xbgr.xq73_u19.qnpn13g2[ib]
print @q.xbgr.xq73_u19.qnpn13g2[ie]
print @q.xbgr.xq73_u19.qnpn13g2[is]
print @r.xbgr.xq73_u19.rsub[i]
print @c.xbgr.xq73_u19.csub[i]
print @q.xbgr.xq73_u20.qnpn13g2[ic]
print @q.xbgr.xq73_u20.qnpn13g2[ib]
print @q.xbgr.xq73_u20.qnpn13g2[ie]
print @q.xbgr.xq73_u20.qnpn13g2[is]
print @r.xbgr.xq73_u20.rsub[i]
print @c.xbgr.xq73_u20.csub[i]
print @q.xbgr.xq73_u21.qnpn13g2[ic]
print @q.xbgr.xq73_u21.qnpn13g2[ib]
print @q.xbgr.xq73_u21.qnpn13g2[ie]
print @q.xbgr.xq73_u21.qnpn13g2[is]
print @r.xbgr.xq73_u21.rsub[i]
print @c.xbgr.xq73_u21.csub[i]
print @q.xbgr.xq73_u22.qnpn13g2[ic]
print @q.xbgr.xq73_u22.qnpn13g2[ib]
print @q.xbgr.xq73_u22.qnpn13g2[ie]
print @q.xbgr.xq73_u22.qnpn13g2[is]
print @r.xbgr.xq73_u22.rsub[i]
print @c.xbgr.xq73_u22.csub[i]
print @q.xbgr.xq73_u23.qnpn13g2[ic]
print @q.xbgr.xq73_u23.qnpn13g2[ib]
print @q.xbgr.xq73_u23.qnpn13g2[ie]
print @q.xbgr.xq73_u23.qnpn13g2[is]
print @r.xbgr.xq73_u23.rsub[i]
print @c.xbgr.xq73_u23.csub[i]
print @q.xbgr.xq73_u24.qnpn13g2[ic]
print @q.xbgr.xq73_u24.qnpn13g2[ib]
print @q.xbgr.xq73_u24.qnpn13g2[ie]
print @q.xbgr.xq73_u24.qnpn13g2[is]
print @r.xbgr.xq73_u24.rsub[i]
print @c.xbgr.xq73_u24.csub[i]
print @q.xbgr.xq74_u2.qnpn13g2[ic]
print @q.xbgr.xq74_u2.qnpn13g2[ib]
print @q.xbgr.xq74_u2.qnpn13g2[ie]
print @q.xbgr.xq74_u2.qnpn13g2[is]
print @r.xbgr.xq74_u2.rsub[i]
print @c.xbgr.xq74_u2.csub[i]
print @q.xbgr.xq74_u3.qnpn13g2[ic]
print @q.xbgr.xq74_u3.qnpn13g2[ib]
print @q.xbgr.xq74_u3.qnpn13g2[ie]
print @q.xbgr.xq74_u3.qnpn13g2[is]
print @r.xbgr.xq74_u3.rsub[i]
print @c.xbgr.xq74_u3.csub[i]
print @q.xbgr.xq74_u4.qnpn13g2[ic]
print @q.xbgr.xq74_u4.qnpn13g2[ib]
print @q.xbgr.xq74_u4.qnpn13g2[ie]
print @q.xbgr.xq74_u4.qnpn13g2[is]
print @r.xbgr.xq74_u4.rsub[i]
print @c.xbgr.xq74_u4.csub[i]
print @q.xbgr.xq74_u5.qnpn13g2[ic]
print @q.xbgr.xq74_u5.qnpn13g2[ib]
print @q.xbgr.xq74_u5.qnpn13g2[ie]
print @q.xbgr.xq74_u5.qnpn13g2[is]
print @r.xbgr.xq74_u5.rsub[i]
print @c.xbgr.xq74_u5.csub[i]
print @q.xbgr.xq74_u6.qnpn13g2[ic]
print @q.xbgr.xq74_u6.qnpn13g2[ib]
print @q.xbgr.xq74_u6.qnpn13g2[ie]
print @q.xbgr.xq74_u6.qnpn13g2[is]
print @r.xbgr.xq74_u6.rsub[i]
print @c.xbgr.xq74_u6.csub[i]
print @q.xbgr.xq74_u7.qnpn13g2[ic]
print @q.xbgr.xq74_u7.qnpn13g2[ib]
print @q.xbgr.xq74_u7.qnpn13g2[ie]
print @q.xbgr.xq74_u7.qnpn13g2[is]
print @r.xbgr.xq74_u7.rsub[i]
print @c.xbgr.xq74_u7.csub[i]
print @q.xbgr.xq74_u8.qnpn13g2[ic]
print @q.xbgr.xq74_u8.qnpn13g2[ib]
print @q.xbgr.xq74_u8.qnpn13g2[ie]
print @q.xbgr.xq74_u8.qnpn13g2[is]
print @r.xbgr.xq74_u8.rsub[i]
print @c.xbgr.xq74_u8.csub[i]
print @q.xbgr.xq74_u9.qnpn13g2[ic]
print @q.xbgr.xq74_u9.qnpn13g2[ib]
print @q.xbgr.xq74_u9.qnpn13g2[ie]
print @q.xbgr.xq74_u9.qnpn13g2[is]
print @r.xbgr.xq74_u9.rsub[i]
print @c.xbgr.xq74_u9.csub[i]
print @q.xbgr.xq74_u10.qnpn13g2[ic]
print @q.xbgr.xq74_u10.qnpn13g2[ib]
print @q.xbgr.xq74_u10.qnpn13g2[ie]
print @q.xbgr.xq74_u10.qnpn13g2[is]
print @r.xbgr.xq74_u10.rsub[i]
print @c.xbgr.xq74_u10.csub[i]
print @q.xbgr.xq74_u11.qnpn13g2[ic]
print @q.xbgr.xq74_u11.qnpn13g2[ib]
print @q.xbgr.xq74_u11.qnpn13g2[ie]
print @q.xbgr.xq74_u11.qnpn13g2[is]
print @r.xbgr.xq74_u11.rsub[i]
print @c.xbgr.xq74_u11.csub[i]
print @q.xbgr.xq74_u12.qnpn13g2[ic]
print @q.xbgr.xq74_u12.qnpn13g2[ib]
print @q.xbgr.xq74_u12.qnpn13g2[ie]
print @q.xbgr.xq74_u12.qnpn13g2[is]
print @r.xbgr.xq74_u12.rsub[i]
print @c.xbgr.xq74_u12.csub[i]
print @q.xbgr.xq74_u13.qnpn13g2[ic]
print @q.xbgr.xq74_u13.qnpn13g2[ib]
print @q.xbgr.xq74_u13.qnpn13g2[ie]
print @q.xbgr.xq74_u13.qnpn13g2[is]
print @r.xbgr.xq74_u13.rsub[i]
print @c.xbgr.xq74_u13.csub[i]
print @q.xbgr.xq74_u14.qnpn13g2[ic]
print @q.xbgr.xq74_u14.qnpn13g2[ib]
print @q.xbgr.xq74_u14.qnpn13g2[ie]
print @q.xbgr.xq74_u14.qnpn13g2[is]
print @r.xbgr.xq74_u14.rsub[i]
print @c.xbgr.xq74_u14.csub[i]
print @q.xbgr.xq74_u15.qnpn13g2[ic]
print @q.xbgr.xq74_u15.qnpn13g2[ib]
print @q.xbgr.xq74_u15.qnpn13g2[ie]
print @q.xbgr.xq74_u15.qnpn13g2[is]
print @r.xbgr.xq74_u15.rsub[i]
print @c.xbgr.xq74_u15.csub[i]
print @q.xbgr.xq74_u16.qnpn13g2[ic]
print @q.xbgr.xq74_u16.qnpn13g2[ib]
print @q.xbgr.xq74_u16.qnpn13g2[ie]
print @q.xbgr.xq74_u16.qnpn13g2[is]
print @r.xbgr.xq74_u16.rsub[i]
print @c.xbgr.xq74_u16.csub[i]
print @q.xbgr.xq74_u17.qnpn13g2[ic]
print @q.xbgr.xq74_u17.qnpn13g2[ib]
print @q.xbgr.xq74_u17.qnpn13g2[ie]
print @q.xbgr.xq74_u17.qnpn13g2[is]
print @r.xbgr.xq74_u17.rsub[i]
print @c.xbgr.xq74_u17.csub[i]
print @q.xbgr.xq74_u18.qnpn13g2[ic]
print @q.xbgr.xq74_u18.qnpn13g2[ib]
print @q.xbgr.xq74_u18.qnpn13g2[ie]
print @q.xbgr.xq74_u18.qnpn13g2[is]
print @r.xbgr.xq74_u18.rsub[i]
print @c.xbgr.xq74_u18.csub[i]
print @q.xbgr.xq74_u19.qnpn13g2[ic]
print @q.xbgr.xq74_u19.qnpn13g2[ib]
print @q.xbgr.xq74_u19.qnpn13g2[ie]
print @q.xbgr.xq74_u19.qnpn13g2[is]
print @r.xbgr.xq74_u19.rsub[i]
print @c.xbgr.xq74_u19.csub[i]
print @q.xbgr.xq74_u20.qnpn13g2[ic]
print @q.xbgr.xq74_u20.qnpn13g2[ib]
print @q.xbgr.xq74_u20.qnpn13g2[ie]
print @q.xbgr.xq74_u20.qnpn13g2[is]
print @r.xbgr.xq74_u20.rsub[i]
print @c.xbgr.xq74_u20.csub[i]
print @q.xbgr.xq74_u21.qnpn13g2[ic]
print @q.xbgr.xq74_u21.qnpn13g2[ib]
print @q.xbgr.xq74_u21.qnpn13g2[ie]
print @q.xbgr.xq74_u21.qnpn13g2[is]
print @r.xbgr.xq74_u21.rsub[i]
print @c.xbgr.xq74_u21.csub[i]
print @q.xbgr.xq74_u22.qnpn13g2[ic]
print @q.xbgr.xq74_u22.qnpn13g2[ib]
print @q.xbgr.xq74_u22.qnpn13g2[ie]
print @q.xbgr.xq74_u22.qnpn13g2[is]
print @r.xbgr.xq74_u22.rsub[i]
print @c.xbgr.xq74_u22.csub[i]
print @q.xbgr.xq74_u23.qnpn13g2[ic]
print @q.xbgr.xq74_u23.qnpn13g2[ib]
print @q.xbgr.xq74_u23.qnpn13g2[ie]
print @q.xbgr.xq74_u23.qnpn13g2[is]
print @r.xbgr.xq74_u23.rsub[i]
print @c.xbgr.xq74_u23.csub[i]
print @q.xbgr.xq74_u24.qnpn13g2[ic]
print @q.xbgr.xq74_u24.qnpn13g2[ib]
print @q.xbgr.xq74_u24.qnpn13g2[ie]
print @q.xbgr.xq74_u24.qnpn13g2[is]
print @r.xbgr.xq74_u24.rsub[i]
print @c.xbgr.xq74_u24.csub[i]
print @q.xbgr.xq75_u2.qnpn13g2[ic]
print @q.xbgr.xq75_u2.qnpn13g2[ib]
print @q.xbgr.xq75_u2.qnpn13g2[ie]
print @q.xbgr.xq75_u2.qnpn13g2[is]
print @r.xbgr.xq75_u2.rsub[i]
print @c.xbgr.xq75_u2.csub[i]
print @q.xbgr.xq75_u3.qnpn13g2[ic]
print @q.xbgr.xq75_u3.qnpn13g2[ib]
print @q.xbgr.xq75_u3.qnpn13g2[ie]
print @q.xbgr.xq75_u3.qnpn13g2[is]
print @r.xbgr.xq75_u3.rsub[i]
print @c.xbgr.xq75_u3.csub[i]
print @q.xbgr.xq75_u4.qnpn13g2[ic]
print @q.xbgr.xq75_u4.qnpn13g2[ib]
print @q.xbgr.xq75_u4.qnpn13g2[ie]
print @q.xbgr.xq75_u4.qnpn13g2[is]
print @r.xbgr.xq75_u4.rsub[i]
print @c.xbgr.xq75_u4.csub[i]
print @q.xbgr.xq75_u5.qnpn13g2[ic]
print @q.xbgr.xq75_u5.qnpn13g2[ib]
print @q.xbgr.xq75_u5.qnpn13g2[ie]
print @q.xbgr.xq75_u5.qnpn13g2[is]
print @r.xbgr.xq75_u5.rsub[i]
print @c.xbgr.xq75_u5.csub[i]
print @q.xbgr.xq75_u6.qnpn13g2[ic]
print @q.xbgr.xq75_u6.qnpn13g2[ib]
print @q.xbgr.xq75_u6.qnpn13g2[ie]
print @q.xbgr.xq75_u6.qnpn13g2[is]
print @r.xbgr.xq75_u6.rsub[i]
print @c.xbgr.xq75_u6.csub[i]
print @q.xbgr.xq75_u7.qnpn13g2[ic]
print @q.xbgr.xq75_u7.qnpn13g2[ib]
print @q.xbgr.xq75_u7.qnpn13g2[ie]
print @q.xbgr.xq75_u7.qnpn13g2[is]
print @r.xbgr.xq75_u7.rsub[i]
print @c.xbgr.xq75_u7.csub[i]
print @q.xbgr.xq75_u8.qnpn13g2[ic]
print @q.xbgr.xq75_u8.qnpn13g2[ib]
print @q.xbgr.xq75_u8.qnpn13g2[ie]
print @q.xbgr.xq75_u8.qnpn13g2[is]
print @r.xbgr.xq75_u8.rsub[i]
print @c.xbgr.xq75_u8.csub[i]
print @q.xbgr.xq75_u9.qnpn13g2[ic]
print @q.xbgr.xq75_u9.qnpn13g2[ib]
print @q.xbgr.xq75_u9.qnpn13g2[ie]
print @q.xbgr.xq75_u9.qnpn13g2[is]
print @r.xbgr.xq75_u9.rsub[i]
print @c.xbgr.xq75_u9.csub[i]
print @q.xbgr.xq75_u10.qnpn13g2[ic]
print @q.xbgr.xq75_u10.qnpn13g2[ib]
print @q.xbgr.xq75_u10.qnpn13g2[ie]
print @q.xbgr.xq75_u10.qnpn13g2[is]
print @r.xbgr.xq75_u10.rsub[i]
print @c.xbgr.xq75_u10.csub[i]
print @q.xbgr.xq75_u11.qnpn13g2[ic]
print @q.xbgr.xq75_u11.qnpn13g2[ib]
print @q.xbgr.xq75_u11.qnpn13g2[ie]
print @q.xbgr.xq75_u11.qnpn13g2[is]
print @r.xbgr.xq75_u11.rsub[i]
print @c.xbgr.xq75_u11.csub[i]
print @q.xbgr.xq75_u12.qnpn13g2[ic]
print @q.xbgr.xq75_u12.qnpn13g2[ib]
print @q.xbgr.xq75_u12.qnpn13g2[ie]
print @q.xbgr.xq75_u12.qnpn13g2[is]
print @r.xbgr.xq75_u12.rsub[i]
print @c.xbgr.xq75_u12.csub[i]
print @q.xbgr.xq75_u13.qnpn13g2[ic]
print @q.xbgr.xq75_u13.qnpn13g2[ib]
print @q.xbgr.xq75_u13.qnpn13g2[ie]
print @q.xbgr.xq75_u13.qnpn13g2[is]
print @r.xbgr.xq75_u13.rsub[i]
print @c.xbgr.xq75_u13.csub[i]
print @q.xbgr.xq75_u14.qnpn13g2[ic]
print @q.xbgr.xq75_u14.qnpn13g2[ib]
print @q.xbgr.xq75_u14.qnpn13g2[ie]
print @q.xbgr.xq75_u14.qnpn13g2[is]
print @r.xbgr.xq75_u14.rsub[i]
print @c.xbgr.xq75_u14.csub[i]
print @q.xbgr.xq75_u15.qnpn13g2[ic]
print @q.xbgr.xq75_u15.qnpn13g2[ib]
print @q.xbgr.xq75_u15.qnpn13g2[ie]
print @q.xbgr.xq75_u15.qnpn13g2[is]
print @r.xbgr.xq75_u15.rsub[i]
print @c.xbgr.xq75_u15.csub[i]
print @q.xbgr.xq75_u16.qnpn13g2[ic]
print @q.xbgr.xq75_u16.qnpn13g2[ib]
print @q.xbgr.xq75_u16.qnpn13g2[ie]
print @q.xbgr.xq75_u16.qnpn13g2[is]
print @r.xbgr.xq75_u16.rsub[i]
print @c.xbgr.xq75_u16.csub[i]
print @q.xbgr.xq75_u17.qnpn13g2[ic]
print @q.xbgr.xq75_u17.qnpn13g2[ib]
print @q.xbgr.xq75_u17.qnpn13g2[ie]
print @q.xbgr.xq75_u17.qnpn13g2[is]
print @r.xbgr.xq75_u17.rsub[i]
print @c.xbgr.xq75_u17.csub[i]
print @q.xbgr.xq75_u18.qnpn13g2[ic]
print @q.xbgr.xq75_u18.qnpn13g2[ib]
print @q.xbgr.xq75_u18.qnpn13g2[ie]
print @q.xbgr.xq75_u18.qnpn13g2[is]
print @r.xbgr.xq75_u18.rsub[i]
print @c.xbgr.xq75_u18.csub[i]
print @q.xbgr.xq75_u19.qnpn13g2[ic]
print @q.xbgr.xq75_u19.qnpn13g2[ib]
print @q.xbgr.xq75_u19.qnpn13g2[ie]
print @q.xbgr.xq75_u19.qnpn13g2[is]
print @r.xbgr.xq75_u19.rsub[i]
print @c.xbgr.xq75_u19.csub[i]
print @q.xbgr.xq75_u20.qnpn13g2[ic]
print @q.xbgr.xq75_u20.qnpn13g2[ib]
print @q.xbgr.xq75_u20.qnpn13g2[ie]
print @q.xbgr.xq75_u20.qnpn13g2[is]
print @r.xbgr.xq75_u20.rsub[i]
print @c.xbgr.xq75_u20.csub[i]
print @q.xbgr.xq75_u21.qnpn13g2[ic]
print @q.xbgr.xq75_u21.qnpn13g2[ib]
print @q.xbgr.xq75_u21.qnpn13g2[ie]
print @q.xbgr.xq75_u21.qnpn13g2[is]
print @r.xbgr.xq75_u21.rsub[i]
print @c.xbgr.xq75_u21.csub[i]
print @q.xbgr.xq75_u22.qnpn13g2[ic]
print @q.xbgr.xq75_u22.qnpn13g2[ib]
print @q.xbgr.xq75_u22.qnpn13g2[ie]
print @q.xbgr.xq75_u22.qnpn13g2[is]
print @r.xbgr.xq75_u22.rsub[i]
print @c.xbgr.xq75_u22.csub[i]
print @q.xbgr.xq75_u23.qnpn13g2[ic]
print @q.xbgr.xq75_u23.qnpn13g2[ib]
print @q.xbgr.xq75_u23.qnpn13g2[ie]
print @q.xbgr.xq75_u23.qnpn13g2[is]
print @r.xbgr.xq75_u23.rsub[i]
print @c.xbgr.xq75_u23.csub[i]
print @q.xbgr.xq75_u24.qnpn13g2[ic]
print @q.xbgr.xq75_u24.qnpn13g2[ib]
print @q.xbgr.xq75_u24.qnpn13g2[ie]
print @q.xbgr.xq75_u24.qnpn13g2[is]
print @r.xbgr.xq75_u24.rsub[i]
print @c.xbgr.xq75_u24.csub[i]
print @q.xbgr.xq76_u2.qnpn13g2[ic]
print @q.xbgr.xq76_u2.qnpn13g2[ib]
print @q.xbgr.xq76_u2.qnpn13g2[ie]
print @q.xbgr.xq76_u2.qnpn13g2[is]
print @r.xbgr.xq76_u2.rsub[i]
print @c.xbgr.xq76_u2.csub[i]
print @q.xbgr.xq76_u3.qnpn13g2[ic]
print @q.xbgr.xq76_u3.qnpn13g2[ib]
print @q.xbgr.xq76_u3.qnpn13g2[ie]
print @q.xbgr.xq76_u3.qnpn13g2[is]
print @r.xbgr.xq76_u3.rsub[i]
print @c.xbgr.xq76_u3.csub[i]
print @q.xbgr.xq76_u4.qnpn13g2[ic]
print @q.xbgr.xq76_u4.qnpn13g2[ib]
print @q.xbgr.xq76_u4.qnpn13g2[ie]
print @q.xbgr.xq76_u4.qnpn13g2[is]
print @r.xbgr.xq76_u4.rsub[i]
print @c.xbgr.xq76_u4.csub[i]
print @q.xbgr.xq76_u5.qnpn13g2[ic]
print @q.xbgr.xq76_u5.qnpn13g2[ib]
print @q.xbgr.xq76_u5.qnpn13g2[ie]
print @q.xbgr.xq76_u5.qnpn13g2[is]
print @r.xbgr.xq76_u5.rsub[i]
print @c.xbgr.xq76_u5.csub[i]
print @q.xbgr.xq76_u6.qnpn13g2[ic]
print @q.xbgr.xq76_u6.qnpn13g2[ib]
print @q.xbgr.xq76_u6.qnpn13g2[ie]
print @q.xbgr.xq76_u6.qnpn13g2[is]
print @r.xbgr.xq76_u6.rsub[i]
print @c.xbgr.xq76_u6.csub[i]
print @q.xbgr.xq76_u7.qnpn13g2[ic]
print @q.xbgr.xq76_u7.qnpn13g2[ib]
print @q.xbgr.xq76_u7.qnpn13g2[ie]
print @q.xbgr.xq76_u7.qnpn13g2[is]
print @r.xbgr.xq76_u7.rsub[i]
print @c.xbgr.xq76_u7.csub[i]
print @q.xbgr.xq76_u8.qnpn13g2[ic]
print @q.xbgr.xq76_u8.qnpn13g2[ib]
print @q.xbgr.xq76_u8.qnpn13g2[ie]
print @q.xbgr.xq76_u8.qnpn13g2[is]
print @r.xbgr.xq76_u8.rsub[i]
print @c.xbgr.xq76_u8.csub[i]
print @q.xbgr.xq76_u9.qnpn13g2[ic]
print @q.xbgr.xq76_u9.qnpn13g2[ib]
print @q.xbgr.xq76_u9.qnpn13g2[ie]
print @q.xbgr.xq76_u9.qnpn13g2[is]
print @r.xbgr.xq76_u9.rsub[i]
print @c.xbgr.xq76_u9.csub[i]
print @q.xbgr.xq76_u10.qnpn13g2[ic]
print @q.xbgr.xq76_u10.qnpn13g2[ib]
print @q.xbgr.xq76_u10.qnpn13g2[ie]
print @q.xbgr.xq76_u10.qnpn13g2[is]
print @r.xbgr.xq76_u10.rsub[i]
print @c.xbgr.xq76_u10.csub[i]
print @q.xbgr.xq76_u11.qnpn13g2[ic]
print @q.xbgr.xq76_u11.qnpn13g2[ib]
print @q.xbgr.xq76_u11.qnpn13g2[ie]
print @q.xbgr.xq76_u11.qnpn13g2[is]
print @r.xbgr.xq76_u11.rsub[i]
print @c.xbgr.xq76_u11.csub[i]
print @q.xbgr.xq76_u12.qnpn13g2[ic]
print @q.xbgr.xq76_u12.qnpn13g2[ib]
print @q.xbgr.xq76_u12.qnpn13g2[ie]
print @q.xbgr.xq76_u12.qnpn13g2[is]
print @r.xbgr.xq76_u12.rsub[i]
print @c.xbgr.xq76_u12.csub[i]
print @q.xbgr.xq76_u13.qnpn13g2[ic]
print @q.xbgr.xq76_u13.qnpn13g2[ib]
print @q.xbgr.xq76_u13.qnpn13g2[ie]
print @q.xbgr.xq76_u13.qnpn13g2[is]
print @r.xbgr.xq76_u13.rsub[i]
print @c.xbgr.xq76_u13.csub[i]
print @q.xbgr.xq76_u14.qnpn13g2[ic]
print @q.xbgr.xq76_u14.qnpn13g2[ib]
print @q.xbgr.xq76_u14.qnpn13g2[ie]
print @q.xbgr.xq76_u14.qnpn13g2[is]
print @r.xbgr.xq76_u14.rsub[i]
print @c.xbgr.xq76_u14.csub[i]
print @q.xbgr.xq76_u15.qnpn13g2[ic]
print @q.xbgr.xq76_u15.qnpn13g2[ib]
print @q.xbgr.xq76_u15.qnpn13g2[ie]
print @q.xbgr.xq76_u15.qnpn13g2[is]
print @r.xbgr.xq76_u15.rsub[i]
print @c.xbgr.xq76_u15.csub[i]
print @q.xbgr.xq76_u16.qnpn13g2[ic]
print @q.xbgr.xq76_u16.qnpn13g2[ib]
print @q.xbgr.xq76_u16.qnpn13g2[ie]
print @q.xbgr.xq76_u16.qnpn13g2[is]
print @r.xbgr.xq76_u16.rsub[i]
print @c.xbgr.xq76_u16.csub[i]
print @q.xbgr.xq76_u17.qnpn13g2[ic]
print @q.xbgr.xq76_u17.qnpn13g2[ib]
print @q.xbgr.xq76_u17.qnpn13g2[ie]
print @q.xbgr.xq76_u17.qnpn13g2[is]
print @r.xbgr.xq76_u17.rsub[i]
print @c.xbgr.xq76_u17.csub[i]
print @q.xbgr.xq76_u18.qnpn13g2[ic]
print @q.xbgr.xq76_u18.qnpn13g2[ib]
print @q.xbgr.xq76_u18.qnpn13g2[ie]
print @q.xbgr.xq76_u18.qnpn13g2[is]
print @r.xbgr.xq76_u18.rsub[i]
print @c.xbgr.xq76_u18.csub[i]
print @q.xbgr.xq76_u19.qnpn13g2[ic]
print @q.xbgr.xq76_u19.qnpn13g2[ib]
print @q.xbgr.xq76_u19.qnpn13g2[ie]
print @q.xbgr.xq76_u19.qnpn13g2[is]
print @r.xbgr.xq76_u19.rsub[i]
print @c.xbgr.xq76_u19.csub[i]
print @q.xbgr.xq76_u20.qnpn13g2[ic]
print @q.xbgr.xq76_u20.qnpn13g2[ib]
print @q.xbgr.xq76_u20.qnpn13g2[ie]
print @q.xbgr.xq76_u20.qnpn13g2[is]
print @r.xbgr.xq76_u20.rsub[i]
print @c.xbgr.xq76_u20.csub[i]
print @q.xbgr.xq76_u21.qnpn13g2[ic]
print @q.xbgr.xq76_u21.qnpn13g2[ib]
print @q.xbgr.xq76_u21.qnpn13g2[ie]
print @q.xbgr.xq76_u21.qnpn13g2[is]
print @r.xbgr.xq76_u21.rsub[i]
print @c.xbgr.xq76_u21.csub[i]
print @q.xbgr.xq76_u22.qnpn13g2[ic]
print @q.xbgr.xq76_u22.qnpn13g2[ib]
print @q.xbgr.xq76_u22.qnpn13g2[ie]
print @q.xbgr.xq76_u22.qnpn13g2[is]
print @r.xbgr.xq76_u22.rsub[i]
print @c.xbgr.xq76_u22.csub[i]
print @q.xbgr.xq76_u23.qnpn13g2[ic]
print @q.xbgr.xq76_u23.qnpn13g2[ib]
print @q.xbgr.xq76_u23.qnpn13g2[ie]
print @q.xbgr.xq76_u23.qnpn13g2[is]
print @r.xbgr.xq76_u23.rsub[i]
print @c.xbgr.xq76_u23.csub[i]
print @q.xbgr.xq76_u24.qnpn13g2[ic]
print @q.xbgr.xq76_u24.qnpn13g2[ib]
print @q.xbgr.xq76_u24.qnpn13g2[ie]
print @q.xbgr.xq76_u24.qnpn13g2[is]
print @r.xbgr.xq76_u24.rsub[i]
print @c.xbgr.xq76_u24.csub[i]
print @n.xbgr.xr77_u2.nr1[ibody]
print @n.xbgr.xr77_u3.nr1[ibody]
print @n.xbgr.xr77_u4.nr1[ibody]
print @n.xbgr.xr77_u5.nr1[ibody]
print @n.xbgr.xr77_u6.nr1[ibody]
print @n.xbgr.xr77_u7.nr1[ibody]
print @n.xbgr.xr77_u8.nr1[ibody]
print @n.xbgr.xr77_u9.nr1[ibody]
print @n.xbgr.xr77_u10.nr1[ibody]
print @n.xbgr.xr77_u11.nr1[ibody]
print @n.xbgr.xr77_u12.nr1[ibody]
print @n.xbgr.xr77_u13.nr1[ibody]
print @n.xbgr.xr77_u14.nr1[ibody]
print @n.xbgr.xr77_u15.nr1[ibody]
print @n.xbgr.xr77_u16.nr1[ibody]
print @n.xbgr.xr77_u17.nr1[ibody]
print @n.xbgr.xr77_u18.nr1[ibody]
print @n.xbgr.xr77_u19.nr1[ibody]
print @n.xbgr.xr77_u20.nr1[ibody]
print @n.xbgr.xr77_u21.nr1[ibody]
print @n.xbgr.xr77_u22.nr1[ibody]
print @n.xbgr.xr77_u23.nr1[ibody]
print @n.xbgr.xr77_u24.nr1[ibody]
print @n.xbgr.xr78_u2.nr1[ibody]
print @n.xbgr.xr78_u3.nr1[ibody]
print @n.xbgr.xr78_u4.nr1[ibody]
print @n.xbgr.xr78_u5.nr1[ibody]
print @n.xbgr.xr78_u6.nr1[ibody]
print @n.xbgr.xr78_u7.nr1[ibody]
print @n.xbgr.xr78_u8.nr1[ibody]
print @n.xbgr.xr78_u9.nr1[ibody]
print @n.xbgr.xr78_u10.nr1[ibody]
print @n.xbgr.xr78_u11.nr1[ibody]
print @n.xbgr.xr78_u12.nr1[ibody]
print @n.xbgr.xr78_u13.nr1[ibody]
print @n.xbgr.xr78_u14.nr1[ibody]
print @n.xbgr.xr78_u15.nr1[ibody]
print @n.xbgr.xr78_u16.nr1[ibody]
print @n.xbgr.xr78_u17.nr1[ibody]
print @n.xbgr.xr78_u18.nr1[ibody]
print @n.xbgr.xr78_u19.nr1[ibody]
print @n.xbgr.xr78_u20.nr1[ibody]
print @n.xbgr.xr78_u21.nr1[ibody]
print @n.xbgr.xr78_u22.nr1[ibody]
print @n.xbgr.xr78_u23.nr1[ibody]
print @n.xbgr.xr78_u24.nr1[ibody]
print @n.xbgr.xr79_u2.nr1[ibody]
print @n.xbgr.xr79_u3.nr1[ibody]
print @n.xbgr.xr79_u4.nr1[ibody]
print @n.xbgr.xr79_u5.nr1[ibody]
print @n.xbgr.xr79_u6.nr1[ibody]
print @n.xbgr.xr79_u7.nr1[ibody]
print @n.xbgr.xr79_u8.nr1[ibody]
print @n.xbgr.xr79_u9.nr1[ibody]
print @n.xbgr.xr79_u10.nr1[ibody]
print @n.xbgr.xr79_u11.nr1[ibody]
print @n.xbgr.xr79_u12.nr1[ibody]
print @n.xbgr.xr79_u13.nr1[ibody]
print @n.xbgr.xr79_u14.nr1[ibody]
print @n.xbgr.xr79_u15.nr1[ibody]
print @n.xbgr.xr79_u16.nr1[ibody]
print @n.xbgr.xr79_u17.nr1[ibody]
print @n.xbgr.xr79_u18.nr1[ibody]
print @n.xbgr.xr79_u19.nr1[ibody]
print @n.xbgr.xr79_u20.nr1[ibody]
print @n.xbgr.xr79_u21.nr1[ibody]
print @n.xbgr.xr79_u22.nr1[ibody]
print @n.xbgr.xr79_u23.nr1[ibody]
print @n.xbgr.xr79_u24.nr1[ibody]
print @n.xbgr.xr80_u2.nr1[ibody]
print @n.xbgr.xr80_u3.nr1[ibody]
print @n.xbgr.xr80_u4.nr1[ibody]
print @n.xbgr.xr80_u5.nr1[ibody]
print @n.xbgr.xr80_u6.nr1[ibody]
print @n.xbgr.xr80_u7.nr1[ibody]
print @n.xbgr.xr80_u8.nr1[ibody]
print @n.xbgr.xr80_u9.nr1[ibody]
print @n.xbgr.xr80_u10.nr1[ibody]
print @n.xbgr.xr80_u11.nr1[ibody]
print @n.xbgr.xr80_u12.nr1[ibody]
print @n.xbgr.xr80_u13.nr1[ibody]
print @n.xbgr.xr80_u14.nr1[ibody]
print @n.xbgr.xr80_u15.nr1[ibody]
print @n.xbgr.xr80_u16.nr1[ibody]
print @n.xbgr.xr80_u17.nr1[ibody]
print @n.xbgr.xr80_u18.nr1[ibody]
print @n.xbgr.xr80_u19.nr1[ibody]
print @n.xbgr.xr80_u20.nr1[ibody]
print @n.xbgr.xr80_u21.nr1[ibody]
print @n.xbgr.xr80_u22.nr1[ibody]
print @n.xbgr.xr80_u23.nr1[ibody]
print @n.xbgr.xr80_u24.nr1[ibody]
print @n.xbgr.xr81_u2.nr1[ibody]
print @n.xbgr.xr81_u3.nr1[ibody]
print @n.xbgr.xr81_u4.nr1[ibody]
print @n.xbgr.xr81_u5.nr1[ibody]
print @n.xbgr.xr81_u6.nr1[ibody]
print @n.xbgr.xr81_u7.nr1[ibody]
print @n.xbgr.xr81_u8.nr1[ibody]
print @n.xbgr.xr81_u9.nr1[ibody]
print @n.xbgr.xr81_u10.nr1[ibody]
print @n.xbgr.xr81_u11.nr1[ibody]
print @n.xbgr.xr81_u12.nr1[ibody]
print @n.xbgr.xr81_u13.nr1[ibody]
print @n.xbgr.xr81_u14.nr1[ibody]
print @n.xbgr.xr81_u15.nr1[ibody]
print @n.xbgr.xr81_u16.nr1[ibody]
print @n.xbgr.xr81_u17.nr1[ibody]
print @n.xbgr.xr81_u18.nr1[ibody]
print @n.xbgr.xr81_u19.nr1[ibody]
print @n.xbgr.xr81_u20.nr1[ibody]
print @n.xbgr.xr81_u21.nr1[ibody]
print @n.xbgr.xr81_u22.nr1[ibody]
print @n.xbgr.xr81_u23.nr1[ibody]
print @n.xbgr.xr81_u24.nr1[ibody]
print @n.xbgr.xr82_u2.nr1[ibody]
print @n.xbgr.xr82_u3.nr1[ibody]
print @n.xbgr.xr82_u4.nr1[ibody]
print @n.xbgr.xr82_u5.nr1[ibody]
print @n.xbgr.xr82_u6.nr1[ibody]
print @n.xbgr.xr82_u7.nr1[ibody]
print @n.xbgr.xr82_u8.nr1[ibody]
print @n.xbgr.xr82_u9.nr1[ibody]
print @n.xbgr.xr82_u10.nr1[ibody]
print @n.xbgr.xr82_u11.nr1[ibody]
print @n.xbgr.xr82_u12.nr1[ibody]
print @n.xbgr.xr82_u13.nr1[ibody]
print @n.xbgr.xr82_u14.nr1[ibody]
print @n.xbgr.xr82_u15.nr1[ibody]
print @n.xbgr.xr82_u16.nr1[ibody]
print @n.xbgr.xr82_u17.nr1[ibody]
print @n.xbgr.xr82_u18.nr1[ibody]
print @n.xbgr.xr82_u19.nr1[ibody]
print @n.xbgr.xr82_u20.nr1[ibody]
print @n.xbgr.xr82_u21.nr1[ibody]
print @n.xbgr.xr82_u22.nr1[ibody]
print @n.xbgr.xr82_u23.nr1[ibody]
print @n.xbgr.xr82_u24.nr1[ibody]
print @n.xbgr.xr83_u2.nr1[ibody]
print @n.xbgr.xr83_u3.nr1[ibody]
print @n.xbgr.xr83_u4.nr1[ibody]
print @n.xbgr.xr83_u5.nr1[ibody]
print @n.xbgr.xr83_u6.nr1[ibody]
print @n.xbgr.xr83_u7.nr1[ibody]
print @n.xbgr.xr83_u8.nr1[ibody]
print @n.xbgr.xr83_u9.nr1[ibody]
print @n.xbgr.xr83_u10.nr1[ibody]
print @n.xbgr.xr83_u11.nr1[ibody]
print @n.xbgr.xr83_u12.nr1[ibody]
print @n.xbgr.xr83_u13.nr1[ibody]
print @n.xbgr.xr83_u14.nr1[ibody]
print @n.xbgr.xr83_u15.nr1[ibody]
print @n.xbgr.xr83_u16.nr1[ibody]
print @n.xbgr.xr83_u17.nr1[ibody]
print @n.xbgr.xr83_u18.nr1[ibody]
print @n.xbgr.xr83_u19.nr1[ibody]
print @n.xbgr.xr83_u20.nr1[ibody]
print @n.xbgr.xr83_u21.nr1[ibody]
print @n.xbgr.xr83_u22.nr1[ibody]
print @n.xbgr.xr83_u23.nr1[ibody]
print @n.xbgr.xr83_u24.nr1[ibody]
print @n.xbgr.xr84_u2.nr1[ibody]
print @n.xbgr.xr84_u3.nr1[ibody]
print @n.xbgr.xr84_u4.nr1[ibody]
print @n.xbgr.xr84_u5.nr1[ibody]
print @n.xbgr.xr84_u6.nr1[ibody]
print @n.xbgr.xr84_u7.nr1[ibody]
print @n.xbgr.xr84_u8.nr1[ibody]
print @n.xbgr.xr84_u9.nr1[ibody]
print @n.xbgr.xr84_u10.nr1[ibody]
print @n.xbgr.xr84_u11.nr1[ibody]
print @n.xbgr.xr84_u12.nr1[ibody]
print @n.xbgr.xr84_u13.nr1[ibody]
print @n.xbgr.xr84_u14.nr1[ibody]
print @n.xbgr.xr84_u15.nr1[ibody]
print @n.xbgr.xr84_u16.nr1[ibody]
print @n.xbgr.xr84_u17.nr1[ibody]
print @n.xbgr.xr84_u18.nr1[ibody]
print @n.xbgr.xr84_u19.nr1[ibody]
print @n.xbgr.xr84_u20.nr1[ibody]
print @n.xbgr.xr84_u21.nr1[ibody]
print @n.xbgr.xr84_u22.nr1[ibody]
print @n.xbgr.xr84_u23.nr1[ibody]
print @n.xbgr.xr84_u24.nr1[ibody]
print @n.xbgr.xr85_u2.nr1[ibody]
print @n.xbgr.xr85_u3.nr1[ibody]
print @n.xbgr.xr85_u4.nr1[ibody]
print @n.xbgr.xr85_u5.nr1[ibody]
print @n.xbgr.xr85_u6.nr1[ibody]
print @n.xbgr.xr85_u7.nr1[ibody]
print @n.xbgr.xr85_u8.nr1[ibody]
print @n.xbgr.xr85_u9.nr1[ibody]
print @n.xbgr.xr85_u10.nr1[ibody]
print @n.xbgr.xr85_u11.nr1[ibody]
print @n.xbgr.xr85_u12.nr1[ibody]
print @n.xbgr.xr85_u13.nr1[ibody]
print @n.xbgr.xr85_u14.nr1[ibody]
print @n.xbgr.xr85_u15.nr1[ibody]
print @n.xbgr.xr85_u16.nr1[ibody]
print @n.xbgr.xr85_u17.nr1[ibody]
print @n.xbgr.xr85_u18.nr1[ibody]
print @n.xbgr.xr85_u19.nr1[ibody]
print @n.xbgr.xr85_u20.nr1[ibody]
print @n.xbgr.xr85_u21.nr1[ibody]
print @n.xbgr.xr85_u22.nr1[ibody]
print @n.xbgr.xr85_u23.nr1[ibody]
print @n.xbgr.xr85_u24.nr1[ibody]
print @n.xbgr.xr86_u2.nr1[ibody]
print @n.xbgr.xr86_u3.nr1[ibody]
print @n.xbgr.xr86_u4.nr1[ibody]
print @n.xbgr.xr86_u5.nr1[ibody]
print @n.xbgr.xr86_u6.nr1[ibody]
print @n.xbgr.xr86_u7.nr1[ibody]
print @n.xbgr.xr86_u8.nr1[ibody]
print @n.xbgr.xr86_u9.nr1[ibody]
print @n.xbgr.xr86_u10.nr1[ibody]
print @n.xbgr.xr86_u11.nr1[ibody]
print @n.xbgr.xr86_u12.nr1[ibody]
print @n.xbgr.xr86_u13.nr1[ibody]
print @n.xbgr.xr86_u14.nr1[ibody]
print @n.xbgr.xr86_u15.nr1[ibody]
print @n.xbgr.xr86_u16.nr1[ibody]
print @n.xbgr.xr86_u17.nr1[ibody]
print @n.xbgr.xr86_u18.nr1[ibody]
print @n.xbgr.xr86_u19.nr1[ibody]
print @n.xbgr.xr86_u20.nr1[ibody]
print @n.xbgr.xr86_u21.nr1[ibody]
print @n.xbgr.xr86_u22.nr1[ibody]
print @n.xbgr.xr86_u23.nr1[ibody]
print @n.xbgr.xr86_u24.nr1[ibody]
echo RAW_CURRENT_LEDGER_END
wrdata op_nodes.dat v(xbgr.b1b) v(xbgr.c2) v(xbgr.d1) v(xbgr.d2) v(xbgr.d3) v(xbgr.d4) v(xbgr.d5) v(xbgr.det) v(dvbe) v(iptat) v(xbgr.kick) v(xbgr.n1) v(xbgr.n_10) v(xbgr.n_11) v(xbgr.n_12) v(xbgr.n_13) v(xbgr.n_14) v(xbgr.n_15) v(xbgr.n_16) v(xbgr.n_17) v(xbgr.n_18) v(xbgr.n_19) v(xbgr.n_2) v(xbgr.n_21) v(xbgr.n_22) v(xbgr.n_23) v(xbgr.n_24) v(xbgr.n_25) v(xbgr.n_26) v(xbgr.n_27) v(xbgr.n_3) v(xbgr.n_30) v(xbgr.n_31) v(xbgr.n_33) v(xbgr.n_34) v(xbgr.n_36) v(xbgr.n_37) v(xbgr.n_4) v(xbgr.n_5) v(xbgr.n_6) v(xbgr.n_7) v(xbgr.n_8) v(xbgr.n_9) v(pbias) v(pcasc) v(r4) v(xbgr.r4n) v(xbgr.vb2) v(vbe) v(xbgr.vbe3) v(xbgr.vd1) v(xbgr.vd2) v(vdd) v(vref) v(vdd)-v(vdd) i(vdd) i(vload) i(vr4) i(vsub)
print @n.xbgr.xr1.nr1[nsmm_rsh]
print @n.xbgr.xr1.nr1[nsmm_w]
print @n.xbgr.xr1.nr1[nsmm_l]
print @n.xbgr.xr2.nr1[nsmm_rsh]
print @n.xbgr.xr2.nr1[nsmm_w]
print @n.xbgr.xr2.nr1[nsmm_l]
print @n.xbgr.xr3.nr1[nsmm_rsh]
print @n.xbgr.xr3.nr1[nsmm_w]
print @n.xbgr.xr3.nr1[nsmm_l]
print @n.xbgr.xr4.nr1[nsmm_rsh]
print @n.xbgr.xr4.nr1[nsmm_w]
print @n.xbgr.xr4.nr1[nsmm_l]
print @n.xbgr.xr5.nr1[nsmm_rsh]
print @n.xbgr.xr5.nr1[nsmm_w]
print @n.xbgr.xr5.nr1[nsmm_l]
print @n.xbgr.xr6.nr1[nsmm_rsh]
print @n.xbgr.xr6.nr1[nsmm_w]
print @n.xbgr.xr6.nr1[nsmm_l]
print @n.xbgr.xr7.nr1[nsmm_rsh]
print @n.xbgr.xr7.nr1[nsmm_w]
print @n.xbgr.xr7.nr1[nsmm_l]
print @n.xbgr.xr8.nr1[nsmm_rsh]
print @n.xbgr.xr8.nr1[nsmm_w]
print @n.xbgr.xr8.nr1[nsmm_l]
print @n.xbgr.xr9.nr1[nsmm_rsh]
print @n.xbgr.xr9.nr1[nsmm_w]
print @n.xbgr.xr9.nr1[nsmm_l]
print @n.xbgr.xr10.nr1[nsmm_rsh]
print @n.xbgr.xr10.nr1[nsmm_w]
print @n.xbgr.xr10.nr1[nsmm_l]
print @n.xbgr.xr11.nr1[nsmm_rsh]
print @n.xbgr.xr11.nr1[nsmm_w]
print @n.xbgr.xr11.nr1[nsmm_l]
print @n.xbgr.xr12.nr1[nsmm_rsh]
print @n.xbgr.xr12.nr1[nsmm_w]
print @n.xbgr.xr12.nr1[nsmm_l]
print @n.xbgr.xr13.nr1[nsmm_rsh]
print @n.xbgr.xr13.nr1[nsmm_w]
print @n.xbgr.xr13.nr1[nsmm_l]
print @n.xbgr.xr14.nr1[nsmm_rsh]
print @n.xbgr.xr14.nr1[nsmm_w]
print @n.xbgr.xr14.nr1[nsmm_l]
print @n.xbgr.xr15.nr1[nsmm_rsh]
print @n.xbgr.xr15.nr1[nsmm_w]
print @n.xbgr.xr15.nr1[nsmm_l]
print @n.xbgr.xr16.nr1[nsmm_rsh]
print @n.xbgr.xr16.nr1[nsmm_w]
print @n.xbgr.xr16.nr1[nsmm_l]
print @n.xbgr.xr17.nr1[nsmm_rsh]
print @n.xbgr.xr17.nr1[nsmm_w]
print @n.xbgr.xr17.nr1[nsmm_l]
print @n.xbgr.xr18.nr1[nsmm_rsh]
print @n.xbgr.xr18.nr1[nsmm_w]
print @n.xbgr.xr18.nr1[nsmm_l]
print @n.xbgr.xr19.nr1[nsmm_rsh]
print @n.xbgr.xr19.nr1[nsmm_w]
print @n.xbgr.xr19.nr1[nsmm_l]
print @n.xbgr.xr20.nr1[nsmm_rsh]
print @n.xbgr.xr20.nr1[nsmm_w]
print @n.xbgr.xr20.nr1[nsmm_l]
print @n.xbgr.xr21.nr1[nsmm_rsh]
print @n.xbgr.xr21.nr1[nsmm_w]
print @n.xbgr.xr21.nr1[nsmm_l]
print @n.xbgr.xr22.nr1[nsmm_rsh]
print @n.xbgr.xr22.nr1[nsmm_w]
print @n.xbgr.xr22.nr1[nsmm_l]
print @n.xbgr.xr23.nr1[nsmm_rsh]
print @n.xbgr.xr23.nr1[nsmm_w]
print @n.xbgr.xr23.nr1[nsmm_l]
print @n.xbgr.xr24.nr1[nsmm_rsh]
print @n.xbgr.xr24.nr1[nsmm_w]
print @n.xbgr.xr24.nr1[nsmm_l]
print @n.xbgr.xr25.nr1[nsmm_rsh]
print @n.xbgr.xr25.nr1[nsmm_w]
print @n.xbgr.xr25.nr1[nsmm_l]
print @n.xbgr.xr26.nr1[nsmm_rsh]
print @n.xbgr.xr26.nr1[nsmm_w]
print @n.xbgr.xr26.nr1[nsmm_l]
print @n.xbgr.xm27.nsg13_hv_pmos[w]
print @n.xbgr.xm27.nsg13_hv_pmos[l]
print @n.xbgr.xm27.nsg13_hv_pmos[delvto]
print @n.xbgr.xm27.nsg13_hv_pmos[factuo]
print @n.xbgr.xm28.nsg13_hv_pmos[w]
print @n.xbgr.xm28.nsg13_hv_pmos[l]
print @n.xbgr.xm28.nsg13_hv_pmos[delvto]
print @n.xbgr.xm28.nsg13_hv_pmos[factuo]
print @n.xbgr.xm29.nsg13_hv_nmos[w]
print @n.xbgr.xm29.nsg13_hv_nmos[l]
print @n.xbgr.xm29.nsg13_hv_nmos[delvto]
print @n.xbgr.xm29.nsg13_hv_nmos[factuo]
print @n.xbgr.xm30.nsg13_hv_nmos[w]
print @n.xbgr.xm30.nsg13_hv_nmos[l]
print @n.xbgr.xm30.nsg13_hv_nmos[delvto]
print @n.xbgr.xm30.nsg13_hv_nmos[factuo]
print @n.xbgr.xm31.nsg13_hv_nmos[w]
print @n.xbgr.xm31.nsg13_hv_nmos[l]
print @n.xbgr.xm31.nsg13_hv_nmos[delvto]
print @n.xbgr.xm31.nsg13_hv_nmos[factuo]
print @n.xbgr.xm32.nsg13_hv_nmos[w]
print @n.xbgr.xm32.nsg13_hv_nmos[l]
print @n.xbgr.xm32.nsg13_hv_nmos[delvto]
print @n.xbgr.xm32.nsg13_hv_nmos[factuo]
print @n.xbgr.xm33.nsg13_hv_nmos[w]
print @n.xbgr.xm33.nsg13_hv_nmos[l]
print @n.xbgr.xm33.nsg13_hv_nmos[delvto]
print @n.xbgr.xm33.nsg13_hv_nmos[factuo]
print @n.xbgr.xm34.nsg13_hv_nmos[w]
print @n.xbgr.xm34.nsg13_hv_nmos[l]
print @n.xbgr.xm34.nsg13_hv_nmos[delvto]
print @n.xbgr.xm34.nsg13_hv_nmos[factuo]
print @n.xbgr.xm35.nsg13_hv_nmos[w]
print @n.xbgr.xm35.nsg13_hv_nmos[l]
print @n.xbgr.xm35.nsg13_hv_nmos[delvto]
print @n.xbgr.xm35.nsg13_hv_nmos[factuo]
print @n.xbgr.xm36.nsg13_hv_nmos[w]
print @n.xbgr.xm36.nsg13_hv_nmos[l]
print @n.xbgr.xm36.nsg13_hv_nmos[delvto]
print @n.xbgr.xm36.nsg13_hv_nmos[factuo]
print @n.xbgr.xm37.nsg13_hv_nmos[w]
print @n.xbgr.xm37.nsg13_hv_nmos[l]
print @n.xbgr.xm37.nsg13_hv_nmos[delvto]
print @n.xbgr.xm37.nsg13_hv_nmos[factuo]
print @n.xbgr.xm38.nsg13_hv_pmos[w]
print @n.xbgr.xm38.nsg13_hv_pmos[l]
print @n.xbgr.xm38.nsg13_hv_pmos[delvto]
print @n.xbgr.xm38.nsg13_hv_pmos[factuo]
print @n.xbgr.xm39.nsg13_hv_pmos[w]
print @n.xbgr.xm39.nsg13_hv_pmos[l]
print @n.xbgr.xm39.nsg13_hv_pmos[delvto]
print @n.xbgr.xm39.nsg13_hv_pmos[factuo]
print @n.xbgr.xm40.nsg13_hv_pmos[w]
print @n.xbgr.xm40.nsg13_hv_pmos[l]
print @n.xbgr.xm40.nsg13_hv_pmos[delvto]
print @n.xbgr.xm40.nsg13_hv_pmos[factuo]
print @n.xbgr.xm41.nsg13_hv_pmos[w]
print @n.xbgr.xm41.nsg13_hv_pmos[l]
print @n.xbgr.xm41.nsg13_hv_pmos[delvto]
print @n.xbgr.xm41.nsg13_hv_pmos[factuo]
print @n.xbgr.xm42.nsg13_hv_pmos[w]
print @n.xbgr.xm42.nsg13_hv_pmos[l]
print @n.xbgr.xm42.nsg13_hv_pmos[delvto]
print @n.xbgr.xm42.nsg13_hv_pmos[factuo]
print @n.xbgr.xm43.nsg13_hv_pmos[w]
print @n.xbgr.xm43.nsg13_hv_pmos[l]
print @n.xbgr.xm43.nsg13_hv_pmos[delvto]
print @n.xbgr.xm43.nsg13_hv_pmos[factuo]
print @n.xbgr.xm44.nsg13_hv_pmos[w]
print @n.xbgr.xm44.nsg13_hv_pmos[l]
print @n.xbgr.xm44.nsg13_hv_pmos[delvto]
print @n.xbgr.xm44.nsg13_hv_pmos[factuo]
print @n.xbgr.xm45.nsg13_hv_pmos[w]
print @n.xbgr.xm45.nsg13_hv_pmos[l]
print @n.xbgr.xm45.nsg13_hv_pmos[delvto]
print @n.xbgr.xm45.nsg13_hv_pmos[factuo]
print @n.xbgr.xm46.nsg13_hv_pmos[w]
print @n.xbgr.xm46.nsg13_hv_pmos[l]
print @n.xbgr.xm46.nsg13_hv_pmos[delvto]
print @n.xbgr.xm46.nsg13_hv_pmos[factuo]
print @n.xbgr.xm47.nsg13_hv_pmos[w]
print @n.xbgr.xm47.nsg13_hv_pmos[l]
print @n.xbgr.xm47.nsg13_hv_pmos[delvto]
print @n.xbgr.xm47.nsg13_hv_pmos[factuo]
print @n.xbgr.xm48.nsg13_hv_pmos[w]
print @n.xbgr.xm48.nsg13_hv_pmos[l]
print @n.xbgr.xm48.nsg13_hv_pmos[delvto]
print @n.xbgr.xm48.nsg13_hv_pmos[factuo]
print @n.xbgr.xm49.nsg13_hv_pmos[w]
print @n.xbgr.xm49.nsg13_hv_pmos[l]
print @n.xbgr.xm49.nsg13_hv_pmos[delvto]
print @n.xbgr.xm49.nsg13_hv_pmos[factuo]
print @n.xbgr.xm50.nsg13_hv_pmos[w]
print @n.xbgr.xm50.nsg13_hv_pmos[l]
print @n.xbgr.xm50.nsg13_hv_pmos[delvto]
print @n.xbgr.xm50.nsg13_hv_pmos[factuo]
print @n.xbgr.xm51.nsg13_hv_pmos[w]
print @n.xbgr.xm51.nsg13_hv_pmos[l]
print @n.xbgr.xm51.nsg13_hv_pmos[delvto]
print @n.xbgr.xm51.nsg13_hv_pmos[factuo]
print @n.xbgr.xm52.nsg13_hv_pmos[w]
print @n.xbgr.xm52.nsg13_hv_pmos[l]
print @n.xbgr.xm52.nsg13_hv_pmos[delvto]
print @n.xbgr.xm52.nsg13_hv_pmos[factuo]
print @n.xbgr.xm53.nsg13_hv_pmos[w]
print @n.xbgr.xm53.nsg13_hv_pmos[l]
print @n.xbgr.xm53.nsg13_hv_pmos[delvto]
print @n.xbgr.xm53.nsg13_hv_pmos[factuo]
print @n.xbgr.xm54.nsg13_hv_pmos[w]
print @n.xbgr.xm54.nsg13_hv_pmos[l]
print @n.xbgr.xm54.nsg13_hv_pmos[delvto]
print @n.xbgr.xm54.nsg13_hv_pmos[factuo]
print @q.xbgr.xq55.qnpn13g2[area]
print @q.xbgr.xq56.qnpn13g2[area]
print @q.xbgr.xq57.qnpn13g2[area]
print @q.xbgr.xq58.qnpn13g2[area]
print @q.xbgr.xq59.qnpn13g2[area]
print @q.xbgr.xq60.qnpn13g2[area]
print @q.xbgr.xq61.qnpn13g2[area]
print @q.xbgr.xq62.qnpn13g2[area]
print @q.xbgr.xq63.qnpn13g2[area]
print @q.xbgr.xq64.qnpn13g2[area]
print @q.xbgr.xq65.qnpn13g2[area]
print @q.xbgr.xq66.qnpn13g2[area]
print @q.xbgr.xq67.qnpn13g2[area]
print @q.xbgr.xq68.qnpn13g2[area]
print @q.xbgr.xq69.qnpn13g2[area]
print @q.xbgr.xq70.qnpn13g2[area]
print @q.xbgr.xq71.qnpn13g2[area]
print @q.xbgr.xq72.qnpn13g2[area]
print @q.xbgr.xq73.qnpn13g2[area]
print @q.xbgr.xq74.qnpn13g2[area]
print @q.xbgr.xq75.qnpn13g2[area]
print @q.xbgr.xq76.qnpn13g2[area]
print @n.xbgr.xr77.nr1[nsmm_rsh]
print @n.xbgr.xr77.nr1[nsmm_w]
print @n.xbgr.xr77.nr1[nsmm_l]
print @n.xbgr.xr78.nr1[nsmm_rsh]
print @n.xbgr.xr78.nr1[nsmm_w]
print @n.xbgr.xr78.nr1[nsmm_l]
print @n.xbgr.xr79.nr1[nsmm_rsh]
print @n.xbgr.xr79.nr1[nsmm_w]
print @n.xbgr.xr79.nr1[nsmm_l]
print @n.xbgr.xr80.nr1[nsmm_rsh]
print @n.xbgr.xr80.nr1[nsmm_w]
print @n.xbgr.xr80.nr1[nsmm_l]
print @n.xbgr.xr81.nr1[nsmm_rsh]
print @n.xbgr.xr81.nr1[nsmm_w]
print @n.xbgr.xr81.nr1[nsmm_l]
print @n.xbgr.xr82.nr1[nsmm_rsh]
print @n.xbgr.xr82.nr1[nsmm_w]
print @n.xbgr.xr82.nr1[nsmm_l]
print @n.xbgr.xr83.nr1[nsmm_rsh]
print @n.xbgr.xr83.nr1[nsmm_w]
print @n.xbgr.xr83.nr1[nsmm_l]
print @n.xbgr.xr84.nr1[nsmm_rsh]
print @n.xbgr.xr84.nr1[nsmm_w]
print @n.xbgr.xr84.nr1[nsmm_l]
print @n.xbgr.xr85.nr1[nsmm_rsh]
print @n.xbgr.xr85.nr1[nsmm_w]
print @n.xbgr.xr85.nr1[nsmm_l]
print @n.xbgr.xr86.nr1[nsmm_rsh]
print @n.xbgr.xr86.nr1[nsmm_w]
print @n.xbgr.xr86.nr1[nsmm_l]
print @n.xbgr.xr16_u2.nr1[nsmm_rsh]
print @n.xbgr.xr16_u2.nr1[nsmm_w]
print @n.xbgr.xr16_u2.nr1[nsmm_l]
print @n.xbgr.xr16_u3.nr1[nsmm_rsh]
print @n.xbgr.xr16_u3.nr1[nsmm_w]
print @n.xbgr.xr16_u3.nr1[nsmm_l]
print @n.xbgr.xr16_u4.nr1[nsmm_rsh]
print @n.xbgr.xr16_u4.nr1[nsmm_w]
print @n.xbgr.xr16_u4.nr1[nsmm_l]
print @n.xbgr.xr16_u5.nr1[nsmm_rsh]
print @n.xbgr.xr16_u5.nr1[nsmm_w]
print @n.xbgr.xr16_u5.nr1[nsmm_l]
print @n.xbgr.xr16_u6.nr1[nsmm_rsh]
print @n.xbgr.xr16_u6.nr1[nsmm_w]
print @n.xbgr.xr16_u6.nr1[nsmm_l]
print @n.xbgr.xr16_u7.nr1[nsmm_rsh]
print @n.xbgr.xr16_u7.nr1[nsmm_w]
print @n.xbgr.xr16_u7.nr1[nsmm_l]
print @n.xbgr.xr16_u8.nr1[nsmm_rsh]
print @n.xbgr.xr16_u8.nr1[nsmm_w]
print @n.xbgr.xr16_u8.nr1[nsmm_l]
print @n.xbgr.xr16_u9.nr1[nsmm_rsh]
print @n.xbgr.xr16_u9.nr1[nsmm_w]
print @n.xbgr.xr16_u9.nr1[nsmm_l]
print @n.xbgr.xr16_u10.nr1[nsmm_rsh]
print @n.xbgr.xr16_u10.nr1[nsmm_w]
print @n.xbgr.xr16_u10.nr1[nsmm_l]
print @n.xbgr.xr16_u11.nr1[nsmm_rsh]
print @n.xbgr.xr16_u11.nr1[nsmm_w]
print @n.xbgr.xr16_u11.nr1[nsmm_l]
print @n.xbgr.xr16_u12.nr1[nsmm_rsh]
print @n.xbgr.xr16_u12.nr1[nsmm_w]
print @n.xbgr.xr16_u12.nr1[nsmm_l]
print @n.xbgr.xr16_u13.nr1[nsmm_rsh]
print @n.xbgr.xr16_u13.nr1[nsmm_w]
print @n.xbgr.xr16_u13.nr1[nsmm_l]
print @n.xbgr.xr16_u14.nr1[nsmm_rsh]
print @n.xbgr.xr16_u14.nr1[nsmm_w]
print @n.xbgr.xr16_u14.nr1[nsmm_l]
print @n.xbgr.xr16_u15.nr1[nsmm_rsh]
print @n.xbgr.xr16_u15.nr1[nsmm_w]
print @n.xbgr.xr16_u15.nr1[nsmm_l]
print @n.xbgr.xr16_u16.nr1[nsmm_rsh]
print @n.xbgr.xr16_u16.nr1[nsmm_w]
print @n.xbgr.xr16_u16.nr1[nsmm_l]
print @n.xbgr.xr16_u17.nr1[nsmm_rsh]
print @n.xbgr.xr16_u17.nr1[nsmm_w]
print @n.xbgr.xr16_u17.nr1[nsmm_l]
print @n.xbgr.xr16_u18.nr1[nsmm_rsh]
print @n.xbgr.xr16_u18.nr1[nsmm_w]
print @n.xbgr.xr16_u18.nr1[nsmm_l]
print @n.xbgr.xr16_u19.nr1[nsmm_rsh]
print @n.xbgr.xr16_u19.nr1[nsmm_w]
print @n.xbgr.xr16_u19.nr1[nsmm_l]
print @n.xbgr.xr16_u20.nr1[nsmm_rsh]
print @n.xbgr.xr16_u20.nr1[nsmm_w]
print @n.xbgr.xr16_u20.nr1[nsmm_l]
print @n.xbgr.xr16_u21.nr1[nsmm_rsh]
print @n.xbgr.xr16_u21.nr1[nsmm_w]
print @n.xbgr.xr16_u21.nr1[nsmm_l]
print @n.xbgr.xr16_u22.nr1[nsmm_rsh]
print @n.xbgr.xr16_u22.nr1[nsmm_w]
print @n.xbgr.xr16_u22.nr1[nsmm_l]
print @n.xbgr.xr16_u23.nr1[nsmm_rsh]
print @n.xbgr.xr16_u23.nr1[nsmm_w]
print @n.xbgr.xr16_u23.nr1[nsmm_l]
print @n.xbgr.xr16_u24.nr1[nsmm_rsh]
print @n.xbgr.xr16_u24.nr1[nsmm_w]
print @n.xbgr.xr16_u24.nr1[nsmm_l]
print @n.xbgr.xr17_u2.nr1[nsmm_rsh]
print @n.xbgr.xr17_u2.nr1[nsmm_w]
print @n.xbgr.xr17_u2.nr1[nsmm_l]
print @n.xbgr.xr17_u3.nr1[nsmm_rsh]
print @n.xbgr.xr17_u3.nr1[nsmm_w]
print @n.xbgr.xr17_u3.nr1[nsmm_l]
print @n.xbgr.xr17_u4.nr1[nsmm_rsh]
print @n.xbgr.xr17_u4.nr1[nsmm_w]
print @n.xbgr.xr17_u4.nr1[nsmm_l]
print @n.xbgr.xr18_u2.nr1[nsmm_rsh]
print @n.xbgr.xr18_u2.nr1[nsmm_w]
print @n.xbgr.xr18_u2.nr1[nsmm_l]
print @n.xbgr.xr18_u3.nr1[nsmm_rsh]
print @n.xbgr.xr18_u3.nr1[nsmm_w]
print @n.xbgr.xr18_u3.nr1[nsmm_l]
print @n.xbgr.xr18_u4.nr1[nsmm_rsh]
print @n.xbgr.xr18_u4.nr1[nsmm_w]
print @n.xbgr.xr18_u4.nr1[nsmm_l]
print @n.xbgr.xr19_u2.nr1[nsmm_rsh]
print @n.xbgr.xr19_u2.nr1[nsmm_w]
print @n.xbgr.xr19_u2.nr1[nsmm_l]
print @n.xbgr.xr19_u3.nr1[nsmm_rsh]
print @n.xbgr.xr19_u3.nr1[nsmm_w]
print @n.xbgr.xr19_u3.nr1[nsmm_l]
print @n.xbgr.xr19_u4.nr1[nsmm_rsh]
print @n.xbgr.xr19_u4.nr1[nsmm_w]
print @n.xbgr.xr19_u4.nr1[nsmm_l]
print @n.xbgr.xr20_u2.nr1[nsmm_rsh]
print @n.xbgr.xr20_u2.nr1[nsmm_w]
print @n.xbgr.xr20_u2.nr1[nsmm_l]
print @n.xbgr.xr20_u3.nr1[nsmm_rsh]
print @n.xbgr.xr20_u3.nr1[nsmm_w]
print @n.xbgr.xr20_u3.nr1[nsmm_l]
print @n.xbgr.xr20_u4.nr1[nsmm_rsh]
print @n.xbgr.xr20_u4.nr1[nsmm_w]
print @n.xbgr.xr20_u4.nr1[nsmm_l]
print @n.xbgr.xr21_u2.nr1[nsmm_rsh]
print @n.xbgr.xr21_u2.nr1[nsmm_w]
print @n.xbgr.xr21_u2.nr1[nsmm_l]
print @n.xbgr.xr21_u3.nr1[nsmm_rsh]
print @n.xbgr.xr21_u3.nr1[nsmm_w]
print @n.xbgr.xr21_u3.nr1[nsmm_l]
print @n.xbgr.xr21_u4.nr1[nsmm_rsh]
print @n.xbgr.xr21_u4.nr1[nsmm_w]
print @n.xbgr.xr21_u4.nr1[nsmm_l]
print @n.xbgr.xr22_u2.nr1[nsmm_rsh]
print @n.xbgr.xr22_u2.nr1[nsmm_w]
print @n.xbgr.xr22_u2.nr1[nsmm_l]
print @n.xbgr.xr22_u3.nr1[nsmm_rsh]
print @n.xbgr.xr22_u3.nr1[nsmm_w]
print @n.xbgr.xr22_u3.nr1[nsmm_l]
print @n.xbgr.xr22_u4.nr1[nsmm_rsh]
print @n.xbgr.xr22_u4.nr1[nsmm_w]
print @n.xbgr.xr22_u4.nr1[nsmm_l]
print @n.xbgr.xr23_u2.nr1[nsmm_rsh]
print @n.xbgr.xr23_u2.nr1[nsmm_w]
print @n.xbgr.xr23_u2.nr1[nsmm_l]
print @n.xbgr.xr23_u3.nr1[nsmm_rsh]
print @n.xbgr.xr23_u3.nr1[nsmm_w]
print @n.xbgr.xr23_u3.nr1[nsmm_l]
print @n.xbgr.xr23_u4.nr1[nsmm_rsh]
print @n.xbgr.xr23_u4.nr1[nsmm_w]
print @n.xbgr.xr23_u4.nr1[nsmm_l]
print @n.xbgr.xr23_u5.nr1[nsmm_rsh]
print @n.xbgr.xr23_u5.nr1[nsmm_w]
print @n.xbgr.xr23_u5.nr1[nsmm_l]
print @n.xbgr.xr23_u6.nr1[nsmm_rsh]
print @n.xbgr.xr23_u6.nr1[nsmm_w]
print @n.xbgr.xr23_u6.nr1[nsmm_l]
print @n.xbgr.xr23_u7.nr1[nsmm_rsh]
print @n.xbgr.xr23_u7.nr1[nsmm_w]
print @n.xbgr.xr23_u7.nr1[nsmm_l]
print @n.xbgr.xr23_u8.nr1[nsmm_rsh]
print @n.xbgr.xr23_u8.nr1[nsmm_w]
print @n.xbgr.xr23_u8.nr1[nsmm_l]
print @n.xbgr.xr23_u9.nr1[nsmm_rsh]
print @n.xbgr.xr23_u9.nr1[nsmm_w]
print @n.xbgr.xr23_u9.nr1[nsmm_l]
print @n.xbgr.xr23_u10.nr1[nsmm_rsh]
print @n.xbgr.xr23_u10.nr1[nsmm_w]
print @n.xbgr.xr23_u10.nr1[nsmm_l]
print @n.xbgr.xr23_u11.nr1[nsmm_rsh]
print @n.xbgr.xr23_u11.nr1[nsmm_w]
print @n.xbgr.xr23_u11.nr1[nsmm_l]
print @n.xbgr.xr23_u12.nr1[nsmm_rsh]
print @n.xbgr.xr23_u12.nr1[nsmm_w]
print @n.xbgr.xr23_u12.nr1[nsmm_l]
print @n.xbgr.xr23_u13.nr1[nsmm_rsh]
print @n.xbgr.xr23_u13.nr1[nsmm_w]
print @n.xbgr.xr23_u13.nr1[nsmm_l]
print @n.xbgr.xr23_u14.nr1[nsmm_rsh]
print @n.xbgr.xr23_u14.nr1[nsmm_w]
print @n.xbgr.xr23_u14.nr1[nsmm_l]
print @n.xbgr.xr23_u15.nr1[nsmm_rsh]
print @n.xbgr.xr23_u15.nr1[nsmm_w]
print @n.xbgr.xr23_u15.nr1[nsmm_l]
print @n.xbgr.xr23_u16.nr1[nsmm_rsh]
print @n.xbgr.xr23_u16.nr1[nsmm_w]
print @n.xbgr.xr23_u16.nr1[nsmm_l]
print @n.xbgr.xr23_u17.nr1[nsmm_rsh]
print @n.xbgr.xr23_u17.nr1[nsmm_w]
print @n.xbgr.xr23_u17.nr1[nsmm_l]
print @n.xbgr.xr23_u18.nr1[nsmm_rsh]
print @n.xbgr.xr23_u18.nr1[nsmm_w]
print @n.xbgr.xr23_u18.nr1[nsmm_l]
print @n.xbgr.xr23_u19.nr1[nsmm_rsh]
print @n.xbgr.xr23_u19.nr1[nsmm_w]
print @n.xbgr.xr23_u19.nr1[nsmm_l]
print @n.xbgr.xr23_u20.nr1[nsmm_rsh]
print @n.xbgr.xr23_u20.nr1[nsmm_w]
print @n.xbgr.xr23_u20.nr1[nsmm_l]
print @n.xbgr.xr23_u21.nr1[nsmm_rsh]
print @n.xbgr.xr23_u21.nr1[nsmm_w]
print @n.xbgr.xr23_u21.nr1[nsmm_l]
print @n.xbgr.xr23_u22.nr1[nsmm_rsh]
print @n.xbgr.xr23_u22.nr1[nsmm_w]
print @n.xbgr.xr23_u22.nr1[nsmm_l]
print @n.xbgr.xr23_u23.nr1[nsmm_rsh]
print @n.xbgr.xr23_u23.nr1[nsmm_w]
print @n.xbgr.xr23_u23.nr1[nsmm_l]
print @n.xbgr.xr23_u24.nr1[nsmm_rsh]
print @n.xbgr.xr23_u24.nr1[nsmm_w]
print @n.xbgr.xr23_u24.nr1[nsmm_l]
print @n.xbgr.xr24_u2.nr1[nsmm_rsh]
print @n.xbgr.xr24_u2.nr1[nsmm_w]
print @n.xbgr.xr24_u2.nr1[nsmm_l]
print @n.xbgr.xr24_u3.nr1[nsmm_rsh]
print @n.xbgr.xr24_u3.nr1[nsmm_w]
print @n.xbgr.xr24_u3.nr1[nsmm_l]
print @n.xbgr.xr24_u4.nr1[nsmm_rsh]
print @n.xbgr.xr24_u4.nr1[nsmm_w]
print @n.xbgr.xr24_u4.nr1[nsmm_l]
print @n.xbgr.xr24_u5.nr1[nsmm_rsh]
print @n.xbgr.xr24_u5.nr1[nsmm_w]
print @n.xbgr.xr24_u5.nr1[nsmm_l]
print @n.xbgr.xr24_u6.nr1[nsmm_rsh]
print @n.xbgr.xr24_u6.nr1[nsmm_w]
print @n.xbgr.xr24_u6.nr1[nsmm_l]
print @n.xbgr.xr24_u7.nr1[nsmm_rsh]
print @n.xbgr.xr24_u7.nr1[nsmm_w]
print @n.xbgr.xr24_u7.nr1[nsmm_l]
print @n.xbgr.xr24_u8.nr1[nsmm_rsh]
print @n.xbgr.xr24_u8.nr1[nsmm_w]
print @n.xbgr.xr24_u8.nr1[nsmm_l]
print @n.xbgr.xr24_u9.nr1[nsmm_rsh]
print @n.xbgr.xr24_u9.nr1[nsmm_w]
print @n.xbgr.xr24_u9.nr1[nsmm_l]
print @n.xbgr.xr24_u10.nr1[nsmm_rsh]
print @n.xbgr.xr24_u10.nr1[nsmm_w]
print @n.xbgr.xr24_u10.nr1[nsmm_l]
print @n.xbgr.xr24_u11.nr1[nsmm_rsh]
print @n.xbgr.xr24_u11.nr1[nsmm_w]
print @n.xbgr.xr24_u11.nr1[nsmm_l]
print @n.xbgr.xr24_u12.nr1[nsmm_rsh]
print @n.xbgr.xr24_u12.nr1[nsmm_w]
print @n.xbgr.xr24_u12.nr1[nsmm_l]
print @n.xbgr.xr24_u13.nr1[nsmm_rsh]
print @n.xbgr.xr24_u13.nr1[nsmm_w]
print @n.xbgr.xr24_u13.nr1[nsmm_l]
print @n.xbgr.xr24_u14.nr1[nsmm_rsh]
print @n.xbgr.xr24_u14.nr1[nsmm_w]
print @n.xbgr.xr24_u14.nr1[nsmm_l]
print @n.xbgr.xr24_u15.nr1[nsmm_rsh]
print @n.xbgr.xr24_u15.nr1[nsmm_w]
print @n.xbgr.xr24_u15.nr1[nsmm_l]
print @n.xbgr.xr24_u16.nr1[nsmm_rsh]
print @n.xbgr.xr24_u16.nr1[nsmm_w]
print @n.xbgr.xr24_u16.nr1[nsmm_l]
print @n.xbgr.xr24_u17.nr1[nsmm_rsh]
print @n.xbgr.xr24_u17.nr1[nsmm_w]
print @n.xbgr.xr24_u17.nr1[nsmm_l]
print @n.xbgr.xr24_u18.nr1[nsmm_rsh]
print @n.xbgr.xr24_u18.nr1[nsmm_w]
print @n.xbgr.xr24_u18.nr1[nsmm_l]
print @n.xbgr.xr24_u19.nr1[nsmm_rsh]
print @n.xbgr.xr24_u19.nr1[nsmm_w]
print @n.xbgr.xr24_u19.nr1[nsmm_l]
print @n.xbgr.xr24_u20.nr1[nsmm_rsh]
print @n.xbgr.xr24_u20.nr1[nsmm_w]
print @n.xbgr.xr24_u20.nr1[nsmm_l]
print @n.xbgr.xr24_u21.nr1[nsmm_rsh]
print @n.xbgr.xr24_u21.nr1[nsmm_w]
print @n.xbgr.xr24_u21.nr1[nsmm_l]
print @n.xbgr.xr24_u22.nr1[nsmm_rsh]
print @n.xbgr.xr24_u22.nr1[nsmm_w]
print @n.xbgr.xr24_u22.nr1[nsmm_l]
print @n.xbgr.xr24_u23.nr1[nsmm_rsh]
print @n.xbgr.xr24_u23.nr1[nsmm_w]
print @n.xbgr.xr24_u23.nr1[nsmm_l]
print @n.xbgr.xr24_u24.nr1[nsmm_rsh]
print @n.xbgr.xr24_u24.nr1[nsmm_w]
print @n.xbgr.xr24_u24.nr1[nsmm_l]
print @n.xbgr.xr25_u2.nr1[nsmm_rsh]
print @n.xbgr.xr25_u2.nr1[nsmm_w]
print @n.xbgr.xr25_u2.nr1[nsmm_l]
print @n.xbgr.xr25_u3.nr1[nsmm_rsh]
print @n.xbgr.xr25_u3.nr1[nsmm_w]
print @n.xbgr.xr25_u3.nr1[nsmm_l]
print @n.xbgr.xr25_u4.nr1[nsmm_rsh]
print @n.xbgr.xr25_u4.nr1[nsmm_w]
print @n.xbgr.xr25_u4.nr1[nsmm_l]
print @n.xbgr.xr25_u5.nr1[nsmm_rsh]
print @n.xbgr.xr25_u5.nr1[nsmm_w]
print @n.xbgr.xr25_u5.nr1[nsmm_l]
print @n.xbgr.xr25_u6.nr1[nsmm_rsh]
print @n.xbgr.xr25_u6.nr1[nsmm_w]
print @n.xbgr.xr25_u6.nr1[nsmm_l]
print @n.xbgr.xr25_u7.nr1[nsmm_rsh]
print @n.xbgr.xr25_u7.nr1[nsmm_w]
print @n.xbgr.xr25_u7.nr1[nsmm_l]
print @n.xbgr.xr25_u8.nr1[nsmm_rsh]
print @n.xbgr.xr25_u8.nr1[nsmm_w]
print @n.xbgr.xr25_u8.nr1[nsmm_l]
print @n.xbgr.xr25_u9.nr1[nsmm_rsh]
print @n.xbgr.xr25_u9.nr1[nsmm_w]
print @n.xbgr.xr25_u9.nr1[nsmm_l]
print @n.xbgr.xr25_u10.nr1[nsmm_rsh]
print @n.xbgr.xr25_u10.nr1[nsmm_w]
print @n.xbgr.xr25_u10.nr1[nsmm_l]
print @n.xbgr.xr25_u11.nr1[nsmm_rsh]
print @n.xbgr.xr25_u11.nr1[nsmm_w]
print @n.xbgr.xr25_u11.nr1[nsmm_l]
print @n.xbgr.xr25_u12.nr1[nsmm_rsh]
print @n.xbgr.xr25_u12.nr1[nsmm_w]
print @n.xbgr.xr25_u12.nr1[nsmm_l]
print @n.xbgr.xr25_u13.nr1[nsmm_rsh]
print @n.xbgr.xr25_u13.nr1[nsmm_w]
print @n.xbgr.xr25_u13.nr1[nsmm_l]
print @n.xbgr.xr25_u14.nr1[nsmm_rsh]
print @n.xbgr.xr25_u14.nr1[nsmm_w]
print @n.xbgr.xr25_u14.nr1[nsmm_l]
print @n.xbgr.xr25_u15.nr1[nsmm_rsh]
print @n.xbgr.xr25_u15.nr1[nsmm_w]
print @n.xbgr.xr25_u15.nr1[nsmm_l]
print @n.xbgr.xr25_u16.nr1[nsmm_rsh]
print @n.xbgr.xr25_u16.nr1[nsmm_w]
print @n.xbgr.xr25_u16.nr1[nsmm_l]
print @n.xbgr.xr25_u17.nr1[nsmm_rsh]
print @n.xbgr.xr25_u17.nr1[nsmm_w]
print @n.xbgr.xr25_u17.nr1[nsmm_l]
print @n.xbgr.xr25_u18.nr1[nsmm_rsh]
print @n.xbgr.xr25_u18.nr1[nsmm_w]
print @n.xbgr.xr25_u18.nr1[nsmm_l]
print @n.xbgr.xr25_u19.nr1[nsmm_rsh]
print @n.xbgr.xr25_u19.nr1[nsmm_w]
print @n.xbgr.xr25_u19.nr1[nsmm_l]
print @n.xbgr.xr25_u20.nr1[nsmm_rsh]
print @n.xbgr.xr25_u20.nr1[nsmm_w]
print @n.xbgr.xr25_u20.nr1[nsmm_l]
print @n.xbgr.xr25_u21.nr1[nsmm_rsh]
print @n.xbgr.xr25_u21.nr1[nsmm_w]
print @n.xbgr.xr25_u21.nr1[nsmm_l]
print @n.xbgr.xr25_u22.nr1[nsmm_rsh]
print @n.xbgr.xr25_u22.nr1[nsmm_w]
print @n.xbgr.xr25_u22.nr1[nsmm_l]
print @n.xbgr.xr25_u23.nr1[nsmm_rsh]
print @n.xbgr.xr25_u23.nr1[nsmm_w]
print @n.xbgr.xr25_u23.nr1[nsmm_l]
print @n.xbgr.xr25_u24.nr1[nsmm_rsh]
print @n.xbgr.xr25_u24.nr1[nsmm_w]
print @n.xbgr.xr25_u24.nr1[nsmm_l]
print @n.xbgr.xr26_u2.nr1[nsmm_rsh]
print @n.xbgr.xr26_u2.nr1[nsmm_w]
print @n.xbgr.xr26_u2.nr1[nsmm_l]
print @n.xbgr.xr26_u3.nr1[nsmm_rsh]
print @n.xbgr.xr26_u3.nr1[nsmm_w]
print @n.xbgr.xr26_u3.nr1[nsmm_l]
print @n.xbgr.xr26_u4.nr1[nsmm_rsh]
print @n.xbgr.xr26_u4.nr1[nsmm_w]
print @n.xbgr.xr26_u4.nr1[nsmm_l]
print @n.xbgr.xr26_u5.nr1[nsmm_rsh]
print @n.xbgr.xr26_u5.nr1[nsmm_w]
print @n.xbgr.xr26_u5.nr1[nsmm_l]
print @n.xbgr.xr26_u6.nr1[nsmm_rsh]
print @n.xbgr.xr26_u6.nr1[nsmm_w]
print @n.xbgr.xr26_u6.nr1[nsmm_l]
print @n.xbgr.xr26_u7.nr1[nsmm_rsh]
print @n.xbgr.xr26_u7.nr1[nsmm_w]
print @n.xbgr.xr26_u7.nr1[nsmm_l]
print @n.xbgr.xr26_u8.nr1[nsmm_rsh]
print @n.xbgr.xr26_u8.nr1[nsmm_w]
print @n.xbgr.xr26_u8.nr1[nsmm_l]
print @n.xbgr.xr26_u9.nr1[nsmm_rsh]
print @n.xbgr.xr26_u9.nr1[nsmm_w]
print @n.xbgr.xr26_u9.nr1[nsmm_l]
print @n.xbgr.xr26_u10.nr1[nsmm_rsh]
print @n.xbgr.xr26_u10.nr1[nsmm_w]
print @n.xbgr.xr26_u10.nr1[nsmm_l]
print @n.xbgr.xr26_u11.nr1[nsmm_rsh]
print @n.xbgr.xr26_u11.nr1[nsmm_w]
print @n.xbgr.xr26_u11.nr1[nsmm_l]
print @n.xbgr.xr26_u12.nr1[nsmm_rsh]
print @n.xbgr.xr26_u12.nr1[nsmm_w]
print @n.xbgr.xr26_u12.nr1[nsmm_l]
print @n.xbgr.xr26_u13.nr1[nsmm_rsh]
print @n.xbgr.xr26_u13.nr1[nsmm_w]
print @n.xbgr.xr26_u13.nr1[nsmm_l]
print @n.xbgr.xr26_u14.nr1[nsmm_rsh]
print @n.xbgr.xr26_u14.nr1[nsmm_w]
print @n.xbgr.xr26_u14.nr1[nsmm_l]
print @n.xbgr.xr26_u15.nr1[nsmm_rsh]
print @n.xbgr.xr26_u15.nr1[nsmm_w]
print @n.xbgr.xr26_u15.nr1[nsmm_l]
print @n.xbgr.xr26_u16.nr1[nsmm_rsh]
print @n.xbgr.xr26_u16.nr1[nsmm_w]
print @n.xbgr.xr26_u16.nr1[nsmm_l]
print @n.xbgr.xr26_u17.nr1[nsmm_rsh]
print @n.xbgr.xr26_u17.nr1[nsmm_w]
print @n.xbgr.xr26_u17.nr1[nsmm_l]
print @n.xbgr.xr26_u18.nr1[nsmm_rsh]
print @n.xbgr.xr26_u18.nr1[nsmm_w]
print @n.xbgr.xr26_u18.nr1[nsmm_l]
print @n.xbgr.xr26_u19.nr1[nsmm_rsh]
print @n.xbgr.xr26_u19.nr1[nsmm_w]
print @n.xbgr.xr26_u19.nr1[nsmm_l]
print @n.xbgr.xr26_u20.nr1[nsmm_rsh]
print @n.xbgr.xr26_u20.nr1[nsmm_w]
print @n.xbgr.xr26_u20.nr1[nsmm_l]
print @n.xbgr.xr26_u21.nr1[nsmm_rsh]
print @n.xbgr.xr26_u21.nr1[nsmm_w]
print @n.xbgr.xr26_u21.nr1[nsmm_l]
print @n.xbgr.xr26_u22.nr1[nsmm_rsh]
print @n.xbgr.xr26_u22.nr1[nsmm_w]
print @n.xbgr.xr26_u22.nr1[nsmm_l]
print @n.xbgr.xr26_u23.nr1[nsmm_rsh]
print @n.xbgr.xr26_u23.nr1[nsmm_w]
print @n.xbgr.xr26_u23.nr1[nsmm_l]
print @n.xbgr.xr26_u24.nr1[nsmm_rsh]
print @n.xbgr.xr26_u24.nr1[nsmm_w]
print @n.xbgr.xr26_u24.nr1[nsmm_l]
print @n.xbgr.xm34_u2.nsg13_hv_nmos[w]
print @n.xbgr.xm34_u2.nsg13_hv_nmos[l]
print @n.xbgr.xm34_u2.nsg13_hv_nmos[delvto]
print @n.xbgr.xm34_u2.nsg13_hv_nmos[factuo]
print @n.xbgr.xm34_u3.nsg13_hv_nmos[w]
print @n.xbgr.xm34_u3.nsg13_hv_nmos[l]
print @n.xbgr.xm34_u3.nsg13_hv_nmos[delvto]
print @n.xbgr.xm34_u3.nsg13_hv_nmos[factuo]
print @n.xbgr.xm34_u4.nsg13_hv_nmos[w]
print @n.xbgr.xm34_u4.nsg13_hv_nmos[l]
print @n.xbgr.xm34_u4.nsg13_hv_nmos[delvto]
print @n.xbgr.xm34_u4.nsg13_hv_nmos[factuo]
print @n.xbgr.xm34_u5.nsg13_hv_nmos[w]
print @n.xbgr.xm34_u5.nsg13_hv_nmos[l]
print @n.xbgr.xm34_u5.nsg13_hv_nmos[delvto]
print @n.xbgr.xm34_u5.nsg13_hv_nmos[factuo]
print @n.xbgr.xm34_u6.nsg13_hv_nmos[w]
print @n.xbgr.xm34_u6.nsg13_hv_nmos[l]
print @n.xbgr.xm34_u6.nsg13_hv_nmos[delvto]
print @n.xbgr.xm34_u6.nsg13_hv_nmos[factuo]
print @n.xbgr.xm34_u7.nsg13_hv_nmos[w]
print @n.xbgr.xm34_u7.nsg13_hv_nmos[l]
print @n.xbgr.xm34_u7.nsg13_hv_nmos[delvto]
print @n.xbgr.xm34_u7.nsg13_hv_nmos[factuo]
print @n.xbgr.xm34_u8.nsg13_hv_nmos[w]
print @n.xbgr.xm34_u8.nsg13_hv_nmos[l]
print @n.xbgr.xm34_u8.nsg13_hv_nmos[delvto]
print @n.xbgr.xm34_u8.nsg13_hv_nmos[factuo]
print @n.xbgr.xm34_u9.nsg13_hv_nmos[w]
print @n.xbgr.xm34_u9.nsg13_hv_nmos[l]
print @n.xbgr.xm34_u9.nsg13_hv_nmos[delvto]
print @n.xbgr.xm34_u9.nsg13_hv_nmos[factuo]
print @n.xbgr.xm34_u10.nsg13_hv_nmos[w]
print @n.xbgr.xm34_u10.nsg13_hv_nmos[l]
print @n.xbgr.xm34_u10.nsg13_hv_nmos[delvto]
print @n.xbgr.xm34_u10.nsg13_hv_nmos[factuo]
print @n.xbgr.xm34_u11.nsg13_hv_nmos[w]
print @n.xbgr.xm34_u11.nsg13_hv_nmos[l]
print @n.xbgr.xm34_u11.nsg13_hv_nmos[delvto]
print @n.xbgr.xm34_u11.nsg13_hv_nmos[factuo]
print @n.xbgr.xm34_u12.nsg13_hv_nmos[w]
print @n.xbgr.xm34_u12.nsg13_hv_nmos[l]
print @n.xbgr.xm34_u12.nsg13_hv_nmos[delvto]
print @n.xbgr.xm34_u12.nsg13_hv_nmos[factuo]
print @n.xbgr.xm34_u13.nsg13_hv_nmos[w]
print @n.xbgr.xm34_u13.nsg13_hv_nmos[l]
print @n.xbgr.xm34_u13.nsg13_hv_nmos[delvto]
print @n.xbgr.xm34_u13.nsg13_hv_nmos[factuo]
print @n.xbgr.xm34_u14.nsg13_hv_nmos[w]
print @n.xbgr.xm34_u14.nsg13_hv_nmos[l]
print @n.xbgr.xm34_u14.nsg13_hv_nmos[delvto]
print @n.xbgr.xm34_u14.nsg13_hv_nmos[factuo]
print @n.xbgr.xm34_u15.nsg13_hv_nmos[w]
print @n.xbgr.xm34_u15.nsg13_hv_nmos[l]
print @n.xbgr.xm34_u15.nsg13_hv_nmos[delvto]
print @n.xbgr.xm34_u15.nsg13_hv_nmos[factuo]
print @n.xbgr.xm34_u16.nsg13_hv_nmos[w]
print @n.xbgr.xm34_u16.nsg13_hv_nmos[l]
print @n.xbgr.xm34_u16.nsg13_hv_nmos[delvto]
print @n.xbgr.xm34_u16.nsg13_hv_nmos[factuo]
print @n.xbgr.xm34_u17.nsg13_hv_nmos[w]
print @n.xbgr.xm34_u17.nsg13_hv_nmos[l]
print @n.xbgr.xm34_u17.nsg13_hv_nmos[delvto]
print @n.xbgr.xm34_u17.nsg13_hv_nmos[factuo]
print @n.xbgr.xm34_u18.nsg13_hv_nmos[w]
print @n.xbgr.xm34_u18.nsg13_hv_nmos[l]
print @n.xbgr.xm34_u18.nsg13_hv_nmos[delvto]
print @n.xbgr.xm34_u18.nsg13_hv_nmos[factuo]
print @n.xbgr.xm34_u19.nsg13_hv_nmos[w]
print @n.xbgr.xm34_u19.nsg13_hv_nmos[l]
print @n.xbgr.xm34_u19.nsg13_hv_nmos[delvto]
print @n.xbgr.xm34_u19.nsg13_hv_nmos[factuo]
print @n.xbgr.xm34_u20.nsg13_hv_nmos[w]
print @n.xbgr.xm34_u20.nsg13_hv_nmos[l]
print @n.xbgr.xm34_u20.nsg13_hv_nmos[delvto]
print @n.xbgr.xm34_u20.nsg13_hv_nmos[factuo]
print @n.xbgr.xm34_u21.nsg13_hv_nmos[w]
print @n.xbgr.xm34_u21.nsg13_hv_nmos[l]
print @n.xbgr.xm34_u21.nsg13_hv_nmos[delvto]
print @n.xbgr.xm34_u21.nsg13_hv_nmos[factuo]
print @n.xbgr.xm34_u22.nsg13_hv_nmos[w]
print @n.xbgr.xm34_u22.nsg13_hv_nmos[l]
print @n.xbgr.xm34_u22.nsg13_hv_nmos[delvto]
print @n.xbgr.xm34_u22.nsg13_hv_nmos[factuo]
print @n.xbgr.xm34_u23.nsg13_hv_nmos[w]
print @n.xbgr.xm34_u23.nsg13_hv_nmos[l]
print @n.xbgr.xm34_u23.nsg13_hv_nmos[delvto]
print @n.xbgr.xm34_u23.nsg13_hv_nmos[factuo]
print @n.xbgr.xm34_u24.nsg13_hv_nmos[w]
print @n.xbgr.xm34_u24.nsg13_hv_nmos[l]
print @n.xbgr.xm34_u24.nsg13_hv_nmos[delvto]
print @n.xbgr.xm34_u24.nsg13_hv_nmos[factuo]
print @n.xbgr.xm35_u2.nsg13_hv_nmos[w]
print @n.xbgr.xm35_u2.nsg13_hv_nmos[l]
print @n.xbgr.xm35_u2.nsg13_hv_nmos[delvto]
print @n.xbgr.xm35_u2.nsg13_hv_nmos[factuo]
print @n.xbgr.xm35_u3.nsg13_hv_nmos[w]
print @n.xbgr.xm35_u3.nsg13_hv_nmos[l]
print @n.xbgr.xm35_u3.nsg13_hv_nmos[delvto]
print @n.xbgr.xm35_u3.nsg13_hv_nmos[factuo]
print @n.xbgr.xm35_u4.nsg13_hv_nmos[w]
print @n.xbgr.xm35_u4.nsg13_hv_nmos[l]
print @n.xbgr.xm35_u4.nsg13_hv_nmos[delvto]
print @n.xbgr.xm35_u4.nsg13_hv_nmos[factuo]
print @n.xbgr.xm35_u5.nsg13_hv_nmos[w]
print @n.xbgr.xm35_u5.nsg13_hv_nmos[l]
print @n.xbgr.xm35_u5.nsg13_hv_nmos[delvto]
print @n.xbgr.xm35_u5.nsg13_hv_nmos[factuo]
print @n.xbgr.xm35_u6.nsg13_hv_nmos[w]
print @n.xbgr.xm35_u6.nsg13_hv_nmos[l]
print @n.xbgr.xm35_u6.nsg13_hv_nmos[delvto]
print @n.xbgr.xm35_u6.nsg13_hv_nmos[factuo]
print @n.xbgr.xm35_u7.nsg13_hv_nmos[w]
print @n.xbgr.xm35_u7.nsg13_hv_nmos[l]
print @n.xbgr.xm35_u7.nsg13_hv_nmos[delvto]
print @n.xbgr.xm35_u7.nsg13_hv_nmos[factuo]
print @n.xbgr.xm35_u8.nsg13_hv_nmos[w]
print @n.xbgr.xm35_u8.nsg13_hv_nmos[l]
print @n.xbgr.xm35_u8.nsg13_hv_nmos[delvto]
print @n.xbgr.xm35_u8.nsg13_hv_nmos[factuo]
print @n.xbgr.xm35_u9.nsg13_hv_nmos[w]
print @n.xbgr.xm35_u9.nsg13_hv_nmos[l]
print @n.xbgr.xm35_u9.nsg13_hv_nmos[delvto]
print @n.xbgr.xm35_u9.nsg13_hv_nmos[factuo]
print @n.xbgr.xm35_u10.nsg13_hv_nmos[w]
print @n.xbgr.xm35_u10.nsg13_hv_nmos[l]
print @n.xbgr.xm35_u10.nsg13_hv_nmos[delvto]
print @n.xbgr.xm35_u10.nsg13_hv_nmos[factuo]
print @n.xbgr.xm35_u11.nsg13_hv_nmos[w]
print @n.xbgr.xm35_u11.nsg13_hv_nmos[l]
print @n.xbgr.xm35_u11.nsg13_hv_nmos[delvto]
print @n.xbgr.xm35_u11.nsg13_hv_nmos[factuo]
print @n.xbgr.xm35_u12.nsg13_hv_nmos[w]
print @n.xbgr.xm35_u12.nsg13_hv_nmos[l]
print @n.xbgr.xm35_u12.nsg13_hv_nmos[delvto]
print @n.xbgr.xm35_u12.nsg13_hv_nmos[factuo]
print @n.xbgr.xm35_u13.nsg13_hv_nmos[w]
print @n.xbgr.xm35_u13.nsg13_hv_nmos[l]
print @n.xbgr.xm35_u13.nsg13_hv_nmos[delvto]
print @n.xbgr.xm35_u13.nsg13_hv_nmos[factuo]
print @n.xbgr.xm35_u14.nsg13_hv_nmos[w]
print @n.xbgr.xm35_u14.nsg13_hv_nmos[l]
print @n.xbgr.xm35_u14.nsg13_hv_nmos[delvto]
print @n.xbgr.xm35_u14.nsg13_hv_nmos[factuo]
print @n.xbgr.xm35_u15.nsg13_hv_nmos[w]
print @n.xbgr.xm35_u15.nsg13_hv_nmos[l]
print @n.xbgr.xm35_u15.nsg13_hv_nmos[delvto]
print @n.xbgr.xm35_u15.nsg13_hv_nmos[factuo]
print @n.xbgr.xm35_u16.nsg13_hv_nmos[w]
print @n.xbgr.xm35_u16.nsg13_hv_nmos[l]
print @n.xbgr.xm35_u16.nsg13_hv_nmos[delvto]
print @n.xbgr.xm35_u16.nsg13_hv_nmos[factuo]
print @n.xbgr.xm35_u17.nsg13_hv_nmos[w]
print @n.xbgr.xm35_u17.nsg13_hv_nmos[l]
print @n.xbgr.xm35_u17.nsg13_hv_nmos[delvto]
print @n.xbgr.xm35_u17.nsg13_hv_nmos[factuo]
print @n.xbgr.xm35_u18.nsg13_hv_nmos[w]
print @n.xbgr.xm35_u18.nsg13_hv_nmos[l]
print @n.xbgr.xm35_u18.nsg13_hv_nmos[delvto]
print @n.xbgr.xm35_u18.nsg13_hv_nmos[factuo]
print @n.xbgr.xm35_u19.nsg13_hv_nmos[w]
print @n.xbgr.xm35_u19.nsg13_hv_nmos[l]
print @n.xbgr.xm35_u19.nsg13_hv_nmos[delvto]
print @n.xbgr.xm35_u19.nsg13_hv_nmos[factuo]
print @n.xbgr.xm35_u20.nsg13_hv_nmos[w]
print @n.xbgr.xm35_u20.nsg13_hv_nmos[l]
print @n.xbgr.xm35_u20.nsg13_hv_nmos[delvto]
print @n.xbgr.xm35_u20.nsg13_hv_nmos[factuo]
print @n.xbgr.xm35_u21.nsg13_hv_nmos[w]
print @n.xbgr.xm35_u21.nsg13_hv_nmos[l]
print @n.xbgr.xm35_u21.nsg13_hv_nmos[delvto]
print @n.xbgr.xm35_u21.nsg13_hv_nmos[factuo]
print @n.xbgr.xm35_u22.nsg13_hv_nmos[w]
print @n.xbgr.xm35_u22.nsg13_hv_nmos[l]
print @n.xbgr.xm35_u22.nsg13_hv_nmos[delvto]
print @n.xbgr.xm35_u22.nsg13_hv_nmos[factuo]
print @n.xbgr.xm35_u23.nsg13_hv_nmos[w]
print @n.xbgr.xm35_u23.nsg13_hv_nmos[l]
print @n.xbgr.xm35_u23.nsg13_hv_nmos[delvto]
print @n.xbgr.xm35_u23.nsg13_hv_nmos[factuo]
print @n.xbgr.xm35_u24.nsg13_hv_nmos[w]
print @n.xbgr.xm35_u24.nsg13_hv_nmos[l]
print @n.xbgr.xm35_u24.nsg13_hv_nmos[delvto]
print @n.xbgr.xm35_u24.nsg13_hv_nmos[factuo]
print @n.xbgr.xm36_u2.nsg13_hv_nmos[w]
print @n.xbgr.xm36_u2.nsg13_hv_nmos[l]
print @n.xbgr.xm36_u2.nsg13_hv_nmos[delvto]
print @n.xbgr.xm36_u2.nsg13_hv_nmos[factuo]
print @n.xbgr.xm36_u3.nsg13_hv_nmos[w]
print @n.xbgr.xm36_u3.nsg13_hv_nmos[l]
print @n.xbgr.xm36_u3.nsg13_hv_nmos[delvto]
print @n.xbgr.xm36_u3.nsg13_hv_nmos[factuo]
print @n.xbgr.xm36_u4.nsg13_hv_nmos[w]
print @n.xbgr.xm36_u4.nsg13_hv_nmos[l]
print @n.xbgr.xm36_u4.nsg13_hv_nmos[delvto]
print @n.xbgr.xm36_u4.nsg13_hv_nmos[factuo]
print @n.xbgr.xm36_u5.nsg13_hv_nmos[w]
print @n.xbgr.xm36_u5.nsg13_hv_nmos[l]
print @n.xbgr.xm36_u5.nsg13_hv_nmos[delvto]
print @n.xbgr.xm36_u5.nsg13_hv_nmos[factuo]
print @n.xbgr.xm36_u6.nsg13_hv_nmos[w]
print @n.xbgr.xm36_u6.nsg13_hv_nmos[l]
print @n.xbgr.xm36_u6.nsg13_hv_nmos[delvto]
print @n.xbgr.xm36_u6.nsg13_hv_nmos[factuo]
print @n.xbgr.xm36_u7.nsg13_hv_nmos[w]
print @n.xbgr.xm36_u7.nsg13_hv_nmos[l]
print @n.xbgr.xm36_u7.nsg13_hv_nmos[delvto]
print @n.xbgr.xm36_u7.nsg13_hv_nmos[factuo]
print @n.xbgr.xm36_u8.nsg13_hv_nmos[w]
print @n.xbgr.xm36_u8.nsg13_hv_nmos[l]
print @n.xbgr.xm36_u8.nsg13_hv_nmos[delvto]
print @n.xbgr.xm36_u8.nsg13_hv_nmos[factuo]
print @n.xbgr.xm36_u9.nsg13_hv_nmos[w]
print @n.xbgr.xm36_u9.nsg13_hv_nmos[l]
print @n.xbgr.xm36_u9.nsg13_hv_nmos[delvto]
print @n.xbgr.xm36_u9.nsg13_hv_nmos[factuo]
print @n.xbgr.xm36_u10.nsg13_hv_nmos[w]
print @n.xbgr.xm36_u10.nsg13_hv_nmos[l]
print @n.xbgr.xm36_u10.nsg13_hv_nmos[delvto]
print @n.xbgr.xm36_u10.nsg13_hv_nmos[factuo]
print @n.xbgr.xm36_u11.nsg13_hv_nmos[w]
print @n.xbgr.xm36_u11.nsg13_hv_nmos[l]
print @n.xbgr.xm36_u11.nsg13_hv_nmos[delvto]
print @n.xbgr.xm36_u11.nsg13_hv_nmos[factuo]
print @n.xbgr.xm36_u12.nsg13_hv_nmos[w]
print @n.xbgr.xm36_u12.nsg13_hv_nmos[l]
print @n.xbgr.xm36_u12.nsg13_hv_nmos[delvto]
print @n.xbgr.xm36_u12.nsg13_hv_nmos[factuo]
print @n.xbgr.xm36_u13.nsg13_hv_nmos[w]
print @n.xbgr.xm36_u13.nsg13_hv_nmos[l]
print @n.xbgr.xm36_u13.nsg13_hv_nmos[delvto]
print @n.xbgr.xm36_u13.nsg13_hv_nmos[factuo]
print @n.xbgr.xm36_u14.nsg13_hv_nmos[w]
print @n.xbgr.xm36_u14.nsg13_hv_nmos[l]
print @n.xbgr.xm36_u14.nsg13_hv_nmos[delvto]
print @n.xbgr.xm36_u14.nsg13_hv_nmos[factuo]
print @n.xbgr.xm36_u15.nsg13_hv_nmos[w]
print @n.xbgr.xm36_u15.nsg13_hv_nmos[l]
print @n.xbgr.xm36_u15.nsg13_hv_nmos[delvto]
print @n.xbgr.xm36_u15.nsg13_hv_nmos[factuo]
print @n.xbgr.xm36_u16.nsg13_hv_nmos[w]
print @n.xbgr.xm36_u16.nsg13_hv_nmos[l]
print @n.xbgr.xm36_u16.nsg13_hv_nmos[delvto]
print @n.xbgr.xm36_u16.nsg13_hv_nmos[factuo]
print @n.xbgr.xm36_u17.nsg13_hv_nmos[w]
print @n.xbgr.xm36_u17.nsg13_hv_nmos[l]
print @n.xbgr.xm36_u17.nsg13_hv_nmos[delvto]
print @n.xbgr.xm36_u17.nsg13_hv_nmos[factuo]
print @n.xbgr.xm36_u18.nsg13_hv_nmos[w]
print @n.xbgr.xm36_u18.nsg13_hv_nmos[l]
print @n.xbgr.xm36_u18.nsg13_hv_nmos[delvto]
print @n.xbgr.xm36_u18.nsg13_hv_nmos[factuo]
print @n.xbgr.xm36_u19.nsg13_hv_nmos[w]
print @n.xbgr.xm36_u19.nsg13_hv_nmos[l]
print @n.xbgr.xm36_u19.nsg13_hv_nmos[delvto]
print @n.xbgr.xm36_u19.nsg13_hv_nmos[factuo]
print @n.xbgr.xm36_u20.nsg13_hv_nmos[w]
print @n.xbgr.xm36_u20.nsg13_hv_nmos[l]
print @n.xbgr.xm36_u20.nsg13_hv_nmos[delvto]
print @n.xbgr.xm36_u20.nsg13_hv_nmos[factuo]
print @n.xbgr.xm36_u21.nsg13_hv_nmos[w]
print @n.xbgr.xm36_u21.nsg13_hv_nmos[l]
print @n.xbgr.xm36_u21.nsg13_hv_nmos[delvto]
print @n.xbgr.xm36_u21.nsg13_hv_nmos[factuo]
print @n.xbgr.xm36_u22.nsg13_hv_nmos[w]
print @n.xbgr.xm36_u22.nsg13_hv_nmos[l]
print @n.xbgr.xm36_u22.nsg13_hv_nmos[delvto]
print @n.xbgr.xm36_u22.nsg13_hv_nmos[factuo]
print @n.xbgr.xm36_u23.nsg13_hv_nmos[w]
print @n.xbgr.xm36_u23.nsg13_hv_nmos[l]
print @n.xbgr.xm36_u23.nsg13_hv_nmos[delvto]
print @n.xbgr.xm36_u23.nsg13_hv_nmos[factuo]
print @n.xbgr.xm36_u24.nsg13_hv_nmos[w]
print @n.xbgr.xm36_u24.nsg13_hv_nmos[l]
print @n.xbgr.xm36_u24.nsg13_hv_nmos[delvto]
print @n.xbgr.xm36_u24.nsg13_hv_nmos[factuo]
print @n.xbgr.xm37_u2.nsg13_hv_nmos[w]
print @n.xbgr.xm37_u2.nsg13_hv_nmos[l]
print @n.xbgr.xm37_u2.nsg13_hv_nmos[delvto]
print @n.xbgr.xm37_u2.nsg13_hv_nmos[factuo]
print @n.xbgr.xm37_u3.nsg13_hv_nmos[w]
print @n.xbgr.xm37_u3.nsg13_hv_nmos[l]
print @n.xbgr.xm37_u3.nsg13_hv_nmos[delvto]
print @n.xbgr.xm37_u3.nsg13_hv_nmos[factuo]
print @n.xbgr.xm37_u4.nsg13_hv_nmos[w]
print @n.xbgr.xm37_u4.nsg13_hv_nmos[l]
print @n.xbgr.xm37_u4.nsg13_hv_nmos[delvto]
print @n.xbgr.xm37_u4.nsg13_hv_nmos[factuo]
print @n.xbgr.xm37_u5.nsg13_hv_nmos[w]
print @n.xbgr.xm37_u5.nsg13_hv_nmos[l]
print @n.xbgr.xm37_u5.nsg13_hv_nmos[delvto]
print @n.xbgr.xm37_u5.nsg13_hv_nmos[factuo]
print @n.xbgr.xm37_u6.nsg13_hv_nmos[w]
print @n.xbgr.xm37_u6.nsg13_hv_nmos[l]
print @n.xbgr.xm37_u6.nsg13_hv_nmos[delvto]
print @n.xbgr.xm37_u6.nsg13_hv_nmos[factuo]
print @n.xbgr.xm37_u7.nsg13_hv_nmos[w]
print @n.xbgr.xm37_u7.nsg13_hv_nmos[l]
print @n.xbgr.xm37_u7.nsg13_hv_nmos[delvto]
print @n.xbgr.xm37_u7.nsg13_hv_nmos[factuo]
print @n.xbgr.xm37_u8.nsg13_hv_nmos[w]
print @n.xbgr.xm37_u8.nsg13_hv_nmos[l]
print @n.xbgr.xm37_u8.nsg13_hv_nmos[delvto]
print @n.xbgr.xm37_u8.nsg13_hv_nmos[factuo]
print @n.xbgr.xm37_u9.nsg13_hv_nmos[w]
print @n.xbgr.xm37_u9.nsg13_hv_nmos[l]
print @n.xbgr.xm37_u9.nsg13_hv_nmos[delvto]
print @n.xbgr.xm37_u9.nsg13_hv_nmos[factuo]
print @n.xbgr.xm37_u10.nsg13_hv_nmos[w]
print @n.xbgr.xm37_u10.nsg13_hv_nmos[l]
print @n.xbgr.xm37_u10.nsg13_hv_nmos[delvto]
print @n.xbgr.xm37_u10.nsg13_hv_nmos[factuo]
print @n.xbgr.xm37_u11.nsg13_hv_nmos[w]
print @n.xbgr.xm37_u11.nsg13_hv_nmos[l]
print @n.xbgr.xm37_u11.nsg13_hv_nmos[delvto]
print @n.xbgr.xm37_u11.nsg13_hv_nmos[factuo]
print @n.xbgr.xm37_u12.nsg13_hv_nmos[w]
print @n.xbgr.xm37_u12.nsg13_hv_nmos[l]
print @n.xbgr.xm37_u12.nsg13_hv_nmos[delvto]
print @n.xbgr.xm37_u12.nsg13_hv_nmos[factuo]
print @n.xbgr.xm37_u13.nsg13_hv_nmos[w]
print @n.xbgr.xm37_u13.nsg13_hv_nmos[l]
print @n.xbgr.xm37_u13.nsg13_hv_nmos[delvto]
print @n.xbgr.xm37_u13.nsg13_hv_nmos[factuo]
print @n.xbgr.xm37_u14.nsg13_hv_nmos[w]
print @n.xbgr.xm37_u14.nsg13_hv_nmos[l]
print @n.xbgr.xm37_u14.nsg13_hv_nmos[delvto]
print @n.xbgr.xm37_u14.nsg13_hv_nmos[factuo]
print @n.xbgr.xm37_u15.nsg13_hv_nmos[w]
print @n.xbgr.xm37_u15.nsg13_hv_nmos[l]
print @n.xbgr.xm37_u15.nsg13_hv_nmos[delvto]
print @n.xbgr.xm37_u15.nsg13_hv_nmos[factuo]
print @n.xbgr.xm37_u16.nsg13_hv_nmos[w]
print @n.xbgr.xm37_u16.nsg13_hv_nmos[l]
print @n.xbgr.xm37_u16.nsg13_hv_nmos[delvto]
print @n.xbgr.xm37_u16.nsg13_hv_nmos[factuo]
print @n.xbgr.xm37_u17.nsg13_hv_nmos[w]
print @n.xbgr.xm37_u17.nsg13_hv_nmos[l]
print @n.xbgr.xm37_u17.nsg13_hv_nmos[delvto]
print @n.xbgr.xm37_u17.nsg13_hv_nmos[factuo]
print @n.xbgr.xm37_u18.nsg13_hv_nmos[w]
print @n.xbgr.xm37_u18.nsg13_hv_nmos[l]
print @n.xbgr.xm37_u18.nsg13_hv_nmos[delvto]
print @n.xbgr.xm37_u18.nsg13_hv_nmos[factuo]
print @n.xbgr.xm37_u19.nsg13_hv_nmos[w]
print @n.xbgr.xm37_u19.nsg13_hv_nmos[l]
print @n.xbgr.xm37_u19.nsg13_hv_nmos[delvto]
print @n.xbgr.xm37_u19.nsg13_hv_nmos[factuo]
print @n.xbgr.xm37_u20.nsg13_hv_nmos[w]
print @n.xbgr.xm37_u20.nsg13_hv_nmos[l]
print @n.xbgr.xm37_u20.nsg13_hv_nmos[delvto]
print @n.xbgr.xm37_u20.nsg13_hv_nmos[factuo]
print @n.xbgr.xm37_u21.nsg13_hv_nmos[w]
print @n.xbgr.xm37_u21.nsg13_hv_nmos[l]
print @n.xbgr.xm37_u21.nsg13_hv_nmos[delvto]
print @n.xbgr.xm37_u21.nsg13_hv_nmos[factuo]
print @n.xbgr.xm37_u22.nsg13_hv_nmos[w]
print @n.xbgr.xm37_u22.nsg13_hv_nmos[l]
print @n.xbgr.xm37_u22.nsg13_hv_nmos[delvto]
print @n.xbgr.xm37_u22.nsg13_hv_nmos[factuo]
print @n.xbgr.xm37_u23.nsg13_hv_nmos[w]
print @n.xbgr.xm37_u23.nsg13_hv_nmos[l]
print @n.xbgr.xm37_u23.nsg13_hv_nmos[delvto]
print @n.xbgr.xm37_u23.nsg13_hv_nmos[factuo]
print @n.xbgr.xm37_u24.nsg13_hv_nmos[w]
print @n.xbgr.xm37_u24.nsg13_hv_nmos[l]
print @n.xbgr.xm37_u24.nsg13_hv_nmos[delvto]
print @n.xbgr.xm37_u24.nsg13_hv_nmos[factuo]
print @n.xbgr.xm38_u2.nsg13_hv_pmos[w]
print @n.xbgr.xm38_u2.nsg13_hv_pmos[l]
print @n.xbgr.xm38_u2.nsg13_hv_pmos[delvto]
print @n.xbgr.xm38_u2.nsg13_hv_pmos[factuo]
print @n.xbgr.xm38_u3.nsg13_hv_pmos[w]
print @n.xbgr.xm38_u3.nsg13_hv_pmos[l]
print @n.xbgr.xm38_u3.nsg13_hv_pmos[delvto]
print @n.xbgr.xm38_u3.nsg13_hv_pmos[factuo]
print @n.xbgr.xm38_u4.nsg13_hv_pmos[w]
print @n.xbgr.xm38_u4.nsg13_hv_pmos[l]
print @n.xbgr.xm38_u4.nsg13_hv_pmos[delvto]
print @n.xbgr.xm38_u4.nsg13_hv_pmos[factuo]
print @n.xbgr.xm38_u5.nsg13_hv_pmos[w]
print @n.xbgr.xm38_u5.nsg13_hv_pmos[l]
print @n.xbgr.xm38_u5.nsg13_hv_pmos[delvto]
print @n.xbgr.xm38_u5.nsg13_hv_pmos[factuo]
print @n.xbgr.xm38_u6.nsg13_hv_pmos[w]
print @n.xbgr.xm38_u6.nsg13_hv_pmos[l]
print @n.xbgr.xm38_u6.nsg13_hv_pmos[delvto]
print @n.xbgr.xm38_u6.nsg13_hv_pmos[factuo]
print @n.xbgr.xm38_u7.nsg13_hv_pmos[w]
print @n.xbgr.xm38_u7.nsg13_hv_pmos[l]
print @n.xbgr.xm38_u7.nsg13_hv_pmos[delvto]
print @n.xbgr.xm38_u7.nsg13_hv_pmos[factuo]
print @n.xbgr.xm38_u8.nsg13_hv_pmos[w]
print @n.xbgr.xm38_u8.nsg13_hv_pmos[l]
print @n.xbgr.xm38_u8.nsg13_hv_pmos[delvto]
print @n.xbgr.xm38_u8.nsg13_hv_pmos[factuo]
print @n.xbgr.xm38_u9.nsg13_hv_pmos[w]
print @n.xbgr.xm38_u9.nsg13_hv_pmos[l]
print @n.xbgr.xm38_u9.nsg13_hv_pmos[delvto]
print @n.xbgr.xm38_u9.nsg13_hv_pmos[factuo]
print @n.xbgr.xm38_u10.nsg13_hv_pmos[w]
print @n.xbgr.xm38_u10.nsg13_hv_pmos[l]
print @n.xbgr.xm38_u10.nsg13_hv_pmos[delvto]
print @n.xbgr.xm38_u10.nsg13_hv_pmos[factuo]
print @n.xbgr.xm38_u11.nsg13_hv_pmos[w]
print @n.xbgr.xm38_u11.nsg13_hv_pmos[l]
print @n.xbgr.xm38_u11.nsg13_hv_pmos[delvto]
print @n.xbgr.xm38_u11.nsg13_hv_pmos[factuo]
print @n.xbgr.xm38_u12.nsg13_hv_pmos[w]
print @n.xbgr.xm38_u12.nsg13_hv_pmos[l]
print @n.xbgr.xm38_u12.nsg13_hv_pmos[delvto]
print @n.xbgr.xm38_u12.nsg13_hv_pmos[factuo]
print @n.xbgr.xm38_u13.nsg13_hv_pmos[w]
print @n.xbgr.xm38_u13.nsg13_hv_pmos[l]
print @n.xbgr.xm38_u13.nsg13_hv_pmos[delvto]
print @n.xbgr.xm38_u13.nsg13_hv_pmos[factuo]
print @n.xbgr.xm38_u14.nsg13_hv_pmos[w]
print @n.xbgr.xm38_u14.nsg13_hv_pmos[l]
print @n.xbgr.xm38_u14.nsg13_hv_pmos[delvto]
print @n.xbgr.xm38_u14.nsg13_hv_pmos[factuo]
print @n.xbgr.xm38_u15.nsg13_hv_pmos[w]
print @n.xbgr.xm38_u15.nsg13_hv_pmos[l]
print @n.xbgr.xm38_u15.nsg13_hv_pmos[delvto]
print @n.xbgr.xm38_u15.nsg13_hv_pmos[factuo]
print @n.xbgr.xm38_u16.nsg13_hv_pmos[w]
print @n.xbgr.xm38_u16.nsg13_hv_pmos[l]
print @n.xbgr.xm38_u16.nsg13_hv_pmos[delvto]
print @n.xbgr.xm38_u16.nsg13_hv_pmos[factuo]
print @n.xbgr.xm38_u17.nsg13_hv_pmos[w]
print @n.xbgr.xm38_u17.nsg13_hv_pmos[l]
print @n.xbgr.xm38_u17.nsg13_hv_pmos[delvto]
print @n.xbgr.xm38_u17.nsg13_hv_pmos[factuo]
print @n.xbgr.xm38_u18.nsg13_hv_pmos[w]
print @n.xbgr.xm38_u18.nsg13_hv_pmos[l]
print @n.xbgr.xm38_u18.nsg13_hv_pmos[delvto]
print @n.xbgr.xm38_u18.nsg13_hv_pmos[factuo]
print @n.xbgr.xm38_u19.nsg13_hv_pmos[w]
print @n.xbgr.xm38_u19.nsg13_hv_pmos[l]
print @n.xbgr.xm38_u19.nsg13_hv_pmos[delvto]
print @n.xbgr.xm38_u19.nsg13_hv_pmos[factuo]
print @n.xbgr.xm38_u20.nsg13_hv_pmos[w]
print @n.xbgr.xm38_u20.nsg13_hv_pmos[l]
print @n.xbgr.xm38_u20.nsg13_hv_pmos[delvto]
print @n.xbgr.xm38_u20.nsg13_hv_pmos[factuo]
print @n.xbgr.xm38_u21.nsg13_hv_pmos[w]
print @n.xbgr.xm38_u21.nsg13_hv_pmos[l]
print @n.xbgr.xm38_u21.nsg13_hv_pmos[delvto]
print @n.xbgr.xm38_u21.nsg13_hv_pmos[factuo]
print @n.xbgr.xm38_u22.nsg13_hv_pmos[w]
print @n.xbgr.xm38_u22.nsg13_hv_pmos[l]
print @n.xbgr.xm38_u22.nsg13_hv_pmos[delvto]
print @n.xbgr.xm38_u22.nsg13_hv_pmos[factuo]
print @n.xbgr.xm38_u23.nsg13_hv_pmos[w]
print @n.xbgr.xm38_u23.nsg13_hv_pmos[l]
print @n.xbgr.xm38_u23.nsg13_hv_pmos[delvto]
print @n.xbgr.xm38_u23.nsg13_hv_pmos[factuo]
print @n.xbgr.xm38_u24.nsg13_hv_pmos[w]
print @n.xbgr.xm38_u24.nsg13_hv_pmos[l]
print @n.xbgr.xm38_u24.nsg13_hv_pmos[delvto]
print @n.xbgr.xm38_u24.nsg13_hv_pmos[factuo]
print @n.xbgr.xm39_u2.nsg13_hv_pmos[w]
print @n.xbgr.xm39_u2.nsg13_hv_pmos[l]
print @n.xbgr.xm39_u2.nsg13_hv_pmos[delvto]
print @n.xbgr.xm39_u2.nsg13_hv_pmos[factuo]
print @n.xbgr.xm39_u3.nsg13_hv_pmos[w]
print @n.xbgr.xm39_u3.nsg13_hv_pmos[l]
print @n.xbgr.xm39_u3.nsg13_hv_pmos[delvto]
print @n.xbgr.xm39_u3.nsg13_hv_pmos[factuo]
print @n.xbgr.xm39_u4.nsg13_hv_pmos[w]
print @n.xbgr.xm39_u4.nsg13_hv_pmos[l]
print @n.xbgr.xm39_u4.nsg13_hv_pmos[delvto]
print @n.xbgr.xm39_u4.nsg13_hv_pmos[factuo]
print @n.xbgr.xm39_u5.nsg13_hv_pmos[w]
print @n.xbgr.xm39_u5.nsg13_hv_pmos[l]
print @n.xbgr.xm39_u5.nsg13_hv_pmos[delvto]
print @n.xbgr.xm39_u5.nsg13_hv_pmos[factuo]
print @n.xbgr.xm39_u6.nsg13_hv_pmos[w]
print @n.xbgr.xm39_u6.nsg13_hv_pmos[l]
print @n.xbgr.xm39_u6.nsg13_hv_pmos[delvto]
print @n.xbgr.xm39_u6.nsg13_hv_pmos[factuo]
print @n.xbgr.xm39_u7.nsg13_hv_pmos[w]
print @n.xbgr.xm39_u7.nsg13_hv_pmos[l]
print @n.xbgr.xm39_u7.nsg13_hv_pmos[delvto]
print @n.xbgr.xm39_u7.nsg13_hv_pmos[factuo]
print @n.xbgr.xm39_u8.nsg13_hv_pmos[w]
print @n.xbgr.xm39_u8.nsg13_hv_pmos[l]
print @n.xbgr.xm39_u8.nsg13_hv_pmos[delvto]
print @n.xbgr.xm39_u8.nsg13_hv_pmos[factuo]
print @n.xbgr.xm39_u9.nsg13_hv_pmos[w]
print @n.xbgr.xm39_u9.nsg13_hv_pmos[l]
print @n.xbgr.xm39_u9.nsg13_hv_pmos[delvto]
print @n.xbgr.xm39_u9.nsg13_hv_pmos[factuo]
print @n.xbgr.xm39_u10.nsg13_hv_pmos[w]
print @n.xbgr.xm39_u10.nsg13_hv_pmos[l]
print @n.xbgr.xm39_u10.nsg13_hv_pmos[delvto]
print @n.xbgr.xm39_u10.nsg13_hv_pmos[factuo]
print @n.xbgr.xm39_u11.nsg13_hv_pmos[w]
print @n.xbgr.xm39_u11.nsg13_hv_pmos[l]
print @n.xbgr.xm39_u11.nsg13_hv_pmos[delvto]
print @n.xbgr.xm39_u11.nsg13_hv_pmos[factuo]
print @n.xbgr.xm39_u12.nsg13_hv_pmos[w]
print @n.xbgr.xm39_u12.nsg13_hv_pmos[l]
print @n.xbgr.xm39_u12.nsg13_hv_pmos[delvto]
print @n.xbgr.xm39_u12.nsg13_hv_pmos[factuo]
print @n.xbgr.xm39_u13.nsg13_hv_pmos[w]
print @n.xbgr.xm39_u13.nsg13_hv_pmos[l]
print @n.xbgr.xm39_u13.nsg13_hv_pmos[delvto]
print @n.xbgr.xm39_u13.nsg13_hv_pmos[factuo]
print @n.xbgr.xm39_u14.nsg13_hv_pmos[w]
print @n.xbgr.xm39_u14.nsg13_hv_pmos[l]
print @n.xbgr.xm39_u14.nsg13_hv_pmos[delvto]
print @n.xbgr.xm39_u14.nsg13_hv_pmos[factuo]
print @n.xbgr.xm39_u15.nsg13_hv_pmos[w]
print @n.xbgr.xm39_u15.nsg13_hv_pmos[l]
print @n.xbgr.xm39_u15.nsg13_hv_pmos[delvto]
print @n.xbgr.xm39_u15.nsg13_hv_pmos[factuo]
print @n.xbgr.xm39_u16.nsg13_hv_pmos[w]
print @n.xbgr.xm39_u16.nsg13_hv_pmos[l]
print @n.xbgr.xm39_u16.nsg13_hv_pmos[delvto]
print @n.xbgr.xm39_u16.nsg13_hv_pmos[factuo]
print @n.xbgr.xm39_u17.nsg13_hv_pmos[w]
print @n.xbgr.xm39_u17.nsg13_hv_pmos[l]
print @n.xbgr.xm39_u17.nsg13_hv_pmos[delvto]
print @n.xbgr.xm39_u17.nsg13_hv_pmos[factuo]
print @n.xbgr.xm39_u18.nsg13_hv_pmos[w]
print @n.xbgr.xm39_u18.nsg13_hv_pmos[l]
print @n.xbgr.xm39_u18.nsg13_hv_pmos[delvto]
print @n.xbgr.xm39_u18.nsg13_hv_pmos[factuo]
print @n.xbgr.xm39_u19.nsg13_hv_pmos[w]
print @n.xbgr.xm39_u19.nsg13_hv_pmos[l]
print @n.xbgr.xm39_u19.nsg13_hv_pmos[delvto]
print @n.xbgr.xm39_u19.nsg13_hv_pmos[factuo]
print @n.xbgr.xm39_u20.nsg13_hv_pmos[w]
print @n.xbgr.xm39_u20.nsg13_hv_pmos[l]
print @n.xbgr.xm39_u20.nsg13_hv_pmos[delvto]
print @n.xbgr.xm39_u20.nsg13_hv_pmos[factuo]
print @n.xbgr.xm39_u21.nsg13_hv_pmos[w]
print @n.xbgr.xm39_u21.nsg13_hv_pmos[l]
print @n.xbgr.xm39_u21.nsg13_hv_pmos[delvto]
print @n.xbgr.xm39_u21.nsg13_hv_pmos[factuo]
print @n.xbgr.xm39_u22.nsg13_hv_pmos[w]
print @n.xbgr.xm39_u22.nsg13_hv_pmos[l]
print @n.xbgr.xm39_u22.nsg13_hv_pmos[delvto]
print @n.xbgr.xm39_u22.nsg13_hv_pmos[factuo]
print @n.xbgr.xm39_u23.nsg13_hv_pmos[w]
print @n.xbgr.xm39_u23.nsg13_hv_pmos[l]
print @n.xbgr.xm39_u23.nsg13_hv_pmos[delvto]
print @n.xbgr.xm39_u23.nsg13_hv_pmos[factuo]
print @n.xbgr.xm39_u24.nsg13_hv_pmos[w]
print @n.xbgr.xm39_u24.nsg13_hv_pmos[l]
print @n.xbgr.xm39_u24.nsg13_hv_pmos[delvto]
print @n.xbgr.xm39_u24.nsg13_hv_pmos[factuo]
print @n.xbgr.xm41_u2.nsg13_hv_pmos[w]
print @n.xbgr.xm41_u2.nsg13_hv_pmos[l]
print @n.xbgr.xm41_u2.nsg13_hv_pmos[delvto]
print @n.xbgr.xm41_u2.nsg13_hv_pmos[factuo]
print @n.xbgr.xm41_u3.nsg13_hv_pmos[w]
print @n.xbgr.xm41_u3.nsg13_hv_pmos[l]
print @n.xbgr.xm41_u3.nsg13_hv_pmos[delvto]
print @n.xbgr.xm41_u3.nsg13_hv_pmos[factuo]
print @n.xbgr.xm41_u4.nsg13_hv_pmos[w]
print @n.xbgr.xm41_u4.nsg13_hv_pmos[l]
print @n.xbgr.xm41_u4.nsg13_hv_pmos[delvto]
print @n.xbgr.xm41_u4.nsg13_hv_pmos[factuo]
print @n.xbgr.xm41_u5.nsg13_hv_pmos[w]
print @n.xbgr.xm41_u5.nsg13_hv_pmos[l]
print @n.xbgr.xm41_u5.nsg13_hv_pmos[delvto]
print @n.xbgr.xm41_u5.nsg13_hv_pmos[factuo]
print @n.xbgr.xm41_u6.nsg13_hv_pmos[w]
print @n.xbgr.xm41_u6.nsg13_hv_pmos[l]
print @n.xbgr.xm41_u6.nsg13_hv_pmos[delvto]
print @n.xbgr.xm41_u6.nsg13_hv_pmos[factuo]
print @n.xbgr.xm41_u7.nsg13_hv_pmos[w]
print @n.xbgr.xm41_u7.nsg13_hv_pmos[l]
print @n.xbgr.xm41_u7.nsg13_hv_pmos[delvto]
print @n.xbgr.xm41_u7.nsg13_hv_pmos[factuo]
print @n.xbgr.xm41_u8.nsg13_hv_pmos[w]
print @n.xbgr.xm41_u8.nsg13_hv_pmos[l]
print @n.xbgr.xm41_u8.nsg13_hv_pmos[delvto]
print @n.xbgr.xm41_u8.nsg13_hv_pmos[factuo]
print @n.xbgr.xm41_u9.nsg13_hv_pmos[w]
print @n.xbgr.xm41_u9.nsg13_hv_pmos[l]
print @n.xbgr.xm41_u9.nsg13_hv_pmos[delvto]
print @n.xbgr.xm41_u9.nsg13_hv_pmos[factuo]
print @n.xbgr.xm41_u10.nsg13_hv_pmos[w]
print @n.xbgr.xm41_u10.nsg13_hv_pmos[l]
print @n.xbgr.xm41_u10.nsg13_hv_pmos[delvto]
print @n.xbgr.xm41_u10.nsg13_hv_pmos[factuo]
print @n.xbgr.xm41_u11.nsg13_hv_pmos[w]
print @n.xbgr.xm41_u11.nsg13_hv_pmos[l]
print @n.xbgr.xm41_u11.nsg13_hv_pmos[delvto]
print @n.xbgr.xm41_u11.nsg13_hv_pmos[factuo]
print @n.xbgr.xm41_u12.nsg13_hv_pmos[w]
print @n.xbgr.xm41_u12.nsg13_hv_pmos[l]
print @n.xbgr.xm41_u12.nsg13_hv_pmos[delvto]
print @n.xbgr.xm41_u12.nsg13_hv_pmos[factuo]
print @n.xbgr.xm41_u13.nsg13_hv_pmos[w]
print @n.xbgr.xm41_u13.nsg13_hv_pmos[l]
print @n.xbgr.xm41_u13.nsg13_hv_pmos[delvto]
print @n.xbgr.xm41_u13.nsg13_hv_pmos[factuo]
print @n.xbgr.xm41_u14.nsg13_hv_pmos[w]
print @n.xbgr.xm41_u14.nsg13_hv_pmos[l]
print @n.xbgr.xm41_u14.nsg13_hv_pmos[delvto]
print @n.xbgr.xm41_u14.nsg13_hv_pmos[factuo]
print @n.xbgr.xm41_u15.nsg13_hv_pmos[w]
print @n.xbgr.xm41_u15.nsg13_hv_pmos[l]
print @n.xbgr.xm41_u15.nsg13_hv_pmos[delvto]
print @n.xbgr.xm41_u15.nsg13_hv_pmos[factuo]
print @n.xbgr.xm41_u16.nsg13_hv_pmos[w]
print @n.xbgr.xm41_u16.nsg13_hv_pmos[l]
print @n.xbgr.xm41_u16.nsg13_hv_pmos[delvto]
print @n.xbgr.xm41_u16.nsg13_hv_pmos[factuo]
print @n.xbgr.xm41_u17.nsg13_hv_pmos[w]
print @n.xbgr.xm41_u17.nsg13_hv_pmos[l]
print @n.xbgr.xm41_u17.nsg13_hv_pmos[delvto]
print @n.xbgr.xm41_u17.nsg13_hv_pmos[factuo]
print @n.xbgr.xm41_u18.nsg13_hv_pmos[w]
print @n.xbgr.xm41_u18.nsg13_hv_pmos[l]
print @n.xbgr.xm41_u18.nsg13_hv_pmos[delvto]
print @n.xbgr.xm41_u18.nsg13_hv_pmos[factuo]
print @n.xbgr.xm41_u19.nsg13_hv_pmos[w]
print @n.xbgr.xm41_u19.nsg13_hv_pmos[l]
print @n.xbgr.xm41_u19.nsg13_hv_pmos[delvto]
print @n.xbgr.xm41_u19.nsg13_hv_pmos[factuo]
print @n.xbgr.xm41_u20.nsg13_hv_pmos[w]
print @n.xbgr.xm41_u20.nsg13_hv_pmos[l]
print @n.xbgr.xm41_u20.nsg13_hv_pmos[delvto]
print @n.xbgr.xm41_u20.nsg13_hv_pmos[factuo]
print @n.xbgr.xm41_u21.nsg13_hv_pmos[w]
print @n.xbgr.xm41_u21.nsg13_hv_pmos[l]
print @n.xbgr.xm41_u21.nsg13_hv_pmos[delvto]
print @n.xbgr.xm41_u21.nsg13_hv_pmos[factuo]
print @n.xbgr.xm41_u22.nsg13_hv_pmos[w]
print @n.xbgr.xm41_u22.nsg13_hv_pmos[l]
print @n.xbgr.xm41_u22.nsg13_hv_pmos[delvto]
print @n.xbgr.xm41_u22.nsg13_hv_pmos[factuo]
print @n.xbgr.xm41_u23.nsg13_hv_pmos[w]
print @n.xbgr.xm41_u23.nsg13_hv_pmos[l]
print @n.xbgr.xm41_u23.nsg13_hv_pmos[delvto]
print @n.xbgr.xm41_u23.nsg13_hv_pmos[factuo]
print @n.xbgr.xm41_u24.nsg13_hv_pmos[w]
print @n.xbgr.xm41_u24.nsg13_hv_pmos[l]
print @n.xbgr.xm41_u24.nsg13_hv_pmos[delvto]
print @n.xbgr.xm41_u24.nsg13_hv_pmos[factuo]
print @n.xbgr.xm43_u2.nsg13_hv_pmos[w]
print @n.xbgr.xm43_u2.nsg13_hv_pmos[l]
print @n.xbgr.xm43_u2.nsg13_hv_pmos[delvto]
print @n.xbgr.xm43_u2.nsg13_hv_pmos[factuo]
print @n.xbgr.xm43_u3.nsg13_hv_pmos[w]
print @n.xbgr.xm43_u3.nsg13_hv_pmos[l]
print @n.xbgr.xm43_u3.nsg13_hv_pmos[delvto]
print @n.xbgr.xm43_u3.nsg13_hv_pmos[factuo]
print @n.xbgr.xm43_u4.nsg13_hv_pmos[w]
print @n.xbgr.xm43_u4.nsg13_hv_pmos[l]
print @n.xbgr.xm43_u4.nsg13_hv_pmos[delvto]
print @n.xbgr.xm43_u4.nsg13_hv_pmos[factuo]
print @n.xbgr.xm44_u2.nsg13_hv_pmos[w]
print @n.xbgr.xm44_u2.nsg13_hv_pmos[l]
print @n.xbgr.xm44_u2.nsg13_hv_pmos[delvto]
print @n.xbgr.xm44_u2.nsg13_hv_pmos[factuo]
print @n.xbgr.xm44_u3.nsg13_hv_pmos[w]
print @n.xbgr.xm44_u3.nsg13_hv_pmos[l]
print @n.xbgr.xm44_u3.nsg13_hv_pmos[delvto]
print @n.xbgr.xm44_u3.nsg13_hv_pmos[factuo]
print @n.xbgr.xm44_u4.nsg13_hv_pmos[w]
print @n.xbgr.xm44_u4.nsg13_hv_pmos[l]
print @n.xbgr.xm44_u4.nsg13_hv_pmos[delvto]
print @n.xbgr.xm44_u4.nsg13_hv_pmos[factuo]
print @n.xbgr.xm45_u2.nsg13_hv_pmos[w]
print @n.xbgr.xm45_u2.nsg13_hv_pmos[l]
print @n.xbgr.xm45_u2.nsg13_hv_pmos[delvto]
print @n.xbgr.xm45_u2.nsg13_hv_pmos[factuo]
print @n.xbgr.xm45_u3.nsg13_hv_pmos[w]
print @n.xbgr.xm45_u3.nsg13_hv_pmos[l]
print @n.xbgr.xm45_u3.nsg13_hv_pmos[delvto]
print @n.xbgr.xm45_u3.nsg13_hv_pmos[factuo]
print @n.xbgr.xm45_u4.nsg13_hv_pmos[w]
print @n.xbgr.xm45_u4.nsg13_hv_pmos[l]
print @n.xbgr.xm45_u4.nsg13_hv_pmos[delvto]
print @n.xbgr.xm45_u4.nsg13_hv_pmos[factuo]
print @n.xbgr.xm45_u5.nsg13_hv_pmos[w]
print @n.xbgr.xm45_u5.nsg13_hv_pmos[l]
print @n.xbgr.xm45_u5.nsg13_hv_pmos[delvto]
print @n.xbgr.xm45_u5.nsg13_hv_pmos[factuo]
print @n.xbgr.xm45_u6.nsg13_hv_pmos[w]
print @n.xbgr.xm45_u6.nsg13_hv_pmos[l]
print @n.xbgr.xm45_u6.nsg13_hv_pmos[delvto]
print @n.xbgr.xm45_u6.nsg13_hv_pmos[factuo]
print @n.xbgr.xm45_u7.nsg13_hv_pmos[w]
print @n.xbgr.xm45_u7.nsg13_hv_pmos[l]
print @n.xbgr.xm45_u7.nsg13_hv_pmos[delvto]
print @n.xbgr.xm45_u7.nsg13_hv_pmos[factuo]
print @n.xbgr.xm45_u8.nsg13_hv_pmos[w]
print @n.xbgr.xm45_u8.nsg13_hv_pmos[l]
print @n.xbgr.xm45_u8.nsg13_hv_pmos[delvto]
print @n.xbgr.xm45_u8.nsg13_hv_pmos[factuo]
print @n.xbgr.xm45_u9.nsg13_hv_pmos[w]
print @n.xbgr.xm45_u9.nsg13_hv_pmos[l]
print @n.xbgr.xm45_u9.nsg13_hv_pmos[delvto]
print @n.xbgr.xm45_u9.nsg13_hv_pmos[factuo]
print @n.xbgr.xm45_u10.nsg13_hv_pmos[w]
print @n.xbgr.xm45_u10.nsg13_hv_pmos[l]
print @n.xbgr.xm45_u10.nsg13_hv_pmos[delvto]
print @n.xbgr.xm45_u10.nsg13_hv_pmos[factuo]
print @n.xbgr.xm45_u11.nsg13_hv_pmos[w]
print @n.xbgr.xm45_u11.nsg13_hv_pmos[l]
print @n.xbgr.xm45_u11.nsg13_hv_pmos[delvto]
print @n.xbgr.xm45_u11.nsg13_hv_pmos[factuo]
print @n.xbgr.xm45_u12.nsg13_hv_pmos[w]
print @n.xbgr.xm45_u12.nsg13_hv_pmos[l]
print @n.xbgr.xm45_u12.nsg13_hv_pmos[delvto]
print @n.xbgr.xm45_u12.nsg13_hv_pmos[factuo]
print @n.xbgr.xm45_u13.nsg13_hv_pmos[w]
print @n.xbgr.xm45_u13.nsg13_hv_pmos[l]
print @n.xbgr.xm45_u13.nsg13_hv_pmos[delvto]
print @n.xbgr.xm45_u13.nsg13_hv_pmos[factuo]
print @n.xbgr.xm45_u14.nsg13_hv_pmos[w]
print @n.xbgr.xm45_u14.nsg13_hv_pmos[l]
print @n.xbgr.xm45_u14.nsg13_hv_pmos[delvto]
print @n.xbgr.xm45_u14.nsg13_hv_pmos[factuo]
print @n.xbgr.xm45_u15.nsg13_hv_pmos[w]
print @n.xbgr.xm45_u15.nsg13_hv_pmos[l]
print @n.xbgr.xm45_u15.nsg13_hv_pmos[delvto]
print @n.xbgr.xm45_u15.nsg13_hv_pmos[factuo]
print @n.xbgr.xm45_u16.nsg13_hv_pmos[w]
print @n.xbgr.xm45_u16.nsg13_hv_pmos[l]
print @n.xbgr.xm45_u16.nsg13_hv_pmos[delvto]
print @n.xbgr.xm45_u16.nsg13_hv_pmos[factuo]
print @n.xbgr.xm45_u17.nsg13_hv_pmos[w]
print @n.xbgr.xm45_u17.nsg13_hv_pmos[l]
print @n.xbgr.xm45_u17.nsg13_hv_pmos[delvto]
print @n.xbgr.xm45_u17.nsg13_hv_pmos[factuo]
print @n.xbgr.xm45_u18.nsg13_hv_pmos[w]
print @n.xbgr.xm45_u18.nsg13_hv_pmos[l]
print @n.xbgr.xm45_u18.nsg13_hv_pmos[delvto]
print @n.xbgr.xm45_u18.nsg13_hv_pmos[factuo]
print @n.xbgr.xm45_u19.nsg13_hv_pmos[w]
print @n.xbgr.xm45_u19.nsg13_hv_pmos[l]
print @n.xbgr.xm45_u19.nsg13_hv_pmos[delvto]
print @n.xbgr.xm45_u19.nsg13_hv_pmos[factuo]
print @n.xbgr.xm45_u20.nsg13_hv_pmos[w]
print @n.xbgr.xm45_u20.nsg13_hv_pmos[l]
print @n.xbgr.xm45_u20.nsg13_hv_pmos[delvto]
print @n.xbgr.xm45_u20.nsg13_hv_pmos[factuo]
print @n.xbgr.xm45_u21.nsg13_hv_pmos[w]
print @n.xbgr.xm45_u21.nsg13_hv_pmos[l]
print @n.xbgr.xm45_u21.nsg13_hv_pmos[delvto]
print @n.xbgr.xm45_u21.nsg13_hv_pmos[factuo]
print @n.xbgr.xm45_u22.nsg13_hv_pmos[w]
print @n.xbgr.xm45_u22.nsg13_hv_pmos[l]
print @n.xbgr.xm45_u22.nsg13_hv_pmos[delvto]
print @n.xbgr.xm45_u22.nsg13_hv_pmos[factuo]
print @n.xbgr.xm45_u23.nsg13_hv_pmos[w]
print @n.xbgr.xm45_u23.nsg13_hv_pmos[l]
print @n.xbgr.xm45_u23.nsg13_hv_pmos[delvto]
print @n.xbgr.xm45_u23.nsg13_hv_pmos[factuo]
print @n.xbgr.xm45_u24.nsg13_hv_pmos[w]
print @n.xbgr.xm45_u24.nsg13_hv_pmos[l]
print @n.xbgr.xm45_u24.nsg13_hv_pmos[delvto]
print @n.xbgr.xm45_u24.nsg13_hv_pmos[factuo]
print @n.xbgr.xm47_u2.nsg13_hv_pmos[w]
print @n.xbgr.xm47_u2.nsg13_hv_pmos[l]
print @n.xbgr.xm47_u2.nsg13_hv_pmos[delvto]
print @n.xbgr.xm47_u2.nsg13_hv_pmos[factuo]
print @n.xbgr.xm47_u3.nsg13_hv_pmos[w]
print @n.xbgr.xm47_u3.nsg13_hv_pmos[l]
print @n.xbgr.xm47_u3.nsg13_hv_pmos[delvto]
print @n.xbgr.xm47_u3.nsg13_hv_pmos[factuo]
print @n.xbgr.xm47_u4.nsg13_hv_pmos[w]
print @n.xbgr.xm47_u4.nsg13_hv_pmos[l]
print @n.xbgr.xm47_u4.nsg13_hv_pmos[delvto]
print @n.xbgr.xm47_u4.nsg13_hv_pmos[factuo]
print @n.xbgr.xm47_u5.nsg13_hv_pmos[w]
print @n.xbgr.xm47_u5.nsg13_hv_pmos[l]
print @n.xbgr.xm47_u5.nsg13_hv_pmos[delvto]
print @n.xbgr.xm47_u5.nsg13_hv_pmos[factuo]
print @n.xbgr.xm47_u6.nsg13_hv_pmos[w]
print @n.xbgr.xm47_u6.nsg13_hv_pmos[l]
print @n.xbgr.xm47_u6.nsg13_hv_pmos[delvto]
print @n.xbgr.xm47_u6.nsg13_hv_pmos[factuo]
print @n.xbgr.xm47_u7.nsg13_hv_pmos[w]
print @n.xbgr.xm47_u7.nsg13_hv_pmos[l]
print @n.xbgr.xm47_u7.nsg13_hv_pmos[delvto]
print @n.xbgr.xm47_u7.nsg13_hv_pmos[factuo]
print @n.xbgr.xm47_u8.nsg13_hv_pmos[w]
print @n.xbgr.xm47_u8.nsg13_hv_pmos[l]
print @n.xbgr.xm47_u8.nsg13_hv_pmos[delvto]
print @n.xbgr.xm47_u8.nsg13_hv_pmos[factuo]
print @n.xbgr.xm47_u9.nsg13_hv_pmos[w]
print @n.xbgr.xm47_u9.nsg13_hv_pmos[l]
print @n.xbgr.xm47_u9.nsg13_hv_pmos[delvto]
print @n.xbgr.xm47_u9.nsg13_hv_pmos[factuo]
print @n.xbgr.xm47_u10.nsg13_hv_pmos[w]
print @n.xbgr.xm47_u10.nsg13_hv_pmos[l]
print @n.xbgr.xm47_u10.nsg13_hv_pmos[delvto]
print @n.xbgr.xm47_u10.nsg13_hv_pmos[factuo]
print @n.xbgr.xm47_u11.nsg13_hv_pmos[w]
print @n.xbgr.xm47_u11.nsg13_hv_pmos[l]
print @n.xbgr.xm47_u11.nsg13_hv_pmos[delvto]
print @n.xbgr.xm47_u11.nsg13_hv_pmos[factuo]
print @n.xbgr.xm47_u12.nsg13_hv_pmos[w]
print @n.xbgr.xm47_u12.nsg13_hv_pmos[l]
print @n.xbgr.xm47_u12.nsg13_hv_pmos[delvto]
print @n.xbgr.xm47_u12.nsg13_hv_pmos[factuo]
print @n.xbgr.xm47_u13.nsg13_hv_pmos[w]
print @n.xbgr.xm47_u13.nsg13_hv_pmos[l]
print @n.xbgr.xm47_u13.nsg13_hv_pmos[delvto]
print @n.xbgr.xm47_u13.nsg13_hv_pmos[factuo]
print @n.xbgr.xm47_u14.nsg13_hv_pmos[w]
print @n.xbgr.xm47_u14.nsg13_hv_pmos[l]
print @n.xbgr.xm47_u14.nsg13_hv_pmos[delvto]
print @n.xbgr.xm47_u14.nsg13_hv_pmos[factuo]
print @n.xbgr.xm47_u15.nsg13_hv_pmos[w]
print @n.xbgr.xm47_u15.nsg13_hv_pmos[l]
print @n.xbgr.xm47_u15.nsg13_hv_pmos[delvto]
print @n.xbgr.xm47_u15.nsg13_hv_pmos[factuo]
print @n.xbgr.xm47_u16.nsg13_hv_pmos[w]
print @n.xbgr.xm47_u16.nsg13_hv_pmos[l]
print @n.xbgr.xm47_u16.nsg13_hv_pmos[delvto]
print @n.xbgr.xm47_u16.nsg13_hv_pmos[factuo]
print @n.xbgr.xm47_u17.nsg13_hv_pmos[w]
print @n.xbgr.xm47_u17.nsg13_hv_pmos[l]
print @n.xbgr.xm47_u17.nsg13_hv_pmos[delvto]
print @n.xbgr.xm47_u17.nsg13_hv_pmos[factuo]
print @n.xbgr.xm47_u18.nsg13_hv_pmos[w]
print @n.xbgr.xm47_u18.nsg13_hv_pmos[l]
print @n.xbgr.xm47_u18.nsg13_hv_pmos[delvto]
print @n.xbgr.xm47_u18.nsg13_hv_pmos[factuo]
print @n.xbgr.xm47_u19.nsg13_hv_pmos[w]
print @n.xbgr.xm47_u19.nsg13_hv_pmos[l]
print @n.xbgr.xm47_u19.nsg13_hv_pmos[delvto]
print @n.xbgr.xm47_u19.nsg13_hv_pmos[factuo]
print @n.xbgr.xm47_u20.nsg13_hv_pmos[w]
print @n.xbgr.xm47_u20.nsg13_hv_pmos[l]
print @n.xbgr.xm47_u20.nsg13_hv_pmos[delvto]
print @n.xbgr.xm47_u20.nsg13_hv_pmos[factuo]
print @n.xbgr.xm47_u21.nsg13_hv_pmos[w]
print @n.xbgr.xm47_u21.nsg13_hv_pmos[l]
print @n.xbgr.xm47_u21.nsg13_hv_pmos[delvto]
print @n.xbgr.xm47_u21.nsg13_hv_pmos[factuo]
print @n.xbgr.xm47_u22.nsg13_hv_pmos[w]
print @n.xbgr.xm47_u22.nsg13_hv_pmos[l]
print @n.xbgr.xm47_u22.nsg13_hv_pmos[delvto]
print @n.xbgr.xm47_u22.nsg13_hv_pmos[factuo]
print @n.xbgr.xm47_u23.nsg13_hv_pmos[w]
print @n.xbgr.xm47_u23.nsg13_hv_pmos[l]
print @n.xbgr.xm47_u23.nsg13_hv_pmos[delvto]
print @n.xbgr.xm47_u23.nsg13_hv_pmos[factuo]
print @n.xbgr.xm47_u24.nsg13_hv_pmos[w]
print @n.xbgr.xm47_u24.nsg13_hv_pmos[l]
print @n.xbgr.xm47_u24.nsg13_hv_pmos[delvto]
print @n.xbgr.xm47_u24.nsg13_hv_pmos[factuo]
print @n.xbgr.xm48_u2.nsg13_hv_pmos[w]
print @n.xbgr.xm48_u2.nsg13_hv_pmos[l]
print @n.xbgr.xm48_u2.nsg13_hv_pmos[delvto]
print @n.xbgr.xm48_u2.nsg13_hv_pmos[factuo]
print @n.xbgr.xm48_u3.nsg13_hv_pmos[w]
print @n.xbgr.xm48_u3.nsg13_hv_pmos[l]
print @n.xbgr.xm48_u3.nsg13_hv_pmos[delvto]
print @n.xbgr.xm48_u3.nsg13_hv_pmos[factuo]
print @n.xbgr.xm48_u4.nsg13_hv_pmos[w]
print @n.xbgr.xm48_u4.nsg13_hv_pmos[l]
print @n.xbgr.xm48_u4.nsg13_hv_pmos[delvto]
print @n.xbgr.xm48_u4.nsg13_hv_pmos[factuo]
print @n.xbgr.xm48_u5.nsg13_hv_pmos[w]
print @n.xbgr.xm48_u5.nsg13_hv_pmos[l]
print @n.xbgr.xm48_u5.nsg13_hv_pmos[delvto]
print @n.xbgr.xm48_u5.nsg13_hv_pmos[factuo]
print @n.xbgr.xm48_u6.nsg13_hv_pmos[w]
print @n.xbgr.xm48_u6.nsg13_hv_pmos[l]
print @n.xbgr.xm48_u6.nsg13_hv_pmos[delvto]
print @n.xbgr.xm48_u6.nsg13_hv_pmos[factuo]
print @n.xbgr.xm48_u7.nsg13_hv_pmos[w]
print @n.xbgr.xm48_u7.nsg13_hv_pmos[l]
print @n.xbgr.xm48_u7.nsg13_hv_pmos[delvto]
print @n.xbgr.xm48_u7.nsg13_hv_pmos[factuo]
print @n.xbgr.xm48_u8.nsg13_hv_pmos[w]
print @n.xbgr.xm48_u8.nsg13_hv_pmos[l]
print @n.xbgr.xm48_u8.nsg13_hv_pmos[delvto]
print @n.xbgr.xm48_u8.nsg13_hv_pmos[factuo]
print @n.xbgr.xm48_u9.nsg13_hv_pmos[w]
print @n.xbgr.xm48_u9.nsg13_hv_pmos[l]
print @n.xbgr.xm48_u9.nsg13_hv_pmos[delvto]
print @n.xbgr.xm48_u9.nsg13_hv_pmos[factuo]
print @n.xbgr.xm48_u10.nsg13_hv_pmos[w]
print @n.xbgr.xm48_u10.nsg13_hv_pmos[l]
print @n.xbgr.xm48_u10.nsg13_hv_pmos[delvto]
print @n.xbgr.xm48_u10.nsg13_hv_pmos[factuo]
print @n.xbgr.xm48_u11.nsg13_hv_pmos[w]
print @n.xbgr.xm48_u11.nsg13_hv_pmos[l]
print @n.xbgr.xm48_u11.nsg13_hv_pmos[delvto]
print @n.xbgr.xm48_u11.nsg13_hv_pmos[factuo]
print @n.xbgr.xm48_u12.nsg13_hv_pmos[w]
print @n.xbgr.xm48_u12.nsg13_hv_pmos[l]
print @n.xbgr.xm48_u12.nsg13_hv_pmos[delvto]
print @n.xbgr.xm48_u12.nsg13_hv_pmos[factuo]
print @n.xbgr.xm48_u13.nsg13_hv_pmos[w]
print @n.xbgr.xm48_u13.nsg13_hv_pmos[l]
print @n.xbgr.xm48_u13.nsg13_hv_pmos[delvto]
print @n.xbgr.xm48_u13.nsg13_hv_pmos[factuo]
print @n.xbgr.xm48_u14.nsg13_hv_pmos[w]
print @n.xbgr.xm48_u14.nsg13_hv_pmos[l]
print @n.xbgr.xm48_u14.nsg13_hv_pmos[delvto]
print @n.xbgr.xm48_u14.nsg13_hv_pmos[factuo]
print @n.xbgr.xm48_u15.nsg13_hv_pmos[w]
print @n.xbgr.xm48_u15.nsg13_hv_pmos[l]
print @n.xbgr.xm48_u15.nsg13_hv_pmos[delvto]
print @n.xbgr.xm48_u15.nsg13_hv_pmos[factuo]
print @n.xbgr.xm48_u16.nsg13_hv_pmos[w]
print @n.xbgr.xm48_u16.nsg13_hv_pmos[l]
print @n.xbgr.xm48_u16.nsg13_hv_pmos[delvto]
print @n.xbgr.xm48_u16.nsg13_hv_pmos[factuo]
print @n.xbgr.xm48_u17.nsg13_hv_pmos[w]
print @n.xbgr.xm48_u17.nsg13_hv_pmos[l]
print @n.xbgr.xm48_u17.nsg13_hv_pmos[delvto]
print @n.xbgr.xm48_u17.nsg13_hv_pmos[factuo]
print @n.xbgr.xm48_u18.nsg13_hv_pmos[w]
print @n.xbgr.xm48_u18.nsg13_hv_pmos[l]
print @n.xbgr.xm48_u18.nsg13_hv_pmos[delvto]
print @n.xbgr.xm48_u18.nsg13_hv_pmos[factuo]
print @n.xbgr.xm48_u19.nsg13_hv_pmos[w]
print @n.xbgr.xm48_u19.nsg13_hv_pmos[l]
print @n.xbgr.xm48_u19.nsg13_hv_pmos[delvto]
print @n.xbgr.xm48_u19.nsg13_hv_pmos[factuo]
print @n.xbgr.xm48_u20.nsg13_hv_pmos[w]
print @n.xbgr.xm48_u20.nsg13_hv_pmos[l]
print @n.xbgr.xm48_u20.nsg13_hv_pmos[delvto]
print @n.xbgr.xm48_u20.nsg13_hv_pmos[factuo]
print @n.xbgr.xm48_u21.nsg13_hv_pmos[w]
print @n.xbgr.xm48_u21.nsg13_hv_pmos[l]
print @n.xbgr.xm48_u21.nsg13_hv_pmos[delvto]
print @n.xbgr.xm48_u21.nsg13_hv_pmos[factuo]
print @n.xbgr.xm48_u22.nsg13_hv_pmos[w]
print @n.xbgr.xm48_u22.nsg13_hv_pmos[l]
print @n.xbgr.xm48_u22.nsg13_hv_pmos[delvto]
print @n.xbgr.xm48_u22.nsg13_hv_pmos[factuo]
print @n.xbgr.xm48_u23.nsg13_hv_pmos[w]
print @n.xbgr.xm48_u23.nsg13_hv_pmos[l]
print @n.xbgr.xm48_u23.nsg13_hv_pmos[delvto]
print @n.xbgr.xm48_u23.nsg13_hv_pmos[factuo]
print @n.xbgr.xm48_u24.nsg13_hv_pmos[w]
print @n.xbgr.xm48_u24.nsg13_hv_pmos[l]
print @n.xbgr.xm48_u24.nsg13_hv_pmos[delvto]
print @n.xbgr.xm48_u24.nsg13_hv_pmos[factuo]
print @n.xbgr.xm50_u2.nsg13_hv_pmos[w]
print @n.xbgr.xm50_u2.nsg13_hv_pmos[l]
print @n.xbgr.xm50_u2.nsg13_hv_pmos[delvto]
print @n.xbgr.xm50_u2.nsg13_hv_pmos[factuo]
print @n.xbgr.xm50_u3.nsg13_hv_pmos[w]
print @n.xbgr.xm50_u3.nsg13_hv_pmos[l]
print @n.xbgr.xm50_u3.nsg13_hv_pmos[delvto]
print @n.xbgr.xm50_u3.nsg13_hv_pmos[factuo]
print @n.xbgr.xm50_u4.nsg13_hv_pmos[w]
print @n.xbgr.xm50_u4.nsg13_hv_pmos[l]
print @n.xbgr.xm50_u4.nsg13_hv_pmos[delvto]
print @n.xbgr.xm50_u4.nsg13_hv_pmos[factuo]
print @n.xbgr.xm50_u5.nsg13_hv_pmos[w]
print @n.xbgr.xm50_u5.nsg13_hv_pmos[l]
print @n.xbgr.xm50_u5.nsg13_hv_pmos[delvto]
print @n.xbgr.xm50_u5.nsg13_hv_pmos[factuo]
print @n.xbgr.xm50_u6.nsg13_hv_pmos[w]
print @n.xbgr.xm50_u6.nsg13_hv_pmos[l]
print @n.xbgr.xm50_u6.nsg13_hv_pmos[delvto]
print @n.xbgr.xm50_u6.nsg13_hv_pmos[factuo]
print @n.xbgr.xm50_u7.nsg13_hv_pmos[w]
print @n.xbgr.xm50_u7.nsg13_hv_pmos[l]
print @n.xbgr.xm50_u7.nsg13_hv_pmos[delvto]
print @n.xbgr.xm50_u7.nsg13_hv_pmos[factuo]
print @n.xbgr.xm50_u8.nsg13_hv_pmos[w]
print @n.xbgr.xm50_u8.nsg13_hv_pmos[l]
print @n.xbgr.xm50_u8.nsg13_hv_pmos[delvto]
print @n.xbgr.xm50_u8.nsg13_hv_pmos[factuo]
print @n.xbgr.xm50_u9.nsg13_hv_pmos[w]
print @n.xbgr.xm50_u9.nsg13_hv_pmos[l]
print @n.xbgr.xm50_u9.nsg13_hv_pmos[delvto]
print @n.xbgr.xm50_u9.nsg13_hv_pmos[factuo]
print @n.xbgr.xm50_u10.nsg13_hv_pmos[w]
print @n.xbgr.xm50_u10.nsg13_hv_pmos[l]
print @n.xbgr.xm50_u10.nsg13_hv_pmos[delvto]
print @n.xbgr.xm50_u10.nsg13_hv_pmos[factuo]
print @n.xbgr.xm50_u11.nsg13_hv_pmos[w]
print @n.xbgr.xm50_u11.nsg13_hv_pmos[l]
print @n.xbgr.xm50_u11.nsg13_hv_pmos[delvto]
print @n.xbgr.xm50_u11.nsg13_hv_pmos[factuo]
print @n.xbgr.xm50_u12.nsg13_hv_pmos[w]
print @n.xbgr.xm50_u12.nsg13_hv_pmos[l]
print @n.xbgr.xm50_u12.nsg13_hv_pmos[delvto]
print @n.xbgr.xm50_u12.nsg13_hv_pmos[factuo]
print @n.xbgr.xm50_u13.nsg13_hv_pmos[w]
print @n.xbgr.xm50_u13.nsg13_hv_pmos[l]
print @n.xbgr.xm50_u13.nsg13_hv_pmos[delvto]
print @n.xbgr.xm50_u13.nsg13_hv_pmos[factuo]
print @n.xbgr.xm50_u14.nsg13_hv_pmos[w]
print @n.xbgr.xm50_u14.nsg13_hv_pmos[l]
print @n.xbgr.xm50_u14.nsg13_hv_pmos[delvto]
print @n.xbgr.xm50_u14.nsg13_hv_pmos[factuo]
print @n.xbgr.xm50_u15.nsg13_hv_pmos[w]
print @n.xbgr.xm50_u15.nsg13_hv_pmos[l]
print @n.xbgr.xm50_u15.nsg13_hv_pmos[delvto]
print @n.xbgr.xm50_u15.nsg13_hv_pmos[factuo]
print @n.xbgr.xm50_u16.nsg13_hv_pmos[w]
print @n.xbgr.xm50_u16.nsg13_hv_pmos[l]
print @n.xbgr.xm50_u16.nsg13_hv_pmos[delvto]
print @n.xbgr.xm50_u16.nsg13_hv_pmos[factuo]
print @n.xbgr.xm50_u17.nsg13_hv_pmos[w]
print @n.xbgr.xm50_u17.nsg13_hv_pmos[l]
print @n.xbgr.xm50_u17.nsg13_hv_pmos[delvto]
print @n.xbgr.xm50_u17.nsg13_hv_pmos[factuo]
print @n.xbgr.xm50_u18.nsg13_hv_pmos[w]
print @n.xbgr.xm50_u18.nsg13_hv_pmos[l]
print @n.xbgr.xm50_u18.nsg13_hv_pmos[delvto]
print @n.xbgr.xm50_u18.nsg13_hv_pmos[factuo]
print @n.xbgr.xm50_u19.nsg13_hv_pmos[w]
print @n.xbgr.xm50_u19.nsg13_hv_pmos[l]
print @n.xbgr.xm50_u19.nsg13_hv_pmos[delvto]
print @n.xbgr.xm50_u19.nsg13_hv_pmos[factuo]
print @n.xbgr.xm50_u20.nsg13_hv_pmos[w]
print @n.xbgr.xm50_u20.nsg13_hv_pmos[l]
print @n.xbgr.xm50_u20.nsg13_hv_pmos[delvto]
print @n.xbgr.xm50_u20.nsg13_hv_pmos[factuo]
print @n.xbgr.xm50_u21.nsg13_hv_pmos[w]
print @n.xbgr.xm50_u21.nsg13_hv_pmos[l]
print @n.xbgr.xm50_u21.nsg13_hv_pmos[delvto]
print @n.xbgr.xm50_u21.nsg13_hv_pmos[factuo]
print @n.xbgr.xm50_u22.nsg13_hv_pmos[w]
print @n.xbgr.xm50_u22.nsg13_hv_pmos[l]
print @n.xbgr.xm50_u22.nsg13_hv_pmos[delvto]
print @n.xbgr.xm50_u22.nsg13_hv_pmos[factuo]
print @n.xbgr.xm50_u23.nsg13_hv_pmos[w]
print @n.xbgr.xm50_u23.nsg13_hv_pmos[l]
print @n.xbgr.xm50_u23.nsg13_hv_pmos[delvto]
print @n.xbgr.xm50_u23.nsg13_hv_pmos[factuo]
print @n.xbgr.xm50_u24.nsg13_hv_pmos[w]
print @n.xbgr.xm50_u24.nsg13_hv_pmos[l]
print @n.xbgr.xm50_u24.nsg13_hv_pmos[delvto]
print @n.xbgr.xm50_u24.nsg13_hv_pmos[factuo]
print @n.xbgr.xm51_u2.nsg13_hv_pmos[w]
print @n.xbgr.xm51_u2.nsg13_hv_pmos[l]
print @n.xbgr.xm51_u2.nsg13_hv_pmos[delvto]
print @n.xbgr.xm51_u2.nsg13_hv_pmos[factuo]
print @n.xbgr.xm51_u3.nsg13_hv_pmos[w]
print @n.xbgr.xm51_u3.nsg13_hv_pmos[l]
print @n.xbgr.xm51_u3.nsg13_hv_pmos[delvto]
print @n.xbgr.xm51_u3.nsg13_hv_pmos[factuo]
print @n.xbgr.xm51_u4.nsg13_hv_pmos[w]
print @n.xbgr.xm51_u4.nsg13_hv_pmos[l]
print @n.xbgr.xm51_u4.nsg13_hv_pmos[delvto]
print @n.xbgr.xm51_u4.nsg13_hv_pmos[factuo]
print @n.xbgr.xm52_u2.nsg13_hv_pmos[w]
print @n.xbgr.xm52_u2.nsg13_hv_pmos[l]
print @n.xbgr.xm52_u2.nsg13_hv_pmos[delvto]
print @n.xbgr.xm52_u2.nsg13_hv_pmos[factuo]
print @n.xbgr.xm52_u3.nsg13_hv_pmos[w]
print @n.xbgr.xm52_u3.nsg13_hv_pmos[l]
print @n.xbgr.xm52_u3.nsg13_hv_pmos[delvto]
print @n.xbgr.xm52_u3.nsg13_hv_pmos[factuo]
print @n.xbgr.xm52_u4.nsg13_hv_pmos[w]
print @n.xbgr.xm52_u4.nsg13_hv_pmos[l]
print @n.xbgr.xm52_u4.nsg13_hv_pmos[delvto]
print @n.xbgr.xm52_u4.nsg13_hv_pmos[factuo]
print @n.xbgr.xm52_u5.nsg13_hv_pmos[w]
print @n.xbgr.xm52_u5.nsg13_hv_pmos[l]
print @n.xbgr.xm52_u5.nsg13_hv_pmos[delvto]
print @n.xbgr.xm52_u5.nsg13_hv_pmos[factuo]
print @n.xbgr.xm52_u6.nsg13_hv_pmos[w]
print @n.xbgr.xm52_u6.nsg13_hv_pmos[l]
print @n.xbgr.xm52_u6.nsg13_hv_pmos[delvto]
print @n.xbgr.xm52_u6.nsg13_hv_pmos[factuo]
print @n.xbgr.xm52_u7.nsg13_hv_pmos[w]
print @n.xbgr.xm52_u7.nsg13_hv_pmos[l]
print @n.xbgr.xm52_u7.nsg13_hv_pmos[delvto]
print @n.xbgr.xm52_u7.nsg13_hv_pmos[factuo]
print @n.xbgr.xm52_u8.nsg13_hv_pmos[w]
print @n.xbgr.xm52_u8.nsg13_hv_pmos[l]
print @n.xbgr.xm52_u8.nsg13_hv_pmos[delvto]
print @n.xbgr.xm52_u8.nsg13_hv_pmos[factuo]
print @n.xbgr.xm52_u9.nsg13_hv_pmos[w]
print @n.xbgr.xm52_u9.nsg13_hv_pmos[l]
print @n.xbgr.xm52_u9.nsg13_hv_pmos[delvto]
print @n.xbgr.xm52_u9.nsg13_hv_pmos[factuo]
print @n.xbgr.xm52_u10.nsg13_hv_pmos[w]
print @n.xbgr.xm52_u10.nsg13_hv_pmos[l]
print @n.xbgr.xm52_u10.nsg13_hv_pmos[delvto]
print @n.xbgr.xm52_u10.nsg13_hv_pmos[factuo]
print @n.xbgr.xm52_u11.nsg13_hv_pmos[w]
print @n.xbgr.xm52_u11.nsg13_hv_pmos[l]
print @n.xbgr.xm52_u11.nsg13_hv_pmos[delvto]
print @n.xbgr.xm52_u11.nsg13_hv_pmos[factuo]
print @n.xbgr.xm52_u12.nsg13_hv_pmos[w]
print @n.xbgr.xm52_u12.nsg13_hv_pmos[l]
print @n.xbgr.xm52_u12.nsg13_hv_pmos[delvto]
print @n.xbgr.xm52_u12.nsg13_hv_pmos[factuo]
print @n.xbgr.xm52_u13.nsg13_hv_pmos[w]
print @n.xbgr.xm52_u13.nsg13_hv_pmos[l]
print @n.xbgr.xm52_u13.nsg13_hv_pmos[delvto]
print @n.xbgr.xm52_u13.nsg13_hv_pmos[factuo]
print @n.xbgr.xm52_u14.nsg13_hv_pmos[w]
print @n.xbgr.xm52_u14.nsg13_hv_pmos[l]
print @n.xbgr.xm52_u14.nsg13_hv_pmos[delvto]
print @n.xbgr.xm52_u14.nsg13_hv_pmos[factuo]
print @n.xbgr.xm52_u15.nsg13_hv_pmos[w]
print @n.xbgr.xm52_u15.nsg13_hv_pmos[l]
print @n.xbgr.xm52_u15.nsg13_hv_pmos[delvto]
print @n.xbgr.xm52_u15.nsg13_hv_pmos[factuo]
print @n.xbgr.xm52_u16.nsg13_hv_pmos[w]
print @n.xbgr.xm52_u16.nsg13_hv_pmos[l]
print @n.xbgr.xm52_u16.nsg13_hv_pmos[delvto]
print @n.xbgr.xm52_u16.nsg13_hv_pmos[factuo]
print @n.xbgr.xm52_u17.nsg13_hv_pmos[w]
print @n.xbgr.xm52_u17.nsg13_hv_pmos[l]
print @n.xbgr.xm52_u17.nsg13_hv_pmos[delvto]
print @n.xbgr.xm52_u17.nsg13_hv_pmos[factuo]
print @n.xbgr.xm52_u18.nsg13_hv_pmos[w]
print @n.xbgr.xm52_u18.nsg13_hv_pmos[l]
print @n.xbgr.xm52_u18.nsg13_hv_pmos[delvto]
print @n.xbgr.xm52_u18.nsg13_hv_pmos[factuo]
print @n.xbgr.xm52_u19.nsg13_hv_pmos[w]
print @n.xbgr.xm52_u19.nsg13_hv_pmos[l]
print @n.xbgr.xm52_u19.nsg13_hv_pmos[delvto]
print @n.xbgr.xm52_u19.nsg13_hv_pmos[factuo]
print @n.xbgr.xm52_u20.nsg13_hv_pmos[w]
print @n.xbgr.xm52_u20.nsg13_hv_pmos[l]
print @n.xbgr.xm52_u20.nsg13_hv_pmos[delvto]
print @n.xbgr.xm52_u20.nsg13_hv_pmos[factuo]
print @n.xbgr.xm52_u21.nsg13_hv_pmos[w]
print @n.xbgr.xm52_u21.nsg13_hv_pmos[l]
print @n.xbgr.xm52_u21.nsg13_hv_pmos[delvto]
print @n.xbgr.xm52_u21.nsg13_hv_pmos[factuo]
print @n.xbgr.xm52_u22.nsg13_hv_pmos[w]
print @n.xbgr.xm52_u22.nsg13_hv_pmos[l]
print @n.xbgr.xm52_u22.nsg13_hv_pmos[delvto]
print @n.xbgr.xm52_u22.nsg13_hv_pmos[factuo]
print @n.xbgr.xm52_u23.nsg13_hv_pmos[w]
print @n.xbgr.xm52_u23.nsg13_hv_pmos[l]
print @n.xbgr.xm52_u23.nsg13_hv_pmos[delvto]
print @n.xbgr.xm52_u23.nsg13_hv_pmos[factuo]
print @n.xbgr.xm52_u24.nsg13_hv_pmos[w]
print @n.xbgr.xm52_u24.nsg13_hv_pmos[l]
print @n.xbgr.xm52_u24.nsg13_hv_pmos[delvto]
print @n.xbgr.xm52_u24.nsg13_hv_pmos[factuo]
print @n.xbgr.xm54_u2.nsg13_hv_pmos[w]
print @n.xbgr.xm54_u2.nsg13_hv_pmos[l]
print @n.xbgr.xm54_u2.nsg13_hv_pmos[delvto]
print @n.xbgr.xm54_u2.nsg13_hv_pmos[factuo]
print @n.xbgr.xm54_u3.nsg13_hv_pmos[w]
print @n.xbgr.xm54_u3.nsg13_hv_pmos[l]
print @n.xbgr.xm54_u3.nsg13_hv_pmos[delvto]
print @n.xbgr.xm54_u3.nsg13_hv_pmos[factuo]
print @n.xbgr.xm54_u4.nsg13_hv_pmos[w]
print @n.xbgr.xm54_u4.nsg13_hv_pmos[l]
print @n.xbgr.xm54_u4.nsg13_hv_pmos[delvto]
print @n.xbgr.xm54_u4.nsg13_hv_pmos[factuo]
print @n.xbgr.xm54_u5.nsg13_hv_pmos[w]
print @n.xbgr.xm54_u5.nsg13_hv_pmos[l]
print @n.xbgr.xm54_u5.nsg13_hv_pmos[delvto]
print @n.xbgr.xm54_u5.nsg13_hv_pmos[factuo]
print @n.xbgr.xm54_u6.nsg13_hv_pmos[w]
print @n.xbgr.xm54_u6.nsg13_hv_pmos[l]
print @n.xbgr.xm54_u6.nsg13_hv_pmos[delvto]
print @n.xbgr.xm54_u6.nsg13_hv_pmos[factuo]
print @n.xbgr.xm54_u7.nsg13_hv_pmos[w]
print @n.xbgr.xm54_u7.nsg13_hv_pmos[l]
print @n.xbgr.xm54_u7.nsg13_hv_pmos[delvto]
print @n.xbgr.xm54_u7.nsg13_hv_pmos[factuo]
print @n.xbgr.xm54_u8.nsg13_hv_pmos[w]
print @n.xbgr.xm54_u8.nsg13_hv_pmos[l]
print @n.xbgr.xm54_u8.nsg13_hv_pmos[delvto]
print @n.xbgr.xm54_u8.nsg13_hv_pmos[factuo]
print @n.xbgr.xm54_u9.nsg13_hv_pmos[w]
print @n.xbgr.xm54_u9.nsg13_hv_pmos[l]
print @n.xbgr.xm54_u9.nsg13_hv_pmos[delvto]
print @n.xbgr.xm54_u9.nsg13_hv_pmos[factuo]
print @n.xbgr.xm54_u10.nsg13_hv_pmos[w]
print @n.xbgr.xm54_u10.nsg13_hv_pmos[l]
print @n.xbgr.xm54_u10.nsg13_hv_pmos[delvto]
print @n.xbgr.xm54_u10.nsg13_hv_pmos[factuo]
print @n.xbgr.xm54_u11.nsg13_hv_pmos[w]
print @n.xbgr.xm54_u11.nsg13_hv_pmos[l]
print @n.xbgr.xm54_u11.nsg13_hv_pmos[delvto]
print @n.xbgr.xm54_u11.nsg13_hv_pmos[factuo]
print @n.xbgr.xm54_u12.nsg13_hv_pmos[w]
print @n.xbgr.xm54_u12.nsg13_hv_pmos[l]
print @n.xbgr.xm54_u12.nsg13_hv_pmos[delvto]
print @n.xbgr.xm54_u12.nsg13_hv_pmos[factuo]
print @n.xbgr.xm54_u13.nsg13_hv_pmos[w]
print @n.xbgr.xm54_u13.nsg13_hv_pmos[l]
print @n.xbgr.xm54_u13.nsg13_hv_pmos[delvto]
print @n.xbgr.xm54_u13.nsg13_hv_pmos[factuo]
print @n.xbgr.xm54_u14.nsg13_hv_pmos[w]
print @n.xbgr.xm54_u14.nsg13_hv_pmos[l]
print @n.xbgr.xm54_u14.nsg13_hv_pmos[delvto]
print @n.xbgr.xm54_u14.nsg13_hv_pmos[factuo]
print @n.xbgr.xm54_u15.nsg13_hv_pmos[w]
print @n.xbgr.xm54_u15.nsg13_hv_pmos[l]
print @n.xbgr.xm54_u15.nsg13_hv_pmos[delvto]
print @n.xbgr.xm54_u15.nsg13_hv_pmos[factuo]
print @n.xbgr.xm54_u16.nsg13_hv_pmos[w]
print @n.xbgr.xm54_u16.nsg13_hv_pmos[l]
print @n.xbgr.xm54_u16.nsg13_hv_pmos[delvto]
print @n.xbgr.xm54_u16.nsg13_hv_pmos[factuo]
print @n.xbgr.xm54_u17.nsg13_hv_pmos[w]
print @n.xbgr.xm54_u17.nsg13_hv_pmos[l]
print @n.xbgr.xm54_u17.nsg13_hv_pmos[delvto]
print @n.xbgr.xm54_u17.nsg13_hv_pmos[factuo]
print @n.xbgr.xm54_u18.nsg13_hv_pmos[w]
print @n.xbgr.xm54_u18.nsg13_hv_pmos[l]
print @n.xbgr.xm54_u18.nsg13_hv_pmos[delvto]
print @n.xbgr.xm54_u18.nsg13_hv_pmos[factuo]
print @n.xbgr.xm54_u19.nsg13_hv_pmos[w]
print @n.xbgr.xm54_u19.nsg13_hv_pmos[l]
print @n.xbgr.xm54_u19.nsg13_hv_pmos[delvto]
print @n.xbgr.xm54_u19.nsg13_hv_pmos[factuo]
print @n.xbgr.xm54_u20.nsg13_hv_pmos[w]
print @n.xbgr.xm54_u20.nsg13_hv_pmos[l]
print @n.xbgr.xm54_u20.nsg13_hv_pmos[delvto]
print @n.xbgr.xm54_u20.nsg13_hv_pmos[factuo]
print @n.xbgr.xm54_u21.nsg13_hv_pmos[w]
print @n.xbgr.xm54_u21.nsg13_hv_pmos[l]
print @n.xbgr.xm54_u21.nsg13_hv_pmos[delvto]
print @n.xbgr.xm54_u21.nsg13_hv_pmos[factuo]
print @n.xbgr.xm54_u22.nsg13_hv_pmos[w]
print @n.xbgr.xm54_u22.nsg13_hv_pmos[l]
print @n.xbgr.xm54_u22.nsg13_hv_pmos[delvto]
print @n.xbgr.xm54_u22.nsg13_hv_pmos[factuo]
print @n.xbgr.xm54_u23.nsg13_hv_pmos[w]
print @n.xbgr.xm54_u23.nsg13_hv_pmos[l]
print @n.xbgr.xm54_u23.nsg13_hv_pmos[delvto]
print @n.xbgr.xm54_u23.nsg13_hv_pmos[factuo]
print @n.xbgr.xm54_u24.nsg13_hv_pmos[w]
print @n.xbgr.xm54_u24.nsg13_hv_pmos[l]
print @n.xbgr.xm54_u24.nsg13_hv_pmos[delvto]
print @n.xbgr.xm54_u24.nsg13_hv_pmos[factuo]
print @q.xbgr.xq56_u2.qnpn13g2[area]
print @q.xbgr.xq56_u3.qnpn13g2[area]
print @q.xbgr.xq56_u4.qnpn13g2[area]
print @q.xbgr.xq56_u5.qnpn13g2[area]
print @q.xbgr.xq56_u6.qnpn13g2[area]
print @q.xbgr.xq56_u7.qnpn13g2[area]
print @q.xbgr.xq56_u8.qnpn13g2[area]
print @q.xbgr.xq56_u9.qnpn13g2[area]
print @q.xbgr.xq56_u10.qnpn13g2[area]
print @q.xbgr.xq56_u11.qnpn13g2[area]
print @q.xbgr.xq56_u12.qnpn13g2[area]
print @q.xbgr.xq56_u13.qnpn13g2[area]
print @q.xbgr.xq56_u14.qnpn13g2[area]
print @q.xbgr.xq56_u15.qnpn13g2[area]
print @q.xbgr.xq56_u16.qnpn13g2[area]
print @q.xbgr.xq56_u17.qnpn13g2[area]
print @q.xbgr.xq56_u18.qnpn13g2[area]
print @q.xbgr.xq56_u19.qnpn13g2[area]
print @q.xbgr.xq56_u20.qnpn13g2[area]
print @q.xbgr.xq56_u21.qnpn13g2[area]
print @q.xbgr.xq56_u22.qnpn13g2[area]
print @q.xbgr.xq56_u23.qnpn13g2[area]
print @q.xbgr.xq56_u24.qnpn13g2[area]
print @q.xbgr.xq60_u2.qnpn13g2[area]
print @q.xbgr.xq60_u3.qnpn13g2[area]
print @q.xbgr.xq60_u4.qnpn13g2[area]
print @q.xbgr.xq62_u2.qnpn13g2[area]
print @q.xbgr.xq62_u3.qnpn13g2[area]
print @q.xbgr.xq62_u4.qnpn13g2[area]
print @q.xbgr.xq62_u5.qnpn13g2[area]
print @q.xbgr.xq62_u6.qnpn13g2[area]
print @q.xbgr.xq62_u7.qnpn13g2[area]
print @q.xbgr.xq62_u8.qnpn13g2[area]
print @q.xbgr.xq62_u9.qnpn13g2[area]
print @q.xbgr.xq62_u10.qnpn13g2[area]
print @q.xbgr.xq62_u11.qnpn13g2[area]
print @q.xbgr.xq62_u12.qnpn13g2[area]
print @q.xbgr.xq62_u13.qnpn13g2[area]
print @q.xbgr.xq62_u14.qnpn13g2[area]
print @q.xbgr.xq62_u15.qnpn13g2[area]
print @q.xbgr.xq62_u16.qnpn13g2[area]
print @q.xbgr.xq62_u17.qnpn13g2[area]
print @q.xbgr.xq62_u18.qnpn13g2[area]
print @q.xbgr.xq62_u19.qnpn13g2[area]
print @q.xbgr.xq62_u20.qnpn13g2[area]
print @q.xbgr.xq62_u21.qnpn13g2[area]
print @q.xbgr.xq62_u22.qnpn13g2[area]
print @q.xbgr.xq62_u23.qnpn13g2[area]
print @q.xbgr.xq62_u24.qnpn13g2[area]
print @q.xbgr.xq67_u2.qnpn13g2[area]
print @q.xbgr.xq67_u3.qnpn13g2[area]
print @q.xbgr.xq67_u4.qnpn13g2[area]
print @q.xbgr.xq67_u5.qnpn13g2[area]
print @q.xbgr.xq67_u6.qnpn13g2[area]
print @q.xbgr.xq67_u7.qnpn13g2[area]
print @q.xbgr.xq67_u8.qnpn13g2[area]
print @q.xbgr.xq67_u9.qnpn13g2[area]
print @q.xbgr.xq67_u10.qnpn13g2[area]
print @q.xbgr.xq67_u11.qnpn13g2[area]
print @q.xbgr.xq67_u12.qnpn13g2[area]
print @q.xbgr.xq67_u13.qnpn13g2[area]
print @q.xbgr.xq67_u14.qnpn13g2[area]
print @q.xbgr.xq67_u15.qnpn13g2[area]
print @q.xbgr.xq67_u16.qnpn13g2[area]
print @q.xbgr.xq67_u17.qnpn13g2[area]
print @q.xbgr.xq67_u18.qnpn13g2[area]
print @q.xbgr.xq67_u19.qnpn13g2[area]
print @q.xbgr.xq67_u20.qnpn13g2[area]
print @q.xbgr.xq67_u21.qnpn13g2[area]
print @q.xbgr.xq67_u22.qnpn13g2[area]
print @q.xbgr.xq67_u23.qnpn13g2[area]
print @q.xbgr.xq67_u24.qnpn13g2[area]
print @q.xbgr.xq68_u2.qnpn13g2[area]
print @q.xbgr.xq68_u3.qnpn13g2[area]
print @q.xbgr.xq68_u4.qnpn13g2[area]
print @q.xbgr.xq68_u5.qnpn13g2[area]
print @q.xbgr.xq68_u6.qnpn13g2[area]
print @q.xbgr.xq68_u7.qnpn13g2[area]
print @q.xbgr.xq68_u8.qnpn13g2[area]
print @q.xbgr.xq68_u9.qnpn13g2[area]
print @q.xbgr.xq68_u10.qnpn13g2[area]
print @q.xbgr.xq68_u11.qnpn13g2[area]
print @q.xbgr.xq68_u12.qnpn13g2[area]
print @q.xbgr.xq68_u13.qnpn13g2[area]
print @q.xbgr.xq68_u14.qnpn13g2[area]
print @q.xbgr.xq68_u15.qnpn13g2[area]
print @q.xbgr.xq68_u16.qnpn13g2[area]
print @q.xbgr.xq68_u17.qnpn13g2[area]
print @q.xbgr.xq68_u18.qnpn13g2[area]
print @q.xbgr.xq68_u19.qnpn13g2[area]
print @q.xbgr.xq68_u20.qnpn13g2[area]
print @q.xbgr.xq68_u21.qnpn13g2[area]
print @q.xbgr.xq68_u22.qnpn13g2[area]
print @q.xbgr.xq68_u23.qnpn13g2[area]
print @q.xbgr.xq68_u24.qnpn13g2[area]
print @q.xbgr.xq69_u2.qnpn13g2[area]
print @q.xbgr.xq69_u3.qnpn13g2[area]
print @q.xbgr.xq69_u4.qnpn13g2[area]
print @q.xbgr.xq69_u5.qnpn13g2[area]
print @q.xbgr.xq69_u6.qnpn13g2[area]
print @q.xbgr.xq69_u7.qnpn13g2[area]
print @q.xbgr.xq69_u8.qnpn13g2[area]
print @q.xbgr.xq69_u9.qnpn13g2[area]
print @q.xbgr.xq69_u10.qnpn13g2[area]
print @q.xbgr.xq69_u11.qnpn13g2[area]
print @q.xbgr.xq69_u12.qnpn13g2[area]
print @q.xbgr.xq69_u13.qnpn13g2[area]
print @q.xbgr.xq69_u14.qnpn13g2[area]
print @q.xbgr.xq69_u15.qnpn13g2[area]
print @q.xbgr.xq69_u16.qnpn13g2[area]
print @q.xbgr.xq69_u17.qnpn13g2[area]
print @q.xbgr.xq69_u18.qnpn13g2[area]
print @q.xbgr.xq69_u19.qnpn13g2[area]
print @q.xbgr.xq69_u20.qnpn13g2[area]
print @q.xbgr.xq69_u21.qnpn13g2[area]
print @q.xbgr.xq69_u22.qnpn13g2[area]
print @q.xbgr.xq69_u23.qnpn13g2[area]
print @q.xbgr.xq69_u24.qnpn13g2[area]
print @q.xbgr.xq70_u2.qnpn13g2[area]
print @q.xbgr.xq70_u3.qnpn13g2[area]
print @q.xbgr.xq70_u4.qnpn13g2[area]
print @q.xbgr.xq70_u5.qnpn13g2[area]
print @q.xbgr.xq70_u6.qnpn13g2[area]
print @q.xbgr.xq70_u7.qnpn13g2[area]
print @q.xbgr.xq70_u8.qnpn13g2[area]
print @q.xbgr.xq70_u9.qnpn13g2[area]
print @q.xbgr.xq70_u10.qnpn13g2[area]
print @q.xbgr.xq70_u11.qnpn13g2[area]
print @q.xbgr.xq70_u12.qnpn13g2[area]
print @q.xbgr.xq70_u13.qnpn13g2[area]
print @q.xbgr.xq70_u14.qnpn13g2[area]
print @q.xbgr.xq70_u15.qnpn13g2[area]
print @q.xbgr.xq70_u16.qnpn13g2[area]
print @q.xbgr.xq70_u17.qnpn13g2[area]
print @q.xbgr.xq70_u18.qnpn13g2[area]
print @q.xbgr.xq70_u19.qnpn13g2[area]
print @q.xbgr.xq70_u20.qnpn13g2[area]
print @q.xbgr.xq70_u21.qnpn13g2[area]
print @q.xbgr.xq70_u22.qnpn13g2[area]
print @q.xbgr.xq70_u23.qnpn13g2[area]
print @q.xbgr.xq70_u24.qnpn13g2[area]
print @q.xbgr.xq71_u2.qnpn13g2[area]
print @q.xbgr.xq71_u3.qnpn13g2[area]
print @q.xbgr.xq71_u4.qnpn13g2[area]
print @q.xbgr.xq71_u5.qnpn13g2[area]
print @q.xbgr.xq71_u6.qnpn13g2[area]
print @q.xbgr.xq71_u7.qnpn13g2[area]
print @q.xbgr.xq71_u8.qnpn13g2[area]
print @q.xbgr.xq71_u9.qnpn13g2[area]
print @q.xbgr.xq71_u10.qnpn13g2[area]
print @q.xbgr.xq71_u11.qnpn13g2[area]
print @q.xbgr.xq71_u12.qnpn13g2[area]
print @q.xbgr.xq71_u13.qnpn13g2[area]
print @q.xbgr.xq71_u14.qnpn13g2[area]
print @q.xbgr.xq71_u15.qnpn13g2[area]
print @q.xbgr.xq71_u16.qnpn13g2[area]
print @q.xbgr.xq71_u17.qnpn13g2[area]
print @q.xbgr.xq71_u18.qnpn13g2[area]
print @q.xbgr.xq71_u19.qnpn13g2[area]
print @q.xbgr.xq71_u20.qnpn13g2[area]
print @q.xbgr.xq71_u21.qnpn13g2[area]
print @q.xbgr.xq71_u22.qnpn13g2[area]
print @q.xbgr.xq71_u23.qnpn13g2[area]
print @q.xbgr.xq71_u24.qnpn13g2[area]
print @q.xbgr.xq72_u2.qnpn13g2[area]
print @q.xbgr.xq72_u3.qnpn13g2[area]
print @q.xbgr.xq72_u4.qnpn13g2[area]
print @q.xbgr.xq72_u5.qnpn13g2[area]
print @q.xbgr.xq72_u6.qnpn13g2[area]
print @q.xbgr.xq72_u7.qnpn13g2[area]
print @q.xbgr.xq72_u8.qnpn13g2[area]
print @q.xbgr.xq72_u9.qnpn13g2[area]
print @q.xbgr.xq72_u10.qnpn13g2[area]
print @q.xbgr.xq72_u11.qnpn13g2[area]
print @q.xbgr.xq72_u12.qnpn13g2[area]
print @q.xbgr.xq72_u13.qnpn13g2[area]
print @q.xbgr.xq72_u14.qnpn13g2[area]
print @q.xbgr.xq72_u15.qnpn13g2[area]
print @q.xbgr.xq72_u16.qnpn13g2[area]
print @q.xbgr.xq72_u17.qnpn13g2[area]
print @q.xbgr.xq72_u18.qnpn13g2[area]
print @q.xbgr.xq72_u19.qnpn13g2[area]
print @q.xbgr.xq72_u20.qnpn13g2[area]
print @q.xbgr.xq72_u21.qnpn13g2[area]
print @q.xbgr.xq72_u22.qnpn13g2[area]
print @q.xbgr.xq72_u23.qnpn13g2[area]
print @q.xbgr.xq72_u24.qnpn13g2[area]
print @q.xbgr.xq73_u2.qnpn13g2[area]
print @q.xbgr.xq73_u3.qnpn13g2[area]
print @q.xbgr.xq73_u4.qnpn13g2[area]
print @q.xbgr.xq73_u5.qnpn13g2[area]
print @q.xbgr.xq73_u6.qnpn13g2[area]
print @q.xbgr.xq73_u7.qnpn13g2[area]
print @q.xbgr.xq73_u8.qnpn13g2[area]
print @q.xbgr.xq73_u9.qnpn13g2[area]
print @q.xbgr.xq73_u10.qnpn13g2[area]
print @q.xbgr.xq73_u11.qnpn13g2[area]
print @q.xbgr.xq73_u12.qnpn13g2[area]
print @q.xbgr.xq73_u13.qnpn13g2[area]
print @q.xbgr.xq73_u14.qnpn13g2[area]
print @q.xbgr.xq73_u15.qnpn13g2[area]
print @q.xbgr.xq73_u16.qnpn13g2[area]
print @q.xbgr.xq73_u17.qnpn13g2[area]
print @q.xbgr.xq73_u18.qnpn13g2[area]
print @q.xbgr.xq73_u19.qnpn13g2[area]
print @q.xbgr.xq73_u20.qnpn13g2[area]
print @q.xbgr.xq73_u21.qnpn13g2[area]
print @q.xbgr.xq73_u22.qnpn13g2[area]
print @q.xbgr.xq73_u23.qnpn13g2[area]
print @q.xbgr.xq73_u24.qnpn13g2[area]
print @q.xbgr.xq74_u2.qnpn13g2[area]
print @q.xbgr.xq74_u3.qnpn13g2[area]
print @q.xbgr.xq74_u4.qnpn13g2[area]
print @q.xbgr.xq74_u5.qnpn13g2[area]
print @q.xbgr.xq74_u6.qnpn13g2[area]
print @q.xbgr.xq74_u7.qnpn13g2[area]
print @q.xbgr.xq74_u8.qnpn13g2[area]
print @q.xbgr.xq74_u9.qnpn13g2[area]
print @q.xbgr.xq74_u10.qnpn13g2[area]
print @q.xbgr.xq74_u11.qnpn13g2[area]
print @q.xbgr.xq74_u12.qnpn13g2[area]
print @q.xbgr.xq74_u13.qnpn13g2[area]
print @q.xbgr.xq74_u14.qnpn13g2[area]
print @q.xbgr.xq74_u15.qnpn13g2[area]
print @q.xbgr.xq74_u16.qnpn13g2[area]
print @q.xbgr.xq74_u17.qnpn13g2[area]
print @q.xbgr.xq74_u18.qnpn13g2[area]
print @q.xbgr.xq74_u19.qnpn13g2[area]
print @q.xbgr.xq74_u20.qnpn13g2[area]
print @q.xbgr.xq74_u21.qnpn13g2[area]
print @q.xbgr.xq74_u22.qnpn13g2[area]
print @q.xbgr.xq74_u23.qnpn13g2[area]
print @q.xbgr.xq74_u24.qnpn13g2[area]
print @q.xbgr.xq75_u2.qnpn13g2[area]
print @q.xbgr.xq75_u3.qnpn13g2[area]
print @q.xbgr.xq75_u4.qnpn13g2[area]
print @q.xbgr.xq75_u5.qnpn13g2[area]
print @q.xbgr.xq75_u6.qnpn13g2[area]
print @q.xbgr.xq75_u7.qnpn13g2[area]
print @q.xbgr.xq75_u8.qnpn13g2[area]
print @q.xbgr.xq75_u9.qnpn13g2[area]
print @q.xbgr.xq75_u10.qnpn13g2[area]
print @q.xbgr.xq75_u11.qnpn13g2[area]
print @q.xbgr.xq75_u12.qnpn13g2[area]
print @q.xbgr.xq75_u13.qnpn13g2[area]
print @q.xbgr.xq75_u14.qnpn13g2[area]
print @q.xbgr.xq75_u15.qnpn13g2[area]
print @q.xbgr.xq75_u16.qnpn13g2[area]
print @q.xbgr.xq75_u17.qnpn13g2[area]
print @q.xbgr.xq75_u18.qnpn13g2[area]
print @q.xbgr.xq75_u19.qnpn13g2[area]
print @q.xbgr.xq75_u20.qnpn13g2[area]
print @q.xbgr.xq75_u21.qnpn13g2[area]
print @q.xbgr.xq75_u22.qnpn13g2[area]
print @q.xbgr.xq75_u23.qnpn13g2[area]
print @q.xbgr.xq75_u24.qnpn13g2[area]
print @q.xbgr.xq76_u2.qnpn13g2[area]
print @q.xbgr.xq76_u3.qnpn13g2[area]
print @q.xbgr.xq76_u4.qnpn13g2[area]
print @q.xbgr.xq76_u5.qnpn13g2[area]
print @q.xbgr.xq76_u6.qnpn13g2[area]
print @q.xbgr.xq76_u7.qnpn13g2[area]
print @q.xbgr.xq76_u8.qnpn13g2[area]
print @q.xbgr.xq76_u9.qnpn13g2[area]
print @q.xbgr.xq76_u10.qnpn13g2[area]
print @q.xbgr.xq76_u11.qnpn13g2[area]
print @q.xbgr.xq76_u12.qnpn13g2[area]
print @q.xbgr.xq76_u13.qnpn13g2[area]
print @q.xbgr.xq76_u14.qnpn13g2[area]
print @q.xbgr.xq76_u15.qnpn13g2[area]
print @q.xbgr.xq76_u16.qnpn13g2[area]
print @q.xbgr.xq76_u17.qnpn13g2[area]
print @q.xbgr.xq76_u18.qnpn13g2[area]
print @q.xbgr.xq76_u19.qnpn13g2[area]
print @q.xbgr.xq76_u20.qnpn13g2[area]
print @q.xbgr.xq76_u21.qnpn13g2[area]
print @q.xbgr.xq76_u22.qnpn13g2[area]
print @q.xbgr.xq76_u23.qnpn13g2[area]
print @q.xbgr.xq76_u24.qnpn13g2[area]
print @n.xbgr.xr77_u2.nr1[nsmm_rsh]
print @n.xbgr.xr77_u2.nr1[nsmm_w]
print @n.xbgr.xr77_u2.nr1[nsmm_l]
print @n.xbgr.xr77_u3.nr1[nsmm_rsh]
print @n.xbgr.xr77_u3.nr1[nsmm_w]
print @n.xbgr.xr77_u3.nr1[nsmm_l]
print @n.xbgr.xr77_u4.nr1[nsmm_rsh]
print @n.xbgr.xr77_u4.nr1[nsmm_w]
print @n.xbgr.xr77_u4.nr1[nsmm_l]
print @n.xbgr.xr77_u5.nr1[nsmm_rsh]
print @n.xbgr.xr77_u5.nr1[nsmm_w]
print @n.xbgr.xr77_u5.nr1[nsmm_l]
print @n.xbgr.xr77_u6.nr1[nsmm_rsh]
print @n.xbgr.xr77_u6.nr1[nsmm_w]
print @n.xbgr.xr77_u6.nr1[nsmm_l]
print @n.xbgr.xr77_u7.nr1[nsmm_rsh]
print @n.xbgr.xr77_u7.nr1[nsmm_w]
print @n.xbgr.xr77_u7.nr1[nsmm_l]
print @n.xbgr.xr77_u8.nr1[nsmm_rsh]
print @n.xbgr.xr77_u8.nr1[nsmm_w]
print @n.xbgr.xr77_u8.nr1[nsmm_l]
print @n.xbgr.xr77_u9.nr1[nsmm_rsh]
print @n.xbgr.xr77_u9.nr1[nsmm_w]
print @n.xbgr.xr77_u9.nr1[nsmm_l]
print @n.xbgr.xr77_u10.nr1[nsmm_rsh]
print @n.xbgr.xr77_u10.nr1[nsmm_w]
print @n.xbgr.xr77_u10.nr1[nsmm_l]
print @n.xbgr.xr77_u11.nr1[nsmm_rsh]
print @n.xbgr.xr77_u11.nr1[nsmm_w]
print @n.xbgr.xr77_u11.nr1[nsmm_l]
print @n.xbgr.xr77_u12.nr1[nsmm_rsh]
print @n.xbgr.xr77_u12.nr1[nsmm_w]
print @n.xbgr.xr77_u12.nr1[nsmm_l]
print @n.xbgr.xr77_u13.nr1[nsmm_rsh]
print @n.xbgr.xr77_u13.nr1[nsmm_w]
print @n.xbgr.xr77_u13.nr1[nsmm_l]
print @n.xbgr.xr77_u14.nr1[nsmm_rsh]
print @n.xbgr.xr77_u14.nr1[nsmm_w]
print @n.xbgr.xr77_u14.nr1[nsmm_l]
print @n.xbgr.xr77_u15.nr1[nsmm_rsh]
print @n.xbgr.xr77_u15.nr1[nsmm_w]
print @n.xbgr.xr77_u15.nr1[nsmm_l]
print @n.xbgr.xr77_u16.nr1[nsmm_rsh]
print @n.xbgr.xr77_u16.nr1[nsmm_w]
print @n.xbgr.xr77_u16.nr1[nsmm_l]
print @n.xbgr.xr77_u17.nr1[nsmm_rsh]
print @n.xbgr.xr77_u17.nr1[nsmm_w]
print @n.xbgr.xr77_u17.nr1[nsmm_l]
print @n.xbgr.xr77_u18.nr1[nsmm_rsh]
print @n.xbgr.xr77_u18.nr1[nsmm_w]
print @n.xbgr.xr77_u18.nr1[nsmm_l]
print @n.xbgr.xr77_u19.nr1[nsmm_rsh]
print @n.xbgr.xr77_u19.nr1[nsmm_w]
print @n.xbgr.xr77_u19.nr1[nsmm_l]
print @n.xbgr.xr77_u20.nr1[nsmm_rsh]
print @n.xbgr.xr77_u20.nr1[nsmm_w]
print @n.xbgr.xr77_u20.nr1[nsmm_l]
print @n.xbgr.xr77_u21.nr1[nsmm_rsh]
print @n.xbgr.xr77_u21.nr1[nsmm_w]
print @n.xbgr.xr77_u21.nr1[nsmm_l]
print @n.xbgr.xr77_u22.nr1[nsmm_rsh]
print @n.xbgr.xr77_u22.nr1[nsmm_w]
print @n.xbgr.xr77_u22.nr1[nsmm_l]
print @n.xbgr.xr77_u23.nr1[nsmm_rsh]
print @n.xbgr.xr77_u23.nr1[nsmm_w]
print @n.xbgr.xr77_u23.nr1[nsmm_l]
print @n.xbgr.xr77_u24.nr1[nsmm_rsh]
print @n.xbgr.xr77_u24.nr1[nsmm_w]
print @n.xbgr.xr77_u24.nr1[nsmm_l]
print @n.xbgr.xr78_u2.nr1[nsmm_rsh]
print @n.xbgr.xr78_u2.nr1[nsmm_w]
print @n.xbgr.xr78_u2.nr1[nsmm_l]
print @n.xbgr.xr78_u3.nr1[nsmm_rsh]
print @n.xbgr.xr78_u3.nr1[nsmm_w]
print @n.xbgr.xr78_u3.nr1[nsmm_l]
print @n.xbgr.xr78_u4.nr1[nsmm_rsh]
print @n.xbgr.xr78_u4.nr1[nsmm_w]
print @n.xbgr.xr78_u4.nr1[nsmm_l]
print @n.xbgr.xr78_u5.nr1[nsmm_rsh]
print @n.xbgr.xr78_u5.nr1[nsmm_w]
print @n.xbgr.xr78_u5.nr1[nsmm_l]
print @n.xbgr.xr78_u6.nr1[nsmm_rsh]
print @n.xbgr.xr78_u6.nr1[nsmm_w]
print @n.xbgr.xr78_u6.nr1[nsmm_l]
print @n.xbgr.xr78_u7.nr1[nsmm_rsh]
print @n.xbgr.xr78_u7.nr1[nsmm_w]
print @n.xbgr.xr78_u7.nr1[nsmm_l]
print @n.xbgr.xr78_u8.nr1[nsmm_rsh]
print @n.xbgr.xr78_u8.nr1[nsmm_w]
print @n.xbgr.xr78_u8.nr1[nsmm_l]
print @n.xbgr.xr78_u9.nr1[nsmm_rsh]
print @n.xbgr.xr78_u9.nr1[nsmm_w]
print @n.xbgr.xr78_u9.nr1[nsmm_l]
print @n.xbgr.xr78_u10.nr1[nsmm_rsh]
print @n.xbgr.xr78_u10.nr1[nsmm_w]
print @n.xbgr.xr78_u10.nr1[nsmm_l]
print @n.xbgr.xr78_u11.nr1[nsmm_rsh]
print @n.xbgr.xr78_u11.nr1[nsmm_w]
print @n.xbgr.xr78_u11.nr1[nsmm_l]
print @n.xbgr.xr78_u12.nr1[nsmm_rsh]
print @n.xbgr.xr78_u12.nr1[nsmm_w]
print @n.xbgr.xr78_u12.nr1[nsmm_l]
print @n.xbgr.xr78_u13.nr1[nsmm_rsh]
print @n.xbgr.xr78_u13.nr1[nsmm_w]
print @n.xbgr.xr78_u13.nr1[nsmm_l]
print @n.xbgr.xr78_u14.nr1[nsmm_rsh]
print @n.xbgr.xr78_u14.nr1[nsmm_w]
print @n.xbgr.xr78_u14.nr1[nsmm_l]
print @n.xbgr.xr78_u15.nr1[nsmm_rsh]
print @n.xbgr.xr78_u15.nr1[nsmm_w]
print @n.xbgr.xr78_u15.nr1[nsmm_l]
print @n.xbgr.xr78_u16.nr1[nsmm_rsh]
print @n.xbgr.xr78_u16.nr1[nsmm_w]
print @n.xbgr.xr78_u16.nr1[nsmm_l]
print @n.xbgr.xr78_u17.nr1[nsmm_rsh]
print @n.xbgr.xr78_u17.nr1[nsmm_w]
print @n.xbgr.xr78_u17.nr1[nsmm_l]
print @n.xbgr.xr78_u18.nr1[nsmm_rsh]
print @n.xbgr.xr78_u18.nr1[nsmm_w]
print @n.xbgr.xr78_u18.nr1[nsmm_l]
print @n.xbgr.xr78_u19.nr1[nsmm_rsh]
print @n.xbgr.xr78_u19.nr1[nsmm_w]
print @n.xbgr.xr78_u19.nr1[nsmm_l]
print @n.xbgr.xr78_u20.nr1[nsmm_rsh]
print @n.xbgr.xr78_u20.nr1[nsmm_w]
print @n.xbgr.xr78_u20.nr1[nsmm_l]
print @n.xbgr.xr78_u21.nr1[nsmm_rsh]
print @n.xbgr.xr78_u21.nr1[nsmm_w]
print @n.xbgr.xr78_u21.nr1[nsmm_l]
print @n.xbgr.xr78_u22.nr1[nsmm_rsh]
print @n.xbgr.xr78_u22.nr1[nsmm_w]
print @n.xbgr.xr78_u22.nr1[nsmm_l]
print @n.xbgr.xr78_u23.nr1[nsmm_rsh]
print @n.xbgr.xr78_u23.nr1[nsmm_w]
print @n.xbgr.xr78_u23.nr1[nsmm_l]
print @n.xbgr.xr78_u24.nr1[nsmm_rsh]
print @n.xbgr.xr78_u24.nr1[nsmm_w]
print @n.xbgr.xr78_u24.nr1[nsmm_l]
print @n.xbgr.xr79_u2.nr1[nsmm_rsh]
print @n.xbgr.xr79_u2.nr1[nsmm_w]
print @n.xbgr.xr79_u2.nr1[nsmm_l]
print @n.xbgr.xr79_u3.nr1[nsmm_rsh]
print @n.xbgr.xr79_u3.nr1[nsmm_w]
print @n.xbgr.xr79_u3.nr1[nsmm_l]
print @n.xbgr.xr79_u4.nr1[nsmm_rsh]
print @n.xbgr.xr79_u4.nr1[nsmm_w]
print @n.xbgr.xr79_u4.nr1[nsmm_l]
print @n.xbgr.xr79_u5.nr1[nsmm_rsh]
print @n.xbgr.xr79_u5.nr1[nsmm_w]
print @n.xbgr.xr79_u5.nr1[nsmm_l]
print @n.xbgr.xr79_u6.nr1[nsmm_rsh]
print @n.xbgr.xr79_u6.nr1[nsmm_w]
print @n.xbgr.xr79_u6.nr1[nsmm_l]
print @n.xbgr.xr79_u7.nr1[nsmm_rsh]
print @n.xbgr.xr79_u7.nr1[nsmm_w]
print @n.xbgr.xr79_u7.nr1[nsmm_l]
print @n.xbgr.xr79_u8.nr1[nsmm_rsh]
print @n.xbgr.xr79_u8.nr1[nsmm_w]
print @n.xbgr.xr79_u8.nr1[nsmm_l]
print @n.xbgr.xr79_u9.nr1[nsmm_rsh]
print @n.xbgr.xr79_u9.nr1[nsmm_w]
print @n.xbgr.xr79_u9.nr1[nsmm_l]
print @n.xbgr.xr79_u10.nr1[nsmm_rsh]
print @n.xbgr.xr79_u10.nr1[nsmm_w]
print @n.xbgr.xr79_u10.nr1[nsmm_l]
print @n.xbgr.xr79_u11.nr1[nsmm_rsh]
print @n.xbgr.xr79_u11.nr1[nsmm_w]
print @n.xbgr.xr79_u11.nr1[nsmm_l]
print @n.xbgr.xr79_u12.nr1[nsmm_rsh]
print @n.xbgr.xr79_u12.nr1[nsmm_w]
print @n.xbgr.xr79_u12.nr1[nsmm_l]
print @n.xbgr.xr79_u13.nr1[nsmm_rsh]
print @n.xbgr.xr79_u13.nr1[nsmm_w]
print @n.xbgr.xr79_u13.nr1[nsmm_l]
print @n.xbgr.xr79_u14.nr1[nsmm_rsh]
print @n.xbgr.xr79_u14.nr1[nsmm_w]
print @n.xbgr.xr79_u14.nr1[nsmm_l]
print @n.xbgr.xr79_u15.nr1[nsmm_rsh]
print @n.xbgr.xr79_u15.nr1[nsmm_w]
print @n.xbgr.xr79_u15.nr1[nsmm_l]
print @n.xbgr.xr79_u16.nr1[nsmm_rsh]
print @n.xbgr.xr79_u16.nr1[nsmm_w]
print @n.xbgr.xr79_u16.nr1[nsmm_l]
print @n.xbgr.xr79_u17.nr1[nsmm_rsh]
print @n.xbgr.xr79_u17.nr1[nsmm_w]
print @n.xbgr.xr79_u17.nr1[nsmm_l]
print @n.xbgr.xr79_u18.nr1[nsmm_rsh]
print @n.xbgr.xr79_u18.nr1[nsmm_w]
print @n.xbgr.xr79_u18.nr1[nsmm_l]
print @n.xbgr.xr79_u19.nr1[nsmm_rsh]
print @n.xbgr.xr79_u19.nr1[nsmm_w]
print @n.xbgr.xr79_u19.nr1[nsmm_l]
print @n.xbgr.xr79_u20.nr1[nsmm_rsh]
print @n.xbgr.xr79_u20.nr1[nsmm_w]
print @n.xbgr.xr79_u20.nr1[nsmm_l]
print @n.xbgr.xr79_u21.nr1[nsmm_rsh]
print @n.xbgr.xr79_u21.nr1[nsmm_w]
print @n.xbgr.xr79_u21.nr1[nsmm_l]
print @n.xbgr.xr79_u22.nr1[nsmm_rsh]
print @n.xbgr.xr79_u22.nr1[nsmm_w]
print @n.xbgr.xr79_u22.nr1[nsmm_l]
print @n.xbgr.xr79_u23.nr1[nsmm_rsh]
print @n.xbgr.xr79_u23.nr1[nsmm_w]
print @n.xbgr.xr79_u23.nr1[nsmm_l]
print @n.xbgr.xr79_u24.nr1[nsmm_rsh]
print @n.xbgr.xr79_u24.nr1[nsmm_w]
print @n.xbgr.xr79_u24.nr1[nsmm_l]
print @n.xbgr.xr80_u2.nr1[nsmm_rsh]
print @n.xbgr.xr80_u2.nr1[nsmm_w]
print @n.xbgr.xr80_u2.nr1[nsmm_l]
print @n.xbgr.xr80_u3.nr1[nsmm_rsh]
print @n.xbgr.xr80_u3.nr1[nsmm_w]
print @n.xbgr.xr80_u3.nr1[nsmm_l]
print @n.xbgr.xr80_u4.nr1[nsmm_rsh]
print @n.xbgr.xr80_u4.nr1[nsmm_w]
print @n.xbgr.xr80_u4.nr1[nsmm_l]
print @n.xbgr.xr80_u5.nr1[nsmm_rsh]
print @n.xbgr.xr80_u5.nr1[nsmm_w]
print @n.xbgr.xr80_u5.nr1[nsmm_l]
print @n.xbgr.xr80_u6.nr1[nsmm_rsh]
print @n.xbgr.xr80_u6.nr1[nsmm_w]
print @n.xbgr.xr80_u6.nr1[nsmm_l]
print @n.xbgr.xr80_u7.nr1[nsmm_rsh]
print @n.xbgr.xr80_u7.nr1[nsmm_w]
print @n.xbgr.xr80_u7.nr1[nsmm_l]
print @n.xbgr.xr80_u8.nr1[nsmm_rsh]
print @n.xbgr.xr80_u8.nr1[nsmm_w]
print @n.xbgr.xr80_u8.nr1[nsmm_l]
print @n.xbgr.xr80_u9.nr1[nsmm_rsh]
print @n.xbgr.xr80_u9.nr1[nsmm_w]
print @n.xbgr.xr80_u9.nr1[nsmm_l]
print @n.xbgr.xr80_u10.nr1[nsmm_rsh]
print @n.xbgr.xr80_u10.nr1[nsmm_w]
print @n.xbgr.xr80_u10.nr1[nsmm_l]
print @n.xbgr.xr80_u11.nr1[nsmm_rsh]
print @n.xbgr.xr80_u11.nr1[nsmm_w]
print @n.xbgr.xr80_u11.nr1[nsmm_l]
print @n.xbgr.xr80_u12.nr1[nsmm_rsh]
print @n.xbgr.xr80_u12.nr1[nsmm_w]
print @n.xbgr.xr80_u12.nr1[nsmm_l]
print @n.xbgr.xr80_u13.nr1[nsmm_rsh]
print @n.xbgr.xr80_u13.nr1[nsmm_w]
print @n.xbgr.xr80_u13.nr1[nsmm_l]
print @n.xbgr.xr80_u14.nr1[nsmm_rsh]
print @n.xbgr.xr80_u14.nr1[nsmm_w]
print @n.xbgr.xr80_u14.nr1[nsmm_l]
print @n.xbgr.xr80_u15.nr1[nsmm_rsh]
print @n.xbgr.xr80_u15.nr1[nsmm_w]
print @n.xbgr.xr80_u15.nr1[nsmm_l]
print @n.xbgr.xr80_u16.nr1[nsmm_rsh]
print @n.xbgr.xr80_u16.nr1[nsmm_w]
print @n.xbgr.xr80_u16.nr1[nsmm_l]
print @n.xbgr.xr80_u17.nr1[nsmm_rsh]
print @n.xbgr.xr80_u17.nr1[nsmm_w]
print @n.xbgr.xr80_u17.nr1[nsmm_l]
print @n.xbgr.xr80_u18.nr1[nsmm_rsh]
print @n.xbgr.xr80_u18.nr1[nsmm_w]
print @n.xbgr.xr80_u18.nr1[nsmm_l]
print @n.xbgr.xr80_u19.nr1[nsmm_rsh]
print @n.xbgr.xr80_u19.nr1[nsmm_w]
print @n.xbgr.xr80_u19.nr1[nsmm_l]
print @n.xbgr.xr80_u20.nr1[nsmm_rsh]
print @n.xbgr.xr80_u20.nr1[nsmm_w]
print @n.xbgr.xr80_u20.nr1[nsmm_l]
print @n.xbgr.xr80_u21.nr1[nsmm_rsh]
print @n.xbgr.xr80_u21.nr1[nsmm_w]
print @n.xbgr.xr80_u21.nr1[nsmm_l]
print @n.xbgr.xr80_u22.nr1[nsmm_rsh]
print @n.xbgr.xr80_u22.nr1[nsmm_w]
print @n.xbgr.xr80_u22.nr1[nsmm_l]
print @n.xbgr.xr80_u23.nr1[nsmm_rsh]
print @n.xbgr.xr80_u23.nr1[nsmm_w]
print @n.xbgr.xr80_u23.nr1[nsmm_l]
print @n.xbgr.xr80_u24.nr1[nsmm_rsh]
print @n.xbgr.xr80_u24.nr1[nsmm_w]
print @n.xbgr.xr80_u24.nr1[nsmm_l]
print @n.xbgr.xr81_u2.nr1[nsmm_rsh]
print @n.xbgr.xr81_u2.nr1[nsmm_w]
print @n.xbgr.xr81_u2.nr1[nsmm_l]
print @n.xbgr.xr81_u3.nr1[nsmm_rsh]
print @n.xbgr.xr81_u3.nr1[nsmm_w]
print @n.xbgr.xr81_u3.nr1[nsmm_l]
print @n.xbgr.xr81_u4.nr1[nsmm_rsh]
print @n.xbgr.xr81_u4.nr1[nsmm_w]
print @n.xbgr.xr81_u4.nr1[nsmm_l]
print @n.xbgr.xr81_u5.nr1[nsmm_rsh]
print @n.xbgr.xr81_u5.nr1[nsmm_w]
print @n.xbgr.xr81_u5.nr1[nsmm_l]
print @n.xbgr.xr81_u6.nr1[nsmm_rsh]
print @n.xbgr.xr81_u6.nr1[nsmm_w]
print @n.xbgr.xr81_u6.nr1[nsmm_l]
print @n.xbgr.xr81_u7.nr1[nsmm_rsh]
print @n.xbgr.xr81_u7.nr1[nsmm_w]
print @n.xbgr.xr81_u7.nr1[nsmm_l]
print @n.xbgr.xr81_u8.nr1[nsmm_rsh]
print @n.xbgr.xr81_u8.nr1[nsmm_w]
print @n.xbgr.xr81_u8.nr1[nsmm_l]
print @n.xbgr.xr81_u9.nr1[nsmm_rsh]
print @n.xbgr.xr81_u9.nr1[nsmm_w]
print @n.xbgr.xr81_u9.nr1[nsmm_l]
print @n.xbgr.xr81_u10.nr1[nsmm_rsh]
print @n.xbgr.xr81_u10.nr1[nsmm_w]
print @n.xbgr.xr81_u10.nr1[nsmm_l]
print @n.xbgr.xr81_u11.nr1[nsmm_rsh]
print @n.xbgr.xr81_u11.nr1[nsmm_w]
print @n.xbgr.xr81_u11.nr1[nsmm_l]
print @n.xbgr.xr81_u12.nr1[nsmm_rsh]
print @n.xbgr.xr81_u12.nr1[nsmm_w]
print @n.xbgr.xr81_u12.nr1[nsmm_l]
print @n.xbgr.xr81_u13.nr1[nsmm_rsh]
print @n.xbgr.xr81_u13.nr1[nsmm_w]
print @n.xbgr.xr81_u13.nr1[nsmm_l]
print @n.xbgr.xr81_u14.nr1[nsmm_rsh]
print @n.xbgr.xr81_u14.nr1[nsmm_w]
print @n.xbgr.xr81_u14.nr1[nsmm_l]
print @n.xbgr.xr81_u15.nr1[nsmm_rsh]
print @n.xbgr.xr81_u15.nr1[nsmm_w]
print @n.xbgr.xr81_u15.nr1[nsmm_l]
print @n.xbgr.xr81_u16.nr1[nsmm_rsh]
print @n.xbgr.xr81_u16.nr1[nsmm_w]
print @n.xbgr.xr81_u16.nr1[nsmm_l]
print @n.xbgr.xr81_u17.nr1[nsmm_rsh]
print @n.xbgr.xr81_u17.nr1[nsmm_w]
print @n.xbgr.xr81_u17.nr1[nsmm_l]
print @n.xbgr.xr81_u18.nr1[nsmm_rsh]
print @n.xbgr.xr81_u18.nr1[nsmm_w]
print @n.xbgr.xr81_u18.nr1[nsmm_l]
print @n.xbgr.xr81_u19.nr1[nsmm_rsh]
print @n.xbgr.xr81_u19.nr1[nsmm_w]
print @n.xbgr.xr81_u19.nr1[nsmm_l]
print @n.xbgr.xr81_u20.nr1[nsmm_rsh]
print @n.xbgr.xr81_u20.nr1[nsmm_w]
print @n.xbgr.xr81_u20.nr1[nsmm_l]
print @n.xbgr.xr81_u21.nr1[nsmm_rsh]
print @n.xbgr.xr81_u21.nr1[nsmm_w]
print @n.xbgr.xr81_u21.nr1[nsmm_l]
print @n.xbgr.xr81_u22.nr1[nsmm_rsh]
print @n.xbgr.xr81_u22.nr1[nsmm_w]
print @n.xbgr.xr81_u22.nr1[nsmm_l]
print @n.xbgr.xr81_u23.nr1[nsmm_rsh]
print @n.xbgr.xr81_u23.nr1[nsmm_w]
print @n.xbgr.xr81_u23.nr1[nsmm_l]
print @n.xbgr.xr81_u24.nr1[nsmm_rsh]
print @n.xbgr.xr81_u24.nr1[nsmm_w]
print @n.xbgr.xr81_u24.nr1[nsmm_l]
print @n.xbgr.xr82_u2.nr1[nsmm_rsh]
print @n.xbgr.xr82_u2.nr1[nsmm_w]
print @n.xbgr.xr82_u2.nr1[nsmm_l]
print @n.xbgr.xr82_u3.nr1[nsmm_rsh]
print @n.xbgr.xr82_u3.nr1[nsmm_w]
print @n.xbgr.xr82_u3.nr1[nsmm_l]
print @n.xbgr.xr82_u4.nr1[nsmm_rsh]
print @n.xbgr.xr82_u4.nr1[nsmm_w]
print @n.xbgr.xr82_u4.nr1[nsmm_l]
print @n.xbgr.xr82_u5.nr1[nsmm_rsh]
print @n.xbgr.xr82_u5.nr1[nsmm_w]
print @n.xbgr.xr82_u5.nr1[nsmm_l]
print @n.xbgr.xr82_u6.nr1[nsmm_rsh]
print @n.xbgr.xr82_u6.nr1[nsmm_w]
print @n.xbgr.xr82_u6.nr1[nsmm_l]
print @n.xbgr.xr82_u7.nr1[nsmm_rsh]
print @n.xbgr.xr82_u7.nr1[nsmm_w]
print @n.xbgr.xr82_u7.nr1[nsmm_l]
print @n.xbgr.xr82_u8.nr1[nsmm_rsh]
print @n.xbgr.xr82_u8.nr1[nsmm_w]
print @n.xbgr.xr82_u8.nr1[nsmm_l]
print @n.xbgr.xr82_u9.nr1[nsmm_rsh]
print @n.xbgr.xr82_u9.nr1[nsmm_w]
print @n.xbgr.xr82_u9.nr1[nsmm_l]
print @n.xbgr.xr82_u10.nr1[nsmm_rsh]
print @n.xbgr.xr82_u10.nr1[nsmm_w]
print @n.xbgr.xr82_u10.nr1[nsmm_l]
print @n.xbgr.xr82_u11.nr1[nsmm_rsh]
print @n.xbgr.xr82_u11.nr1[nsmm_w]
print @n.xbgr.xr82_u11.nr1[nsmm_l]
print @n.xbgr.xr82_u12.nr1[nsmm_rsh]
print @n.xbgr.xr82_u12.nr1[nsmm_w]
print @n.xbgr.xr82_u12.nr1[nsmm_l]
print @n.xbgr.xr82_u13.nr1[nsmm_rsh]
print @n.xbgr.xr82_u13.nr1[nsmm_w]
print @n.xbgr.xr82_u13.nr1[nsmm_l]
print @n.xbgr.xr82_u14.nr1[nsmm_rsh]
print @n.xbgr.xr82_u14.nr1[nsmm_w]
print @n.xbgr.xr82_u14.nr1[nsmm_l]
print @n.xbgr.xr82_u15.nr1[nsmm_rsh]
print @n.xbgr.xr82_u15.nr1[nsmm_w]
print @n.xbgr.xr82_u15.nr1[nsmm_l]
print @n.xbgr.xr82_u16.nr1[nsmm_rsh]
print @n.xbgr.xr82_u16.nr1[nsmm_w]
print @n.xbgr.xr82_u16.nr1[nsmm_l]
print @n.xbgr.xr82_u17.nr1[nsmm_rsh]
print @n.xbgr.xr82_u17.nr1[nsmm_w]
print @n.xbgr.xr82_u17.nr1[nsmm_l]
print @n.xbgr.xr82_u18.nr1[nsmm_rsh]
print @n.xbgr.xr82_u18.nr1[nsmm_w]
print @n.xbgr.xr82_u18.nr1[nsmm_l]
print @n.xbgr.xr82_u19.nr1[nsmm_rsh]
print @n.xbgr.xr82_u19.nr1[nsmm_w]
print @n.xbgr.xr82_u19.nr1[nsmm_l]
print @n.xbgr.xr82_u20.nr1[nsmm_rsh]
print @n.xbgr.xr82_u20.nr1[nsmm_w]
print @n.xbgr.xr82_u20.nr1[nsmm_l]
print @n.xbgr.xr82_u21.nr1[nsmm_rsh]
print @n.xbgr.xr82_u21.nr1[nsmm_w]
print @n.xbgr.xr82_u21.nr1[nsmm_l]
print @n.xbgr.xr82_u22.nr1[nsmm_rsh]
print @n.xbgr.xr82_u22.nr1[nsmm_w]
print @n.xbgr.xr82_u22.nr1[nsmm_l]
print @n.xbgr.xr82_u23.nr1[nsmm_rsh]
print @n.xbgr.xr82_u23.nr1[nsmm_w]
print @n.xbgr.xr82_u23.nr1[nsmm_l]
print @n.xbgr.xr82_u24.nr1[nsmm_rsh]
print @n.xbgr.xr82_u24.nr1[nsmm_w]
print @n.xbgr.xr82_u24.nr1[nsmm_l]
print @n.xbgr.xr83_u2.nr1[nsmm_rsh]
print @n.xbgr.xr83_u2.nr1[nsmm_w]
print @n.xbgr.xr83_u2.nr1[nsmm_l]
print @n.xbgr.xr83_u3.nr1[nsmm_rsh]
print @n.xbgr.xr83_u3.nr1[nsmm_w]
print @n.xbgr.xr83_u3.nr1[nsmm_l]
print @n.xbgr.xr83_u4.nr1[nsmm_rsh]
print @n.xbgr.xr83_u4.nr1[nsmm_w]
print @n.xbgr.xr83_u4.nr1[nsmm_l]
print @n.xbgr.xr83_u5.nr1[nsmm_rsh]
print @n.xbgr.xr83_u5.nr1[nsmm_w]
print @n.xbgr.xr83_u5.nr1[nsmm_l]
print @n.xbgr.xr83_u6.nr1[nsmm_rsh]
print @n.xbgr.xr83_u6.nr1[nsmm_w]
print @n.xbgr.xr83_u6.nr1[nsmm_l]
print @n.xbgr.xr83_u7.nr1[nsmm_rsh]
print @n.xbgr.xr83_u7.nr1[nsmm_w]
print @n.xbgr.xr83_u7.nr1[nsmm_l]
print @n.xbgr.xr83_u8.nr1[nsmm_rsh]
print @n.xbgr.xr83_u8.nr1[nsmm_w]
print @n.xbgr.xr83_u8.nr1[nsmm_l]
print @n.xbgr.xr83_u9.nr1[nsmm_rsh]
print @n.xbgr.xr83_u9.nr1[nsmm_w]
print @n.xbgr.xr83_u9.nr1[nsmm_l]
print @n.xbgr.xr83_u10.nr1[nsmm_rsh]
print @n.xbgr.xr83_u10.nr1[nsmm_w]
print @n.xbgr.xr83_u10.nr1[nsmm_l]
print @n.xbgr.xr83_u11.nr1[nsmm_rsh]
print @n.xbgr.xr83_u11.nr1[nsmm_w]
print @n.xbgr.xr83_u11.nr1[nsmm_l]
print @n.xbgr.xr83_u12.nr1[nsmm_rsh]
print @n.xbgr.xr83_u12.nr1[nsmm_w]
print @n.xbgr.xr83_u12.nr1[nsmm_l]
print @n.xbgr.xr83_u13.nr1[nsmm_rsh]
print @n.xbgr.xr83_u13.nr1[nsmm_w]
print @n.xbgr.xr83_u13.nr1[nsmm_l]
print @n.xbgr.xr83_u14.nr1[nsmm_rsh]
print @n.xbgr.xr83_u14.nr1[nsmm_w]
print @n.xbgr.xr83_u14.nr1[nsmm_l]
print @n.xbgr.xr83_u15.nr1[nsmm_rsh]
print @n.xbgr.xr83_u15.nr1[nsmm_w]
print @n.xbgr.xr83_u15.nr1[nsmm_l]
print @n.xbgr.xr83_u16.nr1[nsmm_rsh]
print @n.xbgr.xr83_u16.nr1[nsmm_w]
print @n.xbgr.xr83_u16.nr1[nsmm_l]
print @n.xbgr.xr83_u17.nr1[nsmm_rsh]
print @n.xbgr.xr83_u17.nr1[nsmm_w]
print @n.xbgr.xr83_u17.nr1[nsmm_l]
print @n.xbgr.xr83_u18.nr1[nsmm_rsh]
print @n.xbgr.xr83_u18.nr1[nsmm_w]
print @n.xbgr.xr83_u18.nr1[nsmm_l]
print @n.xbgr.xr83_u19.nr1[nsmm_rsh]
print @n.xbgr.xr83_u19.nr1[nsmm_w]
print @n.xbgr.xr83_u19.nr1[nsmm_l]
print @n.xbgr.xr83_u20.nr1[nsmm_rsh]
print @n.xbgr.xr83_u20.nr1[nsmm_w]
print @n.xbgr.xr83_u20.nr1[nsmm_l]
print @n.xbgr.xr83_u21.nr1[nsmm_rsh]
print @n.xbgr.xr83_u21.nr1[nsmm_w]
print @n.xbgr.xr83_u21.nr1[nsmm_l]
print @n.xbgr.xr83_u22.nr1[nsmm_rsh]
print @n.xbgr.xr83_u22.nr1[nsmm_w]
print @n.xbgr.xr83_u22.nr1[nsmm_l]
print @n.xbgr.xr83_u23.nr1[nsmm_rsh]
print @n.xbgr.xr83_u23.nr1[nsmm_w]
print @n.xbgr.xr83_u23.nr1[nsmm_l]
print @n.xbgr.xr83_u24.nr1[nsmm_rsh]
print @n.xbgr.xr83_u24.nr1[nsmm_w]
print @n.xbgr.xr83_u24.nr1[nsmm_l]
print @n.xbgr.xr84_u2.nr1[nsmm_rsh]
print @n.xbgr.xr84_u2.nr1[nsmm_w]
print @n.xbgr.xr84_u2.nr1[nsmm_l]
print @n.xbgr.xr84_u3.nr1[nsmm_rsh]
print @n.xbgr.xr84_u3.nr1[nsmm_w]
print @n.xbgr.xr84_u3.nr1[nsmm_l]
print @n.xbgr.xr84_u4.nr1[nsmm_rsh]
print @n.xbgr.xr84_u4.nr1[nsmm_w]
print @n.xbgr.xr84_u4.nr1[nsmm_l]
print @n.xbgr.xr84_u5.nr1[nsmm_rsh]
print @n.xbgr.xr84_u5.nr1[nsmm_w]
print @n.xbgr.xr84_u5.nr1[nsmm_l]
print @n.xbgr.xr84_u6.nr1[nsmm_rsh]
print @n.xbgr.xr84_u6.nr1[nsmm_w]
print @n.xbgr.xr84_u6.nr1[nsmm_l]
print @n.xbgr.xr84_u7.nr1[nsmm_rsh]
print @n.xbgr.xr84_u7.nr1[nsmm_w]
print @n.xbgr.xr84_u7.nr1[nsmm_l]
print @n.xbgr.xr84_u8.nr1[nsmm_rsh]
print @n.xbgr.xr84_u8.nr1[nsmm_w]
print @n.xbgr.xr84_u8.nr1[nsmm_l]
print @n.xbgr.xr84_u9.nr1[nsmm_rsh]
print @n.xbgr.xr84_u9.nr1[nsmm_w]
print @n.xbgr.xr84_u9.nr1[nsmm_l]
print @n.xbgr.xr84_u10.nr1[nsmm_rsh]
print @n.xbgr.xr84_u10.nr1[nsmm_w]
print @n.xbgr.xr84_u10.nr1[nsmm_l]
print @n.xbgr.xr84_u11.nr1[nsmm_rsh]
print @n.xbgr.xr84_u11.nr1[nsmm_w]
print @n.xbgr.xr84_u11.nr1[nsmm_l]
print @n.xbgr.xr84_u12.nr1[nsmm_rsh]
print @n.xbgr.xr84_u12.nr1[nsmm_w]
print @n.xbgr.xr84_u12.nr1[nsmm_l]
print @n.xbgr.xr84_u13.nr1[nsmm_rsh]
print @n.xbgr.xr84_u13.nr1[nsmm_w]
print @n.xbgr.xr84_u13.nr1[nsmm_l]
print @n.xbgr.xr84_u14.nr1[nsmm_rsh]
print @n.xbgr.xr84_u14.nr1[nsmm_w]
print @n.xbgr.xr84_u14.nr1[nsmm_l]
print @n.xbgr.xr84_u15.nr1[nsmm_rsh]
print @n.xbgr.xr84_u15.nr1[nsmm_w]
print @n.xbgr.xr84_u15.nr1[nsmm_l]
print @n.xbgr.xr84_u16.nr1[nsmm_rsh]
print @n.xbgr.xr84_u16.nr1[nsmm_w]
print @n.xbgr.xr84_u16.nr1[nsmm_l]
print @n.xbgr.xr84_u17.nr1[nsmm_rsh]
print @n.xbgr.xr84_u17.nr1[nsmm_w]
print @n.xbgr.xr84_u17.nr1[nsmm_l]
print @n.xbgr.xr84_u18.nr1[nsmm_rsh]
print @n.xbgr.xr84_u18.nr1[nsmm_w]
print @n.xbgr.xr84_u18.nr1[nsmm_l]
print @n.xbgr.xr84_u19.nr1[nsmm_rsh]
print @n.xbgr.xr84_u19.nr1[nsmm_w]
print @n.xbgr.xr84_u19.nr1[nsmm_l]
print @n.xbgr.xr84_u20.nr1[nsmm_rsh]
print @n.xbgr.xr84_u20.nr1[nsmm_w]
print @n.xbgr.xr84_u20.nr1[nsmm_l]
print @n.xbgr.xr84_u21.nr1[nsmm_rsh]
print @n.xbgr.xr84_u21.nr1[nsmm_w]
print @n.xbgr.xr84_u21.nr1[nsmm_l]
print @n.xbgr.xr84_u22.nr1[nsmm_rsh]
print @n.xbgr.xr84_u22.nr1[nsmm_w]
print @n.xbgr.xr84_u22.nr1[nsmm_l]
print @n.xbgr.xr84_u23.nr1[nsmm_rsh]
print @n.xbgr.xr84_u23.nr1[nsmm_w]
print @n.xbgr.xr84_u23.nr1[nsmm_l]
print @n.xbgr.xr84_u24.nr1[nsmm_rsh]
print @n.xbgr.xr84_u24.nr1[nsmm_w]
print @n.xbgr.xr84_u24.nr1[nsmm_l]
print @n.xbgr.xr85_u2.nr1[nsmm_rsh]
print @n.xbgr.xr85_u2.nr1[nsmm_w]
print @n.xbgr.xr85_u2.nr1[nsmm_l]
print @n.xbgr.xr85_u3.nr1[nsmm_rsh]
print @n.xbgr.xr85_u3.nr1[nsmm_w]
print @n.xbgr.xr85_u3.nr1[nsmm_l]
print @n.xbgr.xr85_u4.nr1[nsmm_rsh]
print @n.xbgr.xr85_u4.nr1[nsmm_w]
print @n.xbgr.xr85_u4.nr1[nsmm_l]
print @n.xbgr.xr85_u5.nr1[nsmm_rsh]
print @n.xbgr.xr85_u5.nr1[nsmm_w]
print @n.xbgr.xr85_u5.nr1[nsmm_l]
print @n.xbgr.xr85_u6.nr1[nsmm_rsh]
print @n.xbgr.xr85_u6.nr1[nsmm_w]
print @n.xbgr.xr85_u6.nr1[nsmm_l]
print @n.xbgr.xr85_u7.nr1[nsmm_rsh]
print @n.xbgr.xr85_u7.nr1[nsmm_w]
print @n.xbgr.xr85_u7.nr1[nsmm_l]
print @n.xbgr.xr85_u8.nr1[nsmm_rsh]
print @n.xbgr.xr85_u8.nr1[nsmm_w]
print @n.xbgr.xr85_u8.nr1[nsmm_l]
print @n.xbgr.xr85_u9.nr1[nsmm_rsh]
print @n.xbgr.xr85_u9.nr1[nsmm_w]
print @n.xbgr.xr85_u9.nr1[nsmm_l]
print @n.xbgr.xr85_u10.nr1[nsmm_rsh]
print @n.xbgr.xr85_u10.nr1[nsmm_w]
print @n.xbgr.xr85_u10.nr1[nsmm_l]
print @n.xbgr.xr85_u11.nr1[nsmm_rsh]
print @n.xbgr.xr85_u11.nr1[nsmm_w]
print @n.xbgr.xr85_u11.nr1[nsmm_l]
print @n.xbgr.xr85_u12.nr1[nsmm_rsh]
print @n.xbgr.xr85_u12.nr1[nsmm_w]
print @n.xbgr.xr85_u12.nr1[nsmm_l]
print @n.xbgr.xr85_u13.nr1[nsmm_rsh]
print @n.xbgr.xr85_u13.nr1[nsmm_w]
print @n.xbgr.xr85_u13.nr1[nsmm_l]
print @n.xbgr.xr85_u14.nr1[nsmm_rsh]
print @n.xbgr.xr85_u14.nr1[nsmm_w]
print @n.xbgr.xr85_u14.nr1[nsmm_l]
print @n.xbgr.xr85_u15.nr1[nsmm_rsh]
print @n.xbgr.xr85_u15.nr1[nsmm_w]
print @n.xbgr.xr85_u15.nr1[nsmm_l]
print @n.xbgr.xr85_u16.nr1[nsmm_rsh]
print @n.xbgr.xr85_u16.nr1[nsmm_w]
print @n.xbgr.xr85_u16.nr1[nsmm_l]
print @n.xbgr.xr85_u17.nr1[nsmm_rsh]
print @n.xbgr.xr85_u17.nr1[nsmm_w]
print @n.xbgr.xr85_u17.nr1[nsmm_l]
print @n.xbgr.xr85_u18.nr1[nsmm_rsh]
print @n.xbgr.xr85_u18.nr1[nsmm_w]
print @n.xbgr.xr85_u18.nr1[nsmm_l]
print @n.xbgr.xr85_u19.nr1[nsmm_rsh]
print @n.xbgr.xr85_u19.nr1[nsmm_w]
print @n.xbgr.xr85_u19.nr1[nsmm_l]
print @n.xbgr.xr85_u20.nr1[nsmm_rsh]
print @n.xbgr.xr85_u20.nr1[nsmm_w]
print @n.xbgr.xr85_u20.nr1[nsmm_l]
print @n.xbgr.xr85_u21.nr1[nsmm_rsh]
print @n.xbgr.xr85_u21.nr1[nsmm_w]
print @n.xbgr.xr85_u21.nr1[nsmm_l]
print @n.xbgr.xr85_u22.nr1[nsmm_rsh]
print @n.xbgr.xr85_u22.nr1[nsmm_w]
print @n.xbgr.xr85_u22.nr1[nsmm_l]
print @n.xbgr.xr85_u23.nr1[nsmm_rsh]
print @n.xbgr.xr85_u23.nr1[nsmm_w]
print @n.xbgr.xr85_u23.nr1[nsmm_l]
print @n.xbgr.xr85_u24.nr1[nsmm_rsh]
print @n.xbgr.xr85_u24.nr1[nsmm_w]
print @n.xbgr.xr85_u24.nr1[nsmm_l]
print @n.xbgr.xr86_u2.nr1[nsmm_rsh]
print @n.xbgr.xr86_u2.nr1[nsmm_w]
print @n.xbgr.xr86_u2.nr1[nsmm_l]
print @n.xbgr.xr86_u3.nr1[nsmm_rsh]
print @n.xbgr.xr86_u3.nr1[nsmm_w]
print @n.xbgr.xr86_u3.nr1[nsmm_l]
print @n.xbgr.xr86_u4.nr1[nsmm_rsh]
print @n.xbgr.xr86_u4.nr1[nsmm_w]
print @n.xbgr.xr86_u4.nr1[nsmm_l]
print @n.xbgr.xr86_u5.nr1[nsmm_rsh]
print @n.xbgr.xr86_u5.nr1[nsmm_w]
print @n.xbgr.xr86_u5.nr1[nsmm_l]
print @n.xbgr.xr86_u6.nr1[nsmm_rsh]
print @n.xbgr.xr86_u6.nr1[nsmm_w]
print @n.xbgr.xr86_u6.nr1[nsmm_l]
print @n.xbgr.xr86_u7.nr1[nsmm_rsh]
print @n.xbgr.xr86_u7.nr1[nsmm_w]
print @n.xbgr.xr86_u7.nr1[nsmm_l]
print @n.xbgr.xr86_u8.nr1[nsmm_rsh]
print @n.xbgr.xr86_u8.nr1[nsmm_w]
print @n.xbgr.xr86_u8.nr1[nsmm_l]
print @n.xbgr.xr86_u9.nr1[nsmm_rsh]
print @n.xbgr.xr86_u9.nr1[nsmm_w]
print @n.xbgr.xr86_u9.nr1[nsmm_l]
print @n.xbgr.xr86_u10.nr1[nsmm_rsh]
print @n.xbgr.xr86_u10.nr1[nsmm_w]
print @n.xbgr.xr86_u10.nr1[nsmm_l]
print @n.xbgr.xr86_u11.nr1[nsmm_rsh]
print @n.xbgr.xr86_u11.nr1[nsmm_w]
print @n.xbgr.xr86_u11.nr1[nsmm_l]
print @n.xbgr.xr86_u12.nr1[nsmm_rsh]
print @n.xbgr.xr86_u12.nr1[nsmm_w]
print @n.xbgr.xr86_u12.nr1[nsmm_l]
print @n.xbgr.xr86_u13.nr1[nsmm_rsh]
print @n.xbgr.xr86_u13.nr1[nsmm_w]
print @n.xbgr.xr86_u13.nr1[nsmm_l]
print @n.xbgr.xr86_u14.nr1[nsmm_rsh]
print @n.xbgr.xr86_u14.nr1[nsmm_w]
print @n.xbgr.xr86_u14.nr1[nsmm_l]
print @n.xbgr.xr86_u15.nr1[nsmm_rsh]
print @n.xbgr.xr86_u15.nr1[nsmm_w]
print @n.xbgr.xr86_u15.nr1[nsmm_l]
print @n.xbgr.xr86_u16.nr1[nsmm_rsh]
print @n.xbgr.xr86_u16.nr1[nsmm_w]
print @n.xbgr.xr86_u16.nr1[nsmm_l]
print @n.xbgr.xr86_u17.nr1[nsmm_rsh]
print @n.xbgr.xr86_u17.nr1[nsmm_w]
print @n.xbgr.xr86_u17.nr1[nsmm_l]
print @n.xbgr.xr86_u18.nr1[nsmm_rsh]
print @n.xbgr.xr86_u18.nr1[nsmm_w]
print @n.xbgr.xr86_u18.nr1[nsmm_l]
print @n.xbgr.xr86_u19.nr1[nsmm_rsh]
print @n.xbgr.xr86_u19.nr1[nsmm_w]
print @n.xbgr.xr86_u19.nr1[nsmm_l]
print @n.xbgr.xr86_u20.nr1[nsmm_rsh]
print @n.xbgr.xr86_u20.nr1[nsmm_w]
print @n.xbgr.xr86_u20.nr1[nsmm_l]
print @n.xbgr.xr86_u21.nr1[nsmm_rsh]
print @n.xbgr.xr86_u21.nr1[nsmm_w]
print @n.xbgr.xr86_u21.nr1[nsmm_l]
print @n.xbgr.xr86_u22.nr1[nsmm_rsh]
print @n.xbgr.xr86_u22.nr1[nsmm_w]
print @n.xbgr.xr86_u22.nr1[nsmm_l]
print @n.xbgr.xr86_u23.nr1[nsmm_rsh]
print @n.xbgr.xr86_u23.nr1[nsmm_w]
print @n.xbgr.xr86_u23.nr1[nsmm_l]
print @n.xbgr.xr86_u24.nr1[nsmm_rsh]
print @n.xbgr.xr86_u24.nr1[nsmm_w]
print @n.xbgr.xr86_u24.nr1[nsmm_l]
set numdgt=17
echo METALLIC_POINT_VOLTAGES_BEGIN
print v(xbgr.mr_n70983360)
print v(xbgr.vd2)
print v(xbgr.mr_n70222256)
print v(xbgr.c2)
print v(xbgr.mr_n71272480)
print v(xbgr.mr_n71373664)
print v(xbgr.mr_n71488672)
print v(xbgr.mr_n71545488)
print v(xbgr.mr_n71723568)
print v(xbgr.mr_n71857792)
print v(xbgr.mr_n71924960)
print v(xbgr.mr_n72156432)
print v(xbgr.mr_n72322096)
print v(xbgr.mr_n72448240)
print v(xbgr.mr_n72476384)
print v(xbgr.mr_n72719824)
print v(xbgr.mr_n72853600)
print v(xbgr.mr_n72916768)
print v(xbgr.mr_n73152848)
print v(xbgr.mr_n73530624)
print v(xbgr.mr_n73703536)
print v(xbgr.mr_n73901600)
print v(xbgr.mr_n74068208)
print v(xbgr.mr_n74209152)
print v(xbgr.mr_n74417136)
print v(xbgr.mr_n74616448)
print v(xbgr.mr_n74827552)
print v(xbgr.mr_n71869712)
print v(xbgr.mr_n74913392)
print v(xbgr.mr_n75196000)
print v(xbgr.mr_n75389024)
print v(xbgr.mr_n75605584)
print v(xbgr.mr_n75787024)
print v(xbgr.mr_n76093360)
print v(xbgr.mr_n76296160)
print v(xbgr.mr_n76530592)
print v(xbgr.mr_n76864944)
print v(xbgr.mr_n70982912)
print v(xbgr.mr_n71046800)
print v(xbgr.b1b)
print v(xbgr.mr_n71129584)
print v(xbgr.mr_n71229552)
print v(xbgr.mr_n71326640)
print v(xbgr.mr_n71416000)
print v(xbgr.mr_n71548624)
print v(xbgr.mr_n71662096)
print v(xbgr.mr_n72001344)
print v(xbgr.mr_n72118832)
print v(xbgr.mr_n72250496)
print v(xbgr.mr_n72353040)
print v(xbgr.mr_n72525680)
print v(xbgr.mr_n72641520)
print v(xbgr.mr_n72794304)
print v(xbgr.mr_n73043728)
print v(xbgr.mr_n71003920)
print v(xbgr.mr_n71079600)
print v(xbgr.mr_n70826896)
print v(xbgr.mr_n71218832)
print v(xbgr.mr_n71318448)
print v(xbgr.mr_n71431776)
print v(xbgr.mr_n71491120)
print v(xbgr.mr_n71639360)
print v(xbgr.mr_n71744288)
print v(xbgr.mr_n71858352)
print v(xbgr.mr_n71925152)
print v(xbgr.mr_n72166528)
print v(xbgr.mr_n72328448)
print v(xbgr.mr_n72448352)
print v(xbgr.mr_n72650032)
print v(xbgr.mr_n72766432)
print v(xbgr.mr_n72852416)
print v(xbgr.mr_n73045696)
print v(xbgr.mr_n70168672)
print v(xbgr.mr_n70515520)
print v(xbgr.n_13)
print v(xbgr.n_24)
print v(xbgr.mr_n70250272)
print v(xbgr.mr_n70362032)
print v(xbgr.n_14)
print v(xbgr.mr_n70860256)
print v(xbgr.mr_n70970752)
print v(xbgr.mr_n71046992)
print v(xbgr.mr_n70259104)
print v(xbgr.mr_n71199024)
print v(xbgr.mr_n71275152)
print v(xbgr.mr_n71350384)
print v(xbgr.mr_n71432784)
print v(xbgr.vd1)
print v(xbgr.mr_n71724512)
print v(xbgr.mr_n71822704)
print v(xbgr.mr_n71969776)
print v(xbgr.mr_n72096224)
print v(xbgr.mr_n72319392)
print v(xbgr.mr_n72452464)
print v(xbgr.mr_n72560224)
print v(xbgr.mr_n72703312)
print v(xbgr.mr_n72872096)
print v(xbgr.mr_n72915680)
print v(xbgr.mr_n73392016)
print v(xbgr.mr_n73531888)
print v(xbgr.mr_n73707680)
print v(xbgr.mr_n73901792)
print v(xbgr.mr_n74069200)
print v(xbgr.mr_n74253392)
print v(xbgr.mr_n74455360)
print v(xbgr.mr_n74617616)
print v(xbgr.mr_n74832000)
print v(xbgr.mr_n71873408)
print v(xbgr.mr_n74918928)
print v(xbgr.mr_n75174512)
print v(xbgr.mr_n75388560)
print v(xbgr.mr_n75627152)
print v(xbgr.mr_n75794240)
print v(xbgr.mr_n76093168)
print v(xbgr.mr_n76297152)
print v(xbgr.mr_n76530016)
print v(xbgr.mr_n76867776)
print v(xbgr.mr_n70983936)
print v(xbgr.mr_n71047936)
print v(xbgr.mr_n70205360)
print v(xbgr.mr_n71158336)
print v(xbgr.mr_n71230928)
print v(xbgr.mr_n71326912)
print v(xbgr.mr_n71434064)
print v(xbgr.mr_n71603008)
print v(xbgr.mr_n71663600)
print v(xbgr.mr_n72002736)
print v(xbgr.mr_n72120224)
print v(xbgr.mr_n72251888)
print v(xbgr.mr_n72399856)
print v(xbgr.mr_n72527136)
print v(xbgr.mr_n72557552)
print v(xbgr.mr_n72792496)
print v(xbgr.mr_n72917312)
print v(xbgr.mr_n70168144)
print v(xbgr.mr_n70518448)
print v(xbgr.mr_n70746080)
print v(xbgr.n_26)
print v(xbgr.mr_n70252608)
print v(xbgr.mr_n70462992)
print v(xbgr.n_15)
print v(xbgr.mr_n70861696)
print v(xbgr.mr_n71019552)
print v(xbgr.mr_n71080320)
print v(xbgr.mr_n70387616)
print v(xbgr.mr_n71219536)
print v(xbgr.mr_n71319248)
print v(xbgr.mr_n71435584)
print v(xbgr.mr_n71482160)
print v(xbgr.mr_n71640624)
print v(xbgr.mr_n71745792)
print v(xbgr.mr_n71823328)
print v(xbgr.mr_n72048624)
print v(xbgr.mr_n72038368)
print v(xbgr.mr_n72343616)
print v(xbgr.mr_n72464560)
print v(xbgr.mr_n72651104)
print v(xbgr.mr_n72764064)
print v(xbgr.mr_n72871680)
print v(xbgr.mr_n72917856)
print v(xbgr.mr_n70162976)
print v(xbgr.mr_n70519632)
print v(xbgr.mr_n70747008)
print v(xbgr.n_27)
print v(xbgr.mr_n70253600)
print v(xbgr.mr_n70520288)
print v(xbgr.n_16)
print v(xbgr.mr_n70863136)
print v(xbgr.mr_n70254928)
print v(xbgr.mr_n70520880)
print v(xbgr.mr_n70747472)
print v(xbgr.n_21)
print v(xbgr.mr_n70964784)
print v(xbgr.mr_n71046608)
print v(xbgr.mr_n70229296)
print v(xbgr.mr_n71195744)
print v(xbgr.mr_n70907504)
print v(xbgr.mr_n71374368)
print v(xbgr.mr_n71488336)
print v(xbgr.mr_n71602752)
print v(xbgr.mr_n71745536)
print v(xbgr.mr_n71971856)
print v(xbgr.mr_n72158096)
print v(xbgr.mr_n72343440)
print v(xbgr.mr_n72451648)
print v(xbgr.mr_n72557808)
print v(xbgr.mr_n72764400)
print v(xbgr.mr_n72872960)
print v(xbgr.mr_n73046512)
print v(xbgr.mr_n70254528)
print v(xbgr.mr_n70521472)
print v(xbgr.mr_n73398784)
print v(xbgr.mr_n73510880)
print v(xbgr.mr_n73781040)
print v(xbgr.mr_n73902592)
print v(xbgr.mr_n74081920)
print v(xbgr.mr_n74037520)
print v(xbgr.mr_n74450384)
print v(xbgr.mr_n74607600)
print v(xbgr.mr_n74836656)
print v(xbgr.mr_n75195536)
print v(xbgr.mr_n75404368)
print v(xbgr.mr_n75612304)
print v(xbgr.mr_n75799216)
print v(xbgr.mr_n76115808)
print v(xbgr.mr_n76297264)
print v(xbgr.mr_n76510032)
print v(xbgr.mr_n76878992)
print v(xbgr.mr_n70989696)
print v(xbgr.mr_n71066256)
print v(xbgr.mr_n70183888)
print v(xbgr.mr_n71159728)
print v(xbgr.mr_n71232320)
print v(xbgr.mr_n71327520)
print v(xbgr.mr_n71472608)
print v(xbgr.mr_n71603264)
print v(xbgr.mr_n71677392)
print v(xbgr.mr_n72002272)
print v(xbgr.mr_n72121616)
print v(xbgr.mr_n72253280)
print v(xbgr.mr_n72401632)
print v(xbgr.mr_n72528912)
print v(xbgr.mr_n72534832)
print v(xbgr.mr_n72822688)
print v(xbgr.mr_n73044736)
print v(xbgr.mr_n70255856)
print v(xbgr.mr_n70522064)
print v(xbgr.n_8)
print v(xbgr.vbe3)
print v(xbgr.mr_n71021088)
print v(xbgr.mr_n71080720)
print v(xbgr.mr_n70175488)
print v(xbgr.mr_n71220976)
print v(xbgr.mr_n71319968)
print v(xbgr.mr_n71435984)
print v(xbgr.mr_n71483088)
print v(xbgr.mr_n71641504)
print v(xbgr.mr_n71746752)
print v(xbgr.mr_n72050432)
print v(xbgr.mr_n72168480)
print v(xbgr.mr_n72344416)
print v(xbgr.mr_n72465360)
print v(xbgr.mr_n72652624)
print v(xbgr.mr_n72763392)
print v(xbgr.mr_n72851824)
print v(xbgr.mr_n73044064)
print v(xbgr.mr_n70255392)
print v(xbgr.mr_n70523248)
print v(xbgr.mr_n70595888)
print v(xbgr.mr_n70908656)
print v(xbgr.mr_n70252144)
print v(xbgr.mr_n70525024)
print v(xbgr.mr_n70596128)
print v(xbgr.n_37)
print v(xbgr.mr_n70256320)
print v(xbgr.mr_n70526736)
print v(xbgr.mr_n70596448)
print v(xbgr.mr_n70909584)
print v(xbgr.n_6)
print v(xbgr.vb2)
print v(xbgr.n_2)
print v(xbgr.mr_n70910048)
print v(xbgr.mr_n70983552)
print v(xbgr.mr_n71066960)
print v(xbgr.mr_n70380512)
print v(xbgr.mr_n71195552)
print v(xbgr.mr_n71279088)
print v(xbgr.mr_n71400512)
print v(xbgr.mr_n71483520)
print v(xbgr.mr_n71627408)
print v(xbgr.mr_n71723760)
print v(xbgr.mr_n71972736)
print v(xbgr.mr_n72167168)
print v(xbgr.mr_n72326208)
print v(xbgr.mr_n72451760)
print v(xbgr.mr_n72627776)
print v(xbgr.mr_n72768992)
print v(xbgr.mr_n72854784)
print v(xbgr.mr_n73048576)
print v(xbgr.mr_n73384880)
print v(xbgr.mr_n73568992)
print v(xbgr.mr_n73783632)
print v(xbgr.mr_n73894064)
print v(xbgr.mr_n74076432)
print v(xbgr.mr_n74271264)
print v(xbgr.mr_n74471168)
print v(xbgr.mr_n74616560)
print v(xbgr.mr_n74841632)
print v(xbgr.mr_n75202528)
print v(xbgr.mr_n75409776)
print v(xbgr.mr_n75617168)
print v(xbgr.mr_n75804304)
print v(xbgr.mr_n76109472)
print v(xbgr.mr_n76314240)
print v(xbgr.mr_n76530400)
print v(xbgr.mr_n76866832)
print v(xbgr.mr_n70359200)
print v(xbgr.mr_n70394160)
print v(xbgr.mr_n70597248)
print v(xbgr.mr_n70910576)
print v(xbgr.mr_n70990608)
print v(xbgr.mr_n71067312)
print v(xbgr.mr_n70189360)
print v(xbgr.mr_n71161120)
print v(xbgr.mr_n71233712)
print v(xbgr.mr_n71349344)
print v(xbgr.mr_n71473760)
print v(xbgr.mr_n71579488)
print v(xbgr.mr_n71678784)
print v(xbgr.mr_n72001808)
print v(xbgr.mr_n72123328)
print v(xbgr.mr_n72254992)
print v(xbgr.mr_n72403408)
print v(xbgr.mr_n72530688)
print v(xbgr.mr_n72648448)
print v(xbgr.mr_n72824080)
print v(xbgr.mr_n73046288)
print v(xbgr.mr_n70359936)
print v(xbgr.mr_n70394624)
print v(xbgr.n_7)
print v(xbgr.n_36)
print v(xbgr.mr_n71022144)
print v(xbgr.mr_n71068192)
print v(xbgr.mr_n71087488)
print v(xbgr.mr_n71220272)
print v(xbgr.mr_n71320768)
print v(xbgr.mr_n71436384)
print v(xbgr.mr_n71432112)
print v(xbgr.mr_n71642064)
print v(xbgr.mr_n71747552)
print v(xbgr.mr_n72052240)
print v(xbgr.mr_n72170944)
print v(xbgr.mr_n72345216)
print v(xbgr.mr_n72466160)
print v(xbgr.mr_n72643312)
print v(xbgr.mr_n72768880)
print v(xbgr.mr_n72871344)
print v(xbgr.mr_n73048352)
print v(xbgr.mr_n70360672)
print v(xbgr.mr_n70395088)
print v(xbgr.mr_n70598048)
print v(xbgr.mr_n70911760)
print v(xbgr.mr_n70361408)
print v(xbgr.mr_n70395552)
print v(xbgr.mr_n70594400)
print v(xbgr.mr_n70912352)
print v(xbgr.mr_n70362144)
print v(xbgr.mr_n70396144)
print v(xbgr.mr_n70598848)
print v(xbgr.mr_n70912944)
print v(xbgr.mr_n70162176)
print v(xbgr.mr_n70396736)
print v(xbgr.mr_n70599248)
print v(xbgr.mr_n70913536)
print v(xbgr.mr_n70983744)
print v(xbgr.mr_n71068016)
print v(xbgr.mr_n70434832)
print v(xbgr.mr_n70894336)
print v(xbgr.mr_n71280416)
print v(xbgr.mr_n71401312)
print v(xbgr.mr_n71432448)
print v(xbgr.mr_n71629696)
print v(xbgr.mr_n71745360)
print v(xbgr.mr_n72046208)
print v(xbgr.mr_n72156624)
print v(xbgr.mr_n72328912)
print v(xbgr.mr_n72437536)
print v(xbgr.mr_n72628960)
print v(xbgr.mr_n72770688)
print v(xbgr.mr_n72853008)
print v(xbgr.mr_n73048464)
print v(xbgr.mr_n73398592)
print v(xbgr.mr_n73563888)
print v(xbgr.mr_n73775936)
print v(xbgr.mr_n73920144)
print v(xbgr.mr_n74090976)
print v(xbgr.mr_n74253200)
print v(xbgr.mr_n74468464)
print v(xbgr.mr_n74623424)
print v(xbgr.mr_n74846608)
print v(xbgr.mr_n75212128)
print v(xbgr.mr_n75285904)
print v(xbgr.mr_n75621680)
print v(xbgr.mr_n75809168)
print v(xbgr.mr_n76113104)
print v(xbgr.mr_n76309008)
print v(xbgr.mr_n76438672)
print v(xbgr.mr_n76878544)
print v(xbgr.mr_n70994688)
print v(xbgr.mr_n71068368)
print v(xbgr.mr_n70155024)
print v(xbgr.mr_n71162512)
print v(xbgr.mr_n71235104)
print v(xbgr.mr_n71342928)
print v(xbgr.mr_n71475152)
print v(xbgr.mr_n71629584)
print v(xbgr.mr_n71680176)
print v(xbgr.mr_n72050944)
print v(xbgr.mr_n72125104)
print v(xbgr.mr_n72256768)
print v(xbgr.mr_n72405184)
print v(xbgr.mr_n72532464)
print v(xbgr.mr_n72654672)
print v(xbgr.mr_n72825600)
print v(xbgr.mr_n73050416)
print v(xbgr.mr_n70363392)
print v(xbgr.mr_n70397328)
print v(xbgr.mr_n70599648)
print v(xbgr.mr_n70914720)
print v(xbgr.mr_n70363936)
print v(xbgr.mr_n70397920)
print v(xbgr.n_11)
print v(xbgr.mr_n70914128)
print v(xbgr.mr_n71023920)
print v(xbgr.mr_n71081520)
print v(xbgr.mr_n71090864)
print v(xbgr.mr_n71196320)
print v(xbgr.mr_n71321568)
print v(xbgr.mr_n71436784)
print v(xbgr.mr_n71500976)
print v(xbgr.mr_n71642880)
print v(xbgr.mr_n71748352)
print v(xbgr.mr_n72054224)
print v(xbgr.mr_n72173344)
print v(xbgr.mr_n72346016)
print v(xbgr.mr_n72466960)
print v(xbgr.mr_n72656192)
print v(xbgr.mr_n72767072)
print v(xbgr.mr_n72872848)
print v(xbgr.mr_n73046400)
print v(xbgr.mr_n70364432)
print v(xbgr.mr_n70398512)
print v(xbgr.mr_n70679552)
print v(xbgr.mr_n70915312)
print v(xbgr.mr_n70365488)
print v(xbgr.mr_n70399104)
print v(xbgr.mr_n70680144)
print v(xbgr.mr_n70863744)
print v(xbgr.mr_n70365760)
print v(xbgr.mr_n70399696)
print v(xbgr.mr_n70575520)
print v(xbgr.mr_n70916416)
print v(xbgr.mr_n70988944)
print v(xbgr.mr_n71069424)
print v(xbgr.mr_n70298320)
print v(xbgr.mr_n70901280)
print v(xbgr.mr_n71285232)
print v(xbgr.mr_n71402112)
print v(xbgr.mr_n70945440)
print v(xbgr.mr_n71628960)
print v(xbgr.mr_n71748176)
print v(xbgr.mr_n72034480)
print v(xbgr.mr_n72093536)
print v(xbgr.mr_n72329616)
print v(xbgr.mr_n72451232)
print v(xbgr.mr_n72630144)
print v(xbgr.mr_n72692928)
print v(xbgr.mr_n72876464)
print v(xbgr.mr_n73044400)
print v(xbgr.n_9)
print v(xbgr.mr_n70400288)
print v(xbgr.mr_n70569008)
print v(xbgr.mr_n70917088)
print v(xbgr.mr_n73402944)
print v(xbgr.mr_n73577024)
print v(xbgr.mr_n73655168)
print v(xbgr.mr_n73905136)
print v(xbgr.mr_n74075968)
print v(xbgr.mr_n74275664)
print v(xbgr.mr_n74477136)
print v(xbgr.mr_n74642688)
print v(xbgr.mr_n74851584)
print v(xbgr.mr_n75243568)
print v(xbgr.mr_n75417936)
print v(xbgr.mr_n75626640)
print v(xbgr.mr_n75814144)
print v(xbgr.mr_n76125392)
print v(xbgr.mr_n76303888)
print v(xbgr.mr_n76557920)
print v(xbgr.mr_n76778128)
print v(xbgr.mr_n70995600)
print v(xbgr.mr_n71069072)
print v(xbgr.mr_n70164384)
print v(xbgr.mr_n71163904)
print v(xbgr.mr_n71236496)
print v(xbgr.mr_n71345296)
print v(xbgr.mr_n71476544)
print v(xbgr.mr_n71630624)
print v(xbgr.mr_n71681568)
print v(xbgr.mr_n72049136)
print v(xbgr.mr_n72126880)
print v(xbgr.mr_n72258544)
print v(xbgr.mr_n72406960)
print v(xbgr.mr_n72534240)
print v(xbgr.mr_n72657200)
print v(xbgr.mr_n72827376)
print v(xbgr.mr_n73052480)
print v(xbgr.mr_n70366848)
print v(xbgr.mr_n70400880)
print v(xbgr.mr_n70681136)
print v(xbgr.mr_n70917680)
print v(xbgr.mr_n71025056)
print v(xbgr.mr_n71081920)
print v(xbgr.mr_n71092752)
print v(xbgr.mr_n71219184)
print v(xbgr.mr_n71322368)
print v(xbgr.mr_n71437184)
print v(xbgr.mr_n71493744)
print v(xbgr.mr_n71643760)
print v(xbgr.mr_n71749152)
print v(xbgr.mr_n72056368)
print v(xbgr.mr_n72175152)
print v(xbgr.mr_n72346816)
print v(xbgr.mr_n72467760)
print v(xbgr.mr_n72657712)
print v(xbgr.mr_n72772496)
print v(xbgr.mr_n72874656)
print v(xbgr.mr_n73050640)
print v(xbgr.mr_n70367392)
print v(xbgr.mr_n70401472)
print v(xbgr.mr_n70681600)
print v(xbgr.mr_n70918272)
print v(xbgr.mr_n70367936)
print v(xbgr.mr_n70402064)
print v(xbgr.mr_n70598448)
print v(xbgr.mr_n70918864)
print v(xbgr.mr_n70368480)
print v(xbgr.mr_n70402656)
print v(xbgr.mr_n70682880)
print v(xbgr.mr_n70919456)
print v(xbgr.mr_n70369024)
print v(xbgr.mr_n70403248)
print v(xbgr.mr_n70676000)
print v(xbgr.mr_n70920048)
print v(xbgr.mr_n70991360)
print v(xbgr.mr_n71070128)
print v(xbgr.mr_n71086544)
print v(xbgr.mr_n71150400)
print v(xbgr.mr_n71286560)
print v(xbgr.mr_n71402976)
print v(xbgr.mr_n71498736)
print v(xbgr.mr_n71630048)
print v(xbgr.mr_n71727136)
print v(xbgr.mr_n72052752)
print v(xbgr.mr_n72169264)
print v(xbgr.mr_n72328800)
print v(xbgr.mr_n72466784)
print v(xbgr.mr_n72631328)
print v(xbgr.mr_n72702496)
print v(xbgr.mr_n72878384)
print v(xbgr.mr_n73050528)
print v(xbgr.mr_n73406880)
print v(xbgr.mr_n73572880)
print v(xbgr.mr_n73785344)
print v(xbgr.mr_n73927472)
print v(xbgr.mr_n74071280)
print v(xbgr.mr_n74264256)
print v(xbgr.mr_n74461520)
print v(xbgr.mr_n74632672)
print v(xbgr.mr_n74864688)
print v(xbgr.mr_n75227536)
print v(xbgr.mr_n75426208)
print v(xbgr.mr_n75651632)
print v(xbgr.mr_n75581216)
print v(xbgr.mr_n76125504)
print v(xbgr.mr_n76328208)
print v(xbgr.mr_n76534608)
print v(xbgr.mr_n76767920)
print v(xbgr.mr_n70369568)
print v(xbgr.mr_n70403840)
print v(xbgr.mr_n70684128)
print v(xbgr.mr_n70920640)
print v(xbgr.mr_n70999680)
print v(xbgr.mr_n71070304)
print v(xbgr.mr_n70223136)
print v(xbgr.mr_n71165296)
print v(xbgr.mr_n71236032)
print v(xbgr.mr_n71355312)
print v(xbgr.mr_n71476080)
print v(xbgr.mr_n71631808)
print v(xbgr.mr_n71682960)
print v(xbgr.mr_n72047328)
print v(xbgr.mr_n72126288)
print v(xbgr.mr_n72257952)
print v(xbgr.mr_n72408736)
print v(xbgr.mr_n72533648)
print v(xbgr.mr_n72658304)
print v(xbgr.mr_n72829152)
print v(xbgr.mr_n73054544)
print v(xbgr.mr_n70370384)
print v(xbgr.mr_n70404432)
print v(xbgr.mr_n70684720)
print v(xbgr.mr_n70921232)
print v(xbgr.mr_n71026912)
print v(xbgr.mr_n71082320)
print v(xbgr.mr_n71094560)
print v(xbgr.mr_n71150512)
print v(xbgr.mr_n71323168)
print v(xbgr.mr_n71437584)
print v(xbgr.mr_n71506176)
print v(xbgr.mr_n71644736)
print v(xbgr.mr_n71749952)
print v(xbgr.mr_n72058432)
print v(xbgr.mr_n72177040)
print v(xbgr.mr_n72347616)
print v(xbgr.mr_n72468560)
print v(xbgr.mr_n72651616)
print v(xbgr.mr_n72770800)
print v(xbgr.mr_n72880080)
print v(xbgr.mr_n73052704)
print v(xbgr.mr_n70370656)
print v(xbgr.mr_n70405024)
print v(xbgr.n_3)
print v(xbgr.n_33)
print v(xbgr.mr_n70371200)
print v(xbgr.mr_n70405616)
print v(xbgr.mr_n70593792)
print v(xbgr.mr_n70922336)
print v(xbgr.mr_n70371872)
print v(xbgr.mr_n70406208)
print v(xbgr.mr_n70686496)
print v(xbgr.mr_n70923008)
print v(xbgr.mr_n70373264)
print v(xbgr.mr_n70406800)
print v(xbgr.mr_n70680480)
print v(xbgr.mr_n70923600)
print v(xbgr.mr_n70993936)
print v(xbgr.mr_n71074480)
print v(xbgr.mr_n71086816)
print v(xbgr.mr_n71136576)
print v(xbgr.mr_n71291376)
print v(xbgr.mr_n71404160)
print v(xbgr.mr_n71498512)
print v(xbgr.mr_n71630976)
print v(xbgr.mr_n71723456)
print v(xbgr.mr_n71917392)
print v(xbgr.mr_n72054816)
print v(xbgr.mr_n72173936)
print v(xbgr.mr_n72347440)
print v(xbgr.mr_n72465984)
print v(xbgr.mr_n72632512)
print v(xbgr.mr_n72774416)
print v(xbgr.mr_n72854192)
print v(xbgr.mr_n73058672)
print v(xbgr.mr_n73404624)
print v(xbgr.mr_n73598528)
print v(xbgr.mr_n73802160)
print v(xbgr.mr_n73942608)
print v(xbgr.mr_n74085280)
print v(xbgr.mr_n74286800)
print v(xbgr.mr_n74488272)
print v(xbgr.mr_n74651936)
print v(xbgr.mr_n74861696)
print v(xbgr.mr_n75032128)
print v(xbgr.mr_n75223712)
print v(xbgr.mr_n75437920)
print v(xbgr.mr_n75654080)
print v(xbgr.mr_n75821328)
print v(xbgr.mr_n76138832)
print v(xbgr.mr_n76322976)
print v(xbgr.mr_n76533376)
print v(xbgr.mr_n76727776)
print v(xbgr.mr_n71000592)
print v(xbgr.mr_n71045984)
print v(xbgr.mr_n70176224)
print v(xbgr.mr_n71165760)
print v(xbgr.mr_n71235568)
print v(xbgr.mr_n71346320)
print v(xbgr.mr_n71475616)
print v(xbgr.mr_n71633120)
print v(xbgr.mr_n71684352)
print v(xbgr.mr_n71917504)
print v(xbgr.mr_n72053648)
print v(xbgr.mr_n72125696)
print v(xbgr.mr_n72257360)
print v(xbgr.mr_n72410512)
print v(xbgr.mr_n72533056)
print v(xbgr.mr_n72654784)
print v(xbgr.mr_n72830928)
print v(xbgr.mr_n73054768)
print v(xbgr.mr_n70373728)
print v(xbgr.n_19)
print v(xbgr.mr_n70687680)
print v(xbgr.mr_n70924192)
print v(xbgr.mr_n71028368)
print v(xbgr.mr_n71082720)
print v(xbgr.mr_n71096368)
print v(xbgr.mr_n71198304)
print v(xbgr.mr_n71323968)
print v(xbgr.mr_n71437984)
print v(xbgr.mr_n71508896)
print v(xbgr.mr_n71646192)
print v(xbgr.mr_n71750752)
print v(xbgr.mr_n71928256)
print v(xbgr.mr_n72060496)
print v(xbgr.mr_n72178768)
print v(xbgr.mr_n72348416)
print v(xbgr.mr_n72469360)
print v(xbgr.mr_n72659040)
print v(xbgr.mr_n72767184)
print v(xbgr.mr_n72881888)
print v(xbgr.mr_n73052592)
print v(xbgr.mr_n70374656)
print v(xbgr.mr_n70407984)
print v(xbgr.mr_n70688272)
print v(xbgr.mr_n70924784)
print v(xbgr.mr_n70375584)
print v(xbgr.mr_n70408576)
print v(xbgr.mr_n70688864)
print v(xbgr.mr_n70925376)
print v(xbgr.mr_n70376976)
print v(xbgr.mr_n70409168)
print v(xbgr.mr_n70677776)
print v(xbgr.mr_n70925968)
print v(xbgr.mr_n70376512)
print v(xbgr.mr_n70409760)
print v(xbgr.mr_n70689984)
print v(xbgr.mr_n70926560)
print v(xbgr.mr_n70996352)
print v(xbgr.mr_n71078016)
print v(xbgr.mr_n71086320)
print v(xbgr.mr_n71220656)
print v(xbgr.mr_n71292704)
print v(xbgr.mr_n71405344)
print v(xbgr.mr_n71508192)
print v(xbgr.mr_n71631632)
print v(xbgr.mr_n71688256)
print v(xbgr.mr_n71918048)
print v(xbgr.mr_n72056880)
print v(xbgr.mr_n72156880)
print v(xbgr.mr_n72325040)
print v(xbgr.mr_n72469184)
print v(xbgr.mr_n72633104)
print v(xbgr.mr_n72776112)
print v(xbgr.mr_n72883808)
print v(xbgr.mr_n73058784)
print v(xbgr.mr_n70376048)
print v(xbgr.mr_n70198112)
print v(xbgr.mr_n70681024)
print v(xbgr.mr_n70927152)
print v(xbgr.mr_n73401328)
print v(xbgr.mr_n73603312)
print v(xbgr.mr_n73798640)
print v(xbgr.mr_n73947584)
print v(xbgr.mr_n74079312)
print v(xbgr.mr_n74270752)
print v(xbgr.mr_n74476672)
print v(xbgr.mr_n74641984)
print v(xbgr.mr_n74766512)
print v(xbgr.mr_n75035328)
print v(xbgr.mr_n75240992)
print v(xbgr.mr_n75437408)
print v(xbgr.mr_n75629024)
print v(xbgr.mr_n75835264)
print v(xbgr.mr_n76145296)
print v(xbgr.mr_n76317856)
print v(xbgr.mr_n76511296)
print v(xbgr.mr_n76627440)
print v(xbgr.mr_n71004672)
print v(xbgr.mr_n71045712)
print v(xbgr.mr_n70179632)
print v(xbgr.mr_n71164832)
print v(xbgr.mr_n71234640)
print v(xbgr.mr_n71313488)
print v(xbgr.mr_n71474688)
print v(xbgr.mr_n71633776)
print v(xbgr.mr_n71721392)
print v(xbgr.mr_n71889008)
print v(xbgr.mr_n72055712)
print v(xbgr.mr_n72124512)
print v(xbgr.mr_n72256176)
print v(xbgr.mr_n72412288)
print v(xbgr.mr_n72531872)
print v(xbgr.mr_n72661360)
print v(xbgr.mr_n72832704)
print v(xbgr.mr_n73054656)
print v(xbgr.mr_n70375120)
print v(xbgr.mr_n70217120)
print v(xbgr.mr_n70691232)
print v(xbgr.mr_n70927744)
print v(xbgr.mr_n71029424)
print v(xbgr.mr_n71083360)
print v(xbgr.mr_n71098176)
print v(xbgr.mr_n70262816)
print v(xbgr.mr_n71324368)
print v(xbgr.mr_n71438384)
print v(xbgr.mr_n71511232)
print v(xbgr.mr_n71647072)
print v(xbgr.mr_n71751552)
print v(xbgr.mr_n71931456)
print v(xbgr.mr_n72062560)
print v(xbgr.mr_n72180656)
print v(xbgr.mr_n72349216)
print v(xbgr.mr_n72444944)
print v(xbgr.mr_n72663824)
print v(xbgr.mr_n72763728)
print v(xbgr.mr_n72883696)
print v(xbgr.mr_n73056608)
print v(xbgr.mr_n70374192)
print v(xbgr.mr_n70228384)
print v(xbgr.mr_n70691824)
print v(xbgr.mr_n70928336)
print v(xbgr.mr_n70372800)
print v(xbgr.mr_n70239648)
print v(xbgr.n_4)
print v(xbgr.n_30)
print v(xbgr.mr_n70372336)
print v(xbgr.mr_n70145904)
print v(xbgr.mr_n70683536)
print v(xbgr.mr_n70929520)
print v(xbgr.mr_n70371472)
print v(xbgr.mr_n70362656)
print v(xbgr.mr_n70693600)
print v(xbgr.mr_n70746896)
print v(xbgr.mr_n70998928)
print v(xbgr.mr_n71083184)
print v(xbgr.mr_n71088144)
print v(xbgr.mr_n70898112)
print v(xbgr.mr_n71297520)
print v(xbgr.mr_n71406528)
print v(xbgr.mr_n71501872)
print v(xbgr.mr_n71630512)
print v(xbgr.mr_n71659424)
print v(xbgr.mr_n71890368)
print v(xbgr.mr_n72058944)
print v(xbgr.mr_n72094416)
print v(xbgr.mr_n72344240)
print v(xbgr.mr_n72449056)
print v(xbgr.mr_n72631920)
print v(xbgr.mr_n72778032)
print v(xbgr.mr_n72874768)
print v(xbgr.mr_n73060848)
print v(xbgr.mr_n73149296)
print v(xbgr.mr_n73609088)
print v(xbgr.mr_n73813296)
print v(xbgr.mr_n73953744)
print v(xbgr.mr_n74104368)
print v(xbgr.mr_n74297936)
print v(xbgr.mr_n74499408)
print v(xbgr.mr_n74623152)
print v(xbgr.mr_n74769936)
print v(xbgr.mr_n75054048)
print v(xbgr.mr_n75209920)
print v(xbgr.mr_n75385472)
print v(xbgr.mr_n75624128)
print v(xbgr.mr_n75832368)
print v(xbgr.mr_n76145408)
print v(xbgr.mr_n76299232)
print v(xbgr.mr_n76508768)
print v(xbgr.mr_n76710672)
print v(xbgr.mr_n70370928)
print v(xbgr.mr_n70234720)
print v(xbgr.mr_n70587872)
print v(xbgr.mr_n70930624)
print v(xbgr.mr_n71005584)
print v(xbgr.mr_n71045440)
print v(xbgr.mr_n70183280)
print v(xbgr.mr_n71164368)
print v(xbgr.mr_n71234176)
print v(xbgr.mr_n71359376)
print v(xbgr.mr_n71474224)
print v(xbgr.mr_n71632464)
print v(xbgr.mr_n71664656)
print v(xbgr.mr_n71768736)
print v(xbgr.mr_n72057776)
print v(xbgr.mr_n72123920)
print v(xbgr.mr_n72255584)
print v(xbgr.mr_n72414064)
print v(xbgr.mr_n72531280)
print v(xbgr.mr_n72663072)
print v(xbgr.mr_n72834480)
print v(xbgr.mr_n73056720)
print v(xbgr.mr_n70370112)
print v(xbgr.mr_n70290240)
print v(xbgr.mr_n70694784)
print v(xbgr.mr_n70931296)
print v(xbgr.mr_n71031200)
print v(xbgr.mr_n71084160)
print v(xbgr.mr_n71099984)
print v(xbgr.mr_n70177264)
print v(xbgr.mr_n71323568)
print v(xbgr.mr_n71438784)
print v(xbgr.mr_n71501760)
print v(xbgr.mr_n71648048)
print v(xbgr.mr_n71752112)
print v(xbgr.mr_n71933264)
print v(xbgr.mr_n72064624)
print v(xbgr.mr_n72182464)
print v(xbgr.mr_n72350016)
print v(xbgr.mr_n72470960)
print v(xbgr.mr_n72664704)
print v(xbgr.mr_n72777920)
print v(xbgr.mr_n72885504)
print v(xbgr.mr_n73056832)
print v(xbgr.mr_n70369840)
print v(xbgr.mr_n70229792)
print v(xbgr.mr_n70695376)
print v(xbgr.mr_n70931888)
print v(xbgr.mr_n70369296)
print v(xbgr.mr_n70241760)
print v(xbgr.mr_n70695968)
print v(xbgr.mr_n70932480)
print v(xbgr.mr_n70368752)
print v(xbgr.mr_n70197440)
print v(xbgr.mr_n70687088)
print v(xbgr.mr_n70933072)
print v(xbgr.mr_n71001344)
print v(xbgr.mr_n71071184)
print v(xbgr.mr_n70773632)
print v(xbgr.mr_n71142528)
print v(xbgr.mr_n71298848)
print v(xbgr.mr_n71407712)
print v(xbgr.mr_n71511872)
print v(xbgr.mr_n71628848)
print v(xbgr.mr_n71748976)
print v(xbgr.mr_n71917616)
print v(xbgr.mr_n72032512)
print v(xbgr.mr_n72177552)
print v(xbgr.mr_n72349840)
print v(xbgr.mr_n72465184)
print v(xbgr.mr_n72630736)
print v(xbgr.mr_n72776224)
print v(xbgr.mr_n72887424)
print v(xbgr.mr_n73060736)
print v(xbgr.mr_n70368208)
print v(xbgr.mr_n70198816)
print v(xbgr.mr_n70697088)
print v(xbgr.mr_n70933664)
print v(xbgr.mr_n73394272)
print v(xbgr.mr_n73601872)
print v(xbgr.mr_n73809776)
print v(xbgr.mr_n73909600)
print v(xbgr.mr_n74118912)
print v(xbgr.mr_n74292496)
print v(xbgr.mr_n74468272)
print v(xbgr.mr_n74651232)
print v(xbgr.mr_n71746576)
print v(xbgr.mr_n74770048)
print v(xbgr.mr_n75063872)
print v(xbgr.mr_n75205408)
print v(xbgr.mr_n75443040)
print v(xbgr.mr_n75619232)
print v(xbgr.mr_n75837344)
print v(xbgr.mr_n76152832)
print v(xbgr.mr_n76311728)
print v(xbgr.mr_n76533184)
print v(xbgr.mr_n76712800)
print v(xbgr.mr_n71009664)
print v(xbgr.mr_n71045168)
print v(xbgr.mr_n70267920)
print v(xbgr.mr_n71163440)
print v(xbgr.mr_n71233248)
print v(xbgr.mr_n71360144)
print v(xbgr.mr_n71473296)
print v(xbgr.mr_n71631152)
print v(xbgr.mr_n71738288)
print v(xbgr.mr_n72032320)
print v(xbgr.mr_n72122736)
print v(xbgr.mr_n72254400)
print v(xbgr.mr_n72413232)
print v(xbgr.mr_n72530096)
print v(xbgr.mr_n72661472)
print v(xbgr.mr_n72880192)
print v(xbgr.mr_n73064864)
print v(xbgr.mr_n70367664)
print v(xbgr.mr_n70346800)
print v(xbgr.mr_n70682160)
print v(xbgr.mr_n70934256)
print v(xbgr.mr_n71032736)
print v(xbgr.mr_n71084960)
print v(xbgr.mr_n71093264)
print v(xbgr.mr_n71217072)
print v(xbgr.mr_n71322768)
print v(xbgr.mr_n71439184)
print v(xbgr.mr_n71513680)
print v(xbgr.mr_n71648928)
print v(xbgr.mr_n71747376)
print v(xbgr.mr_n71935072)
print v(xbgr.mr_n72066688)
print v(xbgr.mr_n72184272)
print v(xbgr.mr_n72350816)
print v(xbgr.mr_n72471760)
print v(xbgr.mr_n72667088)
print v(xbgr.mr_n72774304)
print v(xbgr.mr_n72878272)
print v(xbgr.mr_n73058896)
print v(xbgr.mr_n70367120)
print v(xbgr.mr_n70148720)
print v(xbgr.mr_n70698336)
print v(xbgr.mr_n70934848)
print v(xbgr.mr_n70366576)
print v(xbgr.mr_n70235424)
print v(xbgr.mr_n70698928)
print v(xbgr.mr_n70935440)
print v(xbgr.mr_n70366032)
print v(xbgr.mr_n70238272)
print v(xbgr.n_5)
print v(xbgr.mr_n70936032)
print v(xbgr.mr_n70365216)
print v(xbgr.mr_n70244576)
print v(xbgr.mr_n70690640)
print v(xbgr.mr_n70936624)
print v(xbgr.mr_n71008608)
print v(xbgr.mr_n71084784)
print v(xbgr.mr_n71095072)
print v(xbgr.mr_n70903264)
print v(xbgr.mr_n71272928)
print v(xbgr.mr_n71408896)
print v(xbgr.mr_n71509648)
print v(xbgr.mr_n71549776)
print v(xbgr.mr_n71772896)
print v(xbgr.mr_n71929040)
print v(xbgr.mr_n72063072)
print v(xbgr.mr_n72171456)
print v(xbgr.mr_n72345840)
print v(xbgr.mr_n72467584)
print v(xbgr.mr_n72629552)
print v(xbgr.mr_n72772608)
print v(xbgr.mr_n72891152)
print v(xbgr.mr_n73065088)
print v(xbgr.mr_n72934528)
print v(xbgr.mr_n73512768)
print v(xbgr.mr_n73824432)
print v(xbgr.mr_n73953232)
print v(xbgr.mr_n74123568)
print v(xbgr.mr_n74281360)
print v(xbgr.mr_n74483296)
print v(xbgr.mr_n74660144)
print v(xbgr.mr_n71786112)
print v(xbgr.mr_n74758688)
print v(xbgr.mr_n75068848)
print v(xbgr.mr_n75220960)
print v(xbgr.mr_n75423888)
print v(xbgr.mr_n75615488)
print v(xbgr.mr_n75850448)
print v(xbgr.mr_n76165200)
print v(xbgr.mr_n76282000)
print v(xbgr.mr_n76393952)
print v(xbgr.mr_n76764080)
print v(xbgr.mr_n70364944)
print v(xbgr.mr_n70160304)
print v(xbgr.mr_n70700704)
print v(xbgr.mr_n70937216)
print v(xbgr.mr_n71008720)
print v(xbgr.mr_n71044896)
print v(xbgr.mr_n70181280)
print v(xbgr.mr_n71162976)
print v(xbgr.mr_n71232784)
print v(xbgr.mr_n71361072)
print v(xbgr.mr_n71472912)
print v(xbgr.mr_n71630160)
print v(xbgr.mr_n71315792)
print v(xbgr.mr_n72061904)
print v(xbgr.mr_n72122144)
print v(xbgr.mr_n72253808)
print v(xbgr.mr_n72417152)
print v(xbgr.mr_n72529504)
print v(xbgr.mr_n72654560)
print v(xbgr.mr_n72885616)
print v(xbgr.mr_n73062912)
print v(xbgr.mr_n70363664)
print v(xbgr.mr_n70297040)
print v(xbgr.mr_n70685904)
print v(xbgr.mr_n70937808)
print v(xbgr.mr_n71034192)
print v(xbgr.mr_n71085760)
print v(xbgr.mr_n71103600)
print v(xbgr.mr_n71187872)
print v(xbgr.mr_n71321968)
print v(xbgr.mr_n71439584)
print v(xbgr.mr_n71518864)
print v(xbgr.mr_n71649904)
print v(xbgr.mr_n71774256)
print v(xbgr.mr_n71936720)
print v(xbgr.mr_n72068752)
print v(xbgr.mr_n72186080)
print v(xbgr.mr_n72351616)
print v(xbgr.mr_n72472560)
print v(xbgr.mr_n72668048)
print v(xbgr.mr_n72783344)
print v(xbgr.mr_n72882000)
print v(xbgr.mr_n73062800)
print v(xbgr.mr_n70324992)
print v(xbgr.mr_n70531472)
print v(xbgr.mr_n70701888)
print v(xbgr.mr_n70938400)
print v(xbgr.mr_n70325456)
print v(xbgr.mr_n70532128)
print v(xbgr.mr_n70702480)
print v(xbgr.mr_n70938992)
print v(xbgr.mr_n70325920)
print v(xbgr.mr_n70532720)
print v(xbgr.mr_n70703072)
print v(xbgr.mr_n70921824)
print v(xbgr.mr_n70326384)
print v(xbgr.mr_n70533312)
print v(xbgr.mr_n70694192)
print v(xbgr.mr_n70940096)
print v(xbgr.mr_n71003616)
print v(xbgr.mr_n71081120)
print v(xbgr.mr_n71100496)
print v(xbgr.mr_n71149632)
print v(xbgr.mr_n71273184)
print v(xbgr.mr_n71410080)
print v(xbgr.mr_n71513904)
print v(xbgr.mr_n71627520)
print v(xbgr.mr_n71773760)
print v(xbgr.mr_n71927296)
print v(xbgr.mr_n72003200)
print v(xbgr.mr_n72175744)
print v(xbgr.mr_n72350640)
print v(xbgr.mr_n72470784)
print v(xbgr.mr_n72628368)
print v(xbgr.mr_n72781648)
print v(xbgr.mr_n72889232)
print v(xbgr.mr_n73069216)
print v(xbgr.mr_n70015872)
print v(xbgr.mr_n73552432)
print v(xbgr.mr_n73815616)
print v(xbgr.mr_n73945072)
print v(xbgr.mr_n74108560)
print v(xbgr.mr_n74268752)
print v(xbgr.mr_n74464176)
print v(xbgr.mr_n74664608)
print v(xbgr.mr_n71773920)
print v(xbgr.mr_n74764368)
print v(xbgr.mr_n75073824)
print v(xbgr.mr_n75210192)
print v(xbgr.mr_n75420144)
print v(xbgr.mr_n75608112)
print v(xbgr.mr_n75855168)
print v(xbgr.mr_n76149360)
print v(xbgr.mr_n76322512)
print v(xbgr.mr_n76533888)
print v(xbgr.mr_n76632368)
print v(xbgr.mr_n71003728)
print v(xbgr.mr_n71044624)
print v(xbgr.mr_n70179024)
print v(xbgr.mr_n71162048)
print v(xbgr.mr_n71231856)
print v(xbgr.mr_n71360608)
print v(xbgr.mr_n71472304)
print v(xbgr.mr_n71629072)
print v(xbgr.mr_n71786832)
print v(xbgr.mr_n72063968)
print v(xbgr.mr_n72121152)
print v(xbgr.mr_n72252816)
print v(xbgr.mr_n72417760)
print v(xbgr.mr_n72528320)
print v(xbgr.mr_n72665248)
print v(xbgr.mr_n72876576)
print v(xbgr.mr_n73063024)
print v(xbgr.mr_n70326848)
print v(xbgr.mr_n70533904)
print v(xbgr.mr_n70704192)
print v(xbgr.mr_n70940768)
print v(xbgr.mr_n70327312)
print v(xbgr.mr_n70534496)
print v(xbgr.mr_n70689456)
print v(xbgr.mr_n70941360)
print v(xbgr.mr_n71035248)
print v(xbgr.mr_n70182736)
print v(xbgr.mr_n71105328)
print v(xbgr.mr_n71142080)
print v(xbgr.mr_n71321168)
print v(xbgr.mr_n71439984)
print v(xbgr.mr_n71521184)
print v(xbgr.mr_n71650544)
print v(xbgr.mr_n71744928)
print v(xbgr.mr_n71938608)
print v(xbgr.mr_n72070816)
print v(xbgr.mr_n72187888)
print v(xbgr.mr_n72352416)
print v(xbgr.mr_n72473360)
print v(xbgr.mr_n72669712)
print v(xbgr.mr_n72779840)
print v(xbgr.mr_n72890928)
print v(xbgr.mr_n73066928)
print v(xbgr.mr_n70327776)
print v(xbgr.mr_n70526208)
print v(xbgr.mr_n70705440)
print v(xbgr.mr_n70941952)
print v(xbgr.mr_n70323680)
print v(xbgr.mr_n70519104)
print v(xbgr.mr_n70706032)
print v(xbgr.mr_n70942512)
print v(xbgr.mr_n70328640)
print v(xbgr.mr_n70536208)
print v(xbgr.mr_n70706624)
print v(xbgr.n_31)
print v(xbgr.mr_n70998624)
print v(xbgr.mr_n71083984)
print v(xbgr.mr_n71086432)
print v(xbgr.mr_n71185520)
print v(xbgr.mr_n71144768)
print v(xbgr.mr_n71411264)
print v(xbgr.mr_n71516448)
print v(xbgr.mr_n71628336)
print v(xbgr.mr_n71773248)
print v(xbgr.mr_n71920016)
print v(xbgr.mr_n72069264)
print v(xbgr.mr_n72179360)
print v(xbgr.mr_n72352240)
print v(xbgr.mr_n72469984)
print v(xbgr.mr_n72627184)
print v(xbgr.mr_n72781536)
print v(xbgr.mr_n72892992)
print v(xbgr.mr_n73067152)
print v(xbgr.mr_n70329168)
print v(xbgr.mr_n70536864)
print v(xbgr.mr_n70697744)
print v(xbgr.mr_n70943664)
print v(xbgr.mr_n69677904)
print v(xbgr.mr_n73533152)
print v(xbgr.mr_n73804480)
print v(xbgr.mr_n73935408)
print v(xbgr.mr_n74088464)
print v(xbgr.mr_n74259088)
print v(xbgr.mr_n74461056)
print v(xbgr.mr_n74665072)
print v(xbgr.mr_n71790112)
print v(xbgr.mr_n74766624)
print v(xbgr.mr_n75078800)
print v(xbgr.mr_n75225792)
print v(xbgr.mr_n75406112)
print v(xbgr.mr_n75598000)
print v(xbgr.mr_n75860400)
print v(xbgr.mr_n76129456)
print v(xbgr.mr_n76251360)
print v(xbgr.mr_n76532912)
print v(xbgr.mr_n76725568)
print v(xbgr.mr_n70998736)
print v(xbgr.mr_n71044432)
print v(xbgr.mr_n70490128)
print v(xbgr.mr_n71161584)
print v(xbgr.mr_n71231392)
print v(xbgr.mr_n71359680)
print v(xbgr.mr_n71472000)
print v(xbgr.mr_n71555360)
print v(xbgr.mr_n71637072)
print v(xbgr.mr_n72066032)
print v(xbgr.mr_n72120688)
print v(xbgr.mr_n72252352)
print v(xbgr.mr_n72417424)
print v(xbgr.mr_n72527728)
print v(xbgr.mr_n72669216)
print v(xbgr.mr_n72889120)
print v(xbgr.mr_n73060960)
print v(xbgr.mr_n70329632)
print v(xbgr.mr_n70537456)
print v(xbgr.mr_n70707808)
print v(xbgr.mr_n70944256)
print v(xbgr.mr_n71036624)
print v(xbgr.mr_n71085584)
print v(xbgr.mr_n71107216)
print v(xbgr.mr_n71138560)
print v(xbgr.mr_n71320368)
print v(xbgr.mr_n71440384)
print v(xbgr.mr_n71519648)
print v(xbgr.mr_n71651760)
print v(xbgr.mr_n71785216)
print v(xbgr.mr_n71940416)
print v(xbgr.mr_n72072800)
print v(xbgr.mr_n72189696)
print v(xbgr.mr_n72353216)
print v(xbgr.mr_n72474160)
print v(xbgr.mr_n72671456)
print v(xbgr.mr_n72787072)
print v(xbgr.mr_n72887312)
print v(xbgr.mr_n73068992)
print v(xbgr.mr_n70330096)
print v(xbgr.mr_n70538048)
print v(xbgr.mr_n70693008)
print v(xbgr.mr_n70944848)
print v(xbgr.mr_n70330560)
print v(xbgr.n_34)
print v(xbgr.mr_n70708992)
print v(xbgr.mr_n70939584)
print v(xbgr.mr_n70331024)
print v(xbgr.mr_n70539232)
print v(xbgr.mr_n70709584)
print v(xbgr.mr_n70945952)
print v(xbgr.mr_n70331488)
print v(xbgr.mr_n70539824)
print v(xbgr.mr_n70710176)
print v(xbgr.mr_n70946624)
print v(xbgr.mr_n70993632)
print v(xbgr.mr_n70274368)
print v(xbgr.mr_n71098688)
print v(xbgr.mr_n71220800)
print v(xbgr.mr_n71236960)
print v(xbgr.mr_n71412448)
print v(xbgr.mr_n71522096)
print v(xbgr.mr_n71627632)
print v(xbgr.mr_n71778016)
print v(xbgr.mr_n71930800)
print v(xbgr.mr_n72059840)
print v(xbgr.mr_n72127472)
print v(xbgr.mr_n72348240)
print v(xbgr.mr_n72473984)
print v(xbgr.mr_n72558064)
print v(xbgr.mr_n72785264)
print v(xbgr.mr_n72897344)
print v(xbgr.mr_n73071168)
print v(xbgr.mr_n73384496)
print v(xbgr.mr_n73567248)
print v(xbgr.mr_n73793024)
print v(xbgr.mr_n73923376)
print v(xbgr.mr_n74099248)
print v(xbgr.mr_n74255712)
print v(xbgr.mr_n74449920)
print v(xbgr.mr_n74676624)
print v(xbgr.mr_n71767648)
print v(xbgr.mr_n74764176)
print v(xbgr.mr_n75083776)
print v(xbgr.mr_n75208176)
print v(xbgr.mr_n75398928)
print v(xbgr.mr_n75599264)
print v(xbgr.mr_n75865120)
print v(xbgr.mr_n76107344)
print v(xbgr.mr_n76252592)
print v(xbgr.mr_n76538368)
print v(xbgr.mr_n76772848)
print v(xbgr.mr_n70331952)
print v(xbgr.mr_n70540416)
print v(xbgr.mr_n70701296)
print v(xbgr.mr_n70947216)
print v(xbgr.mr_n70993744)
print v(xbgr.mr_n71043040)
print v(xbgr.mr_n70300656)
print v(xbgr.mr_n71160656)
print v(xbgr.mr_n71230480)
print v(xbgr.mr_n71359488)
print v(xbgr.mr_n71359024)
print v(xbgr.mr_n71555056)
print v(xbgr.mr_n71762176)
print v(xbgr.mr_n72061008)
print v(xbgr.mr_n72119760)
print v(xbgr.mr_n72251424)
print v(xbgr.mr_n72416880)
print v(xbgr.mr_n72526608)
print v(xbgr.mr_n72671968)
print v(xbgr.mr_n72893104)
print v(xbgr.mr_n73067040)
print v(xbgr.mr_n70332416)
print v(xbgr.mr_n70541008)
print v(xbgr.mr_n70711296)
print v(xbgr.mr_n70947808)
print v(xbgr.mr_n71038160)
print v(xbgr.mr_n70177872)
print v(xbgr.mr_n71108944)
print v(xbgr.mr_n70505120)
print v(xbgr.mr_n71319568)
print v(xbgr.mr_n71440784)
print v(xbgr.mr_n71523792)
print v(xbgr.mr_n71652640)
print v(xbgr.mr_n71778128)
print v(xbgr.mr_n71942224)
print v(xbgr.mr_n72074944)
print v(xbgr.mr_n72191504)
print v(xbgr.mr_n72354016)
print v(xbgr.mr_n72474960)
print v(xbgr.mr_n72673056)
print v(xbgr.mr_n72783456)
print v(xbgr.mr_n72895056)
print v(xbgr.mr_n73064976)
print v(xbgr.mr_n70319104)
print v(xbgr.mr_n70541600)
print v(xbgr.mr_n70696560)
print v(xbgr.mr_n70948400)
print v(xbgr.mr_n70333280)
print v(xbgr.mr_n70542192)
print v(xbgr.mr_n70712544)
print v(xbgr.mr_n70948992)
print v(xbgr.mr_n70333808)
print v(xbgr.mr_n70517840)
print v(xbgr.mr_n70713136)
print v(xbgr.mr_n70949584)
print v(xbgr.mr_n70334272)
print v(xbgr.mr_n70463712)
print v(xbgr.n_10)
print v(xbgr.mr_n70906096)
print v(xbgr.mr_n70988640)
print v(xbgr.mr_n70248432)
print v(xbgr.mr_n71096880)
print v(xbgr.mr_n71219712)
print v(xbgr.mr_n71272672)
print v(xbgr.mr_n71413632)
print v(xbgr.mr_n71526560)
print v(xbgr.mr_n71547056)
print v(xbgr.mr_n71751376)
print v(xbgr.mr_n71933776)
print v(xbgr.mr_n72065136)
print v(xbgr.mr_n72167376)
print v(xbgr.mr_n72325504)
print v(xbgr.mr_n72471584)
print v(xbgr.mr_n72470160)
print v(xbgr.mr_n72785152)
print v(xbgr.mr_n72893216)
print v(xbgr.mr_n73074304)
print v(xbgr.mr_n70013520)
print v(xbgr.mr_n73565136)
print v(xbgr.mr_n73785200)
print v(xbgr.mr_n73913984)
print v(xbgr.mr_n74142192)
print v(xbgr.mr_n74238400)
print v(xbgr.mr_n74441328)
print v(xbgr.mr_n74681600)
print v(xbgr.mr_n71760080)
print v(xbgr.mr_n74763600)
print v(xbgr.mr_n75088752)
print v(xbgr.mr_n75221472)
print v(xbgr.mr_n75385664)
print v(xbgr.mr_n75587888)
print v(xbgr.mr_n75862224)
print v(xbgr.mr_n76001152)
print v(xbgr.mr_n76225440)
print v(xbgr.mr_n76409792)
print v(xbgr.mr_n76721088)
print v(xbgr.mr_n70988752)
print v(xbgr.mr_n71033856)
print v(xbgr.mr_n71078688)
print v(xbgr.mr_n71160192)
print v(xbgr.mr_n71230016)
print v(xbgr.mr_n71357760)
print v(xbgr.mr_n71417808)
print v(xbgr.mr_n71526448)
print v(xbgr.mr_n71847216)
print v(xbgr.mr_n72074288)
print v(xbgr.mr_n72119296)
print v(xbgr.mr_n72250960)
print v(xbgr.mr_n72411456)
print v(xbgr.mr_n72526144)
print v(xbgr.mr_n72667872)
print v(xbgr.mr_n72897232)
print v(xbgr.mr_n73071056)
print v(xbgr.mr_n70334736)
print v(xbgr.mr_n70530864)
print v(xbgr.mr_n70704848)
print v(xbgr.mr_n70950688)
print v(xbgr.mr_n70335200)
print v(xbgr.mr_n70544496)
print v(xbgr.mr_n70714912)
print v(xbgr.mr_n70627312)
print v(xbgr.mr_n71039856)
print v(xbgr.mr_n70216688)
print v(xbgr.mr_n71110752)
print v(xbgr.mr_n71220544)
print v(xbgr.mr_n71318848)
print v(xbgr.mr_n71441184)
print v(xbgr.mr_n71518112)
print v(xbgr.mr_n71653616)
print v(xbgr.mr_n71790288)
print v(xbgr.mr_n71943952)
print v(xbgr.mr_n72072224)
print v(xbgr.mr_n72193312)
print v(xbgr.mr_n72354816)
print v(xbgr.mr_n72475760)
print v(xbgr.mr_n72674400)
print v(xbgr.mr_n72790576)
print v(xbgr.mr_n72897120)
print v(xbgr.mr_n73073824)
print v(xbgr.mr_n70335664)
print v(xbgr.mr_n70545152)
print v(xbgr.mr_n70700112)
print v(xbgr.mr_n70736816)
print v(xbgr.mr_n70336128)
print v(xbgr.mr_n70150864)
print v(xbgr.mr_n70716096)
print v(xbgr.mr_n70626096)
print v(xbgr.mr_n70336592)
print v(xbgr.mr_n70500576)
print v(xbgr.mr_n70716688)
print v(xbgr.mr_n70906208)
print v(xbgr.mr_n70984880)
print v(xbgr.mr_n71078352)
print v(xbgr.mr_n71101552)
print v(xbgr.mr_n71194256)
print v(xbgr.mr_n71153616)
print v(xbgr.mr_n71414816)
print v(xbgr.mr_n71503792)
print v(xbgr.mr_n71602560)
print v(xbgr.mr_n71797504)
print v(xbgr.mr_n71931968)
print v(xbgr.mr_n72067200)
print v(xbgr.mr_n72186592)
print v(xbgr.mr_n72351440)
print v(xbgr.mr_n72464384)
print v(xbgr.mr_n72557360)
print v(xbgr.mr_n72779728)
print v(xbgr.mr_n72899184)
print v(xbgr.mr_n73081792)
print v(xbgr.mr_n70337056)
print v(xbgr.mr_n70530352)
print v(xbgr.mr_n70717280)
print v(xbgr.mr_n70857824)
print v(xbgr.mr_n73155408)
print v(xbgr.mr_n73555536)
print v(xbgr.mr_n73776624)
print v(xbgr.mr_n73909328)
print v(xbgr.mr_n74127184)
print v(xbgr.mr_n74205424)
print v(xbgr.mr_n74412416)
print v(xbgr.mr_n74686576)
print v(xbgr.mr_n71778304)
print v(xbgr.mr_n74763792)
print v(xbgr.mr_n75049584)
print v(xbgr.mr_n75172944)
print v(xbgr.mr_n75352912)
print v(xbgr.mr_n75616000)
print v(xbgr.mr_n75790304)
print v(xbgr.mr_n76087488)
print v(xbgr.mr_n76223376)
print v(xbgr.mr_n76507504)
print v(xbgr.mr_n76898480)
print v(xbgr.mr_n70956400)
print v(xbgr.mr_n71043968)
print v(xbgr.mr_n70190400)
print v(xbgr.mr_n71159264)
print v(xbgr.mr_n70856928)
print v(xbgr.mr_n71353952)
print v(xbgr.mr_n71361536)
print v(xbgr.mr_n71549312)
print v(xbgr.mr_n71892928)
print v(xbgr.mr_n71966464)
print v(xbgr.mr_n72082432)
print v(xbgr.mr_n72221312)
print v(xbgr.mr_n72415008)
print v(xbgr.mr_n72475584)
print v(xbgr.mr_n72670224)
print v(xbgr.mr_n72895280)
print v(xbgr.mr_n73071280)
print v(xbgr.mr_n70314464)
print v(xbgr.mr_n70222048)
print v(xbgr.mr_n70708400)
print v(xbgr.mr_n70901904)
print v(xbgr.mr_n71041072)
print v(xbgr.mr_n70278000)
print v(xbgr.mr_n71112640)
print v(xbgr.mr_n71194512)
print v(xbgr.mr_n71304992)
print v(xbgr.mr_n71441584)
print v(xbgr.mr_n71528784)
print v(xbgr.mr_n71653264)
print v(xbgr.mr_n71789408)
print v(xbgr.mr_n71945760)
print v(xbgr.mr_n72078816)
print v(xbgr.mr_n72195040)
print v(xbgr.mr_n72355616)
print v(xbgr.mr_n72476560)
print v(xbgr.mr_n72677344)
print v(xbgr.mr_n72788880)
print v(xbgr.mr_n72895168)
print v(xbgr.mr_n73069104)
print v(xbgr.mr_n70337920)
print v(xbgr.mr_n70456704)
print v(xbgr.mr_n70718400)
print v(xbgr.mr_n70903664)
print v(xbgr.mr_n70338448)
print v(xbgr.mr_n70535088)
print v(xbgr.mr_n70703664)
print v(xbgr.mr_n70902896)
print v(xbgr.mr_n70338912)
print v(xbgr.mr_n70294272)
print v(xbgr.mr_n70719648)
print v(xbgr.mr_n70816128)
print v(xbgr.mr_n70339376)
print v(xbgr.mr_n70289232)
print v(xbgr.mr_n70720240)
print v(xbgr.mr_n70822816)
print v(xbgr.mr_n70339840)
print v(xbgr.mr_n70509920)
print v(xbgr.mr_n70720832)
print v(xbgr.mr_n70902304)
print v(xbgr.mr_n70312608)
print v(xbgr.mr_n70543888)
print v(xbgr.mr_n70711952)
print v(xbgr.mr_n70826464)
print v(xbgr.mr_n70340768)
print v(xbgr.mr_n70512912)
print v(xbgr.mr_n70719056)
print v(xbgr.mr_n70951008)
print v(xbgr.mr_n70341232)
print v(xbgr.mr_n70246256)
print v(xbgr.mr_n70707216)
print v(xbgr.mr_n70859200)
print v(xbgr.mr_n71197808)
print v(xbgr.mr_n72676256)
print v(xbgr.mr_n72901472)
print v(xbgr.mr_n73077920)
print v(xbgr.mr_n70341696)
print v(xbgr.mr_n70545712)
print v(xbgr.mr_n70723200)
print v(xbgr.mr_n70952224)
print v(xbgr.d5)
print v(xbgr.d1)
print v(xbgr.mr_n70426944)
print v(xbgr.mr_n71529008)
print v(xbgr.mr_n71041696)
print v(xbgr.mr_n71109536)
print v(xbgr.mr_n71531808)
print v(xbgr.mr_n72675136)
print v(xbgr.n1)
print v(xbgr.mr_n73082272)
print v(xbgr.mr_n70328240)
print v(xbgr.mr_n70535600)
print v(xbgr.mr_n70723792)
print v(xbgr.mr_n70950176)
print v(xbgr.mr_n72473184)
print v(xbgr.mr_n72702240)
print v(xbgr.mr_n72907920)
print v(xbgr.mr_n70982096)
print v(xbgr.mr_n71074208)
print v(xbgr.kick)
print v(xbgr.mr_n71373856)
print v(xbgr.mr_n72674912)
print v(xbgr.mr_n72843568)
print v(xbgr.mr_n73077808)
print v(xbgr.mr_n70342560)
print v(xbgr.mr_n70509696)
print v(xbgr.mr_n70724384)
print v(xbgr.mr_n70930112)
print v(xbgr.mr_n70343088)
print v(xbgr.mr_n70547152)
print v(xbgr.mr_n70715504)
print v(xbgr.mr_n70951440)
print v(xbgr.mr_n71037824)
print v(xbgr.mr_n71113152)
print v(xbgr.mr_n71174208)
print v(xbgr.mr_n71524288)
print v(xbgr.mr_n72677856)
print v(xbgr.mr_n72891040)
print v(xbgr.mr_n73078288)
print v(xbgr.mr_n71652464)
print v(xbgr.mr_n71800336)
print v(xbgr.mr_n71870000)
print v(xbgr.mr_n71888192)
print v(xbgr.mr_n72193824)
print v(xbgr.mr_n72322800)
print v(xbgr.mr_n72433712)
print v(xbgr.mr_n71654256)
print v(xbgr.mr_n71763520)
print v(xbgr.mr_n71843280)
print v(xbgr.mr_n71940928)
print v(xbgr.mr_n72190208)
print v(xbgr.mr_n72325392)
print v(xbgr.mr_n72447824)
print v(xbgr.mr_n70343552)
print v(xbgr.mr_n70547696)
print v(xbgr.mr_n70725504)
print v(xbgr.mr_n70819168)
print v(xbgr.mr_n72673568)
print v(xbgr.mr_n72843232)
print v(xbgr.mr_n73088848)
print v(xbgr.mr_n71555744)
print v(xbgr.mr_n71685744)
print v(xbgr.mr_n71819392)
print v(xbgr.mr_n71879136)
print v(xbgr.mr_n72092848)
print v(xbgr.mr_n72218624)
print v(xbgr.mr_n72345040)
print v(xbgr.mr_n72489104)
print v(xbgr.mr_n72719360)
print v(xbgr.mr_n72920480)
print v(xbgr.mr_n70344016)
print v(xbgr.mr_n70548736)
print v(xbgr.mr_n70710768)
print v(xbgr.mr_n70952768)
print v(xbgr.mr_n72678512)
print v(xbgr.mr_n72843680)
print v(xbgr.mr_n73086256)
print v(xbgr.mr_n71197536)
print v(xbgr.mr_n71651248)
print v(xbgr.d2)
print v(xbgr.mr_n71859888)
print v(xbgr.mr_n71944544)
print v(xbgr.mr_n72188400)
print v(xbgr.mr_n72284592)
print v(xbgr.mr_n72409680)
print v(xbgr.mr_n71041920)
print v(xbgr.mr_n71113264)
print v(xbgr.mr_n71531504)
print v(xbgr.mr_n70344480)
print v(xbgr.mr_n70549488)
print v(xbgr.mr_n70726752)
print v(xbgr.mr_n70957056)
print v(xbgr.mr_n71042032)
print v(xbgr.mr_n71105920)
print v(xbgr.mr_n71532320)
print v(xbgr.mr_n72679248)
print v(xbgr.mr_n72899296)
print v(xbgr.mr_n73081904)
print v(xbgr.mr_n71196432)
print v(xbgr.mr_n70344944)
print v(xbgr.mr_n70550080)
print v(xbgr.mr_n70727344)
print v(xbgr.mr_n70863024)
print v(xbgr.mr_n70982640)
print v(xbgr.mr_n71073936)
print v(xbgr.mr_n71417072)
print v(xbgr.det)
print v(xbgr.mr_n72680048)
print v(xbgr.mr_n72843456)
print v(xbgr.mr_n73073936)
print v(xbgr.mr_n71166224)
print v(xbgr.mr_n70345408)
print v(xbgr.mr_n70550656)
print v(xbgr.mr_n70727936)
print v(xbgr.mr_n70957584)
print v(xbgr.mr_n72490880)
print v(xbgr.mr_n72718896)
print v(xbgr.mr_n72922336)
print v(xbgr.mr_n71040720)
print v(xbgr.mr_n70661440)
print v(xbgr.mr_n71526752)
print v(xbgr.mr_n72677968)
print v(xbgr.mr_n72844384)
print v(xbgr.mr_n73090464)
print v(xbgr.mr_n71654864)
print v(xbgr.mr_n71797040)
print v(xbgr.mr_n71869888)
print v(xbgr.mr_n71917792)
print v(xbgr.mr_n72184784)
print v(xbgr.mr_n72314752)
print v(xbgr.mr_n72440000)
print v(xbgr.mr_n71654976)
print v(xbgr.mr_n71806016)
print v(xbgr.mr_n71860608)
print v(xbgr.mr_n71946464)
print v(xbgr.mr_n72195856)
print v(xbgr.mr_n72318688)
print v(xbgr.mr_n72444832)
print v(xbgr.mr_n70345872)
print v(xbgr.mr_n70551248)
print v(xbgr.mr_n70722016)
print v(xbgr.mr_n70747360)
print v(xbgr.mr_n71579024)
print v(xbgr.mr_n71687664)
print v(xbgr.mr_n71824144)
print v(xbgr.mr_n71893744)
print v(xbgr.mr_n72096880)
print v(xbgr.mr_n72222656)
print v(xbgr.mr_n72356160)
print v(xbgr.mr_n72681408)
print v(xbgr.mr_n72903312)
print v(xbgr.mr_n73088960)
print v(xbgr.mr_n70346336)
print v(xbgr.mr_n70545824)
print v(xbgr.mr_n70726160)
print v(xbgr.mr_n70499568)
print v(xbgr.mr_n72679136)
print v(xbgr.mr_n72848272)
print v(xbgr.mr_n73093744)
print v(xbgr.mr_n70332880)
print v(xbgr.mr_n70364208)
print v(xbgr.mr_n70714320)
print v(xbgr.mr_n70964000)
print v(xbgr.mr_n71116064)
print v(xbgr.mr_n71654528)
print v(xbgr.mr_n71752304)
print v(xbgr.mr_n71874064)
print v(xbgr.mr_n71937312)
print v(xbgr.mr_n72196352)
print v(xbgr.mr_n72282224)
print v(xbgr.mr_n72413888)
print v(xbgr.mr_n71042656)
print v(xbgr.mr_n71114224)
print v(xbgr.mr_n71533008)
print v(xbgr.mr_n72492736)
print v(xbgr.mr_n72718432)
print v(xbgr.mr_n72924192)
print v(xbgr.mr_n71042768)
print v(xbgr.mr_n71113760)
print v(xbgr.mr_n71533632)
print v(xbgr.mr_n72683584)
print v(xbgr.mr_n72847088)
print v(xbgr.mr_n73092928)
print v(xbgr.mr_n70347200)
print v(xbgr.mr_n70546768)
print v(xbgr.mr_n70730304)
print v(xbgr.mr_n70964224)
print v(xbgr.mr_n71170080)
print v(xbgr.mr_n70982368)
print v(xbgr.mr_n71073664)
print v(xbgr.mr_n71119648)
print v(xbgr.mr_n71417344)
print v(xbgr.r4n)
print v(xbgr.mr_n70347728)
print v(xbgr.mr_n70509088)
print v(xbgr.mr_n70730896)
print v(xbgr.mr_n70964336)
print v(xbgr.mr_n72682080)
print v(xbgr.mr_n72905200)
print v(xbgr.mr_n73085888)
print v(xbgr.mr_n71041808)
print v(xbgr.mr_n71114960)
print v(xbgr.mr_n71531616)
print v(xbgr.mr_n71655600)
print v(xbgr.mr_n71794640)
print v(xbgr.mr_n71871360)
print v(xbgr.mr_n71935584)
print v(xbgr.mr_n72195744)
print v(xbgr.mr_n72321632)
print v(xbgr.mr_n72444480)
print v(xbgr.mr_n71654752)
print v(xbgr.mr_n71790784)
print v(xbgr.mr_n71868864)
print v(xbgr.mr_n71939120)
print v(xbgr.mr_n72196240)
print v(xbgr.mr_n72321984)
print v(xbgr.mr_n72439536)
print v(xbgr.mr_n70348192)
print v(xbgr.mr_n70554128)
print v(xbgr.mr_n70731488)
print v(xbgr.mr_n70964448)
print v(xbgr.mr_n72679712)
print v(xbgr.mr_n72846496)
print v(xbgr.mr_n73091360)
print v(xbgr.mr_n72494592)
print v(xbgr.mr_n72717968)
print v(xbgr.mr_n72926048)
print v(xbgr.mr_n71578560)
print v(xbgr.mr_n71687136)
print v(xbgr.mr_n71824960)
print v(xbgr.mr_n71894560)
print v(xbgr.mr_n72097696)
print v(xbgr.mr_n72223472)
print v(xbgr.mr_n72356576)
print v(xbgr.mr_n70348656)
print v(xbgr.mr_n70554800)
print v(xbgr.mr_n70722608)
print v(xbgr.mr_n70964560)
print v(xbgr.mr_n72681520)
print v(xbgr.mr_n72848864)
print v(xbgr.mr_n73093920)
print v(xbgr.mr_n70349120)
print v(xbgr.mr_n70555392)
print v(xbgr.mr_n70732608)
print v(xbgr.mr_n70964672)
print v(xbgr.mr_n71194784)
print v(xbgr.mr_n71655712)
print v(xbgr.mr_n71808608)
print v(xbgr.mr_n71872800)
print v(xbgr.mr_n71946992)
print v(xbgr.mr_n72196816)
print v(xbgr.mr_n72283408)
print v(xbgr.mr_n72407904)
print v(xbgr.mr_n72685552)
print v(xbgr.mr_n72908688)
print v(xbgr.mr_n73091184)
print v(xbgr.mr_n71043392)
print v(xbgr.mr_n71115072)
print v(xbgr.mr_n71524016)
print v(xbgr.mr_n71038672)
print v(xbgr.mr_n71115440)
print v(xbgr.mr_n71535200)
print v(xbgr.mr_n70349584)
print v(xbgr.mr_n70555984)
print v(xbgr.mr_n70717872)
print v(xbgr.mr_n70964896)
print v(xbgr.mr_n72682336)
print v(xbgr.mr_n72850048)
print v(xbgr.mr_n73095488)
print v(xbgr.mr_n71188352)
print v(xbgr.mr_n70981824)
print v(xbgr.mr_n71073392)
print v(xbgr.mr_n71416880)
print v(xbgr.mr_n71135792)
print v(xbgr.mr_n72496448)
print v(xbgr.mr_n72717504)
print v(xbgr.mr_n72927904)
print v(xbgr.mr_n70350048)
print v(xbgr.mr_n70543312)
print v(xbgr.mr_n70733856)
print v(xbgr.mr_n70965088)
print v(xbgr.mr_n71171296)
print v(xbgr.mr_n72685440)
print v(xbgr.mr_n72850640)
print v(xbgr.mr_n73098048)
print v(xbgr.mr_n71042304)
print v(xbgr.mr_n71113376)
print v(xbgr.mr_n71535728)
print v(xbgr.mr_n70350512)
print v(xbgr.mr_n70557104)
print v(xbgr.mr_n70734448)
print v(xbgr.mr_n70965360)
print v(xbgr.mr_n71654640)
print v(xbgr.mr_n71809888)
print v(xbgr.mr_n71874256)
print v(xbgr.mr_n71946800)
print v(xbgr.mr_n72197440)
print v(xbgr.mr_n72308464)
print v(xbgr.mr_n72438272)
print v(xbgr.mr_n71657632)
print v(xbgr.mr_n71806592)
print v(xbgr.mr_n71873872)
print v(xbgr.mr_n71947536)
print v(xbgr.mr_n72192016)
print v(xbgr.mr_n72315280)
print v(xbgr.mr_n72445648)
print v(xbgr.mr_n72688128)
print v(xbgr.mr_n72910320)
print v(xbgr.mr_n73085776)
print v(xbgr.mr_n70350976)
print v(xbgr.mr_n70551840)
print v(xbgr.mr_n70735040)
print v(xbgr.mr_n70965632)
print v(xbgr.mr_n71578096)
print v(xbgr.mr_n71686672)
print v(xbgr.mr_n71825776)
print v(xbgr.mr_n71895296)
print v(xbgr.mr_n72098512)
print v(xbgr.mr_n72224288)
print v(xbgr.mr_n72357392)
print v(xbgr.mr_n72689056)
print v(xbgr.mr_n72851232)
print v(xbgr.mr_n73096480)
print v(xbgr.mr_n70337520)
print v(xbgr.mr_n70558272)
print v(xbgr.mr_n70729120)
print v(xbgr.mr_n70965904)
print v(xbgr.mr_n72498304)
print v(xbgr.mr_n72717056)
print v(xbgr.mr_n72929792)
print v(xbgr.mr_n71656256)
print v(xbgr.mr_n71798384)
print v(xbgr.mr_n71861680)
print v(xbgr.mr_n71947808)
print v(xbgr.mr_n72199392)
print v(xbgr.mr_n72286368)
print v(xbgr.mr_n72412112)
print v(xbgr.mr_n72690000)
print v(xbgr.mr_n72849456)
print v(xbgr.mr_n73096304)
print v(xbgr.mr_n71040896)
print v(xbgr.mr_n71117392)
print v(xbgr.d3)
print v(xbgr.mr_n71532656)
print v(xbgr.mr_n71038784)
print v(xbgr.mr_n71111344)
print v(xbgr.mr_n71358192)
print v(xbgr.mr_n71529280)
print v(xbgr.mr_n70351840)
print v(xbgr.mr_n70558944)
print v(xbgr.mr_n70736224)
print v(xbgr.mr_n70966176)
print v(xbgr.mr_n70981552)
print v(xbgr.mr_n71073120)
print v(xbgr.mr_n71175216)
print v(xbgr.mr_n71415696)
print v(xbgr.mr_n72690528)
print v(xbgr.mr_n72911952)
print v(xbgr.mr_n73099040)
print v(xbgr.mr_n70352368)
print v(xbgr.mr_n70559536)
print v(xbgr.mr_n70721424)
print v(xbgr.mr_n70966448)
print v(xbgr.mr_n72687712)
print v(xbgr.mr_n72845520)
print v(xbgr.mr_n73100608)
print v(xbgr.mr_n70352832)
print v(xbgr.mr_n70560128)
print v(xbgr.mr_n70737408)
print v(xbgr.mr_n70967152)
print v(xbgr.mr_n71039520)
print v(xbgr.mr_n71114608)
print v(xbgr.mr_n71325280)
print v(xbgr.mr_n71537232)
print v(xbgr.mr_n71655824)
print v(xbgr.mr_n71789520)
print v(xbgr.mr_n71868288)
print v(xbgr.mr_n71946688)
print v(xbgr.mr_n72077520)
print v(xbgr.mr_n72198960)
print v(xbgr.mr_n72318224)
print v(xbgr.mr_n72439888)
print v(xbgr.mr_n71658928)
print v(xbgr.mr_n71798608)
print v(xbgr.mr_n71820320)
print v(xbgr.mr_n71948400)
print v(xbgr.mr_n72079328)
print v(xbgr.mr_n72200496)
print v(xbgr.mr_n72318576)
print v(xbgr.mr_n72435056)
print v(xbgr.mr_n72500160)
print v(xbgr.mr_n72716592)
print v(xbgr.mr_n72932160)
print v(xbgr.mr_n72691408)
print v(xbgr.mr_n72847680)
print v(xbgr.mr_n73103168)
print v(xbgr.mr_n70353296)
print v(xbgr.mr_n70557760)
print v(xbgr.mr_n70738000)
print v(xbgr.mr_n70967552)
print v(xbgr.mr_n71577632)
print v(xbgr.mr_n71686208)
print v(xbgr.mr_n71826592)
print v(xbgr.mr_n71894832)
print v(xbgr.mr_n71971168)
print v(xbgr.mr_n72099328)
print v(xbgr.mr_n72225104)
print v(xbgr.mr_n72358208)
print v(xbgr.mr_n70353760)
print v(xbgr.mr_n70561232)
print v(xbgr.mr_n70738592)
print v(xbgr.mr_n70967952)
print v(xbgr.mr_n72690640)
print v(xbgr.mr_n72913040)
print v(xbgr.mr_n73098864)
print v(xbgr.mr_n71657264)
print v(xbgr.mr_n71802752)
print v(xbgr.mr_n71861904)
print v(xbgr.mr_n71942736)
print v(xbgr.mr_n72079664)
print v(xbgr.mr_n72198336)
print v(xbgr.mr_n72285776)
print v(xbgr.mr_n72406128)
print v(xbgr.mr_n71037216)
print v(xbgr.mr_n71118960)
print v(xbgr.mr_n71352928)
print v(xbgr.mr_n71536768)
print v(xbgr.mr_n71039344)
print v(xbgr.mr_n71118080)
print v(xbgr.mr_n71357216)
print v(xbgr.mr_n71538336)
print v(xbgr.mr_n70340304)
print v(xbgr.mr_n70552960)
print v(xbgr.mr_n70729712)
print v(xbgr.mr_n70968352)
print v(xbgr.mr_n72683760)
print v(xbgr.mr_n72753856)
print v(xbgr.mr_n73101600)
print v(xbgr.mr_n72501088)
print v(xbgr.mr_n72716128)
print v(xbgr.mr_n72933344)
print v(xbgr.mr_n70354688)
print v(xbgr.mr_n70562416)
print v(xbgr.mr_n70739712)
print v(xbgr.mr_n70954272)
print v(xbgr.mr_n70981280)
print v(xbgr.mr_n71072848)
print v(xbgr.mr_n70424496)
print v(xbgr.mr_n71414512)
print v(xbgr.mr_n72694112)
print v(xbgr.mr_n72844112)
print v(xbgr.mr_n73105728)
print v(xbgr.mr_n70355152)
print v(xbgr.mr_n70546064)
print v(xbgr.mr_n70724976)
print v(xbgr.mr_n70969552)
print v(xbgr.mr_n71036368)
print v(xbgr.mr_n71113488)
print v(xbgr.mr_n71325824)
print v(xbgr.mr_n71538864)
print v(xbgr.mr_n72694960)
print v(xbgr.mr_n72915216)
print v(xbgr.mr_n73101424)
print v(xbgr.mr_n71659904)
print v(xbgr.mr_n71805632)
print v(xbgr.mr_n71875280)
print v(xbgr.mr_n71949216)
print v(xbgr.mr_n72079440)
print v(xbgr.mr_n72202496)
print v(xbgr.mr_n72303984)
print v(xbgr.mr_n72424016)
print v(xbgr.mr_n71660800)
print v(xbgr.mr_n71799056)
print v(xbgr.mr_n71862352)
print v(xbgr.mr_n71946576)
print v(xbgr.mr_n72080624)
print v(xbgr.mr_n72197552)
print v(xbgr.mr_n72311872)
print v(xbgr.mr_n72440704)
print v(xbgr.mr_n70355616)
print v(xbgr.mr_n70560720)
print v(xbgr.mr_n70740960)
print v(xbgr.mr_n70969952)
print v(xbgr.mr_n72695776)
print v(xbgr.mr_n72843344)
print v(xbgr.mr_n73109104)
print v(xbgr.mr_n71577168)
print v(xbgr.mr_n71685280)
print v(xbgr.mr_n71827664)
print v(xbgr.mr_n71894288)
print v(xbgr.mr_n71973632)
print v(xbgr.mr_n72100144)
print v(xbgr.mr_n72225920)
print v(xbgr.mr_n72359024)
print v(xbgr.mr_n72500624)
print v(xbgr.mr_n72715664)
print v(xbgr.mr_n72932752)
print v(xbgr.mr_n70342160)
print v(xbgr.mr_n70564192)
print v(xbgr.mr_n70741552)
print v(xbgr.mr_n70970352)
print v(xbgr.mr_n72696720)
print v(xbgr.mr_n72760256)
print v(xbgr.mr_n73108288)
print v(xbgr.mr_n71658320)
print v(xbgr.mr_n71799872)
print v(xbgr.mr_n71863168)
print v(xbgr.mr_n71951936)
print v(xbgr.mr_n72081712)
print v(xbgr.mr_n72204096)
print v(xbgr.mr_n72285184)
print v(xbgr.mr_n72410336)
print v(xbgr.mr_n70356480)
print v(xbgr.mr_n70561904)
print v(xbgr.mr_n70742144)
print v(xbgr.mr_n70958176)
print v(xbgr.mr_n71030048)
print v(xbgr.mr_n71120528)
print v(xbgr.mr_n71271568)
print v(xbgr.mr_n71536080)
print v(xbgr.mr_n71037648)
print v(xbgr.mr_n71117040)
print v(xbgr.mr_n71312944)
print v(xbgr.mr_n71539904)
print v(xbgr.mr_n72697248)
print v(xbgr.mr_n72913584)
print v(xbgr.mr_n73103984)
print v(xbgr.mr_n70357008)
print v(xbgr.mr_n70565376)
print v(xbgr.mr_n70733264)
print v(xbgr.mr_n70971552)
print v(xbgr.mr_n70981008)
print v(xbgr.mr_n71072576)
print v(xbgr.mr_n71216672)
print v(xbgr.mr_n71413328)
print v(xbgr.mr_n72692752)
print v(xbgr.mr_n72643840)
print v(xbgr.mr_n73106720)
print v(xbgr.mr_n70357472)
print v(xbgr.mr_n70566048)
print v(xbgr.mr_n70743328)
print v(xbgr.mr_n70971952)
print v(xbgr.mr_n72499696)
print v(xbgr.mr_n72715200)
print v(xbgr.mr_n72931568)
print v(xbgr.mr_n71035760)
print v(xbgr.mr_n71118544)
print v(xbgr.mr_n71325552)
print v(xbgr.mr_n71540432)
print v(xbgr.mr_n71661488)
print v(xbgr.mr_n71798496)
print v(xbgr.mr_n71861792)
print v(xbgr.mr_n71949648)
print v(xbgr.mr_n72080512)
print v(xbgr.mr_n72201808)
print v(xbgr.mr_n72315168)
print v(xbgr.mr_n72434240)
print v(xbgr.mr_n72698464)
print v(xbgr.mr_n72840752)
print v(xbgr.mr_n73110848)
print v(xbgr.mr_n71658432)
print v(xbgr.mr_n71810784)
print v(xbgr.mr_n71863632)
print v(xbgr.mr_n71951504)
print v(xbgr.mr_n72081536)
print v(xbgr.mr_n72203664)
print v(xbgr.mr_n72303120)
print v(xbgr.mr_n72438704)
print v(xbgr.mr_n70357936)
print v(xbgr.mr_n70563680)
print v(xbgr.mr_n70728528)
print v(xbgr.mr_n70963888)
print v(xbgr.mr_n71576704)
print v(xbgr.mr_n71684816)
print v(xbgr.mr_n71828128)
print v(xbgr.mr_n71894016)
print v(xbgr.mr_n71974448)
print v(xbgr.mr_n72100960)
print v(xbgr.mr_n72226736)
print v(xbgr.mr_n72359840)
print v(xbgr.mr_n70324544)
print v(xbgr.mr_n70553536)
print v(xbgr.mr_n70744512)
print v(xbgr.mr_n70972672)
print v(xbgr.mr_n72699280)
print v(xbgr.mr_n72914672)
print v(xbgr.mr_n73104160)
print v(xbgr.mr_n72697136)
print v(xbgr.mr_n72843120)
print v(xbgr.mr_n73106544)
print v(xbgr.mr_n70324144)
print v(xbgr.mr_n70567824)
print v(xbgr.mr_n70678368)
print v(xbgr.mr_n70973152)
print v(xbgr.mr_n71663248)
print v(xbgr.mr_n71799408)
print v(xbgr.mr_n71862704)
print v(xbgr.mr_n71953040)
print v(xbgr.mr_n72081056)
print v(xbgr.mr_n72203184)
print v(xbgr.mr_n72282816)
print v(xbgr.mr_n72404352)
print v(xbgr.mr_n71030608)
print v(xbgr.mr_n71122096)
print v(xbgr.mr_n71253744)
print v(xbgr.mr_n71537648)
print v(xbgr.mr_n71036192)
print v(xbgr.mr_n71121216)
print v(xbgr.mr_n71314736)
print v(xbgr.mr_n71541472)
print v(xbgr.mr_n72499232)
print v(xbgr.mr_n72714736)
print v(xbgr.mr_n72930976)
print v(xbgr.mr_n72701152)
print v(xbgr.mr_n72837792)
print v(xbgr.mr_n73045392)
print v(xbgr.mr_n70309824)
print v(xbgr.mr_n70568416)
print v(xbgr.mr_n70580256)
print v(xbgr.mr_n70973952)
print v(xbgr.mr_n70980736)
print v(xbgr.mr_n71072304)
print v(xbgr.mr_n71192336)
print v(xbgr.mr_n71412144)
print v(xbgr.mr_n70323280)
print v(xbgr.mr_n70542784)
print v(xbgr.mr_n70677184)
print v(xbgr.mr_n70974352)
print v(xbgr.mr_n72701568)
print v(xbgr.mr_n72914128)
print v(xbgr.mr_n73029280)
print v(xbgr.mr_n71035072)
print v(xbgr.mr_n71121680)
print v(xbgr.mr_n71326096)
print v(xbgr.mr_n71534512)
print v(xbgr.mr_n71660432)
print v(xbgr.mr_n71798720)
print v(xbgr.mr_n71862016)
print v(xbgr.mr_n71948160)
print v(xbgr.mr_n72083120)
print v(xbgr.mr_n72199808)
print v(xbgr.mr_n72311760)
print v(xbgr.mr_n72340944)
print v(xbgr.mr_n70322816)
print v(xbgr.mr_n70566640)
print v(xbgr.mr_n70676592)
print v(xbgr.mr_n70974752)
print v(xbgr.mr_n71663968)
print v(xbgr.mr_n71812208)
print v(xbgr.mr_n71878512)
print v(xbgr.mr_n71955040)
print v(xbgr.mr_n72073392)
print v(xbgr.mr_n72207200)
print v(xbgr.mr_n72315984)
print v(xbgr.mr_n72437728)
print v(xbgr.mr_n72699952)
print v(xbgr.mr_n72751488)
print v(xbgr.mr_n73045152)
print v(xbgr.mr_n72498768)
print v(xbgr.mr_n72714272)
print v(xbgr.mr_n72930384)
print v(xbgr.mr_n70322352)
print v(xbgr.mr_n70570112)
print v(xbgr.mr_n70593280)
print v(xbgr.mr_n70975152)
print v(xbgr.mr_n71576240)
print v(xbgr.mr_n71683888)
print v(xbgr.mr_n71827200)
print v(xbgr.mr_n71893472)
print v(xbgr.mr_n71975264)
print v(xbgr.mr_n72100688)
print v(xbgr.mr_n72226464)
print v(xbgr.mr_n72359568)
print v(xbgr.mr_n72701680)
print v(xbgr.mr_n72842320)
print v(xbgr.mr_n73027968)
print v(xbgr.mr_n70321888)
print v(xbgr.mr_n70564864)
print v(xbgr.mr_n70675408)
print v(xbgr.mr_n70975552)
print v(xbgr.mr_n71664304)
print v(xbgr.mr_n71813552)
print v(xbgr.mr_n71879856)
print v(xbgr.mr_n71956640)
print v(xbgr.mr_n72084880)
print v(xbgr.mr_n72208864)
print v(xbgr.mr_n72284000)
print v(xbgr.mr_n72408560)
print v(xbgr.mr_n71032224)
print v(xbgr.mr_n71123664)
print v(xbgr.mr_n71355472)
print v(xbgr.mr_n71534160)
print v(xbgr.mr_n72700208)
print v(xbgr.mr_n72909232)
print v(xbgr.mr_n73111840)
print v(xbgr.mr_n71033680)
print v(xbgr.mr_n71124352)
print v(xbgr.mr_n71314960)
print v(xbgr.mr_n71539216)
print v(xbgr.mr_n70321424)
print v(xbgr.mr_n70571296)
print v(xbgr.mr_n70673408)
print v(xbgr.mr_n70976352)
print v(xbgr.mr_n72698128)
print v(xbgr.mr_n72841936)
print v(xbgr.mr_n73038272)
print v(xbgr.mr_n70980464)
print v(xbgr.mr_n71072112)
print v(xbgr.mr_n71174832)
print v(xbgr.mr_n71410960)
print v(xbgr.mr_n70320960)
print v(xbgr.mr_n70571968)
print v(xbgr.mr_n70749456)
print v(xbgr.mr_n70814768)
print v(xbgr.mr_n72497840)
print v(xbgr.mr_n72713808)
print v(xbgr.mr_n72929296)
print v(xbgr.mr_n72691744)
print v(xbgr.mr_n72842528)
print v(xbgr.mr_n72991696)
print v(xbgr.mr_n71031792)
print v(xbgr.mr_n71123248)
print v(xbgr.mr_n71324752)
print v(xbgr.mr_n71543424)
print v(xbgr.mr_n70320496)
print v(xbgr.mr_n70572560)
print v(xbgr.mr_n70750896)
print v(xbgr.mr_n70814176)
print v(xbgr.mr_n71660080)
print v(xbgr.mr_n71811904)
print v(xbgr.mr_n71879488)
print v(xbgr.mr_n71956208)
print v(xbgr.mr_n72082064)
print v(xbgr.mr_n72201376)
print v(xbgr.mr_n72311344)
print v(xbgr.mr_n72437184)
print v(xbgr.mr_n71663072)
print v(xbgr.mr_n71813184)
print v(xbgr.mr_n71880704)
print v(xbgr.mr_n71957744)
print v(xbgr.mr_n72085600)
print v(xbgr.mr_n72204512)
print v(xbgr.mr_n72300336)
print v(xbgr.mr_n71923744)
print v(xbgr.mr_n72699392)
print v(xbgr.mr_n72912496)
print v(xbgr.mr_n73113408)
print v(xbgr.mr_n70320032)
print v(xbgr.mr_n70552352)
print v(xbgr.mr_n70751296)
print v(xbgr.mr_n70813584)
print v(xbgr.mr_n71575776)
print v(xbgr.mr_n71683424)
print v(xbgr.mr_n71826864)
print v(xbgr.mr_n71893200)
print v(xbgr.mr_n71976080)
print v(xbgr.mr_n72100416)
print v(xbgr.mr_n72226192)
print v(xbgr.mr_n72359296)
print v(xbgr.mr_n72697360)
print v(xbgr.mr_n72838384)
print v(xbgr.mr_n72990384)
print v(xbgr.mr_n70319504)
print v(xbgr.mr_n70573680)
print v(xbgr.mr_n70752496)
print v(xbgr.mr_n70812992)
print v(xbgr.mr_n72497376)
print v(xbgr.mr_n72713344)
print v(xbgr.mr_n72928832)
print v(xbgr.mr_n71661136)
print v(xbgr.mr_n71814400)
print v(xbgr.mr_n71877776)
print v(xbgr.mr_n71953920)
print v(xbgr.mr_n72084224)
print v(xbgr.mr_n72207888)
print v(xbgr.mr_n72281632)
print v(xbgr.mr_n72397328)
print v(xbgr.mr_n71032400)
print v(xbgr.mr_n71125232)
print v(xbgr.mr_n71354928)
print v(xbgr.mr_n71542000)
print v(xbgr.mr_n72693936)
print v(xbgr.mr_n72841344)
print v(xbgr.mr_n73040112)
print v(xbgr.mr_n71033248)
print v(xbgr.mr_n71125920)
print v(xbgr.mr_n71355648)
print v(xbgr.mr_n71543040)
print v(xbgr.mr_n70305184)
print v(xbgr.mr_n70574336)
print v(xbgr.mr_n70753296)
print v(xbgr.mr_n70812400)
print v(xbgr.mr_n70980192)
print v(xbgr.mr_n71071360)
print v(xbgr.mr_n71142976)
print v(xbgr.mr_n71409776)
print v(xbgr.mr_n70318640)
print v(xbgr.mr_n70574928)
print v(xbgr.mr_n70749120)
print v(xbgr.mr_n70811808)
print v(xbgr.mr_n72694848)
print v(xbgr.mr_n73031120)
print v(xbgr.mr_n70318176)
print v(xbgr.mr_n70569536)
print v(xbgr.mr_n70754896)
print v(xbgr.mr_n70811216)
print v(xbgr.mr_n72695520)
print v(xbgr.mr_n73012576)
print v(xbgr.mr_n71025568)
print v(xbgr.mr_n71120176)
print v(xbgr.mr_n71324976)
print v(xbgr.mr_n71545072)
print v(xbgr.mr_n71656912)
print v(xbgr.mr_n71815216)
print v(xbgr.mr_n71881520)
print v(xbgr.mr_n71954352)
print v(xbgr.mr_n72086288)
print v(xbgr.mr_n72210784)
print v(xbgr.mr_n72308352)
print v(xbgr.mr_n72430832)
print v(xbgr.mr_n71641328)
print v(xbgr.mr_n71800224)
print v(xbgr.mr_n71878208)
print v(xbgr.mr_n71959744)
print v(xbgr.mr_n72083728)
print v(xbgr.mr_n72206512)
print v(xbgr.mr_n72312576)
print v(xbgr.mr_n72427424)
print v(xbgr.mr_n72496912)
print v(xbgr.mr_n72928368)
print v(xbgr.mr_n70317712)
print v(xbgr.mr_n70576032)
print v(xbgr.mr_n70755296)
print v(xbgr.mr_n70810624)
print v(xbgr.mr_n72693504)
print v(xbgr.mr_n73030944)
print v(xbgr.mr_n71575312)
print v(xbgr.mr_n71682496)
print v(xbgr.mr_n71826320)
print v(xbgr.mr_n71892656)
print v(xbgr.mr_n71976624)
print v(xbgr.mr_n72099872)
print v(xbgr.mr_n72225648)
print v(xbgr.mr_n72358752)
print v(xbgr.mr_n70317248)
print v(xbgr.mr_n70570784)
print v(xbgr.mr_n70756496)
print v(xbgr.mr_n70810032)
print v(xbgr.mr_n72686768)
print v(xbgr.mr_n73033040)
print v(xbgr.mr_n71657968)
print v(xbgr.mr_n71817296)
print v(xbgr.mr_n71883600)
print v(xbgr.mr_n71959056)
print v(xbgr.mr_n72088048)
print v(xbgr.mr_n72213568)
print v(xbgr.mr_n72279264)
print v(xbgr.mr_n72405008)
print v(xbgr.mr_n71029072)
print v(xbgr.mr_n71126800)
print v(xbgr.mr_n71351408)
print v(xbgr.mr_n71544608)
print v(xbgr.mr_n70316784)
print v(xbgr.mr_n70577216)
print v(xbgr.mr_n70757296)
print v(xbgr.mr_n70760496)
print v(xbgr.mr_n71029936)
print v(xbgr.mr_n71127488)
print v(xbgr.mr_n71354432)
print v(xbgr.mr_n71546176)
print v(xbgr.mr_n72690416)
print v(xbgr.mr_n73025104)
print v(xbgr.mr_n72495984)
print v(xbgr.mr_n72927440)
print v(xbgr.mr_n70316320)
print v(xbgr.mr_n70577888)
print v(xbgr.mr_n70757696)
print v(xbgr.mr_n70808848)
print v(xbgr.mr_n70979920)
print v(xbgr.mr_n71070480)
print v(xbgr.mr_n70672064)
print v(xbgr.mr_n71408592)
print v(xbgr.mr_n72683152)
print v(xbgr.mr_n73114704)
print v(xbgr.mr_n70315856)
print v(xbgr.mr_n70578480)
print v(xbgr.mr_n70748864)
print v(xbgr.mr_n70808256)
print v(xbgr.mr_n71028032)
print v(xbgr.mr_n71126448)
print v(xbgr.mr_n71324864)
print v(xbgr.mr_n71542352)
print v(xbgr.mr_n71655248)
print v(xbgr.mr_n71816928)
print v(xbgr.mr_n71883232)
print v(xbgr.mr_n71957056)
print v(xbgr.mr_n72087872)
print v(xbgr.mr_n72209216)
print v(xbgr.mr_n72309168)
print v(xbgr.mr_n72419152)
print v(xbgr.mr_n72688240)
print v(xbgr.mr_n73111664)
print v(xbgr.mr_n71656736)
print v(xbgr.mr_n71818144)
print v(xbgr.mr_n71884448)
print v(xbgr.mr_n71962448)
print v(xbgr.mr_n72088832)
print v(xbgr.mr_n72214608)
print v(xbgr.mr_n72308000)
print v(xbgr.mr_n72434128)
print v(xbgr.mr_n70315392)
print v(xbgr.mr_n70579072)
print v(xbgr.mr_n70759296)
print v(xbgr.mr_n70807664)
print v(xbgr.mr_n72688800)
print v(xbgr.mr_n73015440)
print v(xbgr.mr_n71574848)
print v(xbgr.mr_n71682032)
print v(xbgr.mr_n71826048)
print v(xbgr.mr_n71892384)
print v(xbgr.mr_n71976352)
print v(xbgr.mr_n72099600)
print v(xbgr.mr_n72225376)
print v(xbgr.mr_n72358480)
print v(xbgr.mr_n70314864)
print v(xbgr.mr_n70579664)
print v(xbgr.mr_n70758496)
print v(xbgr.mr_n70807072)
print v(xbgr.mr_n72495520)
print v(xbgr.mr_n72926976)
print v(xbgr.mr_n72686432)
print v(xbgr.mr_n73115200)
print v(xbgr.mr_n70301024)
print v(xbgr.mr_n70563088)
print v(xbgr.mr_n70760896)
print v(xbgr.mr_n70806480)
print v(xbgr.mr_n71634432)
print v(xbgr.mr_n71812832)
print v(xbgr.mr_n71882816)
print v(xbgr.mr_n71958624)
print v(xbgr.mr_n72087392)
print v(xbgr.mr_n72212528)
print v(xbgr.mr_n72280448)
print v(xbgr.mr_n72397504)
print v(xbgr.mr_n71026240)
print v(xbgr.mr_n71128368)
print v(xbgr.mr_n71352384)
print v(xbgr.mr_n71540784)
print v(xbgr.mr_n71030784)
print v(xbgr.mr_n71129056)
print v(xbgr.mr_n71353104)
print v(xbgr.mr_n71543920)
print v(xbgr.mr_n72685664)
print v(xbgr.mr_n72911408)
print v(xbgr.mr_n72987504)
print v(xbgr.mr_n70314000)
print v(xbgr.mr_n70580768)
print v(xbgr.mr_n70761696)
print v(xbgr.mr_n70805888)
print v(xbgr.mr_n70979648)
print v(xbgr.mr_n71069248)
print v(xbgr.mr_n71148992)
print v(xbgr.mr_n71407408)
print v(xbgr.mr_n72684864)
print v(xbgr.mr_n72838976)
print v(xbgr.mr_n73109280)
print v(xbgr.mr_n70313536)
print v(xbgr.mr_n70581440)
print v(xbgr.mr_n70732080)
print v(xbgr.mr_n70805296)
print v(xbgr.mr_n72495056)
print v(xbgr.mr_n72712880)
print v(xbgr.mr_n72926512)
print v(xbgr.mr_n71027424)
print v(xbgr.mr_n71124880)
print v(xbgr.mr_n71325088)
print v(xbgr.mr_n71548208)
print v(xbgr.mr_n71651424)
print v(xbgr.mr_n71819696)
print v(xbgr.mr_n71885264)
print v(xbgr.mr_n71963328)
print v(xbgr.mr_n72089712)
print v(xbgr.mr_n72211904)
print v(xbgr.mr_n72301040)
print v(xbgr.mr_n72430720)
print v(xbgr.mr_n72684688)
print v(xbgr.mr_n72840160)
print v(xbgr.mr_n73115968)
print v(xbgr.mr_n71640448)
print v(xbgr.mr_n71815648)
print v(xbgr.mr_n71881952)
print v(xbgr.mr_n71958272)
print v(xbgr.mr_n72086400)
print v(xbgr.mr_n72216608)
print v(xbgr.mr_n72288144)
print v(xbgr.mr_n72434944)
print v(xbgr.mr_n70313072)
print v(xbgr.mr_n70582032)
print v(xbgr.mr_n70763296)
print v(xbgr.mr_n70804704)
print v(xbgr.mr_n71574384)
print v(xbgr.mr_n71681104)
print v(xbgr.mr_n71825504)
print v(xbgr.mr_n71892112)
print v(xbgr.mr_n71975808)
print v(xbgr.mr_n72099056)
print v(xbgr.mr_n72224832)
print v(xbgr.mr_n72357936)
print v(xbgr.mr_n70253072)
print v(xbgr.mr_n70582624)
print v(xbgr.mr_n70764560)
print v(xbgr.mr_n70804112)
print v(xbgr.mr_n72676432)
print v(xbgr.mr_n72910864)
print v(xbgr.mr_n73113584)
print v(xbgr.mr_n70312144)
print v(xbgr.mr_n70583216)
print v(xbgr.mr_n70765152)
print v(xbgr.mr_n70803520)
print v(xbgr.mr_n72680992)
print v(xbgr.mr_n72839568)
print v(xbgr.mr_n73117552)
print v(xbgr.mr_n71653440)
print v(xbgr.mr_n71821104)
print v(xbgr.mr_n71884016)
print v(xbgr.mr_n71961760)
print v(xbgr.mr_n72088400)
print v(xbgr.mr_n72218208)
print v(xbgr.mr_n72215488)
print v(xbgr.mr_n72401456)
print v(xbgr.mr_n71029248)
print v(xbgr.mr_n71129936)
print v(xbgr.mr_n71351888)
print v(xbgr.mr_n71546704)
print v(xbgr.mr_n71025680)
print v(xbgr.mr_n71122784)
print v(xbgr.mr_n71348800)
print v(xbgr.mr_n71547744)
print v(xbgr.mr_n72494128)
print v(xbgr.mr_n72712416)
print v(xbgr.mr_n72925584)
print v(xbgr.mr_n70311680)
print v(xbgr.mr_n70583808)
print v(xbgr.mr_n70766928)
print v(xbgr.mr_n70802928)
print v(xbgr.mr_n72678160)
print v(xbgr.mr_n72837200)
print v(xbgr.mr_n73120784)
print v(xbgr.mr_n70979376)
print v(xbgr.mr_n71067136)
print v(xbgr.mr_n70220320)
print v(xbgr.mr_n71406224)
print v(xbgr.mr_n70311216)
print v(xbgr.mr_n70567152)
print v(xbgr.mr_n70768112)
print v(xbgr.mr_n70802336)
print v(xbgr.mr_n72679360)
print v(xbgr.mr_n72909776)
print v(xbgr.mr_n73115696)
print v(xbgr.mr_n71021792)
print v(xbgr.mr_n71128016)
print v(xbgr.mr_n71324640)
print v(xbgr.mr_n71528896)
print v(xbgr.mr_n70310752)
print v(xbgr.mr_n70584912)
print v(xbgr.mr_n70768704)
print v(xbgr.mr_n70801744)
print v(xbgr.mr_n71650816)
print v(xbgr.mr_n71813968)
print v(xbgr.mr_n71885696)
print v(xbgr.mr_n71967152)
print v(xbgr.mr_n72090144)
print v(xbgr.mr_n72217776)
print v(xbgr.mr_n72302656)
print v(xbgr.mr_n72430304)
print v(xbgr.mr_n71645680)
print v(xbgr.mr_n71817712)
print v(xbgr.mr_n71886976)
print v(xbgr.mr_n71965616)
print v(xbgr.mr_n72092000)
print v(xbgr.mr_n72219312)
print v(xbgr.mr_n72303792)
print v(xbgr.mr_n72418576)
print v(xbgr.mr_n72678624)
print v(xbgr.mr_n72836256)
print v(xbgr.mr_n73118160)
print v(xbgr.mr_n72493664)
print v(xbgr.mr_n72711952)
print v(xbgr.mr_n72925120)
print v(xbgr.mr_n70310224)
print v(xbgr.mr_n70585584)
print v(xbgr.mr_n70769888)
print v(xbgr.mr_n70762896)
print v(xbgr.mr_n71573920)
print v(xbgr.mr_n71680640)
print v(xbgr.mr_n71825232)
print v(xbgr.mr_n71891840)
print v(xbgr.mr_n71975536)
print v(xbgr.mr_n72098784)
print v(xbgr.mr_n72224560)
print v(xbgr.mr_n72357664)
print v(xbgr.mr_n72675024)
print v(xbgr.mr_n72835424)
print v(xbgr.mr_n73123696)
print v(xbgr.mr_n70162400)
print v(xbgr.mr_n70586176)
print v(xbgr.mr_n70770480)
print v(xbgr.mr_n70800560)
print v(xbgr.mr_n71647872)
print v(xbgr.mr_n71822208)
print v(xbgr.mr_n71886560)
print v(xbgr.mr_n71965072)
print v(xbgr.mr_n72091456)
print v(xbgr.mr_n72217296)
print v(xbgr.mr_n72281040)
print v(xbgr.mr_n72402576)
print v(xbgr.mr_n71026416)
print v(xbgr.mr_n71131504)
print v(xbgr.mr_n71349776)
print v(xbgr.mr_n71516640)
print v(xbgr.mr_n71027856)
print v(xbgr.mr_n71132192)
print v(xbgr.mr_n71350560)
print v(xbgr.mr_n71503680)
print v(xbgr.mr_n72676688)
print v(xbgr.mr_n72907376)
print v(xbgr.mr_n73118048)
print v(xbgr.mr_n70309360)
print v(xbgr.mr_n70586768)
print v(xbgr.mr_n70759696)
print v(xbgr.mr_n70799968)
print v(xbgr.mr_n72671040)
print v(xbgr.mr_n72832528)
print v(xbgr.mr_n73122128)
print v(xbgr.mr_n70979104)
print v(xbgr.mr_n71066080)
print v(xbgr.mr_n71190896)
print v(xbgr.mr_n71405040)
print v(xbgr.mr_n70308896)
print v(xbgr.mr_n70584400)
print v(xbgr.mr_n70767520)
print v(xbgr.mr_n70799376)
print v(xbgr.mr_n72493200)
print v(xbgr.mr_n72711488)
print v(xbgr.mr_n72924656)
print v(xbgr.mr_n72669040)
print v(xbgr.mr_n72794192)
print v(xbgr.mr_n73121952)
print v(xbgr.mr_n70308432)
print v(xbgr.mr_n70556576)
print v(xbgr.mr_n70766336)
print v(xbgr.mr_n70798784)
print v(xbgr.mr_n71024880)
print v(xbgr.mr_n71131088)
print v(xbgr.mr_n71282464)
print v(xbgr.mr_n71523904)
print v(xbgr.mr_n71649552)
print v(xbgr.mr_n71816512)
print v(xbgr.mr_n71887344)
print v(xbgr.mr_n71968032)
print v(xbgr.mr_n72092432)
print v(xbgr.mr_n72220192)
print v(xbgr.mr_n72301568)
print v(xbgr.mr_n72431536)
print v(xbgr.mr_n71648752)
print v(xbgr.mr_n71820672)
print v(xbgr.mr_n71889744)
print v(xbgr.mr_n71963760)
print v(xbgr.mr_n72095536)
print v(xbgr.mr_n72215920)
print v(xbgr.mr_n72304928)
print v(xbgr.mr_n72427312)
print v(xbgr.mr_n70307968)
print v(xbgr.mr_n70576704)
print v(xbgr.mr_n70765744)
print v(xbgr.mr_n70798192)
print v(xbgr.mr_n72674064)
print v(xbgr.mr_n72908304)
print v(xbgr.mr_n73124688)
print v(xbgr.mr_n71573456)
print v(xbgr.mr_n71679712)
print v(xbgr.mr_n71824688)
print v(xbgr.mr_n71891568)
print v(xbgr.mr_n71974992)
print v(xbgr.mr_n72098240)
print v(xbgr.mr_n72224016)
print v(xbgr.mr_n72357120)
print v(xbgr.mr_n72672464)
print v(xbgr.mr_n72822112)
print v(xbgr.mr_n73129632)
print v(xbgr.mr_n70307504)
print v(xbgr.mr_n70589056)
print v(xbgr.mr_n70764096)
print v(xbgr.mr_n70797600)
print v(xbgr.mr_n72492272)
print v(xbgr.mr_n72711024)
print v(xbgr.mr_n72923728)
print v(xbgr.mr_n71649728)
print v(xbgr.mr_n71818608)
print v(xbgr.mr_n71888592)
print v(xbgr.mr_n71970752)
print v(xbgr.mr_n72094000)
print v(xbgr.mr_n72213920)
print v(xbgr.mr_n72277488)
print v(xbgr.mr_n72403232)
print v(xbgr.mr_n71022768)
print v(xbgr.mr_n71133072)
print v(xbgr.mr_n71348016)
print v(xbgr.mr_n71519760)
print v(xbgr.mr_n71022656)
print v(xbgr.mr_n71133760)
print v(xbgr.mr_n71347840)
print v(xbgr.mr_n71521984)
print v(xbgr.mr_n72658864)
print v(xbgr.mr_n72836080)
print v(xbgr.mr_n73128816)
print v(xbgr.mr_n70256784)
print v(xbgr.mr_n70589728)
print v(xbgr.mr_n70763696)
print v(xbgr.mr_n70797008)
print v(xbgr.mr_n70978832)
print v(xbgr.mr_n71041584)
print v(xbgr.mr_n71169152)
print v(xbgr.mr_n71403856)
print v(xbgr.mr_n70306576)
print v(xbgr.mr_n70587360)
print v(xbgr.mr_n70762496)
print v(xbgr.mr_n70796416)
print v(xbgr.mr_n72672640)
print v(xbgr.mr_n72905744)
print v(xbgr.mr_n73124512)
print v(xbgr.mr_n70306112)
print v(xbgr.mr_n70590832)
print v(xbgr.mr_n70762096)
print v(xbgr.mr_n70795824)
print v(xbgr.mr_n72663248)
print v(xbgr.mr_n72833648)
print v(xbgr.mr_n73127248)
print v(xbgr.mr_n71023504)
print v(xbgr.mr_n71132720)
print v(xbgr.mr_n71303664)
print v(xbgr.mr_n71516336)
print v(xbgr.mr_n71647696)
print v(xbgr.mr_n71815952)
print v(xbgr.mr_n71886000)
print v(xbgr.mr_n71968464)
print v(xbgr.mr_n72090832)
print v(xbgr.mr_n72215136)
print v(xbgr.mr_n72040064)
print v(xbgr.mr_n72426896)
print v(xbgr.mr_n71645856)
print v(xbgr.mr_n71811472)
print v(xbgr.mr_n71884912)
print v(xbgr.mr_n71970320)
print v(xbgr.mr_n72089360)
print v(xbgr.mr_n72209904)
print v(xbgr.mr_n72302544)
print v(xbgr.mr_n72415664)
print v(xbgr.mr_n72491808)
print v(xbgr.mr_n72710560)
print v(xbgr.mr_n72923264)
print v(xbgr.mr_n70305584)
print v(xbgr.mr_n70591504)
print v(xbgr.mr_n70761296)
print v(xbgr.mr_n70795232)
print v(xbgr.mr_n72670336)
print v(xbgr.mr_n72834304)
print v(xbgr.mr_n73131376)
print v(xbgr.mr_n71572992)
print v(xbgr.mr_n71679248)
print v(xbgr.mr_n71824416)
print v(xbgr.mr_n71891296)
print v(xbgr.mr_n71974720)
print v(xbgr.mr_n72097968)
print v(xbgr.mr_n72223744)
print v(xbgr.mr_n72356848)
print v(xbgr.mr_n70162512)
print v(xbgr.mr_n70592096)
print v(xbgr.mr_n70760096)
print v(xbgr.mr_n70794640)
print v(xbgr.mr_n72668480)
print v(xbgr.mr_n72906832)
print v(xbgr.mr_n73129808)
print v(xbgr.mr_n71646896)
print v(xbgr.mr_n71814800)
print v(xbgr.mr_n71880272)
print v(xbgr.mr_n71960432)
print v(xbgr.mr_n72085232)
print v(xbgr.mr_n72211216)
print v(xbgr.mr_n72279856)
print v(xbgr.mr_n72400800)
print v(xbgr.mr_n70304720)
print v(xbgr.mr_n70592688)
print v(xbgr.mr_n70755696)
print v(xbgr.mr_n70794048)
print v(xbgr.mr_n71024704)
print v(xbgr.mr_n71134640)
print v(xbgr.mr_n71326368)
print v(xbgr.mr_n71511984)
print v(xbgr.mr_n71013904)
print v(xbgr.mr_n71130624)
print v(xbgr.mr_n71347296)
print v(xbgr.mr_n71514176)
print v(xbgr.mr_n72666512)
print v(xbgr.mr_n72831872)
print v(xbgr.mr_n73134752)
print v(xbgr.mr_n70304256)
print v(xbgr.mr_n70590320)
print v(xbgr.mr_n70758896)
print v(xbgr.mr_n70793456)
print v(xbgr.mr_n72491344)
print v(xbgr.mr_n72710096)
print v(xbgr.mr_n72922800)
print v(xbgr.mr_n70978560)
print v(xbgr.mr_n71047184)
print v(xbgr.mr_n71191184)
print v(xbgr.mr_n71402672)
print v(xbgr.mr_n72666256)
print v(xbgr.mr_n72828976)
print v(xbgr.mr_n73133936)
print v(xbgr.mr_n70303792)
print v(xbgr.mr_n70573152)
print v(xbgr.mr_n70758096)
print v(xbgr.mr_n70743920)
print v(xbgr.mr_n71023328)
print v(xbgr.mr_n71134288)
print v(xbgr.mr_n71311136)
print v(xbgr.mr_n71513792)
print v(xbgr.mr_n71645248)
print v(xbgr.mr_n71798944)
print v(xbgr.mr_n71882256)
print v(xbgr.mr_n71969152)
print v(xbgr.mr_n72086896)
print v(xbgr.mr_n72210368)
print v(xbgr.mr_n72298832)
print v(xbgr.mr_n72423904)
print v(xbgr.mr_n71644384)
print v(xbgr.mr_n71798832)
print v(xbgr.mr_n71863520)
print v(xbgr.mr_n71967680)
print v(xbgr.mr_n72083232)
print v(xbgr.mr_n72213072)
print v(xbgr.mr_n72300224)
print v(xbgr.mr_n72428128)
print v(xbgr.mr_n72666080)
print v(xbgr.mr_n72906288)
print v(xbgr.mr_n73126256)
print v(xbgr.mr_n70303328)
print v(xbgr.mr_n70588544)
print v(xbgr.mr_n70756896)
print v(xbgr.mr_n70792272)
print v(xbgr.mr_n72665136)
print v(xbgr.mr_n72830096)
print v(xbgr.mr_n73137312)
print v(xbgr.mr_n71572528)
print v(xbgr.mr_n71678320)
print v(xbgr.mr_n71823872)
print v(xbgr.mr_n71891024)
print v(xbgr.mr_n71974176)
print v(xbgr.mr_n72097424)
print v(xbgr.mr_n72223200)
print v(xbgr.mr_n72356384)
print v(xbgr.mr_n70301216)
print v(xbgr.mr_n70594976)
print v(xbgr.mr_n70756096)
print v(xbgr.mr_n70791680)
print v(xbgr.mr_n72490416)
print v(xbgr.mr_n72709632)
print v(xbgr.mr_n72921872)
print v(xbgr.mr_n72664528)
print v(xbgr.mr_n72830752)
print v(xbgr.mr_n73134928)
print v(xbgr.mr_n70170000)
print v(xbgr.mr_n70515696)
print v(xbgr.mr_n70753696)
print v(xbgr.mr_n70791088)
print v(xbgr.mr_n71640272)
print v(xbgr.mr_n71811120)
print v(xbgr.mr_n71881168)
print v(xbgr.mr_n71966048)
print v(xbgr.mr_n72085936)
print v(xbgr.mr_n72206080)
print v(xbgr.mr_n72277152)
print v(xbgr.mr_n72346640)
print v(xbgr.mr_n71020144)
print v(xbgr.mr_n71114336)
print v(xbgr.mr_n71343712)
print v(xbgr.mr_n71506816)
print v(xbgr.mr_n71021968)
print v(xbgr.mr_n71116544)
print v(xbgr.mr_n71346800)
print v(xbgr.mr_n71509536)
print v(xbgr.mr_n70169536)
print v(xbgr.mr_n70515344)
print v(xbgr.mr_n70754496)
print v(xbgr.mr_n70790496)
print v(xbgr.mr_n72660656)
print v(xbgr.mr_n72901248)
print v(xbgr.mr_n73132192)
print v(xbgr.mr_n70978288)
print v(xbgr.mr_n71044320)
print v(xbgr.mr_n71215072)
print v(xbgr.mr_n71401808)
print v(xbgr.mr_n70169072)
print v(xbgr.mr_n70529760)
print v(xbgr.mr_n70754096)
print v(xbgr.mr_n70789904)
print v(xbgr.mr_n72661584)
print v(xbgr.mr_n72828320)
print v(xbgr.mr_n73139872)
print v(xbgr.mr_n72489952)
print v(xbgr.mr_n72709184)
print v(xbgr.mr_n72921408)
print v(xbgr.mr_n71019120)
print v(xbgr.mr_n71113872)
print v(xbgr.mr_n71300896)
print v(xbgr.mr_n71504064)
print v(xbgr.mr_n71642704)
print v(xbgr.mr_n71763712)
print v(xbgr.mr_n71877424)
print v(xbgr.mr_n71964448)
print v(xbgr.mr_n72080400)
print v(xbgr.mr_n72205200)
print v(xbgr.mr_n72299808)
print v(xbgr.mr_n72424720)
print v(xbgr.mr_n70162064)
print v(xbgr.mr_n70529168)
print v(xbgr.mr_n70752896)
print v(xbgr.mr_n70789312)
print v(xbgr.mr_n71638784)
print v(xbgr.mr_n71799760)
print v(xbgr.mr_n71862128)
print v(xbgr.mr_n71961408)
print v(xbgr.mr_n72084704)
print v(xbgr.mr_n72208368)
print v(xbgr.mr_n72289920)
print v(xbgr.mr_n72423488)
print v(xbgr.mr_n72659296)
print v(xbgr.mr_n72822576)
print v(xbgr.mr_n73139056)
print v(xbgr.mr_n70166752)
print v(xbgr.mr_n70528576)
print v(xbgr.mr_n70752096)
print v(xbgr.mr_n70788720)
print v(xbgr.mr_n71572064)
print v(xbgr.mr_n71677856)
print v(xbgr.mr_n71823600)
print v(xbgr.mr_n71890832)
print v(xbgr.mr_n71973904)
print v(xbgr.mr_n72097152)
print v(xbgr.mr_n72222928)
print v(xbgr.mr_n72356272)
print v(xbgr.mr_n72661248)
print v(xbgr.mr_n72904688)
print v(xbgr.mr_n73127072)
print v(xbgr.mr_n70167744)
print v(xbgr.mr_n70527984)
print v(xbgr.mr_n70751696)
print v(xbgr.mr_n70788128)
print v(xbgr.mr_n72660480)
print v(xbgr.mr_n72826544)
print v(xbgr.mr_n73137488)
print v(xbgr.mr_n71644560)
print v(xbgr.mr_n71808800)
print v(xbgr.mr_n71862240)
print v(xbgr.d4)
print v(xbgr.mr_n72082768)
print v(xbgr.mr_n72205584)
print v(xbgr.mr_n72219840)
print v(xbgr.mr_n72397840)
print v(xbgr.mr_n71013600)
print v(xbgr.mr_n71104112)
print v(xbgr.mr_n71344752)
print v(xbgr.mr_n71495040)
print v(xbgr.mr_n71017936)
print v(xbgr.mr_n71091456)
print v(xbgr.mr_n71345472)
print v(xbgr.mr_n71506928)
print v(xbgr.mr_n72489488)
print v(xbgr.mr_n72708736)
print v(xbgr.mr_n72920944)
print v(xbgr.mr_n70162704)
print v(xbgr.mr_n70527392)
print v(xbgr.mr_n70750496)
print v(xbgr.mr_n70787536)
print v(xbgr.mr_n72653888)
print v(xbgr.mr_n72827200)
print v(xbgr.mr_n73141616)
print v(xbgr.mr_n70972352)
print v(xbgr.mr_n71043632)
print v(xbgr.mr_n71217312)
print v(xbgr.mr_n71401008)
print v(xbgr.mr_n70162288)
print v(xbgr.mr_n70241056)
print v(xbgr.mr_n70750096)
print v(xbgr.mr_n70785856)
print v(xbgr.mr_n72660304)
print v(xbgr.mr_n72635120)
print v(xbgr.mr_n73132368)
print v(xbgr.mr_n71020752)
print v(xbgr.mr_n71107728)
print v(xbgr.mr_n71307040)
print v(xbgr.mr_n71503568)
print v(xbgr.mr_n70166288)
print v(xbgr.mr_n70525616)
print v(xbgr.mr_n70636240)
print v(xbgr.mr_n70955728)
print v(xbgr.mr_n71642528)
print v(xbgr.mr_n71807584)
print v(xbgr.mr_n71859584)
print v(xbgr.mr_n71955728)
print v(xbgr.mr_n72068096)
print v(xbgr.mr_n72196704)
print v(xbgr.mr_n72286960)
print v(xbgr.mr_n72418768)
print v(xbgr.mr_n71643584)
print v(xbgr.mr_n71798272)
print v(xbgr.mr_n71863056)
print v(xbgr.mr_n71960912)
print v(xbgr.mr_n72079936)
print v(xbgr.mr_n72195968)
print v(xbgr.mr_n72299376)
print v(xbgr.mr_n72418960)
print v(xbgr.mr_n72656704)
print v(xbgr.mr_n72824896)
print v(xbgr.mr_n73144992)
print v(xbgr.mr_n70165824)
print v(xbgr.mr_n70524432)
print v(xbgr.mr_n70636832)
print v(xbgr.mr_n70977552)
print v(xbgr.mr_n72488800)
print v(xbgr.mr_n72708192)
print v(xbgr.mr_n72920016)
print v(xbgr.mr_n71571600)
print v(xbgr.mr_n71676928)
print v(xbgr.mr_n71823136)
print v(xbgr.mr_n71890720)
print v(xbgr.mr_n71973360)
print v(xbgr.mr_n72096688)
print v(xbgr.mr_n72222464)
print v(xbgr.mr_n72356048)
print v(xbgr.mr_n72657376)
print v(xbgr.mr_n72825424)
print v(xbgr.mr_n73142608)
print v(xbgr.mr_n70165360)
print v(xbgr.mr_n70523840)
print v(xbgr.mr_n70635056)
print v(xbgr.mr_n70977152)
print v(xbgr.mr_n71635088)
print v(xbgr.mr_n71808992)
print v(xbgr.mr_n71870928)
print v(xbgr.mr_n71952352)
print v(xbgr.mr_n72080048)
print v(xbgr.mr_n72201024)
print v(xbgr.mr_n72276976)
print v(xbgr.mr_n72399680)
print v(xbgr.mr_n71019296)
print v(xbgr.mr_n71342752)
print v(xbgr.mr_n71499008)
print v(xbgr.mr_n71020576)
print v(xbgr.mr_n71344256)
print v(xbgr.mr_n71498624)
print v(xbgr.mr_n72655776)
print v(xbgr.mr_n72899408)
print v(xbgr.mr_n73136496)
print v(xbgr.mr_n70163248)
print v(xbgr.mr_n70522656)
print v(xbgr.mr_n70635648)
print v(xbgr.mr_n70976752)
print v(xbgr.mr_n70211696)
print v(xbgr.mr_n70261232)
print v(xbgr.mr_n72653712)
print v(xbgr.mr_n72823504)
print v(xbgr.mr_n73147552)
print v(xbgr.mr_n70969152)
print v(xbgr.mr_n70489216)
print v(xbgr.mr_n71143376)
print v(xbgr.mr_n71374112)
print v(xbgr.mr_n70361296)
print v(xbgr.n_23)
print v(xbgr.mr_n70633872)
print v(xbgr.mr_n70975952)
print v(xbgr.mr_n71071536)
print v(xbgr.mr_n72488496)
print v(xbgr.mr_n72637568)
print v(xbgr.mr_n72919632)
print v(xbgr.mr_n72652288)
print v(xbgr.mr_n72823968)
print v(xbgr.mr_n73146736)
print v(xbgr.n_12)
print v(xbgr.n_25)
print v(xbgr.mr_n70634464)
print v(xbgr.mr_n70973552)
print v(xbgr.mr_n71018688)
print v(xbgr.mr_n71294752)
print v(xbgr.mr_n71494080)
print v(xbgr.mr_n71638448)
print v(xbgr.mr_n71805168)
print v(xbgr.mr_n71876176)
print v(xbgr.mr_n71947424)
print v(xbgr.mr_n72071328)
print v(xbgr.mr_n72197920)
print v(xbgr.mr_n72297168)
print v(xbgr.mr_n72406784)
print v(xbgr.mr_n71634912)
print v(xbgr.mr_n71776384)
print v(xbgr.mr_n71869216)
print v(xbgr.mr_n71950960)
print v(xbgr.mr_n72079552)
print v(xbgr.mr_n72197088)
print v(xbgr.mr_n72287552)
print v(xbgr.mr_n72415840)
print v(xbgr.mr_n70351440)
print v(xbgr.mr_n70462384)
print v(xbgr.mr_n70632688)
print v(xbgr.mr_n70971152)
print v(xbgr.mr_n72633696)
print v(xbgr.mr_n72903424)
print v(xbgr.mr_n73142432)
print v(xbgr.mr_n71571136)
print v(xbgr.mr_n71676544)
print v(xbgr.mr_n71821456)
print v(xbgr.mr_n71887760)
print v(xbgr.mr_n71973168)
print v(xbgr.mr_n72096576)
print v(xbgr.mr_n72222352)
print v(xbgr.mr_n72354640)
print v(xbgr.n_17)
print v(xbgr.n_22)
print v(xbgr.mr_n70633280)
print v(xbgr.mr_n70968752)
print v(xbgr.mr_n72653216)
print v(xbgr.mr_n72790688)
print v(xbgr.mr_n73145168)
print v(xbgr.mr_n72488192)
print v(xbgr.mr_n72637104)
print v(xbgr.mr_n72919328)
print v(xbgr.mr_n71632944)
print v(xbgr.mr_n71786720)
print v(xbgr.mr_n71858784)
print v(xbgr.mr_n71953504)
print v(xbgr.mr_n72070160)
print v(xbgr.mr_n72195632)
print v(xbgr.mr_n72259136)
print v(xbgr.mr_n72353840)
print v(xbgr.mr_n71013712)
print v(xbgr.mr_n71327920)
print v(xbgr.mr_n71488000)
print v(xbgr.n_18)
print v(xbgr.mr_n70460944)
print v(xbgr.mr_n70631504)
print v(xbgr.mr_n70966752)
print v(xbgr.mr_n71014656)
print v(xbgr.mr_n71342208)
print v(xbgr.mr_n71482000)
print v(xbgr.mr_n72652112)
print v(xbgr.mr_n72786960)
print v(xbgr.mr_n73147728)
print v(xbgr.mr_n70260624)
print v(xbgr.mr_n70259776)
print v(xbgr.mr_n70358512)
print v(xbgr.mr_n70460224)
print v(xbgr.mr_n70632096)
print v(xbgr.mr_n70955280)
print v(xbgr.mr_n70977952)
print v(xbgr.mr_n70499008)
print v(xbgr.mr_n71143264)
print v(xbgr.mr_n71376336)
print v(xbgr.mr_n72650928)
print v(xbgr.mr_n72901360)
print v(xbgr.mr_n73140048)
print v(xbgr.mr_n70270352)
print v(xbgr.mr_n70307040)
print v(xbgr.mr_n70459504)
print v(xbgr.mr_n70630912)
print v(xbgr.mr_n70964112)
print v(xbgr.mr_n71008912)
print v(xbgr.mr_n71309808)
print v(xbgr.mr_n71485040)
print v(xbgr.mr_n72641168)
print v(xbgr.mr_n72796112)
print v(xbgr.mr_n73152672)
print v(xbgr.mr_n71634256)
print v(xbgr.mr_n71720880)
print v(xbgr.mr_n71875472)
print v(xbgr.mr_n71950336)
print v(xbgr.mr_n72075456)
print v(xbgr.mr_n72182976)
print v(xbgr.mr_n72289328)
print v(xbgr.mr_n72418224)
print v(xbgr.mr_n71633600)
print v(xbgr.mr_n71721056)
print v(xbgr.mr_n71871776)
print v(xbgr.mr_n71946352)
print v(xbgr.mr_n72076768)
print v(xbgr.mr_n72159296)
print v(xbgr.mr_n72288736)
print v(xbgr.mr_n72419904)
print v(xbgr.mr_n72468384)
print v(xbgr.mr_n72703920)
print v(xbgr.mr_n72916224)
print v(xbgr.mr_n70356080)
print v(xbgr.mr_n70458784)
print v(xbgr.mr_n70629008)
print v(xbgr.mr_n70953232)
print v(xbgr.mr_n72648112)
print v(xbgr.mr_n72796000)
print v(xbgr.mr_n73150288)
print v(xbgr.mr_n71570672)
print v(xbgr.mr_n71661600)
print v(xbgr.mr_n71818960)
print v(xbgr.mr_n71889440)
print v(xbgr.mr_n71972320)
print v(xbgr.mr_n72094848)
print v(xbgr.mr_n72220624)
print v(xbgr.mr_n72355440)
print v(xbgr.mr_n72647776)
print v(xbgr.mr_n72903536)
print v(xbgr.mr_n73144176)
print v(xbgr.mr_n70273088)
print v(xbgr.mr_n71632288)
print v(xbgr.mr_n71662592)
print v(xbgr.mr_n71859216)
print v(xbgr.mr_n71948864)
print v(xbgr.mr_n72076352)
print v(xbgr.mr_n72181168)
print v(xbgr.mr_n72221936)
print v(xbgr.mr_n72349040)
print v(xbgr.mr_n71006336)
print v(xbgr.mr_n71327184)
print v(xbgr.mr_n71489008)
print v(xbgr.mr_n71011328)
print v(xbgr.mr_n71340480)
print v(xbgr.mr_n71356752)
print v(xbgr.mr_n72641344)
print v(xbgr.mr_n72792384)
print v(xbgr.mr_n73151856)
print v(xbgr.mr_n71079024)
print v(xbgr.mr_n72472384)
print v(xbgr.mr_n72703744)
print v(xbgr.mr_n72918400)
print v(xbgr.mr_n70962272)
print v(xbgr.mr_n70219440)
print v(xbgr.mr_n70857376)
print v(xbgr.mr_n71357104)
print v(xbgr.mr_n70282864)
print v(xbgr.mr_n72474784)
print v(xbgr.mr_n72788768)
print v(xbgr.mr_n73154416)
print v(xbgr.mr_n71010576)
print v(xbgr.mr_n71288608)
print v(xbgr.mr_n71477008)
print v(dvbe)
print v(iptat)
print v(pbias)
print v(pcasc)
print v(r4)
print v(vbe)
print v(vdd)
print v(vref)
print v(vdd)-v(vdd)
echo METALLIC_POINT_VOLTAGES_END
echo METALLIC_ALL_NODE_VOLTAGES_BEGIN
print v(xbgr.b1b)
print v(xbgr.c2)
print v(xbgr.d1)
print v(xbgr.d2)
print v(xbgr.d3)
print v(xbgr.d4)
print v(xbgr.d5)
print v(xbgr.det)
print v(dvbe)
print v(iptat)
print v(xbgr.kick)
print v(xbgr.mr_n57034448)
print v(xbgr.mr_n57080064)
print v(xbgr.mr_n57957392)
print v(xbgr.mr_n58967536)
print v(xbgr.mr_n59471856)
print v(xbgr.mr_n59548352)
print v(xbgr.mr_n59570368)
print v(xbgr.mr_n60441888)
print v(xbgr.mr_n60444432)
print v(xbgr.mr_n60444848)
print v(xbgr.mr_n60444960)
print v(xbgr.mr_n60445280)
print v(xbgr.mr_n60445392)
print v(xbgr.mr_n60445824)
print v(xbgr.mr_n60446064)
print v(xbgr.mr_n60446176)
print v(xbgr.mr_n60446528)
print v(xbgr.mr_n60446848)
print v(xbgr.mr_n60446960)
print v(xbgr.mr_n60447392)
print v(xbgr.mr_n60447712)
print v(xbgr.mr_n60447824)
print v(xbgr.mr_n60448256)
print v(xbgr.mr_n60448576)
print v(xbgr.mr_n60448688)
print v(xbgr.mr_n60449120)
print v(xbgr.mr_n60449440)
print v(xbgr.mr_n60449552)
print v(xbgr.mr_n60449984)
print v(xbgr.mr_n60450304)
print v(xbgr.mr_n60450416)
print v(xbgr.mr_n60450848)
print v(xbgr.mr_n60451168)
print v(xbgr.mr_n60451280)
print v(xbgr.mr_n60451712)
print v(xbgr.mr_n60452032)
print v(xbgr.mr_n60452144)
print v(xbgr.mr_n60452576)
print v(xbgr.mr_n60452896)
print v(xbgr.mr_n60453008)
print v(xbgr.mr_n60453440)
print v(xbgr.mr_n60453760)
print v(xbgr.mr_n60453872)
print v(xbgr.mr_n60454304)
print v(xbgr.mr_n60454624)
print v(xbgr.mr_n60454736)
print v(xbgr.mr_n60455168)
print v(xbgr.mr_n60455488)
print v(xbgr.mr_n60455600)
print v(xbgr.mr_n60456032)
print v(xbgr.mr_n60456352)
print v(xbgr.mr_n60456464)
print v(xbgr.mr_n60456896)
print v(xbgr.mr_n60457216)
print v(xbgr.mr_n60457328)
print v(xbgr.mr_n60457760)
print v(xbgr.mr_n60458080)
print v(xbgr.mr_n60458192)
print v(xbgr.mr_n60458624)
print v(xbgr.mr_n60458944)
print v(xbgr.mr_n60459056)
print v(xbgr.mr_n60459488)
print v(xbgr.mr_n60459808)
print v(xbgr.mr_n60459920)
print v(xbgr.mr_n60460240)
print v(xbgr.mr_n60460352)
print v(xbgr.mr_n60460672)
print v(xbgr.mr_n60460784)
print v(xbgr.mr_n60461104)
print v(xbgr.mr_n60461216)
print v(xbgr.mr_n60461536)
print v(xbgr.mr_n60461648)
print v(xbgr.mr_n60461968)
print v(xbgr.mr_n60462080)
print v(xbgr.mr_n60462400)
print v(xbgr.mr_n60462512)
print v(xbgr.mr_n60462832)
print v(xbgr.mr_n60462944)
print v(xbgr.mr_n60463264)
print v(xbgr.mr_n60463376)
print v(xbgr.mr_n60463696)
print v(xbgr.mr_n60463808)
print v(xbgr.mr_n60464128)
print v(xbgr.mr_n60464240)
print v(xbgr.mr_n60464560)
print v(xbgr.mr_n60464672)
print v(xbgr.mr_n60464992)
print v(xbgr.mr_n60465104)
print v(xbgr.mr_n60465424)
print v(xbgr.mr_n60465536)
print v(xbgr.mr_n60465856)
print v(xbgr.mr_n60465968)
print v(xbgr.mr_n60466288)
print v(xbgr.mr_n60466400)
print v(xbgr.mr_n60466720)
print v(xbgr.mr_n60466832)
print v(xbgr.mr_n60467152)
print v(xbgr.mr_n60467264)
print v(xbgr.mr_n60467584)
print v(xbgr.mr_n60467696)
print v(xbgr.mr_n60468016)
print v(xbgr.mr_n60468128)
print v(xbgr.mr_n60468448)
print v(xbgr.mr_n60468560)
print v(xbgr.mr_n60468880)
print v(xbgr.mr_n60468992)
print v(xbgr.mr_n60469312)
print v(xbgr.mr_n60469424)
print v(xbgr.mr_n60469744)
print v(xbgr.mr_n60469856)
print v(xbgr.mr_n60470176)
print v(xbgr.mr_n60470288)
print v(xbgr.mr_n60470608)
print v(xbgr.mr_n60470720)
print v(xbgr.mr_n60471040)
print v(xbgr.mr_n60471152)
print v(xbgr.mr_n60471472)
print v(xbgr.mr_n60471584)
print v(xbgr.mr_n60471904)
print v(xbgr.mr_n60472016)
print v(xbgr.mr_n60472336)
print v(xbgr.mr_n60472448)
print v(xbgr.mr_n60472768)
print v(xbgr.mr_n60472880)
print v(xbgr.mr_n60473200)
print v(xbgr.mr_n60473312)
print v(xbgr.mr_n60473632)
print v(xbgr.mr_n60473744)
print v(xbgr.mr_n60474064)
print v(xbgr.mr_n60474176)
print v(xbgr.mr_n60474496)
print v(xbgr.mr_n60474608)
print v(xbgr.mr_n60474928)
print v(xbgr.mr_n60475040)
print v(xbgr.mr_n60475360)
print v(xbgr.mr_n60475472)
print v(xbgr.mr_n60475600)
print v(xbgr.mr_n60475712)
print v(xbgr.mr_n60476032)
print v(xbgr.mr_n60476144)
print v(xbgr.mr_n60476464)
print v(xbgr.mr_n60476576)
print v(xbgr.mr_n60476896)
print v(xbgr.mr_n60477008)
print v(xbgr.mr_n60477328)
print v(xbgr.mr_n60477440)
print v(xbgr.mr_n60477760)
print v(xbgr.mr_n60477872)
print v(xbgr.mr_n60478192)
print v(xbgr.mr_n60478304)
print v(xbgr.mr_n60478624)
print v(xbgr.mr_n60478736)
print v(xbgr.mr_n60479056)
print v(xbgr.mr_n60479168)
print v(xbgr.mr_n60479488)
print v(xbgr.mr_n60479600)
print v(xbgr.mr_n60479920)
print v(xbgr.mr_n60480032)
print v(xbgr.mr_n60480352)
print v(xbgr.mr_n60480464)
print v(xbgr.mr_n60480784)
print v(xbgr.mr_n60480896)
print v(xbgr.mr_n60481216)
print v(xbgr.mr_n60481328)
print v(xbgr.mr_n60481648)
print v(xbgr.mr_n60481760)
print v(xbgr.mr_n60482080)
print v(xbgr.mr_n60482192)
print v(xbgr.mr_n60482512)
print v(xbgr.mr_n60482624)
print v(xbgr.mr_n60482944)
print v(xbgr.mr_n60483056)
print v(xbgr.mr_n60483376)
print v(xbgr.mr_n60483488)
print v(xbgr.mr_n60483808)
print v(xbgr.mr_n60483920)
print v(xbgr.mr_n60484240)
print v(xbgr.mr_n60484352)
print v(xbgr.mr_n60484672)
print v(xbgr.mr_n60484784)
print v(xbgr.mr_n60485104)
print v(xbgr.mr_n60485216)
print v(xbgr.mr_n60485536)
print v(xbgr.mr_n60485648)
print v(xbgr.mr_n60485968)
print v(xbgr.mr_n60486080)
print v(xbgr.mr_n60486400)
print v(xbgr.mr_n60486512)
print v(xbgr.mr_n60486832)
print v(xbgr.mr_n60486944)
print v(xbgr.mr_n60487264)
print v(xbgr.mr_n60487376)
print v(xbgr.mr_n60487696)
print v(xbgr.mr_n60487808)
print v(xbgr.mr_n60488128)
print v(xbgr.mr_n60488240)
print v(xbgr.mr_n60488560)
print v(xbgr.mr_n60488672)
print v(xbgr.mr_n60488992)
print v(xbgr.mr_n60489104)
print v(xbgr.mr_n60489424)
print v(xbgr.mr_n60489536)
print v(xbgr.mr_n60489856)
print v(xbgr.mr_n60489968)
print v(xbgr.mr_n60490288)
print v(xbgr.mr_n60490400)
print v(xbgr.mr_n60490720)
print v(xbgr.mr_n60490832)
print v(xbgr.mr_n60491152)
print v(xbgr.mr_n60491264)
print v(xbgr.mr_n60491584)
print v(xbgr.mr_n60491696)
print v(xbgr.mr_n60492016)
print v(xbgr.mr_n60492128)
print v(xbgr.mr_n60492448)
print v(xbgr.mr_n60492560)
print v(xbgr.mr_n60492880)
print v(xbgr.mr_n60492992)
print v(xbgr.mr_n60493312)
print v(xbgr.mr_n60493424)
print v(xbgr.mr_n60493744)
print v(xbgr.mr_n60493856)
print v(xbgr.mr_n60494176)
print v(xbgr.mr_n60494288)
print v(xbgr.mr_n60494608)
print v(xbgr.mr_n60494720)
print v(xbgr.mr_n60495040)
print v(xbgr.mr_n60495152)
print v(xbgr.mr_n60495472)
print v(xbgr.mr_n60495584)
print v(xbgr.mr_n60495904)
print v(xbgr.mr_n60496016)
print v(xbgr.mr_n60496336)
print v(xbgr.mr_n60496448)
print v(xbgr.mr_n60496768)
print v(xbgr.mr_n60496880)
print v(xbgr.mr_n60497200)
print v(xbgr.mr_n60497312)
print v(xbgr.mr_n60497632)
print v(xbgr.mr_n60497744)
print v(xbgr.mr_n60498064)
print v(xbgr.mr_n60498176)
print v(xbgr.mr_n60498496)
print v(xbgr.mr_n60498608)
print v(xbgr.mr_n60498928)
print v(xbgr.mr_n60499040)
print v(xbgr.mr_n60499360)
print v(xbgr.mr_n60499472)
print v(xbgr.mr_n60499792)
print v(xbgr.mr_n60499904)
print v(xbgr.mr_n60500224)
print v(xbgr.mr_n60500336)
print v(xbgr.mr_n60500656)
print v(xbgr.mr_n60500768)
print v(xbgr.mr_n60501088)
print v(xbgr.mr_n60501200)
print v(xbgr.mr_n60501520)
print v(xbgr.mr_n60501632)
print v(xbgr.mr_n60501952)
print v(xbgr.mr_n60502064)
print v(xbgr.mr_n60502384)
print v(xbgr.mr_n60502496)
print v(xbgr.mr_n60502816)
print v(xbgr.mr_n60502928)
print v(xbgr.mr_n60503248)
print v(xbgr.mr_n60503360)
print v(xbgr.mr_n60503680)
print v(xbgr.mr_n60503792)
print v(xbgr.mr_n60504112)
print v(xbgr.mr_n60504224)
print v(xbgr.mr_n60504544)
print v(xbgr.mr_n60504656)
print v(xbgr.mr_n60504976)
print v(xbgr.mr_n60505088)
print v(xbgr.mr_n60505408)
print v(xbgr.mr_n60505520)
print v(xbgr.mr_n60505840)
print v(xbgr.mr_n60505952)
print v(xbgr.mr_n60506272)
print v(xbgr.mr_n60506384)
print v(xbgr.mr_n60506704)
print v(xbgr.mr_n60506816)
print v(xbgr.mr_n60507136)
print v(xbgr.mr_n60507248)
print v(xbgr.mr_n60507568)
print v(xbgr.mr_n60507680)
print v(xbgr.mr_n60508000)
print v(xbgr.mr_n60508112)
print v(xbgr.mr_n60508432)
print v(xbgr.mr_n60508544)
print v(xbgr.mr_n60508864)
print v(xbgr.mr_n60508976)
print v(xbgr.mr_n60509296)
print v(xbgr.mr_n60509408)
print v(xbgr.mr_n60509728)
print v(xbgr.mr_n60509840)
print v(xbgr.mr_n60510160)
print v(xbgr.mr_n60510272)
print v(xbgr.mr_n60510592)
print v(xbgr.mr_n60510704)
print v(xbgr.mr_n60511024)
print v(xbgr.mr_n60511136)
print v(xbgr.mr_n60511680)
print v(xbgr.mr_n60511792)
print v(xbgr.mr_n60512112)
print v(xbgr.mr_n60512224)
print v(xbgr.mr_n60512544)
print v(xbgr.mr_n60512656)
print v(xbgr.mr_n60512976)
print v(xbgr.mr_n60513088)
print v(xbgr.mr_n60513408)
print v(xbgr.mr_n60513520)
print v(xbgr.mr_n60513840)
print v(xbgr.mr_n60513952)
print v(xbgr.mr_n60514272)
print v(xbgr.mr_n60514384)
print v(xbgr.mr_n60514704)
print v(xbgr.mr_n60514816)
print v(xbgr.mr_n60515136)
print v(xbgr.mr_n60515248)
print v(xbgr.mr_n60515568)
print v(xbgr.mr_n60515680)
print v(xbgr.mr_n60516000)
print v(xbgr.mr_n60516112)
print v(xbgr.mr_n60516432)
print v(xbgr.mr_n60516544)
print v(xbgr.mr_n60516864)
print v(xbgr.mr_n60516976)
print v(xbgr.mr_n60517296)
print v(xbgr.mr_n60517408)
print v(xbgr.mr_n60517728)
print v(xbgr.mr_n60517840)
print v(xbgr.mr_n60518160)
print v(xbgr.mr_n60518272)
print v(xbgr.mr_n60518592)
print v(xbgr.mr_n60518704)
print v(xbgr.mr_n60519024)
print v(xbgr.mr_n60519136)
print v(xbgr.mr_n60519456)
print v(xbgr.mr_n60519568)
print v(xbgr.mr_n60519888)
print v(xbgr.mr_n60520000)
print v(xbgr.mr_n60520320)
print v(xbgr.mr_n60520432)
print v(xbgr.mr_n60520752)
print v(xbgr.mr_n60520864)
print v(xbgr.mr_n60521184)
print v(xbgr.mr_n60521296)
print v(xbgr.mr_n60521616)
print v(xbgr.mr_n60521728)
print v(xbgr.mr_n60522048)
print v(xbgr.mr_n60522160)
print v(xbgr.mr_n60522480)
print v(xbgr.mr_n60522592)
print v(xbgr.mr_n60522912)
print v(xbgr.mr_n60523024)
print v(xbgr.mr_n60523344)
print v(xbgr.mr_n60523456)
print v(xbgr.mr_n60523776)
print v(xbgr.mr_n60523888)
print v(xbgr.mr_n60524208)
print v(xbgr.mr_n60524320)
print v(xbgr.mr_n60524640)
print v(xbgr.mr_n60524752)
print v(xbgr.mr_n60525072)
print v(xbgr.mr_n60525184)
print v(xbgr.mr_n60525504)
print v(xbgr.mr_n60525616)
print v(xbgr.mr_n60525936)
print v(xbgr.mr_n60526048)
print v(xbgr.mr_n60526368)
print v(xbgr.mr_n60526480)
print v(xbgr.mr_n60526800)
print v(xbgr.mr_n60526912)
print v(xbgr.mr_n60527232)
print v(xbgr.mr_n60527344)
print v(xbgr.mr_n60527664)
print v(xbgr.mr_n60527776)
print v(xbgr.mr_n60528096)
print v(xbgr.mr_n60528208)
print v(xbgr.mr_n60528528)
print v(xbgr.mr_n60528640)
print v(xbgr.mr_n60528960)
print v(xbgr.mr_n60529072)
print v(xbgr.mr_n60529392)
print v(xbgr.mr_n60529504)
print v(xbgr.mr_n60529824)
print v(xbgr.mr_n60529936)
print v(xbgr.mr_n60530256)
print v(xbgr.mr_n60530368)
print v(xbgr.mr_n60530688)
print v(xbgr.mr_n60530800)
print v(xbgr.mr_n60531120)
print v(xbgr.mr_n60531232)
print v(xbgr.mr_n60531552)
print v(xbgr.mr_n60531664)
print v(xbgr.mr_n60531984)
print v(xbgr.mr_n60532096)
print v(xbgr.mr_n60532416)
print v(xbgr.mr_n60532528)
print v(xbgr.mr_n60532848)
print v(xbgr.mr_n60532960)
print v(xbgr.mr_n60533280)
print v(xbgr.mr_n60533392)
print v(xbgr.mr_n60533712)
print v(xbgr.mr_n60533824)
print v(xbgr.mr_n60534144)
print v(xbgr.mr_n60534256)
print v(xbgr.mr_n60534576)
print v(xbgr.mr_n60534688)
print v(xbgr.mr_n60535008)
print v(xbgr.mr_n60535120)
print v(xbgr.mr_n60535440)
print v(xbgr.mr_n60535552)
print v(xbgr.mr_n60535872)
print v(xbgr.mr_n60535984)
print v(xbgr.mr_n60536304)
print v(xbgr.mr_n60536416)
print v(xbgr.mr_n60536736)
print v(xbgr.mr_n60536848)
print v(xbgr.mr_n60537168)
print v(xbgr.mr_n60537280)
print v(xbgr.mr_n60537600)
print v(xbgr.mr_n60537712)
print v(xbgr.mr_n60538032)
print v(xbgr.mr_n60538144)
print v(xbgr.mr_n60538464)
print v(xbgr.mr_n60538576)
print v(xbgr.mr_n60538896)
print v(xbgr.mr_n60539008)
print v(xbgr.mr_n60539328)
print v(xbgr.mr_n60539440)
print v(xbgr.mr_n60539760)
print v(xbgr.mr_n60539872)
print v(xbgr.mr_n60540192)
print v(xbgr.mr_n60540304)
print v(xbgr.mr_n60540624)
print v(xbgr.mr_n60540736)
print v(xbgr.mr_n60541056)
print v(xbgr.mr_n60541168)
print v(xbgr.mr_n60541488)
print v(xbgr.mr_n60541600)
print v(xbgr.mr_n60541920)
print v(xbgr.mr_n60542032)
print v(xbgr.mr_n60542352)
print v(xbgr.mr_n60542464)
print v(xbgr.mr_n60542784)
print v(xbgr.mr_n60542896)
print v(xbgr.mr_n60543216)
print v(xbgr.mr_n60543328)
print v(xbgr.mr_n60543648)
print v(xbgr.mr_n60543760)
print v(xbgr.mr_n60544080)
print v(xbgr.mr_n60544192)
print v(xbgr.mr_n60544512)
print v(xbgr.mr_n60544624)
print v(xbgr.mr_n60544944)
print v(xbgr.mr_n60545056)
print v(xbgr.mr_n60545376)
print v(xbgr.mr_n60545488)
print v(xbgr.mr_n60545808)
print v(xbgr.mr_n60545920)
print v(xbgr.mr_n60546240)
print v(xbgr.mr_n60546352)
print v(xbgr.mr_n60546672)
print v(xbgr.mr_n60546784)
print v(xbgr.mr_n60547104)
print v(xbgr.mr_n60547216)
print v(xbgr.mr_n60547536)
print v(xbgr.mr_n60547648)
print v(xbgr.mr_n60547968)
print v(xbgr.mr_n60548080)
print v(xbgr.mr_n60548400)
print v(xbgr.mr_n60548512)
print v(xbgr.mr_n60548832)
print v(xbgr.mr_n60548944)
print v(xbgr.mr_n60549264)
print v(xbgr.mr_n60549376)
print v(xbgr.mr_n60549696)
print v(xbgr.mr_n60549808)
print v(xbgr.mr_n60550128)
print v(xbgr.mr_n60550240)
print v(xbgr.mr_n60550560)
print v(xbgr.mr_n60550672)
print v(xbgr.mr_n60550992)
print v(xbgr.mr_n60551104)
print v(xbgr.mr_n60551424)
print v(xbgr.mr_n60551536)
print v(xbgr.mr_n60551856)
print v(xbgr.mr_n60551968)
print v(xbgr.mr_n60552288)
print v(xbgr.mr_n60552400)
print v(xbgr.mr_n60552720)
print v(xbgr.mr_n60552832)
print v(xbgr.mr_n60553152)
print v(xbgr.mr_n60553264)
print v(xbgr.mr_n60553584)
print v(xbgr.mr_n60553696)
print v(xbgr.mr_n60554016)
print v(xbgr.mr_n60554128)
print v(xbgr.mr_n60554448)
print v(xbgr.mr_n60554560)
print v(xbgr.mr_n60554880)
print v(xbgr.mr_n60554992)
print v(xbgr.mr_n60555312)
print v(xbgr.mr_n60555424)
print v(xbgr.mr_n60555744)
print v(xbgr.mr_n60555856)
print v(xbgr.mr_n60556176)
print v(xbgr.mr_n60556288)
print v(xbgr.mr_n60556608)
print v(xbgr.mr_n60556720)
print v(xbgr.mr_n60557040)
print v(xbgr.mr_n60557152)
print v(xbgr.mr_n60557472)
print v(xbgr.mr_n60557584)
print v(xbgr.mr_n60557904)
print v(xbgr.mr_n60558016)
print v(xbgr.mr_n60558336)
print v(xbgr.mr_n60558448)
print v(xbgr.mr_n60558768)
print v(xbgr.mr_n60558880)
print v(xbgr.mr_n60559200)
print v(xbgr.mr_n60559312)
print v(xbgr.mr_n60559632)
print v(xbgr.mr_n60559744)
print v(xbgr.mr_n60560064)
print v(xbgr.mr_n60560176)
print v(xbgr.mr_n60560496)
print v(xbgr.mr_n60560608)
print v(xbgr.mr_n60560928)
print v(xbgr.mr_n60561040)
print v(xbgr.mr_n60561360)
print v(xbgr.mr_n60561472)
print v(xbgr.mr_n60561792)
print v(xbgr.mr_n60561904)
print v(xbgr.mr_n60562224)
print v(xbgr.mr_n60562336)
print v(xbgr.mr_n60562656)
print v(xbgr.mr_n60562768)
print v(xbgr.mr_n60563088)
print v(xbgr.mr_n60563200)
print v(xbgr.mr_n60563520)
print v(xbgr.mr_n60563632)
print v(xbgr.mr_n60563952)
print v(xbgr.mr_n60564064)
print v(xbgr.mr_n60564384)
print v(xbgr.mr_n60564496)
print v(xbgr.mr_n60564816)
print v(xbgr.mr_n60564928)
print v(xbgr.mr_n60565248)
print v(xbgr.mr_n60565360)
print v(xbgr.mr_n60565680)
print v(xbgr.mr_n60565792)
print v(xbgr.mr_n60566112)
print v(xbgr.mr_n60566224)
print v(xbgr.mr_n60566544)
print v(xbgr.mr_n60566656)
print v(xbgr.mr_n60566976)
print v(xbgr.mr_n60567088)
print v(xbgr.mr_n60567408)
print v(xbgr.mr_n60567520)
print v(xbgr.mr_n60567840)
print v(xbgr.mr_n60567952)
print v(xbgr.mr_n60568272)
print v(xbgr.mr_n60568384)
print v(xbgr.mr_n60568704)
print v(xbgr.mr_n60568816)
print v(xbgr.mr_n60569136)
print v(xbgr.mr_n60569248)
print v(xbgr.mr_n60569568)
print v(xbgr.mr_n60569680)
print v(xbgr.mr_n60570000)
print v(xbgr.mr_n60570112)
print v(xbgr.mr_n60570432)
print v(xbgr.mr_n60570544)
print v(xbgr.mr_n60570864)
print v(xbgr.mr_n60570976)
print v(xbgr.mr_n60571296)
print v(xbgr.mr_n60571408)
print v(xbgr.mr_n60571728)
print v(xbgr.mr_n60571840)
print v(xbgr.mr_n60572160)
print v(xbgr.mr_n60572272)
print v(xbgr.mr_n60572592)
print v(xbgr.mr_n60572704)
print v(xbgr.mr_n60573024)
print v(xbgr.mr_n60573136)
print v(xbgr.mr_n60573456)
print v(xbgr.mr_n60573568)
print v(xbgr.mr_n60573888)
print v(xbgr.mr_n60574000)
print v(xbgr.mr_n60574320)
print v(xbgr.mr_n60574432)
print v(xbgr.mr_n60574752)
print v(xbgr.mr_n60574864)
print v(xbgr.mr_n60575184)
print v(xbgr.mr_n60575296)
print v(xbgr.mr_n60575616)
print v(xbgr.mr_n60575728)
print v(xbgr.mr_n60576048)
print v(xbgr.mr_n60576160)
print v(xbgr.mr_n60576480)
print v(xbgr.mr_n60576592)
print v(xbgr.mr_n60576912)
print v(xbgr.mr_n60577024)
print v(xbgr.mr_n60577344)
print v(xbgr.mr_n60577456)
print v(xbgr.mr_n60577776)
print v(xbgr.mr_n60577888)
print v(xbgr.mr_n60578208)
print v(xbgr.mr_n60578320)
print v(xbgr.mr_n60578640)
print v(xbgr.mr_n60578752)
print v(xbgr.mr_n60579072)
print v(xbgr.mr_n60579184)
print v(xbgr.mr_n60579504)
print v(xbgr.mr_n60579616)
print v(xbgr.mr_n60579936)
print v(xbgr.mr_n60580048)
print v(xbgr.mr_n60580368)
print v(xbgr.mr_n60580480)
print v(xbgr.mr_n60580800)
print v(xbgr.mr_n60580912)
print v(xbgr.mr_n60581232)
print v(xbgr.mr_n60581344)
print v(xbgr.mr_n60581664)
print v(xbgr.mr_n60581776)
print v(xbgr.mr_n60582096)
print v(xbgr.mr_n60582208)
print v(xbgr.mr_n60582528)
print v(xbgr.mr_n60582640)
print v(xbgr.mr_n60582960)
print v(xbgr.mr_n60583072)
print v(xbgr.mr_n60583392)
print v(xbgr.mr_n60583504)
print v(xbgr.mr_n60583824)
print v(xbgr.mr_n60583936)
print v(xbgr.mr_n60584256)
print v(xbgr.mr_n60584368)
print v(xbgr.mr_n60584688)
print v(xbgr.mr_n60584800)
print v(xbgr.mr_n60585120)
print v(xbgr.mr_n60585232)
print v(xbgr.mr_n60585552)
print v(xbgr.mr_n60585664)
print v(xbgr.mr_n60585984)
print v(xbgr.mr_n60586096)
print v(xbgr.mr_n60586416)
print v(xbgr.mr_n60586528)
print v(xbgr.mr_n60586848)
print v(xbgr.mr_n60586960)
print v(xbgr.mr_n60587280)
print v(xbgr.mr_n60587392)
print v(xbgr.mr_n60587712)
print v(xbgr.mr_n60587824)
print v(xbgr.mr_n60588144)
print v(xbgr.mr_n60588256)
print v(xbgr.mr_n60588576)
print v(xbgr.mr_n60588688)
print v(xbgr.mr_n60589008)
print v(xbgr.mr_n60589120)
print v(xbgr.mr_n60589440)
print v(xbgr.mr_n60589552)
print v(xbgr.mr_n60589872)
print v(xbgr.mr_n60589984)
print v(xbgr.mr_n60590304)
print v(xbgr.mr_n60590416)
print v(xbgr.mr_n60590736)
print v(xbgr.mr_n60590848)
print v(xbgr.mr_n60591168)
print v(xbgr.mr_n60591280)
print v(xbgr.mr_n60591600)
print v(xbgr.mr_n60591712)
print v(xbgr.mr_n60592032)
print v(xbgr.mr_n60592144)
print v(xbgr.mr_n60592464)
print v(xbgr.mr_n60592576)
print v(xbgr.mr_n60592896)
print v(xbgr.mr_n60593008)
print v(xbgr.mr_n60593328)
print v(xbgr.mr_n60593440)
print v(xbgr.mr_n60593760)
print v(xbgr.mr_n60593872)
print v(xbgr.mr_n60594192)
print v(xbgr.mr_n60594304)
print v(xbgr.mr_n60594624)
print v(xbgr.mr_n60594736)
print v(xbgr.mr_n60595056)
print v(xbgr.mr_n60595168)
print v(xbgr.mr_n60595488)
print v(xbgr.mr_n60595600)
print v(xbgr.mr_n60595920)
print v(xbgr.mr_n60596032)
print v(xbgr.mr_n60596352)
print v(xbgr.mr_n60596464)
print v(xbgr.mr_n60596784)
print v(xbgr.mr_n60596896)
print v(xbgr.mr_n60597216)
print v(xbgr.mr_n60597328)
print v(xbgr.mr_n60597648)
print v(xbgr.mr_n60597760)
print v(xbgr.mr_n60598080)
print v(xbgr.mr_n60598192)
print v(xbgr.mr_n60598512)
print v(xbgr.mr_n60598624)
print v(xbgr.mr_n60598944)
print v(xbgr.mr_n60599056)
print v(xbgr.mr_n60599376)
print v(xbgr.mr_n60599488)
print v(xbgr.mr_n60599808)
print v(xbgr.mr_n60599920)
print v(xbgr.mr_n60600240)
print v(xbgr.mr_n60600352)
print v(xbgr.mr_n60600672)
print v(xbgr.mr_n60600784)
print v(xbgr.mr_n60601104)
print v(xbgr.mr_n60601216)
print v(xbgr.mr_n60601536)
print v(xbgr.mr_n60601648)
print v(xbgr.mr_n60601968)
print v(xbgr.mr_n60602080)
print v(xbgr.mr_n60602400)
print v(xbgr.mr_n60602512)
print v(xbgr.mr_n60602832)
print v(xbgr.mr_n60602944)
print v(xbgr.mr_n60603264)
print v(xbgr.mr_n60603376)
print v(xbgr.mr_n60603696)
print v(xbgr.mr_n60603808)
print v(xbgr.mr_n60604128)
print v(xbgr.mr_n60604240)
print v(xbgr.mr_n60604560)
print v(xbgr.mr_n60604672)
print v(xbgr.mr_n60604992)
print v(xbgr.mr_n60605104)
print v(xbgr.mr_n60605424)
print v(xbgr.mr_n60605536)
print v(xbgr.mr_n60605856)
print v(xbgr.mr_n60605968)
print v(xbgr.mr_n60606288)
print v(xbgr.mr_n60606400)
print v(xbgr.mr_n60606720)
print v(xbgr.mr_n60606832)
print v(xbgr.mr_n60607152)
print v(xbgr.mr_n60607264)
print v(xbgr.mr_n60607584)
print v(xbgr.mr_n60607696)
print v(xbgr.mr_n60608016)
print v(xbgr.mr_n60608128)
print v(xbgr.mr_n60608448)
print v(xbgr.mr_n60608560)
print v(xbgr.mr_n60608880)
print v(xbgr.mr_n60608992)
print v(xbgr.mr_n60609312)
print v(xbgr.mr_n60609424)
print v(xbgr.mr_n61614464)
print v(xbgr.mr_n61614576)
print v(xbgr.mr_n61614832)
print v(xbgr.mr_n61614944)
print v(xbgr.mr_n61615200)
print v(xbgr.mr_n61615312)
print v(xbgr.mr_n61615568)
print v(xbgr.mr_n61615680)
print v(xbgr.mr_n61615936)
print v(xbgr.mr_n61616048)
print v(xbgr.mr_n61616304)
print v(xbgr.mr_n61616416)
print v(xbgr.mr_n61616672)
print v(xbgr.mr_n61616784)
print v(xbgr.mr_n61617040)
print v(xbgr.mr_n61617152)
print v(xbgr.mr_n61617472)
print v(xbgr.mr_n61617584)
print v(xbgr.mr_n61617904)
print v(xbgr.mr_n61618016)
print v(xbgr.mr_n61618336)
print v(xbgr.mr_n61618448)
print v(xbgr.mr_n61618768)
print v(xbgr.mr_n61618880)
print v(xbgr.mr_n61619200)
print v(xbgr.mr_n61619312)
print v(xbgr.mr_n61619632)
print v(xbgr.mr_n61619744)
print v(xbgr.mr_n61620064)
print v(xbgr.mr_n61620176)
print v(xbgr.mr_n61620496)
print v(xbgr.mr_n61620608)
print v(xbgr.mr_n61620928)
print v(xbgr.mr_n61621040)
print v(xbgr.mr_n61621360)
print v(xbgr.mr_n61621472)
print v(xbgr.mr_n61621792)
print v(xbgr.mr_n61621904)
print v(xbgr.mr_n61622224)
print v(xbgr.mr_n61622336)
print v(xbgr.mr_n61622656)
print v(xbgr.mr_n61622768)
print v(xbgr.mr_n61623088)
print v(xbgr.mr_n61623200)
print v(xbgr.mr_n61623520)
print v(xbgr.mr_n61623632)
print v(xbgr.mr_n61623952)
print v(xbgr.mr_n61624064)
print v(xbgr.mr_n61624384)
print v(xbgr.mr_n61624496)
print v(xbgr.mr_n61624816)
print v(xbgr.mr_n61624928)
print v(xbgr.mr_n61625248)
print v(xbgr.mr_n61625360)
print v(xbgr.mr_n61625680)
print v(xbgr.mr_n61625792)
print v(xbgr.mr_n61626112)
print v(xbgr.mr_n61626224)
print v(xbgr.mr_n61626544)
print v(xbgr.mr_n61626656)
print v(xbgr.mr_n61626976)
print v(xbgr.mr_n61627088)
print v(xbgr.mr_n61627408)
print v(xbgr.mr_n61627520)
print v(xbgr.mr_n61627840)
print v(xbgr.mr_n61627952)
print v(xbgr.mr_n61628272)
print v(xbgr.mr_n61628384)
print v(xbgr.mr_n61628704)
print v(xbgr.mr_n61628816)
print v(xbgr.mr_n61629136)
print v(xbgr.mr_n61629248)
print v(xbgr.mr_n61629568)
print v(xbgr.mr_n61629680)
print v(xbgr.mr_n61630000)
print v(xbgr.mr_n61630112)
print v(xbgr.mr_n61630432)
print v(xbgr.mr_n61630544)
print v(xbgr.mr_n61630864)
print v(xbgr.mr_n61630976)
print v(xbgr.mr_n61631296)
print v(xbgr.mr_n61631408)
print v(xbgr.mr_n61631728)
print v(xbgr.mr_n61631840)
print v(xbgr.mr_n61632160)
print v(xbgr.mr_n61632272)
print v(xbgr.mr_n61632592)
print v(xbgr.mr_n61632704)
print v(xbgr.mr_n61633024)
print v(xbgr.mr_n61633136)
print v(xbgr.mr_n61633456)
print v(xbgr.mr_n61633568)
print v(xbgr.mr_n61633888)
print v(xbgr.mr_n61634000)
print v(xbgr.mr_n61634320)
print v(xbgr.mr_n61634432)
print v(xbgr.mr_n61634752)
print v(xbgr.mr_n61634864)
print v(xbgr.mr_n61635184)
print v(xbgr.mr_n61635296)
print v(xbgr.mr_n61635616)
print v(xbgr.mr_n61635728)
print v(xbgr.mr_n61636048)
print v(xbgr.mr_n61636160)
print v(xbgr.mr_n61636480)
print v(xbgr.mr_n61636592)
print v(xbgr.mr_n61636912)
print v(xbgr.mr_n61637024)
print v(xbgr.mr_n61637344)
print v(xbgr.mr_n61637456)
print v(xbgr.mr_n61637776)
print v(xbgr.mr_n61637888)
print v(xbgr.mr_n61638208)
print v(xbgr.mr_n61638320)
print v(xbgr.mr_n61638640)
print v(xbgr.mr_n61638752)
print v(xbgr.mr_n61639072)
print v(xbgr.mr_n61639184)
print v(xbgr.mr_n61639504)
print v(xbgr.mr_n61639616)
print v(xbgr.mr_n61639936)
print v(xbgr.mr_n61640048)
print v(xbgr.mr_n61640368)
print v(xbgr.mr_n61640480)
print v(xbgr.mr_n61640800)
print v(xbgr.mr_n61640912)
print v(xbgr.mr_n61641232)
print v(xbgr.mr_n61641344)
print v(xbgr.mr_n61641664)
print v(xbgr.mr_n61641776)
print v(xbgr.mr_n61642096)
print v(xbgr.mr_n61642208)
print v(xbgr.mr_n61642528)
print v(xbgr.mr_n61642640)
print v(xbgr.mr_n61642960)
print v(xbgr.mr_n61643072)
print v(xbgr.mr_n61643392)
print v(xbgr.mr_n61643504)
print v(xbgr.mr_n61643824)
print v(xbgr.mr_n61643936)
print v(xbgr.mr_n61644256)
print v(xbgr.mr_n61644368)
print v(xbgr.mr_n61644688)
print v(xbgr.mr_n61644800)
print v(xbgr.mr_n61645120)
print v(xbgr.mr_n61645232)
print v(xbgr.mr_n61645552)
print v(xbgr.mr_n61645664)
print v(xbgr.mr_n61645984)
print v(xbgr.mr_n61646096)
print v(xbgr.mr_n61646416)
print v(xbgr.mr_n61646528)
print v(xbgr.mr_n61646848)
print v(xbgr.mr_n61646960)
print v(xbgr.mr_n61647280)
print v(xbgr.mr_n61647392)
print v(xbgr.mr_n61647712)
print v(xbgr.mr_n61647824)
print v(xbgr.mr_n61648144)
print v(xbgr.mr_n61648256)
print v(xbgr.mr_n61648576)
print v(xbgr.mr_n61648688)
print v(xbgr.mr_n61649008)
print v(xbgr.mr_n61649120)
print v(xbgr.mr_n61649440)
print v(xbgr.mr_n61649552)
print v(xbgr.mr_n61649872)
print v(xbgr.mr_n61649984)
print v(xbgr.mr_n61650304)
print v(xbgr.mr_n61650416)
print v(xbgr.mr_n61650736)
print v(xbgr.mr_n61650848)
print v(xbgr.mr_n61651168)
print v(xbgr.mr_n61651280)
print v(xbgr.mr_n61651600)
print v(xbgr.mr_n61651712)
print v(xbgr.mr_n61652032)
print v(xbgr.mr_n61652144)
print v(xbgr.mr_n61652464)
print v(xbgr.mr_n61652576)
print v(xbgr.mr_n61652896)
print v(xbgr.mr_n61653008)
print v(xbgr.mr_n61653328)
print v(xbgr.mr_n61653440)
print v(xbgr.mr_n61653760)
print v(xbgr.mr_n61653872)
print v(xbgr.mr_n61654192)
print v(xbgr.mr_n61654304)
print v(xbgr.mr_n61654624)
print v(xbgr.mr_n61654736)
print v(xbgr.mr_n61655056)
print v(xbgr.mr_n61655168)
print v(xbgr.mr_n61655488)
print v(xbgr.mr_n61655600)
print v(xbgr.mr_n61655920)
print v(xbgr.mr_n61656032)
print v(xbgr.mr_n61656352)
print v(xbgr.mr_n61656464)
print v(xbgr.mr_n61656784)
print v(xbgr.mr_n61656896)
print v(xbgr.mr_n61657216)
print v(xbgr.mr_n61657328)
print v(xbgr.mr_n61657648)
print v(xbgr.mr_n61657760)
print v(xbgr.mr_n61658080)
print v(xbgr.mr_n61658192)
print v(xbgr.mr_n61658512)
print v(xbgr.mr_n61658624)
print v(xbgr.mr_n61658944)
print v(xbgr.mr_n61659056)
print v(xbgr.mr_n61659376)
print v(xbgr.mr_n61659488)
print v(xbgr.mr_n61659808)
print v(xbgr.mr_n61659920)
print v(xbgr.mr_n61660240)
print v(xbgr.mr_n61660352)
print v(xbgr.mr_n61660672)
print v(xbgr.mr_n61660784)
print v(xbgr.mr_n61661104)
print v(xbgr.mr_n61661216)
print v(xbgr.mr_n61661536)
print v(xbgr.mr_n61661648)
print v(xbgr.mr_n61661968)
print v(xbgr.mr_n61662080)
print v(xbgr.mr_n61662400)
print v(xbgr.mr_n61662512)
print v(xbgr.mr_n61662832)
print v(xbgr.mr_n61662944)
print v(xbgr.mr_n61663264)
print v(xbgr.mr_n61663376)
print v(xbgr.mr_n61663696)
print v(xbgr.mr_n61663808)
print v(xbgr.mr_n61664128)
print v(xbgr.mr_n61664240)
print v(xbgr.mr_n61664560)
print v(xbgr.mr_n61664672)
print v(xbgr.mr_n61664992)
print v(xbgr.mr_n61665104)
print v(xbgr.mr_n61665424)
print v(xbgr.mr_n61665536)
print v(xbgr.mr_n61665856)
print v(xbgr.mr_n61665968)
print v(xbgr.mr_n61666288)
print v(xbgr.mr_n61666400)
print v(xbgr.mr_n61666720)
print v(xbgr.mr_n61666832)
print v(xbgr.mr_n61667152)
print v(xbgr.mr_n61667264)
print v(xbgr.mr_n61667584)
print v(xbgr.mr_n61667696)
print v(xbgr.mr_n61668016)
print v(xbgr.mr_n61668128)
print v(xbgr.mr_n61668448)
print v(xbgr.mr_n61668560)
print v(xbgr.mr_n61668880)
print v(xbgr.mr_n61668992)
print v(xbgr.mr_n61669312)
print v(xbgr.mr_n61669424)
print v(xbgr.mr_n61669744)
print v(xbgr.mr_n61669856)
print v(xbgr.mr_n61670176)
print v(xbgr.mr_n61670288)
print v(xbgr.mr_n61670608)
print v(xbgr.mr_n61670720)
print v(xbgr.mr_n61671040)
print v(xbgr.mr_n61671152)
print v(xbgr.mr_n61671472)
print v(xbgr.mr_n61671584)
print v(xbgr.mr_n61671904)
print v(xbgr.mr_n61672016)
print v(xbgr.mr_n61672336)
print v(xbgr.mr_n61672448)
print v(xbgr.mr_n61672768)
print v(xbgr.mr_n61672880)
print v(xbgr.mr_n61673200)
print v(xbgr.mr_n61673312)
print v(xbgr.mr_n61673632)
print v(xbgr.mr_n61673744)
print v(xbgr.mr_n61674064)
print v(xbgr.mr_n61674176)
print v(xbgr.mr_n61674496)
print v(xbgr.mr_n61674608)
print v(xbgr.mr_n61674928)
print v(xbgr.mr_n61675040)
print v(xbgr.mr_n61675360)
print v(xbgr.mr_n61675472)
print v(xbgr.mr_n61675792)
print v(xbgr.mr_n61675904)
print v(xbgr.mr_n61676224)
print v(xbgr.mr_n61676336)
print v(xbgr.mr_n61676656)
print v(xbgr.mr_n61676768)
print v(xbgr.mr_n61677088)
print v(xbgr.mr_n61677200)
print v(xbgr.mr_n61677520)
print v(xbgr.mr_n61677632)
print v(xbgr.mr_n61677952)
print v(xbgr.mr_n61678064)
print v(xbgr.mr_n61678384)
print v(xbgr.mr_n61678496)
print v(xbgr.mr_n61678816)
print v(xbgr.mr_n61678928)
print v(xbgr.mr_n61679248)
print v(xbgr.mr_n61679360)
print v(xbgr.mr_n61679680)
print v(xbgr.mr_n61679792)
print v(xbgr.mr_n61680112)
print v(xbgr.mr_n61680224)
print v(xbgr.mr_n61680544)
print v(xbgr.mr_n61680656)
print v(xbgr.mr_n61680976)
print v(xbgr.mr_n61681088)
print v(xbgr.mr_n61681408)
print v(xbgr.mr_n61681520)
print v(xbgr.mr_n61681840)
print v(xbgr.mr_n61681952)
print v(xbgr.mr_n61682272)
print v(xbgr.mr_n61682384)
print v(xbgr.mr_n61682704)
print v(xbgr.mr_n61682816)
print v(xbgr.mr_n61683136)
print v(xbgr.mr_n61683248)
print v(xbgr.mr_n61683568)
print v(xbgr.mr_n61683680)
print v(xbgr.mr_n61684000)
print v(xbgr.mr_n61684112)
print v(xbgr.mr_n61684432)
print v(xbgr.mr_n61684544)
print v(xbgr.mr_n61684864)
print v(xbgr.mr_n61684976)
print v(xbgr.mr_n61685296)
print v(xbgr.mr_n61685408)
print v(xbgr.mr_n61685728)
print v(xbgr.mr_n61685840)
print v(xbgr.mr_n61686160)
print v(xbgr.mr_n61686272)
print v(xbgr.mr_n61686592)
print v(xbgr.mr_n61686704)
print v(xbgr.mr_n61687024)
print v(xbgr.mr_n61687136)
print v(xbgr.mr_n61687456)
print v(xbgr.mr_n61687568)
print v(xbgr.mr_n61687888)
print v(xbgr.mr_n61688000)
print v(xbgr.mr_n61688320)
print v(xbgr.mr_n61688432)
print v(xbgr.mr_n61688752)
print v(xbgr.mr_n61688864)
print v(xbgr.mr_n61689184)
print v(xbgr.mr_n61689296)
print v(xbgr.mr_n61689616)
print v(xbgr.mr_n61689728)
print v(xbgr.mr_n61690048)
print v(xbgr.mr_n61690160)
print v(xbgr.mr_n61690480)
print v(xbgr.mr_n61690592)
print v(xbgr.mr_n61690912)
print v(xbgr.mr_n61691024)
print v(xbgr.mr_n61691344)
print v(xbgr.mr_n61691456)
print v(xbgr.mr_n61691776)
print v(xbgr.mr_n61691888)
print v(xbgr.mr_n61692208)
print v(xbgr.mr_n61692320)
print v(xbgr.mr_n61692640)
print v(xbgr.mr_n61692752)
print v(xbgr.mr_n61693072)
print v(xbgr.mr_n61693184)
print v(xbgr.mr_n61693504)
print v(xbgr.mr_n61693616)
print v(xbgr.mr_n61693936)
print v(xbgr.mr_n61694048)
print v(xbgr.mr_n61694368)
print v(xbgr.mr_n61694480)
print v(xbgr.mr_n61694800)
print v(xbgr.mr_n61694912)
print v(xbgr.mr_n61695232)
print v(xbgr.mr_n61695344)
print v(xbgr.mr_n61695664)
print v(xbgr.mr_n61695776)
print v(xbgr.mr_n61696096)
print v(xbgr.mr_n61696208)
print v(xbgr.mr_n61696528)
print v(xbgr.mr_n61696640)
print v(xbgr.mr_n61696960)
print v(xbgr.mr_n61697072)
print v(xbgr.mr_n61697392)
print v(xbgr.mr_n61697504)
print v(xbgr.mr_n61697824)
print v(xbgr.mr_n61697936)
print v(xbgr.mr_n61698256)
print v(xbgr.mr_n61698368)
print v(xbgr.mr_n61698688)
print v(xbgr.mr_n61698800)
print v(xbgr.mr_n61699120)
print v(xbgr.mr_n61699232)
print v(xbgr.mr_n61699552)
print v(xbgr.mr_n61699664)
print v(xbgr.mr_n61699984)
print v(xbgr.mr_n61700096)
print v(xbgr.mr_n61700416)
print v(xbgr.mr_n61700528)
print v(xbgr.mr_n61700848)
print v(xbgr.mr_n61700960)
print v(xbgr.mr_n61701280)
print v(xbgr.mr_n61701392)
print v(xbgr.mr_n61701712)
print v(xbgr.mr_n61701824)
print v(xbgr.mr_n61702144)
print v(xbgr.mr_n61702256)
print v(xbgr.mr_n61702576)
print v(xbgr.mr_n61702688)
print v(xbgr.mr_n61703008)
print v(xbgr.mr_n61703120)
print v(xbgr.mr_n61703440)
print v(xbgr.mr_n61703552)
print v(xbgr.mr_n61703872)
print v(xbgr.mr_n61703984)
print v(xbgr.mr_n61704304)
print v(xbgr.mr_n61704416)
print v(xbgr.mr_n61704736)
print v(xbgr.mr_n61704848)
print v(xbgr.mr_n61705168)
print v(xbgr.mr_n61705280)
print v(xbgr.mr_n61705600)
print v(xbgr.mr_n61705712)
print v(xbgr.mr_n61706032)
print v(xbgr.mr_n61706144)
print v(xbgr.mr_n61706464)
print v(xbgr.mr_n61706576)
print v(xbgr.mr_n61706896)
print v(xbgr.mr_n61707008)
print v(xbgr.mr_n61707328)
print v(xbgr.mr_n61707440)
print v(xbgr.mr_n61707760)
print v(xbgr.mr_n61707872)
print v(xbgr.mr_n61708192)
print v(xbgr.mr_n61708304)
print v(xbgr.mr_n61708624)
print v(xbgr.mr_n61708736)
print v(xbgr.mr_n61709056)
print v(xbgr.mr_n61709168)
print v(xbgr.mr_n61709488)
print v(xbgr.mr_n61709600)
print v(xbgr.mr_n61709920)
print v(xbgr.mr_n61710032)
print v(xbgr.mr_n61710352)
print v(xbgr.mr_n61710464)
print v(xbgr.mr_n61710784)
print v(xbgr.mr_n61710896)
print v(xbgr.mr_n61711216)
print v(xbgr.mr_n61711328)
print v(xbgr.mr_n61711648)
print v(xbgr.mr_n61711760)
print v(xbgr.mr_n61712080)
print v(xbgr.mr_n61712192)
print v(xbgr.mr_n61712512)
print v(xbgr.mr_n61712624)
print v(xbgr.mr_n61712944)
print v(xbgr.mr_n61713056)
print v(xbgr.mr_n61713376)
print v(xbgr.mr_n61713488)
print v(xbgr.mr_n61713808)
print v(xbgr.mr_n61713920)
print v(xbgr.mr_n61714240)
print v(xbgr.mr_n61714352)
print v(xbgr.mr_n61714672)
print v(xbgr.mr_n61714784)
print v(xbgr.mr_n61715104)
print v(xbgr.mr_n61715216)
print v(xbgr.mr_n61715536)
print v(xbgr.mr_n61715648)
print v(xbgr.mr_n61715968)
print v(xbgr.mr_n61716080)
print v(xbgr.mr_n61716400)
print v(xbgr.mr_n61716512)
print v(xbgr.mr_n61716832)
print v(xbgr.mr_n61716944)
print v(xbgr.mr_n61717264)
print v(xbgr.mr_n61717376)
print v(xbgr.mr_n61717696)
print v(xbgr.mr_n61717808)
print v(xbgr.mr_n61718128)
print v(xbgr.mr_n61718240)
print v(xbgr.mr_n61718528)
print v(xbgr.mr_n61718640)
print v(xbgr.mr_n61718960)
print v(xbgr.mr_n61719072)
print v(xbgr.mr_n61719392)
print v(xbgr.mr_n61719504)
print v(xbgr.mr_n61719824)
print v(xbgr.mr_n61719936)
print v(xbgr.mr_n61720256)
print v(xbgr.mr_n61720368)
print v(xbgr.mr_n61720688)
print v(xbgr.mr_n61720800)
print v(xbgr.mr_n61721120)
print v(xbgr.mr_n61721232)
print v(xbgr.mr_n61721552)
print v(xbgr.mr_n61721664)
print v(xbgr.mr_n61721984)
print v(xbgr.mr_n61722096)
print v(xbgr.mr_n61722416)
print v(xbgr.mr_n61722528)
print v(xbgr.mr_n61722848)
print v(xbgr.mr_n61722960)
print v(xbgr.mr_n61723280)
print v(xbgr.mr_n61723392)
print v(xbgr.mr_n61723712)
print v(xbgr.mr_n61723824)
print v(xbgr.mr_n61724144)
print v(xbgr.mr_n61724256)
print v(xbgr.mr_n61724576)
print v(xbgr.mr_n61724688)
print v(xbgr.mr_n61725008)
print v(xbgr.mr_n61725120)
print v(xbgr.mr_n61725440)
print v(xbgr.mr_n61725552)
print v(xbgr.mr_n61725872)
print v(xbgr.mr_n61725984)
print v(xbgr.mr_n61726304)
print v(xbgr.mr_n61726416)
print v(xbgr.mr_n61726736)
print v(xbgr.mr_n61726848)
print v(xbgr.mr_n61727168)
print v(xbgr.mr_n61727280)
print v(xbgr.mr_n61727600)
print v(xbgr.mr_n61727712)
print v(xbgr.mr_n61728032)
print v(xbgr.mr_n61728144)
print v(xbgr.mr_n61728464)
print v(xbgr.mr_n61728576)
print v(xbgr.mr_n61728896)
print v(xbgr.mr_n61729008)
print v(xbgr.mr_n61729328)
print v(xbgr.mr_n61729440)
print v(xbgr.mr_n61729760)
print v(xbgr.mr_n61729872)
print v(xbgr.mr_n61730192)
print v(xbgr.mr_n61730304)
print v(xbgr.mr_n61730624)
print v(xbgr.mr_n61730736)
print v(xbgr.mr_n61731056)
print v(xbgr.mr_n61731168)
print v(xbgr.mr_n61731488)
print v(xbgr.mr_n61731600)
print v(xbgr.mr_n61731920)
print v(xbgr.mr_n61732032)
print v(xbgr.mr_n61732352)
print v(xbgr.mr_n61732464)
print v(xbgr.mr_n61732784)
print v(xbgr.mr_n61732896)
print v(xbgr.mr_n61733216)
print v(xbgr.mr_n61733328)
print v(xbgr.mr_n61733648)
print v(xbgr.mr_n61733760)
print v(xbgr.mr_n61734080)
print v(xbgr.mr_n61734192)
print v(xbgr.mr_n61734512)
print v(xbgr.mr_n61734624)
print v(xbgr.mr_n61734944)
print v(xbgr.mr_n61735056)
print v(xbgr.mr_n61735376)
print v(xbgr.mr_n61735488)
print v(xbgr.mr_n61735808)
print v(xbgr.mr_n61735920)
print v(xbgr.mr_n61736240)
print v(xbgr.mr_n61736352)
print v(xbgr.mr_n61736672)
print v(xbgr.mr_n61736784)
print v(xbgr.mr_n61737104)
print v(xbgr.mr_n61737216)
print v(xbgr.mr_n61737536)
print v(xbgr.mr_n61737648)
print v(xbgr.mr_n61737968)
print v(xbgr.mr_n61738080)
print v(xbgr.mr_n61738400)
print v(xbgr.mr_n61738512)
print v(xbgr.mr_n61738832)
print v(xbgr.mr_n61738944)
print v(xbgr.mr_n61739264)
print v(xbgr.mr_n61739376)
print v(xbgr.mr_n61739696)
print v(xbgr.mr_n61739808)
print v(xbgr.mr_n61740128)
print v(xbgr.mr_n61740240)
print v(xbgr.mr_n61740560)
print v(xbgr.mr_n61740672)
print v(xbgr.mr_n61740992)
print v(xbgr.mr_n61741104)
print v(xbgr.mr_n61741424)
print v(xbgr.mr_n61741536)
print v(xbgr.mr_n61741856)
print v(xbgr.mr_n61741968)
print v(xbgr.mr_n61742288)
print v(xbgr.mr_n61742400)
print v(xbgr.mr_n61742720)
print v(xbgr.mr_n61742832)
print v(xbgr.mr_n61743152)
print v(xbgr.mr_n61743264)
print v(xbgr.mr_n61743584)
print v(xbgr.mr_n61743696)
print v(xbgr.mr_n61744016)
print v(xbgr.mr_n61744128)
print v(xbgr.mr_n61744448)
print v(xbgr.mr_n61744560)
print v(xbgr.mr_n61744880)
print v(xbgr.mr_n61744992)
print v(xbgr.mr_n61745312)
print v(xbgr.mr_n61745424)
print v(xbgr.mr_n61745744)
print v(xbgr.mr_n61745856)
print v(xbgr.mr_n61746176)
print v(xbgr.mr_n61746288)
print v(xbgr.mr_n61746608)
print v(xbgr.mr_n61746720)
print v(xbgr.mr_n61747040)
print v(xbgr.mr_n61747152)
print v(xbgr.mr_n61747472)
print v(xbgr.mr_n61747584)
print v(xbgr.mr_n61747904)
print v(xbgr.mr_n61748016)
print v(xbgr.mr_n61748336)
print v(xbgr.mr_n61748448)
print v(xbgr.mr_n61748768)
print v(xbgr.mr_n61748880)
print v(xbgr.mr_n61749200)
print v(xbgr.mr_n61749312)
print v(xbgr.mr_n61749632)
print v(xbgr.mr_n61749744)
print v(xbgr.mr_n61750064)
print v(xbgr.mr_n61750176)
print v(xbgr.mr_n61750496)
print v(xbgr.mr_n61750608)
print v(xbgr.mr_n61750928)
print v(xbgr.mr_n61751040)
print v(xbgr.mr_n61751360)
print v(xbgr.mr_n61751472)
print v(xbgr.mr_n61751792)
print v(xbgr.mr_n61751904)
print v(xbgr.mr_n61752224)
print v(xbgr.mr_n61752336)
print v(xbgr.mr_n61752656)
print v(xbgr.mr_n61752768)
print v(xbgr.mr_n61753088)
print v(xbgr.mr_n61753200)
print v(xbgr.mr_n61753520)
print v(xbgr.mr_n61753632)
print v(xbgr.mr_n61753952)
print v(xbgr.mr_n61754064)
print v(xbgr.mr_n61754384)
print v(xbgr.mr_n61754496)
print v(xbgr.mr_n61754816)
print v(xbgr.mr_n61754928)
print v(xbgr.mr_n61755248)
print v(xbgr.mr_n61755360)
print v(xbgr.mr_n61755680)
print v(xbgr.mr_n61755792)
print v(xbgr.mr_n61756112)
print v(xbgr.mr_n61756224)
print v(xbgr.mr_n61756544)
print v(xbgr.mr_n61756656)
print v(xbgr.mr_n61756976)
print v(xbgr.mr_n61757088)
print v(xbgr.mr_n61757408)
print v(xbgr.mr_n61757520)
print v(xbgr.mr_n61757840)
print v(xbgr.mr_n61757952)
print v(xbgr.mr_n61758272)
print v(xbgr.mr_n61758384)
print v(xbgr.mr_n61758704)
print v(xbgr.mr_n61758816)
print v(xbgr.mr_n61759136)
print v(xbgr.mr_n61759248)
print v(xbgr.mr_n61759568)
print v(xbgr.mr_n61759680)
print v(xbgr.mr_n61760000)
print v(xbgr.mr_n61760112)
print v(xbgr.mr_n61760432)
print v(xbgr.mr_n61760544)
print v(xbgr.mr_n61760864)
print v(xbgr.mr_n61760976)
print v(xbgr.mr_n61761296)
print v(xbgr.mr_n61761408)
print v(xbgr.mr_n61761728)
print v(xbgr.mr_n61761840)
print v(xbgr.mr_n61762160)
print v(xbgr.mr_n61762272)
print v(xbgr.mr_n61762592)
print v(xbgr.mr_n61762704)
print v(xbgr.mr_n61763024)
print v(xbgr.mr_n61763136)
print v(xbgr.mr_n61763456)
print v(xbgr.mr_n61763568)
print v(xbgr.mr_n61763888)
print v(xbgr.mr_n61764000)
print v(xbgr.mr_n61764320)
print v(xbgr.mr_n61764432)
print v(xbgr.mr_n61764752)
print v(xbgr.mr_n61764864)
print v(xbgr.mr_n61765184)
print v(xbgr.mr_n61765296)
print v(xbgr.mr_n61765616)
print v(xbgr.mr_n61765728)
print v(xbgr.mr_n61766048)
print v(xbgr.mr_n61766160)
print v(xbgr.mr_n61766480)
print v(xbgr.mr_n61766592)
print v(xbgr.mr_n61766912)
print v(xbgr.mr_n61767024)
print v(xbgr.mr_n61767344)
print v(xbgr.mr_n61767456)
print v(xbgr.mr_n61767776)
print v(xbgr.mr_n61767888)
print v(xbgr.mr_n61768208)
print v(xbgr.mr_n61768320)
print v(xbgr.mr_n61768640)
print v(xbgr.mr_n61768752)
print v(xbgr.mr_n61769072)
print v(xbgr.mr_n61769184)
print v(xbgr.mr_n61769504)
print v(xbgr.mr_n61769616)
print v(xbgr.mr_n61769936)
print v(xbgr.mr_n61770048)
print v(xbgr.mr_n61770368)
print v(xbgr.mr_n61770480)
print v(xbgr.mr_n61770800)
print v(xbgr.mr_n61770912)
print v(xbgr.mr_n61771232)
print v(xbgr.mr_n61771344)
print v(xbgr.mr_n61771664)
print v(xbgr.mr_n61771776)
print v(xbgr.mr_n61772096)
print v(xbgr.mr_n61772208)
print v(xbgr.mr_n61772528)
print v(xbgr.mr_n61772640)
print v(xbgr.mr_n61772960)
print v(xbgr.mr_n61773072)
print v(xbgr.mr_n61773392)
print v(xbgr.mr_n61773504)
print v(xbgr.mr_n61773824)
print v(xbgr.mr_n61773936)
print v(xbgr.mr_n61774256)
print v(xbgr.mr_n61774368)
print v(xbgr.mr_n61774688)
print v(xbgr.mr_n61774800)
print v(xbgr.mr_n61775120)
print v(xbgr.mr_n61775232)
print v(xbgr.mr_n61775552)
print v(xbgr.mr_n61775664)
print v(xbgr.mr_n61775984)
print v(xbgr.mr_n61776096)
print v(xbgr.mr_n61776416)
print v(xbgr.mr_n61776528)
print v(xbgr.mr_n61776848)
print v(xbgr.mr_n61776960)
print v(xbgr.mr_n61777280)
print v(xbgr.mr_n61777392)
print v(xbgr.mr_n61777712)
print v(xbgr.mr_n61777824)
print v(xbgr.mr_n61778144)
print v(xbgr.mr_n61778256)
print v(xbgr.mr_n61778576)
print v(xbgr.mr_n61778688)
print v(xbgr.mr_n61779008)
print v(xbgr.mr_n61779120)
print v(xbgr.mr_n61779440)
print v(xbgr.mr_n61779552)
print v(xbgr.mr_n61779872)
print v(xbgr.mr_n61779984)
print v(xbgr.mr_n61780304)
print v(xbgr.mr_n61780416)
print v(xbgr.mr_n61780736)
print v(xbgr.mr_n61780848)
print v(xbgr.mr_n61781168)
print v(xbgr.mr_n61781280)
print v(xbgr.mr_n61781600)
print v(xbgr.mr_n61781712)
print v(xbgr.mr_n61782032)
print v(xbgr.mr_n61782144)
print v(xbgr.mr_n61782464)
print v(xbgr.mr_n61782576)
print v(xbgr.mr_n61782896)
print v(xbgr.mr_n61783008)
print v(xbgr.mr_n61783328)
print v(xbgr.mr_n61783440)
print v(xbgr.mr_n61783760)
print v(xbgr.mr_n61783872)
print v(xbgr.mr_n61784192)
print v(xbgr.mr_n61784304)
print v(xbgr.mr_n61784624)
print v(xbgr.mr_n61784736)
print v(xbgr.mr_n61785056)
print v(xbgr.mr_n61785168)
print v(xbgr.mr_n61785488)
print v(xbgr.mr_n61785600)
print v(xbgr.mr_n61785920)
print v(xbgr.mr_n61786032)
print v(xbgr.mr_n61786352)
print v(xbgr.mr_n61786464)
print v(xbgr.mr_n61786784)
print v(xbgr.mr_n61786896)
print v(xbgr.mr_n61787216)
print v(xbgr.mr_n61787328)
print v(xbgr.mr_n61787648)
print v(xbgr.mr_n61787760)
print v(xbgr.mr_n61788080)
print v(xbgr.mr_n61788192)
print v(xbgr.mr_n61788512)
print v(xbgr.mr_n61788624)
print v(xbgr.mr_n61788944)
print v(xbgr.mr_n61789056)
print v(xbgr.mr_n61789376)
print v(xbgr.mr_n61789488)
print v(xbgr.mr_n61789808)
print v(xbgr.mr_n61789920)
print v(xbgr.mr_n61790240)
print v(xbgr.mr_n61790352)
print v(xbgr.mr_n61790672)
print v(xbgr.mr_n61790784)
print v(xbgr.mr_n61791104)
print v(xbgr.mr_n61791216)
print v(xbgr.mr_n61791536)
print v(xbgr.mr_n61791648)
print v(xbgr.mr_n61791968)
print v(xbgr.mr_n61792080)
print v(xbgr.mr_n61792400)
print v(xbgr.mr_n61792512)
print v(xbgr.mr_n61792832)
print v(xbgr.mr_n61792944)
print v(xbgr.mr_n61793264)
print v(xbgr.mr_n61793376)
print v(xbgr.mr_n61793696)
print v(xbgr.mr_n61793808)
print v(xbgr.mr_n61794128)
print v(xbgr.mr_n61794240)
print v(xbgr.mr_n61794560)
print v(xbgr.mr_n61794672)
print v(xbgr.mr_n61794992)
print v(xbgr.mr_n61795104)
print v(xbgr.mr_n61795424)
print v(xbgr.mr_n61795536)
print v(xbgr.mr_n61795856)
print v(xbgr.mr_n61795968)
print v(xbgr.mr_n61796288)
print v(xbgr.mr_n61796400)
print v(xbgr.mr_n61796720)
print v(xbgr.mr_n61796832)
print v(xbgr.mr_n61797152)
print v(xbgr.mr_n61797264)
print v(xbgr.mr_n61797584)
print v(xbgr.mr_n61797696)
print v(xbgr.mr_n61798016)
print v(xbgr.mr_n61798128)
print v(xbgr.mr_n61798448)
print v(xbgr.mr_n61798560)
print v(xbgr.mr_n61798880)
print v(xbgr.mr_n61798992)
print v(xbgr.mr_n61799312)
print v(xbgr.mr_n61799424)
print v(xbgr.mr_n61799744)
print v(xbgr.mr_n61799856)
print v(xbgr.mr_n61800176)
print v(xbgr.mr_n61800288)
print v(xbgr.mr_n61800608)
print v(xbgr.mr_n61800720)
print v(xbgr.mr_n61801040)
print v(xbgr.mr_n61801152)
print v(xbgr.mr_n61801472)
print v(xbgr.mr_n61801584)
print v(xbgr.mr_n61801904)
print v(xbgr.mr_n61802016)
print v(xbgr.mr_n61802336)
print v(xbgr.mr_n61802448)
print v(xbgr.mr_n61802768)
print v(xbgr.mr_n61802880)
print v(xbgr.mr_n61803200)
print v(xbgr.mr_n61803312)
print v(xbgr.mr_n61803632)
print v(xbgr.mr_n61803744)
print v(xbgr.mr_n61804064)
print v(xbgr.mr_n61804176)
print v(xbgr.mr_n61804496)
print v(xbgr.mr_n61804608)
print v(xbgr.mr_n61804928)
print v(xbgr.mr_n61805040)
print v(xbgr.mr_n61805360)
print v(xbgr.mr_n61805472)
print v(xbgr.mr_n61805792)
print v(xbgr.mr_n61805904)
print v(xbgr.mr_n61806224)
print v(xbgr.mr_n61806336)
print v(xbgr.mr_n61806656)
print v(xbgr.mr_n61806768)
print v(xbgr.mr_n61807088)
print v(xbgr.mr_n61807200)
print v(xbgr.mr_n61807520)
print v(xbgr.mr_n61807632)
print v(xbgr.mr_n61807952)
print v(xbgr.mr_n61808064)
print v(xbgr.mr_n61808384)
print v(xbgr.mr_n61808496)
print v(xbgr.mr_n61808816)
print v(xbgr.mr_n61808928)
print v(xbgr.mr_n61809248)
print v(xbgr.mr_n61809360)
print v(xbgr.mr_n61809680)
print v(xbgr.mr_n61809792)
print v(xbgr.mr_n61810112)
print v(xbgr.mr_n61810224)
print v(xbgr.mr_n61810544)
print v(xbgr.mr_n61810656)
print v(xbgr.mr_n61810976)
print v(xbgr.mr_n61811088)
print v(xbgr.mr_n61811408)
print v(xbgr.mr_n61811520)
print v(xbgr.mr_n61811840)
print v(xbgr.mr_n61811952)
print v(xbgr.mr_n61812272)
print v(xbgr.mr_n61812384)
print v(xbgr.mr_n61812704)
print v(xbgr.mr_n61812816)
print v(xbgr.mr_n61813136)
print v(xbgr.mr_n61813248)
print v(xbgr.mr_n61813568)
print v(xbgr.mr_n61813680)
print v(xbgr.mr_n61814000)
print v(xbgr.mr_n61814112)
print v(xbgr.mr_n61814432)
print v(xbgr.mr_n61814544)
print v(xbgr.mr_n61814864)
print v(xbgr.mr_n61814976)
print v(xbgr.mr_n61815296)
print v(xbgr.mr_n61815408)
print v(xbgr.mr_n61815728)
print v(xbgr.mr_n61815840)
print v(xbgr.mr_n61816160)
print v(xbgr.mr_n61816272)
print v(xbgr.mr_n61816592)
print v(xbgr.mr_n61816704)
print v(xbgr.mr_n61817024)
print v(xbgr.mr_n61817136)
print v(xbgr.mr_n61817456)
print v(xbgr.mr_n61817568)
print v(xbgr.mr_n61817888)
print v(xbgr.mr_n61818000)
print v(xbgr.mr_n61818320)
print v(xbgr.mr_n61818432)
print v(xbgr.mr_n61818752)
print v(xbgr.mr_n61818864)
print v(xbgr.mr_n61819184)
print v(xbgr.mr_n61819296)
print v(xbgr.mr_n61819616)
print v(xbgr.mr_n61819728)
print v(xbgr.mr_n61820048)
print v(xbgr.mr_n61820160)
print v(xbgr.mr_n61820480)
print v(xbgr.mr_n61820592)
print v(xbgr.mr_n61820912)
print v(xbgr.mr_n61821024)
print v(xbgr.mr_n61821344)
print v(xbgr.mr_n61821456)
print v(xbgr.mr_n61821776)
print v(xbgr.mr_n61821888)
print v(xbgr.mr_n61822208)
print v(xbgr.mr_n61822320)
print v(xbgr.mr_n61822640)
print v(xbgr.mr_n61822752)
print v(xbgr.mr_n61823072)
print v(xbgr.mr_n61823184)
print v(xbgr.mr_n61823504)
print v(xbgr.mr_n61823616)
print v(xbgr.mr_n61823936)
print v(xbgr.mr_n61824048)
print v(xbgr.mr_n61824368)
print v(xbgr.mr_n61824480)
print v(xbgr.mr_n61824800)
print v(xbgr.mr_n61824912)
print v(xbgr.mr_n61825232)
print v(xbgr.mr_n61825344)
print v(xbgr.mr_n61825664)
print v(xbgr.mr_n61825776)
print v(xbgr.mr_n61826096)
print v(xbgr.mr_n61826208)
print v(xbgr.mr_n61826528)
print v(xbgr.mr_n61826640)
print v(xbgr.mr_n61826960)
print v(xbgr.mr_n61827072)
print v(xbgr.mr_n61827392)
print v(xbgr.mr_n61827504)
print v(xbgr.mr_n61827824)
print v(xbgr.mr_n61827936)
print v(xbgr.mr_n61828256)
print v(xbgr.mr_n61828368)
print v(xbgr.mr_n61828688)
print v(xbgr.mr_n61828800)
print v(xbgr.mr_n61829120)
print v(xbgr.mr_n61829232)
print v(xbgr.mr_n61829552)
print v(xbgr.mr_n61829664)
print v(xbgr.mr_n61829984)
print v(xbgr.mr_n61830096)
print v(xbgr.mr_n61830416)
print v(xbgr.mr_n61830528)
print v(xbgr.mr_n61830848)
print v(xbgr.mr_n61830960)
print v(xbgr.mr_n61831280)
print v(xbgr.mr_n61831392)
print v(xbgr.mr_n61831712)
print v(xbgr.mr_n61831824)
print v(xbgr.mr_n61832144)
print v(xbgr.mr_n61832256)
print v(xbgr.mr_n61832576)
print v(xbgr.mr_n61832688)
print v(xbgr.mr_n61833008)
print v(xbgr.mr_n61833120)
print v(xbgr.mr_n61833440)
print v(xbgr.mr_n61833552)
print v(xbgr.mr_n61833872)
print v(xbgr.mr_n61833984)
print v(xbgr.mr_n61834304)
print v(xbgr.mr_n61834416)
print v(xbgr.mr_n61834736)
print v(xbgr.mr_n61834848)
print v(xbgr.mr_n61835168)
print v(xbgr.mr_n61835280)
print v(xbgr.mr_n61835600)
print v(xbgr.mr_n61835712)
print v(xbgr.mr_n61836032)
print v(xbgr.mr_n61836144)
print v(xbgr.mr_n61836464)
print v(xbgr.mr_n61836576)
print v(xbgr.mr_n61836896)
print v(xbgr.mr_n61837008)
print v(xbgr.mr_n61837328)
print v(xbgr.mr_n61837440)
print v(xbgr.mr_n61837760)
print v(xbgr.mr_n61837872)
print v(xbgr.mr_n61838192)
print v(xbgr.mr_n61838304)
print v(xbgr.mr_n61838624)
print v(xbgr.mr_n61838736)
print v(xbgr.mr_n61839056)
print v(xbgr.mr_n61839168)
print v(xbgr.mr_n61839488)
print v(xbgr.mr_n61839600)
print v(xbgr.mr_n61839920)
print v(xbgr.mr_n61840032)
print v(xbgr.mr_n61840352)
print v(xbgr.mr_n61840464)
print v(xbgr.mr_n61840784)
print v(xbgr.mr_n61840896)
print v(xbgr.mr_n61841216)
print v(xbgr.mr_n61841328)
print v(xbgr.mr_n61841648)
print v(xbgr.mr_n61841760)
print v(xbgr.mr_n61842080)
print v(xbgr.mr_n61842192)
print v(xbgr.mr_n61842512)
print v(xbgr.mr_n61842624)
print v(xbgr.mr_n61842944)
print v(xbgr.mr_n61843056)
print v(xbgr.mr_n61843376)
print v(xbgr.mr_n61843488)
print v(xbgr.mr_n61843808)
print v(xbgr.mr_n61843920)
print v(xbgr.mr_n61844240)
print v(xbgr.mr_n61844352)
print v(xbgr.mr_n61844672)
print v(xbgr.mr_n61844784)
print v(xbgr.mr_n61845104)
print v(xbgr.mr_n61845216)
print v(xbgr.mr_n61845536)
print v(xbgr.mr_n61845648)
print v(xbgr.mr_n61845968)
print v(xbgr.mr_n61846080)
print v(xbgr.mr_n61846400)
print v(xbgr.mr_n61846512)
print v(xbgr.mr_n61846832)
print v(xbgr.mr_n61846944)
print v(xbgr.mr_n61847264)
print v(xbgr.mr_n61847376)
print v(xbgr.mr_n61847696)
print v(xbgr.mr_n61847808)
print v(xbgr.mr_n61848128)
print v(xbgr.mr_n61848240)
print v(xbgr.mr_n61848560)
print v(xbgr.mr_n61848672)
print v(xbgr.mr_n61848992)
print v(xbgr.mr_n61849104)
print v(xbgr.mr_n61849424)
print v(xbgr.mr_n61849536)
print v(xbgr.mr_n61849856)
print v(xbgr.mr_n61849968)
print v(xbgr.mr_n61850288)
print v(xbgr.mr_n61850400)
print v(xbgr.mr_n61850720)
print v(xbgr.mr_n61850832)
print v(xbgr.mr_n61851152)
print v(xbgr.mr_n61851264)
print v(xbgr.mr_n61851584)
print v(xbgr.mr_n61851696)
print v(xbgr.mr_n61852016)
print v(xbgr.mr_n61852128)
print v(xbgr.mr_n61852448)
print v(xbgr.mr_n61852560)
print v(xbgr.mr_n61852880)
print v(xbgr.mr_n61852992)
print v(xbgr.mr_n61853312)
print v(xbgr.mr_n61853424)
print v(xbgr.mr_n61853744)
print v(xbgr.mr_n61853856)
print v(xbgr.mr_n61854176)
print v(xbgr.mr_n61854288)
print v(xbgr.mr_n61854608)
print v(xbgr.mr_n61854720)
print v(xbgr.mr_n61855040)
print v(xbgr.mr_n61855152)
print v(xbgr.mr_n61855472)
print v(xbgr.mr_n61855584)
print v(xbgr.mr_n61855904)
print v(xbgr.mr_n61856016)
print v(xbgr.mr_n61856336)
print v(xbgr.mr_n61856448)
print v(xbgr.mr_n61856768)
print v(xbgr.mr_n61856880)
print v(xbgr.mr_n61857200)
print v(xbgr.mr_n61857312)
print v(xbgr.mr_n61857632)
print v(xbgr.mr_n61857744)
print v(xbgr.mr_n61858064)
print v(xbgr.mr_n61858176)
print v(xbgr.mr_n61858496)
print v(xbgr.mr_n61858608)
print v(xbgr.mr_n61858928)
print v(xbgr.mr_n61859040)
print v(xbgr.mr_n61859360)
print v(xbgr.mr_n61859472)
print v(xbgr.mr_n61859792)
print v(xbgr.mr_n61859904)
print v(xbgr.mr_n61860224)
print v(xbgr.mr_n61860336)
print v(xbgr.mr_n61860656)
print v(xbgr.mr_n61860768)
print v(xbgr.mr_n61861088)
print v(xbgr.mr_n61861200)
print v(xbgr.mr_n61861520)
print v(xbgr.mr_n61861632)
print v(xbgr.mr_n61861952)
print v(xbgr.mr_n61862064)
print v(xbgr.mr_n61862384)
print v(xbgr.mr_n61862496)
print v(xbgr.mr_n61862816)
print v(xbgr.mr_n61862928)
print v(xbgr.mr_n61863248)
print v(xbgr.mr_n61863360)
print v(xbgr.mr_n61863680)
print v(xbgr.mr_n61863792)
print v(xbgr.mr_n61864112)
print v(xbgr.mr_n61864224)
print v(xbgr.mr_n61864544)
print v(xbgr.mr_n61864656)
print v(xbgr.mr_n61864976)
print v(xbgr.mr_n61865088)
print v(xbgr.mr_n61865408)
print v(xbgr.mr_n61865520)
print v(xbgr.mr_n61865840)
print v(xbgr.mr_n61865952)
print v(xbgr.mr_n61866272)
print v(xbgr.mr_n61866384)
print v(xbgr.mr_n61866704)
print v(xbgr.mr_n61866816)
print v(xbgr.mr_n61867136)
print v(xbgr.mr_n61867248)
print v(xbgr.mr_n61867568)
print v(xbgr.mr_n61867680)
print v(xbgr.mr_n61868000)
print v(xbgr.mr_n61868112)
print v(xbgr.mr_n61868432)
print v(xbgr.mr_n61868544)
print v(xbgr.mr_n61868864)
print v(xbgr.mr_n61868976)
print v(xbgr.mr_n61869296)
print v(xbgr.mr_n61869408)
print v(xbgr.mr_n61869728)
print v(xbgr.mr_n61869840)
print v(xbgr.mr_n61870160)
print v(xbgr.mr_n61870272)
print v(xbgr.mr_n61870592)
print v(xbgr.mr_n61870704)
print v(xbgr.mr_n61871024)
print v(xbgr.mr_n61871136)
print v(xbgr.mr_n61871456)
print v(xbgr.mr_n61871568)
print v(xbgr.mr_n61871888)
print v(xbgr.mr_n61872000)
print v(xbgr.mr_n61872320)
print v(xbgr.mr_n61872432)
print v(xbgr.mr_n61872752)
print v(xbgr.mr_n61872864)
print v(xbgr.mr_n61873184)
print v(xbgr.mr_n61873296)
print v(xbgr.mr_n61873616)
print v(xbgr.mr_n61873728)
print v(xbgr.mr_n61874048)
print v(xbgr.mr_n61874160)
print v(xbgr.mr_n61874480)
print v(xbgr.mr_n61874592)
print v(xbgr.mr_n61874912)
print v(xbgr.mr_n61875024)
print v(xbgr.mr_n61875344)
print v(xbgr.mr_n61875456)
print v(xbgr.mr_n61875776)
print v(xbgr.mr_n61875888)
print v(xbgr.mr_n61876208)
print v(xbgr.mr_n61876320)
print v(xbgr.mr_n61876640)
print v(xbgr.mr_n61876752)
print v(xbgr.mr_n61877072)
print v(xbgr.mr_n61877184)
print v(xbgr.mr_n61877504)
print v(xbgr.mr_n61877616)
print v(xbgr.mr_n61877936)
print v(xbgr.mr_n61878048)
print v(xbgr.mr_n61878368)
print v(xbgr.mr_n61878480)
print v(xbgr.mr_n61878800)
print v(xbgr.mr_n61878912)
print v(xbgr.mr_n61879232)
print v(xbgr.mr_n61879344)
print v(xbgr.mr_n61879664)
print v(xbgr.mr_n61879776)
print v(xbgr.mr_n61880096)
print v(xbgr.mr_n61880208)
print v(xbgr.mr_n61880528)
print v(xbgr.mr_n61880640)
print v(xbgr.mr_n61880960)
print v(xbgr.mr_n61881072)
print v(xbgr.mr_n61881392)
print v(xbgr.mr_n61881504)
print v(xbgr.mr_n61881824)
print v(xbgr.mr_n61881936)
print v(xbgr.mr_n61882256)
print v(xbgr.mr_n61882368)
print v(xbgr.mr_n61882688)
print v(xbgr.mr_n61882800)
print v(xbgr.mr_n61883120)
print v(xbgr.mr_n61883232)
print v(xbgr.mr_n61883552)
print v(xbgr.mr_n61883664)
print v(xbgr.mr_n61883984)
print v(xbgr.mr_n61884096)
print v(xbgr.mr_n61884416)
print v(xbgr.mr_n61884528)
print v(xbgr.mr_n61884848)
print v(xbgr.mr_n61884960)
print v(xbgr.mr_n61885280)
print v(xbgr.mr_n61885392)
print v(xbgr.mr_n61885712)
print v(xbgr.mr_n61885824)
print v(xbgr.mr_n61886144)
print v(xbgr.mr_n61886256)
print v(xbgr.mr_n61886576)
print v(xbgr.mr_n61886688)
print v(xbgr.mr_n61887008)
print v(xbgr.mr_n61887120)
print v(xbgr.mr_n61887440)
print v(xbgr.mr_n61887552)
print v(xbgr.mr_n61887872)
print v(xbgr.mr_n61887984)
print v(xbgr.mr_n61888304)
print v(xbgr.mr_n61888416)
print v(xbgr.mr_n61888736)
print v(xbgr.mr_n61888848)
print v(xbgr.mr_n61889168)
print v(xbgr.mr_n61889280)
print v(xbgr.mr_n61889600)
print v(xbgr.mr_n61889712)
print v(xbgr.mr_n61890032)
print v(xbgr.mr_n61890144)
print v(xbgr.mr_n61890464)
print v(xbgr.mr_n61890576)
print v(xbgr.mr_n61890896)
print v(xbgr.mr_n61891008)
print v(xbgr.mr_n61891328)
print v(xbgr.mr_n61891440)
print v(xbgr.mr_n61891760)
print v(xbgr.mr_n61891872)
print v(xbgr.mr_n61892192)
print v(xbgr.mr_n61892304)
print v(xbgr.mr_n61892624)
print v(xbgr.mr_n61892736)
print v(xbgr.mr_n61893056)
print v(xbgr.mr_n61893168)
print v(xbgr.mr_n61893488)
print v(xbgr.mr_n61893600)
print v(xbgr.mr_n61893920)
print v(xbgr.mr_n61894032)
print v(xbgr.mr_n61894352)
print v(xbgr.mr_n61894464)
print v(xbgr.mr_n61894784)
print v(xbgr.mr_n61894896)
print v(xbgr.mr_n61895216)
print v(xbgr.mr_n61895328)
print v(xbgr.mr_n61895648)
print v(xbgr.mr_n61895760)
print v(xbgr.mr_n61896080)
print v(xbgr.mr_n61896192)
print v(xbgr.mr_n61896512)
print v(xbgr.mr_n61896624)
print v(xbgr.mr_n61896944)
print v(xbgr.mr_n61897056)
print v(xbgr.mr_n61897376)
print v(xbgr.mr_n61897488)
print v(xbgr.mr_n61897808)
print v(xbgr.mr_n61897920)
print v(xbgr.mr_n61898240)
print v(xbgr.mr_n61898352)
print v(xbgr.mr_n61898672)
print v(xbgr.mr_n61898784)
print v(xbgr.mr_n61899104)
print v(xbgr.mr_n61899216)
print v(xbgr.mr_n61899536)
print v(xbgr.mr_n61899648)
print v(xbgr.mr_n61899968)
print v(xbgr.mr_n61900080)
print v(xbgr.mr_n61900400)
print v(xbgr.mr_n61900512)
print v(xbgr.mr_n61900832)
print v(xbgr.mr_n61900944)
print v(xbgr.mr_n61901264)
print v(xbgr.mr_n61901376)
print v(xbgr.mr_n61901696)
print v(xbgr.mr_n61901808)
print v(xbgr.mr_n61902128)
print v(xbgr.mr_n61902240)
print v(xbgr.mr_n61902560)
print v(xbgr.mr_n61902672)
print v(xbgr.mr_n61902992)
print v(xbgr.mr_n61903104)
print v(xbgr.mr_n61903424)
print v(xbgr.mr_n61903536)
print v(xbgr.mr_n61903856)
print v(xbgr.mr_n61903968)
print v(xbgr.mr_n61904288)
print v(xbgr.mr_n61904400)
print v(xbgr.mr_n61904720)
print v(xbgr.mr_n61904832)
print v(xbgr.mr_n61905152)
print v(xbgr.mr_n61905264)
print v(xbgr.mr_n61905584)
print v(xbgr.mr_n61905696)
print v(xbgr.mr_n61906016)
print v(xbgr.mr_n61906128)
print v(xbgr.mr_n61906448)
print v(xbgr.mr_n61906560)
print v(xbgr.mr_n61906880)
print v(xbgr.mr_n61906992)
print v(xbgr.mr_n61907312)
print v(xbgr.mr_n61907424)
print v(xbgr.mr_n61907744)
print v(xbgr.mr_n61907856)
print v(xbgr.mr_n61908176)
print v(xbgr.mr_n61908288)
print v(xbgr.mr_n61908608)
print v(xbgr.mr_n61908720)
print v(xbgr.mr_n61909040)
print v(xbgr.mr_n61909152)
print v(xbgr.mr_n61909472)
print v(xbgr.mr_n61909584)
print v(xbgr.mr_n61909904)
print v(xbgr.mr_n61910016)
print v(xbgr.mr_n61910336)
print v(xbgr.mr_n61910448)
print v(xbgr.mr_n61910768)
print v(xbgr.mr_n61910880)
print v(xbgr.mr_n61911200)
print v(xbgr.mr_n61911312)
print v(xbgr.mr_n61911632)
print v(xbgr.mr_n61911744)
print v(xbgr.mr_n61912064)
print v(xbgr.mr_n61912176)
print v(xbgr.mr_n61912496)
print v(xbgr.mr_n61912608)
print v(xbgr.mr_n61912928)
print v(xbgr.mr_n61913040)
print v(xbgr.mr_n61913360)
print v(xbgr.mr_n61913472)
print v(xbgr.mr_n61913792)
print v(xbgr.mr_n61913904)
print v(xbgr.mr_n61914224)
print v(xbgr.mr_n61914336)
print v(xbgr.mr_n61914656)
print v(xbgr.mr_n61914768)
print v(xbgr.mr_n61915088)
print v(xbgr.mr_n61915200)
print v(xbgr.mr_n61915520)
print v(xbgr.mr_n61915632)
print v(xbgr.mr_n61915952)
print v(xbgr.mr_n61916064)
print v(xbgr.mr_n61916384)
print v(xbgr.mr_n61916496)
print v(xbgr.mr_n61916816)
print v(xbgr.mr_n61916928)
print v(xbgr.mr_n61917248)
print v(xbgr.mr_n61917360)
print v(xbgr.mr_n61917680)
print v(xbgr.mr_n61917792)
print v(xbgr.mr_n61918112)
print v(xbgr.mr_n61918224)
print v(xbgr.mr_n61918544)
print v(xbgr.mr_n61918656)
print v(xbgr.mr_n61918976)
print v(xbgr.mr_n61919088)
print v(xbgr.mr_n61919408)
print v(xbgr.mr_n61919520)
print v(xbgr.mr_n61919840)
print v(xbgr.mr_n61919952)
print v(xbgr.mr_n61920272)
print v(xbgr.mr_n61920384)
print v(xbgr.mr_n61920704)
print v(xbgr.mr_n61920816)
print v(xbgr.mr_n61921136)
print v(xbgr.mr_n61921248)
print v(xbgr.mr_n61921568)
print v(xbgr.mr_n61921680)
print v(xbgr.mr_n61922000)
print v(xbgr.mr_n61922112)
print v(xbgr.mr_n61922432)
print v(xbgr.mr_n61922544)
print v(xbgr.mr_n61922864)
print v(xbgr.mr_n61922976)
print v(xbgr.mr_n61923296)
print v(xbgr.mr_n61923408)
print v(xbgr.mr_n61923840)
print v(xbgr.mr_n61924160)
print v(xbgr.mr_n61924272)
print v(xbgr.mr_n61924704)
print v(xbgr.mr_n61925024)
print v(xbgr.mr_n61925136)
print v(xbgr.mr_n61925568)
print v(xbgr.mr_n61925888)
print v(xbgr.mr_n61926752)
print v(xbgr.mr_n61927616)
print v(xbgr.mr_n61928480)
print v(xbgr.mr_n61929344)
print v(xbgr.mr_n61930208)
print v(xbgr.mr_n61931072)
print v(xbgr.mr_n61931184)
print v(xbgr.mr_n61931504)
print v(xbgr.mr_n61931616)
print v(xbgr.mr_n61931936)
print v(xbgr.mr_n61932048)
print v(xbgr.mr_n61932368)
print v(xbgr.mr_n61932480)
print v(xbgr.mr_n61932800)
print v(xbgr.mr_n61933664)
print v(xbgr.mr_n61934528)
print v(xbgr.mr_n61935392)
print v(xbgr.mr_n61935504)
print v(xbgr.mr_n61935824)
print v(xbgr.mr_n61935936)
print v(xbgr.mr_n61936256)
print v(xbgr.mr_n61936368)
print v(xbgr.mr_n61936800)
print v(xbgr.mr_n61937232)
print v(xbgr.mr_n61937664)
print v(xbgr.mr_n61937984)
print v(xbgr.mr_n61938096)
print v(xbgr.mr_n61938416)
print v(xbgr.mr_n61938528)
print v(xbgr.mr_n61938848)
print v(xbgr.mr_n61938960)
print v(xbgr.mr_n61939280)
print v(xbgr.mr_n61939392)
print v(xbgr.mr_n61939712)
print v(xbgr.mr_n61939824)
print v(xbgr.mr_n61940144)
print v(xbgr.mr_n61940256)
print v(xbgr.mr_n61940576)
print v(xbgr.mr_n61940688)
print v(xbgr.mr_n61941008)
print v(xbgr.mr_n61941120)
print v(xbgr.mr_n61941440)
print v(xbgr.mr_n61941552)
print v(xbgr.mr_n61941872)
print v(xbgr.mr_n61941984)
print v(xbgr.mr_n61942304)
print v(xbgr.mr_n61942416)
print v(xbgr.mr_n61942736)
print v(xbgr.mr_n61942848)
print v(xbgr.mr_n61943168)
print v(xbgr.mr_n61943280)
print v(xbgr.mr_n61943600)
print v(xbgr.mr_n61943712)
print v(xbgr.mr_n61944032)
print v(xbgr.mr_n61944144)
print v(xbgr.mr_n61944464)
print v(xbgr.mr_n61944576)
print v(xbgr.mr_n61944896)
print v(xbgr.mr_n61945008)
print v(xbgr.mr_n61945328)
print v(xbgr.mr_n61945440)
print v(xbgr.mr_n61945760)
print v(xbgr.mr_n61945872)
print v(xbgr.mr_n61946192)
print v(xbgr.mr_n61946304)
print v(xbgr.mr_n61946624)
print v(xbgr.mr_n61946736)
print v(xbgr.mr_n61947056)
print v(xbgr.mr_n61947168)
print v(xbgr.mr_n61947488)
print v(xbgr.mr_n61947600)
print v(xbgr.mr_n61947920)
print v(xbgr.mr_n61948032)
print v(xbgr.mr_n61948352)
print v(xbgr.mr_n61948464)
print v(xbgr.mr_n61948784)
print v(xbgr.mr_n61948896)
print v(xbgr.mr_n61949216)
print v(xbgr.mr_n61949328)
print v(xbgr.mr_n61949648)
print v(xbgr.mr_n61949760)
print v(xbgr.mr_n61950080)
print v(xbgr.mr_n61950192)
print v(xbgr.mr_n61950512)
print v(xbgr.mr_n61950624)
print v(xbgr.mr_n61950944)
print v(xbgr.mr_n61951056)
print v(xbgr.mr_n61951488)
print v(xbgr.mr_n61951808)
print v(xbgr.mr_n61951920)
print v(xbgr.mr_n61952352)
print v(xbgr.mr_n61952672)
print v(xbgr.mr_n61953536)
print v(xbgr.mr_n61954400)
print v(xbgr.mr_n61955264)
print v(xbgr.mr_n61956128)
print v(xbgr.mr_n61956240)
print v(xbgr.mr_n61956560)
print v(xbgr.mr_n61956672)
print v(xbgr.mr_n61956992)
print v(xbgr.mr_n61957104)
print v(xbgr.mr_n61957424)
print v(xbgr.mr_n61957536)
print v(xbgr.mr_n61957856)
print v(xbgr.mr_n61958720)
print v(xbgr.mr_n61959584)
print v(xbgr.mr_n61959696)
print v(xbgr.mr_n61960016)
print v(xbgr.mr_n61960128)
print v(xbgr.mr_n61960448)
print v(xbgr.mr_n61960560)
print v(xbgr.mr_n61960880)
print v(xbgr.mr_n61960992)
print v(xbgr.mr_n61961312)
print v(xbgr.mr_n61961424)
print v(xbgr.mr_n61961856)
print v(xbgr.mr_n61962176)
print v(xbgr.mr_n61962288)
print v(xbgr.mr_n61962720)
print v(xbgr.mr_n61963040)
print v(xbgr.mr_n61963904)
print v(xbgr.mr_n61964768)
print v(xbgr.mr_n61965632)
print v(xbgr.mr_n61966496)
print v(xbgr.mr_n61966608)
print v(xbgr.mr_n61966928)
print v(xbgr.mr_n61967040)
print v(xbgr.mr_n61967360)
print v(xbgr.mr_n61967472)
print v(xbgr.mr_n61967792)
print v(xbgr.mr_n61967904)
print v(xbgr.mr_n61968224)
print v(xbgr.mr_n61969088)
print v(xbgr.mr_n61969952)
print v(xbgr.mr_n61970064)
print v(xbgr.mr_n61970496)
print v(xbgr.mr_n61970816)
print v(xbgr.mr_n61970928)
print v(xbgr.mr_n61971248)
print v(xbgr.mr_n61971360)
print v(xbgr.mr_n61971680)
print v(xbgr.mr_n61971792)
print v(xbgr.mr_n61972112)
print v(xbgr.mr_n61972224)
print v(xbgr.mr_n61972544)
print v(xbgr.mr_n61972656)
print v(xbgr.mr_n61973088)
print v(xbgr.mr_n61973408)
print v(xbgr.mr_n61974272)
print v(xbgr.mr_n61974384)
print v(xbgr.mr_n61974816)
print v(xbgr.mr_n61975136)
print v(xbgr.mr_n61975248)
print v(xbgr.mr_n61975680)
print v(xbgr.mr_n61976000)
print v(xbgr.mr_n61976112)
print v(xbgr.mr_n61976432)
print v(xbgr.mr_n61976544)
print v(xbgr.mr_n61976864)
print v(xbgr.mr_n61976976)
print v(xbgr.mr_n61977296)
print v(xbgr.mr_n61977408)
print v(xbgr.mr_n61977728)
print v(xbgr.mr_n61978592)
print v(xbgr.mr_n61979456)
print v(xbgr.mr_n61979568)
print v(xbgr.mr_n61979888)
print v(xbgr.mr_n61980000)
print v(xbgr.mr_n61980320)
print v(xbgr.mr_n61980432)
print v(xbgr.mr_n61980752)
print v(xbgr.mr_n61980864)
print v(xbgr.mr_n61981184)
print v(xbgr.mr_n61982048)
print v(xbgr.mr_n61982912)
print v(xbgr.mr_n61983024)
print v(xbgr.mr_n61983344)
print v(xbgr.mr_n61983456)
print v(xbgr.mr_n61983776)
print v(xbgr.mr_n61984640)
print v(xbgr.mr_n61984752)
print v(xbgr.mr_n61985072)
print v(xbgr.mr_n61985184)
print v(xbgr.mr_n61985504)
print v(xbgr.mr_n61985616)
print v(xbgr.mr_n61985936)
print v(xbgr.mr_n61986048)
print v(xbgr.mr_n61986368)
print v(xbgr.mr_n61986480)
print v(xbgr.mr_n61986800)
print v(xbgr.mr_n61986912)
print v(xbgr.mr_n61987232)
print v(xbgr.mr_n61988096)
print v(xbgr.mr_n61988896)
print v(xbgr.mr_n61989008)
print v(xbgr.mr_n61989328)
print v(xbgr.mr_n61989440)
print v(xbgr.mr_n61989760)
print v(xbgr.mr_n61989872)
print v(xbgr.mr_n61990192)
print v(xbgr.mr_n61990304)
print v(xbgr.mr_n61990624)
print v(xbgr.mr_n61990736)
print v(xbgr.mr_n61991056)
print v(xbgr.mr_n61991168)
print v(xbgr.mr_n61991488)
print v(xbgr.mr_n61991600)
print v(xbgr.mr_n61991920)
print v(xbgr.mr_n61992032)
print v(xbgr.mr_n61992352)
print v(xbgr.mr_n61992464)
print v(xbgr.mr_n61992784)
print v(xbgr.mr_n61992896)
print v(xbgr.mr_n61993216)
print v(xbgr.mr_n61993328)
print v(xbgr.mr_n61993648)
print v(xbgr.mr_n61993760)
print v(xbgr.mr_n61994080)
print v(xbgr.mr_n61994192)
print v(xbgr.mr_n61994512)
print v(xbgr.mr_n61994624)
print v(xbgr.mr_n61994944)
print v(xbgr.mr_n61995056)
print v(xbgr.mr_n61995376)
print v(xbgr.mr_n61995488)
print v(xbgr.mr_n61995808)
print v(xbgr.mr_n61995920)
print v(xbgr.mr_n61996240)
print v(xbgr.mr_n61996352)
print v(xbgr.mr_n61996672)
print v(xbgr.mr_n61996784)
print v(xbgr.mr_n61997104)
print v(xbgr.mr_n61997216)
print v(xbgr.mr_n61997536)
print v(xbgr.mr_n61997648)
print v(xbgr.mr_n61997968)
print v(xbgr.mr_n61998080)
print v(xbgr.mr_n61998400)
print v(xbgr.mr_n61998512)
print v(xbgr.mr_n61998832)
print v(xbgr.mr_n61998944)
print v(xbgr.mr_n61999264)
print v(xbgr.mr_n61999376)
print v(xbgr.mr_n61999696)
print v(xbgr.mr_n61999808)
print v(xbgr.mr_n62000128)
print v(xbgr.mr_n62000240)
print v(xbgr.mr_n62000560)
print v(xbgr.mr_n62000672)
print v(xbgr.mr_n62000992)
print v(xbgr.mr_n62001104)
print v(xbgr.mr_n62001424)
print v(xbgr.mr_n62001536)
print v(xbgr.mr_n62001856)
print v(xbgr.mr_n62001968)
print v(xbgr.mr_n62002288)
print v(xbgr.mr_n62002400)
print v(xbgr.mr_n62002720)
print v(xbgr.mr_n62002832)
print v(xbgr.mr_n62003152)
print v(xbgr.mr_n62003264)
print v(xbgr.mr_n62003584)
print v(xbgr.mr_n62003696)
print v(xbgr.mr_n62004016)
print v(xbgr.mr_n62004128)
print v(xbgr.mr_n62004448)
print v(xbgr.mr_n62004560)
print v(xbgr.mr_n62004880)
print v(xbgr.mr_n62004992)
print v(xbgr.mr_n62005312)
print v(xbgr.mr_n62005424)
print v(xbgr.mr_n62005744)
print v(xbgr.mr_n62005856)
print v(xbgr.mr_n62006176)
print v(xbgr.mr_n62006288)
print v(xbgr.mr_n62006608)
print v(xbgr.mr_n62006720)
print v(xbgr.mr_n62007040)
print v(xbgr.mr_n62007152)
print v(xbgr.mr_n62007472)
print v(xbgr.mr_n62007584)
print v(xbgr.mr_n62007904)
print v(xbgr.mr_n62008016)
print v(xbgr.mr_n62008336)
print v(xbgr.mr_n62008448)
print v(xbgr.mr_n62008768)
print v(xbgr.mr_n62008880)
print v(xbgr.mr_n62009200)
print v(xbgr.mr_n62009312)
print v(xbgr.mr_n62009632)
print v(xbgr.mr_n62009744)
print v(xbgr.mr_n62010064)
print v(xbgr.mr_n62010176)
print v(xbgr.mr_n62010496)
print v(xbgr.mr_n62010608)
print v(xbgr.mr_n62010928)
print v(xbgr.mr_n62011040)
print v(xbgr.mr_n62011360)
print v(xbgr.mr_n62011472)
print v(xbgr.mr_n62011792)
print v(xbgr.mr_n62011904)
print v(xbgr.mr_n62012224)
print v(xbgr.mr_n62012336)
print v(xbgr.mr_n62012656)
print v(xbgr.mr_n62012768)
print v(xbgr.mr_n62013088)
print v(xbgr.mr_n62013200)
print v(xbgr.mr_n62013520)
print v(xbgr.mr_n62013632)
print v(xbgr.mr_n62013952)
print v(xbgr.mr_n62014064)
print v(xbgr.mr_n62014384)
print v(xbgr.mr_n62014496)
print v(xbgr.mr_n62014816)
print v(xbgr.mr_n62014928)
print v(xbgr.mr_n62015248)
print v(xbgr.mr_n62015360)
print v(xbgr.mr_n62015680)
print v(xbgr.mr_n62015792)
print v(xbgr.mr_n62016112)
print v(xbgr.mr_n62016224)
print v(xbgr.mr_n62016544)
print v(xbgr.mr_n62016656)
print v(xbgr.mr_n62016976)
print v(xbgr.mr_n62017088)
print v(xbgr.mr_n62017408)
print v(xbgr.mr_n62017520)
print v(xbgr.mr_n62017840)
print v(xbgr.mr_n62017952)
print v(xbgr.mr_n62018272)
print v(xbgr.mr_n62018384)
print v(xbgr.mr_n62018704)
print v(xbgr.mr_n62018816)
print v(xbgr.mr_n62019136)
print v(xbgr.mr_n62019248)
print v(xbgr.mr_n62019568)
print v(xbgr.mr_n62019680)
print v(xbgr.mr_n62020000)
print v(xbgr.mr_n62020112)
print v(xbgr.mr_n62020432)
print v(xbgr.mr_n62020544)
print v(xbgr.mr_n62020864)
print v(xbgr.mr_n62020976)
print v(xbgr.mr_n62021296)
print v(xbgr.mr_n62021408)
print v(xbgr.mr_n62021728)
print v(xbgr.mr_n62021840)
print v(xbgr.mr_n62022160)
print v(xbgr.mr_n62022272)
print v(xbgr.mr_n62022592)
print v(xbgr.mr_n62022704)
print v(xbgr.mr_n62023024)
print v(xbgr.mr_n62023136)
print v(xbgr.mr_n62023456)
print v(xbgr.mr_n62023568)
print v(xbgr.mr_n62023888)
print v(xbgr.mr_n62024000)
print v(xbgr.mr_n62024320)
print v(xbgr.mr_n62024432)
print v(xbgr.mr_n62024752)
print v(xbgr.mr_n62024864)
print v(xbgr.mr_n62025184)
print v(xbgr.mr_n62025296)
print v(xbgr.mr_n62025616)
print v(xbgr.mr_n62025728)
print v(xbgr.mr_n62026048)
print v(xbgr.mr_n62026160)
print v(xbgr.mr_n62026480)
print v(xbgr.mr_n62026592)
print v(xbgr.mr_n62026912)
print v(xbgr.mr_n62027024)
print v(xbgr.mr_n62027344)
print v(xbgr.mr_n62027456)
print v(xbgr.mr_n62027776)
print v(xbgr.mr_n62027888)
print v(xbgr.mr_n62028208)
print v(xbgr.mr_n62028320)
print v(xbgr.mr_n62028640)
print v(xbgr.mr_n62028752)
print v(xbgr.mr_n62029072)
print v(xbgr.mr_n62029184)
print v(xbgr.mr_n62029504)
print v(xbgr.mr_n62029616)
print v(xbgr.mr_n62029936)
print v(xbgr.mr_n62030048)
print v(xbgr.mr_n62030368)
print v(xbgr.mr_n62030480)
print v(xbgr.mr_n62030800)
print v(xbgr.mr_n62030912)
print v(xbgr.mr_n62031232)
print v(xbgr.mr_n62031344)
print v(xbgr.mr_n62031664)
print v(xbgr.mr_n62031776)
print v(xbgr.mr_n62032096)
print v(xbgr.mr_n62032208)
print v(xbgr.mr_n62032528)
print v(xbgr.mr_n62032640)
print v(xbgr.mr_n62032960)
print v(xbgr.mr_n62033072)
print v(xbgr.mr_n62033392)
print v(xbgr.mr_n62033504)
print v(xbgr.mr_n62033824)
print v(xbgr.mr_n62033936)
print v(xbgr.mr_n62034256)
print v(xbgr.mr_n62034368)
print v(xbgr.mr_n62034688)
print v(xbgr.mr_n62034800)
print v(xbgr.mr_n62035120)
print v(xbgr.mr_n62035232)
print v(xbgr.mr_n62035552)
print v(xbgr.mr_n62035664)
print v(xbgr.mr_n62035984)
print v(xbgr.mr_n62036096)
print v(xbgr.mr_n62036416)
print v(xbgr.mr_n62036528)
print v(xbgr.mr_n62036848)
print v(xbgr.mr_n62036960)
print v(xbgr.mr_n62037280)
print v(xbgr.mr_n62037392)
print v(xbgr.mr_n62037712)
print v(xbgr.mr_n62037824)
print v(xbgr.mr_n62038144)
print v(xbgr.mr_n62038256)
print v(xbgr.mr_n62038576)
print v(xbgr.mr_n62038688)
print v(xbgr.mr_n62039008)
print v(xbgr.mr_n62039120)
print v(xbgr.mr_n62039440)
print v(xbgr.mr_n62039552)
print v(xbgr.mr_n62039872)
print v(xbgr.mr_n62039984)
print v(xbgr.mr_n62040304)
print v(xbgr.mr_n62040416)
print v(xbgr.mr_n62040736)
print v(xbgr.mr_n62040848)
print v(xbgr.mr_n62041168)
print v(xbgr.mr_n62041280)
print v(xbgr.mr_n62041600)
print v(xbgr.mr_n62041712)
print v(xbgr.mr_n62042032)
print v(xbgr.mr_n62042144)
print v(xbgr.mr_n62042464)
print v(xbgr.mr_n62042576)
print v(xbgr.mr_n62042896)
print v(xbgr.mr_n62043008)
print v(xbgr.mr_n62043328)
print v(xbgr.mr_n62043440)
print v(xbgr.mr_n62043760)
print v(xbgr.mr_n62043872)
print v(xbgr.mr_n62044192)
print v(xbgr.mr_n62044304)
print v(xbgr.mr_n62044624)
print v(xbgr.mr_n62044736)
print v(xbgr.mr_n62045056)
print v(xbgr.mr_n62045168)
print v(xbgr.mr_n62045488)
print v(xbgr.mr_n62045600)
print v(xbgr.mr_n62045920)
print v(xbgr.mr_n62046032)
print v(xbgr.mr_n62046352)
print v(xbgr.mr_n62046464)
print v(xbgr.mr_n62046784)
print v(xbgr.mr_n62046896)
print v(xbgr.mr_n62047216)
print v(xbgr.mr_n62047328)
print v(xbgr.mr_n62047648)
print v(xbgr.mr_n62047760)
print v(xbgr.mr_n62048080)
print v(xbgr.mr_n62048192)
print v(xbgr.mr_n62048512)
print v(xbgr.mr_n62048624)
print v(xbgr.mr_n62048944)
print v(xbgr.mr_n62049056)
print v(xbgr.mr_n62049376)
print v(xbgr.mr_n62049488)
print v(xbgr.mr_n62049808)
print v(xbgr.mr_n62049920)
print v(xbgr.mr_n62050240)
print v(xbgr.mr_n62050352)
print v(xbgr.mr_n62050672)
print v(xbgr.mr_n62050784)
print v(xbgr.mr_n62051104)
print v(xbgr.mr_n62051216)
print v(xbgr.mr_n62051536)
print v(xbgr.mr_n62051648)
print v(xbgr.mr_n62051968)
print v(xbgr.mr_n62052080)
print v(xbgr.mr_n62052400)
print v(xbgr.mr_n62052512)
print v(xbgr.mr_n62052832)
print v(xbgr.mr_n62052944)
print v(xbgr.mr_n62053264)
print v(xbgr.mr_n62053376)
print v(xbgr.mr_n62053696)
print v(xbgr.mr_n62053808)
print v(xbgr.mr_n62054128)
print v(xbgr.mr_n62054240)
print v(xbgr.mr_n62054560)
print v(xbgr.mr_n62054672)
print v(xbgr.mr_n62054992)
print v(xbgr.mr_n62055104)
print v(xbgr.mr_n62055424)
print v(xbgr.mr_n62055536)
print v(xbgr.mr_n62055856)
print v(xbgr.mr_n62055968)
print v(xbgr.mr_n62056288)
print v(xbgr.mr_n62056400)
print v(xbgr.mr_n62056720)
print v(xbgr.mr_n62056832)
print v(xbgr.mr_n62057152)
print v(xbgr.mr_n62057264)
print v(xbgr.mr_n62057584)
print v(xbgr.mr_n62057696)
print v(xbgr.mr_n62058016)
print v(xbgr.mr_n62058128)
print v(xbgr.mr_n62058448)
print v(xbgr.mr_n62058560)
print v(xbgr.mr_n62058880)
print v(xbgr.mr_n62058992)
print v(xbgr.mr_n62059312)
print v(xbgr.mr_n62059424)
print v(xbgr.mr_n62059744)
print v(xbgr.mr_n62059856)
print v(xbgr.mr_n62060176)
print v(xbgr.mr_n62060288)
print v(xbgr.mr_n62060608)
print v(xbgr.mr_n62060720)
print v(xbgr.mr_n62061040)
print v(xbgr.mr_n62061152)
print v(xbgr.mr_n62061472)
print v(xbgr.mr_n62061584)
print v(xbgr.mr_n62061904)
print v(xbgr.mr_n62062016)
print v(xbgr.mr_n62062336)
print v(xbgr.mr_n62062448)
print v(xbgr.mr_n62062768)
print v(xbgr.mr_n62062880)
print v(xbgr.mr_n62063200)
print v(xbgr.mr_n62063312)
print v(xbgr.mr_n62063632)
print v(xbgr.mr_n62063744)
print v(xbgr.mr_n62064064)
print v(xbgr.mr_n62064176)
print v(xbgr.mr_n62064496)
print v(xbgr.mr_n62064608)
print v(xbgr.mr_n62064928)
print v(xbgr.mr_n62065040)
print v(xbgr.mr_n62065360)
print v(xbgr.mr_n62065472)
print v(xbgr.mr_n62065792)
print v(xbgr.mr_n62065904)
print v(xbgr.mr_n62066224)
print v(xbgr.mr_n62066336)
print v(xbgr.mr_n62066656)
print v(xbgr.mr_n62066768)
print v(xbgr.mr_n62067088)
print v(xbgr.mr_n62067200)
print v(xbgr.mr_n62067520)
print v(xbgr.mr_n62067632)
print v(xbgr.mr_n62067952)
print v(xbgr.mr_n62068064)
print v(xbgr.mr_n62068384)
print v(xbgr.mr_n62068496)
print v(xbgr.mr_n62068816)
print v(xbgr.mr_n62068928)
print v(xbgr.mr_n62069248)
print v(xbgr.mr_n62069360)
print v(xbgr.mr_n62069680)
print v(xbgr.mr_n62069792)
print v(xbgr.mr_n62070112)
print v(xbgr.mr_n62070224)
print v(xbgr.mr_n62070544)
print v(xbgr.mr_n62070656)
print v(xbgr.mr_n62070976)
print v(xbgr.mr_n62071088)
print v(xbgr.mr_n62071408)
print v(xbgr.mr_n62071520)
print v(xbgr.mr_n62071840)
print v(xbgr.mr_n62071952)
print v(xbgr.mr_n62072272)
print v(xbgr.mr_n62072384)
print v(xbgr.mr_n62072704)
print v(xbgr.mr_n62072816)
print v(xbgr.mr_n62073136)
print v(xbgr.mr_n62073248)
print v(xbgr.mr_n62073568)
print v(xbgr.mr_n62073680)
print v(xbgr.mr_n62074000)
print v(xbgr.mr_n62074112)
print v(xbgr.mr_n62074432)
print v(xbgr.mr_n62074544)
print v(xbgr.mr_n62074864)
print v(xbgr.mr_n62074976)
print v(xbgr.mr_n62075296)
print v(xbgr.mr_n62075408)
print v(xbgr.mr_n62075728)
print v(xbgr.mr_n62075840)
print v(xbgr.mr_n62076160)
print v(xbgr.mr_n62076272)
print v(xbgr.mr_n62076592)
print v(xbgr.mr_n62076704)
print v(xbgr.mr_n62077024)
print v(xbgr.mr_n62077136)
print v(xbgr.mr_n62077456)
print v(xbgr.mr_n62077568)
print v(xbgr.mr_n62077888)
print v(xbgr.mr_n62078000)
print v(xbgr.mr_n62078320)
print v(xbgr.mr_n62078432)
print v(xbgr.mr_n62078752)
print v(xbgr.mr_n62078864)
print v(xbgr.mr_n62079184)
print v(xbgr.mr_n62079296)
print v(xbgr.mr_n62079616)
print v(xbgr.mr_n62079728)
print v(xbgr.mr_n62080048)
print v(xbgr.mr_n62080160)
print v(xbgr.mr_n62080480)
print v(xbgr.mr_n62080592)
print v(xbgr.mr_n62080912)
print v(xbgr.mr_n62081024)
print v(xbgr.mr_n62081344)
print v(xbgr.mr_n62081456)
print v(xbgr.mr_n62081776)
print v(xbgr.mr_n62081888)
print v(xbgr.mr_n62082208)
print v(xbgr.mr_n62082320)
print v(xbgr.mr_n62082640)
print v(xbgr.mr_n62082752)
print v(xbgr.mr_n62083072)
print v(xbgr.mr_n62083184)
print v(xbgr.mr_n62083504)
print v(xbgr.mr_n62083616)
print v(xbgr.mr_n62083936)
print v(xbgr.mr_n62084048)
print v(xbgr.mr_n62084368)
print v(xbgr.mr_n62084480)
print v(xbgr.mr_n62084800)
print v(xbgr.mr_n62084912)
print v(xbgr.mr_n62085232)
print v(xbgr.mr_n62085344)
print v(xbgr.mr_n62085664)
print v(xbgr.mr_n62085776)
print v(xbgr.mr_n62086096)
print v(xbgr.mr_n62086208)
print v(xbgr.mr_n62086528)
print v(xbgr.mr_n62086640)
print v(xbgr.mr_n62086960)
print v(xbgr.mr_n62087072)
print v(xbgr.mr_n62087392)
print v(xbgr.mr_n62087504)
print v(xbgr.mr_n62087824)
print v(xbgr.mr_n62087936)
print v(xbgr.mr_n62088256)
print v(xbgr.mr_n62088368)
print v(xbgr.mr_n62088688)
print v(xbgr.mr_n62088800)
print v(xbgr.mr_n62089120)
print v(xbgr.mr_n62089232)
print v(xbgr.mr_n62089552)
print v(xbgr.mr_n62089664)
print v(xbgr.mr_n62089984)
print v(xbgr.mr_n62090096)
print v(xbgr.mr_n62090416)
print v(xbgr.mr_n62090528)
print v(xbgr.mr_n62090848)
print v(xbgr.mr_n62090960)
print v(xbgr.mr_n62091280)
print v(xbgr.mr_n62091392)
print v(xbgr.mr_n62091712)
print v(xbgr.mr_n62091824)
print v(xbgr.mr_n62092144)
print v(xbgr.mr_n62092256)
print v(xbgr.mr_n62092576)
print v(xbgr.mr_n62092688)
print v(xbgr.mr_n62093008)
print v(xbgr.mr_n62093120)
print v(xbgr.mr_n62093440)
print v(xbgr.mr_n62093552)
print v(xbgr.mr_n62093872)
print v(xbgr.mr_n62093984)
print v(xbgr.mr_n62094304)
print v(xbgr.mr_n62094416)
print v(xbgr.mr_n62094736)
print v(xbgr.mr_n62094848)
print v(xbgr.mr_n62095168)
print v(xbgr.mr_n62095280)
print v(xbgr.mr_n62095600)
print v(xbgr.mr_n62095712)
print v(xbgr.mr_n62096032)
print v(xbgr.mr_n62096144)
print v(xbgr.mr_n62096464)
print v(xbgr.mr_n62096576)
print v(xbgr.mr_n62096896)
print v(xbgr.mr_n62097008)
print v(xbgr.mr_n62097328)
print v(xbgr.mr_n62097440)
print v(xbgr.mr_n62097760)
print v(xbgr.mr_n62097872)
print v(xbgr.mr_n62098192)
print v(xbgr.mr_n62098304)
print v(xbgr.mr_n62098624)
print v(xbgr.mr_n62098736)
print v(xbgr.mr_n62099056)
print v(xbgr.mr_n62099168)
print v(xbgr.mr_n62099488)
print v(xbgr.mr_n62099600)
print v(xbgr.mr_n62099920)
print v(xbgr.mr_n62100032)
print v(xbgr.mr_n62100352)
print v(xbgr.mr_n62100464)
print v(xbgr.mr_n62100784)
print v(xbgr.mr_n62100896)
print v(xbgr.mr_n62101216)
print v(xbgr.mr_n62101328)
print v(xbgr.mr_n62101648)
print v(xbgr.mr_n62101760)
print v(xbgr.mr_n62102080)
print v(xbgr.mr_n62102192)
print v(xbgr.mr_n62102512)
print v(xbgr.mr_n62102624)
print v(xbgr.mr_n62102944)
print v(xbgr.mr_n62103056)
print v(xbgr.mr_n62103376)
print v(xbgr.mr_n62103488)
print v(xbgr.mr_n62103808)
print v(xbgr.mr_n62103920)
print v(xbgr.mr_n62104240)
print v(xbgr.mr_n62104352)
print v(xbgr.mr_n62104672)
print v(xbgr.mr_n62104784)
print v(xbgr.mr_n62105104)
print v(xbgr.mr_n62105216)
print v(xbgr.mr_n62105536)
print v(xbgr.mr_n62105648)
print v(xbgr.mr_n62105968)
print v(xbgr.mr_n62106080)
print v(xbgr.mr_n62106400)
print v(xbgr.mr_n62106512)
print v(xbgr.mr_n62106832)
print v(xbgr.mr_n62106944)
print v(xbgr.mr_n62107264)
print v(xbgr.mr_n62107376)
print v(xbgr.mr_n62107696)
print v(xbgr.mr_n62107808)
print v(xbgr.mr_n62108128)
print v(xbgr.mr_n62108240)
print v(xbgr.mr_n62108560)
print v(xbgr.mr_n62108672)
print v(xbgr.mr_n62108992)
print v(xbgr.mr_n62109104)
print v(xbgr.mr_n62109424)
print v(xbgr.mr_n62109536)
print v(xbgr.mr_n62109856)
print v(xbgr.mr_n62109968)
print v(xbgr.mr_n62110288)
print v(xbgr.mr_n62110400)
print v(xbgr.mr_n62110720)
print v(xbgr.mr_n62110832)
print v(xbgr.mr_n62111152)
print v(xbgr.mr_n62111264)
print v(xbgr.mr_n62111584)
print v(xbgr.mr_n62111696)
print v(xbgr.mr_n62112016)
print v(xbgr.mr_n62112128)
print v(xbgr.mr_n62112448)
print v(xbgr.mr_n62112560)
print v(xbgr.mr_n62112880)
print v(xbgr.mr_n62112992)
print v(xbgr.mr_n62113312)
print v(xbgr.mr_n62113424)
print v(xbgr.mr_n62113744)
print v(xbgr.mr_n62113856)
print v(xbgr.mr_n62114176)
print v(xbgr.mr_n62114288)
print v(xbgr.mr_n62114608)
print v(xbgr.mr_n62114720)
print v(xbgr.mr_n62115040)
print v(xbgr.mr_n62115152)
print v(xbgr.mr_n62115472)
print v(xbgr.mr_n62115584)
print v(xbgr.mr_n62115904)
print v(xbgr.mr_n62116016)
print v(xbgr.mr_n62116336)
print v(xbgr.mr_n62116448)
print v(xbgr.mr_n62116768)
print v(xbgr.mr_n62116880)
print v(xbgr.mr_n62117200)
print v(xbgr.mr_n62117312)
print v(xbgr.mr_n62117632)
print v(xbgr.mr_n62117744)
print v(xbgr.mr_n62118064)
print v(xbgr.mr_n62118176)
print v(xbgr.mr_n62118496)
print v(xbgr.mr_n62118608)
print v(xbgr.mr_n62118928)
print v(xbgr.mr_n62119040)
print v(xbgr.mr_n62119360)
print v(xbgr.mr_n62119472)
print v(xbgr.mr_n62119792)
print v(xbgr.mr_n62119904)
print v(xbgr.mr_n62120224)
print v(xbgr.mr_n62120336)
print v(xbgr.mr_n62120656)
print v(xbgr.mr_n62120768)
print v(xbgr.mr_n62121088)
print v(xbgr.mr_n62121200)
print v(xbgr.mr_n62121520)
print v(xbgr.mr_n62121632)
print v(xbgr.mr_n62121952)
print v(xbgr.mr_n62122064)
print v(xbgr.mr_n62122384)
print v(xbgr.mr_n62122496)
print v(xbgr.mr_n62122816)
print v(xbgr.mr_n62122928)
print v(xbgr.mr_n62123248)
print v(xbgr.mr_n62123360)
print v(xbgr.mr_n62123680)
print v(xbgr.mr_n62123792)
print v(xbgr.mr_n62124112)
print v(xbgr.mr_n62124224)
print v(xbgr.mr_n62124544)
print v(xbgr.mr_n62124656)
print v(xbgr.mr_n62124976)
print v(xbgr.mr_n62125088)
print v(xbgr.mr_n62125408)
print v(xbgr.mr_n62125520)
print v(xbgr.mr_n62125840)
print v(xbgr.mr_n62125952)
print v(xbgr.mr_n62126272)
print v(xbgr.mr_n62126384)
print v(xbgr.mr_n62126704)
print v(xbgr.mr_n62126816)
print v(xbgr.mr_n62127136)
print v(xbgr.mr_n62127248)
print v(xbgr.mr_n62127568)
print v(xbgr.mr_n62127680)
print v(xbgr.mr_n62128000)
print v(xbgr.mr_n62128112)
print v(xbgr.mr_n62128432)
print v(xbgr.mr_n62128544)
print v(xbgr.mr_n62128864)
print v(xbgr.mr_n62128976)
print v(xbgr.mr_n62129296)
print v(xbgr.mr_n62129408)
print v(xbgr.mr_n62129728)
print v(xbgr.mr_n62129840)
print v(xbgr.mr_n62130160)
print v(xbgr.mr_n62130272)
print v(xbgr.mr_n62130592)
print v(xbgr.mr_n62130704)
print v(xbgr.mr_n62131024)
print v(xbgr.mr_n62131136)
print v(xbgr.mr_n62131456)
print v(xbgr.mr_n62131568)
print v(xbgr.mr_n62131888)
print v(xbgr.mr_n62132000)
print v(xbgr.mr_n62132320)
print v(xbgr.mr_n62132432)
print v(xbgr.mr_n62132752)
print v(xbgr.mr_n62132864)
print v(xbgr.mr_n62133184)
print v(xbgr.mr_n62133296)
print v(xbgr.mr_n62133616)
print v(xbgr.mr_n62133728)
print v(xbgr.mr_n62134048)
print v(xbgr.mr_n62134160)
print v(xbgr.mr_n62134480)
print v(xbgr.mr_n62134592)
print v(xbgr.mr_n62134912)
print v(xbgr.mr_n62135024)
print v(xbgr.mr_n62135344)
print v(xbgr.mr_n62135456)
print v(xbgr.mr_n62135776)
print v(xbgr.mr_n62135888)
print v(xbgr.mr_n62136208)
print v(xbgr.mr_n62136320)
print v(xbgr.mr_n62136640)
print v(xbgr.mr_n62136752)
print v(xbgr.mr_n62137072)
print v(xbgr.mr_n62137184)
print v(xbgr.mr_n62137504)
print v(xbgr.mr_n62137616)
print v(xbgr.mr_n62137936)
print v(xbgr.mr_n62138048)
print v(xbgr.mr_n62138368)
print v(xbgr.mr_n62138480)
print v(xbgr.mr_n62138800)
print v(xbgr.mr_n62138912)
print v(xbgr.mr_n62139232)
print v(xbgr.mr_n62139344)
print v(xbgr.mr_n62139664)
print v(xbgr.mr_n62139776)
print v(xbgr.mr_n62140096)
print v(xbgr.mr_n62140208)
print v(xbgr.mr_n62140528)
print v(xbgr.mr_n62140640)
print v(xbgr.mr_n62140960)
print v(xbgr.mr_n62141072)
print v(xbgr.mr_n62141392)
print v(xbgr.mr_n62141504)
print v(xbgr.mr_n62141824)
print v(xbgr.mr_n62141936)
print v(xbgr.mr_n62142256)
print v(xbgr.mr_n62142368)
print v(xbgr.mr_n62142688)
print v(xbgr.mr_n62142800)
print v(xbgr.mr_n62143120)
print v(xbgr.mr_n62143232)
print v(xbgr.mr_n62143552)
print v(xbgr.mr_n62143664)
print v(xbgr.mr_n62143984)
print v(xbgr.mr_n62144096)
print v(xbgr.mr_n62144416)
print v(xbgr.mr_n62144528)
print v(xbgr.mr_n62144848)
print v(xbgr.mr_n62144960)
print v(xbgr.mr_n62145280)
print v(xbgr.mr_n62145392)
print v(xbgr.mr_n62145712)
print v(xbgr.mr_n62145824)
print v(xbgr.mr_n62146144)
print v(xbgr.mr_n62146256)
print v(xbgr.mr_n62146576)
print v(xbgr.mr_n62146688)
print v(xbgr.mr_n62147008)
print v(xbgr.mr_n62147120)
print v(xbgr.mr_n62147440)
print v(xbgr.mr_n62147552)
print v(xbgr.mr_n62147872)
print v(xbgr.mr_n62147984)
print v(xbgr.mr_n62148304)
print v(xbgr.mr_n62148416)
print v(xbgr.mr_n62148736)
print v(xbgr.mr_n62148848)
print v(xbgr.mr_n62149168)
print v(xbgr.mr_n62149280)
print v(xbgr.mr_n62149600)
print v(xbgr.mr_n62149712)
print v(xbgr.mr_n62150032)
print v(xbgr.mr_n62150464)
print v(xbgr.mr_n62150576)
print v(xbgr.mr_n62150896)
print v(xbgr.mr_n62151328)
print v(xbgr.mr_n62151440)
print v(xbgr.mr_n62151760)
print v(xbgr.mr_n62151872)
print v(xbgr.mr_n62152192)
print v(xbgr.mr_n62152304)
print v(xbgr.mr_n62152624)
print v(xbgr.mr_n62152736)
print v(xbgr.mr_n62153056)
print v(xbgr.mr_n62153168)
print v(xbgr.mr_n62153488)
print v(xbgr.mr_n62153600)
print v(xbgr.mr_n62153920)
print v(xbgr.mr_n62154032)
print v(xbgr.mr_n62154352)
print v(xbgr.mr_n62154464)
print v(xbgr.mr_n62154784)
print v(xbgr.mr_n62154896)
print v(xbgr.mr_n62155216)
print v(xbgr.mr_n62155328)
print v(xbgr.mr_n62155648)
print v(xbgr.mr_n62155760)
print v(xbgr.mr_n62156080)
print v(xbgr.mr_n62156192)
print v(xbgr.mr_n62156512)
print v(xbgr.mr_n62156624)
print v(xbgr.mr_n62156944)
print v(xbgr.mr_n62157056)
print v(xbgr.mr_n62157376)
print v(xbgr.mr_n62157488)
print v(xbgr.mr_n62157808)
print v(xbgr.mr_n62157920)
print v(xbgr.mr_n62158240)
print v(xbgr.mr_n62158352)
print v(xbgr.mr_n62158672)
print v(xbgr.mr_n62158784)
print v(xbgr.mr_n62159104)
print v(xbgr.mr_n62159216)
print v(xbgr.mr_n62159536)
print v(xbgr.mr_n62159648)
print v(xbgr.mr_n62159968)
print v(xbgr.mr_n62160080)
print v(xbgr.mr_n62160400)
print v(xbgr.mr_n62160512)
print v(xbgr.mr_n62160832)
print v(xbgr.mr_n62161264)
print v(xbgr.mr_n62161376)
print v(xbgr.mr_n62161696)
print v(xbgr.mr_n62162128)
print v(xbgr.mr_n62162240)
print v(xbgr.mr_n62162560)
print v(xbgr.mr_n62162992)
print v(xbgr.mr_n62163104)
print v(xbgr.mr_n62163424)
print v(xbgr.mr_n62163856)
print v(xbgr.mr_n62163968)
print v(xbgr.mr_n62164288)
print v(xbgr.mr_n62164720)
print v(xbgr.mr_n62164832)
print v(xbgr.mr_n62165152)
print v(xbgr.mr_n62165264)
print v(xbgr.mr_n62165584)
print v(xbgr.mr_n62165696)
print v(xbgr.mr_n62166016)
print v(xbgr.mr_n62166128)
print v(xbgr.mr_n62166448)
print v(xbgr.mr_n62166560)
print v(xbgr.mr_n62166880)
print v(xbgr.mr_n62166992)
print v(xbgr.mr_n62167312)
print v(xbgr.mr_n62167424)
print v(xbgr.mr_n62167744)
print v(xbgr.mr_n62167856)
print v(xbgr.mr_n62168176)
print v(xbgr.mr_n62168288)
print v(xbgr.mr_n62168608)
print v(xbgr.mr_n62168720)
print v(xbgr.mr_n62169040)
print v(xbgr.mr_n62169152)
print v(xbgr.mr_n62169472)
print v(xbgr.mr_n62169584)
print v(xbgr.mr_n62169904)
print v(xbgr.mr_n62170016)
print v(xbgr.mr_n62170336)
print v(xbgr.mr_n62170448)
print v(xbgr.mr_n62170768)
print v(xbgr.mr_n62170880)
print v(xbgr.mr_n62171200)
print v(xbgr.mr_n62171312)
print v(xbgr.mr_n62171632)
print v(xbgr.mr_n62171744)
print v(xbgr.mr_n62172064)
print v(xbgr.mr_n62172176)
print v(xbgr.mr_n62172496)
print v(xbgr.mr_n62172608)
print v(xbgr.mr_n62172928)
print v(xbgr.mr_n62173040)
print v(xbgr.mr_n62173360)
print v(xbgr.mr_n62173472)
print v(xbgr.mr_n62173792)
print v(xbgr.mr_n62173904)
print v(xbgr.mr_n62174224)
print v(xbgr.mr_n62174336)
print v(xbgr.mr_n62174656)
print v(xbgr.mr_n62174768)
print v(xbgr.mr_n62175088)
print v(xbgr.mr_n62175200)
print v(xbgr.mr_n62175520)
print v(xbgr.mr_n62175632)
print v(xbgr.mr_n62175952)
print v(xbgr.mr_n62176064)
print v(xbgr.mr_n62176384)
print v(xbgr.mr_n62176496)
print v(xbgr.mr_n62176816)
print v(xbgr.mr_n62176928)
print v(xbgr.mr_n62177248)
print v(xbgr.mr_n62177360)
print v(xbgr.mr_n62177680)
print v(xbgr.mr_n62177792)
print v(xbgr.mr_n62178112)
print v(xbgr.mr_n62178224)
print v(xbgr.mr_n62178544)
print v(xbgr.mr_n62178656)
print v(xbgr.mr_n62178976)
print v(xbgr.mr_n62179088)
print v(xbgr.mr_n62179408)
print v(xbgr.mr_n62179520)
print v(xbgr.mr_n62179840)
print v(xbgr.mr_n62179952)
print v(xbgr.mr_n62180272)
print v(xbgr.mr_n62180384)
print v(xbgr.mr_n62180704)
print v(xbgr.mr_n62180816)
print v(xbgr.mr_n62181136)
print v(xbgr.mr_n62181248)
print v(xbgr.mr_n62181568)
print v(xbgr.mr_n62181680)
print v(xbgr.mr_n62182000)
print v(xbgr.mr_n62182112)
print v(xbgr.mr_n62182432)
print v(xbgr.mr_n62182544)
print v(xbgr.mr_n62182864)
print v(xbgr.mr_n62182976)
print v(xbgr.mr_n62183296)
print v(xbgr.mr_n62183408)
print v(xbgr.mr_n62183728)
print v(xbgr.mr_n62183840)
print v(xbgr.mr_n62184160)
print v(xbgr.mr_n62184272)
print v(xbgr.mr_n62184592)
print v(xbgr.mr_n62185024)
print v(xbgr.mr_n62185136)
print v(xbgr.mr_n62185456)
print v(xbgr.mr_n62185888)
print v(xbgr.mr_n62186000)
print v(xbgr.mr_n62186320)
print v(xbgr.mr_n62186752)
print v(xbgr.mr_n62186864)
print v(xbgr.mr_n62187184)
print v(xbgr.mr_n62187296)
print v(xbgr.mr_n62187616)
print v(xbgr.mr_n62187728)
print v(xbgr.mr_n62188048)
print v(xbgr.mr_n62188160)
print v(xbgr.mr_n62188480)
print v(xbgr.mr_n62188592)
print v(xbgr.mr_n62188912)
print v(xbgr.mr_n62189024)
print v(xbgr.mr_n62189344)
print v(xbgr.mr_n62189456)
print v(xbgr.mr_n62189776)
print v(xbgr.mr_n62189888)
print v(xbgr.mr_n62190208)
print v(xbgr.mr_n62190320)
print v(xbgr.mr_n62190640)
print v(xbgr.mr_n62190752)
print v(xbgr.mr_n62191072)
print v(xbgr.mr_n62191184)
print v(xbgr.mr_n62191504)
print v(xbgr.mr_n62191616)
print v(xbgr.mr_n62191936)
print v(xbgr.mr_n62192048)
print v(xbgr.mr_n62192368)
print v(xbgr.mr_n62192480)
print v(xbgr.mr_n62192800)
print v(xbgr.mr_n62192912)
print v(xbgr.mr_n62193232)
print v(xbgr.mr_n62193344)
print v(xbgr.mr_n62193664)
print v(xbgr.mr_n62193776)
print v(xbgr.mr_n62194096)
print v(xbgr.mr_n62194208)
print v(xbgr.mr_n62194528)
print v(xbgr.mr_n62194640)
print v(xbgr.mr_n62194960)
print v(xbgr.mr_n62195072)
print v(xbgr.mr_n62195392)
print v(xbgr.mr_n62195504)
print v(xbgr.mr_n62195824)
print v(xbgr.mr_n62195936)
print v(xbgr.mr_n62196256)
print v(xbgr.mr_n62196368)
print v(xbgr.mr_n62196688)
print v(xbgr.mr_n62196800)
print v(xbgr.mr_n62197120)
print v(xbgr.mr_n62197232)
print v(xbgr.mr_n62197552)
print v(xbgr.mr_n62197664)
print v(xbgr.mr_n62197984)
print v(xbgr.mr_n62198096)
print v(xbgr.mr_n62198416)
print v(xbgr.mr_n62198528)
print v(xbgr.mr_n62198848)
print v(xbgr.mr_n62198960)
print v(xbgr.mr_n62199280)
print v(xbgr.mr_n62199392)
print v(xbgr.mr_n62199712)
print v(xbgr.mr_n62199824)
print v(xbgr.mr_n62200144)
print v(xbgr.mr_n62200256)
print v(xbgr.mr_n62200576)
print v(xbgr.mr_n62200688)
print v(xbgr.mr_n62201008)
print v(xbgr.mr_n62201120)
print v(xbgr.mr_n62201440)
print v(xbgr.mr_n62201552)
print v(xbgr.mr_n62201872)
print v(xbgr.mr_n62201984)
print v(xbgr.mr_n62202304)
print v(xbgr.mr_n62202416)
print v(xbgr.mr_n62202736)
print v(xbgr.mr_n62202848)
print v(xbgr.mr_n62203168)
print v(xbgr.mr_n62203280)
print v(xbgr.mr_n62203600)
print v(xbgr.mr_n62203712)
print v(xbgr.mr_n62204032)
print v(xbgr.mr_n62204144)
print v(xbgr.mr_n62204464)
print v(xbgr.mr_n62204576)
print v(xbgr.mr_n62204896)
print v(xbgr.mr_n62205008)
print v(xbgr.mr_n62205328)
print v(xbgr.mr_n62205440)
print v(xbgr.mr_n62205760)
print v(xbgr.mr_n62205872)
print v(xbgr.mr_n62206192)
print v(xbgr.mr_n62206304)
print v(xbgr.mr_n62206624)
print v(xbgr.mr_n62206736)
print v(xbgr.mr_n62207056)
print v(xbgr.mr_n62207168)
print v(xbgr.mr_n62207488)
print v(xbgr.mr_n62207600)
print v(xbgr.mr_n62207920)
print v(xbgr.mr_n62208032)
print v(xbgr.mr_n62208352)
print v(xbgr.mr_n62208464)
print v(xbgr.mr_n62208784)
print v(xbgr.mr_n62208896)
print v(xbgr.mr_n62209216)
print v(xbgr.mr_n62209328)
print v(xbgr.mr_n62209648)
print v(xbgr.mr_n62209760)
print v(xbgr.mr_n62210080)
print v(xbgr.mr_n62210192)
print v(xbgr.mr_n62210512)
print v(xbgr.mr_n62210624)
print v(xbgr.mr_n62210944)
print v(xbgr.mr_n62211056)
print v(xbgr.mr_n62211376)
print v(xbgr.mr_n62211488)
print v(xbgr.mr_n62211808)
print v(xbgr.mr_n62211920)
print v(xbgr.mr_n62212240)
print v(xbgr.mr_n62212352)
print v(xbgr.mr_n62212672)
print v(xbgr.mr_n62212784)
print v(xbgr.mr_n62213104)
print v(xbgr.mr_n62213216)
print v(xbgr.mr_n62213536)
print v(xbgr.mr_n62213648)
print v(xbgr.mr_n62213968)
print v(xbgr.mr_n62214080)
print v(xbgr.mr_n62214400)
print v(xbgr.mr_n62214512)
print v(xbgr.mr_n62214832)
print v(xbgr.mr_n62214944)
print v(xbgr.mr_n62215264)
print v(xbgr.mr_n62215376)
print v(xbgr.mr_n62215696)
print v(xbgr.mr_n62215808)
print v(xbgr.mr_n62216128)
print v(xbgr.mr_n62216240)
print v(xbgr.mr_n62216560)
print v(xbgr.mr_n62216672)
print v(xbgr.mr_n62216992)
print v(xbgr.mr_n62217104)
print v(xbgr.mr_n62217424)
print v(xbgr.mr_n62217536)
print v(xbgr.mr_n62217856)
print v(xbgr.mr_n62217968)
print v(xbgr.mr_n62218288)
print v(xbgr.mr_n62218400)
print v(xbgr.mr_n62218720)
print v(xbgr.mr_n62218832)
print v(xbgr.mr_n62219152)
print v(xbgr.mr_n62219264)
print v(xbgr.mr_n62219584)
print v(xbgr.mr_n62219696)
print v(xbgr.mr_n62220016)
print v(xbgr.mr_n62220128)
print v(xbgr.mr_n62220448)
print v(xbgr.mr_n62220560)
print v(xbgr.mr_n62220880)
print v(xbgr.mr_n62220992)
print v(xbgr.mr_n62221312)
print v(xbgr.mr_n62221424)
print v(xbgr.mr_n62221744)
print v(xbgr.mr_n62221856)
print v(xbgr.mr_n62222176)
print v(xbgr.mr_n62222288)
print v(xbgr.mr_n62222608)
print v(xbgr.mr_n62222720)
print v(xbgr.mr_n62223040)
print v(xbgr.mr_n62223152)
print v(xbgr.mr_n62223472)
print v(xbgr.mr_n62223584)
print v(xbgr.mr_n62223904)
print v(xbgr.mr_n62224016)
print v(xbgr.mr_n62224336)
print v(xbgr.mr_n62224448)
print v(xbgr.mr_n62224768)
print v(xbgr.mr_n62224880)
print v(xbgr.mr_n62225200)
print v(xbgr.mr_n62225312)
print v(xbgr.mr_n62225632)
print v(xbgr.mr_n62225744)
print v(xbgr.mr_n62226064)
print v(xbgr.mr_n62226176)
print v(xbgr.mr_n62226496)
print v(xbgr.mr_n62226608)
print v(xbgr.mr_n62226928)
print v(xbgr.mr_n62227040)
print v(xbgr.mr_n62227360)
print v(xbgr.mr_n62227472)
print v(xbgr.mr_n62227792)
print v(xbgr.mr_n62227904)
print v(xbgr.mr_n62228224)
print v(xbgr.mr_n62228336)
print v(xbgr.mr_n62228656)
print v(xbgr.mr_n62228768)
print v(xbgr.mr_n62229088)
print v(xbgr.mr_n62229200)
print v(xbgr.mr_n62229520)
print v(xbgr.mr_n62229632)
print v(xbgr.mr_n62229952)
print v(xbgr.mr_n62230064)
print v(xbgr.mr_n62230384)
print v(xbgr.mr_n62230496)
print v(xbgr.mr_n62230816)
print v(xbgr.mr_n62230928)
print v(xbgr.mr_n62231248)
print v(xbgr.mr_n62231360)
print v(xbgr.mr_n62231680)
print v(xbgr.mr_n62231792)
print v(xbgr.mr_n62232112)
print v(xbgr.mr_n62232224)
print v(xbgr.mr_n62232544)
print v(xbgr.mr_n62232656)
print v(xbgr.mr_n62232976)
print v(xbgr.mr_n62233088)
print v(xbgr.mr_n62233408)
print v(xbgr.mr_n62233520)
print v(xbgr.mr_n62233840)
print v(xbgr.mr_n62233952)
print v(xbgr.mr_n62234272)
print v(xbgr.mr_n62234384)
print v(xbgr.mr_n62234704)
print v(xbgr.mr_n62234816)
print v(xbgr.mr_n62235136)
print v(xbgr.mr_n62235248)
print v(xbgr.mr_n62235568)
print v(xbgr.mr_n62235680)
print v(xbgr.mr_n62236000)
print v(xbgr.mr_n62236112)
print v(xbgr.mr_n62236432)
print v(xbgr.mr_n62236544)
print v(xbgr.mr_n62236864)
print v(xbgr.mr_n62236976)
print v(xbgr.mr_n62237296)
print v(xbgr.mr_n62237408)
print v(xbgr.mr_n62237728)
print v(xbgr.mr_n62237840)
print v(xbgr.mr_n62238160)
print v(xbgr.mr_n62238272)
print v(xbgr.mr_n62238592)
print v(xbgr.mr_n62238704)
print v(xbgr.mr_n62239024)
print v(xbgr.mr_n62239136)
print v(xbgr.mr_n62239456)
print v(xbgr.mr_n62239568)
print v(xbgr.mr_n62239888)
print v(xbgr.mr_n62240000)
print v(xbgr.mr_n62240320)
print v(xbgr.mr_n62240432)
print v(xbgr.mr_n62240752)
print v(xbgr.mr_n62240864)
print v(xbgr.mr_n62241184)
print v(xbgr.mr_n62241296)
print v(xbgr.mr_n62241616)
print v(xbgr.mr_n62241728)
print v(xbgr.mr_n62242048)
print v(xbgr.mr_n62242160)
print v(xbgr.mr_n62242480)
print v(xbgr.mr_n62242592)
print v(xbgr.mr_n62242912)
print v(xbgr.mr_n62243024)
print v(xbgr.mr_n62243344)
print v(xbgr.mr_n62243456)
print v(xbgr.mr_n62243776)
print v(xbgr.mr_n62243888)
print v(xbgr.mr_n62244208)
print v(xbgr.mr_n62244320)
print v(xbgr.mr_n62244640)
print v(xbgr.mr_n62244752)
print v(xbgr.mr_n62245072)
print v(xbgr.mr_n62245184)
print v(xbgr.mr_n62245504)
print v(xbgr.mr_n62245616)
print v(xbgr.mr_n62245936)
print v(xbgr.mr_n62246048)
print v(xbgr.mr_n62246368)
print v(xbgr.mr_n62246480)
print v(xbgr.mr_n62246800)
print v(xbgr.mr_n62246912)
print v(xbgr.mr_n62247232)
print v(xbgr.mr_n62247344)
print v(xbgr.mr_n62247664)
print v(xbgr.mr_n62247776)
print v(xbgr.mr_n62248096)
print v(xbgr.mr_n62248208)
print v(xbgr.mr_n62248528)
print v(xbgr.mr_n62248640)
print v(xbgr.mr_n62248960)
print v(xbgr.mr_n62249072)
print v(xbgr.mr_n62249392)
print v(xbgr.mr_n62249504)
print v(xbgr.mr_n62249824)
print v(xbgr.mr_n62249936)
print v(xbgr.mr_n62250256)
print v(xbgr.mr_n62250368)
print v(xbgr.mr_n62250688)
print v(xbgr.mr_n62250800)
print v(xbgr.mr_n62251120)
print v(xbgr.mr_n62251232)
print v(xbgr.mr_n62251552)
print v(xbgr.mr_n62251664)
print v(xbgr.mr_n62251984)
print v(xbgr.mr_n62252096)
print v(xbgr.mr_n62252416)
print v(xbgr.mr_n62252528)
print v(xbgr.mr_n62252848)
print v(xbgr.mr_n62252960)
print v(xbgr.mr_n62253280)
print v(xbgr.mr_n62253392)
print v(xbgr.mr_n62253712)
print v(xbgr.mr_n62253824)
print v(xbgr.mr_n62254144)
print v(xbgr.mr_n62254256)
print v(xbgr.mr_n62254576)
print v(xbgr.mr_n62254688)
print v(xbgr.mr_n62255008)
print v(xbgr.mr_n62255120)
print v(xbgr.mr_n62255440)
print v(xbgr.mr_n62255552)
print v(xbgr.mr_n62255872)
print v(xbgr.mr_n62255984)
print v(xbgr.mr_n62256304)
print v(xbgr.mr_n62256416)
print v(xbgr.mr_n62256736)
print v(xbgr.mr_n62256848)
print v(xbgr.mr_n62257168)
print v(xbgr.mr_n62257280)
print v(xbgr.mr_n62257600)
print v(xbgr.mr_n62257712)
print v(xbgr.mr_n62258032)
print v(xbgr.mr_n62258144)
print v(xbgr.mr_n62258464)
print v(xbgr.mr_n62258576)
print v(xbgr.mr_n62258896)
print v(xbgr.mr_n62259008)
print v(xbgr.mr_n62259328)
print v(xbgr.mr_n62259440)
print v(xbgr.mr_n62259760)
print v(xbgr.mr_n62259872)
print v(xbgr.mr_n62260192)
print v(xbgr.mr_n62260304)
print v(xbgr.mr_n62260624)
print v(xbgr.mr_n62260736)
print v(xbgr.mr_n62261056)
print v(xbgr.mr_n62261168)
print v(xbgr.mr_n62261488)
print v(xbgr.mr_n62261600)
print v(xbgr.mr_n62261920)
print v(xbgr.mr_n62262032)
print v(xbgr.mr_n62262352)
print v(xbgr.mr_n62262464)
print v(xbgr.mr_n62262784)
print v(xbgr.mr_n62262896)
print v(xbgr.mr_n62263216)
print v(xbgr.mr_n62263328)
print v(xbgr.mr_n62263648)
print v(xbgr.mr_n62263760)
print v(xbgr.mr_n62264080)
print v(xbgr.mr_n62264192)
print v(xbgr.mr_n62264512)
print v(xbgr.mr_n62264624)
print v(xbgr.mr_n62264944)
print v(xbgr.mr_n62265056)
print v(xbgr.mr_n62265376)
print v(xbgr.mr_n62265488)
print v(xbgr.mr_n62265808)
print v(xbgr.mr_n62265920)
print v(xbgr.mr_n62266240)
print v(xbgr.mr_n62266352)
print v(xbgr.mr_n62266672)
print v(xbgr.mr_n62266784)
print v(xbgr.mr_n62267104)
print v(xbgr.mr_n62267216)
print v(xbgr.mr_n62267536)
print v(xbgr.mr_n62267648)
print v(xbgr.mr_n62267968)
print v(xbgr.mr_n62268080)
print v(xbgr.mr_n62268400)
print v(xbgr.mr_n62268512)
print v(xbgr.mr_n62268832)
print v(xbgr.mr_n62268944)
print v(xbgr.mr_n62269264)
print v(xbgr.mr_n62269376)
print v(xbgr.mr_n62269696)
print v(xbgr.mr_n62269808)
print v(xbgr.mr_n62270128)
print v(xbgr.mr_n62270240)
print v(xbgr.mr_n62270560)
print v(xbgr.mr_n62270672)
print v(xbgr.mr_n62270992)
print v(xbgr.mr_n62271104)
print v(xbgr.mr_n62271424)
print v(xbgr.mr_n62271536)
print v(xbgr.mr_n62271856)
print v(xbgr.mr_n62271968)
print v(xbgr.mr_n62272288)
print v(xbgr.mr_n62272400)
print v(xbgr.mr_n62272720)
print v(xbgr.mr_n62272832)
print v(xbgr.mr_n62273152)
print v(xbgr.mr_n62273264)
print v(xbgr.mr_n62273584)
print v(xbgr.mr_n62273696)
print v(xbgr.mr_n62274016)
print v(xbgr.mr_n62274128)
print v(xbgr.mr_n62274448)
print v(xbgr.mr_n62274560)
print v(xbgr.mr_n62274880)
print v(xbgr.mr_n62274992)
print v(xbgr.mr_n62275312)
print v(xbgr.mr_n62275424)
print v(xbgr.mr_n62275744)
print v(xbgr.mr_n62275856)
print v(xbgr.mr_n62276176)
print v(xbgr.mr_n62276288)
print v(xbgr.mr_n62276608)
print v(xbgr.mr_n62276720)
print v(xbgr.mr_n62277040)
print v(xbgr.mr_n62277152)
print v(xbgr.mr_n62277472)
print v(xbgr.mr_n62277584)
print v(xbgr.mr_n62277904)
print v(xbgr.mr_n62278016)
print v(xbgr.mr_n62278336)
print v(xbgr.mr_n62278448)
print v(xbgr.mr_n62278768)
print v(xbgr.mr_n62278880)
print v(xbgr.mr_n62279200)
print v(xbgr.mr_n62279312)
print v(xbgr.mr_n62279632)
print v(xbgr.mr_n62279744)
print v(xbgr.mr_n62280064)
print v(xbgr.mr_n62280176)
print v(xbgr.mr_n62280496)
print v(xbgr.mr_n62280608)
print v(xbgr.mr_n62280928)
print v(xbgr.mr_n62281040)
print v(xbgr.mr_n62281360)
print v(xbgr.mr_n62281472)
print v(xbgr.mr_n62281792)
print v(xbgr.mr_n62281904)
print v(xbgr.mr_n62282224)
print v(xbgr.mr_n62282336)
print v(xbgr.mr_n62282656)
print v(xbgr.mr_n62282768)
print v(xbgr.mr_n62283088)
print v(xbgr.mr_n62283200)
print v(xbgr.mr_n62283520)
print v(xbgr.mr_n62283632)
print v(xbgr.mr_n62283952)
print v(xbgr.mr_n62284064)
print v(xbgr.mr_n62284384)
print v(xbgr.mr_n62284496)
print v(xbgr.mr_n62284816)
print v(xbgr.mr_n62284928)
print v(xbgr.mr_n62285248)
print v(xbgr.mr_n62285360)
print v(xbgr.mr_n62285680)
print v(xbgr.mr_n62285792)
print v(xbgr.mr_n62286112)
print v(xbgr.mr_n62286224)
print v(xbgr.mr_n62286544)
print v(xbgr.mr_n62286656)
print v(xbgr.mr_n62286976)
print v(xbgr.mr_n62287088)
print v(xbgr.mr_n62287408)
print v(xbgr.mr_n62287520)
print v(xbgr.mr_n62287840)
print v(xbgr.mr_n62287952)
print v(xbgr.mr_n62288272)
print v(xbgr.mr_n62288384)
print v(xbgr.mr_n62288704)
print v(xbgr.mr_n62288816)
print v(xbgr.mr_n62289136)
print v(xbgr.mr_n62289248)
print v(xbgr.mr_n62289568)
print v(xbgr.mr_n62289680)
print v(xbgr.mr_n62290000)
print v(xbgr.mr_n62290112)
print v(xbgr.mr_n62290432)
print v(xbgr.mr_n62290544)
print v(xbgr.mr_n62290864)
print v(xbgr.mr_n62290976)
print v(xbgr.mr_n62291296)
print v(xbgr.mr_n62291408)
print v(xbgr.mr_n62291728)
print v(xbgr.mr_n62291840)
print v(xbgr.mr_n62292160)
print v(xbgr.mr_n62292272)
print v(xbgr.mr_n62292592)
print v(xbgr.mr_n62292704)
print v(xbgr.mr_n62293024)
print v(xbgr.mr_n62293136)
print v(xbgr.mr_n62293456)
print v(xbgr.mr_n62293568)
print v(xbgr.mr_n62293888)
print v(xbgr.mr_n62294000)
print v(xbgr.mr_n62294320)
print v(xbgr.mr_n62294432)
print v(xbgr.mr_n62294752)
print v(xbgr.mr_n62294864)
print v(xbgr.mr_n62295184)
print v(xbgr.mr_n62295296)
print v(xbgr.mr_n62295616)
print v(xbgr.mr_n62295728)
print v(xbgr.mr_n62296048)
print v(xbgr.mr_n62296160)
print v(xbgr.mr_n62296480)
print v(xbgr.mr_n62296592)
print v(xbgr.mr_n62296912)
print v(xbgr.mr_n62297024)
print v(xbgr.mr_n62297344)
print v(xbgr.mr_n62297456)
print v(xbgr.mr_n62297776)
print v(xbgr.mr_n62297888)
print v(xbgr.mr_n62298208)
print v(xbgr.mr_n62298320)
print v(xbgr.mr_n62298640)
print v(xbgr.mr_n62298752)
print v(xbgr.mr_n62299072)
print v(xbgr.mr_n62299184)
print v(xbgr.mr_n62299504)
print v(xbgr.mr_n62299616)
print v(xbgr.mr_n62299936)
print v(xbgr.mr_n62300048)
print v(xbgr.mr_n62300368)
print v(xbgr.mr_n62300480)
print v(xbgr.mr_n62300800)
print v(xbgr.mr_n62300912)
print v(xbgr.mr_n62301232)
print v(xbgr.mr_n62301344)
print v(xbgr.mr_n62301664)
print v(xbgr.mr_n62301776)
print v(xbgr.mr_n62302096)
print v(xbgr.mr_n62302208)
print v(xbgr.mr_n62302528)
print v(xbgr.mr_n62302640)
print v(xbgr.mr_n62302960)
print v(xbgr.mr_n62303072)
print v(xbgr.mr_n62303392)
print v(xbgr.mr_n62303504)
print v(xbgr.mr_n62303824)
print v(xbgr.mr_n62303936)
print v(xbgr.mr_n62304256)
print v(xbgr.mr_n62304368)
print v(xbgr.mr_n62304688)
print v(xbgr.mr_n62304800)
print v(xbgr.mr_n62305120)
print v(xbgr.mr_n62305232)
print v(xbgr.mr_n62305552)
print v(xbgr.mr_n62305664)
print v(xbgr.mr_n62305984)
print v(xbgr.mr_n62306096)
print v(xbgr.mr_n62306416)
print v(xbgr.mr_n62306528)
print v(xbgr.mr_n62306848)
print v(xbgr.mr_n62306960)
print v(xbgr.mr_n62307280)
print v(xbgr.mr_n62307392)
print v(xbgr.mr_n62307712)
print v(xbgr.mr_n62307824)
print v(xbgr.mr_n62308144)
print v(xbgr.mr_n62308256)
print v(xbgr.mr_n62308576)
print v(xbgr.mr_n62308688)
print v(xbgr.mr_n62309008)
print v(xbgr.mr_n62309120)
print v(xbgr.mr_n62309440)
print v(xbgr.mr_n62309552)
print v(xbgr.mr_n62309872)
print v(xbgr.mr_n62309984)
print v(xbgr.mr_n62310304)
print v(xbgr.mr_n62310416)
print v(xbgr.mr_n62310736)
print v(xbgr.mr_n62310848)
print v(xbgr.mr_n62311168)
print v(xbgr.mr_n62311280)
print v(xbgr.mr_n62311600)
print v(xbgr.mr_n62311712)
print v(xbgr.mr_n62312032)
print v(xbgr.mr_n62312144)
print v(xbgr.mr_n62312464)
print v(xbgr.mr_n62312576)
print v(xbgr.mr_n62312896)
print v(xbgr.mr_n62313008)
print v(xbgr.mr_n62313328)
print v(xbgr.mr_n62313440)
print v(xbgr.mr_n62313760)
print v(xbgr.mr_n62313872)
print v(xbgr.mr_n62314192)
print v(xbgr.mr_n62314304)
print v(xbgr.mr_n62314624)
print v(xbgr.mr_n62314736)
print v(xbgr.mr_n62315056)
print v(xbgr.mr_n62315168)
print v(xbgr.mr_n62315488)
print v(xbgr.mr_n62315600)
print v(xbgr.mr_n62315920)
print v(xbgr.mr_n62316032)
print v(xbgr.mr_n62316352)
print v(xbgr.mr_n62316464)
print v(xbgr.mr_n62316784)
print v(xbgr.mr_n62316896)
print v(xbgr.mr_n62317216)
print v(xbgr.mr_n62317328)
print v(xbgr.mr_n62317648)
print v(xbgr.mr_n62317760)
print v(xbgr.mr_n62318080)
print v(xbgr.mr_n62318192)
print v(xbgr.mr_n62318512)
print v(xbgr.mr_n62318624)
print v(xbgr.mr_n62318944)
print v(xbgr.mr_n62319056)
print v(xbgr.mr_n62319376)
print v(xbgr.mr_n62319488)
print v(xbgr.mr_n62319808)
print v(xbgr.mr_n62319920)
print v(xbgr.mr_n62320240)
print v(xbgr.mr_n62320352)
print v(xbgr.mr_n62320672)
print v(xbgr.mr_n62320784)
print v(xbgr.mr_n62321104)
print v(xbgr.mr_n62321216)
print v(xbgr.mr_n62321536)
print v(xbgr.mr_n62321648)
print v(xbgr.mr_n62321968)
print v(xbgr.mr_n62322080)
print v(xbgr.mr_n62322400)
print v(xbgr.mr_n62322512)
print v(xbgr.mr_n62322832)
print v(xbgr.mr_n62322944)
print v(xbgr.mr_n62323264)
print v(xbgr.mr_n62323376)
print v(xbgr.mr_n62323696)
print v(xbgr.mr_n62323808)
print v(xbgr.mr_n62324128)
print v(xbgr.mr_n62324240)
print v(xbgr.mr_n62324560)
print v(xbgr.mr_n62324672)
print v(xbgr.mr_n62324992)
print v(xbgr.mr_n62325104)
print v(xbgr.mr_n62325424)
print v(xbgr.mr_n62325536)
print v(xbgr.mr_n62325856)
print v(xbgr.mr_n62325968)
print v(xbgr.mr_n62326288)
print v(xbgr.mr_n62326400)
print v(xbgr.mr_n62326720)
print v(xbgr.mr_n62326832)
print v(xbgr.mr_n62327152)
print v(xbgr.mr_n62327264)
print v(xbgr.mr_n62327584)
print v(xbgr.mr_n62327696)
print v(xbgr.mr_n62328016)
print v(xbgr.mr_n62328128)
print v(xbgr.mr_n62328448)
print v(xbgr.mr_n62328560)
print v(xbgr.mr_n62328880)
print v(xbgr.mr_n62328992)
print v(xbgr.mr_n62329312)
print v(xbgr.mr_n62329424)
print v(xbgr.mr_n62329744)
print v(xbgr.mr_n62329856)
print v(xbgr.mr_n62330176)
print v(xbgr.mr_n62330288)
print v(xbgr.mr_n62330608)
print v(xbgr.mr_n62330720)
print v(xbgr.mr_n62331040)
print v(xbgr.mr_n62331152)
print v(xbgr.mr_n62331472)
print v(xbgr.mr_n62331584)
print v(xbgr.mr_n62331904)
print v(xbgr.mr_n62332016)
print v(xbgr.mr_n62332336)
print v(xbgr.mr_n62332448)
print v(xbgr.mr_n62332768)
print v(xbgr.mr_n62332880)
print v(xbgr.mr_n62333200)
print v(xbgr.mr_n62333312)
print v(xbgr.mr_n62333632)
print v(xbgr.mr_n62333744)
print v(xbgr.mr_n62334064)
print v(xbgr.mr_n62334176)
print v(xbgr.mr_n62334496)
print v(xbgr.mr_n62334608)
print v(xbgr.mr_n62334928)
print v(xbgr.mr_n62335040)
print v(xbgr.mr_n62335360)
print v(xbgr.mr_n62335472)
print v(xbgr.mr_n62335792)
print v(xbgr.mr_n62335904)
print v(xbgr.mr_n62336224)
print v(xbgr.mr_n62336336)
print v(xbgr.mr_n62336656)
print v(xbgr.mr_n62336768)
print v(xbgr.mr_n62337088)
print v(xbgr.mr_n62337200)
print v(xbgr.mr_n62337520)
print v(xbgr.mr_n62337632)
print v(xbgr.mr_n62337952)
print v(xbgr.mr_n62338064)
print v(xbgr.mr_n62338384)
print v(xbgr.mr_n62338496)
print v(xbgr.mr_n62338816)
print v(xbgr.mr_n62338928)
print v(xbgr.mr_n62339248)
print v(xbgr.mr_n62339360)
print v(xbgr.mr_n62339680)
print v(xbgr.mr_n62339792)
print v(xbgr.mr_n62340112)
print v(xbgr.mr_n62340224)
print v(xbgr.mr_n62340544)
print v(xbgr.mr_n62340656)
print v(xbgr.mr_n62340976)
print v(xbgr.mr_n62341088)
print v(xbgr.mr_n62341408)
print v(xbgr.mr_n62341520)
print v(xbgr.mr_n62341840)
print v(xbgr.mr_n62341952)
print v(xbgr.mr_n62342272)
print v(xbgr.mr_n62342384)
print v(xbgr.mr_n62342704)
print v(xbgr.mr_n62342816)
print v(xbgr.mr_n62343136)
print v(xbgr.mr_n62343248)
print v(xbgr.mr_n62343568)
print v(xbgr.mr_n62343680)
print v(xbgr.mr_n62344000)
print v(xbgr.mr_n62344112)
print v(xbgr.mr_n62344432)
print v(xbgr.mr_n62344544)
print v(xbgr.mr_n62344864)
print v(xbgr.mr_n62344976)
print v(xbgr.mr_n62345296)
print v(xbgr.mr_n62345408)
print v(xbgr.mr_n62345728)
print v(xbgr.mr_n62345840)
print v(xbgr.mr_n62346160)
print v(xbgr.mr_n62346272)
print v(xbgr.mr_n62346592)
print v(xbgr.mr_n62346704)
print v(xbgr.mr_n62347024)
print v(xbgr.mr_n62347136)
print v(xbgr.mr_n62347456)
print v(xbgr.mr_n62347568)
print v(xbgr.mr_n62347888)
print v(xbgr.mr_n62348000)
print v(xbgr.mr_n62348320)
print v(xbgr.mr_n62348432)
print v(xbgr.mr_n62348752)
print v(xbgr.mr_n62348864)
print v(xbgr.mr_n62349184)
print v(xbgr.mr_n62349296)
print v(xbgr.mr_n62349616)
print v(xbgr.mr_n62349728)
print v(xbgr.mr_n62350048)
print v(xbgr.mr_n62350160)
print v(xbgr.mr_n62350480)
print v(xbgr.mr_n62350592)
print v(xbgr.mr_n62350912)
print v(xbgr.mr_n62351024)
print v(xbgr.mr_n62351344)
print v(xbgr.mr_n62351456)
print v(xbgr.mr_n62351776)
print v(xbgr.mr_n62351888)
print v(xbgr.mr_n62352320)
print v(xbgr.mr_n62352640)
print v(xbgr.mr_n62352752)
print v(xbgr.mr_n62353184)
print v(xbgr.mr_n62353504)
print v(xbgr.mr_n62353616)
print v(xbgr.mr_n62354048)
print v(xbgr.mr_n62354368)
print v(xbgr.mr_n62355232)
print v(xbgr.mr_n62356096)
print v(xbgr.mr_n62356208)
print v(xbgr.mr_n62356528)
print v(xbgr.mr_n62356640)
print v(xbgr.mr_n62356960)
print v(xbgr.mr_n62357072)
print v(xbgr.mr_n62357392)
print v(xbgr.mr_n62357504)
print v(xbgr.mr_n62357824)
print v(xbgr.mr_n62357936)
print v(xbgr.mr_n62358256)
print v(xbgr.mr_n62358368)
print v(xbgr.mr_n62358688)
print v(xbgr.mr_n62359552)
print v(xbgr.mr_n62360416)
print v(xbgr.mr_n62361280)
print v(xbgr.mr_n62361392)
print v(xbgr.mr_n62361712)
print v(xbgr.mr_n62361824)
print v(xbgr.mr_n62362144)
print v(xbgr.mr_n62362256)
print v(xbgr.mr_n62362576)
print v(xbgr.mr_n62362688)
print v(xbgr.mr_n62363008)
print v(xbgr.mr_n62363872)
print v(xbgr.mr_n62364736)
print v(xbgr.mr_n62364848)
print v(xbgr.mr_n62365168)
print v(xbgr.mr_n62365280)
print v(xbgr.mr_n62365600)
print v(xbgr.mr_n62365712)
print v(xbgr.mr_n62366032)
print v(xbgr.mr_n62366144)
print v(xbgr.mr_n62366464)
print v(xbgr.mr_n62366576)
print v(xbgr.mr_n62366896)
print v(xbgr.mr_n62367008)
print v(xbgr.mr_n62367328)
print v(xbgr.mr_n62368192)
print v(xbgr.mr_n62368304)
print v(xbgr.mr_n62368736)
print v(xbgr.mr_n62369056)
print v(xbgr.mr_n62369168)
print v(xbgr.mr_n62369600)
print v(xbgr.mr_n62369920)
print v(xbgr.mr_n62370032)
print v(xbgr.mr_n62370464)
print v(xbgr.mr_n62370784)
print v(xbgr.mr_n62371648)
print v(xbgr.mr_n62372512)
print v(xbgr.mr_n62373376)
print v(xbgr.mr_n62374240)
print v(xbgr.mr_n62375104)
print v(xbgr.mr_n62375968)
print v(xbgr.mr_n62376080)
print v(xbgr.mr_n62376400)
print v(xbgr.mr_n62376512)
print v(xbgr.mr_n62376832)
print v(xbgr.mr_n62376944)
print v(xbgr.mr_n62377264)
print v(xbgr.mr_n62377376)
print v(xbgr.mr_n62377696)
print v(xbgr.mr_n62378560)
print v(xbgr.mr_n62379424)
print v(xbgr.mr_n62380288)
print v(xbgr.mr_n62381152)
print v(xbgr.mr_n62381264)
print v(xbgr.mr_n62381696)
print v(xbgr.mr_n62382016)
print v(xbgr.mr_n62382128)
print v(xbgr.mr_n62382560)
print v(xbgr.mr_n62382880)
print v(xbgr.mr_n62382992)
print v(xbgr.mr_n62383424)
print v(xbgr.mr_n62383744)
print v(xbgr.mr_n62384608)
print v(xbgr.mr_n62385472)
print v(xbgr.mr_n62386336)
print v(xbgr.mr_n62387200)
print v(xbgr.mr_n62388064)
print v(xbgr.mr_n62388928)
print v(xbgr.mr_n62389040)
print v(xbgr.mr_n62389360)
print v(xbgr.mr_n62389472)
print v(xbgr.mr_n62389792)
print v(xbgr.mr_n62389904)
print v(xbgr.mr_n62390224)
print v(xbgr.mr_n62390336)
print v(xbgr.mr_n62390656)
print v(xbgr.mr_n62391520)
print v(xbgr.mr_n62392384)
print v(xbgr.mr_n62393248)
print v(xbgr.mr_n62393360)
print v(xbgr.mr_n62393680)
print v(xbgr.mr_n62393792)
print v(xbgr.mr_n62394112)
print v(xbgr.mr_n62394224)
print v(xbgr.mr_n62394656)
print v(xbgr.mr_n62395088)
print v(xbgr.mr_n62395520)
print v(xbgr.mr_n62395840)
print v(xbgr.mr_n62395952)
print v(xbgr.mr_n62396272)
print v(xbgr.mr_n62396384)
print v(xbgr.mr_n62396704)
print v(xbgr.mr_n62396816)
print v(xbgr.mr_n62397136)
print v(xbgr.mr_n62397248)
print v(xbgr.mr_n62397568)
print v(xbgr.mr_n62397680)
print v(xbgr.mr_n62398000)
print v(xbgr.mr_n62398112)
print v(xbgr.mr_n62398432)
print v(xbgr.mr_n62398544)
print v(xbgr.mr_n62398976)
print v(xbgr.mr_n62399296)
print v(xbgr.mr_n62399728)
print v(xbgr.mr_n62399840)
print v(xbgr.mr_n62400160)
print v(xbgr.mr_n62400272)
print v(xbgr.mr_n62400592)
print v(xbgr.mr_n62400704)
print v(xbgr.mr_n62401024)
print v(xbgr.mr_n62401136)
print v(xbgr.mr_n62401456)
print v(xbgr.mr_n62401568)
print v(xbgr.mr_n62401888)
print v(xbgr.mr_n62402000)
print v(xbgr.mr_n62402320)
print v(xbgr.mr_n62402432)
print v(xbgr.mr_n62402864)
print v(xbgr.mr_n62403184)
print v(xbgr.mr_n62403296)
print v(xbgr.mr_n62403728)
print v(xbgr.mr_n62404048)
print v(xbgr.mr_n62404160)
print v(xbgr.mr_n62404480)
print v(xbgr.mr_n62404592)
print v(xbgr.mr_n62404912)
print v(xbgr.mr_n62405024)
print v(xbgr.mr_n62405456)
print v(xbgr.mr_n62405888)
print v(xbgr.mr_n62406208)
print v(xbgr.mr_n62406320)
print v(xbgr.mr_n62406640)
print v(xbgr.mr_n62406752)
print v(xbgr.mr_n62407072)
print v(xbgr.mr_n62407184)
print v(xbgr.mr_n62407504)
print v(xbgr.mr_n62407616)
print v(xbgr.mr_n62407936)
print v(xbgr.mr_n62408048)
print v(xbgr.mr_n62408368)
print v(xbgr.mr_n62408480)
print v(xbgr.mr_n62408800)
print v(xbgr.mr_n62408912)
print v(xbgr.mr_n62409232)
print v(xbgr.mr_n62409344)
print v(xbgr.mr_n62409664)
print v(xbgr.mr_n62409776)
print v(xbgr.mr_n62410096)
print v(xbgr.mr_n62410208)
print v(xbgr.mr_n62410528)
print v(xbgr.mr_n62410640)
print v(xbgr.mr_n62410960)
print v(xbgr.mr_n62411824)
print v(xbgr.mr_n62412688)
print v(xbgr.mr_n62412800)
print v(xbgr.mr_n62413232)
print v(xbgr.mr_n62413552)
print v(xbgr.mr_n62413664)
print v(xbgr.mr_n62414416)
print v(xbgr.mr_n62414848)
print v(xbgr.mr_n62414960)
print v(xbgr.mr_n62415280)
print v(xbgr.mr_n62415392)
print v(xbgr.mr_n62415712)
print v(xbgr.mr_n62415824)
print v(xbgr.mr_n62416144)
print v(xbgr.mr_n62416256)
print v(xbgr.mr_n62416576)
print v(xbgr.mr_n62417440)
print v(xbgr.mr_n62417872)
print v(xbgr.mr_n62417984)
print v(xbgr.mr_n62418304)
print v(xbgr.mr_n62418416)
print v(xbgr.mr_n62418736)
print v(xbgr.mr_n62419600)
print v(xbgr.mr_n62420896)
print v(xbgr.mr_n62421760)
print v(xbgr.mr_n62422624)
print v(xbgr.mr_n62422736)
print v(xbgr.mr_n62423488)
print v(xbgr.mr_n62423600)
print v(xbgr.mr_n62424032)
print v(xbgr.mr_n62424464)
print v(xbgr.mr_n62425216)
print v(xbgr.mr_n62426080)
print v(xbgr.mr_n62426944)
print v(xbgr.mr_n62427056)
print v(xbgr.mr_n62427376)
print v(xbgr.mr_n62427488)
print v(xbgr.mr_n62427920)
print v(xbgr.mr_n62428240)
print v(xbgr.mr_n62428352)
print v(xbgr.mr_n62428784)
print v(xbgr.mr_n62429104)
print v(xbgr.mr_n62429216)
print v(xbgr.mr_n62429536)
print v(xbgr.mr_n62429648)
print v(xbgr.mr_n62429968)
print v(xbgr.mr_n62430832)
print v(xbgr.mr_n62430944)
print v(xbgr.mr_n62431376)
print v(xbgr.mr_n62431696)
print v(xbgr.mr_n62432672)
print v(xbgr.mr_n62432992)
print v(xbgr.mr_n62433104)
print v(xbgr.mr_n62433536)
print v(xbgr.mr_n62433856)
print v(xbgr.mr_n62434288)
print v(xbgr.mr_n62434400)
print v(xbgr.mr_n62434720)
print v(xbgr.mr_n62434832)
print v(xbgr.mr_n62435152)
print v(xbgr.mr_n62435584)
print v(xbgr.mr_n62435696)
print v(xbgr.mr_n62436016)
print v(xbgr.mr_n62436128)
print v(xbgr.mr_n62436448)
print v(xbgr.mr_n62436560)
print v(xbgr.mr_n62436880)
print v(xbgr.mr_n62436992)
print v(xbgr.mr_n62437312)
print v(xbgr.mr_n62437424)
print v(xbgr.mr_n62437856)
print v(xbgr.mr_n62438176)
print v(xbgr.mr_n62438288)
print v(xbgr.mr_n62438608)
print v(xbgr.mr_n62438720)
print v(xbgr.mr_n62439040)
print v(xbgr.mr_n62439584)
print v(xbgr.mr_n62440336)
print v(xbgr.mr_n62441632)
print v(xbgr.mr_n62441744)
print v(xbgr.mr_n62442064)
print v(xbgr.mr_n62442176)
print v(xbgr.mr_n62442496)
print v(xbgr.mr_n62443360)
print v(xbgr.mr_n62444224)
print v(xbgr.mr_n62445088)
print v(xbgr.mr_n62445200)
print v(xbgr.mr_n62445520)
print v(xbgr.mr_n62445632)
print v(xbgr.mr_n62445952)
print v(xbgr.mr_n62446064)
print v(xbgr.mr_n62446384)
print v(xbgr.mr_n62446496)
print v(xbgr.mr_n62446816)
print v(xbgr.mr_n62446928)
print v(xbgr.mr_n62447248)
print v(xbgr.mr_n62448112)
print v(xbgr.mr_n62448976)
print v(xbgr.mr_n62449840)
print v(xbgr.mr_n62449952)
print v(xbgr.mr_n62450272)
print v(xbgr.mr_n62450384)
print v(xbgr.mr_n62450704)
print v(xbgr.mr_n62450816)
print v(xbgr.mr_n62451136)
print v(xbgr.mr_n62451248)
print v(xbgr.mr_n62451680)
print v(xbgr.mr_n62452000)
print v(xbgr.mr_n62452112)
print v(xbgr.mr_n62452432)
print v(xbgr.mr_n62452544)
print v(xbgr.mr_n62452864)
print v(xbgr.mr_n62452976)
print v(xbgr.mr_n62453296)
print v(xbgr.mr_n62453408)
print v(xbgr.mr_n62454160)
print v(xbgr.mr_n62454704)
print v(xbgr.mr_n62455136)
print v(xbgr.mr_n62455568)
print v(xbgr.mr_n62456000)
print v(xbgr.mr_n62456320)
print v(xbgr.mr_n62456432)
print v(xbgr.mr_n62457184)
print v(xbgr.mr_n62458048)
print v(xbgr.mr_n62458912)
print v(xbgr.mr_n62459776)
print v(xbgr.mr_n62460640)
print v(xbgr.mr_n62461504)
print v(xbgr.mr_n62462368)
print v(xbgr.mr_n62462480)
print v(xbgr.mr_n62462800)
print v(xbgr.mr_n62462912)
print v(xbgr.mr_n62463344)
print v(xbgr.mr_n62463664)
print v(xbgr.mr_n62463776)
print v(xbgr.mr_n62464208)
print v(xbgr.mr_n62464528)
print v(xbgr.mr_n62464640)
print v(xbgr.mr_n62464960)
print v(xbgr.mr_n62465072)
print v(xbgr.mr_n62465392)
print v(xbgr.mr_n62465504)
print v(xbgr.mr_n62465824)
print v(xbgr.mr_n62465936)
print v(xbgr.mr_n62466256)
print v(xbgr.mr_n62466368)
print v(xbgr.mr_n62466688)
print v(xbgr.mr_n62466800)
print v(xbgr.mr_n62467120)
print v(xbgr.mr_n62467984)
print v(xbgr.mr_n62468416)
print v(xbgr.mr_n62469392)
print v(xbgr.mr_n62469824)
print v(xbgr.mr_n62470256)
print v(xbgr.mr_n62470688)
print v(xbgr.mr_n62471008)
print v(xbgr.mr_n62471872)
print v(xbgr.mr_n62472736)
print v(xbgr.mr_n62473600)
print v(xbgr.mr_n62474464)
print v(xbgr.mr_n62475328)
print v(xbgr.mr_n62476192)
print v(xbgr.mr_n62477488)
print v(xbgr.mr_n62477920)
print v(xbgr.mr_n62479216)
print v(xbgr.mr_n62479328)
print v(xbgr.mr_n62479648)
print v(xbgr.mr_n62479760)
print v(xbgr.mr_n62480080)
print v(xbgr.mr_n62480192)
print v(xbgr.mr_n62480624)
print v(xbgr.mr_n62481056)
print v(xbgr.mr_n62481376)
print v(xbgr.mr_n62481488)
print v(xbgr.mr_n62481808)
print v(xbgr.mr_n62481920)
print v(xbgr.mr_n62482240)
print v(xbgr.mr_n62482352)
print v(xbgr.mr_n62482672)
print v(xbgr.mr_n62482784)
print v(xbgr.mr_n62483216)
print v(xbgr.mr_n62483536)
print v(xbgr.mr_n62484400)
print v(xbgr.mr_n62484512)
print v(xbgr.mr_n62484832)
print v(xbgr.mr_n62484944)
print v(xbgr.mr_n62485264)
print v(xbgr.mr_n62485376)
print v(xbgr.mr_n62485696)
print v(xbgr.mr_n62485808)
print v(xbgr.mr_n62486128)
print v(xbgr.mr_n62486992)
print v(xbgr.mr_n62487424)
print v(xbgr.mr_n62488720)
print v(xbgr.mr_n62488832)
print v(xbgr.mr_n62489152)
print v(xbgr.mr_n62489264)
print v(xbgr.mr_n62489584)
print v(xbgr.mr_n62489696)
print v(xbgr.mr_n62490016)
print v(xbgr.mr_n62490880)
print v(xbgr.mr_n62490992)
print v(xbgr.mr_n62491424)
print v(xbgr.mr_n62491744)
print v(xbgr.mr_n62491856)
print v(xbgr.mr_n62492176)
print v(xbgr.mr_n62492288)
print v(xbgr.mr_n62492608)
print v(xbgr.mr_n62492720)
print v(xbgr.mr_n62493040)
print v(xbgr.mr_n62493152)
print v(xbgr.mr_n62493584)
print v(xbgr.mr_n62493904)
print v(xbgr.mr_n62494768)
print v(xbgr.mr_n62494880)
print v(xbgr.mr_n62495200)
print v(xbgr.mr_n62496064)
print v(xbgr.mr_n62496176)
print v(xbgr.mr_n62496496)
print v(xbgr.mr_n62496608)
print v(xbgr.mr_n62496928)
print v(xbgr.mr_n62497472)
print v(xbgr.mr_n62497904)
print v(xbgr.mr_n62498224)
print v(xbgr.mr_n62498656)
print v(xbgr.mr_n62498768)
print v(xbgr.mr_n62499088)
print v(xbgr.mr_n62499200)
print v(xbgr.mr_n62499520)
print v(xbgr.mr_n62499632)
print v(xbgr.mr_n62499952)
print v(xbgr.mr_n62500064)
print v(xbgr.mr_n62500384)
print v(xbgr.mr_n62500496)
print v(xbgr.mr_n62501248)
print v(xbgr.mr_n62501360)
print v(xbgr.mr_n62501680)
print v(xbgr.mr_n62501792)
print v(xbgr.mr_n62502112)
print v(xbgr.mr_n62503408)
print v(xbgr.mr_n62503520)
print v(xbgr.mr_n62503840)
print v(xbgr.mr_n62503952)
print v(xbgr.mr_n62504272)
print v(xbgr.mr_n62505248)
print v(xbgr.mr_n62505568)
print v(xbgr.mr_n62506432)
print v(xbgr.mr_n62506864)
print v(xbgr.mr_n62506976)
print v(xbgr.mr_n62507296)
print v(xbgr.mr_n62507408)
print v(xbgr.mr_n62507728)
print v(xbgr.mr_n62507840)
print v(xbgr.mr_n62508160)
print v(xbgr.mr_n62509024)
print v(xbgr.mr_n62510320)
print v(xbgr.mr_n62511184)
print v(xbgr.mr_n62512160)
print v(xbgr.mr_n62512480)
print v(xbgr.mr_n62512592)
print v(xbgr.mr_n62513024)
print v(xbgr.mr_n62513344)
print v(xbgr.mr_n62513456)
print v(xbgr.mr_n62513776)
print v(xbgr.mr_n62513888)
print v(xbgr.mr_n62514208)
print v(xbgr.mr_n62514320)
print v(xbgr.mr_n62514640)
print v(xbgr.mr_n62514752)
print v(xbgr.mr_n62515072)
print v(xbgr.mr_n62515184)
print v(xbgr.mr_n62515504)
print v(xbgr.mr_n62515616)
print v(xbgr.mr_n62515936)
print v(xbgr.mr_n62516048)
print v(xbgr.mr_n62516368)
print v(xbgr.mr_n62516480)
print v(xbgr.mr_n62516912)
print v(xbgr.mr_n62517232)
print v(xbgr.mr_n62517344)
print v(xbgr.mr_n62517776)
print v(xbgr.mr_n62518096)
print v(xbgr.mr_n62518960)
print v(xbgr.mr_n62519824)
print v(xbgr.mr_n62520688)
print v(xbgr.mr_n62520800)
print v(xbgr.mr_n62521120)
print v(xbgr.mr_n62521232)
print v(xbgr.mr_n62521552)
print v(xbgr.mr_n62521664)
print v(xbgr.mr_n62521984)
print v(xbgr.mr_n62522096)
print v(xbgr.mr_n62522528)
print v(xbgr.mr_n62522960)
print v(xbgr.mr_n62523392)
print v(xbgr.mr_n62523824)
print v(xbgr.mr_n62524144)
print v(xbgr.mr_n62524256)
print v(xbgr.mr_n62524576)
print v(xbgr.mr_n62524688)
print v(xbgr.mr_n62525008)
print v(xbgr.mr_n62525120)
print v(xbgr.mr_n62525440)
print v(xbgr.mr_n62525552)
print v(xbgr.mr_n62525872)
print v(xbgr.mr_n62525984)
print v(xbgr.mr_n62526304)
print v(xbgr.mr_n62526416)
print v(xbgr.mr_n62526736)
print v(xbgr.mr_n62526848)
print v(xbgr.mr_n62527280)
print v(xbgr.mr_n62527600)
print v(xbgr.mr_n62527712)
print v(xbgr.mr_n62528032)
print v(xbgr.mr_n62528896)
print v(xbgr.mr_n62529632)
print v(xbgr.mr_n62530496)
print v(xbgr.mr_n62531360)
print v(xbgr.mr_n62532224)
print v(xbgr.mr_n62533088)
print v(xbgr.mr_n62533200)
print v(xbgr.mr_n62533632)
print v(xbgr.mr_n62533952)
print v(xbgr.mr_n62534064)
print v(xbgr.mr_n62534496)
print v(xbgr.mr_n62534816)
print v(xbgr.mr_n62534928)
print v(xbgr.mr_n62535248)
print v(xbgr.mr_n62535360)
print v(xbgr.mr_n62535680)
print v(xbgr.mr_n62535792)
print v(xbgr.mr_n62536224)
print v(xbgr.mr_n62536544)
print v(xbgr.mr_n62537408)
print v(xbgr.mr_n62537520)
print v(xbgr.mr_n62537840)
print v(xbgr.mr_n62537952)
print v(xbgr.mr_n62538272)
print v(xbgr.mr_n62538384)
print v(xbgr.mr_n62538704)
print v(xbgr.mr_n62538816)
print v(xbgr.mr_n62539136)
print v(xbgr.mr_n62539248)
print v(xbgr.mr_n62539568)
print v(xbgr.mr_n62539680)
print v(xbgr.mr_n62540000)
print v(xbgr.mr_n62540112)
print v(xbgr.mr_n62540432)
print v(xbgr.mr_n62540864)
print v(xbgr.mr_n62540976)
print v(xbgr.mr_n62541296)
print v(xbgr.mr_n62541408)
print v(xbgr.mr_n62541728)
print v(xbgr.mr_n62541840)
print v(xbgr.mr_n62542160)
print v(xbgr.mr_n62542272)
print v(xbgr.mr_n62542592)
print v(xbgr.mr_n62543888)
print v(xbgr.mr_n62544752)
print v(xbgr.mr_n62545296)
print v(xbgr.mr_n62545728)
print v(xbgr.mr_n62546048)
print v(xbgr.mr_n62546160)
print v(xbgr.mr_n62546480)
print v(xbgr.mr_n62546592)
print v(xbgr.mr_n62546912)
print v(xbgr.mr_n62547024)
print v(xbgr.mr_n62547344)
print v(xbgr.mr_n62547456)
print v(xbgr.mr_n62547776)
print v(xbgr.mr_n62547888)
print v(xbgr.mr_n62548208)
print v(xbgr.mr_n62548320)
print v(xbgr.mr_n62548640)
print v(xbgr.mr_n62548752)
print v(xbgr.mr_n62549072)
print v(xbgr.mr_n62549184)
print v(xbgr.mr_n62549504)
print v(xbgr.mr_n62549616)
print v(xbgr.mr_n62549936)
print v(xbgr.mr_n62550800)
print v(xbgr.mr_n62551664)
print v(xbgr.mr_n62551776)
print v(xbgr.mr_n62552208)
print v(xbgr.mr_n62552960)
print v(xbgr.mr_n62553824)
print v(xbgr.mr_n62554688)
print v(xbgr.mr_n62555664)
print v(xbgr.mr_n62556096)
print v(xbgr.mr_n62556416)
print v(xbgr.mr_n62556528)
print v(xbgr.mr_n62556848)
print v(xbgr.mr_n62556960)
print v(xbgr.mr_n62557280)
print v(xbgr.mr_n62558144)
print v(xbgr.mr_n62559008)
print v(xbgr.mr_n62559120)
print v(xbgr.mr_n62559440)
print v(xbgr.mr_n62559552)
print v(xbgr.mr_n62559872)
print v(xbgr.mr_n62559984)
print v(xbgr.mr_n62560304)
print v(xbgr.mr_n62560416)
print v(xbgr.mr_n62560736)
print v(xbgr.mr_n62560848)
print v(xbgr.mr_n62561168)
print v(xbgr.mr_n62561280)
print v(xbgr.mr_n62561600)
print v(xbgr.mr_n62561712)
print v(xbgr.mr_n62562032)
print v(xbgr.mr_n62562144)
print v(xbgr.mr_n62562464)
print v(xbgr.mr_n62562576)
print v(xbgr.mr_n62563008)
print v(xbgr.mr_n62563328)
print v(xbgr.mr_n62563760)
print v(xbgr.mr_n62563872)
print v(xbgr.mr_n62564624)
print v(xbgr.mr_n62564736)
print v(xbgr.mr_n62565168)
print v(xbgr.mr_n62565920)
print v(xbgr.mr_n62566032)
print v(xbgr.mr_n62566352)
print v(xbgr.mr_n62566464)
print v(xbgr.mr_n62566896)
print v(xbgr.mr_n62567328)
print v(xbgr.mr_n62567760)
print v(xbgr.mr_n62568080)
print v(xbgr.mr_n62568192)
print v(xbgr.mr_n62568512)
print v(xbgr.mr_n62568624)
print v(xbgr.mr_n62569056)
print v(xbgr.mr_n62569376)
print v(xbgr.mr_n62570240)
print v(xbgr.mr_n62570352)
print v(xbgr.mr_n62570672)
print v(xbgr.mr_n62570784)
print v(xbgr.mr_n62571104)
print v(xbgr.mr_n62571216)
print v(xbgr.mr_n62571536)
print v(xbgr.mr_n62571648)
print v(xbgr.mr_n62571968)
print v(xbgr.mr_n62572080)
print v(xbgr.mr_n62572400)
print v(xbgr.mr_n62572512)
print v(xbgr.mr_n62572832)
print v(xbgr.mr_n62573696)
print v(xbgr.mr_n62574560)
print v(xbgr.mr_n62574672)
print v(xbgr.mr_n62574992)
print v(xbgr.mr_n62575104)
print v(xbgr.mr_n62575424)
print v(xbgr.mr_n62575536)
print v(xbgr.mr_n62575856)
print v(xbgr.mr_n62575968)
print v(xbgr.mr_n62576288)
print v(xbgr.mr_n62577152)
print v(xbgr.mr_n62578016)
print v(xbgr.mr_n62578880)
print v(xbgr.mr_n62579744)
print v(xbgr.mr_n62581152)
print v(xbgr.mr_n62581472)
print v(xbgr.mr_n62582336)
print v(xbgr.mr_n62583200)
print v(xbgr.mr_n62583312)
print v(xbgr.mr_n62583744)
print v(xbgr.mr_n62584064)
print v(xbgr.mr_n62584176)
print v(xbgr.mr_n62584608)
print v(xbgr.mr_n62584928)
print v(xbgr.mr_n62585792)
print v(xbgr.mr_n62586656)
print v(xbgr.mr_n62587520)
print v(xbgr.mr_n62588384)
print v(xbgr.mr_n62588496)
print v(xbgr.mr_n62588816)
print v(xbgr.mr_n62588928)
print v(xbgr.mr_n62589248)
print v(xbgr.mr_n62589360)
print v(xbgr.mr_n62589680)
print v(xbgr.mr_n62589792)
print v(xbgr.mr_n62590112)
print v(xbgr.mr_n62590976)
print v(xbgr.mr_n62591840)
print v(xbgr.mr_n62591952)
print v(xbgr.mr_n62592272)
print v(xbgr.mr_n62592384)
print v(xbgr.mr_n62592816)
print v(xbgr.mr_n62593248)
print v(xbgr.mr_n62593568)
print v(xbgr.mr_n62593680)
print v(xbgr.mr_n62594000)
print v(xbgr.mr_n62594112)
print v(xbgr.mr_n62594432)
print v(xbgr.mr_n62594544)
print v(xbgr.mr_n62594864)
print v(xbgr.mr_n62594976)
print v(xbgr.mr_n62595296)
print v(xbgr.mr_n62595408)
print v(xbgr.mr_n62595840)
print v(xbgr.mr_n62596160)
print v(xbgr.mr_n62596272)
print v(xbgr.mr_n62596704)
print v(xbgr.mr_n62597024)
print v(xbgr.mr_n62597888)
print v(xbgr.mr_n62598752)
print v(xbgr.mr_n62599616)
print v(xbgr.mr_n62600480)
print v(xbgr.mr_n62600592)
print v(xbgr.mr_n62600912)
print v(xbgr.mr_n62601024)
print v(xbgr.mr_n62601344)
print v(xbgr.mr_n62601456)
print v(xbgr.mr_n62601776)
print v(xbgr.mr_n62601888)
print v(xbgr.mr_n62602208)
print v(xbgr.mr_n62603072)
print v(xbgr.mr_n62603936)
print v(xbgr.mr_n62604048)
print v(xbgr.mr_n62604368)
print v(xbgr.mr_n62604480)
print v(xbgr.mr_n62604912)
print v(xbgr.mr_n62605344)
print v(xbgr.mr_n62605664)
print v(xbgr.mr_n62605776)
print v(xbgr.mr_n62606096)
print v(xbgr.mr_n62606208)
print v(xbgr.mr_n62606528)
print v(xbgr.mr_n62606640)
print v(xbgr.mr_n62606960)
print v(xbgr.mr_n62607072)
print v(xbgr.mr_n62607392)
print v(xbgr.mr_n62607504)
print v(xbgr.mr_n62607936)
print v(xbgr.mr_n62608256)
print v(xbgr.mr_n62608368)
print v(xbgr.mr_n62608800)
print v(xbgr.mr_n62609120)
print v(xbgr.mr_n62609232)
print v(xbgr.mr_n62609664)
print v(xbgr.mr_n62609984)
print v(xbgr.mr_n62610096)
print v(xbgr.mr_n62610528)
print v(xbgr.mr_n62610848)
print v(xbgr.mr_n62611712)
print v(xbgr.mr_n62612576)
print v(xbgr.mr_n62613440)
print v(xbgr.mr_n62614304)
print v(xbgr.mr_n62615168)
print v(xbgr.mr_n62616032)
print v(xbgr.mr_n62616144)
print v(xbgr.mr_n62616464)
print v(xbgr.mr_n62616576)
print v(xbgr.mr_n62616896)
print v(xbgr.mr_n62617008)
print v(xbgr.mr_n62617328)
print v(xbgr.mr_n62617440)
print v(xbgr.mr_n62617760)
print v(xbgr.mr_n62617872)
print v(xbgr.mr_n62618192)
print v(xbgr.mr_n62618304)
print v(xbgr.mr_n62618624)
print v(xbgr.mr_n62618736)
print v(xbgr.mr_n62619056)
print v(xbgr.mr_n62619168)
print v(xbgr.mr_n62619488)
print v(xbgr.mr_n62619600)
print v(xbgr.mr_n62619920)
print v(xbgr.mr_n62620032)
print v(xbgr.mr_n62620464)
print v(xbgr.mr_n62620896)
print v(xbgr.mr_n62621216)
print v(xbgr.mr_n62622080)
print v(xbgr.mr_n62622944)
print v(xbgr.mr_n62623056)
print v(xbgr.mr_n62623376)
print v(xbgr.mr_n62623488)
print v(xbgr.mr_n62623808)
print v(xbgr.mr_n62623920)
print v(xbgr.mr_n62624240)
print v(xbgr.mr_n62624352)
print v(xbgr.mr_n62624672)
print v(xbgr.mr_n62624784)
print v(xbgr.mr_n62625104)
print v(xbgr.mr_n62625216)
print v(xbgr.mr_n62625536)
print v(xbgr.mr_n62625648)
print v(xbgr.mr_n62625968)
print v(xbgr.mr_n62626080)
print v(xbgr.mr_n62626512)
print v(xbgr.mr_n62626944)
print v(xbgr.mr_n62627264)
print v(xbgr.mr_n62627376)
print v(xbgr.mr_n62627696)
print v(xbgr.mr_n62627808)
print v(xbgr.mr_n62628128)
print v(xbgr.mr_n62628240)
print v(xbgr.mr_n62628560)
print v(xbgr.mr_n62628672)
print v(xbgr.mr_n62628992)
print v(xbgr.mr_n62629104)
print v(xbgr.mr_n62629424)
print v(xbgr.mr_n62629536)
print v(xbgr.mr_n62629856)
print v(xbgr.mr_n62630720)
print v(xbgr.mr_n62631584)
print v(xbgr.mr_n62632448)
print v(xbgr.mr_n62633312)
print v(xbgr.mr_n62633424)
print v(xbgr.mr_n62633856)
print v(xbgr.mr_n62634176)
print v(xbgr.mr_n62634288)
print v(xbgr.mr_n62634608)
print v(xbgr.mr_n62634720)
print v(xbgr.mr_n62635040)
print v(xbgr.mr_n62635152)
print v(xbgr.mr_n62635472)
print v(xbgr.mr_n62635584)
print v(xbgr.mr_n62635904)
print v(xbgr.mr_n62636016)
print v(xbgr.mr_n62636336)
print v(xbgr.mr_n62636448)
print v(xbgr.mr_n62636768)
print v(xbgr.mr_n62636880)
print v(xbgr.mr_n62637312)
print v(xbgr.mr_n62637632)
print v(xbgr.mr_n62638496)
print v(xbgr.mr_n62638608)
print v(xbgr.mr_n62638928)
print v(xbgr.mr_n62639040)
print v(xbgr.mr_n62639360)
print v(xbgr.mr_n62639472)
print v(xbgr.mr_n62639792)
print v(xbgr.mr_n62639904)
print v(xbgr.mr_n62640224)
print v(xbgr.mr_n62640336)
print v(xbgr.mr_n62640768)
print v(xbgr.mr_n62641088)
print v(xbgr.mr_n62641200)
print v(xbgr.mr_n62641632)
print v(xbgr.mr_n62641952)
print v(xbgr.mr_n62642816)
print v(xbgr.mr_n62643680)
print v(xbgr.mr_n62644544)
print v(xbgr.mr_n62645408)
print v(xbgr.mr_n62645520)
print v(xbgr.mr_n62645840)
print v(xbgr.mr_n62645952)
print v(xbgr.mr_n62646272)
print v(xbgr.mr_n62646384)
print v(xbgr.mr_n62646704)
print v(xbgr.mr_n62646816)
print v(xbgr.mr_n62647136)
print v(xbgr.mr_n62647248)
print v(xbgr.mr_n62647568)
print v(xbgr.mr_n62647680)
print v(xbgr.mr_n62648000)
print v(xbgr.mr_n62648864)
print v(xbgr.mr_n62649728)
print v(xbgr.mr_n62649840)
print v(xbgr.mr_n62650160)
print v(xbgr.mr_n62650272)
print v(xbgr.mr_n62650704)
print v(xbgr.mr_n62651136)
print v(xbgr.mr_n62651456)
print v(xbgr.mr_n62651568)
print v(xbgr.mr_n62651888)
print v(xbgr.mr_n62652000)
print v(xbgr.mr_n62652320)
print v(xbgr.mr_n62652432)
print v(xbgr.mr_n62652752)
print v(xbgr.mr_n62652864)
print v(xbgr.mr_n62653184)
print v(xbgr.mr_n62654048)
print v(xbgr.mr_n62654912)
print v(xbgr.mr_n62655776)
print v(xbgr.mr_n62656640)
print v(xbgr.mr_n62657504)
print v(xbgr.mr_n62657616)
print v(xbgr.mr_n62657936)
print v(xbgr.mr_n62658048)
print v(xbgr.mr_n62658368)
print v(xbgr.mr_n62658480)
print v(xbgr.mr_n62658800)
print v(xbgr.mr_n62658912)
print v(xbgr.mr_n62659232)
print v(xbgr.mr_n62659344)
print v(xbgr.mr_n62659776)
print v(xbgr.mr_n62660096)
print v(xbgr.mr_n62660208)
print v(xbgr.mr_n62660640)
print v(xbgr.mr_n62660960)
print v(xbgr.mr_n62661072)
print v(xbgr.mr_n62661504)
print v(xbgr.mr_n62661824)
print v(xbgr.mr_n62661936)
print v(xbgr.mr_n62662368)
print v(xbgr.mr_n62662688)
print v(xbgr.mr_n62663552)
print v(xbgr.mr_n62663664)
print v(xbgr.mr_n62663984)
print v(xbgr.mr_n62664096)
print v(xbgr.mr_n62664416)
print v(xbgr.mr_n62664528)
print v(xbgr.mr_n62664848)
print v(xbgr.mr_n62664960)
print v(xbgr.mr_n62665280)
print v(xbgr.mr_n62666144)
print v(xbgr.mr_n62667008)
print v(xbgr.mr_n62667872)
print v(xbgr.mr_n62668736)
print v(xbgr.mr_n62669600)
print v(xbgr.mr_n62669712)
print v(xbgr.mr_n62670032)
print v(xbgr.mr_n62670144)
print v(xbgr.mr_n62670464)
print v(xbgr.mr_n62670576)
print v(xbgr.mr_n62670896)
print v(xbgr.mr_n62671008)
print v(xbgr.mr_n62671440)
print v(xbgr.mr_n62671872)
print v(xbgr.mr_n62672192)
print v(xbgr.mr_n62672304)
print v(xbgr.mr_n62672624)
print v(xbgr.mr_n62672736)
print v(xbgr.mr_n62673056)
print v(xbgr.mr_n62673920)
print v(xbgr.mr_n62674032)
print v(xbgr.mr_n62674352)
print v(xbgr.mr_n62674464)
print v(xbgr.mr_n62674784)
print v(xbgr.mr_n62675648)
print v(xbgr.mr_n62676512)
print v(xbgr.mr_n62676624)
print v(xbgr.mr_n62676944)
print v(xbgr.mr_n62677056)
print v(xbgr.mr_n62677376)
print v(xbgr.mr_n62678240)
print v(xbgr.mr_n62679104)
print v(xbgr.mr_n62679968)
print v(xbgr.mr_n62680080)
print v(xbgr.mr_n62680400)
print v(xbgr.mr_n62680512)
print v(xbgr.mr_n62680832)
print v(xbgr.mr_n62680944)
print v(xbgr.mr_n62681264)
print v(xbgr.mr_n62681376)
print v(xbgr.mr_n62681696)
print v(xbgr.mr_n62681808)
print v(xbgr.mr_n62682128)
print v(xbgr.mr_n62682240)
print v(xbgr.mr_n62682560)
print v(xbgr.mr_n62682672)
print v(xbgr.mr_n62682992)
print v(xbgr.mr_n62683104)
print v(xbgr.mr_n62683424)
print v(xbgr.mr_n62683536)
print v(xbgr.mr_n62683856)
print v(xbgr.mr_n62683968)
print v(xbgr.mr_n62684288)
print v(xbgr.mr_n62684400)
print v(xbgr.mr_n62684720)
print v(xbgr.mr_n62684832)
print v(xbgr.mr_n62685264)
print v(xbgr.mr_n62685584)
print v(xbgr.mr_n62685696)
print v(xbgr.mr_n62686128)
print v(xbgr.mr_n62686448)
print v(xbgr.mr_n62686560)
print v(xbgr.mr_n62686992)
print v(xbgr.mr_n62687312)
print v(xbgr.mr_n62688176)
print v(xbgr.mr_n62689040)
print v(xbgr.mr_n62689904)
print v(xbgr.mr_n62690016)
print v(xbgr.mr_n62690336)
print v(xbgr.mr_n62690448)
print v(xbgr.mr_n62690768)
print v(xbgr.mr_n62691632)
print v(xbgr.mr_n62692496)
print v(xbgr.mr_n62693360)
print v(xbgr.mr_n62693472)
print v(xbgr.mr_n62693792)
print v(xbgr.mr_n62693904)
print v(xbgr.mr_n62694224)
print v(xbgr.mr_n62694336)
print v(xbgr.mr_n62694656)
print v(xbgr.mr_n62694768)
print v(xbgr.mr_n62695088)
print v(xbgr.mr_n62695200)
print v(xbgr.mr_n62695520)
print v(xbgr.mr_n62695632)
print v(xbgr.mr_n62695952)
print v(xbgr.mr_n62696064)
print v(xbgr.mr_n62696384)
print v(xbgr.mr_n62696496)
print v(xbgr.mr_n62696816)
print v(xbgr.mr_n62696928)
print v(xbgr.mr_n62697248)
print v(xbgr.mr_n62697360)
print v(xbgr.mr_n62697680)
print v(xbgr.mr_n62697792)
print v(xbgr.mr_n62698112)
print v(xbgr.mr_n62698224)
print v(xbgr.mr_n62698544)
print v(xbgr.mr_n62698656)
print v(xbgr.mr_n62699088)
print v(xbgr.mr_n62699408)
print v(xbgr.mr_n62700272)
print v(xbgr.mr_n62701136)
print v(xbgr.mr_n62702000)
print v(xbgr.mr_n62702112)
print v(xbgr.mr_n62702544)
print v(xbgr.mr_n62702864)
print v(xbgr.mr_n62702976)
print v(xbgr.mr_n62703408)
print v(xbgr.mr_n62703728)
print v(xbgr.mr_n62703840)
print v(xbgr.mr_n62704160)
print v(xbgr.mr_n62704272)
print v(xbgr.mr_n62704592)
print v(xbgr.mr_n62704704)
print v(xbgr.mr_n62705136)
print v(xbgr.mr_n62705568)
print v(xbgr.mr_n62706000)
print v(xbgr.mr_n62706320)
print v(xbgr.mr_n62707184)
print v(xbgr.mr_n62708048)
print v(xbgr.mr_n62708912)
print v(xbgr.mr_n62709776)
print v(xbgr.mr_n62710640)
print v(xbgr.mr_n62711504)
print v(xbgr.mr_n62711616)
print v(xbgr.mr_n62711936)
print v(xbgr.mr_n62712048)
print v(xbgr.mr_n62712368)
print v(xbgr.mr_n62712480)
print v(xbgr.mr_n62712800)
print v(xbgr.mr_n62712912)
print v(xbgr.mr_n62713232)
print v(xbgr.mr_n62713344)
print v(xbgr.mr_n62713664)
print v(xbgr.mr_n62713776)
print v(xbgr.mr_n62714096)
print v(xbgr.mr_n62714960)
print v(xbgr.mr_n62715824)
print v(xbgr.mr_n62716800)
print v(xbgr.mr_n62717232)
print v(xbgr.mr_n62717664)
print v(xbgr.mr_n62717984)
print v(xbgr.mr_n62718096)
print v(xbgr.mr_n62718416)
print v(xbgr.mr_n62718528)
print v(xbgr.mr_n62718848)
print v(xbgr.mr_n62718960)
print v(xbgr.mr_n62719392)
print v(xbgr.mr_n62719712)
print v(xbgr.mr_n62719824)
print v(xbgr.mr_n62720144)
print v(xbgr.mr_n62720256)
print v(xbgr.mr_n62720688)
print v(xbgr.mr_n62721008)
print v(xbgr.mr_n62721120)
print v(xbgr.mr_n62721552)
print v(xbgr.mr_n62721872)
print v(xbgr.mr_n62721984)
print v(xbgr.mr_n62722416)
print v(xbgr.mr_n62722736)
print v(xbgr.mr_n62723600)
print v(xbgr.mr_n62724464)
print v(xbgr.mr_n62724576)
print v(xbgr.mr_n62724896)
print v(xbgr.mr_n62725008)
print v(xbgr.mr_n62725328)
print v(xbgr.mr_n62725440)
print v(xbgr.mr_n62725760)
print v(xbgr.mr_n62725872)
print v(xbgr.mr_n62726304)
print v(xbgr.mr_n62726624)
print v(xbgr.mr_n62727488)
print v(xbgr.mr_n62727600)
print v(xbgr.mr_n62727920)
print v(xbgr.mr_n62728032)
print v(xbgr.mr_n62728352)
print v(xbgr.mr_n62728464)
print v(xbgr.mr_n62728784)
print v(xbgr.mr_n62729648)
print v(xbgr.mr_n62730080)
print v(xbgr.mr_n62730944)
print v(xbgr.mr_n62731056)
print v(xbgr.mr_n62731376)
print v(xbgr.mr_n62731488)
print v(xbgr.mr_n62731808)
print v(xbgr.mr_n62731920)
print v(xbgr.mr_n62732240)
print v(xbgr.mr_n62732352)
print v(xbgr.mr_n62732672)
print v(xbgr.mr_n62732784)
print v(xbgr.mr_n62733216)
print v(xbgr.mr_n62733968)
print v(xbgr.mr_n62734832)
print v(xbgr.mr_n62735264)
print v(xbgr.mr_n62735376)
print v(xbgr.mr_n62735696)
print v(xbgr.mr_n62736128)
print v(xbgr.mr_n62736992)
print v(xbgr.mr_n62737856)
print v(xbgr.mr_n62738720)
print v(xbgr.mr_n62739584)
print v(xbgr.mr_n62740880)
print v(xbgr.mr_n62741744)
print v(xbgr.mr_n62742720)
print v(xbgr.mr_n62743040)
print v(xbgr.mr_n62743152)
print v(xbgr.mr_n62743584)
print v(xbgr.mr_n62743904)
print v(xbgr.mr_n62744768)
print v(xbgr.mr_n62744880)
print v(xbgr.mr_n62745200)
print v(xbgr.mr_n62745312)
print v(xbgr.mr_n62745744)
print v(xbgr.mr_n62746064)
print v(xbgr.mr_n62746176)
print v(xbgr.mr_n62746496)
print v(xbgr.mr_n62746608)
print v(xbgr.mr_n62746928)
print v(xbgr.mr_n62747040)
print v(xbgr.mr_n62747360)
print v(xbgr.mr_n62747472)
print v(xbgr.mr_n62747904)
print v(xbgr.mr_n62748224)
print v(xbgr.mr_n62748336)
print v(xbgr.mr_n62748656)
print v(xbgr.mr_n62748768)
print v(xbgr.mr_n62749088)
print v(xbgr.mr_n62749952)
print v(xbgr.mr_n62750064)
print v(xbgr.mr_n62750816)
print v(xbgr.mr_n62750928)
print v(xbgr.mr_n62751248)
print v(xbgr.mr_n62751360)
print v(xbgr.mr_n62751680)
print v(xbgr.mr_n62751792)
print v(xbgr.mr_n62752112)
print v(xbgr.mr_n62752224)
print v(xbgr.mr_n62752544)
print v(xbgr.mr_n62752656)
print v(xbgr.mr_n62752976)
print v(xbgr.mr_n62753088)
print v(xbgr.mr_n62753408)
print v(xbgr.mr_n62753520)
print v(xbgr.mr_n62753840)
print v(xbgr.mr_n62753952)
print v(xbgr.mr_n62754272)
print v(xbgr.mr_n62754384)
print v(xbgr.mr_n62754704)
print v(xbgr.mr_n62754816)
print v(xbgr.mr_n62755136)
print v(xbgr.mr_n62755248)
print v(xbgr.mr_n62755568)
print v(xbgr.mr_n62755680)
print v(xbgr.mr_n62756000)
print v(xbgr.mr_n62756112)
print v(xbgr.mr_n62756544)
print v(xbgr.mr_n62756864)
print v(xbgr.mr_n62756976)
print v(xbgr.mr_n62757408)
print v(xbgr.mr_n62757728)
print v(xbgr.mr_n62757840)
print v(xbgr.mr_n62758272)
print v(xbgr.mr_n62758592)
print v(xbgr.mr_n62759456)
print v(xbgr.mr_n62760320)
print v(xbgr.mr_n62761184)
print v(xbgr.mr_n62762048)
print v(xbgr.mr_n62762912)
print v(xbgr.mr_n62763776)
print v(xbgr.mr_n62763888)
print v(xbgr.mr_n62764208)
print v(xbgr.mr_n62764320)
print v(xbgr.mr_n62764640)
print v(xbgr.mr_n62764752)
print v(xbgr.mr_n62765072)
print v(xbgr.mr_n62765184)
print v(xbgr.mr_n62765504)
print v(xbgr.mr_n62766368)
print v(xbgr.mr_n62767232)
print v(xbgr.mr_n62768096)
print v(xbgr.mr_n62768208)
print v(xbgr.mr_n62768528)
print v(xbgr.mr_n62768640)
print v(xbgr.mr_n62768960)
print v(xbgr.mr_n62769072)
print v(xbgr.mr_n62769504)
print v(xbgr.mr_n62769936)
print v(xbgr.mr_n62770368)
print v(xbgr.mr_n62770688)
print v(xbgr.mr_n62770800)
print v(xbgr.mr_n62771120)
print v(xbgr.mr_n62771232)
print v(xbgr.mr_n62771552)
print v(xbgr.mr_n62771664)
print v(xbgr.mr_n62771984)
print v(xbgr.mr_n62772096)
print v(xbgr.mr_n62772416)
print v(xbgr.mr_n62772528)
print v(xbgr.mr_n62772848)
print v(xbgr.mr_n62772960)
print v(xbgr.mr_n62773280)
print v(xbgr.mr_n62773392)
print v(xbgr.mr_n62773824)
print v(xbgr.mr_n62774144)
print v(xbgr.mr_n62774256)
print v(xbgr.mr_n62774688)
print v(xbgr.mr_n62775008)
print v(xbgr.mr_n62775120)
print v(xbgr.mr_n62775552)
print v(xbgr.mr_n62775872)
print v(xbgr.mr_n62776736)
print v(xbgr.mr_n62777600)
print v(xbgr.mr_n62778464)
print v(xbgr.mr_n62779328)
print v(xbgr.mr_n62780192)
print v(xbgr.mr_n62781056)
print v(xbgr.mr_n62781168)
print v(xbgr.mr_n62781488)
print v(xbgr.mr_n62781600)
print v(xbgr.mr_n62781920)
print v(xbgr.mr_n62782032)
print v(xbgr.mr_n62782352)
print v(xbgr.mr_n62782464)
print v(xbgr.mr_n62782784)
print v(xbgr.mr_n62783648)
print v(xbgr.mr_n62784512)
print v(xbgr.mr_n62785376)
print v(xbgr.mr_n62785488)
print v(xbgr.mr_n62785808)
print v(xbgr.mr_n62785920)
print v(xbgr.mr_n62786240)
print v(xbgr.mr_n62786352)
print v(xbgr.mr_n62786784)
print v(xbgr.mr_n62787104)
print v(xbgr.mr_n62787216)
print v(xbgr.mr_n62787648)
print v(xbgr.mr_n62787968)
print v(xbgr.mr_n62788080)
print v(xbgr.mr_n62788512)
print v(xbgr.mr_n62788832)
print v(xbgr.mr_n62788944)
print v(xbgr.mr_n62789264)
print v(xbgr.mr_n62789376)
print v(xbgr.mr_n62789696)
print v(xbgr.mr_n62789808)
print v(xbgr.mr_n62790240)
print v(xbgr.mr_n62790560)
print v(xbgr.mr_n62791424)
print v(xbgr.mr_n62792288)
print v(xbgr.mr_n62793152)
print v(xbgr.mr_n62793264)
print v(xbgr.mr_n62793584)
print v(xbgr.mr_n62793696)
print v(xbgr.mr_n62794016)
print v(xbgr.mr_n62794880)
print v(xbgr.mr_n62795744)
print v(xbgr.mr_n62796608)
print v(xbgr.mr_n62797472)
print v(xbgr.mr_n62797584)
print v(xbgr.mr_n62797904)
print v(xbgr.mr_n62798016)
print v(xbgr.mr_n62798336)
print v(xbgr.mr_n62799200)
print v(xbgr.mr_n62799744)
print v(xbgr.mr_n62800064)
print v(xbgr.mr_n62800176)
print v(xbgr.mr_n62800496)
print v(xbgr.mr_n62800608)
print v(xbgr.mr_n62800928)
print v(xbgr.mr_n62801040)
print v(xbgr.mr_n62801360)
print v(xbgr.mr_n62801472)
print v(xbgr.mr_n62801904)
print v(xbgr.mr_n62802656)
print v(xbgr.mr_n62803520)
print v(xbgr.mr_n62804384)
print v(xbgr.mr_n62805248)
print v(xbgr.mr_n62805360)
print v(xbgr.mr_n62805680)
print v(xbgr.mr_n62805792)
print v(xbgr.mr_n62806112)
print v(xbgr.mr_n62806224)
print v(xbgr.mr_n62806544)
print v(xbgr.mr_n62806656)
print v(xbgr.mr_n62806976)
print v(xbgr.mr_n62807088)
print v(xbgr.mr_n62807408)
print v(xbgr.mr_n62807520)
print v(xbgr.mr_n62807840)
print v(xbgr.mr_n62807952)
print v(xbgr.mr_n62808384)
print v(xbgr.mr_n62808704)
print v(xbgr.mr_n62808816)
print v(xbgr.mr_n62809136)
print v(xbgr.mr_n62809248)
print v(xbgr.mr_n62809568)
print v(xbgr.mr_n62809680)
print v(xbgr.mr_n62810000)
print v(xbgr.mr_n62810112)
print v(xbgr.mr_n62810432)
print v(xbgr.mr_n62810544)
print v(xbgr.mr_n62810976)
print v(xbgr.mr_n62811296)
print v(xbgr.mr_n62812160)
print v(xbgr.mr_n62812272)
print v(xbgr.mr_n62812592)
print v(xbgr.mr_n62812704)
print v(xbgr.mr_n62813136)
print v(xbgr.mr_n62813568)
print v(xbgr.mr_n62813888)
print v(xbgr.mr_n62814000)
print v(xbgr.mr_n62814320)
print v(xbgr.mr_n62814432)
print v(xbgr.mr_n62814752)
print v(xbgr.mr_n62814864)
print v(xbgr.mr_n62815184)
print v(xbgr.mr_n62815296)
print v(xbgr.mr_n62815616)
print v(xbgr.mr_n62815728)
print v(xbgr.mr_n62816160)
print v(xbgr.mr_n62816480)
print v(xbgr.mr_n62816592)
print v(xbgr.mr_n62817024)
print v(xbgr.mr_n62817344)
print v(xbgr.mr_n62818208)
print v(xbgr.mr_n62819072)
print v(xbgr.mr_n62819936)
print v(xbgr.mr_n62820800)
print v(xbgr.mr_n62820912)
print v(xbgr.mr_n62821232)
print v(xbgr.mr_n62821344)
print v(xbgr.mr_n62821664)
print v(xbgr.mr_n62821776)
print v(xbgr.mr_n62822096)
print v(xbgr.mr_n62822208)
print v(xbgr.mr_n62822528)
print v(xbgr.mr_n62823392)
print v(xbgr.mr_n62824256)
print v(xbgr.mr_n62824368)
print v(xbgr.mr_n62824688)
print v(xbgr.mr_n62824800)
print v(xbgr.mr_n62825232)
print v(xbgr.mr_n62825664)
print v(xbgr.mr_n62825984)
print v(xbgr.mr_n62826096)
print v(xbgr.mr_n62826416)
print v(xbgr.mr_n62826528)
print v(xbgr.mr_n62826848)
print v(xbgr.mr_n62826960)
print v(xbgr.mr_n62827280)
print v(xbgr.mr_n62827392)
print v(xbgr.mr_n62827712)
print v(xbgr.mr_n62828576)
print v(xbgr.mr_n62829440)
print v(xbgr.mr_n62830304)
print v(xbgr.mr_n62831168)
print v(xbgr.mr_n62832032)
print v(xbgr.mr_n62832144)
print v(xbgr.mr_n62832576)
print v(xbgr.mr_n62832896)
print v(xbgr.mr_n62833008)
print v(xbgr.mr_n62833440)
print v(xbgr.mr_n62833760)
print v(xbgr.mr_n62833872)
print v(xbgr.mr_n62834304)
print v(xbgr.mr_n62834624)
print v(xbgr.mr_n62834736)
print v(xbgr.mr_n62835056)
print v(xbgr.mr_n62835168)
print v(xbgr.mr_n62835488)
print v(xbgr.mr_n62835600)
print v(xbgr.mr_n62835920)
print v(xbgr.mr_n62836032)
print v(xbgr.mr_n62836352)
print v(xbgr.mr_n62836464)
print v(xbgr.mr_n62836784)
print v(xbgr.mr_n62836896)
print v(xbgr.mr_n62837216)
print v(xbgr.mr_n62837328)
print v(xbgr.mr_n62837648)
print v(xbgr.mr_n62837760)
print v(xbgr.mr_n62838080)
print v(xbgr.mr_n62838192)
print v(xbgr.mr_n62838512)
print v(xbgr.mr_n62838624)
print v(xbgr.mr_n62838944)
print v(xbgr.mr_n62839056)
print v(xbgr.mr_n62839376)
print v(xbgr.mr_n62839488)
print v(xbgr.mr_n62839808)
print v(xbgr.mr_n62840672)
print v(xbgr.mr_n62841536)
print v(xbgr.mr_n62842400)
print v(xbgr.mr_n62842512)
print v(xbgr.mr_n62842944)
print v(xbgr.mr_n62843264)
print v(xbgr.mr_n62843376)
print v(xbgr.mr_n62843696)
print v(xbgr.mr_n62843808)
print v(xbgr.mr_n62844128)
print v(xbgr.mr_n62844240)
print v(xbgr.mr_n62844560)
print v(xbgr.mr_n62844672)
print v(xbgr.mr_n62845104)
print v(xbgr.mr_n62845536)
print v(xbgr.mr_n62845968)
print v(xbgr.mr_n62846400)
print v(xbgr.mr_n62846720)
print v(xbgr.mr_n62846832)
print v(xbgr.mr_n62847264)
print v(xbgr.mr_n62847584)
print v(xbgr.mr_n62848448)
print v(xbgr.mr_n62848560)
print v(xbgr.mr_n62848880)
print v(xbgr.mr_n62848992)
print v(xbgr.mr_n62849312)
print v(xbgr.mr_n62849424)
print v(xbgr.mr_n62849744)
print v(xbgr.mr_n62850720)
print v(xbgr.mr_n62851152)
print v(xbgr.mr_n62851584)
print v(xbgr.mr_n62851904)
print v(xbgr.mr_n62852768)
print v(xbgr.mr_n62852880)
print v(xbgr.mr_n62853200)
print v(xbgr.mr_n62853312)
print v(xbgr.mr_n62853632)
print v(xbgr.mr_n62853744)
print v(xbgr.mr_n62854064)
print v(xbgr.mr_n62854176)
print v(xbgr.mr_n62854496)
print v(xbgr.mr_n62854608)
print v(xbgr.mr_n62854928)
print v(xbgr.mr_n62855040)
print v(xbgr.mr_n62855360)
print v(xbgr.mr_n62855472)
print v(xbgr.mr_n62855792)
print v(xbgr.mr_n62855904)
print v(xbgr.mr_n62856224)
print v(xbgr.mr_n62857088)
print v(xbgr.mr_n62857952)
print v(xbgr.mr_n62858816)
print v(xbgr.mr_n62859680)
print v(xbgr.mr_n62860544)
print v(xbgr.mr_n62861408)
print v(xbgr.mr_n62862272)
print v(xbgr.mr_n62863136)
print v(xbgr.mr_n62864000)
print v(xbgr.mr_n62864864)
print v(xbgr.mr_n62865728)
print v(xbgr.mr_n62866592)
print v(xbgr.mr_n62866704)
print v(xbgr.mr_n62867024)
print v(xbgr.mr_n62867136)
print v(xbgr.mr_n62867456)
print v(xbgr.mr_n62867568)
print v(xbgr.mr_n62867888)
print v(xbgr.mr_n62868000)
print v(xbgr.mr_n62868320)
print v(xbgr.mr_n62868432)
print v(xbgr.mr_n62868864)
print v(xbgr.mr_n62869184)
print v(xbgr.mr_n62869296)
print v(xbgr.mr_n62869728)
print v(xbgr.mr_n62870048)
print v(xbgr.mr_n62870912)
print v(xbgr.mr_n62871776)
print v(xbgr.mr_n62872640)
print v(xbgr.mr_n62873504)
print v(xbgr.mr_n62873616)
print v(xbgr.mr_n62873936)
print v(xbgr.mr_n62874048)
print v(xbgr.mr_n62874368)
print v(xbgr.mr_n62874480)
print v(xbgr.mr_n62874800)
print v(xbgr.mr_n62874912)
print v(xbgr.mr_n62875232)
print v(xbgr.mr_n62875344)
print v(xbgr.mr_n62875664)
print v(xbgr.mr_n62875776)
print v(xbgr.mr_n62876096)
print v(xbgr.mr_n62876208)
print v(xbgr.mr_n62876528)
print v(xbgr.mr_n62877392)
print v(xbgr.mr_n62878256)
print v(xbgr.mr_n62878368)
print v(xbgr.mr_n62878688)
print v(xbgr.mr_n62878800)
print v(xbgr.mr_n62879232)
print v(xbgr.mr_n62879664)
print v(xbgr.mr_n62879984)
print v(xbgr.mr_n62880096)
print v(xbgr.mr_n62880416)
print v(xbgr.mr_n62880528)
print v(xbgr.mr_n62880848)
print v(xbgr.mr_n62880960)
print v(xbgr.mr_n62881280)
print v(xbgr.mr_n62881392)
print v(xbgr.mr_n62881712)
print v(xbgr.mr_n62881824)
print v(xbgr.mr_n62882256)
print v(xbgr.mr_n62882576)
print v(xbgr.mr_n62882688)
print v(xbgr.mr_n62883120)
print v(xbgr.mr_n62883440)
print v(xbgr.mr_n62883552)
print v(xbgr.mr_n62883872)
print v(xbgr.mr_n62884736)
print v(xbgr.mr_n62885600)
print v(xbgr.mr_n62886464)
print v(xbgr.mr_n62887328)
print v(xbgr.mr_n62887440)
print v(xbgr.mr_n62887760)
print v(xbgr.mr_n62887872)
print v(xbgr.mr_n62888192)
print v(xbgr.mr_n62888304)
print v(xbgr.mr_n62888624)
print v(xbgr.mr_n62888736)
print v(xbgr.mr_n62889056)
print v(xbgr.mr_n62889168)
print v(xbgr.mr_n62889488)
print v(xbgr.mr_n62889600)
print v(xbgr.mr_n62889920)
print v(xbgr.mr_n62890784)
print v(xbgr.mr_n62891648)
print v(xbgr.mr_n62891760)
print v(xbgr.mr_n62892192)
print v(xbgr.mr_n62892512)
print v(xbgr.mr_n62892624)
print v(xbgr.mr_n62892944)
print v(xbgr.mr_n62893056)
print v(xbgr.mr_n62893376)
print v(xbgr.mr_n62893488)
print v(xbgr.mr_n62893808)
print v(xbgr.mr_n62893920)
print v(xbgr.mr_n62894240)
print v(xbgr.mr_n62894352)
print v(xbgr.mr_n62894672)
print v(xbgr.mr_n62894784)
print v(xbgr.mr_n62895216)
print v(xbgr.mr_n62895648)
print v(xbgr.mr_n62896080)
print v(xbgr.mr_n62896512)
print v(xbgr.mr_n62896832)
print v(xbgr.mr_n62897264)
print v(xbgr.mr_n62897376)
print v(xbgr.mr_n62897696)
print v(xbgr.mr_n62897808)
print v(xbgr.mr_n62898128)
print v(xbgr.mr_n62898240)
print v(xbgr.mr_n62898560)
print v(xbgr.mr_n62898672)
print v(xbgr.mr_n62898992)
print v(xbgr.mr_n62899104)
print v(xbgr.mr_n62899424)
print v(xbgr.mr_n62899536)
print v(xbgr.mr_n62900288)
print v(xbgr.mr_n62900400)
print v(xbgr.mr_n62900832)
print v(xbgr.mr_n62901152)
print v(xbgr.mr_n62901584)
print v(xbgr.mr_n62901696)
print v(xbgr.mr_n62902128)
print v(xbgr.mr_n62902448)
print v(xbgr.mr_n62902560)
print v(xbgr.mr_n62902992)
print v(xbgr.mr_n62903312)
print v(xbgr.mr_n62903424)
print v(xbgr.mr_n62903856)
print v(xbgr.mr_n62904608)
print v(xbgr.mr_n62905472)
print v(xbgr.mr_n62906336)
print v(xbgr.mr_n62907200)
print v(xbgr.mr_n62908064)
print v(xbgr.mr_n62908928)
print v(xbgr.mr_n62909040)
print v(xbgr.mr_n62909360)
print v(xbgr.mr_n62909472)
print v(xbgr.mr_n62909792)
print v(xbgr.mr_n62909904)
print v(xbgr.mr_n62910224)
print v(xbgr.mr_n62910336)
print v(xbgr.mr_n62910656)
print v(xbgr.mr_n62911520)
print v(xbgr.mr_n62912384)
print v(xbgr.mr_n62913248)
print v(xbgr.mr_n62913360)
print v(xbgr.mr_n62913680)
print v(xbgr.mr_n62913792)
print v(xbgr.mr_n62914112)
print v(xbgr.mr_n62914224)
print v(xbgr.mr_n62914544)
print v(xbgr.mr_n62914656)
print v(xbgr.mr_n62914976)
print v(xbgr.mr_n62915088)
print v(xbgr.mr_n62915408)
print v(xbgr.mr_n62915520)
print v(xbgr.mr_n62915840)
print v(xbgr.mr_n62915952)
print v(xbgr.mr_n62916272)
print v(xbgr.mr_n62916384)
print v(xbgr.mr_n62916704)
print v(xbgr.mr_n62917568)
print v(xbgr.mr_n62918000)
print v(xbgr.mr_n62918864)
print v(xbgr.mr_n62919296)
print v(xbgr.mr_n62920160)
print v(xbgr.mr_n62921024)
print v(xbgr.mr_n62922320)
print v(xbgr.mr_n62923616)
print v(xbgr.mr_n62923728)
print v(xbgr.mr_n62924048)
print v(xbgr.mr_n62924160)
print v(xbgr.mr_n62924592)
print v(xbgr.mr_n62924912)
print v(xbgr.mr_n62925024)
print v(xbgr.mr_n62925456)
print v(xbgr.mr_n62925776)
print v(xbgr.mr_n62925888)
print v(xbgr.mr_n62926208)
print v(xbgr.mr_n62926320)
print v(xbgr.mr_n62926640)
print v(xbgr.mr_n62926752)
print v(xbgr.mr_n62927184)
print v(xbgr.mr_n62927504)
print v(xbgr.mr_n62927616)
print v(xbgr.mr_n62928048)
print v(xbgr.mr_n62928368)
print v(xbgr.mr_n62928480)
print v(xbgr.mr_n62928912)
print v(xbgr.mr_n62929232)
print v(xbgr.mr_n62929344)
print v(xbgr.mr_n62929664)
print v(xbgr.mr_n62930096)
print v(xbgr.mr_n62930208)
print v(xbgr.mr_n62930528)
print v(xbgr.mr_n62930640)
print v(xbgr.mr_n62930960)
print v(xbgr.mr_n62931072)
print v(xbgr.mr_n62931392)
print v(xbgr.mr_n62931504)
print v(xbgr.mr_n62932256)
print v(xbgr.mr_n62933120)
print v(xbgr.mr_n62933984)
print v(xbgr.mr_n62934096)
print v(xbgr.mr_n62934416)
print v(xbgr.mr_n62934528)
print v(xbgr.mr_n62934848)
print v(xbgr.mr_n62934960)
print v(xbgr.mr_n62935280)
print v(xbgr.mr_n62935392)
print v(xbgr.mr_n62936144)
print v(xbgr.mr_n62936576)
print v(xbgr.mr_n62937440)
print v(xbgr.mr_n62938736)
print v(xbgr.mr_n62939168)
print v(xbgr.mr_n62940032)
print v(xbgr.mr_n62940144)
print v(xbgr.mr_n62940464)
print v(xbgr.mr_n62940576)
print v(xbgr.mr_n62940896)
print v(xbgr.mr_n62941760)
print v(xbgr.mr_n62942192)
print v(xbgr.mr_n62942304)
print v(xbgr.mr_n62942624)
print v(xbgr.mr_n62943488)
print v(xbgr.mr_n62944352)
print v(xbgr.mr_n62945216)
print v(xbgr.mr_n62946080)
print v(xbgr.mr_n62946192)
print v(xbgr.mr_n62946512)
print v(xbgr.mr_n62946624)
print v(xbgr.mr_n62946944)
print v(xbgr.mr_n62947056)
print v(xbgr.mr_n62947376)
print v(xbgr.mr_n62947488)
print v(xbgr.mr_n62948240)
print v(xbgr.mr_n62949104)
print v(xbgr.mr_n62949968)
print v(xbgr.mr_n62950080)
print v(xbgr.mr_n62950512)
print v(xbgr.mr_n62950944)
print v(xbgr.mr_n62951376)
print v(xbgr.mr_n62951696)
print v(xbgr.mr_n62951808)
print v(xbgr.mr_n62952128)
print v(xbgr.mr_n62952240)
print v(xbgr.mr_n62952560)
print v(xbgr.mr_n62952672)
print v(xbgr.mr_n62952992)
print v(xbgr.mr_n62953104)
print v(xbgr.mr_n62953424)
print v(xbgr.mr_n62953536)
print v(xbgr.mr_n62953856)
print v(xbgr.mr_n62953968)
print v(xbgr.mr_n62954288)
print v(xbgr.mr_n62954400)
print v(xbgr.mr_n62954720)
print v(xbgr.mr_n62954832)
print v(xbgr.mr_n62956016)
print v(xbgr.mr_n62956560)
print v(xbgr.mr_n62956992)
print v(xbgr.mr_n62957424)
print v(xbgr.mr_n62958176)
print v(xbgr.mr_n62958288)
print v(xbgr.mr_n62958608)
print v(xbgr.mr_n62958720)
print v(xbgr.mr_n62959040)
print v(xbgr.mr_n62959152)
print v(xbgr.mr_n62959472)
print v(xbgr.mr_n62959584)
print v(xbgr.mr_n62959904)
print v(xbgr.mr_n62960016)
print v(xbgr.mr_n62960336)
print v(xbgr.mr_n62960448)
print v(xbgr.mr_n62960880)
print v(xbgr.mr_n62961200)
print v(xbgr.mr_n62961312)
print v(xbgr.mr_n62961632)
print v(xbgr.mr_n62961744)
print v(xbgr.mr_n62962176)
print v(xbgr.mr_n62962496)
print v(xbgr.mr_n62962608)
print v(xbgr.mr_n62962928)
print v(xbgr.mr_n62963040)
print v(xbgr.mr_n62963360)
print v(xbgr.mr_n62963472)
print v(xbgr.mr_n62963792)
print v(xbgr.mr_n62963904)
print v(xbgr.mr_n62964224)
print v(xbgr.mr_n62964336)
print v(xbgr.mr_n62964656)
print v(xbgr.mr_n62964768)
print v(xbgr.mr_n62965088)
print v(xbgr.mr_n62965952)
print v(xbgr.mr_n62966496)
print v(xbgr.mr_n62966816)
print v(xbgr.mr_n62966928)
print v(xbgr.mr_n62967360)
print v(xbgr.mr_n62967680)
print v(xbgr.mr_n62967792)
print v(xbgr.mr_n62968544)
print v(xbgr.mr_n62969408)
print v(xbgr.mr_n62969520)
print v(xbgr.mr_n62969840)
print v(xbgr.mr_n62969952)
print v(xbgr.mr_n62970272)
print v(xbgr.mr_n62970384)
print v(xbgr.mr_n62970704)
print v(xbgr.mr_n62971136)
print v(xbgr.mr_n62972000)
print v(xbgr.mr_n62973296)
print v(xbgr.mr_n62974272)
print v(xbgr.mr_n62974592)
print v(xbgr.mr_n62974704)
print v(xbgr.mr_n62975024)
print v(xbgr.mr_n62975136)
print v(xbgr.mr_n62975456)
print v(xbgr.mr_n62976320)
print v(xbgr.mr_n62976432)
print v(xbgr.mr_n62976752)
print v(xbgr.mr_n62976864)
print v(xbgr.mr_n62977184)
print v(xbgr.mr_n62977296)
print v(xbgr.mr_n62977616)
print v(xbgr.mr_n62977728)
print v(xbgr.mr_n62978048)
print v(xbgr.mr_n62978160)
print v(xbgr.mr_n62978480)
print v(xbgr.mr_n62979024)
print v(xbgr.mr_n62979344)
print v(xbgr.mr_n62980640)
print v(xbgr.mr_n62981504)
print v(xbgr.mr_n62982048)
print v(xbgr.mr_n62982480)
print v(xbgr.mr_n62983232)
print v(xbgr.mr_n62983344)
print v(xbgr.mr_n62983664)
print v(xbgr.mr_n62983776)
print v(xbgr.mr_n62984096)
print v(xbgr.mr_n62984208)
print v(xbgr.mr_n62984528)
print v(xbgr.mr_n62984640)
print v(xbgr.mr_n62984960)
print v(xbgr.mr_n62985072)
print v(xbgr.mr_n62985392)
print v(xbgr.mr_n62985504)
print v(xbgr.mr_n62985936)
print v(xbgr.mr_n62986256)
print v(xbgr.mr_n62986368)
print v(xbgr.mr_n62986688)
print v(xbgr.mr_n62986800)
print v(xbgr.mr_n62987120)
print v(xbgr.mr_n62987232)
print v(xbgr.mr_n62987552)
print v(xbgr.mr_n62987664)
print v(xbgr.mr_n62987984)
print v(xbgr.mr_n62988096)
print v(xbgr.mr_n62988416)
print v(xbgr.mr_n62988528)
print v(xbgr.mr_n62988848)
print v(xbgr.mr_n62988960)
print v(xbgr.mr_n62989280)
print v(xbgr.mr_n62989392)
print v(xbgr.mr_n62989824)
print v(xbgr.mr_n62990256)
print v(xbgr.mr_n62990688)
print v(xbgr.mr_n62991008)
print v(xbgr.mr_n62991120)
print v(xbgr.mr_n62991440)
print v(xbgr.mr_n62991552)
print v(xbgr.mr_n62991872)
print v(xbgr.mr_n62991984)
print v(xbgr.mr_n62992304)
print v(xbgr.mr_n62992416)
print v(xbgr.mr_n62992736)
print v(xbgr.mr_n62992848)
print v(xbgr.mr_n62993280)
print v(xbgr.mr_n62993600)
print v(xbgr.mr_n62994464)
print v(xbgr.mr_n62995328)
print v(xbgr.mr_n62995440)
print v(xbgr.mr_n62995760)
print v(xbgr.mr_n62995872)
print v(xbgr.mr_n62996192)
print v(xbgr.mr_n62996304)
print v(xbgr.mr_n62996624)
print v(xbgr.mr_n62996736)
print v(xbgr.mr_n62997056)
print v(xbgr.mr_n62998032)
print v(xbgr.mr_n62998352)
print v(xbgr.mr_n62998464)
print v(xbgr.mr_n62998784)
print v(xbgr.mr_n62998896)
print v(xbgr.mr_n62999216)
print v(xbgr.mr_n62999328)
print v(xbgr.mr_n62999648)
print v(xbgr.mr_n62999760)
print v(xbgr.mr_n63000080)
print v(xbgr.mr_n63000192)
print v(xbgr.mr_n63000512)
print v(xbgr.mr_n63001376)
print v(xbgr.mr_n63002240)
print v(xbgr.mr_n63003104)
print v(xbgr.mr_n63003968)
print v(xbgr.mr_n63004080)
print v(xbgr.mr_n63004400)
print v(xbgr.mr_n63004512)
print v(xbgr.mr_n63004832)
print v(xbgr.mr_n63005808)
print v(xbgr.mr_n63006240)
print v(xbgr.mr_n63006560)
print v(xbgr.mr_n63007424)
print v(xbgr.mr_n63008288)
print v(xbgr.mr_n63009152)
print v(xbgr.mr_n63010016)
print v(xbgr.mr_n63010128)
print v(xbgr.mr_n63010560)
print v(xbgr.mr_n63010880)
print v(xbgr.mr_n63010992)
print v(xbgr.mr_n63011312)
print v(xbgr.mr_n63011424)
print v(xbgr.mr_n63011744)
print v(xbgr.mr_n63011856)
print v(xbgr.mr_n63012288)
print v(xbgr.mr_n63012608)
print v(xbgr.mr_n63012720)
print v(xbgr.mr_n63013152)
print v(xbgr.mr_n63013472)
print v(xbgr.mr_n63013584)
print v(xbgr.mr_n63013904)
print v(xbgr.mr_n63014016)
print v(xbgr.mr_n63014336)
print v(xbgr.mr_n63014448)
print v(xbgr.mr_n63014768)
print v(xbgr.mr_n63014880)
print v(xbgr.mr_n63015200)
print v(xbgr.mr_n63015312)
print v(xbgr.mr_n63015632)
print v(xbgr.mr_n63015744)
print v(xbgr.mr_n63016176)
print v(xbgr.mr_n63016496)
print v(xbgr.mr_n63017360)
print v(xbgr.mr_n63017904)
print v(xbgr.mr_n63018224)
print v(xbgr.mr_n63018336)
print v(xbgr.mr_n63018656)
print v(xbgr.mr_n63018768)
print v(xbgr.mr_n63019088)
print v(xbgr.mr_n63019200)
print v(xbgr.mr_n63019520)
print v(xbgr.mr_n63019632)
print v(xbgr.mr_n63019952)
print v(xbgr.mr_n63020064)
print v(xbgr.mr_n63020384)
print v(xbgr.mr_n63020496)
print v(xbgr.mr_n63020928)
print v(xbgr.mr_n63021248)
print v(xbgr.mr_n63022112)
print v(xbgr.mr_n63022544)
print v(xbgr.mr_n63023408)
print v(xbgr.mr_n63024272)
print v(xbgr.mr_n63025680)
print v(xbgr.mr_n63026544)
print v(xbgr.mr_n63026976)
print v(xbgr.mr_n63027296)
print v(xbgr.mr_n63028160)
print v(xbgr.mr_n63028272)
print v(xbgr.mr_n63028592)
print v(xbgr.mr_n63028704)
print v(xbgr.mr_n63029024)
print v(xbgr.mr_n63029136)
print v(xbgr.mr_n63029456)
print v(xbgr.mr_n63029568)
print v(xbgr.mr_n63029888)
print v(xbgr.mr_n63030000)
print v(xbgr.mr_n63030320)
print v(xbgr.mr_n63030432)
print v(xbgr.mr_n63030752)
print v(xbgr.mr_n63030864)
print v(xbgr.mr_n63031184)
print v(xbgr.mr_n63032048)
print v(xbgr.mr_n63033024)
print v(xbgr.mr_n63033456)
print v(xbgr.mr_n63033888)
print v(xbgr.mr_n63034208)
print v(xbgr.mr_n63034320)
print v(xbgr.mr_n63034640)
print v(xbgr.mr_n63034752)
print v(xbgr.mr_n63035072)
print v(xbgr.mr_n63035936)
print v(xbgr.mr_n63036800)
print v(xbgr.mr_n63037664)
print v(xbgr.mr_n63037776)
print v(xbgr.mr_n63038096)
print v(xbgr.mr_n63038208)
print v(xbgr.mr_n63038528)
print v(xbgr.mr_n63039392)
print v(xbgr.mr_n63040256)
print v(xbgr.mr_n63041120)
print v(xbgr.mr_n63041232)
print v(xbgr.mr_n63041552)
print v(xbgr.mr_n63041664)
print v(xbgr.mr_n63041984)
print v(xbgr.mr_n63042096)
print v(xbgr.mr_n63042416)
print v(xbgr.mr_n63042528)
print v(xbgr.mr_n63042848)
print v(xbgr.mr_n63043712)
print v(xbgr.mr_n63044576)
print v(xbgr.mr_n63044688)
print v(xbgr.mr_n63045008)
print v(xbgr.mr_n63045120)
print v(xbgr.mr_n63045440)
print v(xbgr.mr_n63045552)
print v(xbgr.mr_n63045872)
print v(xbgr.mr_n63045984)
print v(xbgr.mr_n63046304)
print v(xbgr.mr_n63046416)
print v(xbgr.mr_n63046848)
print v(xbgr.mr_n63047168)
print v(xbgr.mr_n63047280)
print v(xbgr.mr_n63047600)
print v(xbgr.mr_n63047712)
print v(xbgr.mr_n63048032)
print v(xbgr.mr_n63048144)
print v(xbgr.mr_n63048464)
print v(xbgr.mr_n63048576)
print v(xbgr.mr_n63048896)
print v(xbgr.mr_n63049760)
print v(xbgr.mr_n63049872)
print v(xbgr.mr_n63050304)
print v(xbgr.mr_n63050624)
print v(xbgr.mr_n63050736)
print v(xbgr.mr_n63051056)
print v(xbgr.mr_n63051168)
print v(xbgr.mr_n63051488)
print v(xbgr.mr_n63051600)
print v(xbgr.mr_n63051920)
print v(xbgr.mr_n63052032)
print v(xbgr.mr_n63052352)
print v(xbgr.mr_n63052464)
print v(xbgr.mr_n63052784)
print v(xbgr.mr_n63052896)
print v(xbgr.mr_n63053216)
print v(xbgr.mr_n63053648)
print v(xbgr.mr_n63053760)
print v(xbgr.mr_n63054080)
print v(xbgr.mr_n63054624)
print v(xbgr.mr_n63054944)
print v(xbgr.mr_n63055056)
print v(xbgr.mr_n63055488)
print v(xbgr.mr_n63055920)
print v(xbgr.mr_n63056352)
print v(xbgr.mr_n63056784)
print v(xbgr.mr_n63057216)
print v(xbgr.mr_n63057536)
print v(xbgr.mr_n63057648)
print v(xbgr.mr_n63058080)
print v(xbgr.mr_n63058400)
print v(xbgr.mr_n63058512)
print v(xbgr.mr_n63058944)
print v(xbgr.mr_n63059264)
print v(xbgr.mr_n63060128)
print v(xbgr.mr_n63061424)
print v(xbgr.mr_n63061968)
print v(xbgr.mr_n63062288)
print v(xbgr.mr_n63062832)
print v(xbgr.mr_n63063152)
print v(xbgr.mr_n63063264)
print v(xbgr.mr_n63064016)
print v(xbgr.mr_n63064448)
print v(xbgr.mr_n63065312)
print v(xbgr.mr_n63066176)
print v(xbgr.mr_n63067472)
print v(xbgr.mr_n63068336)
print v(xbgr.mr_n63068768)
print v(xbgr.mr_n63068880)
print v(xbgr.mr_n63069632)
print v(xbgr.mr_n63069744)
print v(xbgr.mr_n63070064)
print v(xbgr.mr_n63070176)
print v(xbgr.mr_n63070496)
print v(xbgr.mr_n63070608)
print v(xbgr.mr_n63071360)
print v(xbgr.mr_n63072656)
print v(xbgr.mr_n63073520)
print v(xbgr.mr_n63074384)
print v(xbgr.mr_n63074816)
print v(xbgr.mr_n63074928)
print v(xbgr.mr_n63075248)
print v(xbgr.mr_n63075360)
print v(xbgr.mr_n63075680)
print v(xbgr.mr_n63075792)
print v(xbgr.mr_n63076112)
print v(xbgr.mr_n63076224)
print v(xbgr.mr_n63076976)
print v(xbgr.mr_n63077088)
print v(xbgr.mr_n63077408)
print v(xbgr.mr_n63077520)
print v(xbgr.mr_n63077840)
print v(xbgr.mr_n63077952)
print v(xbgr.mr_n63078272)
print v(xbgr.mr_n63079136)
print v(xbgr.mr_n63079248)
print v(xbgr.mr_n63079568)
print v(xbgr.mr_n63079680)
print v(xbgr.mr_n63080112)
print v(xbgr.mr_n63080432)
print v(xbgr.mr_n63080544)
print v(xbgr.mr_n63080864)
print v(xbgr.mr_n63080976)
print v(xbgr.mr_n63081296)
print v(xbgr.mr_n63081408)
print v(xbgr.mr_n63081840)
print v(xbgr.mr_n63082272)
print v(xbgr.mr_n63082592)
print v(xbgr.mr_n63082704)
print v(xbgr.mr_n63083024)
print v(xbgr.mr_n63083136)
print v(xbgr.mr_n63083456)
print v(xbgr.mr_n63083568)
print v(xbgr.mr_n63084000)
print v(xbgr.mr_n63084320)
print v(xbgr.mr_n63084432)
print v(xbgr.mr_n63084864)
print v(xbgr.mr_n63085184)
print v(xbgr.mr_n63085296)
print v(xbgr.mr_n63085616)
print v(xbgr.mr_n63085728)
print v(xbgr.mr_n63086048)
print v(xbgr.mr_n63086160)
print v(xbgr.mr_n63086480)
print v(xbgr.mr_n63086592)
print v(xbgr.mr_n63086912)
print v(xbgr.mr_n63087776)
print v(xbgr.mr_n63088640)
print v(xbgr.mr_n63088752)
print v(xbgr.mr_n63089072)
print v(xbgr.mr_n63089616)
print v(xbgr.mr_n63089936)
print v(xbgr.mr_n63090368)
print v(xbgr.mr_n63091664)
print v(xbgr.mr_n63092960)
print v(xbgr.mr_n63093072)
print v(xbgr.mr_n63093392)
print v(xbgr.mr_n63093504)
print v(xbgr.mr_n63093824)
print v(xbgr.mr_n63093936)
print v(xbgr.mr_n63094256)
print v(xbgr.mr_n63094368)
print v(xbgr.mr_n63094688)
print v(xbgr.mr_n63094800)
print v(xbgr.mr_n63095120)
print v(xbgr.mr_n63095232)
print v(xbgr.mr_n63095552)
print v(xbgr.mr_n63095664)
print v(xbgr.mr_n63096096)
print v(xbgr.mr_n63096416)
print v(xbgr.mr_n63097280)
print v(xbgr.mr_n63097392)
print v(xbgr.mr_n63097712)
print v(xbgr.mr_n63097824)
print v(xbgr.mr_n63098144)
print v(xbgr.mr_n63098256)
print v(xbgr.mr_n63098576)
print v(xbgr.mr_n63098688)
print v(xbgr.mr_n63099008)
print v(xbgr.mr_n63099872)
print v(xbgr.mr_n63100736)
print v(xbgr.mr_n63101600)
print v(xbgr.mr_n63102464)
print v(xbgr.mr_n63103328)
print v(xbgr.mr_n63103440)
print v(xbgr.mr_n63103760)
print v(xbgr.mr_n63103872)
print v(xbgr.mr_n63104192)
print v(xbgr.mr_n63104304)
print v(xbgr.mr_n63104624)
print v(xbgr.mr_n63104736)
print v(xbgr.mr_n63105056)
print v(xbgr.mr_n63105168)
print v(xbgr.mr_n63105488)
print v(xbgr.mr_n63105600)
print v(xbgr.mr_n63105920)
print v(xbgr.mr_n63106032)
print v(xbgr.mr_n63106352)
print v(xbgr.mr_n63106464)
print v(xbgr.mr_n63106784)
print v(xbgr.mr_n63106896)
print v(xbgr.mr_n63107216)
print v(xbgr.mr_n63107328)
print v(xbgr.mr_n63107760)
print v(xbgr.mr_n63108080)
print v(xbgr.mr_n63108192)
print v(xbgr.mr_n63108512)
print v(xbgr.mr_n63108624)
print v(xbgr.mr_n63109056)
print v(xbgr.mr_n63109376)
print v(xbgr.mr_n63109488)
print v(xbgr.mr_n63109920)
print v(xbgr.mr_n63110240)
print v(xbgr.mr_n63110352)
print v(xbgr.mr_n63110784)
print v(xbgr.mr_n63111216)
print v(xbgr.mr_n63111536)
print v(xbgr.mr_n63111648)
print v(xbgr.mr_n63112080)
print v(xbgr.mr_n63112400)
print v(xbgr.mr_n63112512)
print v(xbgr.mr_n63112832)
print v(xbgr.mr_n63112944)
print v(xbgr.mr_n63113264)
print v(xbgr.mr_n63113376)
print v(xbgr.mr_n63113696)
print v(xbgr.mr_n63113808)
print v(xbgr.mr_n63114128)
print v(xbgr.mr_n63114240)
print v(xbgr.mr_n63114560)
print v(xbgr.mr_n63114672)
print v(xbgr.mr_n63114992)
print v(xbgr.mr_n63115104)
print v(xbgr.mr_n63115424)
print v(xbgr.mr_n63115536)
print v(xbgr.mr_n63115856)
print v(xbgr.mr_n63116720)
print v(xbgr.mr_n63116832)
print v(xbgr.mr_n63117152)
print v(xbgr.mr_n63117264)
print v(xbgr.mr_n63117584)
print v(xbgr.mr_n63118448)
print v(xbgr.mr_n63119312)
print v(xbgr.mr_n63120176)
print v(xbgr.mr_n63121040)
print v(xbgr.mr_n63121904)
print v(xbgr.mr_n63122016)
print v(xbgr.mr_n63122336)
print v(xbgr.mr_n63122448)
print v(xbgr.mr_n63122768)
print v(xbgr.mr_n63122880)
print v(xbgr.mr_n63123200)
print v(xbgr.mr_n63124064)
print v(xbgr.mr_n63124928)
print v(xbgr.mr_n63125792)
print v(xbgr.mr_n63126656)
print v(xbgr.mr_n63127520)
print v(xbgr.mr_n63128384)
print v(xbgr.mr_n63129248)
print v(xbgr.mr_n63129360)
print v(xbgr.mr_n63129680)
print v(xbgr.mr_n63129792)
print v(xbgr.mr_n63130224)
print v(xbgr.mr_n63130544)
print v(xbgr.mr_n63131408)
print v(xbgr.mr_n63131952)
print v(xbgr.mr_n63132384)
print v(xbgr.mr_n63132816)
print v(xbgr.mr_n63133568)
print v(xbgr.mr_n63134432)
print v(xbgr.mr_n63135296)
print v(xbgr.mr_n63135408)
print v(xbgr.mr_n63135728)
print v(xbgr.mr_n63135840)
print v(xbgr.mr_n63136272)
print v(xbgr.mr_n63136704)
print v(xbgr.mr_n63137024)
print v(xbgr.mr_n63137888)
print v(xbgr.mr_n63138000)
print v(xbgr.mr_n63138432)
print v(xbgr.mr_n63138752)
print v(xbgr.mr_n63138864)
print v(xbgr.mr_n63139296)
print v(xbgr.mr_n63139616)
print v(xbgr.mr_n63140480)
print v(xbgr.mr_n63140592)
print v(xbgr.mr_n63140912)
print v(xbgr.mr_n63141776)
print v(xbgr.mr_n63142640)
print v(xbgr.mr_n63142752)
print v(xbgr.mr_n63143072)
print v(xbgr.mr_n63143184)
print v(xbgr.mr_n63143504)
print v(xbgr.mr_n63144368)
print v(xbgr.mr_n63144800)
print v(xbgr.mr_n63144912)
print v(xbgr.mr_n63145344)
print v(xbgr.mr_n63145664)
print v(xbgr.mr_n63145776)
print v(xbgr.mr_n63146208)
print v(xbgr.mr_n63146960)
print v(xbgr.mr_n63147072)
print v(xbgr.mr_n63147392)
print v(xbgr.mr_n63147504)
print v(xbgr.mr_n63147824)
print v(xbgr.mr_n63147936)
print v(xbgr.mr_n63148256)
print v(xbgr.mr_n63148688)
print v(xbgr.mr_n63148800)
print v(xbgr.mr_n63149552)
print v(xbgr.mr_n63149984)
print v(xbgr.mr_n63150096)
print v(xbgr.mr_n63150960)
print v(xbgr.mr_n63151280)
print v(xbgr.mr_n63151392)
print v(xbgr.mr_n63151712)
print v(xbgr.mr_n63152576)
print v(xbgr.mr_n63153440)
print v(xbgr.mr_n63154304)
print v(xbgr.mr_n63155168)
print v(xbgr.mr_n63155280)
print v(xbgr.mr_n63155600)
print v(xbgr.mr_n63155712)
print v(xbgr.mr_n63156032)
print v(xbgr.mr_n63156144)
print v(xbgr.mr_n63156464)
print v(xbgr.mr_n63156576)
print v(xbgr.mr_n63156896)
print v(xbgr.mr_n63157008)
print v(xbgr.mr_n63157328)
print v(xbgr.mr_n63157440)
print v(xbgr.mr_n63157760)
print v(xbgr.mr_n63157872)
print v(xbgr.mr_n63158192)
print v(xbgr.mr_n63158304)
print v(xbgr.mr_n63158624)
print v(xbgr.mr_n63158736)
print v(xbgr.mr_n63159056)
print v(xbgr.mr_n63159168)
print v(xbgr.mr_n63159600)
print v(xbgr.mr_n63160032)
print v(xbgr.mr_n63160464)
print v(xbgr.mr_n63160784)
print v(xbgr.mr_n63160896)
print v(xbgr.mr_n63161216)
print v(xbgr.mr_n63162080)
print v(xbgr.mr_n63162192)
print v(xbgr.mr_n63162512)
print v(xbgr.mr_n63162624)
print v(xbgr.mr_n63162944)
print v(xbgr.mr_n63163056)
print v(xbgr.mr_n63163488)
print v(xbgr.mr_n63163808)
print v(xbgr.mr_n63163920)
print v(xbgr.mr_n63164240)
print v(xbgr.mr_n63164352)
print v(xbgr.mr_n63164784)
print v(xbgr.mr_n63165104)
print v(xbgr.mr_n63165536)
print v(xbgr.mr_n63165648)
print v(xbgr.mr_n63165968)
print v(xbgr.mr_n63166080)
print v(xbgr.mr_n63166400)
print v(xbgr.mr_n63166512)
print v(xbgr.mr_n63166832)
print v(xbgr.mr_n63166944)
print v(xbgr.mr_n63167376)
print v(xbgr.mr_n63167696)
print v(xbgr.mr_n63167808)
print v(xbgr.mr_n63168128)
print v(xbgr.mr_n63168240)
print v(xbgr.mr_n63168560)
print v(xbgr.mr_n63168672)
print v(xbgr.mr_n63168992)
print v(xbgr.mr_n63169104)
print v(xbgr.mr_n63169424)
print v(xbgr.mr_n63169536)
print v(xbgr.mr_n63169856)
print v(xbgr.mr_n63169968)
print v(xbgr.mr_n63170288)
print v(xbgr.mr_n63170400)
print v(xbgr.mr_n63171152)
print v(xbgr.mr_n63171584)
print v(xbgr.mr_n63172448)
print v(xbgr.mr_n63172560)
print v(xbgr.mr_n63172880)
print v(xbgr.mr_n63173424)
print v(xbgr.mr_n63173856)
print v(xbgr.mr_n63174288)
print v(xbgr.mr_n63174608)
print v(xbgr.mr_n63175040)
print v(xbgr.mr_n63175904)
print v(xbgr.mr_n63178064)
print v(xbgr.mr_n63178928)
print v(xbgr.mr_n63179040)
print v(xbgr.mr_n63179360)
print v(xbgr.mr_n63180224)
print v(xbgr.mr_n63181088)
print v(xbgr.mr_n63181200)
print v(xbgr.mr_n63181520)
print v(xbgr.mr_n63181632)
print v(xbgr.mr_n63181952)
print v(xbgr.mr_n63182064)
print v(xbgr.mr_n63182384)
print v(xbgr.mr_n63182496)
print v(xbgr.mr_n63182816)
print v(xbgr.mr_n63183680)
print v(xbgr.mr_n63184544)
print v(xbgr.mr_n63184656)
print v(xbgr.mr_n63184976)
print v(xbgr.mr_n63185088)
print v(xbgr.mr_n63185408)
print v(xbgr.mr_n63185520)
print v(xbgr.mr_n63185840)
print v(xbgr.mr_n63185952)
print v(xbgr.mr_n63186272)
print v(xbgr.mr_n63186384)
print v(xbgr.mr_n63186704)
print v(xbgr.mr_n63186816)
print v(xbgr.mr_n63187136)
print v(xbgr.mr_n63187248)
print v(xbgr.mr_n63187680)
print v(xbgr.mr_n63188000)
print v(xbgr.mr_n63188112)
print v(xbgr.mr_n63188544)
print v(xbgr.mr_n63188864)
print v(xbgr.mr_n63189408)
print v(xbgr.mr_n63190272)
print v(xbgr.mr_n63190592)
print v(xbgr.mr_n63190704)
print v(xbgr.mr_n63191888)
print v(xbgr.mr_n63192000)
print v(xbgr.mr_n63192320)
print v(xbgr.mr_n63192432)
print v(xbgr.mr_n63192752)
print v(xbgr.mr_n63192864)
print v(xbgr.mr_n63193184)
print v(xbgr.mr_n63193296)
print v(xbgr.mr_n63193616)
print v(xbgr.mr_n63194480)
print v(xbgr.mr_n63195344)
print v(xbgr.mr_n63195456)
print v(xbgr.mr_n63195888)
print v(xbgr.mr_n63196320)
print v(xbgr.mr_n63196752)
print v(xbgr.mr_n63197072)
print v(xbgr.mr_n63197184)
print v(xbgr.mr_n63197504)
print v(xbgr.mr_n63197616)
print v(xbgr.mr_n63197936)
print v(xbgr.mr_n63198048)
print v(xbgr.mr_n63198368)
print v(xbgr.mr_n63198480)
print v(xbgr.mr_n63198800)
print v(xbgr.mr_n63198912)
print v(xbgr.mr_n63199232)
print v(xbgr.mr_n63199344)
print v(xbgr.mr_n63199664)
print v(xbgr.mr_n63200528)
print v(xbgr.mr_n63200640)
print v(xbgr.mr_n63200960)
print v(xbgr.mr_n63201072)
print v(xbgr.mr_n63201392)
print v(xbgr.mr_n63201504)
print v(xbgr.mr_n63201824)
print v(xbgr.mr_n63201936)
print v(xbgr.mr_n63202256)
print v(xbgr.mr_n63202800)
print v(xbgr.mr_n63203552)
print v(xbgr.mr_n63204416)
print v(xbgr.mr_n63205280)
print v(xbgr.mr_n63206144)
print v(xbgr.mr_n63207008)
print v(xbgr.mr_n63207872)
print v(xbgr.mr_n63207984)
print v(xbgr.mr_n63208304)
print v(xbgr.mr_n63208416)
print v(xbgr.mr_n63208736)
print v(xbgr.mr_n63208848)
print v(xbgr.mr_n63209168)
print v(xbgr.mr_n63209280)
print v(xbgr.mr_n63209600)
print v(xbgr.mr_n63209712)
print v(xbgr.mr_n63210032)
print v(xbgr.mr_n63210144)
print v(xbgr.mr_n63210464)
print v(xbgr.mr_n63211328)
print v(xbgr.mr_n63212192)
print v(xbgr.mr_n63213056)
print v(xbgr.mr_n63213920)
print v(xbgr.mr_n63214784)
print v(xbgr.mr_n63215648)
print v(xbgr.mr_n63216512)
print v(xbgr.mr_n63216624)
print v(xbgr.mr_n63216944)
print v(xbgr.mr_n63217056)
print v(xbgr.mr_n63217376)
print v(xbgr.mr_n63217488)
print v(xbgr.mr_n63217808)
print v(xbgr.mr_n63217920)
print v(xbgr.mr_n63218240)
print v(xbgr.mr_n63218352)
print v(xbgr.mr_n63218672)
print v(xbgr.mr_n63218784)
print v(xbgr.mr_n63219104)
print v(xbgr.mr_n63219216)
print v(xbgr.mr_n63219648)
print v(xbgr.mr_n63219968)
print v(xbgr.mr_n63220080)
print v(xbgr.mr_n63220512)
print v(xbgr.mr_n63220832)
print v(xbgr.mr_n63220944)
print v(xbgr.mr_n63221376)
print v(xbgr.mr_n63221696)
print v(xbgr.mr_n63222560)
print v(xbgr.mr_n63223424)
print v(xbgr.mr_n63224288)
print v(xbgr.mr_n63225152)
print v(xbgr.mr_n63226016)
print v(xbgr.mr_n63226880)
print v(xbgr.mr_n63226992)
print v(xbgr.mr_n63227312)
print v(xbgr.mr_n63227424)
print v(xbgr.mr_n63227744)
print v(xbgr.mr_n63227856)
print v(xbgr.mr_n63228176)
print v(xbgr.mr_n63228288)
print v(xbgr.mr_n63228608)
print v(xbgr.mr_n63229472)
print v(xbgr.mr_n63230336)
print v(xbgr.mr_n63231200)
print v(xbgr.mr_n63231312)
print v(xbgr.mr_n63231744)
print v(xbgr.mr_n63232064)
print v(xbgr.mr_n63232176)
print v(xbgr.mr_n63232496)
print v(xbgr.mr_n63232608)
print v(xbgr.mr_n63232928)
print v(xbgr.mr_n63233040)
print v(xbgr.mr_n63233360)
print v(xbgr.mr_n63233472)
print v(xbgr.mr_n63233792)
print v(xbgr.mr_n63233904)
print v(xbgr.mr_n63234336)
print v(xbgr.mr_n63234656)
print v(xbgr.mr_n63234768)
print v(xbgr.mr_n63235200)
print v(xbgr.mr_n63235520)
print v(xbgr.mr_n63235632)
print v(xbgr.mr_n63235952)
print v(xbgr.mr_n63236064)
print v(xbgr.mr_n63236496)
print v(xbgr.mr_n63236928)
print v(xbgr.mr_n63237248)
print v(xbgr.mr_n63237360)
print v(xbgr.mr_n63237792)
print v(xbgr.mr_n63238112)
print v(xbgr.mr_n63238224)
print v(xbgr.mr_n63238656)
print v(xbgr.mr_n63238976)
print v(xbgr.mr_n63239840)
print v(xbgr.mr_n63240704)
print v(xbgr.mr_n63241568)
print v(xbgr.mr_n63242432)
print v(xbgr.mr_n63242544)
print v(xbgr.mr_n63242864)
print v(xbgr.mr_n63242976)
print v(xbgr.mr_n63243296)
print v(xbgr.mr_n63243408)
print v(xbgr.mr_n63243728)
print v(xbgr.mr_n63243840)
print v(xbgr.mr_n63244160)
print v(xbgr.mr_n63245024)
print v(xbgr.mr_n63245888)
print v(xbgr.mr_n63246752)
print v(xbgr.mr_n63247616)
print v(xbgr.mr_n63248480)
print v(xbgr.mr_n63249344)
print v(xbgr.mr_n63250208)
print v(xbgr.mr_n63251072)
print v(xbgr.mr_n63251184)
print v(xbgr.mr_n63251504)
print v(xbgr.mr_n63251616)
print v(xbgr.mr_n63251936)
print v(xbgr.mr_n63252048)
print v(xbgr.mr_n63252368)
print v(xbgr.mr_n63252480)
print v(xbgr.mr_n63252800)
print v(xbgr.mr_n63252912)
print v(xbgr.mr_n63253232)
print v(xbgr.mr_n63253344)
print v(xbgr.mr_n63253664)
print v(xbgr.mr_n63253776)
print v(xbgr.mr_n63254096)
print v(xbgr.mr_n63254208)
print v(xbgr.mr_n63254528)
print v(xbgr.mr_n63254640)
print v(xbgr.mr_n63254960)
print v(xbgr.mr_n63255072)
print v(xbgr.mr_n63255504)
print v(xbgr.mr_n63255824)
print v(xbgr.mr_n63255936)
print v(xbgr.mr_n63256256)
print v(xbgr.mr_n63256368)
print v(xbgr.mr_n63256688)
print v(xbgr.mr_n63256800)
print v(xbgr.mr_n63257120)
print v(xbgr.mr_n63257232)
print v(xbgr.mr_n63257552)
print v(xbgr.mr_n63257664)
print v(xbgr.mr_n63258096)
print v(xbgr.mr_n63258416)
print v(xbgr.mr_n63258528)
print v(xbgr.mr_n63258960)
print v(xbgr.mr_n63259280)
print v(xbgr.mr_n63259392)
print v(xbgr.mr_n63259712)
print v(xbgr.mr_n63260576)
print v(xbgr.mr_n63261440)
print v(xbgr.mr_n63261984)
print v(xbgr.mr_n63262736)
print v(xbgr.mr_n63263168)
print v(xbgr.mr_n63263280)
print v(xbgr.mr_n63264032)
print v(xbgr.mr_n63264144)
print v(xbgr.mr_n63264576)
print v(xbgr.mr_n63265008)
print v(xbgr.mr_n63265328)
print v(xbgr.mr_n63266192)
print v(xbgr.mr_n63266624)
print v(xbgr.mr_n63267488)
print v(xbgr.mr_n63267600)
print v(xbgr.mr_n63268352)
print v(xbgr.mr_n63269648)
print v(xbgr.mr_n63270512)
print v(xbgr.mr_n63270624)
print v(xbgr.mr_n63270944)
print v(xbgr.mr_n63271056)
print v(xbgr.mr_n63271376)
print v(xbgr.mr_n63271488)
print v(xbgr.mr_n63271808)
print v(xbgr.mr_n63271920)
print v(xbgr.mr_n63272240)
print v(xbgr.mr_n63273104)
print v(xbgr.mr_n63273968)
print v(xbgr.mr_n63274832)
print v(xbgr.mr_n63274944)
print v(xbgr.mr_n63275264)
print v(xbgr.mr_n63275376)
print v(xbgr.mr_n63275696)
print v(xbgr.mr_n63276560)
print v(xbgr.mr_n63276672)
print v(xbgr.mr_n63276992)
print v(xbgr.mr_n63277104)
print v(xbgr.mr_n63277424)
print v(xbgr.mr_n63277536)
print v(xbgr.mr_n63277856)
print v(xbgr.mr_n63277968)
print v(xbgr.mr_n63278288)
print v(xbgr.mr_n63279152)
print v(xbgr.mr_n63280016)
print v(xbgr.mr_n63280128)
print v(xbgr.mr_n63280448)
print v(xbgr.mr_n63280560)
print v(xbgr.mr_n63280880)
print v(xbgr.mr_n63280992)
print v(xbgr.mr_n63281312)
print v(xbgr.mr_n63281424)
print v(xbgr.mr_n63281744)
print v(xbgr.mr_n63281856)
print v(xbgr.mr_n63282176)
print v(xbgr.mr_n63282288)
print v(xbgr.mr_n63283040)
print v(xbgr.mr_n63283904)
print v(xbgr.mr_n63284768)
print v(xbgr.mr_n63284880)
print v(xbgr.mr_n63285200)
print v(xbgr.mr_n63285312)
print v(xbgr.mr_n63285632)
print v(xbgr.mr_n63285744)
print v(xbgr.mr_n63286064)
print v(xbgr.mr_n63286176)
print v(xbgr.mr_n63286608)
print v(xbgr.mr_n63286928)
print v(xbgr.mr_n63287040)
print v(xbgr.mr_n63287792)
print v(xbgr.mr_n63288656)
print v(xbgr.mr_n63289520)
print v(xbgr.mr_n63290384)
print v(xbgr.mr_n63290496)
print v(xbgr.mr_n63290816)
print v(xbgr.mr_n63290928)
print v(xbgr.mr_n63291248)
print v(xbgr.mr_n63291360)
print v(xbgr.mr_n63291680)
print v(xbgr.mr_n63291792)
print v(xbgr.mr_n63292112)
print v(xbgr.mr_n63292976)
print v(xbgr.mr_n63294272)
print v(xbgr.mr_n63294384)
print v(xbgr.mr_n63294704)
print v(xbgr.mr_n63294816)
print v(xbgr.mr_n63295248)
print v(xbgr.mr_n63295568)
print v(xbgr.mr_n63295680)
print v(xbgr.mr_n63296112)
print v(xbgr.mr_n63296432)
print v(xbgr.mr_n63296864)
print v(xbgr.mr_n63297728)
print v(xbgr.mr_n63298592)
print v(xbgr.mr_n63298704)
print v(xbgr.mr_n63299024)
print v(xbgr.mr_n63299136)
print v(xbgr.mr_n63299568)
print v(xbgr.mr_n63299888)
print v(xbgr.mr_n63300000)
print v(xbgr.mr_n63300320)
print v(xbgr.mr_n63300432)
print v(xbgr.mr_n63300752)
print v(xbgr.mr_n63300864)
print v(xbgr.mr_n63301184)
print v(xbgr.mr_n63301296)
print v(xbgr.mr_n63301728)
print v(xbgr.mr_n63302160)
print v(xbgr.mr_n63302592)
print v(xbgr.mr_n63303024)
print v(xbgr.mr_n63303344)
print v(xbgr.mr_n63303456)
print v(xbgr.mr_n63303888)
print v(xbgr.mr_n63304208)
print v(xbgr.mr_n63305072)
print v(xbgr.mr_n63305936)
print v(xbgr.mr_n63306368)
print v(xbgr.mr_n63307232)
print v(xbgr.mr_n63307664)
print v(xbgr.mr_n63307776)
print v(xbgr.mr_n63308528)
print v(xbgr.mr_n63309392)
print v(xbgr.mr_n63310256)
print v(xbgr.mr_n63310368)
print v(xbgr.mr_n63310800)
print v(xbgr.mr_n63311120)
print v(xbgr.mr_n63311984)
print v(xbgr.mr_n63312096)
print v(xbgr.mr_n63312416)
print v(xbgr.mr_n63312528)
print v(xbgr.mr_n63312848)
print v(xbgr.mr_n63312960)
print v(xbgr.mr_n63313280)
print v(xbgr.mr_n63313392)
print v(xbgr.mr_n63313712)
print v(xbgr.mr_n63313824)
print v(xbgr.mr_n63314144)
print v(xbgr.mr_n63314256)
print v(xbgr.mr_n63314576)
print v(xbgr.mr_n63314688)
print v(xbgr.mr_n63315008)
print v(xbgr.mr_n63315120)
print v(xbgr.mr_n63315440)
print v(xbgr.mr_n63315552)
print v(xbgr.mr_n63315872)
print v(xbgr.mr_n63315984)
print v(xbgr.mr_n63316736)
print v(xbgr.mr_n63318032)
print v(xbgr.mr_n63318896)
print v(xbgr.mr_n63320192)
print v(xbgr.mr_n63320304)
print v(xbgr.mr_n63320624)
print v(xbgr.mr_n63320736)
print v(xbgr.mr_n63321056)
print v(xbgr.mr_n63321168)
print v(xbgr.mr_n63321488)
print v(xbgr.mr_n63321600)
print v(xbgr.mr_n63322352)
print v(xbgr.mr_n63323216)
print v(xbgr.mr_n63324080)
print v(xbgr.mr_n63324944)
print v(xbgr.mr_n63325056)
print v(xbgr.mr_n63325376)
print v(xbgr.mr_n63325488)
print v(xbgr.mr_n63325808)
print v(xbgr.mr_n63325920)
print v(xbgr.mr_n63326240)
print v(xbgr.mr_n63326352)
print v(xbgr.mr_n63326672)
print v(xbgr.mr_n63326784)
print v(xbgr.mr_n63327104)
print v(xbgr.mr_n63327648)
print v(xbgr.mr_n63328400)
print v(xbgr.mr_n63329264)
print v(xbgr.mr_n63329376)
print v(xbgr.mr_n63329696)
print v(xbgr.mr_n63329808)
print v(xbgr.mr_n63330240)
print v(xbgr.mr_n63330560)
print v(xbgr.mr_n63330672)
print v(xbgr.mr_n63330992)
print v(xbgr.mr_n63331104)
print v(xbgr.mr_n63331424)
print v(xbgr.mr_n63331536)
print v(xbgr.mr_n63331856)
print v(xbgr.mr_n63331968)
print v(xbgr.mr_n63332288)
print v(xbgr.mr_n63332720)
print v(xbgr.mr_n63332832)
print v(xbgr.mr_n63333152)
print v(xbgr.mr_n63333264)
print v(xbgr.mr_n63334016)
print v(xbgr.mr_n63334128)
print v(xbgr.mr_n63334448)
print v(xbgr.mr_n63334560)
print v(xbgr.mr_n63335312)
print v(xbgr.mr_n63336176)
print v(xbgr.mr_n63336288)
print v(xbgr.mr_n63336608)
print v(xbgr.mr_n63337472)
print v(xbgr.mr_n63338016)
print v(xbgr.mr_n63338336)
print v(xbgr.mr_n63338880)
print v(xbgr.mr_n63339312)
print v(xbgr.mr_n63339632)
print v(xbgr.mr_n63339744)
print v(xbgr.mr_n63340496)
print v(xbgr.mr_n63340608)
print v(xbgr.mr_n63340928)
print v(xbgr.mr_n63341040)
print v(xbgr.mr_n63341360)
print v(xbgr.mr_n63342224)
print v(xbgr.mr_n63342656)
print v(xbgr.mr_n63342768)
print v(xbgr.mr_n63343088)
print v(xbgr.mr_n63343200)
print v(xbgr.mr_n63343520)
print v(xbgr.mr_n63343632)
print v(xbgr.mr_n63343952)
print v(xbgr.mr_n63344064)
print v(xbgr.mr_n63344384)
print v(xbgr.mr_n63344496)
print v(xbgr.mr_n63345680)
print v(xbgr.mr_n63345792)
print v(xbgr.mr_n63346112)
print v(xbgr.mr_n63346224)
print v(xbgr.mr_n63346544)
print v(xbgr.mr_n63346656)
print v(xbgr.mr_n63346976)
print v(xbgr.mr_n63347408)
print v(xbgr.mr_n63479792)
print v(xbgr.mr_n63479904)
print v(xbgr.mr_n63480224)
print v(xbgr.mr_n63480336)
print v(xbgr.mr_n63480656)
print v(xbgr.mr_n63480768)
print v(xbgr.mr_n63481088)
print v(xbgr.mr_n63481200)
print v(xbgr.mr_n63481520)
print v(xbgr.mr_n63481632)
print v(xbgr.mr_n63481952)
print v(xbgr.mr_n63482064)
print v(xbgr.mr_n63482384)
print v(xbgr.mr_n63482496)
print v(xbgr.mr_n63482816)
print v(xbgr.mr_n63482928)
print v(xbgr.mr_n63483248)
print v(xbgr.mr_n63483360)
print v(xbgr.mr_n63483680)
print v(xbgr.mr_n63483792)
print v(xbgr.mr_n63484112)
print v(xbgr.mr_n63484224)
print v(xbgr.mr_n63484544)
print v(xbgr.mr_n63484656)
print v(xbgr.mr_n63484976)
print v(xbgr.mr_n63485088)
print v(xbgr.mr_n63485408)
print v(xbgr.mr_n63485520)
print v(xbgr.mr_n63485840)
print v(xbgr.mr_n63485952)
print v(xbgr.mr_n63486272)
print v(xbgr.mr_n63486384)
print v(xbgr.mr_n63486704)
print v(xbgr.mr_n63486816)
print v(xbgr.mr_n63487136)
print v(xbgr.mr_n63487248)
print v(xbgr.mr_n63487568)
print v(xbgr.mr_n63487680)
print v(xbgr.mr_n63488000)
print v(xbgr.mr_n63488112)
print v(xbgr.mr_n63488432)
print v(xbgr.mr_n63488544)
print v(xbgr.mr_n63488864)
print v(xbgr.mr_n63488976)
print v(xbgr.mr_n63489296)
print v(xbgr.mr_n63489408)
print v(xbgr.mr_n63489728)
print v(xbgr.mr_n63489840)
print v(xbgr.mr_n63490160)
print v(xbgr.mr_n63490272)
print v(xbgr.mr_n63490592)
print v(xbgr.mr_n63490704)
print v(xbgr.mr_n63491024)
print v(xbgr.mr_n63491136)
print v(xbgr.mr_n63491456)
print v(xbgr.mr_n63491568)
print v(xbgr.mr_n63491888)
print v(xbgr.mr_n63492000)
print v(xbgr.mr_n63492320)
print v(xbgr.mr_n63492432)
print v(xbgr.mr_n63492752)
print v(xbgr.mr_n63492864)
print v(xbgr.mr_n63493184)
print v(xbgr.mr_n63493296)
print v(xbgr.mr_n63493616)
print v(xbgr.mr_n63493728)
print v(xbgr.mr_n63494048)
print v(xbgr.mr_n63494160)
print v(xbgr.mr_n63494480)
print v(xbgr.mr_n63494592)
print v(xbgr.mr_n63494912)
print v(xbgr.mr_n63495024)
print v(xbgr.mr_n63495344)
print v(xbgr.mr_n63495456)
print v(xbgr.mr_n63495776)
print v(xbgr.mr_n63495888)
print v(xbgr.mr_n63496208)
print v(xbgr.mr_n63496320)
print v(xbgr.mr_n63496640)
print v(xbgr.mr_n63496752)
print v(xbgr.mr_n63497072)
print v(xbgr.mr_n63497184)
print v(xbgr.mr_n63497504)
print v(xbgr.mr_n63497616)
print v(xbgr.mr_n63497936)
print v(xbgr.mr_n63498048)
print v(xbgr.mr_n63498368)
print v(xbgr.mr_n63498480)
print v(xbgr.mr_n63498800)
print v(xbgr.mr_n63498912)
print v(xbgr.mr_n63499232)
print v(xbgr.mr_n63499344)
print v(xbgr.mr_n63499664)
print v(xbgr.mr_n63499776)
print v(xbgr.mr_n63500096)
print v(xbgr.mr_n63500208)
print v(xbgr.mr_n63500528)
print v(xbgr.mr_n63500640)
print v(xbgr.mr_n63500960)
print v(xbgr.mr_n63501072)
print v(xbgr.mr_n63501392)
print v(xbgr.mr_n63501504)
print v(xbgr.mr_n63501824)
print v(xbgr.mr_n63501936)
print v(xbgr.mr_n63502256)
print v(xbgr.mr_n63502368)
print v(xbgr.mr_n63502688)
print v(xbgr.mr_n63502800)
print v(xbgr.mr_n63503120)
print v(xbgr.mr_n63503232)
print v(xbgr.mr_n63503552)
print v(xbgr.mr_n63503664)
print v(xbgr.mr_n63503984)
print v(xbgr.mr_n63504096)
print v(xbgr.mr_n63504416)
print v(xbgr.mr_n63504528)
print v(xbgr.mr_n63504848)
print v(xbgr.mr_n63504960)
print v(xbgr.mr_n63505280)
print v(xbgr.mr_n63505392)
print v(xbgr.mr_n63505712)
print v(xbgr.mr_n63505824)
print v(xbgr.mr_n63506144)
print v(xbgr.mr_n63506256)
print v(xbgr.mr_n63506576)
print v(xbgr.mr_n63506688)
print v(xbgr.mr_n63507008)
print v(xbgr.mr_n63507120)
print v(xbgr.mr_n63507440)
print v(xbgr.mr_n63507552)
print v(xbgr.mr_n63507872)
print v(xbgr.mr_n63507984)
print v(xbgr.mr_n63508304)
print v(xbgr.mr_n63508416)
print v(xbgr.mr_n63508736)
print v(xbgr.mr_n63508848)
print v(xbgr.mr_n63509168)
print v(xbgr.mr_n63509280)
print v(xbgr.mr_n63509600)
print v(xbgr.mr_n63509712)
print v(xbgr.mr_n63510032)
print v(xbgr.mr_n63510144)
print v(xbgr.mr_n63510464)
print v(xbgr.mr_n63510576)
print v(xbgr.mr_n63510896)
print v(xbgr.mr_n63511008)
print v(xbgr.mr_n63511328)
print v(xbgr.mr_n63511440)
print v(xbgr.mr_n63511760)
print v(xbgr.mr_n63511872)
print v(xbgr.mr_n63512192)
print v(xbgr.mr_n63512304)
print v(xbgr.mr_n63512624)
print v(xbgr.mr_n63512736)
print v(xbgr.mr_n63513056)
print v(xbgr.mr_n63513168)
print v(xbgr.mr_n63513488)
print v(xbgr.mr_n63513600)
print v(xbgr.mr_n63513920)
print v(xbgr.mr_n63514032)
print v(xbgr.mr_n63514352)
print v(xbgr.mr_n63514464)
print v(xbgr.mr_n63514784)
print v(xbgr.mr_n63514896)
print v(xbgr.mr_n63515216)
print v(xbgr.mr_n63515328)
print v(xbgr.mr_n63515648)
print v(xbgr.mr_n63515760)
print v(xbgr.mr_n63516080)
print v(xbgr.mr_n63516192)
print v(xbgr.mr_n63516512)
print v(xbgr.mr_n63516624)
print v(xbgr.mr_n63516944)
print v(xbgr.mr_n63517056)
print v(xbgr.mr_n63517376)
print v(xbgr.mr_n63517488)
print v(xbgr.mr_n63517808)
print v(xbgr.mr_n63517920)
print v(xbgr.mr_n63518240)
print v(xbgr.mr_n63518352)
print v(xbgr.mr_n63518672)
print v(xbgr.mr_n63518784)
print v(xbgr.mr_n63519104)
print v(xbgr.mr_n63519216)
print v(xbgr.mr_n63519536)
print v(xbgr.mr_n63519648)
print v(xbgr.mr_n63519968)
print v(xbgr.mr_n63520080)
print v(xbgr.mr_n63520400)
print v(xbgr.mr_n63520512)
print v(xbgr.mr_n63520832)
print v(xbgr.mr_n63520944)
print v(xbgr.mr_n63521264)
print v(xbgr.mr_n63521376)
print v(xbgr.mr_n63521696)
print v(xbgr.mr_n63521808)
print v(xbgr.mr_n63522128)
print v(xbgr.mr_n63522240)
print v(xbgr.mr_n63522560)
print v(xbgr.mr_n63522672)
print v(xbgr.mr_n63522992)
print v(xbgr.mr_n63523104)
print v(xbgr.mr_n63523424)
print v(xbgr.mr_n63523536)
print v(xbgr.mr_n63523856)
print v(xbgr.mr_n63523968)
print v(xbgr.mr_n63524288)
print v(xbgr.mr_n63524400)
print v(xbgr.mr_n63524720)
print v(xbgr.mr_n63524832)
print v(xbgr.mr_n63525152)
print v(xbgr.mr_n63525264)
print v(xbgr.mr_n63525584)
print v(xbgr.mr_n63525696)
print v(xbgr.mr_n63526016)
print v(xbgr.mr_n63526128)
print v(xbgr.mr_n63526448)
print v(xbgr.mr_n63526560)
print v(xbgr.mr_n63526880)
print v(xbgr.mr_n63526992)
print v(xbgr.mr_n63527312)
print v(xbgr.mr_n63527424)
print v(xbgr.mr_n63527744)
print v(xbgr.mr_n63527856)
print v(xbgr.mr_n63528176)
print v(xbgr.mr_n63528288)
print v(xbgr.mr_n63528608)
print v(xbgr.mr_n63528720)
print v(xbgr.mr_n63529040)
print v(xbgr.mr_n63529152)
print v(xbgr.mr_n63529472)
print v(xbgr.mr_n63529584)
print v(xbgr.mr_n63529904)
print v(xbgr.mr_n63530016)
print v(xbgr.mr_n63530336)
print v(xbgr.mr_n63530448)
print v(xbgr.mr_n63530768)
print v(xbgr.mr_n63530880)
print v(xbgr.mr_n63531200)
print v(xbgr.mr_n63531312)
print v(xbgr.mr_n63531632)
print v(xbgr.mr_n63531744)
print v(xbgr.mr_n63532064)
print v(xbgr.mr_n63532176)
print v(xbgr.mr_n63532496)
print v(xbgr.mr_n63532608)
print v(xbgr.mr_n63532928)
print v(xbgr.mr_n63533040)
print v(xbgr.mr_n63533360)
print v(xbgr.mr_n63533472)
print v(xbgr.mr_n63533792)
print v(xbgr.mr_n63533904)
print v(xbgr.mr_n63534224)
print v(xbgr.mr_n63534336)
print v(xbgr.mr_n63534656)
print v(xbgr.mr_n63534768)
print v(xbgr.mr_n63535088)
print v(xbgr.mr_n63535200)
print v(xbgr.mr_n63535520)
print v(xbgr.mr_n63535632)
print v(xbgr.mr_n63535952)
print v(xbgr.mr_n63536064)
print v(xbgr.mr_n63536384)
print v(xbgr.mr_n63536496)
print v(xbgr.mr_n63536816)
print v(xbgr.mr_n63536928)
print v(xbgr.mr_n63537248)
print v(xbgr.mr_n63537360)
print v(xbgr.mr_n63537680)
print v(xbgr.mr_n63537792)
print v(xbgr.mr_n63538112)
print v(xbgr.mr_n63538224)
print v(xbgr.mr_n63538544)
print v(xbgr.mr_n63538656)
print v(xbgr.mr_n63538976)
print v(xbgr.mr_n63539088)
print v(xbgr.mr_n63539408)
print v(xbgr.mr_n63539520)
print v(xbgr.mr_n63539840)
print v(xbgr.mr_n63539952)
print v(xbgr.mr_n63540272)
print v(xbgr.mr_n63540384)
print v(xbgr.mr_n63540704)
print v(xbgr.mr_n63540816)
print v(xbgr.mr_n63541136)
print v(xbgr.mr_n63541248)
print v(xbgr.mr_n63541568)
print v(xbgr.mr_n63541680)
print v(xbgr.mr_n63542000)
print v(xbgr.mr_n63542112)
print v(xbgr.mr_n63542432)
print v(xbgr.mr_n63542544)
print v(xbgr.mr_n63542864)
print v(xbgr.mr_n63542976)
print v(xbgr.mr_n63543296)
print v(xbgr.mr_n63543408)
print v(xbgr.mr_n63543728)
print v(xbgr.mr_n63543840)
print v(xbgr.mr_n63544160)
print v(xbgr.mr_n63544272)
print v(xbgr.mr_n63544592)
print v(xbgr.mr_n63544704)
print v(xbgr.mr_n63545024)
print v(xbgr.mr_n63545136)
print v(xbgr.mr_n63545456)
print v(xbgr.mr_n63545568)
print v(xbgr.mr_n63545888)
print v(xbgr.mr_n63546000)
print v(xbgr.mr_n63546320)
print v(xbgr.mr_n63546432)
print v(xbgr.mr_n63546752)
print v(xbgr.mr_n63546864)
print v(xbgr.mr_n63547184)
print v(xbgr.mr_n63547296)
print v(xbgr.mr_n63547616)
print v(xbgr.mr_n63547728)
print v(xbgr.mr_n63548048)
print v(xbgr.mr_n63548160)
print v(xbgr.mr_n63548480)
print v(xbgr.mr_n63548592)
print v(xbgr.mr_n63548912)
print v(xbgr.mr_n63549024)
print v(xbgr.mr_n63549344)
print v(xbgr.mr_n63549456)
print v(xbgr.mr_n63549776)
print v(xbgr.mr_n63549888)
print v(xbgr.mr_n63550208)
print v(xbgr.mr_n63550320)
print v(xbgr.mr_n63550640)
print v(xbgr.mr_n63550752)
print v(xbgr.mr_n63551072)
print v(xbgr.mr_n63551184)
print v(xbgr.mr_n63551504)
print v(xbgr.mr_n63551616)
print v(xbgr.mr_n63551936)
print v(xbgr.mr_n63552048)
print v(xbgr.mr_n63552368)
print v(xbgr.mr_n63552480)
print v(xbgr.mr_n63552800)
print v(xbgr.mr_n63552912)
print v(xbgr.mr_n63553232)
print v(xbgr.mr_n63553344)
print v(xbgr.mr_n63553664)
print v(xbgr.mr_n63553776)
print v(xbgr.mr_n63554096)
print v(xbgr.mr_n63554208)
print v(xbgr.mr_n63554528)
print v(xbgr.mr_n63554640)
print v(xbgr.mr_n63554960)
print v(xbgr.mr_n63555072)
print v(xbgr.mr_n63555392)
print v(xbgr.mr_n63555504)
print v(xbgr.mr_n63555824)
print v(xbgr.mr_n63555936)
print v(xbgr.mr_n63556256)
print v(xbgr.mr_n63556368)
print v(xbgr.mr_n63556688)
print v(xbgr.mr_n63556800)
print v(xbgr.mr_n63557120)
print v(xbgr.mr_n63557232)
print v(xbgr.mr_n63557552)
print v(xbgr.mr_n63557664)
print v(xbgr.mr_n63557984)
print v(xbgr.mr_n63558096)
print v(xbgr.mr_n63558416)
print v(xbgr.mr_n63558528)
print v(xbgr.mr_n63558848)
print v(xbgr.mr_n63558960)
print v(xbgr.mr_n63559280)
print v(xbgr.mr_n63559392)
print v(xbgr.mr_n63559712)
print v(xbgr.mr_n63559824)
print v(xbgr.mr_n63560144)
print v(xbgr.mr_n63560256)
print v(xbgr.mr_n63560576)
print v(xbgr.mr_n63560688)
print v(xbgr.mr_n63561008)
print v(xbgr.mr_n63561120)
print v(xbgr.mr_n63561440)
print v(xbgr.mr_n63561552)
print v(xbgr.mr_n63561872)
print v(xbgr.mr_n63561984)
print v(xbgr.mr_n63562304)
print v(xbgr.mr_n63562416)
print v(xbgr.mr_n63562720)
print v(xbgr.mr_n63562832)
print v(xbgr.mr_n63563152)
print v(xbgr.mr_n63563264)
print v(xbgr.mr_n63563584)
print v(xbgr.mr_n63563696)
print v(xbgr.mr_n63564016)
print v(xbgr.mr_n63564128)
print v(xbgr.mr_n63564448)
print v(xbgr.mr_n63564560)
print v(xbgr.mr_n63564880)
print v(xbgr.mr_n63564992)
print v(xbgr.mr_n63565312)
print v(xbgr.mr_n63565424)
print v(xbgr.mr_n63565744)
print v(xbgr.mr_n63565856)
print v(xbgr.mr_n63566176)
print v(xbgr.mr_n63566288)
print v(xbgr.mr_n63566608)
print v(xbgr.mr_n63566720)
print v(xbgr.mr_n63567040)
print v(xbgr.mr_n63567152)
print v(xbgr.mr_n63567472)
print v(xbgr.mr_n63567584)
print v(xbgr.mr_n63567904)
print v(xbgr.mr_n63568016)
print v(xbgr.mr_n63568336)
print v(xbgr.mr_n63568448)
print v(xbgr.mr_n63568768)
print v(xbgr.mr_n63568880)
print v(xbgr.mr_n63569200)
print v(xbgr.mr_n63569312)
print v(xbgr.mr_n63569632)
print v(xbgr.mr_n63569744)
print v(xbgr.mr_n63570064)
print v(xbgr.mr_n63570176)
print v(xbgr.mr_n63570496)
print v(xbgr.mr_n63570608)
print v(xbgr.mr_n63570928)
print v(xbgr.mr_n63571040)
print v(xbgr.mr_n63571360)
print v(xbgr.mr_n63571472)
print v(xbgr.mr_n63571792)
print v(xbgr.mr_n63571904)
print v(xbgr.mr_n63572224)
print v(xbgr.mr_n63572336)
print v(xbgr.mr_n63572656)
print v(xbgr.mr_n63572768)
print v(xbgr.mr_n63573088)
print v(xbgr.mr_n63573200)
print v(xbgr.mr_n63573520)
print v(xbgr.mr_n63573632)
print v(xbgr.mr_n63573952)
print v(xbgr.mr_n63574064)
print v(xbgr.mr_n63574384)
print v(xbgr.mr_n63574496)
print v(xbgr.mr_n63574816)
print v(xbgr.mr_n63574928)
print v(xbgr.mr_n63575248)
print v(xbgr.mr_n63575360)
print v(xbgr.mr_n63575680)
print v(xbgr.mr_n63575792)
print v(xbgr.mr_n63576112)
print v(xbgr.mr_n63576224)
print v(xbgr.mr_n63576544)
print v(xbgr.mr_n63576656)
print v(xbgr.mr_n63576976)
print v(xbgr.mr_n63577088)
print v(xbgr.mr_n63577408)
print v(xbgr.mr_n63577520)
print v(xbgr.mr_n63577840)
print v(xbgr.mr_n63577952)
print v(xbgr.mr_n63578272)
print v(xbgr.mr_n63578384)
print v(xbgr.mr_n63578704)
print v(xbgr.mr_n63578816)
print v(xbgr.mr_n63579136)
print v(xbgr.mr_n63579248)
print v(xbgr.mr_n63579568)
print v(xbgr.mr_n63579680)
print v(xbgr.mr_n63580000)
print v(xbgr.mr_n63580112)
print v(xbgr.mr_n63580432)
print v(xbgr.mr_n63580544)
print v(xbgr.mr_n63580864)
print v(xbgr.mr_n63580976)
print v(xbgr.mr_n63581296)
print v(xbgr.mr_n63581408)
print v(xbgr.mr_n63581728)
print v(xbgr.mr_n63581840)
print v(xbgr.mr_n63582160)
print v(xbgr.mr_n63582272)
print v(xbgr.mr_n63582592)
print v(xbgr.mr_n63582704)
print v(xbgr.mr_n63583024)
print v(xbgr.mr_n63583136)
print v(xbgr.mr_n63583456)
print v(xbgr.mr_n63583568)
print v(xbgr.mr_n63583888)
print v(xbgr.mr_n63584000)
print v(xbgr.mr_n63584320)
print v(xbgr.mr_n63584432)
print v(xbgr.mr_n63584752)
print v(xbgr.mr_n63584864)
print v(xbgr.mr_n63585184)
print v(xbgr.mr_n63585296)
print v(xbgr.mr_n63585616)
print v(xbgr.mr_n63585728)
print v(xbgr.mr_n63586048)
print v(xbgr.mr_n63586160)
print v(xbgr.mr_n63586480)
print v(xbgr.mr_n63586592)
print v(xbgr.mr_n63586912)
print v(xbgr.mr_n63587024)
print v(xbgr.mr_n63587344)
print v(xbgr.mr_n63587456)
print v(xbgr.mr_n63587776)
print v(xbgr.mr_n63587888)
print v(xbgr.mr_n63588208)
print v(xbgr.mr_n63588320)
print v(xbgr.mr_n63588640)
print v(xbgr.mr_n63588752)
print v(xbgr.mr_n63589072)
print v(xbgr.mr_n63589184)
print v(xbgr.mr_n63589504)
print v(xbgr.mr_n63589616)
print v(xbgr.mr_n63589936)
print v(xbgr.mr_n63590048)
print v(xbgr.mr_n63590368)
print v(xbgr.mr_n63590480)
print v(xbgr.mr_n63590800)
print v(xbgr.mr_n63590912)
print v(xbgr.mr_n63591232)
print v(xbgr.mr_n63591344)
print v(xbgr.mr_n63591664)
print v(xbgr.mr_n63591776)
print v(xbgr.mr_n63592096)
print v(xbgr.mr_n63592208)
print v(xbgr.mr_n63592528)
print v(xbgr.mr_n63592640)
print v(xbgr.mr_n63592960)
print v(xbgr.mr_n63593072)
print v(xbgr.mr_n63593392)
print v(xbgr.mr_n63593504)
print v(xbgr.mr_n63593824)
print v(xbgr.mr_n63593936)
print v(xbgr.mr_n63594256)
print v(xbgr.mr_n63594368)
print v(xbgr.mr_n63594688)
print v(xbgr.mr_n63594800)
print v(xbgr.mr_n63595120)
print v(xbgr.mr_n63595232)
print v(xbgr.mr_n63595552)
print v(xbgr.mr_n63595664)
print v(xbgr.mr_n63595984)
print v(xbgr.mr_n63596096)
print v(xbgr.mr_n63596416)
print v(xbgr.mr_n63596528)
print v(xbgr.mr_n63596848)
print v(xbgr.mr_n63596960)
print v(xbgr.mr_n63597280)
print v(xbgr.mr_n63597392)
print v(xbgr.mr_n63597712)
print v(xbgr.mr_n63597824)
print v(xbgr.mr_n63598144)
print v(xbgr.mr_n63598256)
print v(xbgr.mr_n63598576)
print v(xbgr.mr_n63598688)
print v(xbgr.mr_n63599008)
print v(xbgr.mr_n63599120)
print v(xbgr.mr_n63599440)
print v(xbgr.mr_n63599552)
print v(xbgr.mr_n63599872)
print v(xbgr.mr_n63599984)
print v(xbgr.mr_n63600304)
print v(xbgr.mr_n63600416)
print v(xbgr.mr_n63600736)
print v(xbgr.mr_n63600848)
print v(xbgr.mr_n63601168)
print v(xbgr.mr_n63601280)
print v(xbgr.mr_n63601600)
print v(xbgr.mr_n63601712)
print v(xbgr.mr_n63602032)
print v(xbgr.mr_n63602144)
print v(xbgr.mr_n63602464)
print v(xbgr.mr_n63602576)
print v(xbgr.mr_n63602896)
print v(xbgr.mr_n63603008)
print v(xbgr.mr_n63603328)
print v(xbgr.mr_n63603440)
print v(xbgr.mr_n63603760)
print v(xbgr.mr_n63603872)
print v(xbgr.mr_n63604192)
print v(xbgr.mr_n63604304)
print v(xbgr.mr_n63604624)
print v(xbgr.mr_n63604736)
print v(xbgr.mr_n63605056)
print v(xbgr.mr_n63605168)
print v(xbgr.mr_n63605488)
print v(xbgr.mr_n63605600)
print v(xbgr.mr_n63605920)
print v(xbgr.mr_n63606032)
print v(xbgr.mr_n63606352)
print v(xbgr.mr_n63606464)
print v(xbgr.mr_n63606784)
print v(xbgr.mr_n63606896)
print v(xbgr.mr_n63607216)
print v(xbgr.mr_n63607328)
print v(xbgr.mr_n63607648)
print v(xbgr.mr_n63607760)
print v(xbgr.mr_n63608080)
print v(xbgr.mr_n63608192)
print v(xbgr.mr_n63608512)
print v(xbgr.mr_n63608624)
print v(xbgr.mr_n63608944)
print v(xbgr.mr_n63609056)
print v(xbgr.mr_n63609376)
print v(xbgr.mr_n63609488)
print v(xbgr.mr_n63609808)
print v(xbgr.mr_n63609920)
print v(xbgr.mr_n63610240)
print v(xbgr.mr_n63610352)
print v(xbgr.mr_n63610672)
print v(xbgr.mr_n63610880)
print v(xbgr.mr_n63611120)
print v(xbgr.mr_n63611984)
print v(xbgr.mr_n63612096)
print v(xbgr.mr_n63612416)
print v(xbgr.mr_n63612528)
print v(xbgr.mr_n63612848)
print v(xbgr.mr_n63612960)
print v(xbgr.mr_n63613280)
print v(xbgr.mr_n63613392)
print v(xbgr.mr_n63613712)
print v(xbgr.mr_n63613824)
print v(xbgr.mr_n63614144)
print v(xbgr.mr_n63614256)
print v(xbgr.mr_n63614576)
print v(xbgr.mr_n63615440)
print v(xbgr.mr_n63616304)
print v(xbgr.mr_n63617168)
print v(xbgr.mr_n63617280)
print v(xbgr.mr_n63618032)
print v(xbgr.mr_n63618144)
print v(xbgr.mr_n63618464)
print v(xbgr.mr_n63619328)
print v(xbgr.mr_n63620192)
print v(xbgr.mr_n63621056)
print v(xbgr.mr_n63621920)
print v(xbgr.mr_n63622464)
print v(xbgr.mr_n63623216)
print v(xbgr.mr_n63623760)
print v(xbgr.mr_n63624192)
print v(xbgr.mr_n63624944)
print v(xbgr.mr_n63625056)
print v(xbgr.mr_n63625376)
print v(xbgr.mr_n63625488)
print v(xbgr.mr_n63625808)
print v(xbgr.mr_n63626672)
print v(xbgr.mr_n63627536)
print v(xbgr.mr_n63628400)
print v(xbgr.mr_n63628512)
print v(xbgr.mr_n63628832)
print v(xbgr.mr_n63628944)
print v(xbgr.mr_n63629376)
print v(xbgr.mr_n63629696)
print v(xbgr.mr_n63629808)
print v(xbgr.mr_n63630128)
print v(xbgr.mr_n63630992)
print v(xbgr.mr_n63631104)
print v(xbgr.mr_n63631536)
print v(xbgr.mr_n63631856)
print v(xbgr.mr_n63631968)
print v(xbgr.mr_n63632288)
print v(xbgr.mr_n63632400)
print v(xbgr.mr_n63632720)
print v(xbgr.mr_n63632832)
print v(xbgr.mr_n63633152)
print v(xbgr.mr_n63633264)
print v(xbgr.mr_n63633584)
print v(xbgr.mr_n63634560)
print v(xbgr.mr_n63634880)
print v(xbgr.mr_n63634992)
print v(xbgr.mr_n63635312)
print v(xbgr.mr_n63635424)
print v(xbgr.mr_n63635744)
print v(xbgr.mr_n63635856)
print v(xbgr.mr_n63636176)
print v(xbgr.mr_n63636288)
print v(xbgr.mr_n63636608)
print v(xbgr.mr_n63637040)
print v(xbgr.mr_n63638016)
print v(xbgr.mr_n63638336)
print v(xbgr.mr_n63639200)
print v(xbgr.mr_n63640064)
print v(xbgr.mr_n63640176)
print v(xbgr.mr_n63640928)
print v(xbgr.mr_n63641792)
print v(xbgr.mr_n63641904)
print v(xbgr.mr_n63642224)
print v(xbgr.mr_n63643088)
print v(xbgr.mr_n63643200)
print v(xbgr.mr_n63643520)
print v(xbgr.mr_n63643632)
print v(xbgr.mr_n63643952)
print v(xbgr.mr_n63644816)
print v(xbgr.mr_n63644928)
print v(xbgr.mr_n63645248)
print v(xbgr.mr_n63645360)
print v(xbgr.mr_n63645680)
print v(xbgr.mr_n63645792)
print v(xbgr.mr_n63646112)
print v(xbgr.mr_n63646224)
print v(xbgr.mr_n63646544)
print v(xbgr.mr_n63647520)
print v(xbgr.mr_n63647952)
print v(xbgr.mr_n63648272)
print v(xbgr.mr_n63649136)
print v(xbgr.mr_n63650000)
print v(xbgr.mr_n63650112)
print v(xbgr.mr_n63650432)
print v(xbgr.mr_n63650544)
print v(xbgr.mr_n63650864)
print v(xbgr.mr_n63650976)
print v(xbgr.mr_n63651296)
print v(xbgr.mr_n63651408)
print v(xbgr.mr_n63651840)
print v(xbgr.mr_n63652272)
print v(xbgr.mr_n63652592)
print v(xbgr.mr_n63652704)
print v(xbgr.mr_n63653024)
print v(xbgr.mr_n63653136)
print v(xbgr.mr_n63653456)
print v(xbgr.mr_n63653568)
print v(xbgr.mr_n63653888)
print v(xbgr.mr_n63654000)
print v(xbgr.mr_n63654320)
print v(xbgr.mr_n63655184)
print v(xbgr.mr_n63656048)
print v(xbgr.mr_n63656160)
print v(xbgr.mr_n63656480)
print v(xbgr.mr_n63657344)
print v(xbgr.mr_n63658208)
print v(xbgr.mr_n63658320)
print v(xbgr.mr_n63658640)
print v(xbgr.mr_n63658752)
print v(xbgr.mr_n63659184)
print v(xbgr.mr_n63659504)
print v(xbgr.mr_n63659616)
print v(xbgr.mr_n63660048)
print v(xbgr.mr_n63660368)
print v(xbgr.mr_n63660800)
print v(xbgr.mr_n63660912)
print v(xbgr.mr_n63661232)
print v(xbgr.mr_n63661344)
print v(xbgr.mr_n63661664)
print v(xbgr.mr_n63662096)
print v(xbgr.mr_n63662208)
print v(xbgr.mr_n63662960)
print v(xbgr.mr_n63663072)
print v(xbgr.mr_n63663392)
print v(xbgr.mr_n63663504)
print v(xbgr.mr_n63663824)
print v(xbgr.mr_n63664256)
print v(xbgr.mr_n63664368)
print v(xbgr.mr_n63664688)
print v(xbgr.mr_n63665120)
print v(xbgr.mr_n63665984)
print v(xbgr.mr_n63667712)
print v(xbgr.mr_n63667824)
print v(xbgr.mr_n63668144)
print v(xbgr.mr_n63668256)
print v(xbgr.mr_n63668576)
print v(xbgr.mr_n63668688)
print v(xbgr.mr_n63669120)
print v(xbgr.mr_n63669552)
print v(xbgr.mr_n63669872)
print v(xbgr.mr_n63669984)
print v(xbgr.mr_n63670304)
print v(xbgr.mr_n63671712)
print v(xbgr.mr_n63672032)
print v(xbgr.mr_n63673008)
print v(xbgr.mr_n63673328)
print v(xbgr.mr_n63673440)
print v(xbgr.mr_n63673760)
print v(xbgr.mr_n63673872)
print v(xbgr.mr_n63674304)
print v(xbgr.mr_n63674624)
print v(xbgr.mr_n63674736)
print v(xbgr.mr_n63675168)
print v(xbgr.mr_n63675488)
print v(xbgr.mr_n63675600)
print v(xbgr.mr_n63675920)
print v(xbgr.mr_n63676032)
print v(xbgr.mr_n63676352)
print v(xbgr.mr_n63677216)
print v(xbgr.mr_n63677648)
print v(xbgr.mr_n63678512)
print v(xbgr.mr_n63678624)
print v(xbgr.mr_n63678944)
print v(xbgr.mr_n63679056)
print v(xbgr.mr_n63679376)
print v(xbgr.mr_n63679488)
print v(xbgr.mr_n63680240)
print v(xbgr.mr_n63680672)
print v(xbgr.mr_n63680784)
print v(xbgr.mr_n63681104)
print v(xbgr.mr_n63681536)
print v(xbgr.mr_n63681648)
print v(xbgr.mr_n63681968)
print v(xbgr.mr_n63682080)
print v(xbgr.mr_n63682400)
print v(xbgr.mr_n63682512)
print v(xbgr.mr_n63682832)
print v(xbgr.mr_n63682944)
print v(xbgr.mr_n63683264)
print v(xbgr.mr_n63683376)
print v(xbgr.mr_n63683696)
print v(xbgr.mr_n63685104)
print v(xbgr.mr_n63685424)
print v(xbgr.mr_n63685536)
print v(xbgr.mr_n63685968)
print v(xbgr.mr_n63686288)
print v(xbgr.mr_n63686400)
print v(xbgr.mr_n63686720)
print v(xbgr.mr_n63687152)
print v(xbgr.mr_n63688016)
print v(xbgr.mr_n63688880)
print v(xbgr.mr_n63689744)
print v(xbgr.mr_n63690608)
print v(xbgr.mr_n63691472)
print v(xbgr.mr_n63692768)
print v(xbgr.mr_n63693200)
print v(xbgr.mr_n63693312)
print v(xbgr.mr_n63693632)
print v(xbgr.mr_n63694064)
print v(xbgr.mr_n63694176)
print v(xbgr.mr_n63694496)
print v(xbgr.mr_n63695360)
print v(xbgr.mr_n63695472)
print v(xbgr.mr_n63695792)
print v(xbgr.mr_n63695904)
print v(xbgr.mr_n63696224)
print v(xbgr.mr_n63697088)
print v(xbgr.mr_n63697200)
print v(xbgr.mr_n63698064)
print v(xbgr.mr_n63698496)
print v(xbgr.mr_n63698928)
print v(xbgr.mr_n63699680)
print v(xbgr.mr_n63699792)
print v(xbgr.mr_n63700224)
print v(xbgr.mr_n63700976)
print v(xbgr.mr_n63701408)
print v(xbgr.mr_n63701520)
print v(xbgr.mr_n63701952)
print v(xbgr.mr_n63702704)
print v(xbgr.mr_n63702816)
print v(xbgr.mr_n63703136)
print v(xbgr.mr_n63703248)
print v(xbgr.mr_n63703568)
print v(xbgr.mr_n63703680)
print v(xbgr.mr_n63704000)
print v(xbgr.mr_n63704112)
print v(xbgr.mr_n63704432)
print v(xbgr.mr_n63704544)
print v(xbgr.mr_n63704864)
print v(xbgr.mr_n63704976)
print v(xbgr.mr_n63705296)
print v(xbgr.mr_n63705408)
print v(xbgr.mr_n63705728)
print v(xbgr.mr_n63705840)
print v(xbgr.mr_n63706160)
print v(xbgr.mr_n63706272)
print v(xbgr.mr_n63706592)
print v(xbgr.mr_n63706704)
print v(xbgr.mr_n63707024)
print v(xbgr.mr_n63707136)
print v(xbgr.mr_n63707456)
print v(xbgr.mr_n63707568)
print v(xbgr.mr_n63707888)
print v(xbgr.mr_n63708000)
print v(xbgr.mr_n63708320)
print v(xbgr.mr_n63708432)
print v(xbgr.mr_n63708864)
print v(xbgr.mr_n63709184)
print v(xbgr.mr_n63709296)
print v(xbgr.mr_n63709728)
print v(xbgr.mr_n63710048)
print v(xbgr.mr_n63710160)
print v(xbgr.mr_n63710912)
print v(xbgr.mr_n63711344)
print v(xbgr.mr_n63712208)
print v(xbgr.mr_n63713072)
print v(xbgr.mr_n63713936)
print v(xbgr.mr_n63714048)
print v(xbgr.mr_n63714368)
print v(xbgr.mr_n63714480)
print v(xbgr.mr_n63714800)
print v(xbgr.mr_n63714912)
print v(xbgr.mr_n63715232)
print v(xbgr.mr_n63715344)
print v(xbgr.mr_n63716096)
print v(xbgr.mr_n63716960)
print v(xbgr.mr_n63717824)
print v(xbgr.mr_n63718688)
print v(xbgr.mr_n63719984)
print v(xbgr.mr_n63720096)
print v(xbgr.mr_n63720416)
print v(xbgr.mr_n63720528)
print v(xbgr.mr_n63720848)
print v(xbgr.mr_n63720960)
print v(xbgr.mr_n63721392)
print v(xbgr.mr_n63721824)
print v(xbgr.mr_n63722256)
print v(xbgr.mr_n63722576)
print v(xbgr.mr_n63722688)
print v(xbgr.mr_n63723120)
print v(xbgr.mr_n63723440)
print v(xbgr.mr_n63723552)
print v(xbgr.mr_n63723872)
print v(xbgr.mr_n63723984)
print v(xbgr.mr_n63724304)
print v(xbgr.mr_n63724416)
print v(xbgr.mr_n63724736)
print v(xbgr.mr_n63724848)
print v(xbgr.mr_n63725168)
print v(xbgr.mr_n63725280)
print v(xbgr.mr_n63725712)
print v(xbgr.mr_n63726032)
print v(xbgr.mr_n63726144)
print v(xbgr.mr_n63726576)
print v(xbgr.mr_n63726896)
print v(xbgr.mr_n63727328)
print v(xbgr.mr_n63727440)
print v(xbgr.mr_n63727872)
print v(xbgr.mr_n63728192)
print v(xbgr.mr_n63728304)
print v(xbgr.mr_n63728736)
print v(xbgr.mr_n63729056)
print v(xbgr.mr_n63729168)
print v(xbgr.mr_n63729600)
print v(xbgr.mr_n63729920)
print v(xbgr.mr_n63730032)
print v(xbgr.mr_n63730352)
print v(xbgr.mr_n63730464)
print v(xbgr.mr_n63730784)
print v(xbgr.mr_n63731648)
print v(xbgr.mr_n63732512)
print v(xbgr.mr_n63733376)
print v(xbgr.mr_n63734240)
print v(xbgr.mr_n63735104)
print v(xbgr.mr_n63735968)
print v(xbgr.mr_n63736080)
print v(xbgr.mr_n63736832)
print v(xbgr.mr_n63737696)
print v(xbgr.mr_n63738560)
print v(xbgr.mr_n63739424)
print v(xbgr.mr_n63740288)
print v(xbgr.mr_n63741152)
print v(xbgr.mr_n63741264)
print v(xbgr.mr_n63741584)
print v(xbgr.mr_n63741696)
print v(xbgr.mr_n63742016)
print v(xbgr.mr_n63742128)
print v(xbgr.mr_n63742448)
print v(xbgr.mr_n63742560)
print v(xbgr.mr_n63742880)
print v(xbgr.mr_n63743744)
print v(xbgr.mr_n63744608)
print v(xbgr.mr_n63745472)
print v(xbgr.mr_n63745584)
print v(xbgr.mr_n63745904)
print v(xbgr.mr_n63746016)
print v(xbgr.mr_n63746336)
print v(xbgr.mr_n63746448)
print v(xbgr.mr_n63746768)
print v(xbgr.mr_n63747632)
print v(xbgr.mr_n63748496)
print v(xbgr.mr_n63749360)
print v(xbgr.mr_n63749472)
print v(xbgr.mr_n63749792)
print v(xbgr.mr_n63749904)
print v(xbgr.mr_n63750224)
print v(xbgr.mr_n63750336)
print v(xbgr.mr_n63750768)
print v(xbgr.mr_n63751200)
print v(xbgr.mr_n63751632)
print v(xbgr.mr_n63751952)
print v(xbgr.mr_n63752064)
print v(xbgr.mr_n63752384)
print v(xbgr.mr_n63752496)
print v(xbgr.mr_n63752816)
print v(xbgr.mr_n63752928)
print v(xbgr.mr_n63753248)
print v(xbgr.mr_n63753360)
print v(xbgr.mr_n63753680)
print v(xbgr.mr_n63753792)
print v(xbgr.mr_n63754112)
print v(xbgr.mr_n63754224)
print v(xbgr.mr_n63754544)
print v(xbgr.mr_n63754656)
print v(xbgr.mr_n63754976)
print v(xbgr.mr_n63755088)
print v(xbgr.mr_n63755408)
print v(xbgr.mr_n63755520)
print v(xbgr.mr_n63755952)
print v(xbgr.mr_n63756272)
print v(xbgr.mr_n63756384)
print v(xbgr.mr_n63756704)
print v(xbgr.mr_n63757136)
print v(xbgr.mr_n63757248)
print v(xbgr.mr_n63757568)
print v(xbgr.mr_n63757680)
print v(xbgr.mr_n63758000)
print v(xbgr.mr_n63758112)
print v(xbgr.mr_n63758432)
print v(xbgr.mr_n63758544)
print v(xbgr.mr_n63759296)
print v(xbgr.mr_n63759408)
print v(xbgr.mr_n63760160)
print v(xbgr.mr_n63761024)
print v(xbgr.mr_n63761136)
print v(xbgr.mr_n63761456)
print v(xbgr.mr_n63761568)
print v(xbgr.mr_n63761888)
print v(xbgr.mr_n63762000)
print v(xbgr.mr_n63762320)
print v(xbgr.mr_n63762432)
print v(xbgr.mr_n63762864)
print v(xbgr.mr_n63763296)
print v(xbgr.mr_n63763616)
print v(xbgr.mr_n63763728)
print v(xbgr.mr_n63764048)
print v(xbgr.mr_n63764160)
print v(xbgr.mr_n63764480)
print v(xbgr.mr_n63765344)
print v(xbgr.mr_n63766640)
print v(xbgr.mr_n63767504)
print v(xbgr.mr_n63767616)
print v(xbgr.mr_n63767936)
print v(xbgr.mr_n63768048)
print v(xbgr.mr_n63768368)
print v(xbgr.mr_n63768480)
print v(xbgr.mr_n63768800)
print v(xbgr.mr_n63768912)
print v(xbgr.mr_n63769344)
print v(xbgr.mr_n63769664)
print v(xbgr.mr_n63769776)
print v(xbgr.mr_n63770096)
print v(xbgr.mr_n63770208)
print v(xbgr.mr_n63770528)
print v(xbgr.mr_n63770640)
print v(xbgr.mr_n63771072)
print v(xbgr.mr_n63771392)
print v(xbgr.mr_n63771504)
print v(xbgr.mr_n63771824)
print v(xbgr.mr_n63771936)
print v(xbgr.mr_n63772256)
print v(xbgr.mr_n63773120)
print v(xbgr.mr_n63773984)
print v(xbgr.mr_n63774848)
print v(xbgr.mr_n63775712)
print v(xbgr.mr_n63775824)
print v(xbgr.mr_n63776144)
print v(xbgr.mr_n63776256)
print v(xbgr.mr_n63776688)
print v(xbgr.mr_n63777120)
print v(xbgr.mr_n63777440)
print v(xbgr.mr_n63777552)
print v(xbgr.mr_n63777872)
print v(xbgr.mr_n63778736)
print v(xbgr.mr_n63779600)
print v(xbgr.mr_n63779712)
print v(xbgr.mr_n63780032)
print v(xbgr.mr_n63780144)
print v(xbgr.mr_n63780464)
print v(xbgr.mr_n63780576)
print v(xbgr.mr_n63780896)
print v(xbgr.mr_n63781008)
print v(xbgr.mr_n63781328)
print v(xbgr.mr_n63781440)
print v(xbgr.mr_n63781872)
print v(xbgr.mr_n63782192)
print v(xbgr.mr_n63782304)
print v(xbgr.mr_n63783056)
print v(xbgr.mr_n63783920)
print v(xbgr.mr_n63784032)
print v(xbgr.mr_n63784352)
print v(xbgr.mr_n63784464)
print v(xbgr.mr_n63784896)
print v(xbgr.mr_n63785216)
print v(xbgr.mr_n63785328)
print v(xbgr.mr_n63785648)
print v(xbgr.mr_n63785760)
print v(xbgr.mr_n63786080)
print v(xbgr.mr_n63786192)
print v(xbgr.mr_n63786512)
print v(xbgr.mr_n63786624)
print v(xbgr.mr_n63786944)
print v(xbgr.mr_n63787056)
print v(xbgr.mr_n63787376)
print v(xbgr.mr_n63788240)
print v(xbgr.mr_n63789216)
print v(xbgr.mr_n63789536)
print v(xbgr.mr_n63790400)
print v(xbgr.mr_n63791264)
print v(xbgr.mr_n63792128)
print v(xbgr.mr_n63792560)
print v(xbgr.mr_n63792992)
print v(xbgr.mr_n63793104)
print v(xbgr.mr_n63793424)
print v(xbgr.mr_n63793536)
print v(xbgr.mr_n63793856)
print v(xbgr.mr_n63793968)
print v(xbgr.mr_n63794288)
print v(xbgr.mr_n63794400)
print v(xbgr.mr_n63794720)
print v(xbgr.mr_n63794832)
print v(xbgr.mr_n63795152)
print v(xbgr.mr_n63795264)
print v(xbgr.mr_n63795584)
print v(xbgr.mr_n63796448)
print v(xbgr.mr_n63797312)
print v(xbgr.mr_n63797424)
print v(xbgr.mr_n63797744)
print v(xbgr.mr_n63797856)
print v(xbgr.mr_n63798176)
print v(xbgr.mr_n63798288)
print v(xbgr.mr_n63798608)
print v(xbgr.mr_n63798720)
print v(xbgr.mr_n63800336)
print v(xbgr.mr_n63801200)
print v(xbgr.mr_n63801312)
print v(xbgr.mr_n63801632)
print v(xbgr.mr_n63801744)
print v(xbgr.mr_n63802064)
print v(xbgr.mr_n63802496)
print v(xbgr.mr_n63802608)
print v(xbgr.mr_n63802928)
print v(xbgr.mr_n63803040)
print v(xbgr.mr_n63803360)
print v(xbgr.mr_n63803472)
print v(xbgr.mr_n63803904)
print v(xbgr.mr_n63804224)
print v(xbgr.mr_n63804336)
print v(xbgr.mr_n63804768)
print v(xbgr.mr_n63805520)
print v(xbgr.mr_n63806384)
print v(xbgr.mr_n63807680)
print v(xbgr.mr_n63807792)
print v(xbgr.mr_n63808224)
print v(xbgr.mr_n63808544)
print v(xbgr.mr_n63809408)
print v(xbgr.mr_n63810272)
print v(xbgr.mr_n63810704)
print v(xbgr.mr_n63812000)
print v(xbgr.mr_n63812864)
print v(xbgr.mr_n63813296)
print v(xbgr.mr_n63814160)
print v(xbgr.mr_n63815456)
print v(xbgr.mr_n63815568)
print v(xbgr.mr_n63815888)
print v(xbgr.mr_n63816000)
print v(xbgr.mr_n63816320)
print v(xbgr.mr_n63816432)
print v(xbgr.mr_n63816752)
print v(xbgr.mr_n63816864)
print v(xbgr.mr_n63817184)
print v(xbgr.mr_n63817296)
print v(xbgr.mr_n63817616)
print v(xbgr.mr_n63817728)
print v(xbgr.mr_n63818048)
print v(xbgr.mr_n63818160)
print v(xbgr.mr_n63818912)
print v(xbgr.mr_n63819024)
print v(xbgr.mr_n63819456)
print v(xbgr.mr_n63819776)
print v(xbgr.mr_n63819888)
print v(xbgr.mr_n63820208)
print v(xbgr.mr_n63820320)
print v(xbgr.mr_n63820640)
print v(xbgr.mr_n63820752)
print v(xbgr.mr_n63821072)
print v(xbgr.mr_n63821184)
print v(xbgr.mr_n63821504)
print v(xbgr.mr_n63821616)
print v(xbgr.mr_n63822048)
print v(xbgr.mr_n63822368)
print v(xbgr.mr_n63822912)
print v(xbgr.mr_n63823232)
print v(xbgr.mr_n63823344)
print v(xbgr.mr_n63823776)
print v(xbgr.mr_n63824096)
print v(xbgr.mr_n63824208)
print v(xbgr.mr_n63824640)
print v(xbgr.mr_n63824960)
print v(xbgr.mr_n63825072)
print v(xbgr.mr_n63825392)
print v(xbgr.mr_n63825504)
print v(xbgr.mr_n63825824)
print v(xbgr.mr_n63825936)
print v(xbgr.mr_n63826256)
print v(xbgr.mr_n63826368)
print v(xbgr.mr_n63826688)
print v(xbgr.mr_n63826800)
print v(xbgr.mr_n63827120)
print v(xbgr.mr_n63827232)
print v(xbgr.mr_n63827552)
print v(xbgr.mr_n63827664)
print v(xbgr.mr_n63827984)
print v(xbgr.mr_n63828096)
print v(xbgr.mr_n63828416)
print v(xbgr.mr_n63829280)
print v(xbgr.mr_n63829392)
print v(xbgr.mr_n63829712)
print v(xbgr.mr_n63829824)
print v(xbgr.mr_n63830144)
print v(xbgr.mr_n63830256)
print v(xbgr.mr_n63830576)
print v(xbgr.mr_n63830688)
print v(xbgr.mr_n63831008)
print v(xbgr.mr_n63831872)
print v(xbgr.mr_n63832736)
print v(xbgr.mr_n63833600)
print v(xbgr.mr_n63834144)
print v(xbgr.mr_n63834576)
print v(xbgr.mr_n63834896)
print v(xbgr.mr_n63835008)
print v(xbgr.mr_n63835328)
print v(xbgr.mr_n63835440)
print v(xbgr.mr_n63835760)
print v(xbgr.mr_n63835872)
print v(xbgr.mr_n63836192)
print v(xbgr.mr_n63836304)
print v(xbgr.mr_n63836624)
print v(xbgr.mr_n63837920)
print v(xbgr.mr_n63838784)
print v(xbgr.mr_n63839760)
print v(xbgr.mr_n63840192)
print v(xbgr.mr_n63840512)
print v(xbgr.mr_n63840944)
print v(xbgr.mr_n63841808)
print v(xbgr.mr_n63842672)
print v(xbgr.mr_n63842784)
print v(xbgr.mr_n63843104)
print v(xbgr.mr_n63843216)
print v(xbgr.mr_n63843536)
print v(xbgr.mr_n63843648)
print v(xbgr.mr_n63843968)
print v(xbgr.mr_n63844080)
print v(xbgr.mr_n63845264)
print v(xbgr.mr_n63845376)
print v(xbgr.mr_n63845696)
print v(xbgr.mr_n63845808)
print v(xbgr.mr_n63846128)
print v(xbgr.mr_n63846240)
print v(xbgr.mr_n63846672)
print v(xbgr.mr_n63846992)
print v(xbgr.mr_n63847424)
print v(xbgr.mr_n63847536)
print v(xbgr.mr_n63847968)
print v(xbgr.mr_n63848288)
print v(xbgr.mr_n63849152)
print v(xbgr.mr_n63849264)
print v(xbgr.mr_n63849696)
print v(xbgr.mr_n63850016)
print v(xbgr.mr_n63850128)
print v(xbgr.mr_n63850880)
print v(xbgr.mr_n63851424)
print v(xbgr.mr_n63851744)
print v(xbgr.mr_n63851856)
print v(xbgr.mr_n63852176)
print v(xbgr.mr_n63852288)
print v(xbgr.mr_n63852608)
print v(xbgr.mr_n63852720)
print v(xbgr.mr_n63853040)
print v(xbgr.mr_n63853472)
print v(xbgr.mr_n63853584)
print v(xbgr.mr_n63853904)
print v(xbgr.mr_n63854016)
print v(xbgr.mr_n63854336)
print v(xbgr.mr_n63854448)
print v(xbgr.mr_n63855200)
print v(xbgr.mr_n63855312)
print v(xbgr.mr_n63855744)
print v(xbgr.mr_n63856064)
print v(xbgr.mr_n63856176)
print v(xbgr.mr_n63856496)
print v(xbgr.mr_n63856608)
print v(xbgr.mr_n63856928)
print v(xbgr.mr_n63857040)
print v(xbgr.mr_n63857360)
print v(xbgr.mr_n63858224)
print v(xbgr.mr_n63858656)
print v(xbgr.mr_n63859088)
print v(xbgr.mr_n63859200)
print v(xbgr.mr_n63859520)
print v(xbgr.mr_n63859632)
print v(xbgr.mr_n63860384)
print v(xbgr.mr_n63860496)
print v(xbgr.mr_n63860816)
print v(xbgr.mr_n63860928)
print v(xbgr.mr_n63861680)
print v(xbgr.mr_n63862544)
print v(xbgr.mr_n63862656)
print v(xbgr.mr_n63862976)
print v(xbgr.mr_n63863840)
print v(xbgr.mr_n63863952)
print v(xbgr.mr_n63864272)
print v(xbgr.mr_n63864384)
print v(xbgr.mr_n63864704)
print v(xbgr.mr_n63864816)
print v(xbgr.mr_n63865136)
print v(xbgr.mr_n63865248)
print v(xbgr.mr_n63865568)
print v(xbgr.mr_n63865680)
print v(xbgr.mr_n63866000)
print v(xbgr.mr_n63866112)
print v(xbgr.mr_n63866432)
print v(xbgr.mr_n63866544)
print v(xbgr.mr_n63866976)
print v(xbgr.mr_n63867408)
print v(xbgr.mr_n63867728)
print v(xbgr.mr_n63868160)
print v(xbgr.mr_n63868272)
print v(xbgr.mr_n63869456)
print v(xbgr.mr_n63871184)
print v(xbgr.mr_n63871296)
print v(xbgr.mr_n63871728)
print v(xbgr.mr_n63872048)
print v(xbgr.mr_n63872160)
print v(xbgr.mr_n63872480)
print v(xbgr.mr_n63872592)
print v(xbgr.mr_n63873024)
print v(xbgr.mr_n63873344)
print v(xbgr.mr_n63873456)
print v(xbgr.mr_n63873776)
print v(xbgr.mr_n63874208)
print v(xbgr.mr_n63874320)
print v(xbgr.mr_n63875072)
print v(xbgr.mr_n63875184)
print v(xbgr.mr_n63875504)
print v(xbgr.mr_n63875616)
print v(xbgr.mr_n63875936)
print v(xbgr.mr_n63876048)
print v(xbgr.mr_n63876368)
print v(xbgr.mr_n63876480)
print v(xbgr.mr_n63876800)
print v(xbgr.mr_n63876912)
print v(xbgr.mr_n63877232)
print v(xbgr.mr_n63878096)
print v(xbgr.mr_n63878960)
print v(xbgr.mr_n63879824)
print v(xbgr.mr_n63879936)
print v(xbgr.mr_n63880256)
print v(xbgr.mr_n63880688)
print v(xbgr.mr_n63880800)
print v(xbgr.mr_n63881120)
print v(xbgr.mr_n63881232)
print v(xbgr.mr_n63881552)
print v(xbgr.mr_n63881664)
print v(xbgr.mr_n63881984)
print v(xbgr.mr_n63882848)
print v(xbgr.mr_n63883824)
print v(xbgr.mr_n63884144)
print v(xbgr.mr_n63884256)
print v(xbgr.mr_n63884576)
print v(xbgr.mr_n63884688)
print v(xbgr.mr_n63885008)
print v(xbgr.mr_n63885120)
print v(xbgr.mr_n63885440)
print v(xbgr.mr_n63885552)
print v(xbgr.mr_n63885872)
print v(xbgr.mr_n63886416)
print v(xbgr.mr_n63886848)
print v(xbgr.mr_n63887280)
print v(xbgr.mr_n63888464)
print v(xbgr.mr_n63888576)
print v(xbgr.mr_n63888896)
print v(xbgr.mr_n63889008)
print v(xbgr.mr_n63889328)
print v(xbgr.mr_n63890192)
print v(xbgr.mr_n63890304)
print v(xbgr.mr_n63890624)
print v(xbgr.mr_n63890736)
print v(xbgr.mr_n63891056)
print v(xbgr.mr_n63891488)
print v(xbgr.mr_n63892352)
print v(xbgr.mr_n63893648)
print v(xbgr.mr_n63893760)
print v(xbgr.mr_n63894080)
print v(xbgr.mr_n63894192)
print v(xbgr.mr_n63894512)
print v(xbgr.mr_n63894944)
print v(xbgr.mr_n63895808)
print v(xbgr.mr_n63896240)
print v(xbgr.mr_n63896352)
print v(xbgr.mr_n63896672)
print v(xbgr.mr_n63896784)
print v(xbgr.mr_n63897104)
print v(xbgr.mr_n63897216)
print v(xbgr.mr_n63897536)
print v(xbgr.mr_n63897648)
print v(xbgr.mr_n63898400)
print v(xbgr.mr_n63898512)
print v(xbgr.mr_n63899264)
print v(xbgr.mr_n63900240)
print v(xbgr.mr_n63900560)
print v(xbgr.mr_n63900672)
print v(xbgr.mr_n63900992)
print v(xbgr.mr_n63901104)
print v(xbgr.mr_n63901424)
print v(xbgr.mr_n63901856)
print v(xbgr.mr_n63902720)
print v(xbgr.mr_n63902832)
print v(xbgr.mr_n63903152)
print v(xbgr.mr_n63903264)
print v(xbgr.mr_n63903584)
print v(xbgr.mr_n63903696)
print v(xbgr.mr_n63904016)
print v(xbgr.mr_n63904128)
print v(xbgr.mr_n63904448)
print v(xbgr.mr_n63904560)
print v(xbgr.mr_n63904992)
print v(xbgr.mr_n63905744)
print v(xbgr.mr_n63906720)
print v(xbgr.mr_n63907152)
print v(xbgr.mr_n63907472)
print v(xbgr.mr_n63907904)
print v(xbgr.mr_n63908880)
print v(xbgr.mr_n63909312)
print v(xbgr.mr_n63909632)
print v(xbgr.mr_n63910064)
print v(xbgr.mr_n63910176)
print v(xbgr.mr_n63910496)
print v(xbgr.mr_n63910608)
print v(xbgr.mr_n63910928)
print v(xbgr.mr_n63911040)
print v(xbgr.mr_n63911360)
print v(xbgr.mr_n63911472)
print v(xbgr.mr_n63912224)
print v(xbgr.mr_n63913088)
print v(xbgr.mr_n63914384)
print v(xbgr.mr_n63914496)
print v(xbgr.mr_n63914816)
print v(xbgr.mr_n63914928)
print v(xbgr.mr_n63915248)
print v(xbgr.mr_n63915360)
print v(xbgr.mr_n63915680)
print v(xbgr.mr_n63915792)
print v(xbgr.mr_n63916112)
print v(xbgr.mr_n63916224)
print v(xbgr.mr_n63916544)
print v(xbgr.mr_n63916976)
print v(xbgr.mr_n63917088)
print v(xbgr.mr_n63917408)
print v(xbgr.mr_n63917520)
print v(xbgr.mr_n63917840)
print v(xbgr.mr_n63917952)
print v(xbgr.mr_n63918272)
print v(xbgr.mr_n63918384)
print v(xbgr.mr_n63918704)
print v(xbgr.mr_n63918816)
print v(xbgr.mr_n63919136)
print v(xbgr.mr_n63919248)
print v(xbgr.mr_n63919568)
print v(xbgr.mr_n63919680)
print v(xbgr.mr_n63920000)
print v(xbgr.mr_n63920112)
print v(xbgr.mr_n63920432)
print v(xbgr.mr_n63920544)
print v(xbgr.mr_n63920976)
print v(xbgr.mr_n63921296)
print v(xbgr.mr_n63921408)
print v(xbgr.mr_n63921840)
print v(xbgr.mr_n63922272)
print v(xbgr.mr_n63922592)
print v(xbgr.mr_n63922704)
print v(xbgr.mr_n63923024)
print v(xbgr.mr_n63923136)
print v(xbgr.mr_n63923456)
print v(xbgr.mr_n63923568)
print v(xbgr.mr_n63923888)
print v(xbgr.mr_n63924000)
print v(xbgr.mr_n63924752)
print v(xbgr.mr_n63924864)
print v(xbgr.mr_n63925296)
print v(xbgr.mr_n63925616)
print v(xbgr.mr_n63926160)
print v(xbgr.mr_n63926480)
print v(xbgr.mr_n63927344)
print v(xbgr.mr_n63927456)
print v(xbgr.mr_n63927776)
print v(xbgr.mr_n63928208)
print v(xbgr.mr_n63928640)
print v(xbgr.mr_n63929072)
print v(xbgr.mr_n63929184)
print v(xbgr.mr_n63929936)
print v(xbgr.mr_n63930048)
print v(xbgr.mr_n63930368)
print v(xbgr.mr_n63930480)
print v(xbgr.mr_n63930800)
print v(xbgr.mr_n63931232)
print v(xbgr.mr_n63931344)
print v(xbgr.mr_n63931664)
print v(xbgr.mr_n63931776)
print v(xbgr.mr_n63932096)
print v(xbgr.mr_n63932208)
print v(xbgr.mr_n63932528)
print v(xbgr.mr_n63932960)
print v(xbgr.mr_n63933824)
print v(xbgr.mr_n63934688)
print v(xbgr.mr_n63935984)
print v(xbgr.mr_n63936848)
print v(xbgr.mr_n63937712)
print v(xbgr.mr_n63938576)
print v(xbgr.mr_n63938688)
print v(xbgr.mr_n63939008)
print v(xbgr.mr_n63939872)
print v(xbgr.mr_n63940736)
print v(xbgr.mr_n63941600)
print v(xbgr.mr_n63941712)
print v(xbgr.mr_n63942032)
print v(xbgr.mr_n63942144)
print v(xbgr.mr_n63942464)
print v(xbgr.mr_n63942576)
print v(xbgr.mr_n63942896)
print v(xbgr.mr_n63943008)
print v(xbgr.mr_n63943328)
print v(xbgr.mr_n63943440)
print v(xbgr.mr_n63943760)
print v(xbgr.mr_n63943872)
print v(xbgr.mr_n63945488)
print v(xbgr.mr_n63946464)
print v(xbgr.mr_n63946896)
print v(xbgr.mr_n63947328)
print v(xbgr.mr_n63947648)
print v(xbgr.mr_n63947760)
print v(xbgr.mr_n63948080)
print v(xbgr.mr_n63948192)
print v(xbgr.mr_n63948512)
print v(xbgr.mr_n63948624)
print v(xbgr.mr_n63948944)
print v(xbgr.mr_n63949056)
print v(xbgr.mr_n63949376)
print v(xbgr.mr_n63949488)
print v(xbgr.mr_n63949808)
print v(xbgr.mr_n63949920)
print v(xbgr.mr_n63950240)
print v(xbgr.mr_n63950352)
print v(xbgr.mr_n63950784)
print v(xbgr.mr_n63951104)
print v(xbgr.mr_n63951216)
print v(xbgr.mr_n63951648)
print v(xbgr.mr_n63952080)
print v(xbgr.mr_n63953264)
print v(xbgr.mr_n63953376)
print v(xbgr.mr_n63953696)
print v(xbgr.mr_n63953808)
print v(xbgr.mr_n63954128)
print v(xbgr.mr_n63954240)
print v(xbgr.mr_n63954560)
print v(xbgr.mr_n63954672)
print v(xbgr.mr_n63954992)
print v(xbgr.mr_n63955104)
print v(xbgr.mr_n63955424)
print v(xbgr.mr_n63955856)
print v(xbgr.mr_n63955968)
print v(xbgr.mr_n63956288)
print v(xbgr.mr_n63956400)
print v(xbgr.mr_n63956720)
print v(xbgr.mr_n63956832)
print v(xbgr.mr_n63957152)
print v(xbgr.mr_n63957264)
print v(xbgr.mr_n63957696)
print v(xbgr.mr_n63958016)
print v(xbgr.mr_n63958448)
print v(xbgr.mr_n63959312)
print v(xbgr.mr_n63959424)
print v(xbgr.mr_n63959744)
print v(xbgr.mr_n63960176)
print v(xbgr.mr_n63960608)
print v(xbgr.mr_n63961152)
print v(xbgr.mr_n63961472)
print v(xbgr.mr_n63962336)
print v(xbgr.mr_n63962448)
print v(xbgr.mr_n63962768)
print v(xbgr.mr_n63962880)
print v(xbgr.mr_n63963312)
print v(xbgr.mr_n63964064)
print v(xbgr.mr_n63964496)
print v(xbgr.mr_n63964928)
print v(xbgr.mr_n63965360)
print v(xbgr.mr_n63965472)
print v(xbgr.mr_n63966656)
print v(xbgr.mr_n63967520)
print v(xbgr.mr_n63968496)
print v(xbgr.mr_n63968816)
print v(xbgr.mr_n63968928)
print v(xbgr.mr_n63969360)
print v(xbgr.mr_n63969680)
print v(xbgr.mr_n63969792)
print v(xbgr.mr_n63970112)
print v(xbgr.mr_n63970224)
print v(xbgr.mr_n63970544)
print v(xbgr.mr_n63970656)
print v(xbgr.mr_n63970976)
print v(xbgr.mr_n63971088)
print v(xbgr.mr_n63971408)
print v(xbgr.mr_n63971520)
print v(xbgr.mr_n63971840)
print v(xbgr.mr_n63971952)
print v(xbgr.mr_n63972384)
print v(xbgr.mr_n63972816)
print v(xbgr.mr_n63973248)
print v(xbgr.mr_n63974000)
print v(xbgr.mr_n63974432)
print v(xbgr.mr_n63975296)
print v(xbgr.mr_n63976160)
print v(xbgr.mr_n63977888)
print v(xbgr.mr_n63978752)
print v(xbgr.mr_n63978864)
print v(xbgr.mr_n63979616)
print v(xbgr.mr_n63979728)
print v(xbgr.mr_n63980048)
print v(xbgr.mr_n63980160)
print v(xbgr.mr_n63980480)
print v(xbgr.mr_n63980592)
print v(xbgr.mr_n63982640)
print v(xbgr.mr_n63982752)
print v(xbgr.mr_n63983072)
print v(xbgr.mr_n63983184)
print v(xbgr.mr_n63983504)
print v(xbgr.mr_n63983616)
print v(xbgr.mr_n63983936)
print v(xbgr.mr_n63984048)
print v(xbgr.mr_n63984368)
print v(xbgr.mr_n63984480)
print v(xbgr.mr_n63984800)
print v(xbgr.mr_n63984912)
print v(xbgr.mr_n63985232)
print v(xbgr.mr_n63985344)
print v(xbgr.mr_n63985776)
print v(xbgr.mr_n63986096)
print v(xbgr.mr_n63986208)
print v(xbgr.mr_n63986640)
print v(xbgr.mr_n63986960)
print v(xbgr.mr_n63987072)
print v(xbgr.mr_n63987504)
print v(xbgr.mr_n63987824)
print v(xbgr.mr_n63987936)
print v(xbgr.mr_n63988256)
print v(xbgr.mr_n63988368)
print v(xbgr.mr_n63988688)
print v(xbgr.mr_n63988800)
print v(xbgr.mr_n63989120)
print v(xbgr.mr_n63989232)
print v(xbgr.mr_n63989552)
print v(xbgr.mr_n63989664)
print v(xbgr.mr_n63989984)
print v(xbgr.mr_n63990096)
print v(xbgr.mr_n63990416)
print v(xbgr.mr_n63990528)
print v(xbgr.mr_n63990848)
print v(xbgr.mr_n63990960)
print v(xbgr.mr_n63991280)
print v(xbgr.mr_n63991392)
print v(xbgr.mr_n63991712)
print v(xbgr.mr_n63991824)
print v(xbgr.mr_n63992144)
print v(xbgr.mr_n63992256)
print v(xbgr.mr_n63992576)
print v(xbgr.mr_n63992688)
print v(xbgr.mr_n63993008)
print v(xbgr.mr_n63993120)
print v(xbgr.mr_n63993440)
print v(xbgr.mr_n63993552)
print v(xbgr.mr_n63993872)
print v(xbgr.mr_n63993984)
print v(xbgr.mr_n63994304)
print v(xbgr.mr_n63994416)
print v(xbgr.mr_n63994736)
print v(xbgr.mr_n63994848)
print v(xbgr.mr_n63995168)
print v(xbgr.mr_n63995280)
print v(xbgr.mr_n63995712)
print v(xbgr.mr_n63996032)
print v(xbgr.mr_n63996144)
print v(xbgr.mr_n63996576)
print v(xbgr.mr_n63996896)
print v(xbgr.mr_n63997008)
print v(xbgr.mr_n63997440)
print v(xbgr.mr_n63997760)
print v(xbgr.mr_n63998624)
print v(xbgr.mr_n63999488)
print v(xbgr.mr_n64000352)
print v(xbgr.mr_n64001216)
print v(xbgr.mr_n64002080)
print v(xbgr.mr_n64002944)
print v(xbgr.mr_n64003056)
print v(xbgr.mr_n64003376)
print v(xbgr.mr_n64003488)
print v(xbgr.mr_n64003808)
print v(xbgr.mr_n64003920)
print v(xbgr.mr_n64004240)
print v(xbgr.mr_n64004352)
print v(xbgr.mr_n64004672)
print v(xbgr.mr_n64004784)
print v(xbgr.mr_n64005104)
print v(xbgr.mr_n64005216)
print v(xbgr.mr_n64005536)
print v(xbgr.mr_n64006400)
print v(xbgr.mr_n64007264)
print v(xbgr.mr_n64008128)
print v(xbgr.mr_n64008240)
print v(xbgr.mr_n64008560)
print v(xbgr.mr_n64008672)
print v(xbgr.mr_n64008992)
print v(xbgr.mr_n64009104)
print v(xbgr.mr_n64009536)
print v(xbgr.mr_n64009968)
print v(xbgr.mr_n64010400)
print v(xbgr.mr_n64010720)
print v(xbgr.mr_n64010832)
print v(xbgr.mr_n64011264)
print v(xbgr.mr_n64011584)
print v(xbgr.mr_n64011696)
print v(xbgr.mr_n64012016)
print v(xbgr.mr_n64012128)
print v(xbgr.mr_n64012448)
print v(xbgr.mr_n64012560)
print v(xbgr.mr_n64012880)
print v(xbgr.mr_n64012992)
print v(xbgr.mr_n64013312)
print v(xbgr.mr_n64013424)
print v(xbgr.mr_n64013744)
print v(xbgr.mr_n64013856)
print v(xbgr.mr_n64014288)
print v(xbgr.mr_n64014720)
print v(xbgr.mr_n64015040)
print v(xbgr.mr_n64015152)
print v(xbgr.mr_n64015584)
print v(xbgr.mr_n64015904)
print v(xbgr.mr_n64016016)
print v(xbgr.mr_n64016448)
print v(xbgr.mr_n64016768)
print v(xbgr.mr_n64016880)
print v(xbgr.mr_n64017312)
print v(xbgr.mr_n64017632)
print v(xbgr.mr_n64018496)
print v(xbgr.mr_n64019360)
print v(xbgr.mr_n64020224)
print v(xbgr.mr_n64021088)
print v(xbgr.mr_n64021952)
print v(xbgr.mr_n64022064)
print v(xbgr.mr_n64022384)
print v(xbgr.mr_n64022496)
print v(xbgr.mr_n64022816)
print v(xbgr.mr_n64022928)
print v(xbgr.mr_n64023248)
print v(xbgr.mr_n64023360)
print v(xbgr.mr_n64023680)
print v(xbgr.mr_n64024544)
print v(xbgr.mr_n64025408)
print v(xbgr.mr_n64026272)
print v(xbgr.mr_n64026384)
print v(xbgr.mr_n64026704)
print v(xbgr.mr_n64026816)
print v(xbgr.mr_n64027136)
print v(xbgr.mr_n64027248)
print v(xbgr.mr_n64027568)
print v(xbgr.mr_n64027680)
print v(xbgr.mr_n64028000)
print v(xbgr.mr_n64028112)
print v(xbgr.mr_n64028432)
print v(xbgr.mr_n64028544)
print v(xbgr.mr_n64028864)
print v(xbgr.mr_n64029728)
print v(xbgr.mr_n64030592)
print v(xbgr.mr_n64031456)
print v(xbgr.mr_n64032320)
print v(xbgr.mr_n64033184)
print v(xbgr.mr_n64034048)
print v(xbgr.mr_n64034912)
print v(xbgr.mr_n64035776)
print v(xbgr.mr_n64036640)
print v(xbgr.mr_n64036752)
print v(xbgr.mr_n64037072)
print v(xbgr.mr_n64037184)
print v(xbgr.mr_n64037504)
print v(xbgr.mr_n64037616)
print v(xbgr.mr_n64037936)
print v(xbgr.mr_n64038048)
print v(xbgr.mr_n64038368)
print v(xbgr.mr_n64038480)
print v(xbgr.mr_n64038800)
print v(xbgr.mr_n64038912)
print v(xbgr.mr_n64039232)
print v(xbgr.mr_n64039344)
print v(xbgr.mr_n64039664)
print v(xbgr.mr_n64039776)
print v(xbgr.mr_n64040096)
print v(xbgr.mr_n64040208)
print v(xbgr.mr_n64040528)
print v(xbgr.mr_n64040640)
print v(xbgr.mr_n64040960)
print v(xbgr.mr_n64041824)
print v(xbgr.mr_n64041936)
print v(xbgr.mr_n64042256)
print v(xbgr.mr_n64042368)
print v(xbgr.mr_n64042688)
print v(xbgr.mr_n64042800)
print v(xbgr.mr_n64043120)
print v(xbgr.mr_n64043232)
print v(xbgr.mr_n64043552)
print v(xbgr.mr_n64043664)
print v(xbgr.mr_n64043984)
print v(xbgr.mr_n64044096)
print v(xbgr.mr_n64044416)
print v(xbgr.mr_n64044528)
print v(xbgr.mr_n64044848)
print v(xbgr.mr_n64044960)
print v(xbgr.mr_n64045280)
print v(xbgr.mr_n64045392)
print v(xbgr.mr_n64045712)
print v(xbgr.mr_n64045824)
print v(xbgr.mr_n64046144)
print v(xbgr.mr_n64046256)
print v(xbgr.mr_n64046688)
print v(xbgr.mr_n64047008)
print v(xbgr.mr_n64047120)
print v(xbgr.mr_n64047552)
print v(xbgr.mr_n64047872)
print v(xbgr.mr_n64047984)
print v(xbgr.mr_n64048416)
print v(xbgr.mr_n64048736)
print v(xbgr.mr_n64048848)
print v(xbgr.mr_n64049280)
print v(xbgr.mr_n64049600)
print v(xbgr.mr_n64049712)
print v(xbgr.mr_n64050032)
print v(xbgr.mr_n64050144)
print v(xbgr.mr_n64050576)
print v(xbgr.mr_n64051008)
print v(xbgr.mr_n64051328)
print v(xbgr.mr_n64051440)
print v(xbgr.mr_n64051760)
print v(xbgr.mr_n64051872)
print v(xbgr.mr_n64052192)
print v(xbgr.mr_n64052304)
print v(xbgr.mr_n64052624)
print v(xbgr.mr_n64052736)
print v(xbgr.mr_n64053056)
print v(xbgr.mr_n64053168)
print v(xbgr.mr_n64053600)
print v(xbgr.mr_n64053920)
print v(xbgr.mr_n64054032)
print v(xbgr.mr_n64054464)
print v(xbgr.mr_n64054784)
print v(xbgr.mr_n64055648)
print v(xbgr.mr_n64056512)
print v(xbgr.mr_n64057376)
print v(xbgr.mr_n64058240)
print v(xbgr.mr_n64058352)
print v(xbgr.mr_n64058672)
print v(xbgr.mr_n64058784)
print v(xbgr.mr_n64059104)
print v(xbgr.mr_n64059216)
print v(xbgr.mr_n64059536)
print v(xbgr.mr_n64059648)
print v(xbgr.mr_n64059968)
print v(xbgr.mr_n64060832)
print v(xbgr.mr_n64061696)
print v(xbgr.mr_n64061808)
print v(xbgr.mr_n64062128)
print v(xbgr.mr_n64062240)
print v(xbgr.mr_n64062672)
print v(xbgr.mr_n64063104)
print v(xbgr.mr_n64063424)
print v(xbgr.mr_n64063536)
print v(xbgr.mr_n64063856)
print v(xbgr.mr_n64063968)
print v(xbgr.mr_n64064288)
print v(xbgr.mr_n64064400)
print v(xbgr.mr_n64064720)
print v(xbgr.mr_n64064832)
print v(xbgr.mr_n64065152)
print v(xbgr.mr_n64065264)
print v(xbgr.mr_n64065696)
print v(xbgr.mr_n64066016)
print v(xbgr.mr_n64066128)
print v(xbgr.mr_n64066560)
print v(xbgr.mr_n64066880)
print v(xbgr.mr_n64066992)
print v(xbgr.mr_n64067312)
print v(xbgr.mr_n64067424)
print v(xbgr.mr_n64067744)
print v(xbgr.mr_n64067856)
print v(xbgr.mr_n64068176)
print v(xbgr.mr_n64068288)
print v(xbgr.mr_n64068608)
print v(xbgr.mr_n64068720)
print v(xbgr.mr_n64069040)
print v(xbgr.mr_n64069152)
print v(xbgr.mr_n64069472)
print v(xbgr.mr_n64069584)
print v(xbgr.mr_n64069904)
print v(xbgr.mr_n64070016)
print v(xbgr.mr_n64070336)
print v(xbgr.mr_n64070448)
print v(xbgr.mr_n64070768)
print v(xbgr.mr_n64070880)
print v(xbgr.mr_n64071200)
print v(xbgr.mr_n64072064)
print v(xbgr.mr_n64072928)
print v(xbgr.mr_n64073792)
print v(xbgr.mr_n64074656)
print v(xbgr.mr_n64074768)
print v(xbgr.mr_n64075088)
print v(xbgr.mr_n64075200)
print v(xbgr.mr_n64075520)
print v(xbgr.mr_n64075632)
print v(xbgr.mr_n64075952)
print v(xbgr.mr_n64076064)
print v(xbgr.mr_n64076496)
print v(xbgr.mr_n64076928)
print v(xbgr.mr_n64077360)
print v(xbgr.mr_n64077792)
print v(xbgr.mr_n64078112)
print v(xbgr.mr_n64078224)
print v(xbgr.mr_n64078544)
print v(xbgr.mr_n64078656)
print v(xbgr.mr_n64078976)
print v(xbgr.mr_n64079088)
print v(xbgr.mr_n64079408)
print v(xbgr.mr_n64079520)
print v(xbgr.mr_n64079840)
print v(xbgr.mr_n64080704)
print v(xbgr.mr_n64081568)
print v(xbgr.mr_n64081680)
print v(xbgr.mr_n64082112)
print v(xbgr.mr_n64082432)
print v(xbgr.mr_n64083296)
print v(xbgr.mr_n64083408)
print v(xbgr.mr_n64083728)
print v(xbgr.mr_n64083840)
print v(xbgr.mr_n64084160)
print v(xbgr.mr_n64084272)
print v(xbgr.mr_n64084592)
print v(xbgr.mr_n64084704)
print v(xbgr.mr_n64085024)
print v(xbgr.mr_n64085888)
print v(xbgr.mr_n64086000)
print v(xbgr.mr_n64086432)
print v(xbgr.mr_n64086752)
print v(xbgr.mr_n64086864)
print v(xbgr.mr_n64087184)
print v(xbgr.mr_n64087296)
print v(xbgr.mr_n64087616)
print v(xbgr.mr_n64087728)
print v(xbgr.mr_n64088048)
print v(xbgr.mr_n64088160)
print v(xbgr.mr_n64088480)
print v(xbgr.mr_n64089344)
print v(xbgr.mr_n64089776)
print v(xbgr.mr_n64089888)
print v(xbgr.mr_n64090208)
print v(xbgr.mr_n64090320)
print v(xbgr.mr_n64090640)
print v(xbgr.mr_n64091072)
print v(xbgr.mr_n64091936)
print v(xbgr.mr_n64092800)
print v(xbgr.mr_n64092912)
print v(xbgr.mr_n64093664)
print v(xbgr.mr_n64093776)
print v(xbgr.mr_n64094096)
print v(xbgr.mr_n64094208)
print v(xbgr.mr_n64094528)
print v(xbgr.mr_n64095392)
print v(xbgr.mr_n64096256)
print v(xbgr.mr_n64096368)
print v(xbgr.mr_n64096688)
print v(xbgr.mr_n64096800)
print v(xbgr.mr_n64097120)
print v(xbgr.mr_n64097984)
print v(xbgr.mr_n64098096)
print v(xbgr.mr_n64098416)
print v(xbgr.mr_n64098528)
print v(xbgr.mr_n64098848)
print v(xbgr.mr_n64098960)
print v(xbgr.mr_n64099280)
print v(xbgr.mr_n64099392)
print v(xbgr.mr_n64099712)
print v(xbgr.mr_n64099824)
print v(xbgr.mr_n64100576)
print v(xbgr.mr_n64101440)
print v(xbgr.mr_n64102304)
print v(xbgr.mr_n64102416)
print v(xbgr.mr_n64102736)
print v(xbgr.mr_n64102848)
print v(xbgr.mr_n64103168)
print v(xbgr.mr_n64103280)
print v(xbgr.mr_n64103600)
print v(xbgr.mr_n64103712)
print v(xbgr.mr_n64104032)
print v(xbgr.mr_n64104144)
print v(xbgr.mr_n64104464)
print v(xbgr.mr_n64104576)
print v(xbgr.mr_n64104896)
print v(xbgr.mr_n64105008)
print v(xbgr.mr_n64105440)
print v(xbgr.mr_n64105760)
print v(xbgr.mr_n64105872)
print v(xbgr.mr_n64106192)
print v(xbgr.mr_n64106304)
print v(xbgr.mr_n64106624)
print v(xbgr.mr_n64107488)
print v(xbgr.mr_n64108352)
print v(xbgr.mr_n64109216)
print v(xbgr.mr_n64110080)
print v(xbgr.mr_n64110512)
print v(xbgr.mr_n64110624)
print v(xbgr.mr_n64110944)
print v(xbgr.mr_n64111056)
print v(xbgr.mr_n64111376)
print v(xbgr.mr_n64111488)
print v(xbgr.mr_n64111920)
print v(xbgr.mr_n64112672)
print v(xbgr.mr_n64112784)
print v(xbgr.mr_n64113104)
print v(xbgr.mr_n64113216)
print v(xbgr.mr_n64113536)
print v(xbgr.mr_n64114400)
print v(xbgr.mr_n64115264)
print v(xbgr.mr_n64115376)
print v(xbgr.mr_n64115696)
print v(xbgr.mr_n64115808)
print v(xbgr.mr_n64116128)
print v(xbgr.mr_n64116992)
print v(xbgr.mr_n64117856)
print v(xbgr.mr_n64118720)
print v(xbgr.mr_n64118832)
print v(xbgr.mr_n64119152)
print v(xbgr.mr_n64119264)
print v(xbgr.mr_n64119584)
print v(xbgr.mr_n64120448)
print v(xbgr.mr_n64121312)
print v(xbgr.mr_n64121424)
print v(xbgr.mr_n64121744)
print v(xbgr.mr_n64121856)
print v(xbgr.mr_n64122176)
print v(xbgr.mr_n64122288)
print v(xbgr.mr_n64122608)
print v(xbgr.mr_n64122720)
print v(xbgr.mr_n64123040)
print v(xbgr.mr_n64123152)
print v(xbgr.mr_n64123472)
print v(xbgr.mr_n64123584)
print v(xbgr.mr_n64123904)
print v(xbgr.mr_n64124016)
print v(xbgr.mr_n64124336)
print v(xbgr.mr_n64124448)
print v(xbgr.mr_n64124768)
print v(xbgr.mr_n64124880)
print v(xbgr.mr_n64125200)
print v(xbgr.mr_n64125312)
print v(xbgr.mr_n64125632)
print v(xbgr.mr_n64125744)
print v(xbgr.mr_n64126064)
print v(xbgr.mr_n64126176)
print v(xbgr.mr_n64126496)
print v(xbgr.mr_n64126608)
print v(xbgr.mr_n64126928)
print v(xbgr.mr_n64127040)
print v(xbgr.mr_n64127360)
print v(xbgr.mr_n64127472)
print v(xbgr.mr_n64127792)
print v(xbgr.mr_n64127904)
print v(xbgr.mr_n64128224)
print v(xbgr.mr_n64128336)
print v(xbgr.mr_n64128656)
print v(xbgr.mr_n64128768)
print v(xbgr.mr_n64129088)
print v(xbgr.mr_n64129200)
print v(xbgr.mr_n64129520)
print v(xbgr.mr_n64129632)
print v(xbgr.mr_n64129952)
print v(xbgr.mr_n64130064)
print v(xbgr.mr_n64130384)
print v(xbgr.mr_n64130496)
print v(xbgr.mr_n64130816)
print v(xbgr.mr_n64130928)
print v(xbgr.mr_n64131248)
print v(xbgr.mr_n64131360)
print v(xbgr.mr_n64131680)
print v(xbgr.mr_n64131792)
print v(xbgr.mr_n64132112)
print v(xbgr.mr_n64132224)
print v(xbgr.mr_n64132656)
print v(xbgr.mr_n64133088)
print v(xbgr.mr_n64133520)
print v(xbgr.mr_n64133952)
print v(xbgr.mr_n64134384)
print v(xbgr.mr_n64134816)
print v(xbgr.mr_n64135248)
print v(xbgr.mr_n64135680)
print v(xbgr.mr_n64136112)
print v(xbgr.mr_n64136544)
print v(xbgr.mr_n64136976)
print v(xbgr.mr_n64137408)
print v(xbgr.mr_n64137840)
print v(xbgr.mr_n64138272)
print v(xbgr.mr_n64138704)
print v(xbgr.mr_n64139136)
print v(xbgr.mr_n64139568)
print v(xbgr.mr_n64140000)
print v(xbgr.mr_n64140432)
print v(xbgr.mr_n64140864)
print v(xbgr.mr_n64141296)
print v(xbgr.mr_n64141728)
print v(xbgr.mr_n64142160)
print v(xbgr.mr_n64142592)
print v(xbgr.mr_n64143024)
print v(xbgr.mr_n64143456)
print v(xbgr.mr_n64143776)
print v(xbgr.mr_n64143888)
print v(xbgr.mr_n64144208)
print v(xbgr.mr_n64144320)
print v(xbgr.mr_n64144640)
print v(xbgr.mr_n64144752)
print v(xbgr.mr_n64145072)
print v(xbgr.mr_n64145184)
print v(xbgr.mr_n64145504)
print v(xbgr.mr_n64145616)
print v(xbgr.mr_n64145936)
print v(xbgr.mr_n64146048)
print v(xbgr.mr_n64146368)
print v(xbgr.mr_n64146480)
print v(xbgr.mr_n64146800)
print v(xbgr.mr_n64146912)
print v(xbgr.mr_n64147232)
print v(xbgr.mr_n64147344)
print v(xbgr.mr_n64147664)
print v(xbgr.mr_n64147776)
print v(xbgr.mr_n64148096)
print v(xbgr.mr_n64148208)
print v(xbgr.mr_n64148528)
print v(xbgr.mr_n64148640)
print v(xbgr.mr_n64148960)
print v(xbgr.mr_n64149072)
print v(xbgr.mr_n64149392)
print v(xbgr.mr_n64149504)
print v(xbgr.mr_n64149824)
print v(xbgr.mr_n64149936)
print v(xbgr.mr_n64150256)
print v(xbgr.mr_n64150368)
print v(xbgr.mr_n64150688)
print v(xbgr.mr_n64150800)
print v(xbgr.mr_n64151120)
print v(xbgr.mr_n64151232)
print v(xbgr.mr_n64151552)
print v(xbgr.mr_n64151664)
print v(xbgr.mr_n64151984)
print v(xbgr.mr_n64152096)
print v(xbgr.mr_n64152416)
print v(xbgr.mr_n64152528)
print v(xbgr.mr_n64152848)
print v(xbgr.mr_n64152960)
print v(xbgr.mr_n64153280)
print v(xbgr.mr_n64153392)
print v(xbgr.mr_n64153712)
print v(xbgr.mr_n64153824)
print v(xbgr.mr_n64154256)
print v(xbgr.mr_n64154688)
print v(xbgr.mr_n64155120)
print v(xbgr.mr_n64155552)
print v(xbgr.mr_n64155872)
print v(xbgr.mr_n64155984)
print v(xbgr.mr_n64156304)
print v(xbgr.mr_n64156416)
print v(xbgr.mr_n64156848)
print v(xbgr.mr_n64157280)
print v(xbgr.mr_n64157712)
print v(xbgr.mr_n64158144)
print v(xbgr.mr_n64158576)
print v(xbgr.mr_n64159008)
print v(xbgr.mr_n64159440)
print v(xbgr.mr_n64159872)
print v(xbgr.mr_n64160304)
print v(xbgr.mr_n64160736)
print v(xbgr.mr_n64161168)
print v(xbgr.mr_n64161600)
print v(xbgr.mr_n64162032)
print v(xbgr.mr_n64162464)
print v(xbgr.mr_n64162896)
print v(xbgr.mr_n64163328)
print v(xbgr.mr_n64163760)
print v(xbgr.mr_n64164192)
print v(xbgr.mr_n64164624)
print v(xbgr.mr_n64165056)
print v(xbgr.mr_n64165488)
print v(xbgr.mr_n64165920)
print v(xbgr.mr_n64166240)
print v(xbgr.mr_n64166352)
print v(xbgr.mr_n64166784)
print v(xbgr.mr_n64167104)
print v(xbgr.mr_n64167216)
print v(xbgr.mr_n64167648)
print v(xbgr.mr_n64167968)
print v(xbgr.mr_n64168080)
print v(xbgr.mr_n64168512)
print v(xbgr.mr_n64168832)
print v(xbgr.mr_n64168944)
print v(xbgr.mr_n64169376)
print v(xbgr.mr_n64169696)
print v(xbgr.mr_n64169808)
print v(xbgr.mr_n64170240)
print v(xbgr.mr_n64170560)
print v(xbgr.mr_n64170672)
print v(xbgr.mr_n64170992)
print v(xbgr.mr_n64171104)
print v(xbgr.mr_n64171424)
print v(xbgr.mr_n64171536)
print v(xbgr.mr_n64171968)
print v(xbgr.mr_n64172400)
print v(xbgr.mr_n64172832)
print v(xbgr.mr_n64173152)
print v(xbgr.mr_n64173264)
print v(xbgr.mr_n64173584)
print v(xbgr.mr_n64173696)
print v(xbgr.mr_n64174016)
print v(xbgr.mr_n64174128)
print v(xbgr.mr_n64174448)
print v(xbgr.mr_n64174560)
print v(xbgr.mr_n64174880)
print v(xbgr.mr_n64174992)
print v(xbgr.mr_n64175312)
print v(xbgr.mr_n64175424)
print v(xbgr.mr_n64175744)
print v(xbgr.mr_n64175856)
print v(xbgr.mr_n64176288)
print v(xbgr.mr_n64176608)
print v(xbgr.mr_n64176720)
print v(xbgr.mr_n64177152)
print v(xbgr.mr_n64177472)
print v(xbgr.mr_n64177584)
print v(xbgr.mr_n64178016)
print v(xbgr.mr_n64178336)
print v(xbgr.mr_n64179200)
print v(xbgr.mr_n64180064)
print v(xbgr.mr_n64180928)
print v(xbgr.mr_n64181792)
print v(xbgr.mr_n64182656)
print v(xbgr.mr_n64183520)
print v(xbgr.mr_n64183632)
print v(xbgr.mr_n64183952)
print v(xbgr.mr_n64184064)
print v(xbgr.mr_n64184384)
print v(xbgr.mr_n64184496)
print v(xbgr.mr_n64184816)
print v(xbgr.mr_n64184928)
print v(xbgr.mr_n64185248)
print v(xbgr.mr_n64186112)
print v(xbgr.mr_n64186976)
print v(xbgr.mr_n64187840)
print v(xbgr.mr_n64187952)
print v(xbgr.mr_n64188272)
print v(xbgr.mr_n64188384)
print v(xbgr.mr_n64188704)
print v(xbgr.mr_n64188816)
print v(xbgr.mr_n64189248)
print v(xbgr.mr_n64189680)
print v(xbgr.mr_n64190112)
print v(xbgr.mr_n64190432)
print v(xbgr.mr_n64190544)
print v(xbgr.mr_n64190864)
print v(xbgr.mr_n64190976)
print v(xbgr.mr_n64191296)
print v(xbgr.mr_n64191408)
print v(xbgr.mr_n64191728)
print v(xbgr.mr_n64191840)
print v(xbgr.mr_n64192160)
print v(xbgr.mr_n64192272)
print v(xbgr.mr_n64192592)
print v(xbgr.mr_n64192704)
print v(xbgr.mr_n64193024)
print v(xbgr.mr_n64193136)
print v(xbgr.mr_n64193456)
print v(xbgr.mr_n64193568)
print v(xbgr.mr_n64193888)
print v(xbgr.mr_n64194000)
print v(xbgr.mr_n64194432)
print v(xbgr.mr_n64194752)
print v(xbgr.mr_n64194864)
print v(xbgr.mr_n64195296)
print v(xbgr.mr_n64195616)
print v(xbgr.mr_n64195728)
print v(xbgr.mr_n64196048)
print v(xbgr.mr_n64196160)
print v(xbgr.mr_n64196480)
print v(xbgr.mr_n64197344)
print v(xbgr.mr_n64198208)
print v(xbgr.mr_n64198320)
print v(xbgr.mr_n64198640)
print v(xbgr.mr_n64198752)
print v(xbgr.mr_n64199072)
print v(xbgr.mr_n64199936)
print v(xbgr.mr_n64200480)
print v(xbgr.mr_n64200912)
print v(xbgr.mr_n64201664)
print v(xbgr.mr_n64202528)
print v(xbgr.mr_n64202640)
print v(xbgr.mr_n64202960)
print v(xbgr.mr_n64203072)
print v(xbgr.mr_n64203392)
print v(xbgr.mr_n64203504)
print v(xbgr.mr_n64203824)
print v(xbgr.mr_n64203936)
print v(xbgr.mr_n64204256)
print v(xbgr.mr_n64204368)
print v(xbgr.mr_n64204688)
print v(xbgr.mr_n64204800)
print v(xbgr.mr_n64205120)
print v(xbgr.mr_n64205232)
print v(xbgr.mr_n64205552)
print v(xbgr.mr_n64205664)
print v(xbgr.mr_n64205984)
print v(xbgr.mr_n64206848)
print v(xbgr.mr_n64206960)
print v(xbgr.mr_n64207280)
print v(xbgr.mr_n64207392)
print v(xbgr.mr_n64207712)
print v(xbgr.mr_n64208576)
print v(xbgr.mr_n64209440)
print v(xbgr.mr_n64209552)
print v(xbgr.mr_n64209872)
print v(xbgr.mr_n64209984)
print v(xbgr.mr_n64210304)
print v(xbgr.mr_n64210416)
print v(xbgr.mr_n64210848)
print v(xbgr.mr_n64211168)
print v(xbgr.mr_n64211600)
print v(xbgr.mr_n64212896)
print v(xbgr.mr_n64213008)
print v(xbgr.mr_n64213328)
print v(xbgr.mr_n64213440)
print v(xbgr.mr_n64213760)
print v(xbgr.mr_n64213872)
print v(xbgr.mr_n64214192)
print v(xbgr.mr_n64214304)
print v(xbgr.mr_n64214624)
print v(xbgr.mr_n64214736)
print v(xbgr.mr_n64215168)
print v(xbgr.mr_n64215488)
print v(xbgr.mr_n64215600)
print v(xbgr.mr_n64215920)
print v(xbgr.mr_n64216032)
print v(xbgr.mr_n64216352)
print v(xbgr.mr_n64216464)
print v(xbgr.mr_n64216784)
print v(xbgr.mr_n64216896)
print v(xbgr.mr_n64217216)
print v(xbgr.mr_n64218080)
print v(xbgr.mr_n64218944)
print v(xbgr.mr_n64219808)
print v(xbgr.mr_n64220672)
print v(xbgr.mr_n64220784)
print v(xbgr.mr_n64221104)
print v(xbgr.mr_n64221216)
print v(xbgr.mr_n64221536)
print v(xbgr.mr_n64221648)
print v(xbgr.mr_n64221968)
print v(xbgr.mr_n64222080)
print v(xbgr.mr_n64222400)
print v(xbgr.mr_n64223264)
print v(xbgr.mr_n64224128)
print v(xbgr.mr_n64224992)
print v(xbgr.mr_n64225856)
print v(xbgr.mr_n64226288)
print v(xbgr.mr_n64226400)
print v(xbgr.mr_n64226720)
print v(xbgr.mr_n64226832)
print v(xbgr.mr_n64227152)
print v(xbgr.mr_n64227264)
print v(xbgr.mr_n64227584)
print v(xbgr.mr_n64227696)
print v(xbgr.mr_n64228016)
print v(xbgr.mr_n64228128)
print v(xbgr.mr_n64228448)
print v(xbgr.mr_n64228560)
print v(xbgr.mr_n64228880)
print v(xbgr.mr_n64228992)
print v(xbgr.mr_n64229312)
print v(xbgr.mr_n64229424)
print v(xbgr.mr_n64229856)
print v(xbgr.mr_n64230176)
print v(xbgr.mr_n64230288)
print v(xbgr.mr_n64230720)
print v(xbgr.mr_n64231040)
print v(xbgr.mr_n64231152)
print v(xbgr.mr_n64231584)
print v(xbgr.mr_n64231904)
print v(xbgr.mr_n64232016)
print v(xbgr.mr_n64232336)
print v(xbgr.mr_n64232448)
print v(xbgr.mr_n64232768)
print v(xbgr.mr_n64233632)
print v(xbgr.mr_n64234496)
print v(xbgr.mr_n64235360)
print v(xbgr.mr_n64236224)
print v(xbgr.mr_n64237088)
print v(xbgr.mr_n64237952)
print v(xbgr.mr_n64238816)
print v(xbgr.mr_n64239680)
print v(xbgr.mr_n64240544)
print v(xbgr.mr_n64240656)
print v(xbgr.mr_n64240976)
print v(xbgr.mr_n64241088)
print v(xbgr.mr_n64241408)
print v(xbgr.mr_n64242272)
print v(xbgr.mr_n64242384)
print v(xbgr.mr_n64242704)
print v(xbgr.mr_n64242816)
print v(xbgr.mr_n64243136)
print v(xbgr.mr_n64243248)
print v(xbgr.mr_n64243568)
print v(xbgr.mr_n64243680)
print v(xbgr.mr_n64244000)
print v(xbgr.mr_n64244112)
print v(xbgr.mr_n64244432)
print v(xbgr.mr_n64244544)
print v(xbgr.mr_n64244864)
print v(xbgr.mr_n64244976)
print v(xbgr.mr_n64245296)
print v(xbgr.mr_n64245408)
print v(xbgr.mr_n64245728)
print v(xbgr.mr_n64246592)
print v(xbgr.mr_n64247456)
print v(xbgr.mr_n64248320)
print v(xbgr.mr_n64248432)
print v(xbgr.mr_n64248752)
print v(xbgr.mr_n64250048)
print v(xbgr.mr_n64250912)
print v(xbgr.mr_n64251776)
print v(xbgr.mr_n64252640)
print v(xbgr.mr_n64252752)
print v(xbgr.mr_n64253072)
print v(xbgr.mr_n64253184)
print v(xbgr.mr_n64253616)
print v(xbgr.mr_n64253936)
print v(xbgr.mr_n64254048)
print v(xbgr.mr_n64254480)
print v(xbgr.mr_n64254800)
print v(xbgr.mr_n64254912)
print v(xbgr.mr_n64255344)
print v(xbgr.mr_n64255664)
print v(xbgr.mr_n64255776)
print v(xbgr.mr_n64256208)
print v(xbgr.mr_n64256528)
print v(xbgr.mr_n64256640)
print v(xbgr.mr_n64257072)
print v(xbgr.mr_n64257392)
print v(xbgr.mr_n64257504)
print v(xbgr.mr_n64257824)
print v(xbgr.mr_n64257936)
print v(xbgr.mr_n64258256)
print v(xbgr.mr_n64258368)
print v(xbgr.mr_n64258800)
print v(xbgr.mr_n64259120)
print v(xbgr.mr_n64259232)
print v(xbgr.mr_n64259552)
print v(xbgr.mr_n64259664)
print v(xbgr.mr_n64259984)
print v(xbgr.mr_n64260096)
print v(xbgr.mr_n64260416)
print v(xbgr.mr_n64260528)
print v(xbgr.mr_n64260848)
print v(xbgr.mr_n64260960)
print v(xbgr.mr_n64261280)
print v(xbgr.mr_n64261392)
print v(xbgr.mr_n64261712)
print v(xbgr.mr_n64261824)
print v(xbgr.mr_n64262144)
print v(xbgr.mr_n64262256)
print v(xbgr.mr_n64262688)
print v(xbgr.mr_n64263008)
print v(xbgr.mr_n64263984)
print v(xbgr.mr_n64264416)
print v(xbgr.mr_n64264736)
print v(xbgr.mr_n64265600)
print v(xbgr.mr_n64265712)
print v(xbgr.mr_n64266032)
print v(xbgr.mr_n64266144)
print v(xbgr.mr_n64266464)
print v(xbgr.mr_n64266576)
print v(xbgr.mr_n64266896)
print v(xbgr.mr_n64267008)
print v(xbgr.mr_n64267328)
print v(xbgr.mr_n64268192)
print v(xbgr.mr_n64268624)
print v(xbgr.mr_n64269488)
print v(xbgr.mr_n64270352)
print v(xbgr.mr_n64270464)
print v(xbgr.mr_n64270784)
print v(xbgr.mr_n64270896)
print v(xbgr.mr_n64271216)
print v(xbgr.mr_n64271328)
print v(xbgr.mr_n64271648)
print v(xbgr.mr_n64271760)
print v(xbgr.mr_n64272512)
print v(xbgr.mr_n64272624)
print v(xbgr.mr_n64272944)
print v(xbgr.mr_n64273056)
print v(xbgr.mr_n64273376)
print v(xbgr.mr_n64273488)
print v(xbgr.mr_n64273808)
print v(xbgr.mr_n64273920)
print v(xbgr.mr_n64274240)
print v(xbgr.mr_n64274784)
print v(xbgr.mr_n64275104)
print v(xbgr.mr_n64275216)
print v(xbgr.mr_n64275648)
print v(xbgr.mr_n64275968)
print v(xbgr.mr_n64276080)
print v(xbgr.mr_n64277264)
print v(xbgr.mr_n64277696)
print v(xbgr.mr_n64277808)
print v(xbgr.mr_n64278128)
print v(xbgr.mr_n64278240)
print v(xbgr.mr_n64278560)
print v(xbgr.mr_n64278672)
print v(xbgr.mr_n64278992)
print v(xbgr.mr_n64279104)
print v(xbgr.mr_n64279424)
print v(xbgr.mr_n64279536)
print v(xbgr.mr_n64279856)
print v(xbgr.mr_n64279968)
print v(xbgr.mr_n64280720)
print v(xbgr.mr_n64281584)
print v(xbgr.mr_n64281696)
print v(xbgr.mr_n64282016)
print v(xbgr.mr_n64282128)
print v(xbgr.mr_n64282448)
print v(xbgr.mr_n64282560)
print v(xbgr.mr_n64282880)
print v(xbgr.mr_n64282992)
print v(xbgr.mr_n64283312)
print v(xbgr.mr_n64283424)
print v(xbgr.mr_n64283744)
print v(xbgr.mr_n64283856)
print v(xbgr.mr_n64284176)
print v(xbgr.mr_n64284288)
print v(xbgr.mr_n64284608)
print v(xbgr.mr_n64284720)
print v(xbgr.mr_n64285040)
print v(xbgr.mr_n64285904)
print v(xbgr.mr_n64286768)
print v(xbgr.mr_n64287632)
print v(xbgr.mr_n64287744)
print v(xbgr.mr_n64288176)
print v(xbgr.mr_n64288608)
print v(xbgr.mr_n64288928)
print v(xbgr.mr_n64289360)
print v(xbgr.mr_n64289472)
print v(xbgr.mr_n64289792)
print v(xbgr.mr_n64289904)
print v(xbgr.mr_n64290656)
print v(xbgr.mr_n64292064)
print v(xbgr.mr_n64292384)
print v(xbgr.mr_n64292496)
print v(xbgr.mr_n64292816)
print v(xbgr.mr_n64292928)
print v(xbgr.mr_n64293248)
print v(xbgr.mr_n64293360)
print v(xbgr.mr_n64293792)
print v(xbgr.mr_n64294112)
print v(xbgr.mr_n64294224)
print v(xbgr.mr_n64294656)
print v(xbgr.mr_n64294976)
print v(xbgr.mr_n64295408)
print v(xbgr.mr_n64295840)
print v(xbgr.mr_n64295952)
print v(xbgr.mr_n64296272)
print v(xbgr.mr_n64296384)
print v(xbgr.mr_n64296704)
print v(xbgr.mr_n64296816)
print v(xbgr.mr_n64297568)
print v(xbgr.mr_n64298432)
print v(xbgr.mr_n64298544)
print v(xbgr.mr_n64298976)
print v(xbgr.mr_n64299296)
print v(xbgr.mr_n64300160)
print v(xbgr.mr_n64301024)
print v(xbgr.mr_n64302320)
print v(xbgr.mr_n64302752)
print v(xbgr.mr_n64302864)
print v(xbgr.mr_n64303184)
print v(xbgr.mr_n64303296)
print v(xbgr.mr_n64303616)
print v(xbgr.mr_n64303728)
print v(xbgr.mr_n64304048)
print v(xbgr.mr_n64304160)
print v(xbgr.mr_n64304480)
print v(xbgr.mr_n64304592)
print v(xbgr.mr_n64304912)
print v(xbgr.mr_n64305024)
print v(xbgr.mr_n64305344)
print v(xbgr.mr_n64305456)
print v(xbgr.mr_n64305776)
print v(xbgr.mr_n64305888)
print v(xbgr.mr_n64306640)
print v(xbgr.mr_n64307504)
print v(xbgr.mr_n64308368)
print v(xbgr.mr_n64308480)
print v(xbgr.mr_n64308800)
print v(xbgr.mr_n64308912)
print v(xbgr.mr_n64309232)
print v(xbgr.mr_n64309344)
print v(xbgr.mr_n64309664)
print v(xbgr.mr_n64310528)
print v(xbgr.mr_n64311392)
print v(xbgr.mr_n64312256)
print v(xbgr.mr_n64313120)
print v(xbgr.mr_n64313984)
print v(xbgr.mr_n64314848)
print v(xbgr.mr_n64314960)
print v(xbgr.mr_n64315280)
print v(xbgr.mr_n64316144)
print v(xbgr.mr_n64316256)
print v(xbgr.mr_n64316576)
print v(xbgr.mr_n64316688)
print v(xbgr.mr_n64317008)
print v(xbgr.mr_n64317872)
print v(xbgr.mr_n64318304)
print v(xbgr.mr_n64318416)
print v(xbgr.mr_n64319168)
print v(xbgr.mr_n64319280)
print v(xbgr.mr_n64319600)
print v(xbgr.mr_n64319712)
print v(xbgr.mr_n64320032)
print v(xbgr.mr_n64320144)
print v(xbgr.mr_n64320464)
print v(xbgr.mr_n64320576)
print v(xbgr.mr_n64320896)
print v(xbgr.mr_n64321008)
print v(xbgr.mr_n64321328)
print v(xbgr.mr_n64321440)
print v(xbgr.mr_n64321760)
print v(xbgr.mr_n64321872)
print v(xbgr.mr_n64322192)
print v(xbgr.mr_n64322304)
print v(xbgr.mr_n64322624)
print v(xbgr.mr_n64322736)
print v(xbgr.mr_n64323056)
print v(xbgr.mr_n64323600)
print v(xbgr.mr_n64324352)
print v(xbgr.mr_n64325216)
print v(xbgr.mr_n64326080)
print v(xbgr.mr_n64326192)
print v(xbgr.mr_n64326624)
print v(xbgr.mr_n64326944)
print v(xbgr.mr_n64327808)
print v(xbgr.mr_n64328672)
print v(xbgr.mr_n64329536)
print v(xbgr.mr_n64330400)
print v(xbgr.mr_n64331264)
print v(xbgr.mr_n64332128)
print v(xbgr.mr_n64332240)
print v(xbgr.mr_n64332560)
print v(xbgr.mr_n64332672)
print v(xbgr.mr_n64332992)
print v(xbgr.mr_n64333856)
print v(xbgr.mr_n64334720)
print v(xbgr.mr_n64334832)
print v(xbgr.mr_n64335152)
print v(xbgr.mr_n64335264)
print v(xbgr.mr_n64335584)
print v(xbgr.mr_n64335696)
print v(xbgr.mr_n64336016)
print v(xbgr.mr_n64336128)
print v(xbgr.mr_n64336448)
print v(xbgr.mr_n64336560)
print v(xbgr.mr_n64336880)
print v(xbgr.mr_n64336992)
print v(xbgr.mr_n64337312)
print v(xbgr.mr_n64337424)
print v(xbgr.mr_n64337744)
print v(xbgr.mr_n64338608)
print v(xbgr.mr_n64338720)
print v(xbgr.mr_n64339040)
print v(xbgr.mr_n64339152)
print v(xbgr.mr_n64339472)
print v(xbgr.mr_n64339584)
print v(xbgr.mr_n64339904)
print v(xbgr.mr_n64340016)
print v(xbgr.mr_n64340336)
print v(xbgr.mr_n64340448)
print v(xbgr.mr_n64340768)
print v(xbgr.mr_n64340880)
print v(xbgr.mr_n64341200)
print v(xbgr.mr_n64341312)
print v(xbgr.mr_n64341632)
print v(xbgr.mr_n64341744)
print v(xbgr.mr_n64342176)
print v(xbgr.mr_n64342608)
print v(xbgr.mr_n64343040)
print v(xbgr.mr_n64343360)
print v(xbgr.mr_n64343472)
print v(xbgr.mr_n64343792)
print v(xbgr.mr_n64343904)
print v(xbgr.mr_n64344224)
print v(xbgr.mr_n64344336)
print v(xbgr.mr_n64344656)
print v(xbgr.mr_n64344768)
print v(xbgr.mr_n64345088)
print v(xbgr.mr_n64345200)
print v(xbgr.mr_n64345520)
print v(xbgr.mr_n64345632)
print v(xbgr.mr_n64345952)
print v(xbgr.mr_n64346064)
print v(xbgr.mr_n64346384)
print v(xbgr.mr_n64346496)
print v(xbgr.mr_n64346816)
print v(xbgr.mr_n64346928)
print v(xbgr.mr_n64347248)
print v(xbgr.mr_n64347360)
print v(xbgr.mr_n64347680)
print v(xbgr.mr_n64347792)
print v(xbgr.mr_n64348112)
print v(xbgr.mr_n64348224)
print v(xbgr.mr_n64348544)
print v(xbgr.mr_n64348656)
print v(xbgr.mr_n64348976)
print v(xbgr.mr_n64349088)
print v(xbgr.mr_n64349408)
print v(xbgr.mr_n64349520)
print v(xbgr.mr_n64349840)
print v(xbgr.mr_n64349952)
print v(xbgr.mr_n64350384)
print v(xbgr.mr_n64350704)
print v(xbgr.mr_n64350816)
print v(xbgr.mr_n64351248)
print v(xbgr.mr_n64351680)
print v(xbgr.mr_n64352000)
print v(xbgr.mr_n64352112)
print v(xbgr.mr_n64352432)
print v(xbgr.mr_n64352544)
print v(xbgr.mr_n64352864)
print v(xbgr.mr_n64352976)
print v(xbgr.mr_n64353296)
print v(xbgr.mr_n64353408)
print v(xbgr.mr_n64353840)
print v(xbgr.mr_n64354272)
print v(xbgr.mr_n64354704)
print v(xbgr.mr_n64355136)
print v(xbgr.mr_n64355568)
print v(xbgr.mr_n64356000)
print v(xbgr.mr_n64356432)
print v(xbgr.mr_n64356864)
print v(xbgr.mr_n64357184)
print v(xbgr.mr_n64357296)
print v(xbgr.mr_n64357616)
print v(xbgr.mr_n64357728)
print v(xbgr.mr_n64358048)
print v(xbgr.mr_n64358160)
print v(xbgr.mr_n64358480)
print v(xbgr.mr_n64358592)
print v(xbgr.mr_n64358912)
print v(xbgr.mr_n64359024)
print v(xbgr.mr_n64359344)
print v(xbgr.mr_n64359456)
print v(xbgr.mr_n64359776)
print v(xbgr.mr_n64359888)
print v(xbgr.mr_n64360208)
print v(xbgr.mr_n64360320)
print v(xbgr.mr_n64360640)
print v(xbgr.mr_n64360752)
print v(xbgr.mr_n64361072)
print v(xbgr.mr_n64361184)
print v(xbgr.mr_n64361504)
print v(xbgr.mr_n64361616)
print v(xbgr.mr_n64361936)
print v(xbgr.mr_n64362048)
print v(xbgr.mr_n64362368)
print v(xbgr.mr_n64362480)
print v(xbgr.mr_n64362800)
print v(xbgr.mr_n64362912)
print v(xbgr.mr_n64363232)
print v(xbgr.mr_n64363344)
print v(xbgr.mr_n64363664)
print v(xbgr.mr_n64363776)
print v(xbgr.mr_n64364096)
print v(xbgr.mr_n64364208)
print v(xbgr.mr_n64364528)
print v(xbgr.mr_n64364640)
print v(xbgr.mr_n64364960)
print v(xbgr.mr_n64365072)
print v(xbgr.mr_n64365392)
print v(xbgr.mr_n64365504)
print v(xbgr.mr_n64365824)
print v(xbgr.mr_n64365936)
print v(xbgr.mr_n64366256)
print v(xbgr.mr_n64366368)
print v(xbgr.mr_n64366688)
print v(xbgr.mr_n64366800)
print v(xbgr.mr_n64367120)
print v(xbgr.mr_n64367232)
print v(xbgr.mr_n64367664)
print v(xbgr.mr_n64368096)
print v(xbgr.mr_n64368416)
print v(xbgr.mr_n64368528)
print v(xbgr.mr_n64368848)
print v(xbgr.mr_n64368960)
print v(xbgr.mr_n64369392)
print v(xbgr.mr_n64369824)
print v(xbgr.mr_n64370256)
print v(xbgr.mr_n64370688)
print v(xbgr.mr_n64371120)
print v(xbgr.mr_n64371552)
print v(xbgr.mr_n64371984)
print v(xbgr.mr_n64372416)
print v(xbgr.mr_n64372848)
print v(xbgr.mr_n64373280)
print v(xbgr.mr_n64373712)
print v(xbgr.mr_n64374144)
print v(xbgr.mr_n64374576)
print v(xbgr.mr_n64375008)
print v(xbgr.mr_n64375440)
print v(xbgr.mr_n64375872)
print v(xbgr.mr_n64376304)
print v(xbgr.mr_n64376736)
print v(xbgr.mr_n64377168)
print v(xbgr.mr_n64377600)
print v(xbgr.mr_n64378032)
print v(xbgr.mr_n64378464)
print v(xbgr.mr_n64378896)
print v(xbgr.mr_n64379328)
print v(xbgr.mr_n64379648)
print v(xbgr.mr_n64379760)
print v(xbgr.mr_n64380080)
print v(xbgr.mr_n64380192)
print v(xbgr.mr_n64380512)
print v(xbgr.mr_n64380624)
print v(xbgr.mr_n64380944)
print v(xbgr.mr_n64381056)
print v(xbgr.mr_n64381376)
print v(xbgr.mr_n64381488)
print v(xbgr.mr_n64381808)
print v(xbgr.mr_n64381920)
print v(xbgr.mr_n64382240)
print v(xbgr.mr_n64382352)
print v(xbgr.mr_n64382672)
print v(xbgr.mr_n64382784)
print v(xbgr.mr_n64383104)
print v(xbgr.mr_n64383216)
print v(xbgr.mr_n64383536)
print v(xbgr.mr_n64383648)
print v(xbgr.mr_n64383968)
print v(xbgr.mr_n64384080)
print v(xbgr.mr_n64384400)
print v(xbgr.mr_n64384512)
print v(xbgr.mr_n64384832)
print v(xbgr.mr_n64384944)
print v(xbgr.mr_n64385376)
print v(xbgr.mr_n64385808)
print v(xbgr.mr_n64386240)
print v(xbgr.mr_n64386672)
print v(xbgr.mr_n64387104)
print v(xbgr.mr_n64387536)
print v(xbgr.mr_n64387968)
print v(xbgr.mr_n64388400)
print v(xbgr.mr_n64388832)
print v(xbgr.mr_n64389264)
print v(xbgr.mr_n64389696)
print v(xbgr.mr_n64390128)
print v(xbgr.mr_n64390560)
print v(xbgr.mr_n64390880)
print v(xbgr.mr_n64390992)
print v(xbgr.mr_n64391312)
print v(xbgr.mr_n64391424)
print v(xbgr.mr_n64391744)
print v(xbgr.mr_n64391856)
print v(xbgr.mr_n64392176)
print v(xbgr.mr_n64392288)
print v(xbgr.mr_n64392608)
print v(xbgr.mr_n64392720)
print v(xbgr.mr_n64393040)
print v(xbgr.mr_n64393152)
print v(xbgr.mr_n64393472)
print v(xbgr.mr_n64393584)
print v(xbgr.mr_n64393904)
print v(xbgr.mr_n64394016)
print v(xbgr.mr_n64394336)
print v(xbgr.mr_n64394448)
print v(xbgr.mr_n64394768)
print v(xbgr.mr_n64394880)
print v(xbgr.mr_n64395200)
print v(xbgr.mr_n64395312)
print v(xbgr.mr_n64395632)
print v(xbgr.mr_n64395744)
print v(xbgr.mr_n64396064)
print v(xbgr.mr_n64396176)
print v(xbgr.mr_n64396608)
print v(xbgr.mr_n64397040)
print v(xbgr.mr_n64397472)
print v(xbgr.mr_n64397904)
print v(xbgr.mr_n64398336)
print v(xbgr.mr_n64398768)
print v(xbgr.mr_n64399200)
print v(xbgr.mr_n64399632)
print v(xbgr.mr_n64400064)
print v(xbgr.mr_n64400496)
print v(xbgr.mr_n64400928)
print v(xbgr.mr_n64401360)
print v(xbgr.mr_n64401792)
print v(xbgr.mr_n64402112)
print v(xbgr.mr_n64402224)
print v(xbgr.mr_n64402544)
print v(xbgr.mr_n64402656)
print v(xbgr.mr_n64402976)
print v(xbgr.mr_n64403088)
print v(xbgr.mr_n64403408)
print v(xbgr.mr_n64403520)
print v(xbgr.mr_n64403840)
print v(xbgr.mr_n64403952)
print v(xbgr.mr_n64404272)
print v(xbgr.mr_n64404384)
print v(xbgr.mr_n64404704)
print v(xbgr.mr_n64404816)
print v(xbgr.mr_n64405136)
print v(xbgr.mr_n64405248)
print v(xbgr.mr_n64405568)
print v(xbgr.mr_n64405680)
print v(xbgr.mr_n64406000)
print v(xbgr.mr_n64406112)
print v(xbgr.mr_n64406432)
print v(xbgr.mr_n64406544)
print v(xbgr.mr_n64406864)
print v(xbgr.mr_n64406976)
print v(xbgr.mr_n64407296)
print v(xbgr.mr_n64407408)
print v(xbgr.mr_n64407840)
print v(xbgr.mr_n64408272)
print v(xbgr.mr_n64408704)
print v(xbgr.mr_n64409136)
print v(xbgr.mr_n64409568)
print v(xbgr.mr_n64410000)
print v(xbgr.mr_n64410432)
print v(xbgr.mr_n64410864)
print v(xbgr.mr_n64411296)
print v(xbgr.mr_n64411728)
print v(xbgr.mr_n64412160)
print v(xbgr.mr_n64412592)
print v(xbgr.mr_n64413024)
print v(xbgr.mr_n64413344)
print v(xbgr.mr_n64413456)
print v(xbgr.mr_n64413776)
print v(xbgr.mr_n64413888)
print v(xbgr.mr_n64414208)
print v(xbgr.mr_n64414320)
print v(xbgr.mr_n64414640)
print v(xbgr.mr_n64414752)
print v(xbgr.mr_n64415072)
print v(xbgr.mr_n64415184)
print v(xbgr.mr_n64415504)
print v(xbgr.mr_n64415616)
print v(xbgr.mr_n64415936)
print v(xbgr.mr_n64416048)
print v(xbgr.mr_n64416480)
print v(xbgr.mr_n64416912)
print v(xbgr.mr_n64417344)
print v(xbgr.mr_n64417776)
print v(xbgr.mr_n64418096)
print v(xbgr.mr_n64418208)
print v(xbgr.mr_n64418528)
print v(xbgr.mr_n64418640)
print v(xbgr.mr_n64418960)
print v(xbgr.mr_n64419072)
print v(xbgr.mr_n64419392)
print v(xbgr.mr_n64419504)
print v(xbgr.mr_n64419824)
print v(xbgr.mr_n64419936)
print v(xbgr.mr_n64420256)
print v(xbgr.mr_n64420368)
print v(xbgr.mr_n64420800)
print v(xbgr.mr_n64421232)
print v(xbgr.mr_n64421664)
print v(xbgr.mr_n64422096)
print v(xbgr.mr_n64422528)
print v(xbgr.mr_n64422960)
print v(xbgr.mr_n64423392)
print v(xbgr.mr_n64423824)
print v(xbgr.mr_n64424256)
print v(xbgr.mr_n64424576)
print v(xbgr.mr_n64424688)
print v(xbgr.mr_n64425008)
print v(xbgr.mr_n64425120)
print v(xbgr.mr_n64425440)
print v(xbgr.mr_n64425552)
print v(xbgr.mr_n64425872)
print v(xbgr.mr_n64425984)
print v(xbgr.mr_n64426304)
print v(xbgr.mr_n64426416)
print v(xbgr.mr_n64426736)
print v(xbgr.mr_n64426848)
print v(xbgr.mr_n64427168)
print v(xbgr.mr_n64427280)
print v(xbgr.mr_n64427600)
print v(xbgr.mr_n64427712)
print v(xbgr.mr_n64428032)
print v(xbgr.mr_n64428144)
print v(xbgr.mr_n64428464)
print v(xbgr.mr_n64428576)
print v(xbgr.mr_n64428896)
print v(xbgr.mr_n64429008)
print v(xbgr.mr_n64429328)
print v(xbgr.mr_n64429440)
print v(xbgr.mr_n64429760)
print v(xbgr.mr_n64429872)
print v(xbgr.mr_n64430192)
print v(xbgr.mr_n64430304)
print v(xbgr.mr_n64430736)
print v(xbgr.mr_n64431168)
print v(xbgr.mr_n64431600)
print v(xbgr.mr_n64432032)
print v(xbgr.mr_n64432352)
print v(xbgr.mr_n64432464)
print v(xbgr.mr_n64432784)
print v(xbgr.mr_n64432896)
print v(xbgr.mr_n64433328)
print v(xbgr.mr_n64433760)
print v(xbgr.mr_n64434192)
print v(xbgr.mr_n64434624)
print v(xbgr.mr_n64435056)
print v(xbgr.mr_n64435488)
print v(xbgr.mr_n64435920)
print v(xbgr.mr_n64436352)
print v(xbgr.mr_n64436672)
print v(xbgr.mr_n64436784)
print v(xbgr.mr_n64437104)
print v(xbgr.mr_n64437216)
print v(xbgr.mr_n64437536)
print v(xbgr.mr_n64437648)
print v(xbgr.mr_n64437968)
print v(xbgr.mr_n64438080)
print v(xbgr.mr_n64438400)
print v(xbgr.mr_n64438512)
print v(xbgr.mr_n64438832)
print v(xbgr.mr_n64438944)
print v(xbgr.mr_n64439264)
print v(xbgr.mr_n64439376)
print v(xbgr.mr_n64439696)
print v(xbgr.mr_n64439808)
print v(xbgr.mr_n64440128)
print v(xbgr.mr_n64440240)
print v(xbgr.mr_n64440560)
print v(xbgr.mr_n64440672)
print v(xbgr.mr_n64440992)
print v(xbgr.mr_n64441104)
print v(xbgr.mr_n64441424)
print v(xbgr.mr_n64441536)
print v(xbgr.mr_n64441968)
print v(xbgr.mr_n64442400)
print v(xbgr.mr_n64442832)
print v(xbgr.mr_n64443264)
print v(xbgr.mr_n64443696)
print v(xbgr.mr_n64444128)
print v(xbgr.mr_n64444448)
print v(xbgr.mr_n64444560)
print v(xbgr.mr_n64444880)
print v(xbgr.mr_n64444992)
print v(xbgr.mr_n64445312)
print v(xbgr.mr_n64445424)
print v(xbgr.mr_n64445744)
print v(xbgr.mr_n64445856)
print v(xbgr.mr_n64446176)
print v(xbgr.mr_n64446288)
print v(xbgr.mr_n64446608)
print v(xbgr.mr_n64446720)
print v(xbgr.mr_n64447040)
print v(xbgr.mr_n64447152)
print v(xbgr.mr_n64447472)
print v(xbgr.mr_n64447584)
print v(xbgr.mr_n64447904)
print v(xbgr.mr_n64448016)
print v(xbgr.mr_n64448336)
print v(xbgr.mr_n64448448)
print v(xbgr.mr_n64448768)
print v(xbgr.mr_n64448880)
print v(xbgr.mr_n64449200)
print v(xbgr.mr_n64449312)
print v(xbgr.mr_n64449632)
print v(xbgr.mr_n64449744)
print v(xbgr.mr_n64450064)
print v(xbgr.mr_n64450176)
print v(xbgr.mr_n64450496)
print v(xbgr.mr_n64450608)
print v(xbgr.mr_n64450928)
print v(xbgr.mr_n64451040)
print v(xbgr.mr_n64451360)
print v(xbgr.mr_n64451472)
print v(xbgr.mr_n64451792)
print v(xbgr.mr_n64451904)
print v(xbgr.mr_n64452336)
print v(xbgr.mr_n64452768)
print v(xbgr.mr_n64453088)
print v(xbgr.mr_n64453200)
print v(xbgr.mr_n64453520)
print v(xbgr.mr_n64453632)
print v(xbgr.mr_n64453952)
print v(xbgr.mr_n64454064)
print v(xbgr.mr_n64454384)
print v(xbgr.mr_n64454496)
print v(xbgr.mr_n64454928)
print v(xbgr.mr_n64455360)
print v(xbgr.mr_n64455792)
print v(xbgr.mr_n64456224)
print v(xbgr.mr_n64456656)
print v(xbgr.mr_n64457088)
print v(xbgr.mr_n64457520)
print v(xbgr.mr_n64457952)
print v(xbgr.mr_n64458384)
print v(xbgr.mr_n64458816)
print v(xbgr.mr_n64459248)
print v(xbgr.mr_n64459680)
print v(xbgr.mr_n64460112)
print v(xbgr.mr_n64460544)
print v(xbgr.mr_n64460976)
print v(xbgr.mr_n64461408)
print v(xbgr.mr_n64461728)
print v(xbgr.mr_n64461840)
print v(xbgr.mr_n64462160)
print v(xbgr.mr_n64462272)
print v(xbgr.mr_n64462592)
print v(xbgr.mr_n64462704)
print v(xbgr.mr_n64463024)
print v(xbgr.mr_n64463136)
print v(xbgr.mr_n64463456)
print v(xbgr.mr_n64463568)
print v(xbgr.mr_n64463888)
print v(xbgr.mr_n64464000)
print v(xbgr.mr_n64464320)
print v(xbgr.mr_n64464432)
print v(xbgr.mr_n64464752)
print v(xbgr.mr_n64464864)
print v(xbgr.mr_n64465184)
print v(xbgr.mr_n64465296)
print v(xbgr.mr_n64465616)
print v(xbgr.mr_n64465728)
print v(xbgr.mr_n64466160)
print v(xbgr.mr_n64466592)
print v(xbgr.mr_n64467024)
print v(xbgr.mr_n64467456)
print v(xbgr.mr_n64467888)
print v(xbgr.mr_n64468320)
print v(xbgr.mr_n64468752)
print v(xbgr.mr_n64469184)
print v(xbgr.mr_n64469504)
print v(xbgr.mr_n64469616)
print v(xbgr.mr_n64469936)
print v(xbgr.mr_n64470048)
print v(xbgr.mr_n64470368)
print v(xbgr.mr_n64470480)
print v(xbgr.mr_n64470800)
print v(xbgr.mr_n64470912)
print v(xbgr.mr_n64471232)
print v(xbgr.mr_n64471344)
print v(xbgr.mr_n64471664)
print v(xbgr.mr_n64471776)
print v(xbgr.mr_n64472096)
print v(xbgr.mr_n64472208)
print v(xbgr.mr_n64472528)
print v(xbgr.mr_n64472640)
print v(xbgr.mr_n64472960)
print v(xbgr.mr_n64473072)
print v(xbgr.mr_n64473392)
print v(xbgr.mr_n64473504)
print v(xbgr.mr_n64473824)
print v(xbgr.mr_n64473936)
print v(xbgr.mr_n64474256)
print v(xbgr.mr_n64474368)
print v(xbgr.mr_n64474688)
print v(xbgr.mr_n64474800)
print v(xbgr.mr_n64475120)
print v(xbgr.mr_n64475232)
print v(xbgr.mr_n64475664)
print v(xbgr.mr_n64476096)
print v(xbgr.mr_n64476528)
print v(xbgr.mr_n64476960)
print v(xbgr.mr_n64477392)
print v(xbgr.mr_n64477824)
print v(xbgr.mr_n64478256)
print v(xbgr.mr_n64478688)
print v(xbgr.mr_n64479120)
print v(xbgr.mr_n64479552)
print v(xbgr.mr_n64479984)
print v(xbgr.mr_n64480416)
print v(xbgr.mr_n64480848)
print v(xbgr.mr_n64481280)
print v(xbgr.mr_n64481600)
print v(xbgr.mr_n64481712)
print v(xbgr.mr_n64482032)
print v(xbgr.mr_n64482144)
print v(xbgr.mr_n64482464)
print v(xbgr.mr_n64482576)
print v(xbgr.mr_n64482896)
print v(xbgr.mr_n64483008)
print v(xbgr.mr_n64483328)
print v(xbgr.mr_n64483440)
print v(xbgr.mr_n64483760)
print v(xbgr.mr_n64483872)
print v(xbgr.mr_n64484192)
print v(xbgr.mr_n64484304)
print v(xbgr.mr_n64484624)
print v(xbgr.mr_n64484736)
print v(xbgr.mr_n64485056)
print v(xbgr.mr_n64485168)
print v(xbgr.mr_n64485488)
print v(xbgr.mr_n64485600)
print v(xbgr.mr_n64485920)
print v(xbgr.mr_n64486032)
print v(xbgr.mr_n64486352)
print v(xbgr.mr_n64486464)
print v(xbgr.mr_n64486784)
print v(xbgr.mr_n64486896)
print v(xbgr.mr_n64487216)
print v(xbgr.mr_n64487328)
print v(xbgr.mr_n64487648)
print v(xbgr.mr_n64487760)
print v(xbgr.mr_n64488080)
print v(xbgr.mr_n64488192)
print v(xbgr.mr_n64488512)
print v(xbgr.mr_n64488624)
print v(xbgr.mr_n64488944)
print v(xbgr.mr_n64489056)
print v(xbgr.mr_n64489376)
print v(xbgr.mr_n64489488)
print v(xbgr.mr_n64489808)
print v(xbgr.mr_n64489920)
print v(xbgr.mr_n64490240)
print v(xbgr.mr_n64490352)
print v(xbgr.mr_n64490672)
print v(xbgr.mr_n64490784)
print v(xbgr.mr_n64491104)
print v(xbgr.mr_n64491216)
print v(xbgr.mr_n64491536)
print v(xbgr.mr_n64491648)
print v(xbgr.mr_n64492080)
print v(xbgr.mr_n64492512)
print v(xbgr.mr_n64492944)
print v(xbgr.mr_n64493376)
print v(xbgr.mr_n64493808)
print v(xbgr.mr_n64494240)
print v(xbgr.mr_n64494672)
print v(xbgr.mr_n64495104)
print v(xbgr.mr_n64495536)
print v(xbgr.mr_n64495968)
print v(xbgr.mr_n64496400)
print v(xbgr.mr_n64496832)
print v(xbgr.mr_n64497264)
print v(xbgr.mr_n64497696)
print v(xbgr.mr_n64498128)
print v(xbgr.mr_n64498560)
print v(xbgr.mr_n64498880)
print v(xbgr.mr_n64498992)
print v(xbgr.mr_n64499312)
print v(xbgr.mr_n64499424)
print v(xbgr.mr_n64499856)
print v(xbgr.mr_n64500288)
print v(xbgr.mr_n64500720)
print v(xbgr.mr_n64501152)
print v(xbgr.mr_n64501584)
print v(xbgr.mr_n64502016)
print v(xbgr.mr_n64502448)
print v(xbgr.mr_n64502880)
print v(xbgr.mr_n64503312)
print v(xbgr.mr_n64503744)
print v(xbgr.mr_n64504064)
print v(xbgr.mr_n64504176)
print v(xbgr.mr_n64504496)
print v(xbgr.mr_n64504608)
print v(xbgr.mr_n64504928)
print v(xbgr.mr_n64505040)
print v(xbgr.mr_n64505360)
print v(xbgr.mr_n64505472)
print v(xbgr.mr_n64505792)
print v(xbgr.mr_n64505904)
print v(xbgr.mr_n64506224)
print v(xbgr.mr_n64506336)
print v(xbgr.mr_n64506656)
print v(xbgr.mr_n64506768)
print v(xbgr.mr_n64507088)
print v(xbgr.mr_n64507200)
print v(xbgr.mr_n64507520)
print v(xbgr.mr_n64507632)
print v(xbgr.mr_n64507952)
print v(xbgr.mr_n64508064)
print v(xbgr.mr_n64508384)
print v(xbgr.mr_n64508496)
print v(xbgr.mr_n64508816)
print v(xbgr.mr_n64508928)
print v(xbgr.mr_n64509248)
print v(xbgr.mr_n64509360)
print v(xbgr.mr_n64509792)
print v(xbgr.mr_n64510224)
print v(xbgr.mr_n64510656)
print v(xbgr.mr_n64511088)
print v(xbgr.mr_n64511520)
print v(xbgr.mr_n64511952)
print v(xbgr.mr_n64512384)
print v(xbgr.mr_n64512816)
print v(xbgr.mr_n64513248)
print v(xbgr.mr_n64513680)
print v(xbgr.mr_n64514112)
print v(xbgr.mr_n64514544)
print v(xbgr.mr_n64514976)
print v(xbgr.mr_n64515296)
print v(xbgr.mr_n64515408)
print v(xbgr.mr_n64515728)
print v(xbgr.mr_n64515840)
print v(xbgr.mr_n64516160)
print v(xbgr.mr_n64516272)
print v(xbgr.mr_n64516592)
print v(xbgr.mr_n64516704)
print v(xbgr.mr_n64517024)
print v(xbgr.mr_n64517136)
print v(xbgr.mr_n64517456)
print v(xbgr.mr_n64517568)
print v(xbgr.mr_n64517888)
print v(xbgr.mr_n64518000)
print v(xbgr.mr_n64518320)
print v(xbgr.mr_n64518432)
print v(xbgr.mr_n64518752)
print v(xbgr.mr_n64518864)
print v(xbgr.mr_n64519184)
print v(xbgr.mr_n64519296)
print v(xbgr.mr_n64519616)
print v(xbgr.mr_n64519728)
print v(xbgr.mr_n64520048)
print v(xbgr.mr_n64520160)
print v(xbgr.mr_n64520480)
print v(xbgr.mr_n64520592)
print v(xbgr.mr_n64521024)
print v(xbgr.mr_n64521456)
print v(xbgr.mr_n64521888)
print v(xbgr.mr_n64522320)
print v(xbgr.mr_n64522752)
print v(xbgr.mr_n64523184)
print v(xbgr.mr_n64523616)
print v(xbgr.mr_n64524048)
print v(xbgr.mr_n64524480)
print v(xbgr.mr_n64524912)
print v(xbgr.mr_n64525344)
print v(xbgr.mr_n64525776)
print v(xbgr.mr_n64526208)
print v(xbgr.mr_n64526528)
print v(xbgr.mr_n64526640)
print v(xbgr.mr_n64526960)
print v(xbgr.mr_n64527072)
print v(xbgr.mr_n64527392)
print v(xbgr.mr_n64527504)
print v(xbgr.mr_n64527824)
print v(xbgr.mr_n64527936)
print v(xbgr.mr_n64528256)
print v(xbgr.mr_n64528368)
print v(xbgr.mr_n64528688)
print v(xbgr.mr_n64528800)
print v(xbgr.mr_n64529120)
print v(xbgr.mr_n64529232)
print v(xbgr.mr_n64529552)
print v(xbgr.mr_n64529664)
print v(xbgr.mr_n64529984)
print v(xbgr.mr_n64530096)
print v(xbgr.mr_n64530416)
print v(xbgr.mr_n64530528)
print v(xbgr.mr_n64530848)
print v(xbgr.mr_n64530960)
print v(xbgr.mr_n64531280)
print v(xbgr.mr_n64531392)
print v(xbgr.mr_n64531712)
print v(xbgr.mr_n64531824)
print v(xbgr.mr_n64532256)
print v(xbgr.mr_n64532688)
print v(xbgr.mr_n64533120)
print v(xbgr.mr_n64533552)
print v(xbgr.mr_n64533984)
print v(xbgr.mr_n64534416)
print v(xbgr.mr_n64534848)
print v(xbgr.mr_n64535280)
print v(xbgr.mr_n64535712)
print v(xbgr.mr_n64536144)
print v(xbgr.mr_n64536576)
print v(xbgr.mr_n64537008)
print v(xbgr.mr_n64537440)
print v(xbgr.mr_n64537760)
print v(xbgr.mr_n64537872)
print v(xbgr.mr_n64538192)
print v(xbgr.mr_n64538304)
print v(xbgr.mr_n64538624)
print v(xbgr.mr_n64538736)
print v(xbgr.mr_n64539056)
print v(xbgr.mr_n64539168)
print v(xbgr.mr_n64539488)
print v(xbgr.mr_n64539600)
print v(xbgr.mr_n64539920)
print v(xbgr.mr_n64540032)
print v(xbgr.mr_n64540352)
print v(xbgr.mr_n64540464)
print v(xbgr.mr_n64540784)
print v(xbgr.mr_n64540896)
print v(xbgr.mr_n64541216)
print v(xbgr.mr_n64541328)
print v(xbgr.mr_n64541648)
print v(xbgr.mr_n64541760)
print v(xbgr.mr_n64542080)
print v(xbgr.mr_n64542192)
print v(xbgr.mr_n64542512)
print v(xbgr.mr_n64542624)
print v(xbgr.mr_n64542944)
print v(xbgr.mr_n64543056)
print v(xbgr.mr_n64543488)
print v(xbgr.mr_n64543920)
print v(xbgr.mr_n64544352)
print v(xbgr.mr_n64544784)
print v(xbgr.mr_n64545216)
print v(xbgr.mr_n64545648)
print v(xbgr.mr_n64546080)
print v(xbgr.mr_n64546512)
print v(xbgr.mr_n64546944)
print v(xbgr.mr_n64547376)
print v(xbgr.mr_n64547808)
print v(xbgr.mr_n64548240)
print v(xbgr.mr_n64548672)
print v(xbgr.mr_n64548992)
print v(xbgr.mr_n64549104)
print v(xbgr.mr_n64549424)
print v(xbgr.mr_n64549536)
print v(xbgr.mr_n64549856)
print v(xbgr.mr_n64549968)
print v(xbgr.mr_n64550288)
print v(xbgr.mr_n64550400)
print v(xbgr.mr_n64550720)
print v(xbgr.mr_n64550832)
print v(xbgr.mr_n64551264)
print v(xbgr.mr_n64551696)
print v(xbgr.mr_n64552128)
print v(xbgr.mr_n64552560)
print v(xbgr.mr_n64552992)
print v(xbgr.mr_n64553312)
print v(xbgr.mr_n64553424)
print v(xbgr.mr_n64553744)
print v(xbgr.mr_n64553856)
print v(xbgr.mr_n64554176)
print v(xbgr.mr_n64554288)
print v(xbgr.mr_n64554608)
print v(xbgr.mr_n64554720)
print v(xbgr.mr_n64555040)
print v(xbgr.mr_n64555152)
print v(xbgr.mr_n64555472)
print v(xbgr.mr_n64555584)
print v(xbgr.mr_n64555904)
print v(xbgr.mr_n64556016)
print v(xbgr.mr_n64556336)
print v(xbgr.mr_n64556448)
print v(xbgr.mr_n64556880)
print v(xbgr.mr_n64557312)
print v(xbgr.mr_n64557744)
print v(xbgr.mr_n64558176)
print v(xbgr.mr_n64558608)
print v(xbgr.mr_n64559040)
print v(xbgr.mr_n64559472)
print v(xbgr.mr_n64559904)
print v(xbgr.mr_n64560224)
print v(xbgr.mr_n64560336)
print v(xbgr.mr_n64560656)
print v(xbgr.mr_n64560768)
print v(xbgr.mr_n64561088)
print v(xbgr.mr_n64561200)
print v(xbgr.mr_n64561520)
print v(xbgr.mr_n64561632)
print v(xbgr.mr_n64561952)
print v(xbgr.mr_n64562064)
print v(xbgr.mr_n64562384)
print v(xbgr.mr_n64562496)
print v(xbgr.mr_n64562816)
print v(xbgr.mr_n64562928)
print v(xbgr.mr_n64563248)
print v(xbgr.mr_n64563360)
print v(xbgr.mr_n64563792)
print v(xbgr.mr_n64564224)
print v(xbgr.mr_n64564656)
print v(xbgr.mr_n64565088)
print v(xbgr.mr_n64565520)
print v(xbgr.mr_n64565840)
print v(xbgr.mr_n64565952)
print v(xbgr.mr_n64566272)
print v(xbgr.mr_n64566384)
print v(xbgr.mr_n64566704)
print v(xbgr.mr_n64566816)
print v(xbgr.mr_n64567136)
print v(xbgr.mr_n64567248)
print v(xbgr.mr_n64567568)
print v(xbgr.mr_n64567680)
print v(xbgr.mr_n64568112)
print v(xbgr.mr_n64568544)
print v(xbgr.mr_n64568976)
print v(xbgr.mr_n64569408)
print v(xbgr.mr_n64569840)
print v(xbgr.mr_n64570272)
print v(xbgr.mr_n64570704)
print v(xbgr.mr_n64571136)
print v(xbgr.mr_n64571456)
print v(xbgr.mr_n64571568)
print v(xbgr.mr_n64571888)
print v(xbgr.mr_n64572000)
print v(xbgr.mr_n64572320)
print v(xbgr.mr_n64572432)
print v(xbgr.mr_n64572752)
print v(xbgr.mr_n64572864)
print v(xbgr.mr_n64573184)
print v(xbgr.mr_n64573296)
print v(xbgr.mr_n64573616)
print v(xbgr.mr_n64573728)
print v(xbgr.mr_n64574048)
print v(xbgr.mr_n64574160)
print v(xbgr.mr_n64574592)
print v(xbgr.mr_n64575024)
print v(xbgr.mr_n64575456)
print v(xbgr.mr_n64575888)
print v(xbgr.mr_n64576208)
print v(xbgr.mr_n64576320)
print v(xbgr.mr_n64576752)
print v(xbgr.mr_n64577184)
print v(xbgr.mr_n64577504)
print v(xbgr.mr_n64577616)
print v(xbgr.mr_n64577936)
print v(xbgr.mr_n64578048)
print v(xbgr.mr_n64578368)
print v(xbgr.mr_n64578480)
print v(xbgr.mr_n64578800)
print v(xbgr.mr_n64578912)
print v(xbgr.mr_n64579232)
print v(xbgr.mr_n64579344)
print v(xbgr.mr_n64579776)
print v(xbgr.mr_n64580208)
print v(xbgr.mr_n64580640)
print v(xbgr.mr_n64581072)
print v(xbgr.mr_n64581504)
print v(xbgr.mr_n64581936)
print v(xbgr.mr_n64582368)
print v(xbgr.mr_n64582688)
print v(xbgr.mr_n64582800)
print v(xbgr.mr_n64583120)
print v(xbgr.mr_n64583232)
print v(xbgr.mr_n64583552)
print v(xbgr.mr_n64583664)
print v(xbgr.mr_n64583984)
print v(xbgr.mr_n64584096)
print v(xbgr.mr_n64584416)
print v(xbgr.mr_n64584528)
print v(xbgr.mr_n64584848)
print v(xbgr.mr_n64584960)
print v(xbgr.mr_n64585280)
print v(xbgr.mr_n64585392)
print v(xbgr.mr_n64585712)
print v(xbgr.mr_n64585824)
print v(xbgr.mr_n64586144)
print v(xbgr.mr_n64586256)
print v(xbgr.mr_n64586576)
print v(xbgr.mr_n64586688)
print v(xbgr.mr_n64587008)
print v(xbgr.mr_n64587120)
print v(xbgr.mr_n64587440)
print v(xbgr.mr_n64587552)
print v(xbgr.mr_n64587872)
print v(xbgr.mr_n64587984)
print v(xbgr.mr_n64588416)
print v(xbgr.mr_n64588848)
print v(xbgr.mr_n64589280)
print v(xbgr.mr_n64589712)
print v(xbgr.mr_n64590144)
print v(xbgr.mr_n64590576)
print v(xbgr.mr_n64591008)
print v(xbgr.mr_n64591440)
print v(xbgr.mr_n64591872)
print v(xbgr.mr_n64592304)
print v(xbgr.mr_n64592736)
print v(xbgr.mr_n64593168)
print v(xbgr.mr_n64593600)
print v(xbgr.mr_n64593920)
print v(xbgr.mr_n64594032)
print v(xbgr.mr_n64594352)
print v(xbgr.mr_n64594464)
print v(xbgr.mr_n64594784)
print v(xbgr.mr_n64594896)
print v(xbgr.mr_n64595216)
print v(xbgr.mr_n64595328)
print v(xbgr.mr_n64595648)
print v(xbgr.mr_n64595760)
print v(xbgr.mr_n64596080)
print v(xbgr.mr_n64596192)
print v(xbgr.mr_n64596512)
print v(xbgr.mr_n64596624)
print v(xbgr.mr_n64596944)
print v(xbgr.mr_n64597056)
print v(xbgr.mr_n64597376)
print v(xbgr.mr_n64597488)
print v(xbgr.mr_n64597808)
print v(xbgr.mr_n64597920)
print v(xbgr.mr_n64598240)
print v(xbgr.mr_n64598352)
print v(xbgr.mr_n64598672)
print v(xbgr.mr_n64598784)
print v(xbgr.mr_n64599104)
print v(xbgr.mr_n64599216)
print v(xbgr.mr_n64599536)
print v(xbgr.mr_n64599648)
print v(xbgr.mr_n64599968)
print v(xbgr.mr_n64600080)
print v(xbgr.mr_n64600400)
print v(xbgr.mr_n64600512)
print v(xbgr.mr_n64600944)
print v(xbgr.mr_n64601376)
print v(xbgr.mr_n64601808)
print v(xbgr.mr_n64602240)
print v(xbgr.mr_n64602672)
print v(xbgr.mr_n64603104)
print v(xbgr.mr_n64603424)
print v(xbgr.mr_n64603536)
print v(xbgr.mr_n64603856)
print v(xbgr.mr_n64603968)
print v(xbgr.mr_n64604288)
print v(xbgr.mr_n64604400)
print v(xbgr.mr_n64604720)
print v(xbgr.mr_n64604832)
print v(xbgr.mr_n64605152)
print v(xbgr.mr_n64605264)
print v(xbgr.mr_n64605584)
print v(xbgr.mr_n64605696)
print v(xbgr.mr_n64606016)
print v(xbgr.mr_n64606128)
print v(xbgr.mr_n64606448)
print v(xbgr.mr_n64606560)
print v(xbgr.mr_n64606880)
print v(xbgr.mr_n64606992)
print v(xbgr.mr_n64607312)
print v(xbgr.mr_n64607424)
print v(xbgr.mr_n64607856)
print v(xbgr.mr_n64608288)
print v(xbgr.mr_n64608720)
print v(xbgr.mr_n64609152)
print v(xbgr.mr_n64609584)
print v(xbgr.mr_n64610016)
print v(xbgr.mr_n64610448)
print v(xbgr.mr_n64610880)
print v(xbgr.mr_n64611312)
print v(xbgr.mr_n64611744)
print v(xbgr.mr_n64612176)
print v(xbgr.mr_n64612608)
print v(xbgr.mr_n64613040)
print v(xbgr.mr_n64613472)
print v(xbgr.mr_n64613904)
print v(xbgr.mr_n64614336)
print v(xbgr.mr_n64614768)
print v(xbgr.mr_n64615200)
print v(xbgr.mr_n64615632)
print v(xbgr.mr_n64616064)
print v(xbgr.mr_n64616384)
print v(xbgr.mr_n64616496)
print v(xbgr.mr_n64616816)
print v(xbgr.mr_n64616928)
print v(xbgr.mr_n64617248)
print v(xbgr.mr_n64617360)
print v(xbgr.mr_n64617680)
print v(xbgr.mr_n64617792)
print v(xbgr.mr_n64618112)
print v(xbgr.mr_n64618224)
print v(xbgr.mr_n64618544)
print v(xbgr.mr_n64618656)
print v(xbgr.mr_n64618976)
print v(xbgr.mr_n64619088)
print v(xbgr.mr_n64619408)
print v(xbgr.mr_n64619520)
print v(xbgr.mr_n64619840)
print v(xbgr.mr_n64619952)
print v(xbgr.mr_n64620272)
print v(xbgr.mr_n64620384)
print v(xbgr.mr_n64620704)
print v(xbgr.mr_n64620816)
print v(xbgr.mr_n64621136)
print v(xbgr.mr_n64621248)
print v(xbgr.mr_n64621568)
print v(xbgr.mr_n64621680)
print v(xbgr.mr_n64622000)
print v(xbgr.mr_n64622112)
print v(xbgr.mr_n64622544)
print v(xbgr.mr_n64622976)
print v(xbgr.mr_n64623408)
print v(xbgr.mr_n64623840)
print v(xbgr.mr_n64624160)
print v(xbgr.mr_n64624272)
print v(xbgr.mr_n64624592)
print v(xbgr.mr_n64624704)
print v(xbgr.mr_n64625024)
print v(xbgr.mr_n64625136)
print v(xbgr.mr_n64625456)
print v(xbgr.mr_n64625568)
print v(xbgr.mr_n64625888)
print v(xbgr.mr_n64626000)
print v(xbgr.mr_n64626320)
print v(xbgr.mr_n64626432)
print v(xbgr.mr_n64626864)
print v(xbgr.mr_n64627296)
print v(xbgr.mr_n64627728)
print v(xbgr.mr_n64628160)
print v(xbgr.mr_n64628592)
print v(xbgr.mr_n64629024)
print v(xbgr.mr_n64629456)
print v(xbgr.mr_n64629888)
print v(xbgr.mr_n64630320)
print v(xbgr.mr_n64630752)
print v(xbgr.mr_n64631072)
print v(xbgr.mr_n64631184)
print v(xbgr.mr_n64631504)
print v(xbgr.mr_n64631616)
print v(xbgr.mr_n64632048)
print v(xbgr.mr_n64632480)
print v(xbgr.mr_n64632800)
print v(xbgr.mr_n64632912)
print v(xbgr.mr_n64633232)
print v(xbgr.mr_n64633344)
print v(xbgr.mr_n64633664)
print v(xbgr.mr_n64633776)
print v(xbgr.mr_n64634096)
print v(xbgr.mr_n64634208)
print v(xbgr.mr_n64634640)
print v(xbgr.mr_n64635072)
print v(xbgr.mr_n64635504)
print v(xbgr.mr_n64635936)
print v(xbgr.mr_n64636368)
print v(xbgr.mr_n64636800)
print v(xbgr.mr_n64637232)
print v(xbgr.mr_n64637664)
print v(xbgr.mr_n64638096)
print v(xbgr.mr_n64638528)
print v(xbgr.mr_n64638848)
print v(xbgr.mr_n64638960)
print v(xbgr.mr_n64639280)
print v(xbgr.mr_n64639392)
print v(xbgr.mr_n64639712)
print v(xbgr.mr_n64639824)
print v(xbgr.mr_n64640144)
print v(xbgr.mr_n64640256)
print v(xbgr.mr_n64640576)
print v(xbgr.mr_n64640688)
print v(xbgr.mr_n64641008)
print v(xbgr.mr_n64641120)
print v(xbgr.mr_n64641440)
print v(xbgr.mr_n64641552)
print v(xbgr.mr_n64641872)
print v(xbgr.mr_n64641984)
print v(xbgr.mr_n64642304)
print v(xbgr.mr_n64642416)
print v(xbgr.mr_n64642736)
print v(xbgr.mr_n64642848)
print v(xbgr.mr_n64643168)
print v(xbgr.mr_n64643280)
print v(xbgr.mr_n64643600)
print v(xbgr.mr_n64643712)
print v(xbgr.mr_n64644032)
print v(xbgr.mr_n64644144)
print v(xbgr.mr_n64644464)
print v(xbgr.mr_n64644576)
print v(xbgr.mr_n64644896)
print v(xbgr.mr_n64645008)
print v(xbgr.mr_n64645328)
print v(xbgr.mr_n64645440)
print v(xbgr.mr_n64645760)
print v(xbgr.mr_n64645872)
print v(xbgr.mr_n64646192)
print v(xbgr.mr_n64646304)
print v(xbgr.mr_n64646624)
print v(xbgr.mr_n64646736)
print v(xbgr.mr_n64647056)
print v(xbgr.mr_n64647168)
print v(xbgr.mr_n64647488)
print v(xbgr.mr_n64647600)
print v(xbgr.mr_n64647920)
print v(xbgr.mr_n64648352)
print v(xbgr.mr_n64648464)
print v(xbgr.mr_n64648784)
print v(xbgr.mr_n64649216)
print v(xbgr.mr_n64649328)
print v(xbgr.mr_n64649648)
print v(xbgr.mr_n64650080)
print v(xbgr.mr_n64650192)
print v(xbgr.mr_n64650512)
print v(xbgr.mr_n64650944)
print v(xbgr.mr_n64651056)
print v(xbgr.mr_n64651376)
print v(xbgr.mr_n64651808)
print v(xbgr.mr_n64651920)
print v(xbgr.mr_n64652240)
print v(xbgr.mr_n64652352)
print v(xbgr.mr_n64652672)
print v(xbgr.mr_n64652784)
print v(xbgr.mr_n64653104)
print v(xbgr.mr_n64653216)
print v(xbgr.mr_n64653536)
print v(xbgr.mr_n64653648)
print v(xbgr.mr_n64653968)
print v(xbgr.mr_n64654080)
print v(xbgr.mr_n64654400)
print v(xbgr.mr_n64654512)
print v(xbgr.mr_n64654832)
print v(xbgr.mr_n64654944)
print v(xbgr.mr_n64655264)
print v(xbgr.mr_n64655376)
print v(xbgr.mr_n64655696)
print v(xbgr.mr_n64655808)
print v(xbgr.mr_n64656128)
print v(xbgr.mr_n64656240)
print v(xbgr.mr_n64656560)
print v(xbgr.mr_n64656672)
print v(xbgr.mr_n64656992)
print v(xbgr.mr_n64657104)
print v(xbgr.mr_n64657424)
print v(xbgr.mr_n64657536)
print v(xbgr.mr_n64657856)
print v(xbgr.mr_n64657968)
print v(xbgr.mr_n64658288)
print v(xbgr.mr_n64658400)
print v(xbgr.mr_n64658720)
print v(xbgr.mr_n64658832)
print v(xbgr.mr_n64659152)
print v(xbgr.mr_n64659264)
print v(xbgr.mr_n64659584)
print v(xbgr.mr_n64659696)
print v(xbgr.mr_n64660016)
print v(xbgr.mr_n64660128)
print v(xbgr.mr_n64660448)
print v(xbgr.mr_n64660560)
print v(xbgr.mr_n64660880)
print v(xbgr.mr_n64660992)
print v(xbgr.mr_n64661312)
print v(xbgr.mr_n64661424)
print v(xbgr.mr_n64661744)
print v(xbgr.mr_n64661856)
print v(xbgr.mr_n64662176)
print v(xbgr.mr_n64662288)
print v(xbgr.mr_n64662608)
print v(xbgr.mr_n64662720)
print v(xbgr.mr_n64663040)
print v(xbgr.mr_n64663152)
print v(xbgr.mr_n64663472)
print v(xbgr.mr_n64663584)
print v(xbgr.mr_n64663904)
print v(xbgr.mr_n64664016)
print v(xbgr.mr_n64664336)
print v(xbgr.mr_n64664448)
print v(xbgr.mr_n64664768)
print v(xbgr.mr_n64664880)
print v(xbgr.mr_n64665200)
print v(xbgr.mr_n64665312)
print v(xbgr.mr_n64665632)
print v(xbgr.mr_n64665744)
print v(xbgr.mr_n64666064)
print v(xbgr.mr_n64666176)
print v(xbgr.mr_n64666496)
print v(xbgr.mr_n64666608)
print v(xbgr.mr_n64666928)
print v(xbgr.mr_n64667040)
print v(xbgr.mr_n64667360)
print v(xbgr.mr_n64667472)
print v(xbgr.mr_n64667792)
print v(xbgr.mr_n64667904)
print v(xbgr.mr_n64668224)
print v(xbgr.mr_n64668336)
print v(xbgr.mr_n64668656)
print v(xbgr.mr_n64668768)
print v(xbgr.mr_n64669088)
print v(xbgr.mr_n64669200)
print v(xbgr.mr_n64669520)
print v(xbgr.mr_n64669632)
print v(xbgr.mr_n64669952)
print v(xbgr.mr_n64670064)
print v(xbgr.mr_n64670384)
print v(xbgr.mr_n64670496)
print v(xbgr.mr_n64670816)
print v(xbgr.mr_n64670928)
print v(xbgr.mr_n64671248)
print v(xbgr.mr_n64671360)
print v(xbgr.mr_n64671680)
print v(xbgr.mr_n64671792)
print v(xbgr.mr_n64672112)
print v(xbgr.mr_n64672224)
print v(xbgr.mr_n64672544)
print v(xbgr.mr_n64672656)
print v(xbgr.mr_n64672976)
print v(xbgr.mr_n64673088)
print v(xbgr.mr_n64673408)
print v(xbgr.mr_n64673520)
print v(xbgr.mr_n64673840)
print v(xbgr.mr_n64673952)
print v(xbgr.mr_n64674272)
print v(xbgr.mr_n64674384)
print v(xbgr.mr_n64674704)
print v(xbgr.mr_n64674816)
print v(xbgr.mr_n64675136)
print v(xbgr.mr_n64675248)
print v(xbgr.mr_n64675568)
print v(xbgr.mr_n64675680)
print v(xbgr.mr_n64676000)
print v(xbgr.mr_n64676112)
print v(xbgr.mr_n64676432)
print v(xbgr.mr_n64676544)
print v(xbgr.mr_n64676864)
print v(xbgr.mr_n64676976)
print v(xbgr.mr_n64677296)
print v(xbgr.mr_n64677408)
print v(xbgr.mr_n64677728)
print v(xbgr.mr_n64677840)
print v(xbgr.mr_n64678160)
print v(xbgr.mr_n64678272)
print v(xbgr.mr_n64678592)
print v(xbgr.mr_n64678704)
print v(xbgr.mr_n64679024)
print v(xbgr.mr_n64679136)
print v(xbgr.mr_n64679456)
print v(xbgr.mr_n64679568)
print v(xbgr.mr_n64679888)
print v(xbgr.mr_n64680000)
print v(xbgr.mr_n64680320)
print v(xbgr.mr_n64680432)
print v(xbgr.mr_n64680752)
print v(xbgr.mr_n64680864)
print v(xbgr.mr_n64681184)
print v(xbgr.mr_n64681296)
print v(xbgr.mr_n64681616)
print v(xbgr.mr_n64681728)
print v(xbgr.mr_n64682048)
print v(xbgr.mr_n64682160)
print v(xbgr.mr_n64682480)
print v(xbgr.mr_n64682592)
print v(xbgr.mr_n64682912)
print v(xbgr.mr_n64683344)
print v(xbgr.mr_n64683456)
print v(xbgr.mr_n64683776)
print v(xbgr.mr_n64684208)
print v(xbgr.mr_n64684320)
print v(xbgr.mr_n64684640)
print v(xbgr.mr_n64685072)
print v(xbgr.mr_n64685184)
print v(xbgr.mr_n64685504)
print v(xbgr.mr_n64685936)
print v(xbgr.mr_n64686048)
print v(xbgr.mr_n64686368)
print v(xbgr.mr_n64686480)
print v(xbgr.mr_n64686800)
print v(xbgr.mr_n64686912)
print v(xbgr.mr_n64687232)
print v(xbgr.mr_n64687344)
print v(xbgr.mr_n64687664)
print v(xbgr.mr_n64688096)
print v(xbgr.mr_n64688208)
print v(xbgr.mr_n64688528)
print v(xbgr.mr_n64688960)
print v(xbgr.mr_n64689072)
print v(xbgr.mr_n64689392)
print v(xbgr.mr_n64689824)
print v(xbgr.mr_n64689936)
print v(xbgr.mr_n64690256)
print v(xbgr.mr_n64690688)
print v(xbgr.mr_n64690800)
print v(xbgr.mr_n64691120)
print v(xbgr.mr_n64691232)
print v(xbgr.mr_n64691552)
print v(xbgr.mr_n64691664)
print v(xbgr.mr_n64691984)
print v(xbgr.mr_n64692096)
print v(xbgr.mr_n64692416)
print v(xbgr.mr_n64692528)
print v(xbgr.mr_n64692848)
print v(xbgr.mr_n64692960)
print v(xbgr.mr_n64693280)
print v(xbgr.mr_n64693392)
print v(xbgr.mr_n64693712)
print v(xbgr.mr_n64693824)
print v(xbgr.mr_n64694144)
print v(xbgr.mr_n64694256)
print v(xbgr.mr_n64694576)
print v(xbgr.mr_n64694688)
print v(xbgr.mr_n64695008)
print v(xbgr.mr_n64695120)
print v(xbgr.mr_n64695440)
print v(xbgr.mr_n64695552)
print v(xbgr.mr_n64695872)
print v(xbgr.mr_n64695984)
print v(xbgr.mr_n64696304)
print v(xbgr.mr_n64696416)
print v(xbgr.mr_n64696736)
print v(xbgr.mr_n64696848)
print v(xbgr.mr_n64697168)
print v(xbgr.mr_n64697280)
print v(xbgr.mr_n64697600)
print v(xbgr.mr_n64697712)
print v(xbgr.mr_n64698032)
print v(xbgr.mr_n64698144)
print v(xbgr.mr_n64698464)
print v(xbgr.mr_n64698576)
print v(xbgr.mr_n64698896)
print v(xbgr.mr_n64699008)
print v(xbgr.mr_n64699328)
print v(xbgr.mr_n64699440)
print v(xbgr.mr_n64699760)
print v(xbgr.mr_n64699872)
print v(xbgr.mr_n64700192)
print v(xbgr.mr_n64700304)
print v(xbgr.mr_n64700624)
print v(xbgr.mr_n64700736)
print v(xbgr.mr_n64701056)
print v(xbgr.mr_n64701168)
print v(xbgr.mr_n64701488)
print v(xbgr.mr_n64701600)
print v(xbgr.mr_n64701920)
print v(xbgr.mr_n64702032)
print v(xbgr.mr_n64702352)
print v(xbgr.mr_n64702464)
print v(xbgr.mr_n64702896)
print v(xbgr.mr_n64703328)
print v(xbgr.mr_n64703760)
print v(xbgr.mr_n64704192)
print v(xbgr.mr_n64704624)
print v(xbgr.mr_n64705056)
print v(xbgr.mr_n64705488)
print v(xbgr.mr_n64705920)
print v(xbgr.mr_n64706352)
print v(xbgr.mr_n64706784)
print v(xbgr.mr_n64707216)
print v(xbgr.mr_n64707648)
print v(xbgr.mr_n64708080)
print v(xbgr.mr_n64708512)
print v(xbgr.mr_n64708944)
print v(xbgr.mr_n64709376)
print v(xbgr.mr_n64709808)
print v(xbgr.mr_n64710240)
print v(xbgr.mr_n64710672)
print v(xbgr.mr_n64711104)
print v(xbgr.mr_n64711536)
print v(xbgr.mr_n64711968)
print v(xbgr.mr_n64712400)
print v(xbgr.mr_n64712832)
print v(xbgr.mr_n64713264)
print v(xbgr.mr_n64713696)
print v(xbgr.mr_n64714016)
print v(xbgr.mr_n64714128)
print v(xbgr.mr_n64714448)
print v(xbgr.mr_n64714560)
print v(xbgr.mr_n64714880)
print v(xbgr.mr_n64714992)
print v(xbgr.mr_n64715312)
print v(xbgr.mr_n64715424)
print v(xbgr.mr_n64715744)
print v(xbgr.mr_n64715856)
print v(xbgr.mr_n64716176)
print v(xbgr.mr_n64716288)
print v(xbgr.mr_n64716608)
print v(xbgr.mr_n64716720)
print v(xbgr.mr_n64717040)
print v(xbgr.mr_n64717152)
print v(xbgr.mr_n64717472)
print v(xbgr.mr_n64717584)
print v(xbgr.mr_n64717904)
print v(xbgr.mr_n64718016)
print v(xbgr.mr_n64718336)
print v(xbgr.mr_n64718448)
print v(xbgr.mr_n64718768)
print v(xbgr.mr_n64718880)
print v(xbgr.mr_n64719200)
print v(xbgr.mr_n64719312)
print v(xbgr.mr_n64719632)
print v(xbgr.mr_n64719744)
print v(xbgr.mr_n64720064)
print v(xbgr.mr_n64720176)
print v(xbgr.mr_n64720496)
print v(xbgr.mr_n64720608)
print v(xbgr.mr_n64720928)
print v(xbgr.mr_n64721040)
print v(xbgr.mr_n64721360)
print v(xbgr.mr_n64721472)
print v(xbgr.mr_n64721792)
print v(xbgr.mr_n64721904)
print v(xbgr.mr_n64722224)
print v(xbgr.mr_n64722336)
print v(xbgr.mr_n64722768)
print v(xbgr.mr_n64723200)
print v(xbgr.mr_n64723632)
print v(xbgr.mr_n64724064)
print v(xbgr.mr_n64724496)
print v(xbgr.mr_n64724928)
print v(xbgr.mr_n64725360)
print v(xbgr.mr_n64725792)
print v(xbgr.mr_n64726224)
print v(xbgr.mr_n64726656)
print v(xbgr.mr_n64727088)
print v(xbgr.mr_n64727520)
print v(xbgr.mr_n64727840)
print v(xbgr.mr_n64727952)
print v(xbgr.mr_n64728272)
print v(xbgr.mr_n64728384)
print v(xbgr.mr_n64728816)
print v(xbgr.mr_n64729248)
print v(xbgr.mr_n64729680)
print v(xbgr.mr_n64730112)
print v(xbgr.mr_n64730544)
print v(xbgr.mr_n64730976)
print v(xbgr.mr_n64731408)
print v(xbgr.mr_n64731840)
print v(xbgr.mr_n64732272)
print v(xbgr.mr_n64732704)
print v(xbgr.mr_n64733024)
print v(xbgr.mr_n64733136)
print v(xbgr.mr_n64733456)
print v(xbgr.mr_n64733568)
print v(xbgr.mr_n64733888)
print v(xbgr.mr_n64734000)
print v(xbgr.mr_n64734320)
print v(xbgr.mr_n64734432)
print v(xbgr.mr_n64734752)
print v(xbgr.mr_n64734864)
print v(xbgr.mr_n64735184)
print v(xbgr.mr_n64735296)
print v(xbgr.mr_n64735616)
print v(xbgr.mr_n64735728)
print v(xbgr.mr_n64736048)
print v(xbgr.mr_n64736160)
print v(xbgr.mr_n64736480)
print v(xbgr.mr_n64736592)
print v(xbgr.mr_n64736912)
print v(xbgr.mr_n64737024)
print v(xbgr.mr_n64737344)
print v(xbgr.mr_n64737456)
print v(xbgr.mr_n64737776)
print v(xbgr.mr_n64737888)
print v(xbgr.mr_n64738208)
print v(xbgr.mr_n64738320)
print v(xbgr.mr_n64738640)
print v(xbgr.mr_n64738752)
print v(xbgr.mr_n64739072)
print v(xbgr.mr_n64739184)
print v(xbgr.mr_n64739504)
print v(xbgr.mr_n64739616)
print v(xbgr.mr_n64739936)
print v(xbgr.mr_n64740048)
print v(xbgr.mr_n64740368)
print v(xbgr.mr_n64740480)
print v(xbgr.mr_n64740800)
print v(xbgr.mr_n64740912)
print v(xbgr.mr_n64741232)
print v(xbgr.mr_n64741344)
print v(xbgr.mr_n64741664)
print v(xbgr.mr_n64741776)
print v(xbgr.mr_n64742096)
print v(xbgr.mr_n64742208)
print v(xbgr.mr_n64742528)
print v(xbgr.mr_n64742640)
print v(xbgr.mr_n64742960)
print v(xbgr.mr_n64743072)
print v(xbgr.mr_n64743392)
print v(xbgr.mr_n64743504)
print v(xbgr.mr_n64743824)
print v(xbgr.mr_n64743936)
print v(xbgr.mr_n64744256)
print v(xbgr.mr_n64744688)
print v(xbgr.mr_n64744800)
print v(xbgr.mr_n64745120)
print v(xbgr.mr_n64745552)
print v(xbgr.mr_n64745664)
print v(xbgr.mr_n64745984)
print v(xbgr.mr_n64746416)
print v(xbgr.mr_n64746528)
print v(xbgr.mr_n64746848)
print v(xbgr.mr_n64747280)
print v(xbgr.mr_n64747392)
print v(xbgr.mr_n64747712)
print v(xbgr.mr_n64748144)
print v(xbgr.mr_n64748256)
print v(xbgr.mr_n64748576)
print v(xbgr.mr_n64748688)
print v(xbgr.mr_n64749008)
print v(xbgr.mr_n64749120)
print v(xbgr.mr_n64749440)
print v(xbgr.mr_n64749552)
print v(xbgr.mr_n64749872)
print v(xbgr.mr_n64749984)
print v(xbgr.mr_n64750304)
print v(xbgr.mr_n64750416)
print v(xbgr.mr_n64750736)
print v(xbgr.mr_n64750848)
print v(xbgr.mr_n64751168)
print v(xbgr.mr_n64751280)
print v(xbgr.mr_n64751600)
print v(xbgr.mr_n64751712)
print v(xbgr.mr_n64752032)
print v(xbgr.mr_n64752144)
print v(xbgr.mr_n64752464)
print v(xbgr.mr_n64752576)
print v(xbgr.mr_n64752896)
print v(xbgr.mr_n64753008)
print v(xbgr.mr_n64753328)
print v(xbgr.mr_n64753440)
print v(xbgr.mr_n64753760)
print v(xbgr.mr_n64753872)
print v(xbgr.mr_n64754192)
print v(xbgr.mr_n64754304)
print v(xbgr.mr_n64754624)
print v(xbgr.mr_n64754736)
print v(xbgr.mr_n64755056)
print v(xbgr.mr_n64755168)
print v(xbgr.mr_n64755488)
print v(xbgr.mr_n64755600)
print v(xbgr.mr_n64755920)
print v(xbgr.mr_n64756032)
print v(xbgr.mr_n64756352)
print v(xbgr.mr_n64756464)
print v(xbgr.mr_n64756784)
print v(xbgr.mr_n64756896)
print v(xbgr.mr_n64757216)
print v(xbgr.mr_n64757328)
print v(xbgr.mr_n64757648)
print v(xbgr.mr_n64757760)
print v(xbgr.mr_n64758080)
print v(xbgr.mr_n64758192)
print v(xbgr.mr_n64758512)
print v(xbgr.mr_n64758624)
print v(xbgr.mr_n64758944)
print v(xbgr.mr_n64759056)
print v(xbgr.mr_n64759376)
print v(xbgr.mr_n64759488)
print v(xbgr.mr_n64759808)
print v(xbgr.mr_n64759920)
print v(xbgr.mr_n64760240)
print v(xbgr.mr_n64760352)
print v(xbgr.mr_n64760672)
print v(xbgr.mr_n64760784)
print v(xbgr.mr_n64761104)
print v(xbgr.mr_n64761216)
print v(xbgr.mr_n64761536)
print v(xbgr.mr_n64761648)
print v(xbgr.mr_n64761968)
print v(xbgr.mr_n64762080)
print v(xbgr.mr_n64762400)
print v(xbgr.mr_n64762512)
print v(xbgr.mr_n64762832)
print v(xbgr.mr_n64762944)
print v(xbgr.mr_n64763264)
print v(xbgr.mr_n64763376)
print v(xbgr.mr_n64763696)
print v(xbgr.mr_n64763808)
print v(xbgr.mr_n64764128)
print v(xbgr.mr_n64764240)
print v(xbgr.mr_n64764560)
print v(xbgr.mr_n64764672)
print v(xbgr.mr_n64764992)
print v(xbgr.mr_n64765104)
print v(xbgr.mr_n64765424)
print v(xbgr.mr_n64765536)
print v(xbgr.mr_n64765856)
print v(xbgr.mr_n64765968)
print v(xbgr.mr_n64766288)
print v(xbgr.mr_n64766400)
print v(xbgr.mr_n64766720)
print v(xbgr.mr_n64767152)
print v(xbgr.mr_n64767264)
print v(xbgr.mr_n64767584)
print v(xbgr.mr_n64767696)
print v(xbgr.mr_n64768016)
print v(xbgr.mr_n64768128)
print v(xbgr.mr_n64768448)
print v(xbgr.mr_n64768880)
print v(xbgr.mr_n64768992)
print v(xbgr.mr_n64769312)
print v(xbgr.mr_n64769744)
print v(xbgr.mr_n64769856)
print v(xbgr.mr_n64770176)
print v(xbgr.mr_n64770288)
print v(xbgr.mr_n64770608)
print v(xbgr.mr_n64770720)
print v(xbgr.mr_n64771040)
print v(xbgr.mr_n64771152)
print v(xbgr.mr_n64771472)
print v(xbgr.mr_n64771584)
print v(xbgr.mr_n64771904)
print v(xbgr.mr_n64772016)
print v(xbgr.mr_n64772336)
print v(xbgr.mr_n64772448)
print v(xbgr.mr_n64772768)
print v(xbgr.mr_n64772880)
print v(xbgr.mr_n64773200)
print v(xbgr.mr_n64773312)
print v(xbgr.mr_n64773632)
print v(xbgr.mr_n64773744)
print v(xbgr.mr_n64774064)
print v(xbgr.mr_n64774176)
print v(xbgr.mr_n64774496)
print v(xbgr.mr_n64774608)
print v(xbgr.mr_n64774928)
print v(xbgr.mr_n64775040)
print v(xbgr.mr_n64775360)
print v(xbgr.mr_n64775792)
print v(xbgr.mr_n64775904)
print v(xbgr.mr_n64776224)
print v(xbgr.mr_n64776336)
print v(xbgr.mr_n64776656)
print v(xbgr.mr_n64776768)
print v(xbgr.mr_n64777088)
print v(xbgr.mr_n64777200)
print v(xbgr.mr_n64777520)
print v(xbgr.mr_n64777632)
print v(xbgr.mr_n64777952)
print v(xbgr.mr_n64778064)
print v(xbgr.mr_n64778384)
print v(xbgr.mr_n64778496)
print v(xbgr.mr_n64778816)
print v(xbgr.mr_n64778928)
print v(xbgr.mr_n64779248)
print v(xbgr.mr_n64779360)
print v(xbgr.mr_n64779680)
print v(xbgr.mr_n64779792)
print v(xbgr.mr_n64780112)
print v(xbgr.mr_n64780224)
print v(xbgr.mr_n64780544)
print v(xbgr.mr_n64780656)
print v(xbgr.mr_n64780976)
print v(xbgr.mr_n64781088)
print v(xbgr.mr_n64781408)
print v(xbgr.mr_n64781520)
print v(xbgr.mr_n64781840)
print v(xbgr.mr_n64781952)
print v(xbgr.mr_n64782272)
print v(xbgr.mr_n64782384)
print v(xbgr.mr_n64782704)
print v(xbgr.mr_n64782816)
print v(xbgr.mr_n64783136)
print v(xbgr.mr_n64783248)
print v(xbgr.mr_n64783568)
print v(xbgr.mr_n64783680)
print v(xbgr.mr_n64784000)
print v(xbgr.mr_n64784112)
print v(xbgr.mr_n64784432)
print v(xbgr.mr_n64784544)
print v(xbgr.mr_n64784864)
print v(xbgr.mr_n64784976)
print v(xbgr.mr_n64785296)
print v(xbgr.mr_n64785408)
print v(xbgr.mr_n64785728)
print v(xbgr.mr_n64785840)
print v(xbgr.mr_n64786160)
print v(xbgr.mr_n64786272)
print v(xbgr.mr_n64786592)
print v(xbgr.mr_n64786704)
print v(xbgr.mr_n64787024)
print v(xbgr.mr_n64787136)
print v(xbgr.mr_n64787456)
print v(xbgr.mr_n64787568)
print v(xbgr.mr_n64787888)
print v(xbgr.mr_n64788000)
print v(xbgr.mr_n64788320)
print v(xbgr.mr_n64788432)
print v(xbgr.mr_n64788752)
print v(xbgr.mr_n64788864)
print v(xbgr.mr_n64789184)
print v(xbgr.mr_n64789296)
print v(xbgr.mr_n64789616)
print v(xbgr.mr_n64789728)
print v(xbgr.mr_n64790048)
print v(xbgr.mr_n64790160)
print v(xbgr.mr_n64790480)
print v(xbgr.mr_n64790592)
print v(xbgr.mr_n64790912)
print v(xbgr.mr_n64791024)
print v(xbgr.mr_n64791344)
print v(xbgr.mr_n64791456)
print v(xbgr.mr_n64791776)
print v(xbgr.mr_n64791888)
print v(xbgr.mr_n64792208)
print v(xbgr.mr_n64792320)
print v(xbgr.mr_n64792640)
print v(xbgr.mr_n64792752)
print v(xbgr.mr_n64793072)
print v(xbgr.mr_n64793184)
print v(xbgr.mr_n64793504)
print v(xbgr.mr_n64793616)
print v(xbgr.mr_n64793936)
print v(xbgr.mr_n64794048)
print v(xbgr.mr_n64794368)
print v(xbgr.mr_n64794480)
print v(xbgr.mr_n64794800)
print v(xbgr.mr_n64794912)
print v(xbgr.mr_n64795232)
print v(xbgr.mr_n64795344)
print v(xbgr.mr_n64795664)
print v(xbgr.mr_n64795776)
print v(xbgr.mr_n64796096)
print v(xbgr.mr_n64796208)
print v(xbgr.mr_n64796528)
print v(xbgr.mr_n64796640)
print v(xbgr.mr_n64796960)
print v(xbgr.mr_n64797072)
print v(xbgr.mr_n64797504)
print v(xbgr.mr_n64797936)
print v(xbgr.mr_n64798368)
print v(xbgr.mr_n64798800)
print v(xbgr.mr_n64799232)
print v(xbgr.mr_n64799664)
print v(xbgr.mr_n64800096)
print v(xbgr.mr_n64800528)
print v(xbgr.mr_n64800848)
print v(xbgr.mr_n64800960)
print v(xbgr.mr_n64801280)
print v(xbgr.mr_n64801392)
print v(xbgr.mr_n64801712)
print v(xbgr.mr_n64801824)
print v(xbgr.mr_n64802144)
print v(xbgr.mr_n64802256)
print v(xbgr.mr_n64802576)
print v(xbgr.mr_n64802688)
print v(xbgr.mr_n64803008)
print v(xbgr.mr_n64803120)
print v(xbgr.mr_n64803440)
print v(xbgr.mr_n64803552)
print v(xbgr.mr_n64803872)
print v(xbgr.mr_n64803984)
print v(xbgr.mr_n64804416)
print v(xbgr.mr_n64804848)
print v(xbgr.mr_n64805280)
print v(xbgr.mr_n64805712)
print v(xbgr.mr_n64806144)
print v(xbgr.mr_n64806576)
print v(xbgr.mr_n64806896)
print v(xbgr.mr_n64807008)
print v(xbgr.mr_n64807440)
print v(xbgr.mr_n64807872)
print v(xbgr.mr_n64808304)
print v(xbgr.mr_n64808736)
print v(xbgr.mr_n64809168)
print v(xbgr.mr_n64809600)
print v(xbgr.mr_n64810032)
print v(xbgr.mr_n64810464)
print v(xbgr.mr_n64810896)
print v(xbgr.mr_n64811328)
print v(xbgr.mr_n64811760)
print v(xbgr.mr_n64812192)
print v(xbgr.mr_n64812512)
print v(xbgr.mr_n64812624)
print v(xbgr.mr_n64812944)
print v(xbgr.mr_n64813056)
print v(xbgr.mr_n64813376)
print v(xbgr.mr_n64813488)
print v(xbgr.mr_n64813808)
print v(xbgr.mr_n64813920)
print v(xbgr.mr_n64814240)
print v(xbgr.mr_n64814352)
print v(xbgr.mr_n64814672)
print v(xbgr.mr_n64814784)
print v(xbgr.mr_n64815104)
print v(xbgr.mr_n64815216)
print v(xbgr.mr_n64815536)
print v(xbgr.mr_n64815648)
print v(xbgr.mr_n64815968)
print v(xbgr.mr_n64816080)
print v(xbgr.mr_n64816400)
print v(xbgr.mr_n64816512)
print v(xbgr.mr_n64816832)
print v(xbgr.mr_n64816944)
print v(xbgr.mr_n64817264)
print v(xbgr.mr_n64817376)
print v(xbgr.mr_n64817696)
print v(xbgr.mr_n64817808)
print v(xbgr.mr_n64818128)
print v(xbgr.mr_n64818240)
print v(xbgr.mr_n64818560)
print v(xbgr.mr_n64818672)
print v(xbgr.mr_n64818992)
print v(xbgr.mr_n64819104)
print v(xbgr.mr_n64819424)
print v(xbgr.mr_n64819536)
print v(xbgr.mr_n64819856)
print v(xbgr.mr_n64819968)
print v(xbgr.mr_n64820288)
print v(xbgr.mr_n64820400)
print v(xbgr.mr_n64820720)
print v(xbgr.mr_n64820832)
print v(xbgr.mr_n64821152)
print v(xbgr.mr_n64821264)
print v(xbgr.mr_n64821696)
print v(xbgr.mr_n64822128)
print v(xbgr.mr_n64822560)
print v(xbgr.mr_n64822992)
print v(xbgr.mr_n64823424)
print v(xbgr.mr_n64823856)
print v(xbgr.mr_n64824288)
print v(xbgr.mr_n64824720)
print v(xbgr.mr_n64825152)
print v(xbgr.mr_n64825584)
print v(xbgr.mr_n64826016)
print v(xbgr.mr_n64826448)
print v(xbgr.mr_n64826880)
print v(xbgr.mr_n64827312)
print v(xbgr.mr_n64827744)
print v(xbgr.mr_n64828176)
print v(xbgr.mr_n64828608)
print v(xbgr.mr_n64829040)
print v(xbgr.mr_n64829472)
print v(xbgr.mr_n64829792)
print v(xbgr.mr_n64829904)
print v(xbgr.mr_n64830224)
print v(xbgr.mr_n64830336)
print v(xbgr.mr_n64830656)
print v(xbgr.mr_n64830768)
print v(xbgr.mr_n64831088)
print v(xbgr.mr_n64831200)
print v(xbgr.mr_n64831520)
print v(xbgr.mr_n64831632)
print v(xbgr.mr_n64832064)
print v(xbgr.mr_n64832496)
print v(xbgr.mr_n64832928)
print v(xbgr.mr_n64833360)
print v(xbgr.mr_n64833792)
print v(xbgr.mr_n64834224)
print v(xbgr.mr_n64834656)
print v(xbgr.mr_n64834976)
print v(xbgr.mr_n64835088)
print v(xbgr.mr_n64835408)
print v(xbgr.mr_n64835520)
print v(xbgr.mr_n64835840)
print v(xbgr.mr_n64835952)
print v(xbgr.mr_n64836272)
print v(xbgr.mr_n64836384)
print v(xbgr.mr_n64836704)
print v(xbgr.mr_n64836816)
print v(xbgr.mr_n64837136)
print v(xbgr.mr_n64837248)
print v(xbgr.mr_n64837568)
print v(xbgr.mr_n64837680)
print v(xbgr.mr_n64838000)
print v(xbgr.mr_n64838112)
print v(xbgr.mr_n64838432)
print v(xbgr.mr_n64838544)
print v(xbgr.mr_n64838864)
print v(xbgr.mr_n64838976)
print v(xbgr.mr_n64839296)
print v(xbgr.mr_n64839408)
print v(xbgr.mr_n64839728)
print v(xbgr.mr_n64839840)
print v(xbgr.mr_n64840160)
print v(xbgr.mr_n64840272)
print v(xbgr.mr_n64840704)
print v(xbgr.mr_n64841136)
print v(xbgr.mr_n64841568)
print v(xbgr.mr_n64842000)
print v(xbgr.mr_n64842432)
print v(xbgr.mr_n64842864)
print v(xbgr.mr_n64843296)
print v(xbgr.mr_n64843728)
print v(xbgr.mr_n64844160)
print v(xbgr.mr_n64844592)
print v(xbgr.mr_n64845024)
print v(xbgr.mr_n64845456)
print v(xbgr.mr_n64845888)
print v(xbgr.mr_n64846208)
print v(xbgr.mr_n64846320)
print v(xbgr.mr_n64846640)
print v(xbgr.mr_n64846752)
print v(xbgr.mr_n64847072)
print v(xbgr.mr_n64847184)
print v(xbgr.mr_n64847504)
print v(xbgr.mr_n64847616)
print v(xbgr.mr_n64847936)
print v(xbgr.mr_n64848048)
print v(xbgr.mr_n64848368)
print v(xbgr.mr_n64848480)
print v(xbgr.mr_n64848800)
print v(xbgr.mr_n64848912)
print v(xbgr.mr_n64849232)
print v(xbgr.mr_n64849344)
print v(xbgr.mr_n64849664)
print v(xbgr.mr_n64849776)
print v(xbgr.mr_n64850096)
print v(xbgr.mr_n64850208)
print v(xbgr.mr_n64850528)
print v(xbgr.mr_n64850640)
print v(xbgr.mr_n64850960)
print v(xbgr.mr_n64851072)
print v(xbgr.mr_n64851504)
print v(xbgr.mr_n64851936)
print v(xbgr.mr_n64852368)
print v(xbgr.mr_n64852800)
print v(xbgr.mr_n64853232)
print v(xbgr.mr_n64853664)
print v(xbgr.mr_n64854096)
print v(xbgr.mr_n64854528)
print v(xbgr.mr_n64854960)
print v(xbgr.mr_n64855392)
print v(xbgr.mr_n64855824)
print v(xbgr.mr_n64856256)
print v(xbgr.mr_n64856576)
print v(xbgr.mr_n64856688)
print v(xbgr.mr_n64857120)
print v(xbgr.mr_n64857440)
print v(xbgr.mr_n64857552)
print v(xbgr.mr_n64857872)
print v(xbgr.mr_n64857984)
print v(xbgr.mr_n64858304)
print v(xbgr.mr_n64858416)
print v(xbgr.mr_n64858736)
print v(xbgr.mr_n64858848)
print v(xbgr.mr_n64859168)
print v(xbgr.mr_n64859280)
print v(xbgr.mr_n64859712)
print v(xbgr.mr_n64860144)
print v(xbgr.mr_n64860464)
print v(xbgr.mr_n64860576)
print v(xbgr.mr_n64860896)
print v(xbgr.mr_n64861008)
print v(xbgr.mr_n64861328)
print v(xbgr.mr_n64861440)
print v(xbgr.mr_n64861760)
print v(xbgr.mr_n64861872)
print v(xbgr.mr_n64862192)
print v(xbgr.mr_n64862304)
print v(xbgr.mr_n64862624)
print v(xbgr.mr_n64862736)
print v(xbgr.mr_n64863056)
print v(xbgr.mr_n64863168)
print v(xbgr.mr_n64863488)
print v(xbgr.mr_n64863600)
print v(xbgr.mr_n64864032)
print v(xbgr.mr_n64864464)
print v(xbgr.mr_n64864896)
print v(xbgr.mr_n64865328)
print v(xbgr.mr_n64865760)
print v(xbgr.mr_n64866192)
print v(xbgr.mr_n64866624)
print v(xbgr.mr_n64867056)
print v(xbgr.mr_n64867488)
print v(xbgr.mr_n64867920)
print v(xbgr.mr_n64868352)
print v(xbgr.mr_n64868672)
print v(xbgr.mr_n64868784)
print v(xbgr.mr_n64869104)
print v(xbgr.mr_n64869216)
print v(xbgr.mr_n64869536)
print v(xbgr.mr_n64869648)
print v(xbgr.mr_n64870080)
print v(xbgr.mr_n64870512)
print v(xbgr.mr_n64870832)
print v(xbgr.mr_n64870944)
print v(xbgr.mr_n64871264)
print v(xbgr.mr_n64871376)
print v(xbgr.mr_n64871696)
print v(xbgr.mr_n64871808)
print v(xbgr.mr_n64872128)
print v(xbgr.mr_n64872240)
print v(xbgr.mr_n64872672)
print v(xbgr.mr_n64872992)
print v(xbgr.mr_n64873104)
print v(xbgr.mr_n64873424)
print v(xbgr.mr_n64873536)
print v(xbgr.mr_n64873856)
print v(xbgr.mr_n64873968)
print v(xbgr.mr_n64874288)
print v(xbgr.mr_n64874400)
print v(xbgr.mr_n64874720)
print v(xbgr.mr_n64874832)
print v(xbgr.mr_n64875152)
print v(xbgr.mr_n64875264)
print v(xbgr.mr_n64875696)
print v(xbgr.mr_n64876128)
print v(xbgr.mr_n64876560)
print v(xbgr.mr_n64876992)
print v(xbgr.mr_n64877424)
print v(xbgr.mr_n64877856)
print v(xbgr.mr_n64878288)
print v(xbgr.mr_n64878720)
print v(xbgr.mr_n64879152)
print v(xbgr.mr_n64879584)
print v(xbgr.mr_n64879904)
print v(xbgr.mr_n64880016)
print v(xbgr.mr_n64880336)
print v(xbgr.mr_n64880448)
print v(xbgr.mr_n64880768)
print v(xbgr.mr_n64880880)
print v(xbgr.mr_n64881200)
print v(xbgr.mr_n64881312)
print v(xbgr.mr_n64881632)
print v(xbgr.mr_n64881744)
print v(xbgr.mr_n64882064)
print v(xbgr.mr_n64882176)
print v(xbgr.mr_n64882496)
print v(xbgr.mr_n64882608)
print v(xbgr.mr_n64882928)
print v(xbgr.mr_n64883040)
print v(xbgr.mr_n64883360)
print v(xbgr.mr_n64883472)
print v(xbgr.mr_n64883792)
print v(xbgr.mr_n64883904)
print v(xbgr.mr_n64884224)
print v(xbgr.mr_n64884336)
print v(xbgr.mr_n64884656)
print v(xbgr.mr_n64884768)
print v(xbgr.mr_n64885088)
print v(xbgr.mr_n64885200)
print v(xbgr.mr_n64885632)
print v(xbgr.mr_n64886064)
print v(xbgr.mr_n64886496)
print v(xbgr.mr_n64886928)
print v(xbgr.mr_n64887360)
print v(xbgr.mr_n64887792)
print v(xbgr.mr_n64888224)
print v(xbgr.mr_n64888656)
print v(xbgr.mr_n64889088)
print v(xbgr.mr_n64889520)
print v(xbgr.mr_n64889952)
print v(xbgr.mr_n64890384)
print v(xbgr.mr_n64890816)
print v(xbgr.mr_n64891136)
print v(xbgr.mr_n64891248)
print v(xbgr.mr_n64891568)
print v(xbgr.mr_n64891680)
print v(xbgr.mr_n64892000)
print v(xbgr.mr_n64892112)
print v(xbgr.mr_n64892432)
print v(xbgr.mr_n64892544)
print v(xbgr.mr_n64892864)
print v(xbgr.mr_n64892976)
print v(xbgr.mr_n64893296)
print v(xbgr.mr_n64893408)
print v(xbgr.mr_n64893728)
print v(xbgr.mr_n64893840)
print v(xbgr.mr_n64894160)
print v(xbgr.mr_n64894272)
print v(xbgr.mr_n64894592)
print v(xbgr.mr_n64894704)
print v(xbgr.mr_n64895024)
print v(xbgr.mr_n64895136)
print v(xbgr.mr_n64895456)
print v(xbgr.mr_n64895568)
print v(xbgr.mr_n64895888)
print v(xbgr.mr_n64896000)
print v(xbgr.mr_n64896320)
print v(xbgr.mr_n64896432)
print v(xbgr.mr_n64896864)
print v(xbgr.mr_n64897296)
print v(xbgr.mr_n64897728)
print v(xbgr.mr_n64898160)
print v(xbgr.mr_n64898592)
print v(xbgr.mr_n64899024)
print v(xbgr.mr_n64899456)
print v(xbgr.mr_n64899888)
print v(xbgr.mr_n64900320)
print v(xbgr.mr_n64900752)
print v(xbgr.mr_n64901184)
print v(xbgr.mr_n64901616)
print v(xbgr.mr_n64902048)
print v(xbgr.mr_n64902368)
print v(xbgr.mr_n64902480)
print v(xbgr.mr_n64902800)
print v(xbgr.mr_n64902912)
print v(xbgr.mr_n64903232)
print v(xbgr.mr_n64903344)
print v(xbgr.mr_n64903664)
print v(xbgr.mr_n64903776)
print v(xbgr.mr_n64904096)
print v(xbgr.mr_n64904208)
print v(xbgr.mr_n64904528)
print v(xbgr.mr_n64904640)
print v(xbgr.mr_n64904960)
print v(xbgr.mr_n64905072)
print v(xbgr.mr_n64905392)
print v(xbgr.mr_n64905504)
print v(xbgr.mr_n64905824)
print v(xbgr.mr_n64905936)
print v(xbgr.mr_n64906256)
print v(xbgr.mr_n64906368)
print v(xbgr.mr_n64906688)
print v(xbgr.mr_n64906800)
print v(xbgr.mr_n64907120)
print v(xbgr.mr_n64907232)
print v(xbgr.mr_n64907552)
print v(xbgr.mr_n64907664)
print v(xbgr.mr_n64908096)
print v(xbgr.mr_n64908528)
print v(xbgr.mr_n64908960)
print v(xbgr.mr_n64909392)
print v(xbgr.mr_n64909824)
print v(xbgr.mr_n64910256)
print v(xbgr.mr_n64910688)
print v(xbgr.mr_n64911120)
print v(xbgr.mr_n64911552)
print v(xbgr.mr_n64911984)
print v(xbgr.mr_n64912416)
print v(xbgr.mr_n64912848)
print v(xbgr.mr_n64913280)
print v(xbgr.mr_n64913600)
print v(xbgr.mr_n64913712)
print v(xbgr.mr_n64914032)
print v(xbgr.mr_n64914144)
print v(xbgr.mr_n64914576)
print v(xbgr.mr_n64914896)
print v(xbgr.mr_n64915008)
print v(xbgr.mr_n64915328)
print v(xbgr.mr_n64915440)
print v(xbgr.mr_n64915760)
print v(xbgr.mr_n64915872)
print v(xbgr.mr_n64916192)
print v(xbgr.mr_n64916304)
print v(xbgr.mr_n64916736)
print v(xbgr.mr_n64917168)
print v(xbgr.mr_n64917600)
print v(xbgr.mr_n64918032)
print v(xbgr.mr_n64918352)
print v(xbgr.mr_n64918464)
print v(xbgr.mr_n64918784)
print v(xbgr.mr_n64918896)
print v(xbgr.mr_n64919328)
print v(xbgr.mr_n64919760)
print v(xbgr.mr_n64920080)
print v(xbgr.mr_n64920192)
print v(xbgr.mr_n64920512)
print v(xbgr.mr_n64920624)
print v(xbgr.mr_n64920944)
print v(xbgr.mr_n64921056)
print v(xbgr.mr_n64921376)
print v(xbgr.mr_n64921488)
print v(xbgr.mr_n64921808)
print v(xbgr.mr_n64921920)
print v(xbgr.mr_n64922352)
print v(xbgr.mr_n64922784)
print v(xbgr.mr_n64923216)
print v(xbgr.mr_n64923648)
print v(xbgr.mr_n64924080)
print v(xbgr.mr_n64924512)
print v(xbgr.mr_n64924832)
print v(xbgr.mr_n64924944)
print v(xbgr.mr_n64925264)
print v(xbgr.mr_n64925376)
print v(xbgr.mr_n64925696)
print v(xbgr.mr_n64925808)
print v(xbgr.mr_n64926128)
print v(xbgr.mr_n64926240)
print v(xbgr.mr_n64926560)
print v(xbgr.mr_n64926672)
print v(xbgr.mr_n64926992)
print v(xbgr.mr_n64927104)
print v(xbgr.mr_n64927424)
print v(xbgr.mr_n64927536)
print v(xbgr.mr_n64927856)
print v(xbgr.mr_n64927968)
print v(xbgr.mr_n64928288)
print v(xbgr.mr_n64928400)
print v(xbgr.mr_n64928720)
print v(xbgr.mr_n64928832)
print v(xbgr.mr_n64929152)
print v(xbgr.mr_n64929264)
print v(xbgr.mr_n64929584)
print v(xbgr.mr_n64929696)
print v(xbgr.mr_n64930128)
print v(xbgr.mr_n64930560)
print v(xbgr.mr_n64930992)
print v(xbgr.mr_n64931424)
print v(xbgr.mr_n64931856)
print v(xbgr.mr_n64932288)
print v(xbgr.mr_n64932720)
print v(xbgr.mr_n64933152)
print v(xbgr.mr_n64933472)
print v(xbgr.mr_n64933584)
print v(xbgr.mr_n64933904)
print v(xbgr.mr_n64934016)
print v(xbgr.mr_n64934336)
print v(xbgr.mr_n64934448)
print v(xbgr.mr_n64934768)
print v(xbgr.mr_n64934880)
print v(xbgr.mr_n64935200)
print v(xbgr.mr_n64935312)
print v(xbgr.mr_n64935632)
print v(xbgr.mr_n64935744)
print v(xbgr.mr_n64936064)
print v(xbgr.mr_n64936176)
print v(xbgr.mr_n64936496)
print v(xbgr.mr_n64936608)
print v(xbgr.mr_n64937040)
print v(xbgr.mr_n64937472)
print v(xbgr.mr_n64937792)
print v(xbgr.mr_n64937904)
print v(xbgr.mr_n64938224)
print v(xbgr.mr_n64938336)
print v(xbgr.mr_n64938656)
print v(xbgr.mr_n64938768)
print v(xbgr.mr_n64939088)
print v(xbgr.mr_n64939200)
print v(xbgr.mr_n64939520)
print v(xbgr.mr_n64939632)
print v(xbgr.mr_n64939952)
print v(xbgr.mr_n64940064)
print v(xbgr.mr_n64940496)
print v(xbgr.mr_n64940928)
print v(xbgr.mr_n64941360)
print v(xbgr.mr_n64941792)
print v(xbgr.mr_n64942224)
print v(xbgr.mr_n64942656)
print v(xbgr.mr_n64943088)
print v(xbgr.mr_n64943520)
print v(xbgr.mr_n64943952)
print v(xbgr.mr_n64944384)
print v(xbgr.mr_n64944816)
print v(xbgr.mr_n64945248)
print v(xbgr.mr_n64945680)
print v(xbgr.mr_n64946112)
print v(xbgr.mr_n64946544)
print v(xbgr.mr_n64946976)
print v(xbgr.mr_n64947296)
print v(xbgr.mr_n64947408)
print v(xbgr.mr_n64947728)
print v(xbgr.mr_n64947840)
print v(xbgr.mr_n64948160)
print v(xbgr.mr_n64948272)
print v(xbgr.mr_n64948592)
print v(xbgr.mr_n64948704)
print v(xbgr.mr_n64949024)
print v(xbgr.mr_n64949136)
print v(xbgr.mr_n64949456)
print v(xbgr.mr_n64949568)
print v(xbgr.mr_n64949888)
print v(xbgr.mr_n64950000)
print v(xbgr.mr_n64950320)
print v(xbgr.mr_n64950432)
print v(xbgr.mr_n64950752)
print v(xbgr.mr_n64950864)
print v(xbgr.mr_n64951184)
print v(xbgr.mr_n64951296)
print v(xbgr.mr_n64951616)
print v(xbgr.mr_n64951728)
print v(xbgr.mr_n64952048)
print v(xbgr.mr_n64952160)
print v(xbgr.mr_n64952480)
print v(xbgr.mr_n64952592)
print v(xbgr.mr_n64952912)
print v(xbgr.mr_n64953024)
print v(xbgr.mr_n64953344)
print v(xbgr.mr_n64953456)
print v(xbgr.mr_n64953776)
print v(xbgr.mr_n64953888)
print v(xbgr.mr_n64954208)
print v(xbgr.mr_n64954320)
print v(xbgr.mr_n64954640)
print v(xbgr.mr_n64954752)
print v(xbgr.mr_n64955072)
print v(xbgr.mr_n64955184)
print v(xbgr.mr_n64955504)
print v(xbgr.mr_n64955616)
print v(xbgr.mr_n64956048)
print v(xbgr.mr_n64956480)
print v(xbgr.mr_n64956912)
print v(xbgr.mr_n64957344)
print v(xbgr.mr_n64957776)
print v(xbgr.mr_n64958208)
print v(xbgr.mr_n64958528)
print v(xbgr.mr_n64958640)
print v(xbgr.mr_n64958960)
print v(xbgr.mr_n64959072)
print v(xbgr.mr_n64959392)
print v(xbgr.mr_n64959504)
print v(xbgr.mr_n64959824)
print v(xbgr.mr_n64959936)
print v(xbgr.mr_n64960256)
print v(xbgr.mr_n64960368)
print v(xbgr.mr_n64960688)
print v(xbgr.mr_n64960800)
print v(xbgr.mr_n64961232)
print v(xbgr.mr_n64961664)
print v(xbgr.mr_n64962096)
print v(xbgr.mr_n64962528)
print v(xbgr.mr_n64962960)
print v(xbgr.mr_n64963392)
print v(xbgr.mr_n64963824)
print v(xbgr.mr_n64964256)
print v(xbgr.mr_n64964688)
print v(xbgr.mr_n64965120)
print v(xbgr.mr_n64965552)
print v(xbgr.mr_n64965984)
print v(xbgr.mr_n64966416)
print v(xbgr.mr_n64966848)
print v(xbgr.mr_n64967280)
print v(xbgr.mr_n64967712)
print v(xbgr.mr_n64968144)
print v(xbgr.mr_n64968576)
print v(xbgr.mr_n64969008)
print v(xbgr.mr_n64969440)
print v(xbgr.mr_n64969760)
print v(xbgr.mr_n64969872)
print v(xbgr.mr_n64970192)
print v(xbgr.mr_n64970304)
print v(xbgr.mr_n64970624)
print v(xbgr.mr_n64970736)
print v(xbgr.mr_n64971056)
print v(xbgr.mr_n64971168)
print v(xbgr.mr_n64971488)
print v(xbgr.mr_n64971600)
print v(xbgr.mr_n64971920)
print v(xbgr.mr_n64972032)
print v(xbgr.mr_n64972352)
print v(xbgr.mr_n64972464)
print v(xbgr.mr_n64972784)
print v(xbgr.mr_n64972896)
print v(xbgr.mr_n64973216)
print v(xbgr.mr_n64973328)
print v(xbgr.mr_n64973648)
print v(xbgr.mr_n64973760)
print v(xbgr.mr_n64974080)
print v(xbgr.mr_n64974192)
print v(xbgr.mr_n64974512)
print v(xbgr.mr_n64974624)
print v(xbgr.mr_n64974944)
print v(xbgr.mr_n64975056)
print v(xbgr.mr_n64975376)
print v(xbgr.mr_n64975488)
print v(xbgr.mr_n64975808)
print v(xbgr.mr_n64975920)
print v(xbgr.mr_n64976240)
print v(xbgr.mr_n64976352)
print v(xbgr.mr_n64976672)
print v(xbgr.mr_n64976784)
print v(xbgr.mr_n64977104)
print v(xbgr.mr_n64977216)
print v(xbgr.mr_n64977536)
print v(xbgr.mr_n64977648)
print v(xbgr.mr_n64977968)
print v(xbgr.mr_n64978080)
print v(xbgr.mr_n64978400)
print v(xbgr.mr_n64978512)
print v(xbgr.mr_n64978832)
print v(xbgr.mr_n64978944)
print v(xbgr.mr_n64979264)
print v(xbgr.mr_n64979376)
print v(xbgr.mr_n64979696)
print v(xbgr.mr_n64979808)
print v(xbgr.mr_n64980128)
print v(xbgr.mr_n64980240)
print v(xbgr.mr_n64980560)
print v(xbgr.mr_n64980672)
print v(xbgr.mr_n64980992)
print v(xbgr.mr_n64981104)
print v(xbgr.mr_n64981424)
print v(xbgr.mr_n64981536)
print v(xbgr.mr_n64981856)
print v(xbgr.mr_n64981968)
print v(xbgr.mr_n64982288)
print v(xbgr.mr_n64982400)
print v(xbgr.mr_n64982720)
print v(xbgr.mr_n64982832)
print v(xbgr.mr_n64983152)
print v(xbgr.mr_n64983264)
print v(xbgr.mr_n64983696)
print v(xbgr.mr_n64984128)
print v(xbgr.mr_n64984448)
print v(xbgr.mr_n64984560)
print v(xbgr.mr_n64984880)
print v(xbgr.mr_n64984992)
print v(xbgr.mr_n64985312)
print v(xbgr.mr_n64985424)
print v(xbgr.mr_n64985744)
print v(xbgr.mr_n64985856)
print v(xbgr.mr_n64986176)
print v(xbgr.mr_n64986288)
print v(xbgr.mr_n64986608)
print v(xbgr.mr_n64986720)
print v(xbgr.mr_n64987040)
print v(xbgr.mr_n64987152)
print v(xbgr.mr_n64987472)
print v(xbgr.mr_n64987584)
print v(xbgr.mr_n64987904)
print v(xbgr.mr_n64988016)
print v(xbgr.mr_n64988336)
print v(xbgr.mr_n64988448)
print v(xbgr.mr_n64988880)
print v(xbgr.mr_n64989312)
print v(xbgr.mr_n64989744)
print v(xbgr.mr_n64990064)
print v(xbgr.mr_n64990176)
print v(xbgr.mr_n64990496)
print v(xbgr.mr_n64990608)
print v(xbgr.mr_n64991040)
print v(xbgr.mr_n64991472)
print v(xbgr.mr_n64991904)
print v(xbgr.mr_n64992336)
print v(xbgr.mr_n64992768)
print v(xbgr.mr_n64993200)
print v(xbgr.mr_n64993632)
print v(xbgr.mr_n64994064)
print v(xbgr.mr_n64994496)
print v(xbgr.mr_n64994928)
print v(xbgr.mr_n64995360)
print v(xbgr.mr_n64995680)
print v(xbgr.mr_n64995792)
print v(xbgr.mr_n64996112)
print v(xbgr.mr_n64996224)
print v(xbgr.mr_n64996544)
print v(xbgr.mr_n64996656)
print v(xbgr.mr_n64996976)
print v(xbgr.mr_n64997088)
print v(xbgr.mr_n64997408)
print v(xbgr.mr_n64997520)
print v(xbgr.mr_n64997840)
print v(xbgr.mr_n64997952)
print v(xbgr.mr_n64998272)
print v(xbgr.mr_n64998384)
print v(xbgr.mr_n64998704)
print v(xbgr.mr_n64998816)
print v(xbgr.mr_n64999248)
print v(xbgr.mr_n64999680)
print v(xbgr.mr_n65000112)
print v(xbgr.mr_n65000544)
print v(xbgr.mr_n65000976)
print v(xbgr.mr_n65001408)
print v(xbgr.mr_n65001840)
print v(xbgr.mr_n65002272)
print v(xbgr.mr_n65002704)
print v(xbgr.mr_n65003136)
print v(xbgr.mr_n65003568)
print v(xbgr.mr_n65004000)
print v(xbgr.mr_n65004432)
print v(xbgr.mr_n65004864)
print v(xbgr.mr_n65005296)
print v(xbgr.mr_n65005728)
print v(xbgr.mr_n65006160)
print v(xbgr.mr_n65006592)
print v(xbgr.mr_n65007024)
print v(xbgr.mr_n65007456)
print v(xbgr.mr_n65007776)
print v(xbgr.mr_n65007888)
print v(xbgr.mr_n65008208)
print v(xbgr.mr_n65008320)
print v(xbgr.mr_n65008640)
print v(xbgr.mr_n65008752)
print v(xbgr.mr_n65009072)
print v(xbgr.mr_n65009184)
print v(xbgr.mr_n65009504)
print v(xbgr.mr_n65009616)
print v(xbgr.mr_n65009936)
print v(xbgr.mr_n65010048)
print v(xbgr.mr_n65010368)
print v(xbgr.mr_n65010480)
print v(xbgr.mr_n65010800)
print v(xbgr.mr_n65010912)
print v(xbgr.mr_n65011232)
print v(xbgr.mr_n65011344)
print v(xbgr.mr_n65011664)
print v(xbgr.mr_n65011776)
print v(xbgr.mr_n65012096)
print v(xbgr.mr_n65012208)
print v(xbgr.mr_n65012528)
print v(xbgr.mr_n65012640)
print v(xbgr.mr_n65012960)
print v(xbgr.mr_n65013072)
print v(xbgr.mr_n65013504)
print v(xbgr.mr_n65013936)
print v(xbgr.mr_n65014368)
print v(xbgr.mr_n65014800)
print v(xbgr.mr_n65015232)
print v(xbgr.mr_n65015664)
print v(xbgr.mr_n65016096)
print v(xbgr.mr_n65016528)
print v(xbgr.mr_n65016960)
print v(xbgr.mr_n65017392)
print v(xbgr.mr_n65017824)
print v(xbgr.mr_n65018256)
print v(xbgr.mr_n65018688)
print v(xbgr.mr_n65019008)
print v(xbgr.mr_n65019120)
print v(xbgr.mr_n65019440)
print v(xbgr.mr_n65019552)
print v(xbgr.mr_n65019872)
print v(xbgr.mr_n65019984)
print v(xbgr.mr_n65020304)
print v(xbgr.mr_n65020416)
print v(xbgr.mr_n65020736)
print v(xbgr.mr_n65020848)
print v(xbgr.mr_n65021168)
print v(xbgr.mr_n65021280)
print v(xbgr.mr_n65021600)
print v(xbgr.mr_n65021712)
print v(xbgr.mr_n65022032)
print v(xbgr.mr_n65022144)
print v(xbgr.mr_n65022464)
print v(xbgr.mr_n65022576)
print v(xbgr.mr_n65022896)
print v(xbgr.mr_n65023008)
print v(xbgr.mr_n65023328)
print v(xbgr.mr_n65023440)
print v(xbgr.mr_n65023760)
print v(xbgr.mr_n65023872)
print v(xbgr.mr_n65024304)
print v(xbgr.mr_n65024624)
print v(xbgr.mr_n65024736)
print v(xbgr.mr_n65025168)
print v(xbgr.mr_n65025600)
print v(xbgr.mr_n65026032)
print v(xbgr.mr_n65026464)
print v(xbgr.mr_n65026896)
print v(xbgr.mr_n65027328)
print v(xbgr.mr_n65027760)
print v(xbgr.mr_n65028192)
print v(xbgr.mr_n65028624)
print v(xbgr.mr_n65029056)
print v(xbgr.mr_n65029488)
print v(xbgr.mr_n65029920)
print v(xbgr.mr_n65030240)
print v(xbgr.mr_n65030352)
print v(xbgr.mr_n65030672)
print v(xbgr.mr_n65030784)
print v(xbgr.mr_n65031104)
print v(xbgr.mr_n65031216)
print v(xbgr.mr_n65031536)
print v(xbgr.mr_n65031648)
print v(xbgr.mr_n65031968)
print v(xbgr.mr_n65032080)
print v(xbgr.mr_n65032400)
print v(xbgr.mr_n65032512)
print v(xbgr.mr_n65032832)
print v(xbgr.mr_n65032944)
print v(xbgr.mr_n65033264)
print v(xbgr.mr_n65033376)
print v(xbgr.mr_n65033696)
print v(xbgr.mr_n65033808)
print v(xbgr.mr_n65034128)
print v(xbgr.mr_n65034240)
print v(xbgr.mr_n65034560)
print v(xbgr.mr_n65034672)
print v(xbgr.mr_n65035104)
print v(xbgr.mr_n65035536)
print v(xbgr.mr_n65035968)
print v(xbgr.mr_n65036288)
print v(xbgr.mr_n65036400)
print v(xbgr.mr_n65036720)
print v(xbgr.mr_n65036832)
print v(xbgr.mr_n65037264)
print v(xbgr.mr_n65037696)
print v(xbgr.mr_n65038128)
print v(xbgr.mr_n65038560)
print v(xbgr.mr_n65038992)
print v(xbgr.mr_n65039424)
print v(xbgr.mr_n65039856)
print v(xbgr.mr_n65040288)
print v(xbgr.mr_n65040720)
print v(xbgr.mr_n65041152)
print v(xbgr.mr_n65041472)
print v(xbgr.mr_n65041584)
print v(xbgr.mr_n65041904)
print v(xbgr.mr_n65042016)
print v(xbgr.mr_n65042336)
print v(xbgr.mr_n65042448)
print v(xbgr.mr_n65042768)
print v(xbgr.mr_n65042880)
print v(xbgr.mr_n65043200)
print v(xbgr.mr_n65043312)
print v(xbgr.mr_n65043632)
print v(xbgr.mr_n65043744)
print v(xbgr.mr_n65044064)
print v(xbgr.mr_n65044176)
print v(xbgr.mr_n65044496)
print v(xbgr.mr_n65044608)
print v(xbgr.mr_n65044928)
print v(xbgr.mr_n65045040)
print v(xbgr.mr_n65045360)
print v(xbgr.mr_n65045472)
print v(xbgr.mr_n65045792)
print v(xbgr.mr_n65045904)
print v(xbgr.mr_n65046224)
print v(xbgr.mr_n65046336)
print v(xbgr.mr_n65046768)
print v(xbgr.mr_n65047200)
print v(xbgr.mr_n65047632)
print v(xbgr.mr_n65048064)
print v(xbgr.mr_n65048496)
print v(xbgr.mr_n65048928)
print v(xbgr.mr_n65049360)
print v(xbgr.mr_n65049680)
print v(xbgr.mr_n65049792)
print v(xbgr.mr_n65050224)
print v(xbgr.mr_n65050656)
print v(xbgr.mr_n65051088)
print v(xbgr.mr_n65051520)
print v(xbgr.mr_n65051952)
print v(xbgr.mr_n65052384)
print v(xbgr.mr_n65052704)
print v(xbgr.mr_n65052816)
print v(xbgr.mr_n65053136)
print v(xbgr.mr_n65053248)
print v(xbgr.mr_n65053568)
print v(xbgr.mr_n65053680)
print v(xbgr.mr_n65054000)
print v(xbgr.mr_n65054112)
print v(xbgr.mr_n65054432)
print v(xbgr.mr_n65054544)
print v(xbgr.mr_n65054864)
print v(xbgr.mr_n65054976)
print v(xbgr.mr_n65055296)
print v(xbgr.mr_n65055408)
print v(xbgr.mr_n65055728)
print v(xbgr.mr_n65055840)
print v(xbgr.mr_n65056160)
print v(xbgr.mr_n65056272)
print v(xbgr.mr_n65056592)
print v(xbgr.mr_n65056704)
print v(xbgr.mr_n65057024)
print v(xbgr.mr_n65057136)
print v(xbgr.mr_n65057456)
print v(xbgr.mr_n65057568)
print v(xbgr.mr_n65057888)
print v(xbgr.mr_n65058000)
print v(xbgr.mr_n65058320)
print v(xbgr.mr_n65058432)
print v(xbgr.mr_n65058752)
print v(xbgr.mr_n65058864)
print v(xbgr.mr_n65059184)
print v(xbgr.mr_n65059296)
print v(xbgr.mr_n65059616)
print v(xbgr.mr_n65059728)
print v(xbgr.mr_n65060048)
print v(xbgr.mr_n65060160)
print v(xbgr.mr_n65060480)
print v(xbgr.mr_n65060592)
print v(xbgr.mr_n65060912)
print v(xbgr.mr_n65061024)
print v(xbgr.mr_n65061344)
print v(xbgr.mr_n65061456)
print v(xbgr.mr_n65061776)
print v(xbgr.mr_n65061888)
print v(xbgr.mr_n65062208)
print v(xbgr.mr_n65062320)
print v(xbgr.mr_n65062640)
print v(xbgr.mr_n65062752)
print v(xbgr.mr_n65063184)
print v(xbgr.mr_n65063616)
print v(xbgr.mr_n65064048)
print v(xbgr.mr_n65064368)
print v(xbgr.mr_n65064480)
print v(xbgr.mr_n65064800)
print v(xbgr.mr_n65064912)
print v(xbgr.mr_n65065344)
print v(xbgr.mr_n65065776)
print v(xbgr.mr_n65066208)
print v(xbgr.mr_n65066640)
print v(xbgr.mr_n65067072)
print v(xbgr.mr_n65067504)
print v(xbgr.mr_n65067936)
print v(xbgr.mr_n65068368)
print v(xbgr.mr_n65068800)
print v(xbgr.mr_n65069232)
print v(xbgr.mr_n65069664)
print v(xbgr.mr_n65070096)
print v(xbgr.mr_n65070528)
print v(xbgr.mr_n65070960)
print v(xbgr.mr_n65071392)
print v(xbgr.mr_n65071824)
print v(xbgr.mr_n65072256)
print v(xbgr.mr_n65072688)
print v(xbgr.mr_n65073120)
print v(xbgr.mr_n65073552)
print v(xbgr.mr_n65073984)
print v(xbgr.mr_n65074416)
print v(xbgr.mr_n65074848)
print v(xbgr.mr_n65075168)
print v(xbgr.mr_n65075280)
print v(xbgr.mr_n65075600)
print v(xbgr.mr_n65075712)
print v(xbgr.mr_n65076032)
print v(xbgr.mr_n65076144)
print v(xbgr.mr_n65076464)
print v(xbgr.mr_n65076576)
print v(xbgr.mr_n65076896)
print v(xbgr.mr_n65077008)
print v(xbgr.mr_n65077328)
print v(xbgr.mr_n65077440)
print v(xbgr.mr_n65077760)
print v(xbgr.mr_n65077872)
print v(xbgr.mr_n65078192)
print v(xbgr.mr_n65078304)
print v(xbgr.mr_n65078624)
print v(xbgr.mr_n65078736)
print v(xbgr.mr_n65079056)
print v(xbgr.mr_n65079168)
print v(xbgr.mr_n65079488)
print v(xbgr.mr_n65079600)
print v(xbgr.mr_n65079920)
print v(xbgr.mr_n65080032)
print v(xbgr.mr_n65080352)
print v(xbgr.mr_n65080464)
print v(xbgr.mr_n65080784)
print v(xbgr.mr_n65080896)
print v(xbgr.mr_n65081328)
print v(xbgr.mr_n65081760)
print v(xbgr.mr_n65082080)
print v(xbgr.mr_n65082192)
print v(xbgr.mr_n65082512)
print v(xbgr.mr_n65082624)
print v(xbgr.mr_n65082944)
print v(xbgr.mr_n65083056)
print v(xbgr.mr_n65083376)
print v(xbgr.mr_n65083488)
print v(xbgr.mr_n65083920)
print v(xbgr.mr_n65084352)
print v(xbgr.mr_n65084672)
print v(xbgr.mr_n65084784)
print v(xbgr.mr_n65085104)
print v(xbgr.mr_n65085216)
print v(xbgr.mr_n65085536)
print v(xbgr.mr_n65085648)
print v(xbgr.mr_n65085968)
print v(xbgr.mr_n65086080)
print v(xbgr.mr_n65086400)
print v(xbgr.mr_n65086512)
print v(xbgr.mr_n65086832)
print v(xbgr.mr_n65086944)
print v(xbgr.mr_n65087264)
print v(xbgr.mr_n65087376)
print v(xbgr.mr_n65087696)
print v(xbgr.mr_n65087808)
print v(xbgr.mr_n65088240)
print v(xbgr.mr_n65088672)
print v(xbgr.mr_n65089104)
print v(xbgr.mr_n65089536)
print v(xbgr.mr_n65089968)
print v(xbgr.mr_n65090400)
print v(xbgr.mr_n65090832)
print v(xbgr.mr_n65091264)
print v(xbgr.mr_n65091696)
print v(xbgr.mr_n65092128)
print v(xbgr.mr_n65092448)
print v(xbgr.mr_n65092560)
print v(xbgr.mr_n65092880)
print v(xbgr.mr_n65092992)
print v(xbgr.mr_n65093312)
print v(xbgr.mr_n65093424)
print v(xbgr.mr_n65093744)
print v(xbgr.mr_n65093856)
print v(xbgr.mr_n65098848)
print v(xbgr.mr_n65098960)
print v(xbgr.mr_n65099296)
print v(xbgr.mr_n65099408)
print v(xbgr.mr_n65099728)
print v(xbgr.mr_n65099840)
print v(xbgr.mr_n65100208)
print v(xbgr.mr_n65100320)
print v(xbgr.mr_n65100640)
print v(xbgr.mr_n65100752)
print v(xbgr.mr_n65101072)
print v(xbgr.mr_n65101184)
print v(xbgr.mr_n65101424)
print v(xbgr.mr_n65101536)
print v(xbgr.mr_n65101856)
print v(xbgr.mr_n65101968)
print v(xbgr.mr_n65102288)
print v(xbgr.mr_n65102400)
print v(xbgr.mr_n65102720)
print v(xbgr.mr_n65102832)
print v(xbgr.mr_n65103152)
print v(xbgr.mr_n65103264)
print v(xbgr.mr_n65103584)
print v(xbgr.mr_n65103696)
print v(xbgr.mr_n65104016)
print v(xbgr.mr_n65104128)
print v(xbgr.mr_n65104448)
print v(xbgr.mr_n65104560)
print v(xbgr.mr_n65104880)
print v(xbgr.mr_n65104992)
print v(xbgr.mr_n65105312)
print v(xbgr.mr_n65105424)
print v(xbgr.mr_n65105744)
print v(xbgr.mr_n65105856)
print v(xbgr.mr_n65106176)
print v(xbgr.mr_n65106288)
print v(xbgr.mr_n65106608)
print v(xbgr.mr_n65106720)
print v(xbgr.mr_n65107040)
print v(xbgr.mr_n65107152)
print v(xbgr.mr_n65107472)
print v(xbgr.mr_n65107584)
print v(xbgr.mr_n65107904)
print v(xbgr.mr_n65108016)
print v(xbgr.mr_n65108336)
print v(xbgr.mr_n65108448)
print v(xbgr.mr_n65108768)
print v(xbgr.mr_n65108880)
print v(xbgr.mr_n65109200)
print v(xbgr.mr_n65109312)
print v(xbgr.mr_n65109632)
print v(xbgr.mr_n65109744)
print v(xbgr.mr_n65110064)
print v(xbgr.mr_n65110176)
print v(xbgr.mr_n65110496)
print v(xbgr.mr_n65110608)
print v(xbgr.mr_n65110928)
print v(xbgr.mr_n65111040)
print v(xbgr.mr_n65111360)
print v(xbgr.mr_n65111472)
print v(xbgr.mr_n65111792)
print v(xbgr.mr_n65111904)
print v(xbgr.mr_n65112224)
print v(xbgr.mr_n65112336)
print v(xbgr.mr_n65112656)
print v(xbgr.mr_n65112768)
print v(xbgr.mr_n65113088)
print v(xbgr.mr_n65113200)
print v(xbgr.mr_n65113520)
print v(xbgr.mr_n65113632)
print v(xbgr.mr_n65113952)
print v(xbgr.mr_n65114064)
print v(xbgr.mr_n65114384)
print v(xbgr.mr_n65114496)
print v(xbgr.mr_n65114816)
print v(xbgr.mr_n65114928)
print v(xbgr.mr_n65115248)
print v(xbgr.mr_n65115360)
print v(xbgr.mr_n65115680)
print v(xbgr.mr_n65115792)
print v(xbgr.mr_n65116112)
print v(xbgr.mr_n65116224)
print v(xbgr.mr_n65116544)
print v(xbgr.mr_n65116656)
print v(xbgr.mr_n65116976)
print v(xbgr.mr_n65117088)
print v(xbgr.mr_n65117408)
print v(xbgr.mr_n65117520)
print v(xbgr.mr_n65117840)
print v(xbgr.mr_n65117952)
print v(xbgr.mr_n65118272)
print v(xbgr.mr_n65118384)
print v(xbgr.mr_n65118704)
print v(xbgr.mr_n65118816)
print v(xbgr.mr_n65119136)
print v(xbgr.mr_n65119248)
print v(xbgr.mr_n65119568)
print v(xbgr.mr_n65119680)
print v(xbgr.mr_n65120000)
print v(xbgr.mr_n65120112)
print v(xbgr.mr_n65120432)
print v(xbgr.mr_n65120544)
print v(xbgr.mr_n65120864)
print v(xbgr.mr_n65120976)
print v(xbgr.mr_n65121296)
print v(xbgr.mr_n65121408)
print v(xbgr.mr_n65121728)
print v(xbgr.mr_n65121840)
print v(xbgr.mr_n65122160)
print v(xbgr.mr_n65122272)
print v(xbgr.mr_n65122592)
print v(xbgr.mr_n65122704)
print v(xbgr.mr_n65123024)
print v(xbgr.mr_n65123136)
print v(xbgr.mr_n65123456)
print v(xbgr.mr_n65123568)
print v(xbgr.mr_n65123888)
print v(xbgr.mr_n65124000)
print v(xbgr.mr_n65124320)
print v(xbgr.mr_n65124432)
print v(xbgr.mr_n65124752)
print v(xbgr.mr_n65124864)
print v(xbgr.mr_n65125184)
print v(xbgr.mr_n65125296)
print v(xbgr.mr_n65125616)
print v(xbgr.mr_n65125728)
print v(xbgr.mr_n65126048)
print v(xbgr.mr_n65126160)
print v(xbgr.mr_n65126480)
print v(xbgr.mr_n65126592)
print v(xbgr.mr_n65126912)
print v(xbgr.mr_n65127024)
print v(xbgr.mr_n65127344)
print v(xbgr.mr_n65127456)
print v(xbgr.mr_n65127776)
print v(xbgr.mr_n65127888)
print v(xbgr.mr_n65128208)
print v(xbgr.mr_n65128320)
print v(xbgr.mr_n65128640)
print v(xbgr.mr_n65128752)
print v(xbgr.mr_n65128976)
print v(xbgr.mr_n65129088)
print v(xbgr.mr_n65129344)
print v(xbgr.mr_n65129456)
print v(xbgr.mr_n65129712)
print v(xbgr.mr_n65129824)
print v(xbgr.mr_n65130080)
print v(xbgr.mr_n65130192)
print v(xbgr.mr_n65130448)
print v(xbgr.mr_n65130560)
print v(xbgr.mr_n65130816)
print v(xbgr.mr_n65130928)
print v(xbgr.mr_n65131184)
print v(xbgr.mr_n65131296)
print v(xbgr.mr_n65131552)
print v(xbgr.mr_n65131664)
print v(xbgr.mr_n65131920)
print v(xbgr.mr_n65132032)
print v(xbgr.mr_n65132352)
print v(xbgr.mr_n65132464)
print v(xbgr.mr_n65132784)
print v(xbgr.mr_n65132896)
print v(xbgr.mr_n65133216)
print v(xbgr.mr_n65133328)
print v(xbgr.mr_n65133648)
print v(xbgr.mr_n65133760)
print v(xbgr.mr_n65134080)
print v(xbgr.mr_n65134192)
print v(xbgr.mr_n65134512)
print v(xbgr.mr_n65134624)
print v(xbgr.mr_n65134944)
print v(xbgr.mr_n65135056)
print v(xbgr.mr_n65135376)
print v(xbgr.mr_n65135488)
print v(xbgr.mr_n65135808)
print v(xbgr.mr_n65135920)
print v(xbgr.mr_n65136240)
print v(xbgr.mr_n65136352)
print v(xbgr.mr_n65136672)
print v(xbgr.mr_n65136784)
print v(xbgr.mr_n65137104)
print v(xbgr.mr_n65137216)
print v(xbgr.mr_n65137536)
print v(xbgr.mr_n65137648)
print v(xbgr.mr_n65137968)
print v(xbgr.mr_n65138080)
print v(xbgr.mr_n65138400)
print v(xbgr.mr_n65138512)
print v(xbgr.mr_n65138832)
print v(xbgr.mr_n65138944)
print v(xbgr.mr_n65139264)
print v(xbgr.mr_n65139376)
print v(xbgr.mr_n65139696)
print v(xbgr.mr_n65139808)
print v(xbgr.mr_n65140128)
print v(xbgr.mr_n65140240)
print v(xbgr.mr_n65140560)
print v(xbgr.mr_n65140672)
print v(xbgr.mr_n65140992)
print v(xbgr.mr_n65141104)
print v(xbgr.mr_n65141424)
print v(xbgr.mr_n65141536)
print v(xbgr.mr_n65141856)
print v(xbgr.mr_n65141968)
print v(xbgr.mr_n65142288)
print v(xbgr.mr_n65142400)
print v(xbgr.mr_n65142720)
print v(xbgr.mr_n65142832)
print v(xbgr.mr_n65143152)
print v(xbgr.mr_n65143264)
print v(xbgr.mr_n65143584)
print v(xbgr.mr_n65143696)
print v(xbgr.mr_n65144016)
print v(xbgr.mr_n65144128)
print v(xbgr.mr_n65144448)
print v(xbgr.mr_n65144560)
print v(xbgr.mr_n65144880)
print v(xbgr.mr_n65144992)
print v(xbgr.mr_n65145312)
print v(xbgr.mr_n65145424)
print v(xbgr.mr_n65145744)
print v(xbgr.mr_n65145856)
print v(xbgr.mr_n65146176)
print v(xbgr.mr_n65146288)
print v(xbgr.mr_n65146608)
print v(xbgr.mr_n65146720)
print v(xbgr.mr_n65147040)
print v(xbgr.mr_n65147152)
print v(xbgr.mr_n65147472)
print v(xbgr.mr_n65147584)
print v(xbgr.mr_n65147904)
print v(xbgr.mr_n65148016)
print v(xbgr.mr_n65148336)
print v(xbgr.mr_n65148448)
print v(xbgr.mr_n65148768)
print v(xbgr.mr_n65148880)
print v(xbgr.mr_n65149200)
print v(xbgr.mr_n65149312)
print v(xbgr.mr_n65149632)
print v(xbgr.mr_n65149744)
print v(xbgr.mr_n65150064)
print v(xbgr.mr_n65150176)
print v(xbgr.mr_n65150496)
print v(xbgr.mr_n65150608)
print v(xbgr.mr_n65150928)
print v(xbgr.mr_n65151040)
print v(xbgr.mr_n65151360)
print v(xbgr.mr_n65151472)
print v(xbgr.mr_n65151792)
print v(xbgr.mr_n65151904)
print v(xbgr.mr_n65152224)
print v(xbgr.mr_n65152336)
print v(xbgr.mr_n65152656)
print v(xbgr.mr_n65152768)
print v(xbgr.mr_n65153088)
print v(xbgr.mr_n65153200)
print v(xbgr.mr_n65153520)
print v(xbgr.mr_n65153632)
print v(xbgr.mr_n65153952)
print v(xbgr.mr_n65154064)
print v(xbgr.mr_n65154384)
print v(xbgr.mr_n65154496)
print v(xbgr.mr_n65154816)
print v(xbgr.mr_n65154928)
print v(xbgr.mr_n65155248)
print v(xbgr.mr_n65155360)
print v(xbgr.mr_n65155680)
print v(xbgr.mr_n65155792)
print v(xbgr.mr_n65156112)
print v(xbgr.mr_n65156224)
print v(xbgr.mr_n65156544)
print v(xbgr.mr_n65156656)
print v(xbgr.mr_n65156976)
print v(xbgr.mr_n65157088)
print v(xbgr.mr_n65157408)
print v(xbgr.mr_n65157520)
print v(xbgr.mr_n65157840)
print v(xbgr.mr_n65157952)
print v(xbgr.mr_n65158272)
print v(xbgr.mr_n65158384)
print v(xbgr.mr_n65158704)
print v(xbgr.mr_n65158816)
print v(xbgr.mr_n65159136)
print v(xbgr.mr_n65159248)
print v(xbgr.mr_n65159568)
print v(xbgr.mr_n65159680)
print v(xbgr.mr_n65160000)
print v(xbgr.mr_n65160112)
print v(xbgr.mr_n65160320)
print v(xbgr.mr_n65160432)
print v(xbgr.mr_n65160752)
print v(xbgr.mr_n65160864)
print v(xbgr.mr_n65161184)
print v(xbgr.mr_n65161296)
print v(xbgr.mr_n65161616)
print v(xbgr.mr_n65161728)
print v(xbgr.mr_n65162048)
print v(xbgr.mr_n65162160)
print v(xbgr.mr_n65162480)
print v(xbgr.mr_n65162592)
print v(xbgr.mr_n65162912)
print v(xbgr.mr_n65163024)
print v(xbgr.mr_n65163344)
print v(xbgr.mr_n65163456)
print v(xbgr.mr_n65163776)
print v(xbgr.mr_n65163888)
print v(xbgr.mr_n65164208)
print v(xbgr.mr_n65164320)
print v(xbgr.mr_n65164640)
print v(xbgr.mr_n65164752)
print v(xbgr.mr_n65165072)
print v(xbgr.mr_n65165184)
print v(xbgr.mr_n65165504)
print v(xbgr.mr_n65165616)
print v(xbgr.mr_n65165936)
print v(xbgr.mr_n65166048)
print v(xbgr.mr_n65166368)
print v(xbgr.mr_n65166480)
print v(xbgr.mr_n65166800)
print v(xbgr.mr_n65166912)
print v(xbgr.mr_n65167232)
print v(xbgr.mr_n65167344)
print v(xbgr.mr_n65167664)
print v(xbgr.mr_n65167776)
print v(xbgr.mr_n65168096)
print v(xbgr.mr_n65168208)
print v(xbgr.mr_n65168528)
print v(xbgr.mr_n65168640)
print v(xbgr.mr_n65168960)
print v(xbgr.mr_n65169072)
print v(xbgr.mr_n65169392)
print v(xbgr.mr_n65169504)
print v(xbgr.mr_n65169824)
print v(xbgr.mr_n65169936)
print v(xbgr.mr_n65170256)
print v(xbgr.mr_n65170368)
print v(xbgr.mr_n65170688)
print v(xbgr.mr_n65170800)
print v(xbgr.mr_n65171120)
print v(xbgr.mr_n65171232)
print v(xbgr.mr_n65171552)
print v(xbgr.mr_n65171664)
print v(xbgr.mr_n65171984)
print v(xbgr.mr_n65172096)
print v(xbgr.mr_n65172416)
print v(xbgr.mr_n65172528)
print v(xbgr.mr_n65172848)
print v(xbgr.mr_n65172960)
print v(xbgr.mr_n65173280)
print v(xbgr.mr_n65173392)
print v(xbgr.mr_n65173712)
print v(xbgr.mr_n65173824)
print v(xbgr.mr_n65174144)
print v(xbgr.mr_n65174256)
print v(xbgr.mr_n65174576)
print v(xbgr.mr_n65174688)
print v(xbgr.mr_n65175008)
print v(xbgr.mr_n65175120)
print v(xbgr.mr_n65175440)
print v(xbgr.mr_n65175552)
print v(xbgr.mr_n65175872)
print v(xbgr.mr_n65175984)
print v(xbgr.mr_n65176304)
print v(xbgr.mr_n65176416)
print v(xbgr.mr_n65176736)
print v(xbgr.mr_n65176848)
print v(xbgr.mr_n65177168)
print v(xbgr.mr_n65177280)
print v(xbgr.mr_n65177600)
print v(xbgr.mr_n65177712)
print v(xbgr.mr_n65178032)
print v(xbgr.mr_n65178144)
print v(xbgr.mr_n65178464)
print v(xbgr.mr_n65178576)
print v(xbgr.mr_n65178896)
print v(xbgr.mr_n65179008)
print v(xbgr.mr_n65179328)
print v(xbgr.mr_n65179440)
print v(xbgr.mr_n65179760)
print v(xbgr.mr_n65179872)
print v(xbgr.mr_n65180192)
print v(xbgr.mr_n65180304)
print v(xbgr.mr_n65180624)
print v(xbgr.mr_n65180736)
print v(xbgr.mr_n65181056)
print v(xbgr.mr_n65181168)
print v(xbgr.mr_n65181488)
print v(xbgr.mr_n65181600)
print v(xbgr.mr_n65181920)
print v(xbgr.mr_n65182032)
print v(xbgr.mr_n65182352)
print v(xbgr.mr_n65182464)
print v(xbgr.mr_n65182784)
print v(xbgr.mr_n65182896)
print v(xbgr.mr_n65183216)
print v(xbgr.mr_n65183328)
print v(xbgr.mr_n65183648)
print v(xbgr.mr_n65183760)
print v(xbgr.mr_n65184080)
print v(xbgr.mr_n65184192)
print v(xbgr.mr_n65184512)
print v(xbgr.mr_n65184624)
print v(xbgr.mr_n65184944)
print v(xbgr.mr_n65185056)
print v(xbgr.mr_n65185376)
print v(xbgr.mr_n65185488)
print v(xbgr.mr_n65185808)
print v(xbgr.mr_n65185920)
print v(xbgr.mr_n65186240)
print v(xbgr.mr_n65186352)
print v(xbgr.mr_n65186672)
print v(xbgr.mr_n65186784)
print v(xbgr.mr_n65187104)
print v(xbgr.mr_n65187216)
print v(xbgr.mr_n65187536)
print v(xbgr.mr_n65187648)
print v(xbgr.mr_n65187968)
print v(xbgr.mr_n65188080)
print v(xbgr.mr_n65188400)
print v(xbgr.mr_n65188512)
print v(xbgr.mr_n65188832)
print v(xbgr.mr_n65188944)
print v(xbgr.mr_n65189264)
print v(xbgr.mr_n65189376)
print v(xbgr.mr_n65189696)
print v(xbgr.mr_n65189808)
print v(xbgr.mr_n65190128)
print v(xbgr.mr_n65190240)
print v(xbgr.mr_n65190560)
print v(xbgr.mr_n65190672)
print v(xbgr.mr_n65190992)
print v(xbgr.mr_n65191104)
print v(xbgr.mr_n65191424)
print v(xbgr.mr_n65191536)
print v(xbgr.mr_n65191856)
print v(xbgr.mr_n65191968)
print v(xbgr.mr_n65192288)
print v(xbgr.mr_n65192400)
print v(xbgr.mr_n65192720)
print v(xbgr.mr_n65192832)
print v(xbgr.mr_n65193152)
print v(xbgr.mr_n65193264)
print v(xbgr.mr_n65193584)
print v(xbgr.mr_n65193696)
print v(xbgr.mr_n65194016)
print v(xbgr.mr_n65194128)
print v(xbgr.mr_n65194448)
print v(xbgr.mr_n65194560)
print v(xbgr.mr_n65194880)
print v(xbgr.mr_n65194992)
print v(xbgr.mr_n65195312)
print v(xbgr.mr_n65195424)
print v(xbgr.mr_n65195744)
print v(xbgr.mr_n65195856)
print v(xbgr.mr_n65196176)
print v(xbgr.mr_n65196288)
print v(xbgr.mr_n65196608)
print v(xbgr.mr_n65196720)
print v(xbgr.mr_n65197040)
print v(xbgr.mr_n65197152)
print v(xbgr.mr_n65197472)
print v(xbgr.mr_n65197584)
print v(xbgr.mr_n65197904)
print v(xbgr.mr_n65198016)
print v(xbgr.mr_n65198336)
print v(xbgr.mr_n65198448)
print v(xbgr.mr_n65198768)
print v(xbgr.mr_n65198880)
print v(xbgr.mr_n65199200)
print v(xbgr.mr_n65199312)
print v(xbgr.mr_n65199632)
print v(xbgr.mr_n65199744)
print v(xbgr.mr_n65200064)
print v(xbgr.mr_n65200176)
print v(xbgr.mr_n65200496)
print v(xbgr.mr_n65200608)
print v(xbgr.mr_n65200928)
print v(xbgr.mr_n65201040)
print v(xbgr.mr_n65201360)
print v(xbgr.mr_n65201472)
print v(xbgr.mr_n65201792)
print v(xbgr.mr_n65201904)
print v(xbgr.mr_n65202224)
print v(xbgr.mr_n65202336)
print v(xbgr.mr_n65202656)
print v(xbgr.mr_n65202768)
print v(xbgr.mr_n65203088)
print v(xbgr.mr_n65203200)
print v(xbgr.mr_n65203520)
print v(xbgr.mr_n65203632)
print v(xbgr.mr_n65203952)
print v(xbgr.mr_n65204064)
print v(xbgr.mr_n65204384)
print v(xbgr.mr_n65204496)
print v(xbgr.mr_n65204816)
print v(xbgr.mr_n65204928)
print v(xbgr.mr_n65205248)
print v(xbgr.mr_n65205360)
print v(xbgr.mr_n65205680)
print v(xbgr.mr_n65205792)
print v(xbgr.mr_n65206112)
print v(xbgr.mr_n65206224)
print v(xbgr.mr_n65206544)
print v(xbgr.mr_n65206656)
print v(xbgr.mr_n65206976)
print v(xbgr.mr_n65207088)
print v(xbgr.mr_n65207408)
print v(xbgr.mr_n65207520)
print v(xbgr.mr_n65207840)
print v(xbgr.mr_n65207952)
print v(xbgr.mr_n65208272)
print v(xbgr.mr_n65208384)
print v(xbgr.mr_n65208704)
print v(xbgr.mr_n65208816)
print v(xbgr.mr_n65209136)
print v(xbgr.mr_n65209248)
print v(xbgr.mr_n65209568)
print v(xbgr.mr_n65209680)
print v(xbgr.mr_n65210000)
print v(xbgr.mr_n65210112)
print v(xbgr.mr_n65210432)
print v(xbgr.mr_n65210544)
print v(xbgr.mr_n65210864)
print v(xbgr.mr_n65210976)
print v(xbgr.mr_n65211296)
print v(xbgr.mr_n65211408)
print v(xbgr.mr_n65211728)
print v(xbgr.mr_n65211840)
print v(xbgr.mr_n65212160)
print v(xbgr.mr_n65212272)
print v(xbgr.mr_n65212592)
print v(xbgr.mr_n65212704)
print v(xbgr.mr_n65213024)
print v(xbgr.mr_n65213136)
print v(xbgr.mr_n65213456)
print v(xbgr.mr_n65213568)
print v(xbgr.mr_n65213888)
print v(xbgr.mr_n65214000)
print v(xbgr.mr_n65214320)
print v(xbgr.mr_n65214432)
print v(xbgr.mr_n65214752)
print v(xbgr.mr_n65214864)
print v(xbgr.mr_n65215184)
print v(xbgr.mr_n65215296)
print v(xbgr.mr_n65215616)
print v(xbgr.mr_n65215728)
print v(xbgr.mr_n65216048)
print v(xbgr.mr_n65216160)
print v(xbgr.mr_n65216480)
print v(xbgr.mr_n65216592)
print v(xbgr.mr_n65216912)
print v(xbgr.mr_n65217024)
print v(xbgr.mr_n65217344)
print v(xbgr.mr_n65217456)
print v(xbgr.mr_n65217776)
print v(xbgr.mr_n65217888)
print v(xbgr.mr_n65218208)
print v(xbgr.mr_n65218320)
print v(xbgr.mr_n65218640)
print v(xbgr.mr_n65218752)
print v(xbgr.mr_n65219072)
print v(xbgr.mr_n65219184)
print v(xbgr.mr_n65219504)
print v(xbgr.mr_n65219616)
print v(xbgr.mr_n65219936)
print v(xbgr.mr_n65220048)
print v(xbgr.mr_n65220368)
print v(xbgr.mr_n65220480)
print v(xbgr.mr_n65220800)
print v(xbgr.mr_n65220912)
print v(xbgr.mr_n65221232)
print v(xbgr.mr_n65221344)
print v(xbgr.mr_n65221872)
print v(xbgr.mr_n65221984)
print v(xbgr.mr_n65222304)
print v(xbgr.mr_n65222416)
print v(xbgr.mr_n65222736)
print v(xbgr.mr_n65222848)
print v(xbgr.mr_n65223168)
print v(xbgr.mr_n65223280)
print v(xbgr.mr_n65223600)
print v(xbgr.mr_n65223712)
print v(xbgr.mr_n65224032)
print v(xbgr.mr_n65224144)
print v(xbgr.mr_n65224464)
print v(xbgr.mr_n65224576)
print v(xbgr.mr_n65224896)
print v(xbgr.mr_n65225008)
print v(xbgr.mr_n65225328)
print v(xbgr.mr_n65225440)
print v(xbgr.mr_n65225760)
print v(xbgr.mr_n65225872)
print v(xbgr.mr_n65226192)
print v(xbgr.mr_n65226304)
print v(xbgr.mr_n65226624)
print v(xbgr.mr_n65226736)
print v(xbgr.mr_n65227056)
print v(xbgr.mr_n65227168)
print v(xbgr.mr_n65227488)
print v(xbgr.mr_n65227600)
print v(xbgr.mr_n65227920)
print v(xbgr.mr_n65228032)
print v(xbgr.mr_n65228352)
print v(xbgr.mr_n65228464)
print v(xbgr.mr_n65228784)
print v(xbgr.mr_n65228896)
print v(xbgr.mr_n65229216)
print v(xbgr.mr_n65229328)
print v(xbgr.mr_n65229648)
print v(xbgr.mr_n65229760)
print v(xbgr.mr_n65230080)
print v(xbgr.mr_n65230192)
print v(xbgr.mr_n65230512)
print v(xbgr.mr_n65230624)
print v(xbgr.mr_n65230944)
print v(xbgr.mr_n65231056)
print v(xbgr.mr_n65231376)
print v(xbgr.mr_n65231488)
print v(xbgr.mr_n65231808)
print v(xbgr.mr_n65231920)
print v(xbgr.mr_n65232240)
print v(xbgr.mr_n65232352)
print v(xbgr.mr_n65232672)
print v(xbgr.mr_n65232784)
print v(xbgr.mr_n65233104)
print v(xbgr.mr_n65233216)
print v(xbgr.mr_n65233536)
print v(xbgr.mr_n65233648)
print v(xbgr.mr_n65233968)
print v(xbgr.mr_n65234080)
print v(xbgr.mr_n65234400)
print v(xbgr.mr_n65234512)
print v(xbgr.mr_n65234832)
print v(xbgr.mr_n65234944)
print v(xbgr.mr_n65235264)
print v(xbgr.mr_n65235376)
print v(xbgr.mr_n65235696)
print v(xbgr.mr_n65235808)
print v(xbgr.mr_n65236128)
print v(xbgr.mr_n65236240)
print v(xbgr.mr_n65236560)
print v(xbgr.mr_n65236672)
print v(xbgr.mr_n65236992)
print v(xbgr.mr_n65237104)
print v(xbgr.mr_n65237424)
print v(xbgr.mr_n65237536)
print v(xbgr.mr_n65237856)
print v(xbgr.mr_n65237968)
print v(xbgr.mr_n65238288)
print v(xbgr.mr_n65238400)
print v(xbgr.mr_n65238720)
print v(xbgr.mr_n65238832)
print v(xbgr.mr_n65239152)
print v(xbgr.mr_n65239264)
print v(xbgr.mr_n65239584)
print v(xbgr.mr_n65239696)
print v(xbgr.mr_n65240016)
print v(xbgr.mr_n65240128)
print v(xbgr.mr_n65240448)
print v(xbgr.mr_n65240560)
print v(xbgr.mr_n65240880)
print v(xbgr.mr_n65240992)
print v(xbgr.mr_n65241312)
print v(xbgr.mr_n65241424)
print v(xbgr.mr_n65241744)
print v(xbgr.mr_n65241856)
print v(xbgr.mr_n65242176)
print v(xbgr.mr_n65242288)
print v(xbgr.mr_n65242608)
print v(xbgr.mr_n65242720)
print v(xbgr.mr_n65243040)
print v(xbgr.mr_n65243152)
print v(xbgr.mr_n65243472)
print v(xbgr.mr_n65243584)
print v(xbgr.mr_n65243904)
print v(xbgr.mr_n65244016)
print v(xbgr.mr_n65244336)
print v(xbgr.mr_n65244448)
print v(xbgr.mr_n65244768)
print v(xbgr.mr_n65244880)
print v(xbgr.mr_n65245200)
print v(xbgr.mr_n65245312)
print v(xbgr.mr_n65245632)
print v(xbgr.mr_n65245744)
print v(xbgr.mr_n65246064)
print v(xbgr.mr_n65246176)
print v(xbgr.mr_n65246496)
print v(xbgr.mr_n65246608)
print v(xbgr.mr_n65246928)
print v(xbgr.mr_n65247040)
print v(xbgr.mr_n65247360)
print v(xbgr.mr_n65247472)
print v(xbgr.mr_n65247792)
print v(xbgr.mr_n65247904)
print v(xbgr.mr_n65248224)
print v(xbgr.mr_n65248336)
print v(xbgr.mr_n65248656)
print v(xbgr.mr_n65248768)
print v(xbgr.mr_n65249088)
print v(xbgr.mr_n65249200)
print v(xbgr.mr_n65249520)
print v(xbgr.mr_n65249632)
print v(xbgr.mr_n65249952)
print v(xbgr.mr_n65250064)
print v(xbgr.mr_n65250384)
print v(xbgr.mr_n65250496)
print v(xbgr.mr_n65250816)
print v(xbgr.mr_n65250928)
print v(xbgr.mr_n65251248)
print v(xbgr.mr_n65251360)
print v(xbgr.mr_n65251680)
print v(xbgr.mr_n65251792)
print v(xbgr.mr_n65252112)
print v(xbgr.mr_n65252224)
print v(xbgr.mr_n65252544)
print v(xbgr.mr_n65252656)
print v(xbgr.mr_n65252976)
print v(xbgr.mr_n65253088)
print v(xbgr.mr_n65253408)
print v(xbgr.mr_n65253520)
print v(xbgr.mr_n65253840)
print v(xbgr.mr_n65253952)
print v(xbgr.mr_n65254272)
print v(xbgr.mr_n65254384)
print v(xbgr.mr_n65254704)
print v(xbgr.mr_n65254816)
print v(xbgr.mr_n65255136)
print v(xbgr.mr_n65255248)
print v(xbgr.mr_n65255568)
print v(xbgr.mr_n65255680)
print v(xbgr.mr_n65256000)
print v(xbgr.mr_n65256112)
print v(xbgr.mr_n65256432)
print v(xbgr.mr_n65256544)
print v(xbgr.mr_n65256864)
print v(xbgr.mr_n65256976)
print v(xbgr.mr_n65257296)
print v(xbgr.mr_n65257408)
print v(xbgr.mr_n65257728)
print v(xbgr.mr_n65257840)
print v(xbgr.mr_n65258160)
print v(xbgr.mr_n65258272)
print v(xbgr.mr_n65258592)
print v(xbgr.mr_n65258704)
print v(xbgr.mr_n65259024)
print v(xbgr.mr_n65259136)
print v(xbgr.mr_n65259456)
print v(xbgr.mr_n65259568)
print v(xbgr.mr_n65259888)
print v(xbgr.mr_n65260000)
print v(xbgr.mr_n65260320)
print v(xbgr.mr_n65260432)
print v(xbgr.mr_n65260752)
print v(xbgr.mr_n65260864)
print v(xbgr.mr_n65261184)
print v(xbgr.mr_n65261296)
print v(xbgr.mr_n65523776)
print v(xbgr.mr_n65524016)
print v(xbgr.mr_n65524128)
print v(xbgr.mr_n65524448)
print v(xbgr.mr_n65524560)
print v(xbgr.mr_n65524880)
print v(xbgr.mr_n65524992)
print v(xbgr.mr_n65525312)
print v(xbgr.mr_n65525424)
print v(xbgr.mr_n65525744)
print v(xbgr.mr_n65525856)
print v(xbgr.mr_n65526176)
print v(xbgr.mr_n65526288)
print v(xbgr.mr_n65526608)
print v(xbgr.mr_n65526720)
print v(xbgr.mr_n65527040)
print v(xbgr.mr_n65527152)
print v(xbgr.mr_n65527472)
print v(xbgr.mr_n65527584)
print v(xbgr.mr_n65527904)
print v(xbgr.mr_n65528016)
print v(xbgr.mr_n65528336)
print v(xbgr.mr_n65528448)
print v(xbgr.mr_n65528768)
print v(xbgr.mr_n65528880)
print v(xbgr.mr_n65529200)
print v(xbgr.mr_n65529312)
print v(xbgr.mr_n65529632)
print v(xbgr.mr_n65529744)
print v(xbgr.mr_n65530064)
print v(xbgr.mr_n65530176)
print v(xbgr.mr_n65530496)
print v(xbgr.mr_n65530608)
print v(xbgr.mr_n65530928)
print v(xbgr.mr_n65531040)
print v(xbgr.mr_n65531360)
print v(xbgr.mr_n65531472)
print v(xbgr.mr_n65531792)
print v(xbgr.mr_n65531904)
print v(xbgr.mr_n65532224)
print v(xbgr.mr_n65532336)
print v(xbgr.mr_n65532656)
print v(xbgr.mr_n65532768)
print v(xbgr.mr_n65533088)
print v(xbgr.mr_n65533200)
print v(xbgr.mr_n65533520)
print v(xbgr.mr_n65533632)
print v(xbgr.mr_n65533952)
print v(xbgr.mr_n65534064)
print v(xbgr.mr_n65534384)
print v(xbgr.mr_n65534496)
print v(xbgr.mr_n65534816)
print v(xbgr.mr_n65534928)
print v(xbgr.mr_n65535248)
print v(xbgr.mr_n65535360)
print v(xbgr.mr_n65535680)
print v(xbgr.mr_n65535792)
print v(xbgr.mr_n65536112)
print v(xbgr.mr_n65536224)
print v(xbgr.mr_n65536544)
print v(xbgr.mr_n65536656)
print v(xbgr.mr_n65536976)
print v(xbgr.mr_n65537088)
print v(xbgr.mr_n65537408)
print v(xbgr.mr_n65537520)
print v(xbgr.mr_n65537840)
print v(xbgr.mr_n65537952)
print v(xbgr.mr_n65538272)
print v(xbgr.mr_n65538384)
print v(xbgr.mr_n65538704)
print v(xbgr.mr_n65538816)
print v(xbgr.mr_n65539136)
print v(xbgr.mr_n65539248)
print v(xbgr.mr_n65539568)
print v(xbgr.mr_n65539680)
print v(xbgr.mr_n65540000)
print v(xbgr.mr_n65540112)
print v(xbgr.mr_n65540432)
print v(xbgr.mr_n65540544)
print v(xbgr.mr_n65540864)
print v(xbgr.mr_n65540976)
print v(xbgr.mr_n65541296)
print v(xbgr.mr_n65541408)
print v(xbgr.mr_n65541728)
print v(xbgr.mr_n65541840)
print v(xbgr.mr_n65542160)
print v(xbgr.mr_n65542272)
print v(xbgr.mr_n65542592)
print v(xbgr.mr_n65542704)
print v(xbgr.mr_n65543024)
print v(xbgr.mr_n65543136)
print v(xbgr.mr_n65543456)
print v(xbgr.mr_n65543568)
print v(xbgr.mr_n65543888)
print v(xbgr.mr_n65544000)
print v(xbgr.mr_n65544320)
print v(xbgr.mr_n65544432)
print v(xbgr.mr_n65544752)
print v(xbgr.mr_n65544864)
print v(xbgr.mr_n65545184)
print v(xbgr.mr_n65545296)
print v(xbgr.mr_n65545616)
print v(xbgr.mr_n65545728)
print v(xbgr.mr_n65546048)
print v(xbgr.mr_n65546160)
print v(xbgr.mr_n65546480)
print v(xbgr.mr_n65546592)
print v(xbgr.mr_n65546912)
print v(xbgr.mr_n65547024)
print v(xbgr.mr_n65547344)
print v(xbgr.mr_n65547456)
print v(xbgr.mr_n65547776)
print v(xbgr.mr_n65547888)
print v(xbgr.mr_n65548208)
print v(xbgr.mr_n65548320)
print v(xbgr.mr_n65548640)
print v(xbgr.mr_n65548752)
print v(xbgr.mr_n65549072)
print v(xbgr.mr_n65549184)
print v(xbgr.mr_n65549504)
print v(xbgr.mr_n65549616)
print v(xbgr.mr_n65549936)
print v(xbgr.mr_n65550048)
print v(xbgr.mr_n65550368)
print v(xbgr.mr_n65550480)
print v(xbgr.mr_n65550800)
print v(xbgr.mr_n65550912)
print v(xbgr.mr_n65551232)
print v(xbgr.mr_n65551344)
print v(xbgr.mr_n65551664)
print v(xbgr.mr_n65551776)
print v(xbgr.mr_n65552096)
print v(xbgr.mr_n65552208)
print v(xbgr.mr_n65552528)
print v(xbgr.mr_n65552640)
print v(xbgr.mr_n65552960)
print v(xbgr.mr_n65553072)
print v(xbgr.mr_n65553392)
print v(xbgr.mr_n65553504)
print v(xbgr.mr_n65553824)
print v(xbgr.mr_n65553936)
print v(xbgr.mr_n65554256)
print v(xbgr.mr_n65554368)
print v(xbgr.mr_n65554688)
print v(xbgr.mr_n65554800)
print v(xbgr.mr_n65555120)
print v(xbgr.mr_n65555232)
print v(xbgr.mr_n65555552)
print v(xbgr.mr_n65555664)
print v(xbgr.mr_n65555984)
print v(xbgr.mr_n65556096)
print v(xbgr.mr_n65556416)
print v(xbgr.mr_n65556528)
print v(xbgr.mr_n65556848)
print v(xbgr.mr_n65556960)
print v(xbgr.mr_n65557280)
print v(xbgr.mr_n65557392)
print v(xbgr.mr_n65557712)
print v(xbgr.mr_n65557824)
print v(xbgr.mr_n65558144)
print v(xbgr.mr_n65558256)
print v(xbgr.mr_n65558576)
print v(xbgr.mr_n65558688)
print v(xbgr.mr_n65559008)
print v(xbgr.mr_n65559120)
print v(xbgr.mr_n65559440)
print v(xbgr.mr_n65559552)
print v(xbgr.mr_n65559872)
print v(xbgr.mr_n65559984)
print v(xbgr.mr_n65560304)
print v(xbgr.mr_n65560416)
print v(xbgr.mr_n65560736)
print v(xbgr.mr_n65560848)
print v(xbgr.mr_n65561168)
print v(xbgr.mr_n65561280)
print v(xbgr.mr_n65561600)
print v(xbgr.mr_n65561712)
print v(xbgr.mr_n65562032)
print v(xbgr.mr_n65562144)
print v(xbgr.mr_n65562464)
print v(xbgr.mr_n65562576)
print v(xbgr.mr_n65562896)
print v(xbgr.mr_n65563008)
print v(xbgr.mr_n65563328)
print v(xbgr.mr_n65563440)
print v(xbgr.mr_n65563760)
print v(xbgr.mr_n65563872)
print v(xbgr.mr_n65564192)
print v(xbgr.mr_n65564304)
print v(xbgr.mr_n65564624)
print v(xbgr.mr_n65564736)
print v(xbgr.mr_n65565056)
print v(xbgr.mr_n65565168)
print v(xbgr.mr_n65565488)
print v(xbgr.mr_n65565600)
print v(xbgr.mr_n65565920)
print v(xbgr.mr_n65566032)
print v(xbgr.mr_n65566352)
print v(xbgr.mr_n65566464)
print v(xbgr.mr_n65566784)
print v(xbgr.mr_n65566896)
print v(xbgr.mr_n65567216)
print v(xbgr.mr_n65567328)
print v(xbgr.mr_n65567648)
print v(xbgr.mr_n65567760)
print v(xbgr.mr_n65568080)
print v(xbgr.mr_n65568192)
print v(xbgr.mr_n65568512)
print v(xbgr.mr_n65568624)
print v(xbgr.mr_n65568944)
print v(xbgr.mr_n65569056)
print v(xbgr.mr_n65569376)
print v(xbgr.mr_n65569488)
print v(xbgr.mr_n65569808)
print v(xbgr.mr_n65569920)
print v(xbgr.mr_n65570240)
print v(xbgr.mr_n65570352)
print v(xbgr.mr_n65570672)
print v(xbgr.mr_n65570784)
print v(xbgr.mr_n65571104)
print v(xbgr.mr_n65571216)
print v(xbgr.mr_n65571536)
print v(xbgr.mr_n65571648)
print v(xbgr.mr_n65571968)
print v(xbgr.mr_n65572080)
print v(xbgr.mr_n65572400)
print v(xbgr.mr_n65572512)
print v(xbgr.mr_n65572832)
print v(xbgr.mr_n65572944)
print v(xbgr.mr_n65573264)
print v(xbgr.mr_n65573376)
print v(xbgr.mr_n65573696)
print v(xbgr.mr_n65573808)
print v(xbgr.mr_n65574128)
print v(xbgr.mr_n65574240)
print v(xbgr.mr_n65574560)
print v(xbgr.mr_n65574672)
print v(xbgr.mr_n65574992)
print v(xbgr.mr_n65575104)
print v(xbgr.mr_n65575424)
print v(xbgr.mr_n65575536)
print v(xbgr.mr_n65575856)
print v(xbgr.mr_n65575968)
print v(xbgr.mr_n65576288)
print v(xbgr.mr_n65576400)
print v(xbgr.mr_n65576720)
print v(xbgr.mr_n65576832)
print v(xbgr.mr_n65577152)
print v(xbgr.mr_n65577264)
print v(xbgr.mr_n65577584)
print v(xbgr.mr_n65577696)
print v(xbgr.mr_n65578016)
print v(xbgr.mr_n65578128)
print v(xbgr.mr_n65578448)
print v(xbgr.mr_n65578560)
print v(xbgr.mr_n65578880)
print v(xbgr.mr_n65578992)
print v(xbgr.mr_n65579312)
print v(xbgr.mr_n65579424)
print v(xbgr.mr_n65579744)
print v(xbgr.mr_n65579856)
print v(xbgr.mr_n65580176)
print v(xbgr.mr_n65580288)
print v(xbgr.mr_n65580608)
print v(xbgr.mr_n65580720)
print v(xbgr.mr_n65581040)
print v(xbgr.mr_n65581152)
print v(xbgr.mr_n65581472)
print v(xbgr.mr_n65581584)
print v(xbgr.mr_n65581904)
print v(xbgr.mr_n65582016)
print v(xbgr.mr_n65582336)
print v(xbgr.mr_n65582448)
print v(xbgr.mr_n65582768)
print v(xbgr.mr_n65582880)
print v(xbgr.mr_n65583200)
print v(xbgr.mr_n65583312)
print v(xbgr.mr_n65583632)
print v(xbgr.mr_n65583744)
print v(xbgr.mr_n65584064)
print v(xbgr.mr_n65584176)
print v(xbgr.mr_n65584496)
print v(xbgr.mr_n65584608)
print v(xbgr.mr_n65584928)
print v(xbgr.mr_n65585040)
print v(xbgr.mr_n65585360)
print v(xbgr.mr_n65585472)
print v(xbgr.mr_n65585792)
print v(xbgr.mr_n65585904)
print v(xbgr.mr_n65586224)
print v(xbgr.mr_n65586336)
print v(xbgr.mr_n65586656)
print v(xbgr.mr_n65586768)
print v(xbgr.mr_n65587088)
print v(xbgr.mr_n65587200)
print v(xbgr.mr_n65587520)
print v(xbgr.mr_n65587632)
print v(xbgr.mr_n65587952)
print v(xbgr.mr_n65588064)
print v(xbgr.mr_n65588384)
print v(xbgr.mr_n65588496)
print v(xbgr.mr_n65588816)
print v(xbgr.mr_n65588928)
print v(xbgr.mr_n65589248)
print v(xbgr.mr_n65589360)
print v(xbgr.mr_n65589680)
print v(xbgr.mr_n65589792)
print v(xbgr.mr_n65590112)
print v(xbgr.mr_n65590224)
print v(xbgr.mr_n65590544)
print v(xbgr.mr_n65590656)
print v(xbgr.mr_n65590976)
print v(xbgr.mr_n65591088)
print v(xbgr.mr_n65591408)
print v(xbgr.mr_n65591520)
print v(xbgr.mr_n65591840)
print v(xbgr.mr_n65591952)
print v(xbgr.mr_n65592272)
print v(xbgr.mr_n65592384)
print v(xbgr.mr_n65592704)
print v(xbgr.mr_n65592816)
print v(xbgr.mr_n65593136)
print v(xbgr.mr_n65593248)
print v(xbgr.mr_n65593568)
print v(xbgr.mr_n65593680)
print v(xbgr.mr_n65594000)
print v(xbgr.mr_n65594112)
print v(xbgr.mr_n65594432)
print v(xbgr.mr_n65594544)
print v(xbgr.mr_n65594864)
print v(xbgr.mr_n65594976)
print v(xbgr.mr_n65595296)
print v(xbgr.mr_n65595408)
print v(xbgr.mr_n65595728)
print v(xbgr.mr_n65595840)
print v(xbgr.mr_n65596160)
print v(xbgr.mr_n65596272)
print v(xbgr.mr_n65596592)
print v(xbgr.mr_n65596704)
print v(xbgr.mr_n65597024)
print v(xbgr.mr_n65597136)
print v(xbgr.mr_n65597456)
print v(xbgr.mr_n65597568)
print v(xbgr.mr_n65597888)
print v(xbgr.mr_n65598000)
print v(xbgr.mr_n65598320)
print v(xbgr.mr_n65598432)
print v(xbgr.mr_n65598752)
print v(xbgr.mr_n65598864)
print v(xbgr.mr_n65599184)
print v(xbgr.mr_n65599296)
print v(xbgr.mr_n65599616)
print v(xbgr.mr_n65599728)
print v(xbgr.mr_n65600048)
print v(xbgr.mr_n65600160)
print v(xbgr.mr_n65600480)
print v(xbgr.mr_n65600592)
print v(xbgr.mr_n65600912)
print v(xbgr.mr_n65601024)
print v(xbgr.mr_n65601344)
print v(xbgr.mr_n65601456)
print v(xbgr.mr_n65601776)
print v(xbgr.mr_n65601888)
print v(xbgr.mr_n65602208)
print v(xbgr.mr_n65602320)
print v(xbgr.mr_n65602640)
print v(xbgr.mr_n65602752)
print v(xbgr.mr_n65603072)
print v(xbgr.mr_n65603184)
print v(xbgr.mr_n65603504)
print v(xbgr.mr_n65603616)
print v(xbgr.mr_n65603936)
print v(xbgr.mr_n65604048)
print v(xbgr.mr_n65604368)
print v(xbgr.mr_n65604480)
print v(xbgr.mr_n65604800)
print v(xbgr.mr_n65604912)
print v(xbgr.mr_n65605232)
print v(xbgr.mr_n65605344)
print v(xbgr.mr_n65605664)
print v(xbgr.mr_n65605776)
print v(xbgr.mr_n65606096)
print v(xbgr.mr_n65606208)
print v(xbgr.mr_n65606528)
print v(xbgr.mr_n65606640)
print v(xbgr.mr_n65606960)
print v(xbgr.mr_n65607072)
print v(xbgr.mr_n65607392)
print v(xbgr.mr_n65607504)
print v(xbgr.mr_n65607824)
print v(xbgr.mr_n65607936)
print v(xbgr.mr_n65608256)
print v(xbgr.mr_n65608368)
print v(xbgr.mr_n65608688)
print v(xbgr.mr_n65608800)
print v(xbgr.mr_n65609120)
print v(xbgr.mr_n65609232)
print v(xbgr.mr_n65609552)
print v(xbgr.mr_n65609664)
print v(xbgr.mr_n65609984)
print v(xbgr.mr_n65610096)
print v(xbgr.mr_n65610416)
print v(xbgr.mr_n65610528)
print v(xbgr.mr_n65610848)
print v(xbgr.mr_n65610960)
print v(xbgr.mr_n65611280)
print v(xbgr.mr_n65611392)
print v(xbgr.mr_n65611712)
print v(xbgr.mr_n65611824)
print v(xbgr.mr_n65612144)
print v(xbgr.mr_n65612256)
print v(xbgr.mr_n65612576)
print v(xbgr.mr_n65612688)
print v(xbgr.mr_n65613008)
print v(xbgr.mr_n65613120)
print v(xbgr.mr_n65613440)
print v(xbgr.mr_n65613552)
print v(xbgr.mr_n65613872)
print v(xbgr.mr_n65613984)
print v(xbgr.mr_n65614304)
print v(xbgr.mr_n65614416)
print v(xbgr.mr_n65614736)
print v(xbgr.mr_n65614848)
print v(xbgr.mr_n65615168)
print v(xbgr.mr_n65615280)
print v(xbgr.mr_n65615600)
print v(xbgr.mr_n65615712)
print v(xbgr.mr_n65616032)
print v(xbgr.mr_n65616144)
print v(xbgr.mr_n65616464)
print v(xbgr.mr_n65616576)
print v(xbgr.mr_n65616896)
print v(xbgr.mr_n65617008)
print v(xbgr.mr_n65617328)
print v(xbgr.mr_n65617440)
print v(xbgr.mr_n65617760)
print v(xbgr.mr_n65617872)
print v(xbgr.mr_n65618192)
print v(xbgr.mr_n65618304)
print v(xbgr.mr_n65618624)
print v(xbgr.mr_n65618736)
print v(xbgr.mr_n65619056)
print v(xbgr.mr_n65619168)
print v(xbgr.mr_n65619488)
print v(xbgr.mr_n65619600)
print v(xbgr.mr_n65619920)
print v(xbgr.mr_n65620032)
print v(xbgr.mr_n65620352)
print v(xbgr.mr_n65620464)
print v(xbgr.mr_n65620784)
print v(xbgr.mr_n65620896)
print v(xbgr.mr_n65621216)
print v(xbgr.mr_n65621328)
print v(xbgr.mr_n65621648)
print v(xbgr.mr_n65621760)
print v(xbgr.mr_n65622080)
print v(xbgr.mr_n65622192)
print v(xbgr.mr_n65622512)
print v(xbgr.mr_n65622624)
print v(xbgr.mr_n65622944)
print v(xbgr.mr_n65623056)
print v(xbgr.mr_n65623376)
print v(xbgr.mr_n65623488)
print v(xbgr.mr_n65623808)
print v(xbgr.mr_n65623920)
print v(xbgr.mr_n65624240)
print v(xbgr.mr_n65624352)
print v(xbgr.mr_n65624672)
print v(xbgr.mr_n65624784)
print v(xbgr.mr_n65625104)
print v(xbgr.mr_n65625216)
print v(xbgr.mr_n65625536)
print v(xbgr.mr_n65625648)
print v(xbgr.mr_n65625968)
print v(xbgr.mr_n65626080)
print v(xbgr.mr_n65626400)
print v(xbgr.mr_n65626512)
print v(xbgr.mr_n65626832)
print v(xbgr.mr_n65626944)
print v(xbgr.mr_n65627264)
print v(xbgr.mr_n65627376)
print v(xbgr.mr_n65627696)
print v(xbgr.mr_n65627808)
print v(xbgr.mr_n65628128)
print v(xbgr.mr_n65628240)
print v(xbgr.mr_n65628560)
print v(xbgr.mr_n65628672)
print v(xbgr.mr_n65628992)
print v(xbgr.mr_n65629104)
print v(xbgr.mr_n65629424)
print v(xbgr.mr_n65629536)
print v(xbgr.mr_n65629856)
print v(xbgr.mr_n65629968)
print v(xbgr.mr_n65630288)
print v(xbgr.mr_n65630400)
print v(xbgr.mr_n65630720)
print v(xbgr.mr_n65630832)
print v(xbgr.mr_n65631152)
print v(xbgr.mr_n65631264)
print v(xbgr.mr_n65631584)
print v(xbgr.mr_n65631696)
print v(xbgr.mr_n65632016)
print v(xbgr.mr_n65632128)
print v(xbgr.mr_n65632448)
print v(xbgr.mr_n65632560)
print v(xbgr.mr_n65632880)
print v(xbgr.mr_n65632992)
print v(xbgr.mr_n65633312)
print v(xbgr.mr_n65633424)
print v(xbgr.mr_n65633744)
print v(xbgr.mr_n65633856)
print v(xbgr.mr_n65634176)
print v(xbgr.mr_n65634288)
print v(xbgr.mr_n65634608)
print v(xbgr.mr_n65634720)
print v(xbgr.mr_n65635040)
print v(xbgr.mr_n65635152)
print v(xbgr.mr_n65635472)
print v(xbgr.mr_n65635584)
print v(xbgr.mr_n65635904)
print v(xbgr.mr_n65636016)
print v(xbgr.mr_n65636336)
print v(xbgr.mr_n65636448)
print v(xbgr.mr_n65636768)
print v(xbgr.mr_n65636880)
print v(xbgr.mr_n65637200)
print v(xbgr.mr_n65637312)
print v(xbgr.mr_n65637632)
print v(xbgr.mr_n65637744)
print v(xbgr.mr_n65638064)
print v(xbgr.mr_n65638176)
print v(xbgr.mr_n65638496)
print v(xbgr.mr_n65638608)
print v(xbgr.mr_n65638928)
print v(xbgr.mr_n65639040)
print v(xbgr.mr_n65639360)
print v(xbgr.mr_n65639472)
print v(xbgr.mr_n65639792)
print v(xbgr.mr_n65639904)
print v(xbgr.mr_n65640224)
print v(xbgr.mr_n65640336)
print v(xbgr.mr_n65640656)
print v(xbgr.mr_n65640768)
print v(xbgr.mr_n65641088)
print v(xbgr.mr_n65641200)
print v(xbgr.mr_n65641520)
print v(xbgr.mr_n65641632)
print v(xbgr.mr_n65641952)
print v(xbgr.mr_n65642064)
print v(xbgr.mr_n65642384)
print v(xbgr.mr_n65642496)
print v(xbgr.mr_n65642816)
print v(xbgr.mr_n65642928)
print v(xbgr.mr_n65643248)
print v(xbgr.mr_n65643360)
print v(xbgr.mr_n65643680)
print v(xbgr.mr_n65643792)
print v(xbgr.mr_n65644112)
print v(xbgr.mr_n65644224)
print v(xbgr.mr_n65644544)
print v(xbgr.mr_n65644656)
print v(xbgr.mr_n65644976)
print v(xbgr.mr_n65645088)
print v(xbgr.mr_n65645408)
print v(xbgr.mr_n65645520)
print v(xbgr.mr_n65645840)
print v(xbgr.mr_n65645952)
print v(xbgr.mr_n65646272)
print v(xbgr.mr_n65646384)
print v(xbgr.mr_n65646704)
print v(xbgr.mr_n65646816)
print v(xbgr.mr_n65647136)
print v(xbgr.mr_n65647248)
print v(xbgr.mr_n65647568)
print v(xbgr.mr_n65647680)
print v(xbgr.mr_n65648000)
print v(xbgr.mr_n65648112)
print v(xbgr.mr_n65648432)
print v(xbgr.mr_n65648544)
print v(xbgr.mr_n65648864)
print v(xbgr.mr_n65648976)
print v(xbgr.mr_n65649296)
print v(xbgr.mr_n65649408)
print v(xbgr.mr_n65649728)
print v(xbgr.mr_n65649840)
print v(xbgr.mr_n65650160)
print v(xbgr.mr_n65650272)
print v(xbgr.mr_n65650592)
print v(xbgr.mr_n65650704)
print v(xbgr.mr_n65651024)
print v(xbgr.mr_n65651136)
print v(xbgr.mr_n65651456)
print v(xbgr.mr_n65651568)
print v(xbgr.mr_n65651888)
print v(xbgr.mr_n65652000)
print v(xbgr.mr_n65652320)
print v(xbgr.mr_n65652432)
print v(xbgr.mr_n65652752)
print v(xbgr.mr_n65652864)
print v(xbgr.mr_n65653184)
print v(xbgr.mr_n65653296)
print v(xbgr.mr_n65653616)
print v(xbgr.mr_n65653728)
print v(xbgr.mr_n65654048)
print v(xbgr.mr_n65654160)
print v(xbgr.mr_n65654480)
print v(xbgr.mr_n65654592)
print v(xbgr.mr_n65654912)
print v(xbgr.mr_n65655024)
print v(xbgr.mr_n65655344)
print v(xbgr.mr_n65655456)
print v(xbgr.mr_n65655776)
print v(xbgr.mr_n65655888)
print v(xbgr.mr_n65656208)
print v(xbgr.mr_n65656320)
print v(xbgr.mr_n65656640)
print v(xbgr.mr_n65656752)
print v(xbgr.mr_n65657072)
print v(xbgr.mr_n65657184)
print v(xbgr.mr_n65657504)
print v(xbgr.mr_n65657616)
print v(xbgr.mr_n65657936)
print v(xbgr.mr_n65658048)
print v(xbgr.mr_n65658368)
print v(xbgr.mr_n65658480)
print v(xbgr.mr_n65658800)
print v(xbgr.mr_n65658912)
print v(xbgr.mr_n65659232)
print v(xbgr.mr_n65659344)
print v(xbgr.mr_n65659664)
print v(xbgr.mr_n65659776)
print v(xbgr.mr_n65660096)
print v(xbgr.mr_n65660208)
print v(xbgr.mr_n65660528)
print v(xbgr.mr_n65660640)
print v(xbgr.mr_n65660960)
print v(xbgr.mr_n65661072)
print v(xbgr.mr_n65661392)
print v(xbgr.mr_n65661504)
print v(xbgr.mr_n65661824)
print v(xbgr.mr_n65661936)
print v(xbgr.mr_n65662256)
print v(xbgr.mr_n65662368)
print v(xbgr.mr_n65662688)
print v(xbgr.mr_n65662800)
print v(xbgr.mr_n65663120)
print v(xbgr.mr_n65663232)
print v(xbgr.mr_n65663552)
print v(xbgr.mr_n65663664)
print v(xbgr.mr_n65663984)
print v(xbgr.mr_n65664096)
print v(xbgr.mr_n65664416)
print v(xbgr.mr_n65664528)
print v(xbgr.mr_n65664848)
print v(xbgr.mr_n65664960)
print v(xbgr.mr_n65665280)
print v(xbgr.mr_n65665392)
print v(xbgr.mr_n65665712)
print v(xbgr.mr_n65665824)
print v(xbgr.mr_n65666144)
print v(xbgr.mr_n65666256)
print v(xbgr.mr_n65666576)
print v(xbgr.mr_n65666688)
print v(xbgr.mr_n65667008)
print v(xbgr.mr_n65667120)
print v(xbgr.mr_n65667440)
print v(xbgr.mr_n65667552)
print v(xbgr.mr_n65667872)
print v(xbgr.mr_n65667984)
print v(xbgr.mr_n65668304)
print v(xbgr.mr_n65668416)
print v(xbgr.mr_n65668736)
print v(xbgr.mr_n65668848)
print v(xbgr.mr_n65669168)
print v(xbgr.mr_n65669280)
print v(xbgr.mr_n65669600)
print v(xbgr.mr_n65669712)
print v(xbgr.mr_n65670032)
print v(xbgr.mr_n65670144)
print v(xbgr.mr_n65670464)
print v(xbgr.mr_n65670576)
print v(xbgr.mr_n65670896)
print v(xbgr.mr_n65671008)
print v(xbgr.mr_n65671328)
print v(xbgr.mr_n65671440)
print v(xbgr.mr_n65671760)
print v(xbgr.mr_n65671872)
print v(xbgr.mr_n65672192)
print v(xbgr.mr_n65672304)
print v(xbgr.mr_n65672624)
print v(xbgr.mr_n65672736)
print v(xbgr.mr_n65673056)
print v(xbgr.mr_n65673168)
print v(xbgr.mr_n65673488)
print v(xbgr.mr_n65673600)
print v(xbgr.mr_n65673920)
print v(xbgr.mr_n65674032)
print v(xbgr.mr_n65674352)
print v(xbgr.mr_n65674464)
print v(xbgr.mr_n65674784)
print v(xbgr.mr_n65674896)
print v(xbgr.mr_n65675216)
print v(xbgr.mr_n65675328)
print v(xbgr.mr_n65675648)
print v(xbgr.mr_n65675760)
print v(xbgr.mr_n65676080)
print v(xbgr.mr_n65676192)
print v(xbgr.mr_n65676512)
print v(xbgr.mr_n65676624)
print v(xbgr.mr_n65676944)
print v(xbgr.mr_n65677056)
print v(xbgr.mr_n65677376)
print v(xbgr.mr_n65677488)
print v(xbgr.mr_n65677808)
print v(xbgr.mr_n65677920)
print v(xbgr.mr_n65678240)
print v(xbgr.mr_n65678352)
print v(xbgr.mr_n65678672)
print v(xbgr.mr_n65678784)
print v(xbgr.mr_n65679104)
print v(xbgr.mr_n65679216)
print v(xbgr.mr_n65679536)
print v(xbgr.mr_n65679648)
print v(xbgr.mr_n65679968)
print v(xbgr.mr_n65680080)
print v(xbgr.mr_n65680400)
print v(xbgr.mr_n65680512)
print v(xbgr.mr_n65680832)
print v(xbgr.mr_n65680944)
print v(xbgr.mr_n65681264)
print v(xbgr.mr_n65681376)
print v(xbgr.mr_n65681696)
print v(xbgr.mr_n65681808)
print v(xbgr.mr_n65682128)
print v(xbgr.mr_n65682240)
print v(xbgr.mr_n65682560)
print v(xbgr.mr_n65682672)
print v(xbgr.mr_n65682992)
print v(xbgr.mr_n65683104)
print v(xbgr.mr_n65683424)
print v(xbgr.mr_n65683536)
print v(xbgr.mr_n65683856)
print v(xbgr.mr_n65683968)
print v(xbgr.mr_n65684288)
print v(xbgr.mr_n65684400)
print v(xbgr.mr_n65684720)
print v(xbgr.mr_n65684832)
print v(xbgr.mr_n65685152)
print v(xbgr.mr_n65685264)
print v(xbgr.mr_n65685584)
print v(xbgr.mr_n65685696)
print v(xbgr.mr_n65686016)
print v(xbgr.mr_n65686128)
print v(xbgr.mr_n65686448)
print v(xbgr.mr_n65686560)
print v(xbgr.mr_n65686880)
print v(xbgr.mr_n65686992)
print v(xbgr.mr_n65687312)
print v(xbgr.mr_n65687424)
print v(xbgr.mr_n65687744)
print v(xbgr.mr_n65687856)
print v(xbgr.mr_n65688176)
print v(xbgr.mr_n65688288)
print v(xbgr.mr_n65688608)
print v(xbgr.mr_n65688720)
print v(xbgr.mr_n65689040)
print v(xbgr.mr_n65689152)
print v(xbgr.mr_n65689472)
print v(xbgr.mr_n65689584)
print v(xbgr.mr_n65689904)
print v(xbgr.mr_n65690016)
print v(xbgr.mr_n65690336)
print v(xbgr.mr_n65690448)
print v(xbgr.mr_n65690768)
print v(xbgr.mr_n65690880)
print v(xbgr.mr_n65691200)
print v(xbgr.mr_n65691312)
print v(xbgr.mr_n65691632)
print v(xbgr.mr_n65691744)
print v(xbgr.mr_n65692064)
print v(xbgr.mr_n65692176)
print v(xbgr.mr_n65692496)
print v(xbgr.mr_n65692608)
print v(xbgr.mr_n65692928)
print v(xbgr.mr_n65693040)
print v(xbgr.mr_n65693360)
print v(xbgr.mr_n65693472)
print v(xbgr.mr_n65693792)
print v(xbgr.mr_n65693904)
print v(xbgr.mr_n65694224)
print v(xbgr.mr_n65694336)
print v(xbgr.mr_n65694656)
print v(xbgr.mr_n65694768)
print v(xbgr.mr_n65695088)
print v(xbgr.mr_n65695200)
print v(xbgr.mr_n65695520)
print v(xbgr.mr_n65695632)
print v(xbgr.mr_n65695952)
print v(xbgr.mr_n65696064)
print v(xbgr.mr_n65696384)
print v(xbgr.mr_n65696496)
print v(xbgr.mr_n65696816)
print v(xbgr.mr_n65696928)
print v(xbgr.mr_n65697248)
print v(xbgr.mr_n65697360)
print v(xbgr.mr_n65697680)
print v(xbgr.mr_n65697792)
print v(xbgr.mr_n65698112)
print v(xbgr.mr_n65698224)
print v(xbgr.mr_n65698544)
print v(xbgr.mr_n65698656)
print v(xbgr.mr_n65698976)
print v(xbgr.mr_n65699088)
print v(xbgr.mr_n65699408)
print v(xbgr.mr_n65699520)
print v(xbgr.mr_n65699840)
print v(xbgr.mr_n65699952)
print v(xbgr.mr_n65700272)
print v(xbgr.mr_n65700384)
print v(xbgr.mr_n65700704)
print v(xbgr.mr_n65700816)
print v(xbgr.mr_n65701136)
print v(xbgr.mr_n65701248)
print v(xbgr.mr_n65701568)
print v(xbgr.mr_n65701680)
print v(xbgr.mr_n65702000)
print v(xbgr.mr_n65702112)
print v(xbgr.mr_n65702432)
print v(xbgr.mr_n65702544)
print v(xbgr.mr_n65702864)
print v(xbgr.mr_n65702976)
print v(xbgr.mr_n65703296)
print v(xbgr.mr_n65703408)
print v(xbgr.mr_n65703728)
print v(xbgr.mr_n65703840)
print v(xbgr.mr_n65704160)
print v(xbgr.mr_n65704272)
print v(xbgr.mr_n65704592)
print v(xbgr.mr_n65704704)
print v(xbgr.mr_n65705024)
print v(xbgr.mr_n65705136)
print v(xbgr.mr_n65705456)
print v(xbgr.mr_n65705568)
print v(xbgr.mr_n65705888)
print v(xbgr.mr_n65706000)
print v(xbgr.mr_n65706320)
print v(xbgr.mr_n65706432)
print v(xbgr.mr_n65706752)
print v(xbgr.mr_n65706864)
print v(xbgr.mr_n65707184)
print v(xbgr.mr_n65707296)
print v(xbgr.mr_n65707616)
print v(xbgr.mr_n65707728)
print v(xbgr.mr_n65708048)
print v(xbgr.mr_n65708160)
print v(xbgr.mr_n65708480)
print v(xbgr.mr_n65708592)
print v(xbgr.mr_n65708912)
print v(xbgr.mr_n65709024)
print v(xbgr.mr_n65709344)
print v(xbgr.mr_n65709456)
print v(xbgr.mr_n65709776)
print v(xbgr.mr_n65709888)
print v(xbgr.mr_n65710208)
print v(xbgr.mr_n65710320)
print v(xbgr.mr_n65710640)
print v(xbgr.mr_n65710752)
print v(xbgr.mr_n65711072)
print v(xbgr.mr_n65711184)
print v(xbgr.mr_n65711504)
print v(xbgr.mr_n65711616)
print v(xbgr.mr_n65711936)
print v(xbgr.mr_n65712048)
print v(xbgr.mr_n65712368)
print v(xbgr.mr_n65712480)
print v(xbgr.mr_n65712800)
print v(xbgr.mr_n65712912)
print v(xbgr.mr_n65713232)
print v(xbgr.mr_n65713344)
print v(xbgr.mr_n65713664)
print v(xbgr.mr_n65713776)
print v(xbgr.mr_n65714096)
print v(xbgr.mr_n65714208)
print v(xbgr.mr_n65714528)
print v(xbgr.mr_n65714640)
print v(xbgr.mr_n65714960)
print v(xbgr.mr_n65715072)
print v(xbgr.mr_n65715392)
print v(xbgr.mr_n65715504)
print v(xbgr.mr_n65715824)
print v(xbgr.mr_n65715936)
print v(xbgr.mr_n65716256)
print v(xbgr.mr_n65716368)
print v(xbgr.mr_n65716688)
print v(xbgr.mr_n65716800)
print v(xbgr.mr_n65717120)
print v(xbgr.mr_n65717232)
print v(xbgr.mr_n65717552)
print v(xbgr.mr_n65717664)
print v(xbgr.mr_n65717984)
print v(xbgr.mr_n65718096)
print v(xbgr.mr_n65718416)
print v(xbgr.mr_n65718528)
print v(xbgr.mr_n65718848)
print v(xbgr.mr_n65718960)
print v(xbgr.mr_n65719280)
print v(xbgr.mr_n65719392)
print v(xbgr.mr_n65719712)
print v(xbgr.mr_n65719824)
print v(xbgr.mr_n65720144)
print v(xbgr.mr_n65720256)
print v(xbgr.mr_n65720576)
print v(xbgr.mr_n65720688)
print v(xbgr.mr_n65721008)
print v(xbgr.mr_n65721120)
print v(xbgr.mr_n65721424)
print v(xbgr.mr_n65721536)
print v(xbgr.mr_n65721856)
print v(xbgr.mr_n65721968)
print v(xbgr.mr_n65722288)
print v(xbgr.mr_n65722400)
print v(xbgr.mr_n65722720)
print v(xbgr.mr_n65722832)
print v(xbgr.mr_n65723152)
print v(xbgr.mr_n65723264)
print v(xbgr.mr_n65723584)
print v(xbgr.mr_n65723696)
print v(xbgr.mr_n65724016)
print v(xbgr.mr_n65724128)
print v(xbgr.mr_n65724448)
print v(xbgr.mr_n65724560)
print v(xbgr.mr_n65724880)
print v(xbgr.mr_n65724992)
print v(xbgr.mr_n65725312)
print v(xbgr.mr_n65725424)
print v(xbgr.mr_n65725744)
print v(xbgr.mr_n65725856)
print v(xbgr.mr_n65726176)
print v(xbgr.mr_n65726288)
print v(xbgr.mr_n65726608)
print v(xbgr.mr_n65726720)
print v(xbgr.mr_n65727040)
print v(xbgr.mr_n65727152)
print v(xbgr.mr_n65727472)
print v(xbgr.mr_n65727584)
print v(xbgr.mr_n65727904)
print v(xbgr.mr_n65728016)
print v(xbgr.mr_n65728336)
print v(xbgr.mr_n65728448)
print v(xbgr.mr_n65728768)
print v(xbgr.mr_n65728880)
print v(xbgr.mr_n65729200)
print v(xbgr.mr_n65729312)
print v(xbgr.mr_n65729632)
print v(xbgr.mr_n65729744)
print v(xbgr.mr_n65730064)
print v(xbgr.mr_n65730176)
print v(xbgr.mr_n65730496)
print v(xbgr.mr_n65730608)
print v(xbgr.mr_n65730928)
print v(xbgr.mr_n65731040)
print v(xbgr.mr_n65731360)
print v(xbgr.mr_n65731472)
print v(xbgr.mr_n65731792)
print v(xbgr.mr_n65731904)
print v(xbgr.mr_n65732224)
print v(xbgr.mr_n65732336)
print v(xbgr.mr_n65732656)
print v(xbgr.mr_n65732768)
print v(xbgr.mr_n65733088)
print v(xbgr.mr_n65733200)
print v(xbgr.mr_n65733520)
print v(xbgr.mr_n65733632)
print v(xbgr.mr_n65733952)
print v(xbgr.mr_n65734064)
print v(xbgr.mr_n65734384)
print v(xbgr.mr_n65734496)
print v(xbgr.mr_n65734816)
print v(xbgr.mr_n65734928)
print v(xbgr.mr_n65735248)
print v(xbgr.mr_n65735360)
print v(xbgr.mr_n65735680)
print v(xbgr.mr_n65735792)
print v(xbgr.mr_n65736112)
print v(xbgr.mr_n65736224)
print v(xbgr.mr_n65736544)
print v(xbgr.mr_n65736656)
print v(xbgr.mr_n65736976)
print v(xbgr.mr_n65737088)
print v(xbgr.mr_n65737408)
print v(xbgr.mr_n65737520)
print v(xbgr.mr_n65737840)
print v(xbgr.mr_n65737952)
print v(xbgr.mr_n65738272)
print v(xbgr.mr_n65738384)
print v(xbgr.mr_n65738704)
print v(xbgr.mr_n65738816)
print v(xbgr.mr_n65739136)
print v(xbgr.mr_n65739248)
print v(xbgr.mr_n65739568)
print v(xbgr.mr_n65739680)
print v(xbgr.mr_n65740000)
print v(xbgr.mr_n65740112)
print v(xbgr.mr_n65740432)
print v(xbgr.mr_n65740544)
print v(xbgr.mr_n65740864)
print v(xbgr.mr_n65740976)
print v(xbgr.mr_n65741296)
print v(xbgr.mr_n65741408)
print v(xbgr.mr_n65741728)
print v(xbgr.mr_n65741840)
print v(xbgr.mr_n65742160)
print v(xbgr.mr_n65742272)
print v(xbgr.mr_n65742592)
print v(xbgr.mr_n65742704)
print v(xbgr.mr_n65743024)
print v(xbgr.mr_n65743136)
print v(xbgr.mr_n65743456)
print v(xbgr.mr_n65743568)
print v(xbgr.mr_n65743888)
print v(xbgr.mr_n65744000)
print v(xbgr.mr_n65744320)
print v(xbgr.mr_n65744432)
print v(xbgr.mr_n65744752)
print v(xbgr.mr_n65744864)
print v(xbgr.mr_n65745184)
print v(xbgr.mr_n65745296)
print v(xbgr.mr_n65745616)
print v(xbgr.mr_n65745728)
print v(xbgr.mr_n65746048)
print v(xbgr.mr_n65746160)
print v(xbgr.mr_n65746480)
print v(xbgr.mr_n65746592)
print v(xbgr.mr_n65746912)
print v(xbgr.mr_n65747024)
print v(xbgr.mr_n65747344)
print v(xbgr.mr_n65747456)
print v(xbgr.mr_n65747776)
print v(xbgr.mr_n65747888)
print v(xbgr.mr_n65748208)
print v(xbgr.mr_n65748320)
print v(xbgr.mr_n65748640)
print v(xbgr.mr_n65748752)
print v(xbgr.mr_n65749072)
print v(xbgr.mr_n65749184)
print v(xbgr.mr_n65749504)
print v(xbgr.mr_n65749616)
print v(xbgr.mr_n65749936)
print v(xbgr.mr_n65750048)
print v(xbgr.mr_n65750368)
print v(xbgr.mr_n65750480)
print v(xbgr.mr_n65750800)
print v(xbgr.mr_n65750912)
print v(xbgr.mr_n65751232)
print v(xbgr.mr_n65751344)
print v(xbgr.mr_n65751664)
print v(xbgr.mr_n65751776)
print v(xbgr.mr_n65752096)
print v(xbgr.mr_n65752208)
print v(xbgr.mr_n65752528)
print v(xbgr.mr_n65752640)
print v(xbgr.mr_n65752960)
print v(xbgr.mr_n65753072)
print v(xbgr.mr_n65753392)
print v(xbgr.mr_n65753504)
print v(xbgr.mr_n65753824)
print v(xbgr.mr_n65753936)
print v(xbgr.mr_n65754256)
print v(xbgr.mr_n65754368)
print v(xbgr.mr_n65754688)
print v(xbgr.mr_n65754800)
print v(xbgr.mr_n65755120)
print v(xbgr.mr_n65755232)
print v(xbgr.mr_n65755552)
print v(xbgr.mr_n65755664)
print v(xbgr.mr_n65755984)
print v(xbgr.mr_n65756096)
print v(xbgr.mr_n65756416)
print v(xbgr.mr_n65756528)
print v(xbgr.mr_n65756848)
print v(xbgr.mr_n65756960)
print v(xbgr.mr_n65757280)
print v(xbgr.mr_n65757392)
print v(xbgr.mr_n65757712)
print v(xbgr.mr_n65757824)
print v(xbgr.mr_n65758144)
print v(xbgr.mr_n65758256)
print v(xbgr.mr_n65758576)
print v(xbgr.mr_n65758688)
print v(xbgr.mr_n65759008)
print v(xbgr.mr_n65759120)
print v(xbgr.mr_n65759440)
print v(xbgr.mr_n65759552)
print v(xbgr.mr_n65759872)
print v(xbgr.mr_n65759984)
print v(xbgr.mr_n65760304)
print v(xbgr.mr_n65760416)
print v(xbgr.mr_n65760736)
print v(xbgr.mr_n65760848)
print v(xbgr.mr_n65761168)
print v(xbgr.mr_n65761280)
print v(xbgr.mr_n65761600)
print v(xbgr.mr_n65761712)
print v(xbgr.mr_n65762032)
print v(xbgr.mr_n65762144)
print v(xbgr.mr_n65762464)
print v(xbgr.mr_n65762576)
print v(xbgr.mr_n65762896)
print v(xbgr.mr_n65763008)
print v(xbgr.mr_n65763328)
print v(xbgr.mr_n65763440)
print v(xbgr.mr_n65763760)
print v(xbgr.mr_n65763872)
print v(xbgr.mr_n65764192)
print v(xbgr.mr_n65764304)
print v(xbgr.mr_n65764624)
print v(xbgr.mr_n65764736)
print v(xbgr.mr_n65765056)
print v(xbgr.mr_n65765168)
print v(xbgr.mr_n65765488)
print v(xbgr.mr_n65765600)
print v(xbgr.mr_n65765920)
print v(xbgr.mr_n65766032)
print v(xbgr.mr_n65766352)
print v(xbgr.mr_n65766464)
print v(xbgr.mr_n65766784)
print v(xbgr.mr_n65766896)
print v(xbgr.mr_n65767216)
print v(xbgr.mr_n65767328)
print v(xbgr.mr_n65767648)
print v(xbgr.mr_n65767760)
print v(xbgr.mr_n65768080)
print v(xbgr.mr_n65768192)
print v(xbgr.mr_n65768512)
print v(xbgr.mr_n65768624)
print v(xbgr.mr_n65768944)
print v(xbgr.mr_n65769056)
print v(xbgr.mr_n65769376)
print v(xbgr.mr_n65769488)
print v(xbgr.mr_n65769808)
print v(xbgr.mr_n65769920)
print v(xbgr.mr_n65770240)
print v(xbgr.mr_n65770352)
print v(xbgr.mr_n65770672)
print v(xbgr.mr_n65770784)
print v(xbgr.mr_n65771104)
print v(xbgr.mr_n65771216)
print v(xbgr.mr_n65771536)
print v(xbgr.mr_n65771648)
print v(xbgr.mr_n65771968)
print v(xbgr.mr_n65772080)
print v(xbgr.mr_n65772400)
print v(xbgr.mr_n65772512)
print v(xbgr.mr_n65772832)
print v(xbgr.mr_n65772944)
print v(xbgr.mr_n65773264)
print v(xbgr.mr_n65773376)
print v(xbgr.mr_n65773696)
print v(xbgr.mr_n65773808)
print v(xbgr.mr_n65774128)
print v(xbgr.mr_n65774240)
print v(xbgr.mr_n65774560)
print v(xbgr.mr_n65774672)
print v(xbgr.mr_n65774992)
print v(xbgr.mr_n65775104)
print v(xbgr.mr_n65775424)
print v(xbgr.mr_n65775536)
print v(xbgr.mr_n65775856)
print v(xbgr.mr_n65775968)
print v(xbgr.mr_n65776288)
print v(xbgr.mr_n65776400)
print v(xbgr.mr_n65776720)
print v(xbgr.mr_n65776832)
print v(xbgr.mr_n65777152)
print v(xbgr.mr_n65777264)
print v(xbgr.mr_n65777584)
print v(xbgr.mr_n65777696)
print v(xbgr.mr_n65778016)
print v(xbgr.mr_n65778128)
print v(xbgr.mr_n65778448)
print v(xbgr.mr_n65778560)
print v(xbgr.mr_n65778880)
print v(xbgr.mr_n65778992)
print v(xbgr.mr_n65779312)
print v(xbgr.mr_n65779424)
print v(xbgr.mr_n65779744)
print v(xbgr.mr_n65779856)
print v(xbgr.mr_n65780176)
print v(xbgr.mr_n65780288)
print v(xbgr.mr_n65780608)
print v(xbgr.mr_n65780720)
print v(xbgr.mr_n65781040)
print v(xbgr.mr_n65781152)
print v(xbgr.mr_n65781472)
print v(xbgr.mr_n65781584)
print v(xbgr.mr_n65781904)
print v(xbgr.mr_n65782016)
print v(xbgr.mr_n65782336)
print v(xbgr.mr_n65782448)
print v(xbgr.mr_n65782768)
print v(xbgr.mr_n65782880)
print v(xbgr.mr_n65783200)
print v(xbgr.mr_n65783312)
print v(xbgr.mr_n65783632)
print v(xbgr.mr_n65783744)
print v(xbgr.mr_n65784064)
print v(xbgr.mr_n65784176)
print v(xbgr.mr_n65784496)
print v(xbgr.mr_n65784608)
print v(xbgr.mr_n65784928)
print v(xbgr.mr_n65785040)
print v(xbgr.mr_n65785360)
print v(xbgr.mr_n65785472)
print v(xbgr.mr_n65785792)
print v(xbgr.mr_n65785904)
print v(xbgr.mr_n65786224)
print v(xbgr.mr_n65786336)
print v(xbgr.mr_n65786656)
print v(xbgr.mr_n65786768)
print v(xbgr.mr_n65787088)
print v(xbgr.mr_n65787200)
print v(xbgr.mr_n65787520)
print v(xbgr.mr_n65787632)
print v(xbgr.mr_n65787952)
print v(xbgr.mr_n65788064)
print v(xbgr.mr_n65788384)
print v(xbgr.mr_n65788496)
print v(xbgr.mr_n65788816)
print v(xbgr.mr_n65788928)
print v(xbgr.mr_n65789248)
print v(xbgr.mr_n65789360)
print v(xbgr.mr_n65789680)
print v(xbgr.mr_n65789792)
print v(xbgr.mr_n65790112)
print v(xbgr.mr_n65790224)
print v(xbgr.mr_n65790544)
print v(xbgr.mr_n65790656)
print v(xbgr.mr_n65790976)
print v(xbgr.mr_n65791088)
print v(xbgr.mr_n65791408)
print v(xbgr.mr_n65791520)
print v(xbgr.mr_n65791840)
print v(xbgr.mr_n65791952)
print v(xbgr.mr_n65792272)
print v(xbgr.mr_n65792384)
print v(xbgr.mr_n65792704)
print v(xbgr.mr_n65792816)
print v(xbgr.mr_n65793136)
print v(xbgr.mr_n65793248)
print v(xbgr.mr_n65793568)
print v(xbgr.mr_n65793680)
print v(xbgr.mr_n65794000)
print v(xbgr.mr_n65794112)
print v(xbgr.mr_n65794432)
print v(xbgr.mr_n65794544)
print v(xbgr.mr_n65794864)
print v(xbgr.mr_n65794976)
print v(xbgr.mr_n65795296)
print v(xbgr.mr_n65795408)
print v(xbgr.mr_n65795728)
print v(xbgr.mr_n65795840)
print v(xbgr.mr_n65796160)
print v(xbgr.mr_n65796272)
print v(xbgr.mr_n65796592)
print v(xbgr.mr_n65796704)
print v(xbgr.mr_n65797024)
print v(xbgr.mr_n65797136)
print v(xbgr.mr_n65797456)
print v(xbgr.mr_n65797568)
print v(xbgr.mr_n65797888)
print v(xbgr.mr_n65798000)
print v(xbgr.mr_n65798320)
print v(xbgr.mr_n65798432)
print v(xbgr.mr_n65798752)
print v(xbgr.mr_n65798864)
print v(xbgr.mr_n65799184)
print v(xbgr.mr_n65799296)
print v(xbgr.mr_n65799616)
print v(xbgr.mr_n65799728)
print v(xbgr.mr_n65800048)
print v(xbgr.mr_n65800160)
print v(xbgr.mr_n65800480)
print v(xbgr.mr_n65800592)
print v(xbgr.mr_n65800912)
print v(xbgr.mr_n65801024)
print v(xbgr.mr_n65801344)
print v(xbgr.mr_n65801456)
print v(xbgr.mr_n65801776)
print v(xbgr.mr_n65801888)
print v(xbgr.mr_n65802208)
print v(xbgr.mr_n65802320)
print v(xbgr.mr_n65802640)
print v(xbgr.mr_n65802752)
print v(xbgr.mr_n65803072)
print v(xbgr.mr_n65803184)
print v(xbgr.mr_n65803504)
print v(xbgr.mr_n65803616)
print v(xbgr.mr_n65803936)
print v(xbgr.mr_n65804048)
print v(xbgr.mr_n65804368)
print v(xbgr.mr_n65804480)
print v(xbgr.mr_n65804800)
print v(xbgr.mr_n65804912)
print v(xbgr.mr_n65805232)
print v(xbgr.mr_n65805344)
print v(xbgr.mr_n65805664)
print v(xbgr.mr_n65805776)
print v(xbgr.mr_n65806096)
print v(xbgr.mr_n65806208)
print v(xbgr.mr_n65806528)
print v(xbgr.mr_n65806640)
print v(xbgr.mr_n65806960)
print v(xbgr.mr_n65807072)
print v(xbgr.mr_n65807392)
print v(xbgr.mr_n65807504)
print v(xbgr.mr_n65807824)
print v(xbgr.mr_n65807936)
print v(xbgr.mr_n65808256)
print v(xbgr.mr_n65808368)
print v(xbgr.mr_n65808688)
print v(xbgr.mr_n65808800)
print v(xbgr.mr_n65809120)
print v(xbgr.mr_n65809232)
print v(xbgr.mr_n65809552)
print v(xbgr.mr_n65809664)
print v(xbgr.mr_n65809984)
print v(xbgr.mr_n65810096)
print v(xbgr.mr_n65810416)
print v(xbgr.mr_n65810528)
print v(xbgr.mr_n65810848)
print v(xbgr.mr_n65810960)
print v(xbgr.mr_n65811280)
print v(xbgr.mr_n65811392)
print v(xbgr.mr_n65811712)
print v(xbgr.mr_n65811824)
print v(xbgr.mr_n65812144)
print v(xbgr.mr_n65812256)
print v(xbgr.mr_n65812576)
print v(xbgr.mr_n65812688)
print v(xbgr.mr_n65813008)
print v(xbgr.mr_n65813120)
print v(xbgr.mr_n65813440)
print v(xbgr.mr_n65813552)
print v(xbgr.mr_n65813872)
print v(xbgr.mr_n65813984)
print v(xbgr.mr_n65814304)
print v(xbgr.mr_n65814416)
print v(xbgr.mr_n65814736)
print v(xbgr.mr_n65814848)
print v(xbgr.mr_n65815168)
print v(xbgr.mr_n65815280)
print v(xbgr.mr_n65815600)
print v(xbgr.mr_n65815712)
print v(xbgr.mr_n65816032)
print v(xbgr.mr_n65816144)
print v(xbgr.mr_n65816464)
print v(xbgr.mr_n65816576)
print v(xbgr.mr_n65816896)
print v(xbgr.mr_n65817008)
print v(xbgr.mr_n65817328)
print v(xbgr.mr_n65817440)
print v(xbgr.mr_n65817760)
print v(xbgr.mr_n65817872)
print v(xbgr.mr_n65818192)
print v(xbgr.mr_n65818304)
print v(xbgr.mr_n65818624)
print v(xbgr.mr_n65818736)
print v(xbgr.mr_n65819056)
print v(xbgr.mr_n65819168)
print v(xbgr.mr_n65819488)
print v(xbgr.mr_n65819600)
print v(xbgr.mr_n65819920)
print v(xbgr.mr_n65820032)
print v(xbgr.mr_n65820352)
print v(xbgr.mr_n65820464)
print v(xbgr.mr_n65820784)
print v(xbgr.mr_n65820896)
print v(xbgr.mr_n65821216)
print v(xbgr.mr_n65821328)
print v(xbgr.mr_n65821648)
print v(xbgr.mr_n65821760)
print v(xbgr.mr_n65822080)
print v(xbgr.mr_n65822192)
print v(xbgr.mr_n65822512)
print v(xbgr.mr_n65822624)
print v(xbgr.mr_n65822944)
print v(xbgr.mr_n65823056)
print v(xbgr.mr_n65823376)
print v(xbgr.mr_n65823488)
print v(xbgr.mr_n65823808)
print v(xbgr.mr_n65823920)
print v(xbgr.mr_n65824240)
print v(xbgr.mr_n65824352)
print v(xbgr.mr_n65824672)
print v(xbgr.mr_n65824784)
print v(xbgr.mr_n65825104)
print v(xbgr.mr_n65825216)
print v(xbgr.mr_n65825536)
print v(xbgr.mr_n65825648)
print v(xbgr.mr_n65825968)
print v(xbgr.mr_n65826080)
print v(xbgr.mr_n65826400)
print v(xbgr.mr_n65826512)
print v(xbgr.mr_n65826832)
print v(xbgr.mr_n65826944)
print v(xbgr.mr_n65827264)
print v(xbgr.mr_n65827376)
print v(xbgr.mr_n65827696)
print v(xbgr.mr_n65827808)
print v(xbgr.mr_n65828128)
print v(xbgr.mr_n65828240)
print v(xbgr.mr_n65828560)
print v(xbgr.mr_n65828672)
print v(xbgr.mr_n65828992)
print v(xbgr.mr_n65829104)
print v(xbgr.mr_n65829424)
print v(xbgr.mr_n65829536)
print v(xbgr.mr_n65829856)
print v(xbgr.mr_n65829968)
print v(xbgr.mr_n65830288)
print v(xbgr.mr_n65830400)
print v(xbgr.mr_n65830720)
print v(xbgr.mr_n65830832)
print v(xbgr.mr_n65831152)
print v(xbgr.mr_n65831264)
print v(xbgr.mr_n65831584)
print v(xbgr.mr_n65831696)
print v(xbgr.mr_n65832016)
print v(xbgr.mr_n65832128)
print v(xbgr.mr_n65832448)
print v(xbgr.mr_n65832560)
print v(xbgr.mr_n65832880)
print v(xbgr.mr_n65832992)
print v(xbgr.mr_n65833312)
print v(xbgr.mr_n65833424)
print v(xbgr.mr_n65833744)
print v(xbgr.mr_n65833856)
print v(xbgr.mr_n65834176)
print v(xbgr.mr_n65834288)
print v(xbgr.mr_n65834608)
print v(xbgr.mr_n65834720)
print v(xbgr.mr_n65835040)
print v(xbgr.mr_n65835152)
print v(xbgr.mr_n65835472)
print v(xbgr.mr_n65835584)
print v(xbgr.mr_n65835904)
print v(xbgr.mr_n65836016)
print v(xbgr.mr_n65836336)
print v(xbgr.mr_n65836448)
print v(xbgr.mr_n65836768)
print v(xbgr.mr_n65836880)
print v(xbgr.mr_n65837200)
print v(xbgr.mr_n65837312)
print v(xbgr.mr_n65837632)
print v(xbgr.mr_n65837744)
print v(xbgr.mr_n65838064)
print v(xbgr.mr_n65838176)
print v(xbgr.mr_n65838496)
print v(xbgr.mr_n65838608)
print v(xbgr.mr_n65838928)
print v(xbgr.mr_n65839040)
print v(xbgr.mr_n65839360)
print v(xbgr.mr_n65839472)
print v(xbgr.mr_n65839792)
print v(xbgr.mr_n65839904)
print v(xbgr.mr_n65840224)
print v(xbgr.mr_n65840336)
print v(xbgr.mr_n65840656)
print v(xbgr.mr_n65840768)
print v(xbgr.mr_n65841088)
print v(xbgr.mr_n65841200)
print v(xbgr.mr_n65841520)
print v(xbgr.mr_n65841632)
print v(xbgr.mr_n65841952)
print v(xbgr.mr_n65842064)
print v(xbgr.mr_n65842384)
print v(xbgr.mr_n65842496)
print v(xbgr.mr_n65842816)
print v(xbgr.mr_n65842928)
print v(xbgr.mr_n65843248)
print v(xbgr.mr_n65843360)
print v(xbgr.mr_n65843680)
print v(xbgr.mr_n65843792)
print v(xbgr.mr_n65844112)
print v(xbgr.mr_n65844224)
print v(xbgr.mr_n65844544)
print v(xbgr.mr_n65844656)
print v(xbgr.mr_n65844976)
print v(xbgr.mr_n65845088)
print v(xbgr.mr_n65845408)
print v(xbgr.mr_n65845520)
print v(xbgr.mr_n65845840)
print v(xbgr.mr_n65845952)
print v(xbgr.mr_n65846272)
print v(xbgr.mr_n65846384)
print v(xbgr.mr_n65846704)
print v(xbgr.mr_n65846816)
print v(xbgr.mr_n65847136)
print v(xbgr.mr_n65847248)
print v(xbgr.mr_n65847568)
print v(xbgr.mr_n65847680)
print v(xbgr.mr_n65848000)
print v(xbgr.mr_n65848112)
print v(xbgr.mr_n65848432)
print v(xbgr.mr_n65848544)
print v(xbgr.mr_n65848864)
print v(xbgr.mr_n65848976)
print v(xbgr.mr_n65849296)
print v(xbgr.mr_n65849408)
print v(xbgr.mr_n65849728)
print v(xbgr.mr_n65849840)
print v(xbgr.mr_n65850160)
print v(xbgr.mr_n65850272)
print v(xbgr.mr_n65850592)
print v(xbgr.mr_n65850704)
print v(xbgr.mr_n65851024)
print v(xbgr.mr_n65851136)
print v(xbgr.mr_n65851456)
print v(xbgr.mr_n65851568)
print v(xbgr.mr_n65851888)
print v(xbgr.mr_n65852000)
print v(xbgr.mr_n65852320)
print v(xbgr.mr_n65852432)
print v(xbgr.mr_n65852752)
print v(xbgr.mr_n65852864)
print v(xbgr.mr_n65853184)
print v(xbgr.mr_n65853296)
print v(xbgr.mr_n65853616)
print v(xbgr.mr_n65853728)
print v(xbgr.mr_n65854048)
print v(xbgr.mr_n65854160)
print v(xbgr.mr_n65854480)
print v(xbgr.mr_n65854592)
print v(xbgr.mr_n65854912)
print v(xbgr.mr_n65855024)
print v(xbgr.mr_n65855344)
print v(xbgr.mr_n65855456)
print v(xbgr.mr_n65855776)
print v(xbgr.mr_n65855888)
print v(xbgr.mr_n65856208)
print v(xbgr.mr_n65856320)
print v(xbgr.mr_n65856640)
print v(xbgr.mr_n65856752)
print v(xbgr.mr_n65857072)
print v(xbgr.mr_n65857184)
print v(xbgr.mr_n65857504)
print v(xbgr.mr_n65857616)
print v(xbgr.mr_n65857936)
print v(xbgr.mr_n65858048)
print v(xbgr.mr_n65858368)
print v(xbgr.mr_n65858480)
print v(xbgr.mr_n65858800)
print v(xbgr.mr_n65858912)
print v(xbgr.mr_n65859232)
print v(xbgr.mr_n65859344)
print v(xbgr.mr_n65859664)
print v(xbgr.mr_n65859776)
print v(xbgr.mr_n65860096)
print v(xbgr.mr_n65860208)
print v(xbgr.mr_n65860528)
print v(xbgr.mr_n65860640)
print v(xbgr.mr_n65860960)
print v(xbgr.mr_n65861072)
print v(xbgr.mr_n65861392)
print v(xbgr.mr_n65861504)
print v(xbgr.mr_n65861824)
print v(xbgr.mr_n65861936)
print v(xbgr.mr_n65862256)
print v(xbgr.mr_n65862368)
print v(xbgr.mr_n65862688)
print v(xbgr.mr_n65862800)
print v(xbgr.mr_n65863120)
print v(xbgr.mr_n65863232)
print v(xbgr.mr_n65863552)
print v(xbgr.mr_n65863664)
print v(xbgr.mr_n65863984)
print v(xbgr.mr_n65864096)
print v(xbgr.mr_n65864416)
print v(xbgr.mr_n65864528)
print v(xbgr.mr_n65864848)
print v(xbgr.mr_n65864960)
print v(xbgr.mr_n65865280)
print v(xbgr.mr_n65865392)
print v(xbgr.mr_n65865712)
print v(xbgr.mr_n65865824)
print v(xbgr.mr_n65866144)
print v(xbgr.mr_n65866256)
print v(xbgr.mr_n65866576)
print v(xbgr.mr_n65866688)
print v(xbgr.mr_n65867008)
print v(xbgr.mr_n65867120)
print v(xbgr.mr_n65867440)
print v(xbgr.mr_n65867552)
print v(xbgr.mr_n65867872)
print v(xbgr.mr_n65867984)
print v(xbgr.mr_n65868304)
print v(xbgr.mr_n65868416)
print v(xbgr.mr_n65868736)
print v(xbgr.mr_n65868848)
print v(xbgr.mr_n65869168)
print v(xbgr.mr_n65869280)
print v(xbgr.mr_n65869600)
print v(xbgr.mr_n65869712)
print v(xbgr.mr_n65870032)
print v(xbgr.mr_n65870144)
print v(xbgr.mr_n65870464)
print v(xbgr.mr_n65870576)
print v(xbgr.mr_n65870896)
print v(xbgr.mr_n65871008)
print v(xbgr.mr_n65871328)
print v(xbgr.mr_n65871440)
print v(xbgr.mr_n65871760)
print v(xbgr.mr_n65871872)
print v(xbgr.mr_n65872192)
print v(xbgr.mr_n65872304)
print v(xbgr.mr_n65872624)
print v(xbgr.mr_n65872736)
print v(xbgr.mr_n65873056)
print v(xbgr.mr_n65873168)
print v(xbgr.mr_n65873488)
print v(xbgr.mr_n65873600)
print v(xbgr.mr_n65873920)
print v(xbgr.mr_n65874032)
print v(xbgr.mr_n65874352)
print v(xbgr.mr_n65874464)
print v(xbgr.mr_n65874784)
print v(xbgr.mr_n65874896)
print v(xbgr.mr_n65875216)
print v(xbgr.mr_n65875328)
print v(xbgr.mr_n65875648)
print v(xbgr.mr_n65875760)
print v(xbgr.mr_n65876080)
print v(xbgr.mr_n65876192)
print v(xbgr.mr_n65876512)
print v(xbgr.mr_n65876624)
print v(xbgr.mr_n65876944)
print v(xbgr.mr_n65877056)
print v(xbgr.mr_n65877376)
print v(xbgr.mr_n65877488)
print v(xbgr.mr_n65877808)
print v(xbgr.mr_n65877920)
print v(xbgr.mr_n65878240)
print v(xbgr.mr_n65878352)
print v(xbgr.mr_n65878672)
print v(xbgr.mr_n65878784)
print v(xbgr.mr_n65879104)
print v(xbgr.mr_n65879216)
print v(xbgr.mr_n65879536)
print v(xbgr.mr_n65879648)
print v(xbgr.mr_n65879968)
print v(xbgr.mr_n65880080)
print v(xbgr.mr_n65880400)
print v(xbgr.mr_n65880512)
print v(xbgr.mr_n65880832)
print v(xbgr.mr_n65880944)
print v(xbgr.mr_n65881264)
print v(xbgr.mr_n65881376)
print v(xbgr.mr_n65881696)
print v(xbgr.mr_n65881808)
print v(xbgr.mr_n65882128)
print v(xbgr.mr_n65882240)
print v(xbgr.mr_n65882560)
print v(xbgr.mr_n65882672)
print v(xbgr.mr_n65882992)
print v(xbgr.mr_n65883104)
print v(xbgr.mr_n65883424)
print v(xbgr.mr_n65883536)
print v(xbgr.mr_n65883856)
print v(xbgr.mr_n65883968)
print v(xbgr.mr_n65884288)
print v(xbgr.mr_n65884400)
print v(xbgr.mr_n65884720)
print v(xbgr.mr_n65884832)
print v(xbgr.mr_n65885152)
print v(xbgr.mr_n65885264)
print v(xbgr.mr_n65885584)
print v(xbgr.mr_n65885696)
print v(xbgr.mr_n65886016)
print v(xbgr.mr_n65886128)
print v(xbgr.mr_n65886448)
print v(xbgr.mr_n65886560)
print v(xbgr.mr_n65886880)
print v(xbgr.mr_n65886992)
print v(xbgr.mr_n65887312)
print v(xbgr.mr_n65887424)
print v(xbgr.mr_n65887744)
print v(xbgr.mr_n65887856)
print v(xbgr.mr_n65888176)
print v(xbgr.mr_n65888288)
print v(xbgr.mr_n65888608)
print v(xbgr.mr_n65888720)
print v(xbgr.mr_n65889040)
print v(xbgr.mr_n65889152)
print v(xbgr.mr_n65889472)
print v(xbgr.mr_n65889584)
print v(xbgr.mr_n65889904)
print v(xbgr.mr_n65890016)
print v(xbgr.mr_n65890336)
print v(xbgr.mr_n65890448)
print v(xbgr.mr_n65890768)
print v(xbgr.mr_n65890880)
print v(xbgr.mr_n65891200)
print v(xbgr.mr_n65891312)
print v(xbgr.mr_n65891632)
print v(xbgr.mr_n65891744)
print v(xbgr.mr_n65892064)
print v(xbgr.mr_n65892176)
print v(xbgr.mr_n65892496)
print v(xbgr.mr_n65892608)
print v(xbgr.mr_n65892928)
print v(xbgr.mr_n65893040)
print v(xbgr.mr_n65893360)
print v(xbgr.mr_n65893472)
print v(xbgr.mr_n65893792)
print v(xbgr.mr_n65893904)
print v(xbgr.mr_n65894224)
print v(xbgr.mr_n65894336)
print v(xbgr.mr_n65894656)
print v(xbgr.mr_n65894768)
print v(xbgr.mr_n65895088)
print v(xbgr.mr_n65895200)
print v(xbgr.mr_n65895520)
print v(xbgr.mr_n65895632)
print v(xbgr.mr_n65895952)
print v(xbgr.mr_n65896064)
print v(xbgr.mr_n65896384)
print v(xbgr.mr_n65896496)
print v(xbgr.mr_n65896816)
print v(xbgr.mr_n65896928)
print v(xbgr.mr_n65897248)
print v(xbgr.mr_n65897360)
print v(xbgr.mr_n65897680)
print v(xbgr.mr_n65897792)
print v(xbgr.mr_n65898112)
print v(xbgr.mr_n65898224)
print v(xbgr.mr_n65898544)
print v(xbgr.mr_n65898656)
print v(xbgr.mr_n65898976)
print v(xbgr.mr_n65899088)
print v(xbgr.mr_n65899408)
print v(xbgr.mr_n65899520)
print v(xbgr.mr_n65899840)
print v(xbgr.mr_n65899952)
print v(xbgr.mr_n65900272)
print v(xbgr.mr_n65900384)
print v(xbgr.mr_n65900704)
print v(xbgr.mr_n65900816)
print v(xbgr.mr_n65901136)
print v(xbgr.mr_n65901248)
print v(xbgr.mr_n65901568)
print v(xbgr.mr_n65901680)
print v(xbgr.mr_n65902000)
print v(xbgr.mr_n65902112)
print v(xbgr.mr_n65902432)
print v(xbgr.mr_n65902544)
print v(xbgr.mr_n65902864)
print v(xbgr.mr_n65902976)
print v(xbgr.mr_n65903296)
print v(xbgr.mr_n65903408)
print v(xbgr.mr_n65903728)
print v(xbgr.mr_n65903840)
print v(xbgr.mr_n65904160)
print v(xbgr.mr_n65904272)
print v(xbgr.mr_n65904592)
print v(xbgr.mr_n65904704)
print v(xbgr.mr_n65905024)
print v(xbgr.mr_n65905136)
print v(xbgr.mr_n65905456)
print v(xbgr.mr_n65905568)
print v(xbgr.mr_n65905888)
print v(xbgr.mr_n65906000)
print v(xbgr.mr_n65906320)
print v(xbgr.mr_n65906432)
print v(xbgr.mr_n65906752)
print v(xbgr.mr_n65906864)
print v(xbgr.mr_n65907184)
print v(xbgr.mr_n65907296)
print v(xbgr.mr_n65907616)
print v(xbgr.mr_n65907728)
print v(xbgr.mr_n65908048)
print v(xbgr.mr_n65908160)
print v(xbgr.mr_n65908480)
print v(xbgr.mr_n65908592)
print v(xbgr.mr_n65908912)
print v(xbgr.mr_n65909024)
print v(xbgr.mr_n65909344)
print v(xbgr.mr_n65909456)
print v(xbgr.mr_n65909776)
print v(xbgr.mr_n65909888)
print v(xbgr.mr_n65910208)
print v(xbgr.mr_n65910320)
print v(xbgr.mr_n65910640)
print v(xbgr.mr_n65910752)
print v(xbgr.mr_n65911072)
print v(xbgr.mr_n65911184)
print v(xbgr.mr_n65911504)
print v(xbgr.mr_n65911616)
print v(xbgr.mr_n65911936)
print v(xbgr.mr_n65912048)
print v(xbgr.mr_n65912368)
print v(xbgr.mr_n65912480)
print v(xbgr.mr_n65912800)
print v(xbgr.mr_n65912912)
print v(xbgr.mr_n65913232)
print v(xbgr.mr_n65913344)
print v(xbgr.mr_n65913664)
print v(xbgr.mr_n65913776)
print v(xbgr.mr_n65914096)
print v(xbgr.mr_n65914208)
print v(xbgr.mr_n65914528)
print v(xbgr.mr_n65914640)
print v(xbgr.mr_n65914960)
print v(xbgr.mr_n65915072)
print v(xbgr.mr_n65915392)
print v(xbgr.mr_n65915504)
print v(xbgr.mr_n65915824)
print v(xbgr.mr_n65915936)
print v(xbgr.mr_n65916256)
print v(xbgr.mr_n65916368)
print v(xbgr.mr_n65916688)
print v(xbgr.mr_n65916800)
print v(xbgr.mr_n65917120)
print v(xbgr.mr_n65917232)
print v(xbgr.mr_n65917552)
print v(xbgr.mr_n65917664)
print v(xbgr.mr_n65917984)
print v(xbgr.mr_n65918096)
print v(xbgr.mr_n65918416)
print v(xbgr.mr_n65918528)
print v(xbgr.mr_n65918848)
print v(xbgr.mr_n65918960)
print v(xbgr.mr_n65919280)
print v(xbgr.mr_n65919392)
print v(xbgr.mr_n65919712)
print v(xbgr.mr_n65919824)
print v(xbgr.mr_n65920144)
print v(xbgr.mr_n65920256)
print v(xbgr.mr_n65920576)
print v(xbgr.mr_n65920688)
print v(xbgr.mr_n65921008)
print v(xbgr.mr_n65921120)
print v(xbgr.mr_n65921440)
print v(xbgr.mr_n65921552)
print v(xbgr.mr_n65921872)
print v(xbgr.mr_n65921984)
print v(xbgr.mr_n65922304)
print v(xbgr.mr_n65922416)
print v(xbgr.mr_n65922736)
print v(xbgr.mr_n65922848)
print v(xbgr.mr_n65923168)
print v(xbgr.mr_n65923280)
print v(xbgr.mr_n65923600)
print v(xbgr.mr_n65923712)
print v(xbgr.mr_n65924032)
print v(xbgr.mr_n65924144)
print v(xbgr.mr_n65924464)
print v(xbgr.mr_n65924576)
print v(xbgr.mr_n65924896)
print v(xbgr.mr_n65925008)
print v(xbgr.mr_n65925328)
print v(xbgr.mr_n65925440)
print v(xbgr.mr_n65925760)
print v(xbgr.mr_n65925872)
print v(xbgr.mr_n65926192)
print v(xbgr.mr_n65926304)
print v(xbgr.mr_n65926624)
print v(xbgr.mr_n65926736)
print v(xbgr.mr_n65927056)
print v(xbgr.mr_n65927168)
print v(xbgr.mr_n65927488)
print v(xbgr.mr_n65927600)
print v(xbgr.mr_n65927920)
print v(xbgr.mr_n65928032)
print v(xbgr.mr_n65928352)
print v(xbgr.mr_n65928464)
print v(xbgr.mr_n65928784)
print v(xbgr.mr_n65928896)
print v(xbgr.mr_n65929216)
print v(xbgr.mr_n65929328)
print v(xbgr.mr_n65929648)
print v(xbgr.mr_n65929760)
print v(xbgr.mr_n65930080)
print v(xbgr.mr_n65930192)
print v(xbgr.mr_n65930512)
print v(xbgr.mr_n65930624)
print v(xbgr.mr_n65930944)
print v(xbgr.mr_n65931056)
print v(xbgr.mr_n65931376)
print v(xbgr.mr_n65931488)
print v(xbgr.mr_n65931808)
print v(xbgr.mr_n65931920)
print v(xbgr.mr_n65932240)
print v(xbgr.mr_n65932352)
print v(xbgr.mr_n65932672)
print v(xbgr.mr_n65932784)
print v(xbgr.mr_n65933104)
print v(xbgr.mr_n65933216)
print v(xbgr.mr_n65933536)
print v(xbgr.mr_n65933648)
print v(xbgr.mr_n65933968)
print v(xbgr.mr_n65934080)
print v(xbgr.mr_n65934400)
print v(xbgr.mr_n65934512)
print v(xbgr.mr_n65934832)
print v(xbgr.mr_n65934944)
print v(xbgr.mr_n65935264)
print v(xbgr.mr_n65935376)
print v(xbgr.mr_n65935696)
print v(xbgr.mr_n65935808)
print v(xbgr.mr_n65936128)
print v(xbgr.mr_n65936240)
print v(xbgr.mr_n65936560)
print v(xbgr.mr_n65936672)
print v(xbgr.mr_n65936992)
print v(xbgr.mr_n65937104)
print v(xbgr.mr_n65937424)
print v(xbgr.mr_n65937536)
print v(xbgr.mr_n65937856)
print v(xbgr.mr_n65937968)
print v(xbgr.mr_n65938288)
print v(xbgr.mr_n65938400)
print v(xbgr.mr_n65938720)
print v(xbgr.mr_n65938832)
print v(xbgr.mr_n65939152)
print v(xbgr.mr_n65939264)
print v(xbgr.mr_n65939584)
print v(xbgr.mr_n65939696)
print v(xbgr.mr_n65940016)
print v(xbgr.mr_n65940128)
print v(xbgr.mr_n65940448)
print v(xbgr.mr_n65940560)
print v(xbgr.mr_n65940880)
print v(xbgr.mr_n65940992)
print v(xbgr.mr_n65941312)
print v(xbgr.mr_n65941424)
print v(xbgr.mr_n65941744)
print v(xbgr.mr_n65941856)
print v(xbgr.mr_n65942176)
print v(xbgr.mr_n65942288)
print v(xbgr.mr_n65942608)
print v(xbgr.mr_n65942720)
print v(xbgr.mr_n65943040)
print v(xbgr.mr_n65943152)
print v(xbgr.mr_n65943472)
print v(xbgr.mr_n65943584)
print v(xbgr.mr_n65943904)
print v(xbgr.mr_n65944016)
print v(xbgr.mr_n65944336)
print v(xbgr.mr_n65944448)
print v(xbgr.mr_n65944768)
print v(xbgr.mr_n65944880)
print v(xbgr.mr_n65945200)
print v(xbgr.mr_n65945312)
print v(xbgr.mr_n65945632)
print v(xbgr.mr_n65945744)
print v(xbgr.mr_n65946064)
print v(xbgr.mr_n65946176)
print v(xbgr.mr_n65946496)
print v(xbgr.mr_n65946608)
print v(xbgr.mr_n65946928)
print v(xbgr.mr_n65947040)
print v(xbgr.mr_n65947360)
print v(xbgr.mr_n65947472)
print v(xbgr.mr_n65947792)
print v(xbgr.mr_n65947904)
print v(xbgr.mr_n65948224)
print v(xbgr.mr_n65948336)
print v(xbgr.mr_n65948656)
print v(xbgr.mr_n65948768)
print v(xbgr.mr_n65949088)
print v(xbgr.mr_n65949200)
print v(xbgr.mr_n65949520)
print v(xbgr.mr_n65949632)
print v(xbgr.mr_n65949952)
print v(xbgr.mr_n65950064)
print v(xbgr.mr_n65950384)
print v(xbgr.mr_n65950496)
print v(xbgr.mr_n65950816)
print v(xbgr.mr_n65950928)
print v(xbgr.mr_n65951248)
print v(xbgr.mr_n65951360)
print v(xbgr.mr_n65951680)
print v(xbgr.mr_n65951792)
print v(xbgr.mr_n65952112)
print v(xbgr.mr_n65952224)
print v(xbgr.mr_n65952544)
print v(xbgr.mr_n65952656)
print v(xbgr.mr_n65952976)
print v(xbgr.mr_n65953088)
print v(xbgr.mr_n65953408)
print v(xbgr.mr_n65953520)
print v(xbgr.mr_n65953840)
print v(xbgr.mr_n65953952)
print v(xbgr.mr_n65954272)
print v(xbgr.mr_n65954384)
print v(xbgr.mr_n65954704)
print v(xbgr.mr_n65954816)
print v(xbgr.mr_n65955136)
print v(xbgr.mr_n65955248)
print v(xbgr.mr_n65955568)
print v(xbgr.mr_n65955680)
print v(xbgr.mr_n65956000)
print v(xbgr.mr_n65956112)
print v(xbgr.mr_n65956432)
print v(xbgr.mr_n65956544)
print v(xbgr.mr_n65956864)
print v(xbgr.mr_n65956976)
print v(xbgr.mr_n65957296)
print v(xbgr.mr_n65957408)
print v(xbgr.mr_n65957728)
print v(xbgr.mr_n65957840)
print v(xbgr.mr_n65958160)
print v(xbgr.mr_n65958272)
print v(xbgr.mr_n65958592)
print v(xbgr.mr_n65958704)
print v(xbgr.mr_n65959024)
print v(xbgr.mr_n65959136)
print v(xbgr.mr_n65959456)
print v(xbgr.mr_n65959568)
print v(xbgr.mr_n65959888)
print v(xbgr.mr_n65960000)
print v(xbgr.mr_n65960320)
print v(xbgr.mr_n65960432)
print v(xbgr.mr_n65960752)
print v(xbgr.mr_n65960864)
print v(xbgr.mr_n65961184)
print v(xbgr.mr_n65961296)
print v(xbgr.mr_n65961616)
print v(xbgr.mr_n65961728)
print v(xbgr.mr_n65962048)
print v(xbgr.mr_n65962160)
print v(xbgr.mr_n65962480)
print v(xbgr.mr_n65962592)
print v(xbgr.mr_n65962912)
print v(xbgr.mr_n65963024)
print v(xbgr.mr_n65963344)
print v(xbgr.mr_n65963456)
print v(xbgr.mr_n65963776)
print v(xbgr.mr_n65963888)
print v(xbgr.mr_n65964208)
print v(xbgr.mr_n65964320)
print v(xbgr.mr_n65964640)
print v(xbgr.mr_n65964752)
print v(xbgr.mr_n65965072)
print v(xbgr.mr_n65965184)
print v(xbgr.mr_n65965504)
print v(xbgr.mr_n65965616)
print v(xbgr.mr_n65965936)
print v(xbgr.mr_n65966048)
print v(xbgr.mr_n65966368)
print v(xbgr.mr_n65966480)
print v(xbgr.mr_n65966800)
print v(xbgr.mr_n65966912)
print v(xbgr.mr_n65967232)
print v(xbgr.mr_n65967344)
print v(xbgr.mr_n65967664)
print v(xbgr.mr_n65967776)
print v(xbgr.mr_n65968096)
print v(xbgr.mr_n65968208)
print v(xbgr.mr_n65968528)
print v(xbgr.mr_n65968640)
print v(xbgr.mr_n65968960)
print v(xbgr.mr_n65969072)
print v(xbgr.mr_n65969392)
print v(xbgr.mr_n65969504)
print v(xbgr.mr_n65969824)
print v(xbgr.mr_n65969936)
print v(xbgr.mr_n65970256)
print v(xbgr.mr_n65970368)
print v(xbgr.mr_n65970688)
print v(xbgr.mr_n65970800)
print v(xbgr.mr_n65971120)
print v(xbgr.mr_n65971232)
print v(xbgr.mr_n65971552)
print v(xbgr.mr_n65971664)
print v(xbgr.mr_n65971984)
print v(xbgr.mr_n65972096)
print v(xbgr.mr_n65972416)
print v(xbgr.mr_n65972528)
print v(xbgr.mr_n65972848)
print v(xbgr.mr_n65972960)
print v(xbgr.mr_n65973280)
print v(xbgr.mr_n65973392)
print v(xbgr.mr_n65973712)
print v(xbgr.mr_n65973824)
print v(xbgr.mr_n65974144)
print v(xbgr.mr_n65974256)
print v(xbgr.mr_n65974576)
print v(xbgr.mr_n65974688)
print v(xbgr.mr_n65975008)
print v(xbgr.mr_n65975120)
print v(xbgr.mr_n65975440)
print v(xbgr.mr_n65975552)
print v(xbgr.mr_n65975872)
print v(xbgr.mr_n65975984)
print v(xbgr.mr_n65976304)
print v(xbgr.mr_n65976416)
print v(xbgr.mr_n65976736)
print v(xbgr.mr_n65976848)
print v(xbgr.mr_n65977168)
print v(xbgr.mr_n65977280)
print v(xbgr.mr_n65977600)
print v(xbgr.mr_n65977712)
print v(xbgr.mr_n65978032)
print v(xbgr.mr_n65978144)
print v(xbgr.mr_n65978464)
print v(xbgr.mr_n65978576)
print v(xbgr.mr_n65978896)
print v(xbgr.mr_n65979008)
print v(xbgr.mr_n65979328)
print v(xbgr.mr_n65979440)
print v(xbgr.mr_n65979760)
print v(xbgr.mr_n65979872)
print v(xbgr.mr_n65980192)
print v(xbgr.mr_n65980304)
print v(xbgr.mr_n65980624)
print v(xbgr.mr_n65980736)
print v(xbgr.mr_n65981056)
print v(xbgr.mr_n65981168)
print v(xbgr.mr_n65981488)
print v(xbgr.mr_n65981600)
print v(xbgr.mr_n65981920)
print v(xbgr.mr_n65982032)
print v(xbgr.mr_n65982352)
print v(xbgr.mr_n65982464)
print v(xbgr.mr_n65982784)
print v(xbgr.mr_n65982896)
print v(xbgr.mr_n65983216)
print v(xbgr.mr_n65983328)
print v(xbgr.mr_n65983648)
print v(xbgr.mr_n65983760)
print v(xbgr.mr_n65984080)
print v(xbgr.mr_n65984192)
print v(xbgr.mr_n65984512)
print v(xbgr.mr_n65984624)
print v(xbgr.mr_n65984944)
print v(xbgr.mr_n65985056)
print v(xbgr.mr_n65985376)
print v(xbgr.mr_n65985488)
print v(xbgr.mr_n65985808)
print v(xbgr.mr_n65985920)
print v(xbgr.mr_n65986240)
print v(xbgr.mr_n65986352)
print v(xbgr.mr_n65986672)
print v(xbgr.mr_n65986784)
print v(xbgr.mr_n65987104)
print v(xbgr.mr_n65987216)
print v(xbgr.mr_n65987536)
print v(xbgr.mr_n65987648)
print v(xbgr.mr_n65987968)
print v(xbgr.mr_n65988080)
print v(xbgr.mr_n65988400)
print v(xbgr.mr_n65988512)
print v(xbgr.mr_n65988832)
print v(xbgr.mr_n65988944)
print v(xbgr.mr_n65989264)
print v(xbgr.mr_n65989376)
print v(xbgr.mr_n65989696)
print v(xbgr.mr_n65989808)
print v(xbgr.mr_n65990128)
print v(xbgr.mr_n65990240)
print v(xbgr.mr_n65990560)
print v(xbgr.mr_n65990672)
print v(xbgr.mr_n65990992)
print v(xbgr.mr_n65991104)
print v(xbgr.mr_n65991424)
print v(xbgr.mr_n65991536)
print v(xbgr.mr_n65991856)
print v(xbgr.mr_n65991968)
print v(xbgr.mr_n65992288)
print v(xbgr.mr_n65992400)
print v(xbgr.mr_n65992720)
print v(xbgr.mr_n65992832)
print v(xbgr.mr_n65993152)
print v(xbgr.mr_n65993264)
print v(xbgr.mr_n65993584)
print v(xbgr.mr_n65993696)
print v(xbgr.mr_n65994016)
print v(xbgr.mr_n65994128)
print v(xbgr.mr_n65994448)
print v(xbgr.mr_n65994560)
print v(xbgr.mr_n65994880)
print v(xbgr.mr_n65994992)
print v(xbgr.mr_n65995312)
print v(xbgr.mr_n65995424)
print v(xbgr.mr_n65995744)
print v(xbgr.mr_n65995856)
print v(xbgr.mr_n65996176)
print v(xbgr.mr_n65996288)
print v(xbgr.mr_n65996608)
print v(xbgr.mr_n65996720)
print v(xbgr.mr_n65997040)
print v(xbgr.mr_n65997152)
print v(xbgr.mr_n65997472)
print v(xbgr.mr_n65997584)
print v(xbgr.mr_n65997904)
print v(xbgr.mr_n65998016)
print v(xbgr.mr_n65998336)
print v(xbgr.mr_n65998448)
print v(xbgr.mr_n65998768)
print v(xbgr.mr_n65998880)
print v(xbgr.mr_n65999200)
print v(xbgr.mr_n65999312)
print v(xbgr.mr_n65999632)
print v(xbgr.mr_n65999744)
print v(xbgr.mr_n66000064)
print v(xbgr.mr_n66000176)
print v(xbgr.mr_n66000496)
print v(xbgr.mr_n66000608)
print v(xbgr.mr_n66000928)
print v(xbgr.mr_n66001040)
print v(xbgr.mr_n66001360)
print v(xbgr.mr_n66001472)
print v(xbgr.mr_n66001792)
print v(xbgr.mr_n66001904)
print v(xbgr.mr_n66002224)
print v(xbgr.mr_n66002336)
print v(xbgr.mr_n66002656)
print v(xbgr.mr_n66002768)
print v(xbgr.mr_n66003088)
print v(xbgr.mr_n66003200)
print v(xbgr.mr_n66003520)
print v(xbgr.mr_n66003632)
print v(xbgr.mr_n66003952)
print v(xbgr.mr_n66004064)
print v(xbgr.mr_n66004384)
print v(xbgr.mr_n66004496)
print v(xbgr.mr_n66004816)
print v(xbgr.mr_n66004928)
print v(xbgr.mr_n66005248)
print v(xbgr.mr_n66005360)
print v(xbgr.mr_n66005680)
print v(xbgr.mr_n66005792)
print v(xbgr.mr_n66006112)
print v(xbgr.mr_n66006224)
print v(xbgr.mr_n66006544)
print v(xbgr.mr_n66006656)
print v(xbgr.mr_n66006976)
print v(xbgr.mr_n66007088)
print v(xbgr.mr_n66007408)
print v(xbgr.mr_n66007520)
print v(xbgr.mr_n66007840)
print v(xbgr.mr_n66007952)
print v(xbgr.mr_n66008272)
print v(xbgr.mr_n66008384)
print v(xbgr.mr_n66008704)
print v(xbgr.mr_n66008816)
print v(xbgr.mr_n66009136)
print v(xbgr.mr_n66009248)
print v(xbgr.mr_n66009568)
print v(xbgr.mr_n66009680)
print v(xbgr.mr_n66010000)
print v(xbgr.mr_n66010112)
print v(xbgr.mr_n66010432)
print v(xbgr.mr_n66010544)
print v(xbgr.mr_n66010864)
print v(xbgr.mr_n66010976)
print v(xbgr.mr_n66011296)
print v(xbgr.mr_n66011408)
print v(xbgr.mr_n66011728)
print v(xbgr.mr_n66011840)
print v(xbgr.mr_n66012160)
print v(xbgr.mr_n66012272)
print v(xbgr.mr_n66012592)
print v(xbgr.mr_n66012704)
print v(xbgr.mr_n66013024)
print v(xbgr.mr_n66013136)
print v(xbgr.mr_n66013456)
print v(xbgr.mr_n66013568)
print v(xbgr.mr_n66013888)
print v(xbgr.mr_n66014000)
print v(xbgr.mr_n66014320)
print v(xbgr.mr_n66014432)
print v(xbgr.mr_n66014752)
print v(xbgr.mr_n66014864)
print v(xbgr.mr_n66015184)
print v(xbgr.mr_n66015296)
print v(xbgr.mr_n66015616)
print v(xbgr.mr_n66015728)
print v(xbgr.mr_n66016048)
print v(xbgr.mr_n66016160)
print v(xbgr.mr_n66016480)
print v(xbgr.mr_n66016592)
print v(xbgr.mr_n66016912)
print v(xbgr.mr_n66017024)
print v(xbgr.mr_n66017344)
print v(xbgr.mr_n66017456)
print v(xbgr.mr_n66017776)
print v(xbgr.mr_n66017888)
print v(xbgr.mr_n66018208)
print v(xbgr.mr_n66018320)
print v(xbgr.mr_n66018640)
print v(xbgr.mr_n66018752)
print v(xbgr.mr_n66019072)
print v(xbgr.mr_n66019184)
print v(xbgr.mr_n66019504)
print v(xbgr.mr_n66019616)
print v(xbgr.mr_n66019936)
print v(xbgr.mr_n66020048)
print v(xbgr.mr_n66020368)
print v(xbgr.mr_n66020480)
print v(xbgr.mr_n66020800)
print v(xbgr.mr_n66020912)
print v(xbgr.mr_n66021232)
print v(xbgr.mr_n66021344)
print v(xbgr.mr_n66021664)
print v(xbgr.mr_n66021776)
print v(xbgr.mr_n66022096)
print v(xbgr.mr_n66022208)
print v(xbgr.mr_n66022528)
print v(xbgr.mr_n66022640)
print v(xbgr.mr_n66022960)
print v(xbgr.mr_n66023072)
print v(xbgr.mr_n66023392)
print v(xbgr.mr_n66023504)
print v(xbgr.mr_n66023824)
print v(xbgr.mr_n66023936)
print v(xbgr.mr_n66024256)
print v(xbgr.mr_n66024368)
print v(xbgr.mr_n66024688)
print v(xbgr.mr_n66024800)
print v(xbgr.mr_n66025120)
print v(xbgr.mr_n66025232)
print v(xbgr.mr_n66025552)
print v(xbgr.mr_n66025664)
print v(xbgr.mr_n66025984)
print v(xbgr.mr_n66026096)
print v(xbgr.mr_n66026416)
print v(xbgr.mr_n66026528)
print v(xbgr.mr_n66026848)
print v(xbgr.mr_n66026960)
print v(xbgr.mr_n66027280)
print v(xbgr.mr_n66027392)
print v(xbgr.mr_n66027712)
print v(xbgr.mr_n66027824)
print v(xbgr.mr_n66028144)
print v(xbgr.mr_n66028256)
print v(xbgr.mr_n66028576)
print v(xbgr.mr_n66028688)
print v(xbgr.mr_n66029008)
print v(xbgr.mr_n66029120)
print v(xbgr.mr_n66029440)
print v(xbgr.mr_n66029552)
print v(xbgr.mr_n66029872)
print v(xbgr.mr_n66029984)
print v(xbgr.mr_n66030304)
print v(xbgr.mr_n66030416)
print v(xbgr.mr_n66030736)
print v(xbgr.mr_n66030848)
print v(xbgr.mr_n66031168)
print v(xbgr.mr_n66031280)
print v(xbgr.mr_n66031600)
print v(xbgr.mr_n66031712)
print v(xbgr.mr_n66032032)
print v(xbgr.mr_n66032144)
print v(xbgr.mr_n66032464)
print v(xbgr.mr_n66032576)
print v(xbgr.mr_n66032896)
print v(xbgr.mr_n66033008)
print v(xbgr.mr_n66033328)
print v(xbgr.mr_n66033440)
print v(xbgr.mr_n66033760)
print v(xbgr.mr_n66033872)
print v(xbgr.mr_n66034192)
print v(xbgr.mr_n66034304)
print v(xbgr.mr_n66034624)
print v(xbgr.mr_n66034736)
print v(xbgr.mr_n66035056)
print v(xbgr.mr_n66035168)
print v(xbgr.mr_n66035488)
print v(xbgr.mr_n66035600)
print v(xbgr.mr_n66035920)
print v(xbgr.mr_n66036032)
print v(xbgr.mr_n66036352)
print v(xbgr.mr_n66036464)
print v(xbgr.mr_n66036784)
print v(xbgr.mr_n66036896)
print v(xbgr.mr_n66037216)
print v(xbgr.mr_n66037328)
print v(xbgr.mr_n66037648)
print v(xbgr.mr_n66037760)
print v(xbgr.mr_n66038080)
print v(xbgr.mr_n66038192)
print v(xbgr.mr_n66038512)
print v(xbgr.mr_n66038624)
print v(xbgr.mr_n66038944)
print v(xbgr.mr_n66039056)
print v(xbgr.mr_n66039376)
print v(xbgr.mr_n66039488)
print v(xbgr.mr_n66039808)
print v(xbgr.mr_n66039920)
print v(xbgr.mr_n66040240)
print v(xbgr.mr_n66040352)
print v(xbgr.mr_n66040672)
print v(xbgr.mr_n66040784)
print v(xbgr.mr_n66041104)
print v(xbgr.mr_n66041216)
print v(xbgr.mr_n66041536)
print v(xbgr.mr_n66041648)
print v(xbgr.mr_n66041968)
print v(xbgr.mr_n66042080)
print v(xbgr.mr_n66042400)
print v(xbgr.mr_n66042512)
print v(xbgr.mr_n66042832)
print v(xbgr.mr_n66042944)
print v(xbgr.mr_n66043264)
print v(xbgr.mr_n66043376)
print v(xbgr.mr_n66043696)
print v(xbgr.mr_n66043808)
print v(xbgr.mr_n66044128)
print v(xbgr.mr_n66044240)
print v(xbgr.mr_n66044560)
print v(xbgr.mr_n66044672)
print v(xbgr.mr_n66044992)
print v(xbgr.mr_n66045104)
print v(xbgr.mr_n66045424)
print v(xbgr.mr_n66045536)
print v(xbgr.mr_n66045856)
print v(xbgr.mr_n66045968)
print v(xbgr.mr_n66046288)
print v(xbgr.mr_n66046400)
print v(xbgr.mr_n66046720)
print v(xbgr.mr_n66046832)
print v(xbgr.mr_n66047152)
print v(xbgr.mr_n66047264)
print v(xbgr.mr_n66047584)
print v(xbgr.mr_n66047696)
print v(xbgr.mr_n66048016)
print v(xbgr.mr_n66048128)
print v(xbgr.mr_n66048448)
print v(xbgr.mr_n66048560)
print v(xbgr.mr_n66048880)
print v(xbgr.mr_n66048992)
print v(xbgr.mr_n66049312)
print v(xbgr.mr_n66049424)
print v(xbgr.mr_n66049744)
print v(xbgr.mr_n66049856)
print v(xbgr.mr_n66050176)
print v(xbgr.mr_n66050288)
print v(xbgr.mr_n66050608)
print v(xbgr.mr_n66050720)
print v(xbgr.mr_n66051040)
print v(xbgr.mr_n66051152)
print v(xbgr.mr_n66051472)
print v(xbgr.mr_n66051584)
print v(xbgr.mr_n66051904)
print v(xbgr.mr_n66052016)
print v(xbgr.mr_n66052336)
print v(xbgr.mr_n66052448)
print v(xbgr.mr_n66052768)
print v(xbgr.mr_n66052880)
print v(xbgr.mr_n66053200)
print v(xbgr.mr_n66053312)
print v(xbgr.mr_n66053632)
print v(xbgr.mr_n66053744)
print v(xbgr.mr_n66054064)
print v(xbgr.mr_n66054176)
print v(xbgr.mr_n66054496)
print v(xbgr.mr_n66054608)
print v(xbgr.mr_n66054928)
print v(xbgr.mr_n66055040)
print v(xbgr.mr_n66055360)
print v(xbgr.mr_n66055472)
print v(xbgr.mr_n66055792)
print v(xbgr.mr_n66055904)
print v(xbgr.mr_n66056224)
print v(xbgr.mr_n66056336)
print v(xbgr.mr_n66056656)
print v(xbgr.mr_n66056768)
print v(xbgr.mr_n66057088)
print v(xbgr.mr_n66057200)
print v(xbgr.mr_n66057520)
print v(xbgr.mr_n66057632)
print v(xbgr.mr_n66057952)
print v(xbgr.mr_n66058064)
print v(xbgr.mr_n66058384)
print v(xbgr.mr_n66058496)
print v(xbgr.mr_n66058816)
print v(xbgr.mr_n66058928)
print v(xbgr.mr_n66059248)
print v(xbgr.mr_n66059360)
print v(xbgr.mr_n66059680)
print v(xbgr.mr_n66059792)
print v(xbgr.mr_n66060112)
print v(xbgr.mr_n66060224)
print v(xbgr.mr_n66060544)
print v(xbgr.mr_n66060656)
print v(xbgr.mr_n66060976)
print v(xbgr.mr_n66061088)
print v(xbgr.mr_n66061408)
print v(xbgr.mr_n66061520)
print v(xbgr.mr_n66061840)
print v(xbgr.mr_n66061952)
print v(xbgr.mr_n66062272)
print v(xbgr.mr_n66062384)
print v(xbgr.mr_n66062704)
print v(xbgr.mr_n66062816)
print v(xbgr.mr_n66063136)
print v(xbgr.mr_n66063248)
print v(xbgr.mr_n66063568)
print v(xbgr.mr_n66063680)
print v(xbgr.mr_n66064000)
print v(xbgr.mr_n66064112)
print v(xbgr.mr_n66064432)
print v(xbgr.mr_n66064544)
print v(xbgr.mr_n66064864)
print v(xbgr.mr_n66064976)
print v(xbgr.mr_n66065296)
print v(xbgr.mr_n66065408)
print v(xbgr.mr_n66065728)
print v(xbgr.mr_n66065840)
print v(xbgr.mr_n66066160)
print v(xbgr.mr_n66066272)
print v(xbgr.mr_n66066592)
print v(xbgr.mr_n66066704)
print v(xbgr.mr_n66067024)
print v(xbgr.mr_n66067136)
print v(xbgr.mr_n66067456)
print v(xbgr.mr_n66067568)
print v(xbgr.mr_n66067888)
print v(xbgr.mr_n66068000)
print v(xbgr.mr_n66068320)
print v(xbgr.mr_n66068432)
print v(xbgr.mr_n66068752)
print v(xbgr.mr_n66068864)
print v(xbgr.mr_n66069184)
print v(xbgr.mr_n66069296)
print v(xbgr.mr_n66069616)
print v(xbgr.mr_n66069728)
print v(xbgr.mr_n66070048)
print v(xbgr.mr_n66070160)
print v(xbgr.mr_n66070480)
print v(xbgr.mr_n66070592)
print v(xbgr.mr_n66070912)
print v(xbgr.mr_n66071024)
print v(xbgr.mr_n66071344)
print v(xbgr.mr_n66071456)
print v(xbgr.mr_n66071776)
print v(xbgr.mr_n66071888)
print v(xbgr.mr_n66072208)
print v(xbgr.mr_n66072320)
print v(xbgr.mr_n66072640)
print v(xbgr.mr_n66072752)
print v(xbgr.mr_n66073072)
print v(xbgr.mr_n66073184)
print v(xbgr.mr_n66073504)
print v(xbgr.mr_n66073616)
print v(xbgr.mr_n66073936)
print v(xbgr.mr_n66074048)
print v(xbgr.mr_n66074368)
print v(xbgr.mr_n66074480)
print v(xbgr.mr_n66074800)
print v(xbgr.mr_n66074912)
print v(xbgr.mr_n66075232)
print v(xbgr.mr_n66075344)
print v(xbgr.mr_n66075664)
print v(xbgr.mr_n66075776)
print v(xbgr.mr_n66076096)
print v(xbgr.mr_n66076208)
print v(xbgr.mr_n66076528)
print v(xbgr.mr_n66076640)
print v(xbgr.mr_n66076960)
print v(xbgr.mr_n66077072)
print v(xbgr.mr_n66077392)
print v(xbgr.mr_n66077504)
print v(xbgr.mr_n66077824)
print v(xbgr.mr_n66077936)
print v(xbgr.mr_n66078256)
print v(xbgr.mr_n66078368)
print v(xbgr.mr_n66078688)
print v(xbgr.mr_n66078800)
print v(xbgr.mr_n66079120)
print v(xbgr.mr_n66079232)
print v(xbgr.mr_n66079552)
print v(xbgr.mr_n66079664)
print v(xbgr.mr_n66079984)
print v(xbgr.mr_n66080096)
print v(xbgr.mr_n66080416)
print v(xbgr.mr_n66080528)
print v(xbgr.mr_n66080848)
print v(xbgr.mr_n66080960)
print v(xbgr.mr_n66081280)
print v(xbgr.mr_n66081392)
print v(xbgr.mr_n66081712)
print v(xbgr.mr_n66081824)
print v(xbgr.mr_n66082144)
print v(xbgr.mr_n66082256)
print v(xbgr.mr_n66082576)
print v(xbgr.mr_n66082688)
print v(xbgr.mr_n66083008)
print v(xbgr.mr_n66083120)
print v(xbgr.mr_n66083440)
print v(xbgr.mr_n66083552)
print v(xbgr.mr_n66083872)
print v(xbgr.mr_n66083984)
print v(xbgr.mr_n66084304)
print v(xbgr.mr_n66084416)
print v(xbgr.mr_n66084736)
print v(xbgr.mr_n66084848)
print v(xbgr.mr_n66085168)
print v(xbgr.mr_n66085280)
print v(xbgr.mr_n66085600)
print v(xbgr.mr_n66085712)
print v(xbgr.mr_n66086032)
print v(xbgr.mr_n66086144)
print v(xbgr.mr_n66086464)
print v(xbgr.mr_n66086576)
print v(xbgr.mr_n66086896)
print v(xbgr.mr_n66087008)
print v(xbgr.mr_n66087328)
print v(xbgr.mr_n66087440)
print v(xbgr.mr_n66087760)
print v(xbgr.mr_n66087872)
print v(xbgr.mr_n66088192)
print v(xbgr.mr_n66088304)
print v(xbgr.mr_n66088624)
print v(xbgr.mr_n66088736)
print v(xbgr.mr_n66089056)
print v(xbgr.mr_n66089168)
print v(xbgr.mr_n66089488)
print v(xbgr.mr_n66089600)
print v(xbgr.mr_n66089920)
print v(xbgr.mr_n66090032)
print v(xbgr.mr_n66090352)
print v(xbgr.mr_n66090464)
print v(xbgr.mr_n66090784)
print v(xbgr.mr_n66090896)
print v(xbgr.mr_n66091216)
print v(xbgr.mr_n66091328)
print v(xbgr.mr_n66091648)
print v(xbgr.mr_n66091760)
print v(xbgr.mr_n66092080)
print v(xbgr.mr_n66092192)
print v(xbgr.mr_n66092512)
print v(xbgr.mr_n66092624)
print v(xbgr.mr_n66092944)
print v(xbgr.mr_n66093056)
print v(xbgr.mr_n66093376)
print v(xbgr.mr_n66093488)
print v(xbgr.mr_n66093808)
print v(xbgr.mr_n66093920)
print v(xbgr.mr_n66094240)
print v(xbgr.mr_n66094352)
print v(xbgr.mr_n66094672)
print v(xbgr.mr_n66094784)
print v(xbgr.mr_n66095104)
print v(xbgr.mr_n66095216)
print v(xbgr.mr_n66095536)
print v(xbgr.mr_n66095648)
print v(xbgr.mr_n66095968)
print v(xbgr.mr_n66096080)
print v(xbgr.mr_n66096400)
print v(xbgr.mr_n66096512)
print v(xbgr.mr_n66096832)
print v(xbgr.mr_n66096944)
print v(xbgr.mr_n66097264)
print v(xbgr.mr_n66097376)
print v(xbgr.mr_n66097696)
print v(xbgr.mr_n66097808)
print v(xbgr.mr_n66098128)
print v(xbgr.mr_n66098240)
print v(xbgr.mr_n66098560)
print v(xbgr.mr_n66098672)
print v(xbgr.mr_n66099104)
print v(xbgr.mr_n66099424)
print v(xbgr.mr_n66099536)
print v(xbgr.mr_n66099856)
print v(xbgr.mr_n66099968)
print v(xbgr.mr_n66100288)
print v(xbgr.mr_n66100400)
print v(xbgr.mr_n66100720)
print v(xbgr.mr_n66100832)
print v(xbgr.mr_n66101152)
print v(xbgr.mr_n66101264)
print v(xbgr.mr_n66101584)
print v(xbgr.mr_n66101696)
print v(xbgr.mr_n66102016)
print v(xbgr.mr_n66102128)
print v(xbgr.mr_n66102448)
print v(xbgr.mr_n66102560)
print v(xbgr.mr_n66102880)
print v(xbgr.mr_n66102992)
print v(xbgr.mr_n66103312)
print v(xbgr.mr_n66103424)
print v(xbgr.mr_n66103744)
print v(xbgr.mr_n66103856)
print v(xbgr.mr_n66104176)
print v(xbgr.mr_n66104288)
print v(xbgr.mr_n66104608)
print v(xbgr.mr_n66104720)
print v(xbgr.mr_n66105152)
print v(xbgr.mr_n66105472)
print v(xbgr.mr_n66105584)
print v(xbgr.mr_n66105904)
print v(xbgr.mr_n66106016)
print v(xbgr.mr_n66106336)
print v(xbgr.mr_n66106448)
print v(xbgr.mr_n66106768)
print v(xbgr.mr_n66106880)
print v(xbgr.mr_n66107200)
print v(xbgr.mr_n66107312)
print v(xbgr.mr_n66107632)
print v(xbgr.mr_n66107744)
print v(xbgr.mr_n66108064)
print v(xbgr.mr_n66108176)
print v(xbgr.mr_n66108496)
print v(xbgr.mr_n66108608)
print v(xbgr.mr_n66108928)
print v(xbgr.mr_n66109040)
print v(xbgr.mr_n66109360)
print v(xbgr.mr_n66109472)
print v(xbgr.mr_n66109792)
print v(xbgr.mr_n66109904)
print v(xbgr.mr_n66110224)
print v(xbgr.mr_n66110336)
print v(xbgr.mr_n66110656)
print v(xbgr.mr_n66110768)
print v(xbgr.mr_n66111088)
print v(xbgr.mr_n66111200)
print v(xbgr.mr_n66111520)
print v(xbgr.mr_n66111632)
print v(xbgr.mr_n66111952)
print v(xbgr.mr_n66112064)
print v(xbgr.mr_n66112384)
print v(xbgr.mr_n66112496)
print v(xbgr.mr_n66112816)
print v(xbgr.mr_n66112928)
print v(xbgr.mr_n66113248)
print v(xbgr.mr_n66113360)
print v(xbgr.mr_n66113680)
print v(xbgr.mr_n66113792)
print v(xbgr.mr_n66114112)
print v(xbgr.mr_n66114224)
print v(xbgr.mr_n66114544)
print v(xbgr.mr_n66114656)
print v(xbgr.mr_n66114976)
print v(xbgr.mr_n66115088)
print v(xbgr.mr_n66115408)
print v(xbgr.mr_n66115520)
print v(xbgr.mr_n66115840)
print v(xbgr.mr_n66115952)
print v(xbgr.mr_n66116272)
print v(xbgr.mr_n66116384)
print v(xbgr.mr_n66116704)
print v(xbgr.mr_n66116816)
print v(xbgr.mr_n66117136)
print v(xbgr.mr_n66117248)
print v(xbgr.mr_n66117568)
print v(xbgr.mr_n66117680)
print v(xbgr.mr_n66118000)
print v(xbgr.mr_n66118112)
print v(xbgr.mr_n66118432)
print v(xbgr.mr_n66118544)
print v(xbgr.mr_n66118864)
print v(xbgr.mr_n66118976)
print v(xbgr.mr_n66119296)
print v(xbgr.mr_n66119408)
print v(xbgr.mr_n66119728)
print v(xbgr.mr_n66119840)
print v(xbgr.mr_n66120160)
print v(xbgr.mr_n66120272)
print v(xbgr.mr_n66120592)
print v(xbgr.mr_n66120704)
print v(xbgr.mr_n66121024)
print v(xbgr.mr_n66121136)
print v(xbgr.mr_n66121456)
print v(xbgr.mr_n66121568)
print v(xbgr.mr_n66121888)
print v(xbgr.mr_n66122000)
print v(xbgr.mr_n66122320)
print v(xbgr.mr_n66122432)
print v(xbgr.mr_n66122752)
print v(xbgr.mr_n66122864)
print v(xbgr.mr_n66123184)
print v(xbgr.mr_n66123296)
print v(xbgr.mr_n66123616)
print v(xbgr.mr_n66123728)
print v(xbgr.mr_n66124048)
print v(xbgr.mr_n66124160)
print v(xbgr.mr_n66124480)
print v(xbgr.mr_n66124592)
print v(xbgr.mr_n66124912)
print v(xbgr.mr_n66125024)
print v(xbgr.mr_n66125344)
print v(xbgr.mr_n66125456)
print v(xbgr.mr_n66125776)
print v(xbgr.mr_n66125888)
print v(xbgr.mr_n66126208)
print v(xbgr.mr_n66126320)
print v(xbgr.mr_n66126640)
print v(xbgr.mr_n66126752)
print v(xbgr.mr_n66127072)
print v(xbgr.mr_n66127184)
print v(xbgr.mr_n66127504)
print v(xbgr.mr_n66127616)
print v(xbgr.mr_n66127936)
print v(xbgr.mr_n66128048)
print v(xbgr.mr_n66128368)
print v(xbgr.mr_n66128480)
print v(xbgr.mr_n66128800)
print v(xbgr.mr_n66128912)
print v(xbgr.mr_n66129232)
print v(xbgr.mr_n66129344)
print v(xbgr.mr_n66129664)
print v(xbgr.mr_n66129776)
print v(xbgr.mr_n66130096)
print v(xbgr.mr_n66130208)
print v(xbgr.mr_n66130528)
print v(xbgr.mr_n66130640)
print v(xbgr.mr_n66130960)
print v(xbgr.mr_n66131072)
print v(xbgr.mr_n66131392)
print v(xbgr.mr_n66131504)
print v(xbgr.mr_n66131824)
print v(xbgr.mr_n66131936)
print v(xbgr.mr_n66132256)
print v(xbgr.mr_n66132368)
print v(xbgr.mr_n66132688)
print v(xbgr.mr_n66132800)
print v(xbgr.mr_n66133120)
print v(xbgr.mr_n66133232)
print v(xbgr.mr_n66133552)
print v(xbgr.mr_n66133664)
print v(xbgr.mr_n66133984)
print v(xbgr.mr_n66134096)
print v(xbgr.mr_n66134416)
print v(xbgr.mr_n66134528)
print v(xbgr.mr_n66134848)
print v(xbgr.mr_n66134960)
print v(xbgr.mr_n66135280)
print v(xbgr.mr_n66135392)
print v(xbgr.mr_n66135712)
print v(xbgr.mr_n66135824)
print v(xbgr.mr_n66136144)
print v(xbgr.mr_n66136256)
print v(xbgr.mr_n66136576)
print v(xbgr.mr_n66136688)
print v(xbgr.mr_n66137008)
print v(xbgr.mr_n66137120)
print v(xbgr.mr_n66137440)
print v(xbgr.mr_n66137552)
print v(xbgr.mr_n66137984)
print v(xbgr.mr_n66138304)
print v(xbgr.mr_n66138416)
print v(xbgr.mr_n66138736)
print v(xbgr.mr_n66138848)
print v(xbgr.mr_n66139168)
print v(xbgr.mr_n66139280)
print v(xbgr.mr_n66139712)
print v(xbgr.mr_n66140032)
print v(xbgr.mr_n66140144)
print v(xbgr.mr_n66140464)
print v(xbgr.mr_n66140576)
print v(xbgr.mr_n66140896)
print v(xbgr.mr_n66141008)
print v(xbgr.mr_n66141440)
print v(xbgr.mr_n66141760)
print v(xbgr.mr_n66141872)
print v(xbgr.mr_n66142192)
print v(xbgr.mr_n66142304)
print v(xbgr.mr_n66142624)
print v(xbgr.mr_n66142736)
print v(xbgr.mr_n66143056)
print v(xbgr.mr_n66143168)
print v(xbgr.mr_n66143488)
print v(xbgr.mr_n66143600)
print v(xbgr.mr_n66143920)
print v(xbgr.mr_n66144032)
print v(xbgr.mr_n66144352)
print v(xbgr.mr_n66144464)
print v(xbgr.mr_n66144784)
print v(xbgr.mr_n66144896)
print v(xbgr.mr_n66145216)
print v(xbgr.mr_n66145328)
print v(xbgr.mr_n66145648)
print v(xbgr.mr_n66145760)
print v(xbgr.mr_n66146080)
print v(xbgr.mr_n66146192)
print v(xbgr.mr_n66146512)
print v(xbgr.mr_n66146624)
print v(xbgr.mr_n66146944)
print v(xbgr.mr_n66147056)
print v(xbgr.mr_n66147376)
print v(xbgr.mr_n66147488)
print v(xbgr.mr_n66147808)
print v(xbgr.mr_n66147920)
print v(xbgr.mr_n66148240)
print v(xbgr.mr_n66148352)
print v(xbgr.mr_n66148672)
print v(xbgr.mr_n66148784)
print v(xbgr.mr_n66149104)
print v(xbgr.mr_n66149216)
print v(xbgr.mr_n66149536)
print v(xbgr.mr_n66149648)
print v(xbgr.mr_n66149968)
print v(xbgr.mr_n66150080)
print v(xbgr.mr_n66150400)
print v(xbgr.mr_n66150512)
print v(xbgr.mr_n66150832)
print v(xbgr.mr_n66150944)
print v(xbgr.mr_n66151264)
print v(xbgr.mr_n66151376)
print v(xbgr.mr_n66151696)
print v(xbgr.mr_n66151808)
print v(xbgr.mr_n66152128)
print v(xbgr.mr_n66152240)
print v(xbgr.mr_n66152560)
print v(xbgr.mr_n66152672)
print v(xbgr.mr_n66152992)
print v(xbgr.mr_n66153104)
print v(xbgr.mr_n66153424)
print v(xbgr.mr_n66153536)
print v(xbgr.mr_n66153856)
print v(xbgr.mr_n66153968)
print v(xbgr.mr_n66154288)
print v(xbgr.mr_n66154400)
print v(xbgr.mr_n66154720)
print v(xbgr.mr_n66154832)
print v(xbgr.mr_n66155152)
print v(xbgr.mr_n66155264)
print v(xbgr.mr_n66155584)
print v(xbgr.mr_n66155696)
print v(xbgr.mr_n66156016)
print v(xbgr.mr_n66156128)
print v(xbgr.mr_n66156448)
print v(xbgr.mr_n66156560)
print v(xbgr.mr_n66156880)
print v(xbgr.mr_n66156992)
print v(xbgr.mr_n66157312)
print v(xbgr.mr_n66157424)
print v(xbgr.mr_n66157744)
print v(xbgr.mr_n66157856)
print v(xbgr.mr_n66158176)
print v(xbgr.mr_n66158288)
print v(xbgr.mr_n66158608)
print v(xbgr.mr_n66158720)
print v(xbgr.mr_n66159040)
print v(xbgr.mr_n66159152)
print v(xbgr.mr_n66159472)
print v(xbgr.mr_n66159584)
print v(xbgr.mr_n66159904)
print v(xbgr.mr_n66160016)
print v(xbgr.mr_n66160336)
print v(xbgr.mr_n66160448)
print v(xbgr.mr_n66160768)
print v(xbgr.mr_n66160880)
print v(xbgr.mr_n66161200)
print v(xbgr.mr_n66161312)
print v(xbgr.mr_n66161744)
print v(xbgr.mr_n66162176)
print v(xbgr.mr_n66162608)
print v(xbgr.mr_n66163040)
print v(xbgr.mr_n66163472)
print v(xbgr.mr_n66163904)
print v(xbgr.mr_n66164336)
print v(xbgr.mr_n66164768)
print v(xbgr.mr_n66165200)
print v(xbgr.mr_n66165632)
print v(xbgr.mr_n66166064)
print v(xbgr.mr_n66166496)
print v(xbgr.mr_n66166928)
print v(xbgr.mr_n66167360)
print v(xbgr.mr_n66167792)
print v(xbgr.mr_n66168224)
print v(xbgr.mr_n66168656)
print v(xbgr.mr_n66169088)
print v(xbgr.mr_n66169520)
print v(xbgr.mr_n66169952)
print v(xbgr.mr_n66170384)
print v(xbgr.mr_n66170816)
print v(xbgr.mr_n66171248)
print v(xbgr.mr_n66171680)
print v(xbgr.mr_n66172112)
print v(xbgr.mr_n66172544)
print v(xbgr.mr_n66172976)
print v(xbgr.mr_n66173408)
print v(xbgr.mr_n66173840)
print v(xbgr.mr_n66174272)
print v(xbgr.mr_n66174704)
print v(xbgr.mr_n66175136)
print v(xbgr.mr_n66175568)
print v(xbgr.mr_n66176000)
print v(xbgr.mr_n66176432)
print v(xbgr.mr_n66176864)
print v(xbgr.mr_n66177296)
print v(xbgr.mr_n66177728)
print v(xbgr.mr_n66178160)
print v(xbgr.mr_n66178592)
print v(xbgr.mr_n66179024)
print v(xbgr.mr_n66179456)
print v(xbgr.mr_n66179888)
print v(xbgr.mr_n66180320)
print v(xbgr.mr_n66180752)
print v(xbgr.mr_n66181184)
print v(xbgr.mr_n66181616)
print v(xbgr.mr_n66182048)
print v(xbgr.mr_n66182480)
print v(xbgr.mr_n66182912)
print v(xbgr.mr_n66183344)
print v(xbgr.mr_n66183776)
print v(xbgr.mr_n66184208)
print v(xbgr.mr_n66184640)
print v(xbgr.mr_n66185072)
print v(xbgr.mr_n66185504)
print v(xbgr.mr_n66185936)
print v(xbgr.mr_n66186368)
print v(xbgr.mr_n66186800)
print v(xbgr.mr_n66187232)
print v(xbgr.mr_n66187664)
print v(xbgr.mr_n66188096)
print v(xbgr.mr_n66188528)
print v(xbgr.mr_n66188960)
print v(xbgr.mr_n66189392)
print v(xbgr.mr_n66189824)
print v(xbgr.mr_n66190256)
print v(xbgr.mr_n66190688)
print v(xbgr.mr_n66191120)
print v(xbgr.mr_n66191552)
print v(xbgr.mr_n66191984)
print v(xbgr.mr_n66192416)
print v(xbgr.mr_n66192848)
print v(xbgr.mr_n66193280)
print v(xbgr.mr_n66193712)
print v(xbgr.mr_n66194144)
print v(xbgr.mr_n66194576)
print v(xbgr.mr_n66195008)
print v(xbgr.mr_n66195440)
print v(xbgr.mr_n66195872)
print v(xbgr.mr_n66196192)
print v(xbgr.mr_n66196304)
print v(xbgr.mr_n66196736)
print v(xbgr.mr_n66197056)
print v(xbgr.mr_n66197168)
print v(xbgr.mr_n66197488)
print v(xbgr.mr_n66197600)
print v(xbgr.mr_n66197920)
print v(xbgr.mr_n66198032)
print v(xbgr.mr_n66198352)
print v(xbgr.mr_n66198464)
print v(xbgr.mr_n66198784)
print v(xbgr.mr_n66198896)
print v(xbgr.mr_n66199216)
print v(xbgr.mr_n66199328)
print v(xbgr.mr_n66199648)
print v(xbgr.mr_n66199760)
print v(xbgr.mr_n66200080)
print v(xbgr.mr_n66200192)
print v(xbgr.mr_n66200512)
print v(xbgr.mr_n66200624)
print v(xbgr.mr_n66200944)
print v(xbgr.mr_n66201056)
print v(xbgr.mr_n66201488)
print v(xbgr.mr_n66201920)
print v(xbgr.mr_n66202352)
print v(xbgr.mr_n66202784)
print v(xbgr.mr_n66203216)
print v(xbgr.mr_n66203648)
print v(xbgr.mr_n66204080)
print v(xbgr.mr_n66204512)
print v(xbgr.mr_n66204944)
print v(xbgr.mr_n66205376)
print v(xbgr.mr_n66205808)
print v(xbgr.mr_n66206240)
print v(xbgr.mr_n66206672)
print v(xbgr.mr_n66207104)
print v(xbgr.mr_n66207536)
print v(xbgr.mr_n66207968)
print v(xbgr.mr_n66208400)
print v(xbgr.mr_n66208832)
print v(xbgr.mr_n66209264)
print v(xbgr.mr_n66209696)
print v(xbgr.mr_n66210128)
print v(xbgr.mr_n66210560)
print v(xbgr.mr_n66210992)
print v(xbgr.mr_n66211424)
print v(xbgr.mr_n66211856)
print v(xbgr.mr_n66212288)
print v(xbgr.mr_n66212720)
print v(xbgr.mr_n66212992)
print v(xbgr.mr_n66213104)
print v(xbgr.mr_n66213424)
print v(xbgr.mr_n66213536)
print v(xbgr.mr_n66213856)
print v(xbgr.mr_n66213968)
print v(xbgr.mr_n66214288)
print v(xbgr.mr_n66214400)
print v(xbgr.mr_n66214720)
print v(xbgr.mr_n66214832)
print v(xbgr.mr_n66215152)
print v(xbgr.mr_n66215264)
print v(xbgr.mr_n66215584)
print v(xbgr.mr_n66215696)
print v(xbgr.mr_n66216016)
print v(xbgr.mr_n66216128)
print v(xbgr.mr_n66216448)
print v(xbgr.mr_n66216560)
print v(xbgr.mr_n66216880)
print v(xbgr.mr_n66216992)
print v(xbgr.mr_n66217312)
print v(xbgr.mr_n66217424)
print v(xbgr.mr_n66217744)
print v(xbgr.mr_n66217856)
print v(xbgr.mr_n66218176)
print v(xbgr.mr_n66218288)
print v(xbgr.mr_n66218608)
print v(xbgr.mr_n66218720)
print v(xbgr.mr_n66219040)
print v(xbgr.mr_n66219152)
print v(xbgr.mr_n66219472)
print v(xbgr.mr_n66219584)
print v(xbgr.mr_n66219904)
print v(xbgr.mr_n66220016)
print v(xbgr.mr_n66220336)
print v(xbgr.mr_n66220448)
print v(xbgr.mr_n66220768)
print v(xbgr.mr_n66220880)
print v(xbgr.mr_n66221200)
print v(xbgr.mr_n66221312)
print v(xbgr.mr_n66221632)
print v(xbgr.mr_n66221744)
print v(xbgr.mr_n66222064)
print v(xbgr.mr_n66222176)
print v(xbgr.mr_n66222496)
print v(xbgr.mr_n66222608)
print v(xbgr.mr_n66222928)
print v(xbgr.mr_n66223040)
print v(xbgr.mr_n66223360)
print v(xbgr.mr_n66223472)
print v(xbgr.mr_n66223792)
print v(xbgr.mr_n66223904)
print v(xbgr.mr_n66224224)
print v(xbgr.mr_n66224336)
print v(xbgr.mr_n66224656)
print v(xbgr.mr_n66224768)
print v(xbgr.mr_n66225088)
print v(xbgr.mr_n66225200)
print v(xbgr.mr_n66225520)
print v(xbgr.mr_n66225632)
print v(xbgr.mr_n66225952)
print v(xbgr.mr_n66226064)
print v(xbgr.mr_n66226384)
print v(xbgr.mr_n66226496)
print v(xbgr.mr_n66226816)
print v(xbgr.mr_n66226928)
print v(xbgr.mr_n66227248)
print v(xbgr.mr_n66227360)
print v(xbgr.mr_n66227680)
print v(xbgr.mr_n66227792)
print v(xbgr.mr_n66228112)
print v(xbgr.mr_n66228224)
print v(xbgr.mr_n66228544)
print v(xbgr.mr_n66228656)
print v(xbgr.mr_n66228976)
print v(xbgr.mr_n66229088)
print v(xbgr.mr_n66229408)
print v(xbgr.mr_n66229520)
print v(xbgr.mr_n66229840)
print v(xbgr.mr_n66229952)
print v(xbgr.mr_n66230272)
print v(xbgr.mr_n66230384)
print v(xbgr.mr_n66230704)
print v(xbgr.mr_n66230816)
print v(xbgr.mr_n66231136)
print v(xbgr.mr_n66231248)
print v(xbgr.mr_n66231568)
print v(xbgr.mr_n66231680)
print v(xbgr.mr_n66232000)
print v(xbgr.mr_n66232112)
print v(xbgr.mr_n66232432)
print v(xbgr.mr_n66232544)
print v(xbgr.mr_n66232864)
print v(xbgr.mr_n66232976)
print v(xbgr.mr_n66233296)
print v(xbgr.mr_n66233408)
print v(xbgr.mr_n66233728)
print v(xbgr.mr_n66233840)
print v(xbgr.mr_n66234160)
print v(xbgr.mr_n66234272)
print v(xbgr.mr_n66234592)
print v(xbgr.mr_n66234704)
print v(xbgr.mr_n66235024)
print v(xbgr.mr_n66235136)
print v(xbgr.mr_n66235456)
print v(xbgr.mr_n66235568)
print v(xbgr.mr_n66235888)
print v(xbgr.mr_n66236000)
print v(xbgr.mr_n66236320)
print v(xbgr.mr_n66236432)
print v(xbgr.mr_n66236752)
print v(xbgr.mr_n66236864)
print v(xbgr.mr_n66237184)
print v(xbgr.mr_n66237296)
print v(xbgr.mr_n66237616)
print v(xbgr.mr_n66237728)
print v(xbgr.mr_n66238048)
print v(xbgr.mr_n66238160)
print v(xbgr.mr_n66238480)
print v(xbgr.mr_n66238592)
print v(xbgr.mr_n66238912)
print v(xbgr.mr_n66239024)
print v(xbgr.mr_n66239344)
print v(xbgr.mr_n66239456)
print v(xbgr.mr_n66239776)
print v(xbgr.mr_n66239888)
print v(xbgr.mr_n66240208)
print v(xbgr.mr_n66240320)
print v(xbgr.mr_n66240640)
print v(xbgr.mr_n66240752)
print v(xbgr.mr_n66241072)
print v(xbgr.mr_n66241184)
print v(xbgr.mr_n66241504)
print v(xbgr.mr_n66241616)
print v(xbgr.mr_n66241936)
print v(xbgr.mr_n66242048)
print v(xbgr.mr_n66242368)
print v(xbgr.mr_n66242480)
print v(xbgr.mr_n66242800)
print v(xbgr.mr_n66242912)
print v(xbgr.mr_n66243232)
print v(xbgr.mr_n66243344)
print v(xbgr.mr_n66243664)
print v(xbgr.mr_n66243776)
print v(xbgr.mr_n66244096)
print v(xbgr.mr_n66244208)
print v(xbgr.mr_n66244528)
print v(xbgr.mr_n66244640)
print v(xbgr.mr_n66244960)
print v(xbgr.mr_n66245072)
print v(xbgr.mr_n66245392)
print v(xbgr.mr_n66245504)
print v(xbgr.mr_n66245824)
print v(xbgr.mr_n66245936)
print v(xbgr.mr_n66246256)
print v(xbgr.mr_n66246368)
print v(xbgr.mr_n66246688)
print v(xbgr.mr_n66246800)
print v(xbgr.mr_n66247120)
print v(xbgr.mr_n66247232)
print v(xbgr.mr_n66247552)
print v(xbgr.mr_n66247664)
print v(xbgr.mr_n66247984)
print v(xbgr.mr_n66248096)
print v(xbgr.mr_n66248416)
print v(xbgr.mr_n66248528)
print v(xbgr.mr_n66248848)
print v(xbgr.mr_n66248960)
print v(xbgr.mr_n66249280)
print v(xbgr.mr_n66249392)
print v(xbgr.mr_n66249712)
print v(xbgr.mr_n66249824)
print v(xbgr.mr_n66250144)
print v(xbgr.mr_n66250256)
print v(xbgr.mr_n66250576)
print v(xbgr.mr_n66250688)
print v(xbgr.mr_n66251008)
print v(xbgr.mr_n66251120)
print v(xbgr.mr_n66251440)
print v(xbgr.mr_n66251552)
print v(xbgr.mr_n66251872)
print v(xbgr.mr_n66251984)
print v(xbgr.mr_n66252304)
print v(xbgr.mr_n66252416)
print v(xbgr.mr_n66252736)
print v(xbgr.mr_n66252848)
print v(xbgr.mr_n66253168)
print v(xbgr.mr_n66253280)
print v(xbgr.mr_n66253600)
print v(xbgr.mr_n66253712)
print v(xbgr.mr_n66254032)
print v(xbgr.mr_n66254144)
print v(xbgr.mr_n66254464)
print v(xbgr.mr_n66254576)
print v(xbgr.mr_n66254896)
print v(xbgr.mr_n66255008)
print v(xbgr.mr_n66255328)
print v(xbgr.mr_n66255440)
print v(xbgr.mr_n66255760)
print v(xbgr.mr_n66255872)
print v(xbgr.mr_n66256192)
print v(xbgr.mr_n66256304)
print v(xbgr.mr_n66256624)
print v(xbgr.mr_n66256736)
print v(xbgr.mr_n66257056)
print v(xbgr.mr_n66257168)
print v(xbgr.mr_n66257488)
print v(xbgr.mr_n66257600)
print v(xbgr.mr_n66257920)
print v(xbgr.mr_n66258032)
print v(xbgr.mr_n66258352)
print v(xbgr.mr_n66258464)
print v(xbgr.mr_n66258784)
print v(xbgr.mr_n66258896)
print v(xbgr.mr_n66259216)
print v(xbgr.mr_n66259328)
print v(xbgr.mr_n66259648)
print v(xbgr.mr_n66259760)
print v(xbgr.mr_n66260080)
print v(xbgr.mr_n66260192)
print v(xbgr.mr_n66260512)
print v(xbgr.mr_n66260624)
print v(xbgr.mr_n66260944)
print v(xbgr.mr_n66261056)
print v(xbgr.mr_n66261376)
print v(xbgr.mr_n66261488)
print v(xbgr.mr_n66261808)
print v(xbgr.mr_n66261920)
print v(xbgr.mr_n66262240)
print v(xbgr.mr_n66262352)
print v(xbgr.mr_n66262672)
print v(xbgr.mr_n66262784)
print v(xbgr.mr_n66263104)
print v(xbgr.mr_n66263216)
print v(xbgr.mr_n66263536)
print v(xbgr.mr_n66263648)
print v(xbgr.mr_n66263968)
print v(xbgr.mr_n66264080)
print v(xbgr.mr_n66264400)
print v(xbgr.mr_n66264512)
print v(xbgr.mr_n66264832)
print v(xbgr.mr_n66264944)
print v(xbgr.mr_n66265264)
print v(xbgr.mr_n66265376)
print v(xbgr.mr_n66265696)
print v(xbgr.mr_n66265808)
print v(xbgr.mr_n66266128)
print v(xbgr.mr_n66266240)
print v(xbgr.mr_n66266560)
print v(xbgr.mr_n66266672)
print v(xbgr.mr_n66266992)
print v(xbgr.mr_n66267104)
print v(xbgr.mr_n66267424)
print v(xbgr.mr_n66267536)
print v(xbgr.mr_n66267856)
print v(xbgr.mr_n66267968)
print v(xbgr.mr_n66268288)
print v(xbgr.mr_n66268400)
print v(xbgr.mr_n66268720)
print v(xbgr.mr_n66268832)
print v(xbgr.mr_n66269152)
print v(xbgr.mr_n66269264)
print v(xbgr.mr_n66269584)
print v(xbgr.mr_n66269696)
print v(xbgr.mr_n66270016)
print v(xbgr.mr_n66270128)
print v(xbgr.mr_n66270448)
print v(xbgr.mr_n66270560)
print v(xbgr.mr_n66270880)
print v(xbgr.mr_n66270992)
print v(xbgr.mr_n66271312)
print v(xbgr.mr_n66271424)
print v(xbgr.mr_n66271744)
print v(xbgr.mr_n66271856)
print v(xbgr.mr_n66272176)
print v(xbgr.mr_n66272288)
print v(xbgr.mr_n66272608)
print v(xbgr.mr_n66272720)
print v(xbgr.mr_n66273040)
print v(xbgr.mr_n66273152)
print v(xbgr.mr_n66273472)
print v(xbgr.mr_n66273584)
print v(xbgr.mr_n66273904)
print v(xbgr.mr_n66274016)
print v(xbgr.mr_n66274336)
print v(xbgr.mr_n66274448)
print v(xbgr.mr_n66274768)
print v(xbgr.mr_n66274880)
print v(xbgr.mr_n66275200)
print v(xbgr.mr_n66275312)
print v(xbgr.mr_n66275632)
print v(xbgr.mr_n66275744)
print v(xbgr.mr_n66276064)
print v(xbgr.mr_n66276176)
print v(xbgr.mr_n66276496)
print v(xbgr.mr_n66276608)
print v(xbgr.mr_n66276928)
print v(xbgr.mr_n66277040)
print v(xbgr.mr_n66277360)
print v(xbgr.mr_n66277472)
print v(xbgr.mr_n66277792)
print v(xbgr.mr_n66277904)
print v(xbgr.mr_n66278224)
print v(xbgr.mr_n66278336)
print v(xbgr.mr_n66278656)
print v(xbgr.mr_n66278768)
print v(xbgr.mr_n66279088)
print v(xbgr.mr_n66279200)
print v(xbgr.mr_n66279520)
print v(xbgr.mr_n66279632)
print v(xbgr.mr_n66279952)
print v(xbgr.mr_n66280064)
print v(xbgr.mr_n66280384)
print v(xbgr.mr_n66280496)
print v(xbgr.mr_n66280816)
print v(xbgr.mr_n66280928)
print v(xbgr.mr_n66281248)
print v(xbgr.mr_n66281360)
print v(xbgr.mr_n66281680)
print v(xbgr.mr_n66281792)
print v(xbgr.mr_n66282112)
print v(xbgr.mr_n66282224)
print v(xbgr.mr_n66282544)
print v(xbgr.mr_n66282656)
print v(xbgr.mr_n66282976)
print v(xbgr.mr_n66283088)
print v(xbgr.mr_n66283408)
print v(xbgr.mr_n66283520)
print v(xbgr.mr_n66283840)
print v(xbgr.mr_n66283952)
print v(xbgr.mr_n66284272)
print v(xbgr.mr_n66284384)
print v(xbgr.mr_n66284704)
print v(xbgr.mr_n66284816)
print v(xbgr.mr_n66285136)
print v(xbgr.mr_n66285248)
print v(xbgr.mr_n66285568)
print v(xbgr.mr_n66285680)
print v(xbgr.mr_n66286000)
print v(xbgr.mr_n66286112)
print v(xbgr.mr_n66286432)
print v(xbgr.mr_n66286544)
print v(xbgr.mr_n66286864)
print v(xbgr.mr_n66286976)
print v(xbgr.mr_n66287296)
print v(xbgr.mr_n66287408)
print v(xbgr.mr_n66287728)
print v(xbgr.mr_n66287840)
print v(xbgr.mr_n66288160)
print v(xbgr.mr_n66288272)
print v(xbgr.mr_n66288592)
print v(xbgr.mr_n66288704)
print v(xbgr.mr_n66289024)
print v(xbgr.mr_n66289136)
print v(xbgr.mr_n66289456)
print v(xbgr.mr_n66289568)
print v(xbgr.mr_n66289888)
print v(xbgr.mr_n66290000)
print v(xbgr.mr_n66290320)
print v(xbgr.mr_n66290432)
print v(xbgr.mr_n66290752)
print v(xbgr.mr_n66290864)
print v(xbgr.mr_n66291184)
print v(xbgr.mr_n66291296)
print v(xbgr.mr_n66291616)
print v(xbgr.mr_n66291728)
print v(xbgr.mr_n66292048)
print v(xbgr.mr_n66292160)
print v(xbgr.mr_n66292480)
print v(xbgr.mr_n66292592)
print v(xbgr.mr_n66292912)
print v(xbgr.mr_n66293024)
print v(xbgr.mr_n66293344)
print v(xbgr.mr_n66293456)
print v(xbgr.mr_n66293776)
print v(xbgr.mr_n66293888)
print v(xbgr.mr_n66294208)
print v(xbgr.mr_n66294320)
print v(xbgr.mr_n66294640)
print v(xbgr.mr_n66294752)
print v(xbgr.mr_n66295072)
print v(xbgr.mr_n66295184)
print v(xbgr.mr_n66295504)
print v(xbgr.mr_n66295616)
print v(xbgr.mr_n66295936)
print v(xbgr.mr_n66296048)
print v(xbgr.mr_n66296368)
print v(xbgr.mr_n66296480)
print v(xbgr.mr_n66296800)
print v(xbgr.mr_n66296912)
print v(xbgr.mr_n66297232)
print v(xbgr.mr_n66297344)
print v(xbgr.mr_n66297776)
print v(xbgr.mr_n66298096)
print v(xbgr.mr_n66298208)
print v(xbgr.mr_n66298528)
print v(xbgr.mr_n66298640)
print v(xbgr.mr_n66298960)
print v(xbgr.mr_n66299072)
print v(xbgr.mr_n66299504)
print v(xbgr.mr_n66299824)
print v(xbgr.mr_n66299936)
print v(xbgr.mr_n66300256)
print v(xbgr.mr_n66300368)
print v(xbgr.mr_n66300688)
print v(xbgr.mr_n66300800)
print v(xbgr.mr_n66301232)
print v(xbgr.mr_n66301552)
print v(xbgr.mr_n66301664)
print v(xbgr.mr_n66301984)
print v(xbgr.mr_n66302096)
print v(xbgr.mr_n66302416)
print v(xbgr.mr_n66302528)
print v(xbgr.mr_n66302960)
print v(xbgr.mr_n66303280)
print v(xbgr.mr_n66303392)
print v(xbgr.mr_n66303712)
print v(xbgr.mr_n66303824)
print v(xbgr.mr_n66304144)
print v(xbgr.mr_n66304256)
print v(xbgr.mr_n66304688)
print v(xbgr.mr_n66305008)
print v(xbgr.mr_n66305120)
print v(xbgr.mr_n66305440)
print v(xbgr.mr_n66305552)
print v(xbgr.mr_n66305872)
print v(xbgr.mr_n66305984)
print v(xbgr.mr_n66306416)
print v(xbgr.mr_n66306736)
print v(xbgr.mr_n66306848)
print v(xbgr.mr_n66307168)
print v(xbgr.mr_n66307280)
print v(xbgr.mr_n66307600)
print v(xbgr.mr_n66307712)
print v(xbgr.mr_n66308144)
print v(xbgr.mr_n66308464)
print v(xbgr.mr_n66308576)
print v(xbgr.mr_n66308896)
print v(xbgr.mr_n66309008)
print v(xbgr.mr_n66309328)
print v(xbgr.mr_n66309440)
print v(xbgr.mr_n66309872)
print v(xbgr.mr_n66310192)
print v(xbgr.mr_n66310304)
print v(xbgr.mr_n66310624)
print v(xbgr.mr_n66310736)
print v(xbgr.mr_n66311056)
print v(xbgr.mr_n66311168)
print v(xbgr.mr_n66311488)
print v(xbgr.mr_n66311600)
print v(xbgr.mr_n66311920)
print v(xbgr.mr_n66312032)
print v(xbgr.mr_n66312352)
print v(xbgr.mr_n66312464)
print v(xbgr.mr_n66312784)
print v(xbgr.mr_n66312896)
print v(xbgr.mr_n66313216)
print v(xbgr.mr_n66313328)
print v(xbgr.mr_n66313648)
print v(xbgr.mr_n66313760)
print v(xbgr.mr_n66314080)
print v(xbgr.mr_n66314192)
print v(xbgr.mr_n66314512)
print v(xbgr.mr_n66314624)
print v(xbgr.mr_n66314944)
print v(xbgr.mr_n66315056)
print v(xbgr.mr_n66315376)
print v(xbgr.mr_n66315488)
print v(xbgr.mr_n66315808)
print v(xbgr.mr_n66315920)
print v(xbgr.mr_n66316240)
print v(xbgr.mr_n66316352)
print v(xbgr.mr_n66316672)
print v(xbgr.mr_n66316784)
print v(xbgr.mr_n66317104)
print v(xbgr.mr_n66317216)
print v(xbgr.mr_n66317536)
print v(xbgr.mr_n66317648)
print v(xbgr.mr_n66317968)
print v(xbgr.mr_n66318080)
print v(xbgr.mr_n66318400)
print v(xbgr.mr_n66318512)
print v(xbgr.mr_n66318832)
print v(xbgr.mr_n66318944)
print v(xbgr.mr_n66319264)
print v(xbgr.mr_n66319376)
print v(xbgr.mr_n66319696)
print v(xbgr.mr_n66319808)
print v(xbgr.mr_n66320128)
print v(xbgr.mr_n66320240)
print v(xbgr.mr_n66320560)
print v(xbgr.mr_n66320672)
print v(xbgr.mr_n66320992)
print v(xbgr.mr_n66321104)
print v(xbgr.mr_n66321424)
print v(xbgr.mr_n66321536)
print v(xbgr.mr_n66321856)
print v(xbgr.mr_n66321968)
print v(xbgr.mr_n66322288)
print v(xbgr.mr_n66322400)
print v(xbgr.mr_n66322720)
print v(xbgr.mr_n66322832)
print v(xbgr.mr_n66323152)
print v(xbgr.mr_n66323264)
print v(xbgr.mr_n66323584)
print v(xbgr.mr_n66323696)
print v(xbgr.mr_n66324016)
print v(xbgr.mr_n66324128)
print v(xbgr.mr_n66324448)
print v(xbgr.mr_n66324560)
print v(xbgr.mr_n66324880)
print v(xbgr.mr_n66324992)
print v(xbgr.mr_n66325312)
print v(xbgr.mr_n66325424)
print v(xbgr.mr_n66325744)
print v(xbgr.mr_n66325856)
print v(xbgr.mr_n66326176)
print v(xbgr.mr_n66326288)
print v(xbgr.mr_n66326608)
print v(xbgr.mr_n66326720)
print v(xbgr.mr_n66327040)
print v(xbgr.mr_n66327152)
print v(xbgr.mr_n66327472)
print v(xbgr.mr_n66327584)
print v(xbgr.mr_n66327904)
print v(xbgr.mr_n66328016)
print v(xbgr.mr_n66328336)
print v(xbgr.mr_n66328448)
print v(xbgr.mr_n66328768)
print v(xbgr.mr_n66328880)
print v(xbgr.mr_n66329200)
print v(xbgr.mr_n66329312)
print v(xbgr.mr_n66329632)
print v(xbgr.mr_n66329744)
print v(xbgr.mr_n66330064)
print v(xbgr.mr_n66330176)
print v(xbgr.mr_n66330496)
print v(xbgr.mr_n66330608)
print v(xbgr.mr_n66330928)
print v(xbgr.mr_n66331040)
print v(xbgr.mr_n66331360)
print v(xbgr.mr_n66331472)
print v(xbgr.mr_n66331792)
print v(xbgr.mr_n66331904)
print v(xbgr.mr_n66332224)
print v(xbgr.mr_n66332336)
print v(xbgr.mr_n66332656)
print v(xbgr.mr_n66332768)
print v(xbgr.mr_n66333088)
print v(xbgr.mr_n66333200)
print v(xbgr.mr_n66333520)
print v(xbgr.mr_n66333632)
print v(xbgr.mr_n66333952)
print v(xbgr.mr_n66334064)
print v(xbgr.mr_n66334384)
print v(xbgr.mr_n66334496)
print v(xbgr.mr_n66334816)
print v(xbgr.mr_n66334928)
print v(xbgr.mr_n66335248)
print v(xbgr.mr_n66335360)
print v(xbgr.mr_n66335680)
print v(xbgr.mr_n66335792)
print v(xbgr.mr_n66336112)
print v(xbgr.mr_n66336224)
print v(xbgr.mr_n66336544)
print v(xbgr.mr_n66336656)
print v(xbgr.mr_n66336976)
print v(xbgr.mr_n66337088)
print v(xbgr.mr_n66337408)
print v(xbgr.mr_n66337520)
print v(xbgr.mr_n66337840)
print v(xbgr.mr_n66337952)
print v(xbgr.mr_n66338272)
print v(xbgr.mr_n66338384)
print v(xbgr.mr_n66338704)
print v(xbgr.mr_n66338816)
print v(xbgr.mr_n66339136)
print v(xbgr.mr_n66339248)
print v(xbgr.mr_n66339568)
print v(xbgr.mr_n66339680)
print v(xbgr.mr_n66340112)
print v(xbgr.mr_n66340432)
print v(xbgr.mr_n66340544)
print v(xbgr.mr_n66340864)
print v(xbgr.mr_n66340976)
print v(xbgr.mr_n66341296)
print v(xbgr.mr_n66341408)
print v(xbgr.mr_n66341840)
print v(xbgr.mr_n66342160)
print v(xbgr.mr_n66342272)
print v(xbgr.mr_n66342592)
print v(xbgr.mr_n66342704)
print v(xbgr.mr_n66343024)
print v(xbgr.mr_n66343136)
print v(xbgr.mr_n66343568)
print v(xbgr.mr_n66343888)
print v(xbgr.mr_n66344000)
print v(xbgr.mr_n66344320)
print v(xbgr.mr_n66344432)
print v(xbgr.mr_n66344752)
print v(xbgr.mr_n66344864)
print v(xbgr.mr_n66345184)
print v(xbgr.mr_n66345296)
print v(xbgr.mr_n66345616)
print v(xbgr.mr_n66345728)
print v(xbgr.mr_n66346048)
print v(xbgr.mr_n66346160)
print v(xbgr.mr_n66346480)
print v(xbgr.mr_n66346592)
print v(xbgr.mr_n66346912)
print v(xbgr.mr_n66347024)
print v(xbgr.mr_n66347344)
print v(xbgr.mr_n66347456)
print v(xbgr.mr_n66347888)
print v(xbgr.mr_n66348208)
print v(xbgr.mr_n66348320)
print v(xbgr.mr_n66348752)
print v(xbgr.mr_n66349072)
print v(xbgr.mr_n66349184)
print v(xbgr.mr_n66349616)
print v(xbgr.mr_n66349936)
print v(xbgr.mr_n66350048)
print v(xbgr.mr_n66350368)
print v(xbgr.mr_n66350480)
print v(xbgr.mr_n66350800)
print v(xbgr.mr_n66350912)
print v(xbgr.mr_n66351344)
print v(xbgr.mr_n66351664)
print v(xbgr.mr_n66351776)
print v(xbgr.mr_n66352096)
print v(xbgr.mr_n66352208)
print v(xbgr.mr_n66352528)
print v(xbgr.mr_n66352640)
print v(xbgr.mr_n66352960)
print v(xbgr.mr_n66353072)
print v(xbgr.mr_n66353392)
print v(xbgr.mr_n66353504)
print v(xbgr.mr_n66353936)
print v(xbgr.mr_n66354256)
print v(xbgr.mr_n66354368)
print v(xbgr.mr_n66354688)
print v(xbgr.mr_n66354800)
print v(xbgr.mr_n66355120)
print v(xbgr.mr_n66355232)
print v(xbgr.mr_n66355552)
print v(xbgr.mr_n66355664)
print v(xbgr.mr_n66355984)
print v(xbgr.mr_n66356096)
print v(xbgr.mr_n66356416)
print v(xbgr.mr_n66356528)
print v(xbgr.mr_n66356848)
print v(xbgr.mr_n66356960)
print v(xbgr.mr_n66357280)
print v(xbgr.mr_n66357392)
print v(xbgr.mr_n66357712)
print v(xbgr.mr_n66357824)
print v(xbgr.mr_n66358144)
print v(xbgr.mr_n66358256)
print v(xbgr.mr_n66358576)
print v(xbgr.mr_n66358688)
print v(xbgr.mr_n66359008)
print v(xbgr.mr_n66359120)
print v(xbgr.mr_n66359440)
print v(xbgr.mr_n66359552)
print v(xbgr.mr_n66359872)
print v(xbgr.mr_n66359984)
print v(xbgr.mr_n66360304)
print v(xbgr.mr_n66360416)
print v(xbgr.mr_n66360736)
print v(xbgr.mr_n66360848)
print v(xbgr.mr_n66361168)
print v(xbgr.mr_n66361280)
print v(xbgr.mr_n66361600)
print v(xbgr.mr_n66361712)
print v(xbgr.mr_n66362032)
print v(xbgr.mr_n66362144)
print v(xbgr.mr_n66362464)
print v(xbgr.mr_n66362576)
print v(xbgr.mr_n66362896)
print v(xbgr.mr_n66363008)
print v(xbgr.mr_n66363328)
print v(xbgr.mr_n66363440)
print v(xbgr.mr_n66363760)
print v(xbgr.mr_n66363872)
print v(xbgr.mr_n66364192)
print v(xbgr.mr_n66364304)
print v(xbgr.mr_n66364624)
print v(xbgr.mr_n66364736)
print v(xbgr.mr_n66365056)
print v(xbgr.mr_n66365168)
print v(xbgr.mr_n66365488)
print v(xbgr.mr_n66365600)
print v(xbgr.mr_n66365920)
print v(xbgr.mr_n66366032)
print v(xbgr.mr_n66366352)
print v(xbgr.mr_n66366464)
print v(xbgr.mr_n66366784)
print v(xbgr.mr_n66366896)
print v(xbgr.mr_n66367216)
print v(xbgr.mr_n66367328)
print v(xbgr.mr_n66367648)
print v(xbgr.mr_n66367760)
print v(xbgr.mr_n66368080)
print v(xbgr.mr_n66368192)
print v(xbgr.mr_n66368512)
print v(xbgr.mr_n66368624)
print v(xbgr.mr_n66368944)
print v(xbgr.mr_n66369056)
print v(xbgr.mr_n66369376)
print v(xbgr.mr_n66369488)
print v(xbgr.mr_n66369808)
print v(xbgr.mr_n66369920)
print v(xbgr.mr_n66370240)
print v(xbgr.mr_n66370352)
print v(xbgr.mr_n66370672)
print v(xbgr.mr_n66370784)
print v(xbgr.mr_n66371104)
print v(xbgr.mr_n66371216)
print v(xbgr.mr_n66371536)
print v(xbgr.mr_n66371648)
print v(xbgr.mr_n66371968)
print v(xbgr.mr_n66372080)
print v(xbgr.mr_n66372400)
print v(xbgr.mr_n66372512)
print v(xbgr.mr_n66372832)
print v(xbgr.mr_n66372944)
print v(xbgr.mr_n66373264)
print v(xbgr.mr_n66373376)
print v(xbgr.mr_n66373696)
print v(xbgr.mr_n66373808)
print v(xbgr.mr_n66374128)
print v(xbgr.mr_n66374240)
print v(xbgr.mr_n66374560)
print v(xbgr.mr_n66374672)
print v(xbgr.mr_n66374992)
print v(xbgr.mr_n66375104)
print v(xbgr.mr_n66375424)
print v(xbgr.mr_n66375536)
print v(xbgr.mr_n66375856)
print v(xbgr.mr_n66375968)
print v(xbgr.mr_n66376288)
print v(xbgr.mr_n66376400)
print v(xbgr.mr_n66376720)
print v(xbgr.mr_n66376832)
print v(xbgr.mr_n66377152)
print v(xbgr.mr_n66377264)
print v(xbgr.mr_n66377584)
print v(xbgr.mr_n66377696)
print v(xbgr.mr_n66378016)
print v(xbgr.mr_n66378128)
print v(xbgr.mr_n66378448)
print v(xbgr.mr_n66378560)
print v(xbgr.mr_n66378880)
print v(xbgr.mr_n66378992)
print v(xbgr.mr_n66379312)
print v(xbgr.mr_n66379424)
print v(xbgr.mr_n66379744)
print v(xbgr.mr_n66379856)
print v(xbgr.mr_n66380176)
print v(xbgr.mr_n66380288)
print v(xbgr.mr_n66380608)
print v(xbgr.mr_n66380720)
print v(xbgr.mr_n66381040)
print v(xbgr.mr_n66381152)
print v(xbgr.mr_n66381472)
print v(xbgr.mr_n66381584)
print v(xbgr.mr_n66381904)
print v(xbgr.mr_n66382016)
print v(xbgr.mr_n66382336)
print v(xbgr.mr_n66382448)
print v(xbgr.mr_n66382768)
print v(xbgr.mr_n66382880)
print v(xbgr.mr_n66383200)
print v(xbgr.mr_n66383312)
print v(xbgr.mr_n66383632)
print v(xbgr.mr_n66383744)
print v(xbgr.mr_n66384064)
print v(xbgr.mr_n66384176)
print v(xbgr.mr_n66384496)
print v(xbgr.mr_n66384608)
print v(xbgr.mr_n66384928)
print v(xbgr.mr_n66385040)
print v(xbgr.mr_n66385360)
print v(xbgr.mr_n66385472)
print v(xbgr.mr_n66385792)
print v(xbgr.mr_n66385904)
print v(xbgr.mr_n66386224)
print v(xbgr.mr_n66386336)
print v(xbgr.mr_n66386656)
print v(xbgr.mr_n66386768)
print v(xbgr.mr_n66387088)
print v(xbgr.mr_n66387200)
print v(xbgr.mr_n66387520)
print v(xbgr.mr_n66387632)
print v(xbgr.mr_n66387952)
print v(xbgr.mr_n66388064)
print v(xbgr.mr_n66388384)
print v(xbgr.mr_n66388496)
print v(xbgr.mr_n66388816)
print v(xbgr.mr_n66388928)
print v(xbgr.mr_n66389248)
print v(xbgr.mr_n66389360)
print v(xbgr.mr_n66389680)
print v(xbgr.mr_n66389792)
print v(xbgr.mr_n66390112)
print v(xbgr.mr_n66390224)
print v(xbgr.mr_n66390544)
print v(xbgr.mr_n66390656)
print v(xbgr.mr_n66390976)
print v(xbgr.mr_n66391088)
print v(xbgr.mr_n66391408)
print v(xbgr.mr_n66391520)
print v(xbgr.mr_n66391840)
print v(xbgr.mr_n66391952)
print v(xbgr.mr_n66392272)
print v(xbgr.mr_n66392384)
print v(xbgr.mr_n66392704)
print v(xbgr.mr_n66392816)
print v(xbgr.mr_n66393136)
print v(xbgr.mr_n66393248)
print v(xbgr.mr_n66393568)
print v(xbgr.mr_n66393680)
print v(xbgr.mr_n66394000)
print v(xbgr.mr_n66394112)
print v(xbgr.mr_n66394432)
print v(xbgr.mr_n66394544)
print v(xbgr.mr_n66394864)
print v(xbgr.mr_n66394976)
print v(xbgr.mr_n66395296)
print v(xbgr.mr_n66395408)
print v(xbgr.mr_n66395728)
print v(xbgr.mr_n66395840)
print v(xbgr.mr_n66396160)
print v(xbgr.mr_n66396272)
print v(xbgr.mr_n66396592)
print v(xbgr.mr_n66396704)
print v(xbgr.mr_n66397024)
print v(xbgr.mr_n66397136)
print v(xbgr.mr_n66397456)
print v(xbgr.mr_n66397568)
print v(xbgr.mr_n66397888)
print v(xbgr.mr_n66398000)
print v(xbgr.mr_n66398320)
print v(xbgr.mr_n66398432)
print v(xbgr.mr_n66398752)
print v(xbgr.mr_n66398864)
print v(xbgr.mr_n66399184)
print v(xbgr.mr_n66399296)
print v(xbgr.mr_n66399616)
print v(xbgr.mr_n66399728)
print v(xbgr.mr_n66400048)
print v(xbgr.mr_n66400160)
print v(xbgr.mr_n66400480)
print v(xbgr.mr_n66400592)
print v(xbgr.mr_n66400912)
print v(xbgr.mr_n66401024)
print v(xbgr.mr_n66401344)
print v(xbgr.mr_n66401456)
print v(xbgr.mr_n66401776)
print v(xbgr.mr_n66401888)
print v(xbgr.mr_n66402208)
print v(xbgr.mr_n66402320)
print v(xbgr.mr_n66402640)
print v(xbgr.mr_n66402752)
print v(xbgr.mr_n66403072)
print v(xbgr.mr_n66403184)
print v(xbgr.mr_n66403504)
print v(xbgr.mr_n66403616)
print v(xbgr.mr_n66403936)
print v(xbgr.mr_n66404048)
print v(xbgr.mr_n66404368)
print v(xbgr.mr_n66404480)
print v(xbgr.mr_n66404800)
print v(xbgr.mr_n66404912)
print v(xbgr.mr_n66405232)
print v(xbgr.mr_n66405344)
print v(xbgr.mr_n66405664)
print v(xbgr.mr_n66405776)
print v(xbgr.mr_n66406096)
print v(xbgr.mr_n66406208)
print v(xbgr.mr_n66406528)
print v(xbgr.mr_n66406640)
print v(xbgr.mr_n66406960)
print v(xbgr.mr_n66407072)
print v(xbgr.mr_n66407392)
print v(xbgr.mr_n66407504)
print v(xbgr.mr_n66407824)
print v(xbgr.mr_n66407936)
print v(xbgr.mr_n66408256)
print v(xbgr.mr_n66408368)
print v(xbgr.mr_n66408688)
print v(xbgr.mr_n66408800)
print v(xbgr.mr_n66409120)
print v(xbgr.mr_n66409232)
print v(xbgr.mr_n66409552)
print v(xbgr.mr_n66409664)
print v(xbgr.mr_n66409984)
print v(xbgr.mr_n66410096)
print v(xbgr.mr_n66410416)
print v(xbgr.mr_n66410528)
print v(xbgr.mr_n66410848)
print v(xbgr.mr_n66410960)
print v(xbgr.mr_n66411280)
print v(xbgr.mr_n66411392)
print v(xbgr.mr_n66411712)
print v(xbgr.mr_n66411824)
print v(xbgr.mr_n66412144)
print v(xbgr.mr_n66412256)
print v(xbgr.mr_n66412576)
print v(xbgr.mr_n66412688)
print v(xbgr.mr_n66413008)
print v(xbgr.mr_n66413120)
print v(xbgr.mr_n66413440)
print v(xbgr.mr_n66413552)
print v(xbgr.mr_n66413872)
print v(xbgr.mr_n66413984)
print v(xbgr.mr_n66414304)
print v(xbgr.mr_n66414416)
print v(xbgr.mr_n66414736)
print v(xbgr.mr_n66414848)
print v(xbgr.mr_n66415168)
print v(xbgr.mr_n66415280)
print v(xbgr.mr_n66415600)
print v(xbgr.mr_n66415712)
print v(xbgr.mr_n66416032)
print v(xbgr.mr_n66416144)
print v(xbgr.mr_n66416464)
print v(xbgr.mr_n66416576)
print v(xbgr.mr_n66416896)
print v(xbgr.mr_n66417008)
print v(xbgr.mr_n66417328)
print v(xbgr.mr_n66417440)
print v(xbgr.mr_n66417760)
print v(xbgr.mr_n66417872)
print v(xbgr.mr_n66418192)
print v(xbgr.mr_n66418304)
print v(xbgr.mr_n66418624)
print v(xbgr.mr_n66418736)
print v(xbgr.mr_n66419056)
print v(xbgr.mr_n66419168)
print v(xbgr.mr_n66419488)
print v(xbgr.mr_n66419600)
print v(xbgr.mr_n66419920)
print v(xbgr.mr_n66420032)
print v(xbgr.mr_n66420352)
print v(xbgr.mr_n66420464)
print v(xbgr.mr_n66420784)
print v(xbgr.mr_n66420896)
print v(xbgr.mr_n66421216)
print v(xbgr.mr_n66421328)
print v(xbgr.mr_n66421648)
print v(xbgr.mr_n66421760)
print v(xbgr.mr_n66422080)
print v(xbgr.mr_n66422192)
print v(xbgr.mr_n66422512)
print v(xbgr.mr_n66422624)
print v(xbgr.mr_n66422944)
print v(xbgr.mr_n66423056)
print v(xbgr.mr_n66423376)
print v(xbgr.mr_n66423488)
print v(xbgr.mr_n66423808)
print v(xbgr.mr_n66423920)
print v(xbgr.mr_n66424240)
print v(xbgr.mr_n66424352)
print v(xbgr.mr_n66424672)
print v(xbgr.mr_n66424784)
print v(xbgr.mr_n66425104)
print v(xbgr.mr_n66425216)
print v(xbgr.mr_n66425536)
print v(xbgr.mr_n66425648)
print v(xbgr.mr_n66425968)
print v(xbgr.mr_n66426080)
print v(xbgr.mr_n66426400)
print v(xbgr.mr_n66426512)
print v(xbgr.mr_n66426832)
print v(xbgr.mr_n66426944)
print v(xbgr.mr_n66427264)
print v(xbgr.mr_n66427376)
print v(xbgr.mr_n66427696)
print v(xbgr.mr_n66427808)
print v(xbgr.mr_n66428128)
print v(xbgr.mr_n66428240)
print v(xbgr.mr_n66428560)
print v(xbgr.mr_n66428672)
print v(xbgr.mr_n66429104)
print v(xbgr.mr_n66429424)
print v(xbgr.mr_n66429536)
print v(xbgr.mr_n66429968)
print v(xbgr.mr_n66430288)
print v(xbgr.mr_n66430400)
print v(xbgr.mr_n66430832)
print v(xbgr.mr_n66431152)
print v(xbgr.mr_n66432016)
print v(xbgr.mr_n66432128)
print v(xbgr.mr_n66432560)
print v(xbgr.mr_n66432880)
print v(xbgr.mr_n66432992)
print v(xbgr.mr_n66433312)
print v(xbgr.mr_n66433424)
print v(xbgr.mr_n66433744)
print v(xbgr.mr_n66433856)
print v(xbgr.mr_n66434176)
print v(xbgr.mr_n66434288)
print v(xbgr.mr_n66434608)
print v(xbgr.mr_n66434720)
print v(xbgr.mr_n66435040)
print v(xbgr.mr_n66435152)
print v(xbgr.mr_n66435472)
print v(xbgr.mr_n66435584)
print v(xbgr.mr_n66435904)
print v(xbgr.mr_n66436016)
print v(xbgr.mr_n66436336)
print v(xbgr.mr_n66437200)
print v(xbgr.mr_n66438064)
print v(xbgr.mr_n66438176)
print v(xbgr.mr_n66438496)
print v(xbgr.mr_n66438608)
print v(xbgr.mr_n66438928)
print v(xbgr.mr_n66439792)
print v(xbgr.mr_n66439904)
print v(xbgr.mr_n66440224)
print v(xbgr.mr_n66440336)
print v(xbgr.mr_n66440656)
print v(xbgr.mr_n66440768)
print v(xbgr.mr_n66441088)
print v(xbgr.mr_n66441200)
print v(xbgr.mr_n66441520)
print v(xbgr.mr_n66441632)
print v(xbgr.mr_n66441952)
print v(xbgr.mr_n66442064)
print v(xbgr.mr_n66442384)
print v(xbgr.mr_n66442496)
print v(xbgr.mr_n66442816)
print v(xbgr.mr_n66442928)
print v(xbgr.mr_n66443248)
print v(xbgr.mr_n66443360)
print v(xbgr.mr_n66443680)
print v(xbgr.mr_n66443792)
print v(xbgr.mr_n66444112)
print v(xbgr.mr_n66444224)
print v(xbgr.mr_n66444544)
print v(xbgr.mr_n66444656)
print v(xbgr.mr_n66444976)
print v(xbgr.mr_n66445088)
print v(xbgr.mr_n66445408)
print v(xbgr.mr_n66445520)
print v(xbgr.mr_n66445840)
print v(xbgr.mr_n66445952)
print v(xbgr.mr_n66446272)
print v(xbgr.mr_n66446384)
print v(xbgr.mr_n66446704)
print v(xbgr.mr_n66446816)
print v(xbgr.mr_n66447136)
print v(xbgr.mr_n66447248)
print v(xbgr.mr_n66447568)
print v(xbgr.mr_n66447680)
print v(xbgr.mr_n66448000)
print v(xbgr.mr_n66448112)
print v(xbgr.mr_n66448432)
print v(xbgr.mr_n66448544)
print v(xbgr.mr_n66448864)
print v(xbgr.mr_n66448976)
print v(xbgr.mr_n66449296)
print v(xbgr.mr_n66449408)
print v(xbgr.mr_n66449728)
print v(xbgr.mr_n66449840)
print v(xbgr.mr_n66450160)
print v(xbgr.mr_n66450272)
print v(xbgr.mr_n66450704)
print v(xbgr.mr_n66451024)
print v(xbgr.mr_n66451136)
print v(xbgr.mr_n66451456)
print v(xbgr.mr_n66451568)
print v(xbgr.mr_n66451888)
print v(xbgr.mr_n66452000)
print v(xbgr.mr_n66452320)
print v(xbgr.mr_n66452432)
print v(xbgr.mr_n66452752)
print v(xbgr.mr_n66452864)
print v(xbgr.mr_n66453184)
print v(xbgr.mr_n66453296)
print v(xbgr.mr_n66453616)
print v(xbgr.mr_n66453728)
print v(xbgr.mr_n66454048)
print v(xbgr.mr_n66454160)
print v(xbgr.mr_n66454480)
print v(xbgr.mr_n66454592)
print v(xbgr.mr_n66454912)
print v(xbgr.mr_n66455024)
print v(xbgr.mr_n66455344)
print v(xbgr.mr_n66455456)
print v(xbgr.mr_n66455776)
print v(xbgr.mr_n66455888)
print v(xbgr.mr_n66456208)
print v(xbgr.mr_n66456320)
print v(xbgr.mr_n66456640)
print v(xbgr.mr_n66456752)
print v(xbgr.mr_n66457072)
print v(xbgr.mr_n66457936)
print v(xbgr.mr_n66458048)
print v(xbgr.mr_n66458368)
print v(xbgr.mr_n66458480)
print v(xbgr.mr_n66458800)
print v(xbgr.mr_n66458912)
print v(xbgr.mr_n66459232)
print v(xbgr.mr_n66459344)
print v(xbgr.mr_n66459664)
print v(xbgr.mr_n66459776)
print v(xbgr.mr_n66460096)
print v(xbgr.mr_n66460208)
print v(xbgr.mr_n66460528)
print v(xbgr.mr_n66460640)
print v(xbgr.mr_n66460960)
print v(xbgr.mr_n66461072)
print v(xbgr.mr_n66461392)
print v(xbgr.mr_n66461504)
print v(xbgr.mr_n66461824)
print v(xbgr.mr_n66461936)
print v(xbgr.mr_n66462256)
print v(xbgr.mr_n66462368)
print v(xbgr.mr_n66462688)
print v(xbgr.mr_n66462800)
print v(xbgr.mr_n66463120)
print v(xbgr.mr_n66463232)
print v(xbgr.mr_n66463552)
print v(xbgr.mr_n66463664)
print v(xbgr.mr_n66463984)
print v(xbgr.mr_n66464096)
print v(xbgr.mr_n66464416)
print v(xbgr.mr_n66464528)
print v(xbgr.mr_n66464848)
print v(xbgr.mr_n66464960)
print v(xbgr.mr_n66465280)
print v(xbgr.mr_n66465392)
print v(xbgr.mr_n66465712)
print v(xbgr.mr_n66465824)
print v(xbgr.mr_n66466144)
print v(xbgr.mr_n66466256)
print v(xbgr.mr_n66466576)
print v(xbgr.mr_n66466688)
print v(xbgr.mr_n66467008)
print v(xbgr.mr_n66467120)
print v(xbgr.mr_n66467440)
print v(xbgr.mr_n66467552)
print v(xbgr.mr_n66467872)
print v(xbgr.mr_n66467984)
print v(xbgr.mr_n66468304)
print v(xbgr.mr_n66468416)
print v(xbgr.mr_n66468736)
print v(xbgr.mr_n66468848)
print v(xbgr.mr_n66469168)
print v(xbgr.mr_n66469280)
print v(xbgr.mr_n66469600)
print v(xbgr.mr_n66469712)
print v(xbgr.mr_n66470032)
print v(xbgr.mr_n66470144)
print v(xbgr.mr_n66470464)
print v(xbgr.mr_n66470576)
print v(xbgr.mr_n66470896)
print v(xbgr.mr_n66471008)
print v(xbgr.mr_n66471328)
print v(xbgr.mr_n66471440)
print v(xbgr.mr_n66471760)
print v(xbgr.mr_n66471872)
print v(xbgr.mr_n66472192)
print v(xbgr.mr_n66472304)
print v(xbgr.mr_n66472624)
print v(xbgr.mr_n66472736)
print v(xbgr.mr_n66473056)
print v(xbgr.mr_n66473168)
print v(xbgr.mr_n66473488)
print v(xbgr.mr_n66473600)
print v(xbgr.mr_n66473920)
print v(xbgr.mr_n66474032)
print v(xbgr.mr_n66474352)
print v(xbgr.mr_n66474464)
print v(xbgr.mr_n66474784)
print v(xbgr.mr_n66474896)
print v(xbgr.mr_n66475216)
print v(xbgr.mr_n66475328)
print v(xbgr.mr_n66475648)
print v(xbgr.mr_n66475760)
print v(xbgr.mr_n66476080)
print v(xbgr.mr_n66476192)
print v(xbgr.mr_n66476512)
print v(xbgr.mr_n66476624)
print v(xbgr.mr_n66476944)
print v(xbgr.mr_n66477056)
print v(xbgr.mr_n66477376)
print v(xbgr.mr_n66477488)
print v(xbgr.mr_n66477808)
print v(xbgr.mr_n66477920)
print v(xbgr.mr_n66478240)
print v(xbgr.mr_n66478352)
print v(xbgr.mr_n66478672)
print v(xbgr.mr_n66478784)
print v(xbgr.mr_n66479104)
print v(xbgr.mr_n66479216)
print v(xbgr.mr_n66479536)
print v(xbgr.mr_n66479648)
print v(xbgr.mr_n66479968)
print v(xbgr.mr_n66480080)
print v(xbgr.mr_n66480400)
print v(xbgr.mr_n66480512)
print v(xbgr.mr_n66480832)
print v(xbgr.mr_n66480944)
print v(xbgr.mr_n66481264)
print v(xbgr.mr_n66481376)
print v(xbgr.mr_n66481696)
print v(xbgr.mr_n66481808)
print v(xbgr.mr_n66482128)
print v(xbgr.mr_n66482240)
print v(xbgr.mr_n66482560)
print v(xbgr.mr_n66482672)
print v(xbgr.mr_n66482992)
print v(xbgr.mr_n66483104)
print v(xbgr.mr_n66483424)
print v(xbgr.mr_n66483536)
print v(xbgr.mr_n66483856)
print v(xbgr.mr_n66483968)
print v(xbgr.mr_n66484288)
print v(xbgr.mr_n66484400)
print v(xbgr.mr_n66484720)
print v(xbgr.mr_n66484832)
print v(xbgr.mr_n66485152)
print v(xbgr.mr_n66485264)
print v(xbgr.mr_n66485584)
print v(xbgr.mr_n66485696)
print v(xbgr.mr_n66486016)
print v(xbgr.mr_n66486128)
print v(xbgr.mr_n66486448)
print v(xbgr.mr_n66486560)
print v(xbgr.mr_n66486880)
print v(xbgr.mr_n66486992)
print v(xbgr.mr_n66487312)
print v(xbgr.mr_n66487424)
print v(xbgr.mr_n66487744)
print v(xbgr.mr_n66487856)
print v(xbgr.mr_n66488176)
print v(xbgr.mr_n66488288)
print v(xbgr.mr_n66488608)
print v(xbgr.mr_n66488720)
print v(xbgr.mr_n66489040)
print v(xbgr.mr_n66489152)
print v(xbgr.mr_n66489472)
print v(xbgr.mr_n66489584)
print v(xbgr.mr_n66489904)
print v(xbgr.mr_n66490016)
print v(xbgr.mr_n66490336)
print v(xbgr.mr_n66490448)
print v(xbgr.mr_n66490768)
print v(xbgr.mr_n66490880)
print v(xbgr.mr_n66491200)
print v(xbgr.mr_n66491312)
print v(xbgr.mr_n66491632)
print v(xbgr.mr_n66491744)
print v(xbgr.mr_n66492064)
print v(xbgr.mr_n66492176)
print v(xbgr.mr_n66492496)
print v(xbgr.mr_n66492608)
print v(xbgr.mr_n66492928)
print v(xbgr.mr_n66493040)
print v(xbgr.mr_n66493360)
print v(xbgr.mr_n66493472)
print v(xbgr.mr_n66493792)
print v(xbgr.mr_n66493904)
print v(xbgr.mr_n66494224)
print v(xbgr.mr_n66494336)
print v(xbgr.mr_n66494656)
print v(xbgr.mr_n66494768)
print v(xbgr.mr_n66495088)
print v(xbgr.mr_n66495200)
print v(xbgr.mr_n66495520)
print v(xbgr.mr_n66495632)
print v(xbgr.mr_n66495952)
print v(xbgr.mr_n66496064)
print v(xbgr.mr_n66496384)
print v(xbgr.mr_n66496496)
print v(xbgr.mr_n66496816)
print v(xbgr.mr_n66496928)
print v(xbgr.mr_n66497248)
print v(xbgr.mr_n66497360)
print v(xbgr.mr_n66497680)
print v(xbgr.mr_n66497792)
print v(xbgr.mr_n66498112)
print v(xbgr.mr_n66498224)
print v(xbgr.mr_n66498544)
print v(xbgr.mr_n66498656)
print v(xbgr.mr_n66498976)
print v(xbgr.mr_n66499088)
print v(xbgr.mr_n66499408)
print v(xbgr.mr_n66499520)
print v(xbgr.mr_n66499840)
print v(xbgr.mr_n66499952)
print v(xbgr.mr_n66500272)
print v(xbgr.mr_n66500384)
print v(xbgr.mr_n66500704)
print v(xbgr.mr_n66500816)
print v(xbgr.mr_n66501136)
print v(xbgr.mr_n66501248)
print v(xbgr.mr_n66501568)
print v(xbgr.mr_n66501680)
print v(xbgr.mr_n66502000)
print v(xbgr.mr_n66502112)
print v(xbgr.mr_n66502432)
print v(xbgr.mr_n66502544)
print v(xbgr.mr_n66502864)
print v(xbgr.mr_n66502976)
print v(xbgr.mr_n66503296)
print v(xbgr.mr_n66503408)
print v(xbgr.mr_n66503728)
print v(xbgr.mr_n66503840)
print v(xbgr.mr_n66504160)
print v(xbgr.mr_n66504272)
print v(xbgr.mr_n66504592)
print v(xbgr.mr_n66504704)
print v(xbgr.mr_n66505024)
print v(xbgr.mr_n66505136)
print v(xbgr.mr_n66505456)
print v(xbgr.mr_n66505568)
print v(xbgr.mr_n66505888)
print v(xbgr.mr_n66506000)
print v(xbgr.mr_n66506320)
print v(xbgr.mr_n66506432)
print v(xbgr.mr_n66506752)
print v(xbgr.mr_n66506864)
print v(xbgr.mr_n66507184)
print v(xbgr.mr_n66507296)
print v(xbgr.mr_n66507616)
print v(xbgr.mr_n66507728)
print v(xbgr.mr_n66508048)
print v(xbgr.mr_n66508160)
print v(xbgr.mr_n66508480)
print v(xbgr.mr_n66508592)
print v(xbgr.mr_n66508912)
print v(xbgr.mr_n66509024)
print v(xbgr.mr_n66509344)
print v(xbgr.mr_n66509456)
print v(xbgr.mr_n66509776)
print v(xbgr.mr_n66509888)
print v(xbgr.mr_n66510208)
print v(xbgr.mr_n66510320)
print v(xbgr.mr_n66510640)
print v(xbgr.mr_n66510752)
print v(xbgr.mr_n66511072)
print v(xbgr.mr_n66511184)
print v(xbgr.mr_n66511504)
print v(xbgr.mr_n66511616)
print v(xbgr.mr_n66511936)
print v(xbgr.mr_n66512048)
print v(xbgr.mr_n66512368)
print v(xbgr.mr_n66512480)
print v(xbgr.mr_n66512800)
print v(xbgr.mr_n66512912)
print v(xbgr.mr_n66513232)
print v(xbgr.mr_n66513344)
print v(xbgr.mr_n66513664)
print v(xbgr.mr_n66513776)
print v(xbgr.mr_n66514096)
print v(xbgr.mr_n66514208)
print v(xbgr.mr_n66514528)
print v(xbgr.mr_n66514640)
print v(xbgr.mr_n66514960)
print v(xbgr.mr_n66515072)
print v(xbgr.mr_n66515392)
print v(xbgr.mr_n66515504)
print v(xbgr.mr_n66515824)
print v(xbgr.mr_n66515936)
print v(xbgr.mr_n66516256)
print v(xbgr.mr_n66516368)
print v(xbgr.mr_n66516688)
print v(xbgr.mr_n66516800)
print v(xbgr.mr_n66517120)
print v(xbgr.mr_n66517232)
print v(xbgr.mr_n66517552)
print v(xbgr.mr_n66517664)
print v(xbgr.mr_n66517984)
print v(xbgr.mr_n66518096)
print v(xbgr.mr_n66518416)
print v(xbgr.mr_n66518528)
print v(xbgr.mr_n66518848)
print v(xbgr.mr_n66518960)
print v(xbgr.mr_n66519280)
print v(xbgr.mr_n66519392)
print v(xbgr.mr_n66519712)
print v(xbgr.mr_n66519824)
print v(xbgr.mr_n66520144)
print v(xbgr.mr_n66520256)
print v(xbgr.mr_n66520576)
print v(xbgr.mr_n66520688)
print v(xbgr.mr_n66521008)
print v(xbgr.mr_n66521120)
print v(xbgr.mr_n66521440)
print v(xbgr.mr_n66521552)
print v(xbgr.mr_n66521872)
print v(xbgr.mr_n66521984)
print v(xbgr.mr_n66522304)
print v(xbgr.mr_n66522416)
print v(xbgr.mr_n66522736)
print v(xbgr.mr_n66522848)
print v(xbgr.mr_n66523168)
print v(xbgr.mr_n66523280)
print v(xbgr.mr_n66523600)
print v(xbgr.mr_n66523712)
print v(xbgr.mr_n66524032)
print v(xbgr.mr_n66524144)
print v(xbgr.mr_n66524464)
print v(xbgr.mr_n66524576)
print v(xbgr.mr_n66524896)
print v(xbgr.mr_n66525008)
print v(xbgr.mr_n66525328)
print v(xbgr.mr_n66525440)
print v(xbgr.mr_n66525760)
print v(xbgr.mr_n66525872)
print v(xbgr.mr_n66526192)
print v(xbgr.mr_n66526304)
print v(xbgr.mr_n66526624)
print v(xbgr.mr_n66526736)
print v(xbgr.mr_n66527056)
print v(xbgr.mr_n66527168)
print v(xbgr.mr_n66527488)
print v(xbgr.mr_n66527600)
print v(xbgr.mr_n66527920)
print v(xbgr.mr_n66528032)
print v(xbgr.mr_n66528352)
print v(xbgr.mr_n66528464)
print v(xbgr.mr_n66528784)
print v(xbgr.mr_n66528896)
print v(xbgr.mr_n66529216)
print v(xbgr.mr_n66529328)
print v(xbgr.mr_n66529648)
print v(xbgr.mr_n66529760)
print v(xbgr.mr_n66530080)
print v(xbgr.mr_n66530192)
print v(xbgr.mr_n66530512)
print v(xbgr.mr_n66530624)
print v(xbgr.mr_n66530944)
print v(xbgr.mr_n66531056)
print v(xbgr.mr_n66531376)
print v(xbgr.mr_n66531488)
print v(xbgr.mr_n66531808)
print v(xbgr.mr_n66531920)
print v(xbgr.mr_n66532240)
print v(xbgr.mr_n66532352)
print v(xbgr.mr_n66532672)
print v(xbgr.mr_n66532784)
print v(xbgr.mr_n66533104)
print v(xbgr.mr_n66533216)
print v(xbgr.mr_n66533536)
print v(xbgr.mr_n66533648)
print v(xbgr.mr_n66533968)
print v(xbgr.mr_n66534080)
print v(xbgr.mr_n66534400)
print v(xbgr.mr_n66534512)
print v(xbgr.mr_n66534832)
print v(xbgr.mr_n66534944)
print v(xbgr.mr_n66535264)
print v(xbgr.mr_n66535376)
print v(xbgr.mr_n66535696)
print v(xbgr.mr_n66535808)
print v(xbgr.mr_n66536128)
print v(xbgr.mr_n66536240)
print v(xbgr.mr_n66536560)
print v(xbgr.mr_n66536672)
print v(xbgr.mr_n66536992)
print v(xbgr.mr_n66537104)
print v(xbgr.mr_n66537424)
print v(xbgr.mr_n66537536)
print v(xbgr.mr_n66537856)
print v(xbgr.mr_n66537968)
print v(xbgr.mr_n66538288)
print v(xbgr.mr_n66538400)
print v(xbgr.mr_n66538720)
print v(xbgr.mr_n66538832)
print v(xbgr.mr_n66539152)
print v(xbgr.mr_n66539264)
print v(xbgr.mr_n66539584)
print v(xbgr.mr_n66539696)
print v(xbgr.mr_n66540016)
print v(xbgr.mr_n66540128)
print v(xbgr.mr_n66540448)
print v(xbgr.mr_n66540560)
print v(xbgr.mr_n66540880)
print v(xbgr.mr_n66540992)
print v(xbgr.mr_n66541312)
print v(xbgr.mr_n66541424)
print v(xbgr.mr_n66541744)
print v(xbgr.mr_n66541856)
print v(xbgr.mr_n66542176)
print v(xbgr.mr_n66542288)
print v(xbgr.mr_n66542608)
print v(xbgr.mr_n66542720)
print v(xbgr.mr_n66543040)
print v(xbgr.mr_n66543152)
print v(xbgr.mr_n66543472)
print v(xbgr.mr_n66543584)
print v(xbgr.mr_n66543904)
print v(xbgr.mr_n66544016)
print v(xbgr.mr_n66544336)
print v(xbgr.mr_n66544448)
print v(xbgr.mr_n66544768)
print v(xbgr.mr_n66544880)
print v(xbgr.mr_n66545200)
print v(xbgr.mr_n66545312)
print v(xbgr.mr_n66545632)
print v(xbgr.mr_n66545744)
print v(xbgr.mr_n66546064)
print v(xbgr.mr_n66546176)
print v(xbgr.mr_n66546496)
print v(xbgr.mr_n66546608)
print v(xbgr.mr_n66546928)
print v(xbgr.mr_n66547040)
print v(xbgr.mr_n66547360)
print v(xbgr.mr_n66547472)
print v(xbgr.mr_n66547792)
print v(xbgr.mr_n66547904)
print v(xbgr.mr_n66548224)
print v(xbgr.mr_n66548336)
print v(xbgr.mr_n66548656)
print v(xbgr.mr_n66548768)
print v(xbgr.mr_n66549088)
print v(xbgr.mr_n66549200)
print v(xbgr.mr_n66549520)
print v(xbgr.mr_n66549632)
print v(xbgr.mr_n66549952)
print v(xbgr.mr_n66550064)
print v(xbgr.mr_n66550384)
print v(xbgr.mr_n66550496)
print v(xbgr.mr_n66550816)
print v(xbgr.mr_n66550928)
print v(xbgr.mr_n66551248)
print v(xbgr.mr_n66551360)
print v(xbgr.mr_n66551680)
print v(xbgr.mr_n66551792)
print v(xbgr.mr_n66552112)
print v(xbgr.mr_n66552224)
print v(xbgr.mr_n66552544)
print v(xbgr.mr_n66552656)
print v(xbgr.mr_n66552976)
print v(xbgr.mr_n66553088)
print v(xbgr.mr_n66553408)
print v(xbgr.mr_n66553520)
print v(xbgr.mr_n66553840)
print v(xbgr.mr_n66553952)
print v(xbgr.mr_n66554272)
print v(xbgr.mr_n66554384)
print v(xbgr.mr_n66554704)
print v(xbgr.mr_n66554816)
print v(xbgr.mr_n66555136)
print v(xbgr.mr_n66555248)
print v(xbgr.mr_n66555568)
print v(xbgr.mr_n66555680)
print v(xbgr.mr_n66556000)
print v(xbgr.mr_n66556112)
print v(xbgr.mr_n66556432)
print v(xbgr.mr_n66556544)
print v(xbgr.mr_n66556864)
print v(xbgr.mr_n66556976)
print v(xbgr.mr_n66557296)
print v(xbgr.mr_n66557408)
print v(xbgr.mr_n66557728)
print v(xbgr.mr_n66557840)
print v(xbgr.mr_n66558160)
print v(xbgr.mr_n66558272)
print v(xbgr.mr_n66558592)
print v(xbgr.mr_n66558704)
print v(xbgr.mr_n66559024)
print v(xbgr.mr_n66559136)
print v(xbgr.mr_n66559456)
print v(xbgr.mr_n66559568)
print v(xbgr.mr_n66559888)
print v(xbgr.mr_n66560000)
print v(xbgr.mr_n66560320)
print v(xbgr.mr_n66560432)
print v(xbgr.mr_n66560752)
print v(xbgr.mr_n66560864)
print v(xbgr.mr_n66561184)
print v(xbgr.mr_n66561296)
print v(xbgr.mr_n66561616)
print v(xbgr.mr_n66561728)
print v(xbgr.mr_n66562048)
print v(xbgr.mr_n66562160)
print v(xbgr.mr_n66562480)
print v(xbgr.mr_n66562592)
print v(xbgr.mr_n66562912)
print v(xbgr.mr_n66563024)
print v(xbgr.mr_n66563344)
print v(xbgr.mr_n66563456)
print v(xbgr.mr_n66563776)
print v(xbgr.mr_n66563888)
print v(xbgr.mr_n66564208)
print v(xbgr.mr_n66564320)
print v(xbgr.mr_n66564640)
print v(xbgr.mr_n66564752)
print v(xbgr.mr_n66565072)
print v(xbgr.mr_n66565184)
print v(xbgr.mr_n66565504)
print v(xbgr.mr_n66565616)
print v(xbgr.mr_n66565936)
print v(xbgr.mr_n66566048)
print v(xbgr.mr_n66566368)
print v(xbgr.mr_n66566480)
print v(xbgr.mr_n66566800)
print v(xbgr.mr_n66566912)
print v(xbgr.mr_n66567232)
print v(xbgr.mr_n66567344)
print v(xbgr.mr_n66567664)
print v(xbgr.mr_n66567776)
print v(xbgr.mr_n66568096)
print v(xbgr.mr_n66568208)
print v(xbgr.mr_n66568528)
print v(xbgr.mr_n66568640)
print v(xbgr.mr_n66568960)
print v(xbgr.mr_n66569072)
print v(xbgr.mr_n66569392)
print v(xbgr.mr_n66569504)
print v(xbgr.mr_n66569824)
print v(xbgr.mr_n66569936)
print v(xbgr.mr_n66570256)
print v(xbgr.mr_n66570368)
print v(xbgr.mr_n66570688)
print v(xbgr.mr_n66570800)
print v(xbgr.mr_n66571120)
print v(xbgr.mr_n66571232)
print v(xbgr.mr_n66571552)
print v(xbgr.mr_n66571664)
print v(xbgr.mr_n66571984)
print v(xbgr.mr_n66572096)
print v(xbgr.mr_n66572416)
print v(xbgr.mr_n66572528)
print v(xbgr.mr_n66572848)
print v(xbgr.mr_n66572960)
print v(xbgr.mr_n66573280)
print v(xbgr.mr_n66573392)
print v(xbgr.mr_n66573712)
print v(xbgr.mr_n66573824)
print v(xbgr.mr_n66574144)
print v(xbgr.mr_n66574256)
print v(xbgr.mr_n66574576)
print v(xbgr.mr_n66574688)
print v(xbgr.mr_n66575008)
print v(xbgr.mr_n66575120)
print v(xbgr.mr_n66575440)
print v(xbgr.mr_n66575552)
print v(xbgr.mr_n66575872)
print v(xbgr.mr_n66575984)
print v(xbgr.mr_n66576304)
print v(xbgr.mr_n66576416)
print v(xbgr.mr_n66576736)
print v(xbgr.mr_n66576848)
print v(xbgr.mr_n66577168)
print v(xbgr.mr_n66577280)
print v(xbgr.mr_n66577600)
print v(xbgr.mr_n66577712)
print v(xbgr.mr_n66578032)
print v(xbgr.mr_n66578144)
print v(xbgr.mr_n66578464)
print v(xbgr.mr_n66578576)
print v(xbgr.mr_n66578896)
print v(xbgr.mr_n66579008)
print v(xbgr.mr_n66579328)
print v(xbgr.mr_n66579440)
print v(xbgr.mr_n66579760)
print v(xbgr.mr_n66579872)
print v(xbgr.mr_n66580192)
print v(xbgr.mr_n66580304)
print v(xbgr.mr_n66580624)
print v(xbgr.mr_n66580736)
print v(xbgr.mr_n66581056)
print v(xbgr.mr_n66581168)
print v(xbgr.mr_n66581488)
print v(xbgr.mr_n66581600)
print v(xbgr.mr_n66581920)
print v(xbgr.mr_n66582032)
print v(xbgr.mr_n66582352)
print v(xbgr.mr_n66582464)
print v(xbgr.mr_n66582784)
print v(xbgr.mr_n66582896)
print v(xbgr.mr_n66583216)
print v(xbgr.mr_n66583328)
print v(xbgr.mr_n66583648)
print v(xbgr.mr_n66583760)
print v(xbgr.mr_n66584080)
print v(xbgr.mr_n66584192)
print v(xbgr.mr_n66584512)
print v(xbgr.mr_n66584624)
print v(xbgr.mr_n66584944)
print v(xbgr.mr_n66585056)
print v(xbgr.mr_n66585376)
print v(xbgr.mr_n66585488)
print v(xbgr.mr_n66585808)
print v(xbgr.mr_n66585920)
print v(xbgr.mr_n66586240)
print v(xbgr.mr_n66586352)
print v(xbgr.mr_n66586672)
print v(xbgr.mr_n66586784)
print v(xbgr.mr_n66587104)
print v(xbgr.mr_n66587216)
print v(xbgr.mr_n66587536)
print v(xbgr.mr_n66587648)
print v(xbgr.mr_n66587968)
print v(xbgr.mr_n66588080)
print v(xbgr.mr_n66588400)
print v(xbgr.mr_n66588512)
print v(xbgr.mr_n66588832)
print v(xbgr.mr_n66588944)
print v(xbgr.mr_n66589264)
print v(xbgr.mr_n66589376)
print v(xbgr.mr_n66589696)
print v(xbgr.mr_n66589808)
print v(xbgr.mr_n66590128)
print v(xbgr.mr_n66590240)
print v(xbgr.mr_n66590560)
print v(xbgr.mr_n66590672)
print v(xbgr.mr_n66590992)
print v(xbgr.mr_n66591104)
print v(xbgr.mr_n66591424)
print v(xbgr.mr_n66591536)
print v(xbgr.mr_n66591856)
print v(xbgr.mr_n66591968)
print v(xbgr.mr_n66592288)
print v(xbgr.mr_n66592400)
print v(xbgr.mr_n66592720)
print v(xbgr.mr_n66592832)
print v(xbgr.mr_n66593152)
print v(xbgr.mr_n66593264)
print v(xbgr.mr_n66593584)
print v(xbgr.mr_n66593696)
print v(xbgr.mr_n66594016)
print v(xbgr.mr_n66594128)
print v(xbgr.mr_n66594448)
print v(xbgr.mr_n66594560)
print v(xbgr.mr_n66594880)
print v(xbgr.mr_n66594992)
print v(xbgr.mr_n66595312)
print v(xbgr.mr_n66595424)
print v(xbgr.mr_n66595744)
print v(xbgr.mr_n66595856)
print v(xbgr.mr_n66596176)
print v(xbgr.mr_n66596288)
print v(xbgr.mr_n66596608)
print v(xbgr.mr_n66596720)
print v(xbgr.mr_n66597040)
print v(xbgr.mr_n66597152)
print v(xbgr.mr_n66597472)
print v(xbgr.mr_n66597584)
print v(xbgr.mr_n66597904)
print v(xbgr.mr_n66598016)
print v(xbgr.mr_n66598336)
print v(xbgr.mr_n66598448)
print v(xbgr.mr_n66598768)
print v(xbgr.mr_n66598880)
print v(xbgr.mr_n66599200)
print v(xbgr.mr_n66599312)
print v(xbgr.mr_n66599632)
print v(xbgr.mr_n66599744)
print v(xbgr.mr_n66600064)
print v(xbgr.mr_n66600176)
print v(xbgr.mr_n66600496)
print v(xbgr.mr_n66600608)
print v(xbgr.mr_n66600928)
print v(xbgr.mr_n66601040)
print v(xbgr.mr_n66601360)
print v(xbgr.mr_n66601472)
print v(xbgr.mr_n66601792)
print v(xbgr.mr_n66601904)
print v(xbgr.mr_n66602224)
print v(xbgr.mr_n66602336)
print v(xbgr.mr_n66602656)
print v(xbgr.mr_n66602768)
print v(xbgr.mr_n66603088)
print v(xbgr.mr_n66603200)
print v(xbgr.mr_n66603520)
print v(xbgr.mr_n66603632)
print v(xbgr.mr_n66603952)
print v(xbgr.mr_n66604064)
print v(xbgr.mr_n66604384)
print v(xbgr.mr_n66604496)
print v(xbgr.mr_n66604816)
print v(xbgr.mr_n66604928)
print v(xbgr.mr_n66605248)
print v(xbgr.mr_n66605360)
print v(xbgr.mr_n66605680)
print v(xbgr.mr_n66605792)
print v(xbgr.mr_n66606112)
print v(xbgr.mr_n66606224)
print v(xbgr.mr_n66606544)
print v(xbgr.mr_n66606656)
print v(xbgr.mr_n66606976)
print v(xbgr.mr_n66607088)
print v(xbgr.mr_n66607408)
print v(xbgr.mr_n66607520)
print v(xbgr.mr_n66607840)
print v(xbgr.mr_n66607952)
print v(xbgr.mr_n66608272)
print v(xbgr.mr_n66608384)
print v(xbgr.mr_n66608704)
print v(xbgr.mr_n66608816)
print v(xbgr.mr_n66609136)
print v(xbgr.mr_n66609248)
print v(xbgr.mr_n66609568)
print v(xbgr.mr_n66609680)
print v(xbgr.mr_n66610000)
print v(xbgr.mr_n66610112)
print v(xbgr.mr_n66610432)
print v(xbgr.mr_n66610544)
print v(xbgr.mr_n66610864)
print v(xbgr.mr_n66610976)
print v(xbgr.mr_n66611296)
print v(xbgr.mr_n66611408)
print v(xbgr.mr_n66611728)
print v(xbgr.mr_n66611840)
print v(xbgr.mr_n66612160)
print v(xbgr.mr_n66612272)
print v(xbgr.mr_n66612592)
print v(xbgr.mr_n66612704)
print v(xbgr.mr_n66613024)
print v(xbgr.mr_n66613136)
print v(xbgr.mr_n66613456)
print v(xbgr.mr_n66613568)
print v(xbgr.mr_n66613888)
print v(xbgr.mr_n66614000)
print v(xbgr.mr_n66614320)
print v(xbgr.mr_n66614432)
print v(xbgr.mr_n66614752)
print v(xbgr.mr_n66614864)
print v(xbgr.mr_n66615184)
print v(xbgr.mr_n66615296)
print v(xbgr.mr_n66615616)
print v(xbgr.mr_n66615728)
print v(xbgr.mr_n66616048)
print v(xbgr.mr_n66616160)
print v(xbgr.mr_n66616480)
print v(xbgr.mr_n66616592)
print v(xbgr.mr_n66616912)
print v(xbgr.mr_n66617024)
print v(xbgr.mr_n66617344)
print v(xbgr.mr_n66617456)
print v(xbgr.mr_n66617776)
print v(xbgr.mr_n66617888)
print v(xbgr.mr_n66618208)
print v(xbgr.mr_n66618320)
print v(xbgr.mr_n66618640)
print v(xbgr.mr_n66618752)
print v(xbgr.mr_n66619072)
print v(xbgr.mr_n66619184)
print v(xbgr.mr_n66619504)
print v(xbgr.mr_n66619616)
print v(xbgr.mr_n66619936)
print v(xbgr.mr_n66620048)
print v(xbgr.mr_n66620368)
print v(xbgr.mr_n66620480)
print v(xbgr.mr_n66620800)
print v(xbgr.mr_n66620912)
print v(xbgr.mr_n66621232)
print v(xbgr.mr_n66621344)
print v(xbgr.mr_n66621664)
print v(xbgr.mr_n66621776)
print v(xbgr.mr_n66622096)
print v(xbgr.mr_n66622208)
print v(xbgr.mr_n66622528)
print v(xbgr.mr_n66622640)
print v(xbgr.mr_n66622960)
print v(xbgr.mr_n66623072)
print v(xbgr.mr_n66623392)
print v(xbgr.mr_n66623504)
print v(xbgr.mr_n66623824)
print v(xbgr.mr_n66623936)
print v(xbgr.mr_n66624256)
print v(xbgr.mr_n66624368)
print v(xbgr.mr_n66624688)
print v(xbgr.mr_n66624800)
print v(xbgr.mr_n66625120)
print v(xbgr.mr_n66625232)
print v(xbgr.mr_n66625552)
print v(xbgr.mr_n66625664)
print v(xbgr.mr_n66625984)
print v(xbgr.mr_n66626096)
print v(xbgr.mr_n66626416)
print v(xbgr.mr_n66626528)
print v(xbgr.mr_n66626848)
print v(xbgr.mr_n66626960)
print v(xbgr.mr_n66627280)
print v(xbgr.mr_n66627392)
print v(xbgr.mr_n66627712)
print v(xbgr.mr_n66627824)
print v(xbgr.mr_n66628144)
print v(xbgr.mr_n66628256)
print v(xbgr.mr_n66628576)
print v(xbgr.mr_n66628688)
print v(xbgr.mr_n66629008)
print v(xbgr.mr_n66629120)
print v(xbgr.mr_n66629552)
print v(xbgr.mr_n66629872)
print v(xbgr.mr_n66629984)
print v(xbgr.mr_n66630304)
print v(xbgr.mr_n66630416)
print v(xbgr.mr_n66630736)
print v(xbgr.mr_n66630848)
print v(xbgr.mr_n66631168)
print v(xbgr.mr_n66631280)
print v(xbgr.mr_n66631600)
print v(xbgr.mr_n66632464)
print v(xbgr.mr_n66632576)
print v(xbgr.mr_n66632896)
print v(xbgr.mr_n66633008)
print v(xbgr.mr_n66633328)
print v(xbgr.mr_n66633440)
print v(xbgr.mr_n66633760)
print v(xbgr.mr_n66633872)
print v(xbgr.mr_n66634192)
print v(xbgr.mr_n66634304)
print v(xbgr.mr_n66634624)
print v(xbgr.mr_n66634736)
print v(xbgr.mr_n66635056)
print v(xbgr.mr_n66635168)
print v(xbgr.mr_n66635488)
print v(xbgr.mr_n66635600)
print v(xbgr.mr_n66635920)
print v(xbgr.mr_n66636032)
print v(xbgr.mr_n66636352)
print v(xbgr.mr_n66636464)
print v(xbgr.mr_n66636784)
print v(xbgr.mr_n66636896)
print v(xbgr.mr_n66637328)
print v(xbgr.mr_n66637648)
print v(xbgr.mr_n66637760)
print v(xbgr.mr_n66638080)
print v(xbgr.mr_n66638192)
print v(xbgr.mr_n66638512)
print v(xbgr.mr_n66638624)
print v(xbgr.mr_n66638944)
print v(xbgr.mr_n66639056)
print v(xbgr.mr_n66639376)
print v(xbgr.mr_n66639488)
print v(xbgr.mr_n66639808)
print v(xbgr.mr_n66639920)
print v(xbgr.mr_n66640240)
print v(xbgr.mr_n66640352)
print v(xbgr.mr_n66640672)
print v(xbgr.mr_n66640784)
print v(xbgr.mr_n66641104)
print v(xbgr.mr_n66641216)
print v(xbgr.mr_n66641536)
print v(xbgr.mr_n66641648)
print v(xbgr.mr_n66641968)
print v(xbgr.mr_n66642080)
print v(xbgr.mr_n66642400)
print v(xbgr.mr_n66642512)
print v(xbgr.mr_n66642832)
print v(xbgr.mr_n66642944)
print v(xbgr.mr_n66643264)
print v(xbgr.mr_n66643376)
print v(xbgr.mr_n66643696)
print v(xbgr.mr_n66643808)
print v(xbgr.mr_n66644128)
print v(xbgr.mr_n66644240)
print v(xbgr.mr_n66644560)
print v(xbgr.mr_n66644672)
print v(xbgr.mr_n66644992)
print v(xbgr.mr_n66645104)
print v(xbgr.mr_n66645424)
print v(xbgr.mr_n66645536)
print v(xbgr.mr_n66645856)
print v(xbgr.mr_n66645968)
print v(xbgr.mr_n66646288)
print v(xbgr.mr_n66646400)
print v(xbgr.mr_n66646720)
print v(xbgr.mr_n66646832)
print v(xbgr.mr_n66647152)
print v(xbgr.mr_n66647264)
print v(xbgr.mr_n66647584)
print v(xbgr.mr_n66647696)
print v(xbgr.mr_n66648016)
print v(xbgr.mr_n66648128)
print v(xbgr.mr_n66648448)
print v(xbgr.mr_n66648560)
print v(xbgr.mr_n66648880)
print v(xbgr.mr_n66648992)
print v(xbgr.mr_n66649312)
print v(xbgr.mr_n66649424)
print v(xbgr.mr_n66649744)
print v(xbgr.mr_n66649856)
print v(xbgr.mr_n66650176)
print v(xbgr.mr_n66650288)
print v(xbgr.mr_n66650608)
print v(xbgr.mr_n66650720)
print v(xbgr.mr_n66651040)
print v(xbgr.mr_n66651152)
print v(xbgr.mr_n66651472)
print v(xbgr.mr_n66651584)
print v(xbgr.mr_n66651904)
print v(xbgr.mr_n66652016)
print v(xbgr.mr_n66652336)
print v(xbgr.mr_n66652448)
print v(xbgr.mr_n66652768)
print v(xbgr.mr_n66652880)
print v(xbgr.mr_n66653200)
print v(xbgr.mr_n66653312)
print v(xbgr.mr_n66653632)
print v(xbgr.mr_n66653744)
print v(xbgr.mr_n66654064)
print v(xbgr.mr_n66654928)
print v(xbgr.mr_n66655040)
print v(xbgr.mr_n66655360)
print v(xbgr.mr_n66655472)
print v(xbgr.mr_n66655792)
print v(xbgr.mr_n66655904)
print v(xbgr.mr_n66656224)
print v(xbgr.mr_n66656336)
print v(xbgr.mr_n66656656)
print v(xbgr.mr_n66656768)
print v(xbgr.mr_n66657088)
print v(xbgr.mr_n66657200)
print v(xbgr.mr_n66657520)
print v(xbgr.mr_n66657632)
print v(xbgr.mr_n66657952)
print v(xbgr.mr_n66658064)
print v(xbgr.mr_n66658384)
print v(xbgr.mr_n66658496)
print v(xbgr.mr_n66658816)
print v(xbgr.mr_n66658928)
print v(xbgr.mr_n66659248)
print v(xbgr.mr_n66659360)
print v(xbgr.mr_n66659680)
print v(xbgr.mr_n66659792)
print v(xbgr.mr_n66660112)
print v(xbgr.mr_n66660224)
print v(xbgr.mr_n66660544)
print v(xbgr.mr_n66660656)
print v(xbgr.mr_n66660976)
print v(xbgr.mr_n66661088)
print v(xbgr.mr_n66661408)
print v(xbgr.mr_n66661520)
print v(xbgr.mr_n66661840)
print v(xbgr.mr_n66661952)
print v(xbgr.mr_n66662272)
print v(xbgr.mr_n66662384)
print v(xbgr.mr_n66662704)
print v(xbgr.mr_n66662816)
print v(xbgr.mr_n66663136)
print v(xbgr.mr_n66663248)
print v(xbgr.mr_n66663568)
print v(xbgr.mr_n66663680)
print v(xbgr.mr_n66664000)
print v(xbgr.mr_n66664112)
print v(xbgr.mr_n66664432)
print v(xbgr.mr_n66664544)
print v(xbgr.mr_n66664864)
print v(xbgr.mr_n66664976)
print v(xbgr.mr_n66665296)
print v(xbgr.mr_n66665408)
print v(xbgr.mr_n66665728)
print v(xbgr.mr_n66665840)
print v(xbgr.mr_n66666160)
print v(xbgr.mr_n66666272)
print v(xbgr.mr_n66666592)
print v(xbgr.mr_n66666704)
print v(xbgr.mr_n66667024)
print v(xbgr.mr_n66667136)
print v(xbgr.mr_n66667456)
print v(xbgr.mr_n66667568)
print v(xbgr.mr_n66667888)
print v(xbgr.mr_n66668000)
print v(xbgr.mr_n66668320)
print v(xbgr.mr_n66668432)
print v(xbgr.mr_n66668752)
print v(xbgr.mr_n66668864)
print v(xbgr.mr_n66669184)
print v(xbgr.mr_n66669296)
print v(xbgr.mr_n66669616)
print v(xbgr.mr_n66669728)
print v(xbgr.mr_n66670048)
print v(xbgr.mr_n66670160)
print v(xbgr.mr_n66670480)
print v(xbgr.mr_n66670592)
print v(xbgr.mr_n66670912)
print v(xbgr.mr_n66671024)
print v(xbgr.mr_n66671344)
print v(xbgr.mr_n66671456)
print v(xbgr.mr_n66671776)
print v(xbgr.mr_n66671888)
print v(xbgr.mr_n66672208)
print v(xbgr.mr_n66672320)
print v(xbgr.mr_n66672640)
print v(xbgr.mr_n66672752)
print v(xbgr.mr_n66673072)
print v(xbgr.mr_n66673184)
print v(xbgr.mr_n66673504)
print v(xbgr.mr_n66673616)
print v(xbgr.mr_n66673936)
print v(xbgr.mr_n66674048)
print v(xbgr.mr_n66674368)
print v(xbgr.mr_n66674480)
print v(xbgr.mr_n66674800)
print v(xbgr.mr_n66674912)
print v(xbgr.mr_n66675232)
print v(xbgr.mr_n66675344)
print v(xbgr.mr_n66675664)
print v(xbgr.mr_n66675776)
print v(xbgr.mr_n66676096)
print v(xbgr.mr_n66676208)
print v(xbgr.mr_n66676528)
print v(xbgr.mr_n66676640)
print v(xbgr.mr_n66676960)
print v(xbgr.mr_n66677072)
print v(xbgr.mr_n66677392)
print v(xbgr.mr_n66677504)
print v(xbgr.mr_n66677824)
print v(xbgr.mr_n66677936)
print v(xbgr.mr_n66678256)
print v(xbgr.mr_n66678368)
print v(xbgr.mr_n66678688)
print v(xbgr.mr_n66678800)
print v(xbgr.mr_n66679120)
print v(xbgr.mr_n66679232)
print v(xbgr.mr_n66679552)
print v(xbgr.mr_n66679664)
print v(xbgr.mr_n66679984)
print v(xbgr.mr_n66680096)
print v(xbgr.mr_n66680416)
print v(xbgr.mr_n66680528)
print v(xbgr.mr_n66680848)
print v(xbgr.mr_n66680960)
print v(xbgr.mr_n66681280)
print v(xbgr.mr_n66681392)
print v(xbgr.mr_n66681712)
print v(xbgr.mr_n66681824)
print v(xbgr.mr_n66682144)
print v(xbgr.mr_n66682256)
print v(xbgr.mr_n66682576)
print v(xbgr.mr_n66682688)
print v(xbgr.mr_n66683008)
print v(xbgr.mr_n66683120)
print v(xbgr.mr_n66683440)
print v(xbgr.mr_n66683552)
print v(xbgr.mr_n66683872)
print v(xbgr.mr_n66683984)
print v(xbgr.mr_n66684304)
print v(xbgr.mr_n66684416)
print v(xbgr.mr_n66684736)
print v(xbgr.mr_n66684848)
print v(xbgr.mr_n66685168)
print v(xbgr.mr_n66685280)
print v(xbgr.mr_n66685600)
print v(xbgr.mr_n66685712)
print v(xbgr.mr_n66686032)
print v(xbgr.mr_n66686144)
print v(xbgr.mr_n66686464)
print v(xbgr.mr_n66686576)
print v(xbgr.mr_n66686896)
print v(xbgr.mr_n66687008)
print v(xbgr.mr_n66687328)
print v(xbgr.mr_n66687440)
print v(xbgr.mr_n66687760)
print v(xbgr.mr_n66687872)
print v(xbgr.mr_n66688192)
print v(xbgr.mr_n66688304)
print v(xbgr.mr_n66688624)
print v(xbgr.mr_n66688736)
print v(xbgr.mr_n66689056)
print v(xbgr.mr_n66689168)
print v(xbgr.mr_n66689488)
print v(xbgr.mr_n66689600)
print v(xbgr.mr_n66689920)
print v(xbgr.mr_n66690032)
print v(xbgr.mr_n66690352)
print v(xbgr.mr_n66690464)
print v(xbgr.mr_n66690784)
print v(xbgr.mr_n66690896)
print v(xbgr.mr_n66691216)
print v(xbgr.mr_n66691328)
print v(xbgr.mr_n66691648)
print v(xbgr.mr_n66691760)
print v(xbgr.mr_n66692080)
print v(xbgr.mr_n66692192)
print v(xbgr.mr_n66692512)
print v(xbgr.mr_n66692624)
print v(xbgr.mr_n66692944)
print v(xbgr.mr_n66693056)
print v(xbgr.mr_n66693376)
print v(xbgr.mr_n66693488)
print v(xbgr.mr_n66693808)
print v(xbgr.mr_n66693920)
print v(xbgr.mr_n66694240)
print v(xbgr.mr_n66694352)
print v(xbgr.mr_n66694672)
print v(xbgr.mr_n66694784)
print v(xbgr.mr_n66695104)
print v(xbgr.mr_n66695216)
print v(xbgr.mr_n66695536)
print v(xbgr.mr_n66695648)
print v(xbgr.mr_n66695968)
print v(xbgr.mr_n66696080)
print v(xbgr.mr_n66696400)
print v(xbgr.mr_n66696512)
print v(xbgr.mr_n66696832)
print v(xbgr.mr_n66696944)
print v(xbgr.mr_n66697264)
print v(xbgr.mr_n66697376)
print v(xbgr.mr_n66697696)
print v(xbgr.mr_n66697808)
print v(xbgr.mr_n66698128)
print v(xbgr.mr_n66698240)
print v(xbgr.mr_n66698560)
print v(xbgr.mr_n66698672)
print v(xbgr.mr_n66698992)
print v(xbgr.mr_n66699104)
print v(xbgr.mr_n66699424)
print v(xbgr.mr_n66699536)
print v(xbgr.mr_n66699856)
print v(xbgr.mr_n66699968)
print v(xbgr.mr_n66700288)
print v(xbgr.mr_n66700400)
print v(xbgr.mr_n66700720)
print v(xbgr.mr_n66700832)
print v(xbgr.mr_n66701152)
print v(xbgr.mr_n66701264)
print v(xbgr.mr_n66701584)
print v(xbgr.mr_n66701696)
print v(xbgr.mr_n66702016)
print v(xbgr.mr_n66702128)
print v(xbgr.mr_n66702448)
print v(xbgr.mr_n66702560)
print v(xbgr.mr_n66702880)
print v(xbgr.mr_n66702992)
print v(xbgr.mr_n66703312)
print v(xbgr.mr_n66703424)
print v(xbgr.mr_n66703744)
print v(xbgr.mr_n66703856)
print v(xbgr.mr_n66704176)
print v(xbgr.mr_n66704288)
print v(xbgr.mr_n66704608)
print v(xbgr.mr_n66704720)
print v(xbgr.mr_n66705040)
print v(xbgr.mr_n66705152)
print v(xbgr.mr_n66705472)
print v(xbgr.mr_n66705584)
print v(xbgr.mr_n66705904)
print v(xbgr.mr_n66706016)
print v(xbgr.mr_n66706336)
print v(xbgr.mr_n66706448)
print v(xbgr.mr_n66706768)
print v(xbgr.mr_n66706880)
print v(xbgr.mr_n66707200)
print v(xbgr.mr_n66707312)
print v(xbgr.mr_n66707632)
print v(xbgr.mr_n66707744)
print v(xbgr.mr_n66708064)
print v(xbgr.mr_n66708176)
print v(xbgr.mr_n66708496)
print v(xbgr.mr_n66708608)
print v(xbgr.mr_n66708928)
print v(xbgr.mr_n66709040)
print v(xbgr.mr_n66709360)
print v(xbgr.mr_n66709472)
print v(xbgr.mr_n66709792)
print v(xbgr.mr_n66709904)
print v(xbgr.mr_n66710224)
print v(xbgr.mr_n66710336)
print v(xbgr.mr_n66710656)
print v(xbgr.mr_n66710768)
print v(xbgr.mr_n66711088)
print v(xbgr.mr_n66711200)
print v(xbgr.mr_n66711520)
print v(xbgr.mr_n66711632)
print v(xbgr.mr_n66711952)
print v(xbgr.mr_n66712064)
print v(xbgr.mr_n66712384)
print v(xbgr.mr_n66712496)
print v(xbgr.mr_n66712816)
print v(xbgr.mr_n66712928)
print v(xbgr.mr_n66713248)
print v(xbgr.mr_n66713360)
print v(xbgr.mr_n66713680)
print v(xbgr.mr_n66713792)
print v(xbgr.mr_n66714112)
print v(xbgr.mr_n66714224)
print v(xbgr.mr_n66714544)
print v(xbgr.mr_n66714656)
print v(xbgr.mr_n66714976)
print v(xbgr.mr_n66715088)
print v(xbgr.mr_n66715408)
print v(xbgr.mr_n66715520)
print v(xbgr.mr_n66715840)
print v(xbgr.mr_n66715952)
print v(xbgr.mr_n66716272)
print v(xbgr.mr_n66716384)
print v(xbgr.mr_n66716704)
print v(xbgr.mr_n66716816)
print v(xbgr.mr_n66717136)
print v(xbgr.mr_n66717248)
print v(xbgr.mr_n66717568)
print v(xbgr.mr_n66717680)
print v(xbgr.mr_n66718000)
print v(xbgr.mr_n66718112)
print v(xbgr.mr_n66718432)
print v(xbgr.mr_n66718544)
print v(xbgr.mr_n66718864)
print v(xbgr.mr_n66718976)
print v(xbgr.mr_n66719296)
print v(xbgr.mr_n66719408)
print v(xbgr.mr_n66719728)
print v(xbgr.mr_n66719840)
print v(xbgr.mr_n66720160)
print v(xbgr.mr_n66720272)
print v(xbgr.mr_n66720592)
print v(xbgr.mr_n66720704)
print v(xbgr.mr_n66721024)
print v(xbgr.mr_n66721136)
print v(xbgr.mr_n66721456)
print v(xbgr.mr_n66721568)
print v(xbgr.mr_n66721888)
print v(xbgr.mr_n66722000)
print v(xbgr.mr_n66722320)
print v(xbgr.mr_n66722432)
print v(xbgr.mr_n66722752)
print v(xbgr.mr_n66722864)
print v(xbgr.mr_n66723184)
print v(xbgr.mr_n66723296)
print v(xbgr.mr_n66723616)
print v(xbgr.mr_n66723728)
print v(xbgr.mr_n66724048)
print v(xbgr.mr_n66724160)
print v(xbgr.mr_n66724480)
print v(xbgr.mr_n66724592)
print v(xbgr.mr_n66724912)
print v(xbgr.mr_n66725024)
print v(xbgr.mr_n66725344)
print v(xbgr.mr_n66725456)
print v(xbgr.mr_n66725776)
print v(xbgr.mr_n66725888)
print v(xbgr.mr_n66726208)
print v(xbgr.mr_n66726320)
print v(xbgr.mr_n66726640)
print v(xbgr.mr_n66726752)
print v(xbgr.mr_n66727072)
print v(xbgr.mr_n66727184)
print v(xbgr.mr_n66727504)
print v(xbgr.mr_n66727616)
print v(xbgr.mr_n66727936)
print v(xbgr.mr_n66728048)
print v(xbgr.mr_n66728368)
print v(xbgr.mr_n66728480)
print v(xbgr.mr_n66728800)
print v(xbgr.mr_n66728912)
print v(xbgr.mr_n66729232)
print v(xbgr.mr_n66729344)
print v(xbgr.mr_n66729664)
print v(xbgr.mr_n66729776)
print v(xbgr.mr_n66730096)
print v(xbgr.mr_n66730208)
print v(xbgr.mr_n66730528)
print v(xbgr.mr_n66730640)
print v(xbgr.mr_n66730960)
print v(xbgr.mr_n66731072)
print v(xbgr.mr_n66731392)
print v(xbgr.mr_n66731504)
print v(xbgr.mr_n66731824)
print v(xbgr.mr_n66731936)
print v(xbgr.mr_n66732256)
print v(xbgr.mr_n66732368)
print v(xbgr.mr_n66732688)
print v(xbgr.mr_n66732800)
print v(xbgr.mr_n66733120)
print v(xbgr.mr_n66733232)
print v(xbgr.mr_n66733552)
print v(xbgr.mr_n66733664)
print v(xbgr.mr_n66733984)
print v(xbgr.mr_n66734096)
print v(xbgr.mr_n66734416)
print v(xbgr.mr_n66734528)
print v(xbgr.mr_n66734848)
print v(xbgr.mr_n66734960)
print v(xbgr.mr_n66735280)
print v(xbgr.mr_n66735392)
print v(xbgr.mr_n66735712)
print v(xbgr.mr_n66735824)
print v(xbgr.mr_n66736144)
print v(xbgr.mr_n66736256)
print v(xbgr.mr_n66736576)
print v(xbgr.mr_n66736688)
print v(xbgr.mr_n66737008)
print v(xbgr.mr_n66737120)
print v(xbgr.mr_n66737440)
print v(xbgr.mr_n66737552)
print v(xbgr.mr_n66737872)
print v(xbgr.mr_n66737984)
print v(xbgr.mr_n66738304)
print v(xbgr.mr_n66738416)
print v(xbgr.mr_n66738736)
print v(xbgr.mr_n66738848)
print v(xbgr.mr_n66739168)
print v(xbgr.mr_n66739280)
print v(xbgr.mr_n66739600)
print v(xbgr.mr_n66739712)
print v(xbgr.mr_n66740032)
print v(xbgr.mr_n66740144)
print v(xbgr.mr_n66740464)
print v(xbgr.mr_n66740576)
print v(xbgr.mr_n66740896)
print v(xbgr.mr_n66741008)
print v(xbgr.mr_n66741328)
print v(xbgr.mr_n66741440)
print v(xbgr.mr_n66741760)
print v(xbgr.mr_n66741872)
print v(xbgr.mr_n66742192)
print v(xbgr.mr_n66742304)
print v(xbgr.mr_n66742624)
print v(xbgr.mr_n66742736)
print v(xbgr.mr_n66743056)
print v(xbgr.mr_n66743168)
print v(xbgr.mr_n66743488)
print v(xbgr.mr_n66743600)
print v(xbgr.mr_n66743920)
print v(xbgr.mr_n66744032)
print v(xbgr.mr_n66744352)
print v(xbgr.mr_n66744464)
print v(xbgr.mr_n66744784)
print v(xbgr.mr_n66744896)
print v(xbgr.mr_n66745216)
print v(xbgr.mr_n66745328)
print v(xbgr.mr_n66745648)
print v(xbgr.mr_n66745760)
print v(xbgr.mr_n66746080)
print v(xbgr.mr_n66746192)
print v(xbgr.mr_n66746512)
print v(xbgr.mr_n66746624)
print v(xbgr.mr_n66746944)
print v(xbgr.mr_n66747056)
print v(xbgr.mr_n66747376)
print v(xbgr.mr_n66747488)
print v(xbgr.mr_n66747808)
print v(xbgr.mr_n66747920)
print v(xbgr.mr_n66748240)
print v(xbgr.mr_n66748352)
print v(xbgr.mr_n66748672)
print v(xbgr.mr_n66748784)
print v(xbgr.mr_n66749104)
print v(xbgr.mr_n66749216)
print v(xbgr.mr_n66749536)
print v(xbgr.mr_n66749648)
print v(xbgr.mr_n66749968)
print v(xbgr.mr_n66750080)
print v(xbgr.mr_n66750400)
print v(xbgr.mr_n66750512)
print v(xbgr.mr_n66750832)
print v(xbgr.mr_n66750944)
print v(xbgr.mr_n66751264)
print v(xbgr.mr_n66751376)
print v(xbgr.mr_n66751696)
print v(xbgr.mr_n66751808)
print v(xbgr.mr_n66752128)
print v(xbgr.mr_n66752240)
print v(xbgr.mr_n66752560)
print v(xbgr.mr_n66752672)
print v(xbgr.mr_n66752992)
print v(xbgr.mr_n66753104)
print v(xbgr.mr_n66753424)
print v(xbgr.mr_n66753536)
print v(xbgr.mr_n66753856)
print v(xbgr.mr_n66753968)
print v(xbgr.mr_n66754288)
print v(xbgr.mr_n66754400)
print v(xbgr.mr_n66754720)
print v(xbgr.mr_n66754832)
print v(xbgr.mr_n66755152)
print v(xbgr.mr_n66755264)
print v(xbgr.mr_n66755584)
print v(xbgr.mr_n66755696)
print v(xbgr.mr_n66756016)
print v(xbgr.mr_n66756128)
print v(xbgr.mr_n66756448)
print v(xbgr.mr_n66756560)
print v(xbgr.mr_n66756880)
print v(xbgr.mr_n66756992)
print v(xbgr.mr_n66757312)
print v(xbgr.mr_n66757424)
print v(xbgr.mr_n66757744)
print v(xbgr.mr_n66757856)
print v(xbgr.mr_n66758176)
print v(xbgr.mr_n66758288)
print v(xbgr.mr_n66758608)
print v(xbgr.mr_n66758720)
print v(xbgr.mr_n66759040)
print v(xbgr.mr_n66759152)
print v(xbgr.mr_n66759472)
print v(xbgr.mr_n66759584)
print v(xbgr.mr_n66759904)
print v(xbgr.mr_n66760016)
print v(xbgr.mr_n66760336)
print v(xbgr.mr_n66760448)
print v(xbgr.mr_n66760768)
print v(xbgr.mr_n66760880)
print v(xbgr.mr_n66761200)
print v(xbgr.mr_n66761312)
print v(xbgr.mr_n66761632)
print v(xbgr.mr_n66761744)
print v(xbgr.mr_n66762064)
print v(xbgr.mr_n66762176)
print v(xbgr.mr_n66762496)
print v(xbgr.mr_n66762608)
print v(xbgr.mr_n66762928)
print v(xbgr.mr_n66763040)
print v(xbgr.mr_n66763360)
print v(xbgr.mr_n66763472)
print v(xbgr.mr_n66763792)
print v(xbgr.mr_n66763904)
print v(xbgr.mr_n66764224)
print v(xbgr.mr_n66764336)
print v(xbgr.mr_n66764656)
print v(xbgr.mr_n66764768)
print v(xbgr.mr_n66765088)
print v(xbgr.mr_n66765200)
print v(xbgr.mr_n66765520)
print v(xbgr.mr_n66765632)
print v(xbgr.mr_n66765952)
print v(xbgr.mr_n66766064)
print v(xbgr.mr_n66766384)
print v(xbgr.mr_n66766496)
print v(xbgr.mr_n66766816)
print v(xbgr.mr_n66766928)
print v(xbgr.mr_n66767248)
print v(xbgr.mr_n66767360)
print v(xbgr.mr_n66767680)
print v(xbgr.mr_n66767792)
print v(xbgr.mr_n66768112)
print v(xbgr.mr_n66768224)
print v(xbgr.mr_n66768544)
print v(xbgr.mr_n66768656)
print v(xbgr.mr_n66768976)
print v(xbgr.mr_n66769088)
print v(xbgr.mr_n66769408)
print v(xbgr.mr_n66769520)
print v(xbgr.mr_n66769840)
print v(xbgr.mr_n66769952)
print v(xbgr.mr_n66770272)
print v(xbgr.mr_n66770384)
print v(xbgr.mr_n66770704)
print v(xbgr.mr_n66770816)
print v(xbgr.mr_n66771136)
print v(xbgr.mr_n66771248)
print v(xbgr.mr_n66771568)
print v(xbgr.mr_n66771680)
print v(xbgr.mr_n66772000)
print v(xbgr.mr_n66772112)
print v(xbgr.mr_n66772432)
print v(xbgr.mr_n66772544)
print v(xbgr.mr_n66772864)
print v(xbgr.mr_n66772976)
print v(xbgr.mr_n66773296)
print v(xbgr.mr_n66773408)
print v(xbgr.mr_n66773728)
print v(xbgr.mr_n66773840)
print v(xbgr.mr_n66774160)
print v(xbgr.mr_n66774272)
print v(xbgr.mr_n66774592)
print v(xbgr.mr_n66774704)
print v(xbgr.mr_n66775024)
print v(xbgr.mr_n66775136)
print v(xbgr.mr_n66775456)
print v(xbgr.mr_n66775568)
print v(xbgr.mr_n66775888)
print v(xbgr.mr_n66776000)
print v(xbgr.mr_n66776320)
print v(xbgr.mr_n66776432)
print v(xbgr.mr_n66776752)
print v(xbgr.mr_n66776864)
print v(xbgr.mr_n66777184)
print v(xbgr.mr_n66777296)
print v(xbgr.mr_n66777616)
print v(xbgr.mr_n66777728)
print v(xbgr.mr_n66778048)
print v(xbgr.mr_n66778160)
print v(xbgr.mr_n66778480)
print v(xbgr.mr_n66778592)
print v(xbgr.mr_n66778912)
print v(xbgr.mr_n66779024)
print v(xbgr.mr_n66779344)
print v(xbgr.mr_n66779456)
print v(xbgr.mr_n66779776)
print v(xbgr.mr_n66779888)
print v(xbgr.mr_n66780208)
print v(xbgr.mr_n66780320)
print v(xbgr.mr_n66780640)
print v(xbgr.mr_n66780752)
print v(xbgr.mr_n66781072)
print v(xbgr.mr_n66781184)
print v(xbgr.mr_n66781616)
print v(xbgr.mr_n66781936)
print v(xbgr.mr_n66782048)
print v(xbgr.mr_n66782368)
print v(xbgr.mr_n66782480)
print v(xbgr.mr_n66782800)
print v(xbgr.mr_n66782912)
print v(xbgr.mr_n66783344)
print v(xbgr.mr_n66783664)
print v(xbgr.mr_n66783776)
print v(xbgr.mr_n66784096)
print v(xbgr.mr_n66784208)
print v(xbgr.mr_n66784528)
print v(xbgr.mr_n66784640)
print v(xbgr.mr_n66784960)
print v(xbgr.mr_n66785072)
print v(xbgr.mr_n66785392)
print v(xbgr.mr_n66785504)
print v(xbgr.mr_n66785824)
print v(xbgr.mr_n66785936)
print v(xbgr.mr_n66786256)
print v(xbgr.mr_n66786368)
print v(xbgr.mr_n66786688)
print v(xbgr.mr_n66786800)
print v(xbgr.mr_n66787120)
print v(xbgr.mr_n66787232)
print v(xbgr.mr_n66787552)
print v(xbgr.mr_n66787664)
print v(xbgr.mr_n66787984)
print v(xbgr.mr_n66788096)
print v(xbgr.mr_n66788416)
print v(xbgr.mr_n66788528)
print v(xbgr.mr_n66788848)
print v(xbgr.mr_n66788960)
print v(xbgr.mr_n66789280)
print v(xbgr.mr_n66789392)
print v(xbgr.mr_n66789712)
print v(xbgr.mr_n66789824)
print v(xbgr.mr_n66790256)
print v(xbgr.mr_n66790576)
print v(xbgr.mr_n66790688)
print v(xbgr.mr_n66791008)
print v(xbgr.mr_n66791120)
print v(xbgr.mr_n66791440)
print v(xbgr.mr_n66791552)
print v(xbgr.mr_n66791872)
print v(xbgr.mr_n66791984)
print v(xbgr.mr_n66792304)
print v(xbgr.mr_n66792416)
print v(xbgr.mr_n66792736)
print v(xbgr.mr_n66792848)
print v(xbgr.mr_n66793168)
print v(xbgr.mr_n66793280)
print v(xbgr.mr_n66793712)
print v(xbgr.mr_n66794032)
print v(xbgr.mr_n66794144)
print v(xbgr.mr_n66794464)
print v(xbgr.mr_n66794576)
print v(xbgr.mr_n66794896)
print v(xbgr.mr_n66795008)
print v(xbgr.mr_n66795328)
print v(xbgr.mr_n66795440)
print v(xbgr.mr_n66795760)
print v(xbgr.mr_n66795872)
print v(xbgr.mr_n66796192)
print v(xbgr.mr_n66796304)
print v(xbgr.mr_n66796624)
print v(xbgr.mr_n66796736)
print v(xbgr.mr_n66797056)
print v(xbgr.mr_n66797168)
print v(xbgr.mr_n66797488)
print v(xbgr.mr_n66797600)
print v(xbgr.mr_n66797920)
print v(xbgr.mr_n66798032)
print v(xbgr.mr_n66798352)
print v(xbgr.mr_n66798464)
print v(xbgr.mr_n66798784)
print v(xbgr.mr_n66798896)
print v(xbgr.mr_n66799216)
print v(xbgr.mr_n66799328)
print v(xbgr.mr_n66799760)
print v(xbgr.mr_n66800080)
print v(xbgr.mr_n66800192)
print v(xbgr.mr_n66800512)
print v(xbgr.mr_n66800624)
print v(xbgr.mr_n66800944)
print v(xbgr.mr_n66801056)
print v(xbgr.mr_n66801488)
print v(xbgr.mr_n66801808)
print v(xbgr.mr_n66801920)
print v(xbgr.mr_n66802240)
print v(xbgr.mr_n66802352)
print v(xbgr.mr_n66802672)
print v(xbgr.mr_n66802784)
print v(xbgr.mr_n66803104)
print v(xbgr.mr_n66803216)
print v(xbgr.mr_n66803536)
print v(xbgr.mr_n66803648)
print v(xbgr.mr_n66804080)
print v(xbgr.mr_n66804400)
print v(xbgr.mr_n66804512)
print v(xbgr.mr_n66804832)
print v(xbgr.mr_n66804944)
print v(xbgr.mr_n66805264)
print v(xbgr.mr_n66805376)
print v(xbgr.mr_n66805696)
print v(xbgr.mr_n66805808)
print v(xbgr.mr_n66806128)
print v(xbgr.mr_n66806240)
print v(xbgr.mr_n66806560)
print v(xbgr.mr_n66806672)
print v(xbgr.mr_n66806992)
print v(xbgr.mr_n66807104)
print v(xbgr.mr_n66807424)
print v(xbgr.mr_n66807536)
print v(xbgr.mr_n66807856)
print v(xbgr.mr_n66807968)
print v(xbgr.mr_n66808288)
print v(xbgr.mr_n66808400)
print v(xbgr.mr_n66808720)
print v(xbgr.mr_n66808832)
print v(xbgr.mr_n66809152)
print v(xbgr.mr_n66809264)
print v(xbgr.mr_n66809584)
print v(xbgr.mr_n66809696)
print v(xbgr.mr_n66810128)
print v(xbgr.mr_n66810448)
print v(xbgr.mr_n66810560)
print v(xbgr.mr_n66810880)
print v(xbgr.mr_n66810992)
print v(xbgr.mr_n66811312)
print v(xbgr.mr_n66811424)
print v(xbgr.mr_n66811856)
print v(xbgr.mr_n66812176)
print v(xbgr.mr_n66812288)
print v(xbgr.mr_n66812720)
print v(xbgr.mr_n66813040)
print v(xbgr.mr_n66813152)
print v(xbgr.mr_n66813472)
print v(xbgr.mr_n66813584)
print v(xbgr.mr_n66813904)
print v(xbgr.mr_n66814016)
print v(xbgr.mr_n66814448)
print v(xbgr.mr_n66814768)
print v(xbgr.mr_n66814880)
print v(xbgr.mr_n66815200)
print v(xbgr.mr_n66815312)
print v(xbgr.mr_n66815632)
print v(xbgr.mr_n66815744)
print v(xbgr.mr_n66816064)
print v(xbgr.mr_n66816176)
print v(xbgr.mr_n66816496)
print v(xbgr.mr_n66816608)
print v(xbgr.mr_n66816928)
print v(xbgr.mr_n66817040)
print v(xbgr.mr_n66817360)
print v(xbgr.mr_n66817472)
print v(xbgr.mr_n66817792)
print v(xbgr.mr_n66817904)
print v(xbgr.mr_n66818224)
print v(xbgr.mr_n66818336)
print v(xbgr.mr_n66818768)
print v(xbgr.mr_n66819088)
print v(xbgr.mr_n66819200)
print v(xbgr.mr_n66819520)
print v(xbgr.mr_n66819632)
print v(xbgr.mr_n66819952)
print v(xbgr.mr_n66820064)
print v(xbgr.mr_n66820384)
print v(xbgr.mr_n66820496)
print v(xbgr.mr_n66820816)
print v(xbgr.mr_n66820928)
print v(xbgr.mr_n66821248)
print v(xbgr.mr_n66821360)
print v(xbgr.mr_n66821680)
print v(xbgr.mr_n66821792)
print v(xbgr.mr_n66822112)
print v(xbgr.mr_n66822224)
print v(xbgr.mr_n66822544)
print v(xbgr.mr_n66822656)
print v(xbgr.mr_n66822976)
print v(xbgr.mr_n66823088)
print v(xbgr.mr_n66823408)
print v(xbgr.mr_n66823520)
print v(xbgr.mr_n66823840)
print v(xbgr.mr_n66823952)
print v(xbgr.mr_n66824272)
print v(xbgr.mr_n66824384)
print v(xbgr.mr_n66824704)
print v(xbgr.mr_n66824816)
print v(xbgr.mr_n66825136)
print v(xbgr.mr_n66825248)
print v(xbgr.mr_n66825568)
print v(xbgr.mr_n66825680)
print v(xbgr.mr_n66826000)
print v(xbgr.mr_n66826112)
print v(xbgr.mr_n66826432)
print v(xbgr.mr_n66826544)
print v(xbgr.mr_n66826864)
print v(xbgr.mr_n66826976)
print v(xbgr.mr_n66827296)
print v(xbgr.mr_n66827408)
print v(xbgr.mr_n66827728)
print v(xbgr.mr_n66827840)
print v(xbgr.mr_n66828160)
print v(xbgr.mr_n66828272)
print v(xbgr.mr_n66828592)
print v(xbgr.mr_n66828704)
print v(xbgr.mr_n66829024)
print v(xbgr.mr_n66829136)
print v(xbgr.mr_n66829456)
print v(xbgr.mr_n66829568)
print v(xbgr.mr_n66829888)
print v(xbgr.mr_n66830000)
print v(xbgr.mr_n66830320)
print v(xbgr.mr_n66830432)
print v(xbgr.mr_n66830752)
print v(xbgr.mr_n66830864)
print v(xbgr.mr_n66831184)
print v(xbgr.mr_n66831296)
print v(xbgr.mr_n66831616)
print v(xbgr.mr_n66831728)
print v(xbgr.mr_n66832048)
print v(xbgr.mr_n66832160)
print v(xbgr.mr_n66832480)
print v(xbgr.mr_n66832592)
print v(xbgr.mr_n66832912)
print v(xbgr.mr_n66833024)
print v(xbgr.mr_n66833344)
print v(xbgr.mr_n66833456)
print v(xbgr.mr_n66833776)
print v(xbgr.mr_n66833888)
print v(xbgr.mr_n66834208)
print v(xbgr.mr_n66834320)
print v(xbgr.mr_n66834640)
print v(xbgr.mr_n66834752)
print v(xbgr.mr_n66835072)
print v(xbgr.mr_n66835184)
print v(xbgr.mr_n66835504)
print v(xbgr.mr_n66835616)
print v(xbgr.mr_n66835936)
print v(xbgr.mr_n66836048)
print v(xbgr.mr_n66836368)
print v(xbgr.mr_n66836480)
print v(xbgr.mr_n66836800)
print v(xbgr.mr_n66836912)
print v(xbgr.mr_n66837232)
print v(xbgr.mr_n66837344)
print v(xbgr.mr_n66837664)
print v(xbgr.mr_n66837776)
print v(xbgr.mr_n66838096)
print v(xbgr.mr_n66838208)
print v(xbgr.mr_n66838528)
print v(xbgr.mr_n66838640)
print v(xbgr.mr_n66838960)
print v(xbgr.mr_n66839072)
print v(xbgr.mr_n66839392)
print v(xbgr.mr_n66839504)
print v(xbgr.mr_n66839824)
print v(xbgr.mr_n66839936)
print v(xbgr.mr_n66840256)
print v(xbgr.mr_n66840368)
print v(xbgr.mr_n66840688)
print v(xbgr.mr_n66840800)
print v(xbgr.mr_n66841120)
print v(xbgr.mr_n66841232)
print v(xbgr.mr_n66841552)
print v(xbgr.mr_n66841664)
print v(xbgr.mr_n66841984)
print v(xbgr.mr_n66842096)
print v(xbgr.mr_n66842416)
print v(xbgr.mr_n66842528)
print v(xbgr.mr_n66842848)
print v(xbgr.mr_n66842960)
print v(xbgr.mr_n66843280)
print v(xbgr.mr_n66843392)
print v(xbgr.mr_n66843712)
print v(xbgr.mr_n66843824)
print v(xbgr.mr_n66844144)
print v(xbgr.mr_n66844256)
print v(xbgr.mr_n66844576)
print v(xbgr.mr_n66844688)
print v(xbgr.mr_n66845008)
print v(xbgr.mr_n66845120)
print v(xbgr.mr_n66845440)
print v(xbgr.mr_n66845552)
print v(xbgr.mr_n66845872)
print v(xbgr.mr_n66845984)
print v(xbgr.mr_n66846304)
print v(xbgr.mr_n66846416)
print v(xbgr.mr_n66846736)
print v(xbgr.mr_n66846848)
print v(xbgr.mr_n66847168)
print v(xbgr.mr_n66847280)
print v(xbgr.mr_n66847600)
print v(xbgr.mr_n66847712)
print v(xbgr.mr_n66848032)
print v(xbgr.mr_n66848144)
print v(xbgr.mr_n66848464)
print v(xbgr.mr_n66848576)
print v(xbgr.mr_n66848896)
print v(xbgr.mr_n66849008)
print v(xbgr.mr_n66849328)
print v(xbgr.mr_n66849440)
print v(xbgr.mr_n66849760)
print v(xbgr.mr_n66849872)
print v(xbgr.mr_n66850192)
print v(xbgr.mr_n66850304)
print v(xbgr.mr_n66850624)
print v(xbgr.mr_n66850736)
print v(xbgr.mr_n66851056)
print v(xbgr.mr_n66851168)
print v(xbgr.mr_n66851488)
print v(xbgr.mr_n66851600)
print v(xbgr.mr_n66851920)
print v(xbgr.mr_n66852032)
print v(xbgr.mr_n66852352)
print v(xbgr.mr_n66852464)
print v(xbgr.mr_n66852784)
print v(xbgr.mr_n66852896)
print v(xbgr.mr_n66853216)
print v(xbgr.mr_n66853328)
print v(xbgr.mr_n66853648)
print v(xbgr.mr_n66853760)
print v(xbgr.mr_n66854080)
print v(xbgr.mr_n66854192)
print v(xbgr.mr_n66854512)
print v(xbgr.mr_n66854624)
print v(xbgr.mr_n66854944)
print v(xbgr.mr_n66855056)
print v(xbgr.mr_n66855376)
print v(xbgr.mr_n66855488)
print v(xbgr.mr_n66855808)
print v(xbgr.mr_n66855920)
print v(xbgr.mr_n66856240)
print v(xbgr.mr_n66856352)
print v(xbgr.mr_n66856672)
print v(xbgr.mr_n66856784)
print v(xbgr.mr_n66857104)
print v(xbgr.mr_n66857216)
print v(xbgr.mr_n66857536)
print v(xbgr.mr_n66857648)
print v(xbgr.mr_n66857968)
print v(xbgr.mr_n66858080)
print v(xbgr.mr_n66858400)
print v(xbgr.mr_n66858512)
print v(xbgr.mr_n66858832)
print v(xbgr.mr_n66858944)
print v(xbgr.mr_n66859264)
print v(xbgr.mr_n66859376)
print v(xbgr.mr_n66859696)
print v(xbgr.mr_n66859808)
print v(xbgr.mr_n66860128)
print v(xbgr.mr_n66860240)
print v(xbgr.mr_n66860560)
print v(xbgr.mr_n66860672)
print v(xbgr.mr_n66860992)
print v(xbgr.mr_n66861104)
print v(xbgr.mr_n66861424)
print v(xbgr.mr_n66861536)
print v(xbgr.mr_n66861856)
print v(xbgr.mr_n66861968)
print v(xbgr.mr_n66862288)
print v(xbgr.mr_n66862400)
print v(xbgr.mr_n66862720)
print v(xbgr.mr_n66862832)
print v(xbgr.mr_n66863152)
print v(xbgr.mr_n66863264)
print v(xbgr.mr_n66863584)
print v(xbgr.mr_n66863696)
print v(xbgr.mr_n66864016)
print v(xbgr.mr_n66864128)
print v(xbgr.mr_n66864448)
print v(xbgr.mr_n66864560)
print v(xbgr.mr_n66864880)
print v(xbgr.mr_n66864992)
print v(xbgr.mr_n66865312)
print v(xbgr.mr_n66865424)
print v(xbgr.mr_n66865744)
print v(xbgr.mr_n66865856)
print v(xbgr.mr_n66866176)
print v(xbgr.mr_n66866288)
print v(xbgr.mr_n66866608)
print v(xbgr.mr_n66866720)
print v(xbgr.mr_n66867040)
print v(xbgr.mr_n66867152)
print v(xbgr.mr_n66867472)
print v(xbgr.mr_n66867584)
print v(xbgr.mr_n66867904)
print v(xbgr.mr_n66868016)
print v(xbgr.mr_n66868336)
print v(xbgr.mr_n66868448)
print v(xbgr.mr_n66868768)
print v(xbgr.mr_n66868880)
print v(xbgr.mr_n66869200)
print v(xbgr.mr_n66869312)
print v(xbgr.mr_n66869632)
print v(xbgr.mr_n66869744)
print v(xbgr.mr_n66870064)
print v(xbgr.mr_n66870176)
print v(xbgr.mr_n66870496)
print v(xbgr.mr_n66870608)
print v(xbgr.mr_n66870928)
print v(xbgr.mr_n66871040)
print v(xbgr.mr_n66871360)
print v(xbgr.mr_n66871472)
print v(xbgr.mr_n66871792)
print v(xbgr.mr_n66871904)
print v(xbgr.mr_n66872224)
print v(xbgr.mr_n66872336)
print v(xbgr.mr_n66872656)
print v(xbgr.mr_n66872768)
print v(xbgr.mr_n66873088)
print v(xbgr.mr_n66873200)
print v(xbgr.mr_n66873520)
print v(xbgr.mr_n66873632)
print v(xbgr.mr_n66873952)
print v(xbgr.mr_n66874064)
print v(xbgr.mr_n66874384)
print v(xbgr.mr_n66874496)
print v(xbgr.mr_n66874816)
print v(xbgr.mr_n66874928)
print v(xbgr.mr_n66875248)
print v(xbgr.mr_n66875360)
print v(xbgr.mr_n66875680)
print v(xbgr.mr_n66875792)
print v(xbgr.mr_n66876112)
print v(xbgr.mr_n66876224)
print v(xbgr.mr_n66876544)
print v(xbgr.mr_n66876656)
print v(xbgr.mr_n66876976)
print v(xbgr.mr_n66877088)
print v(xbgr.mr_n66877408)
print v(xbgr.mr_n66877520)
print v(xbgr.mr_n66877840)
print v(xbgr.mr_n66877952)
print v(xbgr.mr_n66878272)
print v(xbgr.mr_n66878384)
print v(xbgr.mr_n66878704)
print v(xbgr.mr_n66878816)
print v(xbgr.mr_n66879136)
print v(xbgr.mr_n66879248)
print v(xbgr.mr_n66879568)
print v(xbgr.mr_n66879680)
print v(xbgr.mr_n66880000)
print v(xbgr.mr_n66880112)
print v(xbgr.mr_n66880432)
print v(xbgr.mr_n66880544)
print v(xbgr.mr_n66880864)
print v(xbgr.mr_n66880976)
print v(xbgr.mr_n66881296)
print v(xbgr.mr_n66881408)
print v(xbgr.mr_n66881728)
print v(xbgr.mr_n66881840)
print v(xbgr.mr_n66882160)
print v(xbgr.mr_n66882272)
print v(xbgr.mr_n66882592)
print v(xbgr.mr_n66882704)
print v(xbgr.mr_n66883024)
print v(xbgr.mr_n66883136)
print v(xbgr.mr_n66883456)
print v(xbgr.mr_n66883568)
print v(xbgr.mr_n66883888)
print v(xbgr.mr_n66884000)
print v(xbgr.mr_n66884320)
print v(xbgr.mr_n66884432)
print v(xbgr.mr_n66884752)
print v(xbgr.mr_n66884864)
print v(xbgr.mr_n66885184)
print v(xbgr.mr_n66885296)
print v(xbgr.mr_n66885616)
print v(xbgr.mr_n66885728)
print v(xbgr.mr_n66886048)
print v(xbgr.mr_n66886160)
print v(xbgr.mr_n66886480)
print v(xbgr.mr_n66886592)
print v(xbgr.mr_n66886912)
print v(xbgr.mr_n66887024)
print v(xbgr.mr_n66887344)
print v(xbgr.mr_n66887456)
print v(xbgr.mr_n66887776)
print v(xbgr.mr_n66887888)
print v(xbgr.mr_n66888208)
print v(xbgr.mr_n66888320)
print v(xbgr.mr_n66888640)
print v(xbgr.mr_n66888752)
print v(xbgr.mr_n66889072)
print v(xbgr.mr_n66889184)
print v(xbgr.mr_n66889504)
print v(xbgr.mr_n66889616)
print v(xbgr.mr_n66889936)
print v(xbgr.mr_n66890048)
print v(xbgr.mr_n66890368)
print v(xbgr.mr_n66890480)
print v(xbgr.mr_n66890800)
print v(xbgr.mr_n66890912)
print v(xbgr.mr_n66891232)
print v(xbgr.mr_n66891344)
print v(xbgr.mr_n66891664)
print v(xbgr.mr_n66891776)
print v(xbgr.mr_n66892096)
print v(xbgr.mr_n66892208)
print v(xbgr.mr_n66892528)
print v(xbgr.mr_n66892640)
print v(xbgr.mr_n66892960)
print v(xbgr.mr_n66893072)
print v(xbgr.mr_n66893392)
print v(xbgr.mr_n66893504)
print v(xbgr.mr_n66893824)
print v(xbgr.mr_n66893936)
print v(xbgr.mr_n66894256)
print v(xbgr.mr_n66894368)
print v(xbgr.mr_n66894688)
print v(xbgr.mr_n66894800)
print v(xbgr.mr_n66895120)
print v(xbgr.mr_n66895232)
print v(xbgr.mr_n66895552)
print v(xbgr.mr_n66895664)
print v(xbgr.mr_n66895984)
print v(xbgr.mr_n66896096)
print v(xbgr.mr_n66896416)
print v(xbgr.mr_n66896528)
print v(xbgr.mr_n66896848)
print v(xbgr.mr_n66896960)
print v(xbgr.mr_n66897280)
print v(xbgr.mr_n66897392)
print v(xbgr.mr_n66897712)
print v(xbgr.mr_n66897824)
print v(xbgr.mr_n66898144)
print v(xbgr.mr_n66898256)
print v(xbgr.mr_n66898576)
print v(xbgr.mr_n66898688)
print v(xbgr.mr_n66899008)
print v(xbgr.mr_n66899120)
print v(xbgr.mr_n66899440)
print v(xbgr.mr_n66899552)
print v(xbgr.mr_n66899872)
print v(xbgr.mr_n66899984)
print v(xbgr.mr_n66900304)
print v(xbgr.mr_n66900416)
print v(xbgr.mr_n66900736)
print v(xbgr.mr_n66900848)
print v(xbgr.mr_n66901168)
print v(xbgr.mr_n66901280)
print v(xbgr.mr_n66901600)
print v(xbgr.mr_n66901712)
print v(xbgr.mr_n66902032)
print v(xbgr.mr_n66902144)
print v(xbgr.mr_n66902464)
print v(xbgr.mr_n66902576)
print v(xbgr.mr_n66902896)
print v(xbgr.mr_n66903008)
print v(xbgr.mr_n66903328)
print v(xbgr.mr_n66903440)
print v(xbgr.mr_n66903760)
print v(xbgr.mr_n66903872)
print v(xbgr.mr_n66904192)
print v(xbgr.mr_n66904304)
print v(xbgr.mr_n66904624)
print v(xbgr.mr_n66904736)
print v(xbgr.mr_n66905056)
print v(xbgr.mr_n66905168)
print v(xbgr.mr_n66905488)
print v(xbgr.mr_n66905600)
print v(xbgr.mr_n66905920)
print v(xbgr.mr_n66906032)
print v(xbgr.mr_n66906352)
print v(xbgr.mr_n66906464)
print v(xbgr.mr_n66906784)
print v(xbgr.mr_n66906896)
print v(xbgr.mr_n66907216)
print v(xbgr.mr_n66907328)
print v(xbgr.mr_n66907648)
print v(xbgr.mr_n66907760)
print v(xbgr.mr_n66908080)
print v(xbgr.mr_n66908192)
print v(xbgr.mr_n66908512)
print v(xbgr.mr_n66908624)
print v(xbgr.mr_n66908944)
print v(xbgr.mr_n66909056)
print v(xbgr.mr_n66909376)
print v(xbgr.mr_n66909488)
print v(xbgr.mr_n66909808)
print v(xbgr.mr_n66909920)
print v(xbgr.mr_n66910240)
print v(xbgr.mr_n66910352)
print v(xbgr.mr_n66910672)
print v(xbgr.mr_n66910784)
print v(xbgr.mr_n66911104)
print v(xbgr.mr_n66911216)
print v(xbgr.mr_n66911536)
print v(xbgr.mr_n66911648)
print v(xbgr.mr_n66911968)
print v(xbgr.mr_n66912080)
print v(xbgr.mr_n66912400)
print v(xbgr.mr_n66912512)
print v(xbgr.mr_n66912832)
print v(xbgr.mr_n66912944)
print v(xbgr.mr_n66913264)
print v(xbgr.mr_n66913376)
print v(xbgr.mr_n66913696)
print v(xbgr.mr_n66913808)
print v(xbgr.mr_n66914128)
print v(xbgr.mr_n66914240)
print v(xbgr.mr_n66914560)
print v(xbgr.mr_n66914672)
print v(xbgr.mr_n66914992)
print v(xbgr.mr_n66915104)
print v(xbgr.mr_n66915424)
print v(xbgr.mr_n66915536)
print v(xbgr.mr_n66915856)
print v(xbgr.mr_n66915968)
print v(xbgr.mr_n66916288)
print v(xbgr.mr_n66916400)
print v(xbgr.mr_n66916720)
print v(xbgr.mr_n66916832)
print v(xbgr.mr_n66917152)
print v(xbgr.mr_n66917264)
print v(xbgr.mr_n66917584)
print v(xbgr.mr_n66917696)
print v(xbgr.mr_n66918016)
print v(xbgr.mr_n66918128)
print v(xbgr.mr_n66918448)
print v(xbgr.mr_n66918560)
print v(xbgr.mr_n66918880)
print v(xbgr.mr_n66918992)
print v(xbgr.mr_n66919312)
print v(xbgr.mr_n66919424)
print v(xbgr.mr_n66919744)
print v(xbgr.mr_n66919856)
print v(xbgr.mr_n66920176)
print v(xbgr.mr_n66920288)
print v(xbgr.mr_n66920608)
print v(xbgr.mr_n66920720)
print v(xbgr.mr_n66921040)
print v(xbgr.mr_n66921152)
print v(xbgr.mr_n66921472)
print v(xbgr.mr_n66921584)
print v(xbgr.mr_n66921904)
print v(xbgr.mr_n66922016)
print v(xbgr.mr_n66922336)
print v(xbgr.mr_n66922448)
print v(xbgr.mr_n66922768)
print v(xbgr.mr_n66922880)
print v(xbgr.mr_n66923312)
print v(xbgr.mr_n66923632)
print v(xbgr.mr_n66923744)
print v(xbgr.mr_n66924064)
print v(xbgr.mr_n66924176)
print v(xbgr.mr_n66924496)
print v(xbgr.mr_n66924608)
print v(xbgr.mr_n66924928)
print v(xbgr.mr_n66925040)
print v(xbgr.mr_n66925360)
print v(xbgr.mr_n66925472)
print v(xbgr.mr_n66925904)
print v(xbgr.mr_n66926224)
print v(xbgr.mr_n66926336)
print v(xbgr.mr_n66926656)
print v(xbgr.mr_n66926768)
print v(xbgr.mr_n66927088)
print v(xbgr.mr_n66927200)
print v(xbgr.mr_n66927520)
print v(xbgr.mr_n66927632)
print v(xbgr.mr_n66927952)
print v(xbgr.mr_n66928064)
print v(xbgr.mr_n66928496)
print v(xbgr.mr_n66928816)
print v(xbgr.mr_n66928928)
print v(xbgr.mr_n66929248)
print v(xbgr.mr_n66929360)
print v(xbgr.mr_n66929680)
print v(xbgr.mr_n66929792)
print v(xbgr.mr_n66930112)
print v(xbgr.mr_n66930224)
print v(xbgr.mr_n66930544)
print v(xbgr.mr_n66930656)
print v(xbgr.mr_n66930976)
print v(xbgr.mr_n66931088)
print v(xbgr.mr_n66931408)
print v(xbgr.mr_n66931520)
print v(xbgr.mr_n66931952)
print v(xbgr.mr_n66932272)
print v(xbgr.mr_n66932384)
print v(xbgr.mr_n66932816)
print v(xbgr.mr_n66933136)
print v(xbgr.mr_n66933248)
print v(xbgr.mr_n66933568)
print v(xbgr.mr_n66933680)
print v(xbgr.mr_n66934000)
print v(xbgr.mr_n66934112)
print v(xbgr.mr_n66934432)
print v(xbgr.mr_n66934544)
print v(xbgr.mr_n66934864)
print v(xbgr.mr_n66934976)
print v(xbgr.mr_n66935408)
print v(xbgr.mr_n66935728)
print v(xbgr.mr_n66935840)
print v(xbgr.mr_n66936272)
print v(xbgr.mr_n66936592)
print v(xbgr.mr_n66936704)
print v(xbgr.mr_n66937024)
print v(xbgr.mr_n66937136)
print v(xbgr.mr_n66937456)
print v(xbgr.mr_n66937568)
print v(xbgr.mr_n66937888)
print v(xbgr.mr_n66938000)
print v(xbgr.mr_n66938320)
print v(xbgr.mr_n66938432)
print v(xbgr.mr_n66938752)
print v(xbgr.mr_n66938864)
print v(xbgr.mr_n66939184)
print v(xbgr.mr_n66939296)
print v(xbgr.mr_n66939616)
print v(xbgr.mr_n66939728)
print v(xbgr.mr_n66940048)
print v(xbgr.mr_n66940160)
print v(xbgr.mr_n66940480)
print v(xbgr.mr_n66940592)
print v(xbgr.mr_n66940912)
print v(xbgr.mr_n66941024)
print v(xbgr.mr_n66941344)
print v(xbgr.mr_n66941456)
print v(xbgr.mr_n66941776)
print v(xbgr.mr_n66941888)
print v(xbgr.mr_n66942208)
print v(xbgr.mr_n66942320)
print v(xbgr.mr_n66942640)
print v(xbgr.mr_n66942752)
print v(xbgr.mr_n66943072)
print v(xbgr.mr_n66943184)
print v(xbgr.mr_n66943504)
print v(xbgr.mr_n66943616)
print v(xbgr.mr_n66943936)
print v(xbgr.mr_n66944048)
print v(xbgr.mr_n66944368)
print v(xbgr.mr_n66944480)
print v(xbgr.mr_n66944800)
print v(xbgr.mr_n66944912)
print v(xbgr.mr_n66945232)
print v(xbgr.mr_n66945344)
print v(xbgr.mr_n66945664)
print v(xbgr.mr_n66945776)
print v(xbgr.mr_n66946096)
print v(xbgr.mr_n66946208)
print v(xbgr.mr_n66946528)
print v(xbgr.mr_n66946640)
print v(xbgr.mr_n66946960)
print v(xbgr.mr_n66947072)
print v(xbgr.mr_n66947392)
print v(xbgr.mr_n66947504)
print v(xbgr.mr_n66947824)
print v(xbgr.mr_n66947936)
print v(xbgr.mr_n66948256)
print v(xbgr.mr_n66948368)
print v(xbgr.mr_n66948688)
print v(xbgr.mr_n66948800)
print v(xbgr.mr_n66949120)
print v(xbgr.mr_n66949232)
print v(xbgr.mr_n66949552)
print v(xbgr.mr_n66949664)
print v(xbgr.mr_n66949984)
print v(xbgr.mr_n66950096)
print v(xbgr.mr_n66950416)
print v(xbgr.mr_n66950528)
print v(xbgr.mr_n66950848)
print v(xbgr.mr_n66950960)
print v(xbgr.mr_n66951280)
print v(xbgr.mr_n66951392)
print v(xbgr.mr_n66951712)
print v(xbgr.mr_n66951824)
print v(xbgr.mr_n66952144)
print v(xbgr.mr_n66952256)
print v(xbgr.mr_n66952576)
print v(xbgr.mr_n66952688)
print v(xbgr.mr_n66953008)
print v(xbgr.mr_n66953120)
print v(xbgr.mr_n66953440)
print v(xbgr.mr_n66953552)
print v(xbgr.mr_n66953872)
print v(xbgr.mr_n66953984)
print v(xbgr.mr_n66954304)
print v(xbgr.mr_n66954416)
print v(xbgr.mr_n66954736)
print v(xbgr.mr_n66954848)
print v(xbgr.mr_n66955168)
print v(xbgr.mr_n66955280)
print v(xbgr.mr_n66955600)
print v(xbgr.mr_n66955712)
print v(xbgr.mr_n66956032)
print v(xbgr.mr_n66956144)
print v(xbgr.mr_n66956464)
print v(xbgr.mr_n66956576)
print v(xbgr.mr_n66956896)
print v(xbgr.mr_n66957008)
print v(xbgr.mr_n66957328)
print v(xbgr.mr_n66957440)
print v(xbgr.mr_n66957760)
print v(xbgr.mr_n66957872)
print v(xbgr.mr_n66958192)
print v(xbgr.mr_n66958304)
print v(xbgr.mr_n66958624)
print v(xbgr.mr_n66958736)
print v(xbgr.mr_n66959056)
print v(xbgr.mr_n66959168)
print v(xbgr.mr_n66959488)
print v(xbgr.mr_n66959600)
print v(xbgr.mr_n66959920)
print v(xbgr.mr_n66960032)
print v(xbgr.mr_n66960352)
print v(xbgr.mr_n66960464)
print v(xbgr.mr_n66960784)
print v(xbgr.mr_n66960896)
print v(xbgr.mr_n66961216)
print v(xbgr.mr_n66961328)
print v(xbgr.mr_n66961648)
print v(xbgr.mr_n66961760)
print v(xbgr.mr_n66962080)
print v(xbgr.mr_n66962192)
print v(xbgr.mr_n66962512)
print v(xbgr.mr_n66962624)
print v(xbgr.mr_n66962944)
print v(xbgr.mr_n66963056)
print v(xbgr.mr_n66963376)
print v(xbgr.mr_n66963488)
print v(xbgr.mr_n66963808)
print v(xbgr.mr_n66963920)
print v(xbgr.mr_n66964240)
print v(xbgr.mr_n66964352)
print v(xbgr.mr_n66964672)
print v(xbgr.mr_n66964784)
print v(xbgr.mr_n66965104)
print v(xbgr.mr_n66965216)
print v(xbgr.mr_n66965536)
print v(xbgr.mr_n66965648)
print v(xbgr.mr_n66965968)
print v(xbgr.mr_n66966080)
print v(xbgr.mr_n66966400)
print v(xbgr.mr_n66966512)
print v(xbgr.mr_n66966832)
print v(xbgr.mr_n66966944)
print v(xbgr.mr_n66967264)
print v(xbgr.mr_n66967376)
print v(xbgr.mr_n66967696)
print v(xbgr.mr_n66967808)
print v(xbgr.mr_n66968128)
print v(xbgr.mr_n66968240)
print v(xbgr.mr_n66968560)
print v(xbgr.mr_n66968672)
print v(xbgr.mr_n66968992)
print v(xbgr.mr_n66969104)
print v(xbgr.mr_n66969424)
print v(xbgr.mr_n66969536)
print v(xbgr.mr_n66969968)
print v(xbgr.mr_n66970288)
print v(xbgr.mr_n66970400)
print v(xbgr.mr_n66970720)
print v(xbgr.mr_n66970832)
print v(xbgr.mr_n66971152)
print v(xbgr.mr_n66971264)
print v(xbgr.mr_n66971696)
print v(xbgr.mr_n66972016)
print v(xbgr.mr_n66972128)
print v(xbgr.mr_n66972560)
print v(xbgr.mr_n66972880)
print v(xbgr.mr_n66972992)
print v(xbgr.mr_n66973312)
print v(xbgr.mr_n66973424)
print v(xbgr.mr_n66973744)
print v(xbgr.mr_n66973856)
print v(xbgr.mr_n66974176)
print v(xbgr.mr_n66974288)
print v(xbgr.mr_n66974608)
print v(xbgr.mr_n66974720)
print v(xbgr.mr_n66975040)
print v(xbgr.mr_n66975152)
print v(xbgr.mr_n66975472)
print v(xbgr.mr_n66975584)
print v(xbgr.mr_n66975904)
print v(xbgr.mr_n66976016)
print v(xbgr.mr_n66976336)
print v(xbgr.mr_n66976448)
print v(xbgr.mr_n66976768)
print v(xbgr.mr_n66976880)
print v(xbgr.mr_n66977200)
print v(xbgr.mr_n66977312)
print v(xbgr.mr_n66977632)
print v(xbgr.mr_n66977744)
print v(xbgr.mr_n66978064)
print v(xbgr.mr_n66978176)
print v(xbgr.mr_n66978496)
print v(xbgr.mr_n66978608)
print v(xbgr.mr_n66978928)
print v(xbgr.mr_n66979040)
print v(xbgr.mr_n66979360)
print v(xbgr.mr_n66979472)
print v(xbgr.mr_n66979792)
print v(xbgr.mr_n66979904)
print v(xbgr.mr_n66980224)
print v(xbgr.mr_n66980336)
print v(xbgr.mr_n66980656)
print v(xbgr.mr_n66980768)
print v(xbgr.mr_n66981088)
print v(xbgr.mr_n66981200)
print v(xbgr.mr_n66981520)
print v(xbgr.mr_n66981632)
print v(xbgr.mr_n66981952)
print v(xbgr.mr_n66982064)
print v(xbgr.mr_n66982384)
print v(xbgr.mr_n66982496)
print v(xbgr.mr_n66982816)
print v(xbgr.mr_n66982928)
print v(xbgr.mr_n66983248)
print v(xbgr.mr_n66983360)
print v(xbgr.mr_n66983680)
print v(xbgr.mr_n66983792)
print v(xbgr.mr_n66984112)
print v(xbgr.mr_n66984224)
print v(xbgr.mr_n66984656)
print v(xbgr.mr_n66984976)
print v(xbgr.mr_n66985088)
print v(xbgr.mr_n66985408)
print v(xbgr.mr_n66985520)
print v(xbgr.mr_n66985840)
print v(xbgr.mr_n66985952)
print v(xbgr.mr_n66986272)
print v(xbgr.mr_n66986384)
print v(xbgr.mr_n66986704)
print v(xbgr.mr_n66986816)
print v(xbgr.mr_n66987136)
print v(xbgr.mr_n66987248)
print v(xbgr.mr_n66987568)
print v(xbgr.mr_n66987680)
print v(xbgr.mr_n66988000)
print v(xbgr.mr_n66988112)
print v(xbgr.mr_n66988432)
print v(xbgr.mr_n66988544)
print v(xbgr.mr_n66988976)
print v(xbgr.mr_n66989296)
print v(xbgr.mr_n66989408)
print v(xbgr.mr_n66989728)
print v(xbgr.mr_n66989840)
print v(xbgr.mr_n66990160)
print v(xbgr.mr_n66990272)
print v(xbgr.mr_n66990704)
print v(xbgr.mr_n66991024)
print v(xbgr.mr_n66991136)
print v(xbgr.mr_n66991456)
print v(xbgr.mr_n66991568)
print v(xbgr.mr_n66991888)
print v(xbgr.mr_n66992000)
print v(xbgr.mr_n66992320)
print v(xbgr.mr_n66992432)
print v(xbgr.mr_n66992752)
print v(xbgr.mr_n66992864)
print v(xbgr.mr_n66993296)
print v(xbgr.mr_n66993616)
print v(xbgr.mr_n66993728)
print v(xbgr.mr_n66994048)
print v(xbgr.mr_n66994160)
print v(xbgr.mr_n66994480)
print v(xbgr.mr_n66994592)
print v(xbgr.mr_n66994912)
print v(xbgr.mr_n66995024)
print v(xbgr.mr_n66995344)
print v(xbgr.mr_n66995456)
print v(xbgr.mr_n66995776)
print v(xbgr.mr_n66995888)
print v(xbgr.mr_n66996208)
print v(xbgr.mr_n66996320)
print v(xbgr.mr_n66996640)
print v(xbgr.mr_n66996752)
print v(xbgr.mr_n66997072)
print v(xbgr.mr_n66997184)
print v(xbgr.mr_n66997504)
print v(xbgr.mr_n66997616)
print v(xbgr.mr_n66997936)
print v(xbgr.mr_n66998048)
print v(xbgr.mr_n66998368)
print v(xbgr.mr_n66998480)
print v(xbgr.mr_n66998800)
print v(xbgr.mr_n66998912)
print v(xbgr.mr_n66999232)
print v(xbgr.mr_n66999344)
print v(xbgr.mr_n66999664)
print v(xbgr.mr_n66999776)
print v(xbgr.mr_n67000096)
print v(xbgr.mr_n67000208)
print v(xbgr.mr_n67000528)
print v(xbgr.mr_n67000640)
print v(xbgr.mr_n67000960)
print v(xbgr.mr_n67001072)
print v(xbgr.mr_n67001392)
print v(xbgr.mr_n67001504)
print v(xbgr.mr_n67001824)
print v(xbgr.mr_n67001936)
print v(xbgr.mr_n67002256)
print v(xbgr.mr_n67002368)
print v(xbgr.mr_n67002688)
print v(xbgr.mr_n67002800)
print v(xbgr.mr_n67003120)
print v(xbgr.mr_n67003232)
print v(xbgr.mr_n67003552)
print v(xbgr.mr_n67003664)
print v(xbgr.mr_n67003984)
print v(xbgr.mr_n67004096)
print v(xbgr.mr_n67004416)
print v(xbgr.mr_n67004528)
print v(xbgr.mr_n67004848)
print v(xbgr.mr_n67004960)
print v(xbgr.mr_n67005280)
print v(xbgr.mr_n67005392)
print v(xbgr.mr_n67005712)
print v(xbgr.mr_n67005824)
print v(xbgr.mr_n67006144)
print v(xbgr.mr_n67006256)
print v(xbgr.mr_n67006576)
print v(xbgr.mr_n67006688)
print v(xbgr.mr_n67007008)
print v(xbgr.mr_n67007120)
print v(xbgr.mr_n67007440)
print v(xbgr.mr_n67007552)
print v(xbgr.mr_n67007872)
print v(xbgr.mr_n67007984)
print v(xbgr.mr_n67008304)
print v(xbgr.mr_n67008416)
print v(xbgr.mr_n67008736)
print v(xbgr.mr_n67008848)
print v(xbgr.mr_n67009168)
print v(xbgr.mr_n67009280)
print v(xbgr.mr_n67009600)
print v(xbgr.mr_n67009712)
print v(xbgr.mr_n67010032)
print v(xbgr.mr_n67010144)
print v(xbgr.mr_n67010464)
print v(xbgr.mr_n67010576)
print v(xbgr.mr_n67010896)
print v(xbgr.mr_n67011008)
print v(xbgr.mr_n67011328)
print v(xbgr.mr_n67011440)
print v(xbgr.mr_n67011760)
print v(xbgr.mr_n67011872)
print v(xbgr.mr_n67012192)
print v(xbgr.mr_n67012304)
print v(xbgr.mr_n67012624)
print v(xbgr.mr_n67012736)
print v(xbgr.mr_n67013056)
print v(xbgr.mr_n67013168)
print v(xbgr.mr_n67013488)
print v(xbgr.mr_n67013600)
print v(xbgr.mr_n67013920)
print v(xbgr.mr_n67014032)
print v(xbgr.mr_n67014352)
print v(xbgr.mr_n67014464)
print v(xbgr.mr_n67014784)
print v(xbgr.mr_n67014896)
print v(xbgr.mr_n67015216)
print v(xbgr.mr_n67015328)
print v(xbgr.mr_n67015648)
print v(xbgr.mr_n67015760)
print v(xbgr.mr_n67016080)
print v(xbgr.mr_n67016192)
print v(xbgr.mr_n67016512)
print v(xbgr.mr_n67016624)
print v(xbgr.mr_n67016944)
print v(xbgr.mr_n67017056)
print v(xbgr.mr_n67017376)
print v(xbgr.mr_n67017488)
print v(xbgr.mr_n67017808)
print v(xbgr.mr_n67017920)
print v(xbgr.mr_n67018240)
print v(xbgr.mr_n67018352)
print v(xbgr.mr_n67018672)
print v(xbgr.mr_n67018784)
print v(xbgr.mr_n67019104)
print v(xbgr.mr_n67019216)
print v(xbgr.mr_n67019536)
print v(xbgr.mr_n67019648)
print v(xbgr.mr_n67019968)
print v(xbgr.mr_n67020080)
print v(xbgr.mr_n67020400)
print v(xbgr.mr_n67020512)
print v(xbgr.mr_n67020832)
print v(xbgr.mr_n67020944)
print v(xbgr.mr_n67021264)
print v(xbgr.mr_n67021376)
print v(xbgr.mr_n67021696)
print v(xbgr.mr_n67021808)
print v(xbgr.mr_n67022128)
print v(xbgr.mr_n67022240)
print v(xbgr.mr_n67022560)
print v(xbgr.mr_n67022672)
print v(xbgr.mr_n67022992)
print v(xbgr.mr_n67023104)
print v(xbgr.mr_n67023536)
print v(xbgr.mr_n67023856)
print v(xbgr.mr_n67023968)
print v(xbgr.mr_n67024288)
print v(xbgr.mr_n67024400)
print v(xbgr.mr_n67024720)
print v(xbgr.mr_n67024832)
print v(xbgr.mr_n67025264)
print v(xbgr.mr_n67025584)
print v(xbgr.mr_n67025696)
print v(xbgr.mr_n67026128)
print v(xbgr.mr_n67026448)
print v(xbgr.mr_n67026560)
print v(xbgr.mr_n67026880)
print v(xbgr.mr_n67026992)
print v(xbgr.mr_n67027312)
print v(xbgr.mr_n67027424)
print v(xbgr.mr_n67027744)
print v(xbgr.mr_n67027856)
print v(xbgr.mr_n67028176)
print v(xbgr.mr_n67028288)
print v(xbgr.mr_n67028608)
print v(xbgr.mr_n67028720)
print v(xbgr.mr_n67029040)
print v(xbgr.mr_n67029152)
print v(xbgr.mr_n67029472)
print v(xbgr.mr_n67029584)
print v(xbgr.mr_n67029904)
print v(xbgr.mr_n67030016)
print v(xbgr.mr_n67030336)
print v(xbgr.mr_n67030448)
print v(xbgr.mr_n67030768)
print v(xbgr.mr_n67030880)
print v(xbgr.mr_n67031200)
print v(xbgr.mr_n67031312)
print v(xbgr.mr_n67031632)
print v(xbgr.mr_n67031744)
print v(xbgr.mr_n67032064)
print v(xbgr.mr_n67032176)
print v(xbgr.mr_n67032496)
print v(xbgr.mr_n67032608)
print v(xbgr.mr_n67032928)
print v(xbgr.mr_n67033040)
print v(xbgr.mr_n67033360)
print v(xbgr.mr_n67033472)
print v(xbgr.mr_n67033792)
print v(xbgr.mr_n67033904)
print v(xbgr.mr_n67034224)
print v(xbgr.mr_n67034336)
print v(xbgr.mr_n67034656)
print v(xbgr.mr_n67034768)
print v(xbgr.mr_n67035088)
print v(xbgr.mr_n67035200)
print v(xbgr.mr_n67035520)
print v(xbgr.mr_n67035632)
print v(xbgr.mr_n67035952)
print v(xbgr.mr_n67036064)
print v(xbgr.mr_n67036384)
print v(xbgr.mr_n67036496)
print v(xbgr.mr_n67036816)
print v(xbgr.mr_n67036928)
print v(xbgr.mr_n67037248)
print v(xbgr.mr_n67037360)
print v(xbgr.mr_n67037680)
print v(xbgr.mr_n67037792)
print v(xbgr.mr_n67038112)
print v(xbgr.mr_n67038224)
print v(xbgr.mr_n67038544)
print v(xbgr.mr_n67038656)
print v(xbgr.mr_n67038976)
print v(xbgr.mr_n67039088)
print v(xbgr.mr_n67039408)
print v(xbgr.mr_n67039520)
print v(xbgr.mr_n67039840)
print v(xbgr.mr_n67039952)
print v(xbgr.mr_n67040272)
print v(xbgr.mr_n67040384)
print v(xbgr.mr_n67040704)
print v(xbgr.mr_n67040816)
print v(xbgr.mr_n67041136)
print v(xbgr.mr_n67041248)
print v(xbgr.mr_n67041568)
print v(xbgr.mr_n67041680)
print v(xbgr.mr_n67042000)
print v(xbgr.mr_n67042112)
print v(xbgr.mr_n67042432)
print v(xbgr.mr_n67042544)
print v(xbgr.mr_n67042864)
print v(xbgr.mr_n67042976)
print v(xbgr.mr_n67043296)
print v(xbgr.mr_n67043408)
print v(xbgr.mr_n67043728)
print v(xbgr.mr_n67043840)
print v(xbgr.mr_n67044160)
print v(xbgr.mr_n67044272)
print v(xbgr.mr_n67044592)
print v(xbgr.mr_n67044704)
print v(xbgr.mr_n67045024)
print v(xbgr.mr_n67045136)
print v(xbgr.mr_n67045456)
print v(xbgr.mr_n67045568)
print v(xbgr.mr_n67045888)
print v(xbgr.mr_n67046000)
print v(xbgr.mr_n67046320)
print v(xbgr.mr_n67046432)
print v(xbgr.mr_n67046752)
print v(xbgr.mr_n67046864)
print v(xbgr.mr_n67047184)
print v(xbgr.mr_n67047296)
print v(xbgr.mr_n67047616)
print v(xbgr.mr_n67047728)
print v(xbgr.mr_n67048048)
print v(xbgr.mr_n67048160)
print v(xbgr.mr_n67048480)
print v(xbgr.mr_n67048592)
print v(xbgr.mr_n67048912)
print v(xbgr.mr_n67049024)
print v(xbgr.mr_n67049344)
print v(xbgr.mr_n67049456)
print v(xbgr.mr_n67049776)
print v(xbgr.mr_n67049888)
print v(xbgr.mr_n67050208)
print v(xbgr.mr_n67050320)
print v(xbgr.mr_n67050640)
print v(xbgr.mr_n67050752)
print v(xbgr.mr_n67051072)
print v(xbgr.mr_n67051184)
print v(xbgr.mr_n67051504)
print v(xbgr.mr_n67051616)
print v(xbgr.mr_n67051936)
print v(xbgr.mr_n67052048)
print v(xbgr.mr_n67052368)
print v(xbgr.mr_n67052480)
print v(xbgr.mr_n67052800)
print v(xbgr.mr_n67052912)
print v(xbgr.mr_n67053232)
print v(xbgr.mr_n67053344)
print v(xbgr.mr_n67053664)
print v(xbgr.mr_n67053776)
print v(xbgr.mr_n67054096)
print v(xbgr.mr_n67054208)
print v(xbgr.mr_n67054528)
print v(xbgr.mr_n67054640)
print v(xbgr.mr_n67054960)
print v(xbgr.mr_n67055072)
print v(xbgr.mr_n67055392)
print v(xbgr.mr_n67055504)
print v(xbgr.mr_n67055824)
print v(xbgr.mr_n67055936)
print v(xbgr.mr_n67056256)
print v(xbgr.mr_n67056368)
print v(xbgr.mr_n67056688)
print v(xbgr.mr_n67056800)
print v(xbgr.mr_n67057120)
print v(xbgr.mr_n67057232)
print v(xbgr.mr_n67057552)
print v(xbgr.mr_n67057664)
print v(xbgr.mr_n67057984)
print v(xbgr.mr_n67058096)
print v(xbgr.mr_n67058416)
print v(xbgr.mr_n67058528)
print v(xbgr.mr_n67058848)
print v(xbgr.mr_n67058960)
print v(xbgr.mr_n67059280)
print v(xbgr.mr_n67059392)
print v(xbgr.mr_n67059712)
print v(xbgr.mr_n67059824)
print v(xbgr.mr_n67060144)
print v(xbgr.mr_n67060256)
print v(xbgr.mr_n67060576)
print v(xbgr.mr_n67060688)
print v(xbgr.mr_n67061008)
print v(xbgr.mr_n67061120)
print v(xbgr.mr_n67061440)
print v(xbgr.mr_n67061552)
print v(xbgr.mr_n67061872)
print v(xbgr.mr_n67061984)
print v(xbgr.mr_n67062304)
print v(xbgr.mr_n67062416)
print v(xbgr.mr_n67062736)
print v(xbgr.mr_n67062848)
print v(xbgr.mr_n67063168)
print v(xbgr.mr_n67063280)
print v(xbgr.mr_n67063600)
print v(xbgr.mr_n67063712)
print v(xbgr.mr_n67064032)
print v(xbgr.mr_n67064144)
print v(xbgr.mr_n67064464)
print v(xbgr.mr_n67064576)
print v(xbgr.mr_n67064896)
print v(xbgr.mr_n67065008)
print v(xbgr.mr_n67065328)
print v(xbgr.mr_n67065440)
print v(xbgr.mr_n67065760)
print v(xbgr.mr_n67065872)
print v(xbgr.mr_n67066192)
print v(xbgr.mr_n67066304)
print v(xbgr.mr_n67066624)
print v(xbgr.mr_n67066736)
print v(xbgr.mr_n67067056)
print v(xbgr.mr_n67067168)
print v(xbgr.mr_n67067488)
print v(xbgr.mr_n67067600)
print v(xbgr.mr_n67067920)
print v(xbgr.mr_n67068032)
print v(xbgr.mr_n67068352)
print v(xbgr.mr_n67068464)
print v(xbgr.mr_n67068784)
print v(xbgr.mr_n67068896)
print v(xbgr.mr_n67069216)
print v(xbgr.mr_n67069328)
print v(xbgr.mr_n67069648)
print v(xbgr.mr_n67069760)
print v(xbgr.mr_n67070080)
print v(xbgr.mr_n67070192)
print v(xbgr.mr_n67070512)
print v(xbgr.mr_n67070624)
print v(xbgr.mr_n67070944)
print v(xbgr.mr_n67071056)
print v(xbgr.mr_n67071376)
print v(xbgr.mr_n67071488)
print v(xbgr.mr_n67071808)
print v(xbgr.mr_n67071920)
print v(xbgr.mr_n67072240)
print v(xbgr.mr_n67072352)
print v(xbgr.mr_n67072672)
print v(xbgr.mr_n67072784)
print v(xbgr.mr_n67073104)
print v(xbgr.mr_n67073216)
print v(xbgr.mr_n67073536)
print v(xbgr.mr_n67073648)
print v(xbgr.mr_n67073968)
print v(xbgr.mr_n67074080)
print v(xbgr.mr_n67074400)
print v(xbgr.mr_n67074512)
print v(xbgr.mr_n67074832)
print v(xbgr.mr_n67074944)
print v(xbgr.mr_n67075264)
print v(xbgr.mr_n67075376)
print v(xbgr.mr_n67075696)
print v(xbgr.mr_n67075808)
print v(xbgr.mr_n67076128)
print v(xbgr.mr_n67076240)
print v(xbgr.mr_n67076560)
print v(xbgr.mr_n67076672)
print v(xbgr.mr_n67076992)
print v(xbgr.mr_n67077104)
print v(xbgr.mr_n67077424)
print v(xbgr.mr_n67077536)
print v(xbgr.mr_n67077856)
print v(xbgr.mr_n67077968)
print v(xbgr.mr_n67078288)
print v(xbgr.mr_n67078400)
print v(xbgr.mr_n67078720)
print v(xbgr.mr_n67078832)
print v(xbgr.mr_n67079152)
print v(xbgr.mr_n67079264)
print v(xbgr.mr_n67079584)
print v(xbgr.mr_n67079696)
print v(xbgr.mr_n67080016)
print v(xbgr.mr_n67080128)
print v(xbgr.mr_n67080448)
print v(xbgr.mr_n67080560)
print v(xbgr.mr_n67080880)
print v(xbgr.mr_n67080992)
print v(xbgr.mr_n67081312)
print v(xbgr.mr_n67081424)
print v(xbgr.mr_n67081744)
print v(xbgr.mr_n67081856)
print v(xbgr.mr_n67082176)
print v(xbgr.mr_n67082288)
print v(xbgr.mr_n67082608)
print v(xbgr.mr_n67082720)
print v(xbgr.mr_n67083040)
print v(xbgr.mr_n67083152)
print v(xbgr.mr_n67083472)
print v(xbgr.mr_n67083584)
print v(xbgr.mr_n67083904)
print v(xbgr.mr_n67084016)
print v(xbgr.mr_n67084336)
print v(xbgr.mr_n67084448)
print v(xbgr.mr_n67084768)
print v(xbgr.mr_n67084880)
print v(xbgr.mr_n67085200)
print v(xbgr.mr_n67085312)
print v(xbgr.mr_n67085632)
print v(xbgr.mr_n67085744)
print v(xbgr.mr_n67086064)
print v(xbgr.mr_n67086176)
print v(xbgr.mr_n67086496)
print v(xbgr.mr_n67086608)
print v(xbgr.mr_n67086928)
print v(xbgr.mr_n67087040)
print v(xbgr.mr_n67087360)
print v(xbgr.mr_n67087472)
print v(xbgr.mr_n67087792)
print v(xbgr.mr_n67087904)
print v(xbgr.mr_n67088224)
print v(xbgr.mr_n67088336)
print v(xbgr.mr_n67088656)
print v(xbgr.mr_n67088768)
print v(xbgr.mr_n67089088)
print v(xbgr.mr_n67089200)
print v(xbgr.mr_n67089520)
print v(xbgr.mr_n67089632)
print v(xbgr.mr_n67089952)
print v(xbgr.mr_n67090064)
print v(xbgr.mr_n67090384)
print v(xbgr.mr_n67090496)
print v(xbgr.mr_n67090816)
print v(xbgr.mr_n67090928)
print v(xbgr.mr_n67091248)
print v(xbgr.mr_n67091360)
print v(xbgr.mr_n67091680)
print v(xbgr.mr_n67091792)
print v(xbgr.mr_n67092112)
print v(xbgr.mr_n67092224)
print v(xbgr.mr_n67092544)
print v(xbgr.mr_n67092656)
print v(xbgr.mr_n67092976)
print v(xbgr.mr_n67093088)
print v(xbgr.mr_n67093408)
print v(xbgr.mr_n67093520)
print v(xbgr.mr_n67093840)
print v(xbgr.mr_n67093952)
print v(xbgr.mr_n67094272)
print v(xbgr.mr_n67094384)
print v(xbgr.mr_n67094704)
print v(xbgr.mr_n67094816)
print v(xbgr.mr_n67095136)
print v(xbgr.mr_n67095248)
print v(xbgr.mr_n67095568)
print v(xbgr.mr_n67095680)
print v(xbgr.mr_n67096000)
print v(xbgr.mr_n67096112)
print v(xbgr.mr_n67096432)
print v(xbgr.mr_n67096544)
print v(xbgr.mr_n67096864)
print v(xbgr.mr_n67096976)
print v(xbgr.mr_n67097296)
print v(xbgr.mr_n67097408)
print v(xbgr.mr_n67097728)
print v(xbgr.mr_n67097840)
print v(xbgr.mr_n67098160)
print v(xbgr.mr_n67098272)
print v(xbgr.mr_n67098592)
print v(xbgr.mr_n67098704)
print v(xbgr.mr_n67099024)
print v(xbgr.mr_n67099136)
print v(xbgr.mr_n67099456)
print v(xbgr.mr_n67099568)
print v(xbgr.mr_n67099888)
print v(xbgr.mr_n67100000)
print v(xbgr.mr_n67100320)
print v(xbgr.mr_n67100432)
print v(xbgr.mr_n67100752)
print v(xbgr.mr_n67100864)
print v(xbgr.mr_n67101184)
print v(xbgr.mr_n67101296)
print v(xbgr.mr_n67101616)
print v(xbgr.mr_n67101728)
print v(xbgr.mr_n67102048)
print v(xbgr.mr_n67102160)
print v(xbgr.mr_n67102480)
print v(xbgr.mr_n67102592)
print v(xbgr.mr_n67102912)
print v(xbgr.mr_n67103024)
print v(xbgr.mr_n67103344)
print v(xbgr.mr_n67103456)
print v(xbgr.mr_n67103776)
print v(xbgr.mr_n67103888)
print v(xbgr.mr_n67104208)
print v(xbgr.mr_n67104320)
print v(xbgr.mr_n67104640)
print v(xbgr.mr_n67104752)
print v(xbgr.mr_n67105072)
print v(xbgr.mr_n67105184)
print v(xbgr.mr_n67105504)
print v(xbgr.mr_n67105616)
print v(xbgr.mr_n67105936)
print v(xbgr.mr_n67106048)
print v(xbgr.mr_n67106368)
print v(xbgr.mr_n67106480)
print v(xbgr.mr_n67106800)
print v(xbgr.mr_n67106912)
print v(xbgr.mr_n67107232)
print v(xbgr.mr_n67107344)
print v(xbgr.mr_n67107664)
print v(xbgr.mr_n67107776)
print v(xbgr.mr_n67108096)
print v(xbgr.mr_n67108208)
print v(xbgr.mr_n67108528)
print v(xbgr.mr_n67108640)
print v(xbgr.mr_n67108960)
print v(xbgr.mr_n67109072)
print v(xbgr.mr_n67109392)
print v(xbgr.mr_n67109504)
print v(xbgr.mr_n67109824)
print v(xbgr.mr_n67109936)
print v(xbgr.mr_n67110256)
print v(xbgr.mr_n67110368)
print v(xbgr.mr_n67110688)
print v(xbgr.mr_n67110800)
print v(xbgr.mr_n67111120)
print v(xbgr.mr_n67111232)
print v(xbgr.mr_n67111552)
print v(xbgr.mr_n67111664)
print v(xbgr.mr_n67111984)
print v(xbgr.mr_n67112096)
print v(xbgr.mr_n67112416)
print v(xbgr.mr_n67112528)
print v(xbgr.mr_n67112848)
print v(xbgr.mr_n67112960)
print v(xbgr.mr_n67113280)
print v(xbgr.mr_n67113392)
print v(xbgr.mr_n67113712)
print v(xbgr.mr_n67113824)
print v(xbgr.mr_n67114144)
print v(xbgr.mr_n67114256)
print v(xbgr.mr_n67114576)
print v(xbgr.mr_n67114688)
print v(xbgr.mr_n67115008)
print v(xbgr.mr_n67115120)
print v(xbgr.mr_n67115440)
print v(xbgr.mr_n67115552)
print v(xbgr.mr_n67115872)
print v(xbgr.mr_n67115984)
print v(xbgr.mr_n67116304)
print v(xbgr.mr_n67116416)
print v(xbgr.mr_n67182288)
print v(xbgr.mr_n67182400)
print v(xbgr.mr_n67182720)
print v(xbgr.mr_n67182832)
print v(xbgr.mr_n67183152)
print v(xbgr.mr_n67183264)
print v(xbgr.mr_n67183696)
print v(xbgr.mr_n67184016)
print v(xbgr.mr_n67184128)
print v(xbgr.mr_n67184448)
print v(xbgr.mr_n67184560)
print v(xbgr.mr_n67184992)
print v(xbgr.mr_n67185424)
print v(xbgr.mr_n67185744)
print v(xbgr.mr_n67185856)
print v(xbgr.mr_n67186176)
print v(xbgr.mr_n67186288)
print v(xbgr.mr_n67186608)
print v(xbgr.mr_n67186720)
print v(xbgr.mr_n67187040)
print v(xbgr.mr_n67187152)
print v(xbgr.mr_n67187472)
print v(xbgr.mr_n67187584)
print v(xbgr.mr_n67187904)
print v(xbgr.mr_n67188016)
print v(xbgr.mr_n67188336)
print v(xbgr.mr_n67188448)
print v(xbgr.mr_n67188768)
print v(xbgr.mr_n67188880)
print v(xbgr.mr_n67189200)
print v(xbgr.mr_n67189312)
print v(xbgr.mr_n67189632)
print v(xbgr.mr_n67189744)
print v(xbgr.mr_n67190064)
print v(xbgr.mr_n67190176)
print v(xbgr.mr_n67190496)
print v(xbgr.mr_n67190608)
print v(xbgr.mr_n67191040)
print v(xbgr.mr_n67191360)
print v(xbgr.mr_n67191472)
print v(xbgr.mr_n67191792)
print v(xbgr.mr_n67191904)
print v(xbgr.mr_n67192224)
print v(xbgr.mr_n67192336)
print v(xbgr.mr_n67192656)
print v(xbgr.mr_n67192768)
print v(xbgr.mr_n67193088)
print v(xbgr.mr_n67193200)
print v(xbgr.mr_n67193520)
print v(xbgr.mr_n67193632)
print v(xbgr.mr_n67193952)
print v(xbgr.mr_n67194064)
print v(xbgr.mr_n67194384)
print v(xbgr.mr_n67194496)
print v(xbgr.mr_n67194816)
print v(xbgr.mr_n67194928)
print v(xbgr.mr_n67195248)
print v(xbgr.mr_n67195360)
print v(xbgr.mr_n67195792)
print v(xbgr.mr_n67196224)
print v(xbgr.mr_n67196544)
print v(xbgr.mr_n67196656)
print v(xbgr.mr_n67196976)
print v(xbgr.mr_n67197088)
print v(xbgr.mr_n67197408)
print v(xbgr.mr_n67197520)
print v(xbgr.mr_n67197840)
print v(xbgr.mr_n67197952)
print v(xbgr.mr_n67198272)
print v(xbgr.mr_n67198384)
print v(xbgr.mr_n67198704)
print v(xbgr.mr_n67198816)
print v(xbgr.mr_n67199136)
print v(xbgr.mr_n67199248)
print v(xbgr.mr_n67199568)
print v(xbgr.mr_n67199680)
print v(xbgr.mr_n67200000)
print v(xbgr.mr_n67200112)
print v(xbgr.mr_n67200432)
print v(xbgr.mr_n67200544)
print v(xbgr.mr_n67200864)
print v(xbgr.mr_n67200976)
print v(xbgr.mr_n67201296)
print v(xbgr.mr_n67201408)
print v(xbgr.mr_n67201728)
print v(xbgr.mr_n67201840)
print v(xbgr.mr_n67202160)
print v(xbgr.mr_n67202272)
print v(xbgr.mr_n67202592)
print v(xbgr.mr_n67202704)
print v(xbgr.mr_n67203024)
print v(xbgr.mr_n67203136)
print v(xbgr.mr_n67203456)
print v(xbgr.mr_n67203568)
print v(xbgr.mr_n67203888)
print v(xbgr.mr_n67204000)
print v(xbgr.mr_n67204320)
print v(xbgr.mr_n67204432)
print v(xbgr.mr_n67204752)
print v(xbgr.mr_n67204864)
print v(xbgr.mr_n67205184)
print v(xbgr.mr_n67205296)
print v(xbgr.mr_n67205616)
print v(xbgr.mr_n67205728)
print v(xbgr.mr_n67206048)
print v(xbgr.mr_n67206160)
print v(xbgr.mr_n67206480)
print v(xbgr.mr_n67206592)
print v(xbgr.mr_n67206912)
print v(xbgr.mr_n67207024)
print v(xbgr.mr_n67207344)
print v(xbgr.mr_n67207456)
print v(xbgr.mr_n67207776)
print v(xbgr.mr_n67207888)
print v(xbgr.mr_n67208208)
print v(xbgr.mr_n67208320)
print v(xbgr.mr_n67208640)
print v(xbgr.mr_n67208752)
print v(xbgr.mr_n67209072)
print v(xbgr.mr_n67209184)
print v(xbgr.mr_n67209504)
print v(xbgr.mr_n67209616)
print v(xbgr.mr_n67209936)
print v(xbgr.mr_n67210048)
print v(xbgr.mr_n67210368)
print v(xbgr.mr_n67210480)
print v(xbgr.mr_n67210800)
print v(xbgr.mr_n67210912)
print v(xbgr.mr_n67211232)
print v(xbgr.mr_n67211344)
print v(xbgr.mr_n67211664)
print v(xbgr.mr_n67211776)
print v(xbgr.mr_n67212096)
print v(xbgr.mr_n67212208)
print v(xbgr.mr_n67212528)
print v(xbgr.mr_n67212640)
print v(xbgr.mr_n67212960)
print v(xbgr.mr_n67213072)
print v(xbgr.mr_n67213392)
print v(xbgr.mr_n67213504)
print v(xbgr.mr_n67213824)
print v(xbgr.mr_n67213936)
print v(xbgr.mr_n67214256)
print v(xbgr.mr_n67214368)
print v(xbgr.mr_n67214688)
print v(xbgr.mr_n67214800)
print v(xbgr.mr_n67215120)
print v(xbgr.mr_n67215232)
print v(xbgr.mr_n67215552)
print v(xbgr.mr_n67215664)
print v(xbgr.mr_n67215984)
print v(xbgr.mr_n67216096)
print v(xbgr.mr_n67216416)
print v(xbgr.mr_n67216528)
print v(xbgr.mr_n67216848)
print v(xbgr.mr_n67216960)
print v(xbgr.mr_n67217280)
print v(xbgr.mr_n67217392)
print v(xbgr.mr_n67217712)
print v(xbgr.mr_n67217824)
print v(xbgr.mr_n67218144)
print v(xbgr.mr_n67218256)
print v(xbgr.mr_n67218576)
print v(xbgr.mr_n67218688)
print v(xbgr.mr_n67219008)
print v(xbgr.mr_n67219120)
print v(xbgr.mr_n67219440)
print v(xbgr.mr_n67219552)
print v(xbgr.mr_n67219872)
print v(xbgr.mr_n67219984)
print v(xbgr.mr_n67220304)
print v(xbgr.mr_n67220416)
print v(xbgr.mr_n67220736)
print v(xbgr.mr_n67220848)
print v(xbgr.mr_n67221168)
print v(xbgr.mr_n67221280)
print v(xbgr.mr_n67221600)
print v(xbgr.mr_n67221712)
print v(xbgr.mr_n67222032)
print v(xbgr.mr_n67222144)
print v(xbgr.mr_n67222464)
print v(xbgr.mr_n67222576)
print v(xbgr.mr_n67222896)
print v(xbgr.mr_n67223008)
print v(xbgr.mr_n67223328)
print v(xbgr.mr_n67223440)
print v(xbgr.mr_n67223760)
print v(xbgr.mr_n67223872)
print v(xbgr.mr_n67224192)
print v(xbgr.mr_n67224304)
print v(xbgr.mr_n67224624)
print v(xbgr.mr_n67224736)
print v(xbgr.mr_n67225056)
print v(xbgr.mr_n67225168)
print v(xbgr.mr_n67225488)
print v(xbgr.mr_n67225600)
print v(xbgr.mr_n67225920)
print v(xbgr.mr_n67226032)
print v(xbgr.mr_n67226352)
print v(xbgr.mr_n67226464)
print v(xbgr.mr_n67226784)
print v(xbgr.mr_n67226896)
print v(xbgr.mr_n67227216)
print v(xbgr.mr_n67227328)
print v(xbgr.mr_n67227648)
print v(xbgr.mr_n67227760)
print v(xbgr.mr_n67228080)
print v(xbgr.mr_n67228192)
print v(xbgr.mr_n67228512)
print v(xbgr.mr_n67228624)
print v(xbgr.mr_n67228944)
print v(xbgr.mr_n67229056)
print v(xbgr.mr_n67229376)
print v(xbgr.mr_n67229488)
print v(xbgr.mr_n67229808)
print v(xbgr.mr_n67229920)
print v(xbgr.mr_n67230240)
print v(xbgr.mr_n67230352)
print v(xbgr.mr_n67230672)
print v(xbgr.mr_n67230784)
print v(xbgr.mr_n67231104)
print v(xbgr.mr_n67231216)
print v(xbgr.mr_n67231536)
print v(xbgr.mr_n67231648)
print v(xbgr.mr_n67231968)
print v(xbgr.mr_n67232080)
print v(xbgr.mr_n67232400)
print v(xbgr.mr_n67232512)
print v(xbgr.mr_n67232832)
print v(xbgr.mr_n67232944)
print v(xbgr.mr_n67233264)
print v(xbgr.mr_n67233376)
print v(xbgr.mr_n67233696)
print v(xbgr.mr_n67233808)
print v(xbgr.mr_n67234128)
print v(xbgr.mr_n67234240)
print v(xbgr.mr_n67234560)
print v(xbgr.mr_n67234672)
print v(xbgr.mr_n67234992)
print v(xbgr.mr_n67235104)
print v(xbgr.mr_n67235424)
print v(xbgr.mr_n67235536)
print v(xbgr.mr_n67235856)
print v(xbgr.mr_n67235968)
print v(xbgr.mr_n67236288)
print v(xbgr.mr_n67236400)
print v(xbgr.mr_n67236720)
print v(xbgr.mr_n67236832)
print v(xbgr.mr_n67237152)
print v(xbgr.mr_n67237264)
print v(xbgr.mr_n67237584)
print v(xbgr.mr_n67237696)
print v(xbgr.mr_n67238016)
print v(xbgr.mr_n67238128)
print v(xbgr.mr_n67238448)
print v(xbgr.mr_n67238560)
print v(xbgr.mr_n67238880)
print v(xbgr.mr_n67238992)
print v(xbgr.mr_n67239312)
print v(xbgr.mr_n67239424)
print v(xbgr.mr_n67239744)
print v(xbgr.mr_n67239856)
print v(xbgr.mr_n67240176)
print v(xbgr.mr_n67240288)
print v(xbgr.mr_n67240608)
print v(xbgr.mr_n67240720)
print v(xbgr.mr_n67241040)
print v(xbgr.mr_n67241152)
print v(xbgr.mr_n67241472)
print v(xbgr.mr_n67241584)
print v(xbgr.mr_n67241904)
print v(xbgr.mr_n67242016)
print v(xbgr.mr_n67242336)
print v(xbgr.mr_n67242448)
print v(xbgr.mr_n67242768)
print v(xbgr.mr_n67242880)
print v(xbgr.mr_n67243200)
print v(xbgr.mr_n67243312)
print v(xbgr.mr_n67243632)
print v(xbgr.mr_n67243744)
print v(xbgr.mr_n67244064)
print v(xbgr.mr_n67244176)
print v(xbgr.mr_n67244496)
print v(xbgr.mr_n67244608)
print v(xbgr.mr_n67244928)
print v(xbgr.mr_n67245040)
print v(xbgr.mr_n67245360)
print v(xbgr.mr_n67245472)
print v(xbgr.mr_n67245792)
print v(xbgr.mr_n67245904)
print v(xbgr.mr_n67246224)
print v(xbgr.mr_n67246336)
print v(xbgr.mr_n67246656)
print v(xbgr.mr_n67246768)
print v(xbgr.mr_n67247088)
print v(xbgr.mr_n67247200)
print v(xbgr.mr_n67247520)
print v(xbgr.mr_n67247632)
print v(xbgr.mr_n67247952)
print v(xbgr.mr_n67248064)
print v(xbgr.mr_n67248384)
print v(xbgr.mr_n67248496)
print v(xbgr.mr_n67248816)
print v(xbgr.mr_n67248928)
print v(xbgr.mr_n67249248)
print v(xbgr.mr_n67249360)
print v(xbgr.mr_n67249680)
print v(xbgr.mr_n67249792)
print v(xbgr.mr_n67250112)
print v(xbgr.mr_n67250224)
print v(xbgr.mr_n67250544)
print v(xbgr.mr_n67250656)
print v(xbgr.mr_n67250976)
print v(xbgr.mr_n67251088)
print v(xbgr.mr_n67251408)
print v(xbgr.mr_n67251520)
print v(xbgr.mr_n67251840)
print v(xbgr.mr_n67251952)
print v(xbgr.mr_n67252272)
print v(xbgr.mr_n67252384)
print v(xbgr.mr_n67252704)
print v(xbgr.mr_n67252816)
print v(xbgr.mr_n67253136)
print v(xbgr.mr_n67253248)
print v(xbgr.mr_n67253568)
print v(xbgr.mr_n67253680)
print v(xbgr.mr_n67254000)
print v(xbgr.mr_n67254112)
print v(xbgr.mr_n67254432)
print v(xbgr.mr_n67254544)
print v(xbgr.mr_n67254864)
print v(xbgr.mr_n67254976)
print v(xbgr.mr_n67255296)
print v(xbgr.mr_n67255408)
print v(xbgr.mr_n67255728)
print v(xbgr.mr_n67255840)
print v(xbgr.mr_n67256160)
print v(xbgr.mr_n67256272)
print v(xbgr.mr_n67256592)
print v(xbgr.mr_n67256704)
print v(xbgr.mr_n67257024)
print v(xbgr.mr_n67257136)
print v(xbgr.mr_n67257456)
print v(xbgr.mr_n67257568)
print v(xbgr.mr_n67257888)
print v(xbgr.mr_n67258000)
print v(xbgr.mr_n67258320)
print v(xbgr.mr_n67258432)
print v(xbgr.mr_n67258752)
print v(xbgr.mr_n67258864)
print v(xbgr.mr_n67259184)
print v(xbgr.mr_n67259296)
print v(xbgr.mr_n67259616)
print v(xbgr.mr_n67259728)
print v(xbgr.mr_n67260048)
print v(xbgr.mr_n67260160)
print v(xbgr.mr_n67260480)
print v(xbgr.mr_n67260592)
print v(xbgr.mr_n67260912)
print v(xbgr.mr_n67261024)
print v(xbgr.mr_n67261344)
print v(xbgr.mr_n67261456)
print v(xbgr.mr_n67261776)
print v(xbgr.mr_n67261888)
print v(xbgr.mr_n67262208)
print v(xbgr.mr_n67262320)
print v(xbgr.mr_n67262640)
print v(xbgr.mr_n67262752)
print v(xbgr.mr_n67263072)
print v(xbgr.mr_n67263184)
print v(xbgr.mr_n67263504)
print v(xbgr.mr_n67263616)
print v(xbgr.mr_n67263936)
print v(xbgr.mr_n67264048)
print v(xbgr.mr_n67264480)
print v(xbgr.mr_n67264800)
print v(xbgr.mr_n67264912)
print v(xbgr.mr_n67265232)
print v(xbgr.mr_n67265344)
print v(xbgr.mr_n67265664)
print v(xbgr.mr_n67265776)
print v(xbgr.mr_n67266096)
print v(xbgr.mr_n67266208)
print v(xbgr.mr_n67266528)
print v(xbgr.mr_n67267392)
print v(xbgr.mr_n67267504)
print v(xbgr.mr_n67267824)
print v(xbgr.mr_n67267936)
print v(xbgr.mr_n67268256)
print v(xbgr.mr_n67268368)
print v(xbgr.mr_n67268688)
print v(xbgr.mr_n67268800)
print v(xbgr.mr_n67269120)
print v(xbgr.mr_n67269232)
print v(xbgr.mr_n67269664)
print v(xbgr.mr_n67269984)
print v(xbgr.mr_n67270096)
print v(xbgr.mr_n67270416)
print v(xbgr.mr_n67270528)
print v(xbgr.mr_n67270848)
print v(xbgr.mr_n67270960)
print v(xbgr.mr_n67271280)
print v(xbgr.mr_n67271392)
print v(xbgr.mr_n67271712)
print v(xbgr.mr_n67271824)
print v(xbgr.mr_n67272256)
print v(xbgr.mr_n67272576)
print v(xbgr.mr_n67273440)
print v(xbgr.mr_n67273552)
print v(xbgr.mr_n67273984)
print v(xbgr.mr_n67274304)
print v(xbgr.mr_n67275168)
print v(xbgr.mr_n67275280)
print v(xbgr.mr_n67275712)
print v(xbgr.mr_n67276032)
print v(xbgr.mr_n67276144)
print v(xbgr.mr_n67276464)
print v(xbgr.mr_n67276576)
print v(xbgr.mr_n67276896)
print v(xbgr.mr_n67277008)
print v(xbgr.mr_n67277328)
print v(xbgr.mr_n67277440)
print v(xbgr.mr_n67277760)
print v(xbgr.mr_n67277872)
print v(xbgr.mr_n67278192)
print v(xbgr.mr_n67278304)
print v(xbgr.mr_n67278624)
print v(xbgr.mr_n67279488)
print v(xbgr.mr_n67279600)
print v(xbgr.mr_n67279920)
print v(xbgr.mr_n67280032)
print v(xbgr.mr_n67280352)
print v(xbgr.mr_n67281216)
print v(xbgr.mr_n67281328)
print v(xbgr.mr_n67281648)
print v(xbgr.mr_n67281760)
print v(xbgr.mr_n67282080)
print v(xbgr.mr_n67282192)
print v(xbgr.mr_n67282512)
print v(xbgr.mr_n67282624)
print v(xbgr.mr_n67282944)
print v(xbgr.mr_n67283056)
print v(xbgr.mr_n67283376)
print v(xbgr.mr_n67283488)
print v(xbgr.mr_n67283808)
print v(xbgr.mr_n67283920)
print v(xbgr.mr_n67284240)
print v(xbgr.mr_n67284352)
print v(xbgr.mr_n67284672)
print v(xbgr.mr_n67284784)
print v(xbgr.mr_n67285104)
print v(xbgr.mr_n67285216)
print v(xbgr.mr_n67285536)
print v(xbgr.mr_n67285648)
print v(xbgr.mr_n67285968)
print v(xbgr.mr_n67286080)
print v(xbgr.mr_n67286400)
print v(xbgr.mr_n67286512)
print v(xbgr.mr_n67286832)
print v(xbgr.mr_n67286944)
print v(xbgr.mr_n67287264)
print v(xbgr.mr_n67287376)
print v(xbgr.mr_n67287696)
print v(xbgr.mr_n67287808)
print v(xbgr.mr_n67288128)
print v(xbgr.mr_n67288240)
print v(xbgr.mr_n67288560)
print v(xbgr.mr_n67288672)
print v(xbgr.mr_n67288992)
print v(xbgr.mr_n67289104)
print v(xbgr.mr_n67289424)
print v(xbgr.mr_n67289536)
print v(xbgr.mr_n67289856)
print v(xbgr.mr_n67289968)
print v(xbgr.mr_n67290288)
print v(xbgr.mr_n67290400)
print v(xbgr.mr_n67290720)
print v(xbgr.mr_n67290832)
print v(xbgr.mr_n67291152)
print v(xbgr.mr_n67291264)
print v(xbgr.mr_n67291584)
print v(xbgr.mr_n67291696)
print v(xbgr.mr_n67292016)
print v(xbgr.mr_n67292128)
print v(xbgr.mr_n67292560)
print v(xbgr.mr_n67292992)
print v(xbgr.mr_n67293424)
print v(xbgr.mr_n67293856)
print v(xbgr.mr_n67294288)
print v(xbgr.mr_n67294720)
print v(xbgr.mr_n67295152)
print v(xbgr.mr_n67295584)
print v(xbgr.mr_n67296016)
print v(xbgr.mr_n67296448)
print v(xbgr.mr_n67296880)
print v(xbgr.mr_n67297312)
print v(xbgr.mr_n67297744)
print v(xbgr.mr_n67298176)
print v(xbgr.mr_n67298608)
print v(xbgr.mr_n67299040)
print v(xbgr.mr_n67299472)
print v(xbgr.mr_n67299904)
print v(xbgr.mr_n67300336)
print v(xbgr.mr_n67300768)
print v(xbgr.mr_n67301200)
print v(xbgr.mr_n67301632)
print v(xbgr.mr_n67301952)
print v(xbgr.mr_n67302064)
print v(xbgr.mr_n67302496)
print v(xbgr.mr_n67302928)
print v(xbgr.mr_n67303360)
print v(xbgr.mr_n67303792)
print v(xbgr.mr_n67304224)
print v(xbgr.mr_n67304656)
print v(xbgr.mr_n67305088)
print v(xbgr.mr_n67305520)
print v(xbgr.mr_n67305952)
print v(xbgr.mr_n67306384)
print v(xbgr.mr_n67306816)
print v(xbgr.mr_n67307248)
print v(xbgr.mr_n67307680)
print v(xbgr.mr_n67308112)
print v(xbgr.mr_n67308544)
print v(xbgr.mr_n67308976)
print v(xbgr.mr_n67309408)
print v(xbgr.mr_n67309840)
print v(xbgr.mr_n67310272)
print v(xbgr.mr_n67310704)
print v(xbgr.mr_n67311136)
print v(xbgr.mr_n67311568)
print v(xbgr.mr_n67312000)
print v(xbgr.mr_n67312432)
print v(xbgr.mr_n67312864)
print v(xbgr.mr_n67313296)
print v(xbgr.mr_n67313728)
print v(xbgr.mr_n67314160)
print v(xbgr.mr_n67314592)
print v(xbgr.mr_n67315024)
print v(xbgr.mr_n67315456)
print v(xbgr.mr_n67315888)
print v(xbgr.mr_n67316320)
print v(xbgr.mr_n67316752)
print v(xbgr.mr_n67317184)
print v(xbgr.mr_n67317616)
print v(xbgr.mr_n67318048)
print v(xbgr.mr_n67318480)
print v(xbgr.mr_n67318912)
print v(xbgr.mr_n67319344)
print v(xbgr.mr_n67319776)
print v(xbgr.mr_n67320208)
print v(xbgr.mr_n67320640)
print v(xbgr.mr_n67321072)
print v(xbgr.mr_n67321504)
print v(xbgr.mr_n67321936)
print v(xbgr.mr_n67322368)
print v(xbgr.mr_n67322800)
print v(xbgr.mr_n67323232)
print v(xbgr.mr_n67323664)
print v(xbgr.mr_n67324096)
print v(xbgr.mr_n67324528)
print v(xbgr.mr_n67324960)
print v(xbgr.mr_n67325392)
print v(xbgr.mr_n67325824)
print v(xbgr.mr_n67326256)
print v(xbgr.mr_n67326688)
print v(xbgr.mr_n67327120)
print v(xbgr.mr_n67327552)
print v(xbgr.mr_n67327984)
print v(xbgr.mr_n67328416)
print v(xbgr.mr_n67328848)
print v(xbgr.mr_n67329280)
print v(xbgr.mr_n67329600)
print v(xbgr.mr_n67329712)
print v(xbgr.mr_n67330032)
print v(xbgr.mr_n67330144)
print v(xbgr.mr_n67330464)
print v(xbgr.mr_n67330576)
print v(xbgr.mr_n67330896)
print v(xbgr.mr_n67331008)
print v(xbgr.mr_n67331328)
print v(xbgr.mr_n67331440)
print v(xbgr.mr_n67331760)
print v(xbgr.mr_n67331872)
print v(xbgr.mr_n67332192)
print v(xbgr.mr_n67332304)
print v(xbgr.mr_n67332624)
print v(xbgr.mr_n67332736)
print v(xbgr.mr_n67333056)
print v(xbgr.mr_n67333168)
print v(xbgr.mr_n67333488)
print v(xbgr.mr_n67333600)
print v(xbgr.mr_n67333920)
print v(xbgr.mr_n67334032)
print v(xbgr.mr_n67334352)
print v(xbgr.mr_n67334464)
print v(xbgr.mr_n67334784)
print v(xbgr.mr_n67335216)
print v(xbgr.mr_n67335328)
print v(xbgr.mr_n67335648)
print v(xbgr.mr_n67335760)
print v(xbgr.mr_n67336080)
print v(xbgr.mr_n67336192)
print v(xbgr.mr_n67336512)
print v(xbgr.mr_n67336624)
print v(xbgr.mr_n67336944)
print v(xbgr.mr_n67337056)
print v(xbgr.mr_n67337376)
print v(xbgr.mr_n67337488)
print v(xbgr.mr_n67337808)
print v(xbgr.mr_n67337920)
print v(xbgr.mr_n67338240)
print v(xbgr.mr_n67338352)
print v(xbgr.mr_n67338672)
print v(xbgr.mr_n67338784)
print v(xbgr.mr_n67339104)
print v(xbgr.mr_n67339216)
print v(xbgr.mr_n67339536)
print v(xbgr.mr_n67339648)
print v(xbgr.mr_n67340080)
print v(xbgr.mr_n67340512)
print v(xbgr.mr_n67340944)
print v(xbgr.mr_n67341376)
print v(xbgr.mr_n67341808)
print v(xbgr.mr_n67342240)
print v(xbgr.mr_n67342672)
print v(xbgr.mr_n67343104)
print v(xbgr.mr_n67343536)
print v(xbgr.mr_n67343968)
print v(xbgr.mr_n67344400)
print v(xbgr.mr_n67344832)
print v(xbgr.mr_n67345264)
print v(xbgr.mr_n67345696)
print v(xbgr.mr_n67346128)
print v(xbgr.mr_n67346560)
print v(xbgr.mr_n67346992)
print v(xbgr.mr_n67347424)
print v(xbgr.mr_n67347856)
print v(xbgr.mr_n67348288)
print v(xbgr.mr_n67348720)
print v(xbgr.mr_n67349152)
print v(xbgr.mr_n67349584)
print v(xbgr.mr_n67350016)
print v(xbgr.mr_n67350448)
print v(xbgr.mr_n67350880)
print v(xbgr.mr_n67351312)
print v(xbgr.mr_n67351744)
print v(xbgr.mr_n67352176)
print v(xbgr.mr_n67352608)
print v(xbgr.mr_n67353040)
print v(xbgr.mr_n67353472)
print v(xbgr.mr_n67353904)
print v(xbgr.mr_n67354336)
print v(xbgr.mr_n67354768)
print v(xbgr.mr_n67355200)
print v(xbgr.mr_n67355632)
print v(xbgr.mr_n67356064)
print v(xbgr.mr_n67356496)
print v(xbgr.mr_n67356928)
print v(xbgr.mr_n67357360)
print v(xbgr.mr_n67357792)
print v(xbgr.mr_n67358224)
print v(xbgr.mr_n67358656)
print v(xbgr.mr_n67359088)
print v(xbgr.mr_n67359520)
print v(xbgr.mr_n67359952)
print v(xbgr.mr_n67360384)
print v(xbgr.mr_n67360816)
print v(xbgr.mr_n67361248)
print v(xbgr.mr_n67361680)
print v(xbgr.mr_n67362112)
print v(xbgr.mr_n67362544)
print v(xbgr.mr_n67362976)
print v(xbgr.mr_n67363408)
print v(xbgr.mr_n67363840)
print v(xbgr.mr_n67364272)
print v(xbgr.mr_n67364704)
print v(xbgr.mr_n67365136)
print v(xbgr.mr_n67365568)
print v(xbgr.mr_n67366000)
print v(xbgr.mr_n67366432)
print v(xbgr.mr_n67366864)
print v(xbgr.mr_n67367296)
print v(xbgr.mr_n67367728)
print v(xbgr.mr_n67368160)
print v(xbgr.mr_n67368592)
print v(xbgr.mr_n67369024)
print v(xbgr.mr_n67369456)
print v(xbgr.mr_n67369888)
print v(xbgr.mr_n67370320)
print v(xbgr.mr_n67370752)
print v(xbgr.mr_n67371184)
print v(xbgr.mr_n67371616)
print v(xbgr.mr_n67372048)
print v(xbgr.mr_n67372480)
print v(xbgr.mr_n67372912)
print v(xbgr.mr_n67373344)
print v(xbgr.mr_n67373776)
print v(xbgr.mr_n67374208)
print v(xbgr.mr_n67374640)
print v(xbgr.mr_n67375072)
print v(xbgr.mr_n67375504)
print v(xbgr.mr_n67375936)
print v(xbgr.mr_n67376368)
print v(xbgr.mr_n67376800)
print v(xbgr.mr_n67377120)
print v(xbgr.mr_n67377232)
print v(xbgr.mr_n67377552)
print v(xbgr.mr_n67377664)
print v(xbgr.mr_n67377984)
print v(xbgr.mr_n67378096)
print v(xbgr.mr_n67378416)
print v(xbgr.mr_n67378528)
print v(xbgr.mr_n67378848)
print v(xbgr.mr_n67378960)
print v(xbgr.mr_n67379280)
print v(xbgr.mr_n67379392)
print v(xbgr.mr_n67379712)
print v(xbgr.mr_n67379824)
print v(xbgr.mr_n67380144)
print v(xbgr.mr_n67380256)
print v(xbgr.mr_n67380576)
print v(xbgr.mr_n67380688)
print v(xbgr.mr_n67381008)
print v(xbgr.mr_n67381120)
print v(xbgr.mr_n67381440)
print v(xbgr.mr_n67381552)
print v(xbgr.mr_n67381872)
print v(xbgr.mr_n67381984)
print v(xbgr.mr_n67382304)
print v(xbgr.mr_n67382416)
print v(xbgr.mr_n67382736)
print v(xbgr.mr_n67382848)
print v(xbgr.mr_n67383168)
print v(xbgr.mr_n67383280)
print v(xbgr.mr_n67383600)
print v(xbgr.mr_n67383712)
print v(xbgr.mr_n67384032)
print v(xbgr.mr_n67384144)
print v(xbgr.mr_n67384464)
print v(xbgr.mr_n67384576)
print v(xbgr.mr_n67384896)
print v(xbgr.mr_n67385440)
print v(xbgr.mr_n67385760)
print v(xbgr.mr_n67386192)
print v(xbgr.mr_n67386304)
print v(xbgr.mr_n67386624)
print v(xbgr.mr_n67386736)
print v(xbgr.mr_n67387168)
print v(xbgr.mr_n67387488)
print v(xbgr.mr_n67388352)
print v(xbgr.mr_n67388464)
print v(xbgr.mr_n67388896)
print v(xbgr.mr_n67389216)
print v(xbgr.mr_n67390080)
print v(xbgr.mr_n67390192)
print v(xbgr.mr_n67390624)
print v(xbgr.mr_n67390944)
print v(xbgr.mr_n67391056)
print v(xbgr.mr_n67391488)
print v(xbgr.mr_n67391920)
print v(xbgr.mr_n67392240)
print v(xbgr.mr_n67393104)
print v(xbgr.mr_n67394080)
print v(xbgr.mr_n67394400)
print v(xbgr.mr_n67394512)
print v(xbgr.mr_n67394944)
print v(xbgr.mr_n67395264)
print v(xbgr.mr_n67395376)
print v(xbgr.mr_n67395808)
print v(xbgr.mr_n67396128)
print v(xbgr.mr_n67396240)
print v(xbgr.mr_n67396560)
print v(xbgr.mr_n67396672)
print v(xbgr.mr_n67396992)
print v(xbgr.mr_n67397104)
print v(xbgr.mr_n67397424)
print v(xbgr.mr_n67397536)
print v(xbgr.mr_n67397856)
print v(xbgr.mr_n67397968)
print v(xbgr.mr_n67398288)
print v(xbgr.mr_n67398400)
print v(xbgr.mr_n67398720)
print v(xbgr.mr_n67398832)
print v(xbgr.mr_n67399152)
print v(xbgr.mr_n67399264)
print v(xbgr.mr_n67399584)
print v(xbgr.mr_n67399696)
print v(xbgr.mr_n67400016)
print v(xbgr.mr_n67400128)
print v(xbgr.mr_n67400448)
print v(xbgr.mr_n67400560)
print v(xbgr.mr_n67400880)
print v(xbgr.mr_n67400992)
print v(xbgr.mr_n67401312)
print v(xbgr.mr_n67402176)
print v(xbgr.mr_n67403040)
print v(xbgr.mr_n67403472)
print v(xbgr.mr_n67403904)
print v(xbgr.mr_n67404336)
print v(xbgr.mr_n67404768)
print v(xbgr.mr_n67405200)
print v(xbgr.mr_n67405632)
print v(xbgr.mr_n67406064)
print v(xbgr.mr_n67406496)
print v(xbgr.mr_n67406928)
print v(xbgr.mr_n67407360)
print v(xbgr.mr_n67407792)
print v(xbgr.mr_n67408224)
print v(xbgr.mr_n67408336)
print v(xbgr.mr_n67408656)
print v(xbgr.mr_n67408768)
print v(xbgr.mr_n67409088)
print v(xbgr.mr_n67409200)
print v(xbgr.mr_n67409520)
print v(xbgr.mr_n67409632)
print v(xbgr.mr_n67409952)
print v(xbgr.mr_n67410064)
print v(xbgr.mr_n67410384)
print v(xbgr.mr_n67410496)
print v(xbgr.mr_n67410816)
print v(xbgr.mr_n67410928)
print v(xbgr.mr_n67411248)
print v(xbgr.mr_n67411360)
print v(xbgr.mr_n67411680)
print v(xbgr.mr_n67411792)
print v(xbgr.mr_n67412112)
print v(xbgr.mr_n67412224)
print v(xbgr.mr_n67412544)
print v(xbgr.mr_n67412656)
print v(xbgr.mr_n67412976)
print v(xbgr.mr_n67413088)
print v(xbgr.mr_n67413408)
print v(xbgr.mr_n67413840)
print v(xbgr.mr_n67413952)
print v(xbgr.mr_n67414272)
print v(xbgr.mr_n67414384)
print v(xbgr.mr_n67414704)
print v(xbgr.mr_n67414816)
print v(xbgr.mr_n67415136)
print v(xbgr.mr_n67415248)
print v(xbgr.mr_n67415568)
print v(xbgr.mr_n67415680)
print v(xbgr.mr_n67416000)
print v(xbgr.mr_n67416112)
print v(xbgr.mr_n67416432)
print v(xbgr.mr_n67416544)
print v(xbgr.mr_n67416864)
print v(xbgr.mr_n67416976)
print v(xbgr.mr_n67417296)
print v(xbgr.mr_n67417408)
print v(xbgr.mr_n67417728)
print v(xbgr.mr_n67417840)
print v(xbgr.mr_n67418160)
print v(xbgr.mr_n67418272)
print v(xbgr.mr_n67418592)
print v(xbgr.mr_n67418704)
print v(xbgr.mr_n67419024)
print v(xbgr.mr_n67419136)
print v(xbgr.mr_n67419456)
print v(xbgr.mr_n67419568)
print v(xbgr.mr_n67419888)
print v(xbgr.mr_n67420000)
print v(xbgr.mr_n67420320)
print v(xbgr.mr_n67420432)
print v(xbgr.mr_n67420752)
print v(xbgr.mr_n67420864)
print v(xbgr.mr_n67421184)
print v(xbgr.mr_n67421296)
print v(xbgr.mr_n67421616)
print v(xbgr.mr_n67421728)
print v(xbgr.mr_n67422048)
print v(xbgr.mr_n67422160)
print v(xbgr.mr_n67422480)
print v(xbgr.mr_n67422592)
print v(xbgr.mr_n67422912)
print v(xbgr.mr_n67423024)
print v(xbgr.mr_n67423344)
print v(xbgr.mr_n67423456)
print v(xbgr.mr_n67423776)
print v(xbgr.mr_n67423888)
print v(xbgr.mr_n67424208)
print v(xbgr.mr_n67424320)
print v(xbgr.mr_n67424640)
print v(xbgr.mr_n67424752)
print v(xbgr.mr_n67425072)
print v(xbgr.mr_n67425184)
print v(xbgr.mr_n67425504)
print v(xbgr.mr_n67425616)
print v(xbgr.mr_n67425936)
print v(xbgr.mr_n67426048)
print v(xbgr.mr_n67426368)
print v(xbgr.mr_n67426480)
print v(xbgr.mr_n67426800)
print v(xbgr.mr_n67426912)
print v(xbgr.mr_n67427232)
print v(xbgr.mr_n67427344)
print v(xbgr.mr_n67427664)
print v(xbgr.mr_n67427776)
print v(xbgr.mr_n67428096)
print v(xbgr.mr_n67428208)
print v(xbgr.mr_n67428528)
print v(xbgr.mr_n67428640)
print v(xbgr.mr_n67428960)
print v(xbgr.mr_n67429072)
print v(xbgr.mr_n67429392)
print v(xbgr.mr_n67429504)
print v(xbgr.mr_n67429824)
print v(xbgr.mr_n67429936)
print v(xbgr.mr_n67430256)
print v(xbgr.mr_n67430368)
print v(xbgr.mr_n67430688)
print v(xbgr.mr_n67430800)
print v(xbgr.mr_n67431120)
print v(xbgr.mr_n67431232)
print v(xbgr.mr_n67431552)
print v(xbgr.mr_n67431664)
print v(xbgr.mr_n67431984)
print v(xbgr.mr_n67432096)
print v(xbgr.mr_n67432416)
print v(xbgr.mr_n67432528)
print v(xbgr.mr_n67432848)
print v(xbgr.mr_n67432960)
print v(xbgr.mr_n67433280)
print v(xbgr.mr_n67433392)
print v(xbgr.mr_n67433712)
print v(xbgr.mr_n67433824)
print v(xbgr.mr_n67434144)
print v(xbgr.mr_n67434256)
print v(xbgr.mr_n67434576)
print v(xbgr.mr_n67434688)
print v(xbgr.mr_n67435008)
print v(xbgr.mr_n67435120)
print v(xbgr.mr_n67435440)
print v(xbgr.mr_n67435552)
print v(xbgr.mr_n67435872)
print v(xbgr.mr_n67435984)
print v(xbgr.mr_n67436304)
print v(xbgr.mr_n67436416)
print v(xbgr.mr_n67436736)
print v(xbgr.mr_n67436848)
print v(xbgr.mr_n67437168)
print v(xbgr.mr_n67437280)
print v(xbgr.mr_n67437600)
print v(xbgr.mr_n67437712)
print v(xbgr.mr_n67438032)
print v(xbgr.mr_n67438144)
print v(xbgr.mr_n67438464)
print v(xbgr.mr_n67438576)
print v(xbgr.mr_n67438896)
print v(xbgr.mr_n67439008)
print v(xbgr.mr_n67439328)
print v(xbgr.mr_n67439440)
print v(xbgr.mr_n67439760)
print v(xbgr.mr_n67439872)
print v(xbgr.mr_n67440192)
print v(xbgr.mr_n67440304)
print v(xbgr.mr_n67440624)
print v(xbgr.mr_n67440736)
print v(xbgr.mr_n67441056)
print v(xbgr.mr_n67441168)
print v(xbgr.mr_n67441488)
print v(xbgr.mr_n67441600)
print v(xbgr.mr_n67441920)
print v(xbgr.mr_n67442032)
print v(xbgr.mr_n67442352)
print v(xbgr.mr_n67442464)
print v(xbgr.mr_n67442784)
print v(xbgr.mr_n67442896)
print v(xbgr.mr_n67443216)
print v(xbgr.mr_n67443328)
print v(xbgr.mr_n67443648)
print v(xbgr.mr_n67443760)
print v(xbgr.mr_n67444080)
print v(xbgr.mr_n67444192)
print v(xbgr.mr_n67444512)
print v(xbgr.mr_n67444624)
print v(xbgr.mr_n67444944)
print v(xbgr.mr_n67445056)
print v(xbgr.mr_n67445376)
print v(xbgr.mr_n67445808)
print v(xbgr.mr_n67445920)
print v(xbgr.mr_n67446240)
print v(xbgr.mr_n67446352)
print v(xbgr.mr_n67446672)
print v(xbgr.mr_n67446784)
print v(xbgr.mr_n67447104)
print v(xbgr.mr_n67447216)
print v(xbgr.mr_n67447536)
print v(xbgr.mr_n67447648)
print v(xbgr.mr_n67447968)
print v(xbgr.mr_n67448080)
print v(xbgr.mr_n67448400)
print v(xbgr.mr_n67448512)
print v(xbgr.mr_n67448832)
print v(xbgr.mr_n67448944)
print v(xbgr.mr_n67449264)
print v(xbgr.mr_n67449376)
print v(xbgr.mr_n67449696)
print v(xbgr.mr_n67449808)
print v(xbgr.mr_n67450128)
print v(xbgr.mr_n67450240)
print v(xbgr.mr_n67450560)
print v(xbgr.mr_n67450672)
print v(xbgr.mr_n67450992)
print v(xbgr.mr_n67451104)
print v(xbgr.mr_n67451424)
print v(xbgr.mr_n67451536)
print v(xbgr.mr_n67451856)
print v(xbgr.mr_n67451968)
print v(xbgr.mr_n67452288)
print v(xbgr.mr_n67452400)
print v(xbgr.mr_n67452720)
print v(xbgr.mr_n67452832)
print v(xbgr.mr_n67453152)
print v(xbgr.mr_n67453264)
print v(xbgr.mr_n67453584)
print v(xbgr.mr_n67454128)
print v(xbgr.mr_n67454448)
print v(xbgr.mr_n67454560)
print v(xbgr.mr_n67454880)
print v(xbgr.mr_n67454992)
print v(xbgr.mr_n67455424)
print v(xbgr.mr_n67455856)
print v(xbgr.mr_n67456288)
print v(xbgr.mr_n67456720)
print v(xbgr.mr_n67457152)
print v(xbgr.mr_n67457584)
print v(xbgr.mr_n67458016)
print v(xbgr.mr_n67458448)
print v(xbgr.mr_n67458880)
print v(xbgr.mr_n67459312)
print v(xbgr.mr_n67459744)
print v(xbgr.mr_n67460176)
print v(xbgr.mr_n67460608)
print v(xbgr.mr_n67461040)
print v(xbgr.mr_n67461472)
print v(xbgr.mr_n67461904)
print v(xbgr.mr_n67462336)
print v(xbgr.mr_n67462768)
print v(xbgr.mr_n67463200)
print v(xbgr.mr_n67463632)
print v(xbgr.mr_n67464064)
print v(xbgr.mr_n67464496)
print v(xbgr.mr_n67464928)
print v(xbgr.mr_n67465360)
print v(xbgr.mr_n67465792)
print v(xbgr.mr_n67466224)
print v(xbgr.mr_n67466656)
print v(xbgr.mr_n67467088)
print v(xbgr.mr_n67467520)
print v(xbgr.mr_n67467952)
print v(xbgr.mr_n67468384)
print v(xbgr.mr_n67468816)
print v(xbgr.mr_n67469248)
print v(xbgr.mr_n67469680)
print v(xbgr.mr_n67470112)
print v(xbgr.mr_n67470544)
print v(xbgr.mr_n67470976)
print v(xbgr.mr_n67471408)
print v(xbgr.mr_n67471840)
print v(xbgr.mr_n67472272)
print v(xbgr.mr_n67472704)
print v(xbgr.mr_n67473136)
print v(xbgr.mr_n67473568)
print v(xbgr.mr_n67474000)
print v(xbgr.mr_n67474432)
print v(xbgr.mr_n67474864)
print v(xbgr.mr_n67475296)
print v(xbgr.mr_n67475728)
print v(xbgr.mr_n67476160)
print v(xbgr.mr_n67476592)
print v(xbgr.mr_n67477024)
print v(xbgr.mr_n67477456)
print v(xbgr.mr_n67477888)
print v(xbgr.mr_n67478320)
print v(xbgr.mr_n67478752)
print v(xbgr.mr_n67479184)
print v(xbgr.mr_n67479616)
print v(xbgr.mr_n67480048)
print v(xbgr.mr_n67480480)
print v(xbgr.mr_n67480912)
print v(xbgr.mr_n67481344)
print v(xbgr.mr_n67481776)
print v(xbgr.mr_n67482208)
print v(xbgr.mr_n67482640)
print v(xbgr.mr_n67483072)
print v(xbgr.mr_n67483504)
print v(xbgr.mr_n67483936)
print v(xbgr.mr_n67484368)
print v(xbgr.mr_n67484800)
print v(xbgr.mr_n67485232)
print v(xbgr.mr_n67485664)
print v(xbgr.mr_n67486096)
print v(xbgr.mr_n67486528)
print v(xbgr.mr_n67486960)
print v(xbgr.mr_n67487392)
print v(xbgr.mr_n67487824)
print v(xbgr.mr_n67488256)
print v(xbgr.mr_n67488688)
print v(xbgr.mr_n67489120)
print v(xbgr.mr_n67489552)
print v(xbgr.mr_n67489984)
print v(xbgr.mr_n67490416)
print v(xbgr.mr_n67490848)
print v(xbgr.mr_n67491280)
print v(xbgr.mr_n67491712)
print v(xbgr.mr_n67492144)
print v(xbgr.mr_n67492576)
print v(xbgr.mr_n67493008)
print v(xbgr.mr_n67493440)
print v(xbgr.mr_n67493872)
print v(xbgr.mr_n67494304)
print v(xbgr.mr_n67494736)
print v(xbgr.mr_n67495168)
print v(xbgr.mr_n67495600)
print v(xbgr.mr_n67496032)
print v(xbgr.mr_n67496464)
print v(xbgr.mr_n67496896)
print v(xbgr.mr_n67497328)
print v(xbgr.mr_n67497760)
print v(xbgr.mr_n67498192)
print v(xbgr.mr_n67498624)
print v(xbgr.mr_n67499056)
print v(xbgr.mr_n67499488)
print v(xbgr.mr_n67499920)
print v(xbgr.mr_n67500352)
print v(xbgr.mr_n67500672)
print v(xbgr.mr_n67500784)
print v(xbgr.mr_n67501104)
print v(xbgr.mr_n67501216)
print v(xbgr.mr_n67501536)
print v(xbgr.mr_n67501648)
print v(xbgr.mr_n67501968)
print v(xbgr.mr_n67502080)
print v(xbgr.mr_n67502400)
print v(xbgr.mr_n67502512)
print v(xbgr.mr_n67502832)
print v(xbgr.mr_n67502944)
print v(xbgr.mr_n67503264)
print v(xbgr.mr_n67503376)
print v(xbgr.mr_n67503696)
print v(xbgr.mr_n67503808)
print v(xbgr.mr_n67504128)
print v(xbgr.mr_n67504240)
print v(xbgr.mr_n67504560)
print v(xbgr.mr_n67504672)
print v(xbgr.mr_n67504992)
print v(xbgr.mr_n67505104)
print v(xbgr.mr_n67505424)
print v(xbgr.mr_n67505536)
print v(xbgr.mr_n67505856)
print v(xbgr.mr_n67505968)
print v(xbgr.mr_n67506288)
print v(xbgr.mr_n67506400)
print v(xbgr.mr_n67506720)
print v(xbgr.mr_n67506832)
print v(xbgr.mr_n67507152)
print v(xbgr.mr_n67507264)
print v(xbgr.mr_n67507584)
print v(xbgr.mr_n67507696)
print v(xbgr.mr_n67508016)
print v(xbgr.mr_n67508128)
print v(xbgr.mr_n67508448)
print v(xbgr.mr_n67508560)
print v(xbgr.mr_n67508880)
print v(xbgr.mr_n67508992)
print v(xbgr.mr_n67509312)
print v(xbgr.mr_n67509424)
print v(xbgr.mr_n67509744)
print v(xbgr.mr_n67509856)
print v(xbgr.mr_n67510176)
print v(xbgr.mr_n67510288)
print v(xbgr.mr_n67510608)
print v(xbgr.mr_n67510720)
print v(xbgr.mr_n67511040)
print v(xbgr.mr_n67511152)
print v(xbgr.mr_n67511472)
print v(xbgr.mr_n67511584)
print v(xbgr.mr_n67511904)
print v(xbgr.mr_n67512016)
print v(xbgr.mr_n67512336)
print v(xbgr.mr_n67512448)
print v(xbgr.mr_n67512768)
print v(xbgr.mr_n67512880)
print v(xbgr.mr_n67513200)
print v(xbgr.mr_n67513312)
print v(xbgr.mr_n67513632)
print v(xbgr.mr_n67513744)
print v(xbgr.mr_n67514064)
print v(xbgr.mr_n67514176)
print v(xbgr.mr_n67514496)
print v(xbgr.mr_n67514608)
print v(xbgr.mr_n67514928)
print v(xbgr.mr_n67515040)
print v(xbgr.mr_n67515360)
print v(xbgr.mr_n67515472)
print v(xbgr.mr_n67515792)
print v(xbgr.mr_n67515904)
print v(xbgr.mr_n67516224)
print v(xbgr.mr_n67516336)
print v(xbgr.mr_n67516656)
print v(xbgr.mr_n67516768)
print v(xbgr.mr_n67517088)
print v(xbgr.mr_n67517200)
print v(xbgr.mr_n67517520)
print v(xbgr.mr_n67517632)
print v(xbgr.mr_n67517952)
print v(xbgr.mr_n67518064)
print v(xbgr.mr_n67518384)
print v(xbgr.mr_n67518496)
print v(xbgr.mr_n67518816)
print v(xbgr.mr_n67519248)
print v(xbgr.mr_n67519360)
print v(xbgr.mr_n67519680)
print v(xbgr.mr_n67519792)
print v(xbgr.mr_n67520112)
print v(xbgr.mr_n67520224)
print v(xbgr.mr_n67520544)
print v(xbgr.mr_n67520656)
print v(xbgr.mr_n67520976)
print v(xbgr.mr_n67521088)
print v(xbgr.mr_n67521408)
print v(xbgr.mr_n67521520)
print v(xbgr.mr_n67521840)
print v(xbgr.mr_n67521952)
print v(xbgr.mr_n67522272)
print v(xbgr.mr_n67522384)
print v(xbgr.mr_n67522704)
print v(xbgr.mr_n67522816)
print v(xbgr.mr_n67523136)
print v(xbgr.mr_n67523248)
print v(xbgr.mr_n67523568)
print v(xbgr.mr_n67523680)
print v(xbgr.mr_n67524000)
print v(xbgr.mr_n67524112)
print v(xbgr.mr_n67524432)
print v(xbgr.mr_n67524544)
print v(xbgr.mr_n67524864)
print v(xbgr.mr_n67524976)
print v(xbgr.mr_n67525296)
print v(xbgr.mr_n67525408)
print v(xbgr.mr_n67525728)
print v(xbgr.mr_n67525840)
print v(xbgr.mr_n67526160)
print v(xbgr.mr_n67526272)
print v(xbgr.mr_n67526592)
print v(xbgr.mr_n67526704)
print v(xbgr.mr_n67527024)
print v(xbgr.mr_n67527136)
print v(xbgr.mr_n67527456)
print v(xbgr.mr_n67527568)
print v(xbgr.mr_n67527888)
print v(xbgr.mr_n67528000)
print v(xbgr.mr_n67528320)
print v(xbgr.mr_n67528432)
print v(xbgr.mr_n67528752)
print v(xbgr.mr_n67528864)
print v(xbgr.mr_n67529184)
print v(xbgr.mr_n67529296)
print v(xbgr.mr_n67529616)
print v(xbgr.mr_n67529728)
print v(xbgr.mr_n67530048)
print v(xbgr.mr_n67530160)
print v(xbgr.mr_n67530480)
print v(xbgr.mr_n67530592)
print v(xbgr.mr_n67530912)
print v(xbgr.mr_n67531024)
print v(xbgr.mr_n67531344)
print v(xbgr.mr_n67531456)
print v(xbgr.mr_n67531776)
print v(xbgr.mr_n67531888)
print v(xbgr.mr_n67532208)
print v(xbgr.mr_n67532320)
print v(xbgr.mr_n67532640)
print v(xbgr.mr_n67532752)
print v(xbgr.mr_n67533072)
print v(xbgr.mr_n67533184)
print v(xbgr.mr_n67533504)
print v(xbgr.mr_n67533616)
print v(xbgr.mr_n67533936)
print v(xbgr.mr_n67534048)
print v(xbgr.mr_n67534368)
print v(xbgr.mr_n67534480)
print v(xbgr.mr_n67534800)
print v(xbgr.mr_n67534912)
print v(xbgr.mr_n67535232)
print v(xbgr.mr_n67535344)
print v(xbgr.mr_n67535664)
print v(xbgr.mr_n67535776)
print v(xbgr.mr_n67536096)
print v(xbgr.mr_n67536208)
print v(xbgr.mr_n67536528)
print v(xbgr.mr_n67536640)
print v(xbgr.mr_n67536960)
print v(xbgr.mr_n67537072)
print v(xbgr.mr_n67537392)
print v(xbgr.mr_n67537504)
print v(xbgr.mr_n67537824)
print v(xbgr.mr_n67537936)
print v(xbgr.mr_n67538256)
print v(xbgr.mr_n67538368)
print v(xbgr.mr_n67538688)
print v(xbgr.mr_n67538800)
print v(xbgr.mr_n67539120)
print v(xbgr.mr_n67539232)
print v(xbgr.mr_n67539552)
print v(xbgr.mr_n67539664)
print v(xbgr.mr_n67539984)
print v(xbgr.mr_n67540096)
print v(xbgr.mr_n67540416)
print v(xbgr.mr_n67540528)
print v(xbgr.mr_n67540848)
print v(xbgr.mr_n67540960)
print v(xbgr.mr_n67541280)
print v(xbgr.mr_n67541392)
print v(xbgr.mr_n67541712)
print v(xbgr.mr_n67541824)
print v(xbgr.mr_n67542144)
print v(xbgr.mr_n67542256)
print v(xbgr.mr_n67542576)
print v(xbgr.mr_n67542688)
print v(xbgr.mr_n67543008)
print v(xbgr.mr_n67543120)
print v(xbgr.mr_n67543440)
print v(xbgr.mr_n67543552)
print v(xbgr.mr_n67543872)
print v(xbgr.mr_n67543984)
print v(xbgr.mr_n67544304)
print v(xbgr.mr_n67544416)
print v(xbgr.mr_n67544736)
print v(xbgr.mr_n67544848)
print v(xbgr.mr_n67545168)
print v(xbgr.mr_n67545280)
print v(xbgr.mr_n67545600)
print v(xbgr.mr_n67545712)
print v(xbgr.mr_n67546032)
print v(xbgr.mr_n67546144)
print v(xbgr.mr_n67546464)
print v(xbgr.mr_n67546576)
print v(xbgr.mr_n67546896)
print v(xbgr.mr_n67547008)
print v(xbgr.mr_n67547328)
print v(xbgr.mr_n67547440)
print v(xbgr.mr_n67547760)
print v(xbgr.mr_n67547872)
print v(xbgr.mr_n67548192)
print v(xbgr.mr_n67548304)
print v(xbgr.mr_n67548624)
print v(xbgr.mr_n67548736)
print v(xbgr.mr_n67549056)
print v(xbgr.mr_n67549168)
print v(xbgr.mr_n67549488)
print v(xbgr.mr_n67549600)
print v(xbgr.mr_n67549920)
print v(xbgr.mr_n67550032)
print v(xbgr.mr_n67550352)
print v(xbgr.mr_n67550464)
print v(xbgr.mr_n67550784)
print v(xbgr.mr_n67550896)
print v(xbgr.mr_n67551216)
print v(xbgr.mr_n67551328)
print v(xbgr.mr_n67551648)
print v(xbgr.mr_n67551760)
print v(xbgr.mr_n67552080)
print v(xbgr.mr_n67552192)
print v(xbgr.mr_n67552512)
print v(xbgr.mr_n67552624)
print v(xbgr.mr_n67552944)
print v(xbgr.mr_n67553056)
print v(xbgr.mr_n67553376)
print v(xbgr.mr_n67553488)
print v(xbgr.mr_n67553808)
print v(xbgr.mr_n67553920)
print v(xbgr.mr_n67554240)
print v(xbgr.mr_n67554352)
print v(xbgr.mr_n67554672)
print v(xbgr.mr_n67554784)
print v(xbgr.mr_n67555104)
print v(xbgr.mr_n67555216)
print v(xbgr.mr_n67555536)
print v(xbgr.mr_n67555648)
print v(xbgr.mr_n67555968)
print v(xbgr.mr_n67556080)
print v(xbgr.mr_n67556400)
print v(xbgr.mr_n67556512)
print v(xbgr.mr_n67556832)
print v(xbgr.mr_n67556944)
print v(xbgr.mr_n67557264)
print v(xbgr.mr_n67557376)
print v(xbgr.mr_n67557696)
print v(xbgr.mr_n67557808)
print v(xbgr.mr_n67558128)
print v(xbgr.mr_n67558240)
print v(xbgr.mr_n67558560)
print v(xbgr.mr_n67558672)
print v(xbgr.mr_n67558992)
print v(xbgr.mr_n67559104)
print v(xbgr.mr_n67559424)
print v(xbgr.mr_n67559536)
print v(xbgr.mr_n67559856)
print v(xbgr.mr_n67559968)
print v(xbgr.mr_n67560288)
print v(xbgr.mr_n67560400)
print v(xbgr.mr_n67560720)
print v(xbgr.mr_n67560832)
print v(xbgr.mr_n67561152)
print v(xbgr.mr_n67561264)
print v(xbgr.mr_n67561584)
print v(xbgr.mr_n67561696)
print v(xbgr.mr_n67562016)
print v(xbgr.mr_n67562128)
print v(xbgr.mr_n67562448)
print v(xbgr.mr_n67562560)
print v(xbgr.mr_n67562880)
print v(xbgr.mr_n67562992)
print v(xbgr.mr_n67563312)
print v(xbgr.mr_n67563424)
print v(xbgr.mr_n67563744)
print v(xbgr.mr_n67563856)
print v(xbgr.mr_n67564176)
print v(xbgr.mr_n67564288)
print v(xbgr.mr_n67564608)
print v(xbgr.mr_n67564720)
print v(xbgr.mr_n67565040)
print v(xbgr.mr_n67565152)
print v(xbgr.mr_n67565472)
print v(xbgr.mr_n67565584)
print v(xbgr.mr_n67565904)
print v(xbgr.mr_n67566016)
print v(xbgr.mr_n67566336)
print v(xbgr.mr_n67566448)
print v(xbgr.mr_n67566768)
print v(xbgr.mr_n67566880)
print v(xbgr.mr_n67567200)
print v(xbgr.mr_n67567312)
print v(xbgr.mr_n67567632)
print v(xbgr.mr_n67567744)
print v(xbgr.mr_n67568064)
print v(xbgr.mr_n67568176)
print v(xbgr.mr_n67568496)
print v(xbgr.mr_n67568608)
print v(xbgr.mr_n67568928)
print v(xbgr.mr_n67569360)
print v(xbgr.mr_n67569472)
print v(xbgr.mr_n67569792)
print v(xbgr.mr_n67569904)
print v(xbgr.mr_n67570224)
print v(xbgr.mr_n67570336)
print v(xbgr.mr_n67570656)
print v(xbgr.mr_n67570768)
print v(xbgr.mr_n67571088)
print v(xbgr.mr_n67571200)
print v(xbgr.mr_n67571520)
print v(xbgr.mr_n67571632)
print v(xbgr.mr_n67571952)
print v(xbgr.mr_n67572064)
print v(xbgr.mr_n67572384)
print v(xbgr.mr_n67572496)
print v(xbgr.mr_n67572816)
print v(xbgr.mr_n67572928)
print v(xbgr.mr_n67573248)
print v(xbgr.mr_n67573360)
print v(xbgr.mr_n67573680)
print v(xbgr.mr_n67573792)
print v(xbgr.mr_n67574112)
print v(xbgr.mr_n67574224)
print v(xbgr.mr_n67574544)
print v(xbgr.mr_n67574656)
print v(xbgr.mr_n67574976)
print v(xbgr.mr_n67575088)
print v(xbgr.mr_n67575408)
print v(xbgr.mr_n67575520)
print v(xbgr.mr_n67575840)
print v(xbgr.mr_n67575952)
print v(xbgr.mr_n67576272)
print v(xbgr.mr_n67576384)
print v(xbgr.mr_n67576704)
print v(xbgr.mr_n67576816)
print v(xbgr.mr_n67577136)
print v(xbgr.mr_n67577248)
print v(xbgr.mr_n67577568)
print v(xbgr.mr_n67577680)
print v(xbgr.mr_n67578000)
print v(xbgr.mr_n67578112)
print v(xbgr.mr_n67578432)
print v(xbgr.mr_n67578544)
print v(xbgr.mr_n67578864)
print v(xbgr.mr_n67578976)
print v(xbgr.mr_n67579296)
print v(xbgr.mr_n67579408)
print v(xbgr.mr_n67579728)
print v(xbgr.mr_n67579840)
print v(xbgr.mr_n67580160)
print v(xbgr.mr_n67580272)
print v(xbgr.mr_n67580592)
print v(xbgr.mr_n67580704)
print v(xbgr.mr_n67581024)
print v(xbgr.mr_n67581136)
print v(xbgr.mr_n67581456)
print v(xbgr.mr_n67581568)
print v(xbgr.mr_n67581888)
print v(xbgr.mr_n67582000)
print v(xbgr.mr_n67582320)
print v(xbgr.mr_n67582432)
print v(xbgr.mr_n67582752)
print v(xbgr.mr_n67582864)
print v(xbgr.mr_n67583184)
print v(xbgr.mr_n67583296)
print v(xbgr.mr_n67583616)
print v(xbgr.mr_n67583728)
print v(xbgr.mr_n67584048)
print v(xbgr.mr_n67584160)
print v(xbgr.mr_n67584480)
print v(xbgr.mr_n67584592)
print v(xbgr.mr_n67584912)
print v(xbgr.mr_n67585024)
print v(xbgr.mr_n67585344)
print v(xbgr.mr_n67585456)
print v(xbgr.mr_n67585776)
print v(xbgr.mr_n67585888)
print v(xbgr.mr_n67586208)
print v(xbgr.mr_n67586320)
print v(xbgr.mr_n67586640)
print v(xbgr.mr_n67586752)
print v(xbgr.mr_n67587072)
print v(xbgr.mr_n67587184)
print v(xbgr.mr_n67587504)
print v(xbgr.mr_n67587616)
print v(xbgr.mr_n67587936)
print v(xbgr.mr_n67588048)
print v(xbgr.mr_n67588368)
print v(xbgr.mr_n67588480)
print v(xbgr.mr_n67588800)
print v(xbgr.mr_n67588912)
print v(xbgr.mr_n67589232)
print v(xbgr.mr_n67589344)
print v(xbgr.mr_n67589664)
print v(xbgr.mr_n67590096)
print v(xbgr.mr_n67590208)
print v(xbgr.mr_n67590528)
print v(xbgr.mr_n67590640)
print v(xbgr.mr_n67590960)
print v(xbgr.mr_n67591072)
print v(xbgr.mr_n67591392)
print v(xbgr.mr_n67591504)
print v(xbgr.mr_n67591824)
print v(xbgr.mr_n67591936)
print v(xbgr.mr_n67592256)
print v(xbgr.mr_n67592368)
print v(xbgr.mr_n67592800)
print v(xbgr.mr_n67593232)
print v(xbgr.mr_n67593552)
print v(xbgr.mr_n67593664)
print v(xbgr.mr_n67593984)
print v(xbgr.mr_n67594096)
print v(xbgr.mr_n67594416)
print v(xbgr.mr_n67594528)
print v(xbgr.mr_n67594848)
print v(xbgr.mr_n67594960)
print v(xbgr.mr_n67595280)
print v(xbgr.mr_n67595392)
print v(xbgr.mr_n67595712)
print v(xbgr.mr_n67595824)
print v(xbgr.mr_n67596144)
print v(xbgr.mr_n67596256)
print v(xbgr.mr_n67596576)
print v(xbgr.mr_n67596688)
print v(xbgr.mr_n67597008)
print v(xbgr.mr_n67597120)
print v(xbgr.mr_n67597440)
print v(xbgr.mr_n67597552)
print v(xbgr.mr_n67597872)
print v(xbgr.mr_n67597984)
print v(xbgr.mr_n67598304)
print v(xbgr.mr_n67598416)
print v(xbgr.mr_n67598736)
print v(xbgr.mr_n67598848)
print v(xbgr.mr_n67599168)
print v(xbgr.mr_n67599280)
print v(xbgr.mr_n67599600)
print v(xbgr.mr_n67599712)
print v(xbgr.mr_n67600032)
print v(xbgr.mr_n67600144)
print v(xbgr.mr_n67600464)
print v(xbgr.mr_n67600576)
print v(xbgr.mr_n67600896)
print v(xbgr.mr_n67601008)
print v(xbgr.mr_n67601328)
print v(xbgr.mr_n67601440)
print v(xbgr.mr_n67601760)
print v(xbgr.mr_n67601872)
print v(xbgr.mr_n67602192)
print v(xbgr.mr_n67602304)
print v(xbgr.mr_n67602624)
print v(xbgr.mr_n67602736)
print v(xbgr.mr_n67603056)
print v(xbgr.mr_n67603168)
print v(xbgr.mr_n67603488)
print v(xbgr.mr_n67603600)
print v(xbgr.mr_n67603920)
print v(xbgr.mr_n67604032)
print v(xbgr.mr_n67604352)
print v(xbgr.mr_n67604464)
print v(xbgr.mr_n67604784)
print v(xbgr.mr_n67604896)
print v(xbgr.mr_n67605216)
print v(xbgr.mr_n67605328)
print v(xbgr.mr_n67605648)
print v(xbgr.mr_n67605760)
print v(xbgr.mr_n67606080)
print v(xbgr.mr_n67606192)
print v(xbgr.mr_n67606512)
print v(xbgr.mr_n67606624)
print v(xbgr.mr_n67606944)
print v(xbgr.mr_n67607056)
print v(xbgr.mr_n67607376)
print v(xbgr.mr_n67607488)
print v(xbgr.mr_n67607808)
print v(xbgr.mr_n67607920)
print v(xbgr.mr_n67608240)
print v(xbgr.mr_n67608352)
print v(xbgr.mr_n67608672)
print v(xbgr.mr_n67608784)
print v(xbgr.mr_n67609104)
print v(xbgr.mr_n67609216)
print v(xbgr.mr_n67609536)
print v(xbgr.mr_n67609648)
print v(xbgr.mr_n67609968)
print v(xbgr.mr_n67610080)
print v(xbgr.mr_n67610400)
print v(xbgr.mr_n67610512)
print v(xbgr.mr_n67610832)
print v(xbgr.mr_n67610944)
print v(xbgr.mr_n67611264)
print v(xbgr.mr_n67611376)
print v(xbgr.mr_n67611696)
print v(xbgr.mr_n67611808)
print v(xbgr.mr_n67612128)
print v(xbgr.mr_n67612240)
print v(xbgr.mr_n67612560)
print v(xbgr.mr_n67612672)
print v(xbgr.mr_n67612992)
print v(xbgr.mr_n67613104)
print v(xbgr.mr_n67613424)
print v(xbgr.mr_n67613536)
print v(xbgr.mr_n67613856)
print v(xbgr.mr_n67613968)
print v(xbgr.mr_n67614288)
print v(xbgr.mr_n67614400)
print v(xbgr.mr_n67614720)
print v(xbgr.mr_n67614832)
print v(xbgr.mr_n67615152)
print v(xbgr.mr_n67615264)
print v(xbgr.mr_n67615584)
print v(xbgr.mr_n67615696)
print v(xbgr.mr_n67616016)
print v(xbgr.mr_n67616128)
print v(xbgr.mr_n67616448)
print v(xbgr.mr_n67616560)
print v(xbgr.mr_n67616880)
print v(xbgr.mr_n67616992)
print v(xbgr.mr_n67617312)
print v(xbgr.mr_n67617424)
print v(xbgr.mr_n67617744)
print v(xbgr.mr_n67617856)
print v(xbgr.mr_n67618176)
print v(xbgr.mr_n67618288)
print v(xbgr.mr_n67618608)
print v(xbgr.mr_n67618720)
print v(xbgr.mr_n67619040)
print v(xbgr.mr_n67619152)
print v(xbgr.mr_n67619472)
print v(xbgr.mr_n67619584)
print v(xbgr.mr_n67619904)
print v(xbgr.mr_n67620016)
print v(xbgr.mr_n67620336)
print v(xbgr.mr_n67620448)
print v(xbgr.mr_n67620768)
print v(xbgr.mr_n67620880)
print v(xbgr.mr_n67621200)
print v(xbgr.mr_n67621312)
print v(xbgr.mr_n67621632)
print v(xbgr.mr_n67621744)
print v(xbgr.mr_n67622064)
print v(xbgr.mr_n67622176)
print v(xbgr.mr_n67622496)
print v(xbgr.mr_n67622608)
print v(xbgr.mr_n67622928)
print v(xbgr.mr_n67623040)
print v(xbgr.mr_n67623360)
print v(xbgr.mr_n67623472)
print v(xbgr.mr_n67623792)
print v(xbgr.mr_n67623904)
print v(xbgr.mr_n67624224)
print v(xbgr.mr_n67624336)
print v(xbgr.mr_n67624656)
print v(xbgr.mr_n67624768)
print v(xbgr.mr_n67625088)
print v(xbgr.mr_n67625200)
print v(xbgr.mr_n67625520)
print v(xbgr.mr_n67625632)
print v(xbgr.mr_n67625952)
print v(xbgr.mr_n67626064)
print v(xbgr.mr_n67626384)
print v(xbgr.mr_n67626496)
print v(xbgr.mr_n67626816)
print v(xbgr.mr_n67626928)
print v(xbgr.mr_n67627248)
print v(xbgr.mr_n67627360)
print v(xbgr.mr_n67627680)
print v(xbgr.mr_n67627792)
print v(xbgr.mr_n67628112)
print v(xbgr.mr_n67628224)
print v(xbgr.mr_n67628544)
print v(xbgr.mr_n67628656)
print v(xbgr.mr_n67628976)
print v(xbgr.mr_n67629088)
print v(xbgr.mr_n67629408)
print v(xbgr.mr_n67629520)
print v(xbgr.mr_n67629840)
print v(xbgr.mr_n67629952)
print v(xbgr.mr_n67630272)
print v(xbgr.mr_n67630384)
print v(xbgr.mr_n67630704)
print v(xbgr.mr_n67630816)
print v(xbgr.mr_n67631136)
print v(xbgr.mr_n67631248)
print v(xbgr.mr_n67631568)
print v(xbgr.mr_n67631680)
print v(xbgr.mr_n67632000)
print v(xbgr.mr_n67632112)
print v(xbgr.mr_n67632432)
print v(xbgr.mr_n67632544)
print v(xbgr.mr_n67632864)
print v(xbgr.mr_n67632976)
print v(xbgr.mr_n67633296)
print v(xbgr.mr_n67633408)
print v(xbgr.mr_n67633728)
print v(xbgr.mr_n67633840)
print v(xbgr.mr_n67634160)
print v(xbgr.mr_n67634272)
print v(xbgr.mr_n67634592)
print v(xbgr.mr_n67634704)
print v(xbgr.mr_n67635024)
print v(xbgr.mr_n67635136)
print v(xbgr.mr_n67635456)
print v(xbgr.mr_n67635568)
print v(xbgr.mr_n67635888)
print v(xbgr.mr_n67636000)
print v(xbgr.mr_n67636320)
print v(xbgr.mr_n67636432)
print v(xbgr.mr_n67636752)
print v(xbgr.mr_n67636864)
print v(xbgr.mr_n67637184)
print v(xbgr.mr_n67637296)
print v(xbgr.mr_n67637616)
print v(xbgr.mr_n67637728)
print v(xbgr.mr_n67638048)
print v(xbgr.mr_n67638160)
print v(xbgr.mr_n67638480)
print v(xbgr.mr_n67638592)
print v(xbgr.mr_n67638912)
print v(xbgr.mr_n67639024)
print v(xbgr.mr_n67639344)
print v(xbgr.mr_n67639456)
print v(xbgr.mr_n67639776)
print v(xbgr.mr_n67639888)
print v(xbgr.mr_n67640208)
print v(xbgr.mr_n67640320)
print v(xbgr.mr_n67640640)
print v(xbgr.mr_n67640752)
print v(xbgr.mr_n67641072)
print v(xbgr.mr_n67641184)
print v(xbgr.mr_n67641504)
print v(xbgr.mr_n67641616)
print v(xbgr.mr_n67641936)
print v(xbgr.mr_n67642048)
print v(xbgr.mr_n67642368)
print v(xbgr.mr_n67642480)
print v(xbgr.mr_n67642800)
print v(xbgr.mr_n67642912)
print v(xbgr.mr_n67643232)
print v(xbgr.mr_n67643344)
print v(xbgr.mr_n67643664)
print v(xbgr.mr_n67643776)
print v(xbgr.mr_n67644096)
print v(xbgr.mr_n67644208)
print v(xbgr.mr_n67644528)
print v(xbgr.mr_n67644640)
print v(xbgr.mr_n67644960)
print v(xbgr.mr_n67645072)
print v(xbgr.mr_n67645392)
print v(xbgr.mr_n67645504)
print v(xbgr.mr_n67645824)
print v(xbgr.mr_n67645936)
print v(xbgr.mr_n67646256)
print v(xbgr.mr_n67646368)
print v(xbgr.mr_n67646688)
print v(xbgr.mr_n67646800)
print v(xbgr.mr_n67647120)
print v(xbgr.mr_n67647232)
print v(xbgr.mr_n67647552)
print v(xbgr.mr_n67647664)
print v(xbgr.mr_n67647984)
print v(xbgr.mr_n67648096)
print v(xbgr.mr_n67648416)
print v(xbgr.mr_n67648528)
print v(xbgr.mr_n67648848)
print v(xbgr.mr_n67648960)
print v(xbgr.mr_n67649392)
print v(xbgr.mr_n67649824)
print v(xbgr.mr_n67650256)
print v(xbgr.mr_n67650688)
print v(xbgr.mr_n67651120)
print v(xbgr.mr_n67651552)
print v(xbgr.mr_n67651984)
print v(xbgr.mr_n67652416)
print v(xbgr.mr_n67652848)
print v(xbgr.mr_n67653280)
print v(xbgr.mr_n67653712)
print v(xbgr.mr_n67654144)
print v(xbgr.mr_n67654576)
print v(xbgr.mr_n67655008)
print v(xbgr.mr_n67655440)
print v(xbgr.mr_n67655872)
print v(xbgr.mr_n67656304)
print v(xbgr.mr_n67656736)
print v(xbgr.mr_n67657168)
print v(xbgr.mr_n67657600)
print v(xbgr.mr_n67658032)
print v(xbgr.mr_n67658464)
print v(xbgr.mr_n67658896)
print v(xbgr.mr_n67659328)
print v(xbgr.mr_n67659760)
print v(xbgr.mr_n67660192)
print v(xbgr.mr_n67660624)
print v(xbgr.mr_n67661056)
print v(xbgr.mr_n67661488)
print v(xbgr.mr_n67661920)
print v(xbgr.mr_n67662352)
print v(xbgr.mr_n67662784)
print v(xbgr.mr_n67663216)
print v(xbgr.mr_n67663648)
print v(xbgr.mr_n67664080)
print v(xbgr.mr_n67664512)
print v(xbgr.mr_n67664944)
print v(xbgr.mr_n67665376)
print v(xbgr.mr_n67665808)
print v(xbgr.mr_n67666240)
print v(xbgr.mr_n67666672)
print v(xbgr.mr_n67667104)
print v(xbgr.mr_n67667536)
print v(xbgr.mr_n67667968)
print v(xbgr.mr_n67668400)
print v(xbgr.mr_n67668832)
print v(xbgr.mr_n67669264)
print v(xbgr.mr_n67669696)
print v(xbgr.mr_n67670128)
print v(xbgr.mr_n67670560)
print v(xbgr.mr_n67670992)
print v(xbgr.mr_n67671424)
print v(xbgr.mr_n67671856)
print v(xbgr.mr_n67672288)
print v(xbgr.mr_n67672720)
print v(xbgr.mr_n67673152)
print v(xbgr.mr_n67673584)
print v(xbgr.mr_n67674016)
print v(xbgr.mr_n67674448)
print v(xbgr.mr_n67674880)
print v(xbgr.mr_n67675312)
print v(xbgr.mr_n67675744)
print v(xbgr.mr_n67676176)
print v(xbgr.mr_n67676608)
print v(xbgr.mr_n67677040)
print v(xbgr.mr_n67677472)
print v(xbgr.mr_n67677904)
print v(xbgr.mr_n67678336)
print v(xbgr.mr_n67678768)
print v(xbgr.mr_n67679200)
print v(xbgr.mr_n67679632)
print v(xbgr.mr_n67680064)
print v(xbgr.mr_n67680496)
print v(xbgr.mr_n67680928)
print v(xbgr.mr_n67681360)
print v(xbgr.mr_n67681792)
print v(xbgr.mr_n67682224)
print v(xbgr.mr_n67682656)
print v(xbgr.mr_n67683088)
print v(xbgr.mr_n67683520)
print v(xbgr.mr_n67683952)
print v(xbgr.mr_n67684384)
print v(xbgr.mr_n67684816)
print v(xbgr.mr_n67685248)
print v(xbgr.mr_n67685680)
print v(xbgr.mr_n67686112)
print v(xbgr.mr_n67686544)
print v(xbgr.mr_n67686976)
print v(xbgr.mr_n67687408)
print v(xbgr.mr_n67687840)
print v(xbgr.mr_n67688272)
print v(xbgr.mr_n67688704)
print v(xbgr.mr_n67689136)
print v(xbgr.mr_n67689568)
print v(xbgr.mr_n67690000)
print v(xbgr.mr_n67690432)
print v(xbgr.mr_n67690864)
print v(xbgr.mr_n67691296)
print v(xbgr.mr_n67691616)
print v(xbgr.mr_n67691728)
print v(xbgr.mr_n67692048)
print v(xbgr.mr_n67692160)
print v(xbgr.mr_n67692480)
print v(xbgr.mr_n67692592)
print v(xbgr.mr_n67692912)
print v(xbgr.mr_n67693024)
print v(xbgr.mr_n67693344)
print v(xbgr.mr_n67693456)
print v(xbgr.mr_n67693776)
print v(xbgr.mr_n67693888)
print v(xbgr.mr_n67694208)
print v(xbgr.mr_n67694320)
print v(xbgr.mr_n67694640)
print v(xbgr.mr_n67694752)
print v(xbgr.mr_n67695072)
print v(xbgr.mr_n67695184)
print v(xbgr.mr_n67695504)
print v(xbgr.mr_n67695616)
print v(xbgr.mr_n67695936)
print v(xbgr.mr_n67696048)
print v(xbgr.mr_n67696368)
print v(xbgr.mr_n67696480)
print v(xbgr.mr_n67696800)
print v(xbgr.mr_n67696912)
print v(xbgr.mr_n67697232)
print v(xbgr.mr_n67697344)
print v(xbgr.mr_n67697664)
print v(xbgr.mr_n67697776)
print v(xbgr.mr_n67698096)
print v(xbgr.mr_n67698208)
print v(xbgr.mr_n67698528)
print v(xbgr.mr_n67698640)
print v(xbgr.mr_n67698960)
print v(xbgr.mr_n67699072)
print v(xbgr.mr_n67699392)
print v(xbgr.mr_n67699504)
print v(xbgr.mr_n67699824)
print v(xbgr.mr_n67699936)
print v(xbgr.mr_n67700256)
print v(xbgr.mr_n67700368)
print v(xbgr.mr_n67700688)
print v(xbgr.mr_n67700800)
print v(xbgr.mr_n67701120)
print v(xbgr.mr_n67701232)
print v(xbgr.mr_n67701552)
print v(xbgr.mr_n67701664)
print v(xbgr.mr_n67701984)
print v(xbgr.mr_n67702096)
print v(xbgr.mr_n67702416)
print v(xbgr.mr_n67702528)
print v(xbgr.mr_n67702848)
print v(xbgr.mr_n67702960)
print v(xbgr.mr_n67703280)
print v(xbgr.mr_n67703392)
print v(xbgr.mr_n67703712)
print v(xbgr.mr_n67703824)
print v(xbgr.mr_n67704144)
print v(xbgr.mr_n67704256)
print v(xbgr.mr_n67704576)
print v(xbgr.mr_n67704688)
print v(xbgr.mr_n67705008)
print v(xbgr.mr_n67705120)
print v(xbgr.mr_n67705440)
print v(xbgr.mr_n67705552)
print v(xbgr.mr_n67705872)
print v(xbgr.mr_n67705984)
print v(xbgr.mr_n67706304)
print v(xbgr.mr_n67706416)
print v(xbgr.mr_n67706736)
print v(xbgr.mr_n67706848)
print v(xbgr.mr_n67707168)
print v(xbgr.mr_n67707280)
print v(xbgr.mr_n67707600)
print v(xbgr.mr_n67707712)
print v(xbgr.mr_n67708032)
print v(xbgr.mr_n67708144)
print v(xbgr.mr_n67708464)
print v(xbgr.mr_n67708576)
print v(xbgr.mr_n67708896)
print v(xbgr.mr_n67709008)
print v(xbgr.mr_n67709328)
print v(xbgr.mr_n67709440)
print v(xbgr.mr_n67709760)
print v(xbgr.mr_n67709872)
print v(xbgr.mr_n67710192)
print v(xbgr.mr_n67710304)
print v(xbgr.mr_n67710624)
print v(xbgr.mr_n67710736)
print v(xbgr.mr_n67711056)
print v(xbgr.mr_n67711168)
print v(xbgr.mr_n67711488)
print v(xbgr.mr_n67711600)
print v(xbgr.mr_n67711920)
print v(xbgr.mr_n67712032)
print v(xbgr.mr_n67712352)
print v(xbgr.mr_n67712464)
print v(xbgr.mr_n67712784)
print v(xbgr.mr_n67712896)
print v(xbgr.mr_n67713216)
print v(xbgr.mr_n67713328)
print v(xbgr.mr_n67713648)
print v(xbgr.mr_n67713760)
print v(xbgr.mr_n67714080)
print v(xbgr.mr_n67714192)
print v(xbgr.mr_n67714512)
print v(xbgr.mr_n67714624)
print v(xbgr.mr_n67714944)
print v(xbgr.mr_n67715056)
print v(xbgr.mr_n67715376)
print v(xbgr.mr_n67715488)
print v(xbgr.mr_n67715808)
print v(xbgr.mr_n67715920)
print v(xbgr.mr_n67716240)
print v(xbgr.mr_n67716352)
print v(xbgr.mr_n67716672)
print v(xbgr.mr_n67716784)
print v(xbgr.mr_n67717104)
print v(xbgr.mr_n67717216)
print v(xbgr.mr_n67717536)
print v(xbgr.mr_n67717648)
print v(xbgr.mr_n67717968)
print v(xbgr.mr_n67718080)
print v(xbgr.mr_n67718400)
print v(xbgr.mr_n67718512)
print v(xbgr.mr_n67718832)
print v(xbgr.mr_n67718944)
print v(xbgr.mr_n67719264)
print v(xbgr.mr_n67719376)
print v(xbgr.mr_n67719696)
print v(xbgr.mr_n67719808)
print v(xbgr.mr_n67720128)
print v(xbgr.mr_n67720240)
print v(xbgr.mr_n67720560)
print v(xbgr.mr_n67720672)
print v(xbgr.mr_n67720992)
print v(xbgr.mr_n67721104)
print v(xbgr.mr_n67721424)
print v(xbgr.mr_n67721536)
print v(xbgr.mr_n67721856)
print v(xbgr.mr_n67721968)
print v(xbgr.mr_n67722288)
print v(xbgr.mr_n67722400)
print v(xbgr.mr_n67722720)
print v(xbgr.mr_n67722832)
print v(xbgr.mr_n67723152)
print v(xbgr.mr_n67723264)
print v(xbgr.mr_n67723584)
print v(xbgr.mr_n67723696)
print v(xbgr.mr_n67724016)
print v(xbgr.mr_n67724128)
print v(xbgr.mr_n67724448)
print v(xbgr.mr_n67724560)
print v(xbgr.mr_n67724880)
print v(xbgr.mr_n67724992)
print v(xbgr.mr_n67725312)
print v(xbgr.mr_n67725424)
print v(xbgr.mr_n67725744)
print v(xbgr.mr_n67725856)
print v(xbgr.mr_n67726176)
print v(xbgr.mr_n67726288)
print v(xbgr.mr_n67726608)
print v(xbgr.mr_n67726720)
print v(xbgr.mr_n67727040)
print v(xbgr.mr_n67727152)
print v(xbgr.mr_n67727472)
print v(xbgr.mr_n67727584)
print v(xbgr.mr_n67727904)
print v(xbgr.mr_n67728016)
print v(xbgr.mr_n67728336)
print v(xbgr.mr_n67728448)
print v(xbgr.mr_n67728768)
print v(xbgr.mr_n67728880)
print v(xbgr.mr_n67729200)
print v(xbgr.mr_n67729312)
print v(xbgr.mr_n67729632)
print v(xbgr.mr_n67729744)
print v(xbgr.mr_n67730064)
print v(xbgr.mr_n67730176)
print v(xbgr.mr_n67730496)
print v(xbgr.mr_n67730608)
print v(xbgr.mr_n67730928)
print v(xbgr.mr_n67731040)
print v(xbgr.mr_n67731360)
print v(xbgr.mr_n67731472)
print v(xbgr.mr_n67731792)
print v(xbgr.mr_n67731904)
print v(xbgr.mr_n67732224)
print v(xbgr.mr_n67732336)
print v(xbgr.mr_n67732656)
print v(xbgr.mr_n67732768)
print v(xbgr.mr_n67733088)
print v(xbgr.mr_n67733200)
print v(xbgr.mr_n67733520)
print v(xbgr.mr_n67733632)
print v(xbgr.mr_n67733952)
print v(xbgr.mr_n67734064)
print v(xbgr.mr_n67734384)
print v(xbgr.mr_n67734496)
print v(xbgr.mr_n67734816)
print v(xbgr.mr_n67734928)
print v(xbgr.mr_n67735248)
print v(xbgr.mr_n67735360)
print v(xbgr.mr_n67735680)
print v(xbgr.mr_n67735792)
print v(xbgr.mr_n67736112)
print v(xbgr.mr_n67736224)
print v(xbgr.mr_n67736544)
print v(xbgr.mr_n67736656)
print v(xbgr.mr_n67736976)
print v(xbgr.mr_n67737088)
print v(xbgr.mr_n67737408)
print v(xbgr.mr_n67737520)
print v(xbgr.mr_n67737840)
print v(xbgr.mr_n67737952)
print v(xbgr.mr_n67738272)
print v(xbgr.mr_n67738384)
print v(xbgr.mr_n67738704)
print v(xbgr.mr_n67738816)
print v(xbgr.mr_n67739136)
print v(xbgr.mr_n67739248)
print v(xbgr.mr_n67739568)
print v(xbgr.mr_n67739680)
print v(xbgr.mr_n67740000)
print v(xbgr.mr_n67740112)
print v(xbgr.mr_n67740432)
print v(xbgr.mr_n67740544)
print v(xbgr.mr_n67740864)
print v(xbgr.mr_n67740976)
print v(xbgr.mr_n67741296)
print v(xbgr.mr_n67741408)
print v(xbgr.mr_n67741728)
print v(xbgr.mr_n67741840)
print v(xbgr.mr_n67742160)
print v(xbgr.mr_n67742272)
print v(xbgr.mr_n67742592)
print v(xbgr.mr_n67742704)
print v(xbgr.mr_n67743024)
print v(xbgr.mr_n67743136)
print v(xbgr.mr_n67743456)
print v(xbgr.mr_n67743568)
print v(xbgr.mr_n67743888)
print v(xbgr.mr_n67744000)
print v(xbgr.mr_n67744320)
print v(xbgr.mr_n67744432)
print v(xbgr.mr_n67744752)
print v(xbgr.mr_n67744864)
print v(xbgr.mr_n67745184)
print v(xbgr.mr_n67745296)
print v(xbgr.mr_n67745616)
print v(xbgr.mr_n67745728)
print v(xbgr.mr_n67746048)
print v(xbgr.mr_n67746160)
print v(xbgr.mr_n67746480)
print v(xbgr.mr_n67746592)
print v(xbgr.mr_n67746912)
print v(xbgr.mr_n67747024)
print v(xbgr.mr_n67747344)
print v(xbgr.mr_n67747456)
print v(xbgr.mr_n67747776)
print v(xbgr.mr_n67747888)
print v(xbgr.mr_n67748208)
print v(xbgr.mr_n67748320)
print v(xbgr.mr_n67748640)
print v(xbgr.mr_n67748752)
print v(xbgr.mr_n67749072)
print v(xbgr.mr_n67749184)
print v(xbgr.mr_n67749504)
print v(xbgr.mr_n67749616)
print v(xbgr.mr_n67749936)
print v(xbgr.mr_n67750048)
print v(xbgr.mr_n67750368)
print v(xbgr.mr_n67750480)
print v(xbgr.mr_n67750800)
print v(xbgr.mr_n67750912)
print v(xbgr.mr_n67751232)
print v(xbgr.mr_n67751344)
print v(xbgr.mr_n67751664)
print v(xbgr.mr_n67751776)
print v(xbgr.mr_n67752096)
print v(xbgr.mr_n67752208)
print v(xbgr.mr_n67752528)
print v(xbgr.mr_n67752640)
print v(xbgr.mr_n67752960)
print v(xbgr.mr_n67753072)
print v(xbgr.mr_n67753392)
print v(xbgr.mr_n67753504)
print v(xbgr.mr_n67753824)
print v(xbgr.mr_n67753936)
print v(xbgr.mr_n67754256)
print v(xbgr.mr_n67754368)
print v(xbgr.mr_n67754800)
print v(xbgr.mr_n67755232)
print v(xbgr.mr_n67755664)
print v(xbgr.mr_n67756096)
print v(xbgr.mr_n67756528)
print v(xbgr.mr_n67756960)
print v(xbgr.mr_n67757392)
print v(xbgr.mr_n67757824)
print v(xbgr.mr_n67758256)
print v(xbgr.mr_n67758688)
print v(xbgr.mr_n67759120)
print v(xbgr.mr_n67759552)
print v(xbgr.mr_n67759984)
print v(xbgr.mr_n67760416)
print v(xbgr.mr_n67760848)
print v(xbgr.mr_n67761280)
print v(xbgr.mr_n67761712)
print v(xbgr.mr_n67762144)
print v(xbgr.mr_n67762576)
print v(xbgr.mr_n67763008)
print v(xbgr.mr_n67763440)
print v(xbgr.mr_n67763872)
print v(xbgr.mr_n67764304)
print v(xbgr.mr_n67764736)
print v(xbgr.mr_n67765168)
print v(xbgr.mr_n67765600)
print v(xbgr.mr_n67766032)
print v(xbgr.mr_n67766464)
print v(xbgr.mr_n67766896)
print v(xbgr.mr_n67767328)
print v(xbgr.mr_n67767760)
print v(xbgr.mr_n67768192)
print v(xbgr.mr_n67768624)
print v(xbgr.mr_n67769056)
print v(xbgr.mr_n67769488)
print v(xbgr.mr_n67769920)
print v(xbgr.mr_n67770352)
print v(xbgr.mr_n67770784)
print v(xbgr.mr_n67771216)
print v(xbgr.mr_n67771648)
print v(xbgr.mr_n67772080)
print v(xbgr.mr_n67772512)
print v(xbgr.mr_n67772944)
print v(xbgr.mr_n67773376)
print v(xbgr.mr_n67773808)
print v(xbgr.mr_n67774240)
print v(xbgr.mr_n67774672)
print v(xbgr.mr_n67775104)
print v(xbgr.mr_n67775536)
print v(xbgr.mr_n67775968)
print v(xbgr.mr_n67776400)
print v(xbgr.mr_n67776832)
print v(xbgr.mr_n67777264)
print v(xbgr.mr_n67777696)
print v(xbgr.mr_n67778128)
print v(xbgr.mr_n67778560)
print v(xbgr.mr_n67778992)
print v(xbgr.mr_n67779424)
print v(xbgr.mr_n67779856)
print v(xbgr.mr_n67780288)
print v(xbgr.mr_n67780720)
print v(xbgr.mr_n67781152)
print v(xbgr.mr_n67781584)
print v(xbgr.mr_n67782016)
print v(xbgr.mr_n67782448)
print v(xbgr.mr_n67782880)
print v(xbgr.mr_n67783312)
print v(xbgr.mr_n67783744)
print v(xbgr.mr_n67784176)
print v(xbgr.mr_n67784608)
print v(xbgr.mr_n67785040)
print v(xbgr.mr_n67785472)
print v(xbgr.mr_n67785904)
print v(xbgr.mr_n67786336)
print v(xbgr.mr_n67786768)
print v(xbgr.mr_n67787200)
print v(xbgr.mr_n67787632)
print v(xbgr.mr_n67788064)
print v(xbgr.mr_n67788496)
print v(xbgr.mr_n67788928)
print v(xbgr.mr_n67789360)
print v(xbgr.mr_n67789792)
print v(xbgr.mr_n67790224)
print v(xbgr.mr_n67790656)
print v(xbgr.mr_n67791088)
print v(xbgr.mr_n67791520)
print v(xbgr.mr_n67791952)
print v(xbgr.mr_n67792384)
print v(xbgr.mr_n67792816)
print v(xbgr.mr_n67793248)
print v(xbgr.mr_n67793680)
print v(xbgr.mr_n67794112)
print v(xbgr.mr_n67794544)
print v(xbgr.mr_n67794976)
print v(xbgr.mr_n67795408)
print v(xbgr.mr_n67795840)
print v(xbgr.mr_n67796272)
print v(xbgr.mr_n67796704)
print v(xbgr.mr_n67797136)
print v(xbgr.mr_n67797568)
print v(xbgr.mr_n67798000)
print v(xbgr.mr_n67798432)
print v(xbgr.mr_n67798864)
print v(xbgr.mr_n67799296)
print v(xbgr.mr_n67799728)
print v(xbgr.mr_n67800160)
print v(xbgr.mr_n67800592)
print v(xbgr.mr_n67801024)
print v(xbgr.mr_n67801456)
print v(xbgr.mr_n67801888)
print v(xbgr.mr_n67802320)
print v(xbgr.mr_n67802752)
print v(xbgr.mr_n67803184)
print v(xbgr.mr_n67803616)
print v(xbgr.mr_n67804048)
print v(xbgr.mr_n67804480)
print v(xbgr.mr_n67804912)
print v(xbgr.mr_n67805344)
print v(xbgr.mr_n67805776)
print v(xbgr.mr_n67806208)
print v(xbgr.mr_n67806640)
print v(xbgr.mr_n67807072)
print v(xbgr.mr_n67807504)
print v(xbgr.mr_n67807936)
print v(xbgr.mr_n67808368)
print v(xbgr.mr_n67808800)
print v(xbgr.mr_n67809232)
print v(xbgr.mr_n67809664)
print v(xbgr.mr_n67810096)
print v(xbgr.mr_n67810528)
print v(xbgr.mr_n67810960)
print v(xbgr.mr_n67811392)
print v(xbgr.mr_n67811824)
print v(xbgr.mr_n67812256)
print v(xbgr.mr_n67812688)
print v(xbgr.mr_n67813120)
print v(xbgr.mr_n67813552)
print v(xbgr.mr_n67813984)
print v(xbgr.mr_n67814416)
print v(xbgr.mr_n67814848)
print v(xbgr.mr_n67815280)
print v(xbgr.mr_n67815712)
print v(xbgr.mr_n67816144)
print v(xbgr.mr_n67816576)
print v(xbgr.mr_n67817008)
print v(xbgr.mr_n67817440)
print v(xbgr.mr_n67817872)
print v(xbgr.mr_n67818304)
print v(xbgr.mr_n67818736)
print v(xbgr.mr_n67819168)
print v(xbgr.mr_n67819600)
print v(xbgr.mr_n67820032)
print v(xbgr.mr_n67820464)
print v(xbgr.mr_n67820896)
print v(xbgr.mr_n67821328)
print v(xbgr.mr_n67821760)
print v(xbgr.mr_n67822192)
print v(xbgr.mr_n67822624)
print v(xbgr.mr_n67823056)
print v(xbgr.mr_n67823488)
print v(xbgr.mr_n67823920)
print v(xbgr.mr_n67824352)
print v(xbgr.mr_n67824784)
print v(xbgr.mr_n67825216)
print v(xbgr.mr_n67825648)
print v(xbgr.mr_n67826080)
print v(xbgr.mr_n67826512)
print v(xbgr.mr_n67826944)
print v(xbgr.mr_n67827376)
print v(xbgr.mr_n67827808)
print v(xbgr.mr_n67828240)
print v(xbgr.mr_n67828672)
print v(xbgr.mr_n67829104)
print v(xbgr.mr_n67829536)
print v(xbgr.mr_n67829968)
print v(xbgr.mr_n67830400)
print v(xbgr.mr_n67830832)
print v(xbgr.mr_n67831264)
print v(xbgr.mr_n67831696)
print v(xbgr.mr_n67832128)
print v(xbgr.mr_n67832560)
print v(xbgr.mr_n67832992)
print v(xbgr.mr_n67833424)
print v(xbgr.mr_n67833856)
print v(xbgr.mr_n67834288)
print v(xbgr.mr_n67834720)
print v(xbgr.mr_n67835152)
print v(xbgr.mr_n67835584)
print v(xbgr.mr_n67836016)
print v(xbgr.mr_n67836448)
print v(xbgr.mr_n67836880)
print v(xbgr.mr_n67837312)
print v(xbgr.mr_n67837744)
print v(xbgr.mr_n67838176)
print v(xbgr.mr_n67838608)
print v(xbgr.mr_n67839040)
print v(xbgr.mr_n67839472)
print v(xbgr.mr_n67839904)
print v(xbgr.mr_n67840336)
print v(xbgr.mr_n67840768)
print v(xbgr.mr_n67841200)
print v(xbgr.mr_n67841632)
print v(xbgr.mr_n67842064)
print v(xbgr.mr_n67842496)
print v(xbgr.mr_n67842928)
print v(xbgr.mr_n67843360)
print v(xbgr.mr_n67843792)
print v(xbgr.mr_n67844224)
print v(xbgr.mr_n67844656)
print v(xbgr.mr_n67845088)
print v(xbgr.mr_n67845520)
print v(xbgr.mr_n67845952)
print v(xbgr.mr_n67846384)
print v(xbgr.mr_n67846816)
print v(xbgr.mr_n67847136)
print v(xbgr.mr_n67847248)
print v(xbgr.mr_n67847568)
print v(xbgr.mr_n67847680)
print v(xbgr.mr_n67848000)
print v(xbgr.mr_n67848112)
print v(xbgr.mr_n67848432)
print v(xbgr.mr_n67848544)
print v(xbgr.mr_n67848864)
print v(xbgr.mr_n67848976)
print v(xbgr.mr_n67849296)
print v(xbgr.mr_n67849408)
print v(xbgr.mr_n67849728)
print v(xbgr.mr_n67849840)
print v(xbgr.mr_n67850160)
print v(xbgr.mr_n67850272)
print v(xbgr.mr_n67850592)
print v(xbgr.mr_n67850704)
print v(xbgr.mr_n67851024)
print v(xbgr.mr_n67851136)
print v(xbgr.mr_n67851456)
print v(xbgr.mr_n67851568)
print v(xbgr.mr_n67851888)
print v(xbgr.mr_n67852000)
print v(xbgr.mr_n67852320)
print v(xbgr.mr_n67852432)
print v(xbgr.mr_n67852752)
print v(xbgr.mr_n67852864)
print v(xbgr.mr_n67853184)
print v(xbgr.mr_n67853296)
print v(xbgr.mr_n67853616)
print v(xbgr.mr_n67853728)
print v(xbgr.mr_n67854048)
print v(xbgr.mr_n67854160)
print v(xbgr.mr_n67854480)
print v(xbgr.mr_n67854592)
print v(xbgr.mr_n67854912)
print v(xbgr.mr_n67855024)
print v(xbgr.mr_n67855344)
print v(xbgr.mr_n67855456)
print v(xbgr.mr_n67855776)
print v(xbgr.mr_n67855888)
print v(xbgr.mr_n67856208)
print v(xbgr.mr_n67856320)
print v(xbgr.mr_n67856640)
print v(xbgr.mr_n67856752)
print v(xbgr.mr_n67857072)
print v(xbgr.mr_n67857184)
print v(xbgr.mr_n67857504)
print v(xbgr.mr_n67857616)
print v(xbgr.mr_n67857936)
print v(xbgr.mr_n67858048)
print v(xbgr.mr_n67858368)
print v(xbgr.mr_n67858480)
print v(xbgr.mr_n67858800)
print v(xbgr.mr_n67858912)
print v(xbgr.mr_n67859232)
print v(xbgr.mr_n67859344)
print v(xbgr.mr_n67859664)
print v(xbgr.mr_n67859776)
print v(xbgr.mr_n67860096)
print v(xbgr.mr_n67860208)
print v(xbgr.mr_n67860528)
print v(xbgr.mr_n67860640)
print v(xbgr.mr_n67860960)
print v(xbgr.mr_n67861072)
print v(xbgr.mr_n67861392)
print v(xbgr.mr_n67861504)
print v(xbgr.mr_n67861824)
print v(xbgr.mr_n67861936)
print v(xbgr.mr_n67862256)
print v(xbgr.mr_n67862368)
print v(xbgr.mr_n67862688)
print v(xbgr.mr_n67862800)
print v(xbgr.mr_n67863120)
print v(xbgr.mr_n67863232)
print v(xbgr.mr_n67863552)
print v(xbgr.mr_n67863664)
print v(xbgr.mr_n67863984)
print v(xbgr.mr_n67864096)
print v(xbgr.mr_n67864416)
print v(xbgr.mr_n67864528)
print v(xbgr.mr_n67864848)
print v(xbgr.mr_n67864960)
print v(xbgr.mr_n67865280)
print v(xbgr.mr_n67865392)
print v(xbgr.mr_n67865712)
print v(xbgr.mr_n67865824)
print v(xbgr.mr_n67866144)
print v(xbgr.mr_n67866256)
print v(xbgr.mr_n67866576)
print v(xbgr.mr_n67866688)
print v(xbgr.mr_n67867008)
print v(xbgr.mr_n67867120)
print v(xbgr.mr_n67867440)
print v(xbgr.mr_n67867552)
print v(xbgr.mr_n67867872)
print v(xbgr.mr_n67867984)
print v(xbgr.mr_n67868304)
print v(xbgr.mr_n67868416)
print v(xbgr.mr_n67868736)
print v(xbgr.mr_n67868848)
print v(xbgr.mr_n67869168)
print v(xbgr.mr_n67869280)
print v(xbgr.mr_n67869600)
print v(xbgr.mr_n67869712)
print v(xbgr.mr_n67870032)
print v(xbgr.mr_n67870144)
print v(xbgr.mr_n67870464)
print v(xbgr.mr_n67870576)
print v(xbgr.mr_n67870896)
print v(xbgr.mr_n67871008)
print v(xbgr.mr_n67871328)
print v(xbgr.mr_n67871440)
print v(xbgr.mr_n67871760)
print v(xbgr.mr_n67871872)
print v(xbgr.mr_n67872192)
print v(xbgr.mr_n67872304)
print v(xbgr.mr_n67872624)
print v(xbgr.mr_n67872736)
print v(xbgr.mr_n67873056)
print v(xbgr.mr_n67873168)
print v(xbgr.mr_n67873488)
print v(xbgr.mr_n67873600)
print v(xbgr.mr_n67873920)
print v(xbgr.mr_n67874032)
print v(xbgr.mr_n67874352)
print v(xbgr.mr_n67874464)
print v(xbgr.mr_n67874784)
print v(xbgr.mr_n67874896)
print v(xbgr.mr_n67875216)
print v(xbgr.mr_n67875328)
print v(xbgr.mr_n67875648)
print v(xbgr.mr_n67875760)
print v(xbgr.mr_n67876080)
print v(xbgr.mr_n67876192)
print v(xbgr.mr_n67876512)
print v(xbgr.mr_n67876624)
print v(xbgr.mr_n67876944)
print v(xbgr.mr_n67877056)
print v(xbgr.mr_n67877376)
print v(xbgr.mr_n67877488)
print v(xbgr.mr_n67877808)
print v(xbgr.mr_n67877920)
print v(xbgr.mr_n67878240)
print v(xbgr.mr_n67878352)
print v(xbgr.mr_n67878672)
print v(xbgr.mr_n67878784)
print v(xbgr.mr_n67879104)
print v(xbgr.mr_n67879216)
print v(xbgr.mr_n67879536)
print v(xbgr.mr_n67879648)
print v(xbgr.mr_n67879968)
print v(xbgr.mr_n67880080)
print v(xbgr.mr_n67880400)
print v(xbgr.mr_n67880512)
print v(xbgr.mr_n67880832)
print v(xbgr.mr_n67880944)
print v(xbgr.mr_n67881264)
print v(xbgr.mr_n67881376)
print v(xbgr.mr_n67881696)
print v(xbgr.mr_n67881808)
print v(xbgr.mr_n67882128)
print v(xbgr.mr_n67882240)
print v(xbgr.mr_n67882560)
print v(xbgr.mr_n67882672)
print v(xbgr.mr_n67882992)
print v(xbgr.mr_n67883104)
print v(xbgr.mr_n67883424)
print v(xbgr.mr_n67883536)
print v(xbgr.mr_n67883856)
print v(xbgr.mr_n67883968)
print v(xbgr.mr_n67884288)
print v(xbgr.mr_n67884400)
print v(xbgr.mr_n67884720)
print v(xbgr.mr_n67884832)
print v(xbgr.mr_n67885152)
print v(xbgr.mr_n67885264)
print v(xbgr.mr_n67885584)
print v(xbgr.mr_n67885696)
print v(xbgr.mr_n67886016)
print v(xbgr.mr_n67886128)
print v(xbgr.mr_n67886448)
print v(xbgr.mr_n67886560)
print v(xbgr.mr_n67886880)
print v(xbgr.mr_n67886992)
print v(xbgr.mr_n67887312)
print v(xbgr.mr_n67887424)
print v(xbgr.mr_n67887744)
print v(xbgr.mr_n67887856)
print v(xbgr.mr_n67888176)
print v(xbgr.mr_n67888288)
print v(xbgr.mr_n67888608)
print v(xbgr.mr_n67888720)
print v(xbgr.mr_n67889040)
print v(xbgr.mr_n67889152)
print v(xbgr.mr_n67889472)
print v(xbgr.mr_n67889584)
print v(xbgr.mr_n67889904)
print v(xbgr.mr_n67890016)
print v(xbgr.mr_n67890336)
print v(xbgr.mr_n67890448)
print v(xbgr.mr_n67890768)
print v(xbgr.mr_n67890880)
print v(xbgr.mr_n67891200)
print v(xbgr.mr_n67891312)
print v(xbgr.mr_n67891632)
print v(xbgr.mr_n67891744)
print v(xbgr.mr_n67892064)
print v(xbgr.mr_n67892176)
print v(xbgr.mr_n67892496)
print v(xbgr.mr_n67892608)
print v(xbgr.mr_n67892928)
print v(xbgr.mr_n67893040)
print v(xbgr.mr_n67893360)
print v(xbgr.mr_n67893472)
print v(xbgr.mr_n67893792)
print v(xbgr.mr_n67893904)
print v(xbgr.mr_n67894224)
print v(xbgr.mr_n67894336)
print v(xbgr.mr_n67894656)
print v(xbgr.mr_n67894768)
print v(xbgr.mr_n67895088)
print v(xbgr.mr_n67895200)
print v(xbgr.mr_n67895520)
print v(xbgr.mr_n67895632)
print v(xbgr.mr_n67895952)
print v(xbgr.mr_n67896064)
print v(xbgr.mr_n67896384)
print v(xbgr.mr_n67896496)
print v(xbgr.mr_n67896816)
print v(xbgr.mr_n67896928)
print v(xbgr.mr_n67897248)
print v(xbgr.mr_n67897360)
print v(xbgr.mr_n67897680)
print v(xbgr.mr_n67897792)
print v(xbgr.mr_n67898112)
print v(xbgr.mr_n67898224)
print v(xbgr.mr_n67898544)
print v(xbgr.mr_n67898656)
print v(xbgr.mr_n67898976)
print v(xbgr.mr_n67899088)
print v(xbgr.mr_n67899408)
print v(xbgr.mr_n67899520)
print v(xbgr.mr_n67899840)
print v(xbgr.mr_n67899952)
print v(xbgr.mr_n67900272)
print v(xbgr.mr_n67900384)
print v(xbgr.mr_n67900704)
print v(xbgr.mr_n67900816)
print v(xbgr.mr_n67901136)
print v(xbgr.mr_n67901248)
print v(xbgr.mr_n67901568)
print v(xbgr.mr_n67901680)
print v(xbgr.mr_n67902000)
print v(xbgr.mr_n67902112)
print v(xbgr.mr_n67902432)
print v(xbgr.mr_n67902544)
print v(xbgr.mr_n67902864)
print v(xbgr.mr_n67902976)
print v(xbgr.mr_n67903296)
print v(xbgr.mr_n67903408)
print v(xbgr.mr_n67903728)
print v(xbgr.mr_n67903840)
print v(xbgr.mr_n67904160)
print v(xbgr.mr_n67904272)
print v(xbgr.mr_n67904592)
print v(xbgr.mr_n67904704)
print v(xbgr.mr_n67905024)
print v(xbgr.mr_n67905136)
print v(xbgr.mr_n67905456)
print v(xbgr.mr_n67905568)
print v(xbgr.mr_n67905888)
print v(xbgr.mr_n67906000)
print v(xbgr.mr_n67906320)
print v(xbgr.mr_n67906432)
print v(xbgr.mr_n67906752)
print v(xbgr.mr_n67906864)
print v(xbgr.mr_n67907184)
print v(xbgr.mr_n67907296)
print v(xbgr.mr_n67907616)
print v(xbgr.mr_n67907728)
print v(xbgr.mr_n67908048)
print v(xbgr.mr_n67908160)
print v(xbgr.mr_n67908480)
print v(xbgr.mr_n67908592)
print v(xbgr.mr_n67908912)
print v(xbgr.mr_n67909024)
print v(xbgr.mr_n67909344)
print v(xbgr.mr_n67909456)
print v(xbgr.mr_n67909776)
print v(xbgr.mr_n67909888)
print v(xbgr.mr_n67910208)
print v(xbgr.mr_n67910320)
print v(xbgr.mr_n67910640)
print v(xbgr.mr_n67910752)
print v(xbgr.mr_n67911072)
print v(xbgr.mr_n67911184)
print v(xbgr.mr_n67911504)
print v(xbgr.mr_n67911616)
print v(xbgr.mr_n67911936)
print v(xbgr.mr_n67912048)
print v(xbgr.mr_n67912368)
print v(xbgr.mr_n67912480)
print v(xbgr.mr_n67912800)
print v(xbgr.mr_n67912912)
print v(xbgr.mr_n67913232)
print v(xbgr.mr_n67913344)
print v(xbgr.mr_n67913664)
print v(xbgr.mr_n67913776)
print v(xbgr.mr_n67914096)
print v(xbgr.mr_n67914208)
print v(xbgr.mr_n67914528)
print v(xbgr.mr_n67914640)
print v(xbgr.mr_n67914960)
print v(xbgr.mr_n67915072)
print v(xbgr.mr_n67915392)
print v(xbgr.mr_n67915504)
print v(xbgr.mr_n67915824)
print v(xbgr.mr_n67915936)
print v(xbgr.mr_n67916256)
print v(xbgr.mr_n67916368)
print v(xbgr.mr_n67916688)
print v(xbgr.mr_n67916800)
print v(xbgr.mr_n67917120)
print v(xbgr.mr_n67917232)
print v(xbgr.mr_n67917552)
print v(xbgr.mr_n67917664)
print v(xbgr.mr_n67917984)
print v(xbgr.mr_n67918096)
print v(xbgr.mr_n67918416)
print v(xbgr.mr_n67918528)
print v(xbgr.mr_n67918848)
print v(xbgr.mr_n67918960)
print v(xbgr.mr_n67919280)
print v(xbgr.mr_n67919392)
print v(xbgr.mr_n67919712)
print v(xbgr.mr_n67919824)
print v(xbgr.mr_n67920144)
print v(xbgr.mr_n67920256)
print v(xbgr.mr_n67920576)
print v(xbgr.mr_n67920688)
print v(xbgr.mr_n67921008)
print v(xbgr.mr_n67921120)
print v(xbgr.mr_n67921440)
print v(xbgr.mr_n67921552)
print v(xbgr.mr_n67921872)
print v(xbgr.mr_n67921984)
print v(xbgr.mr_n67922304)
print v(xbgr.mr_n67922416)
print v(xbgr.mr_n67922736)
print v(xbgr.mr_n67922848)
print v(xbgr.mr_n67923168)
print v(xbgr.mr_n67923280)
print v(xbgr.mr_n67923600)
print v(xbgr.mr_n67923712)
print v(xbgr.mr_n67924032)
print v(xbgr.mr_n67924144)
print v(xbgr.mr_n67924464)
print v(xbgr.mr_n67924576)
print v(xbgr.mr_n67924896)
print v(xbgr.mr_n67925008)
print v(xbgr.mr_n67925328)
print v(xbgr.mr_n67925440)
print v(xbgr.mr_n67925760)
print v(xbgr.mr_n67925872)
print v(xbgr.mr_n67926192)
print v(xbgr.mr_n67926304)
print v(xbgr.mr_n67926624)
print v(xbgr.mr_n67926736)
print v(xbgr.mr_n67927056)
print v(xbgr.mr_n67927168)
print v(xbgr.mr_n67927488)
print v(xbgr.mr_n67927600)
print v(xbgr.mr_n67927920)
print v(xbgr.mr_n67928032)
print v(xbgr.mr_n67928352)
print v(xbgr.mr_n67928464)
print v(xbgr.mr_n67928784)
print v(xbgr.mr_n67928896)
print v(xbgr.mr_n67929216)
print v(xbgr.mr_n67929328)
print v(xbgr.mr_n67929648)
print v(xbgr.mr_n67929760)
print v(xbgr.mr_n67930080)
print v(xbgr.mr_n67930192)
print v(xbgr.mr_n67930512)
print v(xbgr.mr_n67930624)
print v(xbgr.mr_n67930944)
print v(xbgr.mr_n67931056)
print v(xbgr.mr_n67931376)
print v(xbgr.mr_n67931488)
print v(xbgr.mr_n67931808)
print v(xbgr.mr_n67931920)
print v(xbgr.mr_n67932240)
print v(xbgr.mr_n67932352)
print v(xbgr.mr_n67932672)
print v(xbgr.mr_n67932784)
print v(xbgr.mr_n67933104)
print v(xbgr.mr_n67933216)
print v(xbgr.mr_n67933536)
print v(xbgr.mr_n67933648)
print v(xbgr.mr_n67933968)
print v(xbgr.mr_n67934080)
print v(xbgr.mr_n67934400)
print v(xbgr.mr_n67934512)
print v(xbgr.mr_n67934832)
print v(xbgr.mr_n67934944)
print v(xbgr.mr_n67935264)
print v(xbgr.mr_n67935376)
print v(xbgr.mr_n67935696)
print v(xbgr.mr_n67935808)
print v(xbgr.mr_n67936128)
print v(xbgr.mr_n67936240)
print v(xbgr.mr_n67936560)
print v(xbgr.mr_n67936672)
print v(xbgr.mr_n67936992)
print v(xbgr.mr_n67937104)
print v(xbgr.mr_n67937424)
print v(xbgr.mr_n67937536)
print v(xbgr.mr_n67937856)
print v(xbgr.mr_n67937968)
print v(xbgr.mr_n67938288)
print v(xbgr.mr_n67938400)
print v(xbgr.mr_n67938720)
print v(xbgr.mr_n67938832)
print v(xbgr.mr_n67939152)
print v(xbgr.mr_n67939264)
print v(xbgr.mr_n67939584)
print v(xbgr.mr_n67939696)
print v(xbgr.mr_n67940016)
print v(xbgr.mr_n67940128)
print v(xbgr.mr_n67940448)
print v(xbgr.mr_n67940560)
print v(xbgr.mr_n67940880)
print v(xbgr.mr_n67940992)
print v(xbgr.mr_n67941856)
print v(xbgr.mr_n67942288)
print v(xbgr.mr_n67942720)
print v(xbgr.mr_n67943152)
print v(xbgr.mr_n67943584)
print v(xbgr.mr_n67944016)
print v(xbgr.mr_n67944448)
print v(xbgr.mr_n67944880)
print v(xbgr.mr_n67945312)
print v(xbgr.mr_n67945744)
print v(xbgr.mr_n67946176)
print v(xbgr.mr_n67946608)
print v(xbgr.mr_n67947040)
print v(xbgr.mr_n67947472)
print v(xbgr.mr_n67947904)
print v(xbgr.mr_n67948336)
print v(xbgr.mr_n67948768)
print v(xbgr.mr_n67949200)
print v(xbgr.mr_n67949632)
print v(xbgr.mr_n67950064)
print v(xbgr.mr_n67950496)
print v(xbgr.mr_n67950928)
print v(xbgr.mr_n67951360)
print v(xbgr.mr_n67951792)
print v(xbgr.mr_n67953952)
print v(xbgr.mr_n67954384)
print v(xbgr.mr_n67954816)
print v(xbgr.mr_n67955248)
print v(xbgr.mr_n67955680)
print v(xbgr.mr_n67956112)
print v(xbgr.mr_n67956544)
print v(xbgr.mr_n67956976)
print v(xbgr.mr_n67957408)
print v(xbgr.mr_n67957840)
print v(xbgr.mr_n67958272)
print v(xbgr.mr_n67958704)
print v(xbgr.mr_n67959136)
print v(xbgr.mr_n67959568)
print v(xbgr.mr_n67960000)
print v(xbgr.mr_n67960432)
print v(xbgr.mr_n67960864)
print v(xbgr.mr_n67961296)
print v(xbgr.mr_n67961728)
print v(xbgr.mr_n67962160)
print v(xbgr.mr_n67962592)
print v(xbgr.mr_n67963024)
print v(xbgr.mr_n67963456)
print v(xbgr.mr_n67963888)
print v(xbgr.mr_n67967776)
print v(xbgr.mr_n67968208)
print v(xbgr.mr_n67968640)
print v(xbgr.mr_n67969072)
print v(xbgr.mr_n67969504)
print v(xbgr.mr_n67969936)
print v(xbgr.mr_n67970368)
print v(xbgr.mr_n67970800)
print v(xbgr.mr_n67971232)
print v(xbgr.mr_n67971664)
print v(xbgr.mr_n67972096)
print v(xbgr.mr_n67972528)
print v(xbgr.mr_n67972960)
print v(xbgr.mr_n67973392)
print v(xbgr.mr_n67973824)
print v(xbgr.mr_n67975120)
print v(xbgr.mr_n67975552)
print v(xbgr.mr_n67975984)
print v(xbgr.mr_n67976416)
print v(xbgr.mr_n67976848)
print v(xbgr.mr_n67977280)
print v(xbgr.mr_n67977712)
print v(xbgr.mr_n67978144)
print v(xbgr.mr_n67978576)
print v(xbgr.mr_n67979008)
print v(xbgr.mr_n67980304)
print v(xbgr.mr_n67980736)
print v(xbgr.mr_n67981168)
print v(xbgr.mr_n67981600)
print v(xbgr.mr_n67982032)
print v(xbgr.mr_n67982464)
print v(xbgr.mr_n67982896)
print v(xbgr.mr_n67983328)
print v(xbgr.mr_n67983648)
print v(xbgr.mr_n67983760)
print v(xbgr.mr_n67984080)
print v(xbgr.mr_n67984192)
print v(xbgr.mr_n67984512)
print v(xbgr.mr_n67984624)
print v(xbgr.mr_n67984944)
print v(xbgr.mr_n67985056)
print v(xbgr.mr_n67985376)
print v(xbgr.mr_n67985488)
print v(xbgr.mr_n67985808)
print v(xbgr.mr_n67985920)
print v(xbgr.mr_n67986240)
print v(xbgr.mr_n67986352)
print v(xbgr.mr_n67986672)
print v(xbgr.mr_n67986784)
print v(xbgr.mr_n67987104)
print v(xbgr.mr_n67987216)
print v(xbgr.mr_n67987536)
print v(xbgr.mr_n67987648)
print v(xbgr.mr_n67987968)
print v(xbgr.mr_n67988080)
print v(xbgr.mr_n67988400)
print v(xbgr.mr_n67988512)
print v(xbgr.mr_n67988832)
print v(xbgr.mr_n67988944)
print v(xbgr.mr_n67989264)
print v(xbgr.mr_n67989376)
print v(xbgr.mr_n67989696)
print v(xbgr.mr_n67989808)
print v(xbgr.mr_n67990128)
print v(xbgr.mr_n67990240)
print v(xbgr.mr_n67990560)
print v(xbgr.mr_n67990672)
print v(xbgr.mr_n67990992)
print v(xbgr.mr_n67991104)
print v(xbgr.mr_n67991424)
print v(xbgr.mr_n67991536)
print v(xbgr.mr_n67991856)
print v(xbgr.mr_n67991968)
print v(xbgr.mr_n67992288)
print v(xbgr.mr_n67992400)
print v(xbgr.mr_n67992720)
print v(xbgr.mr_n67992832)
print v(xbgr.mr_n67993152)
print v(xbgr.mr_n67993264)
print v(xbgr.mr_n67993584)
print v(xbgr.mr_n67993696)
print v(xbgr.mr_n67994016)
print v(xbgr.mr_n67994128)
print v(xbgr.mr_n67994448)
print v(xbgr.mr_n67994560)
print v(xbgr.mr_n67994880)
print v(xbgr.mr_n67994992)
print v(xbgr.mr_n67995312)
print v(xbgr.mr_n67995424)
print v(xbgr.mr_n67995744)
print v(xbgr.mr_n67995856)
print v(xbgr.mr_n67996176)
print v(xbgr.mr_n67996288)
print v(xbgr.mr_n67996608)
print v(xbgr.mr_n67996720)
print v(xbgr.mr_n67997040)
print v(xbgr.mr_n67997152)
print v(xbgr.mr_n67997472)
print v(xbgr.mr_n67997584)
print v(xbgr.mr_n67997904)
print v(xbgr.mr_n67998016)
print v(xbgr.mr_n67998336)
print v(xbgr.mr_n67998448)
print v(xbgr.mr_n67998768)
print v(xbgr.mr_n67998880)
print v(xbgr.mr_n67999200)
print v(xbgr.mr_n67999312)
print v(xbgr.mr_n67999632)
print v(xbgr.mr_n67999744)
print v(xbgr.mr_n68000064)
print v(xbgr.mr_n68000176)
print v(xbgr.mr_n68000496)
print v(xbgr.mr_n68000608)
print v(xbgr.mr_n68000928)
print v(xbgr.mr_n68001040)
print v(xbgr.mr_n68001360)
print v(xbgr.mr_n68001472)
print v(xbgr.mr_n68001792)
print v(xbgr.mr_n68001904)
print v(xbgr.mr_n68002224)
print v(xbgr.mr_n68002336)
print v(xbgr.mr_n68002656)
print v(xbgr.mr_n68002768)
print v(xbgr.mr_n68003088)
print v(xbgr.mr_n68003200)
print v(xbgr.mr_n68003520)
print v(xbgr.mr_n68003632)
print v(xbgr.mr_n68003952)
print v(xbgr.mr_n68004064)
print v(xbgr.mr_n68004384)
print v(xbgr.mr_n68004496)
print v(xbgr.mr_n68004816)
print v(xbgr.mr_n68004928)
print v(xbgr.mr_n68005248)
print v(xbgr.mr_n68005360)
print v(xbgr.mr_n68005680)
print v(xbgr.mr_n68005792)
print v(xbgr.mr_n68006112)
print v(xbgr.mr_n68006224)
print v(xbgr.mr_n68006544)
print v(xbgr.mr_n68006656)
print v(xbgr.mr_n68006976)
print v(xbgr.mr_n68007088)
print v(xbgr.mr_n68007408)
print v(xbgr.mr_n68007520)
print v(xbgr.mr_n68007840)
print v(xbgr.mr_n68007952)
print v(xbgr.mr_n68008272)
print v(xbgr.mr_n68008384)
print v(xbgr.mr_n68008704)
print v(xbgr.mr_n68008816)
print v(xbgr.mr_n68009136)
print v(xbgr.mr_n68009248)
print v(xbgr.mr_n68009568)
print v(xbgr.mr_n68009680)
print v(xbgr.mr_n68010000)
print v(xbgr.mr_n68010112)
print v(xbgr.mr_n68010432)
print v(xbgr.mr_n68010544)
print v(xbgr.mr_n68010864)
print v(xbgr.mr_n68010976)
print v(xbgr.mr_n68011296)
print v(xbgr.mr_n68011408)
print v(xbgr.mr_n68011728)
print v(xbgr.mr_n68011840)
print v(xbgr.mr_n68012160)
print v(xbgr.mr_n68012272)
print v(xbgr.mr_n68012592)
print v(xbgr.mr_n68012704)
print v(xbgr.mr_n68013024)
print v(xbgr.mr_n68013136)
print v(xbgr.mr_n68013456)
print v(xbgr.mr_n68013568)
print v(xbgr.mr_n68013888)
print v(xbgr.mr_n68014000)
print v(xbgr.mr_n68014320)
print v(xbgr.mr_n68014432)
print v(xbgr.mr_n68014752)
print v(xbgr.mr_n68014864)
print v(xbgr.mr_n68015184)
print v(xbgr.mr_n68015296)
print v(xbgr.mr_n68015616)
print v(xbgr.mr_n68015728)
print v(xbgr.mr_n68016048)
print v(xbgr.mr_n68016160)
print v(xbgr.mr_n68016480)
print v(xbgr.mr_n68016592)
print v(xbgr.mr_n68016912)
print v(xbgr.mr_n68017024)
print v(xbgr.mr_n68017344)
print v(xbgr.mr_n68017456)
print v(xbgr.mr_n68017776)
print v(xbgr.mr_n68017888)
print v(xbgr.mr_n68018208)
print v(xbgr.mr_n68018320)
print v(xbgr.mr_n68018640)
print v(xbgr.mr_n68018752)
print v(xbgr.mr_n68019072)
print v(xbgr.mr_n68019184)
print v(xbgr.mr_n68019504)
print v(xbgr.mr_n68019616)
print v(xbgr.mr_n68019936)
print v(xbgr.mr_n68020048)
print v(xbgr.mr_n68020368)
print v(xbgr.mr_n68020480)
print v(xbgr.mr_n68020800)
print v(xbgr.mr_n68020912)
print v(xbgr.mr_n68021232)
print v(xbgr.mr_n68021344)
print v(xbgr.mr_n68021664)
print v(xbgr.mr_n68021776)
print v(xbgr.mr_n68022096)
print v(xbgr.mr_n68022208)
print v(xbgr.mr_n68022528)
print v(xbgr.mr_n68022640)
print v(xbgr.mr_n68022960)
print v(xbgr.mr_n68023072)
print v(xbgr.mr_n68023392)
print v(xbgr.mr_n68023504)
print v(xbgr.mr_n68023824)
print v(xbgr.mr_n68023936)
print v(xbgr.mr_n68024256)
print v(xbgr.mr_n68024368)
print v(xbgr.mr_n68024688)
print v(xbgr.mr_n68024800)
print v(xbgr.mr_n68025120)
print v(xbgr.mr_n68025232)
print v(xbgr.mr_n68025552)
print v(xbgr.mr_n68025664)
print v(xbgr.mr_n68025984)
print v(xbgr.mr_n68026096)
print v(xbgr.mr_n68026416)
print v(xbgr.mr_n68026528)
print v(xbgr.mr_n68026848)
print v(xbgr.mr_n68026960)
print v(xbgr.mr_n68027280)
print v(xbgr.mr_n68027392)
print v(xbgr.mr_n68027712)
print v(xbgr.mr_n68027824)
print v(xbgr.mr_n68028144)
print v(xbgr.mr_n68028256)
print v(xbgr.mr_n68028576)
print v(xbgr.mr_n68028688)
print v(xbgr.mr_n68029008)
print v(xbgr.mr_n68029120)
print v(xbgr.mr_n68029440)
print v(xbgr.mr_n68029552)
print v(xbgr.mr_n68029872)
print v(xbgr.mr_n68029984)
print v(xbgr.mr_n68030304)
print v(xbgr.mr_n68030736)
print v(xbgr.mr_n68030848)
print v(xbgr.mr_n68031168)
print v(xbgr.mr_n68031280)
print v(xbgr.mr_n68031600)
print v(xbgr.mr_n68031712)
print v(xbgr.mr_n68032032)
print v(xbgr.mr_n68032144)
print v(xbgr.mr_n68032464)
print v(xbgr.mr_n68032576)
print v(xbgr.mr_n68032896)
print v(xbgr.mr_n68033008)
print v(xbgr.mr_n68033328)
print v(xbgr.mr_n68033440)
print v(xbgr.mr_n68033760)
print v(xbgr.mr_n68033872)
print v(xbgr.mr_n68034192)
print v(xbgr.mr_n68034304)
print v(xbgr.mr_n68034624)
print v(xbgr.mr_n68034736)
print v(xbgr.mr_n68035056)
print v(xbgr.mr_n68035168)
print v(xbgr.mr_n68035488)
print v(xbgr.mr_n68035600)
print v(xbgr.mr_n68035920)
print v(xbgr.mr_n68036032)
print v(xbgr.mr_n68036352)
print v(xbgr.mr_n68036464)
print v(xbgr.mr_n68036784)
print v(xbgr.mr_n68036896)
print v(xbgr.mr_n68037216)
print v(xbgr.mr_n68037328)
print v(xbgr.mr_n68037648)
print v(xbgr.mr_n68037760)
print v(xbgr.mr_n68038080)
print v(xbgr.mr_n68038192)
print v(xbgr.mr_n68038512)
print v(xbgr.mr_n68038624)
print v(xbgr.mr_n68038944)
print v(xbgr.mr_n68039056)
print v(xbgr.mr_n68039376)
print v(xbgr.mr_n68039488)
print v(xbgr.mr_n68039808)
print v(xbgr.mr_n68039920)
print v(xbgr.mr_n68040240)
print v(xbgr.mr_n68040352)
print v(xbgr.mr_n68040672)
print v(xbgr.mr_n68040784)
print v(xbgr.mr_n68041104)
print v(xbgr.mr_n68041216)
print v(xbgr.mr_n68041536)
print v(xbgr.mr_n68041648)
print v(xbgr.mr_n68041968)
print v(xbgr.mr_n68042080)
print v(xbgr.mr_n68042400)
print v(xbgr.mr_n68042512)
print v(xbgr.mr_n68042832)
print v(xbgr.mr_n68042944)
print v(xbgr.mr_n68043264)
print v(xbgr.mr_n68043376)
print v(xbgr.mr_n68043696)
print v(xbgr.mr_n68043808)
print v(xbgr.mr_n68044128)
print v(xbgr.mr_n68044240)
print v(xbgr.mr_n68044560)
print v(xbgr.mr_n68044672)
print v(xbgr.mr_n68044992)
print v(xbgr.mr_n68045104)
print v(xbgr.mr_n68045424)
print v(xbgr.mr_n68045536)
print v(xbgr.mr_n68045856)
print v(xbgr.mr_n68046288)
print v(xbgr.mr_n68046400)
print v(xbgr.mr_n68046720)
print v(xbgr.mr_n68046832)
print v(xbgr.mr_n68047152)
print v(xbgr.mr_n68047264)
print v(xbgr.mr_n68047584)
print v(xbgr.mr_n68048016)
print v(xbgr.mr_n68048128)
print v(xbgr.mr_n68048448)
print v(xbgr.mr_n68048560)
print v(xbgr.mr_n68048880)
print v(xbgr.mr_n68048992)
print v(xbgr.mr_n68049312)
print v(xbgr.mr_n68049744)
print v(xbgr.mr_n68049856)
print v(xbgr.mr_n68050176)
print v(xbgr.mr_n68050288)
print v(xbgr.mr_n68050608)
print v(xbgr.mr_n68050720)
print v(xbgr.mr_n68051040)
print v(xbgr.mr_n68051152)
print v(xbgr.mr_n68051472)
print v(xbgr.mr_n68051584)
print v(xbgr.mr_n68051904)
print v(xbgr.mr_n68052016)
print v(xbgr.mr_n68052336)
print v(xbgr.mr_n68052448)
print v(xbgr.mr_n68052768)
print v(xbgr.mr_n68052880)
print v(xbgr.mr_n68053200)
print v(xbgr.mr_n68053312)
print v(xbgr.mr_n68053632)
print v(xbgr.mr_n68053744)
print v(xbgr.mr_n68054064)
print v(xbgr.mr_n68054176)
print v(xbgr.mr_n68054496)
print v(xbgr.mr_n68054608)
print v(xbgr.mr_n68054928)
print v(xbgr.mr_n68055040)
print v(xbgr.mr_n68055360)
print v(xbgr.mr_n68055472)
print v(xbgr.mr_n68055792)
print v(xbgr.mr_n68055904)
print v(xbgr.mr_n68056224)
print v(xbgr.mr_n68056336)
print v(xbgr.mr_n68056656)
print v(xbgr.mr_n68057088)
print v(xbgr.mr_n68057200)
print v(xbgr.mr_n68057520)
print v(xbgr.mr_n68057632)
print v(xbgr.mr_n68057952)
print v(xbgr.mr_n68058064)
print v(xbgr.mr_n68058384)
print v(xbgr.mr_n68058496)
print v(xbgr.mr_n68058816)
print v(xbgr.mr_n68058928)
print v(xbgr.mr_n68059248)
print v(xbgr.mr_n68059360)
print v(xbgr.mr_n68059680)
print v(xbgr.mr_n68059792)
print v(xbgr.mr_n68060112)
print v(xbgr.mr_n68060224)
print v(xbgr.mr_n68060544)
print v(xbgr.mr_n68060656)
print v(xbgr.mr_n68060976)
print v(xbgr.mr_n68061088)
print v(xbgr.mr_n68061408)
print v(xbgr.mr_n68061840)
print v(xbgr.mr_n68061952)
print v(xbgr.mr_n68062272)
print v(xbgr.mr_n68062704)
print v(xbgr.mr_n68062816)
print v(xbgr.mr_n68063136)
print v(xbgr.mr_n68063248)
print v(xbgr.mr_n68063568)
print v(xbgr.mr_n68063680)
print v(xbgr.mr_n68064000)
print v(xbgr.mr_n68064112)
print v(xbgr.mr_n68064432)
print v(xbgr.mr_n68064544)
print v(xbgr.mr_n68064864)
print v(xbgr.mr_n68065296)
print v(xbgr.mr_n68065408)
print v(xbgr.mr_n68065728)
print v(xbgr.mr_n68065840)
print v(xbgr.mr_n68066160)
print v(xbgr.mr_n68066272)
print v(xbgr.mr_n68069856)
print v(xbgr.mr_n68069968)
print v(xbgr.mr_n68070304)
print v(xbgr.mr_n68070416)
print v(xbgr.mr_n68070736)
print v(xbgr.mr_n68070848)
print v(xbgr.mr_n68071216)
print v(xbgr.mr_n68071328)
print v(xbgr.mr_n68071648)
print v(xbgr.mr_n68071760)
print v(xbgr.mr_n68072080)
print v(xbgr.mr_n68072432)
print v(xbgr.mr_n68072544)
print v(xbgr.mr_n68072864)
print v(xbgr.mr_n68073296)
print v(xbgr.mr_n68073408)
print v(xbgr.mr_n68073728)
print v(xbgr.mr_n68073840)
print v(xbgr.mr_n68074160)
print v(xbgr.mr_n68074272)
print v(xbgr.mr_n68074592)
print v(xbgr.mr_n68074704)
print v(xbgr.mr_n68075024)
print v(xbgr.mr_n68075136)
print v(xbgr.mr_n68075456)
print v(xbgr.mr_n68075888)
print v(xbgr.mr_n68076000)
print v(xbgr.mr_n68076320)
print v(xbgr.mr_n68076752)
print v(xbgr.mr_n68076864)
print v(xbgr.mr_n68077184)
print v(xbgr.mr_n68077296)
print v(xbgr.mr_n68077616)
print v(xbgr.mr_n68077728)
print v(xbgr.mr_n68078048)
print v(xbgr.mr_n68078160)
print v(xbgr.mr_n68078480)
print v(xbgr.mr_n68078592)
print v(xbgr.mr_n68078912)
print v(xbgr.mr_n68079024)
print v(xbgr.mr_n68079344)
print v(xbgr.mr_n68079456)
print v(xbgr.mr_n68079776)
print v(xbgr.mr_n68080208)
print v(xbgr.mr_n68080320)
print v(xbgr.mr_n68080640)
print v(xbgr.mr_n68080752)
print v(xbgr.mr_n68081072)
print v(xbgr.mr_n68081184)
print v(xbgr.mr_n68081504)
print v(xbgr.mr_n68081616)
print v(xbgr.mr_n68081936)
print v(xbgr.mr_n68082048)
print v(xbgr.mr_n68082368)
print v(xbgr.mr_n68082480)
print v(xbgr.mr_n68082800)
print v(xbgr.mr_n68082912)
print v(xbgr.mr_n68083232)
print v(xbgr.mr_n68083664)
print v(xbgr.mr_n68083776)
print v(xbgr.mr_n68084096)
print v(xbgr.mr_n68084528)
print v(xbgr.mr_n68084640)
print v(xbgr.mr_n68084960)
print v(xbgr.mr_n68085072)
print v(xbgr.mr_n68085392)
print v(xbgr.mr_n68085504)
print v(xbgr.mr_n68085824)
print v(xbgr.mr_n68085936)
print v(xbgr.mr_n68086256)
print v(xbgr.mr_n68086368)
print v(xbgr.mr_n68086688)
print v(xbgr.mr_n68086800)
print v(xbgr.mr_n68087120)
print v(xbgr.mr_n68087232)
print v(xbgr.mr_n68087552)
print v(xbgr.mr_n68087984)
print v(xbgr.mr_n68088096)
print v(xbgr.mr_n68088416)
print v(xbgr.mr_n68088528)
print v(xbgr.mr_n68088848)
print v(xbgr.mr_n68088960)
print v(xbgr.mr_n68089280)
print v(xbgr.mr_n68089712)
print v(xbgr.mr_n68089824)
print v(xbgr.mr_n68090144)
print v(xbgr.mr_n68090256)
print v(xbgr.mr_n68090576)
print v(xbgr.mr_n68090688)
print v(xbgr.mr_n68091008)
print v(xbgr.mr_n68091120)
print v(xbgr.mr_n68091440)
print v(xbgr.mr_n68091552)
print v(xbgr.mr_n68091872)
print v(xbgr.mr_n68091984)
print v(xbgr.mr_n68092304)
print v(xbgr.mr_n68092416)
print v(xbgr.mr_n68092736)
print v(xbgr.mr_n68093168)
print v(xbgr.mr_n68093280)
print v(xbgr.mr_n68093600)
print v(xbgr.mr_n68093712)
print v(xbgr.mr_n68094032)
print v(xbgr.mr_n68094144)
print v(xbgr.mr_n68094464)
print v(xbgr.mr_n68094896)
print v(xbgr.mr_n68095008)
print v(xbgr.mr_n68095328)
print v(xbgr.mr_n68095440)
print v(xbgr.mr_n68095760)
print v(xbgr.mr_n68095872)
print v(xbgr.mr_n68096192)
print v(xbgr.mr_n68096304)
print v(xbgr.mr_n68096624)
print v(xbgr.mr_n68096736)
print v(xbgr.mr_n68097056)
print v(xbgr.mr_n68097168)
print v(xbgr.mr_n68097488)
print v(xbgr.mr_n68097600)
print v(xbgr.mr_n68097920)
print v(xbgr.mr_n68098032)
print v(xbgr.mr_n68098352)
print v(xbgr.mr_n68098464)
print v(xbgr.mr_n68098784)
print v(xbgr.mr_n68099216)
print v(xbgr.mr_n68099328)
print v(xbgr.mr_n68099648)
print v(xbgr.mr_n68099760)
print v(xbgr.mr_n68099984)
print v(xbgr.mr_n68100352)
print v(xbgr.mr_n68100464)
print v(xbgr.mr_n68100720)
print v(xbgr.mr_n68100832)
print v(xbgr.mr_n68101088)
print v(xbgr.mr_n68101200)
print v(xbgr.mr_n68101456)
print v(xbgr.mr_n68101568)
print v(xbgr.mr_n68101824)
print v(xbgr.mr_n68101936)
print v(xbgr.mr_n68102192)
print v(xbgr.mr_n68102560)
print v(xbgr.mr_n68102672)
print v(xbgr.mr_n68102928)
print v(xbgr.mr_n68103296)
print v(xbgr.mr_n68103408)
print v(xbgr.mr_n68103664)
print v(xbgr.mr_n68104032)
print v(xbgr.mr_n68104144)
print v(xbgr.mr_n68104400)
print v(xbgr.mr_n68104512)
print v(xbgr.mr_n68104768)
print v(xbgr.mr_n68104880)
print v(xbgr.mr_n68105136)
print v(xbgr.mr_n68105504)
print v(xbgr.mr_n68105616)
print v(xbgr.mr_n68105872)
print v(xbgr.mr_n68106240)
print v(xbgr.mr_n68106352)
print v(xbgr.mr_n68106608)
print v(xbgr.mr_n68106976)
print v(xbgr.mr_n68107088)
print v(xbgr.mr_n68107344)
print v(xbgr.mr_n68107456)
print v(xbgr.mr_n68107712)
print v(xbgr.mr_n68107824)
print v(xbgr.mr_n68108080)
print v(xbgr.mr_n68108192)
print v(xbgr.mr_n68108448)
print v(xbgr.mr_n68108560)
print v(xbgr.mr_n68108816)
print v(xbgr.mr_n68109184)
print v(xbgr.mr_n68109296)
print v(xbgr.mr_n68109552)
print v(xbgr.mr_n68109664)
print v(xbgr.mr_n68109920)
print v(xbgr.mr_n68110032)
print v(xbgr.mr_n68110352)
print v(xbgr.mr_n68110464)
print v(xbgr.mr_n68110784)
print v(xbgr.mr_n68110896)
print v(xbgr.mr_n68111216)
print v(xbgr.mr_n68111648)
print v(xbgr.mr_n68111760)
print v(xbgr.mr_n68112080)
print v(xbgr.mr_n68112512)
print v(xbgr.mr_n68112624)
print v(xbgr.mr_n68112944)
print v(xbgr.mr_n68113056)
print v(xbgr.mr_n68113376)
print v(xbgr.mr_n68113488)
print v(xbgr.mr_n68113808)
print v(xbgr.mr_n68114240)
print v(xbgr.mr_n68114352)
print v(xbgr.mr_n68114672)
print v(xbgr.mr_n68115104)
print v(xbgr.mr_n68115216)
print v(xbgr.mr_n68115536)
print v(xbgr.mr_n68115648)
print v(xbgr.mr_n68115968)
print v(xbgr.mr_n68116080)
print v(xbgr.mr_n68116400)
print v(xbgr.mr_n68116512)
print v(xbgr.mr_n68116832)
print v(xbgr.mr_n68116944)
print v(xbgr.mr_n68117264)
print v(xbgr.mr_n68117376)
print v(xbgr.mr_n68117696)
print v(xbgr.mr_n68117808)
print v(xbgr.mr_n68118128)
print v(xbgr.mr_n68118560)
print v(xbgr.mr_n68118672)
print v(xbgr.mr_n68118992)
print v(xbgr.mr_n68119104)
print v(xbgr.mr_n68119424)
print v(xbgr.mr_n68119536)
print v(xbgr.mr_n68119856)
print v(xbgr.mr_n68119968)
print v(xbgr.mr_n68120288)
print v(xbgr.mr_n68120400)
print v(xbgr.mr_n68120720)
print v(xbgr.mr_n68121152)
print v(xbgr.mr_n68121264)
print v(xbgr.mr_n68121584)
print v(xbgr.mr_n68122016)
print v(xbgr.mr_n68122128)
print v(xbgr.mr_n68122448)
print v(xbgr.mr_n68122560)
print v(xbgr.mr_n68122880)
print v(xbgr.mr_n68122992)
print v(xbgr.mr_n68123312)
print v(xbgr.mr_n68123424)
print v(xbgr.mr_n68123744)
print v(xbgr.mr_n68123856)
print v(xbgr.mr_n68124176)
print v(xbgr.mr_n68124288)
print v(xbgr.mr_n68124608)
print v(xbgr.mr_n68124720)
print v(xbgr.mr_n68125040)
print v(xbgr.mr_n68125152)
print v(xbgr.mr_n68125472)
print v(xbgr.mr_n68126016)
print v(xbgr.mr_n68126448)
print v(xbgr.mr_n68126880)
print v(xbgr.mr_n68127312)
print v(xbgr.mr_n68127744)
print v(xbgr.mr_n68128176)
print v(xbgr.mr_n68128608)
print v(xbgr.mr_n68129040)
print v(xbgr.mr_n68129472)
print v(xbgr.mr_n68129904)
print v(xbgr.mr_n68130224)
print v(xbgr.mr_n68130656)
print v(xbgr.mr_n68131088)
print v(xbgr.mr_n68131520)
print v(xbgr.mr_n68131952)
print v(xbgr.mr_n68132384)
print v(xbgr.mr_n68132816)
print v(xbgr.mr_n68133248)
print v(xbgr.mr_n68133680)
print v(xbgr.mr_n68134112)
print v(xbgr.mr_n68134544)
print v(xbgr.mr_n68134976)
print v(xbgr.mr_n68135408)
print v(xbgr.mr_n68135840)
print v(xbgr.mr_n68136272)
print v(xbgr.mr_n68136704)
print v(xbgr.mr_n68137136)
print v(xbgr.mr_n68137568)
print v(xbgr.mr_n68138000)
print v(xbgr.mr_n68138432)
print v(xbgr.mr_n68138864)
print v(xbgr.mr_n68139296)
print v(xbgr.mr_n68139728)
print v(xbgr.mr_n68140160)
print v(xbgr.mr_n68140592)
print v(xbgr.mr_n68141024)
print v(xbgr.mr_n68141456)
print v(xbgr.mr_n68141888)
print v(xbgr.mr_n68142320)
print v(xbgr.mr_n68142752)
print v(xbgr.mr_n68143184)
print v(xbgr.mr_n68143616)
print v(xbgr.mr_n68144048)
print v(xbgr.mr_n68144480)
print v(xbgr.mr_n68144912)
print v(xbgr.mr_n68145344)
print v(xbgr.mr_n68145776)
print v(xbgr.mr_n68146208)
print v(xbgr.mr_n68146640)
print v(xbgr.mr_n68147072)
print v(xbgr.mr_n68147504)
print v(xbgr.mr_n68147936)
print v(xbgr.mr_n68148368)
print v(xbgr.mr_n68148800)
print v(xbgr.mr_n68149232)
print v(xbgr.mr_n68149664)
print v(xbgr.mr_n68150096)
print v(xbgr.mr_n68150528)
print v(xbgr.mr_n68151824)
print v(xbgr.mr_n68152256)
print v(xbgr.mr_n68152688)
print v(xbgr.mr_n68153120)
print v(xbgr.mr_n68153552)
print v(xbgr.mr_n68153984)
print v(xbgr.mr_n68154416)
print v(xbgr.mr_n68154848)
print v(xbgr.mr_n68155280)
print v(xbgr.mr_n68155712)
print v(xbgr.mr_n68156144)
print v(xbgr.mr_n68156576)
print v(xbgr.mr_n68158736)
print v(xbgr.mr_n68159168)
print v(xbgr.mr_n68159600)
print v(xbgr.mr_n68160032)
print v(xbgr.mr_n68160464)
print v(xbgr.mr_n68160896)
print v(xbgr.mr_n68161328)
print v(xbgr.mr_n68161760)
print v(xbgr.mr_n68162192)
print v(xbgr.mr_n68162624)
print v(xbgr.mr_n68163920)
print v(xbgr.mr_n68164352)
print v(xbgr.mr_n68164784)
print v(xbgr.mr_n68165216)
print v(xbgr.mr_n68165648)
print v(xbgr.mr_n68166080)
print v(xbgr.mr_n68166512)
print v(xbgr.mr_n68166944)
print v(xbgr.mr_n68167376)
print v(xbgr.mr_n68167808)
print v(xbgr.mr_n68168240)
print v(xbgr.mr_n68168672)
print v(xbgr.mr_n68169968)
print v(xbgr.mr_n68170400)
print v(xbgr.mr_n68171696)
print v(xbgr.mr_n68172128)
print v(xbgr.mr_n68172560)
print v(xbgr.mr_n68172992)
print v(xbgr.mr_n68173424)
print v(xbgr.mr_n68173856)
print v(xbgr.mr_n68174288)
print v(xbgr.mr_n68174720)
print v(xbgr.mr_n68176016)
print v(xbgr.mr_n68176448)
print v(xbgr.mr_n68176768)
print v(xbgr.mr_n68176880)
print v(xbgr.mr_n68177200)
print v(xbgr.mr_n68177312)
print v(xbgr.mr_n68177632)
print v(xbgr.mr_n68177744)
print v(xbgr.mr_n68178064)
print v(xbgr.mr_n68178176)
print v(xbgr.mr_n68178496)
print v(xbgr.mr_n68178608)
print v(xbgr.mr_n68178928)
print v(xbgr.mr_n68179040)
print v(xbgr.mr_n68179360)
print v(xbgr.mr_n68179472)
print v(xbgr.mr_n68179792)
print v(xbgr.mr_n68179904)
print v(xbgr.mr_n68180336)
print v(xbgr.mr_n68180768)
print v(xbgr.mr_n68181200)
print v(xbgr.mr_n68181632)
print v(xbgr.mr_n68182064)
print v(xbgr.mr_n68182496)
print v(xbgr.mr_n68182928)
print v(xbgr.mr_n68183360)
print v(xbgr.mr_n68183792)
print v(xbgr.mr_n68184224)
print v(xbgr.mr_n68184656)
print v(xbgr.mr_n68185088)
print v(xbgr.mr_n68185520)
print v(xbgr.mr_n68185952)
print v(xbgr.mr_n68186384)
print v(xbgr.mr_n68186816)
print v(xbgr.mr_n68187248)
print v(xbgr.mr_n68187680)
print v(xbgr.mr_n68188112)
print v(xbgr.mr_n68188544)
print v(xbgr.mr_n68188976)
print v(xbgr.mr_n68189408)
print v(xbgr.mr_n68189840)
print v(xbgr.mr_n68190272)
print v(xbgr.mr_n68190704)
print v(xbgr.mr_n68191136)
print v(xbgr.mr_n68191776)
print v(xbgr.mr_n68192208)
print v(xbgr.mr_n68192640)
print v(xbgr.mr_n68193072)
print v(xbgr.mr_n68193504)
print v(xbgr.mr_n68193936)
print v(xbgr.mr_n68194368)
print v(xbgr.mr_n68194800)
print v(xbgr.mr_n68195232)
print v(xbgr.mr_n68195664)
print v(xbgr.mr_n68196096)
print v(xbgr.mr_n68196528)
print v(xbgr.mr_n68196960)
print v(xbgr.mr_n68197392)
print v(xbgr.mr_n68197824)
print v(xbgr.mr_n68198256)
print v(xbgr.mr_n68198688)
print v(xbgr.mr_n68199120)
print v(xbgr.mr_n68199552)
print v(xbgr.mr_n68199984)
print v(xbgr.mr_n68200416)
print v(xbgr.mr_n68200848)
print v(xbgr.mr_n68201280)
print v(xbgr.mr_n68201712)
print v(xbgr.mr_n68202144)
print v(xbgr.mr_n68202576)
print v(xbgr.mr_n68203008)
print v(xbgr.mr_n68203440)
print v(xbgr.mr_n68203872)
print v(xbgr.mr_n68204304)
print v(xbgr.mr_n68204736)
print v(xbgr.mr_n68205168)
print v(xbgr.mr_n68205600)
print v(xbgr.mr_n68206032)
print v(xbgr.mr_n68206464)
print v(xbgr.mr_n68206896)
print v(xbgr.mr_n68207328)
print v(xbgr.mr_n68207760)
print v(xbgr.mr_n68208192)
print v(xbgr.mr_n68208624)
print v(xbgr.mr_n68209056)
print v(xbgr.mr_n68209488)
print v(xbgr.mr_n68209920)
print v(xbgr.mr_n68210352)
print v(xbgr.mr_n68210784)
print v(xbgr.mr_n68211216)
print v(xbgr.mr_n68211648)
print v(xbgr.mr_n68212080)
print v(xbgr.mr_n68212512)
print v(xbgr.mr_n68212944)
print v(xbgr.mr_n68213376)
print v(xbgr.mr_n68213808)
print v(xbgr.mr_n68214240)
print v(xbgr.mr_n68214672)
print v(xbgr.mr_n68215104)
print v(xbgr.mr_n68215536)
print v(xbgr.mr_n68215968)
print v(xbgr.mr_n68216400)
print v(xbgr.mr_n68216832)
print v(xbgr.mr_n68217264)
print v(xbgr.mr_n68217696)
print v(xbgr.mr_n68218128)
print v(xbgr.mr_n68218560)
print v(xbgr.mr_n68218992)
print v(xbgr.mr_n68219424)
print v(xbgr.mr_n68219856)
print v(xbgr.mr_n68220288)
print v(xbgr.mr_n68220720)
print v(xbgr.mr_n68221152)
print v(xbgr.mr_n68221584)
print v(xbgr.mr_n68222016)
print v(xbgr.mr_n68222448)
print v(xbgr.mr_n68222880)
print v(xbgr.mr_n68223312)
print v(xbgr.mr_n68223744)
print v(xbgr.mr_n68224176)
print v(xbgr.mr_n68224608)
print v(xbgr.mr_n68225040)
print v(xbgr.mr_n68225472)
print v(xbgr.mr_n68225904)
print v(xbgr.mr_n68226336)
print v(xbgr.mr_n68226768)
print v(xbgr.mr_n68227200)
print v(xbgr.mr_n68227632)
print v(xbgr.mr_n68228064)
print v(xbgr.mr_n68228384)
print v(xbgr.mr_n68228496)
print v(xbgr.mr_n68228816)
print v(xbgr.mr_n68228928)
print v(xbgr.mr_n68229248)
print v(xbgr.mr_n68229360)
print v(xbgr.mr_n68229680)
print v(xbgr.mr_n68229792)
print v(xbgr.mr_n68230224)
print v(xbgr.mr_n68230656)
print v(xbgr.mr_n68231088)
print v(xbgr.mr_n68231520)
print v(xbgr.mr_n68231952)
print v(xbgr.mr_n68232384)
print v(xbgr.mr_n68232816)
print v(xbgr.mr_n68233248)
print v(xbgr.mr_n68233680)
print v(xbgr.mr_n68234112)
print v(xbgr.mr_n68234544)
print v(xbgr.mr_n68234976)
print v(xbgr.mr_n68235408)
print v(xbgr.mr_n68235840)
print v(xbgr.mr_n68236272)
print v(xbgr.mr_n68236704)
print v(xbgr.mr_n68237136)
print v(xbgr.mr_n68237568)
print v(xbgr.mr_n68238000)
print v(xbgr.mr_n68238432)
print v(xbgr.mr_n68238864)
print v(xbgr.mr_n68239296)
print v(xbgr.mr_n68239728)
print v(xbgr.mr_n68240160)
print v(xbgr.mr_n68240592)
print v(xbgr.mr_n68241024)
print v(xbgr.mr_n68241456)
print v(xbgr.mr_n68241888)
print v(xbgr.mr_n68242320)
print v(xbgr.mr_n68242752)
print v(xbgr.mr_n68243184)
print v(xbgr.mr_n68243616)
print v(xbgr.mr_n68244048)
print v(xbgr.mr_n68244480)
print v(xbgr.mr_n68244912)
print v(xbgr.mr_n68245344)
print v(xbgr.mr_n68245776)
print v(xbgr.mr_n68246208)
print v(xbgr.mr_n68246640)
print v(xbgr.mr_n68247072)
print v(xbgr.mr_n68247504)
print v(xbgr.mr_n68247936)
print v(xbgr.mr_n68248368)
print v(xbgr.mr_n68248800)
print v(xbgr.mr_n68249232)
print v(xbgr.mr_n68249664)
print v(xbgr.mr_n68250096)
print v(xbgr.mr_n68250528)
print v(xbgr.mr_n68250960)
print v(xbgr.mr_n68251392)
print v(xbgr.mr_n68251824)
print v(xbgr.mr_n68252256)
print v(xbgr.mr_n68252688)
print v(xbgr.mr_n68253120)
print v(xbgr.mr_n68253552)
print v(xbgr.mr_n68253984)
print v(xbgr.mr_n68254416)
print v(xbgr.mr_n68254848)
print v(xbgr.mr_n68255280)
print v(xbgr.mr_n68255712)
print v(xbgr.mr_n68256144)
print v(xbgr.mr_n68256576)
print v(xbgr.mr_n68257008)
print v(xbgr.mr_n68257440)
print v(xbgr.mr_n68258736)
print v(xbgr.mr_n68259168)
print v(xbgr.mr_n68260464)
print v(xbgr.mr_n68260896)
print v(xbgr.mr_n68262192)
print v(xbgr.mr_n68262624)
print v(xbgr.mr_n68263056)
print v(xbgr.mr_n68263488)
print v(xbgr.mr_n68263920)
print v(xbgr.mr_n68264352)
print v(xbgr.mr_n68264784)
print v(xbgr.mr_n68265216)
print v(xbgr.mr_n68265648)
print v(xbgr.mr_n68266080)
print v(xbgr.mr_n68266512)
print v(xbgr.mr_n68266944)
print v(xbgr.mr_n68267376)
print v(xbgr.mr_n68267808)
print v(xbgr.mr_n68268240)
print v(xbgr.mr_n68268672)
print v(xbgr.mr_n68269968)
print v(xbgr.mr_n68270400)
print v(xbgr.mr_n68270832)
print v(xbgr.mr_n68271264)
print v(xbgr.mr_n68271696)
print v(xbgr.mr_n68272128)
print v(xbgr.mr_n68273424)
print v(xbgr.mr_n68273856)
print v(xbgr.mr_n68274288)
print v(xbgr.mr_n68274720)
print v(xbgr.mr_n68275152)
print v(xbgr.mr_n68275584)
print v(xbgr.mr_n68276016)
print v(xbgr.mr_n68276448)
print v(xbgr.mr_n68276880)
print v(xbgr.mr_n68277312)
print v(xbgr.mr_n68277744)
print v(xbgr.mr_n68278176)
print v(xbgr.mr_n68278608)
print v(xbgr.mr_n68279040)
print v(xbgr.mr_n68279472)
print v(xbgr.mr_n68279904)
print v(xbgr.mr_n68280336)
print v(xbgr.mr_n68280768)
print v(xbgr.mr_n68281200)
print v(xbgr.mr_n68281632)
print v(xbgr.mr_n68282064)
print v(xbgr.mr_n68282496)
print v(xbgr.mr_n68282928)
print v(xbgr.mr_n68283360)
print v(xbgr.mr_n68283792)
print v(xbgr.mr_n68284224)
print v(xbgr.mr_n68284656)
print v(xbgr.mr_n68285088)
print v(xbgr.mr_n68285520)
print v(xbgr.mr_n68285952)
print v(xbgr.mr_n68286384)
print v(xbgr.mr_n68286816)
print v(xbgr.mr_n68287248)
print v(xbgr.mr_n68287680)
print v(xbgr.mr_n68288112)
print v(xbgr.mr_n68288544)
print v(xbgr.mr_n68288976)
print v(xbgr.mr_n68289408)
print v(xbgr.mr_n68289840)
print v(xbgr.mr_n68290272)
print v(xbgr.mr_n68290704)
print v(xbgr.mr_n68291136)
print v(xbgr.mr_n68291568)
print v(xbgr.mr_n68292000)
print v(xbgr.mr_n68292432)
print v(xbgr.mr_n68292864)
print v(xbgr.mr_n68293296)
print v(xbgr.mr_n68293728)
print v(xbgr.mr_n68294160)
print v(xbgr.mr_n68294592)
print v(xbgr.mr_n68295024)
print v(xbgr.mr_n68295456)
print v(xbgr.mr_n68295888)
print v(xbgr.mr_n68296320)
print v(xbgr.mr_n68296752)
print v(xbgr.mr_n68297184)
print v(xbgr.mr_n68297616)
print v(xbgr.mr_n68297936)
print v(xbgr.mr_n68298048)
print v(xbgr.mr_n68298368)
print v(xbgr.mr_n68298480)
print v(xbgr.mr_n68298800)
print v(xbgr.mr_n68298912)
print v(xbgr.mr_n68299232)
print v(xbgr.mr_n68299344)
print v(xbgr.mr_n68299664)
print v(xbgr.mr_n68299776)
print v(xbgr.mr_n68300096)
print v(xbgr.mr_n68300208)
print v(xbgr.mr_n68300528)
print v(xbgr.mr_n68300640)
print v(xbgr.mr_n68300960)
print v(xbgr.mr_n68301072)
print v(xbgr.mr_n68301392)
print v(xbgr.mr_n68301504)
print v(xbgr.mr_n68301824)
print v(xbgr.mr_n68301936)
print v(xbgr.mr_n68302256)
print v(xbgr.mr_n68302368)
print v(xbgr.mr_n68302688)
print v(xbgr.mr_n68302800)
print v(xbgr.mr_n68303120)
print v(xbgr.mr_n68303232)
print v(xbgr.mr_n68303552)
print v(xbgr.mr_n68303664)
print v(xbgr.mr_n68303984)
print v(xbgr.mr_n68304096)
print v(xbgr.mr_n68304416)
print v(xbgr.mr_n68304528)
print v(xbgr.mr_n68304848)
print v(xbgr.mr_n68304960)
print v(xbgr.mr_n68305280)
print v(xbgr.mr_n68305392)
print v(xbgr.mr_n68305712)
print v(xbgr.mr_n68305824)
print v(xbgr.mr_n68306144)
print v(xbgr.mr_n68306256)
print v(xbgr.mr_n68306576)
print v(xbgr.mr_n68306688)
print v(xbgr.mr_n68307008)
print v(xbgr.mr_n68307120)
print v(xbgr.mr_n68307440)
print v(xbgr.mr_n68307552)
print v(xbgr.mr_n68307872)
print v(xbgr.mr_n68307984)
print v(xbgr.mr_n68308304)
print v(xbgr.mr_n68308416)
print v(xbgr.mr_n68308736)
print v(xbgr.mr_n68308848)
print v(xbgr.mr_n68309168)
print v(xbgr.mr_n68309280)
print v(xbgr.mr_n68309600)
print v(xbgr.mr_n68309712)
print v(xbgr.mr_n68310032)
print v(xbgr.mr_n68310144)
print v(xbgr.mr_n68310464)
print v(xbgr.mr_n68310576)
print v(xbgr.mr_n68310896)
print v(xbgr.mr_n68311008)
print v(xbgr.mr_n68311328)
print v(xbgr.mr_n68311440)
print v(xbgr.mr_n68311760)
print v(xbgr.mr_n68311872)
print v(xbgr.mr_n68312192)
print v(xbgr.mr_n68312304)
print v(xbgr.mr_n68312624)
print v(xbgr.mr_n68312736)
print v(xbgr.mr_n68313056)
print v(xbgr.mr_n68313168)
print v(xbgr.mr_n68313488)
print v(xbgr.mr_n68313600)
print v(xbgr.mr_n68313920)
print v(xbgr.mr_n68314032)
print v(xbgr.mr_n68314448)
print v(xbgr.mr_n68314880)
print v(xbgr.mr_n68315312)
print v(xbgr.mr_n68315744)
print v(xbgr.mr_n68316176)
print v(xbgr.mr_n68316608)
print v(xbgr.mr_n68317040)
print v(xbgr.mr_n68317472)
print v(xbgr.mr_n68317904)
print v(xbgr.mr_n68318336)
print v(xbgr.mr_n68318768)
print v(xbgr.mr_n68319200)
print v(xbgr.mr_n68319520)
print v(xbgr.mr_n68319632)
print v(xbgr.mr_n68319952)
print v(xbgr.mr_n68320064)
print v(xbgr.mr_n68320496)
print v(xbgr.mr_n68320928)
print v(xbgr.mr_n68321360)
print v(xbgr.mr_n68321792)
print v(xbgr.mr_n68322224)
print v(xbgr.mr_n68322656)
print v(xbgr.mr_n68323088)
print v(xbgr.mr_n68323520)
print v(xbgr.mr_n68323952)
print v(xbgr.mr_n68324384)
print v(xbgr.mr_n68324816)
print v(xbgr.mr_n68325248)
print v(xbgr.mr_n68325680)
print v(xbgr.mr_n68326112)
print v(xbgr.mr_n68326544)
print v(xbgr.mr_n68326976)
print v(xbgr.mr_n68327408)
print v(xbgr.mr_n68327840)
print v(xbgr.mr_n68328272)
print v(xbgr.mr_n68328704)
print v(xbgr.mr_n68329136)
print v(xbgr.mr_n68329568)
print v(xbgr.mr_n68330000)
print v(xbgr.mr_n68330432)
print v(xbgr.mr_n68330864)
print v(xbgr.mr_n68331296)
print v(xbgr.mr_n68331728)
print v(xbgr.mr_n68332160)
print v(xbgr.mr_n68332592)
print v(xbgr.mr_n68333024)
print v(xbgr.mr_n68333456)
print v(xbgr.mr_n68333888)
print v(xbgr.mr_n68334320)
print v(xbgr.mr_n68334752)
print v(xbgr.mr_n68335184)
print v(xbgr.mr_n68335616)
print v(xbgr.mr_n68336048)
print v(xbgr.mr_n68336480)
print v(xbgr.mr_n68336912)
print v(xbgr.mr_n68337344)
print v(xbgr.mr_n68337664)
print v(xbgr.mr_n68337776)
print v(xbgr.mr_n68338096)
print v(xbgr.mr_n68338208)
print v(xbgr.mr_n68338640)
print v(xbgr.mr_n68338960)
print v(xbgr.mr_n68339072)
print v(xbgr.mr_n68339504)
print v(xbgr.mr_n68339936)
print v(xbgr.mr_n68340368)
print v(xbgr.mr_n68340800)
print v(xbgr.mr_n68341232)
print v(xbgr.mr_n68341664)
print v(xbgr.mr_n68342096)
print v(xbgr.mr_n68342528)
print v(xbgr.mr_n68342960)
print v(xbgr.mr_n68343392)
print v(xbgr.mr_n68343824)
print v(xbgr.mr_n68344256)
print v(xbgr.mr_n68344688)
print v(xbgr.mr_n68345120)
print v(xbgr.mr_n68345552)
print v(xbgr.mr_n68345984)
print v(xbgr.mr_n68346416)
print v(xbgr.mr_n68346848)
print v(xbgr.mr_n68347280)
print v(xbgr.mr_n68347712)
print v(xbgr.mr_n68348144)
print v(xbgr.mr_n68348576)
print v(xbgr.mr_n68349008)
print v(xbgr.mr_n68349440)
print v(xbgr.mr_n68349872)
print v(xbgr.mr_n68350304)
print v(xbgr.mr_n68350736)
print v(xbgr.mr_n68351168)
print v(xbgr.mr_n68351600)
print v(xbgr.mr_n68352032)
print v(xbgr.mr_n68352464)
print v(xbgr.mr_n68352896)
print v(xbgr.mr_n68353328)
print v(xbgr.mr_n68353760)
print v(xbgr.mr_n68354192)
print v(xbgr.mr_n68354624)
print v(xbgr.mr_n68355056)
print v(xbgr.mr_n68355488)
print v(xbgr.mr_n68355920)
print v(xbgr.mr_n68356352)
print v(xbgr.mr_n68356784)
print v(xbgr.mr_n68357216)
print v(xbgr.mr_n68357648)
print v(xbgr.mr_n68358080)
print v(xbgr.mr_n68358512)
print v(xbgr.mr_n68358944)
print v(xbgr.mr_n68359376)
print v(xbgr.mr_n68359696)
print v(xbgr.mr_n68359808)
print v(xbgr.mr_n68360240)
print v(xbgr.mr_n68360672)
print v(xbgr.mr_n68360992)
print v(xbgr.mr_n68361104)
print v(xbgr.mr_n68361424)
print v(xbgr.mr_n68361536)
print v(xbgr.mr_n68361856)
print v(xbgr.mr_n68361968)
print v(xbgr.mr_n68362288)
print v(xbgr.mr_n68362400)
print v(xbgr.mr_n68362720)
print v(xbgr.mr_n68362832)
print v(xbgr.mr_n68363152)
print v(xbgr.mr_n68363264)
print v(xbgr.mr_n68363696)
print v(xbgr.mr_n68364016)
print v(xbgr.mr_n68364128)
print v(xbgr.mr_n68364448)
print v(xbgr.mr_n68364560)
print v(xbgr.mr_n68364880)
print v(xbgr.mr_n68364992)
print v(xbgr.mr_n68365312)
print v(xbgr.mr_n68365424)
print v(xbgr.mr_n68365744)
print v(xbgr.mr_n68365856)
print v(xbgr.mr_n68366176)
print v(xbgr.mr_n68366288)
print v(xbgr.mr_n68366720)
print v(xbgr.mr_n68367040)
print v(xbgr.mr_n68367152)
print v(xbgr.mr_n68367472)
print v(xbgr.mr_n68367584)
print v(xbgr.mr_n68367904)
print v(xbgr.mr_n68368016)
print v(xbgr.mr_n68368336)
print v(xbgr.mr_n68368448)
print v(xbgr.mr_n68368768)
print v(xbgr.mr_n68368880)
print v(xbgr.mr_n68369200)
print v(xbgr.mr_n68369312)
print v(xbgr.mr_n68369744)
print v(xbgr.mr_n68370064)
print v(xbgr.mr_n68370176)
print v(xbgr.mr_n68370496)
print v(xbgr.mr_n68370608)
print v(xbgr.mr_n68370928)
print v(xbgr.mr_n68371040)
print v(xbgr.mr_n68371472)
print v(xbgr.mr_n68371792)
print v(xbgr.mr_n68371904)
print v(xbgr.mr_n68372336)
print v(xbgr.mr_n68372768)
print v(xbgr.mr_n68373200)
print v(xbgr.mr_n68373632)
print v(xbgr.mr_n68374928)
print v(xbgr.mr_n68375360)
print v(xbgr.mr_n68376656)
print v(xbgr.mr_n68377088)
print v(xbgr.mr_n68377408)
print v(xbgr.mr_n68377520)
print v(xbgr.mr_n68377840)
print v(xbgr.mr_n68377952)
print v(xbgr.mr_n68378272)
print v(xbgr.mr_n68378384)
print v(xbgr.mr_n68378704)
print v(xbgr.mr_n68379248)
print v(xbgr.mr_n68380000)
print v(xbgr.mr_n68380112)
print v(xbgr.mr_n68380432)
print v(xbgr.mr_n68382704)
print v(xbgr.mr_n68383568)
print v(xbgr.mr_n68384432)
print v(xbgr.mr_n68384864)
print v(xbgr.mr_n68385296)
print v(xbgr.mr_n68385728)
print v(xbgr.mr_n68387776)
print v(xbgr.mr_n68387888)
print v(xbgr.mr_n68388320)
print v(xbgr.mr_n68388640)
print v(xbgr.mr_n68388752)
print v(xbgr.mr_n68389072)
print v(xbgr.mr_n68389184)
print v(xbgr.mr_n68389616)
print v(xbgr.mr_n68389936)
print v(xbgr.mr_n68390048)
print v(xbgr.mr_n68390368)
print v(xbgr.mr_n68390480)
print v(xbgr.mr_n68390800)
print v(xbgr.mr_n68390912)
print v(xbgr.mr_n68391344)
print v(xbgr.mr_n68391664)
print v(xbgr.mr_n68391776)
print v(xbgr.mr_n68392096)
print v(xbgr.mr_n68392208)
print v(xbgr.mr_n68392528)
print v(xbgr.mr_n68392640)
print v(xbgr.mr_n68393072)
print v(xbgr.mr_n68393392)
print v(xbgr.mr_n68393504)
print v(xbgr.mr_n68393824)
print v(xbgr.mr_n68393936)
print v(xbgr.mr_n68394256)
print v(xbgr.mr_n68394368)
print v(xbgr.mr_n68394688)
print v(xbgr.mr_n68394800)
print v(xbgr.mr_n68395120)
print v(xbgr.mr_n68395232)
print v(xbgr.mr_n68395664)
print v(xbgr.mr_n68395984)
print v(xbgr.mr_n68396096)
print v(xbgr.mr_n68396416)
print v(xbgr.mr_n68396528)
print v(xbgr.mr_n68396848)
print v(xbgr.mr_n68396960)
print v(xbgr.mr_n68397280)
print v(xbgr.mr_n68397392)
print v(xbgr.mr_n68397824)
print v(xbgr.mr_n68398144)
print v(xbgr.mr_n68398256)
print v(xbgr.mr_n68398576)
print v(xbgr.mr_n68398688)
print v(xbgr.mr_n68399120)
print v(xbgr.mr_n68399440)
print v(xbgr.mr_n68399552)
print v(xbgr.mr_n68399872)
print v(xbgr.mr_n68399984)
print v(xbgr.mr_n68400304)
print v(xbgr.mr_n68400416)
print v(xbgr.mr_n68400848)
print v(xbgr.mr_n68401168)
print v(xbgr.mr_n68401280)
print v(xbgr.mr_n68401600)
print v(xbgr.mr_n68401712)
print v(xbgr.mr_n68402032)
print v(xbgr.mr_n68402144)
print v(xbgr.mr_n68402576)
print v(xbgr.mr_n68402896)
print v(xbgr.mr_n68403008)
print v(xbgr.mr_n68403328)
print v(xbgr.mr_n68403440)
print v(xbgr.mr_n68403760)
print v(xbgr.mr_n68403872)
print v(xbgr.mr_n68404192)
print v(xbgr.mr_n68404304)
print v(xbgr.mr_n68404624)
print v(xbgr.mr_n68404736)
print v(xbgr.mr_n68405056)
print v(xbgr.mr_n68405168)
print v(xbgr.mr_n68405488)
print v(xbgr.mr_n68405600)
print v(xbgr.mr_n68405920)
print v(xbgr.mr_n68406032)
print v(xbgr.mr_n68406352)
print v(xbgr.mr_n68406464)
print v(xbgr.mr_n68406784)
print v(xbgr.mr_n68406896)
print v(xbgr.mr_n68407216)
print v(xbgr.mr_n68407328)
print v(xbgr.mr_n68407648)
print v(xbgr.mr_n68407760)
print v(xbgr.mr_n68408080)
print v(xbgr.mr_n68408192)
print v(xbgr.mr_n68408624)
print v(xbgr.mr_n68408944)
print v(xbgr.mr_n68409056)
print v(xbgr.mr_n68409376)
print v(xbgr.mr_n68409488)
print v(xbgr.mr_n68409808)
print v(xbgr.mr_n68409920)
print v(xbgr.mr_n68410240)
print v(xbgr.mr_n68410352)
print v(xbgr.mr_n68410672)
print v(xbgr.mr_n68410784)
print v(xbgr.mr_n68411104)
print v(xbgr.mr_n68411216)
print v(xbgr.mr_n68411536)
print v(xbgr.mr_n68411648)
print v(xbgr.mr_n68411968)
print v(xbgr.mr_n68412080)
print v(xbgr.mr_n68412400)
print v(xbgr.mr_n68412512)
print v(xbgr.mr_n68412832)
print v(xbgr.mr_n68412944)
print v(xbgr.mr_n68413376)
print v(xbgr.mr_n68413696)
print v(xbgr.mr_n68413808)
print v(xbgr.mr_n68414128)
print v(xbgr.mr_n68414240)
print v(xbgr.mr_n68414560)
print v(xbgr.mr_n68414672)
print v(xbgr.mr_n68414992)
print v(xbgr.mr_n68415104)
print v(xbgr.mr_n68415424)
print v(xbgr.mr_n68415536)
print v(xbgr.mr_n68415856)
print v(xbgr.mr_n68415968)
print v(xbgr.mr_n68416288)
print v(xbgr.mr_n68416400)
print v(xbgr.mr_n68416720)
print v(xbgr.mr_n68416832)
print v(xbgr.mr_n68417152)
print v(xbgr.mr_n68417264)
print v(xbgr.mr_n68417584)
print v(xbgr.mr_n68417696)
print v(xbgr.mr_n68418016)
print v(xbgr.mr_n68418128)
print v(xbgr.mr_n68418448)
print v(xbgr.mr_n68418560)
print v(xbgr.mr_n68418880)
print v(xbgr.mr_n68418992)
print v(xbgr.mr_n68419312)
print v(xbgr.mr_n68419424)
print v(xbgr.mr_n68419744)
print v(xbgr.mr_n68419856)
print v(xbgr.mr_n68420176)
print v(xbgr.mr_n68420288)
print v(xbgr.mr_n68420720)
print v(xbgr.mr_n68421040)
print v(xbgr.mr_n68421152)
print v(xbgr.mr_n68421472)
print v(xbgr.mr_n68421584)
print v(xbgr.mr_n68421904)
print v(xbgr.mr_n68422016)
print v(xbgr.mr_n68422336)
print v(xbgr.mr_n68422448)
print v(xbgr.mr_n68422768)
print v(xbgr.mr_n68422880)
print v(xbgr.mr_n68423200)
print v(xbgr.mr_n68423312)
print v(xbgr.mr_n68423632)
print v(xbgr.mr_n68423744)
print v(xbgr.mr_n68424064)
print v(xbgr.mr_n68424176)
print v(xbgr.mr_n68424496)
print v(xbgr.mr_n68424608)
print v(xbgr.mr_n68424928)
print v(xbgr.mr_n68425040)
print v(xbgr.mr_n68425360)
print v(xbgr.mr_n68425472)
print v(xbgr.mr_n68425792)
print v(xbgr.mr_n68425904)
print v(xbgr.mr_n68426336)
print v(xbgr.mr_n68426656)
print v(xbgr.mr_n68426768)
print v(xbgr.mr_n68427088)
print v(xbgr.mr_n68427200)
print v(xbgr.mr_n68427520)
print v(xbgr.mr_n68427632)
print v(xbgr.mr_n68427952)
print v(xbgr.mr_n68428064)
print v(xbgr.mr_n68428384)
print v(xbgr.mr_n68428496)
print v(xbgr.mr_n68428816)
print v(xbgr.mr_n68428928)
print v(xbgr.mr_n68429248)
print v(xbgr.mr_n68429360)
print v(xbgr.mr_n68429680)
print v(xbgr.mr_n68429792)
print v(xbgr.mr_n68430112)
print v(xbgr.mr_n68430224)
print v(xbgr.mr_n68430544)
print v(xbgr.mr_n68430656)
print v(xbgr.mr_n68430976)
print v(xbgr.mr_n68431088)
print v(xbgr.mr_n68431408)
print v(xbgr.mr_n68431520)
print v(xbgr.mr_n68431840)
print v(xbgr.mr_n68431952)
print v(xbgr.mr_n68432272)
print v(xbgr.mr_n68432384)
print v(xbgr.mr_n68432704)
print v(xbgr.mr_n68432816)
print v(xbgr.mr_n68433136)
print v(xbgr.mr_n68433248)
print v(xbgr.mr_n68433568)
print v(xbgr.mr_n68433680)
print v(xbgr.mr_n68434000)
print v(xbgr.mr_n68434112)
print v(xbgr.mr_n68434432)
print v(xbgr.mr_n68434544)
print v(xbgr.mr_n68434864)
print v(xbgr.mr_n68434976)
print v(xbgr.mr_n68435408)
print v(xbgr.mr_n68435728)
print v(xbgr.mr_n68435840)
print v(xbgr.mr_n68436160)
print v(xbgr.mr_n68436272)
print v(xbgr.mr_n68436592)
print v(xbgr.mr_n68436704)
print v(xbgr.mr_n68437024)
print v(xbgr.mr_n68437136)
print v(xbgr.mr_n68437456)
print v(xbgr.mr_n68437568)
print v(xbgr.mr_n68437888)
print v(xbgr.mr_n68438000)
print v(xbgr.mr_n68438320)
print v(xbgr.mr_n68438432)
print v(xbgr.mr_n68438752)
print v(xbgr.mr_n68438864)
print v(xbgr.mr_n68439184)
print v(xbgr.mr_n68439296)
print v(xbgr.mr_n68439616)
print v(xbgr.mr_n68439728)
print v(xbgr.mr_n68440048)
print v(xbgr.mr_n68440160)
print v(xbgr.mr_n68440480)
print v(xbgr.mr_n68440592)
print v(xbgr.mr_n68440912)
print v(xbgr.mr_n68441024)
print v(xbgr.mr_n68441344)
print v(xbgr.mr_n68441456)
print v(xbgr.mr_n68441776)
print v(xbgr.mr_n68441888)
print v(xbgr.mr_n68442208)
print v(xbgr.mr_n68442320)
print v(xbgr.mr_n68442640)
print v(xbgr.mr_n68442752)
print v(xbgr.mr_n68443072)
print v(xbgr.mr_n68443184)
print v(xbgr.mr_n68443504)
print v(xbgr.mr_n68443616)
print v(xbgr.mr_n68443936)
print v(xbgr.mr_n68444048)
print v(xbgr.mr_n68444368)
print v(xbgr.mr_n68444480)
print v(xbgr.mr_n68444800)
print v(xbgr.mr_n68444912)
print v(xbgr.mr_n68445344)
print v(xbgr.mr_n68445664)
print v(xbgr.mr_n68445776)
print v(xbgr.mr_n68446096)
print v(xbgr.mr_n68446208)
print v(xbgr.mr_n68446528)
print v(xbgr.mr_n68446640)
print v(xbgr.mr_n68446960)
print v(xbgr.mr_n68447072)
print v(xbgr.mr_n68447392)
print v(xbgr.mr_n68447504)
print v(xbgr.mr_n68447824)
print v(xbgr.mr_n68447936)
print v(xbgr.mr_n68448256)
print v(xbgr.mr_n68448368)
print v(xbgr.mr_n68448688)
print v(xbgr.mr_n68448800)
print v(xbgr.mr_n68449120)
print v(xbgr.mr_n68449232)
print v(xbgr.mr_n68449552)
print v(xbgr.mr_n68449664)
print v(xbgr.mr_n68449984)
print v(xbgr.mr_n68450096)
print v(xbgr.mr_n68450416)
print v(xbgr.mr_n68450528)
print v(xbgr.mr_n68450960)
print v(xbgr.mr_n68451392)
print v(xbgr.mr_n68451824)
print v(xbgr.mr_n68452256)
print v(xbgr.mr_n68452688)
print v(xbgr.mr_n68453120)
print v(xbgr.mr_n68453552)
print v(xbgr.mr_n68453984)
print v(xbgr.mr_n68454416)
print v(xbgr.mr_n68454848)
print v(xbgr.mr_n68455280)
print v(xbgr.mr_n68455712)
print v(xbgr.mr_n68456144)
print v(xbgr.mr_n68456576)
print v(xbgr.mr_n68457008)
print v(xbgr.mr_n68457440)
print v(xbgr.mr_n68457872)
print v(xbgr.mr_n68458304)
print v(xbgr.mr_n68458736)
print v(xbgr.mr_n68459168)
print v(xbgr.mr_n68459600)
print v(xbgr.mr_n68460032)
print v(xbgr.mr_n68460464)
print v(xbgr.mr_n68460896)
print v(xbgr.mr_n68461328)
print v(xbgr.mr_n68461760)
print v(xbgr.mr_n68462192)
print v(xbgr.mr_n68462624)
print v(xbgr.mr_n68463056)
print v(xbgr.mr_n68463488)
print v(xbgr.mr_n68463920)
print v(xbgr.mr_n68464352)
print v(xbgr.mr_n68464784)
print v(xbgr.mr_n68465216)
print v(xbgr.mr_n68465648)
print v(xbgr.mr_n68466080)
print v(xbgr.mr_n68466512)
print v(xbgr.mr_n68466944)
print v(xbgr.mr_n68467376)
print v(xbgr.mr_n68467808)
print v(xbgr.mr_n68468240)
print v(xbgr.mr_n68468672)
print v(xbgr.mr_n68469104)
print v(xbgr.mr_n68469536)
print v(xbgr.mr_n68469968)
print v(xbgr.mr_n68470400)
print v(xbgr.mr_n68470832)
print v(xbgr.mr_n68471264)
print v(xbgr.mr_n68471696)
print v(xbgr.mr_n68472128)
print v(xbgr.mr_n68472560)
print v(xbgr.mr_n68472992)
print v(xbgr.mr_n68473424)
print v(xbgr.mr_n68473856)
print v(xbgr.mr_n68474288)
print v(xbgr.mr_n68474720)
print v(xbgr.mr_n68475152)
print v(xbgr.mr_n68475584)
print v(xbgr.mr_n68476016)
print v(xbgr.mr_n68476448)
print v(xbgr.mr_n68476880)
print v(xbgr.mr_n68477312)
print v(xbgr.mr_n68477744)
print v(xbgr.mr_n68478176)
print v(xbgr.mr_n68478608)
print v(xbgr.mr_n68479040)
print v(xbgr.mr_n68479472)
print v(xbgr.mr_n68479904)
print v(xbgr.mr_n68480336)
print v(xbgr.mr_n68480768)
print v(xbgr.mr_n68481200)
print v(xbgr.mr_n68481632)
print v(xbgr.mr_n68482064)
print v(xbgr.mr_n68482496)
print v(xbgr.mr_n68482928)
print v(xbgr.mr_n68483360)
print v(xbgr.mr_n68483792)
print v(xbgr.mr_n68484224)
print v(xbgr.mr_n68484656)
print v(xbgr.mr_n68485088)
print v(xbgr.mr_n68485520)
print v(xbgr.mr_n68485952)
print v(xbgr.mr_n68486384)
print v(xbgr.mr_n68486816)
print v(xbgr.mr_n68487248)
print v(xbgr.mr_n68487680)
print v(xbgr.mr_n68488112)
print v(xbgr.mr_n68488544)
print v(xbgr.mr_n68488976)
print v(xbgr.mr_n68489408)
print v(xbgr.mr_n68489840)
print v(xbgr.mr_n68490272)
print v(xbgr.mr_n68490704)
print v(xbgr.mr_n68491136)
print v(xbgr.mr_n68491568)
print v(xbgr.mr_n68492000)
print v(xbgr.mr_n68492432)
print v(xbgr.mr_n68492864)
print v(xbgr.mr_n68493296)
print v(xbgr.mr_n68493728)
print v(xbgr.mr_n68494160)
print v(xbgr.mr_n68494592)
print v(xbgr.mr_n68495024)
print v(xbgr.mr_n68495456)
print v(xbgr.mr_n68495888)
print v(xbgr.mr_n68496320)
print v(xbgr.mr_n68496752)
print v(xbgr.mr_n68497184)
print v(xbgr.mr_n68497616)
print v(xbgr.mr_n68498048)
print v(xbgr.mr_n68498368)
print v(xbgr.mr_n68498480)
print v(xbgr.mr_n68498800)
print v(xbgr.mr_n68498912)
print v(xbgr.mr_n68499232)
print v(xbgr.mr_n68499344)
print v(xbgr.mr_n68499664)
print v(xbgr.mr_n68499776)
print v(xbgr.mr_n68500096)
print v(xbgr.mr_n68500208)
print v(xbgr.mr_n68500528)
print v(xbgr.mr_n68500640)
print v(xbgr.mr_n68500960)
print v(xbgr.mr_n68501072)
print v(xbgr.mr_n68501392)
print v(xbgr.mr_n68501504)
print v(xbgr.mr_n68501824)
print v(xbgr.mr_n68501936)
print v(xbgr.mr_n68502256)
print v(xbgr.mr_n68502368)
print v(xbgr.mr_n68502688)
print v(xbgr.mr_n68502800)
print v(xbgr.mr_n68503120)
print v(xbgr.mr_n68503232)
print v(xbgr.mr_n68503552)
print v(xbgr.mr_n68503664)
print v(xbgr.mr_n68503984)
print v(xbgr.mr_n68504096)
print v(xbgr.mr_n68504416)
print v(xbgr.mr_n68504528)
print v(xbgr.mr_n68504848)
print v(xbgr.mr_n68504960)
print v(xbgr.mr_n68505280)
print v(xbgr.mr_n68505392)
print v(xbgr.mr_n68505712)
print v(xbgr.mr_n68505824)
print v(xbgr.mr_n68506144)
print v(xbgr.mr_n68506256)
print v(xbgr.mr_n68506576)
print v(xbgr.mr_n68506688)
print v(xbgr.mr_n68507008)
print v(xbgr.mr_n68507120)
print v(xbgr.mr_n68507440)
print v(xbgr.mr_n68507552)
print v(xbgr.mr_n68507872)
print v(xbgr.mr_n68507984)
print v(xbgr.mr_n68508304)
print v(xbgr.mr_n68508416)
print v(xbgr.mr_n68508736)
print v(xbgr.mr_n68508848)
print v(xbgr.mr_n68509168)
print v(xbgr.mr_n68509280)
print v(xbgr.mr_n68509600)
print v(xbgr.mr_n68509712)
print v(xbgr.mr_n68510032)
print v(xbgr.mr_n68510144)
print v(xbgr.mr_n68510464)
print v(xbgr.mr_n68510576)
print v(xbgr.mr_n68510896)
print v(xbgr.mr_n68511008)
print v(xbgr.mr_n68511328)
print v(xbgr.mr_n68511440)
print v(xbgr.mr_n68511760)
print v(xbgr.mr_n68511872)
print v(xbgr.mr_n68512192)
print v(xbgr.mr_n68512304)
print v(xbgr.mr_n68512624)
print v(xbgr.mr_n68512736)
print v(xbgr.mr_n68513056)
print v(xbgr.mr_n68513168)
print v(xbgr.mr_n68513488)
print v(xbgr.mr_n68513600)
print v(xbgr.mr_n68513920)
print v(xbgr.mr_n68514032)
print v(xbgr.mr_n68514352)
print v(xbgr.mr_n68514464)
print v(xbgr.mr_n68514784)
print v(xbgr.mr_n68514896)
print v(xbgr.mr_n68515216)
print v(xbgr.mr_n68515328)
print v(xbgr.mr_n68515648)
print v(xbgr.mr_n68515760)
print v(xbgr.mr_n68516080)
print v(xbgr.mr_n68516192)
print v(xbgr.mr_n68516512)
print v(xbgr.mr_n68516624)
print v(xbgr.mr_n68516944)
print v(xbgr.mr_n68517056)
print v(xbgr.mr_n68517376)
print v(xbgr.mr_n68517488)
print v(xbgr.mr_n68517808)
print v(xbgr.mr_n68517920)
print v(xbgr.mr_n68518240)
print v(xbgr.mr_n68518352)
print v(xbgr.mr_n68518672)
print v(xbgr.mr_n68518784)
print v(xbgr.mr_n68519104)
print v(xbgr.mr_n68519216)
print v(xbgr.mr_n68519536)
print v(xbgr.mr_n68519648)
print v(xbgr.mr_n68520080)
print v(xbgr.mr_n68520400)
print v(xbgr.mr_n68520512)
print v(xbgr.mr_n68520832)
print v(xbgr.mr_n68520944)
print v(xbgr.mr_n68521264)
print v(xbgr.mr_n68521376)
print v(xbgr.mr_n68521696)
print v(xbgr.mr_n68521808)
print v(xbgr.mr_n68522128)
print v(xbgr.mr_n68522240)
print v(xbgr.mr_n68522560)
print v(xbgr.mr_n68522672)
print v(xbgr.mr_n68522992)
print v(xbgr.mr_n68523104)
print v(xbgr.mr_n68523424)
print v(xbgr.mr_n68523536)
print v(xbgr.mr_n68523856)
print v(xbgr.mr_n68523968)
print v(xbgr.mr_n68524288)
print v(xbgr.mr_n68524400)
print v(xbgr.mr_n68524720)
print v(xbgr.mr_n68524832)
print v(xbgr.mr_n68525152)
print v(xbgr.mr_n68525264)
print v(xbgr.mr_n68525584)
print v(xbgr.mr_n68525696)
print v(xbgr.mr_n68526016)
print v(xbgr.mr_n68526128)
print v(xbgr.mr_n68526448)
print v(xbgr.mr_n68526560)
print v(xbgr.mr_n68526880)
print v(xbgr.mr_n68526992)
print v(xbgr.mr_n68527440)
print v(xbgr.mr_n68527552)
print v(xbgr.mr_n68527872)
print v(xbgr.mr_n68527984)
print v(xbgr.mr_n68528304)
print v(xbgr.mr_n68528416)
print v(xbgr.mr_n68528736)
print v(xbgr.mr_n68528848)
print v(xbgr.mr_n68529168)
print v(xbgr.mr_n68529280)
print v(xbgr.mr_n68529600)
print v(xbgr.mr_n68529712)
print v(xbgr.mr_n68530032)
print v(xbgr.mr_n68530144)
print v(xbgr.mr_n68530464)
print v(xbgr.mr_n68530576)
print v(xbgr.mr_n68530896)
print v(xbgr.mr_n68531008)
print v(xbgr.mr_n68531328)
print v(xbgr.mr_n68531440)
print v(xbgr.mr_n68531760)
print v(xbgr.mr_n68531872)
print v(xbgr.mr_n68532192)
print v(xbgr.mr_n68532304)
print v(xbgr.mr_n68532624)
print v(xbgr.mr_n68532736)
print v(xbgr.mr_n68533056)
print v(xbgr.mr_n68533168)
print v(xbgr.mr_n68533488)
print v(xbgr.mr_n68533600)
print v(xbgr.mr_n68533920)
print v(xbgr.mr_n68534032)
print v(xbgr.mr_n68534464)
print v(xbgr.mr_n68534896)
print v(xbgr.mr_n68535216)
print v(xbgr.mr_n68535328)
print v(xbgr.mr_n68535648)
print v(xbgr.mr_n68535760)
print v(xbgr.mr_n68536080)
print v(xbgr.mr_n68536192)
print v(xbgr.mr_n68536512)
print v(xbgr.mr_n68536624)
print v(xbgr.mr_n68536944)
print v(xbgr.mr_n68537056)
print v(xbgr.mr_n68537376)
print v(xbgr.mr_n68537488)
print v(xbgr.mr_n68537920)
print v(xbgr.mr_n68538240)
print v(xbgr.mr_n68538352)
print v(xbgr.mr_n68538672)
print v(xbgr.mr_n68538784)
print v(xbgr.mr_n68539104)
print v(xbgr.mr_n68539216)
print v(xbgr.mr_n68539536)
print v(xbgr.mr_n68539648)
print v(xbgr.mr_n68539968)
print v(xbgr.mr_n68540080)
print v(xbgr.mr_n68540400)
print v(xbgr.mr_n68540512)
print v(xbgr.mr_n68540832)
print v(xbgr.mr_n68540944)
print v(xbgr.mr_n68541264)
print v(xbgr.mr_n68541376)
print v(xbgr.mr_n68541696)
print v(xbgr.mr_n68541808)
print v(xbgr.mr_n68542128)
print v(xbgr.mr_n68542240)
print v(xbgr.mr_n68542560)
print v(xbgr.mr_n68542672)
print v(xbgr.mr_n68542992)
print v(xbgr.mr_n68543104)
print v(xbgr.mr_n68543536)
print v(xbgr.mr_n68543968)
print v(xbgr.mr_n68544400)
print v(xbgr.mr_n68544832)
print v(xbgr.mr_n68545360)
print v(xbgr.mr_n68545472)
print v(xbgr.mr_n68545808)
print v(xbgr.mr_n68545920)
print v(xbgr.mr_n68546240)
print v(xbgr.mr_n68546352)
print v(xbgr.mr_n68546720)
print v(xbgr.mr_n68546832)
print v(xbgr.mr_n68547152)
print v(xbgr.mr_n68547264)
print v(xbgr.mr_n68547584)
print v(xbgr.mr_n68547696)
print v(xbgr.mr_n68547936)
print v(xbgr.mr_n68548048)
print v(xbgr.mr_n68548368)
print v(xbgr.mr_n68548480)
print v(xbgr.mr_n68548800)
print v(xbgr.mr_n68548912)
print v(xbgr.mr_n68549232)
print v(xbgr.mr_n68549344)
print v(xbgr.mr_n68549664)
print v(xbgr.mr_n68549776)
print v(xbgr.mr_n68550096)
print v(xbgr.mr_n68550208)
print v(xbgr.mr_n68550528)
print v(xbgr.mr_n68550640)
print v(xbgr.mr_n68550960)
print v(xbgr.mr_n68551072)
print v(xbgr.mr_n68551392)
print v(xbgr.mr_n68551504)
print v(xbgr.mr_n68551824)
print v(xbgr.mr_n68551936)
print v(xbgr.mr_n68552256)
print v(xbgr.mr_n68552368)
print v(xbgr.mr_n68552688)
print v(xbgr.mr_n68552800)
print v(xbgr.mr_n68553120)
print v(xbgr.mr_n68553232)
print v(xbgr.mr_n68553552)
print v(xbgr.mr_n68553664)
print v(xbgr.mr_n68553984)
print v(xbgr.mr_n68554096)
print v(xbgr.mr_n68554416)
print v(xbgr.mr_n68554528)
print v(xbgr.mr_n68554848)
print v(xbgr.mr_n68554960)
print v(xbgr.mr_n68555280)
print v(xbgr.mr_n68555392)
print v(xbgr.mr_n68555712)
print v(xbgr.mr_n68555824)
print v(xbgr.mr_n68556144)
print v(xbgr.mr_n68556256)
print v(xbgr.mr_n68556576)
print v(xbgr.mr_n68556688)
print v(xbgr.mr_n68557008)
print v(xbgr.mr_n68557120)
print v(xbgr.mr_n68557440)
print v(xbgr.mr_n68557552)
print v(xbgr.mr_n68557872)
print v(xbgr.mr_n68557984)
print v(xbgr.mr_n68558304)
print v(xbgr.mr_n68558416)
print v(xbgr.mr_n68558848)
print v(xbgr.mr_n68559168)
print v(xbgr.mr_n68560128)
print v(xbgr.mr_n68560240)
print v(xbgr.mr_n68560560)
print v(xbgr.mr_n68560672)
print v(xbgr.mr_n68560992)
print v(xbgr.mr_n68561104)
print v(xbgr.mr_n68561536)
print v(xbgr.mr_n68561856)
print v(xbgr.mr_n68561968)
print v(xbgr.mr_n68562288)
print v(xbgr.mr_n68562400)
print v(xbgr.mr_n68562720)
print v(xbgr.mr_n68562832)
print v(xbgr.mr_n68563152)
print v(xbgr.mr_n68563264)
print v(xbgr.mr_n68563584)
print v(xbgr.mr_n68563696)
print v(xbgr.mr_n68564128)
print v(xbgr.mr_n68564560)
print v(xbgr.mr_n68564992)
print v(xbgr.mr_n68565424)
print v(xbgr.mr_n68565744)
print v(xbgr.mr_n68565856)
print v(xbgr.mr_n68566176)
print v(xbgr.mr_n68566288)
print v(xbgr.mr_n68566608)
print v(xbgr.mr_n68566720)
print v(xbgr.mr_n68567152)
print v(xbgr.mr_n68567584)
print v(xbgr.mr_n68567904)
print v(xbgr.mr_n68568016)
print v(xbgr.mr_n68568336)
print v(xbgr.mr_n68568448)
print v(xbgr.mr_n68568768)
print v(xbgr.mr_n68568880)
print v(xbgr.mr_n68569200)
print v(xbgr.mr_n68569312)
print v(xbgr.mr_n68569744)
print v(xbgr.mr_n68570176)
print v(xbgr.mr_n68570608)
print v(xbgr.mr_n68571040)
print v(xbgr.mr_n68571472)
print v(xbgr.mr_n68571792)
print v(xbgr.mr_n68571904)
print v(xbgr.mr_n68572224)
print v(xbgr.mr_n68572336)
print v(xbgr.mr_n68572656)
print v(xbgr.mr_n68572768)
print v(xbgr.mr_n68573088)
print v(xbgr.mr_n68573200)
print v(xbgr.mr_n68573520)
print v(xbgr.mr_n68573632)
print v(xbgr.mr_n68573952)
print v(xbgr.mr_n68574064)
print v(xbgr.mr_n68574384)
print v(xbgr.mr_n68574496)
print v(xbgr.mr_n68574816)
print v(xbgr.mr_n68574928)
print v(xbgr.mr_n68575248)
print v(xbgr.mr_n68575360)
print v(xbgr.mr_n68575680)
print v(xbgr.mr_n68575792)
print v(xbgr.mr_n68576112)
print v(xbgr.mr_n68576224)
print v(xbgr.mr_n68576544)
print v(xbgr.mr_n68576656)
print v(xbgr.mr_n68577088)
print v(xbgr.mr_n68577408)
print v(xbgr.mr_n68577520)
print v(xbgr.mr_n68577840)
print v(xbgr.mr_n68577952)
print v(xbgr.mr_n68578272)
print v(xbgr.mr_n68578384)
print v(xbgr.mr_n68578704)
print v(xbgr.mr_n68578816)
print v(xbgr.mr_n68579136)
print v(xbgr.mr_n68579248)
print v(xbgr.mr_n68579680)
print v(xbgr.mr_n68580112)
print v(xbgr.mr_n68580544)
print v(xbgr.mr_n68580976)
print v(xbgr.mr_n68581296)
print v(xbgr.mr_n68581408)
print v(xbgr.mr_n68581728)
print v(xbgr.mr_n68581840)
print v(xbgr.mr_n68582160)
print v(xbgr.mr_n68582272)
print v(xbgr.mr_n68582592)
print v(xbgr.mr_n68582704)
print v(xbgr.mr_n68583024)
print v(xbgr.mr_n68583136)
print v(xbgr.mr_n68583456)
print v(xbgr.mr_n68583568)
print v(xbgr.mr_n68583888)
print v(xbgr.mr_n68584000)
print v(xbgr.mr_n68584320)
print v(xbgr.mr_n68584432)
print v(xbgr.mr_n68584752)
print v(xbgr.mr_n68584864)
print v(xbgr.mr_n68585184)
print v(xbgr.mr_n68585296)
print v(xbgr.mr_n68585616)
print v(xbgr.mr_n68585728)
print v(xbgr.mr_n68586048)
print v(xbgr.mr_n68586160)
print v(xbgr.mr_n68586480)
print v(xbgr.mr_n68586592)
print v(xbgr.mr_n68586912)
print v(xbgr.mr_n68587024)
print v(xbgr.mr_n68587344)
print v(xbgr.mr_n68587456)
print v(xbgr.mr_n68587776)
print v(xbgr.mr_n68587888)
print v(xbgr.mr_n68588208)
print v(xbgr.mr_n68588320)
print v(xbgr.mr_n68588640)
print v(xbgr.mr_n68588752)
print v(xbgr.mr_n68589072)
print v(xbgr.mr_n68589184)
print v(xbgr.mr_n68589504)
print v(xbgr.mr_n68589616)
print v(xbgr.mr_n68589936)
print v(xbgr.mr_n68590048)
print v(xbgr.mr_n68590368)
print v(xbgr.mr_n68590480)
print v(xbgr.mr_n68590800)
print v(xbgr.mr_n68590912)
print v(xbgr.mr_n68591232)
print v(xbgr.mr_n68591344)
print v(xbgr.mr_n68591664)
print v(xbgr.mr_n68591776)
print v(xbgr.mr_n68592096)
print v(xbgr.mr_n68592208)
print v(xbgr.mr_n68592528)
print v(xbgr.mr_n68592640)
print v(xbgr.mr_n68592960)
print v(xbgr.mr_n68593072)
print v(xbgr.mr_n68593392)
print v(xbgr.mr_n68593504)
print v(xbgr.mr_n68593824)
print v(xbgr.mr_n68593936)
print v(xbgr.mr_n68594256)
print v(xbgr.mr_n68594368)
print v(xbgr.mr_n68594688)
print v(xbgr.mr_n68594800)
print v(xbgr.mr_n68595120)
print v(xbgr.mr_n68595232)
print v(xbgr.mr_n68595552)
print v(xbgr.mr_n68595664)
print v(xbgr.mr_n68595984)
print v(xbgr.mr_n68596096)
print v(xbgr.mr_n68596416)
print v(xbgr.mr_n68596528)
print v(xbgr.mr_n68596848)
print v(xbgr.mr_n68596960)
print v(xbgr.mr_n68597280)
print v(xbgr.mr_n68597392)
print v(xbgr.mr_n68597712)
print v(xbgr.mr_n68597824)
print v(xbgr.mr_n68598144)
print v(xbgr.mr_n68598256)
print v(xbgr.mr_n68598576)
print v(xbgr.mr_n68598688)
print v(xbgr.mr_n68599008)
print v(xbgr.mr_n68599120)
print v(xbgr.mr_n68599440)
print v(xbgr.mr_n68599552)
print v(xbgr.mr_n68599872)
print v(xbgr.mr_n68599984)
print v(xbgr.mr_n68600416)
print v(xbgr.mr_n68600848)
print v(xbgr.mr_n68601168)
print v(xbgr.mr_n68601280)
print v(xbgr.mr_n68601600)
print v(xbgr.mr_n68601712)
print v(xbgr.mr_n68602032)
print v(xbgr.mr_n68602144)
print v(xbgr.mr_n68602464)
print v(xbgr.mr_n68602576)
print v(xbgr.mr_n68603008)
print v(xbgr.mr_n68603440)
print v(xbgr.mr_n68603760)
print v(xbgr.mr_n68603872)
print v(xbgr.mr_n68604192)
print v(xbgr.mr_n68604304)
print v(xbgr.mr_n68604624)
print v(xbgr.mr_n68604736)
print v(xbgr.mr_n68605056)
print v(xbgr.mr_n68605168)
print v(xbgr.mr_n68605600)
print v(xbgr.mr_n68606032)
print v(xbgr.mr_n68606464)
print v(xbgr.mr_n68606896)
print v(xbgr.mr_n68607328)
print v(xbgr.mr_n68607760)
print v(xbgr.mr_n68608192)
print v(xbgr.mr_n68608624)
print v(xbgr.mr_n68609056)
print v(xbgr.mr_n68609488)
print v(xbgr.mr_n68609920)
print v(xbgr.mr_n68610352)
print v(xbgr.mr_n68610672)
print v(xbgr.mr_n68611104)
print v(xbgr.mr_n68611536)
print v(xbgr.mr_n68611968)
print v(xbgr.mr_n68612400)
print v(xbgr.mr_n68612832)
print v(xbgr.mr_n68613264)
print v(xbgr.mr_n68613696)
print v(xbgr.mr_n68614128)
print v(xbgr.mr_n68614240)
print v(xbgr.mr_n68614560)
print v(xbgr.mr_n68614672)
print v(xbgr.mr_n68614992)
print v(xbgr.mr_n68615104)
print v(xbgr.mr_n68615424)
print v(xbgr.mr_n68615536)
print v(xbgr.mr_n68615856)
print v(xbgr.mr_n68615968)
print v(xbgr.mr_n68616288)
print v(xbgr.mr_n68616400)
print v(xbgr.mr_n68616720)
print v(xbgr.mr_n68616832)
print v(xbgr.mr_n68617152)
print v(xbgr.mr_n68617264)
print v(xbgr.mr_n68617584)
print v(xbgr.mr_n68618016)
print v(xbgr.mr_n68618448)
print v(xbgr.mr_n68618880)
print v(xbgr.mr_n68619312)
print v(xbgr.mr_n68619744)
print v(xbgr.mr_n68620176)
print v(xbgr.mr_n68620608)
print v(xbgr.mr_n68621040)
print v(xbgr.mr_n68621472)
print v(xbgr.mr_n68622016)
print v(xbgr.mr_n68622448)
print v(xbgr.mr_n68622880)
print v(xbgr.mr_n68623312)
print v(xbgr.mr_n68623744)
print v(xbgr.mr_n68624176)
print v(xbgr.mr_n68624608)
print v(xbgr.mr_n68625040)
print v(xbgr.mr_n68625472)
print v(xbgr.mr_n68625904)
print v(xbgr.mr_n68626336)
print v(xbgr.mr_n68626768)
print v(xbgr.mr_n68627200)
print v(xbgr.mr_n68627632)
print v(xbgr.mr_n68628064)
print v(xbgr.mr_n68628496)
print v(xbgr.mr_n68628928)
print v(xbgr.mr_n68629360)
print v(xbgr.mr_n68629792)
print v(xbgr.mr_n68630224)
print v(xbgr.mr_n68630656)
print v(xbgr.mr_n68631088)
print v(xbgr.mr_n68631520)
print v(xbgr.mr_n68631952)
print v(xbgr.mr_n68632384)
print v(xbgr.mr_n68632816)
print v(xbgr.mr_n68633248)
print v(xbgr.mr_n68633680)
print v(xbgr.mr_n68634112)
print v(xbgr.mr_n68634544)
print v(xbgr.mr_n68634976)
print v(xbgr.mr_n68635408)
print v(xbgr.mr_n68635840)
print v(xbgr.mr_n68636272)
print v(xbgr.mr_n68636704)
print v(xbgr.mr_n68637136)
print v(xbgr.mr_n68637568)
print v(xbgr.mr_n68638000)
print v(xbgr.mr_n68638432)
print v(xbgr.mr_n68638864)
print v(xbgr.mr_n68639296)
print v(xbgr.mr_n68639728)
print v(xbgr.mr_n68640160)
print v(xbgr.mr_n68640592)
print v(xbgr.mr_n68641024)
print v(xbgr.mr_n68641456)
print v(xbgr.mr_n68641888)
print v(xbgr.mr_n68642320)
print v(xbgr.mr_n68642752)
print v(xbgr.mr_n68643184)
print v(xbgr.mr_n68643616)
print v(xbgr.mr_n68644048)
print v(xbgr.mr_n68644480)
print v(xbgr.mr_n68644912)
print v(xbgr.mr_n68645344)
print v(xbgr.mr_n68645776)
print v(xbgr.mr_n68646208)
print v(xbgr.mr_n68646640)
print v(xbgr.mr_n68647072)
print v(xbgr.mr_n68647504)
print v(xbgr.mr_n68647936)
print v(xbgr.mr_n68648368)
print v(xbgr.mr_n68648800)
print v(xbgr.mr_n68649232)
print v(xbgr.mr_n68649552)
print v(xbgr.mr_n68649984)
print v(xbgr.mr_n68650416)
print v(xbgr.mr_n68650848)
print v(xbgr.mr_n68651280)
print v(xbgr.mr_n68651712)
print v(xbgr.mr_n68652256)
print v(xbgr.mr_n68652688)
print v(xbgr.mr_n68653120)
print v(xbgr.mr_n68653552)
print v(xbgr.mr_n68653984)
print v(xbgr.mr_n68654416)
print v(xbgr.mr_n68654848)
print v(xbgr.mr_n68655280)
print v(xbgr.mr_n68655712)
print v(xbgr.mr_n68656144)
print v(xbgr.mr_n68656576)
print v(xbgr.mr_n68657008)
print v(xbgr.mr_n68657440)
print v(xbgr.mr_n68657872)
print v(xbgr.mr_n68658304)
print v(xbgr.mr_n68658736)
print v(xbgr.mr_n68659168)
print v(xbgr.mr_n68659600)
print v(xbgr.mr_n68660032)
print v(xbgr.mr_n68660464)
print v(xbgr.mr_n68660896)
print v(xbgr.mr_n68661328)
print v(xbgr.mr_n68661760)
print v(xbgr.mr_n68662192)
print v(xbgr.mr_n68662624)
print v(xbgr.mr_n68663056)
print v(xbgr.mr_n68663376)
print v(xbgr.mr_n68663488)
print v(xbgr.mr_n68663808)
print v(xbgr.mr_n68663920)
print v(xbgr.mr_n68664240)
print v(xbgr.mr_n68664352)
print v(xbgr.mr_n68664672)
print v(xbgr.mr_n68664784)
print v(xbgr.mr_n68665104)
print v(xbgr.mr_n68665216)
print v(xbgr.mr_n68665536)
print v(xbgr.mr_n68665648)
print v(xbgr.mr_n68665968)
print v(xbgr.mr_n68666080)
print v(xbgr.mr_n68666400)
print v(xbgr.mr_n68666512)
print v(xbgr.mr_n68666832)
print v(xbgr.mr_n68666944)
print v(xbgr.mr_n68667264)
print v(xbgr.mr_n68667376)
print v(xbgr.mr_n68667696)
print v(xbgr.mr_n68667808)
print v(xbgr.mr_n68668128)
print v(xbgr.mr_n68668240)
print v(xbgr.mr_n68668560)
print v(xbgr.mr_n68668672)
print v(xbgr.mr_n68668992)
print v(xbgr.mr_n68669104)
print v(xbgr.mr_n68669424)
print v(xbgr.mr_n68669536)
print v(xbgr.mr_n68669856)
print v(xbgr.mr_n68670288)
print v(xbgr.mr_n68670400)
print v(xbgr.mr_n68670720)
print v(xbgr.mr_n68671152)
print v(xbgr.mr_n68671264)
print v(xbgr.mr_n68671584)
print v(xbgr.mr_n68671696)
print v(xbgr.mr_n68672016)
print v(xbgr.mr_n68672128)
print v(xbgr.mr_n68672448)
print v(xbgr.mr_n68672560)
print v(xbgr.mr_n68672880)
print v(xbgr.mr_n68672992)
print v(xbgr.mr_n68673312)
print v(xbgr.mr_n68673424)
print v(xbgr.mr_n68673744)
print v(xbgr.mr_n68673856)
print v(xbgr.mr_n68674176)
print v(xbgr.mr_n68674608)
print v(xbgr.mr_n68674720)
print v(xbgr.mr_n68675040)
print v(xbgr.mr_n68675152)
print v(xbgr.mr_n68675472)
print v(xbgr.mr_n68675584)
print v(xbgr.mr_n68675904)
print v(xbgr.mr_n68676336)
print v(xbgr.mr_n68676448)
print v(xbgr.mr_n68676768)
print v(xbgr.mr_n68676880)
print v(xbgr.mr_n68677200)
print v(xbgr.mr_n68677312)
print v(xbgr.mr_n68677632)
print v(xbgr.mr_n68677744)
print v(xbgr.mr_n68678064)
print v(xbgr.mr_n68678176)
print v(xbgr.mr_n68678496)
print v(xbgr.mr_n68678608)
print v(xbgr.mr_n68678928)
print v(xbgr.mr_n68679040)
print v(xbgr.mr_n68679360)
print v(xbgr.mr_n68679792)
print v(xbgr.mr_n68679904)
print v(xbgr.mr_n68680224)
print v(xbgr.mr_n68680336)
print v(xbgr.mr_n68680656)
print v(xbgr.mr_n68680768)
print v(xbgr.mr_n68681088)
print v(xbgr.mr_n68681200)
print v(xbgr.mr_n68681520)
print v(xbgr.mr_n68681632)
print v(xbgr.mr_n68681952)
print v(xbgr.mr_n68682064)
print v(xbgr.mr_n68682384)
print v(xbgr.mr_n68682496)
print v(xbgr.mr_n68682816)
print v(xbgr.mr_n68682928)
print v(xbgr.mr_n68683248)
print v(xbgr.mr_n68683360)
print v(xbgr.mr_n68683680)
print v(xbgr.mr_n68683792)
print v(xbgr.mr_n68684112)
print v(xbgr.mr_n68684224)
print v(xbgr.mr_n68684544)
print v(xbgr.mr_n68684656)
print v(xbgr.mr_n68684976)
print v(xbgr.mr_n68685088)
print v(xbgr.mr_n68685408)
print v(xbgr.mr_n68685840)
print v(xbgr.mr_n68685952)
print v(xbgr.mr_n68686272)
print v(xbgr.mr_n68686384)
print v(xbgr.mr_n68686704)
print v(xbgr.mr_n68686816)
print v(xbgr.mr_n68687136)
print v(xbgr.mr_n68687248)
print v(xbgr.mr_n68687568)
print v(xbgr.mr_n68687680)
print v(xbgr.mr_n68688000)
print v(xbgr.mr_n68688112)
print v(xbgr.mr_n68688432)
print v(xbgr.mr_n68688544)
print v(xbgr.mr_n68688864)
print v(xbgr.mr_n68689296)
print v(xbgr.mr_n68689408)
print v(xbgr.mr_n68689728)
print v(xbgr.mr_n68690160)
print v(xbgr.mr_n68690272)
print v(xbgr.mr_n68690592)
print v(xbgr.mr_n68690704)
print v(xbgr.mr_n68691024)
print v(xbgr.mr_n68691136)
print v(xbgr.mr_n68691456)
print v(xbgr.mr_n68691568)
print v(xbgr.mr_n68691888)
print v(xbgr.mr_n68692000)
print v(xbgr.mr_n68692320)
print v(xbgr.mr_n68692432)
print v(xbgr.mr_n68692752)
print v(xbgr.mr_n68692864)
print v(xbgr.mr_n68693184)
print v(xbgr.mr_n68693296)
print v(xbgr.mr_n68693616)
print v(xbgr.mr_n68693728)
print v(xbgr.mr_n68694048)
print v(xbgr.mr_n68694160)
print v(xbgr.mr_n68694480)
print v(xbgr.mr_n68694592)
print v(xbgr.mr_n68694912)
print v(xbgr.mr_n68695024)
print v(xbgr.mr_n68695456)
print v(xbgr.mr_n68695888)
print v(xbgr.mr_n68696320)
print v(xbgr.mr_n68696752)
print v(xbgr.mr_n68697184)
print v(xbgr.mr_n68697616)
print v(xbgr.mr_n68698048)
print v(xbgr.mr_n68698480)
print v(xbgr.mr_n68698912)
print v(xbgr.mr_n68699344)
print v(xbgr.mr_n68699776)
print v(xbgr.mr_n68700208)
print v(xbgr.mr_n68700640)
print v(xbgr.mr_n68701072)
print v(xbgr.mr_n68701504)
print v(xbgr.mr_n68701936)
print v(xbgr.mr_n68702368)
print v(xbgr.mr_n68702800)
print v(xbgr.mr_n68703232)
print v(xbgr.mr_n68703664)
print v(xbgr.mr_n68704096)
print v(xbgr.mr_n68704528)
print v(xbgr.mr_n68704960)
print v(xbgr.mr_n68705392)
print v(xbgr.mr_n68705824)
print v(xbgr.mr_n68706256)
print v(xbgr.mr_n68706688)
print v(xbgr.mr_n68707120)
print v(xbgr.mr_n68707552)
print v(xbgr.mr_n68707984)
print v(xbgr.mr_n68708416)
print v(xbgr.mr_n68708848)
print v(xbgr.mr_n68709280)
print v(xbgr.mr_n68709712)
print v(xbgr.mr_n68710144)
print v(xbgr.mr_n68710576)
print v(xbgr.mr_n68711008)
print v(xbgr.mr_n68711440)
print v(xbgr.mr_n68711872)
print v(xbgr.mr_n68712304)
print v(xbgr.mr_n68712736)
print v(xbgr.mr_n68713168)
print v(xbgr.mr_n68713600)
print v(xbgr.mr_n68714032)
print v(xbgr.mr_n68714464)
print v(xbgr.mr_n68714896)
print v(xbgr.mr_n68715328)
print v(xbgr.mr_n68715760)
print v(xbgr.mr_n68716192)
print v(xbgr.mr_n68716624)
print v(xbgr.mr_n68717056)
print v(xbgr.mr_n68717488)
print v(xbgr.mr_n68717920)
print v(xbgr.mr_n68718352)
print v(xbgr.mr_n68718784)
print v(xbgr.mr_n68719216)
print v(xbgr.mr_n68719648)
print v(xbgr.mr_n68720080)
print v(xbgr.mr_n68720512)
print v(xbgr.mr_n68720944)
print v(xbgr.mr_n68721376)
print v(xbgr.mr_n68721808)
print v(xbgr.mr_n68722240)
print v(xbgr.mr_n68722672)
print v(xbgr.mr_n68723104)
print v(xbgr.mr_n68723536)
print v(xbgr.mr_n68723968)
print v(xbgr.mr_n68724400)
print v(xbgr.mr_n68724832)
print v(xbgr.mr_n68725264)
print v(xbgr.mr_n68725696)
print v(xbgr.mr_n68726128)
print v(xbgr.mr_n68726560)
print v(xbgr.mr_n68726992)
print v(xbgr.mr_n68727424)
print v(xbgr.mr_n68727856)
print v(xbgr.mr_n68728288)
print v(xbgr.mr_n68728720)
print v(xbgr.mr_n68729040)
print v(xbgr.mr_n68729152)
print v(xbgr.mr_n68729472)
print v(xbgr.mr_n68729584)
print v(xbgr.mr_n68730016)
print v(xbgr.mr_n68730448)
print v(xbgr.mr_n68730768)
print v(xbgr.mr_n68730880)
print v(xbgr.mr_n68731200)
print v(xbgr.mr_n68731744)
print v(xbgr.mr_n68732176)
print v(xbgr.mr_n68732496)
print v(xbgr.mr_n68732608)
print v(xbgr.mr_n68732928)
print v(xbgr.mr_n68733040)
print v(xbgr.mr_n68733360)
print v(xbgr.mr_n68733472)
print v(xbgr.mr_n68733792)
print v(xbgr.mr_n68733904)
print v(xbgr.mr_n68734224)
print v(xbgr.mr_n68734336)
print v(xbgr.mr_n68734656)
print v(xbgr.mr_n68734768)
print v(xbgr.mr_n68735088)
print v(xbgr.mr_n68735200)
print v(xbgr.mr_n68735520)
print v(xbgr.mr_n68735632)
print v(xbgr.mr_n68735952)
print v(xbgr.mr_n68736064)
print v(xbgr.mr_n68736384)
print v(xbgr.mr_n68736496)
print v(xbgr.mr_n68736816)
print v(xbgr.mr_n68736928)
print v(xbgr.mr_n68737248)
print v(xbgr.mr_n68737360)
print v(xbgr.mr_n68737792)
print v(xbgr.mr_n68738224)
print v(xbgr.mr_n68738544)
print v(xbgr.mr_n68738656)
print v(xbgr.mr_n68738976)
print v(xbgr.mr_n68739088)
print v(xbgr.mr_n68739520)
print v(xbgr.mr_n68739952)
print v(xbgr.mr_n68740384)
print v(xbgr.mr_n68740816)
print v(xbgr.mr_n68741248)
print v(xbgr.mr_n68741680)
print v(xbgr.mr_n68742112)
print v(xbgr.mr_n68742544)
print v(xbgr.mr_n68742976)
print v(xbgr.mr_n68743408)
print v(xbgr.mr_n68743840)
print v(xbgr.mr_n68744272)
print v(xbgr.mr_n68744704)
print v(xbgr.mr_n68745136)
print v(xbgr.mr_n68745568)
print v(xbgr.mr_n68746000)
print v(xbgr.mr_n68746432)
print v(xbgr.mr_n68746864)
print v(xbgr.mr_n68747296)
print v(xbgr.mr_n68747728)
print v(xbgr.mr_n68748160)
print v(xbgr.mr_n68748592)
print v(xbgr.mr_n68749024)
print v(xbgr.mr_n68749456)
print v(xbgr.mr_n68749888)
print v(xbgr.mr_n68750320)
print v(xbgr.mr_n68750752)
print v(xbgr.mr_n68751184)
print v(xbgr.mr_n68751616)
print v(xbgr.mr_n68752048)
print v(xbgr.mr_n68752480)
print v(xbgr.mr_n68752912)
print v(xbgr.mr_n68753344)
print v(xbgr.mr_n68753776)
print v(xbgr.mr_n68754208)
print v(xbgr.mr_n68754640)
print v(xbgr.mr_n68755072)
print v(xbgr.mr_n68755504)
print v(xbgr.mr_n68755936)
print v(xbgr.mr_n68756368)
print v(xbgr.mr_n68756800)
print v(xbgr.mr_n68757232)
print v(xbgr.mr_n68757664)
print v(xbgr.mr_n68758096)
print v(xbgr.mr_n68758528)
print v(xbgr.mr_n68758960)
print v(xbgr.mr_n68759392)
print v(xbgr.mr_n68759824)
print v(xbgr.mr_n68760256)
print v(xbgr.mr_n68760688)
print v(xbgr.mr_n68761120)
print v(xbgr.mr_n68761552)
print v(xbgr.mr_n68761984)
print v(xbgr.mr_n68762416)
print v(xbgr.mr_n68762848)
print v(xbgr.mr_n68763280)
print v(xbgr.mr_n68763712)
print v(xbgr.mr_n68764144)
print v(xbgr.mr_n68764576)
print v(xbgr.mr_n68765008)
print v(xbgr.mr_n68765440)
print v(xbgr.mr_n68765872)
print v(xbgr.mr_n68766304)
print v(xbgr.mr_n68766736)
print v(xbgr.mr_n68767168)
print v(xbgr.mr_n68767600)
print v(xbgr.mr_n68768032)
print v(xbgr.mr_n68768464)
print v(xbgr.mr_n68768896)
print v(xbgr.mr_n68769328)
print v(xbgr.mr_n68769760)
print v(xbgr.mr_n68770192)
print v(xbgr.mr_n68770624)
print v(xbgr.mr_n68771056)
print v(xbgr.mr_n68771488)
print v(xbgr.mr_n68771920)
print v(xbgr.mr_n68772352)
print v(xbgr.mr_n68772784)
print v(xbgr.mr_n68773216)
print v(xbgr.mr_n68773648)
print v(xbgr.mr_n68774080)
print v(xbgr.mr_n68774512)
print v(xbgr.mr_n68774944)
print v(xbgr.mr_n68775376)
print v(xbgr.mr_n68775808)
print v(xbgr.mr_n68776240)
print v(xbgr.mr_n68776672)
print v(xbgr.mr_n68777104)
print v(xbgr.mr_n68777536)
print v(xbgr.mr_n68777968)
print v(xbgr.mr_n68778400)
print v(xbgr.mr_n68778832)
print v(xbgr.mr_n68779264)
print v(xbgr.mr_n68779696)
print v(xbgr.mr_n68780128)
print v(xbgr.mr_n68780560)
print v(xbgr.mr_n68780992)
print v(xbgr.mr_n68781424)
print v(xbgr.mr_n68781856)
print v(xbgr.mr_n68782288)
print v(xbgr.mr_n68782720)
print v(xbgr.mr_n68783152)
print v(xbgr.mr_n68783584)
print v(xbgr.mr_n68784016)
print v(xbgr.mr_n68784448)
print v(xbgr.mr_n68784880)
print v(xbgr.mr_n68785312)
print v(xbgr.mr_n68785744)
print v(xbgr.mr_n68786176)
print v(xbgr.mr_n68786608)
print v(xbgr.mr_n68787040)
print v(xbgr.mr_n68787472)
print v(xbgr.mr_n68787904)
print v(xbgr.mr_n68788336)
print v(xbgr.mr_n68788768)
print v(xbgr.mr_n68789200)
print v(xbgr.mr_n68789632)
print v(xbgr.mr_n68790064)
print v(xbgr.mr_n68790496)
print v(xbgr.mr_n68790928)
print v(xbgr.mr_n68791360)
print v(xbgr.mr_n68791792)
print v(xbgr.mr_n68792224)
print v(xbgr.mr_n68792656)
print v(xbgr.mr_n68793088)
print v(xbgr.mr_n68793520)
print v(xbgr.mr_n68793952)
print v(xbgr.mr_n68794384)
print v(xbgr.mr_n68794816)
print v(xbgr.mr_n68795248)
print v(xbgr.mr_n68795680)
print v(xbgr.mr_n68796112)
print v(xbgr.mr_n68796544)
print v(xbgr.mr_n68796976)
print v(xbgr.mr_n68797408)
print v(xbgr.mr_n68797840)
print v(xbgr.mr_n68798160)
print v(xbgr.mr_n68798272)
print v(xbgr.mr_n68798592)
print v(xbgr.mr_n68798704)
print v(xbgr.mr_n68799024)
print v(xbgr.mr_n68799136)
print v(xbgr.mr_n68799456)
print v(xbgr.mr_n68799568)
print v(xbgr.mr_n68799888)
print v(xbgr.mr_n68800000)
print v(xbgr.mr_n68800320)
print v(xbgr.mr_n68800432)
print v(xbgr.mr_n68800752)
print v(xbgr.mr_n68800864)
print v(xbgr.mr_n68801184)
print v(xbgr.mr_n68801296)
print v(xbgr.mr_n68801616)
print v(xbgr.mr_n68801728)
print v(xbgr.mr_n68802048)
print v(xbgr.mr_n68802160)
print v(xbgr.mr_n68802480)
print v(xbgr.mr_n68802592)
print v(xbgr.mr_n68802912)
print v(xbgr.mr_n68803024)
print v(xbgr.mr_n68803344)
print v(xbgr.mr_n68803456)
print v(xbgr.mr_n68803776)
print v(xbgr.mr_n68803888)
print v(xbgr.mr_n68804208)
print v(xbgr.mr_n68804320)
print v(xbgr.mr_n68804640)
print v(xbgr.mr_n68804752)
print v(xbgr.mr_n68805072)
print v(xbgr.mr_n68805184)
print v(xbgr.mr_n68805504)
print v(xbgr.mr_n68805616)
print v(xbgr.mr_n68805936)
print v(xbgr.mr_n68806048)
print v(xbgr.mr_n68806368)
print v(xbgr.mr_n68806480)
print v(xbgr.mr_n68806800)
print v(xbgr.mr_n68806912)
print v(xbgr.mr_n68807232)
print v(xbgr.mr_n68807344)
print v(xbgr.mr_n68807664)
print v(xbgr.mr_n68807776)
print v(xbgr.mr_n68808096)
print v(xbgr.mr_n68808208)
print v(xbgr.mr_n68808528)
print v(xbgr.mr_n68808640)
print v(xbgr.mr_n68808960)
print v(xbgr.mr_n68809072)
print v(xbgr.mr_n68809392)
print v(xbgr.mr_n68809504)
print v(xbgr.mr_n68809824)
print v(xbgr.mr_n68809936)
print v(xbgr.mr_n68810256)
print v(xbgr.mr_n68810368)
print v(xbgr.mr_n68810688)
print v(xbgr.mr_n68810800)
print v(xbgr.mr_n68811232)
print v(xbgr.mr_n68811664)
print v(xbgr.mr_n68812096)
print v(xbgr.mr_n68812528)
print v(xbgr.mr_n68812848)
print v(xbgr.mr_n68812960)
print v(xbgr.mr_n68813280)
print v(xbgr.mr_n68813392)
print v(xbgr.mr_n68813712)
print v(xbgr.mr_n68813824)
print v(xbgr.mr_n68814144)
print v(xbgr.mr_n68814256)
print v(xbgr.mr_n68814576)
print v(xbgr.mr_n68814688)
print v(xbgr.mr_n68815008)
print v(xbgr.mr_n68815120)
print v(xbgr.mr_n68815552)
print v(xbgr.mr_n68815984)
print v(xbgr.mr_n68816416)
print v(xbgr.mr_n68816736)
print v(xbgr.mr_n68816848)
print v(xbgr.mr_n68817168)
print v(xbgr.mr_n68817280)
print v(xbgr.mr_n68817600)
print v(xbgr.mr_n68817712)
print v(xbgr.mr_n68818032)
print v(xbgr.mr_n68818144)
print v(xbgr.mr_n68818464)
print v(xbgr.mr_n68818576)
print v(xbgr.mr_n68818896)
print v(xbgr.mr_n68819008)
print v(xbgr.mr_n68819328)
print v(xbgr.mr_n68819440)
print v(xbgr.mr_n68819760)
print v(xbgr.mr_n68819872)
print v(xbgr.mr_n68820192)
print v(xbgr.mr_n68820304)
print v(xbgr.mr_n68820624)
print v(xbgr.mr_n68820736)
print v(xbgr.mr_n68821168)
print v(xbgr.mr_n68821600)
print v(xbgr.mr_n68822032)
print v(xbgr.mr_n68822464)
print v(xbgr.mr_n68822896)
print v(xbgr.mr_n68823328)
print v(xbgr.mr_n68823760)
print v(xbgr.mr_n68824192)
print v(xbgr.mr_n68824624)
print v(xbgr.mr_n68825056)
print v(xbgr.mr_n68825488)
print v(xbgr.mr_n68825920)
print v(xbgr.mr_n68826352)
print v(xbgr.mr_n68826672)
print v(xbgr.mr_n68826784)
print v(xbgr.mr_n68827104)
print v(xbgr.mr_n68827216)
print v(xbgr.mr_n68827536)
print v(xbgr.mr_n68827648)
print v(xbgr.mr_n68827968)
print v(xbgr.mr_n68828080)
print v(xbgr.mr_n68828400)
print v(xbgr.mr_n68828512)
print v(xbgr.mr_n68828944)
print v(xbgr.mr_n68829376)
print v(xbgr.mr_n68829808)
print v(xbgr.mr_n68830240)
print v(xbgr.mr_n68830672)
print v(xbgr.mr_n68831104)
print v(xbgr.mr_n68831424)
print v(xbgr.mr_n68831536)
print v(xbgr.mr_n68831856)
print v(xbgr.mr_n68831968)
print v(xbgr.mr_n68832400)
print v(xbgr.mr_n68832832)
print v(xbgr.mr_n68833152)
print v(xbgr.mr_n68833264)
print v(xbgr.mr_n68833584)
print v(xbgr.mr_n68833696)
print v(xbgr.mr_n68834016)
print v(xbgr.mr_n68834128)
print v(xbgr.mr_n68834448)
print v(xbgr.mr_n68834560)
print v(xbgr.mr_n68834880)
print v(xbgr.mr_n68834992)
print v(xbgr.mr_n68835312)
print v(xbgr.mr_n68835424)
print v(xbgr.mr_n68835744)
print v(xbgr.mr_n68835856)
print v(xbgr.mr_n68836176)
print v(xbgr.mr_n68836288)
print v(xbgr.mr_n68836608)
print v(xbgr.mr_n68836720)
print v(xbgr.mr_n68837040)
print v(xbgr.mr_n68837152)
print v(xbgr.mr_n68837472)
print v(xbgr.mr_n68837584)
print v(xbgr.mr_n68837904)
print v(xbgr.mr_n68838016)
print v(xbgr.mr_n68838336)
print v(xbgr.mr_n68838448)
print v(xbgr.mr_n68838768)
print v(xbgr.mr_n68838880)
print v(xbgr.mr_n68839312)
print v(xbgr.mr_n68839744)
print v(xbgr.mr_n68840064)
print v(xbgr.mr_n68840176)
print v(xbgr.mr_n68840496)
print v(xbgr.mr_n68840608)
print v(xbgr.mr_n68840928)
print v(xbgr.mr_n68841040)
print v(xbgr.mr_n68841360)
print v(xbgr.mr_n68841472)
print v(xbgr.mr_n68841792)
print v(xbgr.mr_n68841904)
print v(xbgr.mr_n68842224)
print v(xbgr.mr_n68842336)
print v(xbgr.mr_n68842768)
print v(xbgr.mr_n68843200)
print v(xbgr.mr_n68843520)
print v(xbgr.mr_n68843632)
print v(xbgr.mr_n68843952)
print v(xbgr.mr_n68844064)
print v(xbgr.mr_n68844384)
print v(xbgr.mr_n68844496)
print v(xbgr.mr_n68844816)
print v(xbgr.mr_n68844928)
print v(xbgr.mr_n68845248)
print v(xbgr.mr_n68845360)
print v(xbgr.mr_n68845680)
print v(xbgr.mr_n68845792)
print v(xbgr.mr_n68846112)
print v(xbgr.mr_n68846224)
print v(xbgr.mr_n68846544)
print v(xbgr.mr_n68846656)
print v(xbgr.mr_n68846976)
print v(xbgr.mr_n68847088)
print v(xbgr.mr_n68847408)
print v(xbgr.mr_n68847520)
print v(xbgr.mr_n68847840)
print v(xbgr.mr_n68847952)
print v(xbgr.mr_n68848272)
print v(xbgr.mr_n68848384)
print v(xbgr.mr_n68848704)
print v(xbgr.mr_n68848816)
print v(xbgr.mr_n68849136)
print v(xbgr.mr_n68849248)
print v(xbgr.mr_n68849568)
print v(xbgr.mr_n68849680)
print v(xbgr.mr_n68850000)
print v(xbgr.mr_n68850112)
print v(xbgr.mr_n68850432)
print v(xbgr.mr_n68850544)
print v(xbgr.mr_n68850864)
print v(xbgr.mr_n68850976)
print v(xbgr.mr_n68851296)
print v(xbgr.mr_n68851408)
print v(xbgr.mr_n68851728)
print v(xbgr.mr_n68851840)
print v(xbgr.mr_n68852160)
print v(xbgr.mr_n68852272)
print v(xbgr.mr_n68852592)
print v(xbgr.mr_n68852704)
print v(xbgr.mr_n68853024)
print v(xbgr.mr_n68853136)
print v(xbgr.mr_n68853456)
print v(xbgr.mr_n68853568)
print v(xbgr.mr_n68853888)
print v(xbgr.mr_n68854000)
print v(xbgr.mr_n68854320)
print v(xbgr.mr_n68854432)
print v(xbgr.mr_n68854752)
print v(xbgr.mr_n68854864)
print v(xbgr.mr_n68855184)
print v(xbgr.mr_n68855296)
print v(xbgr.mr_n68855616)
print v(xbgr.mr_n68855728)
print v(xbgr.mr_n68856048)
print v(xbgr.mr_n68856160)
print v(xbgr.mr_n68856480)
print v(xbgr.mr_n68856592)
print v(xbgr.mr_n68856912)
print v(xbgr.mr_n68857024)
print v(xbgr.mr_n68857344)
print v(xbgr.mr_n68857456)
print v(xbgr.mr_n68857776)
print v(xbgr.mr_n68857888)
print v(xbgr.mr_n68858208)
print v(xbgr.mr_n68858320)
print v(xbgr.mr_n68858640)
print v(xbgr.mr_n68858752)
print v(xbgr.mr_n68859072)
print v(xbgr.mr_n68859184)
print v(xbgr.mr_n68859504)
print v(xbgr.mr_n68859616)
print v(xbgr.mr_n68859936)
print v(xbgr.mr_n68860048)
print v(xbgr.mr_n68860368)
print v(xbgr.mr_n68860480)
print v(xbgr.mr_n68860800)
print v(xbgr.mr_n68860912)
print v(xbgr.mr_n68861232)
print v(xbgr.mr_n68861344)
print v(xbgr.mr_n68861664)
print v(xbgr.mr_n68861776)
print v(xbgr.mr_n68862096)
print v(xbgr.mr_n68862208)
print v(xbgr.mr_n68862528)
print v(xbgr.mr_n68862640)
print v(xbgr.mr_n68862960)
print v(xbgr.mr_n68863072)
print v(xbgr.mr_n68863392)
print v(xbgr.mr_n68863504)
print v(xbgr.mr_n68863824)
print v(xbgr.mr_n68863936)
print v(xbgr.mr_n68864256)
print v(xbgr.mr_n68864368)
print v(xbgr.mr_n68864688)
print v(xbgr.mr_n68864800)
print v(xbgr.mr_n68865120)
print v(xbgr.mr_n68865232)
print v(xbgr.mr_n68865552)
print v(xbgr.mr_n68865664)
print v(xbgr.mr_n68865984)
print v(xbgr.mr_n68866096)
print v(xbgr.mr_n68866416)
print v(xbgr.mr_n68866528)
print v(xbgr.mr_n68866848)
print v(xbgr.mr_n68866960)
print v(xbgr.mr_n68867280)
print v(xbgr.mr_n68867392)
print v(xbgr.mr_n68867712)
print v(xbgr.mr_n68867824)
print v(xbgr.mr_n68868144)
print v(xbgr.mr_n68868256)
print v(xbgr.mr_n68868576)
print v(xbgr.mr_n68868688)
print v(xbgr.mr_n68869008)
print v(xbgr.mr_n68869120)
print v(xbgr.mr_n68869440)
print v(xbgr.mr_n68869552)
print v(xbgr.mr_n68869872)
print v(xbgr.mr_n68869984)
print v(xbgr.mr_n68870304)
print v(xbgr.mr_n68870416)
print v(xbgr.mr_n68870736)
print v(xbgr.mr_n68870848)
print v(xbgr.mr_n68871168)
print v(xbgr.mr_n68871280)
print v(xbgr.mr_n68871600)
print v(xbgr.mr_n68871712)
print v(xbgr.mr_n68872032)
print v(xbgr.mr_n68872144)
print v(xbgr.mr_n68872464)
print v(xbgr.mr_n68872576)
print v(xbgr.mr_n68872896)
print v(xbgr.mr_n68873008)
print v(xbgr.mr_n68873328)
print v(xbgr.mr_n68873440)
print v(xbgr.mr_n68873760)
print v(xbgr.mr_n68873872)
print v(xbgr.mr_n68874192)
print v(xbgr.mr_n68874304)
print v(xbgr.mr_n68874624)
print v(xbgr.mr_n68874736)
print v(xbgr.mr_n68875056)
print v(xbgr.mr_n68875168)
print v(xbgr.mr_n68875488)
print v(xbgr.mr_n68875600)
print v(xbgr.mr_n68875920)
print v(xbgr.mr_n68876032)
print v(xbgr.mr_n68876352)
print v(xbgr.mr_n68876464)
print v(xbgr.mr_n68876784)
print v(xbgr.mr_n68876896)
print v(xbgr.mr_n68877216)
print v(xbgr.mr_n68877328)
print v(xbgr.mr_n68877648)
print v(xbgr.mr_n68877760)
print v(xbgr.mr_n68878080)
print v(xbgr.mr_n68878192)
print v(xbgr.mr_n68878512)
print v(xbgr.mr_n68878624)
print v(xbgr.mr_n68878944)
print v(xbgr.mr_n68879056)
print v(xbgr.mr_n68879376)
print v(xbgr.mr_n68879488)
print v(xbgr.mr_n68879808)
print v(xbgr.mr_n68879920)
print v(xbgr.mr_n68880240)
print v(xbgr.mr_n68880352)
print v(xbgr.mr_n68880672)
print v(xbgr.mr_n68880784)
print v(xbgr.mr_n68881104)
print v(xbgr.mr_n68881216)
print v(xbgr.mr_n68881536)
print v(xbgr.mr_n68881648)
print v(xbgr.mr_n68881968)
print v(xbgr.mr_n68882080)
print v(xbgr.mr_n68882400)
print v(xbgr.mr_n68882512)
print v(xbgr.mr_n68882832)
print v(xbgr.mr_n68882944)
print v(xbgr.mr_n68883264)
print v(xbgr.mr_n68883376)
print v(xbgr.mr_n68883696)
print v(xbgr.mr_n68883808)
print v(xbgr.mr_n68884128)
print v(xbgr.mr_n68884240)
print v(xbgr.mr_n68884560)
print v(xbgr.mr_n68884672)
print v(xbgr.mr_n68884992)
print v(xbgr.mr_n68885104)
print v(xbgr.mr_n68885424)
print v(xbgr.mr_n68885536)
print v(xbgr.mr_n68885856)
print v(xbgr.mr_n68885968)
print v(xbgr.mr_n68886288)
print v(xbgr.mr_n68886400)
print v(xbgr.mr_n68886720)
print v(xbgr.mr_n68886832)
print v(xbgr.mr_n68887152)
print v(xbgr.mr_n68887264)
print v(xbgr.mr_n68887584)
print v(xbgr.mr_n68887696)
print v(xbgr.mr_n68888016)
print v(xbgr.mr_n68888128)
print v(xbgr.mr_n68888448)
print v(xbgr.mr_n68888560)
print v(xbgr.mr_n68888880)
print v(xbgr.mr_n68888992)
print v(xbgr.mr_n68889312)
print v(xbgr.mr_n68889424)
print v(xbgr.mr_n68889744)
print v(xbgr.mr_n68889856)
print v(xbgr.mr_n68890176)
print v(xbgr.mr_n68890288)
print v(xbgr.mr_n68890608)
print v(xbgr.mr_n68890720)
print v(xbgr.mr_n68891040)
print v(xbgr.mr_n68891152)
print v(xbgr.mr_n68891472)
print v(xbgr.mr_n68891584)
print v(xbgr.mr_n68891904)
print v(xbgr.mr_n68892016)
print v(xbgr.mr_n68892336)
print v(xbgr.mr_n68892448)
print v(xbgr.mr_n68892768)
print v(xbgr.mr_n68892880)
print v(xbgr.mr_n68893200)
print v(xbgr.mr_n68893312)
print v(xbgr.mr_n68893632)
print v(xbgr.mr_n68893744)
print v(xbgr.mr_n68894176)
print v(xbgr.mr_n68894608)
print v(xbgr.mr_n68895040)
print v(xbgr.mr_n68895472)
print v(xbgr.mr_n68895904)
print v(xbgr.mr_n68896336)
print v(xbgr.mr_n68896768)
print v(xbgr.mr_n68897200)
print v(xbgr.mr_n68897632)
print v(xbgr.mr_n68898064)
print v(xbgr.mr_n68898496)
print v(xbgr.mr_n68898928)
print v(xbgr.mr_n68899360)
print v(xbgr.mr_n68899792)
print v(xbgr.mr_n68900224)
print v(xbgr.mr_n68900656)
print v(xbgr.mr_n68901088)
print v(xbgr.mr_n68901520)
print v(xbgr.mr_n68901952)
print v(xbgr.mr_n68902384)
print v(xbgr.mr_n68902816)
print v(xbgr.mr_n68903248)
print v(xbgr.mr_n68903680)
print v(xbgr.mr_n68904112)
print v(xbgr.mr_n68904544)
print v(xbgr.mr_n68904976)
print v(xbgr.mr_n68905408)
print v(xbgr.mr_n68905840)
print v(xbgr.mr_n68906272)
print v(xbgr.mr_n68906704)
print v(xbgr.mr_n68907136)
print v(xbgr.mr_n68907568)
print v(xbgr.mr_n68908000)
print v(xbgr.mr_n68908432)
print v(xbgr.mr_n68908752)
print v(xbgr.mr_n68908864)
print v(xbgr.mr_n68909184)
print v(xbgr.mr_n68909296)
print v(xbgr.mr_n68909728)
print v(xbgr.mr_n68910048)
print v(xbgr.mr_n68910160)
print v(xbgr.mr_n68910480)
print v(xbgr.mr_n68910592)
print v(xbgr.mr_n68910912)
print v(xbgr.mr_n68911024)
print v(xbgr.mr_n68911344)
print v(xbgr.mr_n68911456)
print v(xbgr.mr_n68911776)
print v(xbgr.mr_n68911888)
print v(xbgr.mr_n68912208)
print v(xbgr.mr_n68912320)
print v(xbgr.mr_n68912640)
print v(xbgr.mr_n68912752)
print v(xbgr.mr_n68913072)
print v(xbgr.mr_n68913184)
print v(xbgr.mr_n68913616)
print v(xbgr.mr_n68914048)
print v(xbgr.mr_n68914480)
print v(xbgr.mr_n68914912)
print v(xbgr.mr_n68915344)
print v(xbgr.mr_n68915776)
print v(xbgr.mr_n68916208)
print v(xbgr.mr_n68916640)
print v(xbgr.mr_n68917072)
print v(xbgr.mr_n68917392)
print v(xbgr.mr_n68917504)
print v(xbgr.mr_n68917824)
print v(xbgr.mr_n68917936)
print v(xbgr.mr_n68918256)
print v(xbgr.mr_n68918368)
print v(xbgr.mr_n68918688)
print v(xbgr.mr_n68918800)
print v(xbgr.mr_n68919232)
print v(xbgr.mr_n68919664)
print v(xbgr.mr_n68920096)
print v(xbgr.mr_n68920528)
print v(xbgr.mr_n68920960)
print v(xbgr.mr_n68921392)
print v(xbgr.mr_n68921824)
print v(xbgr.mr_n68922256)
print v(xbgr.mr_n68922688)
print v(xbgr.mr_n68923120)
print v(xbgr.mr_n68923552)
print v(xbgr.mr_n68923984)
print v(xbgr.mr_n68924416)
print v(xbgr.mr_n68924848)
print v(xbgr.mr_n68925280)
print v(xbgr.mr_n68925712)
print v(xbgr.mr_n68926144)
print v(xbgr.mr_n68926576)
print v(xbgr.mr_n68927008)
print v(xbgr.mr_n68927440)
print v(xbgr.mr_n68927872)
print v(xbgr.mr_n68928304)
print v(xbgr.mr_n68928736)
print v(xbgr.mr_n68929168)
print v(xbgr.mr_n68929600)
print v(xbgr.mr_n68930032)
print v(xbgr.mr_n68930464)
print v(xbgr.mr_n68930896)
print v(xbgr.mr_n68931328)
print v(xbgr.mr_n68931648)
print v(xbgr.mr_n68931760)
print v(xbgr.mr_n68932080)
print v(xbgr.mr_n68932192)
print v(xbgr.mr_n68932512)
print v(xbgr.mr_n68932624)
print v(xbgr.mr_n68932944)
print v(xbgr.mr_n68933056)
print v(xbgr.mr_n68933376)
print v(xbgr.mr_n68933488)
print v(xbgr.mr_n68933808)
print v(xbgr.mr_n68933920)
print v(xbgr.mr_n69196400)
print v(xbgr.mr_n69197200)
print v(xbgr.mr_n69198064)
print v(xbgr.mr_n69198176)
print v(xbgr.mr_n69198496)
print v(xbgr.mr_n69198928)
print v(xbgr.mr_n69199360)
print v(xbgr.mr_n69199792)
print v(xbgr.mr_n69199904)
print v(xbgr.mr_n69200224)
print v(xbgr.mr_n69200656)
print v(xbgr.mr_n69201088)
print v(xbgr.mr_n69201520)
print v(xbgr.mr_n69201632)
print v(xbgr.mr_n69201952)
print v(xbgr.mr_n69202384)
print v(xbgr.mr_n69202816)
print v(xbgr.mr_n69203248)
print v(xbgr.mr_n69203360)
print v(xbgr.mr_n69203680)
print v(xbgr.mr_n69204112)
print v(xbgr.mr_n69204544)
print v(xbgr.mr_n69204976)
print v(xbgr.mr_n69205088)
print v(xbgr.mr_n69205408)
print v(xbgr.mr_n69205520)
print v(xbgr.mr_n69205840)
print v(xbgr.mr_n69205952)
print v(xbgr.mr_n69206384)
print v(xbgr.mr_n69206816)
print v(xbgr.mr_n69207248)
print v(xbgr.mr_n69207568)
print v(xbgr.mr_n69208432)
print v(xbgr.mr_n69208544)
print v(xbgr.mr_n69208864)
print v(xbgr.mr_n69208976)
print v(xbgr.mr_n69209296)
print v(xbgr.mr_n69209408)
print v(xbgr.mr_n69211904)
print v(xbgr.mr_n69212304)
print v(xbgr.mr_n69212624)
print v(xbgr.mr_n69213600)
print v(xbgr.mr_n69213920)
print v(xbgr.mr_n69214896)
print v(xbgr.mr_n69215216)
print v(xbgr.mr_n69216192)
print v(xbgr.mr_n69216512)
print v(xbgr.mr_n69216624)
print v(xbgr.mr_n69217056)
print v(xbgr.mr_n69217488)
print v(xbgr.mr_n69217808)
print v(xbgr.mr_n69218784)
print v(xbgr.mr_n69219104)
print v(xbgr.mr_n69220080)
print v(xbgr.mr_n69220400)
print v(xbgr.mr_n69221376)
print v(xbgr.mr_n69221696)
print v(xbgr.mr_n69221808)
print v(xbgr.mr_n69222128)
print v(xbgr.mr_n69222240)
print v(xbgr.mr_n69222560)
print v(xbgr.mr_n69222992)
print v(xbgr.mr_n69223104)
print v(xbgr.mr_n69223424)
print v(xbgr.mr_n69223856)
print v(xbgr.mr_n69224288)
print v(xbgr.mr_n69225152)
print v(xbgr.mr_n69225264)
print v(xbgr.mr_n69225696)
print v(xbgr.mr_n69226016)
print v(xbgr.mr_n69226560)
print v(xbgr.mr_n69226880)
print v(xbgr.mr_n69227312)
print v(xbgr.mr_n69227744)
print v(xbgr.mr_n69228720)
print v(xbgr.mr_n69229152)
print v(xbgr.mr_n69229584)
print v(xbgr.mr_n69230016)
print v(xbgr.mr_n69230448)
print v(xbgr.mr_n69230880)
print v(xbgr.mr_n69231312)
print v(xbgr.mr_n69231744)
print v(xbgr.mr_n69232176)
print v(xbgr.mr_n69232608)
print v(xbgr.mr_n69233040)
print v(xbgr.mr_n69233472)
print v(xbgr.mr_n69233904)
print v(xbgr.mr_n69234336)
print v(xbgr.mr_n69234768)
print v(xbgr.mr_n69235200)
print v(xbgr.mr_n69235632)
print v(xbgr.mr_n69236064)
print v(xbgr.mr_n69236496)
print v(xbgr.mr_n69236928)
print v(xbgr.mr_n69237360)
print v(xbgr.mr_n69237792)
print v(xbgr.mr_n69238224)
print v(xbgr.mr_n69238656)
print v(xbgr.mr_n69299008)
print v(xbgr.mr_n69299584)
print v(xbgr.mr_n69300752)
print v(xbgr.mr_n69303936)
print v(xbgr.mr_n69305248)
print v(xbgr.mr_n69307488)
print v(xbgr.mr_n69307728)
print v(xbgr.mr_n69309072)
print v(xbgr.mr_n69310176)
print v(xbgr.mr_n69312656)
print v(xbgr.mr_n69314608)
print v(xbgr.mr_n69315984)
print v(xbgr.mr_n69316176)
print v(xbgr.mr_n69316944)
print v(xbgr.mr_n69319504)
print v(xbgr.mr_n69320720)
print v(xbgr.mr_n69322416)
print v(xbgr.mr_n69324768)
print v(xbgr.mr_n69327008)
print v(xbgr.mr_n69329248)
print v(xbgr.mr_n69329488)
print v(xbgr.mr_n69329696)
print v(xbgr.mr_n69329936)
print v(xbgr.mr_n69330592)
print v(xbgr.mr_n69331040)
print v(xbgr.mr_n69331936)
print v(xbgr.mr_n69332832)
print v(xbgr.mr_n69333344)
print v(xbgr.mr_n69339552)
print v(xbgr.mr_n69340000)
print v(xbgr.mr_n69437744)
print v(xbgr.mr_n69446960)
print v(xbgr.mr_n69449136)
print v(xbgr.mr_n69450672)
print v(xbgr.mr_n69451440)
print v(xbgr.mr_n69452080)
print v(xbgr.mr_n69452720)
print v(xbgr.mr_n69466800)
print v(xbgr.mr_n69467440)
print v(xbgr.mr_n69467840)
print v(xbgr.mr_n69473712)
print v(xbgr.mr_n69485872)
print v(xbgr.mr_n69554704)
print v(xbgr.mr_n69557456)
print v(xbgr.mr_n69558528)
print v(xbgr.mr_n69558800)
print v(xbgr.mr_n69560976)
print v(xbgr.mr_n69566240)
print v(xbgr.mr_n69567936)
print v(xbgr.mr_n69568592)
print v(xbgr.mr_n69568832)
print v(xbgr.mr_n69569488)
print v(xbgr.mr_n69569936)
print v(xbgr.mr_n69570704)
print v(xbgr.mr_n69574416)
print v(xbgr.mr_n69574752)
print v(xbgr.mr_n69577056)
print v(xbgr.mr_n69581200)
print v(xbgr.mr_n69582480)
print v(xbgr.mr_n69582992)
print v(xbgr.mr_n69585296)
print v(xbgr.mr_n69585616)
print v(xbgr.mr_n69586480)
print v(xbgr.mr_n69600976)
print v(xbgr.mr_n69602496)
print v(xbgr.mr_n69602832)
print v(xbgr.mr_n69602976)
print v(xbgr.mr_n69613616)
print v(xbgr.mr_n69614192)
print v(xbgr.mr_n69620000)
print v(xbgr.mr_n69655984)
print v(xbgr.mr_n69656160)
print v(xbgr.mr_n69656336)
print v(xbgr.mr_n69659152)
print v(xbgr.mr_n69659920)
print v(xbgr.mr_n69660480)
print v(xbgr.mr_n69665808)
print v(xbgr.mr_n69668896)
print v(xbgr.mr_n69671488)
print v(xbgr.mr_n69673072)
print v(xbgr.mr_n69677664)
print v(xbgr.mr_n69677904)
print v(xbgr.mr_n69678432)
print v(xbgr.mr_n69680304)
print v(xbgr.mr_n69683120)
print v(xbgr.mr_n69687232)
print v(xbgr.mr_n69688544)
print v(xbgr.mr_n69717328)
print v(xbgr.mr_n69718288)
print v(xbgr.mr_n69740224)
print v(xbgr.mr_n69740912)
print v(xbgr.mr_n69742192)
print v(xbgr.mr_n69745136)
print v(xbgr.mr_n69747488)
print v(xbgr.mr_n69748976)
print v(xbgr.mr_n69749344)
print v(xbgr.mr_n69749984)
print v(xbgr.mr_n69801440)
print v(xbgr.mr_n69801632)
print v(xbgr.mr_n69928624)
print v(xbgr.mr_n69928816)
print v(xbgr.mr_n69930496)
print v(xbgr.mr_n69961024)
print v(xbgr.mr_n69961632)
print v(xbgr.mr_n69961824)
print v(xbgr.mr_n69981904)
print v(xbgr.mr_n69982032)
print v(xbgr.mr_n69982480)
print v(xbgr.mr_n69984112)
print v(xbgr.mr_n70013520)
print v(xbgr.mr_n70013760)
print v(xbgr.mr_n70014560)
print v(xbgr.mr_n70014736)
print v(xbgr.mr_n70015872)
print v(xbgr.mr_n70066560)
print v(xbgr.mr_n70067568)
print v(xbgr.mr_n70130960)
print v(xbgr.mr_n70133952)
print v(xbgr.mr_n70145904)
print v(xbgr.mr_n70148720)
print v(xbgr.mr_n70150864)
print v(xbgr.mr_n70153872)
print v(xbgr.mr_n70154112)
print v(xbgr.mr_n70155024)
print v(xbgr.mr_n70155936)
print v(xbgr.mr_n70160304)
print v(xbgr.mr_n70161872)
print v(xbgr.mr_n70162064)
print v(xbgr.mr_n70162176)
print v(xbgr.mr_n70162288)
print v(xbgr.mr_n70162400)
print v(xbgr.mr_n70162512)
print v(xbgr.mr_n70162704)
print v(xbgr.mr_n70162976)
print v(xbgr.mr_n70163248)
print v(xbgr.mr_n70164384)
print v(xbgr.mr_n70165360)
print v(xbgr.mr_n70165824)
print v(xbgr.mr_n70166288)
print v(xbgr.mr_n70166560)
print v(xbgr.mr_n70166752)
print v(xbgr.mr_n70167744)
print v(xbgr.mr_n70168144)
print v(xbgr.mr_n70168672)
print v(xbgr.mr_n70169072)
print v(xbgr.mr_n70169536)
print v(xbgr.mr_n70170000)
print v(xbgr.mr_n70175488)
print v(xbgr.mr_n70176224)
print v(xbgr.mr_n70177264)
print v(xbgr.mr_n70177872)
print v(xbgr.mr_n70178848)
print v(xbgr.mr_n70179024)
print v(xbgr.mr_n70179520)
print v(xbgr.mr_n70179632)
print v(xbgr.mr_n70180240)
print v(xbgr.mr_n70181280)
print v(xbgr.mr_n70181424)
print v(xbgr.mr_n70182128)
print v(xbgr.mr_n70182736)
print v(xbgr.mr_n70183280)
print v(xbgr.mr_n70183888)
print v(xbgr.mr_n70185712)
print v(xbgr.mr_n70187360)
print v(xbgr.mr_n70189360)
print v(xbgr.mr_n70190400)
print v(xbgr.mr_n70192304)
print v(xbgr.mr_n70193984)
print v(xbgr.mr_n70194416)
print v(xbgr.mr_n70196528)
print v(xbgr.mr_n70197440)
print v(xbgr.mr_n70198112)
print v(xbgr.mr_n70198816)
print v(xbgr.mr_n70201104)
print v(xbgr.mr_n70201840)
print v(xbgr.mr_n70204592)
print v(xbgr.mr_n70205360)
print v(xbgr.mr_n70206256)
print v(xbgr.mr_n70208064)
print v(xbgr.mr_n70209952)
print v(xbgr.mr_n70210352)
print v(xbgr.mr_n70211696)
print v(xbgr.mr_n70212064)
print v(xbgr.mr_n70212400)
print v(xbgr.mr_n70216304)
print v(xbgr.mr_n70216688)
print v(xbgr.mr_n70217120)
print v(xbgr.mr_n70217328)
print v(xbgr.mr_n70218096)
print v(xbgr.mr_n70218672)
print v(xbgr.mr_n70219440)
print v(xbgr.mr_n70220320)
print v(xbgr.mr_n70222048)
print v(xbgr.mr_n70222256)
print v(xbgr.mr_n70223136)
print v(xbgr.mr_n70225072)
print v(xbgr.mr_n70227072)
print v(xbgr.mr_n70227248)
print v(xbgr.mr_n70227680)
print v(xbgr.mr_n70227952)
print v(xbgr.mr_n70228384)
print v(xbgr.mr_n70229296)
print v(xbgr.mr_n70229792)
print v(xbgr.mr_n70231008)
print v(xbgr.mr_n70234720)
print v(xbgr.mr_n70234928)
print v(xbgr.mr_n70235424)
print v(xbgr.mr_n70236336)
print v(xbgr.mr_n70236864)
print v(xbgr.mr_n70238272)
print v(xbgr.mr_n70239648)
print v(xbgr.mr_n70239856)
print v(xbgr.mr_n70240624)
print v(xbgr.mr_n70241056)
print v(xbgr.mr_n70241760)
print v(xbgr.mr_n70242496)
print v(xbgr.mr_n70242736)
print v(xbgr.mr_n70244576)
print v(xbgr.mr_n70246256)
print v(xbgr.mr_n70248432)
print v(xbgr.mr_n70250272)
print v(xbgr.mr_n70252144)
print v(xbgr.mr_n70252608)
print v(xbgr.mr_n70253072)
print v(xbgr.mr_n70253600)
print v(xbgr.mr_n70254528)
print v(xbgr.mr_n70254928)
print v(xbgr.mr_n70255392)
print v(xbgr.mr_n70255856)
print v(xbgr.mr_n70256320)
print v(xbgr.mr_n70256784)
print v(xbgr.mr_n70258688)
print v(xbgr.mr_n70258928)
print v(xbgr.mr_n70259104)
print v(xbgr.mr_n70259776)
print v(xbgr.mr_n70260624)
print v(xbgr.mr_n70261232)
print v(xbgr.mr_n70262816)
print v(xbgr.mr_n70267920)
print v(xbgr.mr_n70269200)
print v(xbgr.mr_n70270352)
print v(xbgr.mr_n70270656)
print v(xbgr.mr_n70273088)
print v(xbgr.mr_n70274368)
print v(xbgr.mr_n70276240)
print v(xbgr.mr_n70278000)
print v(xbgr.mr_n70278272)
print v(xbgr.mr_n70278608)
print v(xbgr.mr_n70278976)
print v(xbgr.mr_n70279824)
print v(xbgr.mr_n70281120)
print v(xbgr.mr_n70282448)
print v(xbgr.mr_n70282864)
print v(xbgr.mr_n70283840)
print v(xbgr.mr_n70285104)
print v(xbgr.mr_n70289232)
print v(xbgr.mr_n70290064)
print v(xbgr.mr_n70290240)
print v(xbgr.mr_n70291456)
print v(xbgr.mr_n70293360)
print v(xbgr.mr_n70294272)
print v(xbgr.mr_n70294848)
print v(xbgr.mr_n70295856)
print v(xbgr.mr_n70297040)
print v(xbgr.mr_n70298320)
print v(xbgr.mr_n70300656)
print v(xbgr.mr_n70301024)
print v(xbgr.mr_n70301216)
print v(xbgr.mr_n70303328)
print v(xbgr.mr_n70303792)
print v(xbgr.mr_n70304064)
print v(xbgr.mr_n70304256)
print v(xbgr.mr_n70304720)
print v(xbgr.mr_n70305184)
print v(xbgr.mr_n70305584)
print v(xbgr.mr_n70306112)
print v(xbgr.mr_n70306576)
print v(xbgr.mr_n70307040)
print v(xbgr.mr_n70307504)
print v(xbgr.mr_n70307968)
print v(xbgr.mr_n70308432)
print v(xbgr.mr_n70308896)
print v(xbgr.mr_n70309360)
print v(xbgr.mr_n70309824)
print v(xbgr.mr_n70310224)
print v(xbgr.mr_n70310752)
print v(xbgr.mr_n70311216)
print v(xbgr.mr_n70311680)
print v(xbgr.mr_n70312144)
print v(xbgr.mr_n70312416)
print v(xbgr.mr_n70312608)
print v(xbgr.mr_n70313072)
print v(xbgr.mr_n70313536)
print v(xbgr.mr_n70314000)
print v(xbgr.mr_n70314464)
print v(xbgr.mr_n70314864)
print v(xbgr.mr_n70315392)
print v(xbgr.mr_n70315856)
print v(xbgr.mr_n70316320)
print v(xbgr.mr_n70316784)
print v(xbgr.mr_n70317248)
print v(xbgr.mr_n70317712)
print v(xbgr.mr_n70318176)
print v(xbgr.mr_n70318640)
print v(xbgr.mr_n70319104)
print v(xbgr.mr_n70319504)
print v(xbgr.mr_n70320032)
print v(xbgr.mr_n70320496)
print v(xbgr.mr_n70320960)
print v(xbgr.mr_n70321424)
print v(xbgr.mr_n70321888)
print v(xbgr.mr_n70322352)
print v(xbgr.mr_n70322816)
print v(xbgr.mr_n70323280)
print v(xbgr.mr_n70323680)
print v(xbgr.mr_n70324144)
print v(xbgr.mr_n70324544)
print v(xbgr.mr_n70324992)
print v(xbgr.mr_n70325456)
print v(xbgr.mr_n70325920)
print v(xbgr.mr_n70326384)
print v(xbgr.mr_n70326848)
print v(xbgr.mr_n70327312)
print v(xbgr.mr_n70327776)
print v(xbgr.mr_n70328240)
print v(xbgr.mr_n70328640)
print v(xbgr.mr_n70329168)
print v(xbgr.mr_n70329632)
print v(xbgr.mr_n70330096)
print v(xbgr.mr_n70330560)
print v(xbgr.mr_n70331024)
print v(xbgr.mr_n70331488)
print v(xbgr.mr_n70331952)
print v(xbgr.mr_n70332416)
print v(xbgr.mr_n70332880)
print v(xbgr.mr_n70333280)
print v(xbgr.mr_n70333808)
print v(xbgr.mr_n70334272)
print v(xbgr.mr_n70334736)
print v(xbgr.mr_n70335200)
print v(xbgr.mr_n70335664)
print v(xbgr.mr_n70336128)
print v(xbgr.mr_n70336592)
print v(xbgr.mr_n70337056)
print v(xbgr.mr_n70337520)
print v(xbgr.mr_n70337920)
print v(xbgr.mr_n70338448)
print v(xbgr.mr_n70338912)
print v(xbgr.mr_n70339376)
print v(xbgr.mr_n70339840)
print v(xbgr.mr_n70340304)
print v(xbgr.mr_n70340768)
print v(xbgr.mr_n70341232)
print v(xbgr.mr_n70341696)
print v(xbgr.mr_n70342160)
print v(xbgr.mr_n70342560)
print v(xbgr.mr_n70343088)
print v(xbgr.mr_n70343552)
print v(xbgr.mr_n70344016)
print v(xbgr.mr_n70344480)
print v(xbgr.mr_n70344944)
print v(xbgr.mr_n70345408)
print v(xbgr.mr_n70345872)
print v(xbgr.mr_n70346336)
print v(xbgr.mr_n70346800)
print v(xbgr.mr_n70347200)
print v(xbgr.mr_n70347728)
print v(xbgr.mr_n70348192)
print v(xbgr.mr_n70348656)
print v(xbgr.mr_n70349120)
print v(xbgr.mr_n70349584)
print v(xbgr.mr_n70350048)
print v(xbgr.mr_n70350512)
print v(xbgr.mr_n70350976)
print v(xbgr.mr_n70351440)
print v(xbgr.mr_n70351840)
print v(xbgr.mr_n70352368)
print v(xbgr.mr_n70352832)
print v(xbgr.mr_n70353296)
print v(xbgr.mr_n70353760)
print v(xbgr.mr_n70354224)
print v(xbgr.mr_n70354688)
print v(xbgr.mr_n70355152)
print v(xbgr.mr_n70355616)
print v(xbgr.mr_n70356080)
print v(xbgr.mr_n70356480)
print v(xbgr.mr_n70357008)
print v(xbgr.mr_n70357472)
print v(xbgr.mr_n70357936)
print v(xbgr.mr_n70358400)
print v(xbgr.mr_n70358512)
print v(xbgr.mr_n70358976)
print v(xbgr.mr_n70359200)
print v(xbgr.mr_n70359712)
print v(xbgr.mr_n70359936)
print v(xbgr.mr_n70360448)
print v(xbgr.mr_n70360672)
print v(xbgr.mr_n70361184)
print v(xbgr.mr_n70361296)
print v(xbgr.mr_n70361408)
print v(xbgr.mr_n70361920)
print v(xbgr.mr_n70362032)
print v(xbgr.mr_n70362144)
print v(xbgr.mr_n70362656)
print v(xbgr.mr_n70362768)
print v(xbgr.mr_n70362880)
print v(xbgr.mr_n70363392)
print v(xbgr.mr_n70363664)
print v(xbgr.mr_n70363936)
print v(xbgr.mr_n70364208)
print v(xbgr.mr_n70364320)
print v(xbgr.mr_n70364432)
print v(xbgr.mr_n70364944)
print v(xbgr.mr_n70365216)
print v(xbgr.mr_n70365488)
print v(xbgr.mr_n70365760)
print v(xbgr.mr_n70366032)
print v(xbgr.mr_n70366576)
print v(xbgr.mr_n70366848)
print v(xbgr.mr_n70367120)
print v(xbgr.mr_n70367392)
print v(xbgr.mr_n70367664)
print v(xbgr.mr_n70367936)
print v(xbgr.mr_n70368208)
print v(xbgr.mr_n70368480)
print v(xbgr.mr_n70368752)
print v(xbgr.mr_n70369024)
print v(xbgr.mr_n70369296)
print v(xbgr.mr_n70369568)
print v(xbgr.mr_n70369840)
print v(xbgr.mr_n70370112)
print v(xbgr.mr_n70370384)
print v(xbgr.mr_n70370656)
print v(xbgr.mr_n70370928)
print v(xbgr.mr_n70371200)
print v(xbgr.mr_n70371472)
print v(xbgr.mr_n70371872)
print v(xbgr.mr_n70372336)
print v(xbgr.mr_n70372800)
print v(xbgr.mr_n70373264)
print v(xbgr.mr_n70373728)
print v(xbgr.mr_n70374192)
print v(xbgr.mr_n70374656)
print v(xbgr.mr_n70375120)
print v(xbgr.mr_n70375584)
print v(xbgr.mr_n70376048)
print v(xbgr.mr_n70376512)
print v(xbgr.mr_n70376976)
print v(xbgr.mr_n70380512)
print v(xbgr.mr_n70384768)
print v(xbgr.mr_n70386288)
print v(xbgr.mr_n70387616)
print v(xbgr.mr_n70390832)
print v(xbgr.mr_n70394160)
print v(xbgr.mr_n70394624)
print v(xbgr.mr_n70395088)
print v(xbgr.mr_n70395552)
print v(xbgr.mr_n70396144)
print v(xbgr.mr_n70396736)
print v(xbgr.mr_n70397328)
print v(xbgr.mr_n70397920)
print v(xbgr.mr_n70398512)
print v(xbgr.mr_n70398848)
print v(xbgr.mr_n70399104)
print v(xbgr.mr_n70399696)
print v(xbgr.mr_n70400288)
print v(xbgr.mr_n70400880)
print v(xbgr.mr_n70401472)
print v(xbgr.mr_n70402064)
print v(xbgr.mr_n70402656)
print v(xbgr.mr_n70403248)
print v(xbgr.mr_n70403840)
print v(xbgr.mr_n70404432)
print v(xbgr.mr_n70405024)
print v(xbgr.mr_n70405616)
print v(xbgr.mr_n70406208)
print v(xbgr.mr_n70406800)
print v(xbgr.mr_n70407984)
print v(xbgr.mr_n70408576)
print v(xbgr.mr_n70409168)
print v(xbgr.mr_n70409760)
print v(xbgr.mr_n70417280)
print v(xbgr.mr_n70424496)
print v(xbgr.mr_n70426944)
print v(xbgr.mr_n70427472)
print v(xbgr.mr_n70428624)
print v(xbgr.mr_n70429488)
print v(xbgr.mr_n70430160)
print v(xbgr.mr_n70432336)
print v(xbgr.mr_n70434832)
print v(xbgr.mr_n70435088)
print v(xbgr.mr_n70436176)
print v(xbgr.mr_n70438128)
print v(xbgr.mr_n70445184)
print v(xbgr.mr_n70449904)
print v(xbgr.mr_n70453392)
print v(xbgr.mr_n70454352)
print v(xbgr.mr_n70456704)
print v(xbgr.mr_n70458784)
print v(xbgr.mr_n70459392)
print v(xbgr.mr_n70459504)
print v(xbgr.mr_n70460112)
print v(xbgr.mr_n70460224)
print v(xbgr.mr_n70460832)
print v(xbgr.mr_n70460944)
print v(xbgr.mr_n70461552)
print v(xbgr.mr_n70462272)
print v(xbgr.mr_n70462384)
print v(xbgr.mr_n70462992)
print v(xbgr.mr_n70463712)
print v(xbgr.mr_n70469520)
print v(xbgr.mr_n70472256)
print v(xbgr.mr_n70475600)
print v(xbgr.mr_n70476336)
print v(xbgr.mr_n70476752)
print v(xbgr.mr_n70479184)
print v(xbgr.mr_n70479552)
print v(xbgr.mr_n70483440)
print v(xbgr.mr_n70486016)
print v(xbgr.mr_n70487808)
print v(xbgr.mr_n70489216)
print v(xbgr.mr_n70489936)
print v(xbgr.mr_n70490128)
print v(xbgr.mr_n70491712)
print v(xbgr.mr_n70493536)
print v(xbgr.mr_n70494448)
print v(xbgr.mr_n70494784)
print v(xbgr.mr_n70496208)
print v(xbgr.mr_n70498768)
print v(xbgr.mr_n70499008)
print v(xbgr.mr_n70499568)
print v(xbgr.mr_n70499840)
print v(xbgr.mr_n70500192)
print v(xbgr.mr_n70500576)
print v(xbgr.mr_n70505120)
print v(xbgr.mr_n70509088)
print v(xbgr.mr_n70509696)
print v(xbgr.mr_n70509808)
print v(xbgr.mr_n70509920)
print v(xbgr.mr_n70512912)
print v(xbgr.mr_n70515344)
print v(xbgr.mr_n70515520)
print v(xbgr.mr_n70515696)
print v(xbgr.mr_n70517840)
print v(xbgr.mr_n70518448)
print v(xbgr.mr_n70519104)
print v(xbgr.mr_n70519632)
print v(xbgr.mr_n70520288)
print v(xbgr.mr_n70520880)
print v(xbgr.mr_n70521472)
print v(xbgr.mr_n70522064)
print v(xbgr.mr_n70522656)
print v(xbgr.mr_n70523248)
print v(xbgr.mr_n70523664)
print v(xbgr.mr_n70523840)
print v(xbgr.mr_n70524432)
print v(xbgr.mr_n70525024)
print v(xbgr.mr_n70525616)
print v(xbgr.mr_n70526208)
print v(xbgr.mr_n70526736)
print v(xbgr.mr_n70527392)
print v(xbgr.mr_n70527984)
print v(xbgr.mr_n70528576)
print v(xbgr.mr_n70529168)
print v(xbgr.mr_n70529760)
print v(xbgr.mr_n70530352)
print v(xbgr.mr_n70530864)
print v(xbgr.mr_n70531472)
print v(xbgr.mr_n70532128)
print v(xbgr.mr_n70532720)
print v(xbgr.mr_n70533312)
print v(xbgr.mr_n70533904)
print v(xbgr.mr_n70534496)
print v(xbgr.mr_n70535088)
print v(xbgr.mr_n70535600)
print v(xbgr.mr_n70536208)
print v(xbgr.mr_n70536864)
print v(xbgr.mr_n70537456)
print v(xbgr.mr_n70538048)
print v(xbgr.mr_n70539232)
print v(xbgr.mr_n70539824)
print v(xbgr.mr_n70540416)
print v(xbgr.mr_n70541008)
print v(xbgr.mr_n70541600)
print v(xbgr.mr_n70542192)
print v(xbgr.mr_n70542784)
print v(xbgr.mr_n70543312)
print v(xbgr.mr_n70543888)
print v(xbgr.mr_n70544496)
print v(xbgr.mr_n70545152)
print v(xbgr.mr_n70545712)
print v(xbgr.mr_n70545824)
print v(xbgr.mr_n70546064)
print v(xbgr.mr_n70546768)
print v(xbgr.mr_n70547152)
print v(xbgr.mr_n70547696)
print v(xbgr.mr_n70548736)
print v(xbgr.mr_n70549488)
print v(xbgr.mr_n70550080)
print v(xbgr.mr_n70550656)
print v(xbgr.mr_n70551248)
print v(xbgr.mr_n70551840)
print v(xbgr.mr_n70552352)
print v(xbgr.mr_n70552960)
print v(xbgr.mr_n70553536)
print v(xbgr.mr_n70554128)
print v(xbgr.mr_n70554800)
print v(xbgr.mr_n70555392)
print v(xbgr.mr_n70555984)
print v(xbgr.mr_n70556576)
print v(xbgr.mr_n70557104)
print v(xbgr.mr_n70557760)
print v(xbgr.mr_n70558272)
print v(xbgr.mr_n70558944)
print v(xbgr.mr_n70559536)
print v(xbgr.mr_n70560128)
print v(xbgr.mr_n70560720)
print v(xbgr.mr_n70561232)
print v(xbgr.mr_n70561904)
print v(xbgr.mr_n70562416)
print v(xbgr.mr_n70563088)
print v(xbgr.mr_n70563680)
print v(xbgr.mr_n70564192)
print v(xbgr.mr_n70564864)
print v(xbgr.mr_n70565376)
print v(xbgr.mr_n70566048)
print v(xbgr.mr_n70566640)
print v(xbgr.mr_n70567152)
print v(xbgr.mr_n70567824)
print v(xbgr.mr_n70568416)
print v(xbgr.mr_n70569008)
print v(xbgr.mr_n70569536)
print v(xbgr.mr_n70570112)
print v(xbgr.mr_n70570784)
print v(xbgr.mr_n70571296)
print v(xbgr.mr_n70571712)
print v(xbgr.mr_n70571968)
print v(xbgr.mr_n70572560)
print v(xbgr.mr_n70573152)
print v(xbgr.mr_n70573680)
print v(xbgr.mr_n70574336)
print v(xbgr.mr_n70574928)
print v(xbgr.mr_n70575520)
print v(xbgr.mr_n70576032)
print v(xbgr.mr_n70576704)
print v(xbgr.mr_n70577216)
print v(xbgr.mr_n70577888)
print v(xbgr.mr_n70578480)
print v(xbgr.mr_n70579072)
print v(xbgr.mr_n70579664)
print v(xbgr.mr_n70580256)
print v(xbgr.mr_n70580512)
print v(xbgr.mr_n70580768)
print v(xbgr.mr_n70581440)
print v(xbgr.mr_n70582032)
print v(xbgr.mr_n70582624)
print v(xbgr.mr_n70583216)
print v(xbgr.mr_n70583808)
print v(xbgr.mr_n70584400)
print v(xbgr.mr_n70584912)
print v(xbgr.mr_n70585584)
print v(xbgr.mr_n70586176)
print v(xbgr.mr_n70586768)
print v(xbgr.mr_n70587360)
print v(xbgr.mr_n70587872)
print v(xbgr.mr_n70588544)
print v(xbgr.mr_n70589056)
print v(xbgr.mr_n70589728)
print v(xbgr.mr_n70590320)
print v(xbgr.mr_n70590832)
print v(xbgr.mr_n70591504)
print v(xbgr.mr_n70592096)
print v(xbgr.mr_n70592688)
print v(xbgr.mr_n70593280)
print v(xbgr.mr_n70593792)
print v(xbgr.mr_n70594400)
print v(xbgr.mr_n70594976)
print v(xbgr.mr_n70595888)
print v(xbgr.mr_n70596128)
print v(xbgr.mr_n70596448)
print v(xbgr.mr_n70597248)
print v(xbgr.mr_n70598048)
print v(xbgr.mr_n70598448)
print v(xbgr.mr_n70598848)
print v(xbgr.mr_n70599248)
print v(xbgr.mr_n70599648)
print v(xbgr.mr_n70603312)
print v(xbgr.mr_n70609808)
print v(xbgr.mr_n70612080)
print v(xbgr.mr_n70613168)
print v(xbgr.mr_n70614064)
print v(xbgr.mr_n70615600)
print v(xbgr.mr_n70617840)
print v(xbgr.mr_n70618816)
print v(xbgr.mr_n70620336)
print v(xbgr.mr_n70626096)
print v(xbgr.mr_n70626240)
print v(xbgr.mr_n70627312)
print v(xbgr.mr_n70629008)
print v(xbgr.mr_n70630912)
print v(xbgr.mr_n70631504)
print v(xbgr.mr_n70632096)
print v(xbgr.mr_n70632688)
print v(xbgr.mr_n70633280)
print v(xbgr.mr_n70633872)
print v(xbgr.mr_n70634464)
print v(xbgr.mr_n70635056)
print v(xbgr.mr_n70635648)
print v(xbgr.mr_n70636240)
print v(xbgr.mr_n70636832)
print v(xbgr.mr_n70637248)
print v(xbgr.mr_n70638720)
print v(xbgr.mr_n70642416)
print v(xbgr.mr_n70646896)
print v(xbgr.mr_n70647344)
print v(xbgr.mr_n70647808)
print v(xbgr.mr_n70651888)
print v(xbgr.mr_n70654256)
print v(xbgr.mr_n70654976)
print v(xbgr.mr_n70661440)
print v(xbgr.mr_n70661888)
print v(xbgr.mr_n70665360)
print v(xbgr.mr_n70671504)
print v(xbgr.mr_n70672064)
print v(xbgr.mr_n70673408)
print v(xbgr.mr_n70675408)
print v(xbgr.mr_n70676000)
print v(xbgr.mr_n70676592)
print v(xbgr.mr_n70677184)
print v(xbgr.mr_n70677776)
print v(xbgr.mr_n70678368)
print v(xbgr.mr_n70679552)
print v(xbgr.mr_n70680144)
print v(xbgr.mr_n70680480)
print v(xbgr.mr_n70681024)
print v(xbgr.mr_n70681136)
print v(xbgr.mr_n70681600)
print v(xbgr.mr_n70682160)
print v(xbgr.mr_n70682880)
print v(xbgr.mr_n70683536)
print v(xbgr.mr_n70684128)
print v(xbgr.mr_n70684720)
print v(xbgr.mr_n70685904)
print v(xbgr.mr_n70686496)
print v(xbgr.mr_n70687088)
print v(xbgr.mr_n70687680)
print v(xbgr.mr_n70688272)
print v(xbgr.mr_n70688864)
print v(xbgr.mr_n70689456)
print v(xbgr.mr_n70689984)
print v(xbgr.mr_n70690640)
print v(xbgr.mr_n70691232)
print v(xbgr.mr_n70691824)
print v(xbgr.mr_n70693008)
print v(xbgr.mr_n70693600)
print v(xbgr.mr_n70694192)
print v(xbgr.mr_n70694784)
print v(xbgr.mr_n70695376)
print v(xbgr.mr_n70695968)
print v(xbgr.mr_n70696560)
print v(xbgr.mr_n70697088)
print v(xbgr.mr_n70697744)
print v(xbgr.mr_n70698336)
print v(xbgr.mr_n70698928)
print v(xbgr.mr_n70700112)
print v(xbgr.mr_n70700704)
print v(xbgr.mr_n70701296)
print v(xbgr.mr_n70701888)
print v(xbgr.mr_n70702480)
print v(xbgr.mr_n70703072)
print v(xbgr.mr_n70703664)
print v(xbgr.mr_n70704192)
print v(xbgr.mr_n70704848)
print v(xbgr.mr_n70705440)
print v(xbgr.mr_n70706032)
print v(xbgr.mr_n70706624)
print v(xbgr.mr_n70707216)
print v(xbgr.mr_n70707808)
print v(xbgr.mr_n70708400)
print v(xbgr.mr_n70708992)
print v(xbgr.mr_n70709584)
print v(xbgr.mr_n70710176)
print v(xbgr.mr_n70710768)
print v(xbgr.mr_n70711296)
print v(xbgr.mr_n70711952)
print v(xbgr.mr_n70712544)
print v(xbgr.mr_n70713136)
print v(xbgr.mr_n70714320)
print v(xbgr.mr_n70714912)
print v(xbgr.mr_n70715504)
print v(xbgr.mr_n70716096)
print v(xbgr.mr_n70716688)
print v(xbgr.mr_n70717280)
print v(xbgr.mr_n70717872)
print v(xbgr.mr_n70718400)
print v(xbgr.mr_n70719056)
print v(xbgr.mr_n70719648)
print v(xbgr.mr_n70720240)
print v(xbgr.mr_n70720832)
print v(xbgr.mr_n70721424)
print v(xbgr.mr_n70722016)
print v(xbgr.mr_n70722608)
print v(xbgr.mr_n70723200)
print v(xbgr.mr_n70723792)
print v(xbgr.mr_n70724384)
print v(xbgr.mr_n70724976)
print v(xbgr.mr_n70725504)
print v(xbgr.mr_n70726160)
print v(xbgr.mr_n70726752)
print v(xbgr.mr_n70727344)
print v(xbgr.mr_n70727936)
print v(xbgr.mr_n70728528)
print v(xbgr.mr_n70729120)
print v(xbgr.mr_n70729712)
print v(xbgr.mr_n70730304)
print v(xbgr.mr_n70730896)
print v(xbgr.mr_n70731488)
print v(xbgr.mr_n70732080)
print v(xbgr.mr_n70732608)
print v(xbgr.mr_n70733264)
print v(xbgr.mr_n70733856)
print v(xbgr.mr_n70734448)
print v(xbgr.mr_n70735040)
print v(xbgr.mr_n70735632)
print v(xbgr.mr_n70736224)
print v(xbgr.mr_n70736816)
print v(xbgr.mr_n70737408)
print v(xbgr.mr_n70738000)
print v(xbgr.mr_n70738592)
print v(xbgr.mr_n70739712)
print v(xbgr.mr_n70740368)
print v(xbgr.mr_n70740960)
print v(xbgr.mr_n70741552)
print v(xbgr.mr_n70742144)
print v(xbgr.mr_n70742736)
print v(xbgr.mr_n70743328)
print v(xbgr.mr_n70743920)
print v(xbgr.mr_n70744512)
print v(xbgr.mr_n70745040)
print v(xbgr.mr_n70745504)
print v(xbgr.mr_n70745968)
print v(xbgr.mr_n70746080)
print v(xbgr.mr_n70746432)
print v(xbgr.mr_n70746896)
print v(xbgr.mr_n70747008)
print v(xbgr.mr_n70747360)
print v(xbgr.mr_n70747472)
print v(xbgr.mr_n70748864)
print v(xbgr.mr_n70749120)
print v(xbgr.mr_n70749456)
print v(xbgr.mr_n70750096)
print v(xbgr.mr_n70750496)
print v(xbgr.mr_n70750896)
print v(xbgr.mr_n70751296)
print v(xbgr.mr_n70751696)
print v(xbgr.mr_n70752096)
print v(xbgr.mr_n70752496)
print v(xbgr.mr_n70752896)
print v(xbgr.mr_n70753296)
print v(xbgr.mr_n70753696)
print v(xbgr.mr_n70754096)
print v(xbgr.mr_n70754496)
print v(xbgr.mr_n70754896)
print v(xbgr.mr_n70755296)
print v(xbgr.mr_n70755696)
print v(xbgr.mr_n70756096)
print v(xbgr.mr_n70756496)
print v(xbgr.mr_n70756896)
print v(xbgr.mr_n70757296)
print v(xbgr.mr_n70757696)
print v(xbgr.mr_n70758096)
print v(xbgr.mr_n70758496)
print v(xbgr.mr_n70758896)
print v(xbgr.mr_n70759296)
print v(xbgr.mr_n70759696)
print v(xbgr.mr_n70760096)
print v(xbgr.mr_n70760496)
print v(xbgr.mr_n70760896)
print v(xbgr.mr_n70761296)
print v(xbgr.mr_n70761696)
print v(xbgr.mr_n70762096)
print v(xbgr.mr_n70762496)
print v(xbgr.mr_n70762896)
print v(xbgr.mr_n70763296)
print v(xbgr.mr_n70763696)
print v(xbgr.mr_n70764096)
print v(xbgr.mr_n70764560)
print v(xbgr.mr_n70765152)
print v(xbgr.mr_n70765744)
print v(xbgr.mr_n70766336)
print v(xbgr.mr_n70766928)
print v(xbgr.mr_n70767520)
print v(xbgr.mr_n70768112)
print v(xbgr.mr_n70768704)
print v(xbgr.mr_n70769296)
print v(xbgr.mr_n70769888)
print v(xbgr.mr_n70770480)
print v(xbgr.mr_n70773632)
print v(xbgr.mr_n70778384)
print v(xbgr.mr_n70780096)
print v(xbgr.mr_n70785856)
print v(xbgr.mr_n70786448)
print v(xbgr.mr_n70787536)
print v(xbgr.mr_n70788128)
print v(xbgr.mr_n70788720)
print v(xbgr.mr_n70789312)
print v(xbgr.mr_n70789904)
print v(xbgr.mr_n70790496)
print v(xbgr.mr_n70791088)
print v(xbgr.mr_n70791680)
print v(xbgr.mr_n70792272)
print v(xbgr.mr_n70792864)
print v(xbgr.mr_n70793456)
print v(xbgr.mr_n70794048)
print v(xbgr.mr_n70794640)
print v(xbgr.mr_n70795232)
print v(xbgr.mr_n70795648)
print v(xbgr.mr_n70795824)
print v(xbgr.mr_n70796416)
print v(xbgr.mr_n70797008)
print v(xbgr.mr_n70797600)
print v(xbgr.mr_n70798192)
print v(xbgr.mr_n70798784)
print v(xbgr.mr_n70799120)
print v(xbgr.mr_n70799376)
print v(xbgr.mr_n70799968)
print v(xbgr.mr_n70800560)
print v(xbgr.mr_n70801152)
print v(xbgr.mr_n70801744)
print v(xbgr.mr_n70802336)
print v(xbgr.mr_n70802928)
print v(xbgr.mr_n70803520)
print v(xbgr.mr_n70804112)
print v(xbgr.mr_n70804704)
print v(xbgr.mr_n70805296)
print v(xbgr.mr_n70805888)
print v(xbgr.mr_n70806480)
print v(xbgr.mr_n70807072)
print v(xbgr.mr_n70807664)
print v(xbgr.mr_n70808000)
print v(xbgr.mr_n70808256)
print v(xbgr.mr_n70808848)
print v(xbgr.mr_n70810032)
print v(xbgr.mr_n70810624)
print v(xbgr.mr_n70811216)
print v(xbgr.mr_n70811808)
print v(xbgr.mr_n70812400)
print v(xbgr.mr_n70812992)
print v(xbgr.mr_n70813584)
print v(xbgr.mr_n70814176)
print v(xbgr.mr_n70814768)
print v(xbgr.mr_n70816128)
print v(xbgr.mr_n70819024)
print v(xbgr.mr_n70819168)
print v(xbgr.mr_n70819280)
print v(xbgr.mr_n70819584)
print v(xbgr.mr_n70821424)
print v(xbgr.mr_n70822816)
print v(xbgr.mr_n70826464)
print v(xbgr.mr_n70826896)
print v(xbgr.mr_n70828720)
print v(xbgr.mr_n70832768)
print v(xbgr.mr_n70833920)
print v(xbgr.mr_n70846016)
print v(xbgr.mr_n70853776)
print v(xbgr.mr_n70856928)
print v(xbgr.mr_n70857376)
print v(xbgr.mr_n70857824)
print v(xbgr.mr_n70859200)
print v(xbgr.mr_n70860144)
print v(xbgr.mr_n70860256)
print v(xbgr.mr_n70860864)
print v(xbgr.mr_n70861584)
print v(xbgr.mr_n70861696)
print v(xbgr.mr_n70862304)
print v(xbgr.mr_n70863024)
print v(xbgr.mr_n70863136)
print v(xbgr.mr_n70863744)
print v(xbgr.mr_n70868656)
print v(xbgr.mr_n70874912)
print v(xbgr.mr_n70879968)
print v(xbgr.mr_n70886256)
print v(xbgr.mr_n70894336)
print v(xbgr.mr_n70895616)
print v(xbgr.mr_n70898112)
print v(xbgr.mr_n70898976)
print v(xbgr.mr_n70901280)
print v(xbgr.mr_n70901904)
print v(xbgr.mr_n70902304)
print v(xbgr.mr_n70902896)
print v(xbgr.mr_n70903264)
print v(xbgr.mr_n70903456)
print v(xbgr.mr_n70903664)
print v(xbgr.mr_n70906096)
print v(xbgr.mr_n70906208)
print v(xbgr.mr_n70906720)
print v(xbgr.mr_n70907504)
print v(xbgr.mr_n70908656)
print v(xbgr.mr_n70909584)
print v(xbgr.mr_n70910048)
print v(xbgr.mr_n70910576)
print v(xbgr.mr_n70911760)
print v(xbgr.mr_n70912352)
print v(xbgr.mr_n70912944)
print v(xbgr.mr_n70913536)
print v(xbgr.mr_n70914128)
print v(xbgr.mr_n70914720)
print v(xbgr.mr_n70915312)
print v(xbgr.mr_n70916416)
print v(xbgr.mr_n70917088)
print v(xbgr.mr_n70917680)
print v(xbgr.mr_n70918272)
print v(xbgr.mr_n70918864)
print v(xbgr.mr_n70919456)
print v(xbgr.mr_n70920048)
print v(xbgr.mr_n70920640)
print v(xbgr.mr_n70921232)
print v(xbgr.mr_n70921824)
print v(xbgr.mr_n70922336)
print v(xbgr.mr_n70923008)
print v(xbgr.mr_n70923600)
print v(xbgr.mr_n70924192)
print v(xbgr.mr_n70924784)
print v(xbgr.mr_n70925376)
print v(xbgr.mr_n70925968)
print v(xbgr.mr_n70926560)
print v(xbgr.mr_n70927152)
print v(xbgr.mr_n70927744)
print v(xbgr.mr_n70928336)
print v(xbgr.mr_n70929520)
print v(xbgr.mr_n70930112)
print v(xbgr.mr_n70930624)
print v(xbgr.mr_n70931296)
print v(xbgr.mr_n70931888)
print v(xbgr.mr_n70932480)
print v(xbgr.mr_n70933072)
print v(xbgr.mr_n70933664)
print v(xbgr.mr_n70934256)
print v(xbgr.mr_n70934848)
print v(xbgr.mr_n70935440)
print v(xbgr.mr_n70936032)
print v(xbgr.mr_n70936624)
print v(xbgr.mr_n70937216)
print v(xbgr.mr_n70937808)
print v(xbgr.mr_n70938400)
print v(xbgr.mr_n70938992)
print v(xbgr.mr_n70939584)
print v(xbgr.mr_n70940096)
print v(xbgr.mr_n70940768)
print v(xbgr.mr_n70941360)
print v(xbgr.mr_n70941952)
print v(xbgr.mr_n70942512)
print v(xbgr.mr_n70943664)
print v(xbgr.mr_n70944256)
print v(xbgr.mr_n70944848)
print v(xbgr.mr_n70945440)
print v(xbgr.mr_n70945952)
print v(xbgr.mr_n70946624)
print v(xbgr.mr_n70947216)
print v(xbgr.mr_n70947808)
print v(xbgr.mr_n70948400)
print v(xbgr.mr_n70948992)
print v(xbgr.mr_n70949584)
print v(xbgr.mr_n70950176)
print v(xbgr.mr_n70950688)
print v(xbgr.mr_n70951008)
print v(xbgr.mr_n70951440)
print v(xbgr.mr_n70952224)
print v(xbgr.mr_n70952768)
print v(xbgr.mr_n70953232)
print v(xbgr.mr_n70954272)
print v(xbgr.mr_n70955280)
print v(xbgr.mr_n70955728)
print v(xbgr.mr_n70956400)
print v(xbgr.mr_n70957056)
print v(xbgr.mr_n70957584)
print v(xbgr.mr_n70958176)
print v(xbgr.mr_n70962272)
print v(xbgr.mr_n70963888)
print v(xbgr.mr_n70964000)
print v(xbgr.mr_n70964112)
print v(xbgr.mr_n70964224)
print v(xbgr.mr_n70964336)
print v(xbgr.mr_n70964448)
print v(xbgr.mr_n70964560)
print v(xbgr.mr_n70964672)
print v(xbgr.mr_n70964784)
print v(xbgr.mr_n70964896)
print v(xbgr.mr_n70965088)
print v(xbgr.mr_n70965360)
print v(xbgr.mr_n70965632)
print v(xbgr.mr_n70965904)
print v(xbgr.mr_n70966176)
print v(xbgr.mr_n70966448)
print v(xbgr.mr_n70966752)
print v(xbgr.mr_n70967152)
print v(xbgr.mr_n70967552)
print v(xbgr.mr_n70967952)
print v(xbgr.mr_n70968352)
print v(xbgr.mr_n70968752)
print v(xbgr.mr_n70969152)
print v(xbgr.mr_n70969552)
print v(xbgr.mr_n70969952)
print v(xbgr.mr_n70970352)
print v(xbgr.mr_n70970752)
print v(xbgr.mr_n70971152)
print v(xbgr.mr_n70971552)
print v(xbgr.mr_n70971952)
print v(xbgr.mr_n70972352)
print v(xbgr.mr_n70972672)
print v(xbgr.mr_n70973152)
print v(xbgr.mr_n70973552)
print v(xbgr.mr_n70973952)
print v(xbgr.mr_n70974352)
print v(xbgr.mr_n70974752)
print v(xbgr.mr_n70975152)
print v(xbgr.mr_n70975552)
print v(xbgr.mr_n70975952)
print v(xbgr.mr_n70976352)
print v(xbgr.mr_n70976752)
print v(xbgr.mr_n70977152)
print v(xbgr.mr_n70977552)
print v(xbgr.mr_n70977952)
print v(xbgr.mr_n70978288)
print v(xbgr.mr_n70978560)
print v(xbgr.mr_n70978832)
print v(xbgr.mr_n70979104)
print v(xbgr.mr_n70979376)
print v(xbgr.mr_n70979648)
print v(xbgr.mr_n70979920)
print v(xbgr.mr_n70980192)
print v(xbgr.mr_n70980464)
print v(xbgr.mr_n70980736)
print v(xbgr.mr_n70981008)
print v(xbgr.mr_n70981280)
print v(xbgr.mr_n70981552)
print v(xbgr.mr_n70981824)
print v(xbgr.mr_n70982096)
print v(xbgr.mr_n70982368)
print v(xbgr.mr_n70982640)
print v(xbgr.mr_n70982912)
print v(xbgr.mr_n70983360)
print v(xbgr.mr_n70983552)
print v(xbgr.mr_n70983744)
print v(xbgr.mr_n70983936)
print v(xbgr.mr_n70984880)
print v(xbgr.mr_n70988640)
print v(xbgr.mr_n70988752)
print v(xbgr.mr_n70988944)
print v(xbgr.mr_n70989696)
print v(xbgr.mr_n70990608)
print v(xbgr.mr_n70991360)
print v(xbgr.mr_n70993632)
print v(xbgr.mr_n70993744)
print v(xbgr.mr_n70993936)
print v(xbgr.mr_n70994688)
print v(xbgr.mr_n70995600)
print v(xbgr.mr_n70996352)
print v(xbgr.mr_n70998624)
print v(xbgr.mr_n70998736)
print v(xbgr.mr_n70998928)
print v(xbgr.mr_n70999680)
print v(xbgr.mr_n71000592)
print v(xbgr.mr_n71001344)
print v(xbgr.mr_n71003616)
print v(xbgr.mr_n71003728)
print v(xbgr.mr_n71003920)
print v(xbgr.mr_n71004672)
print v(xbgr.mr_n71005584)
print v(xbgr.mr_n71006336)
print v(xbgr.mr_n71008608)
print v(xbgr.mr_n71008720)
print v(xbgr.mr_n71008912)
print v(xbgr.mr_n71009664)
print v(xbgr.mr_n71010576)
print v(xbgr.mr_n71011328)
print v(xbgr.mr_n71013600)
print v(xbgr.mr_n71013712)
print v(xbgr.mr_n71013904)
print v(xbgr.mr_n71014656)
print v(xbgr.mr_n71017936)
print v(xbgr.mr_n71018688)
print v(xbgr.mr_n71019120)
print v(xbgr.mr_n71019296)
print v(xbgr.mr_n71019552)
print v(xbgr.mr_n71020144)
print v(xbgr.mr_n71020576)
print v(xbgr.mr_n71020752)
print v(xbgr.mr_n71021088)
print v(xbgr.mr_n71021792)
print v(xbgr.mr_n71021968)
print v(xbgr.mr_n71022144)
print v(xbgr.mr_n71022656)
print v(xbgr.mr_n71022768)
print v(xbgr.mr_n71023328)
print v(xbgr.mr_n71023504)
print v(xbgr.mr_n71023920)
print v(xbgr.mr_n71024704)
print v(xbgr.mr_n71024880)
print v(xbgr.mr_n71025056)
print v(xbgr.mr_n71025568)
print v(xbgr.mr_n71025680)
print v(xbgr.mr_n71026240)
print v(xbgr.mr_n71026416)
print v(xbgr.mr_n71026912)
print v(xbgr.mr_n71027424)
print v(xbgr.mr_n71027856)
print v(xbgr.mr_n71028032)
print v(xbgr.mr_n71028368)
print v(xbgr.mr_n71029072)
print v(xbgr.mr_n71029248)
print v(xbgr.mr_n71029424)
print v(xbgr.mr_n71029936)
print v(xbgr.mr_n71030048)
print v(xbgr.mr_n71030608)
print v(xbgr.mr_n71030784)
print v(xbgr.mr_n71031200)
print v(xbgr.mr_n71031792)
print v(xbgr.mr_n71032224)
print v(xbgr.mr_n71032400)
print v(xbgr.mr_n71032736)
print v(xbgr.mr_n71033248)
print v(xbgr.mr_n71033680)
print v(xbgr.mr_n71033856)
print v(xbgr.mr_n71034192)
print v(xbgr.mr_n71035072)
print v(xbgr.mr_n71035248)
print v(xbgr.mr_n71035760)
print v(xbgr.mr_n71036192)
print v(xbgr.mr_n71036368)
print v(xbgr.mr_n71036624)
print v(xbgr.mr_n71037216)
print v(xbgr.mr_n71037648)
print v(xbgr.mr_n71037824)
print v(xbgr.mr_n71038160)
print v(xbgr.mr_n71038672)
print v(xbgr.mr_n71038784)
print v(xbgr.mr_n71039344)
print v(xbgr.mr_n71039520)
print v(xbgr.mr_n71039856)
print v(xbgr.mr_n71040720)
print v(xbgr.mr_n71040896)
print v(xbgr.mr_n71041072)
print v(xbgr.mr_n71041584)
print v(xbgr.mr_n71041696)
print v(xbgr.mr_n71041808)
print v(xbgr.mr_n71041920)
print v(xbgr.mr_n71042032)
print v(xbgr.mr_n71042304)
print v(xbgr.mr_n71042656)
print v(xbgr.mr_n71042768)
print v(xbgr.mr_n71043040)
print v(xbgr.mr_n71043392)
print v(xbgr.mr_n71043632)
print v(xbgr.mr_n71043968)
print v(xbgr.mr_n71044320)
print v(xbgr.mr_n71044432)
print v(xbgr.mr_n71044624)
print v(xbgr.mr_n71044896)
print v(xbgr.mr_n71045168)
print v(xbgr.mr_n71045440)
print v(xbgr.mr_n71045712)
print v(xbgr.mr_n71045984)
print v(xbgr.mr_n71046608)
print v(xbgr.mr_n71046800)
print v(xbgr.mr_n71046992)
print v(xbgr.mr_n71047184)
print v(xbgr.mr_n71047936)
print v(xbgr.mr_n71066080)
print v(xbgr.mr_n71066256)
print v(xbgr.mr_n71066960)
print v(xbgr.mr_n71067136)
print v(xbgr.mr_n71067312)
print v(xbgr.mr_n71068016)
print v(xbgr.mr_n71068192)
print v(xbgr.mr_n71068368)
print v(xbgr.mr_n71069072)
print v(xbgr.mr_n71069248)
print v(xbgr.mr_n71069424)
print v(xbgr.mr_n71070128)
print v(xbgr.mr_n71070304)
print v(xbgr.mr_n71070480)
print v(xbgr.mr_n71071184)
print v(xbgr.mr_n71071360)
print v(xbgr.mr_n71071536)
print v(xbgr.mr_n71072112)
print v(xbgr.mr_n71072304)
print v(xbgr.mr_n71072576)
print v(xbgr.mr_n71072848)
print v(xbgr.mr_n71073120)
print v(xbgr.mr_n71073392)
print v(xbgr.mr_n71073664)
print v(xbgr.mr_n71073936)
print v(xbgr.mr_n71074208)
print v(xbgr.mr_n71074480)
print v(xbgr.mr_n71078016)
print v(xbgr.mr_n71078352)
print v(xbgr.mr_n71078688)
print v(xbgr.mr_n71079024)
print v(xbgr.mr_n71079600)
print v(xbgr.mr_n71080320)
print v(xbgr.mr_n71080720)
print v(xbgr.mr_n71081120)
print v(xbgr.mr_n71081520)
print v(xbgr.mr_n71081920)
print v(xbgr.mr_n71082320)
print v(xbgr.mr_n71082720)
print v(xbgr.mr_n71083184)
print v(xbgr.mr_n71083360)
print v(xbgr.mr_n71083984)
print v(xbgr.mr_n71084160)
print v(xbgr.mr_n71084784)
print v(xbgr.mr_n71084960)
print v(xbgr.mr_n71085584)
print v(xbgr.mr_n71085760)
print v(xbgr.mr_n71086320)
print v(xbgr.mr_n71086432)
print v(xbgr.mr_n71086544)
print v(xbgr.mr_n71086816)
print v(xbgr.mr_n71087488)
print v(xbgr.mr_n71088144)
print v(xbgr.mr_n71090864)
print v(xbgr.mr_n71091456)
print v(xbgr.mr_n71092752)
print v(xbgr.mr_n71093264)
print v(xbgr.mr_n71094560)
print v(xbgr.mr_n71095072)
print v(xbgr.mr_n71096368)
print v(xbgr.mr_n71096880)
print v(xbgr.mr_n71098176)
print v(xbgr.mr_n71098688)
print v(xbgr.mr_n71099984)
print v(xbgr.mr_n71100496)
print v(xbgr.mr_n71101552)
print v(xbgr.mr_n71103600)
print v(xbgr.mr_n71104112)
print v(xbgr.mr_n71105328)
print v(xbgr.mr_n71105920)
print v(xbgr.mr_n71107216)
print v(xbgr.mr_n71107728)
print v(xbgr.mr_n71108944)
print v(xbgr.mr_n71109536)
print v(xbgr.mr_n71110752)
print v(xbgr.mr_n71111344)
print v(xbgr.mr_n71112640)
print v(xbgr.mr_n71113152)
print v(xbgr.mr_n71113264)
print v(xbgr.mr_n71113376)
print v(xbgr.mr_n71113488)
print v(xbgr.mr_n71113760)
print v(xbgr.mr_n71113872)
print v(xbgr.mr_n71114224)
print v(xbgr.mr_n71114336)
print v(xbgr.mr_n71114608)
print v(xbgr.mr_n71114960)
print v(xbgr.mr_n71115072)
print v(xbgr.mr_n71115440)
print v(xbgr.mr_n71116064)
print v(xbgr.mr_n71116544)
print v(xbgr.mr_n71117040)
print v(xbgr.mr_n71117392)
print v(xbgr.mr_n71118080)
print v(xbgr.mr_n71118544)
print v(xbgr.mr_n71118960)
print v(xbgr.mr_n71119648)
print v(xbgr.mr_n71120176)
print v(xbgr.mr_n71120528)
print v(xbgr.mr_n71121216)
print v(xbgr.mr_n71121680)
print v(xbgr.mr_n71122096)
print v(xbgr.mr_n71122784)
print v(xbgr.mr_n71123248)
print v(xbgr.mr_n71123664)
print v(xbgr.mr_n71124352)
print v(xbgr.mr_n71124880)
print v(xbgr.mr_n71125232)
print v(xbgr.mr_n71125920)
print v(xbgr.mr_n71126448)
print v(xbgr.mr_n71126800)
print v(xbgr.mr_n71127488)
print v(xbgr.mr_n71128016)
print v(xbgr.mr_n71128368)
print v(xbgr.mr_n71129056)
print v(xbgr.mr_n71129584)
print v(xbgr.mr_n71129936)
print v(xbgr.mr_n71130624)
print v(xbgr.mr_n71131088)
print v(xbgr.mr_n71131504)
print v(xbgr.mr_n71132192)
print v(xbgr.mr_n71132720)
print v(xbgr.mr_n71133072)
print v(xbgr.mr_n71133760)
print v(xbgr.mr_n71134288)
print v(xbgr.mr_n71134640)
print v(xbgr.mr_n71135328)
print v(xbgr.mr_n71135792)
print v(xbgr.mr_n71136576)
print v(xbgr.mr_n71138560)
print v(xbgr.mr_n71142080)
print v(xbgr.mr_n71142528)
print v(xbgr.mr_n71142976)
print v(xbgr.mr_n71143264)
print v(xbgr.mr_n71143376)
print v(xbgr.mr_n71144768)
print v(xbgr.mr_n71147024)
print v(xbgr.mr_n71147904)
print v(xbgr.mr_n71148992)
print v(xbgr.mr_n71149632)
print v(xbgr.mr_n71150400)
print v(xbgr.mr_n71150512)
print v(xbgr.mr_n71153616)
print v(xbgr.mr_n71158336)
print v(xbgr.mr_n71159264)
print v(xbgr.mr_n71159728)
print v(xbgr.mr_n71160192)
print v(xbgr.mr_n71160656)
print v(xbgr.mr_n71161120)
print v(xbgr.mr_n71161584)
print v(xbgr.mr_n71162048)
print v(xbgr.mr_n71162512)
print v(xbgr.mr_n71162976)
print v(xbgr.mr_n71163440)
print v(xbgr.mr_n71163904)
print v(xbgr.mr_n71164368)
print v(xbgr.mr_n71164832)
print v(xbgr.mr_n71165296)
print v(xbgr.mr_n71165760)
print v(xbgr.mr_n71166224)
print v(xbgr.mr_n71169152)
print v(xbgr.mr_n71170080)
print v(xbgr.mr_n71170288)
print v(xbgr.mr_n71170624)
print v(xbgr.mr_n71171296)
print v(xbgr.mr_n71173616)
print v(xbgr.mr_n71174208)
print v(xbgr.mr_n71174832)
print v(xbgr.mr_n71175216)
print v(xbgr.mr_n71183536)
print v(xbgr.mr_n71184496)
print v(xbgr.mr_n71185520)
print v(xbgr.mr_n71187872)
print v(xbgr.mr_n71188352)
print v(xbgr.mr_n71190896)
print v(xbgr.mr_n71191184)
print v(xbgr.mr_n71192336)
print v(xbgr.mr_n71194256)
print v(xbgr.mr_n71194512)
print v(xbgr.mr_n71194784)
print v(xbgr.mr_n71195552)
print v(xbgr.mr_n71195744)
print v(xbgr.mr_n71196320)
print v(xbgr.mr_n71196432)
print v(xbgr.mr_n71197536)
print v(xbgr.mr_n71197808)
print v(xbgr.mr_n71198304)
print v(xbgr.mr_n71199024)
print v(xbgr.mr_n71215072)
print v(xbgr.mr_n71216672)
print v(xbgr.mr_n71217072)
print v(xbgr.mr_n71217312)
print v(xbgr.mr_n71218832)
print v(xbgr.mr_n71219184)
print v(xbgr.mr_n71219536)
print v(xbgr.mr_n71219712)
print v(xbgr.mr_n71220272)
print v(xbgr.mr_n71220544)
print v(xbgr.mr_n71220656)
print v(xbgr.mr_n71220800)
print v(xbgr.mr_n71220976)
print v(xbgr.mr_n71226176)
print v(xbgr.mr_n71226512)
print v(xbgr.mr_n71227056)
print v(xbgr.mr_n71228480)
print v(xbgr.mr_n71229552)
print v(xbgr.mr_n71230016)
print v(xbgr.mr_n71230480)
print v(xbgr.mr_n71230928)
print v(xbgr.mr_n71231392)
print v(xbgr.mr_n71231856)
print v(xbgr.mr_n71232320)
print v(xbgr.mr_n71232784)
print v(xbgr.mr_n71233248)
print v(xbgr.mr_n71233712)
print v(xbgr.mr_n71234176)
print v(xbgr.mr_n71234640)
print v(xbgr.mr_n71235104)
print v(xbgr.mr_n71235568)
print v(xbgr.mr_n71236032)
print v(xbgr.mr_n71236496)
print v(xbgr.mr_n71236960)
print v(xbgr.mr_n71238992)
print v(xbgr.mr_n71240080)
print v(xbgr.mr_n71240480)
print v(xbgr.mr_n71242448)
print v(xbgr.mr_n71247200)
print v(xbgr.mr_n71247776)
print v(xbgr.mr_n71253488)
print v(xbgr.mr_n71253744)
print v(xbgr.mr_n71270656)
print v(xbgr.mr_n71271568)
print v(xbgr.mr_n71272480)
print v(xbgr.mr_n71272672)
print v(xbgr.mr_n71272928)
print v(xbgr.mr_n71273184)
print v(xbgr.mr_n71275152)
print v(xbgr.mr_n71279088)
print v(xbgr.mr_n71280416)
print v(xbgr.mr_n71282464)
print v(xbgr.mr_n71285232)
print v(xbgr.mr_n71286560)
print v(xbgr.mr_n71288608)
print v(xbgr.mr_n71291376)
print v(xbgr.mr_n71292704)
print v(xbgr.mr_n71294752)
print v(xbgr.mr_n71297520)
print v(xbgr.mr_n71298848)
print v(xbgr.mr_n71300896)
print v(xbgr.mr_n71303664)
print v(xbgr.mr_n71304992)
print v(xbgr.mr_n71307040)
print v(xbgr.mr_n71309808)
print v(xbgr.mr_n71311136)
print v(xbgr.mr_n71312944)
print v(xbgr.mr_n71313488)
print v(xbgr.mr_n71314736)
print v(xbgr.mr_n71314960)
print v(xbgr.mr_n71315792)
print v(xbgr.mr_n71318448)
print v(xbgr.mr_n71318848)
print v(xbgr.mr_n71319248)
print v(xbgr.mr_n71319568)
print v(xbgr.mr_n71319968)
print v(xbgr.mr_n71320368)
print v(xbgr.mr_n71320768)
print v(xbgr.mr_n71321168)
print v(xbgr.mr_n71321568)
print v(xbgr.mr_n71321968)
print v(xbgr.mr_n71322368)
print v(xbgr.mr_n71322768)
print v(xbgr.mr_n71323168)
print v(xbgr.mr_n71323568)
print v(xbgr.mr_n71323968)
print v(xbgr.mr_n71324368)
print v(xbgr.mr_n71324640)
print v(xbgr.mr_n71324752)
print v(xbgr.mr_n71324864)
print v(xbgr.mr_n71324976)
print v(xbgr.mr_n71325088)
print v(xbgr.mr_n71325280)
print v(xbgr.mr_n71325552)
print v(xbgr.mr_n71325824)
print v(xbgr.mr_n71326096)
print v(xbgr.mr_n71326368)
print v(xbgr.mr_n71326640)
print v(xbgr.mr_n71326912)
print v(xbgr.mr_n71327184)
print v(xbgr.mr_n71327520)
print v(xbgr.mr_n71327920)
print v(xbgr.mr_n71329600)
print v(xbgr.mr_n71333568)
print v(xbgr.mr_n71336848)
print v(xbgr.mr_n71337536)
print v(xbgr.mr_n71338048)
print v(xbgr.mr_n71340480)
print v(xbgr.mr_n71342208)
print v(xbgr.mr_n71342752)
print v(xbgr.mr_n71342928)
print v(xbgr.mr_n71343712)
print v(xbgr.mr_n71344256)
print v(xbgr.mr_n71344752)
print v(xbgr.mr_n71345296)
print v(xbgr.mr_n71345472)
print v(xbgr.mr_n71346320)
print v(xbgr.mr_n71346800)
print v(xbgr.mr_n71347296)
print v(xbgr.mr_n71347840)
print v(xbgr.mr_n71348016)
print v(xbgr.mr_n71348800)
print v(xbgr.mr_n71349344)
print v(xbgr.mr_n71349776)
print v(xbgr.mr_n71350384)
print v(xbgr.mr_n71350560)
print v(xbgr.mr_n71351408)
print v(xbgr.mr_n71351888)
print v(xbgr.mr_n71352384)
print v(xbgr.mr_n71352928)
print v(xbgr.mr_n71353104)
print v(xbgr.mr_n71353952)
print v(xbgr.mr_n71354432)
print v(xbgr.mr_n71354928)
print v(xbgr.mr_n71355312)
print v(xbgr.mr_n71355472)
print v(xbgr.mr_n71355648)
print v(xbgr.mr_n71356752)
print v(xbgr.mr_n71357104)
print v(xbgr.mr_n71357216)
print v(xbgr.mr_n71357760)
print v(xbgr.mr_n71358192)
print v(xbgr.mr_n71359024)
print v(xbgr.mr_n71359376)
print v(xbgr.mr_n71359488)
print v(xbgr.mr_n71359680)
print v(xbgr.mr_n71360144)
print v(xbgr.mr_n71360608)
print v(xbgr.mr_n71361072)
print v(xbgr.mr_n71361536)
print v(xbgr.mr_n71366976)
print v(xbgr.mr_n71368176)
print v(xbgr.mr_n71373664)
print v(xbgr.mr_n71373856)
print v(xbgr.mr_n71374112)
print v(xbgr.mr_n71374368)
print v(xbgr.mr_n71376336)
print v(xbgr.mr_n71400512)
print v(xbgr.mr_n71401008)
print v(xbgr.mr_n71401312)
print v(xbgr.mr_n71401808)
print v(xbgr.mr_n71402112)
print v(xbgr.mr_n71402672)
print v(xbgr.mr_n71402976)
print v(xbgr.mr_n71403856)
print v(xbgr.mr_n71404160)
print v(xbgr.mr_n71405040)
print v(xbgr.mr_n71405344)
print v(xbgr.mr_n71406224)
print v(xbgr.mr_n71406528)
print v(xbgr.mr_n71407408)
print v(xbgr.mr_n71407712)
print v(xbgr.mr_n71408592)
print v(xbgr.mr_n71408896)
print v(xbgr.mr_n71409776)
print v(xbgr.mr_n71410080)
print v(xbgr.mr_n71410960)
print v(xbgr.mr_n71411264)
print v(xbgr.mr_n71412144)
print v(xbgr.mr_n71412448)
print v(xbgr.mr_n71413328)
print v(xbgr.mr_n71413632)
print v(xbgr.mr_n71414512)
print v(xbgr.mr_n71414816)
print v(xbgr.mr_n71415696)
print v(xbgr.mr_n71416000)
print v(xbgr.mr_n71416880)
print v(xbgr.mr_n71417072)
print v(xbgr.mr_n71417344)
print v(xbgr.mr_n71417808)
print v(xbgr.mr_n71420096)
print v(xbgr.mr_n71422400)
print v(xbgr.mr_n71427568)
print v(xbgr.mr_n71431776)
print v(xbgr.mr_n71432112)
print v(xbgr.mr_n71432448)
print v(xbgr.mr_n71432784)
print v(xbgr.mr_n71434064)
print v(xbgr.mr_n71435584)
print v(xbgr.mr_n71435984)
print v(xbgr.mr_n71436384)
print v(xbgr.mr_n71436784)
print v(xbgr.mr_n71437184)
print v(xbgr.mr_n71437584)
print v(xbgr.mr_n71437984)
print v(xbgr.mr_n71438384)
print v(xbgr.mr_n71438784)
print v(xbgr.mr_n71439184)
print v(xbgr.mr_n71439584)
print v(xbgr.mr_n71439984)
print v(xbgr.mr_n71440384)
print v(xbgr.mr_n71440784)
print v(xbgr.mr_n71441184)
print v(xbgr.mr_n71441584)
print v(xbgr.mr_n71443776)
print v(xbgr.mr_n71448400)
print v(xbgr.mr_n71462032)
print v(xbgr.mr_n71472000)
print v(xbgr.mr_n71472304)
print v(xbgr.mr_n71472608)
print v(xbgr.mr_n71472912)
print v(xbgr.mr_n71473296)
print v(xbgr.mr_n71473760)
print v(xbgr.mr_n71474224)
print v(xbgr.mr_n71474688)
print v(xbgr.mr_n71475152)
print v(xbgr.mr_n71475616)
print v(xbgr.mr_n71476080)
print v(xbgr.mr_n71476544)
print v(xbgr.mr_n71476896)
print v(xbgr.mr_n71477008)
print v(xbgr.mr_n71480192)
print v(xbgr.mr_n71482000)
print v(xbgr.mr_n71482160)
print v(xbgr.mr_n71483088)
print v(xbgr.mr_n71483520)
print v(xbgr.mr_n71485040)
print v(xbgr.mr_n71488000)
print v(xbgr.mr_n71488336)
print v(xbgr.mr_n71488672)
print v(xbgr.mr_n71489008)
print v(xbgr.mr_n71490336)
print v(xbgr.mr_n71491120)
print v(xbgr.mr_n71493744)
print v(xbgr.mr_n71494080)
print v(xbgr.mr_n71495040)
print v(xbgr.mr_n71498512)
print v(xbgr.mr_n71498624)
print v(xbgr.mr_n71498736)
print v(xbgr.mr_n71499008)
print v(xbgr.mr_n71500976)
print v(xbgr.mr_n71501760)
print v(xbgr.mr_n71501872)
print v(xbgr.mr_n71503568)
print v(xbgr.mr_n71503680)
print v(xbgr.mr_n71503792)
print v(xbgr.mr_n71504064)
print v(xbgr.mr_n71506176)
print v(xbgr.mr_n71506816)
print v(xbgr.mr_n71506928)
print v(xbgr.mr_n71508192)
print v(xbgr.mr_n71508896)
print v(xbgr.mr_n71509536)
print v(xbgr.mr_n71509648)
print v(xbgr.mr_n71511232)
print v(xbgr.mr_n71511872)
print v(xbgr.mr_n71511984)
print v(xbgr.mr_n71513680)
print v(xbgr.mr_n71513792)
print v(xbgr.mr_n71513904)
print v(xbgr.mr_n71514176)
print v(xbgr.mr_n71516336)
print v(xbgr.mr_n71516448)
print v(xbgr.mr_n71516640)
print v(xbgr.mr_n71518112)
print v(xbgr.mr_n71518864)
print v(xbgr.mr_n71519648)
print v(xbgr.mr_n71519760)
print v(xbgr.mr_n71521184)
print v(xbgr.mr_n71521984)
print v(xbgr.mr_n71522096)
print v(xbgr.mr_n71523792)
print v(xbgr.mr_n71523904)
print v(xbgr.mr_n71524016)
print v(xbgr.mr_n71524288)
print v(xbgr.mr_n71526448)
print v(xbgr.mr_n71526560)
print v(xbgr.mr_n71526752)
print v(xbgr.mr_n71528784)
print v(xbgr.mr_n71528896)
print v(xbgr.mr_n71529008)
print v(xbgr.mr_n71529280)
print v(xbgr.mr_n71531504)
print v(xbgr.mr_n71531616)
print v(xbgr.mr_n71531808)
print v(xbgr.mr_n71532320)
print v(xbgr.mr_n71532656)
print v(xbgr.mr_n71533008)
print v(xbgr.mr_n71533632)
print v(xbgr.mr_n71534160)
print v(xbgr.mr_n71534512)
print v(xbgr.mr_n71535200)
print v(xbgr.mr_n71535728)
print v(xbgr.mr_n71536080)
print v(xbgr.mr_n71536768)
print v(xbgr.mr_n71537232)
print v(xbgr.mr_n71537648)
print v(xbgr.mr_n71538336)
print v(xbgr.mr_n71538864)
print v(xbgr.mr_n71539216)
print v(xbgr.mr_n71539904)
print v(xbgr.mr_n71540432)
print v(xbgr.mr_n71540784)
print v(xbgr.mr_n71541472)
print v(xbgr.mr_n71542000)
print v(xbgr.mr_n71542352)
print v(xbgr.mr_n71543040)
print v(xbgr.mr_n71543424)
print v(xbgr.mr_n71543920)
print v(xbgr.mr_n71544608)
print v(xbgr.mr_n71545072)
print v(xbgr.mr_n71545488)
print v(xbgr.mr_n71546176)
print v(xbgr.mr_n71546704)
print v(xbgr.mr_n71547056)
print v(xbgr.mr_n71547744)
print v(xbgr.mr_n71548208)
print v(xbgr.mr_n71548624)
print v(xbgr.mr_n71549312)
print v(xbgr.mr_n71549776)
print v(xbgr.mr_n71551088)
print v(xbgr.mr_n71555056)
print v(xbgr.mr_n71555360)
print v(xbgr.mr_n71555744)
print v(xbgr.mr_n71570672)
print v(xbgr.mr_n71571136)
print v(xbgr.mr_n71571600)
print v(xbgr.mr_n71572064)
print v(xbgr.mr_n71572528)
print v(xbgr.mr_n71572992)
print v(xbgr.mr_n71573456)
print v(xbgr.mr_n71573920)
print v(xbgr.mr_n71574384)
print v(xbgr.mr_n71574848)
print v(xbgr.mr_n71575312)
print v(xbgr.mr_n71575776)
print v(xbgr.mr_n71576240)
print v(xbgr.mr_n71576704)
print v(xbgr.mr_n71577168)
print v(xbgr.mr_n71577632)
print v(xbgr.mr_n71578096)
print v(xbgr.mr_n71578560)
print v(xbgr.mr_n71579024)
print v(xbgr.mr_n71579488)
print v(xbgr.mr_n71590800)
print v(xbgr.mr_n71591952)
print v(xbgr.mr_n71600992)
print v(xbgr.mr_n71602560)
print v(xbgr.mr_n71602752)
print v(xbgr.mr_n71603008)
print v(xbgr.mr_n71603264)
print v(xbgr.mr_n71627408)
print v(xbgr.mr_n71627520)
print v(xbgr.mr_n71627632)
print v(xbgr.mr_n71628336)
print v(xbgr.mr_n71628848)
print v(xbgr.mr_n71628960)
print v(xbgr.mr_n71629072)
print v(xbgr.mr_n71629584)
print v(xbgr.mr_n71629696)
print v(xbgr.mr_n71630048)
print v(xbgr.mr_n71630160)
print v(xbgr.mr_n71630512)
print v(xbgr.mr_n71630624)
print v(xbgr.mr_n71630976)
print v(xbgr.mr_n71631152)
print v(xbgr.mr_n71631632)
print v(xbgr.mr_n71631808)
print v(xbgr.mr_n71632288)
print v(xbgr.mr_n71632464)
print v(xbgr.mr_n71632944)
print v(xbgr.mr_n71633120)
print v(xbgr.mr_n71633600)
print v(xbgr.mr_n71633776)
print v(xbgr.mr_n71634256)
print v(xbgr.mr_n71634432)
print v(xbgr.mr_n71634912)
print v(xbgr.mr_n71635088)
print v(xbgr.mr_n71637072)
print v(xbgr.mr_n71638448)
print v(xbgr.mr_n71638784)
print v(xbgr.mr_n71639360)
print v(xbgr.mr_n71640272)
print v(xbgr.mr_n71640448)
print v(xbgr.mr_n71640624)
print v(xbgr.mr_n71641328)
print v(xbgr.mr_n71641504)
print v(xbgr.mr_n71642064)
print v(xbgr.mr_n71642528)
print v(xbgr.mr_n71642704)
print v(xbgr.mr_n71642880)
print v(xbgr.mr_n71643584)
print v(xbgr.mr_n71643760)
print v(xbgr.mr_n71644384)
print v(xbgr.mr_n71644560)
print v(xbgr.mr_n71644736)
print v(xbgr.mr_n71645248)
print v(xbgr.mr_n71645680)
print v(xbgr.mr_n71645856)
print v(xbgr.mr_n71646192)
print v(xbgr.mr_n71646896)
print v(xbgr.mr_n71647072)
print v(xbgr.mr_n71647696)
print v(xbgr.mr_n71647872)
print v(xbgr.mr_n71648048)
print v(xbgr.mr_n71648752)
print v(xbgr.mr_n71648928)
print v(xbgr.mr_n71649552)
print v(xbgr.mr_n71649728)
print v(xbgr.mr_n71649904)
print v(xbgr.mr_n71650544)
print v(xbgr.mr_n71650816)
print v(xbgr.mr_n71651248)
print v(xbgr.mr_n71651424)
print v(xbgr.mr_n71651760)
print v(xbgr.mr_n71652464)
print v(xbgr.mr_n71652640)
print v(xbgr.mr_n71653264)
print v(xbgr.mr_n71653440)
print v(xbgr.mr_n71653616)
print v(xbgr.mr_n71654256)
print v(xbgr.mr_n71654528)
print v(xbgr.mr_n71654640)
print v(xbgr.mr_n71654752)
print v(xbgr.mr_n71654864)
print v(xbgr.mr_n71654976)
print v(xbgr.mr_n71655248)
print v(xbgr.mr_n71655600)
print v(xbgr.mr_n71655712)
print v(xbgr.mr_n71655824)
print v(xbgr.mr_n71656256)
print v(xbgr.mr_n71656736)
print v(xbgr.mr_n71656912)
print v(xbgr.mr_n71657264)
print v(xbgr.mr_n71657632)
print v(xbgr.mr_n71657968)
print v(xbgr.mr_n71658320)
print v(xbgr.mr_n71658432)
print v(xbgr.mr_n71658928)
print v(xbgr.mr_n71659424)
print v(xbgr.mr_n71659904)
print v(xbgr.mr_n71660080)
print v(xbgr.mr_n71660432)
print v(xbgr.mr_n71660800)
print v(xbgr.mr_n71661136)
print v(xbgr.mr_n71661488)
print v(xbgr.mr_n71661600)
print v(xbgr.mr_n71662096)
print v(xbgr.mr_n71662592)
print v(xbgr.mr_n71663072)
print v(xbgr.mr_n71663248)
print v(xbgr.mr_n71663600)
print v(xbgr.mr_n71663968)
print v(xbgr.mr_n71664304)
print v(xbgr.mr_n71664656)
print v(xbgr.mr_n71667280)
print v(xbgr.mr_n71670208)
print v(xbgr.mr_n71671680)
print v(xbgr.mr_n71675408)
print v(xbgr.mr_n71676544)
print v(xbgr.mr_n71676928)
print v(xbgr.mr_n71677392)
print v(xbgr.mr_n71677856)
print v(xbgr.mr_n71678320)
print v(xbgr.mr_n71678784)
print v(xbgr.mr_n71679248)
print v(xbgr.mr_n71679712)
print v(xbgr.mr_n71680176)
print v(xbgr.mr_n71680640)
print v(xbgr.mr_n71681104)
print v(xbgr.mr_n71681568)
print v(xbgr.mr_n71682032)
print v(xbgr.mr_n71682496)
print v(xbgr.mr_n71682960)
print v(xbgr.mr_n71683424)
print v(xbgr.mr_n71683888)
print v(xbgr.mr_n71684352)
print v(xbgr.mr_n71684816)
print v(xbgr.mr_n71685280)
print v(xbgr.mr_n71685744)
print v(xbgr.mr_n71686208)
print v(xbgr.mr_n71686672)
print v(xbgr.mr_n71687136)
print v(xbgr.mr_n71687664)
print v(xbgr.mr_n71688256)
print v(xbgr.mr_n71688368)
print v(xbgr.mr_n71695024)
print v(xbgr.mr_n71704176)
print v(xbgr.mr_n71708592)
print v(xbgr.mr_n71711744)
print v(xbgr.mr_n71712560)
print v(xbgr.mr_n71720880)
print v(xbgr.mr_n71721056)
print v(xbgr.mr_n71721392)
print v(xbgr.mr_n71721776)
print v(xbgr.mr_n71723456)
print v(xbgr.mr_n71723568)
print v(xbgr.mr_n71723760)
print v(xbgr.mr_n71724512)
print v(xbgr.mr_n71726720)
print v(xbgr.mr_n71727136)
print v(xbgr.mr_n71727888)
print v(xbgr.mr_n71738288)
print v(xbgr.mr_n71744288)
print v(xbgr.mr_n71744928)
print v(xbgr.mr_n71745360)
print v(xbgr.mr_n71745536)
print v(xbgr.mr_n71745792)
print v(xbgr.mr_n71746576)
print v(xbgr.mr_n71746752)
print v(xbgr.mr_n71747376)
print v(xbgr.mr_n71747552)
print v(xbgr.mr_n71748176)
print v(xbgr.mr_n71748352)
print v(xbgr.mr_n71748976)
print v(xbgr.mr_n71749152)
print v(xbgr.mr_n71749776)
print v(xbgr.mr_n71749952)
print v(xbgr.mr_n71750752)
print v(xbgr.mr_n71751376)
print v(xbgr.mr_n71751552)
print v(xbgr.mr_n71752112)
print v(xbgr.mr_n71752304)
print v(xbgr.mr_n71755520)
print v(xbgr.mr_n71760080)
print v(xbgr.mr_n71762176)
print v(xbgr.mr_n71763520)
print v(xbgr.mr_n71763712)
print v(xbgr.mr_n71766752)
print v(xbgr.mr_n71767184)
print v(xbgr.mr_n71767648)
print v(xbgr.mr_n71768736)
print v(xbgr.mr_n71772896)
print v(xbgr.mr_n71773072)
print v(xbgr.mr_n71773248)
print v(xbgr.mr_n71773584)
print v(xbgr.mr_n71773760)
print v(xbgr.mr_n71773920)
print v(xbgr.mr_n71774256)
print v(xbgr.mr_n71775488)
print v(xbgr.mr_n71776384)
print v(xbgr.mr_n71778016)
print v(xbgr.mr_n71778128)
print v(xbgr.mr_n71778304)
print v(xbgr.mr_n71779360)
print v(xbgr.mr_n71780880)
print v(xbgr.mr_n71780992)
print v(xbgr.mr_n71781424)
print v(xbgr.mr_n71782192)
print v(xbgr.mr_n71785216)
print v(xbgr.mr_n71786112)
print v(xbgr.mr_n71786720)
print v(xbgr.mr_n71786832)
print v(xbgr.mr_n71789408)
print v(xbgr.mr_n71789520)
print v(xbgr.mr_n71789632)
print v(xbgr.mr_n71790112)
print v(xbgr.mr_n71790288)
print v(xbgr.mr_n71790784)
print v(xbgr.mr_n71790976)
print v(xbgr.mr_n71794128)
print v(xbgr.mr_n71794640)
print v(xbgr.mr_n71794784)
print v(xbgr.mr_n71795568)
print v(xbgr.mr_n71795744)
print v(xbgr.mr_n71796192)
print v(xbgr.mr_n71796800)
print v(xbgr.mr_n71797040)
print v(xbgr.mr_n71797504)
print v(xbgr.mr_n71798272)
print v(xbgr.mr_n71798384)
print v(xbgr.mr_n71798496)
print v(xbgr.mr_n71798608)
print v(xbgr.mr_n71798720)
print v(xbgr.mr_n71798832)
print v(xbgr.mr_n71798944)
print v(xbgr.mr_n71799056)
print v(xbgr.mr_n71799408)
print v(xbgr.mr_n71799760)
print v(xbgr.mr_n71799872)
print v(xbgr.mr_n71800224)
print v(xbgr.mr_n71800336)
print v(xbgr.mr_n71801024)
print v(xbgr.mr_n71802752)
print v(xbgr.mr_n71803600)
print v(xbgr.mr_n71805168)
print v(xbgr.mr_n71805360)
print v(xbgr.mr_n71805632)
print v(xbgr.mr_n71806016)
print v(xbgr.mr_n71806592)
print v(xbgr.mr_n71807584)
print v(xbgr.mr_n71808608)
print v(xbgr.mr_n71808800)
print v(xbgr.mr_n71808992)
print v(xbgr.mr_n71809888)
print v(xbgr.mr_n71810784)
print v(xbgr.mr_n71811120)
print v(xbgr.mr_n71811472)
print v(xbgr.mr_n71811648)
print v(xbgr.mr_n71811904)
print v(xbgr.mr_n71812208)
print v(xbgr.mr_n71812832)
print v(xbgr.mr_n71813184)
print v(xbgr.mr_n71813552)
print v(xbgr.mr_n71813968)
print v(xbgr.mr_n71814400)
print v(xbgr.mr_n71814800)
print v(xbgr.mr_n71815216)
print v(xbgr.mr_n71815648)
print v(xbgr.mr_n71815952)
print v(xbgr.mr_n71816512)
print v(xbgr.mr_n71816928)
print v(xbgr.mr_n71817296)
print v(xbgr.mr_n71817712)
print v(xbgr.mr_n71818144)
print v(xbgr.mr_n71818608)
print v(xbgr.mr_n71818960)
print v(xbgr.mr_n71819392)
print v(xbgr.mr_n71819696)
print v(xbgr.mr_n71820320)
print v(xbgr.mr_n71820672)
print v(xbgr.mr_n71821104)
print v(xbgr.mr_n71821456)
print v(xbgr.mr_n71821888)
print v(xbgr.mr_n71822208)
print v(xbgr.mr_n71822704)
print v(xbgr.mr_n71823136)
print v(xbgr.mr_n71823328)
print v(xbgr.mr_n71823600)
print v(xbgr.mr_n71823872)
print v(xbgr.mr_n71824144)
print v(xbgr.mr_n71824416)
print v(xbgr.mr_n71824688)
print v(xbgr.mr_n71824960)
print v(xbgr.mr_n71825232)
print v(xbgr.mr_n71825504)
print v(xbgr.mr_n71825776)
print v(xbgr.mr_n71826048)
print v(xbgr.mr_n71826320)
print v(xbgr.mr_n71826592)
print v(xbgr.mr_n71826864)
print v(xbgr.mr_n71827200)
print v(xbgr.mr_n71827664)
print v(xbgr.mr_n71828128)
print v(xbgr.mr_n71828400)
print v(xbgr.mr_n71839760)
print v(xbgr.mr_n71843280)
print v(xbgr.mr_n71843472)
print v(xbgr.mr_n71847216)
print v(xbgr.mr_n71857296)
print v(xbgr.mr_n71857792)
print v(xbgr.mr_n71858352)
print v(xbgr.mr_n71858784)
print v(xbgr.mr_n71859216)
print v(xbgr.mr_n71859584)
print v(xbgr.mr_n71859888)
print v(xbgr.mr_n71860080)
print v(xbgr.mr_n71860608)
print v(xbgr.mr_n71861680)
print v(xbgr.mr_n71861792)
print v(xbgr.mr_n71861904)
print v(xbgr.mr_n71862016)
print v(xbgr.mr_n71862128)
print v(xbgr.mr_n71862240)
print v(xbgr.mr_n71862352)
print v(xbgr.mr_n71862704)
print v(xbgr.mr_n71863056)
print v(xbgr.mr_n71863168)
print v(xbgr.mr_n71863520)
print v(xbgr.mr_n71863632)
print v(xbgr.mr_n71868288)
print v(xbgr.mr_n71868672)
print v(xbgr.mr_n71868864)
print v(xbgr.mr_n71869216)
print v(xbgr.mr_n71869712)
print v(xbgr.mr_n71869888)
print v(xbgr.mr_n71870000)
print v(xbgr.mr_n71870384)
print v(xbgr.mr_n71870928)
print v(xbgr.mr_n71871360)
print v(xbgr.mr_n71871776)
print v(xbgr.mr_n71872688)
print v(xbgr.mr_n71872800)
print v(xbgr.mr_n71873408)
print v(xbgr.mr_n71873680)
print v(xbgr.mr_n71873872)
print v(xbgr.mr_n71874064)
print v(xbgr.mr_n71874256)
print v(xbgr.mr_n71875280)
print v(xbgr.mr_n71875472)
print v(xbgr.mr_n71876176)
print v(xbgr.mr_n71877424)
print v(xbgr.mr_n71877776)
print v(xbgr.mr_n71878208)
print v(xbgr.mr_n71878512)
print v(xbgr.mr_n71879136)
print v(xbgr.mr_n71879488)
print v(xbgr.mr_n71879856)
print v(xbgr.mr_n71880272)
print v(xbgr.mr_n71880704)
print v(xbgr.mr_n71881168)
print v(xbgr.mr_n71881520)
print v(xbgr.mr_n71881952)
print v(xbgr.mr_n71882256)
print v(xbgr.mr_n71882816)
print v(xbgr.mr_n71883232)
print v(xbgr.mr_n71883600)
print v(xbgr.mr_n71884016)
print v(xbgr.mr_n71884448)
print v(xbgr.mr_n71884912)
print v(xbgr.mr_n71885264)
print v(xbgr.mr_n71885696)
print v(xbgr.mr_n71886000)
print v(xbgr.mr_n71886560)
print v(xbgr.mr_n71886976)
print v(xbgr.mr_n71887344)
print v(xbgr.mr_n71887760)
print v(xbgr.mr_n71888192)
print v(xbgr.mr_n71888592)
print v(xbgr.mr_n71889008)
print v(xbgr.mr_n71889440)
print v(xbgr.mr_n71889744)
print v(xbgr.mr_n71890368)
print v(xbgr.mr_n71890720)
print v(xbgr.mr_n71890832)
print v(xbgr.mr_n71891024)
print v(xbgr.mr_n71891296)
print v(xbgr.mr_n71891568)
print v(xbgr.mr_n71891840)
print v(xbgr.mr_n71892112)
print v(xbgr.mr_n71892384)
print v(xbgr.mr_n71892656)
print v(xbgr.mr_n71892928)
print v(xbgr.mr_n71893200)
print v(xbgr.mr_n71893472)
print v(xbgr.mr_n71893744)
print v(xbgr.mr_n71894016)
print v(xbgr.mr_n71894288)
print v(xbgr.mr_n71894560)
print v(xbgr.mr_n71894832)
print v(xbgr.mr_n71895296)
print v(xbgr.mr_n71898960)
print v(xbgr.mr_n71907920)
print v(xbgr.mr_n71917392)
print v(xbgr.mr_n71917504)
print v(xbgr.mr_n71917616)
print v(xbgr.mr_n71917792)
print v(xbgr.mr_n71918048)
print v(xbgr.mr_n71920016)
print v(xbgr.mr_n71923744)
print v(xbgr.mr_n71924960)
print v(xbgr.mr_n71925152)
print v(xbgr.mr_n71927296)
print v(xbgr.mr_n71928256)
print v(xbgr.mr_n71929040)
print v(xbgr.mr_n71930800)
print v(xbgr.mr_n71931456)
print v(xbgr.mr_n71931968)
print v(xbgr.mr_n71933264)
print v(xbgr.mr_n71933776)
print v(xbgr.mr_n71935072)
print v(xbgr.mr_n71935584)
print v(xbgr.mr_n71936720)
print v(xbgr.mr_n71937312)
print v(xbgr.mr_n71938608)
print v(xbgr.mr_n71939120)
print v(xbgr.mr_n71940416)
print v(xbgr.mr_n71940928)
print v(xbgr.mr_n71942224)
print v(xbgr.mr_n71942736)
print v(xbgr.mr_n71943952)
print v(xbgr.mr_n71944544)
print v(xbgr.mr_n71945760)
print v(xbgr.mr_n71946352)
print v(xbgr.mr_n71946464)
print v(xbgr.mr_n71946576)
print v(xbgr.mr_n71946688)
print v(xbgr.mr_n71946800)
print v(xbgr.mr_n71946992)
print v(xbgr.mr_n71947424)
print v(xbgr.mr_n71947536)
print v(xbgr.mr_n71947808)
print v(xbgr.mr_n71948160)
print v(xbgr.mr_n71948400)
print v(xbgr.mr_n71948864)
print v(xbgr.mr_n71949216)
print v(xbgr.mr_n71949648)
print v(xbgr.mr_n71950336)
print v(xbgr.mr_n71950960)
print v(xbgr.mr_n71951504)
print v(xbgr.mr_n71951936)
print v(xbgr.mr_n71952352)
print v(xbgr.mr_n71952592)
print v(xbgr.mr_n71953040)
print v(xbgr.mr_n71953504)
print v(xbgr.mr_n71953920)
print v(xbgr.mr_n71954352)
print v(xbgr.mr_n71955040)
print v(xbgr.mr_n71955728)
print v(xbgr.mr_n71956208)
print v(xbgr.mr_n71956640)
print v(xbgr.mr_n71957056)
print v(xbgr.mr_n71957744)
print v(xbgr.mr_n71958272)
print v(xbgr.mr_n71958624)
print v(xbgr.mr_n71958944)
print v(xbgr.mr_n71959056)
print v(xbgr.mr_n71959744)
print v(xbgr.mr_n71960432)
print v(xbgr.mr_n71960912)
print v(xbgr.mr_n71961408)
print v(xbgr.mr_n71961760)
print v(xbgr.mr_n71962448)
print v(xbgr.mr_n71963328)
print v(xbgr.mr_n71963760)
print v(xbgr.mr_n71964448)
print v(xbgr.mr_n71965072)
print v(xbgr.mr_n71965616)
print v(xbgr.mr_n71966048)
print v(xbgr.mr_n71966464)
print v(xbgr.mr_n71967152)
print v(xbgr.mr_n71967680)
print v(xbgr.mr_n71968032)
print v(xbgr.mr_n71968464)
print v(xbgr.mr_n71969152)
print v(xbgr.mr_n71969776)
print v(xbgr.mr_n71970320)
print v(xbgr.mr_n71970752)
print v(xbgr.mr_n71971168)
print v(xbgr.mr_n71971856)
print v(xbgr.mr_n71972320)
print v(xbgr.mr_n71972736)
print v(xbgr.mr_n71973168)
print v(xbgr.mr_n71973360)
print v(xbgr.mr_n71973632)
print v(xbgr.mr_n71973904)
print v(xbgr.mr_n71974176)
print v(xbgr.mr_n71974448)
print v(xbgr.mr_n71974720)
print v(xbgr.mr_n71974992)
print v(xbgr.mr_n71975264)
print v(xbgr.mr_n71975536)
print v(xbgr.mr_n71975808)
print v(xbgr.mr_n71976080)
print v(xbgr.mr_n71976352)
print v(xbgr.mr_n71976624)
print v(xbgr.mr_n71977760)
print v(xbgr.mr_n71999520)
print v(xbgr.mr_n72001344)
print v(xbgr.mr_n72001808)
print v(xbgr.mr_n72002272)
print v(xbgr.mr_n72002736)
print v(xbgr.mr_n72003200)
print v(xbgr.mr_n72008432)
print v(xbgr.mr_n72009152)
print v(xbgr.mr_n72010416)
print v(xbgr.mr_n72019072)
print v(xbgr.mr_n72026944)
print v(xbgr.mr_n72027600)
print v(xbgr.mr_n72028080)
print v(xbgr.mr_n72028528)
print v(xbgr.mr_n72031440)
print v(xbgr.mr_n72032320)
print v(xbgr.mr_n72032512)
print v(xbgr.mr_n72034480)
print v(xbgr.mr_n72037552)
print v(xbgr.mr_n72038368)
print v(xbgr.mr_n72040064)
print v(xbgr.mr_n72045936)
print v(xbgr.mr_n72046208)
print v(xbgr.mr_n72047328)
print v(xbgr.mr_n72048624)
print v(xbgr.mr_n72049136)
print v(xbgr.mr_n72050432)
print v(xbgr.mr_n72050944)
print v(xbgr.mr_n72052240)
print v(xbgr.mr_n72052752)
print v(xbgr.mr_n72053648)
print v(xbgr.mr_n72054224)
print v(xbgr.mr_n72054816)
print v(xbgr.mr_n72055712)
print v(xbgr.mr_n72056368)
print v(xbgr.mr_n72056880)
print v(xbgr.mr_n72057776)
print v(xbgr.mr_n72058432)
print v(xbgr.mr_n72058944)
print v(xbgr.mr_n72059840)
print v(xbgr.mr_n72060496)
print v(xbgr.mr_n72061008)
print v(xbgr.mr_n72061904)
print v(xbgr.mr_n72062560)
print v(xbgr.mr_n72063072)
print v(xbgr.mr_n72063968)
print v(xbgr.mr_n72064624)
print v(xbgr.mr_n72065136)
print v(xbgr.mr_n72066032)
print v(xbgr.mr_n72066688)
print v(xbgr.mr_n72067200)
print v(xbgr.mr_n72068096)
print v(xbgr.mr_n72068752)
print v(xbgr.mr_n72069264)
print v(xbgr.mr_n72070160)
print v(xbgr.mr_n72070816)
print v(xbgr.mr_n72071328)
print v(xbgr.mr_n72072224)
print v(xbgr.mr_n72072800)
print v(xbgr.mr_n72073392)
print v(xbgr.mr_n72074288)
print v(xbgr.mr_n72074944)
print v(xbgr.mr_n72075456)
print v(xbgr.mr_n72076352)
print v(xbgr.mr_n72076768)
print v(xbgr.mr_n72077520)
print v(xbgr.mr_n72078816)
print v(xbgr.mr_n72079328)
print v(xbgr.mr_n72079440)
print v(xbgr.mr_n72079552)
print v(xbgr.mr_n72079664)
print v(xbgr.mr_n72079936)
print v(xbgr.mr_n72080048)
print v(xbgr.mr_n72080400)
print v(xbgr.mr_n72080512)
print v(xbgr.mr_n72080624)
print v(xbgr.mr_n72081056)
print v(xbgr.mr_n72081536)
print v(xbgr.mr_n72081712)
print v(xbgr.mr_n72082064)
print v(xbgr.mr_n72082432)
print v(xbgr.mr_n72082768)
print v(xbgr.mr_n72083120)
print v(xbgr.mr_n72083232)
print v(xbgr.mr_n72083728)
print v(xbgr.mr_n72084224)
print v(xbgr.mr_n72084704)
print v(xbgr.mr_n72084880)
print v(xbgr.mr_n72085232)
print v(xbgr.mr_n72085600)
print v(xbgr.mr_n72085936)
print v(xbgr.mr_n72086288)
print v(xbgr.mr_n72086400)
print v(xbgr.mr_n72086896)
print v(xbgr.mr_n72087392)
print v(xbgr.mr_n72087872)
print v(xbgr.mr_n72088048)
print v(xbgr.mr_n72088400)
print v(xbgr.mr_n72088832)
print v(xbgr.mr_n72089360)
print v(xbgr.mr_n72089712)
print v(xbgr.mr_n72090144)
print v(xbgr.mr_n72090832)
print v(xbgr.mr_n72091456)
print v(xbgr.mr_n72092000)
print v(xbgr.mr_n72092432)
print v(xbgr.mr_n72092848)
print v(xbgr.mr_n72093536)
print v(xbgr.mr_n72094000)
print v(xbgr.mr_n72094416)
print v(xbgr.mr_n72094848)
print v(xbgr.mr_n72095536)
print v(xbgr.mr_n72096224)
print v(xbgr.mr_n72096576)
print v(xbgr.mr_n72096688)
print v(xbgr.mr_n72096880)
print v(xbgr.mr_n72097152)
print v(xbgr.mr_n72097424)
print v(xbgr.mr_n72097696)
print v(xbgr.mr_n72097968)
print v(xbgr.mr_n72098240)
print v(xbgr.mr_n72098512)
print v(xbgr.mr_n72098784)
print v(xbgr.mr_n72099056)
print v(xbgr.mr_n72099328)
print v(xbgr.mr_n72099600)
print v(xbgr.mr_n72099872)
print v(xbgr.mr_n72100144)
print v(xbgr.mr_n72100416)
print v(xbgr.mr_n72100688)
print v(xbgr.mr_n72100960)
print v(xbgr.mr_n72113120)
print v(xbgr.mr_n72116688)
print v(xbgr.mr_n72118224)
print v(xbgr.mr_n72118832)
print v(xbgr.mr_n72119296)
print v(xbgr.mr_n72119760)
print v(xbgr.mr_n72120224)
print v(xbgr.mr_n72120688)
print v(xbgr.mr_n72121152)
print v(xbgr.mr_n72121616)
print v(xbgr.mr_n72122144)
print v(xbgr.mr_n72122736)
print v(xbgr.mr_n72123328)
print v(xbgr.mr_n72123920)
print v(xbgr.mr_n72124512)
print v(xbgr.mr_n72125104)
print v(xbgr.mr_n72125696)
print v(xbgr.mr_n72126288)
print v(xbgr.mr_n72126880)
print v(xbgr.mr_n72127472)
print v(xbgr.mr_n72127984)
print v(xbgr.mr_n72139136)
print v(xbgr.mr_n72156432)
print v(xbgr.mr_n72156624)
print v(xbgr.mr_n72156880)
print v(xbgr.mr_n72158096)
print v(xbgr.mr_n72159296)
print v(xbgr.mr_n72166528)
print v(xbgr.mr_n72167168)
print v(xbgr.mr_n72167376)
print v(xbgr.mr_n72168480)
print v(xbgr.mr_n72169264)
print v(xbgr.mr_n72170944)
print v(xbgr.mr_n72171456)
print v(xbgr.mr_n72173344)
print v(xbgr.mr_n72173936)
print v(xbgr.mr_n72175152)
print v(xbgr.mr_n72175744)
print v(xbgr.mr_n72177040)
print v(xbgr.mr_n72177552)
print v(xbgr.mr_n72178768)
print v(xbgr.mr_n72179360)
print v(xbgr.mr_n72180656)
print v(xbgr.mr_n72181168)
print v(xbgr.mr_n72182464)
print v(xbgr.mr_n72182976)
print v(xbgr.mr_n72184272)
print v(xbgr.mr_n72184784)
print v(xbgr.mr_n72186080)
print v(xbgr.mr_n72186592)
print v(xbgr.mr_n72187888)
print v(xbgr.mr_n72188400)
print v(xbgr.mr_n72189696)
print v(xbgr.mr_n72190208)
print v(xbgr.mr_n72191504)
print v(xbgr.mr_n72192016)
print v(xbgr.mr_n72193312)
print v(xbgr.mr_n72193824)
print v(xbgr.mr_n72195040)
print v(xbgr.mr_n72195632)
print v(xbgr.mr_n72195744)
print v(xbgr.mr_n72195856)
print v(xbgr.mr_n72195968)
print v(xbgr.mr_n72196240)
print v(xbgr.mr_n72196352)
print v(xbgr.mr_n72196704)
print v(xbgr.mr_n72196816)
print v(xbgr.mr_n72197088)
print v(xbgr.mr_n72197440)
print v(xbgr.mr_n72197552)
print v(xbgr.mr_n72197920)
print v(xbgr.mr_n72198336)
print v(xbgr.mr_n72198960)
print v(xbgr.mr_n72199392)
print v(xbgr.mr_n72199808)
print v(xbgr.mr_n72200496)
print v(xbgr.mr_n72201024)
print v(xbgr.mr_n72201376)
print v(xbgr.mr_n72201808)
print v(xbgr.mr_n72202496)
print v(xbgr.mr_n72203184)
print v(xbgr.mr_n72203664)
print v(xbgr.mr_n72204096)
print v(xbgr.mr_n72204512)
print v(xbgr.mr_n72205200)
print v(xbgr.mr_n72205584)
print v(xbgr.mr_n72206080)
print v(xbgr.mr_n72206512)
print v(xbgr.mr_n72207200)
print v(xbgr.mr_n72207888)
print v(xbgr.mr_n72208368)
print v(xbgr.mr_n72208864)
print v(xbgr.mr_n72209216)
print v(xbgr.mr_n72209904)
print v(xbgr.mr_n72210368)
print v(xbgr.mr_n72210784)
print v(xbgr.mr_n72211216)
print v(xbgr.mr_n72211904)
print v(xbgr.mr_n72212528)
print v(xbgr.mr_n72213072)
print v(xbgr.mr_n72213568)
print v(xbgr.mr_n72213920)
print v(xbgr.mr_n72214608)
print v(xbgr.mr_n72215136)
print v(xbgr.mr_n72215488)
print v(xbgr.mr_n72215920)
print v(xbgr.mr_n72216608)
print v(xbgr.mr_n72217296)
print v(xbgr.mr_n72217776)
print v(xbgr.mr_n72218208)
print v(xbgr.mr_n72218624)
print v(xbgr.mr_n72219312)
print v(xbgr.mr_n72219840)
print v(xbgr.mr_n72220192)
print v(xbgr.mr_n72220624)
print v(xbgr.mr_n72221312)
print v(xbgr.mr_n72221936)
print v(xbgr.mr_n72222352)
print v(xbgr.mr_n72222464)
print v(xbgr.mr_n72222656)
print v(xbgr.mr_n72222928)
print v(xbgr.mr_n72223200)
print v(xbgr.mr_n72223472)
print v(xbgr.mr_n72223744)
print v(xbgr.mr_n72224016)
print v(xbgr.mr_n72224288)
print v(xbgr.mr_n72224560)
print v(xbgr.mr_n72224832)
print v(xbgr.mr_n72225104)
print v(xbgr.mr_n72225376)
print v(xbgr.mr_n72225648)
print v(xbgr.mr_n72225920)
print v(xbgr.mr_n72226192)
print v(xbgr.mr_n72226464)
print v(xbgr.mr_n72226736)
print v(xbgr.mr_n72231840)
print v(xbgr.mr_n72234224)
print v(xbgr.mr_n72239584)
print v(xbgr.mr_n72242672)
print v(xbgr.mr_n72242912)
print v(xbgr.mr_n72246832)
print v(xbgr.mr_n72249888)
print v(xbgr.mr_n72250496)
print v(xbgr.mr_n72250960)
print v(xbgr.mr_n72251424)
print v(xbgr.mr_n72251888)
print v(xbgr.mr_n72252352)
print v(xbgr.mr_n72252816)
print v(xbgr.mr_n72253280)
print v(xbgr.mr_n72253808)
print v(xbgr.mr_n72254400)
print v(xbgr.mr_n72254992)
print v(xbgr.mr_n72255584)
print v(xbgr.mr_n72256176)
print v(xbgr.mr_n72256768)
print v(xbgr.mr_n72257360)
print v(xbgr.mr_n72257952)
print v(xbgr.mr_n72258544)
print v(xbgr.mr_n72259136)
print v(xbgr.mr_n72273360)
print v(xbgr.mr_n72276976)
print v(xbgr.mr_n72277152)
print v(xbgr.mr_n72277488)
print v(xbgr.mr_n72279264)
print v(xbgr.mr_n72279856)
print v(xbgr.mr_n72280448)
print v(xbgr.mr_n72281040)
print v(xbgr.mr_n72281632)
print v(xbgr.mr_n72282224)
print v(xbgr.mr_n72282816)
print v(xbgr.mr_n72283408)
print v(xbgr.mr_n72284000)
print v(xbgr.mr_n72284592)
print v(xbgr.mr_n72285184)
print v(xbgr.mr_n72285776)
print v(xbgr.mr_n72286368)
print v(xbgr.mr_n72286960)
print v(xbgr.mr_n72287552)
print v(xbgr.mr_n72288144)
print v(xbgr.mr_n72288736)
print v(xbgr.mr_n72289328)
print v(xbgr.mr_n72289920)
print v(xbgr.mr_n72293280)
print v(xbgr.mr_n72297168)
print v(xbgr.mr_n72298832)
print v(xbgr.mr_n72299376)
print v(xbgr.mr_n72299808)
print v(xbgr.mr_n72300224)
print v(xbgr.mr_n72300336)
print v(xbgr.mr_n72301040)
print v(xbgr.mr_n72301568)
print v(xbgr.mr_n72302544)
print v(xbgr.mr_n72302656)
print v(xbgr.mr_n72303120)
print v(xbgr.mr_n72303792)
print v(xbgr.mr_n72303984)
print v(xbgr.mr_n72304928)
print v(xbgr.mr_n72308000)
print v(xbgr.mr_n72308352)
print v(xbgr.mr_n72308464)
print v(xbgr.mr_n72309168)
print v(xbgr.mr_n72311344)
print v(xbgr.mr_n72311760)
print v(xbgr.mr_n72311872)
print v(xbgr.mr_n72312576)
print v(xbgr.mr_n72314752)
print v(xbgr.mr_n72315168)
print v(xbgr.mr_n72315280)
print v(xbgr.mr_n72315984)
print v(xbgr.mr_n72318032)
print v(xbgr.mr_n72318224)
print v(xbgr.mr_n72318576)
print v(xbgr.mr_n72318688)
print v(xbgr.mr_n72319392)
print v(xbgr.mr_n72321632)
print v(xbgr.mr_n72321984)
print v(xbgr.mr_n72322096)
print v(xbgr.mr_n72322800)
print v(xbgr.mr_n72325040)
print v(xbgr.mr_n72325392)
print v(xbgr.mr_n72325504)
print v(xbgr.mr_n72326208)
print v(xbgr.mr_n72328448)
print v(xbgr.mr_n72328800)
print v(xbgr.mr_n72328912)
print v(xbgr.mr_n72329616)
print v(xbgr.mr_n72340944)
print v(xbgr.mr_n72343440)
print v(xbgr.mr_n72343616)
print v(xbgr.mr_n72344240)
print v(xbgr.mr_n72344416)
print v(xbgr.mr_n72345040)
print v(xbgr.mr_n72345216)
print v(xbgr.mr_n72345840)
print v(xbgr.mr_n72346016)
print v(xbgr.mr_n72346640)
print v(xbgr.mr_n72346816)
print v(xbgr.mr_n72347440)
print v(xbgr.mr_n72347616)
print v(xbgr.mr_n72348240)
print v(xbgr.mr_n72348416)
print v(xbgr.mr_n72349040)
print v(xbgr.mr_n72349216)
print v(xbgr.mr_n72349840)
print v(xbgr.mr_n72350016)
print v(xbgr.mr_n72350640)
print v(xbgr.mr_n72350816)
print v(xbgr.mr_n72351440)
print v(xbgr.mr_n72351616)
print v(xbgr.mr_n72352240)
print v(xbgr.mr_n72352416)
print v(xbgr.mr_n72353040)
print v(xbgr.mr_n72353216)
print v(xbgr.mr_n72353840)
print v(xbgr.mr_n72354016)
print v(xbgr.mr_n72354640)
print v(xbgr.mr_n72354816)
print v(xbgr.mr_n72355440)
print v(xbgr.mr_n72355616)
print v(xbgr.mr_n72356048)
print v(xbgr.mr_n72356160)
print v(xbgr.mr_n72356272)
print v(xbgr.mr_n72356384)
print v(xbgr.mr_n72356576)
print v(xbgr.mr_n72356848)
print v(xbgr.mr_n72357120)
print v(xbgr.mr_n72357392)
print v(xbgr.mr_n72357664)
print v(xbgr.mr_n72357936)
print v(xbgr.mr_n72358208)
print v(xbgr.mr_n72358480)
print v(xbgr.mr_n72358752)
print v(xbgr.mr_n72359024)
print v(xbgr.mr_n72359296)
print v(xbgr.mr_n72359568)
print v(xbgr.mr_n72359840)
print v(xbgr.mr_n72363232)
print v(xbgr.mr_n72365136)
print v(xbgr.mr_n72366944)
print v(xbgr.mr_n72369344)
print v(xbgr.mr_n72377264)
print v(xbgr.mr_n72379152)
print v(xbgr.mr_n72397328)
print v(xbgr.mr_n72397504)
print v(xbgr.mr_n72397840)
print v(xbgr.mr_n72399680)
print v(xbgr.mr_n72399856)
print v(xbgr.mr_n72400800)
print v(xbgr.mr_n72401456)
print v(xbgr.mr_n72401632)
print v(xbgr.mr_n72402576)
print v(xbgr.mr_n72403232)
print v(xbgr.mr_n72403408)
print v(xbgr.mr_n72404352)
print v(xbgr.mr_n72405008)
print v(xbgr.mr_n72405184)
print v(xbgr.mr_n72406128)
print v(xbgr.mr_n72406784)
print v(xbgr.mr_n72406960)
print v(xbgr.mr_n72407904)
print v(xbgr.mr_n72408560)
print v(xbgr.mr_n72408736)
print v(xbgr.mr_n72409680)
print v(xbgr.mr_n72410336)
print v(xbgr.mr_n72410512)
print v(xbgr.mr_n72411456)
print v(xbgr.mr_n72412112)
print v(xbgr.mr_n72412288)
print v(xbgr.mr_n72413232)
print v(xbgr.mr_n72413888)
print v(xbgr.mr_n72414064)
print v(xbgr.mr_n72415008)
print v(xbgr.mr_n72415664)
print v(xbgr.mr_n72415840)
print v(xbgr.mr_n72416880)
print v(xbgr.mr_n72417152)
print v(xbgr.mr_n72417424)
print v(xbgr.mr_n72417760)
print v(xbgr.mr_n72418224)
print v(xbgr.mr_n72418576)
print v(xbgr.mr_n72418768)
print v(xbgr.mr_n72418960)
print v(xbgr.mr_n72419152)
print v(xbgr.mr_n72419904)
print v(xbgr.mr_n72423488)
print v(xbgr.mr_n72423904)
print v(xbgr.mr_n72424016)
print v(xbgr.mr_n72424720)
print v(xbgr.mr_n72426896)
print v(xbgr.mr_n72427312)
print v(xbgr.mr_n72427424)
print v(xbgr.mr_n72428128)
print v(xbgr.mr_n72430304)
print v(xbgr.mr_n72430720)
print v(xbgr.mr_n72430832)
print v(xbgr.mr_n72431536)
print v(xbgr.mr_n72433712)
print v(xbgr.mr_n72434128)
print v(xbgr.mr_n72434240)
print v(xbgr.mr_n72434944)
print v(xbgr.mr_n72435056)
print v(xbgr.mr_n72437184)
print v(xbgr.mr_n72437536)
print v(xbgr.mr_n72437728)
print v(xbgr.mr_n72438272)
print v(xbgr.mr_n72438704)
print v(xbgr.mr_n72439536)
print v(xbgr.mr_n72439888)
print v(xbgr.mr_n72440000)
print v(xbgr.mr_n72440704)
print v(xbgr.mr_n72444480)
print v(xbgr.mr_n72444832)
print v(xbgr.mr_n72444944)
print v(xbgr.mr_n72445648)
print v(xbgr.mr_n72447824)
print v(xbgr.mr_n72448240)
print v(xbgr.mr_n72448352)
print v(xbgr.mr_n72449056)
print v(xbgr.mr_n72450016)
print v(xbgr.mr_n72451232)
print v(xbgr.mr_n72451648)
print v(xbgr.mr_n72451760)
print v(xbgr.mr_n72452464)
print v(xbgr.mr_n72464384)
print v(xbgr.mr_n72464560)
print v(xbgr.mr_n72465184)
print v(xbgr.mr_n72465360)
print v(xbgr.mr_n72465984)
print v(xbgr.mr_n72466160)
print v(xbgr.mr_n72466784)
print v(xbgr.mr_n72466960)
print v(xbgr.mr_n72467584)
print v(xbgr.mr_n72467760)
print v(xbgr.mr_n72468384)
print v(xbgr.mr_n72468560)
print v(xbgr.mr_n72469184)
print v(xbgr.mr_n72469360)
print v(xbgr.mr_n72469984)
print v(xbgr.mr_n72470160)
print v(xbgr.mr_n72470784)
print v(xbgr.mr_n72470960)
print v(xbgr.mr_n72471584)
print v(xbgr.mr_n72471760)
print v(xbgr.mr_n72472384)
print v(xbgr.mr_n72472560)
print v(xbgr.mr_n72473184)
print v(xbgr.mr_n72473360)
print v(xbgr.mr_n72473984)
print v(xbgr.mr_n72474160)
print v(xbgr.mr_n72474784)
print v(xbgr.mr_n72474960)
print v(xbgr.mr_n72475584)
print v(xbgr.mr_n72475760)
print v(xbgr.mr_n72476384)
print v(xbgr.mr_n72476560)
print v(xbgr.mr_n72478400)
print v(xbgr.mr_n72480288)
print v(xbgr.mr_n72485776)
print v(xbgr.mr_n72488192)
print v(xbgr.mr_n72488496)
print v(xbgr.mr_n72488800)
print v(xbgr.mr_n72489104)
print v(xbgr.mr_n72489488)
print v(xbgr.mr_n72489952)
print v(xbgr.mr_n72490416)
print v(xbgr.mr_n72490880)
print v(xbgr.mr_n72491344)
print v(xbgr.mr_n72491808)
print v(xbgr.mr_n72492272)
print v(xbgr.mr_n72492736)
print v(xbgr.mr_n72493200)
print v(xbgr.mr_n72493664)
print v(xbgr.mr_n72494128)
print v(xbgr.mr_n72494592)
print v(xbgr.mr_n72495056)
print v(xbgr.mr_n72495520)
print v(xbgr.mr_n72495984)
print v(xbgr.mr_n72496448)
print v(xbgr.mr_n72496912)
print v(xbgr.mr_n72497376)
print v(xbgr.mr_n72497840)
print v(xbgr.mr_n72498304)
print v(xbgr.mr_n72498768)
print v(xbgr.mr_n72499232)
print v(xbgr.mr_n72499696)
print v(xbgr.mr_n72500160)
print v(xbgr.mr_n72500624)
print v(xbgr.mr_n72501088)
print v(xbgr.mr_n72504544)
print v(xbgr.mr_n72512224)
print v(xbgr.mr_n72520720)
print v(xbgr.mr_n72525072)
print v(xbgr.mr_n72525680)
print v(xbgr.mr_n72526144)
print v(xbgr.mr_n72526608)
print v(xbgr.mr_n72527136)
print v(xbgr.mr_n72527728)
print v(xbgr.mr_n72528320)
print v(xbgr.mr_n72528912)
print v(xbgr.mr_n72529504)
print v(xbgr.mr_n72530096)
print v(xbgr.mr_n72530688)
print v(xbgr.mr_n72531280)
print v(xbgr.mr_n72531872)
print v(xbgr.mr_n72532464)
print v(xbgr.mr_n72533056)
print v(xbgr.mr_n72533648)
print v(xbgr.mr_n72534240)
print v(xbgr.mr_n72534832)
print v(xbgr.mr_n72538880)
print v(xbgr.mr_n72542384)
print v(xbgr.mr_n72542960)
print v(xbgr.mr_n72544800)
print v(xbgr.mr_n72545568)
print v(xbgr.mr_n72545824)
print v(xbgr.mr_n72545936)
print v(xbgr.mr_n72557360)
print v(xbgr.mr_n72557552)
print v(xbgr.mr_n72557808)
print v(xbgr.mr_n72558064)
print v(xbgr.mr_n72560224)
print v(xbgr.mr_n72583072)
print v(xbgr.mr_n72586640)
print v(xbgr.mr_n72600096)
print v(xbgr.mr_n72604912)
print v(xbgr.mr_n72617744)
print v(xbgr.mr_n72618688)
print v(xbgr.mr_n72621600)
print v(xbgr.mr_n72625168)
print v(xbgr.mr_n72627184)
print v(xbgr.mr_n72627776)
print v(xbgr.mr_n72628368)
print v(xbgr.mr_n72628960)
print v(xbgr.mr_n72629552)
print v(xbgr.mr_n72630144)
print v(xbgr.mr_n72630736)
print v(xbgr.mr_n72631328)
print v(xbgr.mr_n72631920)
print v(xbgr.mr_n72632512)
print v(xbgr.mr_n72633104)
print v(xbgr.mr_n72633696)
print v(xbgr.mr_n72635120)
print v(xbgr.mr_n72637104)
print v(xbgr.mr_n72637568)
print v(xbgr.mr_n72639536)
print v(xbgr.mr_n72641168)
print v(xbgr.mr_n72641344)
print v(xbgr.mr_n72641520)
print v(xbgr.mr_n72643312)
print v(xbgr.mr_n72643840)
print v(xbgr.mr_n72647776)
print v(xbgr.mr_n72648112)
print v(xbgr.mr_n72648448)
print v(xbgr.mr_n72650032)
print v(xbgr.mr_n72650928)
print v(xbgr.mr_n72651104)
print v(xbgr.mr_n72651616)
print v(xbgr.mr_n72652112)
print v(xbgr.mr_n72652288)
print v(xbgr.mr_n72652624)
print v(xbgr.mr_n72653216)
print v(xbgr.mr_n72653712)
print v(xbgr.mr_n72653888)
print v(xbgr.mr_n72654560)
print v(xbgr.mr_n72654672)
print v(xbgr.mr_n72654784)
print v(xbgr.mr_n72655776)
print v(xbgr.mr_n72656192)
print v(xbgr.mr_n72656704)
print v(xbgr.mr_n72657200)
print v(xbgr.mr_n72657376)
print v(xbgr.mr_n72657712)
print v(xbgr.mr_n72658304)
print v(xbgr.mr_n72658864)
print v(xbgr.mr_n72659040)
print v(xbgr.mr_n72659296)
print v(xbgr.mr_n72660304)
print v(xbgr.mr_n72660480)
print v(xbgr.mr_n72660656)
print v(xbgr.mr_n72661248)
print v(xbgr.mr_n72661360)
print v(xbgr.mr_n72661472)
print v(xbgr.mr_n72661584)
print v(xbgr.mr_n72663072)
print v(xbgr.mr_n72663248)
print v(xbgr.mr_n72663824)
print v(xbgr.mr_n72664528)
print v(xbgr.mr_n72664704)
print v(xbgr.mr_n72665136)
print v(xbgr.mr_n72665248)
print v(xbgr.mr_n72666080)
print v(xbgr.mr_n72666256)
print v(xbgr.mr_n72666512)
print v(xbgr.mr_n72667088)
print v(xbgr.mr_n72667872)
print v(xbgr.mr_n72668048)
print v(xbgr.mr_n72668480)
print v(xbgr.mr_n72669040)
print v(xbgr.mr_n72669216)
print v(xbgr.mr_n72669712)
print v(xbgr.mr_n72670224)
print v(xbgr.mr_n72670336)
print v(xbgr.mr_n72671040)
print v(xbgr.mr_n72671456)
print v(xbgr.mr_n72671968)
print v(xbgr.mr_n72672464)
print v(xbgr.mr_n72672640)
print v(xbgr.mr_n72673056)
print v(xbgr.mr_n72673568)
print v(xbgr.mr_n72674064)
print v(xbgr.mr_n72674400)
print v(xbgr.mr_n72674912)
print v(xbgr.mr_n72675024)
print v(xbgr.mr_n72675136)
print v(xbgr.mr_n72676256)
print v(xbgr.mr_n72676432)
print v(xbgr.mr_n72676688)
print v(xbgr.mr_n72677344)
print v(xbgr.mr_n72677856)
print v(xbgr.mr_n72677968)
print v(xbgr.mr_n72678160)
print v(xbgr.mr_n72678512)
print v(xbgr.mr_n72678624)
print v(xbgr.mr_n72679136)
print v(xbgr.mr_n72679248)
print v(xbgr.mr_n72679360)
print v(xbgr.mr_n72679712)
print v(xbgr.mr_n72680048)
print v(xbgr.mr_n72680992)
print v(xbgr.mr_n72681408)
print v(xbgr.mr_n72681520)
print v(xbgr.mr_n72682080)
print v(xbgr.mr_n72682336)
print v(xbgr.mr_n72683152)
print v(xbgr.mr_n72683584)
print v(xbgr.mr_n72683760)
print v(xbgr.mr_n72684688)
print v(xbgr.mr_n72684864)
print v(xbgr.mr_n72685440)
print v(xbgr.mr_n72685552)
print v(xbgr.mr_n72685664)
print v(xbgr.mr_n72686432)
print v(xbgr.mr_n72686768)
print v(xbgr.mr_n72687712)
print v(xbgr.mr_n72688128)
print v(xbgr.mr_n72688240)
print v(xbgr.mr_n72688800)
print v(xbgr.mr_n72689056)
print v(xbgr.mr_n72690000)
print v(xbgr.mr_n72690416)
print v(xbgr.mr_n72690528)
print v(xbgr.mr_n72690640)
print v(xbgr.mr_n72691408)
print v(xbgr.mr_n72691744)
print v(xbgr.mr_n72692752)
print v(xbgr.mr_n72692928)
print v(xbgr.mr_n72693504)
print v(xbgr.mr_n72693936)
print v(xbgr.mr_n72694112)
print v(xbgr.mr_n72694848)
print v(xbgr.mr_n72694960)
print v(xbgr.mr_n72695520)
print v(xbgr.mr_n72695776)
print v(xbgr.mr_n72696720)
print v(xbgr.mr_n72697136)
print v(xbgr.mr_n72697248)
print v(xbgr.mr_n72697360)
print v(xbgr.mr_n72698128)
print v(xbgr.mr_n72698464)
print v(xbgr.mr_n72699280)
print v(xbgr.mr_n72699392)
print v(xbgr.mr_n72699584)
print v(xbgr.mr_n72699952)
print v(xbgr.mr_n72700208)
print v(xbgr.mr_n72701152)
print v(xbgr.mr_n72701568)
print v(xbgr.mr_n72701680)
print v(xbgr.mr_n72702240)
print v(xbgr.mr_n72702496)
print v(xbgr.mr_n72703312)
print v(xbgr.mr_n72703744)
print v(xbgr.mr_n72703920)
print v(xbgr.mr_n72708192)
print v(xbgr.mr_n72708736)
print v(xbgr.mr_n72709184)
print v(xbgr.mr_n72709632)
print v(xbgr.mr_n72710096)
print v(xbgr.mr_n72710560)
print v(xbgr.mr_n72711024)
print v(xbgr.mr_n72711488)
print v(xbgr.mr_n72711952)
print v(xbgr.mr_n72712416)
print v(xbgr.mr_n72712880)
print v(xbgr.mr_n72713344)
print v(xbgr.mr_n72713808)
print v(xbgr.mr_n72714272)
print v(xbgr.mr_n72714736)
print v(xbgr.mr_n72715200)
print v(xbgr.mr_n72715664)
print v(xbgr.mr_n72716128)
print v(xbgr.mr_n72716592)
print v(xbgr.mr_n72717056)
print v(xbgr.mr_n72717504)
print v(xbgr.mr_n72717968)
print v(xbgr.mr_n72718432)
print v(xbgr.mr_n72718896)
print v(xbgr.mr_n72719360)
print v(xbgr.mr_n72719824)
print v(xbgr.mr_n72722256)
print v(xbgr.mr_n72724032)
print v(xbgr.mr_n72727360)
print v(xbgr.mr_n72739616)
print v(xbgr.mr_n72741200)
print v(xbgr.mr_n72741344)
print v(xbgr.mr_n72744864)
print v(xbgr.mr_n72751488)
print v(xbgr.mr_n72753856)
print v(xbgr.mr_n72758272)
print v(xbgr.mr_n72760256)
print v(xbgr.mr_n72761648)
print v(xbgr.mr_n72763392)
print v(xbgr.mr_n72763728)
print v(xbgr.mr_n72764064)
print v(xbgr.mr_n72764400)
print v(xbgr.mr_n72766432)
print v(xbgr.mr_n72767072)
print v(xbgr.mr_n72767184)
print v(xbgr.mr_n72768880)
print v(xbgr.mr_n72768992)
print v(xbgr.mr_n72770688)
print v(xbgr.mr_n72770800)
print v(xbgr.mr_n72772496)
print v(xbgr.mr_n72772608)
print v(xbgr.mr_n72774304)
print v(xbgr.mr_n72774416)
print v(xbgr.mr_n72776112)
print v(xbgr.mr_n72776224)
print v(xbgr.mr_n72777920)
print v(xbgr.mr_n72778032)
print v(xbgr.mr_n72779728)
print v(xbgr.mr_n72779840)
print v(xbgr.mr_n72781536)
print v(xbgr.mr_n72781648)
print v(xbgr.mr_n72783344)
print v(xbgr.mr_n72783456)
print v(xbgr.mr_n72785152)
print v(xbgr.mr_n72785264)
print v(xbgr.mr_n72786960)
print v(xbgr.mr_n72787072)
print v(xbgr.mr_n72788768)
print v(xbgr.mr_n72788880)
print v(xbgr.mr_n72790576)
print v(xbgr.mr_n72790688)
print v(xbgr.mr_n72792384)
print v(xbgr.mr_n72792496)
print v(xbgr.mr_n72794192)
print v(xbgr.mr_n72794304)
print v(xbgr.mr_n72796000)
print v(xbgr.mr_n72796112)
print v(xbgr.mr_n72801552)
print v(xbgr.mr_n72807552)
print v(xbgr.mr_n72807952)
print v(xbgr.mr_n72812560)
print v(xbgr.mr_n72813248)
print v(xbgr.mr_n72817216)
print v(xbgr.mr_n72818944)
print v(xbgr.mr_n72822112)
print v(xbgr.mr_n72822576)
print v(xbgr.mr_n72822688)
print v(xbgr.mr_n72823504)
print v(xbgr.mr_n72823968)
print v(xbgr.mr_n72824080)
print v(xbgr.mr_n72824896)
print v(xbgr.mr_n72825424)
print v(xbgr.mr_n72825600)
print v(xbgr.mr_n72826544)
print v(xbgr.mr_n72827200)
print v(xbgr.mr_n72827376)
print v(xbgr.mr_n72828320)
print v(xbgr.mr_n72828976)
print v(xbgr.mr_n72829152)
print v(xbgr.mr_n72830096)
print v(xbgr.mr_n72830752)
print v(xbgr.mr_n72830928)
print v(xbgr.mr_n72831872)
print v(xbgr.mr_n72832528)
print v(xbgr.mr_n72832704)
print v(xbgr.mr_n72833648)
print v(xbgr.mr_n72834304)
print v(xbgr.mr_n72834480)
print v(xbgr.mr_n72835424)
print v(xbgr.mr_n72836080)
print v(xbgr.mr_n72836256)
print v(xbgr.mr_n72837200)
print v(xbgr.mr_n72837792)
print v(xbgr.mr_n72838384)
print v(xbgr.mr_n72838976)
print v(xbgr.mr_n72839568)
print v(xbgr.mr_n72840160)
print v(xbgr.mr_n72840752)
print v(xbgr.mr_n72841344)
print v(xbgr.mr_n72841936)
print v(xbgr.mr_n72842320)
print v(xbgr.mr_n72842528)
print v(xbgr.mr_n72843120)
print v(xbgr.mr_n72843232)
print v(xbgr.mr_n72843344)
print v(xbgr.mr_n72843456)
print v(xbgr.mr_n72843568)
print v(xbgr.mr_n72843680)
print v(xbgr.mr_n72844112)
print v(xbgr.mr_n72844384)
print v(xbgr.mr_n72845520)
print v(xbgr.mr_n72846496)
print v(xbgr.mr_n72847088)
print v(xbgr.mr_n72847680)
print v(xbgr.mr_n72848272)
print v(xbgr.mr_n72848864)
print v(xbgr.mr_n72849456)
print v(xbgr.mr_n72850048)
print v(xbgr.mr_n72850640)
print v(xbgr.mr_n72851232)
print v(xbgr.mr_n72851824)
print v(xbgr.mr_n72852416)
print v(xbgr.mr_n72853008)
print v(xbgr.mr_n72853600)
print v(xbgr.mr_n72854192)
print v(xbgr.mr_n72854784)
print v(xbgr.mr_n72855392)
print v(xbgr.mr_n72863312)
print v(xbgr.mr_n72871344)
print v(xbgr.mr_n72871680)
print v(xbgr.mr_n72872096)
print v(xbgr.mr_n72872848)
print v(xbgr.mr_n72872960)
print v(xbgr.mr_n72874656)
print v(xbgr.mr_n72874768)
print v(xbgr.mr_n72876464)
print v(xbgr.mr_n72876576)
print v(xbgr.mr_n72878272)
print v(xbgr.mr_n72878384)
print v(xbgr.mr_n72880080)
print v(xbgr.mr_n72880192)
print v(xbgr.mr_n72881888)
print v(xbgr.mr_n72882000)
print v(xbgr.mr_n72883696)
print v(xbgr.mr_n72883808)
print v(xbgr.mr_n72885504)
print v(xbgr.mr_n72885616)
print v(xbgr.mr_n72887312)
print v(xbgr.mr_n72887424)
print v(xbgr.mr_n72889120)
print v(xbgr.mr_n72889232)
print v(xbgr.mr_n72890928)
print v(xbgr.mr_n72891040)
print v(xbgr.mr_n72891152)
print v(xbgr.mr_n72892992)
print v(xbgr.mr_n72893104)
print v(xbgr.mr_n72893216)
print v(xbgr.mr_n72895056)
print v(xbgr.mr_n72895168)
print v(xbgr.mr_n72895280)
print v(xbgr.mr_n72897120)
print v(xbgr.mr_n72897232)
print v(xbgr.mr_n72897344)
print v(xbgr.mr_n72899184)
print v(xbgr.mr_n72899296)
print v(xbgr.mr_n72899408)
print v(xbgr.mr_n72901248)
print v(xbgr.mr_n72901360)
print v(xbgr.mr_n72901472)
print v(xbgr.mr_n72903312)
print v(xbgr.mr_n72903424)
print v(xbgr.mr_n72903536)
print v(xbgr.mr_n72904688)
print v(xbgr.mr_n72905200)
print v(xbgr.mr_n72905744)
print v(xbgr.mr_n72906288)
print v(xbgr.mr_n72906832)
print v(xbgr.mr_n72907376)
print v(xbgr.mr_n72907920)
print v(xbgr.mr_n72908304)
print v(xbgr.mr_n72908688)
print v(xbgr.mr_n72909232)
print v(xbgr.mr_n72909776)
print v(xbgr.mr_n72910320)
print v(xbgr.mr_n72910864)
print v(xbgr.mr_n72911408)
print v(xbgr.mr_n72911952)
print v(xbgr.mr_n72912496)
print v(xbgr.mr_n72913040)
print v(xbgr.mr_n72913584)
print v(xbgr.mr_n72914128)
print v(xbgr.mr_n72914672)
print v(xbgr.mr_n72915216)
print v(xbgr.mr_n72915680)
print v(xbgr.mr_n72916224)
print v(xbgr.mr_n72916768)
print v(xbgr.mr_n72917312)
print v(xbgr.mr_n72917856)
print v(xbgr.mr_n72918400)
print v(xbgr.mr_n72919328)
print v(xbgr.mr_n72919632)
print v(xbgr.mr_n72920016)
print v(xbgr.mr_n72920480)
print v(xbgr.mr_n72920944)
print v(xbgr.mr_n72921408)
print v(xbgr.mr_n72921872)
print v(xbgr.mr_n72922336)
print v(xbgr.mr_n72922800)
print v(xbgr.mr_n72923264)
print v(xbgr.mr_n72923728)
print v(xbgr.mr_n72924192)
print v(xbgr.mr_n72924656)
print v(xbgr.mr_n72925120)
print v(xbgr.mr_n72925584)
print v(xbgr.mr_n72926048)
print v(xbgr.mr_n72926512)
print v(xbgr.mr_n72926976)
print v(xbgr.mr_n72927440)
print v(xbgr.mr_n72927904)
print v(xbgr.mr_n72928368)
print v(xbgr.mr_n72928832)
print v(xbgr.mr_n72929296)
print v(xbgr.mr_n72929792)
print v(xbgr.mr_n72930384)
print v(xbgr.mr_n72930976)
print v(xbgr.mr_n72931568)
print v(xbgr.mr_n72932160)
print v(xbgr.mr_n72932752)
print v(xbgr.mr_n72933344)
print v(xbgr.mr_n72933856)
print v(xbgr.mr_n72934336)
print v(xbgr.mr_n72934528)
print v(xbgr.mr_n72938528)
print v(xbgr.mr_n72947136)
print v(xbgr.mr_n72955376)
print v(xbgr.mr_n72956256)
print v(xbgr.mr_n72956640)
print v(xbgr.mr_n72957088)
print v(xbgr.mr_n72967760)
print v(xbgr.mr_n72969440)
print v(xbgr.mr_n72980336)
print v(xbgr.mr_n72987504)
print v(xbgr.mr_n72990384)
print v(xbgr.mr_n72990656)
print v(xbgr.mr_n72990832)
print v(xbgr.mr_n72991696)
print v(xbgr.mr_n72996144)
print v(xbgr.mr_n72996320)
print v(xbgr.mr_n73000496)
print v(xbgr.mr_n73001184)
print v(xbgr.mr_n73005536)
print v(xbgr.mr_n73005712)
print v(xbgr.mr_n73005888)
print v(xbgr.mr_n73008672)
print v(xbgr.mr_n73008928)
print v(xbgr.mr_n73009536)
print v(xbgr.mr_n73012576)
print v(xbgr.mr_n73013888)
print v(xbgr.mr_n73014064)
print v(xbgr.mr_n73014240)
print v(xbgr.mr_n73015440)
print v(xbgr.mr_n73019888)
print v(xbgr.mr_n73020064)
print v(xbgr.mr_n73024064)
print v(xbgr.mr_n73025104)
print v(xbgr.mr_n73027552)
print v(xbgr.mr_n73027968)
print v(xbgr.mr_n73029280)
print v(xbgr.mr_n73029728)
print v(xbgr.mr_n73030944)
print v(xbgr.mr_n73031120)
print v(xbgr.mr_n73033040)
print v(xbgr.mr_n73038272)
print v(xbgr.mr_n73040112)
print v(xbgr.mr_n73043728)
print v(xbgr.mr_n73044064)
print v(xbgr.mr_n73044400)
print v(xbgr.mr_n73044736)
print v(xbgr.mr_n73045152)
print v(xbgr.mr_n73045392)
print v(xbgr.mr_n73045696)
print v(xbgr.mr_n73046288)
print v(xbgr.mr_n73046400)
print v(xbgr.mr_n73046512)
print v(xbgr.mr_n73048352)
print v(xbgr.mr_n73048464)
print v(xbgr.mr_n73048576)
print v(xbgr.mr_n73050416)
print v(xbgr.mr_n73050528)
print v(xbgr.mr_n73050640)
print v(xbgr.mr_n73052480)
print v(xbgr.mr_n73052592)
print v(xbgr.mr_n73052704)
print v(xbgr.mr_n73054544)
print v(xbgr.mr_n73054656)
print v(xbgr.mr_n73054768)
print v(xbgr.mr_n73056608)
print v(xbgr.mr_n73056720)
print v(xbgr.mr_n73056832)
print v(xbgr.mr_n73058672)
print v(xbgr.mr_n73058784)
print v(xbgr.mr_n73058896)
print v(xbgr.mr_n73060736)
print v(xbgr.mr_n73060848)
print v(xbgr.mr_n73060960)
print v(xbgr.mr_n73062800)
print v(xbgr.mr_n73062912)
print v(xbgr.mr_n73063024)
print v(xbgr.mr_n73064864)
print v(xbgr.mr_n73064976)
print v(xbgr.mr_n73065088)
print v(xbgr.mr_n73066928)
print v(xbgr.mr_n73067040)
print v(xbgr.mr_n73067152)
print v(xbgr.mr_n73068992)
print v(xbgr.mr_n73069104)
print v(xbgr.mr_n73069216)
print v(xbgr.mr_n73071056)
print v(xbgr.mr_n73071168)
print v(xbgr.mr_n73071280)
print v(xbgr.mr_n73073824)
print v(xbgr.mr_n73073936)
print v(xbgr.mr_n73074304)
print v(xbgr.mr_n73076000)
print v(xbgr.mr_n73077808)
print v(xbgr.mr_n73077920)
print v(xbgr.mr_n73078288)
print v(xbgr.mr_n73081792)
print v(xbgr.mr_n73081904)
print v(xbgr.mr_n73082272)
print v(xbgr.mr_n73085776)
print v(xbgr.mr_n73085888)
print v(xbgr.mr_n73086256)
print v(xbgr.mr_n73086432)
print v(xbgr.mr_n73088848)
print v(xbgr.mr_n73088960)
print v(xbgr.mr_n73090464)
print v(xbgr.mr_n73091184)
print v(xbgr.mr_n73091360)
print v(xbgr.mr_n73092928)
print v(xbgr.mr_n73093744)
print v(xbgr.mr_n73093920)
print v(xbgr.mr_n73095488)
print v(xbgr.mr_n73096304)
print v(xbgr.mr_n73096480)
print v(xbgr.mr_n73098048)
print v(xbgr.mr_n73098864)
print v(xbgr.mr_n73099040)
print v(xbgr.mr_n73100608)
print v(xbgr.mr_n73101424)
print v(xbgr.mr_n73101600)
print v(xbgr.mr_n73103168)
print v(xbgr.mr_n73103984)
print v(xbgr.mr_n73104160)
print v(xbgr.mr_n73105728)
print v(xbgr.mr_n73106544)
print v(xbgr.mr_n73106720)
print v(xbgr.mr_n73108288)
print v(xbgr.mr_n73109104)
print v(xbgr.mr_n73109280)
print v(xbgr.mr_n73110848)
print v(xbgr.mr_n73111664)
print v(xbgr.mr_n73111840)
print v(xbgr.mr_n73113408)
print v(xbgr.mr_n73113584)
print v(xbgr.mr_n73114704)
print v(xbgr.mr_n73115200)
print v(xbgr.mr_n73115696)
print v(xbgr.mr_n73115968)
print v(xbgr.mr_n73116608)
print v(xbgr.mr_n73117552)
print v(xbgr.mr_n73118048)
print v(xbgr.mr_n73118160)
print v(xbgr.mr_n73120784)
print v(xbgr.mr_n73121952)
print v(xbgr.mr_n73122128)
print v(xbgr.mr_n73123696)
print v(xbgr.mr_n73124512)
print v(xbgr.mr_n73124688)
print v(xbgr.mr_n73126256)
print v(xbgr.mr_n73127072)
print v(xbgr.mr_n73127248)
print v(xbgr.mr_n73128816)
print v(xbgr.mr_n73129632)
print v(xbgr.mr_n73129808)
print v(xbgr.mr_n73131376)
print v(xbgr.mr_n73132192)
print v(xbgr.mr_n73132368)
print v(xbgr.mr_n73133936)
print v(xbgr.mr_n73134752)
print v(xbgr.mr_n73134928)
print v(xbgr.mr_n73135232)
print v(xbgr.mr_n73136496)
print v(xbgr.mr_n73137312)
print v(xbgr.mr_n73137488)
print v(xbgr.mr_n73139056)
print v(xbgr.mr_n73139872)
print v(xbgr.mr_n73140048)
print v(xbgr.mr_n73141616)
print v(xbgr.mr_n73142432)
print v(xbgr.mr_n73142608)
print v(xbgr.mr_n73143376)
print v(xbgr.mr_n73144176)
print v(xbgr.mr_n73144992)
print v(xbgr.mr_n73145168)
print v(xbgr.mr_n73146736)
print v(xbgr.mr_n73147552)
print v(xbgr.mr_n73147728)
print v(xbgr.mr_n73149296)
print v(xbgr.mr_n73150112)
print v(xbgr.mr_n73150288)
print v(xbgr.mr_n73151856)
print v(xbgr.mr_n73152672)
print v(xbgr.mr_n73152848)
print v(xbgr.mr_n73154416)
print v(xbgr.mr_n73155232)
print v(xbgr.mr_n73155408)
print v(xbgr.mr_n73156976)
print v(xbgr.mr_n73231872)
print v(xbgr.mr_n73234688)
print v(xbgr.mr_n73240720)
print v(xbgr.mr_n73241568)
print v(xbgr.mr_n73245568)
print v(xbgr.mr_n73246288)
print v(xbgr.mr_n73249744)
print v(xbgr.mr_n73262976)
print v(xbgr.mr_n73267120)
print v(xbgr.mr_n73267392)
print v(xbgr.mr_n73269280)
print v(xbgr.mr_n73270944)
print v(xbgr.mr_n73271056)
print v(xbgr.mr_n73272368)
print v(xbgr.mr_n73272896)
print v(xbgr.mr_n73274768)
print v(xbgr.mr_n73375776)
print v(xbgr.mr_n73375888)
print v(xbgr.mr_n73376320)
print v(xbgr.mr_n73376432)
print v(xbgr.mr_n73376864)
print v(xbgr.mr_n73376976)
print v(xbgr.mr_n73377408)
print v(xbgr.mr_n73377520)
print v(xbgr.mr_n73377952)
print v(xbgr.mr_n73378064)
print v(xbgr.mr_n73378496)
print v(xbgr.mr_n73378608)
print v(xbgr.mr_n73379040)
print v(xbgr.mr_n73379152)
print v(xbgr.mr_n73379584)
print v(xbgr.mr_n73379696)
print v(xbgr.mr_n73380128)
print v(xbgr.mr_n73380240)
print v(xbgr.mr_n73380672)
print v(xbgr.mr_n73380784)
print v(xbgr.mr_n73381216)
print v(xbgr.mr_n73381328)
print v(xbgr.mr_n73381760)
print v(xbgr.mr_n73381872)
print v(xbgr.mr_n73382624)
print v(xbgr.mr_n73382736)
print v(xbgr.mr_n73383568)
print v(xbgr.mr_n73383680)
print v(xbgr.mr_n73384496)
print v(xbgr.mr_n73384688)
print v(xbgr.mr_n73384880)
print v(xbgr.mr_n73385584)
print v(xbgr.mr_n73386096)
print v(xbgr.mr_n73386368)
print v(xbgr.mr_n73386736)
print v(xbgr.mr_n73388544)
print v(xbgr.mr_n73391008)
print v(xbgr.mr_n73392016)
print v(xbgr.mr_n73394272)
print v(xbgr.mr_n73397104)
print v(xbgr.mr_n73398592)
print v(xbgr.mr_n73398784)
print v(xbgr.mr_n73401328)
print v(xbgr.mr_n73402944)
print v(xbgr.mr_n73404624)
print v(xbgr.mr_n73406880)
print v(xbgr.mr_n73409136)
print v(xbgr.mr_n73411392)
print v(xbgr.mr_n73413648)
print v(xbgr.mr_n73415904)
print v(xbgr.mr_n73418160)
print v(xbgr.mr_n73420416)
print v(xbgr.mr_n73423168)
print v(xbgr.mr_n73427456)
print v(xbgr.mr_n73431152)
print v(xbgr.mr_n73435200)
print v(xbgr.mr_n73442816)
print v(xbgr.mr_n73442928)
print v(xbgr.mr_n73446288)
print v(xbgr.mr_n73447040)
print v(xbgr.mr_n73447152)
print v(xbgr.mr_n73447616)
print v(xbgr.mr_n73448592)
print v(xbgr.mr_n73449216)
print v(xbgr.mr_n73449856)
print v(xbgr.mr_n73449968)
print v(xbgr.mr_n73450912)
print v(xbgr.mr_n73452064)
print v(xbgr.mr_n73452176)
print v(xbgr.mr_n73452800)
print v(xbgr.mr_n73454336)
print v(xbgr.mr_n73455200)
print v(xbgr.mr_n73456160)
print v(xbgr.mr_n73456272)
print v(xbgr.mr_n73457216)
print v(xbgr.mr_n73458368)
print v(xbgr.mr_n73458480)
print v(xbgr.mr_n73459104)
print v(xbgr.mr_n73460384)
print v(xbgr.mr_n73460640)
print v(xbgr.mr_n73461504)
print v(xbgr.mr_n73462464)
print v(xbgr.mr_n73462576)
print v(xbgr.mr_n73463520)
print v(xbgr.mr_n73464672)
print v(xbgr.mr_n73464784)
print v(xbgr.mr_n73465408)
print v(xbgr.mr_n73466944)
print v(xbgr.mr_n73467808)
print v(xbgr.mr_n73468768)
print v(xbgr.mr_n73468880)
print v(xbgr.mr_n73469824)
print v(xbgr.mr_n73470976)
print v(xbgr.mr_n73471088)
print v(xbgr.mr_n73471712)
print v(xbgr.mr_n73473248)
print v(xbgr.mr_n73474112)
print v(xbgr.mr_n73475072)
print v(xbgr.mr_n73475184)
print v(xbgr.mr_n73476128)
print v(xbgr.mr_n73477280)
print v(xbgr.mr_n73477392)
print v(xbgr.mr_n73478016)
print v(xbgr.mr_n73480192)
print v(xbgr.mr_n73480528)
print v(xbgr.mr_n73482448)
print v(xbgr.mr_n73483008)
print v(xbgr.mr_n73483696)
print v(xbgr.mr_n73484448)
print v(xbgr.mr_n73485392)
print v(xbgr.mr_n73486336)
print v(xbgr.mr_n73487280)
print v(xbgr.mr_n73488224)
print v(xbgr.mr_n73489168)
print v(xbgr.mr_n73490112)
print v(xbgr.mr_n73491056)
print v(xbgr.mr_n73492000)
print v(xbgr.mr_n73492944)
print v(xbgr.mr_n73493888)
print v(xbgr.mr_n73494832)
print v(xbgr.mr_n73495776)
print v(xbgr.mr_n73496720)
print v(xbgr.mr_n73497664)
print v(xbgr.mr_n73498608)
print v(xbgr.mr_n73499552)
print v(xbgr.mr_n73500496)
print v(xbgr.mr_n73501440)
print v(xbgr.mr_n73502384)
print v(xbgr.mr_n73503328)
print v(xbgr.mr_n73504272)
print v(xbgr.mr_n73505216)
print v(xbgr.mr_n73506160)
print v(xbgr.mr_n73507104)
print v(xbgr.mr_n73508048)
print v(xbgr.mr_n73508992)
print v(xbgr.mr_n73509936)
print v(xbgr.mr_n73510880)
print v(xbgr.mr_n73511824)
print v(xbgr.mr_n73512768)
print v(xbgr.mr_n73513712)
print v(xbgr.mr_n73514656)
print v(xbgr.mr_n73515424)
print v(xbgr.mr_n73519792)
print v(xbgr.mr_n73519904)
print v(xbgr.mr_n73521312)
print v(xbgr.mr_n73521424)
print v(xbgr.mr_n73524304)
print v(xbgr.mr_n73524416)
print v(xbgr.mr_n73525568)
print v(xbgr.mr_n73525680)
print v(xbgr.mr_n73526832)
print v(xbgr.mr_n73526944)
print v(xbgr.mr_n73528096)
print v(xbgr.mr_n73528208)
print v(xbgr.mr_n73529360)
print v(xbgr.mr_n73529472)
print v(xbgr.mr_n73530624)
print v(xbgr.mr_n73530736)
print v(xbgr.mr_n73531888)
print v(xbgr.mr_n73532000)
print v(xbgr.mr_n73533152)
print v(xbgr.mr_n73533264)
print v(xbgr.mr_n73534416)
print v(xbgr.mr_n73534528)
print v(xbgr.mr_n73534640)
print v(xbgr.mr_n73536560)
print v(xbgr.mr_n73544064)
print v(xbgr.mr_n73546592)
print v(xbgr.mr_n73548880)
print v(xbgr.mr_n73552176)
print v(xbgr.mr_n73552432)
print v(xbgr.mr_n73552688)
print v(xbgr.mr_n73552944)
print v(xbgr.mr_n73555536)
print v(xbgr.mr_n73555648)
print v(xbgr.mr_n73556224)
print v(xbgr.mr_n73558288)
print v(xbgr.mr_n73559600)
print v(xbgr.mr_n73563888)
print v(xbgr.mr_n73565136)
print v(xbgr.mr_n73565248)
print v(xbgr.mr_n73567248)
print v(xbgr.mr_n73568992)
print v(xbgr.mr_n73569264)
print v(xbgr.mr_n73569456)
print v(xbgr.mr_n73571200)
print v(xbgr.mr_n73572688)
print v(xbgr.mr_n73572880)
print v(xbgr.mr_n73577024)
print v(xbgr.mr_n73577296)
print v(xbgr.mr_n73577488)
print v(xbgr.mr_n73580720)
print v(xbgr.mr_n73580912)
print v(xbgr.mr_n73585056)
print v(xbgr.mr_n73585328)
print v(xbgr.mr_n73585520)
print v(xbgr.mr_n73588752)
print v(xbgr.mr_n73588944)
print v(xbgr.mr_n73593088)
print v(xbgr.mr_n73593360)
print v(xbgr.mr_n73593552)
print v(xbgr.mr_n73597280)
print v(xbgr.mr_n73598528)
print v(xbgr.mr_n73598640)
print v(xbgr.mr_n73601680)
print v(xbgr.mr_n73601872)
print v(xbgr.mr_n73602064)
print v(xbgr.mr_n73603312)
print v(xbgr.mr_n73603424)
print v(xbgr.mr_n73605040)
print v(xbgr.mr_n73607840)
print v(xbgr.mr_n73609088)
print v(xbgr.mr_n73609200)
print v(xbgr.mr_n73616960)
print v(xbgr.mr_n73621136)
print v(xbgr.mr_n73621968)
print v(xbgr.mr_n73622080)
print v(xbgr.mr_n73622912)
print v(xbgr.mr_n73623024)
print v(xbgr.mr_n73623856)
print v(xbgr.mr_n73623968)
print v(xbgr.mr_n73625056)
print v(xbgr.mr_n73625168)
print v(xbgr.mr_n73626320)
print v(xbgr.mr_n73626432)
print v(xbgr.mr_n73627584)
print v(xbgr.mr_n73627696)
print v(xbgr.mr_n73628784)
print v(xbgr.mr_n73628896)
print v(xbgr.mr_n73630112)
print v(xbgr.mr_n73630224)
print v(xbgr.mr_n73631376)
print v(xbgr.mr_n73631488)
print v(xbgr.mr_n73632640)
print v(xbgr.mr_n73632752)
print v(xbgr.mr_n73633904)
print v(xbgr.mr_n73634016)
print v(xbgr.mr_n73635168)
print v(xbgr.mr_n73635280)
print v(xbgr.mr_n73636432)
print v(xbgr.mr_n73636544)
print v(xbgr.mr_n73637696)
print v(xbgr.mr_n73637808)
print v(xbgr.mr_n73638960)
print v(xbgr.mr_n73639072)
print v(xbgr.mr_n73646480)
print v(xbgr.mr_n73647168)
print v(xbgr.mr_n73647856)
print v(xbgr.mr_n73648576)
print v(xbgr.mr_n73649968)
print v(xbgr.mr_n73650576)
print v(xbgr.mr_n73651472)
print v(xbgr.mr_n73651584)
print v(xbgr.mr_n73652368)
print v(xbgr.mr_n73652528)
print v(xbgr.mr_n73653616)
print v(xbgr.mr_n73653728)
print v(xbgr.mr_n73654272)
print v(xbgr.mr_n73655168)
print v(xbgr.mr_n73656000)
print v(xbgr.mr_n73656112)
print v(xbgr.mr_n73658384)
print v(xbgr.mr_n73659728)
print v(xbgr.mr_n73660272)
print v(xbgr.mr_n73661616)
print v(xbgr.mr_n73662160)
print v(xbgr.mr_n73663504)
print v(xbgr.mr_n73664048)
print v(xbgr.mr_n73665392)
print v(xbgr.mr_n73665936)
print v(xbgr.mr_n73667280)
print v(xbgr.mr_n73667824)
print v(xbgr.mr_n73669104)
print v(xbgr.mr_n73669648)
print v(xbgr.mr_n73670288)
print v(xbgr.mr_n73671056)
print v(xbgr.mr_n73671600)
print v(xbgr.mr_n73672944)
print v(xbgr.mr_n73673488)
print v(xbgr.mr_n73674832)
print v(xbgr.mr_n73675696)
print v(xbgr.mr_n73676656)
print v(xbgr.mr_n73676768)
print v(xbgr.mr_n73677712)
print v(xbgr.mr_n73678864)
print v(xbgr.mr_n73678976)
print v(xbgr.mr_n73679920)
print v(xbgr.mr_n73681072)
print v(xbgr.mr_n73681184)
print v(xbgr.mr_n73689104)
print v(xbgr.mr_n73692240)
print v(xbgr.mr_n73692688)
print v(xbgr.mr_n73694976)
print v(xbgr.mr_n73696400)
print v(xbgr.mr_n73696512)
print v(xbgr.mr_n73697392)
print v(xbgr.mr_n73698080)
print v(xbgr.mr_n73698768)
print v(xbgr.mr_n73699488)
print v(xbgr.mr_n73700432)
print v(xbgr.mr_n73700624)
print v(xbgr.mr_n73700816)
print v(xbgr.mr_n73701008)
print v(xbgr.mr_n73701200)
print v(xbgr.mr_n73701392)
print v(xbgr.mr_n73703536)
print v(xbgr.mr_n73703648)
print v(xbgr.mr_n73705664)
print v(xbgr.mr_n73707680)
print v(xbgr.mr_n73707792)
print v(xbgr.mr_n73713440)
print v(xbgr.mr_n73714384)
print v(xbgr.mr_n73717264)
print v(xbgr.mr_n73723984)
print v(xbgr.mr_n73725760)
print v(xbgr.mr_n73725904)
print v(xbgr.mr_n73726080)
print v(xbgr.mr_n73729408)
print v(xbgr.mr_n73730352)
print v(xbgr.mr_n73731296)
print v(xbgr.mr_n73732240)
print v(xbgr.mr_n73733184)
print v(xbgr.mr_n73734128)
print v(xbgr.mr_n73735072)
print v(xbgr.mr_n73736016)
print v(xbgr.mr_n73741568)
print v(xbgr.mr_n73741760)
print v(xbgr.mr_n73742592)
print v(xbgr.mr_n73743104)
print v(xbgr.mr_n73744208)
print v(xbgr.mr_n73744864)
print v(xbgr.mr_n73745056)
print v(xbgr.mr_n73745744)
print v(xbgr.mr_n73746256)
print v(xbgr.mr_n73748016)
print v(xbgr.mr_n73748208)
print v(xbgr.mr_n73748896)
print v(xbgr.mr_n73749408)
print v(xbgr.mr_n73750960)
print v(xbgr.mr_n73751488)
print v(xbgr.mr_n73752048)
print v(xbgr.mr_n73752560)
print v(xbgr.mr_n73754112)
print v(xbgr.mr_n73754640)
print v(xbgr.mr_n73755200)
print v(xbgr.mr_n73755712)
print v(xbgr.mr_n73757264)
print v(xbgr.mr_n73757792)
print v(xbgr.mr_n73758352)
print v(xbgr.mr_n73758864)
print v(xbgr.mr_n73760416)
print v(xbgr.mr_n73760944)
print v(xbgr.mr_n73761504)
print v(xbgr.mr_n73762016)
print v(xbgr.mr_n73763632)
print v(xbgr.mr_n73763824)
print v(xbgr.mr_n73764656)
print v(xbgr.mr_n73765360)
print v(xbgr.mr_n73765920)
print v(xbgr.mr_n73766624)
print v(xbgr.mr_n73767184)
print v(xbgr.mr_n73767760)
print v(xbgr.mr_n73768448)
print v(xbgr.mr_n73768880)
print v(xbgr.mr_n73769712)
print v(xbgr.mr_n73770144)
print v(xbgr.mr_n73770976)
print v(xbgr.mr_n73771552)
print v(xbgr.mr_n73772240)
print v(xbgr.mr_n73772672)
print v(xbgr.mr_n73773504)
print v(xbgr.mr_n73773952)
print v(xbgr.mr_n73775936)
print v(xbgr.mr_n73776624)
print v(xbgr.mr_n73777312)
print v(xbgr.mr_n73779968)
print v(xbgr.mr_n73780160)
print v(xbgr.mr_n73780848)
print v(xbgr.mr_n73781040)
print v(xbgr.mr_n73781616)
print v(xbgr.mr_n73781728)
print v(xbgr.mr_n73782224)
print v(xbgr.mr_n73783632)
print v(xbgr.mr_n73784320)
print v(xbgr.mr_n73784592)
print v(xbgr.mr_n73784704)
print v(xbgr.mr_n73785200)
print v(xbgr.mr_n73785344)
print v(xbgr.mr_n73785456)
print v(xbgr.mr_n73785568)
print v(xbgr.mr_n73785760)
print v(xbgr.mr_n73785952)
print v(xbgr.mr_n73786144)
print v(xbgr.mr_n73786656)
print v(xbgr.mr_n73788400)
print v(xbgr.mr_n73788672)
print v(xbgr.mr_n73788864)
print v(xbgr.mr_n73789728)
print v(xbgr.mr_n73792640)
print v(xbgr.mr_n73792832)
print v(xbgr.mr_n73793024)
print v(xbgr.mr_n73793216)
print v(xbgr.mr_n73795408)
print v(xbgr.mr_n73795680)
print v(xbgr.mr_n73795872)
print v(xbgr.mr_n73796384)
print v(xbgr.mr_n73798640)
print v(xbgr.mr_n73799152)
print v(xbgr.mr_n73801888)
print v(xbgr.mr_n73802160)
print v(xbgr.mr_n73802352)
print v(xbgr.mr_n73802864)
print v(xbgr.mr_n73804480)
print v(xbgr.mr_n73804672)
print v(xbgr.mr_n73806864)
print v(xbgr.mr_n73807136)
print v(xbgr.mr_n73807328)
print v(xbgr.mr_n73807840)
print v(xbgr.mr_n73809776)
print v(xbgr.mr_n73810288)
print v(xbgr.mr_n73813024)
print v(xbgr.mr_n73813296)
print v(xbgr.mr_n73813488)
print v(xbgr.mr_n73814000)
print v(xbgr.mr_n73815616)
print v(xbgr.mr_n73815808)
print v(xbgr.mr_n73818000)
print v(xbgr.mr_n73818272)
print v(xbgr.mr_n73818464)
print v(xbgr.mr_n73818976)
print v(xbgr.mr_n73819792)
print v(xbgr.mr_n73820912)
print v(xbgr.mr_n73821424)
print v(xbgr.mr_n73824160)
print v(xbgr.mr_n73824432)
print v(xbgr.mr_n73824624)
print v(xbgr.mr_n73825136)
print v(xbgr.mr_n73826752)
print v(xbgr.mr_n73826944)
print v(xbgr.mr_n73829136)
print v(xbgr.mr_n73829408)
print v(xbgr.mr_n73829600)
print v(xbgr.mr_n73830112)
print v(xbgr.mr_n73831008)
print v(xbgr.mr_n73832048)
print v(xbgr.mr_n73832560)
print v(xbgr.mr_n73833952)
print v(xbgr.mr_n73835296)
print v(xbgr.mr_n73835568)
print v(xbgr.mr_n73835760)
print v(xbgr.mr_n73836272)
print v(xbgr.mr_n73839984)
print v(xbgr.mr_n73841136)
print v(xbgr.mr_n73841248)
print v(xbgr.mr_n73842400)
print v(xbgr.mr_n73842512)
print v(xbgr.mr_n73843664)
print v(xbgr.mr_n73843776)
print v(xbgr.mr_n73844928)
print v(xbgr.mr_n73845040)
print v(xbgr.mr_n73846192)
print v(xbgr.mr_n73846304)
print v(xbgr.mr_n73847456)
print v(xbgr.mr_n73847568)
print v(xbgr.mr_n73848720)
print v(xbgr.mr_n73848832)
print v(xbgr.mr_n73849984)
print v(xbgr.mr_n73850096)
print v(xbgr.mr_n73851248)
print v(xbgr.mr_n73851360)
print v(xbgr.mr_n73852512)
print v(xbgr.mr_n73852624)
print v(xbgr.mr_n73853776)
print v(xbgr.mr_n73853888)
print v(xbgr.mr_n73855040)
print v(xbgr.mr_n73855152)
print v(xbgr.mr_n73856304)
print v(xbgr.mr_n73856416)
print v(xbgr.mr_n73857568)
print v(xbgr.mr_n73857680)
print v(xbgr.mr_n73858832)
print v(xbgr.mr_n73858944)
print v(xbgr.mr_n73862896)
print v(xbgr.mr_n73866704)
print v(xbgr.mr_n73867040)
print v(xbgr.mr_n73874560)
print v(xbgr.mr_n73876544)
print v(xbgr.mr_n73883360)
print v(xbgr.mr_n73892624)
print v(xbgr.mr_n73893312)
print v(xbgr.mr_n73894064)
print v(xbgr.mr_n73895008)
print v(xbgr.mr_n73896816)
print v(xbgr.mr_n73897008)
print v(xbgr.mr_n73897552)
print v(xbgr.mr_n73899440)
print v(xbgr.mr_n73901600)
print v(xbgr.mr_n73901792)
print v(xbgr.mr_n73902480)
print v(xbgr.mr_n73902592)
print v(xbgr.mr_n73902704)
print v(xbgr.mr_n73902816)
print v(xbgr.mr_n73902928)
print v(xbgr.mr_n73904672)
print v(xbgr.mr_n73904944)
print v(xbgr.mr_n73905136)
print v(xbgr.mr_n73905648)
print v(xbgr.mr_n73907584)
print v(xbgr.mr_n73909328)
print v(xbgr.mr_n73909600)
print v(xbgr.mr_n73909792)
print v(xbgr.mr_n73910304)
print v(xbgr.mr_n73912240)
print v(xbgr.mr_n73913984)
print v(xbgr.mr_n73914256)
print v(xbgr.mr_n73914448)
print v(xbgr.mr_n73914960)
print v(xbgr.mr_n73915264)
print v(xbgr.mr_n73916192)
print v(xbgr.mr_n73916704)
print v(xbgr.mr_n73920144)
print v(xbgr.mr_n73920528)
print v(xbgr.mr_n73921120)
print v(xbgr.mr_n73923376)
print v(xbgr.mr_n73924960)
print v(xbgr.mr_n73926976)
print v(xbgr.mr_n73927088)
print v(xbgr.mr_n73927280)
print v(xbgr.mr_n73927472)
print v(xbgr.mr_n73929216)
print v(xbgr.mr_n73929488)
print v(xbgr.mr_n73929680)
print v(xbgr.mr_n73930192)
print v(xbgr.mr_n73933552)
print v(xbgr.mr_n73933664)
print v(xbgr.mr_n73935408)
print v(xbgr.mr_n73935680)
print v(xbgr.mr_n73935872)
print v(xbgr.mr_n73936384)
print v(xbgr.mr_n73937536)
print v(xbgr.mr_n73938128)
print v(xbgr.mr_n73940096)
print v(xbgr.mr_n73941904)
print v(xbgr.mr_n73942096)
print v(xbgr.mr_n73942608)
print v(xbgr.mr_n73944688)
print v(xbgr.mr_n73944880)
print v(xbgr.mr_n73945072)
print v(xbgr.mr_n73946880)
print v(xbgr.mr_n73947072)
print v(xbgr.mr_n73947584)
print v(xbgr.mr_n73948752)
print v(xbgr.mr_n73949264)
print v(xbgr.mr_n73951232)
print v(xbgr.mr_n73953040)
print v(xbgr.mr_n73953232)
print v(xbgr.mr_n73953744)
print v(xbgr.mr_n73955824)
print v(xbgr.mr_n73955936)
print v(xbgr.mr_n73957680)
print v(xbgr.mr_n73957952)
print v(xbgr.mr_n73958144)
print v(xbgr.mr_n73958656)
print v(xbgr.mr_n73959888)
print v(xbgr.mr_n73960400)
print v(xbgr.mr_n73963840)
print v(xbgr.mr_n73964112)
print v(xbgr.mr_n73964304)
print v(xbgr.mr_n73964816)
print v(xbgr.mr_n73966880)
print v(xbgr.mr_n73966992)
print v(xbgr.mr_n73967504)
print v(xbgr.mr_n73967616)
print v(xbgr.mr_n73968128)
print v(xbgr.mr_n73968240)
print v(xbgr.mr_n73969008)
print v(xbgr.mr_n73969120)
print v(xbgr.mr_n73969952)
print v(xbgr.mr_n73970064)
print v(xbgr.mr_n73970896)
print v(xbgr.mr_n73971008)
print v(xbgr.mr_n73971840)
print v(xbgr.mr_n73971952)
print v(xbgr.mr_n73972784)
print v(xbgr.mr_n73972896)
print v(xbgr.mr_n73973792)
print v(xbgr.mr_n73973904)
print v(xbgr.mr_n73975056)
print v(xbgr.mr_n73975168)
print v(xbgr.mr_n73976320)
print v(xbgr.mr_n73976432)
print v(xbgr.mr_n73977584)
print v(xbgr.mr_n73977696)
print v(xbgr.mr_n73978848)
print v(xbgr.mr_n73978960)
print v(xbgr.mr_n73980112)
print v(xbgr.mr_n73980224)
print v(xbgr.mr_n73981376)
print v(xbgr.mr_n73981488)
print v(xbgr.mr_n73983456)
print v(xbgr.mr_n73991792)
print v(xbgr.mr_n73993264)
print v(xbgr.mr_n73993376)
print v(xbgr.mr_n73994528)
print v(xbgr.mr_n73994640)
print v(xbgr.mr_n73995792)
print v(xbgr.mr_n73995904)
print v(xbgr.mr_n73997056)
print v(xbgr.mr_n73997168)
print v(xbgr.mr_n73998320)
print v(xbgr.mr_n73998432)
print v(xbgr.mr_n73999584)
print v(xbgr.mr_n73999696)
print v(xbgr.mr_n74000848)
print v(xbgr.mr_n74000960)
print v(xbgr.mr_n74002112)
print v(xbgr.mr_n74002224)
print v(xbgr.mr_n74003376)
print v(xbgr.mr_n74003488)
print v(xbgr.mr_n74004640)
print v(xbgr.mr_n74004752)
print v(xbgr.mr_n74005904)
print v(xbgr.mr_n74006016)
print v(xbgr.mr_n74007168)
print v(xbgr.mr_n74007280)
print v(xbgr.mr_n74008432)
print v(xbgr.mr_n74008544)
print v(xbgr.mr_n74009696)
print v(xbgr.mr_n74009808)
print v(xbgr.mr_n74010960)
print v(xbgr.mr_n74011072)
print v(xbgr.mr_n74012224)
print v(xbgr.mr_n74012336)
print v(xbgr.mr_n74013488)
print v(xbgr.mr_n74013600)
print v(xbgr.mr_n74016528)
print v(xbgr.mr_n74021088)
print v(xbgr.mr_n74022944)
print v(xbgr.mr_n74025360)
print v(xbgr.mr_n74026336)
print v(xbgr.mr_n74034064)
print v(xbgr.mr_n74034352)
print v(xbgr.mr_n74034944)
print v(xbgr.mr_n74035056)
print v(xbgr.mr_n74036112)
print v(xbgr.mr_n74036352)
print v(xbgr.mr_n74036464)
print v(xbgr.mr_n74036704)
print v(xbgr.mr_n74037168)
print v(xbgr.mr_n74037344)
print v(xbgr.mr_n74037520)
print v(xbgr.mr_n74038400)
print v(xbgr.mr_n74038640)
print v(xbgr.mr_n74038816)
print v(xbgr.mr_n74039168)
print v(xbgr.mr_n74041744)
print v(xbgr.mr_n74043040)
print v(xbgr.mr_n74043328)
print v(xbgr.mr_n74043680)
print v(xbgr.mr_n74045504)
print v(xbgr.mr_n74046272)
print v(xbgr.mr_n74047088)
print v(xbgr.mr_n74047440)
print v(xbgr.mr_n74048432)
print v(xbgr.mr_n74050608)
print v(xbgr.mr_n74053248)
print v(xbgr.mr_n74053536)
print v(xbgr.mr_n74054416)
print v(xbgr.mr_n74054656)
print v(xbgr.mr_n74054832)
print v(xbgr.mr_n74055712)
print v(xbgr.mr_n74056544)
print v(xbgr.mr_n74056656)
print v(xbgr.mr_n74059744)
print v(xbgr.mr_n74059856)
print v(xbgr.mr_n74060464)
print v(xbgr.mr_n74063456)
print v(xbgr.mr_n74068208)
print v(xbgr.mr_n74068400)
print v(xbgr.mr_n74069088)
print v(xbgr.mr_n74069200)
print v(xbgr.mr_n74069312)
print v(xbgr.mr_n74069424)
print v(xbgr.mr_n74069536)
print v(xbgr.mr_n74071280)
print v(xbgr.mr_n74071552)
print v(xbgr.mr_n74071744)
print v(xbgr.mr_n74072256)
print v(xbgr.mr_n74074224)
print v(xbgr.mr_n74075968)
print v(xbgr.mr_n74076240)
print v(xbgr.mr_n74076432)
print v(xbgr.mr_n74076944)
print v(xbgr.mr_n74079120)
print v(xbgr.mr_n74079312)
print v(xbgr.mr_n74079504)
print v(xbgr.mr_n74079696)
print v(xbgr.mr_n74079888)
print v(xbgr.mr_n74081920)
print v(xbgr.mr_n74083536)
print v(xbgr.mr_n74085280)
print v(xbgr.mr_n74085552)
print v(xbgr.mr_n74085744)
print v(xbgr.mr_n74086256)
print v(xbgr.mr_n74088272)
print v(xbgr.mr_n74088464)
print v(xbgr.mr_n74090272)
print v(xbgr.mr_n74090464)
print v(xbgr.mr_n74090976)
print v(xbgr.mr_n74092848)
print v(xbgr.mr_n74094592)
print v(xbgr.mr_n74094864)
print v(xbgr.mr_n74095056)
print v(xbgr.mr_n74095568)
print v(xbgr.mr_n74097504)
print v(xbgr.mr_n74097760)
print v(xbgr.mr_n74099248)
print v(xbgr.mr_n74099520)
print v(xbgr.mr_n74099712)
print v(xbgr.mr_n74100224)
print v(xbgr.mr_n74102160)
print v(xbgr.mr_n74103904)
print v(xbgr.mr_n74104176)
print v(xbgr.mr_n74104368)
print v(xbgr.mr_n74104880)
print v(xbgr.mr_n74106816)
print v(xbgr.mr_n74108560)
print v(xbgr.mr_n74108832)
print v(xbgr.mr_n74109024)
print v(xbgr.mr_n74109536)
print v(xbgr.mr_n74111472)
print v(xbgr.mr_n74113216)
print v(xbgr.mr_n74113488)
print v(xbgr.mr_n74113680)
print v(xbgr.mr_n74114192)
print v(xbgr.mr_n74116208)
print v(xbgr.mr_n74116400)
print v(xbgr.mr_n74118208)
print v(xbgr.mr_n74118400)
print v(xbgr.mr_n74118912)
print v(xbgr.mr_n74120864)
print v(xbgr.mr_n74121056)
print v(xbgr.mr_n74122864)
print v(xbgr.mr_n74123056)
print v(xbgr.mr_n74123568)
print v(xbgr.mr_n74125440)
print v(xbgr.mr_n74127184)
print v(xbgr.mr_n74127456)
print v(xbgr.mr_n74127648)
print v(xbgr.mr_n74128160)
print v(xbgr.mr_n74130096)
print v(xbgr.mr_n74130432)
print v(xbgr.mr_n74131840)
print v(xbgr.mr_n74132112)
print v(xbgr.mr_n74132304)
print v(xbgr.mr_n74132816)
print v(xbgr.mr_n74134752)
print v(xbgr.mr_n74136496)
print v(xbgr.mr_n74136768)
print v(xbgr.mr_n74136960)
print v(xbgr.mr_n74137472)
print v(xbgr.mr_n74139488)
print v(xbgr.mr_n74139680)
print v(xbgr.mr_n74141488)
print v(xbgr.mr_n74141680)
print v(xbgr.mr_n74142192)
print v(xbgr.mr_n74144064)
print v(xbgr.mr_n74145808)
print v(xbgr.mr_n74146080)
print v(xbgr.mr_n74146272)
print v(xbgr.mr_n74146784)
print v(xbgr.mr_n74149616)
print v(xbgr.mr_n74150400)
print v(xbgr.mr_n74152048)
print v(xbgr.mr_n74152384)
print v(xbgr.mr_n74153568)
print v(xbgr.mr_n74153952)
print v(xbgr.mr_n74154592)
print v(xbgr.mr_n74156256)
print v(xbgr.mr_n74156688)
print v(xbgr.mr_n74157120)
print v(xbgr.mr_n74158544)
print v(xbgr.mr_n74159120)
print v(xbgr.mr_n74159232)
print v(xbgr.mr_n74160176)
print v(xbgr.mr_n74161008)
print v(xbgr.mr_n74161120)
print v(xbgr.mr_n74162064)
print v(xbgr.mr_n74163216)
print v(xbgr.mr_n74163328)
print v(xbgr.mr_n74164272)
print v(xbgr.mr_n74165424)
print v(xbgr.mr_n74165536)
print v(xbgr.mr_n74166480)
print v(xbgr.mr_n74167632)
print v(xbgr.mr_n74167744)
print v(xbgr.mr_n74168688)
print v(xbgr.mr_n74169008)
print v(xbgr.mr_n74169840)
print v(xbgr.mr_n74169952)
print v(xbgr.mr_n74170896)
print v(xbgr.mr_n74171984)
print v(xbgr.mr_n74172096)
print v(xbgr.mr_n74173040)
print v(xbgr.mr_n74174256)
print v(xbgr.mr_n74174368)
print v(xbgr.mr_n74175312)
print v(xbgr.mr_n74176464)
print v(xbgr.mr_n74176576)
print v(xbgr.mr_n74177520)
print v(xbgr.mr_n74178672)
print v(xbgr.mr_n74178784)
print v(xbgr.mr_n74179728)
print v(xbgr.mr_n74180880)
print v(xbgr.mr_n74180992)
print v(xbgr.mr_n74181936)
print v(xbgr.mr_n74183088)
print v(xbgr.mr_n74183200)
print v(xbgr.mr_n74183824)
print v(xbgr.mr_n74184144)
print v(xbgr.mr_n74185296)
print v(xbgr.mr_n74185408)
print v(xbgr.mr_n74186352)
print v(xbgr.mr_n74187504)
print v(xbgr.mr_n74187616)
print v(xbgr.mr_n74188560)
print v(xbgr.mr_n74189712)
print v(xbgr.mr_n74189824)
print v(xbgr.mr_n74190976)
print v(xbgr.mr_n74191088)
print v(xbgr.mr_n74192240)
print v(xbgr.mr_n74192352)
print v(xbgr.mr_n74195568)
print v(xbgr.mr_n74195680)
print v(xbgr.mr_n74196752)
print v(xbgr.mr_n74196864)
print v(xbgr.mr_n74197696)
print v(xbgr.mr_n74197808)
print v(xbgr.mr_n74199888)
print v(xbgr.mr_n74200000)
print v(xbgr.mr_n74201568)
print v(xbgr.mr_n74201680)
print v(xbgr.mr_n74202896)
print v(xbgr.mr_n74203008)
print v(xbgr.mr_n74204160)
print v(xbgr.mr_n74204272)
print v(xbgr.mr_n74205424)
print v(xbgr.mr_n74205536)
print v(xbgr.mr_n74206688)
print v(xbgr.mr_n74206800)
print v(xbgr.mr_n74207952)
print v(xbgr.mr_n74208064)
print v(xbgr.mr_n74209152)
print v(xbgr.mr_n74209264)
print v(xbgr.mr_n74209376)
print v(xbgr.mr_n74209696)
print v(xbgr.mr_n74211056)
print v(xbgr.mr_n74211936)
print v(xbgr.mr_n74222352)
print v(xbgr.mr_n74224960)
print v(xbgr.mr_n74228800)
print v(xbgr.mr_n74229440)
print v(xbgr.mr_n74238400)
print v(xbgr.mr_n74238592)
print v(xbgr.mr_n74238784)
print v(xbgr.mr_n74238976)
print v(xbgr.mr_n74241296)
print v(xbgr.mr_n74241568)
print v(xbgr.mr_n74241760)
print v(xbgr.mr_n74242272)
print v(xbgr.mr_n74245584)
print v(xbgr.mr_n74247952)
print v(xbgr.mr_n74248224)
print v(xbgr.mr_n74248416)
print v(xbgr.mr_n74248928)
print v(xbgr.mr_n74251072)
print v(xbgr.mr_n74251184)
print v(xbgr.mr_n74252928)
print v(xbgr.mr_n74253200)
print v(xbgr.mr_n74253392)
print v(xbgr.mr_n74253904)
print v(xbgr.mr_n74255200)
print v(xbgr.mr_n74255712)
print v(xbgr.mr_n74259088)
print v(xbgr.mr_n74259360)
print v(xbgr.mr_n74259552)
print v(xbgr.mr_n74260064)
print v(xbgr.mr_n74262208)
print v(xbgr.mr_n74262320)
print v(xbgr.mr_n74264064)
print v(xbgr.mr_n74264256)
print v(xbgr.mr_n74264448)
print v(xbgr.mr_n74265040)
print v(xbgr.mr_n74266272)
print v(xbgr.mr_n74266784)
print v(xbgr.mr_n74268752)
print v(xbgr.mr_n74270560)
print v(xbgr.mr_n74270752)
print v(xbgr.mr_n74271264)
print v(xbgr.mr_n74273344)
print v(xbgr.mr_n74273456)
print v(xbgr.mr_n74275200)
print v(xbgr.mr_n74275472)
print v(xbgr.mr_n74275664)
print v(xbgr.mr_n74276176)
print v(xbgr.mr_n74276544)
print v(xbgr.mr_n74277408)
print v(xbgr.mr_n74277920)
print v(xbgr.mr_n74280016)
print v(xbgr.mr_n74281360)
print v(xbgr.mr_n74281632)
print v(xbgr.mr_n74281824)
print v(xbgr.mr_n74282336)
print v(xbgr.mr_n74284480)
print v(xbgr.mr_n74284592)
print v(xbgr.mr_n74286336)
print v(xbgr.mr_n74286608)
print v(xbgr.mr_n74286800)
print v(xbgr.mr_n74287312)
print v(xbgr.mr_n74288544)
print v(xbgr.mr_n74289056)
print v(xbgr.mr_n74292496)
print v(xbgr.mr_n74292688)
print v(xbgr.mr_n74292880)
print v(xbgr.mr_n74293472)
print v(xbgr.mr_n74295616)
print v(xbgr.mr_n74295728)
print v(xbgr.mr_n74297472)
print v(xbgr.mr_n74297744)
print v(xbgr.mr_n74297936)
print v(xbgr.mr_n74298448)
print v(xbgr.mr_n74299680)
print v(xbgr.mr_n74300192)
print v(xbgr.mr_n74303632)
print v(xbgr.mr_n74303824)
print v(xbgr.mr_n74304016)
print v(xbgr.mr_n74304608)
print v(xbgr.mr_n74307744)
print v(xbgr.mr_n74309744)
print v(xbgr.mr_n74309856)
print v(xbgr.mr_n74310752)
print v(xbgr.mr_n74310864)
print v(xbgr.mr_n74311696)
print v(xbgr.mr_n74311808)
print v(xbgr.mr_n74312896)
print v(xbgr.mr_n74313008)
print v(xbgr.mr_n74314160)
print v(xbgr.mr_n74314272)
print v(xbgr.mr_n74315360)
print v(xbgr.mr_n74315472)
print v(xbgr.mr_n74316688)
print v(xbgr.mr_n74316800)
print v(xbgr.mr_n74317952)
print v(xbgr.mr_n74318064)
print v(xbgr.mr_n74319216)
print v(xbgr.mr_n74319328)
print v(xbgr.mr_n74320480)
print v(xbgr.mr_n74320592)
print v(xbgr.mr_n74321744)
print v(xbgr.mr_n74321856)
print v(xbgr.mr_n74323008)
print v(xbgr.mr_n74323120)
print v(xbgr.mr_n74324208)
print v(xbgr.mr_n74324320)
print v(xbgr.mr_n74325536)
print v(xbgr.mr_n74325648)
print v(xbgr.mr_n74326800)
print v(xbgr.mr_n74326912)
print v(xbgr.mr_n74329712)
print v(xbgr.mr_n74337424)
print v(xbgr.mr_n74338112)
print v(xbgr.mr_n74338800)
print v(xbgr.mr_n74339488)
print v(xbgr.mr_n74340176)
print v(xbgr.mr_n74341248)
print v(xbgr.mr_n74342896)
print v(xbgr.mr_n74343840)
print v(xbgr.mr_n74344784)
print v(xbgr.mr_n74345728)
print v(xbgr.mr_n74346672)
print v(xbgr.mr_n74349088)
print v(xbgr.mr_n74349424)
print v(xbgr.mr_n74351632)
print v(xbgr.mr_n74353200)
print v(xbgr.mr_n74354768)
print v(xbgr.mr_n74356336)
print v(xbgr.mr_n74357904)
print v(xbgr.mr_n74359472)
print v(xbgr.mr_n74360976)
print v(xbgr.mr_n74361552)
print v(xbgr.mr_n74362608)
print v(xbgr.mr_n74367088)
print v(xbgr.mr_n74367776)
print v(xbgr.mr_n74368464)
print v(xbgr.mr_n74369216)
print v(xbgr.mr_n74370832)
print v(xbgr.mr_n74372112)
print v(xbgr.mr_n74372224)
print v(xbgr.mr_n74373168)
print v(xbgr.mr_n74374320)
print v(xbgr.mr_n74374432)
print v(xbgr.mr_n74375376)
print v(xbgr.mr_n74376528)
print v(xbgr.mr_n74376640)
print v(xbgr.mr_n74377584)
print v(xbgr.mr_n74378736)
print v(xbgr.mr_n74378848)
print v(xbgr.mr_n74379792)
print v(xbgr.mr_n74380944)
print v(xbgr.mr_n74381056)
print v(xbgr.mr_n74382000)
print v(xbgr.mr_n74383152)
print v(xbgr.mr_n74383264)
print v(xbgr.mr_n74384208)
print v(xbgr.mr_n74385360)
print v(xbgr.mr_n74385472)
print v(xbgr.mr_n74386416)
print v(xbgr.mr_n74387568)
print v(xbgr.mr_n74387680)
print v(xbgr.mr_n74388624)
print v(xbgr.mr_n74389776)
print v(xbgr.mr_n74389888)
print v(xbgr.mr_n74390832)
print v(xbgr.mr_n74391984)
print v(xbgr.mr_n74392096)
print v(xbgr.mr_n74393040)
print v(xbgr.mr_n74393216)
print v(xbgr.mr_n74394192)
print v(xbgr.mr_n74394304)
print v(xbgr.mr_n74395248)
print v(xbgr.mr_n74396400)
print v(xbgr.mr_n74396512)
print v(xbgr.mr_n74397456)
print v(xbgr.mr_n74398608)
print v(xbgr.mr_n74398720)
print v(xbgr.mr_n74399664)
print v(xbgr.mr_n74400816)
print v(xbgr.mr_n74400928)
print v(xbgr.mr_n74401872)
print v(xbgr.mr_n74403024)
print v(xbgr.mr_n74403136)
print v(xbgr.mr_n74404080)
print v(xbgr.mr_n74405232)
print v(xbgr.mr_n74405344)
print v(xbgr.mr_n74406288)
print v(xbgr.mr_n74407440)
print v(xbgr.mr_n74407552)
print v(xbgr.mr_n74408432)
print v(xbgr.mr_n74409120)
print v(xbgr.mr_n74409808)
print v(xbgr.mr_n74410528)
print v(xbgr.mr_n74411472)
print v(xbgr.mr_n74412416)
print v(xbgr.mr_n74413360)
print v(xbgr.mr_n74414304)
print v(xbgr.mr_n74415248)
print v(xbgr.mr_n74416192)
print v(xbgr.mr_n74417136)
print v(xbgr.mr_n74418224)
print v(xbgr.mr_n74426656)
print v(xbgr.mr_n74428656)
print v(xbgr.mr_n74429280)
print v(xbgr.mr_n74437664)
print v(xbgr.mr_n74440256)
print v(xbgr.mr_n74441328)
print v(xbgr.mr_n74441520)
print v(xbgr.mr_n74441712)
print v(xbgr.mr_n74441904)
print v(xbgr.mr_n74442368)
print v(xbgr.mr_n74444224)
print v(xbgr.mr_n74444496)
print v(xbgr.mr_n74444688)
print v(xbgr.mr_n74445200)
print v(xbgr.mr_n74446240)
print v(xbgr.mr_n74449920)
print v(xbgr.mr_n74450192)
print v(xbgr.mr_n74450384)
print v(xbgr.mr_n74450896)
print v(xbgr.mr_n74453040)
print v(xbgr.mr_n74453152)
print v(xbgr.mr_n74454896)
print v(xbgr.mr_n74455168)
print v(xbgr.mr_n74455360)
print v(xbgr.mr_n74455872)
print v(xbgr.mr_n74457104)
print v(xbgr.mr_n74457616)
print v(xbgr.mr_n74461056)
print v(xbgr.mr_n74461328)
print v(xbgr.mr_n74461520)
print v(xbgr.mr_n74462032)
print v(xbgr.mr_n74464176)
print v(xbgr.mr_n74464288)
print v(xbgr.mr_n74465248)
print v(xbgr.mr_n74465856)
print v(xbgr.mr_n74465968)
print v(xbgr.mr_n74466288)
print v(xbgr.mr_n74467888)
print v(xbgr.mr_n74468080)
print v(xbgr.mr_n74468272)
print v(xbgr.mr_n74468464)
print v(xbgr.mr_n74468656)
print v(xbgr.mr_n74470464)
print v(xbgr.mr_n74470656)
print v(xbgr.mr_n74471168)
print v(xbgr.mr_n74474816)
print v(xbgr.mr_n74474928)
print v(xbgr.mr_n74476672)
print v(xbgr.mr_n74476944)
print v(xbgr.mr_n74477136)
print v(xbgr.mr_n74477648)
print v(xbgr.mr_n74478880)
print v(xbgr.mr_n74479392)
print v(xbgr.mr_n74482832)
print v(xbgr.mr_n74483104)
print v(xbgr.mr_n74483296)
print v(xbgr.mr_n74483808)
print v(xbgr.mr_n74485952)
print v(xbgr.mr_n74486064)
print v(xbgr.mr_n74487808)
print v(xbgr.mr_n74488080)
print v(xbgr.mr_n74488272)
print v(xbgr.mr_n74488784)
print v(xbgr.mr_n74490016)
print v(xbgr.mr_n74490528)
print v(xbgr.mr_n74493968)
print v(xbgr.mr_n74494240)
print v(xbgr.mr_n74494432)
print v(xbgr.mr_n74494944)
print v(xbgr.mr_n74497088)
print v(xbgr.mr_n74497200)
print v(xbgr.mr_n74498944)
print v(xbgr.mr_n74499216)
print v(xbgr.mr_n74499408)
print v(xbgr.mr_n74499920)
print v(xbgr.mr_n74501152)
print v(xbgr.mr_n74501664)
print v(xbgr.mr_n74505104)
print v(xbgr.mr_n74505376)
print v(xbgr.mr_n74505568)
print v(xbgr.mr_n74506080)
print v(xbgr.mr_n74511024)
print v(xbgr.mr_n74511136)
print v(xbgr.mr_n74511968)
print v(xbgr.mr_n74512080)
print v(xbgr.mr_n74512912)
print v(xbgr.mr_n74513024)
print v(xbgr.mr_n74514112)
print v(xbgr.mr_n74514224)
print v(xbgr.mr_n74515376)
print v(xbgr.mr_n74515488)
print v(xbgr.mr_n74516640)
print v(xbgr.mr_n74516752)
print v(xbgr.mr_n74517904)
print v(xbgr.mr_n74518016)
print v(xbgr.mr_n74519168)
print v(xbgr.mr_n74519280)
print v(xbgr.mr_n74520432)
print v(xbgr.mr_n74520544)
print v(xbgr.mr_n74521696)
print v(xbgr.mr_n74521808)
print v(xbgr.mr_n74522960)
print v(xbgr.mr_n74523072)
print v(xbgr.mr_n74524224)
print v(xbgr.mr_n74524336)
print v(xbgr.mr_n74525488)
print v(xbgr.mr_n74525600)
print v(xbgr.mr_n74526752)
print v(xbgr.mr_n74526864)
print v(xbgr.mr_n74528016)
print v(xbgr.mr_n74528128)
print v(xbgr.mr_n74529664)
print v(xbgr.mr_n74529776)
print v(xbgr.mr_n74530928)
print v(xbgr.mr_n74531040)
print v(xbgr.mr_n74532192)
print v(xbgr.mr_n74532304)
print v(xbgr.mr_n74533456)
print v(xbgr.mr_n74533568)
print v(xbgr.mr_n74534720)
print v(xbgr.mr_n74534832)
print v(xbgr.mr_n74535984)
print v(xbgr.mr_n74536096)
print v(xbgr.mr_n74537248)
print v(xbgr.mr_n74537360)
print v(xbgr.mr_n74538512)
print v(xbgr.mr_n74538624)
print v(xbgr.mr_n74539776)
print v(xbgr.mr_n74539888)
print v(xbgr.mr_n74541040)
print v(xbgr.mr_n74541152)
print v(xbgr.mr_n74542304)
print v(xbgr.mr_n74542416)
print v(xbgr.mr_n74543568)
print v(xbgr.mr_n74543680)
print v(xbgr.mr_n74544832)
print v(xbgr.mr_n74544944)
print v(xbgr.mr_n74546096)
print v(xbgr.mr_n74546208)
print v(xbgr.mr_n74547360)
print v(xbgr.mr_n74547472)
print v(xbgr.mr_n74548624)
print v(xbgr.mr_n74548736)
print v(xbgr.mr_n74549888)
print v(xbgr.mr_n74550000)
print v(xbgr.mr_n74553392)
print v(xbgr.mr_n74558576)
print v(xbgr.mr_n74558848)
print v(xbgr.mr_n74558960)
print v(xbgr.mr_n74562144)
print v(xbgr.mr_n74563104)
print v(xbgr.mr_n74564640)
print v(xbgr.mr_n74567728)
print v(xbgr.mr_n74569712)
print v(xbgr.mr_n74572832)
print v(xbgr.mr_n74582208)
print v(xbgr.mr_n74582448)
print v(xbgr.mr_n74583104)
print v(xbgr.mr_n74584704)
print v(xbgr.mr_n74586304)
print v(xbgr.mr_n74586992)
print v(xbgr.mr_n74587680)
print v(xbgr.mr_n74588400)
print v(xbgr.mr_n74589344)
print v(xbgr.mr_n74590288)
print v(xbgr.mr_n74591232)
print v(xbgr.mr_n74592176)
print v(xbgr.mr_n74593120)
print v(xbgr.mr_n74594064)
print v(xbgr.mr_n74595008)
print v(xbgr.mr_n74595952)
print v(xbgr.mr_n74596896)
print v(xbgr.mr_n74597840)
print v(xbgr.mr_n74598784)
print v(xbgr.mr_n74599728)
print v(xbgr.mr_n74607600)
print v(xbgr.mr_n74611616)
print v(xbgr.mr_n74616448)
print v(xbgr.mr_n74616560)
print v(xbgr.mr_n74617392)
print v(xbgr.mr_n74617504)
print v(xbgr.mr_n74617616)
print v(xbgr.mr_n74617728)
print v(xbgr.mr_n74617840)
print v(xbgr.mr_n74619584)
print v(xbgr.mr_n74619856)
print v(xbgr.mr_n74620048)
print v(xbgr.mr_n74620560)
print v(xbgr.mr_n74621024)
print v(xbgr.mr_n74623152)
print v(xbgr.mr_n74623424)
print v(xbgr.mr_n74623616)
print v(xbgr.mr_n74624128)
print v(xbgr.mr_n74627616)
print v(xbgr.mr_n74627888)
print v(xbgr.mr_n74628080)
print v(xbgr.mr_n74628592)
print v(xbgr.mr_n74630144)
print v(xbgr.mr_n74632400)
print v(xbgr.mr_n74632672)
print v(xbgr.mr_n74632864)
print v(xbgr.mr_n74633376)
print v(xbgr.mr_n74636864)
print v(xbgr.mr_n74637056)
print v(xbgr.mr_n74637248)
print v(xbgr.mr_n74637840)
print v(xbgr.mr_n74639472)
print v(xbgr.mr_n74639664)
print v(xbgr.mr_n74641984)
print v(xbgr.mr_n74642176)
print v(xbgr.mr_n74642688)
print v(xbgr.mr_n74646112)
print v(xbgr.mr_n74646384)
print v(xbgr.mr_n74646576)
print v(xbgr.mr_n74647088)
print v(xbgr.mr_n74648720)
print v(xbgr.mr_n74648912)
print v(xbgr.mr_n74649424)
print v(xbgr.mr_n74651232)
print v(xbgr.mr_n74651424)
print v(xbgr.mr_n74651936)
print v(xbgr.mr_n74655360)
print v(xbgr.mr_n74655632)
print v(xbgr.mr_n74655824)
print v(xbgr.mr_n74656336)
print v(xbgr.mr_n74657888)
print v(xbgr.mr_n74660144)
print v(xbgr.mr_n74660416)
print v(xbgr.mr_n74660608)
print v(xbgr.mr_n74661120)
print v(xbgr.mr_n74664608)
print v(xbgr.mr_n74664880)
print v(xbgr.mr_n74665072)
print v(xbgr.mr_n74665584)
print v(xbgr.mr_n74667120)
print v(xbgr.mr_n74668448)
print v(xbgr.mr_n74668720)
print v(xbgr.mr_n74668912)
print v(xbgr.mr_n74669424)
print v(xbgr.mr_n74672288)
print v(xbgr.mr_n74672560)
print v(xbgr.mr_n74672752)
print v(xbgr.mr_n74673264)
print v(xbgr.mr_n74676624)
print v(xbgr.mr_n74676736)
print v(xbgr.mr_n74676928)
print v(xbgr.mr_n74678480)
print v(xbgr.mr_n74678752)
print v(xbgr.mr_n74678944)
print v(xbgr.mr_n74679456)
print v(xbgr.mr_n74681600)
print v(xbgr.mr_n74681712)
print v(xbgr.mr_n74683456)
print v(xbgr.mr_n74683728)
print v(xbgr.mr_n74683920)
print v(xbgr.mr_n74684432)
print v(xbgr.mr_n74686576)
print v(xbgr.mr_n74686688)
print v(xbgr.mr_n74688432)
print v(xbgr.mr_n74688704)
print v(xbgr.mr_n74688896)
print v(xbgr.mr_n74689408)
print v(xbgr.mr_n74691552)
print v(xbgr.mr_n74691664)
print v(xbgr.mr_n74693408)
print v(xbgr.mr_n74693680)
print v(xbgr.mr_n74693872)
print v(xbgr.mr_n74694384)
print v(xbgr.mr_n74699552)
print v(xbgr.mr_n74701744)
print v(xbgr.mr_n74703312)
print v(xbgr.mr_n74704256)
print v(xbgr.mr_n74706448)
print v(xbgr.mr_n74708016)
print v(xbgr.mr_n74708960)
print v(xbgr.mr_n74711152)
print v(xbgr.mr_n74712768)
print v(xbgr.mr_n74713344)
print v(xbgr.mr_n74713456)
print v(xbgr.mr_n74714288)
print v(xbgr.mr_n74714400)
print v(xbgr.mr_n74715232)
print v(xbgr.mr_n74715344)
print v(xbgr.mr_n74716176)
print v(xbgr.mr_n74716288)
print v(xbgr.mr_n74717120)
print v(xbgr.mr_n74717232)
print v(xbgr.mr_n74718064)
print v(xbgr.mr_n74718176)
print v(xbgr.mr_n74719008)
print v(xbgr.mr_n74719120)
print v(xbgr.mr_n74719952)
print v(xbgr.mr_n74720064)
print v(xbgr.mr_n74720896)
print v(xbgr.mr_n74721008)
print v(xbgr.mr_n74721968)
print v(xbgr.mr_n74722080)
print v(xbgr.mr_n74723984)
print v(xbgr.mr_n74724560)
print v(xbgr.mr_n74726032)
print v(xbgr.mr_n74732816)
print v(xbgr.mr_n74744144)
print v(xbgr.mr_n74746704)
print v(xbgr.mr_n74747392)
print v(xbgr.mr_n74748080)
print v(xbgr.mr_n74748768)
print v(xbgr.mr_n74749456)
print v(xbgr.mr_n74750944)
print v(xbgr.mr_n74752080)
print v(xbgr.mr_n74753024)
print v(xbgr.mr_n74753968)
print v(xbgr.mr_n74754912)
print v(xbgr.mr_n74755856)
print v(xbgr.mr_n74756800)
print v(xbgr.mr_n74757744)
print v(xbgr.mr_n74758688)
print v(xbgr.mr_n74759632)
print v(xbgr.mr_n74760576)
print v(xbgr.mr_n74761520)
print v(xbgr.mr_n74762464)
print v(xbgr.mr_n74763408)
print v(xbgr.mr_n74763600)
print v(xbgr.mr_n74763792)
print v(xbgr.mr_n74763984)
print v(xbgr.mr_n74764176)
print v(xbgr.mr_n74764368)
print v(xbgr.mr_n74766512)
print v(xbgr.mr_n74766624)
print v(xbgr.mr_n74769936)
print v(xbgr.mr_n74770048)
print v(xbgr.mr_n74774928)
print v(xbgr.mr_n74776768)
print v(xbgr.mr_n74778608)
print v(xbgr.mr_n74780448)
print v(xbgr.mr_n74782736)
print v(xbgr.mr_n74783952)
print v(xbgr.mr_n74785808)
print v(xbgr.mr_n74786832)
print v(xbgr.mr_n74789008)
print v(xbgr.mr_n74797616)
print v(xbgr.mr_n74799184)
print v(xbgr.mr_n74800752)
print v(xbgr.mr_n74802320)
print v(xbgr.mr_n74803888)
print v(xbgr.mr_n74805456)
print v(xbgr.mr_n74807024)
print v(xbgr.mr_n74808592)
print v(xbgr.mr_n74810160)
print v(xbgr.mr_n74811728)
print v(xbgr.mr_n74813296)
print v(xbgr.mr_n74814864)
print v(xbgr.mr_n74816432)
print v(xbgr.mr_n74818000)
print v(xbgr.mr_n74819568)
print v(xbgr.mr_n74821136)
print v(xbgr.mr_n74824384)
print v(xbgr.mr_n74824720)
print v(xbgr.mr_n74824832)
print v(xbgr.mr_n74825664)
print v(xbgr.mr_n74825776)
print v(xbgr.mr_n74826608)
print v(xbgr.mr_n74826720)
print v(xbgr.mr_n74827552)
print v(xbgr.mr_n74827664)
print v(xbgr.mr_n74831152)
print v(xbgr.mr_n74831664)
print v(xbgr.mr_n74831776)
print v(xbgr.mr_n74831888)
print v(xbgr.mr_n74832000)
print v(xbgr.mr_n74832112)
print v(xbgr.mr_n74833536)
print v(xbgr.mr_n74833728)
print v(xbgr.mr_n74833920)
print v(xbgr.mr_n74834512)
print v(xbgr.mr_n74836656)
print v(xbgr.mr_n74836768)
print v(xbgr.mr_n74838512)
print v(xbgr.mr_n74838784)
print v(xbgr.mr_n74838976)
print v(xbgr.mr_n74839488)
print v(xbgr.mr_n74841632)
print v(xbgr.mr_n74841744)
print v(xbgr.mr_n74843488)
print v(xbgr.mr_n74843760)
print v(xbgr.mr_n74843952)
print v(xbgr.mr_n74844464)
print v(xbgr.mr_n74846608)
print v(xbgr.mr_n74846720)
print v(xbgr.mr_n74846992)
print v(xbgr.mr_n74848464)
print v(xbgr.mr_n74848736)
print v(xbgr.mr_n74848928)
print v(xbgr.mr_n74849440)
print v(xbgr.mr_n74851584)
print v(xbgr.mr_n74851696)
print v(xbgr.mr_n74852032)
print v(xbgr.mr_n74853440)
print v(xbgr.mr_n74853712)
print v(xbgr.mr_n74853904)
print v(xbgr.mr_n74854416)
print v(xbgr.mr_n74856560)
print v(xbgr.mr_n74856672)
print v(xbgr.mr_n74858416)
print v(xbgr.mr_n74858688)
print v(xbgr.mr_n74858880)
print v(xbgr.mr_n74859392)
print v(xbgr.mr_n74861696)
print v(xbgr.mr_n74861888)
print v(xbgr.mr_n74862080)
print v(xbgr.mr_n74862272)
print v(xbgr.mr_n74862464)
print v(xbgr.mr_n74864688)
print v(xbgr.mr_n74866512)
print v(xbgr.mr_n74866624)
print v(xbgr.mr_n74868368)
print v(xbgr.mr_n74868640)
print v(xbgr.mr_n74868832)
print v(xbgr.mr_n74869344)
print v(xbgr.mr_n74870208)
print v(xbgr.mr_n74872416)
print v(xbgr.mr_n74872608)
print v(xbgr.mr_n74874640)
print v(xbgr.mr_n74875328)
print v(xbgr.mr_n74876016)
print v(xbgr.mr_n74876704)
print v(xbgr.mr_n74877392)
print v(xbgr.mr_n74878080)
print v(xbgr.mr_n74878768)
print v(xbgr.mr_n74879456)
print v(xbgr.mr_n74881360)
print v(xbgr.mr_n74882592)
print v(xbgr.mr_n74883536)
print v(xbgr.mr_n74884480)
print v(xbgr.mr_n74885424)
print v(xbgr.mr_n74886368)
print v(xbgr.mr_n74887312)
print v(xbgr.mr_n74888256)
print v(xbgr.mr_n74889200)
print v(xbgr.mr_n74890144)
print v(xbgr.mr_n74891088)
print v(xbgr.mr_n74892032)
print v(xbgr.mr_n74905344)
print v(xbgr.mr_n74906368)
print v(xbgr.mr_n74908960)
print v(xbgr.mr_n74910528)
print v(xbgr.mr_n74911568)
print v(xbgr.mr_n74911680)
print v(xbgr.mr_n74911792)
print v(xbgr.mr_n74913392)
print v(xbgr.mr_n74913504)
print v(xbgr.mr_n74915248)
print v(xbgr.mr_n74916816)
print v(xbgr.mr_n74917712)
print v(xbgr.mr_n74918928)
print v(xbgr.mr_n74919040)
print v(xbgr.mr_n74922784)
print v(xbgr.mr_n74924256)
print v(xbgr.mr_n74925824)
print v(xbgr.mr_n74927392)
print v(xbgr.mr_n74928960)
print v(xbgr.mr_n74932368)
print v(xbgr.mr_n74935040)
print v(xbgr.mr_n74935312)
print v(xbgr.mr_n74937616)
print v(xbgr.mr_n74937808)
print v(xbgr.mr_n74938352)
print v(xbgr.mr_n74939184)
print v(xbgr.mr_n74939296)
print v(xbgr.mr_n74941456)
print v(xbgr.mr_n74943008)
print v(xbgr.mr_n74944128)
print v(xbgr.mr_n74944816)
print v(xbgr.mr_n74947712)
print v(xbgr.mr_n74949280)
print v(xbgr.mr_n74950224)
print v(xbgr.mr_n74951584)
print v(xbgr.mr_n74954464)
print v(xbgr.mr_n74957376)
print v(xbgr.mr_n74958992)
print v(xbgr.mr_n74959104)
print v(xbgr.mr_n74960256)
print v(xbgr.mr_n74960368)
print v(xbgr.mr_n74961520)
print v(xbgr.mr_n74961632)
print v(xbgr.mr_n74962784)
print v(xbgr.mr_n74962896)
print v(xbgr.mr_n74964048)
print v(xbgr.mr_n74964160)
print v(xbgr.mr_n74965248)
print v(xbgr.mr_n74965360)
print v(xbgr.mr_n74966576)
print v(xbgr.mr_n74966688)
print v(xbgr.mr_n74967776)
print v(xbgr.mr_n74967888)
print v(xbgr.mr_n74969104)
print v(xbgr.mr_n74969216)
print v(xbgr.mr_n74970368)
print v(xbgr.mr_n74970480)
print v(xbgr.mr_n74971552)
print v(xbgr.mr_n74975200)
print v(xbgr.mr_n74979488)
print v(xbgr.mr_n74983456)
print v(xbgr.mr_n74984928)
print v(xbgr.mr_n74989200)
print v(xbgr.mr_n74989984)
print v(xbgr.mr_n74990096)
print v(xbgr.mr_n74990288)
print v(xbgr.mr_n74990480)
print v(xbgr.mr_n74990672)
print v(xbgr.mr_n74993088)
print v(xbgr.mr_n74998928)
print v(xbgr.mr_n74999872)
print v(xbgr.mr_n75000816)
print v(xbgr.mr_n75001760)
print v(xbgr.mr_n75002704)
print v(xbgr.mr_n75003648)
print v(xbgr.mr_n75004592)
print v(xbgr.mr_n75005536)
print v(xbgr.mr_n75005872)
print v(xbgr.mr_n75005984)
print v(xbgr.mr_n75006096)
print v(xbgr.mr_n75006560)
print v(xbgr.mr_n75007648)
print v(xbgr.mr_n75009072)
print v(xbgr.mr_n75011104)
print v(xbgr.mr_n75012048)
print v(xbgr.mr_n75012992)
print v(xbgr.mr_n75013936)
print v(xbgr.mr_n75014880)
print v(xbgr.mr_n75015824)
print v(xbgr.mr_n75016768)
print v(xbgr.mr_n75017712)
print v(xbgr.mr_n75018656)
print v(xbgr.mr_n75019600)
print v(xbgr.mr_n75020544)
print v(xbgr.mr_n75021488)
print v(xbgr.mr_n75022432)
print v(xbgr.mr_n75023376)
print v(xbgr.mr_n75023552)
print v(xbgr.mr_n75026304)
print v(xbgr.mr_n75027136)
print v(xbgr.mr_n75028080)
print v(xbgr.mr_n75029024)
print v(xbgr.mr_n75029216)
print v(xbgr.mr_n75029408)
print v(xbgr.mr_n75029600)
print v(xbgr.mr_n75029792)
print v(xbgr.mr_n75029984)
print v(xbgr.mr_n75032128)
print v(xbgr.mr_n75032240)
print v(xbgr.mr_n75035328)
print v(xbgr.mr_n75035440)
print v(xbgr.mr_n75041088)
print v(xbgr.mr_n75042032)
print v(xbgr.mr_n75042976)
print v(xbgr.mr_n75043920)
print v(xbgr.mr_n75044864)
print v(xbgr.mr_n75045808)
print v(xbgr.mr_n75047696)
print v(xbgr.mr_n75048640)
print v(xbgr.mr_n75049584)
print v(xbgr.mr_n75051840)
print v(xbgr.mr_n75052416)
print v(xbgr.mr_n75052528)
print v(xbgr.mr_n75053472)
print v(xbgr.mr_n75053664)
print v(xbgr.mr_n75053856)
print v(xbgr.mr_n75054048)
print v(xbgr.mr_n75056240)
print v(xbgr.mr_n75056512)
print v(xbgr.mr_n75056704)
print v(xbgr.mr_n75057216)
print v(xbgr.mr_n75058832)
print v(xbgr.mr_n75062704)
print v(xbgr.mr_n75063536)
print v(xbgr.mr_n75063648)
print v(xbgr.mr_n75063760)
print v(xbgr.mr_n75063872)
print v(xbgr.mr_n75063984)
print v(xbgr.mr_n75065728)
print v(xbgr.mr_n75066000)
print v(xbgr.mr_n75066192)
print v(xbgr.mr_n75066704)
print v(xbgr.mr_n75068848)
print v(xbgr.mr_n75068960)
print v(xbgr.mr_n75070704)
print v(xbgr.mr_n75070976)
print v(xbgr.mr_n75071168)
print v(xbgr.mr_n75071680)
print v(xbgr.mr_n75073824)
print v(xbgr.mr_n75073936)
print v(xbgr.mr_n75075680)
print v(xbgr.mr_n75075952)
print v(xbgr.mr_n75076144)
print v(xbgr.mr_n75076656)
print v(xbgr.mr_n75078800)
print v(xbgr.mr_n75078912)
print v(xbgr.mr_n75080656)
print v(xbgr.mr_n75080928)
print v(xbgr.mr_n75081120)
print v(xbgr.mr_n75081632)
print v(xbgr.mr_n75083776)
print v(xbgr.mr_n75083888)
print v(xbgr.mr_n75085632)
print v(xbgr.mr_n75085904)
print v(xbgr.mr_n75086096)
print v(xbgr.mr_n75086608)
print v(xbgr.mr_n75088752)
print v(xbgr.mr_n75090608)
print v(xbgr.mr_n75090880)
print v(xbgr.mr_n75091584)
print v(xbgr.mr_n75093728)
print v(xbgr.mr_n75093840)
print v(xbgr.mr_n75095584)
print v(xbgr.mr_n75095856)
print v(xbgr.mr_n75096048)
print v(xbgr.mr_n75096560)
print v(xbgr.mr_n75098976)
print v(xbgr.mr_n75099232)
print v(xbgr.mr_n75105520)
print v(xbgr.mr_n75106560)
print v(xbgr.mr_n75106752)
print v(xbgr.mr_n75106944)
print v(xbgr.mr_n75108128)
print v(xbgr.mr_n75108240)
print v(xbgr.mr_n75109968)
print v(xbgr.mr_n75114640)
print v(xbgr.mr_n75115328)
print v(xbgr.mr_n75116016)
print v(xbgr.mr_n75116704)
print v(xbgr.mr_n75117392)
print v(xbgr.mr_n75118080)
print v(xbgr.mr_n75118768)
print v(xbgr.mr_n75119456)
print v(xbgr.mr_n75120144)
print v(xbgr.mr_n75120832)
print v(xbgr.mr_n75121520)
print v(xbgr.mr_n75122208)
print v(xbgr.mr_n75125072)
print v(xbgr.mr_n75125520)
print v(xbgr.mr_n75126496)
print v(xbgr.mr_n75133200)
print v(xbgr.mr_n75135056)
print v(xbgr.mr_n75135168)
print v(xbgr.mr_n75137440)
print v(xbgr.mr_n75137552)
print v(xbgr.mr_n75138640)
print v(xbgr.mr_n75138752)
print v(xbgr.mr_n75139968)
print v(xbgr.mr_n75140080)
print v(xbgr.mr_n75140192)
print v(xbgr.mr_n75141216)
print v(xbgr.mr_n75141328)
print v(xbgr.mr_n75141440)
print v(xbgr.mr_n75142048)
print v(xbgr.mr_n75143408)
print v(xbgr.mr_n75143520)
print v(xbgr.mr_n75145728)
print v(xbgr.mr_n75145840)
print v(xbgr.mr_n75147632)
print v(xbgr.mr_n75147744)
print v(xbgr.mr_n75148896)
print v(xbgr.mr_n75149008)
print v(xbgr.mr_n75150160)
print v(xbgr.mr_n75150272)
print v(xbgr.mr_n75151424)
print v(xbgr.mr_n75151536)
print v(xbgr.mr_n75152688)
print v(xbgr.mr_n75152800)
print v(xbgr.mr_n75153952)
print v(xbgr.mr_n75154064)
print v(xbgr.mr_n75156112)
print v(xbgr.mr_n75157808)
print v(xbgr.mr_n75158928)
print v(xbgr.mr_n75160400)
print v(xbgr.mr_n75161968)
print v(xbgr.mr_n75163536)
print v(xbgr.mr_n75165104)
print v(xbgr.mr_n75166672)
print v(xbgr.mr_n75168240)
print v(xbgr.mr_n75169808)
print v(xbgr.mr_n75171376)
print v(xbgr.mr_n75172944)
print v(xbgr.mr_n75174512)
print v(xbgr.mr_n75176704)
print v(xbgr.mr_n75178272)
print v(xbgr.mr_n75179840)
print v(xbgr.mr_n75186032)
print v(xbgr.mr_n75188976)
print v(xbgr.mr_n75191568)
print v(xbgr.mr_n75192192)
print v(xbgr.mr_n75192640)
print v(xbgr.mr_n75192832)
print v(xbgr.mr_n75193024)
print v(xbgr.mr_n75193216)
print v(xbgr.mr_n75193408)
print v(xbgr.mr_n75195536)
print v(xbgr.mr_n75195808)
print v(xbgr.mr_n75196000)
print v(xbgr.mr_n75196512)
print v(xbgr.mr_n75199920)
print v(xbgr.mr_n75200112)
print v(xbgr.mr_n75200304)
print v(xbgr.mr_n75202528)
print v(xbgr.mr_n75204944)
print v(xbgr.mr_n75205216)
print v(xbgr.mr_n75205408)
print v(xbgr.mr_n75205920)
print v(xbgr.mr_n75208064)
print v(xbgr.mr_n75208176)
print v(xbgr.mr_n75209920)
print v(xbgr.mr_n75210192)
print v(xbgr.mr_n75210384)
print v(xbgr.mr_n75210896)
print v(xbgr.mr_n75212128)
print v(xbgr.mr_n75212640)
print v(xbgr.mr_n75218384)
print v(xbgr.mr_n75220768)
print v(xbgr.mr_n75220960)
print v(xbgr.mr_n75221472)
print v(xbgr.mr_n75222768)
print v(xbgr.mr_n75223280)
print v(xbgr.mr_n75223712)
print v(xbgr.mr_n75225792)
print v(xbgr.mr_n75227536)
print v(xbgr.mr_n75228048)
print v(xbgr.mr_n75230112)
print v(xbgr.mr_n75230624)
print v(xbgr.mr_n75232688)
print v(xbgr.mr_n75233200)
print v(xbgr.mr_n75234288)
print v(xbgr.mr_n75235264)
print v(xbgr.mr_n75235776)
print v(xbgr.mr_n75237840)
print v(xbgr.mr_n75238352)
print v(xbgr.mr_n75240480)
print v(xbgr.mr_n75240992)
print v(xbgr.mr_n75243056)
print v(xbgr.mr_n75243568)
print v(xbgr.mr_n75245568)
print v(xbgr.mr_n75246080)
print v(xbgr.mr_n75248144)
print v(xbgr.mr_n75248656)
print v(xbgr.mr_n75248928)
print v(xbgr.mr_n75250656)
print v(xbgr.mr_n75251984)
print v(xbgr.mr_n75256896)
print v(xbgr.mr_n75257008)
print v(xbgr.mr_n75258160)
print v(xbgr.mr_n75258272)
print v(xbgr.mr_n75259424)
print v(xbgr.mr_n75259536)
print v(xbgr.mr_n75260688)
print v(xbgr.mr_n75260800)
print v(xbgr.mr_n75261888)
print v(xbgr.mr_n75262000)
print v(xbgr.mr_n75263216)
print v(xbgr.mr_n75263328)
print v(xbgr.mr_n75264480)
print v(xbgr.mr_n75264592)
print v(xbgr.mr_n75265680)
print v(xbgr.mr_n75265792)
print v(xbgr.mr_n75266944)
print v(xbgr.mr_n75267056)
print v(xbgr.mr_n75268272)
print v(xbgr.mr_n75268384)
print v(xbgr.mr_n75269536)
print v(xbgr.mr_n75269648)
print v(xbgr.mr_n75270800)
print v(xbgr.mr_n75270912)
print v(xbgr.mr_n75272064)
print v(xbgr.mr_n75272176)
print v(xbgr.mr_n75273328)
print v(xbgr.mr_n75273440)
print v(xbgr.mr_n75273552)
print v(xbgr.mr_n75277008)
print v(xbgr.mr_n75277984)
print v(xbgr.mr_n75285904)
print v(xbgr.mr_n75286016)
print v(xbgr.mr_n75288784)
print v(xbgr.mr_n75289472)
print v(xbgr.mr_n75290320)
print v(xbgr.mr_n75292096)
print v(xbgr.mr_n75293040)
print v(xbgr.mr_n75293984)
print v(xbgr.mr_n75294928)
print v(xbgr.mr_n75295872)
print v(xbgr.mr_n75296816)
print v(xbgr.mr_n75297760)
print v(xbgr.mr_n75298704)
print v(xbgr.mr_n75299648)
print v(xbgr.mr_n75300592)
print v(xbgr.mr_n75301536)
print v(xbgr.mr_n75302480)
print v(xbgr.mr_n75303424)
print v(xbgr.mr_n75304368)
print v(xbgr.mr_n75305312)
print v(xbgr.mr_n75306256)
print v(xbgr.mr_n75311168)
print v(xbgr.mr_n75311312)
print v(xbgr.mr_n75312576)
print v(xbgr.mr_n75314144)
print v(xbgr.mr_n75317488)
print v(xbgr.mr_n75318192)
print v(xbgr.mr_n75318720)
print v(xbgr.mr_n75318832)
print v(xbgr.mr_n75319776)
print v(xbgr.mr_n75320928)
print v(xbgr.mr_n75321040)
print v(xbgr.mr_n75322816)
print v(xbgr.mr_n75322928)
print v(xbgr.mr_n75323872)
print v(xbgr.mr_n75325024)
print v(xbgr.mr_n75325136)
print v(xbgr.mr_n75326912)
print v(xbgr.mr_n75327024)
print v(xbgr.mr_n75327968)
print v(xbgr.mr_n75329120)
print v(xbgr.mr_n75329232)
print v(xbgr.mr_n75330480)
print v(xbgr.mr_n75331008)
print v(xbgr.mr_n75331120)
print v(xbgr.mr_n75332064)
print v(xbgr.mr_n75333216)
print v(xbgr.mr_n75333328)
print v(xbgr.mr_n75335104)
print v(xbgr.mr_n75335216)
print v(xbgr.mr_n75336160)
print v(xbgr.mr_n75337312)
print v(xbgr.mr_n75337424)
print v(xbgr.mr_n75339200)
print v(xbgr.mr_n75339312)
print v(xbgr.mr_n75340256)
print v(xbgr.mr_n75341408)
print v(xbgr.mr_n75341520)
print v(xbgr.mr_n75343296)
print v(xbgr.mr_n75343408)
print v(xbgr.mr_n75344352)
print v(xbgr.mr_n75345504)
print v(xbgr.mr_n75345616)
print v(xbgr.mr_n75346784)
print v(xbgr.mr_n75347392)
print v(xbgr.mr_n75347504)
print v(xbgr.mr_n75348448)
print v(xbgr.mr_n75349600)
print v(xbgr.mr_n75349712)
print v(xbgr.mr_n75351488)
print v(xbgr.mr_n75351600)
print v(xbgr.mr_n75352912)
print v(xbgr.mr_n75356128)
print v(xbgr.mr_n75357696)
print v(xbgr.mr_n75359264)
print v(xbgr.mr_n75360832)
print v(xbgr.mr_n75362400)
print v(xbgr.mr_n75363968)
print v(xbgr.mr_n75365536)
print v(xbgr.mr_n75366752)
print v(xbgr.mr_n75367440)
print v(xbgr.mr_n75379296)
print v(xbgr.mr_n75381712)
print v(xbgr.mr_n75384400)
print v(xbgr.mr_n75385472)
print v(xbgr.mr_n75385664)
print v(xbgr.mr_n75385856)
print v(xbgr.mr_n75386240)
print v(xbgr.mr_n75388560)
print v(xbgr.mr_n75388832)
print v(xbgr.mr_n75389024)
print v(xbgr.mr_n75389536)
print v(xbgr.mr_n75390448)
print v(xbgr.mr_n75391632)
print v(xbgr.mr_n75392656)
print v(xbgr.mr_n75395488)
print v(xbgr.mr_n75395680)
print v(xbgr.mr_n75396192)
print v(xbgr.mr_n75398928)
print v(xbgr.mr_n75399200)
print v(xbgr.mr_n75399392)
print v(xbgr.mr_n75399904)
print v(xbgr.mr_n75402048)
print v(xbgr.mr_n75402160)
print v(xbgr.mr_n75402496)
print v(xbgr.mr_n75403904)
print v(xbgr.mr_n75404176)
print v(xbgr.mr_n75404368)
print v(xbgr.mr_n75404880)
print v(xbgr.mr_n75404992)
print v(xbgr.mr_n75406112)
print v(xbgr.mr_n75406624)
print v(xbgr.mr_n75406928)
print v(xbgr.mr_n75409776)
print v(xbgr.mr_n75409888)
print v(xbgr.mr_n75410528)
print v(xbgr.mr_n75410720)
print v(xbgr.mr_n75411040)
print v(xbgr.mr_n75411520)
print v(xbgr.mr_n75411712)
print v(xbgr.mr_n75412224)
print v(xbgr.mr_n75412336)
print v(xbgr.mr_n75412720)
print v(xbgr.mr_n75414224)
print v(xbgr.mr_n75415952)
print v(xbgr.mr_n75417936)
print v(xbgr.mr_n75419680)
print v(xbgr.mr_n75419952)
print v(xbgr.mr_n75420144)
print v(xbgr.mr_n75420656)
print v(xbgr.mr_n75423888)
print v(xbgr.mr_n75424000)
print v(xbgr.mr_n75425744)
print v(xbgr.mr_n75426016)
print v(xbgr.mr_n75426208)
print v(xbgr.mr_n75426720)
print v(xbgr.mr_n75427952)
print v(xbgr.mr_n75428464)
print v(xbgr.mr_n75431904)
print v(xbgr.mr_n75432176)
print v(xbgr.mr_n75432368)
print v(xbgr.mr_n75432880)
print v(xbgr.mr_n75435024)
print v(xbgr.mr_n75435216)
print v(xbgr.mr_n75435408)
print v(xbgr.mr_n75437216)
print v(xbgr.mr_n75437408)
print v(xbgr.mr_n75437920)
print v(xbgr.mr_n75439088)
print v(xbgr.mr_n75439600)
print v(xbgr.mr_n75443040)
print v(xbgr.mr_n75443312)
print v(xbgr.mr_n75443504)
print v(xbgr.mr_n75444016)
print v(xbgr.mr_n75446160)
print v(xbgr.mr_n75446272)
print v(xbgr.mr_n75448016)
print v(xbgr.mr_n75448288)
print v(xbgr.mr_n75448480)
print v(xbgr.mr_n75448992)
print v(xbgr.mr_n75450224)
print v(xbgr.mr_n75450736)
print v(xbgr.mr_n75455904)
print v(xbgr.mr_n75457792)
print v(xbgr.mr_n75457904)
print v(xbgr.mr_n75458736)
print v(xbgr.mr_n75458848)
print v(xbgr.mr_n75459680)
print v(xbgr.mr_n75459792)
print v(xbgr.mr_n75460880)
print v(xbgr.mr_n75460992)
print v(xbgr.mr_n75462144)
print v(xbgr.mr_n75462256)
print v(xbgr.mr_n75463408)
print v(xbgr.mr_n75463520)
print v(xbgr.mr_n75464672)
print v(xbgr.mr_n75464784)
print v(xbgr.mr_n75465936)
print v(xbgr.mr_n75466048)
print v(xbgr.mr_n75467200)
print v(xbgr.mr_n75467312)
print v(xbgr.mr_n75468464)
print v(xbgr.mr_n75468576)
print v(xbgr.mr_n75469728)
print v(xbgr.mr_n75469840)
print v(xbgr.mr_n75470992)
print v(xbgr.mr_n75471104)
print v(xbgr.mr_n75472256)
print v(xbgr.mr_n75472368)
print v(xbgr.mr_n75473520)
print v(xbgr.mr_n75473632)
print v(xbgr.mr_n75474784)
print v(xbgr.mr_n75474896)
print v(xbgr.mr_n75481408)
print v(xbgr.mr_n75482096)
print v(xbgr.mr_n75482784)
print v(xbgr.mr_n75483504)
print v(xbgr.mr_n75484448)
print v(xbgr.mr_n75485392)
print v(xbgr.mr_n75486336)
print v(xbgr.mr_n75487280)
print v(xbgr.mr_n75488224)
print v(xbgr.mr_n75489168)
print v(xbgr.mr_n75490112)
print v(xbgr.mr_n75491056)
print v(xbgr.mr_n75492000)
print v(xbgr.mr_n75492944)
print v(xbgr.mr_n75493888)
print v(xbgr.mr_n75494832)
print v(xbgr.mr_n75495776)
print v(xbgr.mr_n75496720)
print v(xbgr.mr_n75497664)
print v(xbgr.mr_n75504112)
print v(xbgr.mr_n75507648)
print v(xbgr.mr_n75510912)
print v(xbgr.mr_n75513200)
print v(xbgr.mr_n75514768)
print v(xbgr.mr_n75517248)
print v(xbgr.mr_n75518384)
print v(xbgr.mr_n75518496)
print v(xbgr.mr_n75519440)
print v(xbgr.mr_n75520592)
print v(xbgr.mr_n75520704)
print v(xbgr.mr_n75522480)
print v(xbgr.mr_n75522592)
print v(xbgr.mr_n75523536)
print v(xbgr.mr_n75524624)
print v(xbgr.mr_n75524736)
print v(xbgr.mr_n75526576)
print v(xbgr.mr_n75526688)
print v(xbgr.mr_n75527632)
print v(xbgr.mr_n75528784)
print v(xbgr.mr_n75528896)
print v(xbgr.mr_n75530064)
print v(xbgr.mr_n75530672)
print v(xbgr.mr_n75530784)
print v(xbgr.mr_n75531728)
print v(xbgr.mr_n75532880)
print v(xbgr.mr_n75532992)
print v(xbgr.mr_n75534160)
print v(xbgr.mr_n75534768)
print v(xbgr.mr_n75534880)
print v(xbgr.mr_n75535824)
print v(xbgr.mr_n75536976)
print v(xbgr.mr_n75537088)
print v(xbgr.mr_n75538864)
print v(xbgr.mr_n75538976)
print v(xbgr.mr_n75539920)
print v(xbgr.mr_n75541072)
print v(xbgr.mr_n75541184)
print v(xbgr.mr_n75542960)
print v(xbgr.mr_n75543072)
print v(xbgr.mr_n75544016)
print v(xbgr.mr_n75545168)
print v(xbgr.mr_n75545280)
print v(xbgr.mr_n75546576)
print v(xbgr.mr_n75546832)
print v(xbgr.mr_n75546944)
print v(xbgr.mr_n75548736)
print v(xbgr.mr_n75549856)
print v(xbgr.mr_n75552752)
print v(xbgr.mr_n75554320)
print v(xbgr.mr_n75555888)
print v(xbgr.mr_n75557456)
print v(xbgr.mr_n75559024)
print v(xbgr.mr_n75560592)
print v(xbgr.mr_n75562160)
print v(xbgr.mr_n75569136)
print v(xbgr.mr_n75578080)
print v(xbgr.mr_n75580912)
print v(xbgr.mr_n75581216)
print v(xbgr.mr_n75582528)
print v(xbgr.mr_n75587696)
print v(xbgr.mr_n75587888)
print v(xbgr.mr_n75588576)
print v(xbgr.mr_n75589152)
print v(xbgr.mr_n75589840)
print v(xbgr.mr_n75590272)
print v(xbgr.mr_n75591104)
print v(xbgr.mr_n75591808)
print v(xbgr.mr_n75592368)
print v(xbgr.mr_n75592800)
print v(xbgr.mr_n75593632)
print v(xbgr.mr_n75594064)
print v(xbgr.mr_n75594896)
print v(xbgr.mr_n75595472)
print v(xbgr.mr_n75596160)
print v(xbgr.mr_n75596592)
print v(xbgr.mr_n75597424)
print v(xbgr.mr_n75598000)
print v(xbgr.mr_n75598688)
print v(xbgr.mr_n75599264)
print v(xbgr.mr_n75599952)
print v(xbgr.mr_n75600528)
print v(xbgr.mr_n75601216)
print v(xbgr.mr_n75601920)
print v(xbgr.mr_n75602480)
print v(xbgr.mr_n75603056)
print v(xbgr.mr_n75603744)
print v(xbgr.mr_n75604448)
print v(xbgr.mr_n75605008)
print v(xbgr.mr_n75605584)
print v(xbgr.mr_n75606272)
print v(xbgr.mr_n75606848)
print v(xbgr.mr_n75607536)
print v(xbgr.mr_n75608112)
print v(xbgr.mr_n75608800)
print v(xbgr.mr_n75612304)
print v(xbgr.mr_n75612416)
print v(xbgr.mr_n75612528)
print v(xbgr.mr_n75612720)
print v(xbgr.mr_n75612912)
print v(xbgr.mr_n75615296)
print v(xbgr.mr_n75615488)
print v(xbgr.mr_n75616000)
print v(xbgr.mr_n75617168)
print v(xbgr.mr_n75617680)
print v(xbgr.mr_n75618368)
print v(xbgr.mr_n75619232)
print v(xbgr.mr_n75619744)
print v(xbgr.mr_n75621680)
print v(xbgr.mr_n75622192)
print v(xbgr.mr_n75623008)
print v(xbgr.mr_n75624128)
print v(xbgr.mr_n75624640)
print v(xbgr.mr_n75626640)
print v(xbgr.mr_n75627152)
print v(xbgr.mr_n75629024)
print v(xbgr.mr_n75629536)
print v(xbgr.mr_n75631392)
print v(xbgr.mr_n75631984)
print v(xbgr.mr_n75633920)
print v(xbgr.mr_n75634432)
print v(xbgr.mr_n75636368)
print v(xbgr.mr_n75636880)
print v(xbgr.mr_n75638816)
print v(xbgr.mr_n75639328)
print v(xbgr.mr_n75640144)
print v(xbgr.mr_n75641264)
print v(xbgr.mr_n75641776)
print v(xbgr.mr_n75643632)
print v(xbgr.mr_n75644224)
print v(xbgr.mr_n75646160)
print v(xbgr.mr_n75646672)
print v(xbgr.mr_n75648608)
print v(xbgr.mr_n75649120)
print v(xbgr.mr_n75651120)
print v(xbgr.mr_n75651632)
print v(xbgr.mr_n75652448)
print v(xbgr.mr_n75653568)
print v(xbgr.mr_n75654080)
print v(xbgr.mr_n75654960)
print v(xbgr.mr_n75656304)
print v(xbgr.mr_n75661872)
print v(xbgr.mr_n75663088)
print v(xbgr.mr_n75663200)
print v(xbgr.mr_n75664352)
print v(xbgr.mr_n75664464)
print v(xbgr.mr_n75665616)
print v(xbgr.mr_n75665728)
print v(xbgr.mr_n75666880)
print v(xbgr.mr_n75666992)
print v(xbgr.mr_n75668144)
print v(xbgr.mr_n75668256)
print v(xbgr.mr_n75669408)
print v(xbgr.mr_n75669520)
print v(xbgr.mr_n75670672)
print v(xbgr.mr_n75670784)
print v(xbgr.mr_n75671872)
print v(xbgr.mr_n75671984)
print v(xbgr.mr_n75673200)
print v(xbgr.mr_n75673312)
print v(xbgr.mr_n75674400)
print v(xbgr.mr_n75674512)
print v(xbgr.mr_n75675664)
print v(xbgr.mr_n75675776)
print v(xbgr.mr_n75676928)
print v(xbgr.mr_n75677040)
print v(xbgr.mr_n75678256)
print v(xbgr.mr_n75678368)
print v(xbgr.mr_n75679520)
print v(xbgr.mr_n75679632)
print v(xbgr.mr_n75679744)
print v(xbgr.mr_n75680784)
print v(xbgr.mr_n75680896)
print v(xbgr.mr_n75681776)
print v(xbgr.mr_n75681888)
print v(xbgr.mr_n75682000)
print v(xbgr.mr_n75682112)
print v(xbgr.mr_n75682224)
print v(xbgr.mr_n75682336)
print v(xbgr.mr_n75682448)
print v(xbgr.mr_n75683696)
print v(xbgr.mr_n75684384)
print v(xbgr.mr_n75686224)
print v(xbgr.mr_n75687840)
print v(xbgr.mr_n75688784)
print v(xbgr.mr_n75689728)
print v(xbgr.mr_n75694640)
print v(xbgr.mr_n75705552)
print v(xbgr.mr_n75707424)
print v(xbgr.mr_n75710384)
print v(xbgr.mr_n75713552)
print v(xbgr.mr_n75715120)
print v(xbgr.mr_n75716928)
print v(xbgr.mr_n75717984)
print v(xbgr.mr_n75719216)
print v(xbgr.mr_n75719328)
print v(xbgr.mr_n75720272)
print v(xbgr.mr_n75721424)
print v(xbgr.mr_n75721536)
print v(xbgr.mr_n75723248)
print v(xbgr.mr_n75723360)
print v(xbgr.mr_n75724304)
print v(xbgr.mr_n75725520)
print v(xbgr.mr_n75725632)
print v(xbgr.mr_n75726800)
print v(xbgr.mr_n75727408)
print v(xbgr.mr_n75727520)
print v(xbgr.mr_n75728464)
print v(xbgr.mr_n75729616)
print v(xbgr.mr_n75729728)
print v(xbgr.mr_n75731504)
print v(xbgr.mr_n75731616)
print v(xbgr.mr_n75732560)
print v(xbgr.mr_n75733712)
print v(xbgr.mr_n75733824)
print v(xbgr.mr_n75735536)
print v(xbgr.mr_n75735648)
print v(xbgr.mr_n75736592)
print v(xbgr.mr_n75737808)
print v(xbgr.mr_n75737920)
print v(xbgr.mr_n75739696)
print v(xbgr.mr_n75739808)
print v(xbgr.mr_n75740752)
print v(xbgr.mr_n75741904)
print v(xbgr.mr_n75742016)
print v(xbgr.mr_n75743792)
print v(xbgr.mr_n75743904)
print v(xbgr.mr_n75744848)
print v(xbgr.mr_n75746000)
print v(xbgr.mr_n75746112)
print v(xbgr.mr_n75747280)
print v(xbgr.mr_n75747888)
print v(xbgr.mr_n75748000)
print v(xbgr.mr_n75748944)
print v(xbgr.mr_n75750096)
print v(xbgr.mr_n75750208)
print v(xbgr.mr_n75751984)
print v(xbgr.mr_n75752096)
print v(xbgr.mr_n75753408)
print v(xbgr.mr_n75754528)
print v(xbgr.mr_n75756624)
print v(xbgr.mr_n75758192)
print v(xbgr.mr_n75759760)
print v(xbgr.mr_n75761328)
print v(xbgr.mr_n75762896)
print v(xbgr.mr_n75764464)
print v(xbgr.mr_n75766032)
print v(xbgr.mr_n75767184)
print v(xbgr.mr_n75769024)
print v(xbgr.mr_n75770208)
print v(xbgr.mr_n75771712)
print v(xbgr.mr_n75777024)
print v(xbgr.mr_n75778560)
print v(xbgr.mr_n75779584)
print v(xbgr.mr_n75783776)
print v(xbgr.mr_n75785568)
print v(xbgr.mr_n75785680)
print v(xbgr.mr_n75786448)
print v(xbgr.mr_n75786640)
print v(xbgr.mr_n75786832)
print v(xbgr.mr_n75787024)
print v(xbgr.mr_n75787216)
print v(xbgr.mr_n75789792)
print v(xbgr.mr_n75790304)
print v(xbgr.mr_n75794240)
print v(xbgr.mr_n75794352)
print v(xbgr.mr_n75796096)
print v(xbgr.mr_n75796368)
print v(xbgr.mr_n75796560)
print v(xbgr.mr_n75797072)
print v(xbgr.mr_n75799216)
print v(xbgr.mr_n75799328)
print v(xbgr.mr_n75801072)
print v(xbgr.mr_n75801344)
print v(xbgr.mr_n75801536)
print v(xbgr.mr_n75802048)
print v(xbgr.mr_n75804192)
print v(xbgr.mr_n75804304)
print v(xbgr.mr_n75806048)
print v(xbgr.mr_n75806240)
print v(xbgr.mr_n75806432)
print v(xbgr.mr_n75807024)
print v(xbgr.mr_n75809168)
print v(xbgr.mr_n75809280)
print v(xbgr.mr_n75811024)
print v(xbgr.mr_n75811296)
print v(xbgr.mr_n75811488)
print v(xbgr.mr_n75812000)
print v(xbgr.mr_n75814144)
print v(xbgr.mr_n75814256)
print v(xbgr.mr_n75816000)
print v(xbgr.mr_n75816272)
print v(xbgr.mr_n75816464)
print v(xbgr.mr_n75818144)
print v(xbgr.mr_n75818976)
print v(xbgr.mr_n75821104)
print v(xbgr.mr_n75821216)
print v(xbgr.mr_n75821328)
print v(xbgr.mr_n75821440)
print v(xbgr.mr_n75823184)
print v(xbgr.mr_n75823456)
print v(xbgr.mr_n75823648)
print v(xbgr.mr_n75824160)
print v(xbgr.mr_n75827392)
print v(xbgr.mr_n75827504)
print v(xbgr.mr_n75829248)
print v(xbgr.mr_n75829520)
print v(xbgr.mr_n75829712)
print v(xbgr.mr_n75830224)
print v(xbgr.mr_n75832368)
print v(xbgr.mr_n75832560)
print v(xbgr.mr_n75832752)
print v(xbgr.mr_n75834560)
print v(xbgr.mr_n75834752)
print v(xbgr.mr_n75835264)
print v(xbgr.mr_n75837344)
print v(xbgr.mr_n75837456)
print v(xbgr.mr_n75839200)
print v(xbgr.mr_n75839472)
print v(xbgr.mr_n75839664)
print v(xbgr.mr_n75840176)
print v(xbgr.mr_n75842320)
print v(xbgr.mr_n75842432)
print v(xbgr.mr_n75844176)
print v(xbgr.mr_n75844448)
print v(xbgr.mr_n75844640)
print v(xbgr.mr_n75845152)
print v(xbgr.mr_n75847456)
print v(xbgr.mr_n75847648)
print v(xbgr.mr_n75847840)
print v(xbgr.mr_n75848032)
print v(xbgr.mr_n75848224)
print v(xbgr.mr_n75850448)
print v(xbgr.mr_n75852272)
print v(xbgr.mr_n75852464)
print v(xbgr.mr_n75852656)
print v(xbgr.mr_n75854464)
print v(xbgr.mr_n75854656)
print v(xbgr.mr_n75855168)
print v(xbgr.mr_n75857408)
print v(xbgr.mr_n75857600)
print v(xbgr.mr_n75857792)
print v(xbgr.mr_n75857984)
print v(xbgr.mr_n75858176)
print v(xbgr.mr_n75860400)
print v(xbgr.mr_n75862224)
print v(xbgr.mr_n75862416)
print v(xbgr.mr_n75862608)
print v(xbgr.mr_n75864416)
print v(xbgr.mr_n75864608)
print v(xbgr.mr_n75865120)
print v(xbgr.mr_n75867200)
print v(xbgr.mr_n75867312)
print v(xbgr.mr_n75869056)
print v(xbgr.mr_n75869328)
print v(xbgr.mr_n75869520)
print v(xbgr.mr_n75870032)
print v(xbgr.mr_n75871392)
print v(xbgr.mr_n75872640)
print v(xbgr.mr_n75873856)
print v(xbgr.mr_n75876256)
print v(xbgr.mr_n75881664)
print v(xbgr.mr_n75885856)
print v(xbgr.mr_n75888832)
print v(xbgr.mr_n75890784)
print v(xbgr.mr_n75891840)
print v(xbgr.mr_n75893152)
print v(xbgr.mr_n75901392)
print v(xbgr.mr_n75901824)
print v(xbgr.mr_n75902080)
print v(xbgr.mr_n75902496)
print v(xbgr.mr_n75903488)
print v(xbgr.mr_n75907328)
print v(xbgr.mr_n75907440)
print v(xbgr.mr_n75908592)
print v(xbgr.mr_n75908704)
print v(xbgr.mr_n75909856)
print v(xbgr.mr_n75909968)
print v(xbgr.mr_n75911120)
print v(xbgr.mr_n75911232)
print v(xbgr.mr_n75912384)
print v(xbgr.mr_n75912496)
print v(xbgr.mr_n75913648)
print v(xbgr.mr_n75913760)
print v(xbgr.mr_n75914912)
print v(xbgr.mr_n75915024)
print v(xbgr.mr_n75916176)
print v(xbgr.mr_n75916288)
print v(xbgr.mr_n75917440)
print v(xbgr.mr_n75917552)
print v(xbgr.mr_n75918704)
print v(xbgr.mr_n75918816)
print v(xbgr.mr_n75919968)
print v(xbgr.mr_n75920080)
print v(xbgr.mr_n75921232)
print v(xbgr.mr_n75921344)
print v(xbgr.mr_n75922496)
print v(xbgr.mr_n75922608)
print v(xbgr.mr_n75923760)
print v(xbgr.mr_n75923872)
print v(xbgr.mr_n75925024)
print v(xbgr.mr_n75925136)
print v(xbgr.mr_n75927872)
print v(xbgr.mr_n75929728)
print v(xbgr.mr_n75930080)
print v(xbgr.mr_n75935296)
print v(xbgr.mr_n75935984)
print v(xbgr.mr_n75936672)
print v(xbgr.mr_n75937392)
print v(xbgr.mr_n75938336)
print v(xbgr.mr_n75939280)
print v(xbgr.mr_n75940224)
print v(xbgr.mr_n75941168)
print v(xbgr.mr_n75942112)
print v(xbgr.mr_n75943056)
print v(xbgr.mr_n75944000)
print v(xbgr.mr_n75944944)
print v(xbgr.mr_n75945888)
print v(xbgr.mr_n75946832)
print v(xbgr.mr_n75947776)
print v(xbgr.mr_n75948720)
print v(xbgr.mr_n75949664)
print v(xbgr.mr_n75950608)
print v(xbgr.mr_n75951552)
print v(xbgr.mr_n75952112)
print v(xbgr.mr_n75952224)
print v(xbgr.mr_n75952480)
print v(xbgr.mr_n75953568)
print v(xbgr.mr_n75955472)
print v(xbgr.mr_n75956800)
print v(xbgr.mr_n75957744)
print v(xbgr.mr_n75958688)
print v(xbgr.mr_n75961008)
print v(xbgr.mr_n75963856)
print v(xbgr.mr_n75966800)
print v(xbgr.mr_n75971024)
print v(xbgr.mr_n75973856)
print v(xbgr.mr_n75974912)
print v(xbgr.mr_n75978688)
print v(xbgr.mr_n75978864)
print v(xbgr.mr_n75979808)
print v(xbgr.mr_n75980336)
print v(xbgr.mr_n75980624)
print v(xbgr.mr_n75980800)
print v(xbgr.mr_n75983856)
print v(xbgr.mr_n75984208)
print v(xbgr.mr_n75984320)
print v(xbgr.mr_n75986144)
print v(xbgr.mr_n75987200)
print v(xbgr.mr_n75988192)
print v(xbgr.mr_n75989136)
print v(xbgr.mr_n75991248)
print v(xbgr.mr_n75992768)
print v(xbgr.mr_n75993008)
print v(xbgr.mr_n75993504)
print v(xbgr.mr_n75993824)
print v(xbgr.mr_n75998640)
print v(xbgr.mr_n76001152)
print v(xbgr.mr_n76001840)
print v(xbgr.mr_n76002192)
print v(xbgr.mr_n76003424)
print v(xbgr.mr_n76004192)
print v(xbgr.mr_n76005136)
print v(xbgr.mr_n76006080)
print v(xbgr.mr_n76007024)
print v(xbgr.mr_n76007968)
print v(xbgr.mr_n76008912)
print v(xbgr.mr_n76009856)
print v(xbgr.mr_n76010800)
print v(xbgr.mr_n76011744)
print v(xbgr.mr_n76012688)
print v(xbgr.mr_n76013632)
print v(xbgr.mr_n76014576)
print v(xbgr.mr_n76015520)
print v(xbgr.mr_n76016464)
print v(xbgr.mr_n76017408)
print v(xbgr.mr_n76018352)
print v(xbgr.mr_n76019296)
print v(xbgr.mr_n76020240)
print v(xbgr.mr_n76021184)
print v(xbgr.mr_n76022128)
print v(xbgr.mr_n76023072)
print v(xbgr.mr_n76024016)
print v(xbgr.mr_n76024960)
print v(xbgr.mr_n76025904)
print v(xbgr.mr_n76026848)
print v(xbgr.mr_n76027792)
print v(xbgr.mr_n76028736)
print v(xbgr.mr_n76029680)
print v(xbgr.mr_n76030624)
print v(xbgr.mr_n76031568)
print v(xbgr.mr_n76032512)
print v(xbgr.mr_n76033456)
print v(xbgr.mr_n76034400)
print v(xbgr.mr_n76035344)
print v(xbgr.mr_n76036288)
print v(xbgr.mr_n76037232)
print v(xbgr.mr_n76038176)
print v(xbgr.mr_n76039120)
print v(xbgr.mr_n76040064)
print v(xbgr.mr_n76041008)
print v(xbgr.mr_n76041952)
print v(xbgr.mr_n76042896)
print v(xbgr.mr_n76043840)
print v(xbgr.mr_n76044784)
print v(xbgr.mr_n76045728)
print v(xbgr.mr_n76046672)
print v(xbgr.mr_n76047616)
print v(xbgr.mr_n76048560)
print v(xbgr.mr_n76049504)
print v(xbgr.mr_n76050448)
print v(xbgr.mr_n76051392)
print v(xbgr.mr_n76052336)
print v(xbgr.mr_n76053280)
print v(xbgr.mr_n76054224)
print v(xbgr.mr_n76055168)
print v(xbgr.mr_n76056112)
print v(xbgr.mr_n76057056)
print v(xbgr.mr_n76058000)
print v(xbgr.mr_n76058944)
print v(xbgr.mr_n76059888)
print v(xbgr.mr_n76060832)
print v(xbgr.mr_n76061776)
print v(xbgr.mr_n76062720)
print v(xbgr.mr_n76063664)
print v(xbgr.mr_n76064608)
print v(xbgr.mr_n76065552)
print v(xbgr.mr_n76066496)
print v(xbgr.mr_n76067440)
print v(xbgr.mr_n76068384)
print v(xbgr.mr_n76069328)
print v(xbgr.mr_n76070272)
print v(xbgr.mr_n76071216)
print v(xbgr.mr_n76072160)
print v(xbgr.mr_n76073104)
print v(xbgr.mr_n76074048)
print v(xbgr.mr_n76074992)
print v(xbgr.mr_n76075936)
print v(xbgr.mr_n76076880)
print v(xbgr.mr_n76077824)
print v(xbgr.mr_n76078768)
print v(xbgr.mr_n76079712)
print v(xbgr.mr_n76080656)
print v(xbgr.mr_n76081600)
print v(xbgr.mr_n76082544)
print v(xbgr.mr_n76083488)
print v(xbgr.mr_n76084432)
print v(xbgr.mr_n76084544)
print v(xbgr.mr_n76085376)
print v(xbgr.mr_n76086320)
print v(xbgr.mr_n76087264)
print v(xbgr.mr_n76087376)
print v(xbgr.mr_n76087488)
print v(xbgr.mr_n76088720)
print v(xbgr.mr_n76089424)
print v(xbgr.mr_n76089536)
print v(xbgr.mr_n76092784)
print v(xbgr.mr_n76092976)
print v(xbgr.mr_n76093168)
print v(xbgr.mr_n76093360)
print v(xbgr.mr_n76094272)
print v(xbgr.mr_n76094544)
print v(xbgr.mr_n76094736)
print v(xbgr.mr_n76095248)
print v(xbgr.mr_n76100464)
print v(xbgr.mr_n76100576)
print v(xbgr.mr_n76101488)
print v(xbgr.mr_n76101760)
print v(xbgr.mr_n76101952)
print v(xbgr.mr_n76102464)
print v(xbgr.mr_n76105264)
print v(xbgr.mr_n76105376)
print v(xbgr.mr_n76105488)
print v(xbgr.mr_n76105600)
print v(xbgr.mr_n76107344)
print v(xbgr.mr_n76107616)
print v(xbgr.mr_n76107808)
print v(xbgr.mr_n76108320)
print v(xbgr.mr_n76109472)
print v(xbgr.mr_n76110064)
print v(xbgr.mr_n76112304)
print v(xbgr.mr_n76112912)
print v(xbgr.mr_n76113104)
print v(xbgr.mr_n76113296)
print v(xbgr.mr_n76115104)
print v(xbgr.mr_n76115296)
print v(xbgr.mr_n76115808)
print v(xbgr.mr_n76118928)
print v(xbgr.mr_n76119040)
print v(xbgr.mr_n76119152)
print v(xbgr.mr_n76119264)
print v(xbgr.mr_n76121008)
print v(xbgr.mr_n76121280)
print v(xbgr.mr_n76121472)
print v(xbgr.mr_n76121984)
print v(xbgr.mr_n76125168)
print v(xbgr.mr_n76125280)
print v(xbgr.mr_n76125392)
print v(xbgr.mr_n76125504)
print v(xbgr.mr_n76127248)
print v(xbgr.mr_n76127520)
print v(xbgr.mr_n76127712)
print v(xbgr.mr_n76128224)
print v(xbgr.mr_n76129456)
print v(xbgr.mr_n76129968)
print v(xbgr.mr_n76132816)
print v(xbgr.mr_n76132928)
print v(xbgr.mr_n76134672)
print v(xbgr.mr_n76134944)
print v(xbgr.mr_n76135136)
print v(xbgr.mr_n76135648)
print v(xbgr.mr_n76138832)
print v(xbgr.mr_n76138944)
print v(xbgr.mr_n76139056)
print v(xbgr.mr_n76139168)
print v(xbgr.mr_n76140912)
print v(xbgr.mr_n76141184)
print v(xbgr.mr_n76141376)
print v(xbgr.mr_n76141888)
print v(xbgr.mr_n76145072)
print v(xbgr.mr_n76145184)
print v(xbgr.mr_n76145296)
print v(xbgr.mr_n76145408)
print v(xbgr.mr_n76147152)
print v(xbgr.mr_n76147424)
print v(xbgr.mr_n76147616)
print v(xbgr.mr_n76148128)
print v(xbgr.mr_n76149360)
print v(xbgr.mr_n76149872)
print v(xbgr.mr_n76152720)
print v(xbgr.mr_n76152832)
print v(xbgr.mr_n76154576)
print v(xbgr.mr_n76154848)
print v(xbgr.mr_n76155040)
print v(xbgr.mr_n76155552)
print v(xbgr.mr_n76158736)
print v(xbgr.mr_n76158848)
print v(xbgr.mr_n76158960)
print v(xbgr.mr_n76159072)
print v(xbgr.mr_n76160816)
print v(xbgr.mr_n76161088)
print v(xbgr.mr_n76161280)
print v(xbgr.mr_n76161792)
print v(xbgr.mr_n76164976)
print v(xbgr.mr_n76165088)
print v(xbgr.mr_n76165200)
print v(xbgr.mr_n76165312)
print v(xbgr.mr_n76167056)
print v(xbgr.mr_n76167328)
print v(xbgr.mr_n76167520)
print v(xbgr.mr_n76168032)
print v(xbgr.mr_n76169264)
print v(xbgr.mr_n76169776)
print v(xbgr.mr_n76172624)
print v(xbgr.mr_n76172736)
print v(xbgr.mr_n76174480)
print v(xbgr.mr_n76174752)
print v(xbgr.mr_n76174944)
print v(xbgr.mr_n76175456)
print v(xbgr.mr_n76177520)
print v(xbgr.mr_n76177632)
print v(xbgr.mr_n76178144)
print v(xbgr.mr_n76178256)
print v(xbgr.mr_n76178768)
print v(xbgr.mr_n76178880)
print v(xbgr.mr_n76179648)
print v(xbgr.mr_n76179760)
print v(xbgr.mr_n76180592)
print v(xbgr.mr_n76180704)
print v(xbgr.mr_n76181792)
print v(xbgr.mr_n76181904)
print v(xbgr.mr_n76183056)
print v(xbgr.mr_n76183168)
print v(xbgr.mr_n76184320)
print v(xbgr.mr_n76184432)
print v(xbgr.mr_n76185584)
print v(xbgr.mr_n76185696)
print v(xbgr.mr_n76186848)
print v(xbgr.mr_n76186960)
print v(xbgr.mr_n76188112)
print v(xbgr.mr_n76188224)
print v(xbgr.mr_n76189376)
print v(xbgr.mr_n76189488)
print v(xbgr.mr_n76190640)
print v(xbgr.mr_n76190752)
print v(xbgr.mr_n76191904)
print v(xbgr.mr_n76192016)
print v(xbgr.mr_n76193168)
print v(xbgr.mr_n76193280)
print v(xbgr.mr_n76194432)
print v(xbgr.mr_n76194544)
print v(xbgr.mr_n76196640)
print v(xbgr.mr_n76200992)
print v(xbgr.mr_n76204464)
print v(xbgr.mr_n76215008)
print v(xbgr.mr_n76217312)
print v(xbgr.mr_n76219232)
print v(xbgr.mr_n76220560)
print v(xbgr.mr_n76222256)
print v(xbgr.mr_n76223376)
print v(xbgr.mr_n76223488)
print v(xbgr.mr_n76223792)
print v(xbgr.mr_n76223904)
print v(xbgr.mr_n76224016)
print v(xbgr.mr_n76225440)
print v(xbgr.mr_n76225552)
print v(xbgr.mr_n76232832)
print v(xbgr.mr_n76234592)
print v(xbgr.mr_n76242624)
print v(xbgr.mr_n76244032)
print v(xbgr.mr_n76245536)
print v(xbgr.mr_n76246464)
print v(xbgr.mr_n76246640)
print v(xbgr.mr_n76248512)
print v(xbgr.mr_n76250464)
print v(xbgr.mr_n76250880)
print v(xbgr.mr_n76251360)
print v(xbgr.mr_n76252160)
print v(xbgr.mr_n76252592)
print v(xbgr.mr_n76260288)
print v(xbgr.mr_n76261232)
print v(xbgr.mr_n76262176)
print v(xbgr.mr_n76263120)
print v(xbgr.mr_n76264064)
print v(xbgr.mr_n76265008)
print v(xbgr.mr_n76265952)
print v(xbgr.mr_n76266896)
print v(xbgr.mr_n76267840)
print v(xbgr.mr_n76268784)
print v(xbgr.mr_n76269728)
print v(xbgr.mr_n76270672)
print v(xbgr.mr_n76271616)
print v(xbgr.mr_n76272560)
print v(xbgr.mr_n76273504)
print v(xbgr.mr_n76274448)
print v(xbgr.mr_n76275392)
print v(xbgr.mr_n76276336)
print v(xbgr.mr_n76277280)
print v(xbgr.mr_n76278224)
print v(xbgr.mr_n76279168)
print v(xbgr.mr_n76280112)
print v(xbgr.mr_n76281056)
print v(xbgr.mr_n76282000)
print v(xbgr.mr_n76283520)
print v(xbgr.mr_n76287936)
print v(xbgr.mr_n76288880)
print v(xbgr.mr_n76289824)
print v(xbgr.mr_n76292336)
print v(xbgr.mr_n76296160)
print v(xbgr.mr_n76296352)
print v(xbgr.mr_n76297040)
print v(xbgr.mr_n76297152)
print v(xbgr.mr_n76297264)
print v(xbgr.mr_n76297376)
print v(xbgr.mr_n76297488)
print v(xbgr.mr_n76299232)
print v(xbgr.mr_n76299504)
print v(xbgr.mr_n76299696)
print v(xbgr.mr_n76300208)
print v(xbgr.mr_n76302144)
print v(xbgr.mr_n76303888)
print v(xbgr.mr_n76304160)
print v(xbgr.mr_n76304352)
print v(xbgr.mr_n76304864)
print v(xbgr.mr_n76306800)
print v(xbgr.mr_n76308544)
print v(xbgr.mr_n76308816)
print v(xbgr.mr_n76309008)
print v(xbgr.mr_n76309520)
print v(xbgr.mr_n76311536)
print v(xbgr.mr_n76311728)
print v(xbgr.mr_n76313536)
print v(xbgr.mr_n76313728)
print v(xbgr.mr_n76314240)
print v(xbgr.mr_n76316112)
print v(xbgr.mr_n76317856)
print v(xbgr.mr_n76318128)
print v(xbgr.mr_n76318320)
print v(xbgr.mr_n76318832)
print v(xbgr.mr_n76320768)
print v(xbgr.mr_n76322512)
print v(xbgr.mr_n76322784)
print v(xbgr.mr_n76322976)
print v(xbgr.mr_n76323488)
print v(xbgr.mr_n76325504)
print v(xbgr.mr_n76325696)
print v(xbgr.mr_n76327504)
print v(xbgr.mr_n76327696)
print v(xbgr.mr_n76328208)
print v(xbgr.mr_n76330080)
print v(xbgr.mr_n76331824)
print v(xbgr.mr_n76332096)
print v(xbgr.mr_n76332288)
print v(xbgr.mr_n76332800)
print v(xbgr.mr_n76334736)
print v(xbgr.mr_n76336480)
print v(xbgr.mr_n76336752)
print v(xbgr.mr_n76336944)
print v(xbgr.mr_n76337456)
print v(xbgr.mr_n76339392)
print v(xbgr.mr_n76341136)
print v(xbgr.mr_n76341408)
print v(xbgr.mr_n76341600)
print v(xbgr.mr_n76342112)
print v(xbgr.mr_n76344048)
print v(xbgr.mr_n76345792)
print v(xbgr.mr_n76346064)
print v(xbgr.mr_n76346256)
print v(xbgr.mr_n76346768)
print v(xbgr.mr_n76348704)
print v(xbgr.mr_n76348976)
print v(xbgr.mr_n76350448)
print v(xbgr.mr_n76350720)
print v(xbgr.mr_n76350912)
print v(xbgr.mr_n76351424)
print v(xbgr.mr_n76353360)
print v(xbgr.mr_n76355104)
print v(xbgr.mr_n76355376)
print v(xbgr.mr_n76355568)
print v(xbgr.mr_n76356080)
print v(xbgr.mr_n76357600)
print v(xbgr.mr_n76358016)
print v(xbgr.mr_n76358640)
print v(xbgr.mr_n76358832)
print v(xbgr.mr_n76359152)
print v(xbgr.mr_n76359344)
print v(xbgr.mr_n76360176)
print v(xbgr.mr_n76361904)
print v(xbgr.mr_n76362224)
print v(xbgr.mr_n76362688)
print v(xbgr.mr_n76362880)
print v(xbgr.mr_n76364272)
print v(xbgr.mr_n76364672)
print v(xbgr.mr_n76364864)
print v(xbgr.mr_n76365552)
print v(xbgr.mr_n76368400)
print v(xbgr.mr_n76369648)
print v(xbgr.mr_n76370032)
print v(xbgr.mr_n76370576)
print v(xbgr.mr_n76371264)
print v(xbgr.mr_n76372496)
print v(xbgr.mr_n76372672)
print v(xbgr.mr_n76373248)
print v(xbgr.mr_n76373440)
print v(xbgr.mr_n76373712)
print v(xbgr.mr_n76374016)
print v(xbgr.mr_n76376528)
print v(xbgr.mr_n76378704)
print v(xbgr.mr_n76379968)
print v(xbgr.mr_n76380576)
print v(xbgr.mr_n76381696)
print v(xbgr.mr_n76383232)
print v(xbgr.mr_n76383808)
print v(xbgr.mr_n76387568)
print v(xbgr.mr_n76388416)
print v(xbgr.mr_n76389872)
print v(xbgr.mr_n76391312)
print v(xbgr.mr_n76391456)
print v(xbgr.mr_n76392640)
print v(xbgr.mr_n76393440)
print v(xbgr.mr_n76393952)
print v(xbgr.mr_n76395360)
print v(xbgr.mr_n76402928)
print v(xbgr.mr_n76404032)
print v(xbgr.mr_n76405600)
print v(xbgr.mr_n76405824)
print v(xbgr.mr_n76407008)
print v(xbgr.mr_n76408208)
print v(xbgr.mr_n76409680)
print v(xbgr.mr_n76409792)
print v(xbgr.mr_n76410784)
print v(xbgr.mr_n76412816)
print v(xbgr.mr_n76414768)
print v(xbgr.mr_n76414960)
print v(xbgr.mr_n76418672)
print v(xbgr.mr_n76419296)
print v(xbgr.mr_n76420016)
print v(xbgr.mr_n76422000)
print v(xbgr.mr_n76422736)
print v(xbgr.mr_n76423984)
print v(xbgr.mr_n76425312)
print v(xbgr.mr_n76425520)
print v(xbgr.mr_n76428832)
print v(xbgr.mr_n76429264)
print v(xbgr.mr_n76429968)
print v(xbgr.mr_n76431952)
print v(xbgr.mr_n76436672)
print v(xbgr.mr_n76437216)
print v(xbgr.mr_n76438000)
print v(xbgr.mr_n76438672)
print v(xbgr.mr_n76439664)
print v(xbgr.mr_n76440800)
print v(xbgr.mr_n76441824)
print v(xbgr.mr_n76442160)
print v(xbgr.mr_n76442352)
print v(xbgr.mr_n76445232)
print v(xbgr.mr_n76445904)
print v(xbgr.mr_n76446144)
print v(xbgr.mr_n76446608)
print v(xbgr.mr_n76446800)
print v(xbgr.mr_n76447744)
print v(xbgr.mr_n76447936)
print v(xbgr.mr_n76448272)
print v(xbgr.mr_n76448848)
print v(xbgr.mr_n76449552)
print v(xbgr.mr_n76455520)
print v(xbgr.mr_n76456640)
print v(xbgr.mr_n76457616)
print v(xbgr.mr_n76458320)
print v(xbgr.mr_n76458432)
print v(xbgr.mr_n76459152)
print v(xbgr.mr_n76459584)
print v(xbgr.mr_n76460400)
print v(xbgr.mr_n76461104)
print v(xbgr.mr_n76461568)
print v(xbgr.mr_n76462032)
print v(xbgr.mr_n76462224)
print v(xbgr.mr_n76463024)
print v(xbgr.mr_n76463296)
print v(xbgr.mr_n76463408)
print v(xbgr.mr_n76463712)
print v(xbgr.mr_n76463904)
print v(xbgr.mr_n76464368)
print v(xbgr.mr_n76464832)
print v(xbgr.mr_n76465744)
print v(xbgr.mr_n76469584)
print v(xbgr.mr_n76470096)
print v(xbgr.mr_n76470208)
print v(xbgr.mr_n76470640)
print v(xbgr.mr_n76471104)
print v(xbgr.mr_n76473696)
print v(xbgr.mr_n76474096)
print v(xbgr.mr_n76474560)
print v(xbgr.mr_n76476352)
print v(xbgr.mr_n76478928)
print v(xbgr.mr_n76479760)
print v(xbgr.mr_n76481504)
print v(xbgr.mr_n76481616)
print v(xbgr.mr_n76482496)
print v(xbgr.mr_n76483184)
print v(xbgr.mr_n76483872)
print v(xbgr.mr_n76484560)
print v(xbgr.mr_n76485248)
print v(xbgr.mr_n76485936)
print v(xbgr.mr_n76486624)
print v(xbgr.mr_n76487312)
print v(xbgr.mr_n76488000)
print v(xbgr.mr_n76488688)
print v(xbgr.mr_n76489376)
print v(xbgr.mr_n76490064)
print v(xbgr.mr_n76490752)
print v(xbgr.mr_n76491440)
print v(xbgr.mr_n76492128)
print v(xbgr.mr_n76497056)
print v(xbgr.mr_n76497168)
print v(xbgr.mr_n76498000)
print v(xbgr.mr_n76498112)
print v(xbgr.mr_n76498944)
print v(xbgr.mr_n76499056)
print v(xbgr.mr_n76499888)
print v(xbgr.mr_n76500000)
print v(xbgr.mr_n76500832)
print v(xbgr.mr_n76500944)
print v(xbgr.mr_n76501776)
print v(xbgr.mr_n76501888)
print v(xbgr.mr_n76502720)
print v(xbgr.mr_n76502832)
print v(xbgr.mr_n76503664)
print v(xbgr.mr_n76503776)
print v(xbgr.mr_n76504608)
print v(xbgr.mr_n76504720)
print v(xbgr.mr_n76505552)
print v(xbgr.mr_n76505664)
print v(xbgr.mr_n76506496)
print v(xbgr.mr_n76506608)
print v(xbgr.mr_n76507504)
print v(xbgr.mr_n76507616)
print v(xbgr.mr_n76508768)
print v(xbgr.mr_n76508880)
print v(xbgr.mr_n76510032)
print v(xbgr.mr_n76510144)
print v(xbgr.mr_n76511296)
print v(xbgr.mr_n76511408)
print v(xbgr.mr_n76517424)
print v(xbgr.mr_n76519520)
print v(xbgr.mr_n76526080)
print v(xbgr.mr_n76530016)
print v(xbgr.mr_n76530208)
print v(xbgr.mr_n76530400)
print v(xbgr.mr_n76530592)
print v(xbgr.mr_n76532912)
print v(xbgr.mr_n76533184)
print v(xbgr.mr_n76533376)
print v(xbgr.mr_n76533888)
print v(xbgr.mr_n76534000)
print v(xbgr.mr_n76534112)
print v(xbgr.mr_n76534224)
print v(xbgr.mr_n76534416)
print v(xbgr.mr_n76534608)
print v(xbgr.mr_n76534800)
print v(xbgr.mr_n76538368)
print v(xbgr.mr_n76554384)
print v(xbgr.mr_n76557920)
print v(xbgr.mr_n76559536)
print v(xbgr.mr_n76561216)
print v(xbgr.mr_n76563472)
print v(xbgr.mr_n76565728)
print v(xbgr.mr_n76567984)
print v(xbgr.mr_n76570240)
print v(xbgr.mr_n76573936)
print v(xbgr.mr_n76575728)
print v(xbgr.mr_n76578864)
print v(xbgr.mr_n76591536)
print v(xbgr.mr_n76592112)
print v(xbgr.mr_n76592800)
print v(xbgr.mr_n76593376)
print v(xbgr.mr_n76594064)
print v(xbgr.mr_n76594768)
print v(xbgr.mr_n76595328)
print v(xbgr.mr_n76595760)
print v(xbgr.mr_n76596592)
print v(xbgr.mr_n76597168)
print v(xbgr.mr_n76597856)
print v(xbgr.mr_n76598288)
print v(xbgr.mr_n76599120)
print v(xbgr.mr_n76599696)
print v(xbgr.mr_n76600384)
print v(xbgr.mr_n76609456)
print v(xbgr.mr_n76609600)
print v(xbgr.mr_n76611312)
print v(xbgr.mr_n76624896)
print v(xbgr.mr_n76627056)
print v(xbgr.mr_n76627440)
print v(xbgr.mr_n76630112)
print v(xbgr.mr_n76630496)
print v(xbgr.mr_n76630688)
print v(xbgr.mr_n76631488)
print v(xbgr.mr_n76632368)
print v(xbgr.mr_n76633152)
print v(xbgr.mr_n76633472)
print v(xbgr.mr_n76634368)
print v(xbgr.mr_n76634480)
print v(xbgr.mr_n76634592)
print v(xbgr.mr_n76634704)
print v(xbgr.mr_n76634816)
print v(xbgr.mr_n76634928)
print v(xbgr.mr_n76635040)
print v(xbgr.mr_n76635312)
print v(xbgr.mr_n76635424)
print v(xbgr.mr_n76635920)
print v(xbgr.mr_n76636640)
print v(xbgr.mr_n76636832)
print v(xbgr.mr_n76637168)
print v(xbgr.mr_n76639104)
print v(xbgr.mr_n76639504)
print v(xbgr.mr_n76639696)
print v(xbgr.mr_n76639888)
print v(xbgr.mr_n76640560)
print v(xbgr.mr_n76640896)
print v(xbgr.mr_n76641232)
print v(xbgr.mr_n76641632)
print v(xbgr.mr_n76641824)
print v(xbgr.mr_n76642720)
print v(xbgr.mr_n76645184)
print v(xbgr.mr_n76645296)
print v(xbgr.mr_n76645808)
print v(xbgr.mr_n76645920)
print v(xbgr.mr_n76646432)
print v(xbgr.mr_n76646544)
print v(xbgr.mr_n76647056)
print v(xbgr.mr_n76647168)
print v(xbgr.mr_n76647680)
print v(xbgr.mr_n76647792)
print v(xbgr.mr_n76648304)
print v(xbgr.mr_n76648416)
print v(xbgr.mr_n76648928)
print v(xbgr.mr_n76649040)
print v(xbgr.mr_n76649552)
print v(xbgr.mr_n76649664)
print v(xbgr.mr_n76663152)
print v(xbgr.mr_n76663840)
print v(xbgr.mr_n76664528)
print v(xbgr.mr_n76665216)
print v(xbgr.mr_n76665904)
print v(xbgr.mr_n76666688)
print v(xbgr.mr_n76668624)
print v(xbgr.mr_n76669568)
print v(xbgr.mr_n76670512)
print v(xbgr.mr_n76671456)
print v(xbgr.mr_n76672400)
print v(xbgr.mr_n76673344)
print v(xbgr.mr_n76674288)
print v(xbgr.mr_n76675232)
print v(xbgr.mr_n76676176)
print v(xbgr.mr_n76677120)
print v(xbgr.mr_n76678064)
print v(xbgr.mr_n76678400)
print v(xbgr.mr_n76679008)
print v(xbgr.mr_n76686960)
print v(xbgr.mr_n76687728)
print v(xbgr.mr_n76689648)
print v(xbgr.mr_n76690032)
print v(xbgr.mr_n76690416)
print v(xbgr.mr_n76691184)
print v(xbgr.mr_n76691648)
print v(xbgr.mr_n76692032)
print v(xbgr.mr_n76692336)
print v(xbgr.mr_n76693872)
print v(xbgr.mr_n76694256)
print v(xbgr.mr_n76694720)
print v(xbgr.mr_n76695104)
print v(xbgr.mr_n76696176)
print v(xbgr.mr_n76696560)
print v(xbgr.mr_n76696944)
print v(xbgr.mr_n76699248)
print v(xbgr.mr_n76699440)
print v(xbgr.mr_n76699632)
print v(xbgr.mr_n76699824)
print v(xbgr.mr_n76701360)
print v(xbgr.mr_n76702240)
print v(xbgr.mr_n76704816)
print v(xbgr.mr_n76706608)
print v(xbgr.mr_n76707360)
print v(xbgr.mr_n76709968)
print v(xbgr.mr_n76710416)
print v(xbgr.mr_n76710672)
print v(xbgr.mr_n76710864)
print v(xbgr.mr_n76711136)
print v(xbgr.mr_n76712208)
print v(xbgr.mr_n76712800)
print v(xbgr.mr_n76712912)
print v(xbgr.mr_n76714080)
print v(xbgr.mr_n76719520)
print v(xbgr.mr_n76721088)
print v(xbgr.mr_n76723328)
print v(xbgr.mr_n76725568)
print v(xbgr.mr_n76725792)
print v(xbgr.mr_n76726336)
print v(xbgr.mr_n76727776)
print v(xbgr.mr_n76728064)
print v(xbgr.mr_n76731376)
print v(xbgr.mr_n76733280)
print v(xbgr.mr_n76733872)
print v(xbgr.mr_n76734016)
print v(xbgr.mr_n76734384)
print v(xbgr.mr_n76735568)
print v(xbgr.mr_n76736080)
print v(xbgr.mr_n76736192)
print v(xbgr.mr_n76736624)
print v(xbgr.mr_n76737136)
print v(xbgr.mr_n76737248)
print v(xbgr.mr_n76737680)
print v(xbgr.mr_n76738192)
print v(xbgr.mr_n76738304)
print v(xbgr.mr_n76738736)
print v(xbgr.mr_n76739808)
print v(xbgr.mr_n76741056)
print v(xbgr.mr_n76741920)
print v(xbgr.mr_n76745744)
print v(xbgr.mr_n76747280)
print v(xbgr.mr_n76747728)
print v(xbgr.mr_n76749744)
print v(xbgr.mr_n76751568)
print v(xbgr.mr_n76751760)
print v(xbgr.mr_n76752784)
print v(xbgr.mr_n76753520)
print v(xbgr.mr_n76758064)
print v(xbgr.mr_n76758256)
print v(xbgr.mr_n76759984)
print v(xbgr.mr_n76760544)
print v(xbgr.mr_n76763056)
print v(xbgr.mr_n76764080)
print v(xbgr.mr_n76764192)
print v(xbgr.mr_n76766128)
print v(xbgr.mr_n76767920)
print v(xbgr.mr_n76768144)
print v(xbgr.mr_n76769104)
print v(xbgr.mr_n76769840)
print v(xbgr.mr_n76772848)
print v(xbgr.mr_n76774016)
print v(xbgr.mr_n76778128)
print v(xbgr.mr_n76779904)
print v(xbgr.mr_n76780480)
print v(xbgr.mr_n76781392)
print v(xbgr.mr_n76782256)
print v(xbgr.mr_n76783600)
print v(xbgr.mr_n76785232)
print v(xbgr.mr_n76786288)
print v(xbgr.mr_n76786480)
print v(xbgr.mr_n76787424)
print v(xbgr.mr_n76788240)
print v(xbgr.mr_n76788576)
print v(xbgr.mr_n76789040)
print v(xbgr.mr_n76789504)
print v(xbgr.mr_n76790448)
print v(xbgr.mr_n76791504)
print v(xbgr.mr_n76791728)
print v(xbgr.mr_n76792192)
print v(xbgr.mr_n76792528)
print v(xbgr.mr_n76792992)
print v(xbgr.mr_n76793456)
print v(xbgr.mr_n76793920)
print v(xbgr.mr_n76794592)
print v(xbgr.mr_n76794784)
print v(xbgr.mr_n76795248)
print v(xbgr.mr_n76796192)
print v(xbgr.mr_n76796528)
print v(xbgr.mr_n76796992)
print v(xbgr.mr_n76797456)
print v(xbgr.mr_n76797920)
print v(xbgr.mr_n76798864)
print v(xbgr.mr_n76799200)
print v(xbgr.mr_n76800144)
print v(xbgr.mr_n76800640)
print v(xbgr.mr_n76805664)
print v(xbgr.mr_n76810032)
print v(xbgr.mr_n76810224)
print v(xbgr.mr_n76810560)
print v(xbgr.mr_n76810752)
print v(xbgr.mr_n76811168)
print v(xbgr.mr_n76811968)
print v(xbgr.mr_n76812208)
print v(xbgr.mr_n76814640)
print v(xbgr.mr_n76816176)
print v(xbgr.mr_n76817136)
print v(xbgr.mr_n76818368)
print v(xbgr.mr_n76820368)
print v(xbgr.mr_n76820480)
print v(xbgr.mr_n76820912)
print v(xbgr.mr_n76821424)
print v(xbgr.mr_n76821536)
print v(xbgr.mr_n76821968)
print v(xbgr.mr_n76822480)
print v(xbgr.mr_n76822592)
print v(xbgr.mr_n76823024)
print v(xbgr.mr_n76823536)
print v(xbgr.mr_n76823648)
print v(xbgr.mr_n76824080)
print v(xbgr.mr_n76824592)
print v(xbgr.mr_n76824704)
print v(xbgr.mr_n76825136)
print v(xbgr.mr_n76825648)
print v(xbgr.mr_n76825760)
print v(xbgr.mr_n76826192)
print v(xbgr.mr_n76826704)
print v(xbgr.mr_n76826816)
print v(xbgr.mr_n76827248)
print v(xbgr.mr_n76827760)
print v(xbgr.mr_n76827872)
print v(xbgr.mr_n76828304)
print v(xbgr.mr_n76828816)
print v(xbgr.mr_n76828928)
print v(xbgr.mr_n76829360)
print v(xbgr.mr_n76830320)
print v(xbgr.mr_n76830432)
print v(xbgr.mr_n76831312)
print v(xbgr.mr_n76832000)
print v(xbgr.mr_n76832688)
print v(xbgr.mr_n76833376)
print v(xbgr.mr_n76834064)
print v(xbgr.mr_n76834752)
print v(xbgr.mr_n76835440)
print v(xbgr.mr_n76836128)
print v(xbgr.mr_n76836816)
print v(xbgr.mr_n76837504)
print v(xbgr.mr_n76838192)
print v(xbgr.mr_n76838880)
print v(xbgr.mr_n76839568)
print v(xbgr.mr_n76840256)
print v(xbgr.mr_n76840944)
print v(xbgr.mr_n76841632)
print v(xbgr.mr_n76842320)
print v(xbgr.mr_n76843008)
print v(xbgr.mr_n76843696)
print v(xbgr.mr_n76844800)
print v(xbgr.mr_n76846064)
print v(xbgr.mr_n76847008)
print v(xbgr.mr_n76847952)
print v(xbgr.mr_n76848896)
print v(xbgr.mr_n76849840)
print v(xbgr.mr_n76850784)
print v(xbgr.mr_n76851728)
print v(xbgr.mr_n76852672)
print v(xbgr.mr_n76853616)
print v(xbgr.mr_n76854560)
print v(xbgr.mr_n76855504)
print v(xbgr.mr_n76856448)
print v(xbgr.mr_n76857392)
print v(xbgr.mr_n76858336)
print v(xbgr.mr_n76859280)
print v(xbgr.mr_n76860224)
print v(xbgr.mr_n76861168)
print v(xbgr.mr_n76862112)
print v(xbgr.mr_n76863056)
print v(xbgr.mr_n76864000)
print v(xbgr.mr_n76864944)
print v(xbgr.mr_n76865888)
print v(xbgr.mr_n76866832)
print v(xbgr.mr_n76867776)
print v(xbgr.mr_n76868720)
print v(xbgr.mr_n76869664)
print v(xbgr.mr_n76873952)
print v(xbgr.mr_n76874464)
print v(xbgr.mr_n76874720)
print v(xbgr.mr_n76874976)
print v(xbgr.mr_n76875232)
print v(xbgr.mr_n76875488)
print v(xbgr.mr_n76875744)
print v(xbgr.mr_n76876144)
print v(xbgr.mr_n76878544)
print v(xbgr.mr_n76878992)
print v(xbgr.mr_n76879184)
print v(xbgr.mr_n76879376)
print v(xbgr.mr_n76879568)
print v(xbgr.mr_n76879760)
print v(xbgr.mr_n76879952)
print v(xbgr.mr_n76880208)
print v(xbgr.mr_n76885216)
print v(xbgr.mr_n76889504)
print v(xbgr.mr_n76898480)
print v(xbgr.mr_n76905360)
print v(xbgr.mr_n76905616)
print v(xbgr.mr_n76906320)
print v(xbgr.mr_n76907152)
print v(xbgr.mr_n76907408)
print v(xbgr.mr_n76922304)
print v(xbgr.mr_n76923168)
print v(xbgr.mr_n76925888)
print v(xbgr.mr_n76926752)
print v(xbgr.mr_n76927648)
print v(xbgr.mr_n76927968)
print v(xbgr.mr_n76929280)
print v(xbgr.mr_n76929680)
print v(xbgr.mr_n76930048)
print v(xbgr.mr_n76930240)
print v(xbgr.mr_n76931024)
print v(xbgr.mr_n76931776)
print v(xbgr.mr_n76934384)
print v(xbgr.mr_n76935168)
print v(xbgr.mr_n76935568)
print v(xbgr.mr_n76936608)
print v(xbgr.mr_n76936800)
print v(xbgr.mr_n76938176)
print v(xbgr.mr_n77219248)
print v(xbgr.mr_n77220512)
print v(xbgr.mr_n77308368)
print v(xbgr.mr_n77308560)
print v(xbgr.mr_n77308752)
print v(xbgr.mr_n77308944)
print v(xbgr.mr_n77326464)
print v(xbgr.mr_n77353456)
print v(xbgr.mr_n77353792)
print v(xbgr.mr_n77354000)
print v(xbgr.mr_n77354592)
print v(xbgr.mr_n77354992)
print v(xbgr.mr_n77355104)
print v(xbgr.mr_n77370544)
print v(xbgr.mr_n77370816)
print v(xbgr.mr_n77371008)
print v(xbgr.mr_n77371632)
print v(xbgr.mr_n77372144)
print v(xbgr.mr_n77473840)
print v(xbgr.mr_n77475584)
print v(xbgr.mr_n77522000)
print v(xbgr.mr_n77542688)
print v(xbgr.mr_n77605280)
print v(xbgr.mr_n77605792)
print v(xbgr.mr_n77605904)
print v(xbgr.mr_n77606224)
print v(xbgr.mr_n77606512)
print v(xbgr.mr_n77611776)
print v(xbgr.mr_n77702912)
print v(xbgr.mr_n77717200)
print v(xbgr.mr_n77718080)
print v(xbgr.mr_n77721584)
print v(xbgr.mr_n77738176)
print v(xbgr.mr_n77738432)
print v(xbgr.mr_n77739520)
print v(xbgr.mr_n77739744)
print v(xbgr.mr_n77739888)
print v(xbgr.mr_n77764784)
print v(xbgr.mr_n77765056)
print v(xbgr.mr_n77765520)
print v(xbgr.mr_n77766160)
print v(xbgr.mr_n77799200)
print v(xbgr.mr_n77808384)
print v(xbgr.mr_n77809120)
print v(xbgr.mr_n77809312)
print v(xbgr.mr_n77809744)
print v(xbgr.mr_n77839808)
print v(xbgr.mr_n77851152)
print v(xbgr.mr_n77852176)
print v(xbgr.mr_n77879088)
print v(xbgr.mr_n77884576)
print v(xbgr.mr_n77885136)
print v(xbgr.mr_n77928848)
print v(xbgr.mr_n77932560)
print v(xbgr.mr_n77934304)
print v(xbgr.mr_n77944272)
print v(xbgr.mr_n77944416)
print v(xbgr.mr_n77971600)
print v(xbgr.mr_n77980512)
print v(xbgr.mr_n77987264)
print v(xbgr.mr_n77988032)
print v(xbgr.mr_n77993536)
print v(xbgr.mr_n77993856)
print v(xbgr.n1)
print v(xbgr.n_10)
print v(xbgr.n_11)
print v(xbgr.n_12)
print v(xbgr.n_13)
print v(xbgr.n_14)
print v(xbgr.n_15)
print v(xbgr.n_16)
print v(xbgr.n_17)
print v(xbgr.n_18)
print v(xbgr.n_19)
print v(xbgr.n_2)
print v(xbgr.n_21)
print v(xbgr.n_22)
print v(xbgr.n_23)
print v(xbgr.n_24)
print v(xbgr.n_25)
print v(xbgr.n_26)
print v(xbgr.n_27)
print v(xbgr.n_3)
print v(xbgr.n_30)
print v(xbgr.n_31)
print v(xbgr.n_33)
print v(xbgr.n_34)
print v(xbgr.n_36)
print v(xbgr.n_37)
print v(xbgr.n_4)
print v(xbgr.n_5)
print v(xbgr.n_6)
print v(xbgr.n_7)
print v(xbgr.n_8)
print v(xbgr.n_9)
print v(pbias)
print v(pcasc)
print v(r4)
print v(xbgr.r4n)
print v(xbgr.vb2)
print v(vbe)
print v(xbgr.vbe3)
print v(xbgr.vd1)
print v(xbgr.vd2)
print v(vdd)
print v(vref)
print v(vdd)-v(vdd)
echo METALLIC_ALL_NODE_VOLTAGES_END
quit
.endc
.end
