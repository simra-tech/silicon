* G1_BGR standalone capacitance-PEX qualification
.lib /foss/pdks/ihp-sg13g2/libs.tech/ngspice/models/cornerHBT.lib hbt_typ
.lib /foss/pdks/ihp-sg13g2/libs.tech/ngspice/models/cornerMOShv.lib mos_tt
.lib /foss/pdks/ihp-sg13g2/libs.tech/ngspice/models/cornerRES.lib res_typ
.include conditional_metal.spice
.option seed=44001 gmin=1e-15 abstol=1e-14 reltol=1e-5 vntol=1e-7
.global sub!
Vsub sub! 0 0
Vdd vdd 0 3.3
Vr4 r4 0 0
Xbgr vdd 0 r4 vref iptat pbias pcasc vbe dvbe g1_bgr
Vload iptat 0 1
Cload vref 0 1e-12
.control
set num_threads=1
set numdgt=15
set wr_singlescale
set wr_vecnames
op
echo RAW_CURRENT_LEDGER_BEGIN
print @n.xbgr.xr1.nr1[ibody]
print @n.xbgr.xr2.nr1[ibody]
print @n.xbgr.xr3.nr1[ibody]
print @n.xbgr.xr4.nr1[ibody]
print @n.xbgr.xr5.nr1[ibody]
print @n.xbgr.xr6.nr1[ibody]
print @n.xbgr.xr7.nr1[ibody]
print @n.xbgr.xr8.nr1[ibody]
print @n.xbgr.xr9.nr1[ibody]
print @n.xbgr.xr10.nr1[ibody]
print @n.xbgr.xr11.nr1[ibody]
print @n.xbgr.xr12.nr1[ibody]
print @n.xbgr.xr13.nr1[ibody]
print @n.xbgr.xr14.nr1[ibody]
print @n.xbgr.xr15.nr1[ibody]
print @n.xbgr.xr16.nr1[ibody]
print @n.xbgr.xr17.nr1[ibody]
print @n.xbgr.xr18.nr1[ibody]
print @n.xbgr.xr19.nr1[ibody]
print @n.xbgr.xr20.nr1[ibody]
print @n.xbgr.xr21.nr1[ibody]
print @n.xbgr.xr22.nr1[ibody]
print @n.xbgr.xr23.nr1[ibody]
print @n.xbgr.xr24.nr1[ibody]
print @n.xbgr.xr25.nr1[ibody]
print @n.xbgr.xr26.nr1[ibody]
print @n.xbgr.xm27.nsg13_hv_pmos[ide]
print @n.xbgr.xm27.nsg13_hv_pmos[ige]
print @n.xbgr.xm27.nsg13_hv_pmos[ise]
print @n.xbgr.xm27.nsg13_hv_pmos[ibe]
print @n.xbgr.xm27.nsg13_hv_pmos[ctype]
print @n.xbgr.xm28.nsg13_hv_pmos[ide]
print @n.xbgr.xm28.nsg13_hv_pmos[ige]
print @n.xbgr.xm28.nsg13_hv_pmos[ise]
print @n.xbgr.xm28.nsg13_hv_pmos[ibe]
print @n.xbgr.xm28.nsg13_hv_pmos[ctype]
print @n.xbgr.xm29.nsg13_hv_nmos[ide]
print @n.xbgr.xm29.nsg13_hv_nmos[ige]
print @n.xbgr.xm29.nsg13_hv_nmos[ise]
print @n.xbgr.xm29.nsg13_hv_nmos[ibe]
print @n.xbgr.xm29.nsg13_hv_nmos[ctype]
print @n.xbgr.xm30.nsg13_hv_nmos[ide]
print @n.xbgr.xm30.nsg13_hv_nmos[ige]
print @n.xbgr.xm30.nsg13_hv_nmos[ise]
print @n.xbgr.xm30.nsg13_hv_nmos[ibe]
print @n.xbgr.xm30.nsg13_hv_nmos[ctype]
print @n.xbgr.xm31.nsg13_hv_nmos[ide]
print @n.xbgr.xm31.nsg13_hv_nmos[ige]
print @n.xbgr.xm31.nsg13_hv_nmos[ise]
print @n.xbgr.xm31.nsg13_hv_nmos[ibe]
print @n.xbgr.xm31.nsg13_hv_nmos[ctype]
print @n.xbgr.xm32.nsg13_hv_nmos[ide]
print @n.xbgr.xm32.nsg13_hv_nmos[ige]
print @n.xbgr.xm32.nsg13_hv_nmos[ise]
print @n.xbgr.xm32.nsg13_hv_nmos[ibe]
print @n.xbgr.xm32.nsg13_hv_nmos[ctype]
print @n.xbgr.xm33.nsg13_hv_nmos[ide]
print @n.xbgr.xm33.nsg13_hv_nmos[ige]
print @n.xbgr.xm33.nsg13_hv_nmos[ise]
print @n.xbgr.xm33.nsg13_hv_nmos[ibe]
print @n.xbgr.xm33.nsg13_hv_nmos[ctype]
print @n.xbgr.xm34.nsg13_hv_nmos[ide]
print @n.xbgr.xm34.nsg13_hv_nmos[ige]
print @n.xbgr.xm34.nsg13_hv_nmos[ise]
print @n.xbgr.xm34.nsg13_hv_nmos[ibe]
print @n.xbgr.xm34.nsg13_hv_nmos[ctype]
print @n.xbgr.xm35.nsg13_hv_nmos[ide]
print @n.xbgr.xm35.nsg13_hv_nmos[ige]
print @n.xbgr.xm35.nsg13_hv_nmos[ise]
print @n.xbgr.xm35.nsg13_hv_nmos[ibe]
print @n.xbgr.xm35.nsg13_hv_nmos[ctype]
print @n.xbgr.xm36.nsg13_hv_nmos[ide]
print @n.xbgr.xm36.nsg13_hv_nmos[ige]
print @n.xbgr.xm36.nsg13_hv_nmos[ise]
print @n.xbgr.xm36.nsg13_hv_nmos[ibe]
print @n.xbgr.xm36.nsg13_hv_nmos[ctype]
print @n.xbgr.xm37.nsg13_hv_nmos[ide]
print @n.xbgr.xm37.nsg13_hv_nmos[ige]
print @n.xbgr.xm37.nsg13_hv_nmos[ise]
print @n.xbgr.xm37.nsg13_hv_nmos[ibe]
print @n.xbgr.xm37.nsg13_hv_nmos[ctype]
print @n.xbgr.xm38.nsg13_hv_pmos[ide]
print @n.xbgr.xm38.nsg13_hv_pmos[ige]
print @n.xbgr.xm38.nsg13_hv_pmos[ise]
print @n.xbgr.xm38.nsg13_hv_pmos[ibe]
print @n.xbgr.xm38.nsg13_hv_pmos[ctype]
print @n.xbgr.xm39.nsg13_hv_pmos[ide]
print @n.xbgr.xm39.nsg13_hv_pmos[ige]
print @n.xbgr.xm39.nsg13_hv_pmos[ise]
print @n.xbgr.xm39.nsg13_hv_pmos[ibe]
print @n.xbgr.xm39.nsg13_hv_pmos[ctype]
print @n.xbgr.xm40.nsg13_hv_pmos[ide]
print @n.xbgr.xm40.nsg13_hv_pmos[ige]
print @n.xbgr.xm40.nsg13_hv_pmos[ise]
print @n.xbgr.xm40.nsg13_hv_pmos[ibe]
print @n.xbgr.xm40.nsg13_hv_pmos[ctype]
print @n.xbgr.xm41.nsg13_hv_pmos[ide]
print @n.xbgr.xm41.nsg13_hv_pmos[ige]
print @n.xbgr.xm41.nsg13_hv_pmos[ise]
print @n.xbgr.xm41.nsg13_hv_pmos[ibe]
print @n.xbgr.xm41.nsg13_hv_pmos[ctype]
print @n.xbgr.xm42.nsg13_hv_pmos[ide]
print @n.xbgr.xm42.nsg13_hv_pmos[ige]
print @n.xbgr.xm42.nsg13_hv_pmos[ise]
print @n.xbgr.xm42.nsg13_hv_pmos[ibe]
print @n.xbgr.xm42.nsg13_hv_pmos[ctype]
print @n.xbgr.xm43.nsg13_hv_pmos[ide]
print @n.xbgr.xm43.nsg13_hv_pmos[ige]
print @n.xbgr.xm43.nsg13_hv_pmos[ise]
print @n.xbgr.xm43.nsg13_hv_pmos[ibe]
print @n.xbgr.xm43.nsg13_hv_pmos[ctype]
print @n.xbgr.xm44.nsg13_hv_pmos[ide]
print @n.xbgr.xm44.nsg13_hv_pmos[ige]
print @n.xbgr.xm44.nsg13_hv_pmos[ise]
print @n.xbgr.xm44.nsg13_hv_pmos[ibe]
print @n.xbgr.xm44.nsg13_hv_pmos[ctype]
print @n.xbgr.xm45.nsg13_hv_pmos[ide]
print @n.xbgr.xm45.nsg13_hv_pmos[ige]
print @n.xbgr.xm45.nsg13_hv_pmos[ise]
print @n.xbgr.xm45.nsg13_hv_pmos[ibe]
print @n.xbgr.xm45.nsg13_hv_pmos[ctype]
print @n.xbgr.xm46.nsg13_hv_pmos[ide]
print @n.xbgr.xm46.nsg13_hv_pmos[ige]
print @n.xbgr.xm46.nsg13_hv_pmos[ise]
print @n.xbgr.xm46.nsg13_hv_pmos[ibe]
print @n.xbgr.xm46.nsg13_hv_pmos[ctype]
print @n.xbgr.xm47.nsg13_hv_pmos[ide]
print @n.xbgr.xm47.nsg13_hv_pmos[ige]
print @n.xbgr.xm47.nsg13_hv_pmos[ise]
print @n.xbgr.xm47.nsg13_hv_pmos[ibe]
print @n.xbgr.xm47.nsg13_hv_pmos[ctype]
print @n.xbgr.xm48.nsg13_hv_pmos[ide]
print @n.xbgr.xm48.nsg13_hv_pmos[ige]
print @n.xbgr.xm48.nsg13_hv_pmos[ise]
print @n.xbgr.xm48.nsg13_hv_pmos[ibe]
print @n.xbgr.xm48.nsg13_hv_pmos[ctype]
print @n.xbgr.xm49.nsg13_hv_pmos[ide]
print @n.xbgr.xm49.nsg13_hv_pmos[ige]
print @n.xbgr.xm49.nsg13_hv_pmos[ise]
print @n.xbgr.xm49.nsg13_hv_pmos[ibe]
print @n.xbgr.xm49.nsg13_hv_pmos[ctype]
print @n.xbgr.xm50.nsg13_hv_pmos[ide]
print @n.xbgr.xm50.nsg13_hv_pmos[ige]
print @n.xbgr.xm50.nsg13_hv_pmos[ise]
print @n.xbgr.xm50.nsg13_hv_pmos[ibe]
print @n.xbgr.xm50.nsg13_hv_pmos[ctype]
print @n.xbgr.xm51.nsg13_hv_pmos[ide]
print @n.xbgr.xm51.nsg13_hv_pmos[ige]
print @n.xbgr.xm51.nsg13_hv_pmos[ise]
print @n.xbgr.xm51.nsg13_hv_pmos[ibe]
print @n.xbgr.xm51.nsg13_hv_pmos[ctype]
print @n.xbgr.xm52.nsg13_hv_pmos[ide]
print @n.xbgr.xm52.nsg13_hv_pmos[ige]
print @n.xbgr.xm52.nsg13_hv_pmos[ise]
print @n.xbgr.xm52.nsg13_hv_pmos[ibe]
print @n.xbgr.xm52.nsg13_hv_pmos[ctype]
print @n.xbgr.xm53.nsg13_hv_pmos[ide]
print @n.xbgr.xm53.nsg13_hv_pmos[ige]
print @n.xbgr.xm53.nsg13_hv_pmos[ise]
print @n.xbgr.xm53.nsg13_hv_pmos[ibe]
print @n.xbgr.xm53.nsg13_hv_pmos[ctype]
print @n.xbgr.xm54.nsg13_hv_pmos[ide]
print @n.xbgr.xm54.nsg13_hv_pmos[ige]
print @n.xbgr.xm54.nsg13_hv_pmos[ise]
print @n.xbgr.xm54.nsg13_hv_pmos[ibe]
print @n.xbgr.xm54.nsg13_hv_pmos[ctype]
print @q.xbgr.xq55.qnpn13g2[ic]
print @q.xbgr.xq55.qnpn13g2[ib]
print @q.xbgr.xq55.qnpn13g2[ie]
print @q.xbgr.xq55.qnpn13g2[is]
print @r.xbgr.xq55.rsub[i]
print @c.xbgr.xq55.csub[i]
print @q.xbgr.xq56.qnpn13g2[ic]
print @q.xbgr.xq56.qnpn13g2[ib]
print @q.xbgr.xq56.qnpn13g2[ie]
print @q.xbgr.xq56.qnpn13g2[is]
print @r.xbgr.xq56.rsub[i]
print @c.xbgr.xq56.csub[i]
print @q.xbgr.xq57.qnpn13g2[ic]
print @q.xbgr.xq57.qnpn13g2[ib]
print @q.xbgr.xq57.qnpn13g2[ie]
print @q.xbgr.xq57.qnpn13g2[is]
print @r.xbgr.xq57.rsub[i]
print @c.xbgr.xq57.csub[i]
print @q.xbgr.xq58.qnpn13g2[ic]
print @q.xbgr.xq58.qnpn13g2[ib]
print @q.xbgr.xq58.qnpn13g2[ie]
print @q.xbgr.xq58.qnpn13g2[is]
print @r.xbgr.xq58.rsub[i]
print @c.xbgr.xq58.csub[i]
print @q.xbgr.xq59.qnpn13g2[ic]
print @q.xbgr.xq59.qnpn13g2[ib]
print @q.xbgr.xq59.qnpn13g2[ie]
print @q.xbgr.xq59.qnpn13g2[is]
print @r.xbgr.xq59.rsub[i]
print @c.xbgr.xq59.csub[i]
print @q.xbgr.xq60.qnpn13g2[ic]
print @q.xbgr.xq60.qnpn13g2[ib]
print @q.xbgr.xq60.qnpn13g2[ie]
print @q.xbgr.xq60.qnpn13g2[is]
print @r.xbgr.xq60.rsub[i]
print @c.xbgr.xq60.csub[i]
print @q.xbgr.xq61.qnpn13g2[ic]
print @q.xbgr.xq61.qnpn13g2[ib]
print @q.xbgr.xq61.qnpn13g2[ie]
print @q.xbgr.xq61.qnpn13g2[is]
print @r.xbgr.xq61.rsub[i]
print @c.xbgr.xq61.csub[i]
print @q.xbgr.xq62.qnpn13g2[ic]
print @q.xbgr.xq62.qnpn13g2[ib]
print @q.xbgr.xq62.qnpn13g2[ie]
print @q.xbgr.xq62.qnpn13g2[is]
print @r.xbgr.xq62.rsub[i]
print @c.xbgr.xq62.csub[i]
print @q.xbgr.xq63.qnpn13g2[ic]
print @q.xbgr.xq63.qnpn13g2[ib]
print @q.xbgr.xq63.qnpn13g2[ie]
print @q.xbgr.xq63.qnpn13g2[is]
print @r.xbgr.xq63.rsub[i]
print @c.xbgr.xq63.csub[i]
print @q.xbgr.xq64.qnpn13g2[ic]
print @q.xbgr.xq64.qnpn13g2[ib]
print @q.xbgr.xq64.qnpn13g2[ie]
print @q.xbgr.xq64.qnpn13g2[is]
print @r.xbgr.xq64.rsub[i]
print @c.xbgr.xq64.csub[i]
print @q.xbgr.xq65.qnpn13g2[ic]
print @q.xbgr.xq65.qnpn13g2[ib]
print @q.xbgr.xq65.qnpn13g2[ie]
print @q.xbgr.xq65.qnpn13g2[is]
print @r.xbgr.xq65.rsub[i]
print @c.xbgr.xq65.csub[i]
print @q.xbgr.xq66.qnpn13g2[ic]
print @q.xbgr.xq66.qnpn13g2[ib]
print @q.xbgr.xq66.qnpn13g2[ie]
print @q.xbgr.xq66.qnpn13g2[is]
print @r.xbgr.xq66.rsub[i]
print @c.xbgr.xq66.csub[i]
print @q.xbgr.xq67.qnpn13g2[ic]
print @q.xbgr.xq67.qnpn13g2[ib]
print @q.xbgr.xq67.qnpn13g2[ie]
print @q.xbgr.xq67.qnpn13g2[is]
print @r.xbgr.xq67.rsub[i]
print @c.xbgr.xq67.csub[i]
print @q.xbgr.xq68.qnpn13g2[ic]
print @q.xbgr.xq68.qnpn13g2[ib]
print @q.xbgr.xq68.qnpn13g2[ie]
print @q.xbgr.xq68.qnpn13g2[is]
print @r.xbgr.xq68.rsub[i]
print @c.xbgr.xq68.csub[i]
print @q.xbgr.xq69.qnpn13g2[ic]
print @q.xbgr.xq69.qnpn13g2[ib]
print @q.xbgr.xq69.qnpn13g2[ie]
print @q.xbgr.xq69.qnpn13g2[is]
print @r.xbgr.xq69.rsub[i]
print @c.xbgr.xq69.csub[i]
print @q.xbgr.xq70.qnpn13g2[ic]
print @q.xbgr.xq70.qnpn13g2[ib]
print @q.xbgr.xq70.qnpn13g2[ie]
print @q.xbgr.xq70.qnpn13g2[is]
print @r.xbgr.xq70.rsub[i]
print @c.xbgr.xq70.csub[i]
print @q.xbgr.xq71.qnpn13g2[ic]
print @q.xbgr.xq71.qnpn13g2[ib]
print @q.xbgr.xq71.qnpn13g2[ie]
print @q.xbgr.xq71.qnpn13g2[is]
print @r.xbgr.xq71.rsub[i]
print @c.xbgr.xq71.csub[i]
print @q.xbgr.xq72.qnpn13g2[ic]
print @q.xbgr.xq72.qnpn13g2[ib]
print @q.xbgr.xq72.qnpn13g2[ie]
print @q.xbgr.xq72.qnpn13g2[is]
print @r.xbgr.xq72.rsub[i]
print @c.xbgr.xq72.csub[i]
print @q.xbgr.xq73.qnpn13g2[ic]
print @q.xbgr.xq73.qnpn13g2[ib]
print @q.xbgr.xq73.qnpn13g2[ie]
print @q.xbgr.xq73.qnpn13g2[is]
print @r.xbgr.xq73.rsub[i]
print @c.xbgr.xq73.csub[i]
print @q.xbgr.xq74.qnpn13g2[ic]
print @q.xbgr.xq74.qnpn13g2[ib]
print @q.xbgr.xq74.qnpn13g2[ie]
print @q.xbgr.xq74.qnpn13g2[is]
print @r.xbgr.xq74.rsub[i]
print @c.xbgr.xq74.csub[i]
print @q.xbgr.xq75.qnpn13g2[ic]
print @q.xbgr.xq75.qnpn13g2[ib]
print @q.xbgr.xq75.qnpn13g2[ie]
print @q.xbgr.xq75.qnpn13g2[is]
print @r.xbgr.xq75.rsub[i]
print @c.xbgr.xq75.csub[i]
print @q.xbgr.xq76.qnpn13g2[ic]
print @q.xbgr.xq76.qnpn13g2[ib]
print @q.xbgr.xq76.qnpn13g2[ie]
print @q.xbgr.xq76.qnpn13g2[is]
print @r.xbgr.xq76.rsub[i]
print @c.xbgr.xq76.csub[i]
print @n.xbgr.xr77.nr1[ibody]
print @n.xbgr.xr78.nr1[ibody]
print @n.xbgr.xr79.nr1[ibody]
print @n.xbgr.xr80.nr1[ibody]
print @n.xbgr.xr81.nr1[ibody]
print @n.xbgr.xr82.nr1[ibody]
print @n.xbgr.xr83.nr1[ibody]
print @n.xbgr.xr84.nr1[ibody]
print @n.xbgr.xr85.nr1[ibody]
print @n.xbgr.xr86.nr1[ibody]
print @n.xbgr.xr16_u2.nr1[ibody]
print @n.xbgr.xr16_u3.nr1[ibody]
print @n.xbgr.xr16_u4.nr1[ibody]
print @n.xbgr.xr16_u5.nr1[ibody]
print @n.xbgr.xr16_u6.nr1[ibody]
print @n.xbgr.xr16_u7.nr1[ibody]
print @n.xbgr.xr16_u8.nr1[ibody]
print @n.xbgr.xr16_u9.nr1[ibody]
print @n.xbgr.xr16_u10.nr1[ibody]
print @n.xbgr.xr16_u11.nr1[ibody]
print @n.xbgr.xr16_u12.nr1[ibody]
print @n.xbgr.xr16_u13.nr1[ibody]
print @n.xbgr.xr16_u14.nr1[ibody]
print @n.xbgr.xr16_u15.nr1[ibody]
print @n.xbgr.xr16_u16.nr1[ibody]
print @n.xbgr.xr16_u17.nr1[ibody]
print @n.xbgr.xr16_u18.nr1[ibody]
print @n.xbgr.xr16_u19.nr1[ibody]
print @n.xbgr.xr16_u20.nr1[ibody]
print @n.xbgr.xr16_u21.nr1[ibody]
print @n.xbgr.xr16_u22.nr1[ibody]
print @n.xbgr.xr16_u23.nr1[ibody]
print @n.xbgr.xr16_u24.nr1[ibody]
print @n.xbgr.xr17_u2.nr1[ibody]
print @n.xbgr.xr17_u3.nr1[ibody]
print @n.xbgr.xr17_u4.nr1[ibody]
print @n.xbgr.xr18_u2.nr1[ibody]
print @n.xbgr.xr18_u3.nr1[ibody]
print @n.xbgr.xr18_u4.nr1[ibody]
print @n.xbgr.xr19_u2.nr1[ibody]
print @n.xbgr.xr19_u3.nr1[ibody]
print @n.xbgr.xr19_u4.nr1[ibody]
print @n.xbgr.xr20_u2.nr1[ibody]
print @n.xbgr.xr20_u3.nr1[ibody]
print @n.xbgr.xr20_u4.nr1[ibody]
print @n.xbgr.xr21_u2.nr1[ibody]
print @n.xbgr.xr21_u3.nr1[ibody]
print @n.xbgr.xr21_u4.nr1[ibody]
print @n.xbgr.xr22_u2.nr1[ibody]
print @n.xbgr.xr22_u3.nr1[ibody]
print @n.xbgr.xr22_u4.nr1[ibody]
print @n.xbgr.xr23_u2.nr1[ibody]
print @n.xbgr.xr23_u3.nr1[ibody]
print @n.xbgr.xr23_u4.nr1[ibody]
print @n.xbgr.xr23_u5.nr1[ibody]
print @n.xbgr.xr23_u6.nr1[ibody]
print @n.xbgr.xr23_u7.nr1[ibody]
print @n.xbgr.xr23_u8.nr1[ibody]
print @n.xbgr.xr23_u9.nr1[ibody]
print @n.xbgr.xr23_u10.nr1[ibody]
print @n.xbgr.xr23_u11.nr1[ibody]
print @n.xbgr.xr23_u12.nr1[ibody]
print @n.xbgr.xr23_u13.nr1[ibody]
print @n.xbgr.xr23_u14.nr1[ibody]
print @n.xbgr.xr23_u15.nr1[ibody]
print @n.xbgr.xr23_u16.nr1[ibody]
print @n.xbgr.xr23_u17.nr1[ibody]
print @n.xbgr.xr23_u18.nr1[ibody]
print @n.xbgr.xr23_u19.nr1[ibody]
print @n.xbgr.xr23_u20.nr1[ibody]
print @n.xbgr.xr23_u21.nr1[ibody]
print @n.xbgr.xr23_u22.nr1[ibody]
print @n.xbgr.xr23_u23.nr1[ibody]
print @n.xbgr.xr23_u24.nr1[ibody]
print @n.xbgr.xr24_u2.nr1[ibody]
print @n.xbgr.xr24_u3.nr1[ibody]
print @n.xbgr.xr24_u4.nr1[ibody]
print @n.xbgr.xr24_u5.nr1[ibody]
print @n.xbgr.xr24_u6.nr1[ibody]
print @n.xbgr.xr24_u7.nr1[ibody]
print @n.xbgr.xr24_u8.nr1[ibody]
print @n.xbgr.xr24_u9.nr1[ibody]
print @n.xbgr.xr24_u10.nr1[ibody]
print @n.xbgr.xr24_u11.nr1[ibody]
print @n.xbgr.xr24_u12.nr1[ibody]
print @n.xbgr.xr24_u13.nr1[ibody]
print @n.xbgr.xr24_u14.nr1[ibody]
print @n.xbgr.xr24_u15.nr1[ibody]
print @n.xbgr.xr24_u16.nr1[ibody]
print @n.xbgr.xr24_u17.nr1[ibody]
print @n.xbgr.xr24_u18.nr1[ibody]
print @n.xbgr.xr24_u19.nr1[ibody]
print @n.xbgr.xr24_u20.nr1[ibody]
print @n.xbgr.xr24_u21.nr1[ibody]
print @n.xbgr.xr24_u22.nr1[ibody]
print @n.xbgr.xr24_u23.nr1[ibody]
print @n.xbgr.xr24_u24.nr1[ibody]
print @n.xbgr.xr25_u2.nr1[ibody]
print @n.xbgr.xr25_u3.nr1[ibody]
print @n.xbgr.xr25_u4.nr1[ibody]
print @n.xbgr.xr25_u5.nr1[ibody]
print @n.xbgr.xr25_u6.nr1[ibody]
print @n.xbgr.xr25_u7.nr1[ibody]
print @n.xbgr.xr25_u8.nr1[ibody]
print @n.xbgr.xr25_u9.nr1[ibody]
print @n.xbgr.xr25_u10.nr1[ibody]
print @n.xbgr.xr25_u11.nr1[ibody]
print @n.xbgr.xr25_u12.nr1[ibody]
print @n.xbgr.xr25_u13.nr1[ibody]
print @n.xbgr.xr25_u14.nr1[ibody]
print @n.xbgr.xr25_u15.nr1[ibody]
print @n.xbgr.xr25_u16.nr1[ibody]
print @n.xbgr.xr25_u17.nr1[ibody]
print @n.xbgr.xr25_u18.nr1[ibody]
print @n.xbgr.xr25_u19.nr1[ibody]
print @n.xbgr.xr25_u20.nr1[ibody]
print @n.xbgr.xr25_u21.nr1[ibody]
print @n.xbgr.xr25_u22.nr1[ibody]
print @n.xbgr.xr25_u23.nr1[ibody]
print @n.xbgr.xr25_u24.nr1[ibody]
print @n.xbgr.xr26_u2.nr1[ibody]
print @n.xbgr.xr26_u3.nr1[ibody]
print @n.xbgr.xr26_u4.nr1[ibody]
print @n.xbgr.xr26_u5.nr1[ibody]
print @n.xbgr.xr26_u6.nr1[ibody]
print @n.xbgr.xr26_u7.nr1[ibody]
print @n.xbgr.xr26_u8.nr1[ibody]
print @n.xbgr.xr26_u9.nr1[ibody]
print @n.xbgr.xr26_u10.nr1[ibody]
print @n.xbgr.xr26_u11.nr1[ibody]
print @n.xbgr.xr26_u12.nr1[ibody]
print @n.xbgr.xr26_u13.nr1[ibody]
print @n.xbgr.xr26_u14.nr1[ibody]
print @n.xbgr.xr26_u15.nr1[ibody]
print @n.xbgr.xr26_u16.nr1[ibody]
print @n.xbgr.xr26_u17.nr1[ibody]
print @n.xbgr.xr26_u18.nr1[ibody]
print @n.xbgr.xr26_u19.nr1[ibody]
print @n.xbgr.xr26_u20.nr1[ibody]
print @n.xbgr.xr26_u21.nr1[ibody]
print @n.xbgr.xr26_u22.nr1[ibody]
print @n.xbgr.xr26_u23.nr1[ibody]
print @n.xbgr.xr26_u24.nr1[ibody]
print @n.xbgr.xm34_u2.nsg13_hv_nmos[ide]
print @n.xbgr.xm34_u2.nsg13_hv_nmos[ige]
print @n.xbgr.xm34_u2.nsg13_hv_nmos[ise]
print @n.xbgr.xm34_u2.nsg13_hv_nmos[ibe]
print @n.xbgr.xm34_u2.nsg13_hv_nmos[ctype]
print @n.xbgr.xm34_u3.nsg13_hv_nmos[ide]
print @n.xbgr.xm34_u3.nsg13_hv_nmos[ige]
print @n.xbgr.xm34_u3.nsg13_hv_nmos[ise]
print @n.xbgr.xm34_u3.nsg13_hv_nmos[ibe]
print @n.xbgr.xm34_u3.nsg13_hv_nmos[ctype]
print @n.xbgr.xm34_u4.nsg13_hv_nmos[ide]
print @n.xbgr.xm34_u4.nsg13_hv_nmos[ige]
print @n.xbgr.xm34_u4.nsg13_hv_nmos[ise]
print @n.xbgr.xm34_u4.nsg13_hv_nmos[ibe]
print @n.xbgr.xm34_u4.nsg13_hv_nmos[ctype]
print @n.xbgr.xm34_u5.nsg13_hv_nmos[ide]
print @n.xbgr.xm34_u5.nsg13_hv_nmos[ige]
print @n.xbgr.xm34_u5.nsg13_hv_nmos[ise]
print @n.xbgr.xm34_u5.nsg13_hv_nmos[ibe]
print @n.xbgr.xm34_u5.nsg13_hv_nmos[ctype]
print @n.xbgr.xm34_u6.nsg13_hv_nmos[ide]
print @n.xbgr.xm34_u6.nsg13_hv_nmos[ige]
print @n.xbgr.xm34_u6.nsg13_hv_nmos[ise]
print @n.xbgr.xm34_u6.nsg13_hv_nmos[ibe]
print @n.xbgr.xm34_u6.nsg13_hv_nmos[ctype]
print @n.xbgr.xm34_u7.nsg13_hv_nmos[ide]
print @n.xbgr.xm34_u7.nsg13_hv_nmos[ige]
print @n.xbgr.xm34_u7.nsg13_hv_nmos[ise]
print @n.xbgr.xm34_u7.nsg13_hv_nmos[ibe]
print @n.xbgr.xm34_u7.nsg13_hv_nmos[ctype]
print @n.xbgr.xm34_u8.nsg13_hv_nmos[ide]
print @n.xbgr.xm34_u8.nsg13_hv_nmos[ige]
print @n.xbgr.xm34_u8.nsg13_hv_nmos[ise]
print @n.xbgr.xm34_u8.nsg13_hv_nmos[ibe]
print @n.xbgr.xm34_u8.nsg13_hv_nmos[ctype]
print @n.xbgr.xm34_u9.nsg13_hv_nmos[ide]
print @n.xbgr.xm34_u9.nsg13_hv_nmos[ige]
print @n.xbgr.xm34_u9.nsg13_hv_nmos[ise]
print @n.xbgr.xm34_u9.nsg13_hv_nmos[ibe]
print @n.xbgr.xm34_u9.nsg13_hv_nmos[ctype]
print @n.xbgr.xm34_u10.nsg13_hv_nmos[ide]
print @n.xbgr.xm34_u10.nsg13_hv_nmos[ige]
print @n.xbgr.xm34_u10.nsg13_hv_nmos[ise]
print @n.xbgr.xm34_u10.nsg13_hv_nmos[ibe]
print @n.xbgr.xm34_u10.nsg13_hv_nmos[ctype]
print @n.xbgr.xm34_u11.nsg13_hv_nmos[ide]
print @n.xbgr.xm34_u11.nsg13_hv_nmos[ige]
print @n.xbgr.xm34_u11.nsg13_hv_nmos[ise]
print @n.xbgr.xm34_u11.nsg13_hv_nmos[ibe]
print @n.xbgr.xm34_u11.nsg13_hv_nmos[ctype]
print @n.xbgr.xm34_u12.nsg13_hv_nmos[ide]
print @n.xbgr.xm34_u12.nsg13_hv_nmos[ige]
print @n.xbgr.xm34_u12.nsg13_hv_nmos[ise]
print @n.xbgr.xm34_u12.nsg13_hv_nmos[ibe]
print @n.xbgr.xm34_u12.nsg13_hv_nmos[ctype]
print @n.xbgr.xm34_u13.nsg13_hv_nmos[ide]
print @n.xbgr.xm34_u13.nsg13_hv_nmos[ige]
print @n.xbgr.xm34_u13.nsg13_hv_nmos[ise]
print @n.xbgr.xm34_u13.nsg13_hv_nmos[ibe]
print @n.xbgr.xm34_u13.nsg13_hv_nmos[ctype]
print @n.xbgr.xm34_u14.nsg13_hv_nmos[ide]
print @n.xbgr.xm34_u14.nsg13_hv_nmos[ige]
print @n.xbgr.xm34_u14.nsg13_hv_nmos[ise]
print @n.xbgr.xm34_u14.nsg13_hv_nmos[ibe]
print @n.xbgr.xm34_u14.nsg13_hv_nmos[ctype]
print @n.xbgr.xm34_u15.nsg13_hv_nmos[ide]
print @n.xbgr.xm34_u15.nsg13_hv_nmos[ige]
print @n.xbgr.xm34_u15.nsg13_hv_nmos[ise]
print @n.xbgr.xm34_u15.nsg13_hv_nmos[ibe]
print @n.xbgr.xm34_u15.nsg13_hv_nmos[ctype]
print @n.xbgr.xm34_u16.nsg13_hv_nmos[ide]
print @n.xbgr.xm34_u16.nsg13_hv_nmos[ige]
print @n.xbgr.xm34_u16.nsg13_hv_nmos[ise]
print @n.xbgr.xm34_u16.nsg13_hv_nmos[ibe]
print @n.xbgr.xm34_u16.nsg13_hv_nmos[ctype]
print @n.xbgr.xm34_u17.nsg13_hv_nmos[ide]
print @n.xbgr.xm34_u17.nsg13_hv_nmos[ige]
print @n.xbgr.xm34_u17.nsg13_hv_nmos[ise]
print @n.xbgr.xm34_u17.nsg13_hv_nmos[ibe]
print @n.xbgr.xm34_u17.nsg13_hv_nmos[ctype]
print @n.xbgr.xm34_u18.nsg13_hv_nmos[ide]
print @n.xbgr.xm34_u18.nsg13_hv_nmos[ige]
print @n.xbgr.xm34_u18.nsg13_hv_nmos[ise]
print @n.xbgr.xm34_u18.nsg13_hv_nmos[ibe]
print @n.xbgr.xm34_u18.nsg13_hv_nmos[ctype]
print @n.xbgr.xm34_u19.nsg13_hv_nmos[ide]
print @n.xbgr.xm34_u19.nsg13_hv_nmos[ige]
print @n.xbgr.xm34_u19.nsg13_hv_nmos[ise]
print @n.xbgr.xm34_u19.nsg13_hv_nmos[ibe]
print @n.xbgr.xm34_u19.nsg13_hv_nmos[ctype]
print @n.xbgr.xm34_u20.nsg13_hv_nmos[ide]
print @n.xbgr.xm34_u20.nsg13_hv_nmos[ige]
print @n.xbgr.xm34_u20.nsg13_hv_nmos[ise]
print @n.xbgr.xm34_u20.nsg13_hv_nmos[ibe]
print @n.xbgr.xm34_u20.nsg13_hv_nmos[ctype]
print @n.xbgr.xm34_u21.nsg13_hv_nmos[ide]
print @n.xbgr.xm34_u21.nsg13_hv_nmos[ige]
print @n.xbgr.xm34_u21.nsg13_hv_nmos[ise]
print @n.xbgr.xm34_u21.nsg13_hv_nmos[ibe]
print @n.xbgr.xm34_u21.nsg13_hv_nmos[ctype]
print @n.xbgr.xm34_u22.nsg13_hv_nmos[ide]
print @n.xbgr.xm34_u22.nsg13_hv_nmos[ige]
print @n.xbgr.xm34_u22.nsg13_hv_nmos[ise]
print @n.xbgr.xm34_u22.nsg13_hv_nmos[ibe]
print @n.xbgr.xm34_u22.nsg13_hv_nmos[ctype]
print @n.xbgr.xm34_u23.nsg13_hv_nmos[ide]
print @n.xbgr.xm34_u23.nsg13_hv_nmos[ige]
print @n.xbgr.xm34_u23.nsg13_hv_nmos[ise]
print @n.xbgr.xm34_u23.nsg13_hv_nmos[ibe]
print @n.xbgr.xm34_u23.nsg13_hv_nmos[ctype]
print @n.xbgr.xm34_u24.nsg13_hv_nmos[ide]
print @n.xbgr.xm34_u24.nsg13_hv_nmos[ige]
print @n.xbgr.xm34_u24.nsg13_hv_nmos[ise]
print @n.xbgr.xm34_u24.nsg13_hv_nmos[ibe]
print @n.xbgr.xm34_u24.nsg13_hv_nmos[ctype]
print @n.xbgr.xm35_u2.nsg13_hv_nmos[ide]
print @n.xbgr.xm35_u2.nsg13_hv_nmos[ige]
print @n.xbgr.xm35_u2.nsg13_hv_nmos[ise]
print @n.xbgr.xm35_u2.nsg13_hv_nmos[ibe]
print @n.xbgr.xm35_u2.nsg13_hv_nmos[ctype]
print @n.xbgr.xm35_u3.nsg13_hv_nmos[ide]
print @n.xbgr.xm35_u3.nsg13_hv_nmos[ige]
print @n.xbgr.xm35_u3.nsg13_hv_nmos[ise]
print @n.xbgr.xm35_u3.nsg13_hv_nmos[ibe]
print @n.xbgr.xm35_u3.nsg13_hv_nmos[ctype]
print @n.xbgr.xm35_u4.nsg13_hv_nmos[ide]
print @n.xbgr.xm35_u4.nsg13_hv_nmos[ige]
print @n.xbgr.xm35_u4.nsg13_hv_nmos[ise]
print @n.xbgr.xm35_u4.nsg13_hv_nmos[ibe]
print @n.xbgr.xm35_u4.nsg13_hv_nmos[ctype]
print @n.xbgr.xm35_u5.nsg13_hv_nmos[ide]
print @n.xbgr.xm35_u5.nsg13_hv_nmos[ige]
print @n.xbgr.xm35_u5.nsg13_hv_nmos[ise]
print @n.xbgr.xm35_u5.nsg13_hv_nmos[ibe]
print @n.xbgr.xm35_u5.nsg13_hv_nmos[ctype]
print @n.xbgr.xm35_u6.nsg13_hv_nmos[ide]
print @n.xbgr.xm35_u6.nsg13_hv_nmos[ige]
print @n.xbgr.xm35_u6.nsg13_hv_nmos[ise]
print @n.xbgr.xm35_u6.nsg13_hv_nmos[ibe]
print @n.xbgr.xm35_u6.nsg13_hv_nmos[ctype]
print @n.xbgr.xm35_u7.nsg13_hv_nmos[ide]
print @n.xbgr.xm35_u7.nsg13_hv_nmos[ige]
print @n.xbgr.xm35_u7.nsg13_hv_nmos[ise]
print @n.xbgr.xm35_u7.nsg13_hv_nmos[ibe]
print @n.xbgr.xm35_u7.nsg13_hv_nmos[ctype]
print @n.xbgr.xm35_u8.nsg13_hv_nmos[ide]
print @n.xbgr.xm35_u8.nsg13_hv_nmos[ige]
print @n.xbgr.xm35_u8.nsg13_hv_nmos[ise]
print @n.xbgr.xm35_u8.nsg13_hv_nmos[ibe]
print @n.xbgr.xm35_u8.nsg13_hv_nmos[ctype]
print @n.xbgr.xm35_u9.nsg13_hv_nmos[ide]
print @n.xbgr.xm35_u9.nsg13_hv_nmos[ige]
print @n.xbgr.xm35_u9.nsg13_hv_nmos[ise]
print @n.xbgr.xm35_u9.nsg13_hv_nmos[ibe]
print @n.xbgr.xm35_u9.nsg13_hv_nmos[ctype]
print @n.xbgr.xm35_u10.nsg13_hv_nmos[ide]
print @n.xbgr.xm35_u10.nsg13_hv_nmos[ige]
print @n.xbgr.xm35_u10.nsg13_hv_nmos[ise]
print @n.xbgr.xm35_u10.nsg13_hv_nmos[ibe]
print @n.xbgr.xm35_u10.nsg13_hv_nmos[ctype]
print @n.xbgr.xm35_u11.nsg13_hv_nmos[ide]
print @n.xbgr.xm35_u11.nsg13_hv_nmos[ige]
print @n.xbgr.xm35_u11.nsg13_hv_nmos[ise]
print @n.xbgr.xm35_u11.nsg13_hv_nmos[ibe]
print @n.xbgr.xm35_u11.nsg13_hv_nmos[ctype]
print @n.xbgr.xm35_u12.nsg13_hv_nmos[ide]
print @n.xbgr.xm35_u12.nsg13_hv_nmos[ige]
print @n.xbgr.xm35_u12.nsg13_hv_nmos[ise]
print @n.xbgr.xm35_u12.nsg13_hv_nmos[ibe]
print @n.xbgr.xm35_u12.nsg13_hv_nmos[ctype]
print @n.xbgr.xm35_u13.nsg13_hv_nmos[ide]
print @n.xbgr.xm35_u13.nsg13_hv_nmos[ige]
print @n.xbgr.xm35_u13.nsg13_hv_nmos[ise]
print @n.xbgr.xm35_u13.nsg13_hv_nmos[ibe]
print @n.xbgr.xm35_u13.nsg13_hv_nmos[ctype]
print @n.xbgr.xm35_u14.nsg13_hv_nmos[ide]
print @n.xbgr.xm35_u14.nsg13_hv_nmos[ige]
print @n.xbgr.xm35_u14.nsg13_hv_nmos[ise]
print @n.xbgr.xm35_u14.nsg13_hv_nmos[ibe]
print @n.xbgr.xm35_u14.nsg13_hv_nmos[ctype]
print @n.xbgr.xm35_u15.nsg13_hv_nmos[ide]
print @n.xbgr.xm35_u15.nsg13_hv_nmos[ige]
print @n.xbgr.xm35_u15.nsg13_hv_nmos[ise]
print @n.xbgr.xm35_u15.nsg13_hv_nmos[ibe]
print @n.xbgr.xm35_u15.nsg13_hv_nmos[ctype]
print @n.xbgr.xm35_u16.nsg13_hv_nmos[ide]
print @n.xbgr.xm35_u16.nsg13_hv_nmos[ige]
print @n.xbgr.xm35_u16.nsg13_hv_nmos[ise]
print @n.xbgr.xm35_u16.nsg13_hv_nmos[ibe]
print @n.xbgr.xm35_u16.nsg13_hv_nmos[ctype]
print @n.xbgr.xm35_u17.nsg13_hv_nmos[ide]
print @n.xbgr.xm35_u17.nsg13_hv_nmos[ige]
print @n.xbgr.xm35_u17.nsg13_hv_nmos[ise]
print @n.xbgr.xm35_u17.nsg13_hv_nmos[ibe]
print @n.xbgr.xm35_u17.nsg13_hv_nmos[ctype]
print @n.xbgr.xm35_u18.nsg13_hv_nmos[ide]
print @n.xbgr.xm35_u18.nsg13_hv_nmos[ige]
print @n.xbgr.xm35_u18.nsg13_hv_nmos[ise]
print @n.xbgr.xm35_u18.nsg13_hv_nmos[ibe]
print @n.xbgr.xm35_u18.nsg13_hv_nmos[ctype]
print @n.xbgr.xm35_u19.nsg13_hv_nmos[ide]
print @n.xbgr.xm35_u19.nsg13_hv_nmos[ige]
print @n.xbgr.xm35_u19.nsg13_hv_nmos[ise]
print @n.xbgr.xm35_u19.nsg13_hv_nmos[ibe]
print @n.xbgr.xm35_u19.nsg13_hv_nmos[ctype]
print @n.xbgr.xm35_u20.nsg13_hv_nmos[ide]
print @n.xbgr.xm35_u20.nsg13_hv_nmos[ige]
print @n.xbgr.xm35_u20.nsg13_hv_nmos[ise]
print @n.xbgr.xm35_u20.nsg13_hv_nmos[ibe]
print @n.xbgr.xm35_u20.nsg13_hv_nmos[ctype]
print @n.xbgr.xm35_u21.nsg13_hv_nmos[ide]
print @n.xbgr.xm35_u21.nsg13_hv_nmos[ige]
print @n.xbgr.xm35_u21.nsg13_hv_nmos[ise]
print @n.xbgr.xm35_u21.nsg13_hv_nmos[ibe]
print @n.xbgr.xm35_u21.nsg13_hv_nmos[ctype]
print @n.xbgr.xm35_u22.nsg13_hv_nmos[ide]
print @n.xbgr.xm35_u22.nsg13_hv_nmos[ige]
print @n.xbgr.xm35_u22.nsg13_hv_nmos[ise]
print @n.xbgr.xm35_u22.nsg13_hv_nmos[ibe]
print @n.xbgr.xm35_u22.nsg13_hv_nmos[ctype]
print @n.xbgr.xm35_u23.nsg13_hv_nmos[ide]
print @n.xbgr.xm35_u23.nsg13_hv_nmos[ige]
print @n.xbgr.xm35_u23.nsg13_hv_nmos[ise]
print @n.xbgr.xm35_u23.nsg13_hv_nmos[ibe]
print @n.xbgr.xm35_u23.nsg13_hv_nmos[ctype]
print @n.xbgr.xm35_u24.nsg13_hv_nmos[ide]
print @n.xbgr.xm35_u24.nsg13_hv_nmos[ige]
print @n.xbgr.xm35_u24.nsg13_hv_nmos[ise]
print @n.xbgr.xm35_u24.nsg13_hv_nmos[ibe]
print @n.xbgr.xm35_u24.nsg13_hv_nmos[ctype]
print @n.xbgr.xm36_u2.nsg13_hv_nmos[ide]
print @n.xbgr.xm36_u2.nsg13_hv_nmos[ige]
print @n.xbgr.xm36_u2.nsg13_hv_nmos[ise]
print @n.xbgr.xm36_u2.nsg13_hv_nmos[ibe]
print @n.xbgr.xm36_u2.nsg13_hv_nmos[ctype]
print @n.xbgr.xm36_u3.nsg13_hv_nmos[ide]
print @n.xbgr.xm36_u3.nsg13_hv_nmos[ige]
print @n.xbgr.xm36_u3.nsg13_hv_nmos[ise]
print @n.xbgr.xm36_u3.nsg13_hv_nmos[ibe]
print @n.xbgr.xm36_u3.nsg13_hv_nmos[ctype]
print @n.xbgr.xm36_u4.nsg13_hv_nmos[ide]
print @n.xbgr.xm36_u4.nsg13_hv_nmos[ige]
print @n.xbgr.xm36_u4.nsg13_hv_nmos[ise]
print @n.xbgr.xm36_u4.nsg13_hv_nmos[ibe]
print @n.xbgr.xm36_u4.nsg13_hv_nmos[ctype]
print @n.xbgr.xm36_u5.nsg13_hv_nmos[ide]
print @n.xbgr.xm36_u5.nsg13_hv_nmos[ige]
print @n.xbgr.xm36_u5.nsg13_hv_nmos[ise]
print @n.xbgr.xm36_u5.nsg13_hv_nmos[ibe]
print @n.xbgr.xm36_u5.nsg13_hv_nmos[ctype]
print @n.xbgr.xm36_u6.nsg13_hv_nmos[ide]
print @n.xbgr.xm36_u6.nsg13_hv_nmos[ige]
print @n.xbgr.xm36_u6.nsg13_hv_nmos[ise]
print @n.xbgr.xm36_u6.nsg13_hv_nmos[ibe]
print @n.xbgr.xm36_u6.nsg13_hv_nmos[ctype]
print @n.xbgr.xm36_u7.nsg13_hv_nmos[ide]
print @n.xbgr.xm36_u7.nsg13_hv_nmos[ige]
print @n.xbgr.xm36_u7.nsg13_hv_nmos[ise]
print @n.xbgr.xm36_u7.nsg13_hv_nmos[ibe]
print @n.xbgr.xm36_u7.nsg13_hv_nmos[ctype]
print @n.xbgr.xm36_u8.nsg13_hv_nmos[ide]
print @n.xbgr.xm36_u8.nsg13_hv_nmos[ige]
print @n.xbgr.xm36_u8.nsg13_hv_nmos[ise]
print @n.xbgr.xm36_u8.nsg13_hv_nmos[ibe]
print @n.xbgr.xm36_u8.nsg13_hv_nmos[ctype]
print @n.xbgr.xm36_u9.nsg13_hv_nmos[ide]
print @n.xbgr.xm36_u9.nsg13_hv_nmos[ige]
print @n.xbgr.xm36_u9.nsg13_hv_nmos[ise]
print @n.xbgr.xm36_u9.nsg13_hv_nmos[ibe]
print @n.xbgr.xm36_u9.nsg13_hv_nmos[ctype]
print @n.xbgr.xm36_u10.nsg13_hv_nmos[ide]
print @n.xbgr.xm36_u10.nsg13_hv_nmos[ige]
print @n.xbgr.xm36_u10.nsg13_hv_nmos[ise]
print @n.xbgr.xm36_u10.nsg13_hv_nmos[ibe]
print @n.xbgr.xm36_u10.nsg13_hv_nmos[ctype]
print @n.xbgr.xm36_u11.nsg13_hv_nmos[ide]
print @n.xbgr.xm36_u11.nsg13_hv_nmos[ige]
print @n.xbgr.xm36_u11.nsg13_hv_nmos[ise]
print @n.xbgr.xm36_u11.nsg13_hv_nmos[ibe]
print @n.xbgr.xm36_u11.nsg13_hv_nmos[ctype]
print @n.xbgr.xm36_u12.nsg13_hv_nmos[ide]
print @n.xbgr.xm36_u12.nsg13_hv_nmos[ige]
print @n.xbgr.xm36_u12.nsg13_hv_nmos[ise]
print @n.xbgr.xm36_u12.nsg13_hv_nmos[ibe]
print @n.xbgr.xm36_u12.nsg13_hv_nmos[ctype]
print @n.xbgr.xm36_u13.nsg13_hv_nmos[ide]
print @n.xbgr.xm36_u13.nsg13_hv_nmos[ige]
print @n.xbgr.xm36_u13.nsg13_hv_nmos[ise]
print @n.xbgr.xm36_u13.nsg13_hv_nmos[ibe]
print @n.xbgr.xm36_u13.nsg13_hv_nmos[ctype]
print @n.xbgr.xm36_u14.nsg13_hv_nmos[ide]
print @n.xbgr.xm36_u14.nsg13_hv_nmos[ige]
print @n.xbgr.xm36_u14.nsg13_hv_nmos[ise]
print @n.xbgr.xm36_u14.nsg13_hv_nmos[ibe]
print @n.xbgr.xm36_u14.nsg13_hv_nmos[ctype]
print @n.xbgr.xm36_u15.nsg13_hv_nmos[ide]
print @n.xbgr.xm36_u15.nsg13_hv_nmos[ige]
print @n.xbgr.xm36_u15.nsg13_hv_nmos[ise]
print @n.xbgr.xm36_u15.nsg13_hv_nmos[ibe]
print @n.xbgr.xm36_u15.nsg13_hv_nmos[ctype]
print @n.xbgr.xm36_u16.nsg13_hv_nmos[ide]
print @n.xbgr.xm36_u16.nsg13_hv_nmos[ige]
print @n.xbgr.xm36_u16.nsg13_hv_nmos[ise]
print @n.xbgr.xm36_u16.nsg13_hv_nmos[ibe]
print @n.xbgr.xm36_u16.nsg13_hv_nmos[ctype]
print @n.xbgr.xm36_u17.nsg13_hv_nmos[ide]
print @n.xbgr.xm36_u17.nsg13_hv_nmos[ige]
print @n.xbgr.xm36_u17.nsg13_hv_nmos[ise]
print @n.xbgr.xm36_u17.nsg13_hv_nmos[ibe]
print @n.xbgr.xm36_u17.nsg13_hv_nmos[ctype]
print @n.xbgr.xm36_u18.nsg13_hv_nmos[ide]
print @n.xbgr.xm36_u18.nsg13_hv_nmos[ige]
print @n.xbgr.xm36_u18.nsg13_hv_nmos[ise]
print @n.xbgr.xm36_u18.nsg13_hv_nmos[ibe]
print @n.xbgr.xm36_u18.nsg13_hv_nmos[ctype]
print @n.xbgr.xm36_u19.nsg13_hv_nmos[ide]
print @n.xbgr.xm36_u19.nsg13_hv_nmos[ige]
print @n.xbgr.xm36_u19.nsg13_hv_nmos[ise]
print @n.xbgr.xm36_u19.nsg13_hv_nmos[ibe]
print @n.xbgr.xm36_u19.nsg13_hv_nmos[ctype]
print @n.xbgr.xm36_u20.nsg13_hv_nmos[ide]
print @n.xbgr.xm36_u20.nsg13_hv_nmos[ige]
print @n.xbgr.xm36_u20.nsg13_hv_nmos[ise]
print @n.xbgr.xm36_u20.nsg13_hv_nmos[ibe]
print @n.xbgr.xm36_u20.nsg13_hv_nmos[ctype]
print @n.xbgr.xm36_u21.nsg13_hv_nmos[ide]
print @n.xbgr.xm36_u21.nsg13_hv_nmos[ige]
print @n.xbgr.xm36_u21.nsg13_hv_nmos[ise]
print @n.xbgr.xm36_u21.nsg13_hv_nmos[ibe]
print @n.xbgr.xm36_u21.nsg13_hv_nmos[ctype]
print @n.xbgr.xm36_u22.nsg13_hv_nmos[ide]
print @n.xbgr.xm36_u22.nsg13_hv_nmos[ige]
print @n.xbgr.xm36_u22.nsg13_hv_nmos[ise]
print @n.xbgr.xm36_u22.nsg13_hv_nmos[ibe]
print @n.xbgr.xm36_u22.nsg13_hv_nmos[ctype]
print @n.xbgr.xm36_u23.nsg13_hv_nmos[ide]
print @n.xbgr.xm36_u23.nsg13_hv_nmos[ige]
print @n.xbgr.xm36_u23.nsg13_hv_nmos[ise]
print @n.xbgr.xm36_u23.nsg13_hv_nmos[ibe]
print @n.xbgr.xm36_u23.nsg13_hv_nmos[ctype]
print @n.xbgr.xm36_u24.nsg13_hv_nmos[ide]
print @n.xbgr.xm36_u24.nsg13_hv_nmos[ige]
print @n.xbgr.xm36_u24.nsg13_hv_nmos[ise]
print @n.xbgr.xm36_u24.nsg13_hv_nmos[ibe]
print @n.xbgr.xm36_u24.nsg13_hv_nmos[ctype]
print @n.xbgr.xm37_u2.nsg13_hv_nmos[ide]
print @n.xbgr.xm37_u2.nsg13_hv_nmos[ige]
print @n.xbgr.xm37_u2.nsg13_hv_nmos[ise]
print @n.xbgr.xm37_u2.nsg13_hv_nmos[ibe]
print @n.xbgr.xm37_u2.nsg13_hv_nmos[ctype]
print @n.xbgr.xm37_u3.nsg13_hv_nmos[ide]
print @n.xbgr.xm37_u3.nsg13_hv_nmos[ige]
print @n.xbgr.xm37_u3.nsg13_hv_nmos[ise]
print @n.xbgr.xm37_u3.nsg13_hv_nmos[ibe]
print @n.xbgr.xm37_u3.nsg13_hv_nmos[ctype]
print @n.xbgr.xm37_u4.nsg13_hv_nmos[ide]
print @n.xbgr.xm37_u4.nsg13_hv_nmos[ige]
print @n.xbgr.xm37_u4.nsg13_hv_nmos[ise]
print @n.xbgr.xm37_u4.nsg13_hv_nmos[ibe]
print @n.xbgr.xm37_u4.nsg13_hv_nmos[ctype]
print @n.xbgr.xm37_u5.nsg13_hv_nmos[ide]
print @n.xbgr.xm37_u5.nsg13_hv_nmos[ige]
print @n.xbgr.xm37_u5.nsg13_hv_nmos[ise]
print @n.xbgr.xm37_u5.nsg13_hv_nmos[ibe]
print @n.xbgr.xm37_u5.nsg13_hv_nmos[ctype]
print @n.xbgr.xm37_u6.nsg13_hv_nmos[ide]
print @n.xbgr.xm37_u6.nsg13_hv_nmos[ige]
print @n.xbgr.xm37_u6.nsg13_hv_nmos[ise]
print @n.xbgr.xm37_u6.nsg13_hv_nmos[ibe]
print @n.xbgr.xm37_u6.nsg13_hv_nmos[ctype]
print @n.xbgr.xm37_u7.nsg13_hv_nmos[ide]
print @n.xbgr.xm37_u7.nsg13_hv_nmos[ige]
print @n.xbgr.xm37_u7.nsg13_hv_nmos[ise]
print @n.xbgr.xm37_u7.nsg13_hv_nmos[ibe]
print @n.xbgr.xm37_u7.nsg13_hv_nmos[ctype]
print @n.xbgr.xm37_u8.nsg13_hv_nmos[ide]
print @n.xbgr.xm37_u8.nsg13_hv_nmos[ige]
print @n.xbgr.xm37_u8.nsg13_hv_nmos[ise]
print @n.xbgr.xm37_u8.nsg13_hv_nmos[ibe]
print @n.xbgr.xm37_u8.nsg13_hv_nmos[ctype]
print @n.xbgr.xm37_u9.nsg13_hv_nmos[ide]
print @n.xbgr.xm37_u9.nsg13_hv_nmos[ige]
print @n.xbgr.xm37_u9.nsg13_hv_nmos[ise]
print @n.xbgr.xm37_u9.nsg13_hv_nmos[ibe]
print @n.xbgr.xm37_u9.nsg13_hv_nmos[ctype]
print @n.xbgr.xm37_u10.nsg13_hv_nmos[ide]
print @n.xbgr.xm37_u10.nsg13_hv_nmos[ige]
print @n.xbgr.xm37_u10.nsg13_hv_nmos[ise]
print @n.xbgr.xm37_u10.nsg13_hv_nmos[ibe]
print @n.xbgr.xm37_u10.nsg13_hv_nmos[ctype]
print @n.xbgr.xm37_u11.nsg13_hv_nmos[ide]
print @n.xbgr.xm37_u11.nsg13_hv_nmos[ige]
print @n.xbgr.xm37_u11.nsg13_hv_nmos[ise]
print @n.xbgr.xm37_u11.nsg13_hv_nmos[ibe]
print @n.xbgr.xm37_u11.nsg13_hv_nmos[ctype]
print @n.xbgr.xm37_u12.nsg13_hv_nmos[ide]
print @n.xbgr.xm37_u12.nsg13_hv_nmos[ige]
print @n.xbgr.xm37_u12.nsg13_hv_nmos[ise]
print @n.xbgr.xm37_u12.nsg13_hv_nmos[ibe]
print @n.xbgr.xm37_u12.nsg13_hv_nmos[ctype]
print @n.xbgr.xm37_u13.nsg13_hv_nmos[ide]
print @n.xbgr.xm37_u13.nsg13_hv_nmos[ige]
print @n.xbgr.xm37_u13.nsg13_hv_nmos[ise]
print @n.xbgr.xm37_u13.nsg13_hv_nmos[ibe]
print @n.xbgr.xm37_u13.nsg13_hv_nmos[ctype]
print @n.xbgr.xm37_u14.nsg13_hv_nmos[ide]
print @n.xbgr.xm37_u14.nsg13_hv_nmos[ige]
print @n.xbgr.xm37_u14.nsg13_hv_nmos[ise]
print @n.xbgr.xm37_u14.nsg13_hv_nmos[ibe]
print @n.xbgr.xm37_u14.nsg13_hv_nmos[ctype]
print @n.xbgr.xm37_u15.nsg13_hv_nmos[ide]
print @n.xbgr.xm37_u15.nsg13_hv_nmos[ige]
print @n.xbgr.xm37_u15.nsg13_hv_nmos[ise]
print @n.xbgr.xm37_u15.nsg13_hv_nmos[ibe]
print @n.xbgr.xm37_u15.nsg13_hv_nmos[ctype]
print @n.xbgr.xm37_u16.nsg13_hv_nmos[ide]
print @n.xbgr.xm37_u16.nsg13_hv_nmos[ige]
print @n.xbgr.xm37_u16.nsg13_hv_nmos[ise]
print @n.xbgr.xm37_u16.nsg13_hv_nmos[ibe]
print @n.xbgr.xm37_u16.nsg13_hv_nmos[ctype]
print @n.xbgr.xm37_u17.nsg13_hv_nmos[ide]
print @n.xbgr.xm37_u17.nsg13_hv_nmos[ige]
print @n.xbgr.xm37_u17.nsg13_hv_nmos[ise]
print @n.xbgr.xm37_u17.nsg13_hv_nmos[ibe]
print @n.xbgr.xm37_u17.nsg13_hv_nmos[ctype]
print @n.xbgr.xm37_u18.nsg13_hv_nmos[ide]
print @n.xbgr.xm37_u18.nsg13_hv_nmos[ige]
print @n.xbgr.xm37_u18.nsg13_hv_nmos[ise]
print @n.xbgr.xm37_u18.nsg13_hv_nmos[ibe]
print @n.xbgr.xm37_u18.nsg13_hv_nmos[ctype]
print @n.xbgr.xm37_u19.nsg13_hv_nmos[ide]
print @n.xbgr.xm37_u19.nsg13_hv_nmos[ige]
print @n.xbgr.xm37_u19.nsg13_hv_nmos[ise]
print @n.xbgr.xm37_u19.nsg13_hv_nmos[ibe]
print @n.xbgr.xm37_u19.nsg13_hv_nmos[ctype]
print @n.xbgr.xm37_u20.nsg13_hv_nmos[ide]
print @n.xbgr.xm37_u20.nsg13_hv_nmos[ige]
print @n.xbgr.xm37_u20.nsg13_hv_nmos[ise]
print @n.xbgr.xm37_u20.nsg13_hv_nmos[ibe]
print @n.xbgr.xm37_u20.nsg13_hv_nmos[ctype]
print @n.xbgr.xm37_u21.nsg13_hv_nmos[ide]
print @n.xbgr.xm37_u21.nsg13_hv_nmos[ige]
print @n.xbgr.xm37_u21.nsg13_hv_nmos[ise]
print @n.xbgr.xm37_u21.nsg13_hv_nmos[ibe]
print @n.xbgr.xm37_u21.nsg13_hv_nmos[ctype]
print @n.xbgr.xm37_u22.nsg13_hv_nmos[ide]
print @n.xbgr.xm37_u22.nsg13_hv_nmos[ige]
print @n.xbgr.xm37_u22.nsg13_hv_nmos[ise]
print @n.xbgr.xm37_u22.nsg13_hv_nmos[ibe]
print @n.xbgr.xm37_u22.nsg13_hv_nmos[ctype]
print @n.xbgr.xm37_u23.nsg13_hv_nmos[ide]
print @n.xbgr.xm37_u23.nsg13_hv_nmos[ige]
print @n.xbgr.xm37_u23.nsg13_hv_nmos[ise]
print @n.xbgr.xm37_u23.nsg13_hv_nmos[ibe]
print @n.xbgr.xm37_u23.nsg13_hv_nmos[ctype]
print @n.xbgr.xm37_u24.nsg13_hv_nmos[ide]
print @n.xbgr.xm37_u24.nsg13_hv_nmos[ige]
print @n.xbgr.xm37_u24.nsg13_hv_nmos[ise]
print @n.xbgr.xm37_u24.nsg13_hv_nmos[ibe]
print @n.xbgr.xm37_u24.nsg13_hv_nmos[ctype]
print @n.xbgr.xm38_u2.nsg13_hv_pmos[ide]
print @n.xbgr.xm38_u2.nsg13_hv_pmos[ige]
print @n.xbgr.xm38_u2.nsg13_hv_pmos[ise]
print @n.xbgr.xm38_u2.nsg13_hv_pmos[ibe]
print @n.xbgr.xm38_u2.nsg13_hv_pmos[ctype]
print @n.xbgr.xm38_u3.nsg13_hv_pmos[ide]
print @n.xbgr.xm38_u3.nsg13_hv_pmos[ige]
print @n.xbgr.xm38_u3.nsg13_hv_pmos[ise]
print @n.xbgr.xm38_u3.nsg13_hv_pmos[ibe]
print @n.xbgr.xm38_u3.nsg13_hv_pmos[ctype]
print @n.xbgr.xm38_u4.nsg13_hv_pmos[ide]
print @n.xbgr.xm38_u4.nsg13_hv_pmos[ige]
print @n.xbgr.xm38_u4.nsg13_hv_pmos[ise]
print @n.xbgr.xm38_u4.nsg13_hv_pmos[ibe]
print @n.xbgr.xm38_u4.nsg13_hv_pmos[ctype]
print @n.xbgr.xm38_u5.nsg13_hv_pmos[ide]
print @n.xbgr.xm38_u5.nsg13_hv_pmos[ige]
print @n.xbgr.xm38_u5.nsg13_hv_pmos[ise]
print @n.xbgr.xm38_u5.nsg13_hv_pmos[ibe]
print @n.xbgr.xm38_u5.nsg13_hv_pmos[ctype]
print @n.xbgr.xm38_u6.nsg13_hv_pmos[ide]
print @n.xbgr.xm38_u6.nsg13_hv_pmos[ige]
print @n.xbgr.xm38_u6.nsg13_hv_pmos[ise]
print @n.xbgr.xm38_u6.nsg13_hv_pmos[ibe]
print @n.xbgr.xm38_u6.nsg13_hv_pmos[ctype]
print @n.xbgr.xm38_u7.nsg13_hv_pmos[ide]
print @n.xbgr.xm38_u7.nsg13_hv_pmos[ige]
print @n.xbgr.xm38_u7.nsg13_hv_pmos[ise]
print @n.xbgr.xm38_u7.nsg13_hv_pmos[ibe]
print @n.xbgr.xm38_u7.nsg13_hv_pmos[ctype]
print @n.xbgr.xm38_u8.nsg13_hv_pmos[ide]
print @n.xbgr.xm38_u8.nsg13_hv_pmos[ige]
print @n.xbgr.xm38_u8.nsg13_hv_pmos[ise]
print @n.xbgr.xm38_u8.nsg13_hv_pmos[ibe]
print @n.xbgr.xm38_u8.nsg13_hv_pmos[ctype]
print @n.xbgr.xm38_u9.nsg13_hv_pmos[ide]
print @n.xbgr.xm38_u9.nsg13_hv_pmos[ige]
print @n.xbgr.xm38_u9.nsg13_hv_pmos[ise]
print @n.xbgr.xm38_u9.nsg13_hv_pmos[ibe]
print @n.xbgr.xm38_u9.nsg13_hv_pmos[ctype]
print @n.xbgr.xm38_u10.nsg13_hv_pmos[ide]
print @n.xbgr.xm38_u10.nsg13_hv_pmos[ige]
print @n.xbgr.xm38_u10.nsg13_hv_pmos[ise]
print @n.xbgr.xm38_u10.nsg13_hv_pmos[ibe]
print @n.xbgr.xm38_u10.nsg13_hv_pmos[ctype]
print @n.xbgr.xm38_u11.nsg13_hv_pmos[ide]
print @n.xbgr.xm38_u11.nsg13_hv_pmos[ige]
print @n.xbgr.xm38_u11.nsg13_hv_pmos[ise]
print @n.xbgr.xm38_u11.nsg13_hv_pmos[ibe]
print @n.xbgr.xm38_u11.nsg13_hv_pmos[ctype]
print @n.xbgr.xm38_u12.nsg13_hv_pmos[ide]
print @n.xbgr.xm38_u12.nsg13_hv_pmos[ige]
print @n.xbgr.xm38_u12.nsg13_hv_pmos[ise]
print @n.xbgr.xm38_u12.nsg13_hv_pmos[ibe]
print @n.xbgr.xm38_u12.nsg13_hv_pmos[ctype]
print @n.xbgr.xm38_u13.nsg13_hv_pmos[ide]
print @n.xbgr.xm38_u13.nsg13_hv_pmos[ige]
print @n.xbgr.xm38_u13.nsg13_hv_pmos[ise]
print @n.xbgr.xm38_u13.nsg13_hv_pmos[ibe]
print @n.xbgr.xm38_u13.nsg13_hv_pmos[ctype]
print @n.xbgr.xm38_u14.nsg13_hv_pmos[ide]
print @n.xbgr.xm38_u14.nsg13_hv_pmos[ige]
print @n.xbgr.xm38_u14.nsg13_hv_pmos[ise]
print @n.xbgr.xm38_u14.nsg13_hv_pmos[ibe]
print @n.xbgr.xm38_u14.nsg13_hv_pmos[ctype]
print @n.xbgr.xm38_u15.nsg13_hv_pmos[ide]
print @n.xbgr.xm38_u15.nsg13_hv_pmos[ige]
print @n.xbgr.xm38_u15.nsg13_hv_pmos[ise]
print @n.xbgr.xm38_u15.nsg13_hv_pmos[ibe]
print @n.xbgr.xm38_u15.nsg13_hv_pmos[ctype]
print @n.xbgr.xm38_u16.nsg13_hv_pmos[ide]
print @n.xbgr.xm38_u16.nsg13_hv_pmos[ige]
print @n.xbgr.xm38_u16.nsg13_hv_pmos[ise]
print @n.xbgr.xm38_u16.nsg13_hv_pmos[ibe]
print @n.xbgr.xm38_u16.nsg13_hv_pmos[ctype]
print @n.xbgr.xm38_u17.nsg13_hv_pmos[ide]
print @n.xbgr.xm38_u17.nsg13_hv_pmos[ige]
print @n.xbgr.xm38_u17.nsg13_hv_pmos[ise]
print @n.xbgr.xm38_u17.nsg13_hv_pmos[ibe]
print @n.xbgr.xm38_u17.nsg13_hv_pmos[ctype]
print @n.xbgr.xm38_u18.nsg13_hv_pmos[ide]
print @n.xbgr.xm38_u18.nsg13_hv_pmos[ige]
print @n.xbgr.xm38_u18.nsg13_hv_pmos[ise]
print @n.xbgr.xm38_u18.nsg13_hv_pmos[ibe]
print @n.xbgr.xm38_u18.nsg13_hv_pmos[ctype]
print @n.xbgr.xm38_u19.nsg13_hv_pmos[ide]
print @n.xbgr.xm38_u19.nsg13_hv_pmos[ige]
print @n.xbgr.xm38_u19.nsg13_hv_pmos[ise]
print @n.xbgr.xm38_u19.nsg13_hv_pmos[ibe]
print @n.xbgr.xm38_u19.nsg13_hv_pmos[ctype]
print @n.xbgr.xm38_u20.nsg13_hv_pmos[ide]
print @n.xbgr.xm38_u20.nsg13_hv_pmos[ige]
print @n.xbgr.xm38_u20.nsg13_hv_pmos[ise]
print @n.xbgr.xm38_u20.nsg13_hv_pmos[ibe]
print @n.xbgr.xm38_u20.nsg13_hv_pmos[ctype]
print @n.xbgr.xm38_u21.nsg13_hv_pmos[ide]
print @n.xbgr.xm38_u21.nsg13_hv_pmos[ige]
print @n.xbgr.xm38_u21.nsg13_hv_pmos[ise]
print @n.xbgr.xm38_u21.nsg13_hv_pmos[ibe]
print @n.xbgr.xm38_u21.nsg13_hv_pmos[ctype]
print @n.xbgr.xm38_u22.nsg13_hv_pmos[ide]
print @n.xbgr.xm38_u22.nsg13_hv_pmos[ige]
print @n.xbgr.xm38_u22.nsg13_hv_pmos[ise]
print @n.xbgr.xm38_u22.nsg13_hv_pmos[ibe]
print @n.xbgr.xm38_u22.nsg13_hv_pmos[ctype]
print @n.xbgr.xm38_u23.nsg13_hv_pmos[ide]
print @n.xbgr.xm38_u23.nsg13_hv_pmos[ige]
print @n.xbgr.xm38_u23.nsg13_hv_pmos[ise]
print @n.xbgr.xm38_u23.nsg13_hv_pmos[ibe]
print @n.xbgr.xm38_u23.nsg13_hv_pmos[ctype]
print @n.xbgr.xm38_u24.nsg13_hv_pmos[ide]
print @n.xbgr.xm38_u24.nsg13_hv_pmos[ige]
print @n.xbgr.xm38_u24.nsg13_hv_pmos[ise]
print @n.xbgr.xm38_u24.nsg13_hv_pmos[ibe]
print @n.xbgr.xm38_u24.nsg13_hv_pmos[ctype]
print @n.xbgr.xm39_u2.nsg13_hv_pmos[ide]
print @n.xbgr.xm39_u2.nsg13_hv_pmos[ige]
print @n.xbgr.xm39_u2.nsg13_hv_pmos[ise]
print @n.xbgr.xm39_u2.nsg13_hv_pmos[ibe]
print @n.xbgr.xm39_u2.nsg13_hv_pmos[ctype]
print @n.xbgr.xm39_u3.nsg13_hv_pmos[ide]
print @n.xbgr.xm39_u3.nsg13_hv_pmos[ige]
print @n.xbgr.xm39_u3.nsg13_hv_pmos[ise]
print @n.xbgr.xm39_u3.nsg13_hv_pmos[ibe]
print @n.xbgr.xm39_u3.nsg13_hv_pmos[ctype]
print @n.xbgr.xm39_u4.nsg13_hv_pmos[ide]
print @n.xbgr.xm39_u4.nsg13_hv_pmos[ige]
print @n.xbgr.xm39_u4.nsg13_hv_pmos[ise]
print @n.xbgr.xm39_u4.nsg13_hv_pmos[ibe]
print @n.xbgr.xm39_u4.nsg13_hv_pmos[ctype]
print @n.xbgr.xm39_u5.nsg13_hv_pmos[ide]
print @n.xbgr.xm39_u5.nsg13_hv_pmos[ige]
print @n.xbgr.xm39_u5.nsg13_hv_pmos[ise]
print @n.xbgr.xm39_u5.nsg13_hv_pmos[ibe]
print @n.xbgr.xm39_u5.nsg13_hv_pmos[ctype]
print @n.xbgr.xm39_u6.nsg13_hv_pmos[ide]
print @n.xbgr.xm39_u6.nsg13_hv_pmos[ige]
print @n.xbgr.xm39_u6.nsg13_hv_pmos[ise]
print @n.xbgr.xm39_u6.nsg13_hv_pmos[ibe]
print @n.xbgr.xm39_u6.nsg13_hv_pmos[ctype]
print @n.xbgr.xm39_u7.nsg13_hv_pmos[ide]
print @n.xbgr.xm39_u7.nsg13_hv_pmos[ige]
print @n.xbgr.xm39_u7.nsg13_hv_pmos[ise]
print @n.xbgr.xm39_u7.nsg13_hv_pmos[ibe]
print @n.xbgr.xm39_u7.nsg13_hv_pmos[ctype]
print @n.xbgr.xm39_u8.nsg13_hv_pmos[ide]
print @n.xbgr.xm39_u8.nsg13_hv_pmos[ige]
print @n.xbgr.xm39_u8.nsg13_hv_pmos[ise]
print @n.xbgr.xm39_u8.nsg13_hv_pmos[ibe]
print @n.xbgr.xm39_u8.nsg13_hv_pmos[ctype]
print @n.xbgr.xm39_u9.nsg13_hv_pmos[ide]
print @n.xbgr.xm39_u9.nsg13_hv_pmos[ige]
print @n.xbgr.xm39_u9.nsg13_hv_pmos[ise]
print @n.xbgr.xm39_u9.nsg13_hv_pmos[ibe]
print @n.xbgr.xm39_u9.nsg13_hv_pmos[ctype]
print @n.xbgr.xm39_u10.nsg13_hv_pmos[ide]
print @n.xbgr.xm39_u10.nsg13_hv_pmos[ige]
print @n.xbgr.xm39_u10.nsg13_hv_pmos[ise]
print @n.xbgr.xm39_u10.nsg13_hv_pmos[ibe]
print @n.xbgr.xm39_u10.nsg13_hv_pmos[ctype]
print @n.xbgr.xm39_u11.nsg13_hv_pmos[ide]
print @n.xbgr.xm39_u11.nsg13_hv_pmos[ige]
print @n.xbgr.xm39_u11.nsg13_hv_pmos[ise]
print @n.xbgr.xm39_u11.nsg13_hv_pmos[ibe]
print @n.xbgr.xm39_u11.nsg13_hv_pmos[ctype]
print @n.xbgr.xm39_u12.nsg13_hv_pmos[ide]
print @n.xbgr.xm39_u12.nsg13_hv_pmos[ige]
print @n.xbgr.xm39_u12.nsg13_hv_pmos[ise]
print @n.xbgr.xm39_u12.nsg13_hv_pmos[ibe]
print @n.xbgr.xm39_u12.nsg13_hv_pmos[ctype]
print @n.xbgr.xm39_u13.nsg13_hv_pmos[ide]
print @n.xbgr.xm39_u13.nsg13_hv_pmos[ige]
print @n.xbgr.xm39_u13.nsg13_hv_pmos[ise]
print @n.xbgr.xm39_u13.nsg13_hv_pmos[ibe]
print @n.xbgr.xm39_u13.nsg13_hv_pmos[ctype]
print @n.xbgr.xm39_u14.nsg13_hv_pmos[ide]
print @n.xbgr.xm39_u14.nsg13_hv_pmos[ige]
print @n.xbgr.xm39_u14.nsg13_hv_pmos[ise]
print @n.xbgr.xm39_u14.nsg13_hv_pmos[ibe]
print @n.xbgr.xm39_u14.nsg13_hv_pmos[ctype]
print @n.xbgr.xm39_u15.nsg13_hv_pmos[ide]
print @n.xbgr.xm39_u15.nsg13_hv_pmos[ige]
print @n.xbgr.xm39_u15.nsg13_hv_pmos[ise]
print @n.xbgr.xm39_u15.nsg13_hv_pmos[ibe]
print @n.xbgr.xm39_u15.nsg13_hv_pmos[ctype]
print @n.xbgr.xm39_u16.nsg13_hv_pmos[ide]
print @n.xbgr.xm39_u16.nsg13_hv_pmos[ige]
print @n.xbgr.xm39_u16.nsg13_hv_pmos[ise]
print @n.xbgr.xm39_u16.nsg13_hv_pmos[ibe]
print @n.xbgr.xm39_u16.nsg13_hv_pmos[ctype]
print @n.xbgr.xm39_u17.nsg13_hv_pmos[ide]
print @n.xbgr.xm39_u17.nsg13_hv_pmos[ige]
print @n.xbgr.xm39_u17.nsg13_hv_pmos[ise]
print @n.xbgr.xm39_u17.nsg13_hv_pmos[ibe]
print @n.xbgr.xm39_u17.nsg13_hv_pmos[ctype]
print @n.xbgr.xm39_u18.nsg13_hv_pmos[ide]
print @n.xbgr.xm39_u18.nsg13_hv_pmos[ige]
print @n.xbgr.xm39_u18.nsg13_hv_pmos[ise]
print @n.xbgr.xm39_u18.nsg13_hv_pmos[ibe]
print @n.xbgr.xm39_u18.nsg13_hv_pmos[ctype]
print @n.xbgr.xm39_u19.nsg13_hv_pmos[ide]
print @n.xbgr.xm39_u19.nsg13_hv_pmos[ige]
print @n.xbgr.xm39_u19.nsg13_hv_pmos[ise]
print @n.xbgr.xm39_u19.nsg13_hv_pmos[ibe]
print @n.xbgr.xm39_u19.nsg13_hv_pmos[ctype]
print @n.xbgr.xm39_u20.nsg13_hv_pmos[ide]
print @n.xbgr.xm39_u20.nsg13_hv_pmos[ige]
print @n.xbgr.xm39_u20.nsg13_hv_pmos[ise]
print @n.xbgr.xm39_u20.nsg13_hv_pmos[ibe]
print @n.xbgr.xm39_u20.nsg13_hv_pmos[ctype]
print @n.xbgr.xm39_u21.nsg13_hv_pmos[ide]
print @n.xbgr.xm39_u21.nsg13_hv_pmos[ige]
print @n.xbgr.xm39_u21.nsg13_hv_pmos[ise]
print @n.xbgr.xm39_u21.nsg13_hv_pmos[ibe]
print @n.xbgr.xm39_u21.nsg13_hv_pmos[ctype]
print @n.xbgr.xm39_u22.nsg13_hv_pmos[ide]
print @n.xbgr.xm39_u22.nsg13_hv_pmos[ige]
print @n.xbgr.xm39_u22.nsg13_hv_pmos[ise]
print @n.xbgr.xm39_u22.nsg13_hv_pmos[ibe]
print @n.xbgr.xm39_u22.nsg13_hv_pmos[ctype]
print @n.xbgr.xm39_u23.nsg13_hv_pmos[ide]
print @n.xbgr.xm39_u23.nsg13_hv_pmos[ige]
print @n.xbgr.xm39_u23.nsg13_hv_pmos[ise]
print @n.xbgr.xm39_u23.nsg13_hv_pmos[ibe]
print @n.xbgr.xm39_u23.nsg13_hv_pmos[ctype]
print @n.xbgr.xm39_u24.nsg13_hv_pmos[ide]
print @n.xbgr.xm39_u24.nsg13_hv_pmos[ige]
print @n.xbgr.xm39_u24.nsg13_hv_pmos[ise]
print @n.xbgr.xm39_u24.nsg13_hv_pmos[ibe]
print @n.xbgr.xm39_u24.nsg13_hv_pmos[ctype]
print @n.xbgr.xm41_u2.nsg13_hv_pmos[ide]
print @n.xbgr.xm41_u2.nsg13_hv_pmos[ige]
print @n.xbgr.xm41_u2.nsg13_hv_pmos[ise]
print @n.xbgr.xm41_u2.nsg13_hv_pmos[ibe]
print @n.xbgr.xm41_u2.nsg13_hv_pmos[ctype]
print @n.xbgr.xm41_u3.nsg13_hv_pmos[ide]
print @n.xbgr.xm41_u3.nsg13_hv_pmos[ige]
print @n.xbgr.xm41_u3.nsg13_hv_pmos[ise]
print @n.xbgr.xm41_u3.nsg13_hv_pmos[ibe]
print @n.xbgr.xm41_u3.nsg13_hv_pmos[ctype]
print @n.xbgr.xm41_u4.nsg13_hv_pmos[ide]
print @n.xbgr.xm41_u4.nsg13_hv_pmos[ige]
print @n.xbgr.xm41_u4.nsg13_hv_pmos[ise]
print @n.xbgr.xm41_u4.nsg13_hv_pmos[ibe]
print @n.xbgr.xm41_u4.nsg13_hv_pmos[ctype]
print @n.xbgr.xm41_u5.nsg13_hv_pmos[ide]
print @n.xbgr.xm41_u5.nsg13_hv_pmos[ige]
print @n.xbgr.xm41_u5.nsg13_hv_pmos[ise]
print @n.xbgr.xm41_u5.nsg13_hv_pmos[ibe]
print @n.xbgr.xm41_u5.nsg13_hv_pmos[ctype]
print @n.xbgr.xm41_u6.nsg13_hv_pmos[ide]
print @n.xbgr.xm41_u6.nsg13_hv_pmos[ige]
print @n.xbgr.xm41_u6.nsg13_hv_pmos[ise]
print @n.xbgr.xm41_u6.nsg13_hv_pmos[ibe]
print @n.xbgr.xm41_u6.nsg13_hv_pmos[ctype]
print @n.xbgr.xm41_u7.nsg13_hv_pmos[ide]
print @n.xbgr.xm41_u7.nsg13_hv_pmos[ige]
print @n.xbgr.xm41_u7.nsg13_hv_pmos[ise]
print @n.xbgr.xm41_u7.nsg13_hv_pmos[ibe]
print @n.xbgr.xm41_u7.nsg13_hv_pmos[ctype]
print @n.xbgr.xm41_u8.nsg13_hv_pmos[ide]
print @n.xbgr.xm41_u8.nsg13_hv_pmos[ige]
print @n.xbgr.xm41_u8.nsg13_hv_pmos[ise]
print @n.xbgr.xm41_u8.nsg13_hv_pmos[ibe]
print @n.xbgr.xm41_u8.nsg13_hv_pmos[ctype]
print @n.xbgr.xm41_u9.nsg13_hv_pmos[ide]
print @n.xbgr.xm41_u9.nsg13_hv_pmos[ige]
print @n.xbgr.xm41_u9.nsg13_hv_pmos[ise]
print @n.xbgr.xm41_u9.nsg13_hv_pmos[ibe]
print @n.xbgr.xm41_u9.nsg13_hv_pmos[ctype]
print @n.xbgr.xm41_u10.nsg13_hv_pmos[ide]
print @n.xbgr.xm41_u10.nsg13_hv_pmos[ige]
print @n.xbgr.xm41_u10.nsg13_hv_pmos[ise]
print @n.xbgr.xm41_u10.nsg13_hv_pmos[ibe]
print @n.xbgr.xm41_u10.nsg13_hv_pmos[ctype]
print @n.xbgr.xm41_u11.nsg13_hv_pmos[ide]
print @n.xbgr.xm41_u11.nsg13_hv_pmos[ige]
print @n.xbgr.xm41_u11.nsg13_hv_pmos[ise]
print @n.xbgr.xm41_u11.nsg13_hv_pmos[ibe]
print @n.xbgr.xm41_u11.nsg13_hv_pmos[ctype]
print @n.xbgr.xm41_u12.nsg13_hv_pmos[ide]
print @n.xbgr.xm41_u12.nsg13_hv_pmos[ige]
print @n.xbgr.xm41_u12.nsg13_hv_pmos[ise]
print @n.xbgr.xm41_u12.nsg13_hv_pmos[ibe]
print @n.xbgr.xm41_u12.nsg13_hv_pmos[ctype]
print @n.xbgr.xm41_u13.nsg13_hv_pmos[ide]
print @n.xbgr.xm41_u13.nsg13_hv_pmos[ige]
print @n.xbgr.xm41_u13.nsg13_hv_pmos[ise]
print @n.xbgr.xm41_u13.nsg13_hv_pmos[ibe]
print @n.xbgr.xm41_u13.nsg13_hv_pmos[ctype]
print @n.xbgr.xm41_u14.nsg13_hv_pmos[ide]
print @n.xbgr.xm41_u14.nsg13_hv_pmos[ige]
print @n.xbgr.xm41_u14.nsg13_hv_pmos[ise]
print @n.xbgr.xm41_u14.nsg13_hv_pmos[ibe]
print @n.xbgr.xm41_u14.nsg13_hv_pmos[ctype]
print @n.xbgr.xm41_u15.nsg13_hv_pmos[ide]
print @n.xbgr.xm41_u15.nsg13_hv_pmos[ige]
print @n.xbgr.xm41_u15.nsg13_hv_pmos[ise]
print @n.xbgr.xm41_u15.nsg13_hv_pmos[ibe]
print @n.xbgr.xm41_u15.nsg13_hv_pmos[ctype]
print @n.xbgr.xm41_u16.nsg13_hv_pmos[ide]
print @n.xbgr.xm41_u16.nsg13_hv_pmos[ige]
print @n.xbgr.xm41_u16.nsg13_hv_pmos[ise]
print @n.xbgr.xm41_u16.nsg13_hv_pmos[ibe]
print @n.xbgr.xm41_u16.nsg13_hv_pmos[ctype]
print @n.xbgr.xm41_u17.nsg13_hv_pmos[ide]
print @n.xbgr.xm41_u17.nsg13_hv_pmos[ige]
print @n.xbgr.xm41_u17.nsg13_hv_pmos[ise]
print @n.xbgr.xm41_u17.nsg13_hv_pmos[ibe]
print @n.xbgr.xm41_u17.nsg13_hv_pmos[ctype]
print @n.xbgr.xm41_u18.nsg13_hv_pmos[ide]
print @n.xbgr.xm41_u18.nsg13_hv_pmos[ige]
print @n.xbgr.xm41_u18.nsg13_hv_pmos[ise]
print @n.xbgr.xm41_u18.nsg13_hv_pmos[ibe]
print @n.xbgr.xm41_u18.nsg13_hv_pmos[ctype]
print @n.xbgr.xm41_u19.nsg13_hv_pmos[ide]
print @n.xbgr.xm41_u19.nsg13_hv_pmos[ige]
print @n.xbgr.xm41_u19.nsg13_hv_pmos[ise]
print @n.xbgr.xm41_u19.nsg13_hv_pmos[ibe]
print @n.xbgr.xm41_u19.nsg13_hv_pmos[ctype]
print @n.xbgr.xm41_u20.nsg13_hv_pmos[ide]
print @n.xbgr.xm41_u20.nsg13_hv_pmos[ige]
print @n.xbgr.xm41_u20.nsg13_hv_pmos[ise]
print @n.xbgr.xm41_u20.nsg13_hv_pmos[ibe]
print @n.xbgr.xm41_u20.nsg13_hv_pmos[ctype]
print @n.xbgr.xm41_u21.nsg13_hv_pmos[ide]
print @n.xbgr.xm41_u21.nsg13_hv_pmos[ige]
print @n.xbgr.xm41_u21.nsg13_hv_pmos[ise]
print @n.xbgr.xm41_u21.nsg13_hv_pmos[ibe]
print @n.xbgr.xm41_u21.nsg13_hv_pmos[ctype]
print @n.xbgr.xm41_u22.nsg13_hv_pmos[ide]
print @n.xbgr.xm41_u22.nsg13_hv_pmos[ige]
print @n.xbgr.xm41_u22.nsg13_hv_pmos[ise]
print @n.xbgr.xm41_u22.nsg13_hv_pmos[ibe]
print @n.xbgr.xm41_u22.nsg13_hv_pmos[ctype]
print @n.xbgr.xm41_u23.nsg13_hv_pmos[ide]
print @n.xbgr.xm41_u23.nsg13_hv_pmos[ige]
print @n.xbgr.xm41_u23.nsg13_hv_pmos[ise]
print @n.xbgr.xm41_u23.nsg13_hv_pmos[ibe]
print @n.xbgr.xm41_u23.nsg13_hv_pmos[ctype]
print @n.xbgr.xm41_u24.nsg13_hv_pmos[ide]
print @n.xbgr.xm41_u24.nsg13_hv_pmos[ige]
print @n.xbgr.xm41_u24.nsg13_hv_pmos[ise]
print @n.xbgr.xm41_u24.nsg13_hv_pmos[ibe]
print @n.xbgr.xm41_u24.nsg13_hv_pmos[ctype]
print @n.xbgr.xm43_u2.nsg13_hv_pmos[ide]
print @n.xbgr.xm43_u2.nsg13_hv_pmos[ige]
print @n.xbgr.xm43_u2.nsg13_hv_pmos[ise]
print @n.xbgr.xm43_u2.nsg13_hv_pmos[ibe]
print @n.xbgr.xm43_u2.nsg13_hv_pmos[ctype]
print @n.xbgr.xm43_u3.nsg13_hv_pmos[ide]
print @n.xbgr.xm43_u3.nsg13_hv_pmos[ige]
print @n.xbgr.xm43_u3.nsg13_hv_pmos[ise]
print @n.xbgr.xm43_u3.nsg13_hv_pmos[ibe]
print @n.xbgr.xm43_u3.nsg13_hv_pmos[ctype]
print @n.xbgr.xm43_u4.nsg13_hv_pmos[ide]
print @n.xbgr.xm43_u4.nsg13_hv_pmos[ige]
print @n.xbgr.xm43_u4.nsg13_hv_pmos[ise]
print @n.xbgr.xm43_u4.nsg13_hv_pmos[ibe]
print @n.xbgr.xm43_u4.nsg13_hv_pmos[ctype]
print @n.xbgr.xm44_u2.nsg13_hv_pmos[ide]
print @n.xbgr.xm44_u2.nsg13_hv_pmos[ige]
print @n.xbgr.xm44_u2.nsg13_hv_pmos[ise]
print @n.xbgr.xm44_u2.nsg13_hv_pmos[ibe]
print @n.xbgr.xm44_u2.nsg13_hv_pmos[ctype]
print @n.xbgr.xm44_u3.nsg13_hv_pmos[ide]
print @n.xbgr.xm44_u3.nsg13_hv_pmos[ige]
print @n.xbgr.xm44_u3.nsg13_hv_pmos[ise]
print @n.xbgr.xm44_u3.nsg13_hv_pmos[ibe]
print @n.xbgr.xm44_u3.nsg13_hv_pmos[ctype]
print @n.xbgr.xm44_u4.nsg13_hv_pmos[ide]
print @n.xbgr.xm44_u4.nsg13_hv_pmos[ige]
print @n.xbgr.xm44_u4.nsg13_hv_pmos[ise]
print @n.xbgr.xm44_u4.nsg13_hv_pmos[ibe]
print @n.xbgr.xm44_u4.nsg13_hv_pmos[ctype]
print @n.xbgr.xm45_u2.nsg13_hv_pmos[ide]
print @n.xbgr.xm45_u2.nsg13_hv_pmos[ige]
print @n.xbgr.xm45_u2.nsg13_hv_pmos[ise]
print @n.xbgr.xm45_u2.nsg13_hv_pmos[ibe]
print @n.xbgr.xm45_u2.nsg13_hv_pmos[ctype]
print @n.xbgr.xm45_u3.nsg13_hv_pmos[ide]
print @n.xbgr.xm45_u3.nsg13_hv_pmos[ige]
print @n.xbgr.xm45_u3.nsg13_hv_pmos[ise]
print @n.xbgr.xm45_u3.nsg13_hv_pmos[ibe]
print @n.xbgr.xm45_u3.nsg13_hv_pmos[ctype]
print @n.xbgr.xm45_u4.nsg13_hv_pmos[ide]
print @n.xbgr.xm45_u4.nsg13_hv_pmos[ige]
print @n.xbgr.xm45_u4.nsg13_hv_pmos[ise]
print @n.xbgr.xm45_u4.nsg13_hv_pmos[ibe]
print @n.xbgr.xm45_u4.nsg13_hv_pmos[ctype]
print @n.xbgr.xm45_u5.nsg13_hv_pmos[ide]
print @n.xbgr.xm45_u5.nsg13_hv_pmos[ige]
print @n.xbgr.xm45_u5.nsg13_hv_pmos[ise]
print @n.xbgr.xm45_u5.nsg13_hv_pmos[ibe]
print @n.xbgr.xm45_u5.nsg13_hv_pmos[ctype]
print @n.xbgr.xm45_u6.nsg13_hv_pmos[ide]
print @n.xbgr.xm45_u6.nsg13_hv_pmos[ige]
print @n.xbgr.xm45_u6.nsg13_hv_pmos[ise]
print @n.xbgr.xm45_u6.nsg13_hv_pmos[ibe]
print @n.xbgr.xm45_u6.nsg13_hv_pmos[ctype]
print @n.xbgr.xm45_u7.nsg13_hv_pmos[ide]
print @n.xbgr.xm45_u7.nsg13_hv_pmos[ige]
print @n.xbgr.xm45_u7.nsg13_hv_pmos[ise]
print @n.xbgr.xm45_u7.nsg13_hv_pmos[ibe]
print @n.xbgr.xm45_u7.nsg13_hv_pmos[ctype]
print @n.xbgr.xm45_u8.nsg13_hv_pmos[ide]
print @n.xbgr.xm45_u8.nsg13_hv_pmos[ige]
print @n.xbgr.xm45_u8.nsg13_hv_pmos[ise]
print @n.xbgr.xm45_u8.nsg13_hv_pmos[ibe]
print @n.xbgr.xm45_u8.nsg13_hv_pmos[ctype]
print @n.xbgr.xm45_u9.nsg13_hv_pmos[ide]
print @n.xbgr.xm45_u9.nsg13_hv_pmos[ige]
print @n.xbgr.xm45_u9.nsg13_hv_pmos[ise]
print @n.xbgr.xm45_u9.nsg13_hv_pmos[ibe]
print @n.xbgr.xm45_u9.nsg13_hv_pmos[ctype]
print @n.xbgr.xm45_u10.nsg13_hv_pmos[ide]
print @n.xbgr.xm45_u10.nsg13_hv_pmos[ige]
print @n.xbgr.xm45_u10.nsg13_hv_pmos[ise]
print @n.xbgr.xm45_u10.nsg13_hv_pmos[ibe]
print @n.xbgr.xm45_u10.nsg13_hv_pmos[ctype]
print @n.xbgr.xm45_u11.nsg13_hv_pmos[ide]
print @n.xbgr.xm45_u11.nsg13_hv_pmos[ige]
print @n.xbgr.xm45_u11.nsg13_hv_pmos[ise]
print @n.xbgr.xm45_u11.nsg13_hv_pmos[ibe]
print @n.xbgr.xm45_u11.nsg13_hv_pmos[ctype]
print @n.xbgr.xm45_u12.nsg13_hv_pmos[ide]
print @n.xbgr.xm45_u12.nsg13_hv_pmos[ige]
print @n.xbgr.xm45_u12.nsg13_hv_pmos[ise]
print @n.xbgr.xm45_u12.nsg13_hv_pmos[ibe]
print @n.xbgr.xm45_u12.nsg13_hv_pmos[ctype]
print @n.xbgr.xm45_u13.nsg13_hv_pmos[ide]
print @n.xbgr.xm45_u13.nsg13_hv_pmos[ige]
print @n.xbgr.xm45_u13.nsg13_hv_pmos[ise]
print @n.xbgr.xm45_u13.nsg13_hv_pmos[ibe]
print @n.xbgr.xm45_u13.nsg13_hv_pmos[ctype]
print @n.xbgr.xm45_u14.nsg13_hv_pmos[ide]
print @n.xbgr.xm45_u14.nsg13_hv_pmos[ige]
print @n.xbgr.xm45_u14.nsg13_hv_pmos[ise]
print @n.xbgr.xm45_u14.nsg13_hv_pmos[ibe]
print @n.xbgr.xm45_u14.nsg13_hv_pmos[ctype]
print @n.xbgr.xm45_u15.nsg13_hv_pmos[ide]
print @n.xbgr.xm45_u15.nsg13_hv_pmos[ige]
print @n.xbgr.xm45_u15.nsg13_hv_pmos[ise]
print @n.xbgr.xm45_u15.nsg13_hv_pmos[ibe]
print @n.xbgr.xm45_u15.nsg13_hv_pmos[ctype]
print @n.xbgr.xm45_u16.nsg13_hv_pmos[ide]
print @n.xbgr.xm45_u16.nsg13_hv_pmos[ige]
print @n.xbgr.xm45_u16.nsg13_hv_pmos[ise]
print @n.xbgr.xm45_u16.nsg13_hv_pmos[ibe]
print @n.xbgr.xm45_u16.nsg13_hv_pmos[ctype]
print @n.xbgr.xm45_u17.nsg13_hv_pmos[ide]
print @n.xbgr.xm45_u17.nsg13_hv_pmos[ige]
print @n.xbgr.xm45_u17.nsg13_hv_pmos[ise]
print @n.xbgr.xm45_u17.nsg13_hv_pmos[ibe]
print @n.xbgr.xm45_u17.nsg13_hv_pmos[ctype]
print @n.xbgr.xm45_u18.nsg13_hv_pmos[ide]
print @n.xbgr.xm45_u18.nsg13_hv_pmos[ige]
print @n.xbgr.xm45_u18.nsg13_hv_pmos[ise]
print @n.xbgr.xm45_u18.nsg13_hv_pmos[ibe]
print @n.xbgr.xm45_u18.nsg13_hv_pmos[ctype]
print @n.xbgr.xm45_u19.nsg13_hv_pmos[ide]
print @n.xbgr.xm45_u19.nsg13_hv_pmos[ige]
print @n.xbgr.xm45_u19.nsg13_hv_pmos[ise]
print @n.xbgr.xm45_u19.nsg13_hv_pmos[ibe]
print @n.xbgr.xm45_u19.nsg13_hv_pmos[ctype]
print @n.xbgr.xm45_u20.nsg13_hv_pmos[ide]
print @n.xbgr.xm45_u20.nsg13_hv_pmos[ige]
print @n.xbgr.xm45_u20.nsg13_hv_pmos[ise]
print @n.xbgr.xm45_u20.nsg13_hv_pmos[ibe]
print @n.xbgr.xm45_u20.nsg13_hv_pmos[ctype]
print @n.xbgr.xm45_u21.nsg13_hv_pmos[ide]
print @n.xbgr.xm45_u21.nsg13_hv_pmos[ige]
print @n.xbgr.xm45_u21.nsg13_hv_pmos[ise]
print @n.xbgr.xm45_u21.nsg13_hv_pmos[ibe]
print @n.xbgr.xm45_u21.nsg13_hv_pmos[ctype]
print @n.xbgr.xm45_u22.nsg13_hv_pmos[ide]
print @n.xbgr.xm45_u22.nsg13_hv_pmos[ige]
print @n.xbgr.xm45_u22.nsg13_hv_pmos[ise]
print @n.xbgr.xm45_u22.nsg13_hv_pmos[ibe]
print @n.xbgr.xm45_u22.nsg13_hv_pmos[ctype]
print @n.xbgr.xm45_u23.nsg13_hv_pmos[ide]
print @n.xbgr.xm45_u23.nsg13_hv_pmos[ige]
print @n.xbgr.xm45_u23.nsg13_hv_pmos[ise]
print @n.xbgr.xm45_u23.nsg13_hv_pmos[ibe]
print @n.xbgr.xm45_u23.nsg13_hv_pmos[ctype]
print @n.xbgr.xm45_u24.nsg13_hv_pmos[ide]
print @n.xbgr.xm45_u24.nsg13_hv_pmos[ige]
print @n.xbgr.xm45_u24.nsg13_hv_pmos[ise]
print @n.xbgr.xm45_u24.nsg13_hv_pmos[ibe]
print @n.xbgr.xm45_u24.nsg13_hv_pmos[ctype]
print @n.xbgr.xm47_u2.nsg13_hv_pmos[ide]
print @n.xbgr.xm47_u2.nsg13_hv_pmos[ige]
print @n.xbgr.xm47_u2.nsg13_hv_pmos[ise]
print @n.xbgr.xm47_u2.nsg13_hv_pmos[ibe]
print @n.xbgr.xm47_u2.nsg13_hv_pmos[ctype]
print @n.xbgr.xm47_u3.nsg13_hv_pmos[ide]
print @n.xbgr.xm47_u3.nsg13_hv_pmos[ige]
print @n.xbgr.xm47_u3.nsg13_hv_pmos[ise]
print @n.xbgr.xm47_u3.nsg13_hv_pmos[ibe]
print @n.xbgr.xm47_u3.nsg13_hv_pmos[ctype]
print @n.xbgr.xm47_u4.nsg13_hv_pmos[ide]
print @n.xbgr.xm47_u4.nsg13_hv_pmos[ige]
print @n.xbgr.xm47_u4.nsg13_hv_pmos[ise]
print @n.xbgr.xm47_u4.nsg13_hv_pmos[ibe]
print @n.xbgr.xm47_u4.nsg13_hv_pmos[ctype]
print @n.xbgr.xm47_u5.nsg13_hv_pmos[ide]
print @n.xbgr.xm47_u5.nsg13_hv_pmos[ige]
print @n.xbgr.xm47_u5.nsg13_hv_pmos[ise]
print @n.xbgr.xm47_u5.nsg13_hv_pmos[ibe]
print @n.xbgr.xm47_u5.nsg13_hv_pmos[ctype]
print @n.xbgr.xm47_u6.nsg13_hv_pmos[ide]
print @n.xbgr.xm47_u6.nsg13_hv_pmos[ige]
print @n.xbgr.xm47_u6.nsg13_hv_pmos[ise]
print @n.xbgr.xm47_u6.nsg13_hv_pmos[ibe]
print @n.xbgr.xm47_u6.nsg13_hv_pmos[ctype]
print @n.xbgr.xm47_u7.nsg13_hv_pmos[ide]
print @n.xbgr.xm47_u7.nsg13_hv_pmos[ige]
print @n.xbgr.xm47_u7.nsg13_hv_pmos[ise]
print @n.xbgr.xm47_u7.nsg13_hv_pmos[ibe]
print @n.xbgr.xm47_u7.nsg13_hv_pmos[ctype]
print @n.xbgr.xm47_u8.nsg13_hv_pmos[ide]
print @n.xbgr.xm47_u8.nsg13_hv_pmos[ige]
print @n.xbgr.xm47_u8.nsg13_hv_pmos[ise]
print @n.xbgr.xm47_u8.nsg13_hv_pmos[ibe]
print @n.xbgr.xm47_u8.nsg13_hv_pmos[ctype]
print @n.xbgr.xm47_u9.nsg13_hv_pmos[ide]
print @n.xbgr.xm47_u9.nsg13_hv_pmos[ige]
print @n.xbgr.xm47_u9.nsg13_hv_pmos[ise]
print @n.xbgr.xm47_u9.nsg13_hv_pmos[ibe]
print @n.xbgr.xm47_u9.nsg13_hv_pmos[ctype]
print @n.xbgr.xm47_u10.nsg13_hv_pmos[ide]
print @n.xbgr.xm47_u10.nsg13_hv_pmos[ige]
print @n.xbgr.xm47_u10.nsg13_hv_pmos[ise]
print @n.xbgr.xm47_u10.nsg13_hv_pmos[ibe]
print @n.xbgr.xm47_u10.nsg13_hv_pmos[ctype]
print @n.xbgr.xm47_u11.nsg13_hv_pmos[ide]
print @n.xbgr.xm47_u11.nsg13_hv_pmos[ige]
print @n.xbgr.xm47_u11.nsg13_hv_pmos[ise]
print @n.xbgr.xm47_u11.nsg13_hv_pmos[ibe]
print @n.xbgr.xm47_u11.nsg13_hv_pmos[ctype]
print @n.xbgr.xm47_u12.nsg13_hv_pmos[ide]
print @n.xbgr.xm47_u12.nsg13_hv_pmos[ige]
print @n.xbgr.xm47_u12.nsg13_hv_pmos[ise]
print @n.xbgr.xm47_u12.nsg13_hv_pmos[ibe]
print @n.xbgr.xm47_u12.nsg13_hv_pmos[ctype]
print @n.xbgr.xm47_u13.nsg13_hv_pmos[ide]
print @n.xbgr.xm47_u13.nsg13_hv_pmos[ige]
print @n.xbgr.xm47_u13.nsg13_hv_pmos[ise]
print @n.xbgr.xm47_u13.nsg13_hv_pmos[ibe]
print @n.xbgr.xm47_u13.nsg13_hv_pmos[ctype]
print @n.xbgr.xm47_u14.nsg13_hv_pmos[ide]
print @n.xbgr.xm47_u14.nsg13_hv_pmos[ige]
print @n.xbgr.xm47_u14.nsg13_hv_pmos[ise]
print @n.xbgr.xm47_u14.nsg13_hv_pmos[ibe]
print @n.xbgr.xm47_u14.nsg13_hv_pmos[ctype]
print @n.xbgr.xm47_u15.nsg13_hv_pmos[ide]
print @n.xbgr.xm47_u15.nsg13_hv_pmos[ige]
print @n.xbgr.xm47_u15.nsg13_hv_pmos[ise]
print @n.xbgr.xm47_u15.nsg13_hv_pmos[ibe]
print @n.xbgr.xm47_u15.nsg13_hv_pmos[ctype]
print @n.xbgr.xm47_u16.nsg13_hv_pmos[ide]
print @n.xbgr.xm47_u16.nsg13_hv_pmos[ige]
print @n.xbgr.xm47_u16.nsg13_hv_pmos[ise]
print @n.xbgr.xm47_u16.nsg13_hv_pmos[ibe]
print @n.xbgr.xm47_u16.nsg13_hv_pmos[ctype]
print @n.xbgr.xm47_u17.nsg13_hv_pmos[ide]
print @n.xbgr.xm47_u17.nsg13_hv_pmos[ige]
print @n.xbgr.xm47_u17.nsg13_hv_pmos[ise]
print @n.xbgr.xm47_u17.nsg13_hv_pmos[ibe]
print @n.xbgr.xm47_u17.nsg13_hv_pmos[ctype]
print @n.xbgr.xm47_u18.nsg13_hv_pmos[ide]
print @n.xbgr.xm47_u18.nsg13_hv_pmos[ige]
print @n.xbgr.xm47_u18.nsg13_hv_pmos[ise]
print @n.xbgr.xm47_u18.nsg13_hv_pmos[ibe]
print @n.xbgr.xm47_u18.nsg13_hv_pmos[ctype]
print @n.xbgr.xm47_u19.nsg13_hv_pmos[ide]
print @n.xbgr.xm47_u19.nsg13_hv_pmos[ige]
print @n.xbgr.xm47_u19.nsg13_hv_pmos[ise]
print @n.xbgr.xm47_u19.nsg13_hv_pmos[ibe]
print @n.xbgr.xm47_u19.nsg13_hv_pmos[ctype]
print @n.xbgr.xm47_u20.nsg13_hv_pmos[ide]
print @n.xbgr.xm47_u20.nsg13_hv_pmos[ige]
print @n.xbgr.xm47_u20.nsg13_hv_pmos[ise]
print @n.xbgr.xm47_u20.nsg13_hv_pmos[ibe]
print @n.xbgr.xm47_u20.nsg13_hv_pmos[ctype]
print @n.xbgr.xm47_u21.nsg13_hv_pmos[ide]
print @n.xbgr.xm47_u21.nsg13_hv_pmos[ige]
print @n.xbgr.xm47_u21.nsg13_hv_pmos[ise]
print @n.xbgr.xm47_u21.nsg13_hv_pmos[ibe]
print @n.xbgr.xm47_u21.nsg13_hv_pmos[ctype]
print @n.xbgr.xm47_u22.nsg13_hv_pmos[ide]
print @n.xbgr.xm47_u22.nsg13_hv_pmos[ige]
print @n.xbgr.xm47_u22.nsg13_hv_pmos[ise]
print @n.xbgr.xm47_u22.nsg13_hv_pmos[ibe]
print @n.xbgr.xm47_u22.nsg13_hv_pmos[ctype]
print @n.xbgr.xm47_u23.nsg13_hv_pmos[ide]
print @n.xbgr.xm47_u23.nsg13_hv_pmos[ige]
print @n.xbgr.xm47_u23.nsg13_hv_pmos[ise]
print @n.xbgr.xm47_u23.nsg13_hv_pmos[ibe]
print @n.xbgr.xm47_u23.nsg13_hv_pmos[ctype]
print @n.xbgr.xm47_u24.nsg13_hv_pmos[ide]
print @n.xbgr.xm47_u24.nsg13_hv_pmos[ige]
print @n.xbgr.xm47_u24.nsg13_hv_pmos[ise]
print @n.xbgr.xm47_u24.nsg13_hv_pmos[ibe]
print @n.xbgr.xm47_u24.nsg13_hv_pmos[ctype]
print @n.xbgr.xm48_u2.nsg13_hv_pmos[ide]
print @n.xbgr.xm48_u2.nsg13_hv_pmos[ige]
print @n.xbgr.xm48_u2.nsg13_hv_pmos[ise]
print @n.xbgr.xm48_u2.nsg13_hv_pmos[ibe]
print @n.xbgr.xm48_u2.nsg13_hv_pmos[ctype]
print @n.xbgr.xm48_u3.nsg13_hv_pmos[ide]
print @n.xbgr.xm48_u3.nsg13_hv_pmos[ige]
print @n.xbgr.xm48_u3.nsg13_hv_pmos[ise]
print @n.xbgr.xm48_u3.nsg13_hv_pmos[ibe]
print @n.xbgr.xm48_u3.nsg13_hv_pmos[ctype]
print @n.xbgr.xm48_u4.nsg13_hv_pmos[ide]
print @n.xbgr.xm48_u4.nsg13_hv_pmos[ige]
print @n.xbgr.xm48_u4.nsg13_hv_pmos[ise]
print @n.xbgr.xm48_u4.nsg13_hv_pmos[ibe]
print @n.xbgr.xm48_u4.nsg13_hv_pmos[ctype]
print @n.xbgr.xm48_u5.nsg13_hv_pmos[ide]
print @n.xbgr.xm48_u5.nsg13_hv_pmos[ige]
print @n.xbgr.xm48_u5.nsg13_hv_pmos[ise]
print @n.xbgr.xm48_u5.nsg13_hv_pmos[ibe]
print @n.xbgr.xm48_u5.nsg13_hv_pmos[ctype]
print @n.xbgr.xm48_u6.nsg13_hv_pmos[ide]
print @n.xbgr.xm48_u6.nsg13_hv_pmos[ige]
print @n.xbgr.xm48_u6.nsg13_hv_pmos[ise]
print @n.xbgr.xm48_u6.nsg13_hv_pmos[ibe]
print @n.xbgr.xm48_u6.nsg13_hv_pmos[ctype]
print @n.xbgr.xm48_u7.nsg13_hv_pmos[ide]
print @n.xbgr.xm48_u7.nsg13_hv_pmos[ige]
print @n.xbgr.xm48_u7.nsg13_hv_pmos[ise]
print @n.xbgr.xm48_u7.nsg13_hv_pmos[ibe]
print @n.xbgr.xm48_u7.nsg13_hv_pmos[ctype]
print @n.xbgr.xm48_u8.nsg13_hv_pmos[ide]
print @n.xbgr.xm48_u8.nsg13_hv_pmos[ige]
print @n.xbgr.xm48_u8.nsg13_hv_pmos[ise]
print @n.xbgr.xm48_u8.nsg13_hv_pmos[ibe]
print @n.xbgr.xm48_u8.nsg13_hv_pmos[ctype]
print @n.xbgr.xm48_u9.nsg13_hv_pmos[ide]
print @n.xbgr.xm48_u9.nsg13_hv_pmos[ige]
print @n.xbgr.xm48_u9.nsg13_hv_pmos[ise]
print @n.xbgr.xm48_u9.nsg13_hv_pmos[ibe]
print @n.xbgr.xm48_u9.nsg13_hv_pmos[ctype]
print @n.xbgr.xm48_u10.nsg13_hv_pmos[ide]
print @n.xbgr.xm48_u10.nsg13_hv_pmos[ige]
print @n.xbgr.xm48_u10.nsg13_hv_pmos[ise]
print @n.xbgr.xm48_u10.nsg13_hv_pmos[ibe]
print @n.xbgr.xm48_u10.nsg13_hv_pmos[ctype]
print @n.xbgr.xm48_u11.nsg13_hv_pmos[ide]
print @n.xbgr.xm48_u11.nsg13_hv_pmos[ige]
print @n.xbgr.xm48_u11.nsg13_hv_pmos[ise]
print @n.xbgr.xm48_u11.nsg13_hv_pmos[ibe]
print @n.xbgr.xm48_u11.nsg13_hv_pmos[ctype]
print @n.xbgr.xm48_u12.nsg13_hv_pmos[ide]
print @n.xbgr.xm48_u12.nsg13_hv_pmos[ige]
print @n.xbgr.xm48_u12.nsg13_hv_pmos[ise]
print @n.xbgr.xm48_u12.nsg13_hv_pmos[ibe]
print @n.xbgr.xm48_u12.nsg13_hv_pmos[ctype]
print @n.xbgr.xm48_u13.nsg13_hv_pmos[ide]
print @n.xbgr.xm48_u13.nsg13_hv_pmos[ige]
print @n.xbgr.xm48_u13.nsg13_hv_pmos[ise]
print @n.xbgr.xm48_u13.nsg13_hv_pmos[ibe]
print @n.xbgr.xm48_u13.nsg13_hv_pmos[ctype]
print @n.xbgr.xm48_u14.nsg13_hv_pmos[ide]
print @n.xbgr.xm48_u14.nsg13_hv_pmos[ige]
print @n.xbgr.xm48_u14.nsg13_hv_pmos[ise]
print @n.xbgr.xm48_u14.nsg13_hv_pmos[ibe]
print @n.xbgr.xm48_u14.nsg13_hv_pmos[ctype]
print @n.xbgr.xm48_u15.nsg13_hv_pmos[ide]
print @n.xbgr.xm48_u15.nsg13_hv_pmos[ige]
print @n.xbgr.xm48_u15.nsg13_hv_pmos[ise]
print @n.xbgr.xm48_u15.nsg13_hv_pmos[ibe]
print @n.xbgr.xm48_u15.nsg13_hv_pmos[ctype]
print @n.xbgr.xm48_u16.nsg13_hv_pmos[ide]
print @n.xbgr.xm48_u16.nsg13_hv_pmos[ige]
print @n.xbgr.xm48_u16.nsg13_hv_pmos[ise]
print @n.xbgr.xm48_u16.nsg13_hv_pmos[ibe]
print @n.xbgr.xm48_u16.nsg13_hv_pmos[ctype]
print @n.xbgr.xm48_u17.nsg13_hv_pmos[ide]
print @n.xbgr.xm48_u17.nsg13_hv_pmos[ige]
print @n.xbgr.xm48_u17.nsg13_hv_pmos[ise]
print @n.xbgr.xm48_u17.nsg13_hv_pmos[ibe]
print @n.xbgr.xm48_u17.nsg13_hv_pmos[ctype]
print @n.xbgr.xm48_u18.nsg13_hv_pmos[ide]
print @n.xbgr.xm48_u18.nsg13_hv_pmos[ige]
print @n.xbgr.xm48_u18.nsg13_hv_pmos[ise]
print @n.xbgr.xm48_u18.nsg13_hv_pmos[ibe]
print @n.xbgr.xm48_u18.nsg13_hv_pmos[ctype]
print @n.xbgr.xm48_u19.nsg13_hv_pmos[ide]
print @n.xbgr.xm48_u19.nsg13_hv_pmos[ige]
print @n.xbgr.xm48_u19.nsg13_hv_pmos[ise]
print @n.xbgr.xm48_u19.nsg13_hv_pmos[ibe]
print @n.xbgr.xm48_u19.nsg13_hv_pmos[ctype]
print @n.xbgr.xm48_u20.nsg13_hv_pmos[ide]
print @n.xbgr.xm48_u20.nsg13_hv_pmos[ige]
print @n.xbgr.xm48_u20.nsg13_hv_pmos[ise]
print @n.xbgr.xm48_u20.nsg13_hv_pmos[ibe]
print @n.xbgr.xm48_u20.nsg13_hv_pmos[ctype]
print @n.xbgr.xm48_u21.nsg13_hv_pmos[ide]
print @n.xbgr.xm48_u21.nsg13_hv_pmos[ige]
print @n.xbgr.xm48_u21.nsg13_hv_pmos[ise]
print @n.xbgr.xm48_u21.nsg13_hv_pmos[ibe]
print @n.xbgr.xm48_u21.nsg13_hv_pmos[ctype]
print @n.xbgr.xm48_u22.nsg13_hv_pmos[ide]
print @n.xbgr.xm48_u22.nsg13_hv_pmos[ige]
print @n.xbgr.xm48_u22.nsg13_hv_pmos[ise]
print @n.xbgr.xm48_u22.nsg13_hv_pmos[ibe]
print @n.xbgr.xm48_u22.nsg13_hv_pmos[ctype]
print @n.xbgr.xm48_u23.nsg13_hv_pmos[ide]
print @n.xbgr.xm48_u23.nsg13_hv_pmos[ige]
print @n.xbgr.xm48_u23.nsg13_hv_pmos[ise]
print @n.xbgr.xm48_u23.nsg13_hv_pmos[ibe]
print @n.xbgr.xm48_u23.nsg13_hv_pmos[ctype]
print @n.xbgr.xm48_u24.nsg13_hv_pmos[ide]
print @n.xbgr.xm48_u24.nsg13_hv_pmos[ige]
print @n.xbgr.xm48_u24.nsg13_hv_pmos[ise]
print @n.xbgr.xm48_u24.nsg13_hv_pmos[ibe]
print @n.xbgr.xm48_u24.nsg13_hv_pmos[ctype]
print @n.xbgr.xm50_u2.nsg13_hv_pmos[ide]
print @n.xbgr.xm50_u2.nsg13_hv_pmos[ige]
print @n.xbgr.xm50_u2.nsg13_hv_pmos[ise]
print @n.xbgr.xm50_u2.nsg13_hv_pmos[ibe]
print @n.xbgr.xm50_u2.nsg13_hv_pmos[ctype]
print @n.xbgr.xm50_u3.nsg13_hv_pmos[ide]
print @n.xbgr.xm50_u3.nsg13_hv_pmos[ige]
print @n.xbgr.xm50_u3.nsg13_hv_pmos[ise]
print @n.xbgr.xm50_u3.nsg13_hv_pmos[ibe]
print @n.xbgr.xm50_u3.nsg13_hv_pmos[ctype]
print @n.xbgr.xm50_u4.nsg13_hv_pmos[ide]
print @n.xbgr.xm50_u4.nsg13_hv_pmos[ige]
print @n.xbgr.xm50_u4.nsg13_hv_pmos[ise]
print @n.xbgr.xm50_u4.nsg13_hv_pmos[ibe]
print @n.xbgr.xm50_u4.nsg13_hv_pmos[ctype]
print @n.xbgr.xm50_u5.nsg13_hv_pmos[ide]
print @n.xbgr.xm50_u5.nsg13_hv_pmos[ige]
print @n.xbgr.xm50_u5.nsg13_hv_pmos[ise]
print @n.xbgr.xm50_u5.nsg13_hv_pmos[ibe]
print @n.xbgr.xm50_u5.nsg13_hv_pmos[ctype]
print @n.xbgr.xm50_u6.nsg13_hv_pmos[ide]
print @n.xbgr.xm50_u6.nsg13_hv_pmos[ige]
print @n.xbgr.xm50_u6.nsg13_hv_pmos[ise]
print @n.xbgr.xm50_u6.nsg13_hv_pmos[ibe]
print @n.xbgr.xm50_u6.nsg13_hv_pmos[ctype]
print @n.xbgr.xm50_u7.nsg13_hv_pmos[ide]
print @n.xbgr.xm50_u7.nsg13_hv_pmos[ige]
print @n.xbgr.xm50_u7.nsg13_hv_pmos[ise]
print @n.xbgr.xm50_u7.nsg13_hv_pmos[ibe]
print @n.xbgr.xm50_u7.nsg13_hv_pmos[ctype]
print @n.xbgr.xm50_u8.nsg13_hv_pmos[ide]
print @n.xbgr.xm50_u8.nsg13_hv_pmos[ige]
print @n.xbgr.xm50_u8.nsg13_hv_pmos[ise]
print @n.xbgr.xm50_u8.nsg13_hv_pmos[ibe]
print @n.xbgr.xm50_u8.nsg13_hv_pmos[ctype]
print @n.xbgr.xm50_u9.nsg13_hv_pmos[ide]
print @n.xbgr.xm50_u9.nsg13_hv_pmos[ige]
print @n.xbgr.xm50_u9.nsg13_hv_pmos[ise]
print @n.xbgr.xm50_u9.nsg13_hv_pmos[ibe]
print @n.xbgr.xm50_u9.nsg13_hv_pmos[ctype]
print @n.xbgr.xm50_u10.nsg13_hv_pmos[ide]
print @n.xbgr.xm50_u10.nsg13_hv_pmos[ige]
print @n.xbgr.xm50_u10.nsg13_hv_pmos[ise]
print @n.xbgr.xm50_u10.nsg13_hv_pmos[ibe]
print @n.xbgr.xm50_u10.nsg13_hv_pmos[ctype]
print @n.xbgr.xm50_u11.nsg13_hv_pmos[ide]
print @n.xbgr.xm50_u11.nsg13_hv_pmos[ige]
print @n.xbgr.xm50_u11.nsg13_hv_pmos[ise]
print @n.xbgr.xm50_u11.nsg13_hv_pmos[ibe]
print @n.xbgr.xm50_u11.nsg13_hv_pmos[ctype]
print @n.xbgr.xm50_u12.nsg13_hv_pmos[ide]
print @n.xbgr.xm50_u12.nsg13_hv_pmos[ige]
print @n.xbgr.xm50_u12.nsg13_hv_pmos[ise]
print @n.xbgr.xm50_u12.nsg13_hv_pmos[ibe]
print @n.xbgr.xm50_u12.nsg13_hv_pmos[ctype]
print @n.xbgr.xm50_u13.nsg13_hv_pmos[ide]
print @n.xbgr.xm50_u13.nsg13_hv_pmos[ige]
print @n.xbgr.xm50_u13.nsg13_hv_pmos[ise]
print @n.xbgr.xm50_u13.nsg13_hv_pmos[ibe]
print @n.xbgr.xm50_u13.nsg13_hv_pmos[ctype]
print @n.xbgr.xm50_u14.nsg13_hv_pmos[ide]
print @n.xbgr.xm50_u14.nsg13_hv_pmos[ige]
print @n.xbgr.xm50_u14.nsg13_hv_pmos[ise]
print @n.xbgr.xm50_u14.nsg13_hv_pmos[ibe]
print @n.xbgr.xm50_u14.nsg13_hv_pmos[ctype]
print @n.xbgr.xm50_u15.nsg13_hv_pmos[ide]
print @n.xbgr.xm50_u15.nsg13_hv_pmos[ige]
print @n.xbgr.xm50_u15.nsg13_hv_pmos[ise]
print @n.xbgr.xm50_u15.nsg13_hv_pmos[ibe]
print @n.xbgr.xm50_u15.nsg13_hv_pmos[ctype]
print @n.xbgr.xm50_u16.nsg13_hv_pmos[ide]
print @n.xbgr.xm50_u16.nsg13_hv_pmos[ige]
print @n.xbgr.xm50_u16.nsg13_hv_pmos[ise]
print @n.xbgr.xm50_u16.nsg13_hv_pmos[ibe]
print @n.xbgr.xm50_u16.nsg13_hv_pmos[ctype]
print @n.xbgr.xm50_u17.nsg13_hv_pmos[ide]
print @n.xbgr.xm50_u17.nsg13_hv_pmos[ige]
print @n.xbgr.xm50_u17.nsg13_hv_pmos[ise]
print @n.xbgr.xm50_u17.nsg13_hv_pmos[ibe]
print @n.xbgr.xm50_u17.nsg13_hv_pmos[ctype]
print @n.xbgr.xm50_u18.nsg13_hv_pmos[ide]
print @n.xbgr.xm50_u18.nsg13_hv_pmos[ige]
print @n.xbgr.xm50_u18.nsg13_hv_pmos[ise]
print @n.xbgr.xm50_u18.nsg13_hv_pmos[ibe]
print @n.xbgr.xm50_u18.nsg13_hv_pmos[ctype]
print @n.xbgr.xm50_u19.nsg13_hv_pmos[ide]
print @n.xbgr.xm50_u19.nsg13_hv_pmos[ige]
print @n.xbgr.xm50_u19.nsg13_hv_pmos[ise]
print @n.xbgr.xm50_u19.nsg13_hv_pmos[ibe]
print @n.xbgr.xm50_u19.nsg13_hv_pmos[ctype]
print @n.xbgr.xm50_u20.nsg13_hv_pmos[ide]
print @n.xbgr.xm50_u20.nsg13_hv_pmos[ige]
print @n.xbgr.xm50_u20.nsg13_hv_pmos[ise]
print @n.xbgr.xm50_u20.nsg13_hv_pmos[ibe]
print @n.xbgr.xm50_u20.nsg13_hv_pmos[ctype]
print @n.xbgr.xm50_u21.nsg13_hv_pmos[ide]
print @n.xbgr.xm50_u21.nsg13_hv_pmos[ige]
print @n.xbgr.xm50_u21.nsg13_hv_pmos[ise]
print @n.xbgr.xm50_u21.nsg13_hv_pmos[ibe]
print @n.xbgr.xm50_u21.nsg13_hv_pmos[ctype]
print @n.xbgr.xm50_u22.nsg13_hv_pmos[ide]
print @n.xbgr.xm50_u22.nsg13_hv_pmos[ige]
print @n.xbgr.xm50_u22.nsg13_hv_pmos[ise]
print @n.xbgr.xm50_u22.nsg13_hv_pmos[ibe]
print @n.xbgr.xm50_u22.nsg13_hv_pmos[ctype]
print @n.xbgr.xm50_u23.nsg13_hv_pmos[ide]
print @n.xbgr.xm50_u23.nsg13_hv_pmos[ige]
print @n.xbgr.xm50_u23.nsg13_hv_pmos[ise]
print @n.xbgr.xm50_u23.nsg13_hv_pmos[ibe]
print @n.xbgr.xm50_u23.nsg13_hv_pmos[ctype]
print @n.xbgr.xm50_u24.nsg13_hv_pmos[ide]
print @n.xbgr.xm50_u24.nsg13_hv_pmos[ige]
print @n.xbgr.xm50_u24.nsg13_hv_pmos[ise]
print @n.xbgr.xm50_u24.nsg13_hv_pmos[ibe]
print @n.xbgr.xm50_u24.nsg13_hv_pmos[ctype]
print @n.xbgr.xm51_u2.nsg13_hv_pmos[ide]
print @n.xbgr.xm51_u2.nsg13_hv_pmos[ige]
print @n.xbgr.xm51_u2.nsg13_hv_pmos[ise]
print @n.xbgr.xm51_u2.nsg13_hv_pmos[ibe]
print @n.xbgr.xm51_u2.nsg13_hv_pmos[ctype]
print @n.xbgr.xm51_u3.nsg13_hv_pmos[ide]
print @n.xbgr.xm51_u3.nsg13_hv_pmos[ige]
print @n.xbgr.xm51_u3.nsg13_hv_pmos[ise]
print @n.xbgr.xm51_u3.nsg13_hv_pmos[ibe]
print @n.xbgr.xm51_u3.nsg13_hv_pmos[ctype]
print @n.xbgr.xm51_u4.nsg13_hv_pmos[ide]
print @n.xbgr.xm51_u4.nsg13_hv_pmos[ige]
print @n.xbgr.xm51_u4.nsg13_hv_pmos[ise]
print @n.xbgr.xm51_u4.nsg13_hv_pmos[ibe]
print @n.xbgr.xm51_u4.nsg13_hv_pmos[ctype]
print @n.xbgr.xm52_u2.nsg13_hv_pmos[ide]
print @n.xbgr.xm52_u2.nsg13_hv_pmos[ige]
print @n.xbgr.xm52_u2.nsg13_hv_pmos[ise]
print @n.xbgr.xm52_u2.nsg13_hv_pmos[ibe]
print @n.xbgr.xm52_u2.nsg13_hv_pmos[ctype]
print @n.xbgr.xm52_u3.nsg13_hv_pmos[ide]
print @n.xbgr.xm52_u3.nsg13_hv_pmos[ige]
print @n.xbgr.xm52_u3.nsg13_hv_pmos[ise]
print @n.xbgr.xm52_u3.nsg13_hv_pmos[ibe]
print @n.xbgr.xm52_u3.nsg13_hv_pmos[ctype]
print @n.xbgr.xm52_u4.nsg13_hv_pmos[ide]
print @n.xbgr.xm52_u4.nsg13_hv_pmos[ige]
print @n.xbgr.xm52_u4.nsg13_hv_pmos[ise]
print @n.xbgr.xm52_u4.nsg13_hv_pmos[ibe]
print @n.xbgr.xm52_u4.nsg13_hv_pmos[ctype]
print @n.xbgr.xm52_u5.nsg13_hv_pmos[ide]
print @n.xbgr.xm52_u5.nsg13_hv_pmos[ige]
print @n.xbgr.xm52_u5.nsg13_hv_pmos[ise]
print @n.xbgr.xm52_u5.nsg13_hv_pmos[ibe]
print @n.xbgr.xm52_u5.nsg13_hv_pmos[ctype]
print @n.xbgr.xm52_u6.nsg13_hv_pmos[ide]
print @n.xbgr.xm52_u6.nsg13_hv_pmos[ige]
print @n.xbgr.xm52_u6.nsg13_hv_pmos[ise]
print @n.xbgr.xm52_u6.nsg13_hv_pmos[ibe]
print @n.xbgr.xm52_u6.nsg13_hv_pmos[ctype]
print @n.xbgr.xm52_u7.nsg13_hv_pmos[ide]
print @n.xbgr.xm52_u7.nsg13_hv_pmos[ige]
print @n.xbgr.xm52_u7.nsg13_hv_pmos[ise]
print @n.xbgr.xm52_u7.nsg13_hv_pmos[ibe]
print @n.xbgr.xm52_u7.nsg13_hv_pmos[ctype]
print @n.xbgr.xm52_u8.nsg13_hv_pmos[ide]
print @n.xbgr.xm52_u8.nsg13_hv_pmos[ige]
print @n.xbgr.xm52_u8.nsg13_hv_pmos[ise]
print @n.xbgr.xm52_u8.nsg13_hv_pmos[ibe]
print @n.xbgr.xm52_u8.nsg13_hv_pmos[ctype]
print @n.xbgr.xm52_u9.nsg13_hv_pmos[ide]
print @n.xbgr.xm52_u9.nsg13_hv_pmos[ige]
print @n.xbgr.xm52_u9.nsg13_hv_pmos[ise]
print @n.xbgr.xm52_u9.nsg13_hv_pmos[ibe]
print @n.xbgr.xm52_u9.nsg13_hv_pmos[ctype]
print @n.xbgr.xm52_u10.nsg13_hv_pmos[ide]
print @n.xbgr.xm52_u10.nsg13_hv_pmos[ige]
print @n.xbgr.xm52_u10.nsg13_hv_pmos[ise]
print @n.xbgr.xm52_u10.nsg13_hv_pmos[ibe]
print @n.xbgr.xm52_u10.nsg13_hv_pmos[ctype]
print @n.xbgr.xm52_u11.nsg13_hv_pmos[ide]
print @n.xbgr.xm52_u11.nsg13_hv_pmos[ige]
print @n.xbgr.xm52_u11.nsg13_hv_pmos[ise]
print @n.xbgr.xm52_u11.nsg13_hv_pmos[ibe]
print @n.xbgr.xm52_u11.nsg13_hv_pmos[ctype]
print @n.xbgr.xm52_u12.nsg13_hv_pmos[ide]
print @n.xbgr.xm52_u12.nsg13_hv_pmos[ige]
print @n.xbgr.xm52_u12.nsg13_hv_pmos[ise]
print @n.xbgr.xm52_u12.nsg13_hv_pmos[ibe]
print @n.xbgr.xm52_u12.nsg13_hv_pmos[ctype]
print @n.xbgr.xm52_u13.nsg13_hv_pmos[ide]
print @n.xbgr.xm52_u13.nsg13_hv_pmos[ige]
print @n.xbgr.xm52_u13.nsg13_hv_pmos[ise]
print @n.xbgr.xm52_u13.nsg13_hv_pmos[ibe]
print @n.xbgr.xm52_u13.nsg13_hv_pmos[ctype]
print @n.xbgr.xm52_u14.nsg13_hv_pmos[ide]
print @n.xbgr.xm52_u14.nsg13_hv_pmos[ige]
print @n.xbgr.xm52_u14.nsg13_hv_pmos[ise]
print @n.xbgr.xm52_u14.nsg13_hv_pmos[ibe]
print @n.xbgr.xm52_u14.nsg13_hv_pmos[ctype]
print @n.xbgr.xm52_u15.nsg13_hv_pmos[ide]
print @n.xbgr.xm52_u15.nsg13_hv_pmos[ige]
print @n.xbgr.xm52_u15.nsg13_hv_pmos[ise]
print @n.xbgr.xm52_u15.nsg13_hv_pmos[ibe]
print @n.xbgr.xm52_u15.nsg13_hv_pmos[ctype]
print @n.xbgr.xm52_u16.nsg13_hv_pmos[ide]
print @n.xbgr.xm52_u16.nsg13_hv_pmos[ige]
print @n.xbgr.xm52_u16.nsg13_hv_pmos[ise]
print @n.xbgr.xm52_u16.nsg13_hv_pmos[ibe]
print @n.xbgr.xm52_u16.nsg13_hv_pmos[ctype]
print @n.xbgr.xm52_u17.nsg13_hv_pmos[ide]
print @n.xbgr.xm52_u17.nsg13_hv_pmos[ige]
print @n.xbgr.xm52_u17.nsg13_hv_pmos[ise]
print @n.xbgr.xm52_u17.nsg13_hv_pmos[ibe]
print @n.xbgr.xm52_u17.nsg13_hv_pmos[ctype]
print @n.xbgr.xm52_u18.nsg13_hv_pmos[ide]
print @n.xbgr.xm52_u18.nsg13_hv_pmos[ige]
print @n.xbgr.xm52_u18.nsg13_hv_pmos[ise]
print @n.xbgr.xm52_u18.nsg13_hv_pmos[ibe]
print @n.xbgr.xm52_u18.nsg13_hv_pmos[ctype]
print @n.xbgr.xm52_u19.nsg13_hv_pmos[ide]
print @n.xbgr.xm52_u19.nsg13_hv_pmos[ige]
print @n.xbgr.xm52_u19.nsg13_hv_pmos[ise]
print @n.xbgr.xm52_u19.nsg13_hv_pmos[ibe]
print @n.xbgr.xm52_u19.nsg13_hv_pmos[ctype]
print @n.xbgr.xm52_u20.nsg13_hv_pmos[ide]
print @n.xbgr.xm52_u20.nsg13_hv_pmos[ige]
print @n.xbgr.xm52_u20.nsg13_hv_pmos[ise]
print @n.xbgr.xm52_u20.nsg13_hv_pmos[ibe]
print @n.xbgr.xm52_u20.nsg13_hv_pmos[ctype]
print @n.xbgr.xm52_u21.nsg13_hv_pmos[ide]
print @n.xbgr.xm52_u21.nsg13_hv_pmos[ige]
print @n.xbgr.xm52_u21.nsg13_hv_pmos[ise]
print @n.xbgr.xm52_u21.nsg13_hv_pmos[ibe]
print @n.xbgr.xm52_u21.nsg13_hv_pmos[ctype]
print @n.xbgr.xm52_u22.nsg13_hv_pmos[ide]
print @n.xbgr.xm52_u22.nsg13_hv_pmos[ige]
print @n.xbgr.xm52_u22.nsg13_hv_pmos[ise]
print @n.xbgr.xm52_u22.nsg13_hv_pmos[ibe]
print @n.xbgr.xm52_u22.nsg13_hv_pmos[ctype]
print @n.xbgr.xm52_u23.nsg13_hv_pmos[ide]
print @n.xbgr.xm52_u23.nsg13_hv_pmos[ige]
print @n.xbgr.xm52_u23.nsg13_hv_pmos[ise]
print @n.xbgr.xm52_u23.nsg13_hv_pmos[ibe]
print @n.xbgr.xm52_u23.nsg13_hv_pmos[ctype]
print @n.xbgr.xm52_u24.nsg13_hv_pmos[ide]
print @n.xbgr.xm52_u24.nsg13_hv_pmos[ige]
print @n.xbgr.xm52_u24.nsg13_hv_pmos[ise]
print @n.xbgr.xm52_u24.nsg13_hv_pmos[ibe]
print @n.xbgr.xm52_u24.nsg13_hv_pmos[ctype]
print @n.xbgr.xm54_u2.nsg13_hv_pmos[ide]
print @n.xbgr.xm54_u2.nsg13_hv_pmos[ige]
print @n.xbgr.xm54_u2.nsg13_hv_pmos[ise]
print @n.xbgr.xm54_u2.nsg13_hv_pmos[ibe]
print @n.xbgr.xm54_u2.nsg13_hv_pmos[ctype]
print @n.xbgr.xm54_u3.nsg13_hv_pmos[ide]
print @n.xbgr.xm54_u3.nsg13_hv_pmos[ige]
print @n.xbgr.xm54_u3.nsg13_hv_pmos[ise]
print @n.xbgr.xm54_u3.nsg13_hv_pmos[ibe]
print @n.xbgr.xm54_u3.nsg13_hv_pmos[ctype]
print @n.xbgr.xm54_u4.nsg13_hv_pmos[ide]
print @n.xbgr.xm54_u4.nsg13_hv_pmos[ige]
print @n.xbgr.xm54_u4.nsg13_hv_pmos[ise]
print @n.xbgr.xm54_u4.nsg13_hv_pmos[ibe]
print @n.xbgr.xm54_u4.nsg13_hv_pmos[ctype]
print @n.xbgr.xm54_u5.nsg13_hv_pmos[ide]
print @n.xbgr.xm54_u5.nsg13_hv_pmos[ige]
print @n.xbgr.xm54_u5.nsg13_hv_pmos[ise]
print @n.xbgr.xm54_u5.nsg13_hv_pmos[ibe]
print @n.xbgr.xm54_u5.nsg13_hv_pmos[ctype]
print @n.xbgr.xm54_u6.nsg13_hv_pmos[ide]
print @n.xbgr.xm54_u6.nsg13_hv_pmos[ige]
print @n.xbgr.xm54_u6.nsg13_hv_pmos[ise]
print @n.xbgr.xm54_u6.nsg13_hv_pmos[ibe]
print @n.xbgr.xm54_u6.nsg13_hv_pmos[ctype]
print @n.xbgr.xm54_u7.nsg13_hv_pmos[ide]
print @n.xbgr.xm54_u7.nsg13_hv_pmos[ige]
print @n.xbgr.xm54_u7.nsg13_hv_pmos[ise]
print @n.xbgr.xm54_u7.nsg13_hv_pmos[ibe]
print @n.xbgr.xm54_u7.nsg13_hv_pmos[ctype]
print @n.xbgr.xm54_u8.nsg13_hv_pmos[ide]
print @n.xbgr.xm54_u8.nsg13_hv_pmos[ige]
print @n.xbgr.xm54_u8.nsg13_hv_pmos[ise]
print @n.xbgr.xm54_u8.nsg13_hv_pmos[ibe]
print @n.xbgr.xm54_u8.nsg13_hv_pmos[ctype]
print @n.xbgr.xm54_u9.nsg13_hv_pmos[ide]
print @n.xbgr.xm54_u9.nsg13_hv_pmos[ige]
print @n.xbgr.xm54_u9.nsg13_hv_pmos[ise]
print @n.xbgr.xm54_u9.nsg13_hv_pmos[ibe]
print @n.xbgr.xm54_u9.nsg13_hv_pmos[ctype]
print @n.xbgr.xm54_u10.nsg13_hv_pmos[ide]
print @n.xbgr.xm54_u10.nsg13_hv_pmos[ige]
print @n.xbgr.xm54_u10.nsg13_hv_pmos[ise]
print @n.xbgr.xm54_u10.nsg13_hv_pmos[ibe]
print @n.xbgr.xm54_u10.nsg13_hv_pmos[ctype]
print @n.xbgr.xm54_u11.nsg13_hv_pmos[ide]
print @n.xbgr.xm54_u11.nsg13_hv_pmos[ige]
print @n.xbgr.xm54_u11.nsg13_hv_pmos[ise]
print @n.xbgr.xm54_u11.nsg13_hv_pmos[ibe]
print @n.xbgr.xm54_u11.nsg13_hv_pmos[ctype]
print @n.xbgr.xm54_u12.nsg13_hv_pmos[ide]
print @n.xbgr.xm54_u12.nsg13_hv_pmos[ige]
print @n.xbgr.xm54_u12.nsg13_hv_pmos[ise]
print @n.xbgr.xm54_u12.nsg13_hv_pmos[ibe]
print @n.xbgr.xm54_u12.nsg13_hv_pmos[ctype]
print @n.xbgr.xm54_u13.nsg13_hv_pmos[ide]
print @n.xbgr.xm54_u13.nsg13_hv_pmos[ige]
print @n.xbgr.xm54_u13.nsg13_hv_pmos[ise]
print @n.xbgr.xm54_u13.nsg13_hv_pmos[ibe]
print @n.xbgr.xm54_u13.nsg13_hv_pmos[ctype]
print @n.xbgr.xm54_u14.nsg13_hv_pmos[ide]
print @n.xbgr.xm54_u14.nsg13_hv_pmos[ige]
print @n.xbgr.xm54_u14.nsg13_hv_pmos[ise]
print @n.xbgr.xm54_u14.nsg13_hv_pmos[ibe]
print @n.xbgr.xm54_u14.nsg13_hv_pmos[ctype]
print @n.xbgr.xm54_u15.nsg13_hv_pmos[ide]
print @n.xbgr.xm54_u15.nsg13_hv_pmos[ige]
print @n.xbgr.xm54_u15.nsg13_hv_pmos[ise]
print @n.xbgr.xm54_u15.nsg13_hv_pmos[ibe]
print @n.xbgr.xm54_u15.nsg13_hv_pmos[ctype]
print @n.xbgr.xm54_u16.nsg13_hv_pmos[ide]
print @n.xbgr.xm54_u16.nsg13_hv_pmos[ige]
print @n.xbgr.xm54_u16.nsg13_hv_pmos[ise]
print @n.xbgr.xm54_u16.nsg13_hv_pmos[ibe]
print @n.xbgr.xm54_u16.nsg13_hv_pmos[ctype]
print @n.xbgr.xm54_u17.nsg13_hv_pmos[ide]
print @n.xbgr.xm54_u17.nsg13_hv_pmos[ige]
print @n.xbgr.xm54_u17.nsg13_hv_pmos[ise]
print @n.xbgr.xm54_u17.nsg13_hv_pmos[ibe]
print @n.xbgr.xm54_u17.nsg13_hv_pmos[ctype]
print @n.xbgr.xm54_u18.nsg13_hv_pmos[ide]
print @n.xbgr.xm54_u18.nsg13_hv_pmos[ige]
print @n.xbgr.xm54_u18.nsg13_hv_pmos[ise]
print @n.xbgr.xm54_u18.nsg13_hv_pmos[ibe]
print @n.xbgr.xm54_u18.nsg13_hv_pmos[ctype]
print @n.xbgr.xm54_u19.nsg13_hv_pmos[ide]
print @n.xbgr.xm54_u19.nsg13_hv_pmos[ige]
print @n.xbgr.xm54_u19.nsg13_hv_pmos[ise]
print @n.xbgr.xm54_u19.nsg13_hv_pmos[ibe]
print @n.xbgr.xm54_u19.nsg13_hv_pmos[ctype]
print @n.xbgr.xm54_u20.nsg13_hv_pmos[ide]
print @n.xbgr.xm54_u20.nsg13_hv_pmos[ige]
print @n.xbgr.xm54_u20.nsg13_hv_pmos[ise]
print @n.xbgr.xm54_u20.nsg13_hv_pmos[ibe]
print @n.xbgr.xm54_u20.nsg13_hv_pmos[ctype]
print @n.xbgr.xm54_u21.nsg13_hv_pmos[ide]
print @n.xbgr.xm54_u21.nsg13_hv_pmos[ige]
print @n.xbgr.xm54_u21.nsg13_hv_pmos[ise]
print @n.xbgr.xm54_u21.nsg13_hv_pmos[ibe]
print @n.xbgr.xm54_u21.nsg13_hv_pmos[ctype]
print @n.xbgr.xm54_u22.nsg13_hv_pmos[ide]
print @n.xbgr.xm54_u22.nsg13_hv_pmos[ige]
print @n.xbgr.xm54_u22.nsg13_hv_pmos[ise]
print @n.xbgr.xm54_u22.nsg13_hv_pmos[ibe]
print @n.xbgr.xm54_u22.nsg13_hv_pmos[ctype]
print @n.xbgr.xm54_u23.nsg13_hv_pmos[ide]
print @n.xbgr.xm54_u23.nsg13_hv_pmos[ige]
print @n.xbgr.xm54_u23.nsg13_hv_pmos[ise]
print @n.xbgr.xm54_u23.nsg13_hv_pmos[ibe]
print @n.xbgr.xm54_u23.nsg13_hv_pmos[ctype]
print @n.xbgr.xm54_u24.nsg13_hv_pmos[ide]
print @n.xbgr.xm54_u24.nsg13_hv_pmos[ige]
print @n.xbgr.xm54_u24.nsg13_hv_pmos[ise]
print @n.xbgr.xm54_u24.nsg13_hv_pmos[ibe]
print @n.xbgr.xm54_u24.nsg13_hv_pmos[ctype]
print @q.xbgr.xq56_u2.qnpn13g2[ic]
print @q.xbgr.xq56_u2.qnpn13g2[ib]
print @q.xbgr.xq56_u2.qnpn13g2[ie]
print @q.xbgr.xq56_u2.qnpn13g2[is]
print @r.xbgr.xq56_u2.rsub[i]
print @c.xbgr.xq56_u2.csub[i]
print @q.xbgr.xq56_u3.qnpn13g2[ic]
print @q.xbgr.xq56_u3.qnpn13g2[ib]
print @q.xbgr.xq56_u3.qnpn13g2[ie]
print @q.xbgr.xq56_u3.qnpn13g2[is]
print @r.xbgr.xq56_u3.rsub[i]
print @c.xbgr.xq56_u3.csub[i]
print @q.xbgr.xq56_u4.qnpn13g2[ic]
print @q.xbgr.xq56_u4.qnpn13g2[ib]
print @q.xbgr.xq56_u4.qnpn13g2[ie]
print @q.xbgr.xq56_u4.qnpn13g2[is]
print @r.xbgr.xq56_u4.rsub[i]
print @c.xbgr.xq56_u4.csub[i]
print @q.xbgr.xq56_u5.qnpn13g2[ic]
print @q.xbgr.xq56_u5.qnpn13g2[ib]
print @q.xbgr.xq56_u5.qnpn13g2[ie]
print @q.xbgr.xq56_u5.qnpn13g2[is]
print @r.xbgr.xq56_u5.rsub[i]
print @c.xbgr.xq56_u5.csub[i]
print @q.xbgr.xq56_u6.qnpn13g2[ic]
print @q.xbgr.xq56_u6.qnpn13g2[ib]
print @q.xbgr.xq56_u6.qnpn13g2[ie]
print @q.xbgr.xq56_u6.qnpn13g2[is]
print @r.xbgr.xq56_u6.rsub[i]
print @c.xbgr.xq56_u6.csub[i]
print @q.xbgr.xq56_u7.qnpn13g2[ic]
print @q.xbgr.xq56_u7.qnpn13g2[ib]
print @q.xbgr.xq56_u7.qnpn13g2[ie]
print @q.xbgr.xq56_u7.qnpn13g2[is]
print @r.xbgr.xq56_u7.rsub[i]
print @c.xbgr.xq56_u7.csub[i]
print @q.xbgr.xq56_u8.qnpn13g2[ic]
print @q.xbgr.xq56_u8.qnpn13g2[ib]
print @q.xbgr.xq56_u8.qnpn13g2[ie]
print @q.xbgr.xq56_u8.qnpn13g2[is]
print @r.xbgr.xq56_u8.rsub[i]
print @c.xbgr.xq56_u8.csub[i]
print @q.xbgr.xq56_u9.qnpn13g2[ic]
print @q.xbgr.xq56_u9.qnpn13g2[ib]
print @q.xbgr.xq56_u9.qnpn13g2[ie]
print @q.xbgr.xq56_u9.qnpn13g2[is]
print @r.xbgr.xq56_u9.rsub[i]
print @c.xbgr.xq56_u9.csub[i]
print @q.xbgr.xq56_u10.qnpn13g2[ic]
print @q.xbgr.xq56_u10.qnpn13g2[ib]
print @q.xbgr.xq56_u10.qnpn13g2[ie]
print @q.xbgr.xq56_u10.qnpn13g2[is]
print @r.xbgr.xq56_u10.rsub[i]
print @c.xbgr.xq56_u10.csub[i]
print @q.xbgr.xq56_u11.qnpn13g2[ic]
print @q.xbgr.xq56_u11.qnpn13g2[ib]
print @q.xbgr.xq56_u11.qnpn13g2[ie]
print @q.xbgr.xq56_u11.qnpn13g2[is]
print @r.xbgr.xq56_u11.rsub[i]
print @c.xbgr.xq56_u11.csub[i]
print @q.xbgr.xq56_u12.qnpn13g2[ic]
print @q.xbgr.xq56_u12.qnpn13g2[ib]
print @q.xbgr.xq56_u12.qnpn13g2[ie]
print @q.xbgr.xq56_u12.qnpn13g2[is]
print @r.xbgr.xq56_u12.rsub[i]
print @c.xbgr.xq56_u12.csub[i]
print @q.xbgr.xq56_u13.qnpn13g2[ic]
print @q.xbgr.xq56_u13.qnpn13g2[ib]
print @q.xbgr.xq56_u13.qnpn13g2[ie]
print @q.xbgr.xq56_u13.qnpn13g2[is]
print @r.xbgr.xq56_u13.rsub[i]
print @c.xbgr.xq56_u13.csub[i]
print @q.xbgr.xq56_u14.qnpn13g2[ic]
print @q.xbgr.xq56_u14.qnpn13g2[ib]
print @q.xbgr.xq56_u14.qnpn13g2[ie]
print @q.xbgr.xq56_u14.qnpn13g2[is]
print @r.xbgr.xq56_u14.rsub[i]
print @c.xbgr.xq56_u14.csub[i]
print @q.xbgr.xq56_u15.qnpn13g2[ic]
print @q.xbgr.xq56_u15.qnpn13g2[ib]
print @q.xbgr.xq56_u15.qnpn13g2[ie]
print @q.xbgr.xq56_u15.qnpn13g2[is]
print @r.xbgr.xq56_u15.rsub[i]
print @c.xbgr.xq56_u15.csub[i]
print @q.xbgr.xq56_u16.qnpn13g2[ic]
print @q.xbgr.xq56_u16.qnpn13g2[ib]
print @q.xbgr.xq56_u16.qnpn13g2[ie]
print @q.xbgr.xq56_u16.qnpn13g2[is]
print @r.xbgr.xq56_u16.rsub[i]
print @c.xbgr.xq56_u16.csub[i]
print @q.xbgr.xq56_u17.qnpn13g2[ic]
print @q.xbgr.xq56_u17.qnpn13g2[ib]
print @q.xbgr.xq56_u17.qnpn13g2[ie]
print @q.xbgr.xq56_u17.qnpn13g2[is]
print @r.xbgr.xq56_u17.rsub[i]
print @c.xbgr.xq56_u17.csub[i]
print @q.xbgr.xq56_u18.qnpn13g2[ic]
print @q.xbgr.xq56_u18.qnpn13g2[ib]
print @q.xbgr.xq56_u18.qnpn13g2[ie]
print @q.xbgr.xq56_u18.qnpn13g2[is]
print @r.xbgr.xq56_u18.rsub[i]
print @c.xbgr.xq56_u18.csub[i]
print @q.xbgr.xq56_u19.qnpn13g2[ic]
print @q.xbgr.xq56_u19.qnpn13g2[ib]
print @q.xbgr.xq56_u19.qnpn13g2[ie]
print @q.xbgr.xq56_u19.qnpn13g2[is]
print @r.xbgr.xq56_u19.rsub[i]
print @c.xbgr.xq56_u19.csub[i]
print @q.xbgr.xq56_u20.qnpn13g2[ic]
print @q.xbgr.xq56_u20.qnpn13g2[ib]
print @q.xbgr.xq56_u20.qnpn13g2[ie]
print @q.xbgr.xq56_u20.qnpn13g2[is]
print @r.xbgr.xq56_u20.rsub[i]
print @c.xbgr.xq56_u20.csub[i]
print @q.xbgr.xq56_u21.qnpn13g2[ic]
print @q.xbgr.xq56_u21.qnpn13g2[ib]
print @q.xbgr.xq56_u21.qnpn13g2[ie]
print @q.xbgr.xq56_u21.qnpn13g2[is]
print @r.xbgr.xq56_u21.rsub[i]
print @c.xbgr.xq56_u21.csub[i]
print @q.xbgr.xq56_u22.qnpn13g2[ic]
print @q.xbgr.xq56_u22.qnpn13g2[ib]
print @q.xbgr.xq56_u22.qnpn13g2[ie]
print @q.xbgr.xq56_u22.qnpn13g2[is]
print @r.xbgr.xq56_u22.rsub[i]
print @c.xbgr.xq56_u22.csub[i]
print @q.xbgr.xq56_u23.qnpn13g2[ic]
print @q.xbgr.xq56_u23.qnpn13g2[ib]
print @q.xbgr.xq56_u23.qnpn13g2[ie]
print @q.xbgr.xq56_u23.qnpn13g2[is]
print @r.xbgr.xq56_u23.rsub[i]
print @c.xbgr.xq56_u23.csub[i]
print @q.xbgr.xq56_u24.qnpn13g2[ic]
print @q.xbgr.xq56_u24.qnpn13g2[ib]
print @q.xbgr.xq56_u24.qnpn13g2[ie]
print @q.xbgr.xq56_u24.qnpn13g2[is]
print @r.xbgr.xq56_u24.rsub[i]
print @c.xbgr.xq56_u24.csub[i]
print @q.xbgr.xq60_u2.qnpn13g2[ic]
print @q.xbgr.xq60_u2.qnpn13g2[ib]
print @q.xbgr.xq60_u2.qnpn13g2[ie]
print @q.xbgr.xq60_u2.qnpn13g2[is]
print @r.xbgr.xq60_u2.rsub[i]
print @c.xbgr.xq60_u2.csub[i]
print @q.xbgr.xq60_u3.qnpn13g2[ic]
print @q.xbgr.xq60_u3.qnpn13g2[ib]
print @q.xbgr.xq60_u3.qnpn13g2[ie]
print @q.xbgr.xq60_u3.qnpn13g2[is]
print @r.xbgr.xq60_u3.rsub[i]
print @c.xbgr.xq60_u3.csub[i]
print @q.xbgr.xq60_u4.qnpn13g2[ic]
print @q.xbgr.xq60_u4.qnpn13g2[ib]
print @q.xbgr.xq60_u4.qnpn13g2[ie]
print @q.xbgr.xq60_u4.qnpn13g2[is]
print @r.xbgr.xq60_u4.rsub[i]
print @c.xbgr.xq60_u4.csub[i]
print @q.xbgr.xq62_u2.qnpn13g2[ic]
print @q.xbgr.xq62_u2.qnpn13g2[ib]
print @q.xbgr.xq62_u2.qnpn13g2[ie]
print @q.xbgr.xq62_u2.qnpn13g2[is]
print @r.xbgr.xq62_u2.rsub[i]
print @c.xbgr.xq62_u2.csub[i]
print @q.xbgr.xq62_u3.qnpn13g2[ic]
print @q.xbgr.xq62_u3.qnpn13g2[ib]
print @q.xbgr.xq62_u3.qnpn13g2[ie]
print @q.xbgr.xq62_u3.qnpn13g2[is]
print @r.xbgr.xq62_u3.rsub[i]
print @c.xbgr.xq62_u3.csub[i]
print @q.xbgr.xq62_u4.qnpn13g2[ic]
print @q.xbgr.xq62_u4.qnpn13g2[ib]
print @q.xbgr.xq62_u4.qnpn13g2[ie]
print @q.xbgr.xq62_u4.qnpn13g2[is]
print @r.xbgr.xq62_u4.rsub[i]
print @c.xbgr.xq62_u4.csub[i]
print @q.xbgr.xq62_u5.qnpn13g2[ic]
print @q.xbgr.xq62_u5.qnpn13g2[ib]
print @q.xbgr.xq62_u5.qnpn13g2[ie]
print @q.xbgr.xq62_u5.qnpn13g2[is]
print @r.xbgr.xq62_u5.rsub[i]
print @c.xbgr.xq62_u5.csub[i]
print @q.xbgr.xq62_u6.qnpn13g2[ic]
print @q.xbgr.xq62_u6.qnpn13g2[ib]
print @q.xbgr.xq62_u6.qnpn13g2[ie]
print @q.xbgr.xq62_u6.qnpn13g2[is]
print @r.xbgr.xq62_u6.rsub[i]
print @c.xbgr.xq62_u6.csub[i]
print @q.xbgr.xq62_u7.qnpn13g2[ic]
print @q.xbgr.xq62_u7.qnpn13g2[ib]
print @q.xbgr.xq62_u7.qnpn13g2[ie]
print @q.xbgr.xq62_u7.qnpn13g2[is]
print @r.xbgr.xq62_u7.rsub[i]
print @c.xbgr.xq62_u7.csub[i]
print @q.xbgr.xq62_u8.qnpn13g2[ic]
print @q.xbgr.xq62_u8.qnpn13g2[ib]
print @q.xbgr.xq62_u8.qnpn13g2[ie]
print @q.xbgr.xq62_u8.qnpn13g2[is]
print @r.xbgr.xq62_u8.rsub[i]
print @c.xbgr.xq62_u8.csub[i]
print @q.xbgr.xq62_u9.qnpn13g2[ic]
print @q.xbgr.xq62_u9.qnpn13g2[ib]
print @q.xbgr.xq62_u9.qnpn13g2[ie]
print @q.xbgr.xq62_u9.qnpn13g2[is]
print @r.xbgr.xq62_u9.rsub[i]
print @c.xbgr.xq62_u9.csub[i]
print @q.xbgr.xq62_u10.qnpn13g2[ic]
print @q.xbgr.xq62_u10.qnpn13g2[ib]
print @q.xbgr.xq62_u10.qnpn13g2[ie]
print @q.xbgr.xq62_u10.qnpn13g2[is]
print @r.xbgr.xq62_u10.rsub[i]
print @c.xbgr.xq62_u10.csub[i]
print @q.xbgr.xq62_u11.qnpn13g2[ic]
print @q.xbgr.xq62_u11.qnpn13g2[ib]
print @q.xbgr.xq62_u11.qnpn13g2[ie]
print @q.xbgr.xq62_u11.qnpn13g2[is]
print @r.xbgr.xq62_u11.rsub[i]
print @c.xbgr.xq62_u11.csub[i]
print @q.xbgr.xq62_u12.qnpn13g2[ic]
print @q.xbgr.xq62_u12.qnpn13g2[ib]
print @q.xbgr.xq62_u12.qnpn13g2[ie]
print @q.xbgr.xq62_u12.qnpn13g2[is]
print @r.xbgr.xq62_u12.rsub[i]
print @c.xbgr.xq62_u12.csub[i]
print @q.xbgr.xq62_u13.qnpn13g2[ic]
print @q.xbgr.xq62_u13.qnpn13g2[ib]
print @q.xbgr.xq62_u13.qnpn13g2[ie]
print @q.xbgr.xq62_u13.qnpn13g2[is]
print @r.xbgr.xq62_u13.rsub[i]
print @c.xbgr.xq62_u13.csub[i]
print @q.xbgr.xq62_u14.qnpn13g2[ic]
print @q.xbgr.xq62_u14.qnpn13g2[ib]
print @q.xbgr.xq62_u14.qnpn13g2[ie]
print @q.xbgr.xq62_u14.qnpn13g2[is]
print @r.xbgr.xq62_u14.rsub[i]
print @c.xbgr.xq62_u14.csub[i]
print @q.xbgr.xq62_u15.qnpn13g2[ic]
print @q.xbgr.xq62_u15.qnpn13g2[ib]
print @q.xbgr.xq62_u15.qnpn13g2[ie]
print @q.xbgr.xq62_u15.qnpn13g2[is]
print @r.xbgr.xq62_u15.rsub[i]
print @c.xbgr.xq62_u15.csub[i]
print @q.xbgr.xq62_u16.qnpn13g2[ic]
print @q.xbgr.xq62_u16.qnpn13g2[ib]
print @q.xbgr.xq62_u16.qnpn13g2[ie]
print @q.xbgr.xq62_u16.qnpn13g2[is]
print @r.xbgr.xq62_u16.rsub[i]
print @c.xbgr.xq62_u16.csub[i]
print @q.xbgr.xq62_u17.qnpn13g2[ic]
print @q.xbgr.xq62_u17.qnpn13g2[ib]
print @q.xbgr.xq62_u17.qnpn13g2[ie]
print @q.xbgr.xq62_u17.qnpn13g2[is]
print @r.xbgr.xq62_u17.rsub[i]
print @c.xbgr.xq62_u17.csub[i]
print @q.xbgr.xq62_u18.qnpn13g2[ic]
print @q.xbgr.xq62_u18.qnpn13g2[ib]
print @q.xbgr.xq62_u18.qnpn13g2[ie]
print @q.xbgr.xq62_u18.qnpn13g2[is]
print @r.xbgr.xq62_u18.rsub[i]
print @c.xbgr.xq62_u18.csub[i]
print @q.xbgr.xq62_u19.qnpn13g2[ic]
print @q.xbgr.xq62_u19.qnpn13g2[ib]
print @q.xbgr.xq62_u19.qnpn13g2[ie]
print @q.xbgr.xq62_u19.qnpn13g2[is]
print @r.xbgr.xq62_u19.rsub[i]
print @c.xbgr.xq62_u19.csub[i]
print @q.xbgr.xq62_u20.qnpn13g2[ic]
print @q.xbgr.xq62_u20.qnpn13g2[ib]
print @q.xbgr.xq62_u20.qnpn13g2[ie]
print @q.xbgr.xq62_u20.qnpn13g2[is]
print @r.xbgr.xq62_u20.rsub[i]
print @c.xbgr.xq62_u20.csub[i]
print @q.xbgr.xq62_u21.qnpn13g2[ic]
print @q.xbgr.xq62_u21.qnpn13g2[ib]
print @q.xbgr.xq62_u21.qnpn13g2[ie]
print @q.xbgr.xq62_u21.qnpn13g2[is]
print @r.xbgr.xq62_u21.rsub[i]
print @c.xbgr.xq62_u21.csub[i]
print @q.xbgr.xq62_u22.qnpn13g2[ic]
print @q.xbgr.xq62_u22.qnpn13g2[ib]
print @q.xbgr.xq62_u22.qnpn13g2[ie]
print @q.xbgr.xq62_u22.qnpn13g2[is]
print @r.xbgr.xq62_u22.rsub[i]
print @c.xbgr.xq62_u22.csub[i]
print @q.xbgr.xq62_u23.qnpn13g2[ic]
print @q.xbgr.xq62_u23.qnpn13g2[ib]
print @q.xbgr.xq62_u23.qnpn13g2[ie]
print @q.xbgr.xq62_u23.qnpn13g2[is]
print @r.xbgr.xq62_u23.rsub[i]
print @c.xbgr.xq62_u23.csub[i]
print @q.xbgr.xq62_u24.qnpn13g2[ic]
print @q.xbgr.xq62_u24.qnpn13g2[ib]
print @q.xbgr.xq62_u24.qnpn13g2[ie]
print @q.xbgr.xq62_u24.qnpn13g2[is]
print @r.xbgr.xq62_u24.rsub[i]
print @c.xbgr.xq62_u24.csub[i]
print @q.xbgr.xq67_u2.qnpn13g2[ic]
print @q.xbgr.xq67_u2.qnpn13g2[ib]
print @q.xbgr.xq67_u2.qnpn13g2[ie]
print @q.xbgr.xq67_u2.qnpn13g2[is]
print @r.xbgr.xq67_u2.rsub[i]
print @c.xbgr.xq67_u2.csub[i]
print @q.xbgr.xq67_u3.qnpn13g2[ic]
print @q.xbgr.xq67_u3.qnpn13g2[ib]
print @q.xbgr.xq67_u3.qnpn13g2[ie]
print @q.xbgr.xq67_u3.qnpn13g2[is]
print @r.xbgr.xq67_u3.rsub[i]
print @c.xbgr.xq67_u3.csub[i]
print @q.xbgr.xq67_u4.qnpn13g2[ic]
print @q.xbgr.xq67_u4.qnpn13g2[ib]
print @q.xbgr.xq67_u4.qnpn13g2[ie]
print @q.xbgr.xq67_u4.qnpn13g2[is]
print @r.xbgr.xq67_u4.rsub[i]
print @c.xbgr.xq67_u4.csub[i]
print @q.xbgr.xq67_u5.qnpn13g2[ic]
print @q.xbgr.xq67_u5.qnpn13g2[ib]
print @q.xbgr.xq67_u5.qnpn13g2[ie]
print @q.xbgr.xq67_u5.qnpn13g2[is]
print @r.xbgr.xq67_u5.rsub[i]
print @c.xbgr.xq67_u5.csub[i]
print @q.xbgr.xq67_u6.qnpn13g2[ic]
print @q.xbgr.xq67_u6.qnpn13g2[ib]
print @q.xbgr.xq67_u6.qnpn13g2[ie]
print @q.xbgr.xq67_u6.qnpn13g2[is]
print @r.xbgr.xq67_u6.rsub[i]
print @c.xbgr.xq67_u6.csub[i]
print @q.xbgr.xq67_u7.qnpn13g2[ic]
print @q.xbgr.xq67_u7.qnpn13g2[ib]
print @q.xbgr.xq67_u7.qnpn13g2[ie]
print @q.xbgr.xq67_u7.qnpn13g2[is]
print @r.xbgr.xq67_u7.rsub[i]
print @c.xbgr.xq67_u7.csub[i]
print @q.xbgr.xq67_u8.qnpn13g2[ic]
print @q.xbgr.xq67_u8.qnpn13g2[ib]
print @q.xbgr.xq67_u8.qnpn13g2[ie]
print @q.xbgr.xq67_u8.qnpn13g2[is]
print @r.xbgr.xq67_u8.rsub[i]
print @c.xbgr.xq67_u8.csub[i]
print @q.xbgr.xq67_u9.qnpn13g2[ic]
print @q.xbgr.xq67_u9.qnpn13g2[ib]
print @q.xbgr.xq67_u9.qnpn13g2[ie]
print @q.xbgr.xq67_u9.qnpn13g2[is]
print @r.xbgr.xq67_u9.rsub[i]
print @c.xbgr.xq67_u9.csub[i]
print @q.xbgr.xq67_u10.qnpn13g2[ic]
print @q.xbgr.xq67_u10.qnpn13g2[ib]
print @q.xbgr.xq67_u10.qnpn13g2[ie]
print @q.xbgr.xq67_u10.qnpn13g2[is]
print @r.xbgr.xq67_u10.rsub[i]
print @c.xbgr.xq67_u10.csub[i]
print @q.xbgr.xq67_u11.qnpn13g2[ic]
print @q.xbgr.xq67_u11.qnpn13g2[ib]
print @q.xbgr.xq67_u11.qnpn13g2[ie]
print @q.xbgr.xq67_u11.qnpn13g2[is]
print @r.xbgr.xq67_u11.rsub[i]
print @c.xbgr.xq67_u11.csub[i]
print @q.xbgr.xq67_u12.qnpn13g2[ic]
print @q.xbgr.xq67_u12.qnpn13g2[ib]
print @q.xbgr.xq67_u12.qnpn13g2[ie]
print @q.xbgr.xq67_u12.qnpn13g2[is]
print @r.xbgr.xq67_u12.rsub[i]
print @c.xbgr.xq67_u12.csub[i]
print @q.xbgr.xq67_u13.qnpn13g2[ic]
print @q.xbgr.xq67_u13.qnpn13g2[ib]
print @q.xbgr.xq67_u13.qnpn13g2[ie]
print @q.xbgr.xq67_u13.qnpn13g2[is]
print @r.xbgr.xq67_u13.rsub[i]
print @c.xbgr.xq67_u13.csub[i]
print @q.xbgr.xq67_u14.qnpn13g2[ic]
print @q.xbgr.xq67_u14.qnpn13g2[ib]
print @q.xbgr.xq67_u14.qnpn13g2[ie]
print @q.xbgr.xq67_u14.qnpn13g2[is]
print @r.xbgr.xq67_u14.rsub[i]
print @c.xbgr.xq67_u14.csub[i]
print @q.xbgr.xq67_u15.qnpn13g2[ic]
print @q.xbgr.xq67_u15.qnpn13g2[ib]
print @q.xbgr.xq67_u15.qnpn13g2[ie]
print @q.xbgr.xq67_u15.qnpn13g2[is]
print @r.xbgr.xq67_u15.rsub[i]
print @c.xbgr.xq67_u15.csub[i]
print @q.xbgr.xq67_u16.qnpn13g2[ic]
print @q.xbgr.xq67_u16.qnpn13g2[ib]
print @q.xbgr.xq67_u16.qnpn13g2[ie]
print @q.xbgr.xq67_u16.qnpn13g2[is]
print @r.xbgr.xq67_u16.rsub[i]
print @c.xbgr.xq67_u16.csub[i]
print @q.xbgr.xq67_u17.qnpn13g2[ic]
print @q.xbgr.xq67_u17.qnpn13g2[ib]
print @q.xbgr.xq67_u17.qnpn13g2[ie]
print @q.xbgr.xq67_u17.qnpn13g2[is]
print @r.xbgr.xq67_u17.rsub[i]
print @c.xbgr.xq67_u17.csub[i]
print @q.xbgr.xq67_u18.qnpn13g2[ic]
print @q.xbgr.xq67_u18.qnpn13g2[ib]
print @q.xbgr.xq67_u18.qnpn13g2[ie]
print @q.xbgr.xq67_u18.qnpn13g2[is]
print @r.xbgr.xq67_u18.rsub[i]
print @c.xbgr.xq67_u18.csub[i]
print @q.xbgr.xq67_u19.qnpn13g2[ic]
print @q.xbgr.xq67_u19.qnpn13g2[ib]
print @q.xbgr.xq67_u19.qnpn13g2[ie]
print @q.xbgr.xq67_u19.qnpn13g2[is]
print @r.xbgr.xq67_u19.rsub[i]
print @c.xbgr.xq67_u19.csub[i]
print @q.xbgr.xq67_u20.qnpn13g2[ic]
print @q.xbgr.xq67_u20.qnpn13g2[ib]
print @q.xbgr.xq67_u20.qnpn13g2[ie]
print @q.xbgr.xq67_u20.qnpn13g2[is]
print @r.xbgr.xq67_u20.rsub[i]
print @c.xbgr.xq67_u20.csub[i]
print @q.xbgr.xq67_u21.qnpn13g2[ic]
print @q.xbgr.xq67_u21.qnpn13g2[ib]
print @q.xbgr.xq67_u21.qnpn13g2[ie]
print @q.xbgr.xq67_u21.qnpn13g2[is]
print @r.xbgr.xq67_u21.rsub[i]
print @c.xbgr.xq67_u21.csub[i]
print @q.xbgr.xq67_u22.qnpn13g2[ic]
print @q.xbgr.xq67_u22.qnpn13g2[ib]
print @q.xbgr.xq67_u22.qnpn13g2[ie]
print @q.xbgr.xq67_u22.qnpn13g2[is]
print @r.xbgr.xq67_u22.rsub[i]
print @c.xbgr.xq67_u22.csub[i]
print @q.xbgr.xq67_u23.qnpn13g2[ic]
print @q.xbgr.xq67_u23.qnpn13g2[ib]
print @q.xbgr.xq67_u23.qnpn13g2[ie]
print @q.xbgr.xq67_u23.qnpn13g2[is]
print @r.xbgr.xq67_u23.rsub[i]
print @c.xbgr.xq67_u23.csub[i]
print @q.xbgr.xq67_u24.qnpn13g2[ic]
print @q.xbgr.xq67_u24.qnpn13g2[ib]
print @q.xbgr.xq67_u24.qnpn13g2[ie]
print @q.xbgr.xq67_u24.qnpn13g2[is]
print @r.xbgr.xq67_u24.rsub[i]
print @c.xbgr.xq67_u24.csub[i]
print @q.xbgr.xq68_u2.qnpn13g2[ic]
print @q.xbgr.xq68_u2.qnpn13g2[ib]
print @q.xbgr.xq68_u2.qnpn13g2[ie]
print @q.xbgr.xq68_u2.qnpn13g2[is]
print @r.xbgr.xq68_u2.rsub[i]
print @c.xbgr.xq68_u2.csub[i]
print @q.xbgr.xq68_u3.qnpn13g2[ic]
print @q.xbgr.xq68_u3.qnpn13g2[ib]
print @q.xbgr.xq68_u3.qnpn13g2[ie]
print @q.xbgr.xq68_u3.qnpn13g2[is]
print @r.xbgr.xq68_u3.rsub[i]
print @c.xbgr.xq68_u3.csub[i]
print @q.xbgr.xq68_u4.qnpn13g2[ic]
print @q.xbgr.xq68_u4.qnpn13g2[ib]
print @q.xbgr.xq68_u4.qnpn13g2[ie]
print @q.xbgr.xq68_u4.qnpn13g2[is]
print @r.xbgr.xq68_u4.rsub[i]
print @c.xbgr.xq68_u4.csub[i]
print @q.xbgr.xq68_u5.qnpn13g2[ic]
print @q.xbgr.xq68_u5.qnpn13g2[ib]
print @q.xbgr.xq68_u5.qnpn13g2[ie]
print @q.xbgr.xq68_u5.qnpn13g2[is]
print @r.xbgr.xq68_u5.rsub[i]
print @c.xbgr.xq68_u5.csub[i]
print @q.xbgr.xq68_u6.qnpn13g2[ic]
print @q.xbgr.xq68_u6.qnpn13g2[ib]
print @q.xbgr.xq68_u6.qnpn13g2[ie]
print @q.xbgr.xq68_u6.qnpn13g2[is]
print @r.xbgr.xq68_u6.rsub[i]
print @c.xbgr.xq68_u6.csub[i]
print @q.xbgr.xq68_u7.qnpn13g2[ic]
print @q.xbgr.xq68_u7.qnpn13g2[ib]
print @q.xbgr.xq68_u7.qnpn13g2[ie]
print @q.xbgr.xq68_u7.qnpn13g2[is]
print @r.xbgr.xq68_u7.rsub[i]
print @c.xbgr.xq68_u7.csub[i]
print @q.xbgr.xq68_u8.qnpn13g2[ic]
print @q.xbgr.xq68_u8.qnpn13g2[ib]
print @q.xbgr.xq68_u8.qnpn13g2[ie]
print @q.xbgr.xq68_u8.qnpn13g2[is]
print @r.xbgr.xq68_u8.rsub[i]
print @c.xbgr.xq68_u8.csub[i]
print @q.xbgr.xq68_u9.qnpn13g2[ic]
print @q.xbgr.xq68_u9.qnpn13g2[ib]
print @q.xbgr.xq68_u9.qnpn13g2[ie]
print @q.xbgr.xq68_u9.qnpn13g2[is]
print @r.xbgr.xq68_u9.rsub[i]
print @c.xbgr.xq68_u9.csub[i]
print @q.xbgr.xq68_u10.qnpn13g2[ic]
print @q.xbgr.xq68_u10.qnpn13g2[ib]
print @q.xbgr.xq68_u10.qnpn13g2[ie]
print @q.xbgr.xq68_u10.qnpn13g2[is]
print @r.xbgr.xq68_u10.rsub[i]
print @c.xbgr.xq68_u10.csub[i]
print @q.xbgr.xq68_u11.qnpn13g2[ic]
print @q.xbgr.xq68_u11.qnpn13g2[ib]
print @q.xbgr.xq68_u11.qnpn13g2[ie]
print @q.xbgr.xq68_u11.qnpn13g2[is]
print @r.xbgr.xq68_u11.rsub[i]
print @c.xbgr.xq68_u11.csub[i]
print @q.xbgr.xq68_u12.qnpn13g2[ic]
print @q.xbgr.xq68_u12.qnpn13g2[ib]
print @q.xbgr.xq68_u12.qnpn13g2[ie]
print @q.xbgr.xq68_u12.qnpn13g2[is]
print @r.xbgr.xq68_u12.rsub[i]
print @c.xbgr.xq68_u12.csub[i]
print @q.xbgr.xq68_u13.qnpn13g2[ic]
print @q.xbgr.xq68_u13.qnpn13g2[ib]
print @q.xbgr.xq68_u13.qnpn13g2[ie]
print @q.xbgr.xq68_u13.qnpn13g2[is]
print @r.xbgr.xq68_u13.rsub[i]
print @c.xbgr.xq68_u13.csub[i]
print @q.xbgr.xq68_u14.qnpn13g2[ic]
print @q.xbgr.xq68_u14.qnpn13g2[ib]
print @q.xbgr.xq68_u14.qnpn13g2[ie]
print @q.xbgr.xq68_u14.qnpn13g2[is]
print @r.xbgr.xq68_u14.rsub[i]
print @c.xbgr.xq68_u14.csub[i]
print @q.xbgr.xq68_u15.qnpn13g2[ic]
print @q.xbgr.xq68_u15.qnpn13g2[ib]
print @q.xbgr.xq68_u15.qnpn13g2[ie]
print @q.xbgr.xq68_u15.qnpn13g2[is]
print @r.xbgr.xq68_u15.rsub[i]
print @c.xbgr.xq68_u15.csub[i]
print @q.xbgr.xq68_u16.qnpn13g2[ic]
print @q.xbgr.xq68_u16.qnpn13g2[ib]
print @q.xbgr.xq68_u16.qnpn13g2[ie]
print @q.xbgr.xq68_u16.qnpn13g2[is]
print @r.xbgr.xq68_u16.rsub[i]
print @c.xbgr.xq68_u16.csub[i]
print @q.xbgr.xq68_u17.qnpn13g2[ic]
print @q.xbgr.xq68_u17.qnpn13g2[ib]
print @q.xbgr.xq68_u17.qnpn13g2[ie]
print @q.xbgr.xq68_u17.qnpn13g2[is]
print @r.xbgr.xq68_u17.rsub[i]
print @c.xbgr.xq68_u17.csub[i]
print @q.xbgr.xq68_u18.qnpn13g2[ic]
print @q.xbgr.xq68_u18.qnpn13g2[ib]
print @q.xbgr.xq68_u18.qnpn13g2[ie]
print @q.xbgr.xq68_u18.qnpn13g2[is]
print @r.xbgr.xq68_u18.rsub[i]
print @c.xbgr.xq68_u18.csub[i]
print @q.xbgr.xq68_u19.qnpn13g2[ic]
print @q.xbgr.xq68_u19.qnpn13g2[ib]
print @q.xbgr.xq68_u19.qnpn13g2[ie]
print @q.xbgr.xq68_u19.qnpn13g2[is]
print @r.xbgr.xq68_u19.rsub[i]
print @c.xbgr.xq68_u19.csub[i]
print @q.xbgr.xq68_u20.qnpn13g2[ic]
print @q.xbgr.xq68_u20.qnpn13g2[ib]
print @q.xbgr.xq68_u20.qnpn13g2[ie]
print @q.xbgr.xq68_u20.qnpn13g2[is]
print @r.xbgr.xq68_u20.rsub[i]
print @c.xbgr.xq68_u20.csub[i]
print @q.xbgr.xq68_u21.qnpn13g2[ic]
print @q.xbgr.xq68_u21.qnpn13g2[ib]
print @q.xbgr.xq68_u21.qnpn13g2[ie]
print @q.xbgr.xq68_u21.qnpn13g2[is]
print @r.xbgr.xq68_u21.rsub[i]
print @c.xbgr.xq68_u21.csub[i]
print @q.xbgr.xq68_u22.qnpn13g2[ic]
print @q.xbgr.xq68_u22.qnpn13g2[ib]
print @q.xbgr.xq68_u22.qnpn13g2[ie]
print @q.xbgr.xq68_u22.qnpn13g2[is]
print @r.xbgr.xq68_u22.rsub[i]
print @c.xbgr.xq68_u22.csub[i]
print @q.xbgr.xq68_u23.qnpn13g2[ic]
print @q.xbgr.xq68_u23.qnpn13g2[ib]
print @q.xbgr.xq68_u23.qnpn13g2[ie]
print @q.xbgr.xq68_u23.qnpn13g2[is]
print @r.xbgr.xq68_u23.rsub[i]
print @c.xbgr.xq68_u23.csub[i]
print @q.xbgr.xq68_u24.qnpn13g2[ic]
print @q.xbgr.xq68_u24.qnpn13g2[ib]
print @q.xbgr.xq68_u24.qnpn13g2[ie]
print @q.xbgr.xq68_u24.qnpn13g2[is]
print @r.xbgr.xq68_u24.rsub[i]
print @c.xbgr.xq68_u24.csub[i]
print @q.xbgr.xq69_u2.qnpn13g2[ic]
print @q.xbgr.xq69_u2.qnpn13g2[ib]
print @q.xbgr.xq69_u2.qnpn13g2[ie]
print @q.xbgr.xq69_u2.qnpn13g2[is]
print @r.xbgr.xq69_u2.rsub[i]
print @c.xbgr.xq69_u2.csub[i]
print @q.xbgr.xq69_u3.qnpn13g2[ic]
print @q.xbgr.xq69_u3.qnpn13g2[ib]
print @q.xbgr.xq69_u3.qnpn13g2[ie]
print @q.xbgr.xq69_u3.qnpn13g2[is]
print @r.xbgr.xq69_u3.rsub[i]
print @c.xbgr.xq69_u3.csub[i]
print @q.xbgr.xq69_u4.qnpn13g2[ic]
print @q.xbgr.xq69_u4.qnpn13g2[ib]
print @q.xbgr.xq69_u4.qnpn13g2[ie]
print @q.xbgr.xq69_u4.qnpn13g2[is]
print @r.xbgr.xq69_u4.rsub[i]
print @c.xbgr.xq69_u4.csub[i]
print @q.xbgr.xq69_u5.qnpn13g2[ic]
print @q.xbgr.xq69_u5.qnpn13g2[ib]
print @q.xbgr.xq69_u5.qnpn13g2[ie]
print @q.xbgr.xq69_u5.qnpn13g2[is]
print @r.xbgr.xq69_u5.rsub[i]
print @c.xbgr.xq69_u5.csub[i]
print @q.xbgr.xq69_u6.qnpn13g2[ic]
print @q.xbgr.xq69_u6.qnpn13g2[ib]
print @q.xbgr.xq69_u6.qnpn13g2[ie]
print @q.xbgr.xq69_u6.qnpn13g2[is]
print @r.xbgr.xq69_u6.rsub[i]
print @c.xbgr.xq69_u6.csub[i]
print @q.xbgr.xq69_u7.qnpn13g2[ic]
print @q.xbgr.xq69_u7.qnpn13g2[ib]
print @q.xbgr.xq69_u7.qnpn13g2[ie]
print @q.xbgr.xq69_u7.qnpn13g2[is]
print @r.xbgr.xq69_u7.rsub[i]
print @c.xbgr.xq69_u7.csub[i]
print @q.xbgr.xq69_u8.qnpn13g2[ic]
print @q.xbgr.xq69_u8.qnpn13g2[ib]
print @q.xbgr.xq69_u8.qnpn13g2[ie]
print @q.xbgr.xq69_u8.qnpn13g2[is]
print @r.xbgr.xq69_u8.rsub[i]
print @c.xbgr.xq69_u8.csub[i]
print @q.xbgr.xq69_u9.qnpn13g2[ic]
print @q.xbgr.xq69_u9.qnpn13g2[ib]
print @q.xbgr.xq69_u9.qnpn13g2[ie]
print @q.xbgr.xq69_u9.qnpn13g2[is]
print @r.xbgr.xq69_u9.rsub[i]
print @c.xbgr.xq69_u9.csub[i]
print @q.xbgr.xq69_u10.qnpn13g2[ic]
print @q.xbgr.xq69_u10.qnpn13g2[ib]
print @q.xbgr.xq69_u10.qnpn13g2[ie]
print @q.xbgr.xq69_u10.qnpn13g2[is]
print @r.xbgr.xq69_u10.rsub[i]
print @c.xbgr.xq69_u10.csub[i]
print @q.xbgr.xq69_u11.qnpn13g2[ic]
print @q.xbgr.xq69_u11.qnpn13g2[ib]
print @q.xbgr.xq69_u11.qnpn13g2[ie]
print @q.xbgr.xq69_u11.qnpn13g2[is]
print @r.xbgr.xq69_u11.rsub[i]
print @c.xbgr.xq69_u11.csub[i]
print @q.xbgr.xq69_u12.qnpn13g2[ic]
print @q.xbgr.xq69_u12.qnpn13g2[ib]
print @q.xbgr.xq69_u12.qnpn13g2[ie]
print @q.xbgr.xq69_u12.qnpn13g2[is]
print @r.xbgr.xq69_u12.rsub[i]
print @c.xbgr.xq69_u12.csub[i]
print @q.xbgr.xq69_u13.qnpn13g2[ic]
print @q.xbgr.xq69_u13.qnpn13g2[ib]
print @q.xbgr.xq69_u13.qnpn13g2[ie]
print @q.xbgr.xq69_u13.qnpn13g2[is]
print @r.xbgr.xq69_u13.rsub[i]
print @c.xbgr.xq69_u13.csub[i]
print @q.xbgr.xq69_u14.qnpn13g2[ic]
print @q.xbgr.xq69_u14.qnpn13g2[ib]
print @q.xbgr.xq69_u14.qnpn13g2[ie]
print @q.xbgr.xq69_u14.qnpn13g2[is]
print @r.xbgr.xq69_u14.rsub[i]
print @c.xbgr.xq69_u14.csub[i]
print @q.xbgr.xq69_u15.qnpn13g2[ic]
print @q.xbgr.xq69_u15.qnpn13g2[ib]
print @q.xbgr.xq69_u15.qnpn13g2[ie]
print @q.xbgr.xq69_u15.qnpn13g2[is]
print @r.xbgr.xq69_u15.rsub[i]
print @c.xbgr.xq69_u15.csub[i]
print @q.xbgr.xq69_u16.qnpn13g2[ic]
print @q.xbgr.xq69_u16.qnpn13g2[ib]
print @q.xbgr.xq69_u16.qnpn13g2[ie]
print @q.xbgr.xq69_u16.qnpn13g2[is]
print @r.xbgr.xq69_u16.rsub[i]
print @c.xbgr.xq69_u16.csub[i]
print @q.xbgr.xq69_u17.qnpn13g2[ic]
print @q.xbgr.xq69_u17.qnpn13g2[ib]
print @q.xbgr.xq69_u17.qnpn13g2[ie]
print @q.xbgr.xq69_u17.qnpn13g2[is]
print @r.xbgr.xq69_u17.rsub[i]
print @c.xbgr.xq69_u17.csub[i]
print @q.xbgr.xq69_u18.qnpn13g2[ic]
print @q.xbgr.xq69_u18.qnpn13g2[ib]
print @q.xbgr.xq69_u18.qnpn13g2[ie]
print @q.xbgr.xq69_u18.qnpn13g2[is]
print @r.xbgr.xq69_u18.rsub[i]
print @c.xbgr.xq69_u18.csub[i]
print @q.xbgr.xq69_u19.qnpn13g2[ic]
print @q.xbgr.xq69_u19.qnpn13g2[ib]
print @q.xbgr.xq69_u19.qnpn13g2[ie]
print @q.xbgr.xq69_u19.qnpn13g2[is]
print @r.xbgr.xq69_u19.rsub[i]
print @c.xbgr.xq69_u19.csub[i]
print @q.xbgr.xq69_u20.qnpn13g2[ic]
print @q.xbgr.xq69_u20.qnpn13g2[ib]
print @q.xbgr.xq69_u20.qnpn13g2[ie]
print @q.xbgr.xq69_u20.qnpn13g2[is]
print @r.xbgr.xq69_u20.rsub[i]
print @c.xbgr.xq69_u20.csub[i]
print @q.xbgr.xq69_u21.qnpn13g2[ic]
print @q.xbgr.xq69_u21.qnpn13g2[ib]
print @q.xbgr.xq69_u21.qnpn13g2[ie]
print @q.xbgr.xq69_u21.qnpn13g2[is]
print @r.xbgr.xq69_u21.rsub[i]
print @c.xbgr.xq69_u21.csub[i]
print @q.xbgr.xq69_u22.qnpn13g2[ic]
print @q.xbgr.xq69_u22.qnpn13g2[ib]
print @q.xbgr.xq69_u22.qnpn13g2[ie]
print @q.xbgr.xq69_u22.qnpn13g2[is]
print @r.xbgr.xq69_u22.rsub[i]
print @c.xbgr.xq69_u22.csub[i]
print @q.xbgr.xq69_u23.qnpn13g2[ic]
print @q.xbgr.xq69_u23.qnpn13g2[ib]
print @q.xbgr.xq69_u23.qnpn13g2[ie]
print @q.xbgr.xq69_u23.qnpn13g2[is]
print @r.xbgr.xq69_u23.rsub[i]
print @c.xbgr.xq69_u23.csub[i]
print @q.xbgr.xq69_u24.qnpn13g2[ic]
print @q.xbgr.xq69_u24.qnpn13g2[ib]
print @q.xbgr.xq69_u24.qnpn13g2[ie]
print @q.xbgr.xq69_u24.qnpn13g2[is]
print @r.xbgr.xq69_u24.rsub[i]
print @c.xbgr.xq69_u24.csub[i]
print @q.xbgr.xq70_u2.qnpn13g2[ic]
print @q.xbgr.xq70_u2.qnpn13g2[ib]
print @q.xbgr.xq70_u2.qnpn13g2[ie]
print @q.xbgr.xq70_u2.qnpn13g2[is]
print @r.xbgr.xq70_u2.rsub[i]
print @c.xbgr.xq70_u2.csub[i]
print @q.xbgr.xq70_u3.qnpn13g2[ic]
print @q.xbgr.xq70_u3.qnpn13g2[ib]
print @q.xbgr.xq70_u3.qnpn13g2[ie]
print @q.xbgr.xq70_u3.qnpn13g2[is]
print @r.xbgr.xq70_u3.rsub[i]
print @c.xbgr.xq70_u3.csub[i]
print @q.xbgr.xq70_u4.qnpn13g2[ic]
print @q.xbgr.xq70_u4.qnpn13g2[ib]
print @q.xbgr.xq70_u4.qnpn13g2[ie]
print @q.xbgr.xq70_u4.qnpn13g2[is]
print @r.xbgr.xq70_u4.rsub[i]
print @c.xbgr.xq70_u4.csub[i]
print @q.xbgr.xq70_u5.qnpn13g2[ic]
print @q.xbgr.xq70_u5.qnpn13g2[ib]
print @q.xbgr.xq70_u5.qnpn13g2[ie]
print @q.xbgr.xq70_u5.qnpn13g2[is]
print @r.xbgr.xq70_u5.rsub[i]
print @c.xbgr.xq70_u5.csub[i]
print @q.xbgr.xq70_u6.qnpn13g2[ic]
print @q.xbgr.xq70_u6.qnpn13g2[ib]
print @q.xbgr.xq70_u6.qnpn13g2[ie]
print @q.xbgr.xq70_u6.qnpn13g2[is]
print @r.xbgr.xq70_u6.rsub[i]
print @c.xbgr.xq70_u6.csub[i]
print @q.xbgr.xq70_u7.qnpn13g2[ic]
print @q.xbgr.xq70_u7.qnpn13g2[ib]
print @q.xbgr.xq70_u7.qnpn13g2[ie]
print @q.xbgr.xq70_u7.qnpn13g2[is]
print @r.xbgr.xq70_u7.rsub[i]
print @c.xbgr.xq70_u7.csub[i]
print @q.xbgr.xq70_u8.qnpn13g2[ic]
print @q.xbgr.xq70_u8.qnpn13g2[ib]
print @q.xbgr.xq70_u8.qnpn13g2[ie]
print @q.xbgr.xq70_u8.qnpn13g2[is]
print @r.xbgr.xq70_u8.rsub[i]
print @c.xbgr.xq70_u8.csub[i]
print @q.xbgr.xq70_u9.qnpn13g2[ic]
print @q.xbgr.xq70_u9.qnpn13g2[ib]
print @q.xbgr.xq70_u9.qnpn13g2[ie]
print @q.xbgr.xq70_u9.qnpn13g2[is]
print @r.xbgr.xq70_u9.rsub[i]
print @c.xbgr.xq70_u9.csub[i]
print @q.xbgr.xq70_u10.qnpn13g2[ic]
print @q.xbgr.xq70_u10.qnpn13g2[ib]
print @q.xbgr.xq70_u10.qnpn13g2[ie]
print @q.xbgr.xq70_u10.qnpn13g2[is]
print @r.xbgr.xq70_u10.rsub[i]
print @c.xbgr.xq70_u10.csub[i]
print @q.xbgr.xq70_u11.qnpn13g2[ic]
print @q.xbgr.xq70_u11.qnpn13g2[ib]
print @q.xbgr.xq70_u11.qnpn13g2[ie]
print @q.xbgr.xq70_u11.qnpn13g2[is]
print @r.xbgr.xq70_u11.rsub[i]
print @c.xbgr.xq70_u11.csub[i]
print @q.xbgr.xq70_u12.qnpn13g2[ic]
print @q.xbgr.xq70_u12.qnpn13g2[ib]
print @q.xbgr.xq70_u12.qnpn13g2[ie]
print @q.xbgr.xq70_u12.qnpn13g2[is]
print @r.xbgr.xq70_u12.rsub[i]
print @c.xbgr.xq70_u12.csub[i]
print @q.xbgr.xq70_u13.qnpn13g2[ic]
print @q.xbgr.xq70_u13.qnpn13g2[ib]
print @q.xbgr.xq70_u13.qnpn13g2[ie]
print @q.xbgr.xq70_u13.qnpn13g2[is]
print @r.xbgr.xq70_u13.rsub[i]
print @c.xbgr.xq70_u13.csub[i]
print @q.xbgr.xq70_u14.qnpn13g2[ic]
print @q.xbgr.xq70_u14.qnpn13g2[ib]
print @q.xbgr.xq70_u14.qnpn13g2[ie]
print @q.xbgr.xq70_u14.qnpn13g2[is]
print @r.xbgr.xq70_u14.rsub[i]
print @c.xbgr.xq70_u14.csub[i]
print @q.xbgr.xq70_u15.qnpn13g2[ic]
print @q.xbgr.xq70_u15.qnpn13g2[ib]
print @q.xbgr.xq70_u15.qnpn13g2[ie]
print @q.xbgr.xq70_u15.qnpn13g2[is]
print @r.xbgr.xq70_u15.rsub[i]
print @c.xbgr.xq70_u15.csub[i]
print @q.xbgr.xq70_u16.qnpn13g2[ic]
print @q.xbgr.xq70_u16.qnpn13g2[ib]
print @q.xbgr.xq70_u16.qnpn13g2[ie]
print @q.xbgr.xq70_u16.qnpn13g2[is]
print @r.xbgr.xq70_u16.rsub[i]
print @c.xbgr.xq70_u16.csub[i]
print @q.xbgr.xq70_u17.qnpn13g2[ic]
print @q.xbgr.xq70_u17.qnpn13g2[ib]
print @q.xbgr.xq70_u17.qnpn13g2[ie]
print @q.xbgr.xq70_u17.qnpn13g2[is]
print @r.xbgr.xq70_u17.rsub[i]
print @c.xbgr.xq70_u17.csub[i]
print @q.xbgr.xq70_u18.qnpn13g2[ic]
print @q.xbgr.xq70_u18.qnpn13g2[ib]
print @q.xbgr.xq70_u18.qnpn13g2[ie]
print @q.xbgr.xq70_u18.qnpn13g2[is]
print @r.xbgr.xq70_u18.rsub[i]
print @c.xbgr.xq70_u18.csub[i]
print @q.xbgr.xq70_u19.qnpn13g2[ic]
print @q.xbgr.xq70_u19.qnpn13g2[ib]
print @q.xbgr.xq70_u19.qnpn13g2[ie]
print @q.xbgr.xq70_u19.qnpn13g2[is]
print @r.xbgr.xq70_u19.rsub[i]
print @c.xbgr.xq70_u19.csub[i]
print @q.xbgr.xq70_u20.qnpn13g2[ic]
print @q.xbgr.xq70_u20.qnpn13g2[ib]
print @q.xbgr.xq70_u20.qnpn13g2[ie]
print @q.xbgr.xq70_u20.qnpn13g2[is]
print @r.xbgr.xq70_u20.rsub[i]
print @c.xbgr.xq70_u20.csub[i]
print @q.xbgr.xq70_u21.qnpn13g2[ic]
print @q.xbgr.xq70_u21.qnpn13g2[ib]
print @q.xbgr.xq70_u21.qnpn13g2[ie]
print @q.xbgr.xq70_u21.qnpn13g2[is]
print @r.xbgr.xq70_u21.rsub[i]
print @c.xbgr.xq70_u21.csub[i]
print @q.xbgr.xq70_u22.qnpn13g2[ic]
print @q.xbgr.xq70_u22.qnpn13g2[ib]
print @q.xbgr.xq70_u22.qnpn13g2[ie]
print @q.xbgr.xq70_u22.qnpn13g2[is]
print @r.xbgr.xq70_u22.rsub[i]
print @c.xbgr.xq70_u22.csub[i]
print @q.xbgr.xq70_u23.qnpn13g2[ic]
print @q.xbgr.xq70_u23.qnpn13g2[ib]
print @q.xbgr.xq70_u23.qnpn13g2[ie]
print @q.xbgr.xq70_u23.qnpn13g2[is]
print @r.xbgr.xq70_u23.rsub[i]
print @c.xbgr.xq70_u23.csub[i]
print @q.xbgr.xq70_u24.qnpn13g2[ic]
print @q.xbgr.xq70_u24.qnpn13g2[ib]
print @q.xbgr.xq70_u24.qnpn13g2[ie]
print @q.xbgr.xq70_u24.qnpn13g2[is]
print @r.xbgr.xq70_u24.rsub[i]
print @c.xbgr.xq70_u24.csub[i]
print @q.xbgr.xq71_u2.qnpn13g2[ic]
print @q.xbgr.xq71_u2.qnpn13g2[ib]
print @q.xbgr.xq71_u2.qnpn13g2[ie]
print @q.xbgr.xq71_u2.qnpn13g2[is]
print @r.xbgr.xq71_u2.rsub[i]
print @c.xbgr.xq71_u2.csub[i]
print @q.xbgr.xq71_u3.qnpn13g2[ic]
print @q.xbgr.xq71_u3.qnpn13g2[ib]
print @q.xbgr.xq71_u3.qnpn13g2[ie]
print @q.xbgr.xq71_u3.qnpn13g2[is]
print @r.xbgr.xq71_u3.rsub[i]
print @c.xbgr.xq71_u3.csub[i]
print @q.xbgr.xq71_u4.qnpn13g2[ic]
print @q.xbgr.xq71_u4.qnpn13g2[ib]
print @q.xbgr.xq71_u4.qnpn13g2[ie]
print @q.xbgr.xq71_u4.qnpn13g2[is]
print @r.xbgr.xq71_u4.rsub[i]
print @c.xbgr.xq71_u4.csub[i]
print @q.xbgr.xq71_u5.qnpn13g2[ic]
print @q.xbgr.xq71_u5.qnpn13g2[ib]
print @q.xbgr.xq71_u5.qnpn13g2[ie]
print @q.xbgr.xq71_u5.qnpn13g2[is]
print @r.xbgr.xq71_u5.rsub[i]
print @c.xbgr.xq71_u5.csub[i]
print @q.xbgr.xq71_u6.qnpn13g2[ic]
print @q.xbgr.xq71_u6.qnpn13g2[ib]
print @q.xbgr.xq71_u6.qnpn13g2[ie]
print @q.xbgr.xq71_u6.qnpn13g2[is]
print @r.xbgr.xq71_u6.rsub[i]
print @c.xbgr.xq71_u6.csub[i]
print @q.xbgr.xq71_u7.qnpn13g2[ic]
print @q.xbgr.xq71_u7.qnpn13g2[ib]
print @q.xbgr.xq71_u7.qnpn13g2[ie]
print @q.xbgr.xq71_u7.qnpn13g2[is]
print @r.xbgr.xq71_u7.rsub[i]
print @c.xbgr.xq71_u7.csub[i]
print @q.xbgr.xq71_u8.qnpn13g2[ic]
print @q.xbgr.xq71_u8.qnpn13g2[ib]
print @q.xbgr.xq71_u8.qnpn13g2[ie]
print @q.xbgr.xq71_u8.qnpn13g2[is]
print @r.xbgr.xq71_u8.rsub[i]
print @c.xbgr.xq71_u8.csub[i]
print @q.xbgr.xq71_u9.qnpn13g2[ic]
print @q.xbgr.xq71_u9.qnpn13g2[ib]
print @q.xbgr.xq71_u9.qnpn13g2[ie]
print @q.xbgr.xq71_u9.qnpn13g2[is]
print @r.xbgr.xq71_u9.rsub[i]
print @c.xbgr.xq71_u9.csub[i]
print @q.xbgr.xq71_u10.qnpn13g2[ic]
print @q.xbgr.xq71_u10.qnpn13g2[ib]
print @q.xbgr.xq71_u10.qnpn13g2[ie]
print @q.xbgr.xq71_u10.qnpn13g2[is]
print @r.xbgr.xq71_u10.rsub[i]
print @c.xbgr.xq71_u10.csub[i]
print @q.xbgr.xq71_u11.qnpn13g2[ic]
print @q.xbgr.xq71_u11.qnpn13g2[ib]
print @q.xbgr.xq71_u11.qnpn13g2[ie]
print @q.xbgr.xq71_u11.qnpn13g2[is]
print @r.xbgr.xq71_u11.rsub[i]
print @c.xbgr.xq71_u11.csub[i]
print @q.xbgr.xq71_u12.qnpn13g2[ic]
print @q.xbgr.xq71_u12.qnpn13g2[ib]
print @q.xbgr.xq71_u12.qnpn13g2[ie]
print @q.xbgr.xq71_u12.qnpn13g2[is]
print @r.xbgr.xq71_u12.rsub[i]
print @c.xbgr.xq71_u12.csub[i]
print @q.xbgr.xq71_u13.qnpn13g2[ic]
print @q.xbgr.xq71_u13.qnpn13g2[ib]
print @q.xbgr.xq71_u13.qnpn13g2[ie]
print @q.xbgr.xq71_u13.qnpn13g2[is]
print @r.xbgr.xq71_u13.rsub[i]
print @c.xbgr.xq71_u13.csub[i]
print @q.xbgr.xq71_u14.qnpn13g2[ic]
print @q.xbgr.xq71_u14.qnpn13g2[ib]
print @q.xbgr.xq71_u14.qnpn13g2[ie]
print @q.xbgr.xq71_u14.qnpn13g2[is]
print @r.xbgr.xq71_u14.rsub[i]
print @c.xbgr.xq71_u14.csub[i]
print @q.xbgr.xq71_u15.qnpn13g2[ic]
print @q.xbgr.xq71_u15.qnpn13g2[ib]
print @q.xbgr.xq71_u15.qnpn13g2[ie]
print @q.xbgr.xq71_u15.qnpn13g2[is]
print @r.xbgr.xq71_u15.rsub[i]
print @c.xbgr.xq71_u15.csub[i]
print @q.xbgr.xq71_u16.qnpn13g2[ic]
print @q.xbgr.xq71_u16.qnpn13g2[ib]
print @q.xbgr.xq71_u16.qnpn13g2[ie]
print @q.xbgr.xq71_u16.qnpn13g2[is]
print @r.xbgr.xq71_u16.rsub[i]
print @c.xbgr.xq71_u16.csub[i]
print @q.xbgr.xq71_u17.qnpn13g2[ic]
print @q.xbgr.xq71_u17.qnpn13g2[ib]
print @q.xbgr.xq71_u17.qnpn13g2[ie]
print @q.xbgr.xq71_u17.qnpn13g2[is]
print @r.xbgr.xq71_u17.rsub[i]
print @c.xbgr.xq71_u17.csub[i]
print @q.xbgr.xq71_u18.qnpn13g2[ic]
print @q.xbgr.xq71_u18.qnpn13g2[ib]
print @q.xbgr.xq71_u18.qnpn13g2[ie]
print @q.xbgr.xq71_u18.qnpn13g2[is]
print @r.xbgr.xq71_u18.rsub[i]
print @c.xbgr.xq71_u18.csub[i]
print @q.xbgr.xq71_u19.qnpn13g2[ic]
print @q.xbgr.xq71_u19.qnpn13g2[ib]
print @q.xbgr.xq71_u19.qnpn13g2[ie]
print @q.xbgr.xq71_u19.qnpn13g2[is]
print @r.xbgr.xq71_u19.rsub[i]
print @c.xbgr.xq71_u19.csub[i]
print @q.xbgr.xq71_u20.qnpn13g2[ic]
print @q.xbgr.xq71_u20.qnpn13g2[ib]
print @q.xbgr.xq71_u20.qnpn13g2[ie]
print @q.xbgr.xq71_u20.qnpn13g2[is]
print @r.xbgr.xq71_u20.rsub[i]
print @c.xbgr.xq71_u20.csub[i]
print @q.xbgr.xq71_u21.qnpn13g2[ic]
print @q.xbgr.xq71_u21.qnpn13g2[ib]
print @q.xbgr.xq71_u21.qnpn13g2[ie]
print @q.xbgr.xq71_u21.qnpn13g2[is]
print @r.xbgr.xq71_u21.rsub[i]
print @c.xbgr.xq71_u21.csub[i]
print @q.xbgr.xq71_u22.qnpn13g2[ic]
print @q.xbgr.xq71_u22.qnpn13g2[ib]
print @q.xbgr.xq71_u22.qnpn13g2[ie]
print @q.xbgr.xq71_u22.qnpn13g2[is]
print @r.xbgr.xq71_u22.rsub[i]
print @c.xbgr.xq71_u22.csub[i]
print @q.xbgr.xq71_u23.qnpn13g2[ic]
print @q.xbgr.xq71_u23.qnpn13g2[ib]
print @q.xbgr.xq71_u23.qnpn13g2[ie]
print @q.xbgr.xq71_u23.qnpn13g2[is]
print @r.xbgr.xq71_u23.rsub[i]
print @c.xbgr.xq71_u23.csub[i]
print @q.xbgr.xq71_u24.qnpn13g2[ic]
print @q.xbgr.xq71_u24.qnpn13g2[ib]
print @q.xbgr.xq71_u24.qnpn13g2[ie]
print @q.xbgr.xq71_u24.qnpn13g2[is]
print @r.xbgr.xq71_u24.rsub[i]
print @c.xbgr.xq71_u24.csub[i]
print @q.xbgr.xq72_u2.qnpn13g2[ic]
print @q.xbgr.xq72_u2.qnpn13g2[ib]
print @q.xbgr.xq72_u2.qnpn13g2[ie]
print @q.xbgr.xq72_u2.qnpn13g2[is]
print @r.xbgr.xq72_u2.rsub[i]
print @c.xbgr.xq72_u2.csub[i]
print @q.xbgr.xq72_u3.qnpn13g2[ic]
print @q.xbgr.xq72_u3.qnpn13g2[ib]
print @q.xbgr.xq72_u3.qnpn13g2[ie]
print @q.xbgr.xq72_u3.qnpn13g2[is]
print @r.xbgr.xq72_u3.rsub[i]
print @c.xbgr.xq72_u3.csub[i]
print @q.xbgr.xq72_u4.qnpn13g2[ic]
print @q.xbgr.xq72_u4.qnpn13g2[ib]
print @q.xbgr.xq72_u4.qnpn13g2[ie]
print @q.xbgr.xq72_u4.qnpn13g2[is]
print @r.xbgr.xq72_u4.rsub[i]
print @c.xbgr.xq72_u4.csub[i]
print @q.xbgr.xq72_u5.qnpn13g2[ic]
print @q.xbgr.xq72_u5.qnpn13g2[ib]
print @q.xbgr.xq72_u5.qnpn13g2[ie]
print @q.xbgr.xq72_u5.qnpn13g2[is]
print @r.xbgr.xq72_u5.rsub[i]
print @c.xbgr.xq72_u5.csub[i]
print @q.xbgr.xq72_u6.qnpn13g2[ic]
print @q.xbgr.xq72_u6.qnpn13g2[ib]
print @q.xbgr.xq72_u6.qnpn13g2[ie]
print @q.xbgr.xq72_u6.qnpn13g2[is]
print @r.xbgr.xq72_u6.rsub[i]
print @c.xbgr.xq72_u6.csub[i]
print @q.xbgr.xq72_u7.qnpn13g2[ic]
print @q.xbgr.xq72_u7.qnpn13g2[ib]
print @q.xbgr.xq72_u7.qnpn13g2[ie]
print @q.xbgr.xq72_u7.qnpn13g2[is]
print @r.xbgr.xq72_u7.rsub[i]
print @c.xbgr.xq72_u7.csub[i]
print @q.xbgr.xq72_u8.qnpn13g2[ic]
print @q.xbgr.xq72_u8.qnpn13g2[ib]
print @q.xbgr.xq72_u8.qnpn13g2[ie]
print @q.xbgr.xq72_u8.qnpn13g2[is]
print @r.xbgr.xq72_u8.rsub[i]
print @c.xbgr.xq72_u8.csub[i]
print @q.xbgr.xq72_u9.qnpn13g2[ic]
print @q.xbgr.xq72_u9.qnpn13g2[ib]
print @q.xbgr.xq72_u9.qnpn13g2[ie]
print @q.xbgr.xq72_u9.qnpn13g2[is]
print @r.xbgr.xq72_u9.rsub[i]
print @c.xbgr.xq72_u9.csub[i]
print @q.xbgr.xq72_u10.qnpn13g2[ic]
print @q.xbgr.xq72_u10.qnpn13g2[ib]
print @q.xbgr.xq72_u10.qnpn13g2[ie]
print @q.xbgr.xq72_u10.qnpn13g2[is]
print @r.xbgr.xq72_u10.rsub[i]
print @c.xbgr.xq72_u10.csub[i]
print @q.xbgr.xq72_u11.qnpn13g2[ic]
print @q.xbgr.xq72_u11.qnpn13g2[ib]
print @q.xbgr.xq72_u11.qnpn13g2[ie]
print @q.xbgr.xq72_u11.qnpn13g2[is]
print @r.xbgr.xq72_u11.rsub[i]
print @c.xbgr.xq72_u11.csub[i]
print @q.xbgr.xq72_u12.qnpn13g2[ic]
print @q.xbgr.xq72_u12.qnpn13g2[ib]
print @q.xbgr.xq72_u12.qnpn13g2[ie]
print @q.xbgr.xq72_u12.qnpn13g2[is]
print @r.xbgr.xq72_u12.rsub[i]
print @c.xbgr.xq72_u12.csub[i]
print @q.xbgr.xq72_u13.qnpn13g2[ic]
print @q.xbgr.xq72_u13.qnpn13g2[ib]
print @q.xbgr.xq72_u13.qnpn13g2[ie]
print @q.xbgr.xq72_u13.qnpn13g2[is]
print @r.xbgr.xq72_u13.rsub[i]
print @c.xbgr.xq72_u13.csub[i]
print @q.xbgr.xq72_u14.qnpn13g2[ic]
print @q.xbgr.xq72_u14.qnpn13g2[ib]
print @q.xbgr.xq72_u14.qnpn13g2[ie]
print @q.xbgr.xq72_u14.qnpn13g2[is]
print @r.xbgr.xq72_u14.rsub[i]
print @c.xbgr.xq72_u14.csub[i]
print @q.xbgr.xq72_u15.qnpn13g2[ic]
print @q.xbgr.xq72_u15.qnpn13g2[ib]
print @q.xbgr.xq72_u15.qnpn13g2[ie]
print @q.xbgr.xq72_u15.qnpn13g2[is]
print @r.xbgr.xq72_u15.rsub[i]
print @c.xbgr.xq72_u15.csub[i]
print @q.xbgr.xq72_u16.qnpn13g2[ic]
print @q.xbgr.xq72_u16.qnpn13g2[ib]
print @q.xbgr.xq72_u16.qnpn13g2[ie]
print @q.xbgr.xq72_u16.qnpn13g2[is]
print @r.xbgr.xq72_u16.rsub[i]
print @c.xbgr.xq72_u16.csub[i]
print @q.xbgr.xq72_u17.qnpn13g2[ic]
print @q.xbgr.xq72_u17.qnpn13g2[ib]
print @q.xbgr.xq72_u17.qnpn13g2[ie]
print @q.xbgr.xq72_u17.qnpn13g2[is]
print @r.xbgr.xq72_u17.rsub[i]
print @c.xbgr.xq72_u17.csub[i]
print @q.xbgr.xq72_u18.qnpn13g2[ic]
print @q.xbgr.xq72_u18.qnpn13g2[ib]
print @q.xbgr.xq72_u18.qnpn13g2[ie]
print @q.xbgr.xq72_u18.qnpn13g2[is]
print @r.xbgr.xq72_u18.rsub[i]
print @c.xbgr.xq72_u18.csub[i]
print @q.xbgr.xq72_u19.qnpn13g2[ic]
print @q.xbgr.xq72_u19.qnpn13g2[ib]
print @q.xbgr.xq72_u19.qnpn13g2[ie]
print @q.xbgr.xq72_u19.qnpn13g2[is]
print @r.xbgr.xq72_u19.rsub[i]
print @c.xbgr.xq72_u19.csub[i]
print @q.xbgr.xq72_u20.qnpn13g2[ic]
print @q.xbgr.xq72_u20.qnpn13g2[ib]
print @q.xbgr.xq72_u20.qnpn13g2[ie]
print @q.xbgr.xq72_u20.qnpn13g2[is]
print @r.xbgr.xq72_u20.rsub[i]
print @c.xbgr.xq72_u20.csub[i]
print @q.xbgr.xq72_u21.qnpn13g2[ic]
print @q.xbgr.xq72_u21.qnpn13g2[ib]
print @q.xbgr.xq72_u21.qnpn13g2[ie]
print @q.xbgr.xq72_u21.qnpn13g2[is]
print @r.xbgr.xq72_u21.rsub[i]
print @c.xbgr.xq72_u21.csub[i]
print @q.xbgr.xq72_u22.qnpn13g2[ic]
print @q.xbgr.xq72_u22.qnpn13g2[ib]
print @q.xbgr.xq72_u22.qnpn13g2[ie]
print @q.xbgr.xq72_u22.qnpn13g2[is]
print @r.xbgr.xq72_u22.rsub[i]
print @c.xbgr.xq72_u22.csub[i]
print @q.xbgr.xq72_u23.qnpn13g2[ic]
print @q.xbgr.xq72_u23.qnpn13g2[ib]
print @q.xbgr.xq72_u23.qnpn13g2[ie]
print @q.xbgr.xq72_u23.qnpn13g2[is]
print @r.xbgr.xq72_u23.rsub[i]
print @c.xbgr.xq72_u23.csub[i]
print @q.xbgr.xq72_u24.qnpn13g2[ic]
print @q.xbgr.xq72_u24.qnpn13g2[ib]
print @q.xbgr.xq72_u24.qnpn13g2[ie]
print @q.xbgr.xq72_u24.qnpn13g2[is]
print @r.xbgr.xq72_u24.rsub[i]
print @c.xbgr.xq72_u24.csub[i]
print @q.xbgr.xq73_u2.qnpn13g2[ic]
print @q.xbgr.xq73_u2.qnpn13g2[ib]
print @q.xbgr.xq73_u2.qnpn13g2[ie]
print @q.xbgr.xq73_u2.qnpn13g2[is]
print @r.xbgr.xq73_u2.rsub[i]
print @c.xbgr.xq73_u2.csub[i]
print @q.xbgr.xq73_u3.qnpn13g2[ic]
print @q.xbgr.xq73_u3.qnpn13g2[ib]
print @q.xbgr.xq73_u3.qnpn13g2[ie]
print @q.xbgr.xq73_u3.qnpn13g2[is]
print @r.xbgr.xq73_u3.rsub[i]
print @c.xbgr.xq73_u3.csub[i]
print @q.xbgr.xq73_u4.qnpn13g2[ic]
print @q.xbgr.xq73_u4.qnpn13g2[ib]
print @q.xbgr.xq73_u4.qnpn13g2[ie]
print @q.xbgr.xq73_u4.qnpn13g2[is]
print @r.xbgr.xq73_u4.rsub[i]
print @c.xbgr.xq73_u4.csub[i]
print @q.xbgr.xq73_u5.qnpn13g2[ic]
print @q.xbgr.xq73_u5.qnpn13g2[ib]
print @q.xbgr.xq73_u5.qnpn13g2[ie]
print @q.xbgr.xq73_u5.qnpn13g2[is]
print @r.xbgr.xq73_u5.rsub[i]
print @c.xbgr.xq73_u5.csub[i]
print @q.xbgr.xq73_u6.qnpn13g2[ic]
print @q.xbgr.xq73_u6.qnpn13g2[ib]
print @q.xbgr.xq73_u6.qnpn13g2[ie]
print @q.xbgr.xq73_u6.qnpn13g2[is]
print @r.xbgr.xq73_u6.rsub[i]
print @c.xbgr.xq73_u6.csub[i]
print @q.xbgr.xq73_u7.qnpn13g2[ic]
print @q.xbgr.xq73_u7.qnpn13g2[ib]
print @q.xbgr.xq73_u7.qnpn13g2[ie]
print @q.xbgr.xq73_u7.qnpn13g2[is]
print @r.xbgr.xq73_u7.rsub[i]
print @c.xbgr.xq73_u7.csub[i]
print @q.xbgr.xq73_u8.qnpn13g2[ic]
print @q.xbgr.xq73_u8.qnpn13g2[ib]
print @q.xbgr.xq73_u8.qnpn13g2[ie]
print @q.xbgr.xq73_u8.qnpn13g2[is]
print @r.xbgr.xq73_u8.rsub[i]
print @c.xbgr.xq73_u8.csub[i]
print @q.xbgr.xq73_u9.qnpn13g2[ic]
print @q.xbgr.xq73_u9.qnpn13g2[ib]
print @q.xbgr.xq73_u9.qnpn13g2[ie]
print @q.xbgr.xq73_u9.qnpn13g2[is]
print @r.xbgr.xq73_u9.rsub[i]
print @c.xbgr.xq73_u9.csub[i]
print @q.xbgr.xq73_u10.qnpn13g2[ic]
print @q.xbgr.xq73_u10.qnpn13g2[ib]
print @q.xbgr.xq73_u10.qnpn13g2[ie]
print @q.xbgr.xq73_u10.qnpn13g2[is]
print @r.xbgr.xq73_u10.rsub[i]
print @c.xbgr.xq73_u10.csub[i]
print @q.xbgr.xq73_u11.qnpn13g2[ic]
print @q.xbgr.xq73_u11.qnpn13g2[ib]
print @q.xbgr.xq73_u11.qnpn13g2[ie]
print @q.xbgr.xq73_u11.qnpn13g2[is]
print @r.xbgr.xq73_u11.rsub[i]
print @c.xbgr.xq73_u11.csub[i]
print @q.xbgr.xq73_u12.qnpn13g2[ic]
print @q.xbgr.xq73_u12.qnpn13g2[ib]
print @q.xbgr.xq73_u12.qnpn13g2[ie]
print @q.xbgr.xq73_u12.qnpn13g2[is]
print @r.xbgr.xq73_u12.rsub[i]
print @c.xbgr.xq73_u12.csub[i]
print @q.xbgr.xq73_u13.qnpn13g2[ic]
print @q.xbgr.xq73_u13.qnpn13g2[ib]
print @q.xbgr.xq73_u13.qnpn13g2[ie]
print @q.xbgr.xq73_u13.qnpn13g2[is]
print @r.xbgr.xq73_u13.rsub[i]
print @c.xbgr.xq73_u13.csub[i]
print @q.xbgr.xq73_u14.qnpn13g2[ic]
print @q.xbgr.xq73_u14.qnpn13g2[ib]
print @q.xbgr.xq73_u14.qnpn13g2[ie]
print @q.xbgr.xq73_u14.qnpn13g2[is]
print @r.xbgr.xq73_u14.rsub[i]
print @c.xbgr.xq73_u14.csub[i]
print @q.xbgr.xq73_u15.qnpn13g2[ic]
print @q.xbgr.xq73_u15.qnpn13g2[ib]
print @q.xbgr.xq73_u15.qnpn13g2[ie]
print @q.xbgr.xq73_u15.qnpn13g2[is]
print @r.xbgr.xq73_u15.rsub[i]
print @c.xbgr.xq73_u15.csub[i]
print @q.xbgr.xq73_u16.qnpn13g2[ic]
print @q.xbgr.xq73_u16.qnpn13g2[ib]
print @q.xbgr.xq73_u16.qnpn13g2[ie]
print @q.xbgr.xq73_u16.qnpn13g2[is]
print @r.xbgr.xq73_u16.rsub[i]
print @c.xbgr.xq73_u16.csub[i]
print @q.xbgr.xq73_u17.qnpn13g2[ic]
print @q.xbgr.xq73_u17.qnpn13g2[ib]
print @q.xbgr.xq73_u17.qnpn13g2[ie]
print @q.xbgr.xq73_u17.qnpn13g2[is]
print @r.xbgr.xq73_u17.rsub[i]
print @c.xbgr.xq73_u17.csub[i]
print @q.xbgr.xq73_u18.qnpn13g2[ic]
print @q.xbgr.xq73_u18.qnpn13g2[ib]
print @q.xbgr.xq73_u18.qnpn13g2[ie]
print @q.xbgr.xq73_u18.qnpn13g2[is]
print @r.xbgr.xq73_u18.rsub[i]
print @c.xbgr.xq73_u18.csub[i]
print @q.xbgr.xq73_u19.qnpn13g2[ic]
print @q.xbgr.xq73_u19.qnpn13g2[ib]
print @q.xbgr.xq73_u19.qnpn13g2[ie]
print @q.xbgr.xq73_u19.qnpn13g2[is]
print @r.xbgr.xq73_u19.rsub[i]
print @c.xbgr.xq73_u19.csub[i]
print @q.xbgr.xq73_u20.qnpn13g2[ic]
print @q.xbgr.xq73_u20.qnpn13g2[ib]
print @q.xbgr.xq73_u20.qnpn13g2[ie]
print @q.xbgr.xq73_u20.qnpn13g2[is]
print @r.xbgr.xq73_u20.rsub[i]
print @c.xbgr.xq73_u20.csub[i]
print @q.xbgr.xq73_u21.qnpn13g2[ic]
print @q.xbgr.xq73_u21.qnpn13g2[ib]
print @q.xbgr.xq73_u21.qnpn13g2[ie]
print @q.xbgr.xq73_u21.qnpn13g2[is]
print @r.xbgr.xq73_u21.rsub[i]
print @c.xbgr.xq73_u21.csub[i]
print @q.xbgr.xq73_u22.qnpn13g2[ic]
print @q.xbgr.xq73_u22.qnpn13g2[ib]
print @q.xbgr.xq73_u22.qnpn13g2[ie]
print @q.xbgr.xq73_u22.qnpn13g2[is]
print @r.xbgr.xq73_u22.rsub[i]
print @c.xbgr.xq73_u22.csub[i]
print @q.xbgr.xq73_u23.qnpn13g2[ic]
print @q.xbgr.xq73_u23.qnpn13g2[ib]
print @q.xbgr.xq73_u23.qnpn13g2[ie]
print @q.xbgr.xq73_u23.qnpn13g2[is]
print @r.xbgr.xq73_u23.rsub[i]
print @c.xbgr.xq73_u23.csub[i]
print @q.xbgr.xq73_u24.qnpn13g2[ic]
print @q.xbgr.xq73_u24.qnpn13g2[ib]
print @q.xbgr.xq73_u24.qnpn13g2[ie]
print @q.xbgr.xq73_u24.qnpn13g2[is]
print @r.xbgr.xq73_u24.rsub[i]
print @c.xbgr.xq73_u24.csub[i]
print @q.xbgr.xq74_u2.qnpn13g2[ic]
print @q.xbgr.xq74_u2.qnpn13g2[ib]
print @q.xbgr.xq74_u2.qnpn13g2[ie]
print @q.xbgr.xq74_u2.qnpn13g2[is]
print @r.xbgr.xq74_u2.rsub[i]
print @c.xbgr.xq74_u2.csub[i]
print @q.xbgr.xq74_u3.qnpn13g2[ic]
print @q.xbgr.xq74_u3.qnpn13g2[ib]
print @q.xbgr.xq74_u3.qnpn13g2[ie]
print @q.xbgr.xq74_u3.qnpn13g2[is]
print @r.xbgr.xq74_u3.rsub[i]
print @c.xbgr.xq74_u3.csub[i]
print @q.xbgr.xq74_u4.qnpn13g2[ic]
print @q.xbgr.xq74_u4.qnpn13g2[ib]
print @q.xbgr.xq74_u4.qnpn13g2[ie]
print @q.xbgr.xq74_u4.qnpn13g2[is]
print @r.xbgr.xq74_u4.rsub[i]
print @c.xbgr.xq74_u4.csub[i]
print @q.xbgr.xq74_u5.qnpn13g2[ic]
print @q.xbgr.xq74_u5.qnpn13g2[ib]
print @q.xbgr.xq74_u5.qnpn13g2[ie]
print @q.xbgr.xq74_u5.qnpn13g2[is]
print @r.xbgr.xq74_u5.rsub[i]
print @c.xbgr.xq74_u5.csub[i]
print @q.xbgr.xq74_u6.qnpn13g2[ic]
print @q.xbgr.xq74_u6.qnpn13g2[ib]
print @q.xbgr.xq74_u6.qnpn13g2[ie]
print @q.xbgr.xq74_u6.qnpn13g2[is]
print @r.xbgr.xq74_u6.rsub[i]
print @c.xbgr.xq74_u6.csub[i]
print @q.xbgr.xq74_u7.qnpn13g2[ic]
print @q.xbgr.xq74_u7.qnpn13g2[ib]
print @q.xbgr.xq74_u7.qnpn13g2[ie]
print @q.xbgr.xq74_u7.qnpn13g2[is]
print @r.xbgr.xq74_u7.rsub[i]
print @c.xbgr.xq74_u7.csub[i]
print @q.xbgr.xq74_u8.qnpn13g2[ic]
print @q.xbgr.xq74_u8.qnpn13g2[ib]
print @q.xbgr.xq74_u8.qnpn13g2[ie]
print @q.xbgr.xq74_u8.qnpn13g2[is]
print @r.xbgr.xq74_u8.rsub[i]
print @c.xbgr.xq74_u8.csub[i]
print @q.xbgr.xq74_u9.qnpn13g2[ic]
print @q.xbgr.xq74_u9.qnpn13g2[ib]
print @q.xbgr.xq74_u9.qnpn13g2[ie]
print @q.xbgr.xq74_u9.qnpn13g2[is]
print @r.xbgr.xq74_u9.rsub[i]
print @c.xbgr.xq74_u9.csub[i]
print @q.xbgr.xq74_u10.qnpn13g2[ic]
print @q.xbgr.xq74_u10.qnpn13g2[ib]
print @q.xbgr.xq74_u10.qnpn13g2[ie]
print @q.xbgr.xq74_u10.qnpn13g2[is]
print @r.xbgr.xq74_u10.rsub[i]
print @c.xbgr.xq74_u10.csub[i]
print @q.xbgr.xq74_u11.qnpn13g2[ic]
print @q.xbgr.xq74_u11.qnpn13g2[ib]
print @q.xbgr.xq74_u11.qnpn13g2[ie]
print @q.xbgr.xq74_u11.qnpn13g2[is]
print @r.xbgr.xq74_u11.rsub[i]
print @c.xbgr.xq74_u11.csub[i]
print @q.xbgr.xq74_u12.qnpn13g2[ic]
print @q.xbgr.xq74_u12.qnpn13g2[ib]
print @q.xbgr.xq74_u12.qnpn13g2[ie]
print @q.xbgr.xq74_u12.qnpn13g2[is]
print @r.xbgr.xq74_u12.rsub[i]
print @c.xbgr.xq74_u12.csub[i]
print @q.xbgr.xq74_u13.qnpn13g2[ic]
print @q.xbgr.xq74_u13.qnpn13g2[ib]
print @q.xbgr.xq74_u13.qnpn13g2[ie]
print @q.xbgr.xq74_u13.qnpn13g2[is]
print @r.xbgr.xq74_u13.rsub[i]
print @c.xbgr.xq74_u13.csub[i]
print @q.xbgr.xq74_u14.qnpn13g2[ic]
print @q.xbgr.xq74_u14.qnpn13g2[ib]
print @q.xbgr.xq74_u14.qnpn13g2[ie]
print @q.xbgr.xq74_u14.qnpn13g2[is]
print @r.xbgr.xq74_u14.rsub[i]
print @c.xbgr.xq74_u14.csub[i]
print @q.xbgr.xq74_u15.qnpn13g2[ic]
print @q.xbgr.xq74_u15.qnpn13g2[ib]
print @q.xbgr.xq74_u15.qnpn13g2[ie]
print @q.xbgr.xq74_u15.qnpn13g2[is]
print @r.xbgr.xq74_u15.rsub[i]
print @c.xbgr.xq74_u15.csub[i]
print @q.xbgr.xq74_u16.qnpn13g2[ic]
print @q.xbgr.xq74_u16.qnpn13g2[ib]
print @q.xbgr.xq74_u16.qnpn13g2[ie]
print @q.xbgr.xq74_u16.qnpn13g2[is]
print @r.xbgr.xq74_u16.rsub[i]
print @c.xbgr.xq74_u16.csub[i]
print @q.xbgr.xq74_u17.qnpn13g2[ic]
print @q.xbgr.xq74_u17.qnpn13g2[ib]
print @q.xbgr.xq74_u17.qnpn13g2[ie]
print @q.xbgr.xq74_u17.qnpn13g2[is]
print @r.xbgr.xq74_u17.rsub[i]
print @c.xbgr.xq74_u17.csub[i]
print @q.xbgr.xq74_u18.qnpn13g2[ic]
print @q.xbgr.xq74_u18.qnpn13g2[ib]
print @q.xbgr.xq74_u18.qnpn13g2[ie]
print @q.xbgr.xq74_u18.qnpn13g2[is]
print @r.xbgr.xq74_u18.rsub[i]
print @c.xbgr.xq74_u18.csub[i]
print @q.xbgr.xq74_u19.qnpn13g2[ic]
print @q.xbgr.xq74_u19.qnpn13g2[ib]
print @q.xbgr.xq74_u19.qnpn13g2[ie]
print @q.xbgr.xq74_u19.qnpn13g2[is]
print @r.xbgr.xq74_u19.rsub[i]
print @c.xbgr.xq74_u19.csub[i]
print @q.xbgr.xq74_u20.qnpn13g2[ic]
print @q.xbgr.xq74_u20.qnpn13g2[ib]
print @q.xbgr.xq74_u20.qnpn13g2[ie]
print @q.xbgr.xq74_u20.qnpn13g2[is]
print @r.xbgr.xq74_u20.rsub[i]
print @c.xbgr.xq74_u20.csub[i]
print @q.xbgr.xq74_u21.qnpn13g2[ic]
print @q.xbgr.xq74_u21.qnpn13g2[ib]
print @q.xbgr.xq74_u21.qnpn13g2[ie]
print @q.xbgr.xq74_u21.qnpn13g2[is]
print @r.xbgr.xq74_u21.rsub[i]
print @c.xbgr.xq74_u21.csub[i]
print @q.xbgr.xq74_u22.qnpn13g2[ic]
print @q.xbgr.xq74_u22.qnpn13g2[ib]
print @q.xbgr.xq74_u22.qnpn13g2[ie]
print @q.xbgr.xq74_u22.qnpn13g2[is]
print @r.xbgr.xq74_u22.rsub[i]
print @c.xbgr.xq74_u22.csub[i]
print @q.xbgr.xq74_u23.qnpn13g2[ic]
print @q.xbgr.xq74_u23.qnpn13g2[ib]
print @q.xbgr.xq74_u23.qnpn13g2[ie]
print @q.xbgr.xq74_u23.qnpn13g2[is]
print @r.xbgr.xq74_u23.rsub[i]
print @c.xbgr.xq74_u23.csub[i]
print @q.xbgr.xq74_u24.qnpn13g2[ic]
print @q.xbgr.xq74_u24.qnpn13g2[ib]
print @q.xbgr.xq74_u24.qnpn13g2[ie]
print @q.xbgr.xq74_u24.qnpn13g2[is]
print @r.xbgr.xq74_u24.rsub[i]
print @c.xbgr.xq74_u24.csub[i]
print @q.xbgr.xq75_u2.qnpn13g2[ic]
print @q.xbgr.xq75_u2.qnpn13g2[ib]
print @q.xbgr.xq75_u2.qnpn13g2[ie]
print @q.xbgr.xq75_u2.qnpn13g2[is]
print @r.xbgr.xq75_u2.rsub[i]
print @c.xbgr.xq75_u2.csub[i]
print @q.xbgr.xq75_u3.qnpn13g2[ic]
print @q.xbgr.xq75_u3.qnpn13g2[ib]
print @q.xbgr.xq75_u3.qnpn13g2[ie]
print @q.xbgr.xq75_u3.qnpn13g2[is]
print @r.xbgr.xq75_u3.rsub[i]
print @c.xbgr.xq75_u3.csub[i]
print @q.xbgr.xq75_u4.qnpn13g2[ic]
print @q.xbgr.xq75_u4.qnpn13g2[ib]
print @q.xbgr.xq75_u4.qnpn13g2[ie]
print @q.xbgr.xq75_u4.qnpn13g2[is]
print @r.xbgr.xq75_u4.rsub[i]
print @c.xbgr.xq75_u4.csub[i]
print @q.xbgr.xq75_u5.qnpn13g2[ic]
print @q.xbgr.xq75_u5.qnpn13g2[ib]
print @q.xbgr.xq75_u5.qnpn13g2[ie]
print @q.xbgr.xq75_u5.qnpn13g2[is]
print @r.xbgr.xq75_u5.rsub[i]
print @c.xbgr.xq75_u5.csub[i]
print @q.xbgr.xq75_u6.qnpn13g2[ic]
print @q.xbgr.xq75_u6.qnpn13g2[ib]
print @q.xbgr.xq75_u6.qnpn13g2[ie]
print @q.xbgr.xq75_u6.qnpn13g2[is]
print @r.xbgr.xq75_u6.rsub[i]
print @c.xbgr.xq75_u6.csub[i]
print @q.xbgr.xq75_u7.qnpn13g2[ic]
print @q.xbgr.xq75_u7.qnpn13g2[ib]
print @q.xbgr.xq75_u7.qnpn13g2[ie]
print @q.xbgr.xq75_u7.qnpn13g2[is]
print @r.xbgr.xq75_u7.rsub[i]
print @c.xbgr.xq75_u7.csub[i]
print @q.xbgr.xq75_u8.qnpn13g2[ic]
print @q.xbgr.xq75_u8.qnpn13g2[ib]
print @q.xbgr.xq75_u8.qnpn13g2[ie]
print @q.xbgr.xq75_u8.qnpn13g2[is]
print @r.xbgr.xq75_u8.rsub[i]
print @c.xbgr.xq75_u8.csub[i]
print @q.xbgr.xq75_u9.qnpn13g2[ic]
print @q.xbgr.xq75_u9.qnpn13g2[ib]
print @q.xbgr.xq75_u9.qnpn13g2[ie]
print @q.xbgr.xq75_u9.qnpn13g2[is]
print @r.xbgr.xq75_u9.rsub[i]
print @c.xbgr.xq75_u9.csub[i]
print @q.xbgr.xq75_u10.qnpn13g2[ic]
print @q.xbgr.xq75_u10.qnpn13g2[ib]
print @q.xbgr.xq75_u10.qnpn13g2[ie]
print @q.xbgr.xq75_u10.qnpn13g2[is]
print @r.xbgr.xq75_u10.rsub[i]
print @c.xbgr.xq75_u10.csub[i]
print @q.xbgr.xq75_u11.qnpn13g2[ic]
print @q.xbgr.xq75_u11.qnpn13g2[ib]
print @q.xbgr.xq75_u11.qnpn13g2[ie]
print @q.xbgr.xq75_u11.qnpn13g2[is]
print @r.xbgr.xq75_u11.rsub[i]
print @c.xbgr.xq75_u11.csub[i]
print @q.xbgr.xq75_u12.qnpn13g2[ic]
print @q.xbgr.xq75_u12.qnpn13g2[ib]
print @q.xbgr.xq75_u12.qnpn13g2[ie]
print @q.xbgr.xq75_u12.qnpn13g2[is]
print @r.xbgr.xq75_u12.rsub[i]
print @c.xbgr.xq75_u12.csub[i]
print @q.xbgr.xq75_u13.qnpn13g2[ic]
print @q.xbgr.xq75_u13.qnpn13g2[ib]
print @q.xbgr.xq75_u13.qnpn13g2[ie]
print @q.xbgr.xq75_u13.qnpn13g2[is]
print @r.xbgr.xq75_u13.rsub[i]
print @c.xbgr.xq75_u13.csub[i]
print @q.xbgr.xq75_u14.qnpn13g2[ic]
print @q.xbgr.xq75_u14.qnpn13g2[ib]
print @q.xbgr.xq75_u14.qnpn13g2[ie]
print @q.xbgr.xq75_u14.qnpn13g2[is]
print @r.xbgr.xq75_u14.rsub[i]
print @c.xbgr.xq75_u14.csub[i]
print @q.xbgr.xq75_u15.qnpn13g2[ic]
print @q.xbgr.xq75_u15.qnpn13g2[ib]
print @q.xbgr.xq75_u15.qnpn13g2[ie]
print @q.xbgr.xq75_u15.qnpn13g2[is]
print @r.xbgr.xq75_u15.rsub[i]
print @c.xbgr.xq75_u15.csub[i]
print @q.xbgr.xq75_u16.qnpn13g2[ic]
print @q.xbgr.xq75_u16.qnpn13g2[ib]
print @q.xbgr.xq75_u16.qnpn13g2[ie]
print @q.xbgr.xq75_u16.qnpn13g2[is]
print @r.xbgr.xq75_u16.rsub[i]
print @c.xbgr.xq75_u16.csub[i]
print @q.xbgr.xq75_u17.qnpn13g2[ic]
print @q.xbgr.xq75_u17.qnpn13g2[ib]
print @q.xbgr.xq75_u17.qnpn13g2[ie]
print @q.xbgr.xq75_u17.qnpn13g2[is]
print @r.xbgr.xq75_u17.rsub[i]
print @c.xbgr.xq75_u17.csub[i]
print @q.xbgr.xq75_u18.qnpn13g2[ic]
print @q.xbgr.xq75_u18.qnpn13g2[ib]
print @q.xbgr.xq75_u18.qnpn13g2[ie]
print @q.xbgr.xq75_u18.qnpn13g2[is]
print @r.xbgr.xq75_u18.rsub[i]
print @c.xbgr.xq75_u18.csub[i]
print @q.xbgr.xq75_u19.qnpn13g2[ic]
print @q.xbgr.xq75_u19.qnpn13g2[ib]
print @q.xbgr.xq75_u19.qnpn13g2[ie]
print @q.xbgr.xq75_u19.qnpn13g2[is]
print @r.xbgr.xq75_u19.rsub[i]
print @c.xbgr.xq75_u19.csub[i]
print @q.xbgr.xq75_u20.qnpn13g2[ic]
print @q.xbgr.xq75_u20.qnpn13g2[ib]
print @q.xbgr.xq75_u20.qnpn13g2[ie]
print @q.xbgr.xq75_u20.qnpn13g2[is]
print @r.xbgr.xq75_u20.rsub[i]
print @c.xbgr.xq75_u20.csub[i]
print @q.xbgr.xq75_u21.qnpn13g2[ic]
print @q.xbgr.xq75_u21.qnpn13g2[ib]
print @q.xbgr.xq75_u21.qnpn13g2[ie]
print @q.xbgr.xq75_u21.qnpn13g2[is]
print @r.xbgr.xq75_u21.rsub[i]
print @c.xbgr.xq75_u21.csub[i]
print @q.xbgr.xq75_u22.qnpn13g2[ic]
print @q.xbgr.xq75_u22.qnpn13g2[ib]
print @q.xbgr.xq75_u22.qnpn13g2[ie]
print @q.xbgr.xq75_u22.qnpn13g2[is]
print @r.xbgr.xq75_u22.rsub[i]
print @c.xbgr.xq75_u22.csub[i]
print @q.xbgr.xq75_u23.qnpn13g2[ic]
print @q.xbgr.xq75_u23.qnpn13g2[ib]
print @q.xbgr.xq75_u23.qnpn13g2[ie]
print @q.xbgr.xq75_u23.qnpn13g2[is]
print @r.xbgr.xq75_u23.rsub[i]
print @c.xbgr.xq75_u23.csub[i]
print @q.xbgr.xq75_u24.qnpn13g2[ic]
print @q.xbgr.xq75_u24.qnpn13g2[ib]
print @q.xbgr.xq75_u24.qnpn13g2[ie]
print @q.xbgr.xq75_u24.qnpn13g2[is]
print @r.xbgr.xq75_u24.rsub[i]
print @c.xbgr.xq75_u24.csub[i]
print @q.xbgr.xq76_u2.qnpn13g2[ic]
print @q.xbgr.xq76_u2.qnpn13g2[ib]
print @q.xbgr.xq76_u2.qnpn13g2[ie]
print @q.xbgr.xq76_u2.qnpn13g2[is]
print @r.xbgr.xq76_u2.rsub[i]
print @c.xbgr.xq76_u2.csub[i]
print @q.xbgr.xq76_u3.qnpn13g2[ic]
print @q.xbgr.xq76_u3.qnpn13g2[ib]
print @q.xbgr.xq76_u3.qnpn13g2[ie]
print @q.xbgr.xq76_u3.qnpn13g2[is]
print @r.xbgr.xq76_u3.rsub[i]
print @c.xbgr.xq76_u3.csub[i]
print @q.xbgr.xq76_u4.qnpn13g2[ic]
print @q.xbgr.xq76_u4.qnpn13g2[ib]
print @q.xbgr.xq76_u4.qnpn13g2[ie]
print @q.xbgr.xq76_u4.qnpn13g2[is]
print @r.xbgr.xq76_u4.rsub[i]
print @c.xbgr.xq76_u4.csub[i]
print @q.xbgr.xq76_u5.qnpn13g2[ic]
print @q.xbgr.xq76_u5.qnpn13g2[ib]
print @q.xbgr.xq76_u5.qnpn13g2[ie]
print @q.xbgr.xq76_u5.qnpn13g2[is]
print @r.xbgr.xq76_u5.rsub[i]
print @c.xbgr.xq76_u5.csub[i]
print @q.xbgr.xq76_u6.qnpn13g2[ic]
print @q.xbgr.xq76_u6.qnpn13g2[ib]
print @q.xbgr.xq76_u6.qnpn13g2[ie]
print @q.xbgr.xq76_u6.qnpn13g2[is]
print @r.xbgr.xq76_u6.rsub[i]
print @c.xbgr.xq76_u6.csub[i]
print @q.xbgr.xq76_u7.qnpn13g2[ic]
print @q.xbgr.xq76_u7.qnpn13g2[ib]
print @q.xbgr.xq76_u7.qnpn13g2[ie]
print @q.xbgr.xq76_u7.qnpn13g2[is]
print @r.xbgr.xq76_u7.rsub[i]
print @c.xbgr.xq76_u7.csub[i]
print @q.xbgr.xq76_u8.qnpn13g2[ic]
print @q.xbgr.xq76_u8.qnpn13g2[ib]
print @q.xbgr.xq76_u8.qnpn13g2[ie]
print @q.xbgr.xq76_u8.qnpn13g2[is]
print @r.xbgr.xq76_u8.rsub[i]
print @c.xbgr.xq76_u8.csub[i]
print @q.xbgr.xq76_u9.qnpn13g2[ic]
print @q.xbgr.xq76_u9.qnpn13g2[ib]
print @q.xbgr.xq76_u9.qnpn13g2[ie]
print @q.xbgr.xq76_u9.qnpn13g2[is]
print @r.xbgr.xq76_u9.rsub[i]
print @c.xbgr.xq76_u9.csub[i]
print @q.xbgr.xq76_u10.qnpn13g2[ic]
print @q.xbgr.xq76_u10.qnpn13g2[ib]
print @q.xbgr.xq76_u10.qnpn13g2[ie]
print @q.xbgr.xq76_u10.qnpn13g2[is]
print @r.xbgr.xq76_u10.rsub[i]
print @c.xbgr.xq76_u10.csub[i]
print @q.xbgr.xq76_u11.qnpn13g2[ic]
print @q.xbgr.xq76_u11.qnpn13g2[ib]
print @q.xbgr.xq76_u11.qnpn13g2[ie]
print @q.xbgr.xq76_u11.qnpn13g2[is]
print @r.xbgr.xq76_u11.rsub[i]
print @c.xbgr.xq76_u11.csub[i]
print @q.xbgr.xq76_u12.qnpn13g2[ic]
print @q.xbgr.xq76_u12.qnpn13g2[ib]
print @q.xbgr.xq76_u12.qnpn13g2[ie]
print @q.xbgr.xq76_u12.qnpn13g2[is]
print @r.xbgr.xq76_u12.rsub[i]
print @c.xbgr.xq76_u12.csub[i]
print @q.xbgr.xq76_u13.qnpn13g2[ic]
print @q.xbgr.xq76_u13.qnpn13g2[ib]
print @q.xbgr.xq76_u13.qnpn13g2[ie]
print @q.xbgr.xq76_u13.qnpn13g2[is]
print @r.xbgr.xq76_u13.rsub[i]
print @c.xbgr.xq76_u13.csub[i]
print @q.xbgr.xq76_u14.qnpn13g2[ic]
print @q.xbgr.xq76_u14.qnpn13g2[ib]
print @q.xbgr.xq76_u14.qnpn13g2[ie]
print @q.xbgr.xq76_u14.qnpn13g2[is]
print @r.xbgr.xq76_u14.rsub[i]
print @c.xbgr.xq76_u14.csub[i]
print @q.xbgr.xq76_u15.qnpn13g2[ic]
print @q.xbgr.xq76_u15.qnpn13g2[ib]
print @q.xbgr.xq76_u15.qnpn13g2[ie]
print @q.xbgr.xq76_u15.qnpn13g2[is]
print @r.xbgr.xq76_u15.rsub[i]
print @c.xbgr.xq76_u15.csub[i]
print @q.xbgr.xq76_u16.qnpn13g2[ic]
print @q.xbgr.xq76_u16.qnpn13g2[ib]
print @q.xbgr.xq76_u16.qnpn13g2[ie]
print @q.xbgr.xq76_u16.qnpn13g2[is]
print @r.xbgr.xq76_u16.rsub[i]
print @c.xbgr.xq76_u16.csub[i]
print @q.xbgr.xq76_u17.qnpn13g2[ic]
print @q.xbgr.xq76_u17.qnpn13g2[ib]
print @q.xbgr.xq76_u17.qnpn13g2[ie]
print @q.xbgr.xq76_u17.qnpn13g2[is]
print @r.xbgr.xq76_u17.rsub[i]
print @c.xbgr.xq76_u17.csub[i]
print @q.xbgr.xq76_u18.qnpn13g2[ic]
print @q.xbgr.xq76_u18.qnpn13g2[ib]
print @q.xbgr.xq76_u18.qnpn13g2[ie]
print @q.xbgr.xq76_u18.qnpn13g2[is]
print @r.xbgr.xq76_u18.rsub[i]
print @c.xbgr.xq76_u18.csub[i]
print @q.xbgr.xq76_u19.qnpn13g2[ic]
print @q.xbgr.xq76_u19.qnpn13g2[ib]
print @q.xbgr.xq76_u19.qnpn13g2[ie]
print @q.xbgr.xq76_u19.qnpn13g2[is]
print @r.xbgr.xq76_u19.rsub[i]
print @c.xbgr.xq76_u19.csub[i]
print @q.xbgr.xq76_u20.qnpn13g2[ic]
print @q.xbgr.xq76_u20.qnpn13g2[ib]
print @q.xbgr.xq76_u20.qnpn13g2[ie]
print @q.xbgr.xq76_u20.qnpn13g2[is]
print @r.xbgr.xq76_u20.rsub[i]
print @c.xbgr.xq76_u20.csub[i]
print @q.xbgr.xq76_u21.qnpn13g2[ic]
print @q.xbgr.xq76_u21.qnpn13g2[ib]
print @q.xbgr.xq76_u21.qnpn13g2[ie]
print @q.xbgr.xq76_u21.qnpn13g2[is]
print @r.xbgr.xq76_u21.rsub[i]
print @c.xbgr.xq76_u21.csub[i]
print @q.xbgr.xq76_u22.qnpn13g2[ic]
print @q.xbgr.xq76_u22.qnpn13g2[ib]
print @q.xbgr.xq76_u22.qnpn13g2[ie]
print @q.xbgr.xq76_u22.qnpn13g2[is]
print @r.xbgr.xq76_u22.rsub[i]
print @c.xbgr.xq76_u22.csub[i]
print @q.xbgr.xq76_u23.qnpn13g2[ic]
print @q.xbgr.xq76_u23.qnpn13g2[ib]
print @q.xbgr.xq76_u23.qnpn13g2[ie]
print @q.xbgr.xq76_u23.qnpn13g2[is]
print @r.xbgr.xq76_u23.rsub[i]
print @c.xbgr.xq76_u23.csub[i]
print @q.xbgr.xq76_u24.qnpn13g2[ic]
print @q.xbgr.xq76_u24.qnpn13g2[ib]
print @q.xbgr.xq76_u24.qnpn13g2[ie]
print @q.xbgr.xq76_u24.qnpn13g2[is]
print @r.xbgr.xq76_u24.rsub[i]
print @c.xbgr.xq76_u24.csub[i]
print @n.xbgr.xr77_u2.nr1[ibody]
print @n.xbgr.xr77_u3.nr1[ibody]
print @n.xbgr.xr77_u4.nr1[ibody]
print @n.xbgr.xr77_u5.nr1[ibody]
print @n.xbgr.xr77_u6.nr1[ibody]
print @n.xbgr.xr77_u7.nr1[ibody]
print @n.xbgr.xr77_u8.nr1[ibody]
print @n.xbgr.xr77_u9.nr1[ibody]
print @n.xbgr.xr77_u10.nr1[ibody]
print @n.xbgr.xr77_u11.nr1[ibody]
print @n.xbgr.xr77_u12.nr1[ibody]
print @n.xbgr.xr77_u13.nr1[ibody]
print @n.xbgr.xr77_u14.nr1[ibody]
print @n.xbgr.xr77_u15.nr1[ibody]
print @n.xbgr.xr77_u16.nr1[ibody]
print @n.xbgr.xr77_u17.nr1[ibody]
print @n.xbgr.xr77_u18.nr1[ibody]
print @n.xbgr.xr77_u19.nr1[ibody]
print @n.xbgr.xr77_u20.nr1[ibody]
print @n.xbgr.xr77_u21.nr1[ibody]
print @n.xbgr.xr77_u22.nr1[ibody]
print @n.xbgr.xr77_u23.nr1[ibody]
print @n.xbgr.xr77_u24.nr1[ibody]
print @n.xbgr.xr78_u2.nr1[ibody]
print @n.xbgr.xr78_u3.nr1[ibody]
print @n.xbgr.xr78_u4.nr1[ibody]
print @n.xbgr.xr78_u5.nr1[ibody]
print @n.xbgr.xr78_u6.nr1[ibody]
print @n.xbgr.xr78_u7.nr1[ibody]
print @n.xbgr.xr78_u8.nr1[ibody]
print @n.xbgr.xr78_u9.nr1[ibody]
print @n.xbgr.xr78_u10.nr1[ibody]
print @n.xbgr.xr78_u11.nr1[ibody]
print @n.xbgr.xr78_u12.nr1[ibody]
print @n.xbgr.xr78_u13.nr1[ibody]
print @n.xbgr.xr78_u14.nr1[ibody]
print @n.xbgr.xr78_u15.nr1[ibody]
print @n.xbgr.xr78_u16.nr1[ibody]
print @n.xbgr.xr78_u17.nr1[ibody]
print @n.xbgr.xr78_u18.nr1[ibody]
print @n.xbgr.xr78_u19.nr1[ibody]
print @n.xbgr.xr78_u20.nr1[ibody]
print @n.xbgr.xr78_u21.nr1[ibody]
print @n.xbgr.xr78_u22.nr1[ibody]
print @n.xbgr.xr78_u23.nr1[ibody]
print @n.xbgr.xr78_u24.nr1[ibody]
print @n.xbgr.xr79_u2.nr1[ibody]
print @n.xbgr.xr79_u3.nr1[ibody]
print @n.xbgr.xr79_u4.nr1[ibody]
print @n.xbgr.xr79_u5.nr1[ibody]
print @n.xbgr.xr79_u6.nr1[ibody]
print @n.xbgr.xr79_u7.nr1[ibody]
print @n.xbgr.xr79_u8.nr1[ibody]
print @n.xbgr.xr79_u9.nr1[ibody]
print @n.xbgr.xr79_u10.nr1[ibody]
print @n.xbgr.xr79_u11.nr1[ibody]
print @n.xbgr.xr79_u12.nr1[ibody]
print @n.xbgr.xr79_u13.nr1[ibody]
print @n.xbgr.xr79_u14.nr1[ibody]
print @n.xbgr.xr79_u15.nr1[ibody]
print @n.xbgr.xr79_u16.nr1[ibody]
print @n.xbgr.xr79_u17.nr1[ibody]
print @n.xbgr.xr79_u18.nr1[ibody]
print @n.xbgr.xr79_u19.nr1[ibody]
print @n.xbgr.xr79_u20.nr1[ibody]
print @n.xbgr.xr79_u21.nr1[ibody]
print @n.xbgr.xr79_u22.nr1[ibody]
print @n.xbgr.xr79_u23.nr1[ibody]
print @n.xbgr.xr79_u24.nr1[ibody]
print @n.xbgr.xr80_u2.nr1[ibody]
print @n.xbgr.xr80_u3.nr1[ibody]
print @n.xbgr.xr80_u4.nr1[ibody]
print @n.xbgr.xr80_u5.nr1[ibody]
print @n.xbgr.xr80_u6.nr1[ibody]
print @n.xbgr.xr80_u7.nr1[ibody]
print @n.xbgr.xr80_u8.nr1[ibody]
print @n.xbgr.xr80_u9.nr1[ibody]
print @n.xbgr.xr80_u10.nr1[ibody]
print @n.xbgr.xr80_u11.nr1[ibody]
print @n.xbgr.xr80_u12.nr1[ibody]
print @n.xbgr.xr80_u13.nr1[ibody]
print @n.xbgr.xr80_u14.nr1[ibody]
print @n.xbgr.xr80_u15.nr1[ibody]
print @n.xbgr.xr80_u16.nr1[ibody]
print @n.xbgr.xr80_u17.nr1[ibody]
print @n.xbgr.xr80_u18.nr1[ibody]
print @n.xbgr.xr80_u19.nr1[ibody]
print @n.xbgr.xr80_u20.nr1[ibody]
print @n.xbgr.xr80_u21.nr1[ibody]
print @n.xbgr.xr80_u22.nr1[ibody]
print @n.xbgr.xr80_u23.nr1[ibody]
print @n.xbgr.xr80_u24.nr1[ibody]
print @n.xbgr.xr81_u2.nr1[ibody]
print @n.xbgr.xr81_u3.nr1[ibody]
print @n.xbgr.xr81_u4.nr1[ibody]
print @n.xbgr.xr81_u5.nr1[ibody]
print @n.xbgr.xr81_u6.nr1[ibody]
print @n.xbgr.xr81_u7.nr1[ibody]
print @n.xbgr.xr81_u8.nr1[ibody]
print @n.xbgr.xr81_u9.nr1[ibody]
print @n.xbgr.xr81_u10.nr1[ibody]
print @n.xbgr.xr81_u11.nr1[ibody]
print @n.xbgr.xr81_u12.nr1[ibody]
print @n.xbgr.xr81_u13.nr1[ibody]
print @n.xbgr.xr81_u14.nr1[ibody]
print @n.xbgr.xr81_u15.nr1[ibody]
print @n.xbgr.xr81_u16.nr1[ibody]
print @n.xbgr.xr81_u17.nr1[ibody]
print @n.xbgr.xr81_u18.nr1[ibody]
print @n.xbgr.xr81_u19.nr1[ibody]
print @n.xbgr.xr81_u20.nr1[ibody]
print @n.xbgr.xr81_u21.nr1[ibody]
print @n.xbgr.xr81_u22.nr1[ibody]
print @n.xbgr.xr81_u23.nr1[ibody]
print @n.xbgr.xr81_u24.nr1[ibody]
print @n.xbgr.xr82_u2.nr1[ibody]
print @n.xbgr.xr82_u3.nr1[ibody]
print @n.xbgr.xr82_u4.nr1[ibody]
print @n.xbgr.xr82_u5.nr1[ibody]
print @n.xbgr.xr82_u6.nr1[ibody]
print @n.xbgr.xr82_u7.nr1[ibody]
print @n.xbgr.xr82_u8.nr1[ibody]
print @n.xbgr.xr82_u9.nr1[ibody]
print @n.xbgr.xr82_u10.nr1[ibody]
print @n.xbgr.xr82_u11.nr1[ibody]
print @n.xbgr.xr82_u12.nr1[ibody]
print @n.xbgr.xr82_u13.nr1[ibody]
print @n.xbgr.xr82_u14.nr1[ibody]
print @n.xbgr.xr82_u15.nr1[ibody]
print @n.xbgr.xr82_u16.nr1[ibody]
print @n.xbgr.xr82_u17.nr1[ibody]
print @n.xbgr.xr82_u18.nr1[ibody]
print @n.xbgr.xr82_u19.nr1[ibody]
print @n.xbgr.xr82_u20.nr1[ibody]
print @n.xbgr.xr82_u21.nr1[ibody]
print @n.xbgr.xr82_u22.nr1[ibody]
print @n.xbgr.xr82_u23.nr1[ibody]
print @n.xbgr.xr82_u24.nr1[ibody]
print @n.xbgr.xr83_u2.nr1[ibody]
print @n.xbgr.xr83_u3.nr1[ibody]
print @n.xbgr.xr83_u4.nr1[ibody]
print @n.xbgr.xr83_u5.nr1[ibody]
print @n.xbgr.xr83_u6.nr1[ibody]
print @n.xbgr.xr83_u7.nr1[ibody]
print @n.xbgr.xr83_u8.nr1[ibody]
print @n.xbgr.xr83_u9.nr1[ibody]
print @n.xbgr.xr83_u10.nr1[ibody]
print @n.xbgr.xr83_u11.nr1[ibody]
print @n.xbgr.xr83_u12.nr1[ibody]
print @n.xbgr.xr83_u13.nr1[ibody]
print @n.xbgr.xr83_u14.nr1[ibody]
print @n.xbgr.xr83_u15.nr1[ibody]
print @n.xbgr.xr83_u16.nr1[ibody]
print @n.xbgr.xr83_u17.nr1[ibody]
print @n.xbgr.xr83_u18.nr1[ibody]
print @n.xbgr.xr83_u19.nr1[ibody]
print @n.xbgr.xr83_u20.nr1[ibody]
print @n.xbgr.xr83_u21.nr1[ibody]
print @n.xbgr.xr83_u22.nr1[ibody]
print @n.xbgr.xr83_u23.nr1[ibody]
print @n.xbgr.xr83_u24.nr1[ibody]
print @n.xbgr.xr84_u2.nr1[ibody]
print @n.xbgr.xr84_u3.nr1[ibody]
print @n.xbgr.xr84_u4.nr1[ibody]
print @n.xbgr.xr84_u5.nr1[ibody]
print @n.xbgr.xr84_u6.nr1[ibody]
print @n.xbgr.xr84_u7.nr1[ibody]
print @n.xbgr.xr84_u8.nr1[ibody]
print @n.xbgr.xr84_u9.nr1[ibody]
print @n.xbgr.xr84_u10.nr1[ibody]
print @n.xbgr.xr84_u11.nr1[ibody]
print @n.xbgr.xr84_u12.nr1[ibody]
print @n.xbgr.xr84_u13.nr1[ibody]
print @n.xbgr.xr84_u14.nr1[ibody]
print @n.xbgr.xr84_u15.nr1[ibody]
print @n.xbgr.xr84_u16.nr1[ibody]
print @n.xbgr.xr84_u17.nr1[ibody]
print @n.xbgr.xr84_u18.nr1[ibody]
print @n.xbgr.xr84_u19.nr1[ibody]
print @n.xbgr.xr84_u20.nr1[ibody]
print @n.xbgr.xr84_u21.nr1[ibody]
print @n.xbgr.xr84_u22.nr1[ibody]
print @n.xbgr.xr84_u23.nr1[ibody]
print @n.xbgr.xr84_u24.nr1[ibody]
print @n.xbgr.xr85_u2.nr1[ibody]
print @n.xbgr.xr85_u3.nr1[ibody]
print @n.xbgr.xr85_u4.nr1[ibody]
print @n.xbgr.xr85_u5.nr1[ibody]
print @n.xbgr.xr85_u6.nr1[ibody]
print @n.xbgr.xr85_u7.nr1[ibody]
print @n.xbgr.xr85_u8.nr1[ibody]
print @n.xbgr.xr85_u9.nr1[ibody]
print @n.xbgr.xr85_u10.nr1[ibody]
print @n.xbgr.xr85_u11.nr1[ibody]
print @n.xbgr.xr85_u12.nr1[ibody]
print @n.xbgr.xr85_u13.nr1[ibody]
print @n.xbgr.xr85_u14.nr1[ibody]
print @n.xbgr.xr85_u15.nr1[ibody]
print @n.xbgr.xr85_u16.nr1[ibody]
print @n.xbgr.xr85_u17.nr1[ibody]
print @n.xbgr.xr85_u18.nr1[ibody]
print @n.xbgr.xr85_u19.nr1[ibody]
print @n.xbgr.xr85_u20.nr1[ibody]
print @n.xbgr.xr85_u21.nr1[ibody]
print @n.xbgr.xr85_u22.nr1[ibody]
print @n.xbgr.xr85_u23.nr1[ibody]
print @n.xbgr.xr85_u24.nr1[ibody]
print @n.xbgr.xr86_u2.nr1[ibody]
print @n.xbgr.xr86_u3.nr1[ibody]
print @n.xbgr.xr86_u4.nr1[ibody]
print @n.xbgr.xr86_u5.nr1[ibody]
print @n.xbgr.xr86_u6.nr1[ibody]
print @n.xbgr.xr86_u7.nr1[ibody]
print @n.xbgr.xr86_u8.nr1[ibody]
print @n.xbgr.xr86_u9.nr1[ibody]
print @n.xbgr.xr86_u10.nr1[ibody]
print @n.xbgr.xr86_u11.nr1[ibody]
print @n.xbgr.xr86_u12.nr1[ibody]
print @n.xbgr.xr86_u13.nr1[ibody]
print @n.xbgr.xr86_u14.nr1[ibody]
print @n.xbgr.xr86_u15.nr1[ibody]
print @n.xbgr.xr86_u16.nr1[ibody]
print @n.xbgr.xr86_u17.nr1[ibody]
print @n.xbgr.xr86_u18.nr1[ibody]
print @n.xbgr.xr86_u19.nr1[ibody]
print @n.xbgr.xr86_u20.nr1[ibody]
print @n.xbgr.xr86_u21.nr1[ibody]
print @n.xbgr.xr86_u22.nr1[ibody]
print @n.xbgr.xr86_u23.nr1[ibody]
print @n.xbgr.xr86_u24.nr1[ibody]
echo RAW_CURRENT_LEDGER_END
wrdata op_nodes.dat v(xbgr.b1b) v(xbgr.c2) v(xbgr.d1) v(xbgr.d2) v(xbgr.d3) v(xbgr.d4) v(xbgr.d5) v(xbgr.det) v(dvbe) v(iptat) v(xbgr.kick) v(xbgr.n1) v(xbgr.n_10) v(xbgr.n_11) v(xbgr.n_12) v(xbgr.n_13) v(xbgr.n_14) v(xbgr.n_15) v(xbgr.n_16) v(xbgr.n_17) v(xbgr.n_18) v(xbgr.n_19) v(xbgr.n_2) v(xbgr.n_21) v(xbgr.n_22) v(xbgr.n_23) v(xbgr.n_24) v(xbgr.n_25) v(xbgr.n_26) v(xbgr.n_27) v(xbgr.n_3) v(xbgr.n_30) v(xbgr.n_31) v(xbgr.n_33) v(xbgr.n_34) v(xbgr.n_36) v(xbgr.n_37) v(xbgr.n_4) v(xbgr.n_5) v(xbgr.n_6) v(xbgr.n_7) v(xbgr.n_8) v(xbgr.n_9) v(pbias) v(pcasc) v(r4) v(xbgr.r4n) v(xbgr.vb2) v(vbe) v(xbgr.vbe3) v(xbgr.vd1) v(xbgr.vd2) v(vdd) v(vref) v(vdd)-v(vdd) i(vdd) i(vload) i(vr4) i(vsub)
print @n.xbgr.xr1.nr1[nsmm_rsh]
print @n.xbgr.xr1.nr1[nsmm_w]
print @n.xbgr.xr1.nr1[nsmm_l]
print @n.xbgr.xr2.nr1[nsmm_rsh]
print @n.xbgr.xr2.nr1[nsmm_w]
print @n.xbgr.xr2.nr1[nsmm_l]
print @n.xbgr.xr3.nr1[nsmm_rsh]
print @n.xbgr.xr3.nr1[nsmm_w]
print @n.xbgr.xr3.nr1[nsmm_l]
print @n.xbgr.xr4.nr1[nsmm_rsh]
print @n.xbgr.xr4.nr1[nsmm_w]
print @n.xbgr.xr4.nr1[nsmm_l]
print @n.xbgr.xr5.nr1[nsmm_rsh]
print @n.xbgr.xr5.nr1[nsmm_w]
print @n.xbgr.xr5.nr1[nsmm_l]
print @n.xbgr.xr6.nr1[nsmm_rsh]
print @n.xbgr.xr6.nr1[nsmm_w]
print @n.xbgr.xr6.nr1[nsmm_l]
print @n.xbgr.xr7.nr1[nsmm_rsh]
print @n.xbgr.xr7.nr1[nsmm_w]
print @n.xbgr.xr7.nr1[nsmm_l]
print @n.xbgr.xr8.nr1[nsmm_rsh]
print @n.xbgr.xr8.nr1[nsmm_w]
print @n.xbgr.xr8.nr1[nsmm_l]
print @n.xbgr.xr9.nr1[nsmm_rsh]
print @n.xbgr.xr9.nr1[nsmm_w]
print @n.xbgr.xr9.nr1[nsmm_l]
print @n.xbgr.xr10.nr1[nsmm_rsh]
print @n.xbgr.xr10.nr1[nsmm_w]
print @n.xbgr.xr10.nr1[nsmm_l]
print @n.xbgr.xr11.nr1[nsmm_rsh]
print @n.xbgr.xr11.nr1[nsmm_w]
print @n.xbgr.xr11.nr1[nsmm_l]
print @n.xbgr.xr12.nr1[nsmm_rsh]
print @n.xbgr.xr12.nr1[nsmm_w]
print @n.xbgr.xr12.nr1[nsmm_l]
print @n.xbgr.xr13.nr1[nsmm_rsh]
print @n.xbgr.xr13.nr1[nsmm_w]
print @n.xbgr.xr13.nr1[nsmm_l]
print @n.xbgr.xr14.nr1[nsmm_rsh]
print @n.xbgr.xr14.nr1[nsmm_w]
print @n.xbgr.xr14.nr1[nsmm_l]
print @n.xbgr.xr15.nr1[nsmm_rsh]
print @n.xbgr.xr15.nr1[nsmm_w]
print @n.xbgr.xr15.nr1[nsmm_l]
print @n.xbgr.xr16.nr1[nsmm_rsh]
print @n.xbgr.xr16.nr1[nsmm_w]
print @n.xbgr.xr16.nr1[nsmm_l]
print @n.xbgr.xr17.nr1[nsmm_rsh]
print @n.xbgr.xr17.nr1[nsmm_w]
print @n.xbgr.xr17.nr1[nsmm_l]
print @n.xbgr.xr18.nr1[nsmm_rsh]
print @n.xbgr.xr18.nr1[nsmm_w]
print @n.xbgr.xr18.nr1[nsmm_l]
print @n.xbgr.xr19.nr1[nsmm_rsh]
print @n.xbgr.xr19.nr1[nsmm_w]
print @n.xbgr.xr19.nr1[nsmm_l]
print @n.xbgr.xr20.nr1[nsmm_rsh]
print @n.xbgr.xr20.nr1[nsmm_w]
print @n.xbgr.xr20.nr1[nsmm_l]
print @n.xbgr.xr21.nr1[nsmm_rsh]
print @n.xbgr.xr21.nr1[nsmm_w]
print @n.xbgr.xr21.nr1[nsmm_l]
print @n.xbgr.xr22.nr1[nsmm_rsh]
print @n.xbgr.xr22.nr1[nsmm_w]
print @n.xbgr.xr22.nr1[nsmm_l]
print @n.xbgr.xr23.nr1[nsmm_rsh]
print @n.xbgr.xr23.nr1[nsmm_w]
print @n.xbgr.xr23.nr1[nsmm_l]
print @n.xbgr.xr24.nr1[nsmm_rsh]
print @n.xbgr.xr24.nr1[nsmm_w]
print @n.xbgr.xr24.nr1[nsmm_l]
print @n.xbgr.xr25.nr1[nsmm_rsh]
print @n.xbgr.xr25.nr1[nsmm_w]
print @n.xbgr.xr25.nr1[nsmm_l]
print @n.xbgr.xr26.nr1[nsmm_rsh]
print @n.xbgr.xr26.nr1[nsmm_w]
print @n.xbgr.xr26.nr1[nsmm_l]
print @n.xbgr.xm27.nsg13_hv_pmos[w]
print @n.xbgr.xm27.nsg13_hv_pmos[l]
print @n.xbgr.xm27.nsg13_hv_pmos[delvto]
print @n.xbgr.xm27.nsg13_hv_pmos[factuo]
print @n.xbgr.xm28.nsg13_hv_pmos[w]
print @n.xbgr.xm28.nsg13_hv_pmos[l]
print @n.xbgr.xm28.nsg13_hv_pmos[delvto]
print @n.xbgr.xm28.nsg13_hv_pmos[factuo]
print @n.xbgr.xm29.nsg13_hv_nmos[w]
print @n.xbgr.xm29.nsg13_hv_nmos[l]
print @n.xbgr.xm29.nsg13_hv_nmos[delvto]
print @n.xbgr.xm29.nsg13_hv_nmos[factuo]
print @n.xbgr.xm30.nsg13_hv_nmos[w]
print @n.xbgr.xm30.nsg13_hv_nmos[l]
print @n.xbgr.xm30.nsg13_hv_nmos[delvto]
print @n.xbgr.xm30.nsg13_hv_nmos[factuo]
print @n.xbgr.xm31.nsg13_hv_nmos[w]
print @n.xbgr.xm31.nsg13_hv_nmos[l]
print @n.xbgr.xm31.nsg13_hv_nmos[delvto]
print @n.xbgr.xm31.nsg13_hv_nmos[factuo]
print @n.xbgr.xm32.nsg13_hv_nmos[w]
print @n.xbgr.xm32.nsg13_hv_nmos[l]
print @n.xbgr.xm32.nsg13_hv_nmos[delvto]
print @n.xbgr.xm32.nsg13_hv_nmos[factuo]
print @n.xbgr.xm33.nsg13_hv_nmos[w]
print @n.xbgr.xm33.nsg13_hv_nmos[l]
print @n.xbgr.xm33.nsg13_hv_nmos[delvto]
print @n.xbgr.xm33.nsg13_hv_nmos[factuo]
print @n.xbgr.xm34.nsg13_hv_nmos[w]
print @n.xbgr.xm34.nsg13_hv_nmos[l]
print @n.xbgr.xm34.nsg13_hv_nmos[delvto]
print @n.xbgr.xm34.nsg13_hv_nmos[factuo]
print @n.xbgr.xm35.nsg13_hv_nmos[w]
print @n.xbgr.xm35.nsg13_hv_nmos[l]
print @n.xbgr.xm35.nsg13_hv_nmos[delvto]
print @n.xbgr.xm35.nsg13_hv_nmos[factuo]
print @n.xbgr.xm36.nsg13_hv_nmos[w]
print @n.xbgr.xm36.nsg13_hv_nmos[l]
print @n.xbgr.xm36.nsg13_hv_nmos[delvto]
print @n.xbgr.xm36.nsg13_hv_nmos[factuo]
print @n.xbgr.xm37.nsg13_hv_nmos[w]
print @n.xbgr.xm37.nsg13_hv_nmos[l]
print @n.xbgr.xm37.nsg13_hv_nmos[delvto]
print @n.xbgr.xm37.nsg13_hv_nmos[factuo]
print @n.xbgr.xm38.nsg13_hv_pmos[w]
print @n.xbgr.xm38.nsg13_hv_pmos[l]
print @n.xbgr.xm38.nsg13_hv_pmos[delvto]
print @n.xbgr.xm38.nsg13_hv_pmos[factuo]
print @n.xbgr.xm39.nsg13_hv_pmos[w]
print @n.xbgr.xm39.nsg13_hv_pmos[l]
print @n.xbgr.xm39.nsg13_hv_pmos[delvto]
print @n.xbgr.xm39.nsg13_hv_pmos[factuo]
print @n.xbgr.xm40.nsg13_hv_pmos[w]
print @n.xbgr.xm40.nsg13_hv_pmos[l]
print @n.xbgr.xm40.nsg13_hv_pmos[delvto]
print @n.xbgr.xm40.nsg13_hv_pmos[factuo]
print @n.xbgr.xm41.nsg13_hv_pmos[w]
print @n.xbgr.xm41.nsg13_hv_pmos[l]
print @n.xbgr.xm41.nsg13_hv_pmos[delvto]
print @n.xbgr.xm41.nsg13_hv_pmos[factuo]
print @n.xbgr.xm42.nsg13_hv_pmos[w]
print @n.xbgr.xm42.nsg13_hv_pmos[l]
print @n.xbgr.xm42.nsg13_hv_pmos[delvto]
print @n.xbgr.xm42.nsg13_hv_pmos[factuo]
print @n.xbgr.xm43.nsg13_hv_pmos[w]
print @n.xbgr.xm43.nsg13_hv_pmos[l]
print @n.xbgr.xm43.nsg13_hv_pmos[delvto]
print @n.xbgr.xm43.nsg13_hv_pmos[factuo]
print @n.xbgr.xm44.nsg13_hv_pmos[w]
print @n.xbgr.xm44.nsg13_hv_pmos[l]
print @n.xbgr.xm44.nsg13_hv_pmos[delvto]
print @n.xbgr.xm44.nsg13_hv_pmos[factuo]
print @n.xbgr.xm45.nsg13_hv_pmos[w]
print @n.xbgr.xm45.nsg13_hv_pmos[l]
print @n.xbgr.xm45.nsg13_hv_pmos[delvto]
print @n.xbgr.xm45.nsg13_hv_pmos[factuo]
print @n.xbgr.xm46.nsg13_hv_pmos[w]
print @n.xbgr.xm46.nsg13_hv_pmos[l]
print @n.xbgr.xm46.nsg13_hv_pmos[delvto]
print @n.xbgr.xm46.nsg13_hv_pmos[factuo]
print @n.xbgr.xm47.nsg13_hv_pmos[w]
print @n.xbgr.xm47.nsg13_hv_pmos[l]
print @n.xbgr.xm47.nsg13_hv_pmos[delvto]
print @n.xbgr.xm47.nsg13_hv_pmos[factuo]
print @n.xbgr.xm48.nsg13_hv_pmos[w]
print @n.xbgr.xm48.nsg13_hv_pmos[l]
print @n.xbgr.xm48.nsg13_hv_pmos[delvto]
print @n.xbgr.xm48.nsg13_hv_pmos[factuo]
print @n.xbgr.xm49.nsg13_hv_pmos[w]
print @n.xbgr.xm49.nsg13_hv_pmos[l]
print @n.xbgr.xm49.nsg13_hv_pmos[delvto]
print @n.xbgr.xm49.nsg13_hv_pmos[factuo]
print @n.xbgr.xm50.nsg13_hv_pmos[w]
print @n.xbgr.xm50.nsg13_hv_pmos[l]
print @n.xbgr.xm50.nsg13_hv_pmos[delvto]
print @n.xbgr.xm50.nsg13_hv_pmos[factuo]
print @n.xbgr.xm51.nsg13_hv_pmos[w]
print @n.xbgr.xm51.nsg13_hv_pmos[l]
print @n.xbgr.xm51.nsg13_hv_pmos[delvto]
print @n.xbgr.xm51.nsg13_hv_pmos[factuo]
print @n.xbgr.xm52.nsg13_hv_pmos[w]
print @n.xbgr.xm52.nsg13_hv_pmos[l]
print @n.xbgr.xm52.nsg13_hv_pmos[delvto]
print @n.xbgr.xm52.nsg13_hv_pmos[factuo]
print @n.xbgr.xm53.nsg13_hv_pmos[w]
print @n.xbgr.xm53.nsg13_hv_pmos[l]
print @n.xbgr.xm53.nsg13_hv_pmos[delvto]
print @n.xbgr.xm53.nsg13_hv_pmos[factuo]
print @n.xbgr.xm54.nsg13_hv_pmos[w]
print @n.xbgr.xm54.nsg13_hv_pmos[l]
print @n.xbgr.xm54.nsg13_hv_pmos[delvto]
print @n.xbgr.xm54.nsg13_hv_pmos[factuo]
print @q.xbgr.xq55.qnpn13g2[area]
print @q.xbgr.xq56.qnpn13g2[area]
print @q.xbgr.xq57.qnpn13g2[area]
print @q.xbgr.xq58.qnpn13g2[area]
print @q.xbgr.xq59.qnpn13g2[area]
print @q.xbgr.xq60.qnpn13g2[area]
print @q.xbgr.xq61.qnpn13g2[area]
print @q.xbgr.xq62.qnpn13g2[area]
print @q.xbgr.xq63.qnpn13g2[area]
print @q.xbgr.xq64.qnpn13g2[area]
print @q.xbgr.xq65.qnpn13g2[area]
print @q.xbgr.xq66.qnpn13g2[area]
print @q.xbgr.xq67.qnpn13g2[area]
print @q.xbgr.xq68.qnpn13g2[area]
print @q.xbgr.xq69.qnpn13g2[area]
print @q.xbgr.xq70.qnpn13g2[area]
print @q.xbgr.xq71.qnpn13g2[area]
print @q.xbgr.xq72.qnpn13g2[area]
print @q.xbgr.xq73.qnpn13g2[area]
print @q.xbgr.xq74.qnpn13g2[area]
print @q.xbgr.xq75.qnpn13g2[area]
print @q.xbgr.xq76.qnpn13g2[area]
print @n.xbgr.xr77.nr1[nsmm_rsh]
print @n.xbgr.xr77.nr1[nsmm_w]
print @n.xbgr.xr77.nr1[nsmm_l]
print @n.xbgr.xr78.nr1[nsmm_rsh]
print @n.xbgr.xr78.nr1[nsmm_w]
print @n.xbgr.xr78.nr1[nsmm_l]
print @n.xbgr.xr79.nr1[nsmm_rsh]
print @n.xbgr.xr79.nr1[nsmm_w]
print @n.xbgr.xr79.nr1[nsmm_l]
print @n.xbgr.xr80.nr1[nsmm_rsh]
print @n.xbgr.xr80.nr1[nsmm_w]
print @n.xbgr.xr80.nr1[nsmm_l]
print @n.xbgr.xr81.nr1[nsmm_rsh]
print @n.xbgr.xr81.nr1[nsmm_w]
print @n.xbgr.xr81.nr1[nsmm_l]
print @n.xbgr.xr82.nr1[nsmm_rsh]
print @n.xbgr.xr82.nr1[nsmm_w]
print @n.xbgr.xr82.nr1[nsmm_l]
print @n.xbgr.xr83.nr1[nsmm_rsh]
print @n.xbgr.xr83.nr1[nsmm_w]
print @n.xbgr.xr83.nr1[nsmm_l]
print @n.xbgr.xr84.nr1[nsmm_rsh]
print @n.xbgr.xr84.nr1[nsmm_w]
print @n.xbgr.xr84.nr1[nsmm_l]
print @n.xbgr.xr85.nr1[nsmm_rsh]
print @n.xbgr.xr85.nr1[nsmm_w]
print @n.xbgr.xr85.nr1[nsmm_l]
print @n.xbgr.xr86.nr1[nsmm_rsh]
print @n.xbgr.xr86.nr1[nsmm_w]
print @n.xbgr.xr86.nr1[nsmm_l]
print @n.xbgr.xr16_u2.nr1[nsmm_rsh]
print @n.xbgr.xr16_u2.nr1[nsmm_w]
print @n.xbgr.xr16_u2.nr1[nsmm_l]
print @n.xbgr.xr16_u3.nr1[nsmm_rsh]
print @n.xbgr.xr16_u3.nr1[nsmm_w]
print @n.xbgr.xr16_u3.nr1[nsmm_l]
print @n.xbgr.xr16_u4.nr1[nsmm_rsh]
print @n.xbgr.xr16_u4.nr1[nsmm_w]
print @n.xbgr.xr16_u4.nr1[nsmm_l]
print @n.xbgr.xr16_u5.nr1[nsmm_rsh]
print @n.xbgr.xr16_u5.nr1[nsmm_w]
print @n.xbgr.xr16_u5.nr1[nsmm_l]
print @n.xbgr.xr16_u6.nr1[nsmm_rsh]
print @n.xbgr.xr16_u6.nr1[nsmm_w]
print @n.xbgr.xr16_u6.nr1[nsmm_l]
print @n.xbgr.xr16_u7.nr1[nsmm_rsh]
print @n.xbgr.xr16_u7.nr1[nsmm_w]
print @n.xbgr.xr16_u7.nr1[nsmm_l]
print @n.xbgr.xr16_u8.nr1[nsmm_rsh]
print @n.xbgr.xr16_u8.nr1[nsmm_w]
print @n.xbgr.xr16_u8.nr1[nsmm_l]
print @n.xbgr.xr16_u9.nr1[nsmm_rsh]
print @n.xbgr.xr16_u9.nr1[nsmm_w]
print @n.xbgr.xr16_u9.nr1[nsmm_l]
print @n.xbgr.xr16_u10.nr1[nsmm_rsh]
print @n.xbgr.xr16_u10.nr1[nsmm_w]
print @n.xbgr.xr16_u10.nr1[nsmm_l]
print @n.xbgr.xr16_u11.nr1[nsmm_rsh]
print @n.xbgr.xr16_u11.nr1[nsmm_w]
print @n.xbgr.xr16_u11.nr1[nsmm_l]
print @n.xbgr.xr16_u12.nr1[nsmm_rsh]
print @n.xbgr.xr16_u12.nr1[nsmm_w]
print @n.xbgr.xr16_u12.nr1[nsmm_l]
print @n.xbgr.xr16_u13.nr1[nsmm_rsh]
print @n.xbgr.xr16_u13.nr1[nsmm_w]
print @n.xbgr.xr16_u13.nr1[nsmm_l]
print @n.xbgr.xr16_u14.nr1[nsmm_rsh]
print @n.xbgr.xr16_u14.nr1[nsmm_w]
print @n.xbgr.xr16_u14.nr1[nsmm_l]
print @n.xbgr.xr16_u15.nr1[nsmm_rsh]
print @n.xbgr.xr16_u15.nr1[nsmm_w]
print @n.xbgr.xr16_u15.nr1[nsmm_l]
print @n.xbgr.xr16_u16.nr1[nsmm_rsh]
print @n.xbgr.xr16_u16.nr1[nsmm_w]
print @n.xbgr.xr16_u16.nr1[nsmm_l]
print @n.xbgr.xr16_u17.nr1[nsmm_rsh]
print @n.xbgr.xr16_u17.nr1[nsmm_w]
print @n.xbgr.xr16_u17.nr1[nsmm_l]
print @n.xbgr.xr16_u18.nr1[nsmm_rsh]
print @n.xbgr.xr16_u18.nr1[nsmm_w]
print @n.xbgr.xr16_u18.nr1[nsmm_l]
print @n.xbgr.xr16_u19.nr1[nsmm_rsh]
print @n.xbgr.xr16_u19.nr1[nsmm_w]
print @n.xbgr.xr16_u19.nr1[nsmm_l]
print @n.xbgr.xr16_u20.nr1[nsmm_rsh]
print @n.xbgr.xr16_u20.nr1[nsmm_w]
print @n.xbgr.xr16_u20.nr1[nsmm_l]
print @n.xbgr.xr16_u21.nr1[nsmm_rsh]
print @n.xbgr.xr16_u21.nr1[nsmm_w]
print @n.xbgr.xr16_u21.nr1[nsmm_l]
print @n.xbgr.xr16_u22.nr1[nsmm_rsh]
print @n.xbgr.xr16_u22.nr1[nsmm_w]
print @n.xbgr.xr16_u22.nr1[nsmm_l]
print @n.xbgr.xr16_u23.nr1[nsmm_rsh]
print @n.xbgr.xr16_u23.nr1[nsmm_w]
print @n.xbgr.xr16_u23.nr1[nsmm_l]
print @n.xbgr.xr16_u24.nr1[nsmm_rsh]
print @n.xbgr.xr16_u24.nr1[nsmm_w]
print @n.xbgr.xr16_u24.nr1[nsmm_l]
print @n.xbgr.xr17_u2.nr1[nsmm_rsh]
print @n.xbgr.xr17_u2.nr1[nsmm_w]
print @n.xbgr.xr17_u2.nr1[nsmm_l]
print @n.xbgr.xr17_u3.nr1[nsmm_rsh]
print @n.xbgr.xr17_u3.nr1[nsmm_w]
print @n.xbgr.xr17_u3.nr1[nsmm_l]
print @n.xbgr.xr17_u4.nr1[nsmm_rsh]
print @n.xbgr.xr17_u4.nr1[nsmm_w]
print @n.xbgr.xr17_u4.nr1[nsmm_l]
print @n.xbgr.xr18_u2.nr1[nsmm_rsh]
print @n.xbgr.xr18_u2.nr1[nsmm_w]
print @n.xbgr.xr18_u2.nr1[nsmm_l]
print @n.xbgr.xr18_u3.nr1[nsmm_rsh]
print @n.xbgr.xr18_u3.nr1[nsmm_w]
print @n.xbgr.xr18_u3.nr1[nsmm_l]
print @n.xbgr.xr18_u4.nr1[nsmm_rsh]
print @n.xbgr.xr18_u4.nr1[nsmm_w]
print @n.xbgr.xr18_u4.nr1[nsmm_l]
print @n.xbgr.xr19_u2.nr1[nsmm_rsh]
print @n.xbgr.xr19_u2.nr1[nsmm_w]
print @n.xbgr.xr19_u2.nr1[nsmm_l]
print @n.xbgr.xr19_u3.nr1[nsmm_rsh]
print @n.xbgr.xr19_u3.nr1[nsmm_w]
print @n.xbgr.xr19_u3.nr1[nsmm_l]
print @n.xbgr.xr19_u4.nr1[nsmm_rsh]
print @n.xbgr.xr19_u4.nr1[nsmm_w]
print @n.xbgr.xr19_u4.nr1[nsmm_l]
print @n.xbgr.xr20_u2.nr1[nsmm_rsh]
print @n.xbgr.xr20_u2.nr1[nsmm_w]
print @n.xbgr.xr20_u2.nr1[nsmm_l]
print @n.xbgr.xr20_u3.nr1[nsmm_rsh]
print @n.xbgr.xr20_u3.nr1[nsmm_w]
print @n.xbgr.xr20_u3.nr1[nsmm_l]
print @n.xbgr.xr20_u4.nr1[nsmm_rsh]
print @n.xbgr.xr20_u4.nr1[nsmm_w]
print @n.xbgr.xr20_u4.nr1[nsmm_l]
print @n.xbgr.xr21_u2.nr1[nsmm_rsh]
print @n.xbgr.xr21_u2.nr1[nsmm_w]
print @n.xbgr.xr21_u2.nr1[nsmm_l]
print @n.xbgr.xr21_u3.nr1[nsmm_rsh]
print @n.xbgr.xr21_u3.nr1[nsmm_w]
print @n.xbgr.xr21_u3.nr1[nsmm_l]
print @n.xbgr.xr21_u4.nr1[nsmm_rsh]
print @n.xbgr.xr21_u4.nr1[nsmm_w]
print @n.xbgr.xr21_u4.nr1[nsmm_l]
print @n.xbgr.xr22_u2.nr1[nsmm_rsh]
print @n.xbgr.xr22_u2.nr1[nsmm_w]
print @n.xbgr.xr22_u2.nr1[nsmm_l]
print @n.xbgr.xr22_u3.nr1[nsmm_rsh]
print @n.xbgr.xr22_u3.nr1[nsmm_w]
print @n.xbgr.xr22_u3.nr1[nsmm_l]
print @n.xbgr.xr22_u4.nr1[nsmm_rsh]
print @n.xbgr.xr22_u4.nr1[nsmm_w]
print @n.xbgr.xr22_u4.nr1[nsmm_l]
print @n.xbgr.xr23_u2.nr1[nsmm_rsh]
print @n.xbgr.xr23_u2.nr1[nsmm_w]
print @n.xbgr.xr23_u2.nr1[nsmm_l]
print @n.xbgr.xr23_u3.nr1[nsmm_rsh]
print @n.xbgr.xr23_u3.nr1[nsmm_w]
print @n.xbgr.xr23_u3.nr1[nsmm_l]
print @n.xbgr.xr23_u4.nr1[nsmm_rsh]
print @n.xbgr.xr23_u4.nr1[nsmm_w]
print @n.xbgr.xr23_u4.nr1[nsmm_l]
print @n.xbgr.xr23_u5.nr1[nsmm_rsh]
print @n.xbgr.xr23_u5.nr1[nsmm_w]
print @n.xbgr.xr23_u5.nr1[nsmm_l]
print @n.xbgr.xr23_u6.nr1[nsmm_rsh]
print @n.xbgr.xr23_u6.nr1[nsmm_w]
print @n.xbgr.xr23_u6.nr1[nsmm_l]
print @n.xbgr.xr23_u7.nr1[nsmm_rsh]
print @n.xbgr.xr23_u7.nr1[nsmm_w]
print @n.xbgr.xr23_u7.nr1[nsmm_l]
print @n.xbgr.xr23_u8.nr1[nsmm_rsh]
print @n.xbgr.xr23_u8.nr1[nsmm_w]
print @n.xbgr.xr23_u8.nr1[nsmm_l]
print @n.xbgr.xr23_u9.nr1[nsmm_rsh]
print @n.xbgr.xr23_u9.nr1[nsmm_w]
print @n.xbgr.xr23_u9.nr1[nsmm_l]
print @n.xbgr.xr23_u10.nr1[nsmm_rsh]
print @n.xbgr.xr23_u10.nr1[nsmm_w]
print @n.xbgr.xr23_u10.nr1[nsmm_l]
print @n.xbgr.xr23_u11.nr1[nsmm_rsh]
print @n.xbgr.xr23_u11.nr1[nsmm_w]
print @n.xbgr.xr23_u11.nr1[nsmm_l]
print @n.xbgr.xr23_u12.nr1[nsmm_rsh]
print @n.xbgr.xr23_u12.nr1[nsmm_w]
print @n.xbgr.xr23_u12.nr1[nsmm_l]
print @n.xbgr.xr23_u13.nr1[nsmm_rsh]
print @n.xbgr.xr23_u13.nr1[nsmm_w]
print @n.xbgr.xr23_u13.nr1[nsmm_l]
print @n.xbgr.xr23_u14.nr1[nsmm_rsh]
print @n.xbgr.xr23_u14.nr1[nsmm_w]
print @n.xbgr.xr23_u14.nr1[nsmm_l]
print @n.xbgr.xr23_u15.nr1[nsmm_rsh]
print @n.xbgr.xr23_u15.nr1[nsmm_w]
print @n.xbgr.xr23_u15.nr1[nsmm_l]
print @n.xbgr.xr23_u16.nr1[nsmm_rsh]
print @n.xbgr.xr23_u16.nr1[nsmm_w]
print @n.xbgr.xr23_u16.nr1[nsmm_l]
print @n.xbgr.xr23_u17.nr1[nsmm_rsh]
print @n.xbgr.xr23_u17.nr1[nsmm_w]
print @n.xbgr.xr23_u17.nr1[nsmm_l]
print @n.xbgr.xr23_u18.nr1[nsmm_rsh]
print @n.xbgr.xr23_u18.nr1[nsmm_w]
print @n.xbgr.xr23_u18.nr1[nsmm_l]
print @n.xbgr.xr23_u19.nr1[nsmm_rsh]
print @n.xbgr.xr23_u19.nr1[nsmm_w]
print @n.xbgr.xr23_u19.nr1[nsmm_l]
print @n.xbgr.xr23_u20.nr1[nsmm_rsh]
print @n.xbgr.xr23_u20.nr1[nsmm_w]
print @n.xbgr.xr23_u20.nr1[nsmm_l]
print @n.xbgr.xr23_u21.nr1[nsmm_rsh]
print @n.xbgr.xr23_u21.nr1[nsmm_w]
print @n.xbgr.xr23_u21.nr1[nsmm_l]
print @n.xbgr.xr23_u22.nr1[nsmm_rsh]
print @n.xbgr.xr23_u22.nr1[nsmm_w]
print @n.xbgr.xr23_u22.nr1[nsmm_l]
print @n.xbgr.xr23_u23.nr1[nsmm_rsh]
print @n.xbgr.xr23_u23.nr1[nsmm_w]
print @n.xbgr.xr23_u23.nr1[nsmm_l]
print @n.xbgr.xr23_u24.nr1[nsmm_rsh]
print @n.xbgr.xr23_u24.nr1[nsmm_w]
print @n.xbgr.xr23_u24.nr1[nsmm_l]
print @n.xbgr.xr24_u2.nr1[nsmm_rsh]
print @n.xbgr.xr24_u2.nr1[nsmm_w]
print @n.xbgr.xr24_u2.nr1[nsmm_l]
print @n.xbgr.xr24_u3.nr1[nsmm_rsh]
print @n.xbgr.xr24_u3.nr1[nsmm_w]
print @n.xbgr.xr24_u3.nr1[nsmm_l]
print @n.xbgr.xr24_u4.nr1[nsmm_rsh]
print @n.xbgr.xr24_u4.nr1[nsmm_w]
print @n.xbgr.xr24_u4.nr1[nsmm_l]
print @n.xbgr.xr24_u5.nr1[nsmm_rsh]
print @n.xbgr.xr24_u5.nr1[nsmm_w]
print @n.xbgr.xr24_u5.nr1[nsmm_l]
print @n.xbgr.xr24_u6.nr1[nsmm_rsh]
print @n.xbgr.xr24_u6.nr1[nsmm_w]
print @n.xbgr.xr24_u6.nr1[nsmm_l]
print @n.xbgr.xr24_u7.nr1[nsmm_rsh]
print @n.xbgr.xr24_u7.nr1[nsmm_w]
print @n.xbgr.xr24_u7.nr1[nsmm_l]
print @n.xbgr.xr24_u8.nr1[nsmm_rsh]
print @n.xbgr.xr24_u8.nr1[nsmm_w]
print @n.xbgr.xr24_u8.nr1[nsmm_l]
print @n.xbgr.xr24_u9.nr1[nsmm_rsh]
print @n.xbgr.xr24_u9.nr1[nsmm_w]
print @n.xbgr.xr24_u9.nr1[nsmm_l]
print @n.xbgr.xr24_u10.nr1[nsmm_rsh]
print @n.xbgr.xr24_u10.nr1[nsmm_w]
print @n.xbgr.xr24_u10.nr1[nsmm_l]
print @n.xbgr.xr24_u11.nr1[nsmm_rsh]
print @n.xbgr.xr24_u11.nr1[nsmm_w]
print @n.xbgr.xr24_u11.nr1[nsmm_l]
print @n.xbgr.xr24_u12.nr1[nsmm_rsh]
print @n.xbgr.xr24_u12.nr1[nsmm_w]
print @n.xbgr.xr24_u12.nr1[nsmm_l]
print @n.xbgr.xr24_u13.nr1[nsmm_rsh]
print @n.xbgr.xr24_u13.nr1[nsmm_w]
print @n.xbgr.xr24_u13.nr1[nsmm_l]
print @n.xbgr.xr24_u14.nr1[nsmm_rsh]
print @n.xbgr.xr24_u14.nr1[nsmm_w]
print @n.xbgr.xr24_u14.nr1[nsmm_l]
print @n.xbgr.xr24_u15.nr1[nsmm_rsh]
print @n.xbgr.xr24_u15.nr1[nsmm_w]
print @n.xbgr.xr24_u15.nr1[nsmm_l]
print @n.xbgr.xr24_u16.nr1[nsmm_rsh]
print @n.xbgr.xr24_u16.nr1[nsmm_w]
print @n.xbgr.xr24_u16.nr1[nsmm_l]
print @n.xbgr.xr24_u17.nr1[nsmm_rsh]
print @n.xbgr.xr24_u17.nr1[nsmm_w]
print @n.xbgr.xr24_u17.nr1[nsmm_l]
print @n.xbgr.xr24_u18.nr1[nsmm_rsh]
print @n.xbgr.xr24_u18.nr1[nsmm_w]
print @n.xbgr.xr24_u18.nr1[nsmm_l]
print @n.xbgr.xr24_u19.nr1[nsmm_rsh]
print @n.xbgr.xr24_u19.nr1[nsmm_w]
print @n.xbgr.xr24_u19.nr1[nsmm_l]
print @n.xbgr.xr24_u20.nr1[nsmm_rsh]
print @n.xbgr.xr24_u20.nr1[nsmm_w]
print @n.xbgr.xr24_u20.nr1[nsmm_l]
print @n.xbgr.xr24_u21.nr1[nsmm_rsh]
print @n.xbgr.xr24_u21.nr1[nsmm_w]
print @n.xbgr.xr24_u21.nr1[nsmm_l]
print @n.xbgr.xr24_u22.nr1[nsmm_rsh]
print @n.xbgr.xr24_u22.nr1[nsmm_w]
print @n.xbgr.xr24_u22.nr1[nsmm_l]
print @n.xbgr.xr24_u23.nr1[nsmm_rsh]
print @n.xbgr.xr24_u23.nr1[nsmm_w]
print @n.xbgr.xr24_u23.nr1[nsmm_l]
print @n.xbgr.xr24_u24.nr1[nsmm_rsh]
print @n.xbgr.xr24_u24.nr1[nsmm_w]
print @n.xbgr.xr24_u24.nr1[nsmm_l]
print @n.xbgr.xr25_u2.nr1[nsmm_rsh]
print @n.xbgr.xr25_u2.nr1[nsmm_w]
print @n.xbgr.xr25_u2.nr1[nsmm_l]
print @n.xbgr.xr25_u3.nr1[nsmm_rsh]
print @n.xbgr.xr25_u3.nr1[nsmm_w]
print @n.xbgr.xr25_u3.nr1[nsmm_l]
print @n.xbgr.xr25_u4.nr1[nsmm_rsh]
print @n.xbgr.xr25_u4.nr1[nsmm_w]
print @n.xbgr.xr25_u4.nr1[nsmm_l]
print @n.xbgr.xr25_u5.nr1[nsmm_rsh]
print @n.xbgr.xr25_u5.nr1[nsmm_w]
print @n.xbgr.xr25_u5.nr1[nsmm_l]
print @n.xbgr.xr25_u6.nr1[nsmm_rsh]
print @n.xbgr.xr25_u6.nr1[nsmm_w]
print @n.xbgr.xr25_u6.nr1[nsmm_l]
print @n.xbgr.xr25_u7.nr1[nsmm_rsh]
print @n.xbgr.xr25_u7.nr1[nsmm_w]
print @n.xbgr.xr25_u7.nr1[nsmm_l]
print @n.xbgr.xr25_u8.nr1[nsmm_rsh]
print @n.xbgr.xr25_u8.nr1[nsmm_w]
print @n.xbgr.xr25_u8.nr1[nsmm_l]
print @n.xbgr.xr25_u9.nr1[nsmm_rsh]
print @n.xbgr.xr25_u9.nr1[nsmm_w]
print @n.xbgr.xr25_u9.nr1[nsmm_l]
print @n.xbgr.xr25_u10.nr1[nsmm_rsh]
print @n.xbgr.xr25_u10.nr1[nsmm_w]
print @n.xbgr.xr25_u10.nr1[nsmm_l]
print @n.xbgr.xr25_u11.nr1[nsmm_rsh]
print @n.xbgr.xr25_u11.nr1[nsmm_w]
print @n.xbgr.xr25_u11.nr1[nsmm_l]
print @n.xbgr.xr25_u12.nr1[nsmm_rsh]
print @n.xbgr.xr25_u12.nr1[nsmm_w]
print @n.xbgr.xr25_u12.nr1[nsmm_l]
print @n.xbgr.xr25_u13.nr1[nsmm_rsh]
print @n.xbgr.xr25_u13.nr1[nsmm_w]
print @n.xbgr.xr25_u13.nr1[nsmm_l]
print @n.xbgr.xr25_u14.nr1[nsmm_rsh]
print @n.xbgr.xr25_u14.nr1[nsmm_w]
print @n.xbgr.xr25_u14.nr1[nsmm_l]
print @n.xbgr.xr25_u15.nr1[nsmm_rsh]
print @n.xbgr.xr25_u15.nr1[nsmm_w]
print @n.xbgr.xr25_u15.nr1[nsmm_l]
print @n.xbgr.xr25_u16.nr1[nsmm_rsh]
print @n.xbgr.xr25_u16.nr1[nsmm_w]
print @n.xbgr.xr25_u16.nr1[nsmm_l]
print @n.xbgr.xr25_u17.nr1[nsmm_rsh]
print @n.xbgr.xr25_u17.nr1[nsmm_w]
print @n.xbgr.xr25_u17.nr1[nsmm_l]
print @n.xbgr.xr25_u18.nr1[nsmm_rsh]
print @n.xbgr.xr25_u18.nr1[nsmm_w]
print @n.xbgr.xr25_u18.nr1[nsmm_l]
print @n.xbgr.xr25_u19.nr1[nsmm_rsh]
print @n.xbgr.xr25_u19.nr1[nsmm_w]
print @n.xbgr.xr25_u19.nr1[nsmm_l]
print @n.xbgr.xr25_u20.nr1[nsmm_rsh]
print @n.xbgr.xr25_u20.nr1[nsmm_w]
print @n.xbgr.xr25_u20.nr1[nsmm_l]
print @n.xbgr.xr25_u21.nr1[nsmm_rsh]
print @n.xbgr.xr25_u21.nr1[nsmm_w]
print @n.xbgr.xr25_u21.nr1[nsmm_l]
print @n.xbgr.xr25_u22.nr1[nsmm_rsh]
print @n.xbgr.xr25_u22.nr1[nsmm_w]
print @n.xbgr.xr25_u22.nr1[nsmm_l]
print @n.xbgr.xr25_u23.nr1[nsmm_rsh]
print @n.xbgr.xr25_u23.nr1[nsmm_w]
print @n.xbgr.xr25_u23.nr1[nsmm_l]
print @n.xbgr.xr25_u24.nr1[nsmm_rsh]
print @n.xbgr.xr25_u24.nr1[nsmm_w]
print @n.xbgr.xr25_u24.nr1[nsmm_l]
print @n.xbgr.xr26_u2.nr1[nsmm_rsh]
print @n.xbgr.xr26_u2.nr1[nsmm_w]
print @n.xbgr.xr26_u2.nr1[nsmm_l]
print @n.xbgr.xr26_u3.nr1[nsmm_rsh]
print @n.xbgr.xr26_u3.nr1[nsmm_w]
print @n.xbgr.xr26_u3.nr1[nsmm_l]
print @n.xbgr.xr26_u4.nr1[nsmm_rsh]
print @n.xbgr.xr26_u4.nr1[nsmm_w]
print @n.xbgr.xr26_u4.nr1[nsmm_l]
print @n.xbgr.xr26_u5.nr1[nsmm_rsh]
print @n.xbgr.xr26_u5.nr1[nsmm_w]
print @n.xbgr.xr26_u5.nr1[nsmm_l]
print @n.xbgr.xr26_u6.nr1[nsmm_rsh]
print @n.xbgr.xr26_u6.nr1[nsmm_w]
print @n.xbgr.xr26_u6.nr1[nsmm_l]
print @n.xbgr.xr26_u7.nr1[nsmm_rsh]
print @n.xbgr.xr26_u7.nr1[nsmm_w]
print @n.xbgr.xr26_u7.nr1[nsmm_l]
print @n.xbgr.xr26_u8.nr1[nsmm_rsh]
print @n.xbgr.xr26_u8.nr1[nsmm_w]
print @n.xbgr.xr26_u8.nr1[nsmm_l]
print @n.xbgr.xr26_u9.nr1[nsmm_rsh]
print @n.xbgr.xr26_u9.nr1[nsmm_w]
print @n.xbgr.xr26_u9.nr1[nsmm_l]
print @n.xbgr.xr26_u10.nr1[nsmm_rsh]
print @n.xbgr.xr26_u10.nr1[nsmm_w]
print @n.xbgr.xr26_u10.nr1[nsmm_l]
print @n.xbgr.xr26_u11.nr1[nsmm_rsh]
print @n.xbgr.xr26_u11.nr1[nsmm_w]
print @n.xbgr.xr26_u11.nr1[nsmm_l]
print @n.xbgr.xr26_u12.nr1[nsmm_rsh]
print @n.xbgr.xr26_u12.nr1[nsmm_w]
print @n.xbgr.xr26_u12.nr1[nsmm_l]
print @n.xbgr.xr26_u13.nr1[nsmm_rsh]
print @n.xbgr.xr26_u13.nr1[nsmm_w]
print @n.xbgr.xr26_u13.nr1[nsmm_l]
print @n.xbgr.xr26_u14.nr1[nsmm_rsh]
print @n.xbgr.xr26_u14.nr1[nsmm_w]
print @n.xbgr.xr26_u14.nr1[nsmm_l]
print @n.xbgr.xr26_u15.nr1[nsmm_rsh]
print @n.xbgr.xr26_u15.nr1[nsmm_w]
print @n.xbgr.xr26_u15.nr1[nsmm_l]
print @n.xbgr.xr26_u16.nr1[nsmm_rsh]
print @n.xbgr.xr26_u16.nr1[nsmm_w]
print @n.xbgr.xr26_u16.nr1[nsmm_l]
print @n.xbgr.xr26_u17.nr1[nsmm_rsh]
print @n.xbgr.xr26_u17.nr1[nsmm_w]
print @n.xbgr.xr26_u17.nr1[nsmm_l]
print @n.xbgr.xr26_u18.nr1[nsmm_rsh]
print @n.xbgr.xr26_u18.nr1[nsmm_w]
print @n.xbgr.xr26_u18.nr1[nsmm_l]
print @n.xbgr.xr26_u19.nr1[nsmm_rsh]
print @n.xbgr.xr26_u19.nr1[nsmm_w]
print @n.xbgr.xr26_u19.nr1[nsmm_l]
print @n.xbgr.xr26_u20.nr1[nsmm_rsh]
print @n.xbgr.xr26_u20.nr1[nsmm_w]
print @n.xbgr.xr26_u20.nr1[nsmm_l]
print @n.xbgr.xr26_u21.nr1[nsmm_rsh]
print @n.xbgr.xr26_u21.nr1[nsmm_w]
print @n.xbgr.xr26_u21.nr1[nsmm_l]
print @n.xbgr.xr26_u22.nr1[nsmm_rsh]
print @n.xbgr.xr26_u22.nr1[nsmm_w]
print @n.xbgr.xr26_u22.nr1[nsmm_l]
print @n.xbgr.xr26_u23.nr1[nsmm_rsh]
print @n.xbgr.xr26_u23.nr1[nsmm_w]
print @n.xbgr.xr26_u23.nr1[nsmm_l]
print @n.xbgr.xr26_u24.nr1[nsmm_rsh]
print @n.xbgr.xr26_u24.nr1[nsmm_w]
print @n.xbgr.xr26_u24.nr1[nsmm_l]
print @n.xbgr.xm34_u2.nsg13_hv_nmos[w]
print @n.xbgr.xm34_u2.nsg13_hv_nmos[l]
print @n.xbgr.xm34_u2.nsg13_hv_nmos[delvto]
print @n.xbgr.xm34_u2.nsg13_hv_nmos[factuo]
print @n.xbgr.xm34_u3.nsg13_hv_nmos[w]
print @n.xbgr.xm34_u3.nsg13_hv_nmos[l]
print @n.xbgr.xm34_u3.nsg13_hv_nmos[delvto]
print @n.xbgr.xm34_u3.nsg13_hv_nmos[factuo]
print @n.xbgr.xm34_u4.nsg13_hv_nmos[w]
print @n.xbgr.xm34_u4.nsg13_hv_nmos[l]
print @n.xbgr.xm34_u4.nsg13_hv_nmos[delvto]
print @n.xbgr.xm34_u4.nsg13_hv_nmos[factuo]
print @n.xbgr.xm34_u5.nsg13_hv_nmos[w]
print @n.xbgr.xm34_u5.nsg13_hv_nmos[l]
print @n.xbgr.xm34_u5.nsg13_hv_nmos[delvto]
print @n.xbgr.xm34_u5.nsg13_hv_nmos[factuo]
print @n.xbgr.xm34_u6.nsg13_hv_nmos[w]
print @n.xbgr.xm34_u6.nsg13_hv_nmos[l]
print @n.xbgr.xm34_u6.nsg13_hv_nmos[delvto]
print @n.xbgr.xm34_u6.nsg13_hv_nmos[factuo]
print @n.xbgr.xm34_u7.nsg13_hv_nmos[w]
print @n.xbgr.xm34_u7.nsg13_hv_nmos[l]
print @n.xbgr.xm34_u7.nsg13_hv_nmos[delvto]
print @n.xbgr.xm34_u7.nsg13_hv_nmos[factuo]
print @n.xbgr.xm34_u8.nsg13_hv_nmos[w]
print @n.xbgr.xm34_u8.nsg13_hv_nmos[l]
print @n.xbgr.xm34_u8.nsg13_hv_nmos[delvto]
print @n.xbgr.xm34_u8.nsg13_hv_nmos[factuo]
print @n.xbgr.xm34_u9.nsg13_hv_nmos[w]
print @n.xbgr.xm34_u9.nsg13_hv_nmos[l]
print @n.xbgr.xm34_u9.nsg13_hv_nmos[delvto]
print @n.xbgr.xm34_u9.nsg13_hv_nmos[factuo]
print @n.xbgr.xm34_u10.nsg13_hv_nmos[w]
print @n.xbgr.xm34_u10.nsg13_hv_nmos[l]
print @n.xbgr.xm34_u10.nsg13_hv_nmos[delvto]
print @n.xbgr.xm34_u10.nsg13_hv_nmos[factuo]
print @n.xbgr.xm34_u11.nsg13_hv_nmos[w]
print @n.xbgr.xm34_u11.nsg13_hv_nmos[l]
print @n.xbgr.xm34_u11.nsg13_hv_nmos[delvto]
print @n.xbgr.xm34_u11.nsg13_hv_nmos[factuo]
print @n.xbgr.xm34_u12.nsg13_hv_nmos[w]
print @n.xbgr.xm34_u12.nsg13_hv_nmos[l]
print @n.xbgr.xm34_u12.nsg13_hv_nmos[delvto]
print @n.xbgr.xm34_u12.nsg13_hv_nmos[factuo]
print @n.xbgr.xm34_u13.nsg13_hv_nmos[w]
print @n.xbgr.xm34_u13.nsg13_hv_nmos[l]
print @n.xbgr.xm34_u13.nsg13_hv_nmos[delvto]
print @n.xbgr.xm34_u13.nsg13_hv_nmos[factuo]
print @n.xbgr.xm34_u14.nsg13_hv_nmos[w]
print @n.xbgr.xm34_u14.nsg13_hv_nmos[l]
print @n.xbgr.xm34_u14.nsg13_hv_nmos[delvto]
print @n.xbgr.xm34_u14.nsg13_hv_nmos[factuo]
print @n.xbgr.xm34_u15.nsg13_hv_nmos[w]
print @n.xbgr.xm34_u15.nsg13_hv_nmos[l]
print @n.xbgr.xm34_u15.nsg13_hv_nmos[delvto]
print @n.xbgr.xm34_u15.nsg13_hv_nmos[factuo]
print @n.xbgr.xm34_u16.nsg13_hv_nmos[w]
print @n.xbgr.xm34_u16.nsg13_hv_nmos[l]
print @n.xbgr.xm34_u16.nsg13_hv_nmos[delvto]
print @n.xbgr.xm34_u16.nsg13_hv_nmos[factuo]
print @n.xbgr.xm34_u17.nsg13_hv_nmos[w]
print @n.xbgr.xm34_u17.nsg13_hv_nmos[l]
print @n.xbgr.xm34_u17.nsg13_hv_nmos[delvto]
print @n.xbgr.xm34_u17.nsg13_hv_nmos[factuo]
print @n.xbgr.xm34_u18.nsg13_hv_nmos[w]
print @n.xbgr.xm34_u18.nsg13_hv_nmos[l]
print @n.xbgr.xm34_u18.nsg13_hv_nmos[delvto]
print @n.xbgr.xm34_u18.nsg13_hv_nmos[factuo]
print @n.xbgr.xm34_u19.nsg13_hv_nmos[w]
print @n.xbgr.xm34_u19.nsg13_hv_nmos[l]
print @n.xbgr.xm34_u19.nsg13_hv_nmos[delvto]
print @n.xbgr.xm34_u19.nsg13_hv_nmos[factuo]
print @n.xbgr.xm34_u20.nsg13_hv_nmos[w]
print @n.xbgr.xm34_u20.nsg13_hv_nmos[l]
print @n.xbgr.xm34_u20.nsg13_hv_nmos[delvto]
print @n.xbgr.xm34_u20.nsg13_hv_nmos[factuo]
print @n.xbgr.xm34_u21.nsg13_hv_nmos[w]
print @n.xbgr.xm34_u21.nsg13_hv_nmos[l]
print @n.xbgr.xm34_u21.nsg13_hv_nmos[delvto]
print @n.xbgr.xm34_u21.nsg13_hv_nmos[factuo]
print @n.xbgr.xm34_u22.nsg13_hv_nmos[w]
print @n.xbgr.xm34_u22.nsg13_hv_nmos[l]
print @n.xbgr.xm34_u22.nsg13_hv_nmos[delvto]
print @n.xbgr.xm34_u22.nsg13_hv_nmos[factuo]
print @n.xbgr.xm34_u23.nsg13_hv_nmos[w]
print @n.xbgr.xm34_u23.nsg13_hv_nmos[l]
print @n.xbgr.xm34_u23.nsg13_hv_nmos[delvto]
print @n.xbgr.xm34_u23.nsg13_hv_nmos[factuo]
print @n.xbgr.xm34_u24.nsg13_hv_nmos[w]
print @n.xbgr.xm34_u24.nsg13_hv_nmos[l]
print @n.xbgr.xm34_u24.nsg13_hv_nmos[delvto]
print @n.xbgr.xm34_u24.nsg13_hv_nmos[factuo]
print @n.xbgr.xm35_u2.nsg13_hv_nmos[w]
print @n.xbgr.xm35_u2.nsg13_hv_nmos[l]
print @n.xbgr.xm35_u2.nsg13_hv_nmos[delvto]
print @n.xbgr.xm35_u2.nsg13_hv_nmos[factuo]
print @n.xbgr.xm35_u3.nsg13_hv_nmos[w]
print @n.xbgr.xm35_u3.nsg13_hv_nmos[l]
print @n.xbgr.xm35_u3.nsg13_hv_nmos[delvto]
print @n.xbgr.xm35_u3.nsg13_hv_nmos[factuo]
print @n.xbgr.xm35_u4.nsg13_hv_nmos[w]
print @n.xbgr.xm35_u4.nsg13_hv_nmos[l]
print @n.xbgr.xm35_u4.nsg13_hv_nmos[delvto]
print @n.xbgr.xm35_u4.nsg13_hv_nmos[factuo]
print @n.xbgr.xm35_u5.nsg13_hv_nmos[w]
print @n.xbgr.xm35_u5.nsg13_hv_nmos[l]
print @n.xbgr.xm35_u5.nsg13_hv_nmos[delvto]
print @n.xbgr.xm35_u5.nsg13_hv_nmos[factuo]
print @n.xbgr.xm35_u6.nsg13_hv_nmos[w]
print @n.xbgr.xm35_u6.nsg13_hv_nmos[l]
print @n.xbgr.xm35_u6.nsg13_hv_nmos[delvto]
print @n.xbgr.xm35_u6.nsg13_hv_nmos[factuo]
print @n.xbgr.xm35_u7.nsg13_hv_nmos[w]
print @n.xbgr.xm35_u7.nsg13_hv_nmos[l]
print @n.xbgr.xm35_u7.nsg13_hv_nmos[delvto]
print @n.xbgr.xm35_u7.nsg13_hv_nmos[factuo]
print @n.xbgr.xm35_u8.nsg13_hv_nmos[w]
print @n.xbgr.xm35_u8.nsg13_hv_nmos[l]
print @n.xbgr.xm35_u8.nsg13_hv_nmos[delvto]
print @n.xbgr.xm35_u8.nsg13_hv_nmos[factuo]
print @n.xbgr.xm35_u9.nsg13_hv_nmos[w]
print @n.xbgr.xm35_u9.nsg13_hv_nmos[l]
print @n.xbgr.xm35_u9.nsg13_hv_nmos[delvto]
print @n.xbgr.xm35_u9.nsg13_hv_nmos[factuo]
print @n.xbgr.xm35_u10.nsg13_hv_nmos[w]
print @n.xbgr.xm35_u10.nsg13_hv_nmos[l]
print @n.xbgr.xm35_u10.nsg13_hv_nmos[delvto]
print @n.xbgr.xm35_u10.nsg13_hv_nmos[factuo]
print @n.xbgr.xm35_u11.nsg13_hv_nmos[w]
print @n.xbgr.xm35_u11.nsg13_hv_nmos[l]
print @n.xbgr.xm35_u11.nsg13_hv_nmos[delvto]
print @n.xbgr.xm35_u11.nsg13_hv_nmos[factuo]
print @n.xbgr.xm35_u12.nsg13_hv_nmos[w]
print @n.xbgr.xm35_u12.nsg13_hv_nmos[l]
print @n.xbgr.xm35_u12.nsg13_hv_nmos[delvto]
print @n.xbgr.xm35_u12.nsg13_hv_nmos[factuo]
print @n.xbgr.xm35_u13.nsg13_hv_nmos[w]
print @n.xbgr.xm35_u13.nsg13_hv_nmos[l]
print @n.xbgr.xm35_u13.nsg13_hv_nmos[delvto]
print @n.xbgr.xm35_u13.nsg13_hv_nmos[factuo]
print @n.xbgr.xm35_u14.nsg13_hv_nmos[w]
print @n.xbgr.xm35_u14.nsg13_hv_nmos[l]
print @n.xbgr.xm35_u14.nsg13_hv_nmos[delvto]
print @n.xbgr.xm35_u14.nsg13_hv_nmos[factuo]
print @n.xbgr.xm35_u15.nsg13_hv_nmos[w]
print @n.xbgr.xm35_u15.nsg13_hv_nmos[l]
print @n.xbgr.xm35_u15.nsg13_hv_nmos[delvto]
print @n.xbgr.xm35_u15.nsg13_hv_nmos[factuo]
print @n.xbgr.xm35_u16.nsg13_hv_nmos[w]
print @n.xbgr.xm35_u16.nsg13_hv_nmos[l]
print @n.xbgr.xm35_u16.nsg13_hv_nmos[delvto]
print @n.xbgr.xm35_u16.nsg13_hv_nmos[factuo]
print @n.xbgr.xm35_u17.nsg13_hv_nmos[w]
print @n.xbgr.xm35_u17.nsg13_hv_nmos[l]
print @n.xbgr.xm35_u17.nsg13_hv_nmos[delvto]
print @n.xbgr.xm35_u17.nsg13_hv_nmos[factuo]
print @n.xbgr.xm35_u18.nsg13_hv_nmos[w]
print @n.xbgr.xm35_u18.nsg13_hv_nmos[l]
print @n.xbgr.xm35_u18.nsg13_hv_nmos[delvto]
print @n.xbgr.xm35_u18.nsg13_hv_nmos[factuo]
print @n.xbgr.xm35_u19.nsg13_hv_nmos[w]
print @n.xbgr.xm35_u19.nsg13_hv_nmos[l]
print @n.xbgr.xm35_u19.nsg13_hv_nmos[delvto]
print @n.xbgr.xm35_u19.nsg13_hv_nmos[factuo]
print @n.xbgr.xm35_u20.nsg13_hv_nmos[w]
print @n.xbgr.xm35_u20.nsg13_hv_nmos[l]
print @n.xbgr.xm35_u20.nsg13_hv_nmos[delvto]
print @n.xbgr.xm35_u20.nsg13_hv_nmos[factuo]
print @n.xbgr.xm35_u21.nsg13_hv_nmos[w]
print @n.xbgr.xm35_u21.nsg13_hv_nmos[l]
print @n.xbgr.xm35_u21.nsg13_hv_nmos[delvto]
print @n.xbgr.xm35_u21.nsg13_hv_nmos[factuo]
print @n.xbgr.xm35_u22.nsg13_hv_nmos[w]
print @n.xbgr.xm35_u22.nsg13_hv_nmos[l]
print @n.xbgr.xm35_u22.nsg13_hv_nmos[delvto]
print @n.xbgr.xm35_u22.nsg13_hv_nmos[factuo]
print @n.xbgr.xm35_u23.nsg13_hv_nmos[w]
print @n.xbgr.xm35_u23.nsg13_hv_nmos[l]
print @n.xbgr.xm35_u23.nsg13_hv_nmos[delvto]
print @n.xbgr.xm35_u23.nsg13_hv_nmos[factuo]
print @n.xbgr.xm35_u24.nsg13_hv_nmos[w]
print @n.xbgr.xm35_u24.nsg13_hv_nmos[l]
print @n.xbgr.xm35_u24.nsg13_hv_nmos[delvto]
print @n.xbgr.xm35_u24.nsg13_hv_nmos[factuo]
print @n.xbgr.xm36_u2.nsg13_hv_nmos[w]
print @n.xbgr.xm36_u2.nsg13_hv_nmos[l]
print @n.xbgr.xm36_u2.nsg13_hv_nmos[delvto]
print @n.xbgr.xm36_u2.nsg13_hv_nmos[factuo]
print @n.xbgr.xm36_u3.nsg13_hv_nmos[w]
print @n.xbgr.xm36_u3.nsg13_hv_nmos[l]
print @n.xbgr.xm36_u3.nsg13_hv_nmos[delvto]
print @n.xbgr.xm36_u3.nsg13_hv_nmos[factuo]
print @n.xbgr.xm36_u4.nsg13_hv_nmos[w]
print @n.xbgr.xm36_u4.nsg13_hv_nmos[l]
print @n.xbgr.xm36_u4.nsg13_hv_nmos[delvto]
print @n.xbgr.xm36_u4.nsg13_hv_nmos[factuo]
print @n.xbgr.xm36_u5.nsg13_hv_nmos[w]
print @n.xbgr.xm36_u5.nsg13_hv_nmos[l]
print @n.xbgr.xm36_u5.nsg13_hv_nmos[delvto]
print @n.xbgr.xm36_u5.nsg13_hv_nmos[factuo]
print @n.xbgr.xm36_u6.nsg13_hv_nmos[w]
print @n.xbgr.xm36_u6.nsg13_hv_nmos[l]
print @n.xbgr.xm36_u6.nsg13_hv_nmos[delvto]
print @n.xbgr.xm36_u6.nsg13_hv_nmos[factuo]
print @n.xbgr.xm36_u7.nsg13_hv_nmos[w]
print @n.xbgr.xm36_u7.nsg13_hv_nmos[l]
print @n.xbgr.xm36_u7.nsg13_hv_nmos[delvto]
print @n.xbgr.xm36_u7.nsg13_hv_nmos[factuo]
print @n.xbgr.xm36_u8.nsg13_hv_nmos[w]
print @n.xbgr.xm36_u8.nsg13_hv_nmos[l]
print @n.xbgr.xm36_u8.nsg13_hv_nmos[delvto]
print @n.xbgr.xm36_u8.nsg13_hv_nmos[factuo]
print @n.xbgr.xm36_u9.nsg13_hv_nmos[w]
print @n.xbgr.xm36_u9.nsg13_hv_nmos[l]
print @n.xbgr.xm36_u9.nsg13_hv_nmos[delvto]
print @n.xbgr.xm36_u9.nsg13_hv_nmos[factuo]
print @n.xbgr.xm36_u10.nsg13_hv_nmos[w]
print @n.xbgr.xm36_u10.nsg13_hv_nmos[l]
print @n.xbgr.xm36_u10.nsg13_hv_nmos[delvto]
print @n.xbgr.xm36_u10.nsg13_hv_nmos[factuo]
print @n.xbgr.xm36_u11.nsg13_hv_nmos[w]
print @n.xbgr.xm36_u11.nsg13_hv_nmos[l]
print @n.xbgr.xm36_u11.nsg13_hv_nmos[delvto]
print @n.xbgr.xm36_u11.nsg13_hv_nmos[factuo]
print @n.xbgr.xm36_u12.nsg13_hv_nmos[w]
print @n.xbgr.xm36_u12.nsg13_hv_nmos[l]
print @n.xbgr.xm36_u12.nsg13_hv_nmos[delvto]
print @n.xbgr.xm36_u12.nsg13_hv_nmos[factuo]
print @n.xbgr.xm36_u13.nsg13_hv_nmos[w]
print @n.xbgr.xm36_u13.nsg13_hv_nmos[l]
print @n.xbgr.xm36_u13.nsg13_hv_nmos[delvto]
print @n.xbgr.xm36_u13.nsg13_hv_nmos[factuo]
print @n.xbgr.xm36_u14.nsg13_hv_nmos[w]
print @n.xbgr.xm36_u14.nsg13_hv_nmos[l]
print @n.xbgr.xm36_u14.nsg13_hv_nmos[delvto]
print @n.xbgr.xm36_u14.nsg13_hv_nmos[factuo]
print @n.xbgr.xm36_u15.nsg13_hv_nmos[w]
print @n.xbgr.xm36_u15.nsg13_hv_nmos[l]
print @n.xbgr.xm36_u15.nsg13_hv_nmos[delvto]
print @n.xbgr.xm36_u15.nsg13_hv_nmos[factuo]
print @n.xbgr.xm36_u16.nsg13_hv_nmos[w]
print @n.xbgr.xm36_u16.nsg13_hv_nmos[l]
print @n.xbgr.xm36_u16.nsg13_hv_nmos[delvto]
print @n.xbgr.xm36_u16.nsg13_hv_nmos[factuo]
print @n.xbgr.xm36_u17.nsg13_hv_nmos[w]
print @n.xbgr.xm36_u17.nsg13_hv_nmos[l]
print @n.xbgr.xm36_u17.nsg13_hv_nmos[delvto]
print @n.xbgr.xm36_u17.nsg13_hv_nmos[factuo]
print @n.xbgr.xm36_u18.nsg13_hv_nmos[w]
print @n.xbgr.xm36_u18.nsg13_hv_nmos[l]
print @n.xbgr.xm36_u18.nsg13_hv_nmos[delvto]
print @n.xbgr.xm36_u18.nsg13_hv_nmos[factuo]
print @n.xbgr.xm36_u19.nsg13_hv_nmos[w]
print @n.xbgr.xm36_u19.nsg13_hv_nmos[l]
print @n.xbgr.xm36_u19.nsg13_hv_nmos[delvto]
print @n.xbgr.xm36_u19.nsg13_hv_nmos[factuo]
print @n.xbgr.xm36_u20.nsg13_hv_nmos[w]
print @n.xbgr.xm36_u20.nsg13_hv_nmos[l]
print @n.xbgr.xm36_u20.nsg13_hv_nmos[delvto]
print @n.xbgr.xm36_u20.nsg13_hv_nmos[factuo]
print @n.xbgr.xm36_u21.nsg13_hv_nmos[w]
print @n.xbgr.xm36_u21.nsg13_hv_nmos[l]
print @n.xbgr.xm36_u21.nsg13_hv_nmos[delvto]
print @n.xbgr.xm36_u21.nsg13_hv_nmos[factuo]
print @n.xbgr.xm36_u22.nsg13_hv_nmos[w]
print @n.xbgr.xm36_u22.nsg13_hv_nmos[l]
print @n.xbgr.xm36_u22.nsg13_hv_nmos[delvto]
print @n.xbgr.xm36_u22.nsg13_hv_nmos[factuo]
print @n.xbgr.xm36_u23.nsg13_hv_nmos[w]
print @n.xbgr.xm36_u23.nsg13_hv_nmos[l]
print @n.xbgr.xm36_u23.nsg13_hv_nmos[delvto]
print @n.xbgr.xm36_u23.nsg13_hv_nmos[factuo]
print @n.xbgr.xm36_u24.nsg13_hv_nmos[w]
print @n.xbgr.xm36_u24.nsg13_hv_nmos[l]
print @n.xbgr.xm36_u24.nsg13_hv_nmos[delvto]
print @n.xbgr.xm36_u24.nsg13_hv_nmos[factuo]
print @n.xbgr.xm37_u2.nsg13_hv_nmos[w]
print @n.xbgr.xm37_u2.nsg13_hv_nmos[l]
print @n.xbgr.xm37_u2.nsg13_hv_nmos[delvto]
print @n.xbgr.xm37_u2.nsg13_hv_nmos[factuo]
print @n.xbgr.xm37_u3.nsg13_hv_nmos[w]
print @n.xbgr.xm37_u3.nsg13_hv_nmos[l]
print @n.xbgr.xm37_u3.nsg13_hv_nmos[delvto]
print @n.xbgr.xm37_u3.nsg13_hv_nmos[factuo]
print @n.xbgr.xm37_u4.nsg13_hv_nmos[w]
print @n.xbgr.xm37_u4.nsg13_hv_nmos[l]
print @n.xbgr.xm37_u4.nsg13_hv_nmos[delvto]
print @n.xbgr.xm37_u4.nsg13_hv_nmos[factuo]
print @n.xbgr.xm37_u5.nsg13_hv_nmos[w]
print @n.xbgr.xm37_u5.nsg13_hv_nmos[l]
print @n.xbgr.xm37_u5.nsg13_hv_nmos[delvto]
print @n.xbgr.xm37_u5.nsg13_hv_nmos[factuo]
print @n.xbgr.xm37_u6.nsg13_hv_nmos[w]
print @n.xbgr.xm37_u6.nsg13_hv_nmos[l]
print @n.xbgr.xm37_u6.nsg13_hv_nmos[delvto]
print @n.xbgr.xm37_u6.nsg13_hv_nmos[factuo]
print @n.xbgr.xm37_u7.nsg13_hv_nmos[w]
print @n.xbgr.xm37_u7.nsg13_hv_nmos[l]
print @n.xbgr.xm37_u7.nsg13_hv_nmos[delvto]
print @n.xbgr.xm37_u7.nsg13_hv_nmos[factuo]
print @n.xbgr.xm37_u8.nsg13_hv_nmos[w]
print @n.xbgr.xm37_u8.nsg13_hv_nmos[l]
print @n.xbgr.xm37_u8.nsg13_hv_nmos[delvto]
print @n.xbgr.xm37_u8.nsg13_hv_nmos[factuo]
print @n.xbgr.xm37_u9.nsg13_hv_nmos[w]
print @n.xbgr.xm37_u9.nsg13_hv_nmos[l]
print @n.xbgr.xm37_u9.nsg13_hv_nmos[delvto]
print @n.xbgr.xm37_u9.nsg13_hv_nmos[factuo]
print @n.xbgr.xm37_u10.nsg13_hv_nmos[w]
print @n.xbgr.xm37_u10.nsg13_hv_nmos[l]
print @n.xbgr.xm37_u10.nsg13_hv_nmos[delvto]
print @n.xbgr.xm37_u10.nsg13_hv_nmos[factuo]
print @n.xbgr.xm37_u11.nsg13_hv_nmos[w]
print @n.xbgr.xm37_u11.nsg13_hv_nmos[l]
print @n.xbgr.xm37_u11.nsg13_hv_nmos[delvto]
print @n.xbgr.xm37_u11.nsg13_hv_nmos[factuo]
print @n.xbgr.xm37_u12.nsg13_hv_nmos[w]
print @n.xbgr.xm37_u12.nsg13_hv_nmos[l]
print @n.xbgr.xm37_u12.nsg13_hv_nmos[delvto]
print @n.xbgr.xm37_u12.nsg13_hv_nmos[factuo]
print @n.xbgr.xm37_u13.nsg13_hv_nmos[w]
print @n.xbgr.xm37_u13.nsg13_hv_nmos[l]
print @n.xbgr.xm37_u13.nsg13_hv_nmos[delvto]
print @n.xbgr.xm37_u13.nsg13_hv_nmos[factuo]
print @n.xbgr.xm37_u14.nsg13_hv_nmos[w]
print @n.xbgr.xm37_u14.nsg13_hv_nmos[l]
print @n.xbgr.xm37_u14.nsg13_hv_nmos[delvto]
print @n.xbgr.xm37_u14.nsg13_hv_nmos[factuo]
print @n.xbgr.xm37_u15.nsg13_hv_nmos[w]
print @n.xbgr.xm37_u15.nsg13_hv_nmos[l]
print @n.xbgr.xm37_u15.nsg13_hv_nmos[delvto]
print @n.xbgr.xm37_u15.nsg13_hv_nmos[factuo]
print @n.xbgr.xm37_u16.nsg13_hv_nmos[w]
print @n.xbgr.xm37_u16.nsg13_hv_nmos[l]
print @n.xbgr.xm37_u16.nsg13_hv_nmos[delvto]
print @n.xbgr.xm37_u16.nsg13_hv_nmos[factuo]
print @n.xbgr.xm37_u17.nsg13_hv_nmos[w]
print @n.xbgr.xm37_u17.nsg13_hv_nmos[l]
print @n.xbgr.xm37_u17.nsg13_hv_nmos[delvto]
print @n.xbgr.xm37_u17.nsg13_hv_nmos[factuo]
print @n.xbgr.xm37_u18.nsg13_hv_nmos[w]
print @n.xbgr.xm37_u18.nsg13_hv_nmos[l]
print @n.xbgr.xm37_u18.nsg13_hv_nmos[delvto]
print @n.xbgr.xm37_u18.nsg13_hv_nmos[factuo]
print @n.xbgr.xm37_u19.nsg13_hv_nmos[w]
print @n.xbgr.xm37_u19.nsg13_hv_nmos[l]
print @n.xbgr.xm37_u19.nsg13_hv_nmos[delvto]
print @n.xbgr.xm37_u19.nsg13_hv_nmos[factuo]
print @n.xbgr.xm37_u20.nsg13_hv_nmos[w]
print @n.xbgr.xm37_u20.nsg13_hv_nmos[l]
print @n.xbgr.xm37_u20.nsg13_hv_nmos[delvto]
print @n.xbgr.xm37_u20.nsg13_hv_nmos[factuo]
print @n.xbgr.xm37_u21.nsg13_hv_nmos[w]
print @n.xbgr.xm37_u21.nsg13_hv_nmos[l]
print @n.xbgr.xm37_u21.nsg13_hv_nmos[delvto]
print @n.xbgr.xm37_u21.nsg13_hv_nmos[factuo]
print @n.xbgr.xm37_u22.nsg13_hv_nmos[w]
print @n.xbgr.xm37_u22.nsg13_hv_nmos[l]
print @n.xbgr.xm37_u22.nsg13_hv_nmos[delvto]
print @n.xbgr.xm37_u22.nsg13_hv_nmos[factuo]
print @n.xbgr.xm37_u23.nsg13_hv_nmos[w]
print @n.xbgr.xm37_u23.nsg13_hv_nmos[l]
print @n.xbgr.xm37_u23.nsg13_hv_nmos[delvto]
print @n.xbgr.xm37_u23.nsg13_hv_nmos[factuo]
print @n.xbgr.xm37_u24.nsg13_hv_nmos[w]
print @n.xbgr.xm37_u24.nsg13_hv_nmos[l]
print @n.xbgr.xm37_u24.nsg13_hv_nmos[delvto]
print @n.xbgr.xm37_u24.nsg13_hv_nmos[factuo]
print @n.xbgr.xm38_u2.nsg13_hv_pmos[w]
print @n.xbgr.xm38_u2.nsg13_hv_pmos[l]
print @n.xbgr.xm38_u2.nsg13_hv_pmos[delvto]
print @n.xbgr.xm38_u2.nsg13_hv_pmos[factuo]
print @n.xbgr.xm38_u3.nsg13_hv_pmos[w]
print @n.xbgr.xm38_u3.nsg13_hv_pmos[l]
print @n.xbgr.xm38_u3.nsg13_hv_pmos[delvto]
print @n.xbgr.xm38_u3.nsg13_hv_pmos[factuo]
print @n.xbgr.xm38_u4.nsg13_hv_pmos[w]
print @n.xbgr.xm38_u4.nsg13_hv_pmos[l]
print @n.xbgr.xm38_u4.nsg13_hv_pmos[delvto]
print @n.xbgr.xm38_u4.nsg13_hv_pmos[factuo]
print @n.xbgr.xm38_u5.nsg13_hv_pmos[w]
print @n.xbgr.xm38_u5.nsg13_hv_pmos[l]
print @n.xbgr.xm38_u5.nsg13_hv_pmos[delvto]
print @n.xbgr.xm38_u5.nsg13_hv_pmos[factuo]
print @n.xbgr.xm38_u6.nsg13_hv_pmos[w]
print @n.xbgr.xm38_u6.nsg13_hv_pmos[l]
print @n.xbgr.xm38_u6.nsg13_hv_pmos[delvto]
print @n.xbgr.xm38_u6.nsg13_hv_pmos[factuo]
print @n.xbgr.xm38_u7.nsg13_hv_pmos[w]
print @n.xbgr.xm38_u7.nsg13_hv_pmos[l]
print @n.xbgr.xm38_u7.nsg13_hv_pmos[delvto]
print @n.xbgr.xm38_u7.nsg13_hv_pmos[factuo]
print @n.xbgr.xm38_u8.nsg13_hv_pmos[w]
print @n.xbgr.xm38_u8.nsg13_hv_pmos[l]
print @n.xbgr.xm38_u8.nsg13_hv_pmos[delvto]
print @n.xbgr.xm38_u8.nsg13_hv_pmos[factuo]
print @n.xbgr.xm38_u9.nsg13_hv_pmos[w]
print @n.xbgr.xm38_u9.nsg13_hv_pmos[l]
print @n.xbgr.xm38_u9.nsg13_hv_pmos[delvto]
print @n.xbgr.xm38_u9.nsg13_hv_pmos[factuo]
print @n.xbgr.xm38_u10.nsg13_hv_pmos[w]
print @n.xbgr.xm38_u10.nsg13_hv_pmos[l]
print @n.xbgr.xm38_u10.nsg13_hv_pmos[delvto]
print @n.xbgr.xm38_u10.nsg13_hv_pmos[factuo]
print @n.xbgr.xm38_u11.nsg13_hv_pmos[w]
print @n.xbgr.xm38_u11.nsg13_hv_pmos[l]
print @n.xbgr.xm38_u11.nsg13_hv_pmos[delvto]
print @n.xbgr.xm38_u11.nsg13_hv_pmos[factuo]
print @n.xbgr.xm38_u12.nsg13_hv_pmos[w]
print @n.xbgr.xm38_u12.nsg13_hv_pmos[l]
print @n.xbgr.xm38_u12.nsg13_hv_pmos[delvto]
print @n.xbgr.xm38_u12.nsg13_hv_pmos[factuo]
print @n.xbgr.xm38_u13.nsg13_hv_pmos[w]
print @n.xbgr.xm38_u13.nsg13_hv_pmos[l]
print @n.xbgr.xm38_u13.nsg13_hv_pmos[delvto]
print @n.xbgr.xm38_u13.nsg13_hv_pmos[factuo]
print @n.xbgr.xm38_u14.nsg13_hv_pmos[w]
print @n.xbgr.xm38_u14.nsg13_hv_pmos[l]
print @n.xbgr.xm38_u14.nsg13_hv_pmos[delvto]
print @n.xbgr.xm38_u14.nsg13_hv_pmos[factuo]
print @n.xbgr.xm38_u15.nsg13_hv_pmos[w]
print @n.xbgr.xm38_u15.nsg13_hv_pmos[l]
print @n.xbgr.xm38_u15.nsg13_hv_pmos[delvto]
print @n.xbgr.xm38_u15.nsg13_hv_pmos[factuo]
print @n.xbgr.xm38_u16.nsg13_hv_pmos[w]
print @n.xbgr.xm38_u16.nsg13_hv_pmos[l]
print @n.xbgr.xm38_u16.nsg13_hv_pmos[delvto]
print @n.xbgr.xm38_u16.nsg13_hv_pmos[factuo]
print @n.xbgr.xm38_u17.nsg13_hv_pmos[w]
print @n.xbgr.xm38_u17.nsg13_hv_pmos[l]
print @n.xbgr.xm38_u17.nsg13_hv_pmos[delvto]
print @n.xbgr.xm38_u17.nsg13_hv_pmos[factuo]
print @n.xbgr.xm38_u18.nsg13_hv_pmos[w]
print @n.xbgr.xm38_u18.nsg13_hv_pmos[l]
print @n.xbgr.xm38_u18.nsg13_hv_pmos[delvto]
print @n.xbgr.xm38_u18.nsg13_hv_pmos[factuo]
print @n.xbgr.xm38_u19.nsg13_hv_pmos[w]
print @n.xbgr.xm38_u19.nsg13_hv_pmos[l]
print @n.xbgr.xm38_u19.nsg13_hv_pmos[delvto]
print @n.xbgr.xm38_u19.nsg13_hv_pmos[factuo]
print @n.xbgr.xm38_u20.nsg13_hv_pmos[w]
print @n.xbgr.xm38_u20.nsg13_hv_pmos[l]
print @n.xbgr.xm38_u20.nsg13_hv_pmos[delvto]
print @n.xbgr.xm38_u20.nsg13_hv_pmos[factuo]
print @n.xbgr.xm38_u21.nsg13_hv_pmos[w]
print @n.xbgr.xm38_u21.nsg13_hv_pmos[l]
print @n.xbgr.xm38_u21.nsg13_hv_pmos[delvto]
print @n.xbgr.xm38_u21.nsg13_hv_pmos[factuo]
print @n.xbgr.xm38_u22.nsg13_hv_pmos[w]
print @n.xbgr.xm38_u22.nsg13_hv_pmos[l]
print @n.xbgr.xm38_u22.nsg13_hv_pmos[delvto]
print @n.xbgr.xm38_u22.nsg13_hv_pmos[factuo]
print @n.xbgr.xm38_u23.nsg13_hv_pmos[w]
print @n.xbgr.xm38_u23.nsg13_hv_pmos[l]
print @n.xbgr.xm38_u23.nsg13_hv_pmos[delvto]
print @n.xbgr.xm38_u23.nsg13_hv_pmos[factuo]
print @n.xbgr.xm38_u24.nsg13_hv_pmos[w]
print @n.xbgr.xm38_u24.nsg13_hv_pmos[l]
print @n.xbgr.xm38_u24.nsg13_hv_pmos[delvto]
print @n.xbgr.xm38_u24.nsg13_hv_pmos[factuo]
print @n.xbgr.xm39_u2.nsg13_hv_pmos[w]
print @n.xbgr.xm39_u2.nsg13_hv_pmos[l]
print @n.xbgr.xm39_u2.nsg13_hv_pmos[delvto]
print @n.xbgr.xm39_u2.nsg13_hv_pmos[factuo]
print @n.xbgr.xm39_u3.nsg13_hv_pmos[w]
print @n.xbgr.xm39_u3.nsg13_hv_pmos[l]
print @n.xbgr.xm39_u3.nsg13_hv_pmos[delvto]
print @n.xbgr.xm39_u3.nsg13_hv_pmos[factuo]
print @n.xbgr.xm39_u4.nsg13_hv_pmos[w]
print @n.xbgr.xm39_u4.nsg13_hv_pmos[l]
print @n.xbgr.xm39_u4.nsg13_hv_pmos[delvto]
print @n.xbgr.xm39_u4.nsg13_hv_pmos[factuo]
print @n.xbgr.xm39_u5.nsg13_hv_pmos[w]
print @n.xbgr.xm39_u5.nsg13_hv_pmos[l]
print @n.xbgr.xm39_u5.nsg13_hv_pmos[delvto]
print @n.xbgr.xm39_u5.nsg13_hv_pmos[factuo]
print @n.xbgr.xm39_u6.nsg13_hv_pmos[w]
print @n.xbgr.xm39_u6.nsg13_hv_pmos[l]
print @n.xbgr.xm39_u6.nsg13_hv_pmos[delvto]
print @n.xbgr.xm39_u6.nsg13_hv_pmos[factuo]
print @n.xbgr.xm39_u7.nsg13_hv_pmos[w]
print @n.xbgr.xm39_u7.nsg13_hv_pmos[l]
print @n.xbgr.xm39_u7.nsg13_hv_pmos[delvto]
print @n.xbgr.xm39_u7.nsg13_hv_pmos[factuo]
print @n.xbgr.xm39_u8.nsg13_hv_pmos[w]
print @n.xbgr.xm39_u8.nsg13_hv_pmos[l]
print @n.xbgr.xm39_u8.nsg13_hv_pmos[delvto]
print @n.xbgr.xm39_u8.nsg13_hv_pmos[factuo]
print @n.xbgr.xm39_u9.nsg13_hv_pmos[w]
print @n.xbgr.xm39_u9.nsg13_hv_pmos[l]
print @n.xbgr.xm39_u9.nsg13_hv_pmos[delvto]
print @n.xbgr.xm39_u9.nsg13_hv_pmos[factuo]
print @n.xbgr.xm39_u10.nsg13_hv_pmos[w]
print @n.xbgr.xm39_u10.nsg13_hv_pmos[l]
print @n.xbgr.xm39_u10.nsg13_hv_pmos[delvto]
print @n.xbgr.xm39_u10.nsg13_hv_pmos[factuo]
print @n.xbgr.xm39_u11.nsg13_hv_pmos[w]
print @n.xbgr.xm39_u11.nsg13_hv_pmos[l]
print @n.xbgr.xm39_u11.nsg13_hv_pmos[delvto]
print @n.xbgr.xm39_u11.nsg13_hv_pmos[factuo]
print @n.xbgr.xm39_u12.nsg13_hv_pmos[w]
print @n.xbgr.xm39_u12.nsg13_hv_pmos[l]
print @n.xbgr.xm39_u12.nsg13_hv_pmos[delvto]
print @n.xbgr.xm39_u12.nsg13_hv_pmos[factuo]
print @n.xbgr.xm39_u13.nsg13_hv_pmos[w]
print @n.xbgr.xm39_u13.nsg13_hv_pmos[l]
print @n.xbgr.xm39_u13.nsg13_hv_pmos[delvto]
print @n.xbgr.xm39_u13.nsg13_hv_pmos[factuo]
print @n.xbgr.xm39_u14.nsg13_hv_pmos[w]
print @n.xbgr.xm39_u14.nsg13_hv_pmos[l]
print @n.xbgr.xm39_u14.nsg13_hv_pmos[delvto]
print @n.xbgr.xm39_u14.nsg13_hv_pmos[factuo]
print @n.xbgr.xm39_u15.nsg13_hv_pmos[w]
print @n.xbgr.xm39_u15.nsg13_hv_pmos[l]
print @n.xbgr.xm39_u15.nsg13_hv_pmos[delvto]
print @n.xbgr.xm39_u15.nsg13_hv_pmos[factuo]
print @n.xbgr.xm39_u16.nsg13_hv_pmos[w]
print @n.xbgr.xm39_u16.nsg13_hv_pmos[l]
print @n.xbgr.xm39_u16.nsg13_hv_pmos[delvto]
print @n.xbgr.xm39_u16.nsg13_hv_pmos[factuo]
print @n.xbgr.xm39_u17.nsg13_hv_pmos[w]
print @n.xbgr.xm39_u17.nsg13_hv_pmos[l]
print @n.xbgr.xm39_u17.nsg13_hv_pmos[delvto]
print @n.xbgr.xm39_u17.nsg13_hv_pmos[factuo]
print @n.xbgr.xm39_u18.nsg13_hv_pmos[w]
print @n.xbgr.xm39_u18.nsg13_hv_pmos[l]
print @n.xbgr.xm39_u18.nsg13_hv_pmos[delvto]
print @n.xbgr.xm39_u18.nsg13_hv_pmos[factuo]
print @n.xbgr.xm39_u19.nsg13_hv_pmos[w]
print @n.xbgr.xm39_u19.nsg13_hv_pmos[l]
print @n.xbgr.xm39_u19.nsg13_hv_pmos[delvto]
print @n.xbgr.xm39_u19.nsg13_hv_pmos[factuo]
print @n.xbgr.xm39_u20.nsg13_hv_pmos[w]
print @n.xbgr.xm39_u20.nsg13_hv_pmos[l]
print @n.xbgr.xm39_u20.nsg13_hv_pmos[delvto]
print @n.xbgr.xm39_u20.nsg13_hv_pmos[factuo]
print @n.xbgr.xm39_u21.nsg13_hv_pmos[w]
print @n.xbgr.xm39_u21.nsg13_hv_pmos[l]
print @n.xbgr.xm39_u21.nsg13_hv_pmos[delvto]
print @n.xbgr.xm39_u21.nsg13_hv_pmos[factuo]
print @n.xbgr.xm39_u22.nsg13_hv_pmos[w]
print @n.xbgr.xm39_u22.nsg13_hv_pmos[l]
print @n.xbgr.xm39_u22.nsg13_hv_pmos[delvto]
print @n.xbgr.xm39_u22.nsg13_hv_pmos[factuo]
print @n.xbgr.xm39_u23.nsg13_hv_pmos[w]
print @n.xbgr.xm39_u23.nsg13_hv_pmos[l]
print @n.xbgr.xm39_u23.nsg13_hv_pmos[delvto]
print @n.xbgr.xm39_u23.nsg13_hv_pmos[factuo]
print @n.xbgr.xm39_u24.nsg13_hv_pmos[w]
print @n.xbgr.xm39_u24.nsg13_hv_pmos[l]
print @n.xbgr.xm39_u24.nsg13_hv_pmos[delvto]
print @n.xbgr.xm39_u24.nsg13_hv_pmos[factuo]
print @n.xbgr.xm41_u2.nsg13_hv_pmos[w]
print @n.xbgr.xm41_u2.nsg13_hv_pmos[l]
print @n.xbgr.xm41_u2.nsg13_hv_pmos[delvto]
print @n.xbgr.xm41_u2.nsg13_hv_pmos[factuo]
print @n.xbgr.xm41_u3.nsg13_hv_pmos[w]
print @n.xbgr.xm41_u3.nsg13_hv_pmos[l]
print @n.xbgr.xm41_u3.nsg13_hv_pmos[delvto]
print @n.xbgr.xm41_u3.nsg13_hv_pmos[factuo]
print @n.xbgr.xm41_u4.nsg13_hv_pmos[w]
print @n.xbgr.xm41_u4.nsg13_hv_pmos[l]
print @n.xbgr.xm41_u4.nsg13_hv_pmos[delvto]
print @n.xbgr.xm41_u4.nsg13_hv_pmos[factuo]
print @n.xbgr.xm41_u5.nsg13_hv_pmos[w]
print @n.xbgr.xm41_u5.nsg13_hv_pmos[l]
print @n.xbgr.xm41_u5.nsg13_hv_pmos[delvto]
print @n.xbgr.xm41_u5.nsg13_hv_pmos[factuo]
print @n.xbgr.xm41_u6.nsg13_hv_pmos[w]
print @n.xbgr.xm41_u6.nsg13_hv_pmos[l]
print @n.xbgr.xm41_u6.nsg13_hv_pmos[delvto]
print @n.xbgr.xm41_u6.nsg13_hv_pmos[factuo]
print @n.xbgr.xm41_u7.nsg13_hv_pmos[w]
print @n.xbgr.xm41_u7.nsg13_hv_pmos[l]
print @n.xbgr.xm41_u7.nsg13_hv_pmos[delvto]
print @n.xbgr.xm41_u7.nsg13_hv_pmos[factuo]
print @n.xbgr.xm41_u8.nsg13_hv_pmos[w]
print @n.xbgr.xm41_u8.nsg13_hv_pmos[l]
print @n.xbgr.xm41_u8.nsg13_hv_pmos[delvto]
print @n.xbgr.xm41_u8.nsg13_hv_pmos[factuo]
print @n.xbgr.xm41_u9.nsg13_hv_pmos[w]
print @n.xbgr.xm41_u9.nsg13_hv_pmos[l]
print @n.xbgr.xm41_u9.nsg13_hv_pmos[delvto]
print @n.xbgr.xm41_u9.nsg13_hv_pmos[factuo]
print @n.xbgr.xm41_u10.nsg13_hv_pmos[w]
print @n.xbgr.xm41_u10.nsg13_hv_pmos[l]
print @n.xbgr.xm41_u10.nsg13_hv_pmos[delvto]
print @n.xbgr.xm41_u10.nsg13_hv_pmos[factuo]
print @n.xbgr.xm41_u11.nsg13_hv_pmos[w]
print @n.xbgr.xm41_u11.nsg13_hv_pmos[l]
print @n.xbgr.xm41_u11.nsg13_hv_pmos[delvto]
print @n.xbgr.xm41_u11.nsg13_hv_pmos[factuo]
print @n.xbgr.xm41_u12.nsg13_hv_pmos[w]
print @n.xbgr.xm41_u12.nsg13_hv_pmos[l]
print @n.xbgr.xm41_u12.nsg13_hv_pmos[delvto]
print @n.xbgr.xm41_u12.nsg13_hv_pmos[factuo]
print @n.xbgr.xm41_u13.nsg13_hv_pmos[w]
print @n.xbgr.xm41_u13.nsg13_hv_pmos[l]
print @n.xbgr.xm41_u13.nsg13_hv_pmos[delvto]
print @n.xbgr.xm41_u13.nsg13_hv_pmos[factuo]
print @n.xbgr.xm41_u14.nsg13_hv_pmos[w]
print @n.xbgr.xm41_u14.nsg13_hv_pmos[l]
print @n.xbgr.xm41_u14.nsg13_hv_pmos[delvto]
print @n.xbgr.xm41_u14.nsg13_hv_pmos[factuo]
print @n.xbgr.xm41_u15.nsg13_hv_pmos[w]
print @n.xbgr.xm41_u15.nsg13_hv_pmos[l]
print @n.xbgr.xm41_u15.nsg13_hv_pmos[delvto]
print @n.xbgr.xm41_u15.nsg13_hv_pmos[factuo]
print @n.xbgr.xm41_u16.nsg13_hv_pmos[w]
print @n.xbgr.xm41_u16.nsg13_hv_pmos[l]
print @n.xbgr.xm41_u16.nsg13_hv_pmos[delvto]
print @n.xbgr.xm41_u16.nsg13_hv_pmos[factuo]
print @n.xbgr.xm41_u17.nsg13_hv_pmos[w]
print @n.xbgr.xm41_u17.nsg13_hv_pmos[l]
print @n.xbgr.xm41_u17.nsg13_hv_pmos[delvto]
print @n.xbgr.xm41_u17.nsg13_hv_pmos[factuo]
print @n.xbgr.xm41_u18.nsg13_hv_pmos[w]
print @n.xbgr.xm41_u18.nsg13_hv_pmos[l]
print @n.xbgr.xm41_u18.nsg13_hv_pmos[delvto]
print @n.xbgr.xm41_u18.nsg13_hv_pmos[factuo]
print @n.xbgr.xm41_u19.nsg13_hv_pmos[w]
print @n.xbgr.xm41_u19.nsg13_hv_pmos[l]
print @n.xbgr.xm41_u19.nsg13_hv_pmos[delvto]
print @n.xbgr.xm41_u19.nsg13_hv_pmos[factuo]
print @n.xbgr.xm41_u20.nsg13_hv_pmos[w]
print @n.xbgr.xm41_u20.nsg13_hv_pmos[l]
print @n.xbgr.xm41_u20.nsg13_hv_pmos[delvto]
print @n.xbgr.xm41_u20.nsg13_hv_pmos[factuo]
print @n.xbgr.xm41_u21.nsg13_hv_pmos[w]
print @n.xbgr.xm41_u21.nsg13_hv_pmos[l]
print @n.xbgr.xm41_u21.nsg13_hv_pmos[delvto]
print @n.xbgr.xm41_u21.nsg13_hv_pmos[factuo]
print @n.xbgr.xm41_u22.nsg13_hv_pmos[w]
print @n.xbgr.xm41_u22.nsg13_hv_pmos[l]
print @n.xbgr.xm41_u22.nsg13_hv_pmos[delvto]
print @n.xbgr.xm41_u22.nsg13_hv_pmos[factuo]
print @n.xbgr.xm41_u23.nsg13_hv_pmos[w]
print @n.xbgr.xm41_u23.nsg13_hv_pmos[l]
print @n.xbgr.xm41_u23.nsg13_hv_pmos[delvto]
print @n.xbgr.xm41_u23.nsg13_hv_pmos[factuo]
print @n.xbgr.xm41_u24.nsg13_hv_pmos[w]
print @n.xbgr.xm41_u24.nsg13_hv_pmos[l]
print @n.xbgr.xm41_u24.nsg13_hv_pmos[delvto]
print @n.xbgr.xm41_u24.nsg13_hv_pmos[factuo]
print @n.xbgr.xm43_u2.nsg13_hv_pmos[w]
print @n.xbgr.xm43_u2.nsg13_hv_pmos[l]
print @n.xbgr.xm43_u2.nsg13_hv_pmos[delvto]
print @n.xbgr.xm43_u2.nsg13_hv_pmos[factuo]
print @n.xbgr.xm43_u3.nsg13_hv_pmos[w]
print @n.xbgr.xm43_u3.nsg13_hv_pmos[l]
print @n.xbgr.xm43_u3.nsg13_hv_pmos[delvto]
print @n.xbgr.xm43_u3.nsg13_hv_pmos[factuo]
print @n.xbgr.xm43_u4.nsg13_hv_pmos[w]
print @n.xbgr.xm43_u4.nsg13_hv_pmos[l]
print @n.xbgr.xm43_u4.nsg13_hv_pmos[delvto]
print @n.xbgr.xm43_u4.nsg13_hv_pmos[factuo]
print @n.xbgr.xm44_u2.nsg13_hv_pmos[w]
print @n.xbgr.xm44_u2.nsg13_hv_pmos[l]
print @n.xbgr.xm44_u2.nsg13_hv_pmos[delvto]
print @n.xbgr.xm44_u2.nsg13_hv_pmos[factuo]
print @n.xbgr.xm44_u3.nsg13_hv_pmos[w]
print @n.xbgr.xm44_u3.nsg13_hv_pmos[l]
print @n.xbgr.xm44_u3.nsg13_hv_pmos[delvto]
print @n.xbgr.xm44_u3.nsg13_hv_pmos[factuo]
print @n.xbgr.xm44_u4.nsg13_hv_pmos[w]
print @n.xbgr.xm44_u4.nsg13_hv_pmos[l]
print @n.xbgr.xm44_u4.nsg13_hv_pmos[delvto]
print @n.xbgr.xm44_u4.nsg13_hv_pmos[factuo]
print @n.xbgr.xm45_u2.nsg13_hv_pmos[w]
print @n.xbgr.xm45_u2.nsg13_hv_pmos[l]
print @n.xbgr.xm45_u2.nsg13_hv_pmos[delvto]
print @n.xbgr.xm45_u2.nsg13_hv_pmos[factuo]
print @n.xbgr.xm45_u3.nsg13_hv_pmos[w]
print @n.xbgr.xm45_u3.nsg13_hv_pmos[l]
print @n.xbgr.xm45_u3.nsg13_hv_pmos[delvto]
print @n.xbgr.xm45_u3.nsg13_hv_pmos[factuo]
print @n.xbgr.xm45_u4.nsg13_hv_pmos[w]
print @n.xbgr.xm45_u4.nsg13_hv_pmos[l]
print @n.xbgr.xm45_u4.nsg13_hv_pmos[delvto]
print @n.xbgr.xm45_u4.nsg13_hv_pmos[factuo]
print @n.xbgr.xm45_u5.nsg13_hv_pmos[w]
print @n.xbgr.xm45_u5.nsg13_hv_pmos[l]
print @n.xbgr.xm45_u5.nsg13_hv_pmos[delvto]
print @n.xbgr.xm45_u5.nsg13_hv_pmos[factuo]
print @n.xbgr.xm45_u6.nsg13_hv_pmos[w]
print @n.xbgr.xm45_u6.nsg13_hv_pmos[l]
print @n.xbgr.xm45_u6.nsg13_hv_pmos[delvto]
print @n.xbgr.xm45_u6.nsg13_hv_pmos[factuo]
print @n.xbgr.xm45_u7.nsg13_hv_pmos[w]
print @n.xbgr.xm45_u7.nsg13_hv_pmos[l]
print @n.xbgr.xm45_u7.nsg13_hv_pmos[delvto]
print @n.xbgr.xm45_u7.nsg13_hv_pmos[factuo]
print @n.xbgr.xm45_u8.nsg13_hv_pmos[w]
print @n.xbgr.xm45_u8.nsg13_hv_pmos[l]
print @n.xbgr.xm45_u8.nsg13_hv_pmos[delvto]
print @n.xbgr.xm45_u8.nsg13_hv_pmos[factuo]
print @n.xbgr.xm45_u9.nsg13_hv_pmos[w]
print @n.xbgr.xm45_u9.nsg13_hv_pmos[l]
print @n.xbgr.xm45_u9.nsg13_hv_pmos[delvto]
print @n.xbgr.xm45_u9.nsg13_hv_pmos[factuo]
print @n.xbgr.xm45_u10.nsg13_hv_pmos[w]
print @n.xbgr.xm45_u10.nsg13_hv_pmos[l]
print @n.xbgr.xm45_u10.nsg13_hv_pmos[delvto]
print @n.xbgr.xm45_u10.nsg13_hv_pmos[factuo]
print @n.xbgr.xm45_u11.nsg13_hv_pmos[w]
print @n.xbgr.xm45_u11.nsg13_hv_pmos[l]
print @n.xbgr.xm45_u11.nsg13_hv_pmos[delvto]
print @n.xbgr.xm45_u11.nsg13_hv_pmos[factuo]
print @n.xbgr.xm45_u12.nsg13_hv_pmos[w]
print @n.xbgr.xm45_u12.nsg13_hv_pmos[l]
print @n.xbgr.xm45_u12.nsg13_hv_pmos[delvto]
print @n.xbgr.xm45_u12.nsg13_hv_pmos[factuo]
print @n.xbgr.xm45_u13.nsg13_hv_pmos[w]
print @n.xbgr.xm45_u13.nsg13_hv_pmos[l]
print @n.xbgr.xm45_u13.nsg13_hv_pmos[delvto]
print @n.xbgr.xm45_u13.nsg13_hv_pmos[factuo]
print @n.xbgr.xm45_u14.nsg13_hv_pmos[w]
print @n.xbgr.xm45_u14.nsg13_hv_pmos[l]
print @n.xbgr.xm45_u14.nsg13_hv_pmos[delvto]
print @n.xbgr.xm45_u14.nsg13_hv_pmos[factuo]
print @n.xbgr.xm45_u15.nsg13_hv_pmos[w]
print @n.xbgr.xm45_u15.nsg13_hv_pmos[l]
print @n.xbgr.xm45_u15.nsg13_hv_pmos[delvto]
print @n.xbgr.xm45_u15.nsg13_hv_pmos[factuo]
print @n.xbgr.xm45_u16.nsg13_hv_pmos[w]
print @n.xbgr.xm45_u16.nsg13_hv_pmos[l]
print @n.xbgr.xm45_u16.nsg13_hv_pmos[delvto]
print @n.xbgr.xm45_u16.nsg13_hv_pmos[factuo]
print @n.xbgr.xm45_u17.nsg13_hv_pmos[w]
print @n.xbgr.xm45_u17.nsg13_hv_pmos[l]
print @n.xbgr.xm45_u17.nsg13_hv_pmos[delvto]
print @n.xbgr.xm45_u17.nsg13_hv_pmos[factuo]
print @n.xbgr.xm45_u18.nsg13_hv_pmos[w]
print @n.xbgr.xm45_u18.nsg13_hv_pmos[l]
print @n.xbgr.xm45_u18.nsg13_hv_pmos[delvto]
print @n.xbgr.xm45_u18.nsg13_hv_pmos[factuo]
print @n.xbgr.xm45_u19.nsg13_hv_pmos[w]
print @n.xbgr.xm45_u19.nsg13_hv_pmos[l]
print @n.xbgr.xm45_u19.nsg13_hv_pmos[delvto]
print @n.xbgr.xm45_u19.nsg13_hv_pmos[factuo]
print @n.xbgr.xm45_u20.nsg13_hv_pmos[w]
print @n.xbgr.xm45_u20.nsg13_hv_pmos[l]
print @n.xbgr.xm45_u20.nsg13_hv_pmos[delvto]
print @n.xbgr.xm45_u20.nsg13_hv_pmos[factuo]
print @n.xbgr.xm45_u21.nsg13_hv_pmos[w]
print @n.xbgr.xm45_u21.nsg13_hv_pmos[l]
print @n.xbgr.xm45_u21.nsg13_hv_pmos[delvto]
print @n.xbgr.xm45_u21.nsg13_hv_pmos[factuo]
print @n.xbgr.xm45_u22.nsg13_hv_pmos[w]
print @n.xbgr.xm45_u22.nsg13_hv_pmos[l]
print @n.xbgr.xm45_u22.nsg13_hv_pmos[delvto]
print @n.xbgr.xm45_u22.nsg13_hv_pmos[factuo]
print @n.xbgr.xm45_u23.nsg13_hv_pmos[w]
print @n.xbgr.xm45_u23.nsg13_hv_pmos[l]
print @n.xbgr.xm45_u23.nsg13_hv_pmos[delvto]
print @n.xbgr.xm45_u23.nsg13_hv_pmos[factuo]
print @n.xbgr.xm45_u24.nsg13_hv_pmos[w]
print @n.xbgr.xm45_u24.nsg13_hv_pmos[l]
print @n.xbgr.xm45_u24.nsg13_hv_pmos[delvto]
print @n.xbgr.xm45_u24.nsg13_hv_pmos[factuo]
print @n.xbgr.xm47_u2.nsg13_hv_pmos[w]
print @n.xbgr.xm47_u2.nsg13_hv_pmos[l]
print @n.xbgr.xm47_u2.nsg13_hv_pmos[delvto]
print @n.xbgr.xm47_u2.nsg13_hv_pmos[factuo]
print @n.xbgr.xm47_u3.nsg13_hv_pmos[w]
print @n.xbgr.xm47_u3.nsg13_hv_pmos[l]
print @n.xbgr.xm47_u3.nsg13_hv_pmos[delvto]
print @n.xbgr.xm47_u3.nsg13_hv_pmos[factuo]
print @n.xbgr.xm47_u4.nsg13_hv_pmos[w]
print @n.xbgr.xm47_u4.nsg13_hv_pmos[l]
print @n.xbgr.xm47_u4.nsg13_hv_pmos[delvto]
print @n.xbgr.xm47_u4.nsg13_hv_pmos[factuo]
print @n.xbgr.xm47_u5.nsg13_hv_pmos[w]
print @n.xbgr.xm47_u5.nsg13_hv_pmos[l]
print @n.xbgr.xm47_u5.nsg13_hv_pmos[delvto]
print @n.xbgr.xm47_u5.nsg13_hv_pmos[factuo]
print @n.xbgr.xm47_u6.nsg13_hv_pmos[w]
print @n.xbgr.xm47_u6.nsg13_hv_pmos[l]
print @n.xbgr.xm47_u6.nsg13_hv_pmos[delvto]
print @n.xbgr.xm47_u6.nsg13_hv_pmos[factuo]
print @n.xbgr.xm47_u7.nsg13_hv_pmos[w]
print @n.xbgr.xm47_u7.nsg13_hv_pmos[l]
print @n.xbgr.xm47_u7.nsg13_hv_pmos[delvto]
print @n.xbgr.xm47_u7.nsg13_hv_pmos[factuo]
print @n.xbgr.xm47_u8.nsg13_hv_pmos[w]
print @n.xbgr.xm47_u8.nsg13_hv_pmos[l]
print @n.xbgr.xm47_u8.nsg13_hv_pmos[delvto]
print @n.xbgr.xm47_u8.nsg13_hv_pmos[factuo]
print @n.xbgr.xm47_u9.nsg13_hv_pmos[w]
print @n.xbgr.xm47_u9.nsg13_hv_pmos[l]
print @n.xbgr.xm47_u9.nsg13_hv_pmos[delvto]
print @n.xbgr.xm47_u9.nsg13_hv_pmos[factuo]
print @n.xbgr.xm47_u10.nsg13_hv_pmos[w]
print @n.xbgr.xm47_u10.nsg13_hv_pmos[l]
print @n.xbgr.xm47_u10.nsg13_hv_pmos[delvto]
print @n.xbgr.xm47_u10.nsg13_hv_pmos[factuo]
print @n.xbgr.xm47_u11.nsg13_hv_pmos[w]
print @n.xbgr.xm47_u11.nsg13_hv_pmos[l]
print @n.xbgr.xm47_u11.nsg13_hv_pmos[delvto]
print @n.xbgr.xm47_u11.nsg13_hv_pmos[factuo]
print @n.xbgr.xm47_u12.nsg13_hv_pmos[w]
print @n.xbgr.xm47_u12.nsg13_hv_pmos[l]
print @n.xbgr.xm47_u12.nsg13_hv_pmos[delvto]
print @n.xbgr.xm47_u12.nsg13_hv_pmos[factuo]
print @n.xbgr.xm47_u13.nsg13_hv_pmos[w]
print @n.xbgr.xm47_u13.nsg13_hv_pmos[l]
print @n.xbgr.xm47_u13.nsg13_hv_pmos[delvto]
print @n.xbgr.xm47_u13.nsg13_hv_pmos[factuo]
print @n.xbgr.xm47_u14.nsg13_hv_pmos[w]
print @n.xbgr.xm47_u14.nsg13_hv_pmos[l]
print @n.xbgr.xm47_u14.nsg13_hv_pmos[delvto]
print @n.xbgr.xm47_u14.nsg13_hv_pmos[factuo]
print @n.xbgr.xm47_u15.nsg13_hv_pmos[w]
print @n.xbgr.xm47_u15.nsg13_hv_pmos[l]
print @n.xbgr.xm47_u15.nsg13_hv_pmos[delvto]
print @n.xbgr.xm47_u15.nsg13_hv_pmos[factuo]
print @n.xbgr.xm47_u16.nsg13_hv_pmos[w]
print @n.xbgr.xm47_u16.nsg13_hv_pmos[l]
print @n.xbgr.xm47_u16.nsg13_hv_pmos[delvto]
print @n.xbgr.xm47_u16.nsg13_hv_pmos[factuo]
print @n.xbgr.xm47_u17.nsg13_hv_pmos[w]
print @n.xbgr.xm47_u17.nsg13_hv_pmos[l]
print @n.xbgr.xm47_u17.nsg13_hv_pmos[delvto]
print @n.xbgr.xm47_u17.nsg13_hv_pmos[factuo]
print @n.xbgr.xm47_u18.nsg13_hv_pmos[w]
print @n.xbgr.xm47_u18.nsg13_hv_pmos[l]
print @n.xbgr.xm47_u18.nsg13_hv_pmos[delvto]
print @n.xbgr.xm47_u18.nsg13_hv_pmos[factuo]
print @n.xbgr.xm47_u19.nsg13_hv_pmos[w]
print @n.xbgr.xm47_u19.nsg13_hv_pmos[l]
print @n.xbgr.xm47_u19.nsg13_hv_pmos[delvto]
print @n.xbgr.xm47_u19.nsg13_hv_pmos[factuo]
print @n.xbgr.xm47_u20.nsg13_hv_pmos[w]
print @n.xbgr.xm47_u20.nsg13_hv_pmos[l]
print @n.xbgr.xm47_u20.nsg13_hv_pmos[delvto]
print @n.xbgr.xm47_u20.nsg13_hv_pmos[factuo]
print @n.xbgr.xm47_u21.nsg13_hv_pmos[w]
print @n.xbgr.xm47_u21.nsg13_hv_pmos[l]
print @n.xbgr.xm47_u21.nsg13_hv_pmos[delvto]
print @n.xbgr.xm47_u21.nsg13_hv_pmos[factuo]
print @n.xbgr.xm47_u22.nsg13_hv_pmos[w]
print @n.xbgr.xm47_u22.nsg13_hv_pmos[l]
print @n.xbgr.xm47_u22.nsg13_hv_pmos[delvto]
print @n.xbgr.xm47_u22.nsg13_hv_pmos[factuo]
print @n.xbgr.xm47_u23.nsg13_hv_pmos[w]
print @n.xbgr.xm47_u23.nsg13_hv_pmos[l]
print @n.xbgr.xm47_u23.nsg13_hv_pmos[delvto]
print @n.xbgr.xm47_u23.nsg13_hv_pmos[factuo]
print @n.xbgr.xm47_u24.nsg13_hv_pmos[w]
print @n.xbgr.xm47_u24.nsg13_hv_pmos[l]
print @n.xbgr.xm47_u24.nsg13_hv_pmos[delvto]
print @n.xbgr.xm47_u24.nsg13_hv_pmos[factuo]
print @n.xbgr.xm48_u2.nsg13_hv_pmos[w]
print @n.xbgr.xm48_u2.nsg13_hv_pmos[l]
print @n.xbgr.xm48_u2.nsg13_hv_pmos[delvto]
print @n.xbgr.xm48_u2.nsg13_hv_pmos[factuo]
print @n.xbgr.xm48_u3.nsg13_hv_pmos[w]
print @n.xbgr.xm48_u3.nsg13_hv_pmos[l]
print @n.xbgr.xm48_u3.nsg13_hv_pmos[delvto]
print @n.xbgr.xm48_u3.nsg13_hv_pmos[factuo]
print @n.xbgr.xm48_u4.nsg13_hv_pmos[w]
print @n.xbgr.xm48_u4.nsg13_hv_pmos[l]
print @n.xbgr.xm48_u4.nsg13_hv_pmos[delvto]
print @n.xbgr.xm48_u4.nsg13_hv_pmos[factuo]
print @n.xbgr.xm48_u5.nsg13_hv_pmos[w]
print @n.xbgr.xm48_u5.nsg13_hv_pmos[l]
print @n.xbgr.xm48_u5.nsg13_hv_pmos[delvto]
print @n.xbgr.xm48_u5.nsg13_hv_pmos[factuo]
print @n.xbgr.xm48_u6.nsg13_hv_pmos[w]
print @n.xbgr.xm48_u6.nsg13_hv_pmos[l]
print @n.xbgr.xm48_u6.nsg13_hv_pmos[delvto]
print @n.xbgr.xm48_u6.nsg13_hv_pmos[factuo]
print @n.xbgr.xm48_u7.nsg13_hv_pmos[w]
print @n.xbgr.xm48_u7.nsg13_hv_pmos[l]
print @n.xbgr.xm48_u7.nsg13_hv_pmos[delvto]
print @n.xbgr.xm48_u7.nsg13_hv_pmos[factuo]
print @n.xbgr.xm48_u8.nsg13_hv_pmos[w]
print @n.xbgr.xm48_u8.nsg13_hv_pmos[l]
print @n.xbgr.xm48_u8.nsg13_hv_pmos[delvto]
print @n.xbgr.xm48_u8.nsg13_hv_pmos[factuo]
print @n.xbgr.xm48_u9.nsg13_hv_pmos[w]
print @n.xbgr.xm48_u9.nsg13_hv_pmos[l]
print @n.xbgr.xm48_u9.nsg13_hv_pmos[delvto]
print @n.xbgr.xm48_u9.nsg13_hv_pmos[factuo]
print @n.xbgr.xm48_u10.nsg13_hv_pmos[w]
print @n.xbgr.xm48_u10.nsg13_hv_pmos[l]
print @n.xbgr.xm48_u10.nsg13_hv_pmos[delvto]
print @n.xbgr.xm48_u10.nsg13_hv_pmos[factuo]
print @n.xbgr.xm48_u11.nsg13_hv_pmos[w]
print @n.xbgr.xm48_u11.nsg13_hv_pmos[l]
print @n.xbgr.xm48_u11.nsg13_hv_pmos[delvto]
print @n.xbgr.xm48_u11.nsg13_hv_pmos[factuo]
print @n.xbgr.xm48_u12.nsg13_hv_pmos[w]
print @n.xbgr.xm48_u12.nsg13_hv_pmos[l]
print @n.xbgr.xm48_u12.nsg13_hv_pmos[delvto]
print @n.xbgr.xm48_u12.nsg13_hv_pmos[factuo]
print @n.xbgr.xm48_u13.nsg13_hv_pmos[w]
print @n.xbgr.xm48_u13.nsg13_hv_pmos[l]
print @n.xbgr.xm48_u13.nsg13_hv_pmos[delvto]
print @n.xbgr.xm48_u13.nsg13_hv_pmos[factuo]
print @n.xbgr.xm48_u14.nsg13_hv_pmos[w]
print @n.xbgr.xm48_u14.nsg13_hv_pmos[l]
print @n.xbgr.xm48_u14.nsg13_hv_pmos[delvto]
print @n.xbgr.xm48_u14.nsg13_hv_pmos[factuo]
print @n.xbgr.xm48_u15.nsg13_hv_pmos[w]
print @n.xbgr.xm48_u15.nsg13_hv_pmos[l]
print @n.xbgr.xm48_u15.nsg13_hv_pmos[delvto]
print @n.xbgr.xm48_u15.nsg13_hv_pmos[factuo]
print @n.xbgr.xm48_u16.nsg13_hv_pmos[w]
print @n.xbgr.xm48_u16.nsg13_hv_pmos[l]
print @n.xbgr.xm48_u16.nsg13_hv_pmos[delvto]
print @n.xbgr.xm48_u16.nsg13_hv_pmos[factuo]
print @n.xbgr.xm48_u17.nsg13_hv_pmos[w]
print @n.xbgr.xm48_u17.nsg13_hv_pmos[l]
print @n.xbgr.xm48_u17.nsg13_hv_pmos[delvto]
print @n.xbgr.xm48_u17.nsg13_hv_pmos[factuo]
print @n.xbgr.xm48_u18.nsg13_hv_pmos[w]
print @n.xbgr.xm48_u18.nsg13_hv_pmos[l]
print @n.xbgr.xm48_u18.nsg13_hv_pmos[delvto]
print @n.xbgr.xm48_u18.nsg13_hv_pmos[factuo]
print @n.xbgr.xm48_u19.nsg13_hv_pmos[w]
print @n.xbgr.xm48_u19.nsg13_hv_pmos[l]
print @n.xbgr.xm48_u19.nsg13_hv_pmos[delvto]
print @n.xbgr.xm48_u19.nsg13_hv_pmos[factuo]
print @n.xbgr.xm48_u20.nsg13_hv_pmos[w]
print @n.xbgr.xm48_u20.nsg13_hv_pmos[l]
print @n.xbgr.xm48_u20.nsg13_hv_pmos[delvto]
print @n.xbgr.xm48_u20.nsg13_hv_pmos[factuo]
print @n.xbgr.xm48_u21.nsg13_hv_pmos[w]
print @n.xbgr.xm48_u21.nsg13_hv_pmos[l]
print @n.xbgr.xm48_u21.nsg13_hv_pmos[delvto]
print @n.xbgr.xm48_u21.nsg13_hv_pmos[factuo]
print @n.xbgr.xm48_u22.nsg13_hv_pmos[w]
print @n.xbgr.xm48_u22.nsg13_hv_pmos[l]
print @n.xbgr.xm48_u22.nsg13_hv_pmos[delvto]
print @n.xbgr.xm48_u22.nsg13_hv_pmos[factuo]
print @n.xbgr.xm48_u23.nsg13_hv_pmos[w]
print @n.xbgr.xm48_u23.nsg13_hv_pmos[l]
print @n.xbgr.xm48_u23.nsg13_hv_pmos[delvto]
print @n.xbgr.xm48_u23.nsg13_hv_pmos[factuo]
print @n.xbgr.xm48_u24.nsg13_hv_pmos[w]
print @n.xbgr.xm48_u24.nsg13_hv_pmos[l]
print @n.xbgr.xm48_u24.nsg13_hv_pmos[delvto]
print @n.xbgr.xm48_u24.nsg13_hv_pmos[factuo]
print @n.xbgr.xm50_u2.nsg13_hv_pmos[w]
print @n.xbgr.xm50_u2.nsg13_hv_pmos[l]
print @n.xbgr.xm50_u2.nsg13_hv_pmos[delvto]
print @n.xbgr.xm50_u2.nsg13_hv_pmos[factuo]
print @n.xbgr.xm50_u3.nsg13_hv_pmos[w]
print @n.xbgr.xm50_u3.nsg13_hv_pmos[l]
print @n.xbgr.xm50_u3.nsg13_hv_pmos[delvto]
print @n.xbgr.xm50_u3.nsg13_hv_pmos[factuo]
print @n.xbgr.xm50_u4.nsg13_hv_pmos[w]
print @n.xbgr.xm50_u4.nsg13_hv_pmos[l]
print @n.xbgr.xm50_u4.nsg13_hv_pmos[delvto]
print @n.xbgr.xm50_u4.nsg13_hv_pmos[factuo]
print @n.xbgr.xm50_u5.nsg13_hv_pmos[w]
print @n.xbgr.xm50_u5.nsg13_hv_pmos[l]
print @n.xbgr.xm50_u5.nsg13_hv_pmos[delvto]
print @n.xbgr.xm50_u5.nsg13_hv_pmos[factuo]
print @n.xbgr.xm50_u6.nsg13_hv_pmos[w]
print @n.xbgr.xm50_u6.nsg13_hv_pmos[l]
print @n.xbgr.xm50_u6.nsg13_hv_pmos[delvto]
print @n.xbgr.xm50_u6.nsg13_hv_pmos[factuo]
print @n.xbgr.xm50_u7.nsg13_hv_pmos[w]
print @n.xbgr.xm50_u7.nsg13_hv_pmos[l]
print @n.xbgr.xm50_u7.nsg13_hv_pmos[delvto]
print @n.xbgr.xm50_u7.nsg13_hv_pmos[factuo]
print @n.xbgr.xm50_u8.nsg13_hv_pmos[w]
print @n.xbgr.xm50_u8.nsg13_hv_pmos[l]
print @n.xbgr.xm50_u8.nsg13_hv_pmos[delvto]
print @n.xbgr.xm50_u8.nsg13_hv_pmos[factuo]
print @n.xbgr.xm50_u9.nsg13_hv_pmos[w]
print @n.xbgr.xm50_u9.nsg13_hv_pmos[l]
print @n.xbgr.xm50_u9.nsg13_hv_pmos[delvto]
print @n.xbgr.xm50_u9.nsg13_hv_pmos[factuo]
print @n.xbgr.xm50_u10.nsg13_hv_pmos[w]
print @n.xbgr.xm50_u10.nsg13_hv_pmos[l]
print @n.xbgr.xm50_u10.nsg13_hv_pmos[delvto]
print @n.xbgr.xm50_u10.nsg13_hv_pmos[factuo]
print @n.xbgr.xm50_u11.nsg13_hv_pmos[w]
print @n.xbgr.xm50_u11.nsg13_hv_pmos[l]
print @n.xbgr.xm50_u11.nsg13_hv_pmos[delvto]
print @n.xbgr.xm50_u11.nsg13_hv_pmos[factuo]
print @n.xbgr.xm50_u12.nsg13_hv_pmos[w]
print @n.xbgr.xm50_u12.nsg13_hv_pmos[l]
print @n.xbgr.xm50_u12.nsg13_hv_pmos[delvto]
print @n.xbgr.xm50_u12.nsg13_hv_pmos[factuo]
print @n.xbgr.xm50_u13.nsg13_hv_pmos[w]
print @n.xbgr.xm50_u13.nsg13_hv_pmos[l]
print @n.xbgr.xm50_u13.nsg13_hv_pmos[delvto]
print @n.xbgr.xm50_u13.nsg13_hv_pmos[factuo]
print @n.xbgr.xm50_u14.nsg13_hv_pmos[w]
print @n.xbgr.xm50_u14.nsg13_hv_pmos[l]
print @n.xbgr.xm50_u14.nsg13_hv_pmos[delvto]
print @n.xbgr.xm50_u14.nsg13_hv_pmos[factuo]
print @n.xbgr.xm50_u15.nsg13_hv_pmos[w]
print @n.xbgr.xm50_u15.nsg13_hv_pmos[l]
print @n.xbgr.xm50_u15.nsg13_hv_pmos[delvto]
print @n.xbgr.xm50_u15.nsg13_hv_pmos[factuo]
print @n.xbgr.xm50_u16.nsg13_hv_pmos[w]
print @n.xbgr.xm50_u16.nsg13_hv_pmos[l]
print @n.xbgr.xm50_u16.nsg13_hv_pmos[delvto]
print @n.xbgr.xm50_u16.nsg13_hv_pmos[factuo]
print @n.xbgr.xm50_u17.nsg13_hv_pmos[w]
print @n.xbgr.xm50_u17.nsg13_hv_pmos[l]
print @n.xbgr.xm50_u17.nsg13_hv_pmos[delvto]
print @n.xbgr.xm50_u17.nsg13_hv_pmos[factuo]
print @n.xbgr.xm50_u18.nsg13_hv_pmos[w]
print @n.xbgr.xm50_u18.nsg13_hv_pmos[l]
print @n.xbgr.xm50_u18.nsg13_hv_pmos[delvto]
print @n.xbgr.xm50_u18.nsg13_hv_pmos[factuo]
print @n.xbgr.xm50_u19.nsg13_hv_pmos[w]
print @n.xbgr.xm50_u19.nsg13_hv_pmos[l]
print @n.xbgr.xm50_u19.nsg13_hv_pmos[delvto]
print @n.xbgr.xm50_u19.nsg13_hv_pmos[factuo]
print @n.xbgr.xm50_u20.nsg13_hv_pmos[w]
print @n.xbgr.xm50_u20.nsg13_hv_pmos[l]
print @n.xbgr.xm50_u20.nsg13_hv_pmos[delvto]
print @n.xbgr.xm50_u20.nsg13_hv_pmos[factuo]
print @n.xbgr.xm50_u21.nsg13_hv_pmos[w]
print @n.xbgr.xm50_u21.nsg13_hv_pmos[l]
print @n.xbgr.xm50_u21.nsg13_hv_pmos[delvto]
print @n.xbgr.xm50_u21.nsg13_hv_pmos[factuo]
print @n.xbgr.xm50_u22.nsg13_hv_pmos[w]
print @n.xbgr.xm50_u22.nsg13_hv_pmos[l]
print @n.xbgr.xm50_u22.nsg13_hv_pmos[delvto]
print @n.xbgr.xm50_u22.nsg13_hv_pmos[factuo]
print @n.xbgr.xm50_u23.nsg13_hv_pmos[w]
print @n.xbgr.xm50_u23.nsg13_hv_pmos[l]
print @n.xbgr.xm50_u23.nsg13_hv_pmos[delvto]
print @n.xbgr.xm50_u23.nsg13_hv_pmos[factuo]
print @n.xbgr.xm50_u24.nsg13_hv_pmos[w]
print @n.xbgr.xm50_u24.nsg13_hv_pmos[l]
print @n.xbgr.xm50_u24.nsg13_hv_pmos[delvto]
print @n.xbgr.xm50_u24.nsg13_hv_pmos[factuo]
print @n.xbgr.xm51_u2.nsg13_hv_pmos[w]
print @n.xbgr.xm51_u2.nsg13_hv_pmos[l]
print @n.xbgr.xm51_u2.nsg13_hv_pmos[delvto]
print @n.xbgr.xm51_u2.nsg13_hv_pmos[factuo]
print @n.xbgr.xm51_u3.nsg13_hv_pmos[w]
print @n.xbgr.xm51_u3.nsg13_hv_pmos[l]
print @n.xbgr.xm51_u3.nsg13_hv_pmos[delvto]
print @n.xbgr.xm51_u3.nsg13_hv_pmos[factuo]
print @n.xbgr.xm51_u4.nsg13_hv_pmos[w]
print @n.xbgr.xm51_u4.nsg13_hv_pmos[l]
print @n.xbgr.xm51_u4.nsg13_hv_pmos[delvto]
print @n.xbgr.xm51_u4.nsg13_hv_pmos[factuo]
print @n.xbgr.xm52_u2.nsg13_hv_pmos[w]
print @n.xbgr.xm52_u2.nsg13_hv_pmos[l]
print @n.xbgr.xm52_u2.nsg13_hv_pmos[delvto]
print @n.xbgr.xm52_u2.nsg13_hv_pmos[factuo]
print @n.xbgr.xm52_u3.nsg13_hv_pmos[w]
print @n.xbgr.xm52_u3.nsg13_hv_pmos[l]
print @n.xbgr.xm52_u3.nsg13_hv_pmos[delvto]
print @n.xbgr.xm52_u3.nsg13_hv_pmos[factuo]
print @n.xbgr.xm52_u4.nsg13_hv_pmos[w]
print @n.xbgr.xm52_u4.nsg13_hv_pmos[l]
print @n.xbgr.xm52_u4.nsg13_hv_pmos[delvto]
print @n.xbgr.xm52_u4.nsg13_hv_pmos[factuo]
print @n.xbgr.xm52_u5.nsg13_hv_pmos[w]
print @n.xbgr.xm52_u5.nsg13_hv_pmos[l]
print @n.xbgr.xm52_u5.nsg13_hv_pmos[delvto]
print @n.xbgr.xm52_u5.nsg13_hv_pmos[factuo]
print @n.xbgr.xm52_u6.nsg13_hv_pmos[w]
print @n.xbgr.xm52_u6.nsg13_hv_pmos[l]
print @n.xbgr.xm52_u6.nsg13_hv_pmos[delvto]
print @n.xbgr.xm52_u6.nsg13_hv_pmos[factuo]
print @n.xbgr.xm52_u7.nsg13_hv_pmos[w]
print @n.xbgr.xm52_u7.nsg13_hv_pmos[l]
print @n.xbgr.xm52_u7.nsg13_hv_pmos[delvto]
print @n.xbgr.xm52_u7.nsg13_hv_pmos[factuo]
print @n.xbgr.xm52_u8.nsg13_hv_pmos[w]
print @n.xbgr.xm52_u8.nsg13_hv_pmos[l]
print @n.xbgr.xm52_u8.nsg13_hv_pmos[delvto]
print @n.xbgr.xm52_u8.nsg13_hv_pmos[factuo]
print @n.xbgr.xm52_u9.nsg13_hv_pmos[w]
print @n.xbgr.xm52_u9.nsg13_hv_pmos[l]
print @n.xbgr.xm52_u9.nsg13_hv_pmos[delvto]
print @n.xbgr.xm52_u9.nsg13_hv_pmos[factuo]
print @n.xbgr.xm52_u10.nsg13_hv_pmos[w]
print @n.xbgr.xm52_u10.nsg13_hv_pmos[l]
print @n.xbgr.xm52_u10.nsg13_hv_pmos[delvto]
print @n.xbgr.xm52_u10.nsg13_hv_pmos[factuo]
print @n.xbgr.xm52_u11.nsg13_hv_pmos[w]
print @n.xbgr.xm52_u11.nsg13_hv_pmos[l]
print @n.xbgr.xm52_u11.nsg13_hv_pmos[delvto]
print @n.xbgr.xm52_u11.nsg13_hv_pmos[factuo]
print @n.xbgr.xm52_u12.nsg13_hv_pmos[w]
print @n.xbgr.xm52_u12.nsg13_hv_pmos[l]
print @n.xbgr.xm52_u12.nsg13_hv_pmos[delvto]
print @n.xbgr.xm52_u12.nsg13_hv_pmos[factuo]
print @n.xbgr.xm52_u13.nsg13_hv_pmos[w]
print @n.xbgr.xm52_u13.nsg13_hv_pmos[l]
print @n.xbgr.xm52_u13.nsg13_hv_pmos[delvto]
print @n.xbgr.xm52_u13.nsg13_hv_pmos[factuo]
print @n.xbgr.xm52_u14.nsg13_hv_pmos[w]
print @n.xbgr.xm52_u14.nsg13_hv_pmos[l]
print @n.xbgr.xm52_u14.nsg13_hv_pmos[delvto]
print @n.xbgr.xm52_u14.nsg13_hv_pmos[factuo]
print @n.xbgr.xm52_u15.nsg13_hv_pmos[w]
print @n.xbgr.xm52_u15.nsg13_hv_pmos[l]
print @n.xbgr.xm52_u15.nsg13_hv_pmos[delvto]
print @n.xbgr.xm52_u15.nsg13_hv_pmos[factuo]
print @n.xbgr.xm52_u16.nsg13_hv_pmos[w]
print @n.xbgr.xm52_u16.nsg13_hv_pmos[l]
print @n.xbgr.xm52_u16.nsg13_hv_pmos[delvto]
print @n.xbgr.xm52_u16.nsg13_hv_pmos[factuo]
print @n.xbgr.xm52_u17.nsg13_hv_pmos[w]
print @n.xbgr.xm52_u17.nsg13_hv_pmos[l]
print @n.xbgr.xm52_u17.nsg13_hv_pmos[delvto]
print @n.xbgr.xm52_u17.nsg13_hv_pmos[factuo]
print @n.xbgr.xm52_u18.nsg13_hv_pmos[w]
print @n.xbgr.xm52_u18.nsg13_hv_pmos[l]
print @n.xbgr.xm52_u18.nsg13_hv_pmos[delvto]
print @n.xbgr.xm52_u18.nsg13_hv_pmos[factuo]
print @n.xbgr.xm52_u19.nsg13_hv_pmos[w]
print @n.xbgr.xm52_u19.nsg13_hv_pmos[l]
print @n.xbgr.xm52_u19.nsg13_hv_pmos[delvto]
print @n.xbgr.xm52_u19.nsg13_hv_pmos[factuo]
print @n.xbgr.xm52_u20.nsg13_hv_pmos[w]
print @n.xbgr.xm52_u20.nsg13_hv_pmos[l]
print @n.xbgr.xm52_u20.nsg13_hv_pmos[delvto]
print @n.xbgr.xm52_u20.nsg13_hv_pmos[factuo]
print @n.xbgr.xm52_u21.nsg13_hv_pmos[w]
print @n.xbgr.xm52_u21.nsg13_hv_pmos[l]
print @n.xbgr.xm52_u21.nsg13_hv_pmos[delvto]
print @n.xbgr.xm52_u21.nsg13_hv_pmos[factuo]
print @n.xbgr.xm52_u22.nsg13_hv_pmos[w]
print @n.xbgr.xm52_u22.nsg13_hv_pmos[l]
print @n.xbgr.xm52_u22.nsg13_hv_pmos[delvto]
print @n.xbgr.xm52_u22.nsg13_hv_pmos[factuo]
print @n.xbgr.xm52_u23.nsg13_hv_pmos[w]
print @n.xbgr.xm52_u23.nsg13_hv_pmos[l]
print @n.xbgr.xm52_u23.nsg13_hv_pmos[delvto]
print @n.xbgr.xm52_u23.nsg13_hv_pmos[factuo]
print @n.xbgr.xm52_u24.nsg13_hv_pmos[w]
print @n.xbgr.xm52_u24.nsg13_hv_pmos[l]
print @n.xbgr.xm52_u24.nsg13_hv_pmos[delvto]
print @n.xbgr.xm52_u24.nsg13_hv_pmos[factuo]
print @n.xbgr.xm54_u2.nsg13_hv_pmos[w]
print @n.xbgr.xm54_u2.nsg13_hv_pmos[l]
print @n.xbgr.xm54_u2.nsg13_hv_pmos[delvto]
print @n.xbgr.xm54_u2.nsg13_hv_pmos[factuo]
print @n.xbgr.xm54_u3.nsg13_hv_pmos[w]
print @n.xbgr.xm54_u3.nsg13_hv_pmos[l]
print @n.xbgr.xm54_u3.nsg13_hv_pmos[delvto]
print @n.xbgr.xm54_u3.nsg13_hv_pmos[factuo]
print @n.xbgr.xm54_u4.nsg13_hv_pmos[w]
print @n.xbgr.xm54_u4.nsg13_hv_pmos[l]
print @n.xbgr.xm54_u4.nsg13_hv_pmos[delvto]
print @n.xbgr.xm54_u4.nsg13_hv_pmos[factuo]
print @n.xbgr.xm54_u5.nsg13_hv_pmos[w]
print @n.xbgr.xm54_u5.nsg13_hv_pmos[l]
print @n.xbgr.xm54_u5.nsg13_hv_pmos[delvto]
print @n.xbgr.xm54_u5.nsg13_hv_pmos[factuo]
print @n.xbgr.xm54_u6.nsg13_hv_pmos[w]
print @n.xbgr.xm54_u6.nsg13_hv_pmos[l]
print @n.xbgr.xm54_u6.nsg13_hv_pmos[delvto]
print @n.xbgr.xm54_u6.nsg13_hv_pmos[factuo]
print @n.xbgr.xm54_u7.nsg13_hv_pmos[w]
print @n.xbgr.xm54_u7.nsg13_hv_pmos[l]
print @n.xbgr.xm54_u7.nsg13_hv_pmos[delvto]
print @n.xbgr.xm54_u7.nsg13_hv_pmos[factuo]
print @n.xbgr.xm54_u8.nsg13_hv_pmos[w]
print @n.xbgr.xm54_u8.nsg13_hv_pmos[l]
print @n.xbgr.xm54_u8.nsg13_hv_pmos[delvto]
print @n.xbgr.xm54_u8.nsg13_hv_pmos[factuo]
print @n.xbgr.xm54_u9.nsg13_hv_pmos[w]
print @n.xbgr.xm54_u9.nsg13_hv_pmos[l]
print @n.xbgr.xm54_u9.nsg13_hv_pmos[delvto]
print @n.xbgr.xm54_u9.nsg13_hv_pmos[factuo]
print @n.xbgr.xm54_u10.nsg13_hv_pmos[w]
print @n.xbgr.xm54_u10.nsg13_hv_pmos[l]
print @n.xbgr.xm54_u10.nsg13_hv_pmos[delvto]
print @n.xbgr.xm54_u10.nsg13_hv_pmos[factuo]
print @n.xbgr.xm54_u11.nsg13_hv_pmos[w]
print @n.xbgr.xm54_u11.nsg13_hv_pmos[l]
print @n.xbgr.xm54_u11.nsg13_hv_pmos[delvto]
print @n.xbgr.xm54_u11.nsg13_hv_pmos[factuo]
print @n.xbgr.xm54_u12.nsg13_hv_pmos[w]
print @n.xbgr.xm54_u12.nsg13_hv_pmos[l]
print @n.xbgr.xm54_u12.nsg13_hv_pmos[delvto]
print @n.xbgr.xm54_u12.nsg13_hv_pmos[factuo]
print @n.xbgr.xm54_u13.nsg13_hv_pmos[w]
print @n.xbgr.xm54_u13.nsg13_hv_pmos[l]
print @n.xbgr.xm54_u13.nsg13_hv_pmos[delvto]
print @n.xbgr.xm54_u13.nsg13_hv_pmos[factuo]
print @n.xbgr.xm54_u14.nsg13_hv_pmos[w]
print @n.xbgr.xm54_u14.nsg13_hv_pmos[l]
print @n.xbgr.xm54_u14.nsg13_hv_pmos[delvto]
print @n.xbgr.xm54_u14.nsg13_hv_pmos[factuo]
print @n.xbgr.xm54_u15.nsg13_hv_pmos[w]
print @n.xbgr.xm54_u15.nsg13_hv_pmos[l]
print @n.xbgr.xm54_u15.nsg13_hv_pmos[delvto]
print @n.xbgr.xm54_u15.nsg13_hv_pmos[factuo]
print @n.xbgr.xm54_u16.nsg13_hv_pmos[w]
print @n.xbgr.xm54_u16.nsg13_hv_pmos[l]
print @n.xbgr.xm54_u16.nsg13_hv_pmos[delvto]
print @n.xbgr.xm54_u16.nsg13_hv_pmos[factuo]
print @n.xbgr.xm54_u17.nsg13_hv_pmos[w]
print @n.xbgr.xm54_u17.nsg13_hv_pmos[l]
print @n.xbgr.xm54_u17.nsg13_hv_pmos[delvto]
print @n.xbgr.xm54_u17.nsg13_hv_pmos[factuo]
print @n.xbgr.xm54_u18.nsg13_hv_pmos[w]
print @n.xbgr.xm54_u18.nsg13_hv_pmos[l]
print @n.xbgr.xm54_u18.nsg13_hv_pmos[delvto]
print @n.xbgr.xm54_u18.nsg13_hv_pmos[factuo]
print @n.xbgr.xm54_u19.nsg13_hv_pmos[w]
print @n.xbgr.xm54_u19.nsg13_hv_pmos[l]
print @n.xbgr.xm54_u19.nsg13_hv_pmos[delvto]
print @n.xbgr.xm54_u19.nsg13_hv_pmos[factuo]
print @n.xbgr.xm54_u20.nsg13_hv_pmos[w]
print @n.xbgr.xm54_u20.nsg13_hv_pmos[l]
print @n.xbgr.xm54_u20.nsg13_hv_pmos[delvto]
print @n.xbgr.xm54_u20.nsg13_hv_pmos[factuo]
print @n.xbgr.xm54_u21.nsg13_hv_pmos[w]
print @n.xbgr.xm54_u21.nsg13_hv_pmos[l]
print @n.xbgr.xm54_u21.nsg13_hv_pmos[delvto]
print @n.xbgr.xm54_u21.nsg13_hv_pmos[factuo]
print @n.xbgr.xm54_u22.nsg13_hv_pmos[w]
print @n.xbgr.xm54_u22.nsg13_hv_pmos[l]
print @n.xbgr.xm54_u22.nsg13_hv_pmos[delvto]
print @n.xbgr.xm54_u22.nsg13_hv_pmos[factuo]
print @n.xbgr.xm54_u23.nsg13_hv_pmos[w]
print @n.xbgr.xm54_u23.nsg13_hv_pmos[l]
print @n.xbgr.xm54_u23.nsg13_hv_pmos[delvto]
print @n.xbgr.xm54_u23.nsg13_hv_pmos[factuo]
print @n.xbgr.xm54_u24.nsg13_hv_pmos[w]
print @n.xbgr.xm54_u24.nsg13_hv_pmos[l]
print @n.xbgr.xm54_u24.nsg13_hv_pmos[delvto]
print @n.xbgr.xm54_u24.nsg13_hv_pmos[factuo]
print @q.xbgr.xq56_u2.qnpn13g2[area]
print @q.xbgr.xq56_u3.qnpn13g2[area]
print @q.xbgr.xq56_u4.qnpn13g2[area]
print @q.xbgr.xq56_u5.qnpn13g2[area]
print @q.xbgr.xq56_u6.qnpn13g2[area]
print @q.xbgr.xq56_u7.qnpn13g2[area]
print @q.xbgr.xq56_u8.qnpn13g2[area]
print @q.xbgr.xq56_u9.qnpn13g2[area]
print @q.xbgr.xq56_u10.qnpn13g2[area]
print @q.xbgr.xq56_u11.qnpn13g2[area]
print @q.xbgr.xq56_u12.qnpn13g2[area]
print @q.xbgr.xq56_u13.qnpn13g2[area]
print @q.xbgr.xq56_u14.qnpn13g2[area]
print @q.xbgr.xq56_u15.qnpn13g2[area]
print @q.xbgr.xq56_u16.qnpn13g2[area]
print @q.xbgr.xq56_u17.qnpn13g2[area]
print @q.xbgr.xq56_u18.qnpn13g2[area]
print @q.xbgr.xq56_u19.qnpn13g2[area]
print @q.xbgr.xq56_u20.qnpn13g2[area]
print @q.xbgr.xq56_u21.qnpn13g2[area]
print @q.xbgr.xq56_u22.qnpn13g2[area]
print @q.xbgr.xq56_u23.qnpn13g2[area]
print @q.xbgr.xq56_u24.qnpn13g2[area]
print @q.xbgr.xq60_u2.qnpn13g2[area]
print @q.xbgr.xq60_u3.qnpn13g2[area]
print @q.xbgr.xq60_u4.qnpn13g2[area]
print @q.xbgr.xq62_u2.qnpn13g2[area]
print @q.xbgr.xq62_u3.qnpn13g2[area]
print @q.xbgr.xq62_u4.qnpn13g2[area]
print @q.xbgr.xq62_u5.qnpn13g2[area]
print @q.xbgr.xq62_u6.qnpn13g2[area]
print @q.xbgr.xq62_u7.qnpn13g2[area]
print @q.xbgr.xq62_u8.qnpn13g2[area]
print @q.xbgr.xq62_u9.qnpn13g2[area]
print @q.xbgr.xq62_u10.qnpn13g2[area]
print @q.xbgr.xq62_u11.qnpn13g2[area]
print @q.xbgr.xq62_u12.qnpn13g2[area]
print @q.xbgr.xq62_u13.qnpn13g2[area]
print @q.xbgr.xq62_u14.qnpn13g2[area]
print @q.xbgr.xq62_u15.qnpn13g2[area]
print @q.xbgr.xq62_u16.qnpn13g2[area]
print @q.xbgr.xq62_u17.qnpn13g2[area]
print @q.xbgr.xq62_u18.qnpn13g2[area]
print @q.xbgr.xq62_u19.qnpn13g2[area]
print @q.xbgr.xq62_u20.qnpn13g2[area]
print @q.xbgr.xq62_u21.qnpn13g2[area]
print @q.xbgr.xq62_u22.qnpn13g2[area]
print @q.xbgr.xq62_u23.qnpn13g2[area]
print @q.xbgr.xq62_u24.qnpn13g2[area]
print @q.xbgr.xq67_u2.qnpn13g2[area]
print @q.xbgr.xq67_u3.qnpn13g2[area]
print @q.xbgr.xq67_u4.qnpn13g2[area]
print @q.xbgr.xq67_u5.qnpn13g2[area]
print @q.xbgr.xq67_u6.qnpn13g2[area]
print @q.xbgr.xq67_u7.qnpn13g2[area]
print @q.xbgr.xq67_u8.qnpn13g2[area]
print @q.xbgr.xq67_u9.qnpn13g2[area]
print @q.xbgr.xq67_u10.qnpn13g2[area]
print @q.xbgr.xq67_u11.qnpn13g2[area]
print @q.xbgr.xq67_u12.qnpn13g2[area]
print @q.xbgr.xq67_u13.qnpn13g2[area]
print @q.xbgr.xq67_u14.qnpn13g2[area]
print @q.xbgr.xq67_u15.qnpn13g2[area]
print @q.xbgr.xq67_u16.qnpn13g2[area]
print @q.xbgr.xq67_u17.qnpn13g2[area]
print @q.xbgr.xq67_u18.qnpn13g2[area]
print @q.xbgr.xq67_u19.qnpn13g2[area]
print @q.xbgr.xq67_u20.qnpn13g2[area]
print @q.xbgr.xq67_u21.qnpn13g2[area]
print @q.xbgr.xq67_u22.qnpn13g2[area]
print @q.xbgr.xq67_u23.qnpn13g2[area]
print @q.xbgr.xq67_u24.qnpn13g2[area]
print @q.xbgr.xq68_u2.qnpn13g2[area]
print @q.xbgr.xq68_u3.qnpn13g2[area]
print @q.xbgr.xq68_u4.qnpn13g2[area]
print @q.xbgr.xq68_u5.qnpn13g2[area]
print @q.xbgr.xq68_u6.qnpn13g2[area]
print @q.xbgr.xq68_u7.qnpn13g2[area]
print @q.xbgr.xq68_u8.qnpn13g2[area]
print @q.xbgr.xq68_u9.qnpn13g2[area]
print @q.xbgr.xq68_u10.qnpn13g2[area]
print @q.xbgr.xq68_u11.qnpn13g2[area]
print @q.xbgr.xq68_u12.qnpn13g2[area]
print @q.xbgr.xq68_u13.qnpn13g2[area]
print @q.xbgr.xq68_u14.qnpn13g2[area]
print @q.xbgr.xq68_u15.qnpn13g2[area]
print @q.xbgr.xq68_u16.qnpn13g2[area]
print @q.xbgr.xq68_u17.qnpn13g2[area]
print @q.xbgr.xq68_u18.qnpn13g2[area]
print @q.xbgr.xq68_u19.qnpn13g2[area]
print @q.xbgr.xq68_u20.qnpn13g2[area]
print @q.xbgr.xq68_u21.qnpn13g2[area]
print @q.xbgr.xq68_u22.qnpn13g2[area]
print @q.xbgr.xq68_u23.qnpn13g2[area]
print @q.xbgr.xq68_u24.qnpn13g2[area]
print @q.xbgr.xq69_u2.qnpn13g2[area]
print @q.xbgr.xq69_u3.qnpn13g2[area]
print @q.xbgr.xq69_u4.qnpn13g2[area]
print @q.xbgr.xq69_u5.qnpn13g2[area]
print @q.xbgr.xq69_u6.qnpn13g2[area]
print @q.xbgr.xq69_u7.qnpn13g2[area]
print @q.xbgr.xq69_u8.qnpn13g2[area]
print @q.xbgr.xq69_u9.qnpn13g2[area]
print @q.xbgr.xq69_u10.qnpn13g2[area]
print @q.xbgr.xq69_u11.qnpn13g2[area]
print @q.xbgr.xq69_u12.qnpn13g2[area]
print @q.xbgr.xq69_u13.qnpn13g2[area]
print @q.xbgr.xq69_u14.qnpn13g2[area]
print @q.xbgr.xq69_u15.qnpn13g2[area]
print @q.xbgr.xq69_u16.qnpn13g2[area]
print @q.xbgr.xq69_u17.qnpn13g2[area]
print @q.xbgr.xq69_u18.qnpn13g2[area]
print @q.xbgr.xq69_u19.qnpn13g2[area]
print @q.xbgr.xq69_u20.qnpn13g2[area]
print @q.xbgr.xq69_u21.qnpn13g2[area]
print @q.xbgr.xq69_u22.qnpn13g2[area]
print @q.xbgr.xq69_u23.qnpn13g2[area]
print @q.xbgr.xq69_u24.qnpn13g2[area]
print @q.xbgr.xq70_u2.qnpn13g2[area]
print @q.xbgr.xq70_u3.qnpn13g2[area]
print @q.xbgr.xq70_u4.qnpn13g2[area]
print @q.xbgr.xq70_u5.qnpn13g2[area]
print @q.xbgr.xq70_u6.qnpn13g2[area]
print @q.xbgr.xq70_u7.qnpn13g2[area]
print @q.xbgr.xq70_u8.qnpn13g2[area]
print @q.xbgr.xq70_u9.qnpn13g2[area]
print @q.xbgr.xq70_u10.qnpn13g2[area]
print @q.xbgr.xq70_u11.qnpn13g2[area]
print @q.xbgr.xq70_u12.qnpn13g2[area]
print @q.xbgr.xq70_u13.qnpn13g2[area]
print @q.xbgr.xq70_u14.qnpn13g2[area]
print @q.xbgr.xq70_u15.qnpn13g2[area]
print @q.xbgr.xq70_u16.qnpn13g2[area]
print @q.xbgr.xq70_u17.qnpn13g2[area]
print @q.xbgr.xq70_u18.qnpn13g2[area]
print @q.xbgr.xq70_u19.qnpn13g2[area]
print @q.xbgr.xq70_u20.qnpn13g2[area]
print @q.xbgr.xq70_u21.qnpn13g2[area]
print @q.xbgr.xq70_u22.qnpn13g2[area]
print @q.xbgr.xq70_u23.qnpn13g2[area]
print @q.xbgr.xq70_u24.qnpn13g2[area]
print @q.xbgr.xq71_u2.qnpn13g2[area]
print @q.xbgr.xq71_u3.qnpn13g2[area]
print @q.xbgr.xq71_u4.qnpn13g2[area]
print @q.xbgr.xq71_u5.qnpn13g2[area]
print @q.xbgr.xq71_u6.qnpn13g2[area]
print @q.xbgr.xq71_u7.qnpn13g2[area]
print @q.xbgr.xq71_u8.qnpn13g2[area]
print @q.xbgr.xq71_u9.qnpn13g2[area]
print @q.xbgr.xq71_u10.qnpn13g2[area]
print @q.xbgr.xq71_u11.qnpn13g2[area]
print @q.xbgr.xq71_u12.qnpn13g2[area]
print @q.xbgr.xq71_u13.qnpn13g2[area]
print @q.xbgr.xq71_u14.qnpn13g2[area]
print @q.xbgr.xq71_u15.qnpn13g2[area]
print @q.xbgr.xq71_u16.qnpn13g2[area]
print @q.xbgr.xq71_u17.qnpn13g2[area]
print @q.xbgr.xq71_u18.qnpn13g2[area]
print @q.xbgr.xq71_u19.qnpn13g2[area]
print @q.xbgr.xq71_u20.qnpn13g2[area]
print @q.xbgr.xq71_u21.qnpn13g2[area]
print @q.xbgr.xq71_u22.qnpn13g2[area]
print @q.xbgr.xq71_u23.qnpn13g2[area]
print @q.xbgr.xq71_u24.qnpn13g2[area]
print @q.xbgr.xq72_u2.qnpn13g2[area]
print @q.xbgr.xq72_u3.qnpn13g2[area]
print @q.xbgr.xq72_u4.qnpn13g2[area]
print @q.xbgr.xq72_u5.qnpn13g2[area]
print @q.xbgr.xq72_u6.qnpn13g2[area]
print @q.xbgr.xq72_u7.qnpn13g2[area]
print @q.xbgr.xq72_u8.qnpn13g2[area]
print @q.xbgr.xq72_u9.qnpn13g2[area]
print @q.xbgr.xq72_u10.qnpn13g2[area]
print @q.xbgr.xq72_u11.qnpn13g2[area]
print @q.xbgr.xq72_u12.qnpn13g2[area]
print @q.xbgr.xq72_u13.qnpn13g2[area]
print @q.xbgr.xq72_u14.qnpn13g2[area]
print @q.xbgr.xq72_u15.qnpn13g2[area]
print @q.xbgr.xq72_u16.qnpn13g2[area]
print @q.xbgr.xq72_u17.qnpn13g2[area]
print @q.xbgr.xq72_u18.qnpn13g2[area]
print @q.xbgr.xq72_u19.qnpn13g2[area]
print @q.xbgr.xq72_u20.qnpn13g2[area]
print @q.xbgr.xq72_u21.qnpn13g2[area]
print @q.xbgr.xq72_u22.qnpn13g2[area]
print @q.xbgr.xq72_u23.qnpn13g2[area]
print @q.xbgr.xq72_u24.qnpn13g2[area]
print @q.xbgr.xq73_u2.qnpn13g2[area]
print @q.xbgr.xq73_u3.qnpn13g2[area]
print @q.xbgr.xq73_u4.qnpn13g2[area]
print @q.xbgr.xq73_u5.qnpn13g2[area]
print @q.xbgr.xq73_u6.qnpn13g2[area]
print @q.xbgr.xq73_u7.qnpn13g2[area]
print @q.xbgr.xq73_u8.qnpn13g2[area]
print @q.xbgr.xq73_u9.qnpn13g2[area]
print @q.xbgr.xq73_u10.qnpn13g2[area]
print @q.xbgr.xq73_u11.qnpn13g2[area]
print @q.xbgr.xq73_u12.qnpn13g2[area]
print @q.xbgr.xq73_u13.qnpn13g2[area]
print @q.xbgr.xq73_u14.qnpn13g2[area]
print @q.xbgr.xq73_u15.qnpn13g2[area]
print @q.xbgr.xq73_u16.qnpn13g2[area]
print @q.xbgr.xq73_u17.qnpn13g2[area]
print @q.xbgr.xq73_u18.qnpn13g2[area]
print @q.xbgr.xq73_u19.qnpn13g2[area]
print @q.xbgr.xq73_u20.qnpn13g2[area]
print @q.xbgr.xq73_u21.qnpn13g2[area]
print @q.xbgr.xq73_u22.qnpn13g2[area]
print @q.xbgr.xq73_u23.qnpn13g2[area]
print @q.xbgr.xq73_u24.qnpn13g2[area]
print @q.xbgr.xq74_u2.qnpn13g2[area]
print @q.xbgr.xq74_u3.qnpn13g2[area]
print @q.xbgr.xq74_u4.qnpn13g2[area]
print @q.xbgr.xq74_u5.qnpn13g2[area]
print @q.xbgr.xq74_u6.qnpn13g2[area]
print @q.xbgr.xq74_u7.qnpn13g2[area]
print @q.xbgr.xq74_u8.qnpn13g2[area]
print @q.xbgr.xq74_u9.qnpn13g2[area]
print @q.xbgr.xq74_u10.qnpn13g2[area]
print @q.xbgr.xq74_u11.qnpn13g2[area]
print @q.xbgr.xq74_u12.qnpn13g2[area]
print @q.xbgr.xq74_u13.qnpn13g2[area]
print @q.xbgr.xq74_u14.qnpn13g2[area]
print @q.xbgr.xq74_u15.qnpn13g2[area]
print @q.xbgr.xq74_u16.qnpn13g2[area]
print @q.xbgr.xq74_u17.qnpn13g2[area]
print @q.xbgr.xq74_u18.qnpn13g2[area]
print @q.xbgr.xq74_u19.qnpn13g2[area]
print @q.xbgr.xq74_u20.qnpn13g2[area]
print @q.xbgr.xq74_u21.qnpn13g2[area]
print @q.xbgr.xq74_u22.qnpn13g2[area]
print @q.xbgr.xq74_u23.qnpn13g2[area]
print @q.xbgr.xq74_u24.qnpn13g2[area]
print @q.xbgr.xq75_u2.qnpn13g2[area]
print @q.xbgr.xq75_u3.qnpn13g2[area]
print @q.xbgr.xq75_u4.qnpn13g2[area]
print @q.xbgr.xq75_u5.qnpn13g2[area]
print @q.xbgr.xq75_u6.qnpn13g2[area]
print @q.xbgr.xq75_u7.qnpn13g2[area]
print @q.xbgr.xq75_u8.qnpn13g2[area]
print @q.xbgr.xq75_u9.qnpn13g2[area]
print @q.xbgr.xq75_u10.qnpn13g2[area]
print @q.xbgr.xq75_u11.qnpn13g2[area]
print @q.xbgr.xq75_u12.qnpn13g2[area]
print @q.xbgr.xq75_u13.qnpn13g2[area]
print @q.xbgr.xq75_u14.qnpn13g2[area]
print @q.xbgr.xq75_u15.qnpn13g2[area]
print @q.xbgr.xq75_u16.qnpn13g2[area]
print @q.xbgr.xq75_u17.qnpn13g2[area]
print @q.xbgr.xq75_u18.qnpn13g2[area]
print @q.xbgr.xq75_u19.qnpn13g2[area]
print @q.xbgr.xq75_u20.qnpn13g2[area]
print @q.xbgr.xq75_u21.qnpn13g2[area]
print @q.xbgr.xq75_u22.qnpn13g2[area]
print @q.xbgr.xq75_u23.qnpn13g2[area]
print @q.xbgr.xq75_u24.qnpn13g2[area]
print @q.xbgr.xq76_u2.qnpn13g2[area]
print @q.xbgr.xq76_u3.qnpn13g2[area]
print @q.xbgr.xq76_u4.qnpn13g2[area]
print @q.xbgr.xq76_u5.qnpn13g2[area]
print @q.xbgr.xq76_u6.qnpn13g2[area]
print @q.xbgr.xq76_u7.qnpn13g2[area]
print @q.xbgr.xq76_u8.qnpn13g2[area]
print @q.xbgr.xq76_u9.qnpn13g2[area]
print @q.xbgr.xq76_u10.qnpn13g2[area]
print @q.xbgr.xq76_u11.qnpn13g2[area]
print @q.xbgr.xq76_u12.qnpn13g2[area]
print @q.xbgr.xq76_u13.qnpn13g2[area]
print @q.xbgr.xq76_u14.qnpn13g2[area]
print @q.xbgr.xq76_u15.qnpn13g2[area]
print @q.xbgr.xq76_u16.qnpn13g2[area]
print @q.xbgr.xq76_u17.qnpn13g2[area]
print @q.xbgr.xq76_u18.qnpn13g2[area]
print @q.xbgr.xq76_u19.qnpn13g2[area]
print @q.xbgr.xq76_u20.qnpn13g2[area]
print @q.xbgr.xq76_u21.qnpn13g2[area]
print @q.xbgr.xq76_u22.qnpn13g2[area]
print @q.xbgr.xq76_u23.qnpn13g2[area]
print @q.xbgr.xq76_u24.qnpn13g2[area]
print @n.xbgr.xr77_u2.nr1[nsmm_rsh]
print @n.xbgr.xr77_u2.nr1[nsmm_w]
print @n.xbgr.xr77_u2.nr1[nsmm_l]
print @n.xbgr.xr77_u3.nr1[nsmm_rsh]
print @n.xbgr.xr77_u3.nr1[nsmm_w]
print @n.xbgr.xr77_u3.nr1[nsmm_l]
print @n.xbgr.xr77_u4.nr1[nsmm_rsh]
print @n.xbgr.xr77_u4.nr1[nsmm_w]
print @n.xbgr.xr77_u4.nr1[nsmm_l]
print @n.xbgr.xr77_u5.nr1[nsmm_rsh]
print @n.xbgr.xr77_u5.nr1[nsmm_w]
print @n.xbgr.xr77_u5.nr1[nsmm_l]
print @n.xbgr.xr77_u6.nr1[nsmm_rsh]
print @n.xbgr.xr77_u6.nr1[nsmm_w]
print @n.xbgr.xr77_u6.nr1[nsmm_l]
print @n.xbgr.xr77_u7.nr1[nsmm_rsh]
print @n.xbgr.xr77_u7.nr1[nsmm_w]
print @n.xbgr.xr77_u7.nr1[nsmm_l]
print @n.xbgr.xr77_u8.nr1[nsmm_rsh]
print @n.xbgr.xr77_u8.nr1[nsmm_w]
print @n.xbgr.xr77_u8.nr1[nsmm_l]
print @n.xbgr.xr77_u9.nr1[nsmm_rsh]
print @n.xbgr.xr77_u9.nr1[nsmm_w]
print @n.xbgr.xr77_u9.nr1[nsmm_l]
print @n.xbgr.xr77_u10.nr1[nsmm_rsh]
print @n.xbgr.xr77_u10.nr1[nsmm_w]
print @n.xbgr.xr77_u10.nr1[nsmm_l]
print @n.xbgr.xr77_u11.nr1[nsmm_rsh]
print @n.xbgr.xr77_u11.nr1[nsmm_w]
print @n.xbgr.xr77_u11.nr1[nsmm_l]
print @n.xbgr.xr77_u12.nr1[nsmm_rsh]
print @n.xbgr.xr77_u12.nr1[nsmm_w]
print @n.xbgr.xr77_u12.nr1[nsmm_l]
print @n.xbgr.xr77_u13.nr1[nsmm_rsh]
print @n.xbgr.xr77_u13.nr1[nsmm_w]
print @n.xbgr.xr77_u13.nr1[nsmm_l]
print @n.xbgr.xr77_u14.nr1[nsmm_rsh]
print @n.xbgr.xr77_u14.nr1[nsmm_w]
print @n.xbgr.xr77_u14.nr1[nsmm_l]
print @n.xbgr.xr77_u15.nr1[nsmm_rsh]
print @n.xbgr.xr77_u15.nr1[nsmm_w]
print @n.xbgr.xr77_u15.nr1[nsmm_l]
print @n.xbgr.xr77_u16.nr1[nsmm_rsh]
print @n.xbgr.xr77_u16.nr1[nsmm_w]
print @n.xbgr.xr77_u16.nr1[nsmm_l]
print @n.xbgr.xr77_u17.nr1[nsmm_rsh]
print @n.xbgr.xr77_u17.nr1[nsmm_w]
print @n.xbgr.xr77_u17.nr1[nsmm_l]
print @n.xbgr.xr77_u18.nr1[nsmm_rsh]
print @n.xbgr.xr77_u18.nr1[nsmm_w]
print @n.xbgr.xr77_u18.nr1[nsmm_l]
print @n.xbgr.xr77_u19.nr1[nsmm_rsh]
print @n.xbgr.xr77_u19.nr1[nsmm_w]
print @n.xbgr.xr77_u19.nr1[nsmm_l]
print @n.xbgr.xr77_u20.nr1[nsmm_rsh]
print @n.xbgr.xr77_u20.nr1[nsmm_w]
print @n.xbgr.xr77_u20.nr1[nsmm_l]
print @n.xbgr.xr77_u21.nr1[nsmm_rsh]
print @n.xbgr.xr77_u21.nr1[nsmm_w]
print @n.xbgr.xr77_u21.nr1[nsmm_l]
print @n.xbgr.xr77_u22.nr1[nsmm_rsh]
print @n.xbgr.xr77_u22.nr1[nsmm_w]
print @n.xbgr.xr77_u22.nr1[nsmm_l]
print @n.xbgr.xr77_u23.nr1[nsmm_rsh]
print @n.xbgr.xr77_u23.nr1[nsmm_w]
print @n.xbgr.xr77_u23.nr1[nsmm_l]
print @n.xbgr.xr77_u24.nr1[nsmm_rsh]
print @n.xbgr.xr77_u24.nr1[nsmm_w]
print @n.xbgr.xr77_u24.nr1[nsmm_l]
print @n.xbgr.xr78_u2.nr1[nsmm_rsh]
print @n.xbgr.xr78_u2.nr1[nsmm_w]
print @n.xbgr.xr78_u2.nr1[nsmm_l]
print @n.xbgr.xr78_u3.nr1[nsmm_rsh]
print @n.xbgr.xr78_u3.nr1[nsmm_w]
print @n.xbgr.xr78_u3.nr1[nsmm_l]
print @n.xbgr.xr78_u4.nr1[nsmm_rsh]
print @n.xbgr.xr78_u4.nr1[nsmm_w]
print @n.xbgr.xr78_u4.nr1[nsmm_l]
print @n.xbgr.xr78_u5.nr1[nsmm_rsh]
print @n.xbgr.xr78_u5.nr1[nsmm_w]
print @n.xbgr.xr78_u5.nr1[nsmm_l]
print @n.xbgr.xr78_u6.nr1[nsmm_rsh]
print @n.xbgr.xr78_u6.nr1[nsmm_w]
print @n.xbgr.xr78_u6.nr1[nsmm_l]
print @n.xbgr.xr78_u7.nr1[nsmm_rsh]
print @n.xbgr.xr78_u7.nr1[nsmm_w]
print @n.xbgr.xr78_u7.nr1[nsmm_l]
print @n.xbgr.xr78_u8.nr1[nsmm_rsh]
print @n.xbgr.xr78_u8.nr1[nsmm_w]
print @n.xbgr.xr78_u8.nr1[nsmm_l]
print @n.xbgr.xr78_u9.nr1[nsmm_rsh]
print @n.xbgr.xr78_u9.nr1[nsmm_w]
print @n.xbgr.xr78_u9.nr1[nsmm_l]
print @n.xbgr.xr78_u10.nr1[nsmm_rsh]
print @n.xbgr.xr78_u10.nr1[nsmm_w]
print @n.xbgr.xr78_u10.nr1[nsmm_l]
print @n.xbgr.xr78_u11.nr1[nsmm_rsh]
print @n.xbgr.xr78_u11.nr1[nsmm_w]
print @n.xbgr.xr78_u11.nr1[nsmm_l]
print @n.xbgr.xr78_u12.nr1[nsmm_rsh]
print @n.xbgr.xr78_u12.nr1[nsmm_w]
print @n.xbgr.xr78_u12.nr1[nsmm_l]
print @n.xbgr.xr78_u13.nr1[nsmm_rsh]
print @n.xbgr.xr78_u13.nr1[nsmm_w]
print @n.xbgr.xr78_u13.nr1[nsmm_l]
print @n.xbgr.xr78_u14.nr1[nsmm_rsh]
print @n.xbgr.xr78_u14.nr1[nsmm_w]
print @n.xbgr.xr78_u14.nr1[nsmm_l]
print @n.xbgr.xr78_u15.nr1[nsmm_rsh]
print @n.xbgr.xr78_u15.nr1[nsmm_w]
print @n.xbgr.xr78_u15.nr1[nsmm_l]
print @n.xbgr.xr78_u16.nr1[nsmm_rsh]
print @n.xbgr.xr78_u16.nr1[nsmm_w]
print @n.xbgr.xr78_u16.nr1[nsmm_l]
print @n.xbgr.xr78_u17.nr1[nsmm_rsh]
print @n.xbgr.xr78_u17.nr1[nsmm_w]
print @n.xbgr.xr78_u17.nr1[nsmm_l]
print @n.xbgr.xr78_u18.nr1[nsmm_rsh]
print @n.xbgr.xr78_u18.nr1[nsmm_w]
print @n.xbgr.xr78_u18.nr1[nsmm_l]
print @n.xbgr.xr78_u19.nr1[nsmm_rsh]
print @n.xbgr.xr78_u19.nr1[nsmm_w]
print @n.xbgr.xr78_u19.nr1[nsmm_l]
print @n.xbgr.xr78_u20.nr1[nsmm_rsh]
print @n.xbgr.xr78_u20.nr1[nsmm_w]
print @n.xbgr.xr78_u20.nr1[nsmm_l]
print @n.xbgr.xr78_u21.nr1[nsmm_rsh]
print @n.xbgr.xr78_u21.nr1[nsmm_w]
print @n.xbgr.xr78_u21.nr1[nsmm_l]
print @n.xbgr.xr78_u22.nr1[nsmm_rsh]
print @n.xbgr.xr78_u22.nr1[nsmm_w]
print @n.xbgr.xr78_u22.nr1[nsmm_l]
print @n.xbgr.xr78_u23.nr1[nsmm_rsh]
print @n.xbgr.xr78_u23.nr1[nsmm_w]
print @n.xbgr.xr78_u23.nr1[nsmm_l]
print @n.xbgr.xr78_u24.nr1[nsmm_rsh]
print @n.xbgr.xr78_u24.nr1[nsmm_w]
print @n.xbgr.xr78_u24.nr1[nsmm_l]
print @n.xbgr.xr79_u2.nr1[nsmm_rsh]
print @n.xbgr.xr79_u2.nr1[nsmm_w]
print @n.xbgr.xr79_u2.nr1[nsmm_l]
print @n.xbgr.xr79_u3.nr1[nsmm_rsh]
print @n.xbgr.xr79_u3.nr1[nsmm_w]
print @n.xbgr.xr79_u3.nr1[nsmm_l]
print @n.xbgr.xr79_u4.nr1[nsmm_rsh]
print @n.xbgr.xr79_u4.nr1[nsmm_w]
print @n.xbgr.xr79_u4.nr1[nsmm_l]
print @n.xbgr.xr79_u5.nr1[nsmm_rsh]
print @n.xbgr.xr79_u5.nr1[nsmm_w]
print @n.xbgr.xr79_u5.nr1[nsmm_l]
print @n.xbgr.xr79_u6.nr1[nsmm_rsh]
print @n.xbgr.xr79_u6.nr1[nsmm_w]
print @n.xbgr.xr79_u6.nr1[nsmm_l]
print @n.xbgr.xr79_u7.nr1[nsmm_rsh]
print @n.xbgr.xr79_u7.nr1[nsmm_w]
print @n.xbgr.xr79_u7.nr1[nsmm_l]
print @n.xbgr.xr79_u8.nr1[nsmm_rsh]
print @n.xbgr.xr79_u8.nr1[nsmm_w]
print @n.xbgr.xr79_u8.nr1[nsmm_l]
print @n.xbgr.xr79_u9.nr1[nsmm_rsh]
print @n.xbgr.xr79_u9.nr1[nsmm_w]
print @n.xbgr.xr79_u9.nr1[nsmm_l]
print @n.xbgr.xr79_u10.nr1[nsmm_rsh]
print @n.xbgr.xr79_u10.nr1[nsmm_w]
print @n.xbgr.xr79_u10.nr1[nsmm_l]
print @n.xbgr.xr79_u11.nr1[nsmm_rsh]
print @n.xbgr.xr79_u11.nr1[nsmm_w]
print @n.xbgr.xr79_u11.nr1[nsmm_l]
print @n.xbgr.xr79_u12.nr1[nsmm_rsh]
print @n.xbgr.xr79_u12.nr1[nsmm_w]
print @n.xbgr.xr79_u12.nr1[nsmm_l]
print @n.xbgr.xr79_u13.nr1[nsmm_rsh]
print @n.xbgr.xr79_u13.nr1[nsmm_w]
print @n.xbgr.xr79_u13.nr1[nsmm_l]
print @n.xbgr.xr79_u14.nr1[nsmm_rsh]
print @n.xbgr.xr79_u14.nr1[nsmm_w]
print @n.xbgr.xr79_u14.nr1[nsmm_l]
print @n.xbgr.xr79_u15.nr1[nsmm_rsh]
print @n.xbgr.xr79_u15.nr1[nsmm_w]
print @n.xbgr.xr79_u15.nr1[nsmm_l]
print @n.xbgr.xr79_u16.nr1[nsmm_rsh]
print @n.xbgr.xr79_u16.nr1[nsmm_w]
print @n.xbgr.xr79_u16.nr1[nsmm_l]
print @n.xbgr.xr79_u17.nr1[nsmm_rsh]
print @n.xbgr.xr79_u17.nr1[nsmm_w]
print @n.xbgr.xr79_u17.nr1[nsmm_l]
print @n.xbgr.xr79_u18.nr1[nsmm_rsh]
print @n.xbgr.xr79_u18.nr1[nsmm_w]
print @n.xbgr.xr79_u18.nr1[nsmm_l]
print @n.xbgr.xr79_u19.nr1[nsmm_rsh]
print @n.xbgr.xr79_u19.nr1[nsmm_w]
print @n.xbgr.xr79_u19.nr1[nsmm_l]
print @n.xbgr.xr79_u20.nr1[nsmm_rsh]
print @n.xbgr.xr79_u20.nr1[nsmm_w]
print @n.xbgr.xr79_u20.nr1[nsmm_l]
print @n.xbgr.xr79_u21.nr1[nsmm_rsh]
print @n.xbgr.xr79_u21.nr1[nsmm_w]
print @n.xbgr.xr79_u21.nr1[nsmm_l]
print @n.xbgr.xr79_u22.nr1[nsmm_rsh]
print @n.xbgr.xr79_u22.nr1[nsmm_w]
print @n.xbgr.xr79_u22.nr1[nsmm_l]
print @n.xbgr.xr79_u23.nr1[nsmm_rsh]
print @n.xbgr.xr79_u23.nr1[nsmm_w]
print @n.xbgr.xr79_u23.nr1[nsmm_l]
print @n.xbgr.xr79_u24.nr1[nsmm_rsh]
print @n.xbgr.xr79_u24.nr1[nsmm_w]
print @n.xbgr.xr79_u24.nr1[nsmm_l]
print @n.xbgr.xr80_u2.nr1[nsmm_rsh]
print @n.xbgr.xr80_u2.nr1[nsmm_w]
print @n.xbgr.xr80_u2.nr1[nsmm_l]
print @n.xbgr.xr80_u3.nr1[nsmm_rsh]
print @n.xbgr.xr80_u3.nr1[nsmm_w]
print @n.xbgr.xr80_u3.nr1[nsmm_l]
print @n.xbgr.xr80_u4.nr1[nsmm_rsh]
print @n.xbgr.xr80_u4.nr1[nsmm_w]
print @n.xbgr.xr80_u4.nr1[nsmm_l]
print @n.xbgr.xr80_u5.nr1[nsmm_rsh]
print @n.xbgr.xr80_u5.nr1[nsmm_w]
print @n.xbgr.xr80_u5.nr1[nsmm_l]
print @n.xbgr.xr80_u6.nr1[nsmm_rsh]
print @n.xbgr.xr80_u6.nr1[nsmm_w]
print @n.xbgr.xr80_u6.nr1[nsmm_l]
print @n.xbgr.xr80_u7.nr1[nsmm_rsh]
print @n.xbgr.xr80_u7.nr1[nsmm_w]
print @n.xbgr.xr80_u7.nr1[nsmm_l]
print @n.xbgr.xr80_u8.nr1[nsmm_rsh]
print @n.xbgr.xr80_u8.nr1[nsmm_w]
print @n.xbgr.xr80_u8.nr1[nsmm_l]
print @n.xbgr.xr80_u9.nr1[nsmm_rsh]
print @n.xbgr.xr80_u9.nr1[nsmm_w]
print @n.xbgr.xr80_u9.nr1[nsmm_l]
print @n.xbgr.xr80_u10.nr1[nsmm_rsh]
print @n.xbgr.xr80_u10.nr1[nsmm_w]
print @n.xbgr.xr80_u10.nr1[nsmm_l]
print @n.xbgr.xr80_u11.nr1[nsmm_rsh]
print @n.xbgr.xr80_u11.nr1[nsmm_w]
print @n.xbgr.xr80_u11.nr1[nsmm_l]
print @n.xbgr.xr80_u12.nr1[nsmm_rsh]
print @n.xbgr.xr80_u12.nr1[nsmm_w]
print @n.xbgr.xr80_u12.nr1[nsmm_l]
print @n.xbgr.xr80_u13.nr1[nsmm_rsh]
print @n.xbgr.xr80_u13.nr1[nsmm_w]
print @n.xbgr.xr80_u13.nr1[nsmm_l]
print @n.xbgr.xr80_u14.nr1[nsmm_rsh]
print @n.xbgr.xr80_u14.nr1[nsmm_w]
print @n.xbgr.xr80_u14.nr1[nsmm_l]
print @n.xbgr.xr80_u15.nr1[nsmm_rsh]
print @n.xbgr.xr80_u15.nr1[nsmm_w]
print @n.xbgr.xr80_u15.nr1[nsmm_l]
print @n.xbgr.xr80_u16.nr1[nsmm_rsh]
print @n.xbgr.xr80_u16.nr1[nsmm_w]
print @n.xbgr.xr80_u16.nr1[nsmm_l]
print @n.xbgr.xr80_u17.nr1[nsmm_rsh]
print @n.xbgr.xr80_u17.nr1[nsmm_w]
print @n.xbgr.xr80_u17.nr1[nsmm_l]
print @n.xbgr.xr80_u18.nr1[nsmm_rsh]
print @n.xbgr.xr80_u18.nr1[nsmm_w]
print @n.xbgr.xr80_u18.nr1[nsmm_l]
print @n.xbgr.xr80_u19.nr1[nsmm_rsh]
print @n.xbgr.xr80_u19.nr1[nsmm_w]
print @n.xbgr.xr80_u19.nr1[nsmm_l]
print @n.xbgr.xr80_u20.nr1[nsmm_rsh]
print @n.xbgr.xr80_u20.nr1[nsmm_w]
print @n.xbgr.xr80_u20.nr1[nsmm_l]
print @n.xbgr.xr80_u21.nr1[nsmm_rsh]
print @n.xbgr.xr80_u21.nr1[nsmm_w]
print @n.xbgr.xr80_u21.nr1[nsmm_l]
print @n.xbgr.xr80_u22.nr1[nsmm_rsh]
print @n.xbgr.xr80_u22.nr1[nsmm_w]
print @n.xbgr.xr80_u22.nr1[nsmm_l]
print @n.xbgr.xr80_u23.nr1[nsmm_rsh]
print @n.xbgr.xr80_u23.nr1[nsmm_w]
print @n.xbgr.xr80_u23.nr1[nsmm_l]
print @n.xbgr.xr80_u24.nr1[nsmm_rsh]
print @n.xbgr.xr80_u24.nr1[nsmm_w]
print @n.xbgr.xr80_u24.nr1[nsmm_l]
print @n.xbgr.xr81_u2.nr1[nsmm_rsh]
print @n.xbgr.xr81_u2.nr1[nsmm_w]
print @n.xbgr.xr81_u2.nr1[nsmm_l]
print @n.xbgr.xr81_u3.nr1[nsmm_rsh]
print @n.xbgr.xr81_u3.nr1[nsmm_w]
print @n.xbgr.xr81_u3.nr1[nsmm_l]
print @n.xbgr.xr81_u4.nr1[nsmm_rsh]
print @n.xbgr.xr81_u4.nr1[nsmm_w]
print @n.xbgr.xr81_u4.nr1[nsmm_l]
print @n.xbgr.xr81_u5.nr1[nsmm_rsh]
print @n.xbgr.xr81_u5.nr1[nsmm_w]
print @n.xbgr.xr81_u5.nr1[nsmm_l]
print @n.xbgr.xr81_u6.nr1[nsmm_rsh]
print @n.xbgr.xr81_u6.nr1[nsmm_w]
print @n.xbgr.xr81_u6.nr1[nsmm_l]
print @n.xbgr.xr81_u7.nr1[nsmm_rsh]
print @n.xbgr.xr81_u7.nr1[nsmm_w]
print @n.xbgr.xr81_u7.nr1[nsmm_l]
print @n.xbgr.xr81_u8.nr1[nsmm_rsh]
print @n.xbgr.xr81_u8.nr1[nsmm_w]
print @n.xbgr.xr81_u8.nr1[nsmm_l]
print @n.xbgr.xr81_u9.nr1[nsmm_rsh]
print @n.xbgr.xr81_u9.nr1[nsmm_w]
print @n.xbgr.xr81_u9.nr1[nsmm_l]
print @n.xbgr.xr81_u10.nr1[nsmm_rsh]
print @n.xbgr.xr81_u10.nr1[nsmm_w]
print @n.xbgr.xr81_u10.nr1[nsmm_l]
print @n.xbgr.xr81_u11.nr1[nsmm_rsh]
print @n.xbgr.xr81_u11.nr1[nsmm_w]
print @n.xbgr.xr81_u11.nr1[nsmm_l]
print @n.xbgr.xr81_u12.nr1[nsmm_rsh]
print @n.xbgr.xr81_u12.nr1[nsmm_w]
print @n.xbgr.xr81_u12.nr1[nsmm_l]
print @n.xbgr.xr81_u13.nr1[nsmm_rsh]
print @n.xbgr.xr81_u13.nr1[nsmm_w]
print @n.xbgr.xr81_u13.nr1[nsmm_l]
print @n.xbgr.xr81_u14.nr1[nsmm_rsh]
print @n.xbgr.xr81_u14.nr1[nsmm_w]
print @n.xbgr.xr81_u14.nr1[nsmm_l]
print @n.xbgr.xr81_u15.nr1[nsmm_rsh]
print @n.xbgr.xr81_u15.nr1[nsmm_w]
print @n.xbgr.xr81_u15.nr1[nsmm_l]
print @n.xbgr.xr81_u16.nr1[nsmm_rsh]
print @n.xbgr.xr81_u16.nr1[nsmm_w]
print @n.xbgr.xr81_u16.nr1[nsmm_l]
print @n.xbgr.xr81_u17.nr1[nsmm_rsh]
print @n.xbgr.xr81_u17.nr1[nsmm_w]
print @n.xbgr.xr81_u17.nr1[nsmm_l]
print @n.xbgr.xr81_u18.nr1[nsmm_rsh]
print @n.xbgr.xr81_u18.nr1[nsmm_w]
print @n.xbgr.xr81_u18.nr1[nsmm_l]
print @n.xbgr.xr81_u19.nr1[nsmm_rsh]
print @n.xbgr.xr81_u19.nr1[nsmm_w]
print @n.xbgr.xr81_u19.nr1[nsmm_l]
print @n.xbgr.xr81_u20.nr1[nsmm_rsh]
print @n.xbgr.xr81_u20.nr1[nsmm_w]
print @n.xbgr.xr81_u20.nr1[nsmm_l]
print @n.xbgr.xr81_u21.nr1[nsmm_rsh]
print @n.xbgr.xr81_u21.nr1[nsmm_w]
print @n.xbgr.xr81_u21.nr1[nsmm_l]
print @n.xbgr.xr81_u22.nr1[nsmm_rsh]
print @n.xbgr.xr81_u22.nr1[nsmm_w]
print @n.xbgr.xr81_u22.nr1[nsmm_l]
print @n.xbgr.xr81_u23.nr1[nsmm_rsh]
print @n.xbgr.xr81_u23.nr1[nsmm_w]
print @n.xbgr.xr81_u23.nr1[nsmm_l]
print @n.xbgr.xr81_u24.nr1[nsmm_rsh]
print @n.xbgr.xr81_u24.nr1[nsmm_w]
print @n.xbgr.xr81_u24.nr1[nsmm_l]
print @n.xbgr.xr82_u2.nr1[nsmm_rsh]
print @n.xbgr.xr82_u2.nr1[nsmm_w]
print @n.xbgr.xr82_u2.nr1[nsmm_l]
print @n.xbgr.xr82_u3.nr1[nsmm_rsh]
print @n.xbgr.xr82_u3.nr1[nsmm_w]
print @n.xbgr.xr82_u3.nr1[nsmm_l]
print @n.xbgr.xr82_u4.nr1[nsmm_rsh]
print @n.xbgr.xr82_u4.nr1[nsmm_w]
print @n.xbgr.xr82_u4.nr1[nsmm_l]
print @n.xbgr.xr82_u5.nr1[nsmm_rsh]
print @n.xbgr.xr82_u5.nr1[nsmm_w]
print @n.xbgr.xr82_u5.nr1[nsmm_l]
print @n.xbgr.xr82_u6.nr1[nsmm_rsh]
print @n.xbgr.xr82_u6.nr1[nsmm_w]
print @n.xbgr.xr82_u6.nr1[nsmm_l]
print @n.xbgr.xr82_u7.nr1[nsmm_rsh]
print @n.xbgr.xr82_u7.nr1[nsmm_w]
print @n.xbgr.xr82_u7.nr1[nsmm_l]
print @n.xbgr.xr82_u8.nr1[nsmm_rsh]
print @n.xbgr.xr82_u8.nr1[nsmm_w]
print @n.xbgr.xr82_u8.nr1[nsmm_l]
print @n.xbgr.xr82_u9.nr1[nsmm_rsh]
print @n.xbgr.xr82_u9.nr1[nsmm_w]
print @n.xbgr.xr82_u9.nr1[nsmm_l]
print @n.xbgr.xr82_u10.nr1[nsmm_rsh]
print @n.xbgr.xr82_u10.nr1[nsmm_w]
print @n.xbgr.xr82_u10.nr1[nsmm_l]
print @n.xbgr.xr82_u11.nr1[nsmm_rsh]
print @n.xbgr.xr82_u11.nr1[nsmm_w]
print @n.xbgr.xr82_u11.nr1[nsmm_l]
print @n.xbgr.xr82_u12.nr1[nsmm_rsh]
print @n.xbgr.xr82_u12.nr1[nsmm_w]
print @n.xbgr.xr82_u12.nr1[nsmm_l]
print @n.xbgr.xr82_u13.nr1[nsmm_rsh]
print @n.xbgr.xr82_u13.nr1[nsmm_w]
print @n.xbgr.xr82_u13.nr1[nsmm_l]
print @n.xbgr.xr82_u14.nr1[nsmm_rsh]
print @n.xbgr.xr82_u14.nr1[nsmm_w]
print @n.xbgr.xr82_u14.nr1[nsmm_l]
print @n.xbgr.xr82_u15.nr1[nsmm_rsh]
print @n.xbgr.xr82_u15.nr1[nsmm_w]
print @n.xbgr.xr82_u15.nr1[nsmm_l]
print @n.xbgr.xr82_u16.nr1[nsmm_rsh]
print @n.xbgr.xr82_u16.nr1[nsmm_w]
print @n.xbgr.xr82_u16.nr1[nsmm_l]
print @n.xbgr.xr82_u17.nr1[nsmm_rsh]
print @n.xbgr.xr82_u17.nr1[nsmm_w]
print @n.xbgr.xr82_u17.nr1[nsmm_l]
print @n.xbgr.xr82_u18.nr1[nsmm_rsh]
print @n.xbgr.xr82_u18.nr1[nsmm_w]
print @n.xbgr.xr82_u18.nr1[nsmm_l]
print @n.xbgr.xr82_u19.nr1[nsmm_rsh]
print @n.xbgr.xr82_u19.nr1[nsmm_w]
print @n.xbgr.xr82_u19.nr1[nsmm_l]
print @n.xbgr.xr82_u20.nr1[nsmm_rsh]
print @n.xbgr.xr82_u20.nr1[nsmm_w]
print @n.xbgr.xr82_u20.nr1[nsmm_l]
print @n.xbgr.xr82_u21.nr1[nsmm_rsh]
print @n.xbgr.xr82_u21.nr1[nsmm_w]
print @n.xbgr.xr82_u21.nr1[nsmm_l]
print @n.xbgr.xr82_u22.nr1[nsmm_rsh]
print @n.xbgr.xr82_u22.nr1[nsmm_w]
print @n.xbgr.xr82_u22.nr1[nsmm_l]
print @n.xbgr.xr82_u23.nr1[nsmm_rsh]
print @n.xbgr.xr82_u23.nr1[nsmm_w]
print @n.xbgr.xr82_u23.nr1[nsmm_l]
print @n.xbgr.xr82_u24.nr1[nsmm_rsh]
print @n.xbgr.xr82_u24.nr1[nsmm_w]
print @n.xbgr.xr82_u24.nr1[nsmm_l]
print @n.xbgr.xr83_u2.nr1[nsmm_rsh]
print @n.xbgr.xr83_u2.nr1[nsmm_w]
print @n.xbgr.xr83_u2.nr1[nsmm_l]
print @n.xbgr.xr83_u3.nr1[nsmm_rsh]
print @n.xbgr.xr83_u3.nr1[nsmm_w]
print @n.xbgr.xr83_u3.nr1[nsmm_l]
print @n.xbgr.xr83_u4.nr1[nsmm_rsh]
print @n.xbgr.xr83_u4.nr1[nsmm_w]
print @n.xbgr.xr83_u4.nr1[nsmm_l]
print @n.xbgr.xr83_u5.nr1[nsmm_rsh]
print @n.xbgr.xr83_u5.nr1[nsmm_w]
print @n.xbgr.xr83_u5.nr1[nsmm_l]
print @n.xbgr.xr83_u6.nr1[nsmm_rsh]
print @n.xbgr.xr83_u6.nr1[nsmm_w]
print @n.xbgr.xr83_u6.nr1[nsmm_l]
print @n.xbgr.xr83_u7.nr1[nsmm_rsh]
print @n.xbgr.xr83_u7.nr1[nsmm_w]
print @n.xbgr.xr83_u7.nr1[nsmm_l]
print @n.xbgr.xr83_u8.nr1[nsmm_rsh]
print @n.xbgr.xr83_u8.nr1[nsmm_w]
print @n.xbgr.xr83_u8.nr1[nsmm_l]
print @n.xbgr.xr83_u9.nr1[nsmm_rsh]
print @n.xbgr.xr83_u9.nr1[nsmm_w]
print @n.xbgr.xr83_u9.nr1[nsmm_l]
print @n.xbgr.xr83_u10.nr1[nsmm_rsh]
print @n.xbgr.xr83_u10.nr1[nsmm_w]
print @n.xbgr.xr83_u10.nr1[nsmm_l]
print @n.xbgr.xr83_u11.nr1[nsmm_rsh]
print @n.xbgr.xr83_u11.nr1[nsmm_w]
print @n.xbgr.xr83_u11.nr1[nsmm_l]
print @n.xbgr.xr83_u12.nr1[nsmm_rsh]
print @n.xbgr.xr83_u12.nr1[nsmm_w]
print @n.xbgr.xr83_u12.nr1[nsmm_l]
print @n.xbgr.xr83_u13.nr1[nsmm_rsh]
print @n.xbgr.xr83_u13.nr1[nsmm_w]
print @n.xbgr.xr83_u13.nr1[nsmm_l]
print @n.xbgr.xr83_u14.nr1[nsmm_rsh]
print @n.xbgr.xr83_u14.nr1[nsmm_w]
print @n.xbgr.xr83_u14.nr1[nsmm_l]
print @n.xbgr.xr83_u15.nr1[nsmm_rsh]
print @n.xbgr.xr83_u15.nr1[nsmm_w]
print @n.xbgr.xr83_u15.nr1[nsmm_l]
print @n.xbgr.xr83_u16.nr1[nsmm_rsh]
print @n.xbgr.xr83_u16.nr1[nsmm_w]
print @n.xbgr.xr83_u16.nr1[nsmm_l]
print @n.xbgr.xr83_u17.nr1[nsmm_rsh]
print @n.xbgr.xr83_u17.nr1[nsmm_w]
print @n.xbgr.xr83_u17.nr1[nsmm_l]
print @n.xbgr.xr83_u18.nr1[nsmm_rsh]
print @n.xbgr.xr83_u18.nr1[nsmm_w]
print @n.xbgr.xr83_u18.nr1[nsmm_l]
print @n.xbgr.xr83_u19.nr1[nsmm_rsh]
print @n.xbgr.xr83_u19.nr1[nsmm_w]
print @n.xbgr.xr83_u19.nr1[nsmm_l]
print @n.xbgr.xr83_u20.nr1[nsmm_rsh]
print @n.xbgr.xr83_u20.nr1[nsmm_w]
print @n.xbgr.xr83_u20.nr1[nsmm_l]
print @n.xbgr.xr83_u21.nr1[nsmm_rsh]
print @n.xbgr.xr83_u21.nr1[nsmm_w]
print @n.xbgr.xr83_u21.nr1[nsmm_l]
print @n.xbgr.xr83_u22.nr1[nsmm_rsh]
print @n.xbgr.xr83_u22.nr1[nsmm_w]
print @n.xbgr.xr83_u22.nr1[nsmm_l]
print @n.xbgr.xr83_u23.nr1[nsmm_rsh]
print @n.xbgr.xr83_u23.nr1[nsmm_w]
print @n.xbgr.xr83_u23.nr1[nsmm_l]
print @n.xbgr.xr83_u24.nr1[nsmm_rsh]
print @n.xbgr.xr83_u24.nr1[nsmm_w]
print @n.xbgr.xr83_u24.nr1[nsmm_l]
print @n.xbgr.xr84_u2.nr1[nsmm_rsh]
print @n.xbgr.xr84_u2.nr1[nsmm_w]
print @n.xbgr.xr84_u2.nr1[nsmm_l]
print @n.xbgr.xr84_u3.nr1[nsmm_rsh]
print @n.xbgr.xr84_u3.nr1[nsmm_w]
print @n.xbgr.xr84_u3.nr1[nsmm_l]
print @n.xbgr.xr84_u4.nr1[nsmm_rsh]
print @n.xbgr.xr84_u4.nr1[nsmm_w]
print @n.xbgr.xr84_u4.nr1[nsmm_l]
print @n.xbgr.xr84_u5.nr1[nsmm_rsh]
print @n.xbgr.xr84_u5.nr1[nsmm_w]
print @n.xbgr.xr84_u5.nr1[nsmm_l]
print @n.xbgr.xr84_u6.nr1[nsmm_rsh]
print @n.xbgr.xr84_u6.nr1[nsmm_w]
print @n.xbgr.xr84_u6.nr1[nsmm_l]
print @n.xbgr.xr84_u7.nr1[nsmm_rsh]
print @n.xbgr.xr84_u7.nr1[nsmm_w]
print @n.xbgr.xr84_u7.nr1[nsmm_l]
print @n.xbgr.xr84_u8.nr1[nsmm_rsh]
print @n.xbgr.xr84_u8.nr1[nsmm_w]
print @n.xbgr.xr84_u8.nr1[nsmm_l]
print @n.xbgr.xr84_u9.nr1[nsmm_rsh]
print @n.xbgr.xr84_u9.nr1[nsmm_w]
print @n.xbgr.xr84_u9.nr1[nsmm_l]
print @n.xbgr.xr84_u10.nr1[nsmm_rsh]
print @n.xbgr.xr84_u10.nr1[nsmm_w]
print @n.xbgr.xr84_u10.nr1[nsmm_l]
print @n.xbgr.xr84_u11.nr1[nsmm_rsh]
print @n.xbgr.xr84_u11.nr1[nsmm_w]
print @n.xbgr.xr84_u11.nr1[nsmm_l]
print @n.xbgr.xr84_u12.nr1[nsmm_rsh]
print @n.xbgr.xr84_u12.nr1[nsmm_w]
print @n.xbgr.xr84_u12.nr1[nsmm_l]
print @n.xbgr.xr84_u13.nr1[nsmm_rsh]
print @n.xbgr.xr84_u13.nr1[nsmm_w]
print @n.xbgr.xr84_u13.nr1[nsmm_l]
print @n.xbgr.xr84_u14.nr1[nsmm_rsh]
print @n.xbgr.xr84_u14.nr1[nsmm_w]
print @n.xbgr.xr84_u14.nr1[nsmm_l]
print @n.xbgr.xr84_u15.nr1[nsmm_rsh]
print @n.xbgr.xr84_u15.nr1[nsmm_w]
print @n.xbgr.xr84_u15.nr1[nsmm_l]
print @n.xbgr.xr84_u16.nr1[nsmm_rsh]
print @n.xbgr.xr84_u16.nr1[nsmm_w]
print @n.xbgr.xr84_u16.nr1[nsmm_l]
print @n.xbgr.xr84_u17.nr1[nsmm_rsh]
print @n.xbgr.xr84_u17.nr1[nsmm_w]
print @n.xbgr.xr84_u17.nr1[nsmm_l]
print @n.xbgr.xr84_u18.nr1[nsmm_rsh]
print @n.xbgr.xr84_u18.nr1[nsmm_w]
print @n.xbgr.xr84_u18.nr1[nsmm_l]
print @n.xbgr.xr84_u19.nr1[nsmm_rsh]
print @n.xbgr.xr84_u19.nr1[nsmm_w]
print @n.xbgr.xr84_u19.nr1[nsmm_l]
print @n.xbgr.xr84_u20.nr1[nsmm_rsh]
print @n.xbgr.xr84_u20.nr1[nsmm_w]
print @n.xbgr.xr84_u20.nr1[nsmm_l]
print @n.xbgr.xr84_u21.nr1[nsmm_rsh]
print @n.xbgr.xr84_u21.nr1[nsmm_w]
print @n.xbgr.xr84_u21.nr1[nsmm_l]
print @n.xbgr.xr84_u22.nr1[nsmm_rsh]
print @n.xbgr.xr84_u22.nr1[nsmm_w]
print @n.xbgr.xr84_u22.nr1[nsmm_l]
print @n.xbgr.xr84_u23.nr1[nsmm_rsh]
print @n.xbgr.xr84_u23.nr1[nsmm_w]
print @n.xbgr.xr84_u23.nr1[nsmm_l]
print @n.xbgr.xr84_u24.nr1[nsmm_rsh]
print @n.xbgr.xr84_u24.nr1[nsmm_w]
print @n.xbgr.xr84_u24.nr1[nsmm_l]
print @n.xbgr.xr85_u2.nr1[nsmm_rsh]
print @n.xbgr.xr85_u2.nr1[nsmm_w]
print @n.xbgr.xr85_u2.nr1[nsmm_l]
print @n.xbgr.xr85_u3.nr1[nsmm_rsh]
print @n.xbgr.xr85_u3.nr1[nsmm_w]
print @n.xbgr.xr85_u3.nr1[nsmm_l]
print @n.xbgr.xr85_u4.nr1[nsmm_rsh]
print @n.xbgr.xr85_u4.nr1[nsmm_w]
print @n.xbgr.xr85_u4.nr1[nsmm_l]
print @n.xbgr.xr85_u5.nr1[nsmm_rsh]
print @n.xbgr.xr85_u5.nr1[nsmm_w]
print @n.xbgr.xr85_u5.nr1[nsmm_l]
print @n.xbgr.xr85_u6.nr1[nsmm_rsh]
print @n.xbgr.xr85_u6.nr1[nsmm_w]
print @n.xbgr.xr85_u6.nr1[nsmm_l]
print @n.xbgr.xr85_u7.nr1[nsmm_rsh]
print @n.xbgr.xr85_u7.nr1[nsmm_w]
print @n.xbgr.xr85_u7.nr1[nsmm_l]
print @n.xbgr.xr85_u8.nr1[nsmm_rsh]
print @n.xbgr.xr85_u8.nr1[nsmm_w]
print @n.xbgr.xr85_u8.nr1[nsmm_l]
print @n.xbgr.xr85_u9.nr1[nsmm_rsh]
print @n.xbgr.xr85_u9.nr1[nsmm_w]
print @n.xbgr.xr85_u9.nr1[nsmm_l]
print @n.xbgr.xr85_u10.nr1[nsmm_rsh]
print @n.xbgr.xr85_u10.nr1[nsmm_w]
print @n.xbgr.xr85_u10.nr1[nsmm_l]
print @n.xbgr.xr85_u11.nr1[nsmm_rsh]
print @n.xbgr.xr85_u11.nr1[nsmm_w]
print @n.xbgr.xr85_u11.nr1[nsmm_l]
print @n.xbgr.xr85_u12.nr1[nsmm_rsh]
print @n.xbgr.xr85_u12.nr1[nsmm_w]
print @n.xbgr.xr85_u12.nr1[nsmm_l]
print @n.xbgr.xr85_u13.nr1[nsmm_rsh]
print @n.xbgr.xr85_u13.nr1[nsmm_w]
print @n.xbgr.xr85_u13.nr1[nsmm_l]
print @n.xbgr.xr85_u14.nr1[nsmm_rsh]
print @n.xbgr.xr85_u14.nr1[nsmm_w]
print @n.xbgr.xr85_u14.nr1[nsmm_l]
print @n.xbgr.xr85_u15.nr1[nsmm_rsh]
print @n.xbgr.xr85_u15.nr1[nsmm_w]
print @n.xbgr.xr85_u15.nr1[nsmm_l]
print @n.xbgr.xr85_u16.nr1[nsmm_rsh]
print @n.xbgr.xr85_u16.nr1[nsmm_w]
print @n.xbgr.xr85_u16.nr1[nsmm_l]
print @n.xbgr.xr85_u17.nr1[nsmm_rsh]
print @n.xbgr.xr85_u17.nr1[nsmm_w]
print @n.xbgr.xr85_u17.nr1[nsmm_l]
print @n.xbgr.xr85_u18.nr1[nsmm_rsh]
print @n.xbgr.xr85_u18.nr1[nsmm_w]
print @n.xbgr.xr85_u18.nr1[nsmm_l]
print @n.xbgr.xr85_u19.nr1[nsmm_rsh]
print @n.xbgr.xr85_u19.nr1[nsmm_w]
print @n.xbgr.xr85_u19.nr1[nsmm_l]
print @n.xbgr.xr85_u20.nr1[nsmm_rsh]
print @n.xbgr.xr85_u20.nr1[nsmm_w]
print @n.xbgr.xr85_u20.nr1[nsmm_l]
print @n.xbgr.xr85_u21.nr1[nsmm_rsh]
print @n.xbgr.xr85_u21.nr1[nsmm_w]
print @n.xbgr.xr85_u21.nr1[nsmm_l]
print @n.xbgr.xr85_u22.nr1[nsmm_rsh]
print @n.xbgr.xr85_u22.nr1[nsmm_w]
print @n.xbgr.xr85_u22.nr1[nsmm_l]
print @n.xbgr.xr85_u23.nr1[nsmm_rsh]
print @n.xbgr.xr85_u23.nr1[nsmm_w]
print @n.xbgr.xr85_u23.nr1[nsmm_l]
print @n.xbgr.xr85_u24.nr1[nsmm_rsh]
print @n.xbgr.xr85_u24.nr1[nsmm_w]
print @n.xbgr.xr85_u24.nr1[nsmm_l]
print @n.xbgr.xr86_u2.nr1[nsmm_rsh]
print @n.xbgr.xr86_u2.nr1[nsmm_w]
print @n.xbgr.xr86_u2.nr1[nsmm_l]
print @n.xbgr.xr86_u3.nr1[nsmm_rsh]
print @n.xbgr.xr86_u3.nr1[nsmm_w]
print @n.xbgr.xr86_u3.nr1[nsmm_l]
print @n.xbgr.xr86_u4.nr1[nsmm_rsh]
print @n.xbgr.xr86_u4.nr1[nsmm_w]
print @n.xbgr.xr86_u4.nr1[nsmm_l]
print @n.xbgr.xr86_u5.nr1[nsmm_rsh]
print @n.xbgr.xr86_u5.nr1[nsmm_w]
print @n.xbgr.xr86_u5.nr1[nsmm_l]
print @n.xbgr.xr86_u6.nr1[nsmm_rsh]
print @n.xbgr.xr86_u6.nr1[nsmm_w]
print @n.xbgr.xr86_u6.nr1[nsmm_l]
print @n.xbgr.xr86_u7.nr1[nsmm_rsh]
print @n.xbgr.xr86_u7.nr1[nsmm_w]
print @n.xbgr.xr86_u7.nr1[nsmm_l]
print @n.xbgr.xr86_u8.nr1[nsmm_rsh]
print @n.xbgr.xr86_u8.nr1[nsmm_w]
print @n.xbgr.xr86_u8.nr1[nsmm_l]
print @n.xbgr.xr86_u9.nr1[nsmm_rsh]
print @n.xbgr.xr86_u9.nr1[nsmm_w]
print @n.xbgr.xr86_u9.nr1[nsmm_l]
print @n.xbgr.xr86_u10.nr1[nsmm_rsh]
print @n.xbgr.xr86_u10.nr1[nsmm_w]
print @n.xbgr.xr86_u10.nr1[nsmm_l]
print @n.xbgr.xr86_u11.nr1[nsmm_rsh]
print @n.xbgr.xr86_u11.nr1[nsmm_w]
print @n.xbgr.xr86_u11.nr1[nsmm_l]
print @n.xbgr.xr86_u12.nr1[nsmm_rsh]
print @n.xbgr.xr86_u12.nr1[nsmm_w]
print @n.xbgr.xr86_u12.nr1[nsmm_l]
print @n.xbgr.xr86_u13.nr1[nsmm_rsh]
print @n.xbgr.xr86_u13.nr1[nsmm_w]
print @n.xbgr.xr86_u13.nr1[nsmm_l]
print @n.xbgr.xr86_u14.nr1[nsmm_rsh]
print @n.xbgr.xr86_u14.nr1[nsmm_w]
print @n.xbgr.xr86_u14.nr1[nsmm_l]
print @n.xbgr.xr86_u15.nr1[nsmm_rsh]
print @n.xbgr.xr86_u15.nr1[nsmm_w]
print @n.xbgr.xr86_u15.nr1[nsmm_l]
print @n.xbgr.xr86_u16.nr1[nsmm_rsh]
print @n.xbgr.xr86_u16.nr1[nsmm_w]
print @n.xbgr.xr86_u16.nr1[nsmm_l]
print @n.xbgr.xr86_u17.nr1[nsmm_rsh]
print @n.xbgr.xr86_u17.nr1[nsmm_w]
print @n.xbgr.xr86_u17.nr1[nsmm_l]
print @n.xbgr.xr86_u18.nr1[nsmm_rsh]
print @n.xbgr.xr86_u18.nr1[nsmm_w]
print @n.xbgr.xr86_u18.nr1[nsmm_l]
print @n.xbgr.xr86_u19.nr1[nsmm_rsh]
print @n.xbgr.xr86_u19.nr1[nsmm_w]
print @n.xbgr.xr86_u19.nr1[nsmm_l]
print @n.xbgr.xr86_u20.nr1[nsmm_rsh]
print @n.xbgr.xr86_u20.nr1[nsmm_w]
print @n.xbgr.xr86_u20.nr1[nsmm_l]
print @n.xbgr.xr86_u21.nr1[nsmm_rsh]
print @n.xbgr.xr86_u21.nr1[nsmm_w]
print @n.xbgr.xr86_u21.nr1[nsmm_l]
print @n.xbgr.xr86_u22.nr1[nsmm_rsh]
print @n.xbgr.xr86_u22.nr1[nsmm_w]
print @n.xbgr.xr86_u22.nr1[nsmm_l]
print @n.xbgr.xr86_u23.nr1[nsmm_rsh]
print @n.xbgr.xr86_u23.nr1[nsmm_w]
print @n.xbgr.xr86_u23.nr1[nsmm_l]
print @n.xbgr.xr86_u24.nr1[nsmm_rsh]
print @n.xbgr.xr86_u24.nr1[nsmm_w]
print @n.xbgr.xr86_u24.nr1[nsmm_l]
set numdgt=17
echo METALLIC_POINT_VOLTAGES_BEGIN
print v(xbgr.mr_n80316320)
print v(xbgr.vd2)
print v(xbgr.mr_n79534096)
print v(xbgr.c2)
print v(xbgr.mr_n80608000)
print v(xbgr.mr_n80705936)
print v(xbgr.mr_n80750496)
print v(xbgr.mr_n80883120)
print v(xbgr.mr_n80999792)
print v(xbgr.mr_n81101504)
print v(xbgr.mr_n81261200)
print v(xbgr.mr_n81494032)
print v(xbgr.mr_n81624496)
print v(xbgr.mr_n81785088)
print v(xbgr.mr_n81811024)
print v(xbgr.mr_n82038576)
print v(xbgr.mr_n82191088)
print v(xbgr.mr_n82250832)
print v(xbgr.mr_n78671424)
print v(xbgr.mr_n82850528)
print v(xbgr.mr_n83039808)
print v(xbgr.mr_n83228048)
print v(xbgr.mr_n83402320)
print v(xbgr.mr_n83588416)
print v(xbgr.mr_n83751392)
print v(xbgr.mr_n83950528)
print v(xbgr.mr_n84161632)
print v(xbgr.mr_n81207584)
print v(xbgr.mr_n84247456)
print v(xbgr.mr_n84529568)
print v(xbgr.mr_n84723184)
print v(xbgr.mr_n84939376)
print v(xbgr.mr_n85120864)
print v(xbgr.mr_n85427600)
print v(xbgr.mr_n85630768)
print v(xbgr.mr_n85865152)
print v(xbgr.mr_n86199424)
print v(xbgr.mr_n80316768)
print v(xbgr.mr_n80380976)
print v(xbgr.b1b)
print v(xbgr.mr_n80465856)
print v(xbgr.mr_n80565104)
print v(xbgr.mr_n80661200)
print v(xbgr.mr_n80774752)
print v(xbgr.mr_n80883536)
print v(xbgr.mr_n80997632)
print v(xbgr.mr_n81338848)
print v(xbgr.mr_n81456432)
print v(xbgr.mr_n81588624)
print v(xbgr.mr_n81690928)
print v(xbgr.mr_n81863520)
print v(xbgr.mr_n81976784)
print v(xbgr.mr_n82130400)
print v(xbgr.mr_n82378976)
print v(xbgr.mr_n80352352)
print v(xbgr.mr_n80413776)
print v(xbgr.mr_n79516352)
print v(xbgr.mr_n80554448)
print v(xbgr.mr_n80653744)
print v(xbgr.mr_n80769440)
print v(xbgr.mr_n80826800)
print v(xbgr.mr_n80976640)
print v(xbgr.mr_n81080048)
print v(xbgr.mr_n81197248)
print v(xbgr.mr_n81257184)
print v(xbgr.mr_n81504128)
print v(xbgr.mr_n81666832)
print v(xbgr.mr_n81785552)
print v(xbgr.mr_n81985296)
print v(xbgr.mr_n82055568)
print v(xbgr.mr_n82209152)
print v(xbgr.mr_n82381024)
print v(xbgr.mr_n79587216)
print v(xbgr.mr_n79851424)
print v(xbgr.n_13)
print v(xbgr.n_24)
print v(xbgr.mr_n79585344)
print v(xbgr.mr_n79853728)
print v(xbgr.n_14)
print v(xbgr.mr_n80196000)
print v(xbgr.mr_n80241376)
print v(xbgr.mr_n80381168)
print v(xbgr.mr_n79605424)
print v(xbgr.mr_n80555152)
print v(xbgr.mr_n80610672)
print v(xbgr.mr_n80694288)
print v(xbgr.mr_n80607328)
print v(xbgr.vd1)
print v(xbgr.mr_n81060192)
print v(xbgr.mr_n81196576)
print v(xbgr.mr_n81307280)
print v(xbgr.mr_n81433760)
print v(xbgr.mr_n81663360)
print v(xbgr.mr_n81757280)
print v(xbgr.mr_n81898256)
print v(xbgr.mr_n82099200)
print v(xbgr.mr_n82208240)
print v(xbgr.mr_n82379984)
print v(xbgr.mr_n82727760)
print v(xbgr.mr_n82867776)
print v(xbgr.mr_n83043952)
print v(xbgr.mr_n83236720)
print v(xbgr.mr_n83348288)
print v(xbgr.mr_n83586176)
print v(xbgr.mr_n83789616)
print v(xbgr.mr_n83951696)
print v(xbgr.mr_n84166080)
print v(xbgr.mr_n81208944)
print v(xbgr.mr_n84252992)
print v(xbgr.mr_n84545008)
print v(xbgr.mr_n84720608)
print v(xbgr.mr_n84940640)
print v(xbgr.mr_n85128416)
print v(xbgr.mr_n85426256)
print v(xbgr.mr_n85631760)
print v(xbgr.mr_n85864576)
print v(xbgr.mr_n86202256)
print v(xbgr.mr_n80317344)
print v(xbgr.mr_n80382112)
print v(xbgr.mr_n79630640)
print v(xbgr.mr_n80493568)
print v(xbgr.mr_n80566496)
print v(xbgr.mr_n80661472)
print v(xbgr.mr_n80767216)
print v(xbgr.mr_n80940144)
print v(xbgr.mr_n81000800)
print v(xbgr.mr_n81340240)
print v(xbgr.mr_n81457824)
print v(xbgr.mr_n81590016)
print v(xbgr.mr_n81738368)
print v(xbgr.mr_n81864976)
print v(xbgr.mr_n81807024)
print v(xbgr.mr_n82128480)
print v(xbgr.mr_n82379648)
print v(xbgr.mr_n79588144)
print v(xbgr.mr_n79854320)
print v(xbgr.mr_n80081120)
print v(xbgr.n_26)
print v(xbgr.mr_n79497136)
print v(xbgr.mr_n79854912)
print v(xbgr.n_15)
print v(xbgr.mr_n80197440)
print v(xbgr.mr_n80347888)
print v(xbgr.mr_n80412528)
print v(xbgr.mr_n79715472)
print v(xbgr.mr_n80555888)
print v(xbgr.mr_n80654544)
print v(xbgr.mr_n80770352)
print v(xbgr.mr_n80824544)
print v(xbgr.mr_n80977824)
print v(xbgr.mr_n81081632)
print v(xbgr.mr_n81100800)
print v(xbgr.mr_n81386224)
print v(xbgr.mr_n81506064)
print v(xbgr.mr_n81682128)
print v(xbgr.mr_n81802400)
print v(xbgr.mr_n81986368)
print v(xbgr.mr_n82099872)
print v(xbgr.mr_n82188720)
print v(xbgr.mr_n82255184)
print v(xbgr.mr_n79589072)
print v(xbgr.mr_n79798304)
print v(xbgr.mr_n80082048)
print v(xbgr.n_27)
print v(xbgr.mr_n79498048)
print v(xbgr.mr_n79850992)
print v(xbgr.n_16)
print v(xbgr.mr_n80198880)
print v(xbgr.mr_n79590000)
print v(xbgr.mr_n79856752)
print v(xbgr.mr_n80082512)
print v(xbgr.n_21)
print v(xbgr.mr_n80316960)
print v(xbgr.mr_n80380784)
print v(xbgr.mr_n80169504)
print v(xbgr.mr_n80531152)
print v(xbgr.mr_n80476800)
print v(xbgr.mr_n80706640)
print v(xbgr.mr_n80811776)
print v(xbgr.mr_n80884688)
print v(xbgr.mr_n81059888)
print v(xbgr.mr_n81371952)
print v(xbgr.mr_n81504768)
print v(xbgr.mr_n81663888)
print v(xbgr.mr_n81780688)
print v(xbgr.mr_n81895840)
print v(xbgr.mr_n82033728)
print v(xbgr.mr_n82190496)
print v(xbgr.mr_n82381536)
print v(xbgr.mr_n79589536)
print v(xbgr.mr_n79851168)
print v(xbgr.mr_n82735680)
print v(xbgr.mr_n82869040)
print v(xbgr.mr_n83116800)
print v(xbgr.mr_n83237920)
print v(xbgr.mr_n83403568)
print v(xbgr.mr_n83599616)
print v(xbgr.mr_n83747616)
print v(xbgr.mr_n83936736)
print v(xbgr.mr_n84178608)
print v(xbgr.mr_n84529376)
print v(xbgr.mr_n84738464)
print v(xbgr.mr_n84965840)
print v(xbgr.mr_n85133392)
print v(xbgr.mr_n85440880)
print v(xbgr.mr_n85631872)
print v(xbgr.mr_n85844592)
print v(xbgr.mr_n86213472)
print v(xbgr.mr_n80323872)
print v(xbgr.mr_n80400432)
print v(xbgr.mr_n79596912)
print v(xbgr.mr_n80494960)
print v(xbgr.mr_n80567888)
print v(xbgr.mr_n80662896)
print v(xbgr.mr_n80807376)
print v(xbgr.mr_n80938176)
print v(xbgr.mr_n81014592)
print v(xbgr.mr_n81339776)
print v(xbgr.mr_n81459216)
print v(xbgr.mr_n81591408)
print v(xbgr.mr_n81740144)
print v(xbgr.mr_n81866752)
print v(xbgr.mr_n81987376)
print v(xbgr.mr_n82158784)
print v(xbgr.mr_n82379312)
print v(xbgr.mr_n79590928)
print v(xbgr.mr_n79857792)
print v(xbgr.n_8)
print v(xbgr.vbe3)
print v(xbgr.mr_n80355264)
print v(xbgr.mr_n80414896)
print v(xbgr.mr_n80240960)
print v(xbgr.mr_n80556848)
print v(xbgr.mr_n80655344)
print v(xbgr.mr_n80770752)
print v(xbgr.mr_n80816112)
print v(xbgr.mr_n80978704)
print v(xbgr.mr_n81082512)
print v(xbgr.mr_n81388032)
print v(xbgr.mr_n81494480)
print v(xbgr.mr_n81682928)
print v(xbgr.mr_n81803200)
print v(xbgr.mr_n81987888)
print v(xbgr.mr_n82099536)
print v(xbgr.mr_n82189312)
print v(xbgr.mr_n82254640)
print v(xbgr.mr_n79501824)
print v(xbgr.mr_n79859056)
print v(xbgr.mr_n79931264)
print v(xbgr.mr_n80133392)
print v(xbgr.mr_n79591856)
print v(xbgr.mr_n79860832)
print v(xbgr.mr_n79931664)
print v(xbgr.n_37)
print v(xbgr.mr_n79497248)
print v(xbgr.mr_n79862528)
print v(xbgr.mr_n79697104)
print v(xbgr.mr_n80138128)
print v(xbgr.n_6)
print v(xbgr.vb2)
print v(xbgr.n_2)
print v(xbgr.mr_n80245552)
print v(xbgr.mr_n80317152)
print v(xbgr.mr_n80401136)
print v(xbgr.mr_n80168896)
print v(xbgr.mr_n80557552)
print v(xbgr.mr_n80614384)
print v(xbgr.mr_n80733200)
print v(xbgr.mr_n80816448)
print v(xbgr.mr_n80821584)
print v(xbgr.mr_n81064320)
print v(xbgr.mr_n81383664)
print v(xbgr.mr_n81375968)
print v(xbgr.mr_n81660480)
print v(xbgr.mr_n81788848)
print v(xbgr.mr_n81964144)
print v(xbgr.mr_n82104976)
print v(xbgr.mr_n82211552)
print v(xbgr.mr_n82254096)
print v(xbgr.mr_n82718784)
print v(xbgr.mr_n82888704)
print v(xbgr.mr_n83119248)
print v(xbgr.mr_n83240000)
print v(xbgr.mr_n83345760)
print v(xbgr.mr_n83597392)
print v(xbgr.mr_n83748560)
print v(xbgr.mr_n83950640)
print v(xbgr.mr_n84175712)
print v(xbgr.mr_n84526208)
print v(xbgr.mr_n84733488)
print v(xbgr.mr_n84950960)
print v(xbgr.mr_n85138368)
print v(xbgr.mr_n85436768)
print v(xbgr.mr_n85648848)
print v(xbgr.mr_n85864960)
print v(xbgr.mr_n86201312)
print v(xbgr.mr_n79694272)
print v(xbgr.mr_n79729296)
print v(xbgr.mr_n79922080)
print v(xbgr.mr_n80198768)
print v(xbgr.mr_n80296656)
print v(xbgr.mr_n80401488)
print v(xbgr.mr_n79595088)
print v(xbgr.mr_n80496352)
print v(xbgr.mr_n80569280)
print v(xbgr.mr_n80684656)
print v(xbgr.mr_n80808528)
print v(xbgr.mr_n80819328)
print v(xbgr.mr_n81015984)
print v(xbgr.mr_n81339312)
print v(xbgr.mr_n81460928)
print v(xbgr.mr_n81593120)
print v(xbgr.mr_n81741920)
print v(xbgr.mr_n81868528)
print v(xbgr.mr_n81983712)
print v(xbgr.mr_n82160176)
print v(xbgr.mr_n82383600)
print v(xbgr.mr_n79695008)
print v(xbgr.mr_n79729856)
print v(xbgr.n_7)
print v(xbgr.n_36)
print v(xbgr.mr_n80356320)
print v(xbgr.mr_n80415296)
print v(xbgr.mr_n79782816)
print v(xbgr.mr_n80557728)
print v(xbgr.mr_n80656144)
print v(xbgr.mr_n80611680)
print v(xbgr.mr_n80832160)
print v(xbgr.mr_n80972096)
print v(xbgr.mr_n81083312)
print v(xbgr.mr_n81389840)
print v(xbgr.mr_n81507312)
print v(xbgr.mr_n81683728)
print v(xbgr.mr_n81804000)
print v(xbgr.mr_n81989312)
print v(xbgr.mr_n82037760)
print v(xbgr.mr_n82211664)
print v(xbgr.mr_n82381760)
print v(xbgr.mr_n79500896)
print v(xbgr.mr_n79730448)
print v(xbgr.mr_n79929776)
print v(xbgr.mr_n80247328)
print v(xbgr.mr_n79696480)
print v(xbgr.mr_n79731040)
print v(xbgr.mr_n79934064)
print v(xbgr.mr_n80247920)
print v(xbgr.mr_n79697216)
print v(xbgr.mr_n79731632)
print v(xbgr.mr_n79930432)
print v(xbgr.mr_n80248512)
print v(xbgr.mr_n79697952)
print v(xbgr.mr_n79732224)
print v(xbgr.mr_n79934864)
print v(xbgr.mr_n80249104)
print v(xbgr.mr_n80325536)
print v(xbgr.mr_n80402192)
print v(xbgr.mr_n79525472)
print v(xbgr.mr_n80508256)
print v(xbgr.mr_n80615712)
print v(xbgr.mr_n80734000)
print v(xbgr.mr_n80822256)
print v(xbgr.mr_n80818128)
print v(xbgr.mr_n81083136)
print v(xbgr.mr_n81310240)
print v(xbgr.mr_n81496896)
print v(xbgr.mr_n81681952)
print v(xbgr.mr_n81803824)
print v(xbgr.mr_n81965328)
print v(xbgr.mr_n82101552)
print v(xbgr.mr_n82208576)
print v(xbgr.mr_n82381648)
print v(xbgr.mr_n82735488)
print v(xbgr.mr_n82905728)
print v(xbgr.mr_n83121328)
print v(xbgr.mr_n83255472)
print v(xbgr.mr_n83395872)
print v(xbgr.mr_n83610496)
print v(xbgr.mr_n83800560)
print v(xbgr.mr_n83957504)
print v(xbgr.mr_n84180688)
print v(xbgr.mr_n84546176)
print v(xbgr.mr_n84738000)
print v(xbgr.mr_n84955472)
print v(xbgr.mr_n85143344)
print v(xbgr.mr_n85448416)
print v(xbgr.mr_n85633840)
print v(xbgr.mr_n85699952)
print v(xbgr.mr_n86214240)
print v(xbgr.mr_n80328864)
print v(xbgr.mr_n80402544)
print v(xbgr.mr_n79604816)
print v(xbgr.mr_n80497744)
print v(xbgr.mr_n80570672)
print v(xbgr.mr_n80678064)
print v(xbgr.mr_n80809920)
print v(xbgr.mr_n80965712)
print v(xbgr.mr_n81017376)
print v(xbgr.mr_n81309360)
print v(xbgr.mr_n81462704)
print v(xbgr.mr_n81594896)
print v(xbgr.mr_n81743696)
print v(xbgr.mr_n81870304)
print v(xbgr.mr_n81970064)
print v(xbgr.mr_n82161696)
print v(xbgr.mr_n82385664)
print v(xbgr.mr_n79698464)
print v(xbgr.mr_n79732816)
print v(xbgr.mr_n79935264)
print v(xbgr.mr_n80250288)
print v(xbgr.mr_n79699008)
print v(xbgr.mr_n79733408)
print v(xbgr.n_11)
print v(xbgr.mr_n80241776)
print v(xbgr.mr_n80358176)
print v(xbgr.mr_n80415696)
print v(xbgr.mr_n80106864)
print v(xbgr.mr_n80558928)
print v(xbgr.mr_n80656944)
print v(xbgr.mr_n80771552)
print v(xbgr.mr_n80823872)
print v(xbgr.mr_n80980080)
print v(xbgr.mr_n81084112)
print v(xbgr.mr_n81391824)
print v(xbgr.mr_n81511488)
print v(xbgr.mr_n81684528)
print v(xbgr.mr_n81804800)
print v(xbgr.mr_n81991456)
print v(xbgr.mr_n82105088)
print v(xbgr.mr_n82209744)
print v(xbgr.mr_n82383824)
print v(xbgr.mr_n79699504)
print v(xbgr.mr_n79734000)
print v(xbgr.mr_n80015248)
print v(xbgr.mr_n80250880)
print v(xbgr.mr_n79700560)
print v(xbgr.mr_n79734592)
print v(xbgr.mr_n79968096)
print v(xbgr.mr_n80199488)
print v(xbgr.mr_n79700832)
print v(xbgr.mr_n79735184)
print v(xbgr.mr_n80009200)
print v(xbgr.mr_n80251984)
print v(xbgr.mr_n80323120)
print v(xbgr.mr_n80403248)
print v(xbgr.mr_n79607248)
print v(xbgr.mr_n80556592)
print v(xbgr.mr_n80620528)
print v(xbgr.mr_n80734800)
print v(xbgr.mr_n80833184)
print v(xbgr.mr_n80762736)
print v(xbgr.mr_n81083936)
print v(xbgr.mr_n81390352)
print v(xbgr.mr_n81506768)
print v(xbgr.mr_n81684352)
print v(xbgr.mr_n81802224)
print v(xbgr.mr_n81966512)
print v(xbgr.mr_n82108592)
print v(xbgr.mr_n82189904)
print v(xbgr.mr_n82385776)
print v(xbgr.n_9)
print v(xbgr.mr_n79735776)
print v(xbgr.mr_n79972176)
print v(xbgr.mr_n80252656)
print v(xbgr.mr_n82739840)
print v(xbgr.mr_n82848640)
print v(xbgr.mr_n83138352)
print v(xbgr.mr_n83255936)
print v(xbgr.mr_n83402512)
print v(xbgr.mr_n83609984)
print v(xbgr.mr_n83808304)
print v(xbgr.mr_n83951808)
print v(xbgr.mr_n84193536)
print v(xbgr.mr_n84556816)
print v(xbgr.mr_n84738272)
print v(xbgr.mr_n84960368)
print v(xbgr.mr_n85148320)
print v(xbgr.mr_n85460784)
print v(xbgr.mr_n85648336)
print v(xbgr.mr_n85892480)
print v(xbgr.mr_n86107360)
print v(xbgr.mr_n80329776)
print v(xbgr.mr_n80403600)
print v(xbgr.mr_n79602384)
print v(xbgr.mr_n80499136)
print v(xbgr.mr_n80572064)
print v(xbgr.mr_n80689744)
print v(xbgr.mr_n80811312)
print v(xbgr.mr_n80967184)
print v(xbgr.mr_n81018768)
print v(xbgr.mr_n81391248)
print v(xbgr.mr_n81464480)
print v(xbgr.mr_n81596672)
print v(xbgr.mr_n81745472)
print v(xbgr.mr_n81872080)
print v(xbgr.mr_n81992464)
print v(xbgr.mr_n82163472)
print v(xbgr.mr_n82387728)
print v(xbgr.mr_n79701920)
print v(xbgr.mr_n79736368)
print v(xbgr.mr_n80017552)
print v(xbgr.mr_n80253248)
print v(xbgr.mr_n80359232)
print v(xbgr.mr_n80416096)
print v(xbgr.mr_n80425712)
print v(xbgr.mr_n79486832)
print v(xbgr.mr_n80657744)
print v(xbgr.mr_n80771952)
print v(xbgr.mr_n80829840)
print v(xbgr.mr_n80980960)
print v(xbgr.mr_n81080688)
print v(xbgr.mr_n81384928)
print v(xbgr.mr_n81513296)
print v(xbgr.mr_n81685328)
print v(xbgr.mr_n81805600)
print v(xbgr.mr_n81993056)
print v(xbgr.mr_n82100208)
print v(xbgr.mr_n82213472)
print v(xbgr.mr_n82385888)
print v(xbgr.mr_n79702464)
print v(xbgr.mr_n79736960)
print v(xbgr.mr_n79972768)
print v(xbgr.mr_n80253840)
print v(xbgr.mr_n79703008)
print v(xbgr.mr_n79737552)
print v(xbgr.mr_n80015840)
print v(xbgr.mr_n80254432)
print v(xbgr.mr_n79703552)
print v(xbgr.mr_n79738144)
print v(xbgr.mr_n80013472)
print v(xbgr.mr_n80255024)
print v(xbgr.mr_n79704096)
print v(xbgr.mr_n79738736)
print v(xbgr.mr_n80010080)
print v(xbgr.mr_n80255616)
print v(xbgr.mr_n80324784)
print v(xbgr.mr_n80404656)
print v(xbgr.mr_n79601776)
print v(xbgr.mr_n80558752)
print v(xbgr.mr_n80621856)
print v(xbgr.mr_n80735664)
print v(xbgr.mr_n80765344)
print v(xbgr.mr_n80966064)
print v(xbgr.mr_n81060000)
print v(xbgr.mr_n81258672)
print v(xbgr.mr_n81429120)
print v(xbgr.mr_n81654368)
print v(xbgr.mr_n81781216)
print v(xbgr.mr_n81967696)
print v(xbgr.mr_n82106784)
print v(xbgr.mr_n82191680)
print v(xbgr.mr_n82387952)
print v(xbgr.mr_n82743776)
print v(xbgr.mr_n82905264)
print v(xbgr.mr_n83124432)
print v(xbgr.mr_n83271472)
print v(xbgr.mr_n83415040)
print v(xbgr.mr_n83621632)
print v(xbgr.mr_n83801568)
print v(xbgr.mr_n83966752)
print v(xbgr.mr_n84198768)
print v(xbgr.mr_n84561648)
print v(xbgr.mr_n84759744)
print v(xbgr.mr_n84965328)
print v(xbgr.mr_n85153408)
print v(xbgr.mr_n85460896)
print v(xbgr.mr_n85643152)
print v(xbgr.mr_n85869168)
print v(xbgr.mr_n86112000)
print v(xbgr.mr_n79704640)
print v(xbgr.mr_n79739328)
print v(xbgr.mr_n79958224)
print v(xbgr.mr_n80241664)
print v(xbgr.mr_n80333856)
print v(xbgr.mr_n80404304)
print v(xbgr.mr_n79557328)
print v(xbgr.mr_n80500528)
print v(xbgr.mr_n80571600)
print v(xbgr.mr_n80692288)
print v(xbgr.mr_n80810848)
print v(xbgr.mr_n80968816)
print v(xbgr.mr_n81020160)
print v(xbgr.mr_n81386736)
print v(xbgr.mr_n81463888)
print v(xbgr.mr_n81596080)
print v(xbgr.mr_n81747248)
print v(xbgr.mr_n81871488)
print v(xbgr.mr_n81994128)
print v(xbgr.mr_n82165248)
print v(xbgr.mr_n82389792)
print v(xbgr.mr_n79704368)
print v(xbgr.mr_n79739920)
print v(xbgr.mr_n80019632)
print v(xbgr.mr_n80256720)
print v(xbgr.mr_n80361008)
print v(xbgr.mr_n80416496)
print v(xbgr.mr_n80429184)
print v(xbgr.mr_n80501456)
print v(xbgr.mr_n80658544)
print v(xbgr.mr_n80772352)
print v(xbgr.mr_n80841088)
print v(xbgr.mr_n80975456)
print v(xbgr.mr_n81085712)
print v(xbgr.mr_n81396032)
print v(xbgr.mr_n81430032)
print v(xbgr.mr_n81686128)
print v(xbgr.mr_n81806400)
print v(xbgr.mr_n81994800)
print v(xbgr.mr_n82110400)
print v(xbgr.mr_n82216976)
print v(xbgr.mr_n82383712)
print v(xbgr.mr_n79705728)
print v(xbgr.mr_n79740512)
print v(xbgr.n_3)
print v(xbgr.n_33)
print v(xbgr.mr_n79706272)
print v(xbgr.mr_n79741104)
print v(xbgr.mr_n80018736)
print v(xbgr.mr_n80243904)
print v(xbgr.mr_n79707008)
print v(xbgr.mr_n79741696)
print v(xbgr.mr_n80006800)
print v(xbgr.mr_n80244960)
print v(xbgr.mr_n79708400)
print v(xbgr.mr_n79742288)
print v(xbgr.mr_n80022304)
print v(xbgr.mr_n80256208)
print v(xbgr.mr_n80328112)
print v(xbgr.mr_n80412192)
print v(xbgr.mr_n79511488)
print v(xbgr.mr_n80506112)
print v(xbgr.mr_n80626672)
print v(xbgr.mr_n80736848)
print v(xbgr.mr_n80841840)
print v(xbgr.mr_n80967984)
print v(xbgr.mr_n81085536)
print v(xbgr.mr_n81253936)
print v(xbgr.mr_n81393728)
print v(xbgr.mr_n81506880)
print v(xbgr.mr_n81667184)
print v(xbgr.mr_n81806224)
print v(xbgr.mr_n81968880)
print v(xbgr.mr_n82112208)
print v(xbgr.mr_n82215280)
print v(xbgr.mr_n82391968)
print v(xbgr.mr_n82741520)
print v(xbgr.mr_n82934800)
print v(xbgr.mr_n83137648)
print v(xbgr.mr_n83277408)
print v(xbgr.mr_n83419696)
print v(xbgr.mr_n83621120)
print v(xbgr.mr_n83821584)
print v(xbgr.mr_n83986016)
print v(xbgr.mr_n84195776)
print v(xbgr.mr_n84366368)
print v(xbgr.mr_n84559008)
print v(xbgr.mr_n84756256)
print v(xbgr.mr_n84987872)
print v(xbgr.mr_n85042608)
print v(xbgr.mr_n85468320)
print v(xbgr.mr_n85638496)
print v(xbgr.mr_n85867936)
print v(xbgr.mr_n86110752)
print v(xbgr.mr_n80334768)
print v(xbgr.mr_n80380160)
print v(xbgr.mr_n79602992)
print v(xbgr.mr_n80500992)
print v(xbgr.mr_n80571136)
print v(xbgr.mr_n80691808)
print v(xbgr.mr_n80810384)
print v(xbgr.mr_n80970128)
print v(xbgr.mr_n81021552)
print v(xbgr.mr_n81254128)
print v(xbgr.mr_n81395376)
print v(xbgr.mr_n81463296)
print v(xbgr.mr_n81595488)
print v(xbgr.mr_n81749024)
print v(xbgr.mr_n81870896)
print v(xbgr.mr_n81993568)
print v(xbgr.mr_n82167024)
print v(xbgr.mr_n82390016)
print v(xbgr.mr_n79708864)
print v(xbgr.n_19)
print v(xbgr.mr_n80022896)
print v(xbgr.mr_n80259680)
print v(xbgr.mr_n80362544)
print v(xbgr.mr_n80412864)
print v(xbgr.mr_n80431664)
print v(xbgr.mr_n80486208)
print v(xbgr.mr_n80659344)
print v(xbgr.mr_n80772752)
print v(xbgr.mr_n80843744)
print v(xbgr.mr_n80983312)
print v(xbgr.mr_n81086512)
print v(xbgr.mr_n81265232)
print v(xbgr.mr_n81397936)
print v(xbgr.mr_n81516912)
print v(xbgr.mr_n81686928)
print v(xbgr.mr_n81807200)
print v(xbgr.mr_n81996000)
print v(xbgr.mr_n82112320)
print v(xbgr.mr_n82218784)
print v(xbgr.mr_n82387840)
print v(xbgr.mr_n79709792)
print v(xbgr.mr_n79706000)
print v(xbgr.mr_n80023488)
print v(xbgr.mr_n80260352)
print v(xbgr.mr_n79710720)
print v(xbgr.mr_n79743984)
print v(xbgr.mr_n80012288)
print v(xbgr.mr_n80260944)
print v(xbgr.mr_n79692624)
print v(xbgr.mr_n79744656)
print v(xbgr.mr_n80024608)
print v(xbgr.mr_n80246144)
print v(xbgr.mr_n79711648)
print v(xbgr.mr_n79745248)
print v(xbgr.mr_n80025264)
print v(xbgr.mr_n80262128)
print v(xbgr.mr_n80330528)
print v(xbgr.mr_n80408656)
print v(xbgr.mr_n80293120)
print v(xbgr.mr_n80559792)
print v(xbgr.mr_n80628000)
print v(xbgr.mr_n80738032)
print v(xbgr.mr_n80838592)
print v(xbgr.mr_n80968640)
print v(xbgr.mr_n81025456)
print v(xbgr.mr_n81254832)
print v(xbgr.mr_n81396544)
print v(xbgr.mr_n81513808)
print v(xbgr.mr_n81685152)
print v(xbgr.mr_n81788496)
print v(xbgr.mr_n81969472)
print v(xbgr.mr_n82114016)
print v(xbgr.mr_n82218896)
print v(xbgr.mr_n82396208)
print v(xbgr.mr_n79711184)
print v(xbgr.mr_n79707472)
print v(xbgr.mr_n80025856)
print v(xbgr.mr_n80258576)
print v(xbgr.mr_n82738224)
print v(xbgr.mr_n82939584)
print v(xbgr.mr_n83132784)
print v(xbgr.mr_n83282384)
print v(xbgr.mr_n83434128)
print v(xbgr.mr_n83575552)
print v(xbgr.mr_n83807840)
print v(xbgr.mr_n83976000)
print v(xbgr.mr_n84100592)
print v(xbgr.mr_n84369568)
print v(xbgr.mr_n84575040)
print v(xbgr.mr_n84770880)
print v(xbgr.mr_n84962816)
print v(xbgr.mr_n85159808)
print v(xbgr.mr_n85480800)
print v(xbgr.mr_n85615536)
print v(xbgr.mr_n85845856)
print v(xbgr.mr_n86068560)
print v(xbgr.mr_n80338848)
print v(xbgr.mr_n80379888)
print v(xbgr.mr_n79825600)
print v(xbgr.mr_n80500064)
print v(xbgr.mr_n80570208)
print v(xbgr.mr_n80611568)
print v(xbgr.mr_n80809456)
print v(xbgr.mr_n80970784)
print v(xbgr.mr_n81058016)
print v(xbgr.mr_n81226640)
print v(xbgr.mr_n81393312)
print v(xbgr.mr_n81462112)
print v(xbgr.mr_n81594304)
print v(xbgr.mr_n81750800)
print v(xbgr.mr_n81869712)
print v(xbgr.mr_n81996624)
print v(xbgr.mr_n82168800)
print v(xbgr.mr_n82393920)
print v(xbgr.mr_n79710256)
print v(xbgr.mr_n79746368)
print v(xbgr.mr_n80018208)
print v(xbgr.mr_n80263312)
print v(xbgr.mr_n80363600)
print v(xbgr.mr_n80417536)
print v(xbgr.mr_n80433472)
print v(xbgr.mr_n80556416)
print v(xbgr.mr_n80659744)
print v(xbgr.mr_n80773152)
print v(xbgr.mr_n80846144)
print v(xbgr.mr_n80984272)
print v(xbgr.mr_n81087312)
print v(xbgr.mr_n81268944)
print v(xbgr.mr_n81400160)
print v(xbgr.mr_n81518640)
print v(xbgr.mr_n81687728)
print v(xbgr.mr_n81808000)
print v(xbgr.mr_n81999088)
print v(xbgr.mr_n82110512)
print v(xbgr.mr_n82209856)
print v(xbgr.mr_n82391856)
print v(xbgr.mr_n79709328)
print v(xbgr.mr_n79747024)
print v(xbgr.mr_n80026976)
print v(xbgr.mr_n80263904)
print v(xbgr.mr_n79707872)
print v(xbgr.mr_n79747616)
print v(xbgr.n_4)
print v(xbgr.n_30)
print v(xbgr.mr_n79701648)
print v(xbgr.mr_n79748208)
print v(xbgr.mr_n80020160)
print v(xbgr.mr_n80265152)
print v(xbgr.mr_n79706544)
print v(xbgr.mr_n79748800)
print v(xbgr.mr_n80028816)
print v(xbgr.mr_n80265680)
print v(xbgr.mr_n80333104)
print v(xbgr.mr_n80417360)
print v(xbgr.mr_n80170208)
print v(xbgr.mr_n79511728)
print v(xbgr.mr_n80632816)
print v(xbgr.mr_n80739216)
print v(xbgr.mr_n80841728)
print v(xbgr.mr_n80967008)
print v(xbgr.mr_n81001168)
print v(xbgr.mr_n81268288)
print v(xbgr.mr_n81258128)
print v(xbgr.mr_n81508128)
print v(xbgr.mr_n81668000)
print v(xbgr.mr_n81804624)
print v(xbgr.mr_n81968288)
print v(xbgr.mr_n82102880)
print v(xbgr.mr_n82215168)
print v(xbgr.mr_n82394144)
print v(xbgr.mr_n82488928)
print v(xbgr.mr_n82945360)
print v(xbgr.mr_n83148720)
print v(xbgr.mr_n83276896)
print v(xbgr.mr_n83429008)
print v(xbgr.mr_n83638928)
print v(xbgr.mr_n83832720)
print v(xbgr.mr_n83941680)
print v(xbgr.mr_n84104016)
print v(xbgr.mr_n84388160)
print v(xbgr.mr_n84569888)
print v(xbgr.mr_n84757200)
print v(xbgr.mr_n84957920)
print v(xbgr.mr_n85166336)
print v(xbgr.mr_n85482544)
print v(xbgr.mr_n85616480)
print v(xbgr.mr_n85843328)
print v(xbgr.mr_n86034512)
print v(xbgr.mr_n79703280)
print v(xbgr.mr_n79625328)
print v(xbgr.mr_n80028224)
print v(xbgr.mr_n80266272)
print v(xbgr.mr_n80339760)
print v(xbgr.mr_n80379616)
print v(xbgr.mr_n80422960)
print v(xbgr.mr_n80499600)
print v(xbgr.mr_n80569744)
print v(xbgr.mr_n80647280)
print v(xbgr.mr_n80808992)
print v(xbgr.mr_n80969472)
print v(xbgr.mr_n81001856)
print v(xbgr.mr_n80973312)
print v(xbgr.mr_n81388544)
print v(xbgr.mr_n81461520)
print v(xbgr.mr_n81593712)
print v(xbgr.mr_n81752576)
print v(xbgr.mr_n81869120)
print v(xbgr.mr_n81998512)
print v(xbgr.mr_n82170576)
print v(xbgr.mr_n82389904)
print v(xbgr.mr_n79705184)
print v(xbgr.mr_n79529664)
print v(xbgr.mr_n80026448)
print v(xbgr.mr_n80266864)
print v(xbgr.mr_n80365376)
print v(xbgr.mr_n80418336)
print v(xbgr.mr_n80435200)
print v(xbgr.mr_n80519984)
print v(xbgr.mr_n80630048)
print v(xbgr.mr_n80773552)
print v(xbgr.mr_n80838976)
print v(xbgr.mr_n80985248)
print v(xbgr.mr_n81087872)
print v(xbgr.mr_n81270672)
print v(xbgr.mr_n81402144)
print v(xbgr.mr_n81520528)
print v(xbgr.mr_n81688528)
print v(xbgr.mr_n81808800)
print v(xbgr.mr_n81999968)
print v(xbgr.mr_n82102992)
print v(xbgr.mr_n82222400)
print v(xbgr.mr_n82395984)
print v(xbgr.mr_n79704912)
print v(xbgr.mr_n79699392)
print v(xbgr.mr_n80027632)
print v(xbgr.mr_n80267456)
print v(xbgr.mr_n79699280)
print v(xbgr.mr_n79555008)
print v(xbgr.mr_n80006032)
print v(xbgr.mr_n80268048)
print v(xbgr.mr_n79703824)
print v(xbgr.mr_n79568384)
print v(xbgr.mr_n80031776)
print v(xbgr.mr_n80268640)
print v(xbgr.mr_n80343840)
print v(xbgr.mr_n80413200)
print v(xbgr.mr_n79843792)
print v(xbgr.mr_n80488832)
print v(xbgr.mr_n80634144)
print v(xbgr.mr_n80740400)
print v(xbgr.mr_n80848816)
print v(xbgr.mr_n80965600)
print v(xbgr.mr_n81081120)
print v(xbgr.mr_n81254320)
print v(xbgr.mr_n81400672)
print v(xbgr.mr_n81494736)
print v(xbgr.mr_n81683552)
print v(xbgr.mr_n81808624)
print v(xbgr.mr_n81967104)
print v(xbgr.mr_n82106896)
print v(xbgr.mr_n82220704)
print v(xbgr.mr_n82394032)
print v(xbgr.mr_n79504608)
print v(xbgr.mr_n79743472)
print v(xbgr.mr_n80032368)
print v(xbgr.mr_n80269232)
print v(xbgr.mr_n82731168)
print v(xbgr.mr_n82938144)
print v(xbgr.mr_n83145200)
print v(xbgr.mr_n83293520)
print v(xbgr.mr_n83433664)
print v(xbgr.mr_n83626752)
print v(xbgr.mr_n83805520)
print v(xbgr.mr_n83985312)
print v(xbgr.mr_n81087136)
print v(xbgr.mr_n84104128)
print v(xbgr.mr_n84397984)
print v(xbgr.mr_n84542496)
print v(xbgr.mr_n84776576)
print v(xbgr.mr_n84953024)
print v(xbgr.mr_n85171312)
print v(xbgr.mr_n85488224)
print v(xbgr.mr_n85646336)
print v(xbgr.mr_n85867744)
print v(xbgr.mr_n85969488)
print v(xbgr.mr_n80335520)
print v(xbgr.mr_n80379344)
print v(xbgr.mr_n80424480)
print v(xbgr.mr_n80498672)
print v(xbgr.mr_n80568816)
print v(xbgr.mr_n80600576)
print v(xbgr.mr_n80808064)
print v(xbgr.mr_n80968160)
print v(xbgr.mr_n81095376)
print v(xbgr.mr_n81401568)
print v(xbgr.mr_n81460336)
print v(xbgr.mr_n81592528)
print v(xbgr.mr_n81748192)
print v(xbgr.mr_n81867936)
print v(xbgr.mr_n81996736)
print v(xbgr.mr_n82217088)
print v(xbgr.mr_n82400112)
print v(xbgr.mr_n79702736)
print v(xbgr.mr_n79537408)
print v(xbgr.mr_n80020832)
print v(xbgr.mr_n80269824)
print v(xbgr.mr_n80366832)
print v(xbgr.mr_n80419136)
print v(xbgr.mr_n80437008)
print v(xbgr.mr_n80559360)
print v(xbgr.mr_n80658144)
print v(xbgr.mr_n80773952)
print v(xbgr.mr_n80848592)
print v(xbgr.mr_n80986128)
print v(xbgr.mr_n81082336)
print v(xbgr.mr_n81272480)
print v(xbgr.mr_n81404208)
print v(xbgr.mr_n81522336)
print v(xbgr.mr_n81667296)
print v(xbgr.mr_n81809600)
print v(xbgr.mr_n82002432)
print v(xbgr.mr_n82114128)
print v(xbgr.mr_n82213360)
print v(xbgr.mr_n82398048)
print v(xbgr.mr_n79680560)
print v(xbgr.mr_n79084912)
print v(xbgr.mr_n80033552)
print v(xbgr.mr_n80270416)
print v(xbgr.mr_n79697728)
print v(xbgr.mr_n79552896)
print v(xbgr.mr_n80034144)
print v(xbgr.mr_n80271008)
print v(xbgr.mr_n79701104)
print v(xbgr.mr_n79572608)
print v(xbgr.n_5)
print v(xbgr.mr_n80271600)
print v(xbgr.mr_n79700288)
print v(xbgr.mr_n66362768)
print v(xbgr.mr_n80024080)
print v(xbgr.mr_n80272192)
print v(xbgr.mr_n80342896)
print v(xbgr.mr_n80416896)
print v(xbgr.mr_n80425520)
print v(xbgr.mr_n79537616)
print v(xbgr.mr_n80608448)
print v(xbgr.mr_n80741584)
print v(xbgr.mr_n80849088)
print v(xbgr.mr_n80818624)
print v(xbgr.mr_n81109536)
print v(xbgr.mr_n81269456)
print v(xbgr.mr_n81340704)
print v(xbgr.mr_n81517424)
print v(xbgr.mr_n81685952)
print v(xbgr.mr_n81788960)
print v(xbgr.mr_n81965920)
print v(xbgr.mr_n82115936)
print v(xbgr.mr_n82224320)
print v(xbgr.mr_n82398160)
print v(xbgr.mr_n82721232)
print v(xbgr.mr_n82891920)
print v(xbgr.mr_n83159856)
print v(xbgr.mr_n83287968)
print v(xbgr.mr_n83438320)
print v(xbgr.mr_n83615616)
print v(xbgr.mr_n83804640)
print v(xbgr.mr_n83994224)
print v(xbgr.mr_n81110544)
print v(xbgr.mr_n84092768)
print v(xbgr.mr_n84402960)
print v(xbgr.mr_n84510272)
print v(xbgr.mr_n84765440)
print v(xbgr.mr_n84949216)
print v(xbgr.mr_n85184160)
print v(xbgr.mr_n85510912)
print v(xbgr.mr_n85652464)
print v(xbgr.mr_n85741104)
print v(xbgr.mr_n86037792)
print v(xbgr.mr_n79700016)
print v(xbgr.mr_n79550080)
print v(xbgr.mr_n80035856)
print v(xbgr.mr_n80272784)
print v(xbgr.mr_n80343088)
print v(xbgr.mr_n80379072)
print v(xbgr.mr_n79595696)
print v(xbgr.mr_n80498208)
print v(xbgr.mr_n80568352)
print v(xbgr.mr_n80589424)
print v(xbgr.mr_n80807680)
print v(xbgr.mr_n80966336)
print v(xbgr.mr_n81110352)
print v(xbgr.mr_n81398608)
print v(xbgr.mr_n81459744)
print v(xbgr.mr_n81591936)
print v(xbgr.mr_n81755664)
print v(xbgr.mr_n81867344)
print v(xbgr.mr_n82001520)
print v(xbgr.mr_n82226016)
print v(xbgr.mr_n82400336)
print v(xbgr.mr_n79698736)
print v(xbgr.mr_n79576128)
print v(xbgr.mr_n80036512)
print v(xbgr.mr_n80273376)
print v(xbgr.mr_n80368368)
print v(xbgr.mr_n80419936)
print v(xbgr.mr_n80438896)
print v(xbgr.mr_n79618560)
print v(xbgr.mr_n80657344)
print v(xbgr.mr_n80774352)
print v(xbgr.mr_n80853712)
print v(xbgr.mr_n80987104)
print v(xbgr.mr_n81081296)
print v(xbgr.mr_n81274368)
print v(xbgr.mr_n81406352)
print v(xbgr.mr_n81524064)
print v(xbgr.mr_n81690128)
print v(xbgr.mr_n81810400)
print v(xbgr.mr_n82003312)
print v(xbgr.mr_n82119440)
print v(xbgr.mr_n82222512)
print v(xbgr.mr_n82392080)
print v(xbgr.mr_n79660144)
print v(xbgr.mr_n79867344)
print v(xbgr.mr_n80029408)
print v(xbgr.mr_n80273952)
print v(xbgr.mr_n79660608)
print v(xbgr.mr_n79863200)
print v(xbgr.mr_n80037632)
print v(xbgr.mr_n80249696)
print v(xbgr.mr_n79661072)
print v(xbgr.mr_n79868592)
print v(xbgr.mr_n80030000)
print v(xbgr.mr_n80264496)
print v(xbgr.mr_n79661536)
print v(xbgr.mr_n79869120)
print v(xbgr.mr_n80035328)
print v(xbgr.mr_n80275792)
print v(xbgr.mr_n80337792)
print v(xbgr.mr_n80405360)
print v(xbgr.mr_n80433984)
print v(xbgr.mr_n80559616)
print v(xbgr.mr_n80608704)
print v(xbgr.mr_n80742768)
print v(xbgr.mr_n80848704)
print v(xbgr.mr_n80817952)
print v(xbgr.mr_n81113280)
print v(xbgr.mr_n81256800)
print v(xbgr.mr_n81399504)
print v(xbgr.mr_n81512000)
print v(xbgr.mr_n81689328)
print v(xbgr.mr_n81810224)
print v(xbgr.mr_n81964736)
print v(xbgr.mr_n82117632)
print v(xbgr.mr_n82230112)
print v(xbgr.mr_n82402400)
print v(xbgr.mr_n82481248)
print v(xbgr.mr_n82908960)
print v(xbgr.mr_n83168048)
print v(xbgr.mr_n83279872)
print v(xbgr.mr_n83462640)
print v(xbgr.mr_n83604480)
print v(xbgr.mr_n83784640)
print v(xbgr.mr_n83998688)
print v(xbgr.mr_n81125856)
print v(xbgr.mr_n84098448)
print v(xbgr.mr_n84407936)
print v(xbgr.mr_n84562160)
print v(xbgr.mr_n84696496)
print v(xbgr.mr_n84941904)
print v(xbgr.mr_n85181264)
print v(xbgr.mr_n85490432)
print v(xbgr.mr_n85657120)
print v(xbgr.mr_n85868448)
print v(xbgr.mr_n86102640)
print v(xbgr.mr_n80337904)
print v(xbgr.mr_n80378800)
print v(xbgr.mr_n79597520)
print v(xbgr.mr_n80497280)
print v(xbgr.mr_n80567424)
print v(xbgr.mr_n80601312)
print v(xbgr.mr_n80807072)
print v(xbgr.mr_n80817312)
print v(xbgr.mr_n81187680)
print v(xbgr.mr_n81397440)
print v(xbgr.mr_n81458752)
print v(xbgr.mr_n81590944)
print v(xbgr.mr_n81756272)
print v(xbgr.mr_n81866160)
print v(xbgr.mr_n82003744)
print v(xbgr.mr_n82224208)
print v(xbgr.mr_n82400224)
print v(xbgr.mr_n79662000)
print v(xbgr.mr_n79869712)
print v(xbgr.mr_n80039408)
print v(xbgr.mr_n80276320)
print v(xbgr.mr_n79653248)
print v(xbgr.mr_n79870304)
print v(xbgr.mr_n80031184)
print v(xbgr.mr_n80276912)
print v(xbgr.mr_n80369424)
print v(xbgr.mr_n80420736)
print v(xbgr.mr_n80440704)
print v(xbgr.mr_n80553392)
print v(xbgr.mr_n80656544)
print v(xbgr.mr_n80766544)
print v(xbgr.mr_n80856256)
print v(xbgr.mr_n80987744)
print v(xbgr.mr_n81084912)
print v(xbgr.mr_n81276176)
print v(xbgr.mr_n81408336)
print v(xbgr.mr_n81525872)
print v(xbgr.mr_n81687552)
print v(xbgr.mr_n81811200)
print v(xbgr.mr_n81999792)
print v(xbgr.mr_n82119552)
print v(xbgr.mr_n82220592)
print v(xbgr.mr_n82398272)
print v(xbgr.mr_n79662992)
print v(xbgr.mr_n79870896)
print v(xbgr.mr_n80040656)
print v(xbgr.mr_n80277504)
print v(xbgr.mr_n79663392)
print v(xbgr.mr_n79855504)
print v(xbgr.mr_n80041248)
print v(xbgr.mr_n80261536)
print v(xbgr.mr_n79663856)
print v(xbgr.mr_n79864384)
print v(xbgr.mr_n80037104)
print v(xbgr.n_31)
print v(xbgr.mr_n80332800)
print v(xbgr.mr_n80420560)
print v(xbgr.mr_n80426304)
print v(xbgr.mr_n79522608)
print v(xbgr.mr_n80510912)
print v(xbgr.mr_n80743952)
print v(xbgr.mr_n80851360)
print v(xbgr.mr_n80937920)
print v(xbgr.mr_n81119424)
print v(xbgr.mr_n81224256)
print v(xbgr.mr_n81406864)
print v(xbgr.mr_n81465072)
print v(xbgr.mr_n81689952)
print v(xbgr.mr_n81789664)
print v(xbgr.mr_n81963552)
print v(xbgr.mr_n82115824)
print v(xbgr.mr_n82227936)
print v(xbgr.mr_n82404240)
print v(xbgr.mr_n79664320)
print v(xbgr.mr_n79872736)
print v(xbgr.mr_n80042432)
print v(xbgr.mr_n80279280)
print v(xbgr.mr_n78637152)
print v(xbgr.mr_n82911984)
print v(xbgr.mr_n83139968)
print v(xbgr.mr_n83268864)
print v(xbgr.mr_n83442976)
print v(xbgr.mr_n83601104)
print v(xbgr.mr_n83795312)
print v(xbgr.mr_n83982992)
print v(xbgr.mr_n81120672)
print v(xbgr.mr_n84100704)
print v(xbgr.mr_n84412912)
print v(xbgr.mr_n84542112)
print v(xbgr.mr_n84744160)
print v(xbgr.mr_n84924208)
print v(xbgr.mr_n85186240)
print v(xbgr.mr_n85470528)
print v(xbgr.mr_n85661776)
print v(xbgr.mr_n85867472)
print v(xbgr.mr_n86035728)
print v(xbgr.mr_n80332912)
print v(xbgr.mr_n80378608)
print v(xbgr.mr_n79598128)
print v(xbgr.mr_n80496816)
print v(xbgr.mr_n80566960)
print v(xbgr.mr_n80651120)
print v(xbgr.mr_n80806768)
print v(xbgr.mr_n80890272)
print v(xbgr.mr_n81128464)
print v(xbgr.mr_n81394480)
print v(xbgr.mr_n81458288)
print v(xbgr.mr_n81590480)
print v(xbgr.mr_n81755936)
print v(xbgr.mr_n81865568)
print v(xbgr.mr_n82003136)
print v(xbgr.mr_n82231952)
print v(xbgr.mr_n82402176)
print v(xbgr.mr_n79662464)
print v(xbgr.mr_n79873264)
print v(xbgr.mr_n80043024)
print v(xbgr.mr_n80279872)
print v(xbgr.mr_n80370880)
print v(xbgr.mr_n80414496)
print v(xbgr.mr_n80442512)
print v(xbgr.mr_n80510704)
print v(xbgr.mr_n80655744)
print v(xbgr.mr_n80775152)
print v(xbgr.mr_n80854560)
print v(xbgr.mr_n80988960)
print v(xbgr.mr_n81112128)
print v(xbgr.mr_n81277904)
print v(xbgr.mr_n81410480)
print v(xbgr.mr_n81527760)
print v(xbgr.mr_n81691728)
print v(xbgr.mr_n81812000)
print v(xbgr.mr_n82006720)
print v(xbgr.mr_n82117744)
print v(xbgr.mr_n82229888)
print v(xbgr.mr_n82396096)
print v(xbgr.mr_n79665248)
print v(xbgr.mr_n79873856)
print v(xbgr.mr_n80043616)
print v(xbgr.mr_n80280464)
print v(xbgr.mr_n79665712)
print v(xbgr.n_34)
print v(xbgr.mr_n80032960)
print v(xbgr.mr_n80278096)
print v(xbgr.mr_n79652336)
print v(xbgr.mr_n79875040)
print v(xbgr.mr_n80044736)
print v(xbgr.mr_n80281568)
print v(xbgr.mr_n79666640)
print v(xbgr.mr_n79875632)
print v(xbgr.mr_n80030528)
print v(xbgr.mr_n80282240)
print v(xbgr.mr_n80327808)
print v(xbgr.mr_n80419760)
print v(xbgr.mr_n80424928)
print v(xbgr.mr_n80534640)
print v(xbgr.mr_n80572528)
print v(xbgr.mr_n80745136)
print v(xbgr.mr_n80857008)
print v(xbgr.mr_n80937664)
print v(xbgr.mr_n81116032)
print v(xbgr.mr_n81274880)
print v(xbgr.mr_n81404800)
print v(xbgr.mr_n81524656)
print v(xbgr.mr_n81689152)
print v(xbgr.mr_n81807824)
print v(xbgr.mr_n81896096)
print v(xbgr.mr_n82123056)
print v(xbgr.mr_n82230000)
print v(xbgr.mr_n82404464)
print v(xbgr.mr_n82720656)
print v(xbgr.mr_n82903520)
print v(xbgr.mr_n78892256)
print v(xbgr.mr_n83129584)
print v(xbgr.mr_n83447632)
print v(xbgr.mr_n83582208)
print v(xbgr.mr_n83784176)
print v(xbgr.mr_n84010704)
print v(xbgr.mr_n81120528)
print v(xbgr.mr_n84098256)
print v(xbgr.mr_n84417888)
print v(xbgr.mr_n84542304)
print v(xbgr.mr_n84733024)
print v(xbgr.mr_n84931648)
print v(xbgr.mr_n85191216)
print v(xbgr.mr_n85450624)
print v(xbgr.mr_n85689712)
print v(xbgr.mr_n85872928)
print v(xbgr.mr_n85790800)
print v(xbgr.mr_n79657824)
print v(xbgr.mr_n79871488)
print v(xbgr.mr_n80038288)
print v(xbgr.mr_n80282832)
print v(xbgr.mr_n80327920)
print v(xbgr.mr_n80377216)
print v(xbgr.mr_n80424368)
print v(xbgr.mr_n80495888)
print v(xbgr.mr_n80566032)
print v(xbgr.mr_n80484032)
print v(xbgr.mr_n80766880)
print v(xbgr.mr_n80889968)
print v(xbgr.mr_n81191968)
print v(xbgr.mr_n81409824)
print v(xbgr.mr_n81457360)
print v(xbgr.mr_n81589552)
print v(xbgr.mr_n81755392)
print v(xbgr.mr_n81864448)
print v(xbgr.mr_n82005488)
print v(xbgr.mr_n82226128)
print v(xbgr.mr_n82406304)
print v(xbgr.mr_n79667632)
print v(xbgr.mr_n79876880)
print v(xbgr.mr_n80046512)
print v(xbgr.mr_n80283424)
print v(xbgr.mr_n80372256)
print v(xbgr.mr_n80422336)
print v(xbgr.mr_n80444320)
print v(xbgr.mr_n80533920)
print v(xbgr.mr_n80654944)
print v(xbgr.mr_n80775552)
print v(xbgr.mr_n80858704)
print v(xbgr.mr_n80989840)
print v(xbgr.mr_n81105264)
print v(xbgr.mr_n81279712)
print v(xbgr.mr_n81412544)
print v(xbgr.mr_n81529488)
print v(xbgr.mr_n81692528)
print v(xbgr.mr_n81812800)
print v(xbgr.mr_n82004480)
print v(xbgr.mr_n82121360)
print v(xbgr.mr_n82228048)
print v(xbgr.mr_n82402288)
print v(xbgr.mr_n79668032)
print v(xbgr.mr_n79877408)
print v(xbgr.mr_n80038880)
print v(xbgr.mr_n80284016)
print v(xbgr.mr_n79668496)
print v(xbgr.mr_n79878000)
print v(xbgr.mr_n80044208)
print v(xbgr.mr_n80284608)
print v(xbgr.mr_n79668960)
print v(xbgr.mr_n79878592)
print v(xbgr.mr_n80048288)
print v(xbgr.mr_n80274544)
print v(xbgr.mr_n79667104)
print v(xbgr.mr_n79879184)
print v(xbgr.n_10)
print v(xbgr.mr_n80285856)
print v(xbgr.mr_n80322816)
print v(xbgr.mr_n80418960)
print v(xbgr.mr_n80437600)
print v(xbgr.mr_n80467952)
print v(xbgr.mr_n80608192)
print v(xbgr.mr_n80746320)
print v(xbgr.mr_n80858928)
print v(xbgr.mr_n80881968)
print v(xbgr.mr_n81120192)
print v(xbgr.mr_n81254576)
print v(xbgr.mr_n81407760)
print v(xbgr.mr_n81526464)
print v(xbgr.mr_n81682752)
print v(xbgr.mr_n81805424)
print v(xbgr.mr_n81809424)
print v(xbgr.mr_n82126784)
print v(xbgr.mr_n82236080)
print v(xbgr.mr_n82413536)
print v(xbgr.mr_n82719344)
print v(xbgr.mr_n82901408)
print v(xbgr.mr_n83133296)
print v(xbgr.mr_n83263232)
print v(xbgr.mr_n83410384)
print v(xbgr.mr_n83572656)
print v(xbgr.mr_n83775584)
print v(xbgr.mr_n84015680)
print v(xbgr.mr_n81060944)
print v(xbgr.mr_n84097680)
print v(xbgr.mr_n84422864)
print v(xbgr.mr_n84555520)
print v(xbgr.mr_n84719840)
print v(xbgr.mr_n84932912)
print v(xbgr.mr_n85196192)
print v(xbgr.mr_n85427792)
print v(xbgr.mr_n85557984)
print v(xbgr.mr_n85325392)
print v(xbgr.mr_n86104640)
print v(xbgr.mr_n80322928)
print v(xbgr.mr_n80372960)
print v(xbgr.mr_n79629632)
print v(xbgr.mr_n80495424)
print v(xbgr.mr_n80565568)
print v(xbgr.mr_n80679440)
print v(xbgr.mr_n80767552)
print v(xbgr.mr_n80861360)
print v(xbgr.mr_n81166688)
print v(xbgr.mr_n81405696)
print v(xbgr.mr_n81456896)
print v(xbgr.mr_n81589088)
print v(xbgr.mr_n81742864)
print v(xbgr.mr_n81863984)
print v(xbgr.mr_n82004736)
print v(xbgr.mr_n82234128)
print v(xbgr.mr_n82406416)
print v(xbgr.mr_n79669888)
print v(xbgr.mr_n79879776)
print v(xbgr.mr_n80049536)
print v(xbgr.mr_n80259232)
print v(xbgr.mr_n79670352)
print v(xbgr.mr_n79880368)
print v(xbgr.mr_n80050128)
print v(xbgr.mr_n80286976)
print v(xbgr.mr_n80374192)
print v(xbgr.mr_n80423136)
print v(xbgr.mr_n80446048)
print v(xbgr.mr_n80558288)
print v(xbgr.mr_n80654144)
print v(xbgr.mr_n80775952)
print v(xbgr.mr_n80858816)
print v(xbgr.mr_n80989664)
print v(xbgr.mr_n81124720)
print v(xbgr.mr_n81281600)
print v(xbgr.mr_n81414528)
print v(xbgr.mr_n81531296)
print v(xbgr.mr_n81693328)
print v(xbgr.mr_n81813600)
print v(xbgr.mr_n82009664)
print v(xbgr.mr_n82126672)
print v(xbgr.mr_n82232176)
print v(xbgr.mr_n82406528)
print v(xbgr.mr_n79670816)
print v(xbgr.mr_n79876224)
print v(xbgr.mr_n80050720)
print v(xbgr.mr_n80257392)
print v(xbgr.mr_n79652784)
print v(xbgr.mr_n79881616)
print v(xbgr.mr_n80045392)
print v(xbgr.mr_n80288160)
print v(xbgr.mr_n79664784)
print v(xbgr.mr_n79882144)
print v(xbgr.mr_n80051904)
print v(xbgr.mr_n80288752)
print v(xbgr.mr_n80311200)
print v(xbgr.mr_n80421360)
print v(xbgr.mr_n80435792)
print v(xbgr.mr_n80532480)
print v(xbgr.mr_n80473408)
print v(xbgr.mr_n80747504)
print v(xbgr.mr_n80863920)
print v(xbgr.mr_n80937472)
print v(xbgr.mr_n81130544)
print v(xbgr.mr_n81264304)
print v(xbgr.mr_n81403632)
print v(xbgr.mr_n81519232)
print v(xbgr.mr_n81690752)
print v(xbgr.mr_n81812624)
print v(xbgr.mr_n81895392)
print v(xbgr.mr_n82124976)
print v(xbgr.mr_n82236304)
print v(xbgr.mr_n82404352)
print v(xbgr.mr_n79672272)
print v(xbgr.mr_n79882736)
print v(xbgr.mr_n80052496)
print v(xbgr.mr_n80289344)
print v(xbgr.mr_n82718400)
print v(xbgr.mr_n82891808)
print v(xbgr.mr_n83111696)
print v(xbgr.mr_n83244656)
print v(xbgr.mr_n83481264)
print v(xbgr.mr_n83537600)
print v(xbgr.mr_n83746672)
print v(xbgr.mr_n84020768)
print v(xbgr.mr_n81142640)
print v(xbgr.mr_n84097872)
print v(xbgr.mr_n84383824)
print v(xbgr.mr_n84506512)
print v(xbgr.mr_n84723696)
print v(xbgr.mr_n84938112)
print v(xbgr.mr_n85099824)
print v(xbgr.mr_n85317008)
print v(xbgr.mr_n85560832)
print v(xbgr.mr_n85842064)
print v(xbgr.mr_n86097792)
print v(xbgr.mr_n80318288)
print v(xbgr.mr_n80378144)
print v(xbgr.mr_n79616736)
print v(xbgr.mr_n80494496)
print v(xbgr.mr_n80478208)
print v(xbgr.mr_n80680480)
print v(xbgr.mr_n80748688)
print v(xbgr.mr_n80884224)
print v(xbgr.mr_n81230560)
print v(xbgr.mr_n81303968)
print v(xbgr.mr_n81433136)
print v(xbgr.mr_n81559440)
print v(xbgr.mr_n81753520)
print v(xbgr.mr_n81813424)
print v(xbgr.mr_n82007904)
print v(xbgr.mr_n82236192)
print v(xbgr.mr_n82409552)
print v(xbgr.mr_n79672672)
print v(xbgr.mr_n79883328)
print v(xbgr.mr_n80045984)
print v(xbgr.mr_n80191808)
print v(xbgr.mr_n80375248)
print v(xbgr.mr_n80423936)
print v(xbgr.mr_n80447936)
print v(xbgr.mr_n80555328)
print v(xbgr.mr_n80623904)
print v(xbgr.mr_n80776352)
print v(xbgr.mr_n80863696)
print v(xbgr.mr_n80991456)
print v(xbgr.mr_n81125584)
print v(xbgr.mr_n81283328)
print v(xbgr.mr_n81416416)
print v(xbgr.mr_n81533184)
print v(xbgr.mr_n81694128)
print v(xbgr.mr_n81814400)
print v(xbgr.mr_n82012448)
print v(xbgr.mr_n82121248)
print v(xbgr.mr_n82227824)
print v(xbgr.mr_n82413056)
print v(xbgr.mr_n79673136)
print v(xbgr.mr_n79883920)
print v(xbgr.mr_n80053616)
print v(xbgr.mr_n80146416)
print v(xbgr.mr_n79671280)
print v(xbgr.mr_n79712112)
print v(xbgr.mr_n80054272)
print v(xbgr.mr_n80257904)
print v(xbgr.mr_n79674064)
print v(xbgr.mr_n79839376)
print v(xbgr.mr_n80047168)
print v(xbgr.mr_n80287568)
print v(xbgr.mr_n79503680)
print v(xbgr.mr_n79843408)
print v(xbgr.mr_n80055392)
print v(xbgr.mr_n80285200)
print v(xbgr.mr_n79669424)
print v(xbgr.mr_n79566976)
print v(xbgr.mr_n80041840)
print v(xbgr.mr_n80275136)
print v(xbgr.mr_n79675456)
print v(xbgr.mr_n79702192)
print v(xbgr.mr_n80053088)
print v(xbgr.mr_n80281056)
print v(xbgr.mr_n79675920)
print v(xbgr.mr_n79846304)
print v(xbgr.mr_n80057168)
print v(xbgr.mr_n79842400)
print v(xbgr.mr_n79674992)
print v(xbgr.mr_n79592416)
print v(xbgr.mr_n80048944)
print v(xbgr.mr_n80237280)
print v(xbgr.mr_n80533728)
print v(xbgr.mr_n82011952)
print v(xbgr.mr_n82238368)
print v(xbgr.mr_n82417520)
print v(xbgr.mr_n79676912)
print v(xbgr.mr_n79792160)
print v(xbgr.mr_n80058416)
print v(xbgr.mr_n80158560)
print v(xbgr.d5)
print v(xbgr.d1)
print v(xbgr.mr_n80528432)
print v(xbgr.mr_n80864192)
print v(xbgr.mr_n80372848)
print v(xbgr.mr_n80292464)
print v(xbgr.mr_n80866720)
print v(xbgr.mr_n82011696)
print v(xbgr.n1)
print v(xbgr.mr_n82417152)
print v(xbgr.mr_n79677312)
print v(xbgr.mr_n79564160)
print v(xbgr.mr_n80059008)
print v(xbgr.mr_n80286384)
print v(xbgr.mr_n81811824)
print v(xbgr.mr_n82037504)
print v(xbgr.mr_n82253552)
print v(xbgr.mr_n80315504)
print v(xbgr.mr_n80408384)
print v(xbgr.kick)
print v(xbgr.mr_n80706128)
print v(xbgr.mr_n82010400)
print v(xbgr.mr_n82092576)
print v(xbgr.mr_n82417040)
print v(xbgr.mr_n79677776)
print v(xbgr.mr_n79631280)
print v(xbgr.mr_n80054864)
print v(xbgr.mr_n80165856)
print v(xbgr.mr_n79678240)
print v(xbgr.mr_n79847248)
print v(xbgr.mr_n80060192)
print v(xbgr.mr_n79844416)
print v(xbgr.mr_n80374896)
print v(xbgr.mr_n80448448)
print v(xbgr.mr_n80505312)
print v(xbgr.mr_n80859200)
print v(xbgr.mr_n82011520)
print v(xbgr.mr_n82240208)
print v(xbgr.mr_n82409184)
print v(xbgr.mr_n80981760)
print v(xbgr.mr_n81137824)
print v(xbgr.mr_n81206640)
print v(xbgr.mr_n81276688)
print v(xbgr.mr_n81494224)
print v(xbgr.mr_n81657072)
print v(xbgr.mr_n81776976)
print v(xbgr.mr_n80988624)
print v(xbgr.mr_n81105504)
print v(xbgr.mr_n81206864)
print v(xbgr.mr_n81271264)
print v(xbgr.mr_n81521040)
print v(xbgr.mr_n81663776)
print v(xbgr.mr_n81785440)
print v(xbgr.mr_n79678704)
print v(xbgr.mr_n79585152)
print v(xbgr.mr_n80060784)
print v(xbgr.mr_n80289744)
print v(xbgr.mr_n82007728)
print v(xbgr.mr_n82182112)
print v(xbgr.mr_n82421136)
print v(xbgr.mr_n80890656)
print v(xbgr.mr_n81022944)
print v(xbgr.mr_n81088320)
print v(xbgr.mr_n81226288)
print v(xbgr.mr_n81430448)
print v(xbgr.mr_n81556752)
print v(xbgr.mr_n81686752)
print v(xbgr.mr_n81826944)
print v(xbgr.mr_n82055104)
print v(xbgr.mr_n82257552)
print v(xbgr.mr_n79679168)
print v(xbgr.mr_n79884256)
print v(xbgr.mr_n80061376)
print v(xbgr.mr_n80242768)
print v(xbgr.mr_n82013120)
print v(xbgr.mr_n82182224)
print v(xbgr.mr_n82409072)
print v(xbgr.mr_n80532800)
print v(xbgr.mr_n80988016)
print v(xbgr.d2)
print v(xbgr.mr_n81213648)
print v(xbgr.mr_n81228000)
print v(xbgr.mr_n81515616)
print v(xbgr.mr_n81626272)
print v(xbgr.mr_n81751744)
print v(xbgr.mr_n80376096)
print v(xbgr.mr_n80448560)
print v(xbgr.mr_n80866416)
print v(xbgr.mr_n79679632)
print v(xbgr.mr_n79884368)
print v(xbgr.mr_n80047696)
print v(xbgr.mr_n80290944)
print v(xbgr.mr_n80376208)
print v(xbgr.mr_n80448672)
print v(xbgr.mr_n80867232)
print v(xbgr.mr_n82014512)
print v(xbgr.mr_n82238144)
print v(xbgr.mr_n82413168)
print v(xbgr.mr_n80531664)
print v(xbgr.mr_n79680096)
print v(xbgr.mr_n79872000)
print v(xbgr.mr_n80062496)
print v(xbgr.mr_n80007216)
print v(xbgr.mr_n80316048)
print v(xbgr.mr_n80408112)
print v(xbgr.mr_n80749760)
print v(xbgr.det)
print v(xbgr.mr_n82015312)
print v(xbgr.mr_n82091616)
print v(xbgr.mr_n82421504)
print v(xbgr.mr_n80508848)
print v(xbgr.mr_n79673600)
print v(xbgr.mr_n79885440)
print v(xbgr.mr_n80063152)
print v(xbgr.mr_n80239328)
print v(xbgr.mr_n81828720)
print v(xbgr.mr_n82054640)
print v(xbgr.mr_n82259408)
print v(xbgr.mr_n80375984)
print v(xbgr.mr_n80432176)
print v(xbgr.mr_n80866528)
print v(xbgr.mr_n82016256)
print v(xbgr.mr_n82183072)
print v(xbgr.mr_n82424208)
print v(xbgr.mr_n80992064)
print v(xbgr.mr_n81129888)
print v(xbgr.mr_n81206528)
print v(xbgr.mr_n81266016)
print v(xbgr.mr_n81531888)
print v(xbgr.mr_n81660368)
print v(xbgr.mr_n81777312)
print v(xbgr.mr_n80990816)
print v(xbgr.mr_n81133632)
print v(xbgr.mr_n81208672)
print v(xbgr.mr_n81278496)
print v(xbgr.mr_n81533920)
print v(xbgr.mr_n81664592)
print v(xbgr.mr_n81786256)
print v(xbgr.mr_n79671744)
print v(xbgr.mr_n79885840)
print v(xbgr.mr_n80056048)
print v(xbgr.mr_n80291872)
print v(xbgr.mr_n80913936)
print v(xbgr.mr_n81024864)
print v(xbgr.mr_n81146048)
print v(xbgr.mr_n81231376)
print v(xbgr.mr_n81434480)
print v(xbgr.mr_n81560784)
print v(xbgr.mr_n81694672)
print v(xbgr.mr_n82016672)
print v(xbgr.mr_n82242752)
print v(xbgr.mr_n82421024)
print v(xbgr.mr_n79681552)
print v(xbgr.mr_n79887168)
print v(xbgr.mr_n80064272)
print v(xbgr.mr_n80236224)
print v(xbgr.mr_n82014400)
print v(xbgr.mr_n82182336)
print v(xbgr.mr_n82425712)
print v(xbgr.mr_n79681952)
print v(xbgr.mr_n79887760)
print v(xbgr.mr_n80064928)
print v(xbgr.mr_n80296544)
print v(xbgr.mr_n80530960)
print v(xbgr.mr_n80991728)
print v(xbgr.mr_n81143632)
print v(xbgr.mr_n81196912)
print v(xbgr.mr_n81284144)
print v(xbgr.mr_n81534416)
print v(xbgr.mr_n81623904)
print v(xbgr.mr_n81752400)
print v(xbgr.mr_n80376832)
print v(xbgr.mr_n80449520)
print v(xbgr.mr_n80867920)
print v(xbgr.mr_n81830576)
print v(xbgr.mr_n82054176)
print v(xbgr.mr_n82261264)
print v(xbgr.mr_n80375072)
print v(xbgr.mr_n80449632)
print v(xbgr.mr_n80854672)
print v(xbgr.mr_n82018848)
print v(xbgr.mr_n82182448)
print v(xbgr.mr_n82426608)
print v(xbgr.mr_n79682416)
print v(xbgr.mr_n79485936)
print v(xbgr.mr_n80057824)
print v(xbgr.mr_n80296432)
print v(xbgr.mr_n80505856)
print v(xbgr.mr_n80315776)
print v(xbgr.mr_n80407840)
print v(xbgr.mr_n80468992)
print v(xbgr.mr_n80750032)
print v(xbgr.r4n)
print v(xbgr.mr_n79682880)
print v(xbgr.mr_n79880960)
print v(xbgr.mr_n80066048)
print v(xbgr.mr_n80297040)
print v(xbgr.mr_n82013232)
print v(xbgr.mr_n82244384)
print v(xbgr.mr_n82424096)
print v(xbgr.mr_n80376480)
print v(xbgr.mr_n80450256)
print v(xbgr.mr_n80869008)
print v(xbgr.mr_n80992800)
print v(xbgr.mr_n81117408)
print v(xbgr.mr_n81195936)
print v(xbgr.mr_n81280304)
print v(xbgr.mr_n81533808)
print v(xbgr.mr_n81660016)
print v(xbgr.mr_n81372256)
print v(xbgr.mr_n80988448)
print v(xbgr.mr_n81105616)
print v(xbgr.mr_n81206032)
print v(xbgr.mr_n81284032)
print v(xbgr.mr_n81534304)
print v(xbgr.mr_n81657776)
print v(xbgr.mr_n81781104)
print v(xbgr.mr_n79681024)
print v(xbgr.mr_n79889600)
print v(xbgr.mr_n80056640)
print v(xbgr.mr_n80297280)
print v(xbgr.mr_n82013776)
print v(xbgr.mr_n82184848)
print v(xbgr.mr_n82428176)
print v(xbgr.mr_n81832432)
print v(xbgr.mr_n82053712)
print v(xbgr.mr_n82263120)
print v(xbgr.mr_n80913472)
print v(xbgr.mr_n81024336)
print v(xbgr.mr_n81146864)
print v(xbgr.mr_n81232192)
print v(xbgr.mr_n81435296)
print v(xbgr.mr_n81561600)
print v(xbgr.mr_n81695088)
print v(xbgr.mr_n79683808)
print v(xbgr.mr_n79890128)
print v(xbgr.mr_n80067232)
print v(xbgr.mr_n80297520)
print v(xbgr.mr_n82018416)
print v(xbgr.mr_n82187536)
print v(xbgr.mr_n82429168)
print v(xbgr.mr_n79684272)
print v(xbgr.mr_n79890720)
print v(xbgr.mr_n80067888)
print v(xbgr.mr_n80297760)
print v(xbgr.mr_n80529904)
print v(xbgr.mr_n80991952)
print v(xbgr.mr_n81112400)
print v(xbgr.mr_n81206416)
print v(xbgr.mr_n81284560)
print v(xbgr.mr_n81534032)
print v(xbgr.mr_n81625088)
print v(xbgr.mr_n81749968)
print v(xbgr.mr_n82020816)
print v(xbgr.mr_n82246016)
print v(xbgr.mr_n82426432)
print v(xbgr.mr_n80377568)
print v(xbgr.mr_n80450368)
print v(xbgr.mr_n80868544)
print v(xbgr.mr_n80376944)
print v(xbgr.mr_n80449904)
print v(xbgr.mr_n80870112)
print v(xbgr.mr_n79684736)
print v(xbgr.mr_n79891296)
print v(xbgr.mr_n80063744)
print v(xbgr.mr_n80298240)
print v(xbgr.mr_n82020704)
print v(xbgr.mr_n82186944)
print v(xbgr.mr_n82430736)
print v(xbgr.mr_n80523584)
print v(xbgr.mr_n80315232)
print v(xbgr.mr_n80407568)
print v(xbgr.mr_n80749568)
print v(xbgr.mr_n80471088)
print v(xbgr.mr_n81834288)
print v(xbgr.mr_n82053248)
print v(xbgr.mr_n82264976)
print v(xbgr.mr_n79685200)
print v(xbgr.mr_n79889008)
print v(xbgr.mr_n80069072)
print v(xbgr.mr_n80237776)
print v(xbgr.mr_n80506528)
print v(xbgr.mr_n82022976)
print v(xbgr.mr_n82185760)
print v(xbgr.mr_n82428992)
print v(xbgr.mr_n80375872)
print v(xbgr.mr_n80449168)
print v(xbgr.mr_n80851248)
print v(xbgr.mr_n79676384)
print v(xbgr.mr_n79892400)
print v(xbgr.mr_n80069664)
print v(xbgr.mr_n80298720)
print v(xbgr.mr_n80993936)
print v(xbgr.mr_n81112896)
print v(xbgr.mr_n81211920)
print v(xbgr.mr_n81284368)
print v(xbgr.mr_n81535504)
print v(xbgr.mr_n81653664)
print v(xbgr.mr_n81779856)
print v(xbgr.mr_n80994832)
print v(xbgr.mr_n81112784)
print v(xbgr.mr_n81208480)
print v(xbgr.mr_n81285104)
print v(xbgr.mr_n81528272)
print v(xbgr.mr_n81661184)
print v(xbgr.mr_n81781920)
print v(xbgr.mr_n82023392)
print v(xbgr.mr_n82247648)
print v(xbgr.mr_n82431728)
print v(xbgr.mr_n79686192)
print v(xbgr.mr_n79893072)
print v(xbgr.mr_n80070256)
print v(xbgr.mr_n80298960)
print v(xbgr.mr_n80913008)
print v(xbgr.mr_n81023872)
print v(xbgr.mr_n81147680)
print v(xbgr.mr_n81232928)
print v(xbgr.mr_n81436112)
print v(xbgr.mr_n81562416)
print v(xbgr.mr_n81695904)
print v(xbgr.mr_n82024320)
print v(xbgr.mr_n82183776)
print v(xbgr.mr_n82433296)
print v(xbgr.mr_n79686592)
print v(xbgr.mr_n79862016)
print v(xbgr.mr_n80059600)
print v(xbgr.mr_n80298000)
print v(xbgr.mr_n81836144)
print v(xbgr.mr_n82052784)
print v(xbgr.mr_n82266864)
print v(xbgr.mr_n80992176)
print v(xbgr.mr_n81139936)
print v(xbgr.mr_n81198320)
print v(xbgr.mr_n81283920)
print v(xbgr.mr_n81534768)
print v(xbgr.mr_n81622720)
print v(xbgr.mr_n81748848)
print v(xbgr.mr_n82025264)
print v(xbgr.mr_n82188128)
print v(xbgr.mr_n82434288)
print v(xbgr.mr_n80371392)
print v(xbgr.mr_n80452624)
print v(xbgr.d3)
print v(xbgr.mr_n80867568)
print v(xbgr.mr_n80370544)
print v(xbgr.mr_n80429696)
print v(xbgr.mr_n80680608)
print v(xbgr.mr_n80861664)
print v(xbgr.mr_n79687056)
print v(xbgr.mr_n79894176)
print v(xbgr.mr_n80071376)
print v(xbgr.mr_n80299600)
print v(xbgr.mr_n80314960)
print v(xbgr.mr_n80407296)
print v(xbgr.mr_n80157088)
print v(xbgr.mr_n80748384)
print v(xbgr.mr_n82025792)
print v(xbgr.mr_n82249280)
print v(xbgr.mr_n82431552)
print v(xbgr.mr_n79687520)
print v(xbgr.mr_n79867936)
print v(xbgr.mr_n80072032)
print v(xbgr.mr_n80300080)
print v(xbgr.mr_n82017600)
print v(xbgr.mr_n82186352)
print v(xbgr.mr_n82435856)
print v(xbgr.mr_n79687984)
print v(xbgr.mr_n79895440)
print v(xbgr.mr_n80061968)
print v(xbgr.mr_n80290240)
print v(xbgr.mr_n80373696)
print v(xbgr.mr_n80452272)
print v(xbgr.mr_n80662288)
print v(xbgr.mr_n80869424)
print v(xbgr.mr_n80995520)
print v(xbgr.mr_n81140592)
print v(xbgr.mr_n81212656)
print v(xbgr.mr_n81282112)
print v(xbgr.mr_n81413056)
print v(xbgr.mr_n81537088)
print v(xbgr.mr_n81656608)
print v(xbgr.mr_n81777200)
print v(xbgr.mr_n80992912)
print v(xbgr.mr_n81100032)
print v(xbgr.mr_n81209136)
print v(xbgr.mr_n81284256)
print v(xbgr.mr_n81416928)
print v(xbgr.mr_n81538624)
print v(xbgr.mr_n81656960)
print v(xbgr.mr_n81777088)
print v(xbgr.mr_n81838000)
print v(xbgr.mr_n82052320)
print v(xbgr.mr_n82269232)
print v(xbgr.mr_n82026672)
print v(xbgr.mr_n82181136)
print v(xbgr.mr_n82436848)
print v(xbgr.mr_n79688448)
print v(xbgr.mr_n79896032)
print v(xbgr.mr_n80073152)
print v(xbgr.mr_n80301200)
print v(xbgr.mr_n80912544)
print v(xbgr.mr_n81023408)
print v(xbgr.mr_n81148496)
print v(xbgr.mr_n81232464)
print v(xbgr.mr_n81308672)
print v(xbgr.mr_n81436928)
print v(xbgr.mr_n81563232)
print v(xbgr.mr_n81696720)
print v(xbgr.mr_n79688912)
print v(xbgr.mr_n79896624)
print v(xbgr.mr_n80073808)
print v(xbgr.mr_n80301680)
print v(xbgr.mr_n82025680)
print v(xbgr.mr_n82248192)
print v(xbgr.mr_n82434112)
print v(xbgr.mr_n80994464)
print v(xbgr.mr_n81037344)
print v(xbgr.mr_n81198096)
print v(xbgr.mr_n81273072)
print v(xbgr.mr_n81417264)
print v(xbgr.mr_n81536544)
print v(xbgr.mr_n81620352)
print v(xbgr.mr_n81741088)
print v(xbgr.mr_n80366576)
print v(xbgr.mr_n80454192)
print v(xbgr.mr_n80611456)
print v(xbgr.mr_n80870640)
print v(xbgr.mr_n80373520)
print v(xbgr.mr_n80453312)
print v(xbgr.mr_n80693504)
print v(xbgr.mr_n80871680)
print v(xbgr.mr_n79666176)
print v(xbgr.mr_n79897216)
print v(xbgr.mr_n80066704)
print v(xbgr.mr_n80302080)
print v(xbgr.mr_n82020128)
print v(xbgr.mr_n82182800)
print v(xbgr.mr_n82438416)
print v(xbgr.mr_n81838928)
print v(xbgr.mr_n82051856)
print v(xbgr.mr_n82270416)
print v(xbgr.mr_n79689840)
print v(xbgr.mr_n79897808)
print v(xbgr.mr_n80051312)
print v(xbgr.mr_n80302880)
print v(xbgr.mr_n80314688)
print v(xbgr.mr_n80407024)
print v(xbgr.mr_n80472512)
print v(xbgr.mr_n80747200)
print v(xbgr.mr_n82029376)
print v(xbgr.mr_n82181584)
print v(xbgr.mr_n82439408)
print v(xbgr.mr_n79683344)
print v(xbgr.mr_n79898400)
print v(xbgr.mr_n80065520)
print v(xbgr.mr_n80299280)
print v(xbgr.mr_n80369936)
print v(xbgr.mr_n80449056)
print v(xbgr.mr_n80662016)
print v(xbgr.mr_n80873712)
print v(xbgr.mr_n82030224)
print v(xbgr.mr_n82250368)
print v(xbgr.mr_n82436672)
print v(xbgr.mr_n80995632)
print v(xbgr.mr_n81074272)
print v(xbgr.mr_n81205840)
print v(xbgr.mr_n81286720)
print v(xbgr.mr_n81417040)
print v(xbgr.mr_n81539504)
print v(xbgr.mr_n81504880)
print v(xbgr.mr_n81776864)
print v(xbgr.mr_n80997104)
print v(xbgr.mr_n81144720)
print v(xbgr.mr_n81198992)
print v(xbgr.mr_n81285376)
print v(xbgr.mr_n81418224)
print v(xbgr.mr_n81535616)
print v(xbgr.mr_n81650256)
print v(xbgr.mr_n81776160)
print v(xbgr.mr_n79690832)
print v(xbgr.mr_n79898992)
print v(xbgr.mr_n80076112)
print v(xbgr.mr_n80303600)
print v(xbgr.mr_n82031040)
print v(xbgr.mr_n82181376)
print v(xbgr.mr_n82440976)
print v(xbgr.mr_n80912080)
print v(xbgr.mr_n81022480)
print v(xbgr.mr_n81149568)
print v(xbgr.mr_n81231920)
print v(xbgr.mr_n81311136)
print v(xbgr.mr_n81437744)
print v(xbgr.mr_n81564048)
print v(xbgr.mr_n81697536)
print v(xbgr.mr_n81838464)
print v(xbgr.mr_n82051392)
print v(xbgr.mr_n82269824)
print v(xbgr.mr_n79691232)
print v(xbgr.mr_n79899584)
print v(xbgr.mr_n80076768)
print v(xbgr.mr_n80300880)
print v(xbgr.mr_n82031984)
print v(xbgr.mr_n82180400)
print v(xbgr.mr_n82443536)
print v(xbgr.mr_n80996624)
print v(xbgr.mr_n81089840)
print v(xbgr.mr_n81199808)
print v(xbgr.mr_n81285728)
print v(xbgr.mr_n81419312)
print v(xbgr.mr_n81539936)
print v(xbgr.mr_n81623312)
print v(xbgr.mr_n81747072)
print v(xbgr.mr_n79691696)
print v(xbgr.mr_n79884912)
print v(xbgr.mr_n80072624)
print v(xbgr.mr_n80304480)
print v(xbgr.mr_n80371824)
print v(xbgr.mr_n80455760)
print v(xbgr.mr_n80693328)
print v(xbgr.mr_n80872144)
print v(xbgr.mr_n80364960)
print v(xbgr.mr_n80456448)
print v(xbgr.mr_n80694832)
print v(xbgr.mr_n80873248)
print v(xbgr.mr_n82032512)
print v(xbgr.mr_n82253008)
print v(xbgr.mr_n82439232)
print v(xbgr.mr_n79692160)
print v(xbgr.mr_n79900832)
print v(xbgr.mr_n80077952)
print v(xbgr.mr_n80305200)
print v(xbgr.mr_n80314416)
print v(xbgr.mr_n80406752)
print v(xbgr.mr_n79528704)
print v(xbgr.mr_n80746016)
print v(xbgr.mr_n82033392)
print v(xbgr.mr_n82087424)
print v(xbgr.mr_n82441968)
print v(xbgr.mr_n79690304)
print v(xbgr.mr_n79901360)
print v(xbgr.mr_n80078544)
print v(xbgr.mr_n80305680)
print v(xbgr.mr_n81837536)
print v(xbgr.mr_n82050928)
print v(xbgr.mr_n82268640)
print v(xbgr.mr_n80367424)
print v(xbgr.mr_n80455408)
print v(xbgr.mr_n80661744)
print v(xbgr.mr_n80875280)
print v(xbgr.mr_n80998688)
print v(xbgr.mr_n81118368)
print v(xbgr.mr_n81198432)
print v(xbgr.mr_n81287152)
print v(xbgr.mr_n81418112)
print v(xbgr.mr_n81540624)
print v(xbgr.mr_n81653136)
print v(xbgr.mr_n81506320)
print v(xbgr.mr_n82028192)
print v(xbgr.mr_n82094528)
print v(xbgr.mr_n82444528)
print v(xbgr.mr_n80997280)
print v(xbgr.mr_n81113088)
print v(xbgr.mr_n81214656)
print v(xbgr.mr_n81289008)
print v(xbgr.mr_n81419136)
print v(xbgr.mr_n81537936)
print v(xbgr.mr_n81653552)
print v(xbgr.mr_n81252912)
print v(xbgr.mr_n79693088)
print v(xbgr.mr_n79901952)
print v(xbgr.mr_n80079136)
print v(xbgr.mr_n80306080)
print v(xbgr.mr_n80911616)
print v(xbgr.mr_n81022016)
print v(xbgr.mr_n81150032)
print v(xbgr.mr_n81231648)
print v(xbgr.mr_n81311952)
print v(xbgr.mr_n81438560)
print v(xbgr.mr_n81564864)
print v(xbgr.mr_n81698352)
print v(xbgr.mr_n79659680)
print v(xbgr.mr_n79902544)
print v(xbgr.mr_n80068480)
print v(xbgr.mr_n80306480)
print v(xbgr.mr_n82034544)
print v(xbgr.mr_n82251920)
print v(xbgr.mr_n82441792)
print v(xbgr.mr_n82035472)
print v(xbgr.mr_n82179216)
print v(xbgr.mr_n82446096)
print v(xbgr.mr_n79659216)
print v(xbgr.mr_n79900176)
print v(xbgr.mr_n80014128)
print v(xbgr.mr_n80304880)
print v(xbgr.mr_n81000448)
print v(xbgr.mr_n81088976)
print v(xbgr.mr_n81199344)
print v(xbgr.mr_n81290544)
print v(xbgr.mr_n81420032)
print v(xbgr.mr_n81541248)
print v(xbgr.mr_n81620944)
print v(xbgr.mr_n81746416)
print v(xbgr.mr_n80370368)
print v(xbgr.mr_n80457328)
print v(xbgr.mr_n80684176)
print v(xbgr.mr_n80874816)
print v(xbgr.mr_n80366400)
print v(xbgr.mr_n80454880)
print v(xbgr.mr_n80692720)
print v(xbgr.mr_n80876384)
print v(xbgr.mr_n81837072)
print v(xbgr.mr_n82050464)
print v(xbgr.mr_n82268048)
print v(xbgr.mr_n82030784)
print v(xbgr.mr_n82179808)
print v(xbgr.mr_n82448656)
print v(xbgr.mr_n79658752)
print v(xbgr.mr_n79903648)
print v(xbgr.mr_n79970400)
print v(xbgr.mr_n80307600)
print v(xbgr.mr_n80314144)
print v(xbgr.mr_n80406480)
print v(xbgr.mr_n80516336)
print v(xbgr.mr_n80744832)
print v(xbgr.mr_n79658352)
print v(xbgr.mr_n79904320)
print v(xbgr.mr_n80012816)
print v(xbgr.mr_n80308080)
print v(xbgr.mr_n82036832)
print v(xbgr.mr_n82251376)
print v(xbgr.mr_n82444352)
print v(xbgr.mr_n80369248)
print v(xbgr.mr_n80453776)
print v(xbgr.mr_n80660656)
print v(xbgr.mr_n80876912)
print v(xbgr.mr_n80998800)
print v(xbgr.mr_n81094032)
print v(xbgr.mr_n81216144)
print v(xbgr.mr_n81291424)
print v(xbgr.mr_n81420720)
print v(xbgr.mr_n81542288)
print v(xbgr.mr_n81646176)
print v(xbgr.mr_n81772752)
print v(xbgr.mr_n79650944)
print v(xbgr.mr_n79903136)
print v(xbgr.mr_n79966848)
print v(xbgr.mr_n80308480)
print v(xbgr.mr_n81000272)
print v(xbgr.mr_n81140192)
print v(xbgr.mr_n81198656)
print v(xbgr.mr_n81289440)
print v(xbgr.mr_n81392416)
print v(xbgr.mr_n81545328)
print v(xbgr.mr_n81650144)
print v(xbgr.mr_n81772640)
print v(xbgr.mr_n82032400)
print v(xbgr.mr_n82178624)
print v(xbgr.mr_n82447088)
print v(xbgr.mr_n81836608)
print v(xbgr.mr_n82050000)
print v(xbgr.mr_n82267456)
print v(xbgr.mr_n79657360)
print v(xbgr.mr_n79888352)
print v(xbgr.mr_n80011632)
print v(xbgr.mr_n80306880)
print v(xbgr.mr_n80911152)
print v(xbgr.mr_n81021088)
print v(xbgr.mr_n81149104)
print v(xbgr.mr_n81231104)
print v(xbgr.mr_n81312768)
print v(xbgr.mr_n81438288)
print v(xbgr.mr_n81564592)
print v(xbgr.mr_n81698080)
print v(xbgr.mr_n82039008)
print v(xbgr.mr_n82178032)
print v(xbgr.mr_n82449648)
print v(xbgr.mr_n79656896)
print v(xbgr.mr_n79906032)
print v(xbgr.mr_n79835344)
print v(xbgr.mr_n80309200)
print v(xbgr.mr_n80998000)
print v(xbgr.mr_n81127232)
print v(xbgr.mr_n81215840)
print v(xbgr.mr_n81294208)
print v(xbgr.mr_n81420832)
print v(xbgr.mr_n81546928)
print v(xbgr.mr_n81622128)
print v(xbgr.mr_n81745296)
print v(xbgr.mr_n80369072)
print v(xbgr.mr_n80458896)
print v(xbgr.mr_n80690784)
print v(xbgr.mr_n80874128)
print v(xbgr.mr_n82035216)
print v(xbgr.mr_n82246560)
print v(xbgr.mr_n82380400)
print v(xbgr.mr_n80363424)
print v(xbgr.mr_n80459584)
print v(xbgr.mr_n80689264)
print v(xbgr.mr_n80877952)
print v(xbgr.mr_n79656432)
print v(xbgr.mr_n79906688)
print v(xbgr.mr_n79967376)
print v(xbgr.mr_n80310080)
print v(xbgr.mr_n82036416)
print v(xbgr.mr_n82177440)
print v(xbgr.mr_n82380640)
print v(xbgr.mr_n80313872)
print v(xbgr.mr_n80406288)
print v(xbgr.mr_n80517296)
print v(xbgr.mr_n80743648)
print v(xbgr.mr_n79655968)
print v(xbgr.mr_n79907280)
print v(xbgr.mr_n80084592)
print v(xbgr.mr_n80135760)
print v(xbgr.mr_n81835680)
print v(xbgr.mr_n82049536)
print v(xbgr.mr_n82266368)
print v(xbgr.mr_n82032624)
print v(xbgr.mr_n82176848)
print v(xbgr.mr_n82452032)
print v(xbgr.mr_n80367856)
print v(xbgr.mr_n80450736)
print v(xbgr.mr_n80658944)
print v(xbgr.mr_n80878480)
print v(xbgr.mr_n79655504)
print v(xbgr.mr_n79907872)
print v(xbgr.mr_n80086032)
print v(xbgr.mr_n80149376)
print v(xbgr.mr_n80999296)
print v(xbgr.mr_n81132336)
print v(xbgr.mr_n81198880)
print v(xbgr.mr_n81289856)
print v(xbgr.mr_n81419664)
print v(xbgr.mr_n81544640)
print v(xbgr.mr_n81649792)
print v(xbgr.mr_n81776048)
print v(xbgr.mr_n80993456)
print v(xbgr.mr_n80972352)
print v(xbgr.mr_n81214544)
print v(xbgr.mr_n81295248)
print v(xbgr.mr_n81423200)
print v(xbgr.mr_n81546496)
print v(xbgr.mr_n81645712)
print v(xbgr.mr_n81769344)
print v(xbgr.mr_n82034656)
print v(xbgr.mr_n82249824)
print v(xbgr.mr_n82452208)
print v(xbgr.mr_n79655040)
print v(xbgr.mr_n79908464)
print v(xbgr.mr_n80082400)
print v(xbgr.mr_n80148784)
print v(xbgr.mr_n80910688)
print v(xbgr.mr_n81020624)
print v(xbgr.mr_n81148768)
print v(xbgr.mr_n81230832)
print v(xbgr.mr_n81313584)
print v(xbgr.mr_n81438016)
print v(xbgr.mr_n81564320)
print v(xbgr.mr_n81697808)
print v(xbgr.mr_n82027008)
print v(xbgr.mr_n82174480)
print v(xbgr.mr_n82363504)
print v(xbgr.mr_n79654576)
print v(xbgr.mr_n79891888)
print v(xbgr.mr_n80087632)
print v(xbgr.mr_n80136944)
print v(xbgr.mr_n81835216)
print v(xbgr.mr_n82049072)
print v(xbgr.mr_n82265904)
print v(xbgr.mr_n80998336)
print v(xbgr.mr_n81104576)
print v(xbgr.mr_n81218336)
print v(xbgr.mr_n81288464)
print v(xbgr.mr_n81421824)
print v(xbgr.mr_n81546016)
print v(xbgr.mr_n81621536)
print v(xbgr.mr_n81744640)
print v(xbgr.mr_n80364784)
print v(xbgr.mr_n80460464)
print v(xbgr.mr_n80690176)
print v(xbgr.mr_n80875696)
print v(xbgr.mr_n82029200)
print v(xbgr.mr_n82175664)
print v(xbgr.mr_n82449472)
print v(xbgr.mr_n80368032)
print v(xbgr.mr_n80456976)
print v(xbgr.mr_n80690960)
print v(xbgr.mr_n80879520)
print v(xbgr.mr_n79654112)
print v(xbgr.mr_n79904912)
print v(xbgr.mr_n80070848)
print v(xbgr.mr_n80140496)
print v(xbgr.mr_n80313600)
print v(xbgr.mr_n80404480)
print v(xbgr.mr_n80484640)
print v(xbgr.mr_n80742464)
print v(xbgr.mr_n79653712)
print v(xbgr.mr_n79910304)
print v(xbgr.mr_n80086832)
print v(xbgr.mr_n80146944)
print v(xbgr.mr_n82030112)
print v(xbgr.mr_n82451216)
print v(xbgr.mr_n79643984)
print v(xbgr.mr_n79910832)
print v(xbgr.mr_n80090032)
print v(xbgr.mr_n80131552)
print v(xbgr.mr_n82028016)
print v(xbgr.mr_n82342624)
print v(xbgr.mr_n80362032)
print v(xbgr.mr_n80458480)
print v(xbgr.mr_n80660352)
print v(xbgr.mr_n80880048)
print v(xbgr.mr_n80996128)
print v(xbgr.mr_n81122832)
print v(xbgr.mr_n81217552)
print v(xbgr.mr_n81292544)
print v(xbgr.mr_n81423888)
print v(xbgr.mr_n81542640)
print v(xbgr.mr_n81642336)
print v(xbgr.mr_n81762000)
print v(xbgr.mr_n80994112)
print v(xbgr.mr_n81134928)
print v(xbgr.mr_n81219888)
print v(xbgr.mr_n81297248)
print v(xbgr.mr_n81421328)
print v(xbgr.mr_n81550032)
print v(xbgr.mr_n81650960)
print v(xbgr.mr_n81775632)
print v(xbgr.mr_n81834752)
print v(xbgr.mr_n82265440)
print v(xbgr.mr_n79588608)
print v(xbgr.mr_n79893664)
print v(xbgr.mr_n80090432)
print v(xbgr.mr_n80145824)
print v(xbgr.mr_n82028768)
print v(xbgr.mr_n82446912)
print v(xbgr.mr_n80910224)
print v(xbgr.mr_n81019696)
print v(xbgr.mr_n81148224)
print v(xbgr.mr_n81230288)
print v(xbgr.mr_n81314128)
print v(xbgr.mr_n81437472)
print v(xbgr.mr_n81563776)
print v(xbgr.mr_n81697264)
print v(xbgr.mr_n79647696)
print v(xbgr.mr_n79912016)
print v(xbgr.mr_n80084256)
print v(xbgr.mr_n80145232)
print v(xbgr.mr_n82022032)
print v(xbgr.mr_n82335584)
print v(xbgr.mr_n80995168)
print v(xbgr.mr_n81073904)
print v(xbgr.mr_n81221296)
print v(xbgr.mr_n81298912)
print v(xbgr.mr_n81422832)
print v(xbgr.mr_n81551632)
print v(xbgr.mr_n81597264)
print v(xbgr.mr_n81743520)
print v(xbgr.mr_n80364224)
print v(xbgr.mr_n80462032)
print v(xbgr.mr_n80688240)
print v(xbgr.mr_n80877264)
print v(xbgr.mr_n79651872)
print v(xbgr.mr_n79912608)
print v(xbgr.mr_n80086432)
print v(xbgr.mr_n80144640)
print v(xbgr.mr_n80365968)
print v(xbgr.mr_n80461152)
print v(xbgr.mr_n80686656)
print v(xbgr.mr_n80881088)
print v(xbgr.mr_n82025904)
print v(xbgr.mr_n82348112)
print v(xbgr.mr_n81833824)
print v(xbgr.mr_n82264512)
print v(xbgr.mr_n79651408)
print v(xbgr.mr_n79913200)
print v(xbgr.mr_n80092832)
print v(xbgr.mr_n80144048)
print v(xbgr.mr_n80313328)
print v(xbgr.mr_n80403424)
print v(xbgr.mr_n80478096)
print v(xbgr.mr_n80741280)
print v(xbgr.mr_n82019952)
print v(xbgr.mr_n82350976)
print v(xbgr.mr_n79648624)
print v(xbgr.mr_n79913792)
print v(xbgr.mr_n80093632)
print v(xbgr.mr_n80143456)
print v(xbgr.mr_n80359744)
print v(xbgr.mr_n80461616)
print v(xbgr.mr_n80642336)
print v(xbgr.mr_n80881616)
print v(xbgr.mr_n80993024)
print v(xbgr.mr_n81108160)
print v(xbgr.mr_n81217904)
print v(xbgr.mr_n81294560)
print v(xbgr.mr_n81424000)
print v(xbgr.mr_n81551200)
print v(xbgr.mr_n81643280)
print v(xbgr.mr_n81773456)
print v(xbgr.mr_n82023504)
print v(xbgr.mr_n82368880)
print v(xbgr.mr_n80985072)
print v(xbgr.mr_n81108448)
print v(xbgr.mr_n81222080)
print v(xbgr.mr_n81299952)
print v(xbgr.mr_n81425472)
print v(xbgr.mr_n81552736)
print v(xbgr.mr_n81646064)
print v(xbgr.mr_n81772224)
print v(xbgr.mr_n79650480)
print v(xbgr.mr_n79914384)
print v(xbgr.mr_n80094432)
print v(xbgr.mr_n80142864)
print v(xbgr.mr_n82024064)
print v(xbgr.mr_n82367632)
print v(xbgr.mr_n80909760)
print v(xbgr.mr_n81019232)
print v(xbgr.mr_n81147952)
print v(xbgr.mr_n81230016)
print v(xbgr.mr_n81313856)
print v(xbgr.mr_n81437200)
print v(xbgr.mr_n81563504)
print v(xbgr.mr_n81696992)
print v(xbgr.mr_n79650016)
print v(xbgr.mr_n79905568)
print v(xbgr.mr_n80084000)
print v(xbgr.mr_n80142272)
print v(xbgr.mr_n81833360)
print v(xbgr.mr_n82264048)
print v(xbgr.mr_n82021696)
print v(xbgr.mr_n82452448)
print v(xbgr.mr_n79649552)
print v(xbgr.mr_n79915504)
print v(xbgr.mr_n80096032)
print v(xbgr.mr_n80141680)
print v(xbgr.mr_n80992448)
print v(xbgr.mr_n81096208)
print v(xbgr.mr_n81220512)
print v(xbgr.mr_n81297936)
print v(xbgr.mr_n81426432)
print v(xbgr.mr_n81548912)
print v(xbgr.mr_n81618576)
print v(xbgr.mr_n81736016)
print v(xbgr.mr_n80364112)
print v(xbgr.mr_n80463600)
print v(xbgr.mr_n80687696)
print v(xbgr.mr_n80870992)
print v(xbgr.mr_n80361600)
print v(xbgr.mr_n80462720)
print v(xbgr.mr_n80688416)
print v(xbgr.mr_n80878832)
print v(xbgr.mr_n82020928)
print v(xbgr.mr_n82248736)
print v(xbgr.mr_n82452560)
print v(xbgr.mr_n79649152)
print v(xbgr.mr_n79916160)
print v(xbgr.mr_n80090832)
print v(xbgr.mr_n80141024)
print v(xbgr.mr_n80313056)
print v(xbgr.mr_n80402368)
print v(xbgr.mr_n79820800)
print v(xbgr.mr_n80740096)
print v(xbgr.mr_n82019024)
print v(xbgr.mr_n82175072)
print v(xbgr.mr_n82453248)
print v(xbgr.mr_n79639344)
print v(xbgr.mr_n79916752)
print v(xbgr.mr_n80092032)
print v(xbgr.mr_n80135168)
print v(xbgr.mr_n81832896)
print v(xbgr.mr_n82048608)
print v(xbgr.mr_n82263584)
print v(xbgr.mr_n80356144)
print v(xbgr.mr_n80463184)
print v(xbgr.mr_n80660464)
print v(xbgr.mr_n80880400)
print v(xbgr.mr_n80991840)
print v(xbgr.mr_n81134624)
print v(xbgr.mr_n81218736)
print v(xbgr.mr_n81300832)
print v(xbgr.mr_n81425648)
print v(xbgr.mr_n81549344)
print v(xbgr.mr_n81372448)
print v(xbgr.mr_n81765936)
print v(xbgr.mr_n82016784)
print v(xbgr.mr_n82176256)
print v(xbgr.mr_n82367872)
print v(xbgr.mr_n80990464)
print v(xbgr.mr_n81075728)
print v(xbgr.mr_n81223632)
print v(xbgr.mr_n81295776)
print v(xbgr.mr_n81428432)
print v(xbgr.mr_n81554736)
print v(xbgr.mr_n81646880)
print v(xbgr.mr_n81769232)
print v(xbgr.mr_n79648160)
print v(xbgr.mr_n79917344)
print v(xbgr.mr_n80098432)
print v(xbgr.mr_n80123328)
print v(xbgr.mr_n80909296)
print v(xbgr.mr_n81018304)
print v(xbgr.mr_n81147408)
print v(xbgr.mr_n81229744)
print v(xbgr.mr_n81313312)
print v(xbgr.mr_n81436656)
print v(xbgr.mr_n81562960)
print v(xbgr.mr_n81696448)
print v(xbgr.mr_n79638416)
print v(xbgr.mr_n79917936)
print v(xbgr.mr_n80099760)
print v(xbgr.mr_n80139312)
print v(xbgr.mr_n82014976)
print v(xbgr.mr_n82243840)
print v(xbgr.mr_n82343936)
print v(xbgr.mr_n79647232)
print v(xbgr.mr_n79909712)
print v(xbgr.mr_n80100352)
print v(xbgr.mr_n80138720)
print v(xbgr.mr_n82017344)
print v(xbgr.mr_n82128592)
print v(xbgr.mr_n82452672)
print v(xbgr.mr_n80990640)
print v(xbgr.mr_n81102320)
print v(xbgr.mr_n81223328)
print v(xbgr.mr_n81299264)
print v(xbgr.mr_n81426000)
print v(xbgr.mr_n81554048)
print v(xbgr.mr_n81619760)
print v(xbgr.mr_n81741744)
print v(xbgr.mr_n80363248)
print v(xbgr.mr_n80465168)
print v(xbgr.mr_n80685696)
print v(xbgr.mr_n80872560)
print v(xbgr.mr_n80360416)
print v(xbgr.mr_n80464288)
print v(xbgr.mr_n80687200)
print v(xbgr.mr_n80882656)
print v(xbgr.mr_n81831968)
print v(xbgr.mr_n82048160)
print v(xbgr.mr_n82262656)
print v(xbgr.mr_n79646768)
print v(xbgr.mr_n79919040)
print v(xbgr.mr_n80102128)
print v(xbgr.mr_n80131024)
print v(xbgr.mr_n82013424)
print v(xbgr.mr_n82173296)
print v(xbgr.mr_n82453520)
print v(xbgr.mr_n80312784)
print v(xbgr.mr_n80401312)
print v(xbgr.mr_n80478576)
print v(xbgr.mr_n80738912)
print v(xbgr.mr_n79646304)
print v(xbgr.mr_n79919712)
print v(xbgr.mr_n80103312)
print v(xbgr.mr_n80137536)
print v(xbgr.mr_n82014624)
print v(xbgr.mr_n82247104)
print v(xbgr.mr_n82324288)
print v(xbgr.mr_n80362208)
print v(xbgr.mr_n80458016)
print v(xbgr.mr_n80617760)
print v(xbgr.mr_n80863808)
print v(xbgr.mr_n79645840)
print v(xbgr.mr_n79920304)
print v(xbgr.mr_n80103904)
print v(xbgr.mr_n80126880)
print v(xbgr.mr_n80985952)
print v(xbgr.mr_n81134192)
print v(xbgr.mr_n81221648)
print v(xbgr.mr_n81304656)
print v(xbgr.mr_n81429600)
print v(xbgr.mr_n81552048)
print v(xbgr.mr_n81641552)
print v(xbgr.mr_n81768880)
print v(xbgr.mr_n80984896)
print v(xbgr.mr_n81137584)
print v(xbgr.mr_n81225824)
print v(xbgr.mr_n81303120)
print v(xbgr.mr_n81431136)
print v(xbgr.mr_n81557440)
print v(xbgr.mr_n81642144)
print v(xbgr.mr_n81766640)
print v(xbgr.mr_n82013888)
print v(xbgr.mr_n82172352)
print v(xbgr.mr_n82455040)
print v(xbgr.mr_n81831504)
print v(xbgr.mr_n82047616)
print v(xbgr.mr_n82262192)
print v(xbgr.mr_n79645376)
print v(xbgr.mr_n79920896)
print v(xbgr.mr_n80105088)
print v(xbgr.mr_n80136288)
print v(xbgr.mr_n80908832)
print v(xbgr.mr_n81017840)
print v(xbgr.mr_n81147136)
print v(xbgr.mr_n81229472)
print v(xbgr.mr_n81313040)
print v(xbgr.mr_n81436384)
print v(xbgr.mr_n81562688)
print v(xbgr.mr_n81696176)
print v(xbgr.mr_n82010176)
print v(xbgr.mr_n82173888)
print v(xbgr.mr_n82455648)
print v(xbgr.mr_n79644912)
print v(xbgr.mr_n79921488)
print v(xbgr.mr_n80096832)
print v(xbgr.mr_n80105680)
print v(xbgr.mr_n80986752)
print v(xbgr.mr_n81091536)
print v(xbgr.mr_n81222896)
print v(xbgr.mr_n81296128)
print v(xbgr.mr_n81427312)
print v(xbgr.mr_n81553616)
print v(xbgr.mr_n81619168)
print v(xbgr.mr_n81735840)
print v(xbgr.mr_n80360592)
print v(xbgr.mr_n80466736)
print v(xbgr.mr_n80663296)
print v(xbgr.mr_n80856896)
print v(xbgr.mr_n80345504)
print v(xbgr.mr_n80467424)
print v(xbgr.mr_n80685088)
print v(xbgr.mr_n80861472)
print v(xbgr.mr_n82008080)
print v(xbgr.mr_n82242208)
print v(xbgr.mr_n82369552)
print v(xbgr.mr_n79644512)
print v(xbgr.mr_n79909056)
print v(xbgr.mr_n80098832)
print v(xbgr.mr_n80128656)
print v(xbgr.mr_n82010288)
print v(xbgr.mr_n82172176)
print v(xbgr.mr_n82457152)
print v(xbgr.mr_n80312512)
print v(xbgr.mr_n80400256)
print v(xbgr.mr_n80478464)
print v(xbgr.mr_n80737728)
print v(xbgr.mr_n79591392)
print v(xbgr.mr_n79922608)
print v(xbgr.mr_n80102720)
print v(xbgr.mr_n80134576)
print v(xbgr.mr_n81831040)
print v(xbgr.mr_n82047072)
print v(xbgr.mr_n82261728)
print v(xbgr.mr_n82009328)
print v(xbgr.mr_n82130288)
print v(xbgr.mr_n82455536)
print v(xbgr.mr_n79643520)
print v(xbgr.mr_n79923264)
print v(xbgr.mr_n80101472)
print v(xbgr.mr_n80133984)
print v(xbgr.mr_n80359056)
print v(xbgr.mr_n80460112)
print v(xbgr.mr_n80660240)
print v(xbgr.mr_n80853024)
print v(xbgr.mr_n80984096)
print v(xbgr.mr_n81141840)
print v(xbgr.mr_n81219584)
print v(xbgr.mr_n81305536)
print v(xbgr.mr_n81432016)
print v(xbgr.mr_n81558320)
print v(xbgr.mr_n81635296)
print v(xbgr.mr_n81762528)
print v(xbgr.mr_n80986928)
print v(xbgr.mr_n81097840)
print v(xbgr.mr_n81227376)
print v(xbgr.mr_n81301264)
print v(xbgr.mr_n81427744)
print v(xbgr.mr_n81553264)
print v(xbgr.mr_n81638464)
print v(xbgr.mr_n81770048)
print v(xbgr.mr_n79643056)
print v(xbgr.mr_n79923856)
print v(xbgr.mr_n80092432)
print v(xbgr.mr_n80098032)
print v(xbgr.mr_n82007232)
print v(xbgr.mr_n82245472)
print v(xbgr.mr_n82457760)
print v(xbgr.mr_n80908368)
print v(xbgr.mr_n81016912)
print v(xbgr.mr_n81146592)
print v(xbgr.mr_n81229200)
print v(xbgr.mr_n81312496)
print v(xbgr.mr_n81435840)
print v(xbgr.mr_n81562144)
print v(xbgr.mr_n81695632)
print v(xbgr.mr_n82004304)
print v(xbgr.mr_n82171520)
print v(xbgr.mr_n82460416)
print v(xbgr.mr_n79642592)
print v(xbgr.mr_n79918528)
print v(xbgr.mr_n80099232)
print v(xbgr.mr_n80132800)
print v(xbgr.mr_n81830112)
print v(xbgr.mr_n82046960)
print v(xbgr.mr_n82260800)
print v(xbgr.mr_n80980784)
print v(xbgr.mr_n81104960)
print v(xbgr.mr_n81225040)
print v(xbgr.mr_n81308256)
print v(xbgr.mr_n81431664)
print v(xbgr.mr_n81556400)
print v(xbgr.mr_n81557968)
print v(xbgr.mr_n81691552)
print v(xbgr.mr_n80357680)
print v(xbgr.mr_n80468304)
print v(xbgr.mr_n80683152)
print v(xbgr.mr_n80838704)
print v(xbgr.mr_n80359856)
print v(xbgr.mr_n80464752)
print v(xbgr.mr_n80681632)
print v(xbgr.mr_n80843104)
print v(xbgr.mr_n82008832)
print v(xbgr.mr_n82168624)
print v(xbgr.mr_n82457648)
print v(xbgr.mr_n79642128)
print v(xbgr.mr_n79924960)
print v(xbgr.mr_n80091632)
print v(xbgr.mr_n80132208)
print v(xbgr.mr_n80312240)
print v(xbgr.mr_n80375760)
print v(xbgr.mr_n80515056)
print v(xbgr.mr_n80736544)
print v(xbgr.mr_n79641664)
print v(xbgr.mr_n79914976)
print v(xbgr.mr_n80097632)
print v(xbgr.mr_n80123920)
print v(xbgr.mr_n82006304)
print v(xbgr.mr_n82244928)
print v(xbgr.mr_n82461760)
print v(xbgr.mr_n79641200)
print v(xbgr.mr_n79926288)
print v(xbgr.mr_n80097232)
print v(xbgr.mr_n80100944)
print v(xbgr.mr_n81998336)
print v(xbgr.mr_n82169744)
print v(xbgr.mr_n82463328)
print v(xbgr.mr_n80354320)
print v(xbgr.mr_n80466320)
print v(xbgr.mr_n80660128)
print v(xbgr.mr_n80846896)
print v(xbgr.mr_n80969952)
print v(xbgr.mr_n81109216)
print v(xbgr.mr_n81219152)
print v(xbgr.mr_n81305968)
print v(xbgr.mr_n81426896)
print v(xbgr.mr_n81550720)
print v(xbgr.mr_n81639168)
print v(xbgr.mr_n81765472)
print v(xbgr.mr_n80971440)
print v(xbgr.mr_n81138080)
print v(xbgr.mr_n81224608)
print v(xbgr.mr_n81307824)
print v(xbgr.mr_n81424992)
print v(xbgr.mr_n81555904)
print v(xbgr.mr_n81641440)
print v(xbgr.mr_n81765824)
print v(xbgr.mr_n81829648)
print v(xbgr.mr_n81972576)
print v(xbgr.mr_n82260336)
print v(xbgr.mr_n79640736)
print v(xbgr.mr_n79926816)
print v(xbgr.mr_n80088432)
print v(xbgr.mr_n80130432)
print v(xbgr.mr_n82005600)
print v(xbgr.mr_n82170400)
print v(xbgr.mr_n82464320)
print v(xbgr.mr_n80907904)
print v(xbgr.mr_n81016448)
print v(xbgr.mr_n81146320)
print v(xbgr.mr_n81228928)
print v(xbgr.mr_n81312224)
print v(xbgr.mr_n81435568)
print v(xbgr.mr_n81561872)
print v(xbgr.mr_n81695360)
print v(xbgr.mr_n79640272)
print v(xbgr.mr_n79927408)
print v(xbgr.mr_n80095232)
print v(xbgr.mr_n80129840)
print v(xbgr.mr_n82000512)
print v(xbgr.mr_n82241696)
print v(xbgr.mr_n82461584)
print v(xbgr.mr_n80979264)
print v(xbgr.mr_n81095984)
print v(xbgr.mr_n81222544)
print v(xbgr.mr_n81309824)
print v(xbgr.mr_n81418656)
print v(xbgr.mr_n81547344)
print v(xbgr.mr_n81615104)
print v(xbgr.mr_n81739312)
print v(xbgr.mr_n79639872)
print v(xbgr.mr_n79894848)
print v(xbgr.mr_n80094832)
print v(xbgr.mr_n80129184)
print v(xbgr.mr_n80358880)
print v(xbgr.mr_n80469872)
print v(xbgr.mr_n80682608)
print v(xbgr.mr_n80844448)
print v(xbgr.mr_n80356944)
print v(xbgr.mr_n80470560)
print v(xbgr.mr_n80683328)
print v(xbgr.mr_n80851552)
print v(xbgr.mr_n81989936)
print v(xbgr.mr_n82167968)
print v(xbgr.mr_n82465888)
print v(xbgr.mr_n79636112)
print v(xbgr.mr_n79928592)
print v(xbgr.mr_n80094032)
print v(xbgr.mr_n80081936)
print v(xbgr.mr_n81829184)
print v(xbgr.mr_n81972112)
print v(xbgr.mr_n82259872)
print v(xbgr.mr_n80312128)
print v(xbgr.mr_n80381360)
print v(xbgr.mr_n80510128)
print v(xbgr.mr_n80735360)
print v(xbgr.mr_n82001344)
print v(xbgr.mr_n82165072)
print v(xbgr.mr_n82466880)
print v(xbgr.mr_n79638880)
print v(xbgr.mr_n79929184)
print v(xbgr.mr_n80093232)
print v(xbgr.mr_n80128064)
print v(xbgr.mr_n80342784)
print v(xbgr.mr_n80469456)
print v(xbgr.mr_n80660016)
print v(xbgr.mr_n80836064)
print v(xbgr.mr_n80983056)
print v(xbgr.mr_n81087984)
print v(xbgr.mr_n81216768)
print v(xbgr.mr_n81306656)
print v(xbgr.mr_n81424496)
print v(xbgr.mr_n81548496)
print v(xbgr.mr_n81636960)
print v(xbgr.mr_n81754352)
print v(xbgr.mr_n80982448)
print v(xbgr.mr_n81121760)
print v(xbgr.mr_n81220864)
print v(xbgr.mr_n81303552)
print v(xbgr.mr_n81422480)
print v(xbgr.mr_n81548032)
print v(xbgr.mr_n81506512)
print v(xbgr.mr_n81757664)
print v(xbgr.mr_n82001776)
print v(xbgr.mr_n82243296)
print v(xbgr.mr_n82464144)
print v(xbgr.mr_n79590464)
print v(xbgr.mr_n79928000)
print v(xbgr.mr_n80074400)
print v(xbgr.mr_n80127472)
print v(xbgr.mr_n81991968)
print v(xbgr.mr_n82166192)
print v(xbgr.mr_n82468448)
print v(xbgr.mr_n80907440)
print v(xbgr.mr_n81015520)
print v(xbgr.mr_n81145776)
print v(xbgr.mr_n81228656)
print v(xbgr.mr_n81311680)
print v(xbgr.mr_n81435024)
print v(xbgr.mr_n81561328)
print v(xbgr.mr_n81694896)
print v(xbgr.mr_n79636304)
print v(xbgr.mr_n79925632)
print v(xbgr.mr_n80091232)
print v(xbgr.mr_n80104496)
print v(xbgr.mr_n81828256)
print v(xbgr.mr_n81971648)
print v(xbgr.mr_n82258944)
print v(xbgr.mr_n82000400)
print v(xbgr.mr_n82166848)
print v(xbgr.mr_n82469440)
print v(xbgr.mr_n79505072)
print v(xbgr.mr_n79866752)
print v(xbgr.mr_n80088832)
print v(xbgr.mr_n80126288)
print v(xbgr.mr_n80982880)
print v(xbgr.mr_n81104096)
print v(xbgr.mr_n81215408)
print v(xbgr.mr_n81305184)
print v(xbgr.mr_n81423536)
print v(xbgr.mr_n81544208)
print v(xbgr.mr_n81617392)
print v(xbgr.mr_n81739968)
print v(xbgr.mr_n80356832)
print v(xbgr.mr_n80448784)
print v(xbgr.mr_n80679088)
print v(xbgr.mr_n80844560)
print v(xbgr.mr_n80357504)
print v(xbgr.mr_n80451776)
print v(xbgr.mr_n80682112)
print v(xbgr.mr_n80846784)
print v(xbgr.mr_n79497584)
print v(xbgr.mr_n79866160)
print v(xbgr.mr_n80089632)
print v(xbgr.mr_n80125696)
print v(xbgr.mr_n81996848)
print v(xbgr.mr_n82241344)
print v(xbgr.mr_n82466704)
print v(xbgr.mr_n80312016)
print v(xbgr.mr_n80378496)
print v(xbgr.mr_n80506992)
print v(xbgr.mr_n80734496)
print v(xbgr.mr_n79504144)
print v(xbgr.mr_n79865568)
print v(xbgr.mr_n80089232)
print v(xbgr.mr_n80125104)
print v(xbgr.mr_n81994304)
print v(xbgr.mr_n82164416)
print v(xbgr.mr_n82471008)
print v(xbgr.mr_n81827792)
print v(xbgr.mr_n81971184)
print v(xbgr.mr_n82258480)
print v(xbgr.mr_n80352864)
print v(xbgr.mr_n80441216)
print v(xbgr.mr_n80640288)
print v(xbgr.mr_n80832912)
print v(xbgr.mr_n80981936)
print v(xbgr.mr_n81143440)
print v(xbgr.mr_n81198768)
print v(xbgr.mr_n81301952)
print v(xbgr.mr_n81418000)
print v(xbgr.mr_n81543792)
print v(xbgr.mr_n81638000)
print v(xbgr.mr_n81757088)
print v(xbgr.mr_n79497776)
print v(xbgr.mr_n79865040)
print v(xbgr.mr_n80088032)
print v(xbgr.mr_n80124448)
print v(xbgr.mr_n80981584)
print v(xbgr.mr_n81139360)
print v(xbgr.mr_n81217120)
print v(xbgr.mr_n81300480)
print v(xbgr.mr_n81422304)
print v(xbgr.mr_n81543328)
print v(xbgr.mr_n81638352)
print v(xbgr.mr_n81762416)
print v(xbgr.mr_n81988976)
print v(xbgr.mr_n82161520)
print v(xbgr.mr_n82473568)
print v(xbgr.mr_n79503216)
print v(xbgr.mr_n79799280)
print v(xbgr.mr_n80087232)
print v(xbgr.mr_n80095632)
print v(xbgr.mr_n80906976)
print v(xbgr.mr_n81015056)
print v(xbgr.mr_n81101776)
print v(xbgr.mr_n81228464)
print v(xbgr.mr_n81311408)
print v(xbgr.mr_n81434752)
print v(xbgr.mr_n81561056)
print v(xbgr.mr_n81694784)
print v(xbgr.mr_n81996512)
print v(xbgr.mr_n82234016)
print v(xbgr.mr_n82472000)
print v(xbgr.mr_n79502752)
print v(xbgr.mr_n79863712)
print v(xbgr.mr_n80019520)
print v(xbgr.mr_n80096432)
print v(xbgr.mr_n81995568)
print v(xbgr.mr_n82162640)
print v(xbgr.mr_n82469264)
print v(xbgr.mr_n80979728)
print v(xbgr.mr_n81111904)
print v(xbgr.mr_n81215056)
print v(xbgr.d4)
print v(xbgr.mr_n81420368)
print v(xbgr.mr_n81534880)
print v(xbgr.mr_n81615616)
print v(xbgr.mr_n81736352)
print v(xbgr.mr_n80353648)
print v(xbgr.mr_n80443024)
print v(xbgr.mr_n80680064)
print v(xbgr.mr_n80838480)
print v(xbgr.mr_n80355968)
print v(xbgr.mr_n80444832)
print v(xbgr.mr_n80680784)
print v(xbgr.mr_n80836176)
print v(xbgr.mr_n81827328)
print v(xbgr.mr_n81970720)
print v(xbgr.mr_n82258016)
print v(xbgr.mr_n79502288)
print v(xbgr.mr_n79857280)
print v(xbgr.mr_n80085632)
print v(xbgr.mr_n80122736)
print v(xbgr.mr_n81995744)
print v(xbgr.mr_n82163296)
print v(xbgr.mr_n82474560)
print v(xbgr.mr_n80304080)
print v(xbgr.mr_n80377808)
print v(xbgr.mr_n80510448)
print v(xbgr.mr_n80733696)
print v(xbgr.mr_n79497472)
print v(xbgr.mr_n79856160)
print v(xbgr.mr_n80085232)
print v(xbgr.mr_n80121056)
print v(xbgr.mr_n81989824)
print v(xbgr.mr_n82232064)
print v(xbgr.mr_n82471824)
print v(xbgr.mr_n80354928)
print v(xbgr.mr_n80439408)
print v(xbgr.mr_n80636192)
print v(xbgr.mr_n80827808)
print v(xbgr.mr_n79501360)
print v(xbgr.mr_n79861424)
print v(xbgr.mr_n79969216)
print v(xbgr.mr_n80311600)
print v(xbgr.mr_n80977648)
print v(xbgr.mr_n81131936)
print v(xbgr.mr_n81198544)
print v(xbgr.mr_n81293168)
print v(xbgr.mr_n81410992)
print v(xbgr.mr_n81539152)
print v(xbgr.mr_n81628048)
print v(xbgr.mr_n81757472)
print v(xbgr.mr_n80979904)
print v(xbgr.mr_n81143248)
print v(xbgr.mr_n81199696)
print v(xbgr.mr_n81298416)
print v(xbgr.mr_n81417536)
print v(xbgr.mr_n81541792)
print v(xbgr.mr_n81617984)
print v(xbgr.mr_n81763232)
print v(xbgr.mr_n81987552)
print v(xbgr.mr_n82160992)
print v(xbgr.mr_n82479504)
print v(xbgr.mr_n79497360)
print v(xbgr.mr_n79860240)
print v(xbgr.mr_n79932864)
print v(xbgr.mr_n80307200)
print v(xbgr.mr_n81826640)
print v(xbgr.mr_n81975712)
print v(xbgr.mr_n82257088)
print v(xbgr.mr_n80906512)
print v(xbgr.mr_n81014128)
print v(xbgr.mr_n81101232)
print v(xbgr.mr_n81228352)
print v(xbgr.mr_n81310864)
print v(xbgr.mr_n81434288)
print v(xbgr.mr_n81560592)
print v(xbgr.mr_n81694560)
print v(xbgr.mr_n81992640)
print v(xbgr.mr_n82158672)
print v(xbgr.mr_n82477120)
print v(xbgr.mr_n79500432)
print v(xbgr.mr_n79859648)
print v(xbgr.mr_n79971056)
print v(xbgr.mr_n80308880)
print v(xbgr.mr_n80977472)
print v(xbgr.mr_n81139552)
print v(xbgr.mr_n81212464)
print v(xbgr.mr_n81291856)
print v(xbgr.mr_n81417648)
print v(xbgr.mr_n81537520)
print v(xbgr.mr_n81555424)
print v(xbgr.mr_n81738192)
print v(xbgr.mr_n80338096)
print v(xbgr.mr_n80660928)
print v(xbgr.mr_n80834944)
print v(xbgr.mr_n80354752)
print v(xbgr.mr_n80679568)
print v(xbgr.mr_n80832800)
print v(xbgr.mr_n81991040)
print v(xbgr.mr_n82240320)
print v(xbgr.mr_n82474384)
print v(xbgr.mr_n79498320)
print v(xbgr.mr_n79858464)
print v(xbgr.mr_n79971584)
print v(xbgr.mr_n80310480)
print v(xbgr.mr_n80424816)
print v(xbgr.mr_n80421536)
print v(xbgr.mr_n81986880)
print v(xbgr.mr_n82159600)
print v(xbgr.mr_n82482064)
print v(xbgr.mr_n80310880)
print v(xbgr.mr_n80422160)
print v(xbgr.mr_n80477504)
print v(xbgr.mr_n80706384)
print v(xbgr.mr_n79696368)
print v(xbgr.n_23)
print v(xbgr.mr_n79969744)
print v(xbgr.mr_n80309680)
print v(xbgr.mr_n79840592)
print v(xbgr.mr_n81826336)
print v(xbgr.mr_n81980288)
print v(xbgr.mr_n82256704)
print v(xbgr.mr_n81990048)
print v(xbgr.mr_n82160064)
print v(xbgr.mr_n82479680)
print v(xbgr.n_12)
print v(xbgr.n_25)
print v(xbgr.mr_n79934464)
print v(xbgr.mr_n80303280)
print v(xbgr.mr_n80353472)
print v(xbgr.mr_n80638960)
print v(xbgr.mr_n79485344)
print v(xbgr.mr_n80978528)
print v(xbgr.mr_n81142368)
print v(xbgr.mr_n81209328)
print v(xbgr.mr_n81285968)
print v(xbgr.mr_n81411888)
print v(xbgr.mr_n81535984)
print v(xbgr.mr_n81625680)
print v(xbgr.mr_n81758416)
print v(xbgr.mr_n80975792)
print v(xbgr.mr_n81139168)
print v(xbgr.mr_n81198208)
print v(xbgr.mr_n81293712)
print v(xbgr.mr_n81417152)
print v(xbgr.mr_n81535152)
print v(xbgr.mr_n81637504)
print v(xbgr.mr_n81750624)
print v(xbgr.mr_n79695632)
print v(xbgr.mr_n79797280)
print v(xbgr.mr_n79968560)
print v(xbgr.mr_n80298480)
print v(xbgr.mr_n81988480)
print v(xbgr.mr_n82234240)
print v(xbgr.mr_n82476944)
print v(xbgr.mr_n80906048)
print v(xbgr.mr_n81013744)
print v(xbgr.mr_n81102592)
print v(xbgr.mr_n81225392)
print v(xbgr.mr_n81310672)
print v(xbgr.mr_n81434176)
print v(xbgr.mr_n81560480)
print v(xbgr.mr_n81693152)
print v(xbgr.n_17)
print v(xbgr.n_22)
print v(xbgr.mr_n79932064)
print v(xbgr.mr_n80302480)
print v(xbgr.mr_n81895584)
print v(xbgr.mr_n82158208)
print v(xbgr.mr_n82484624)
print v(xbgr.mr_n81826032)
print v(xbgr.mr_n81257296)
print v(xbgr.mr_n82256400)
print v(xbgr.mr_n80971920)
print v(xbgr.mr_n81093488)
print v(xbgr.mr_n81204320)
print v(xbgr.mr_n81291008)
print v(xbgr.mr_n81408928)
print v(xbgr.mr_n81533696)
print v(xbgr.mr_n81615280)
print v(xbgr.mr_n81692352)
print v(xbgr.mr_n80348080)
print v(xbgr.mr_n80677520)
print v(xbgr.mr_n80823536)
print v(xbgr.n_18)
print v(xbgr.mr_n79795840)
print v(xbgr.mr_n79932464)
print v(xbgr.mr_n80300480)
print v(xbgr.mr_n80353296)
print v(xbgr.mr_n80678240)
print v(xbgr.mr_n80830560)
print v(xbgr.mr_n81983376)
print v(xbgr.mr_n82123168)
print v(xbgr.mr_n82482240)
print v(xbgr.mr_n79625600)
print v(xbgr.mr_n80235664)
print v(xbgr.mr_n79693664)
print v(xbgr.mr_n79795120)
print v(xbgr.mr_n79911424)
print v(xbgr.mr_n80296800)
print v(xbgr.mr_n80291408)
print v(xbgr.mr_n80423760)
print v(xbgr.mr_n80485008)
print v(xbgr.mr_n80708608)
print v(xbgr.mr_n81986192)
print v(xbgr.mr_n82238256)
print v(xbgr.mr_n82476128)
print v(xbgr.mr_n80424704)
print v(xbgr.mr_n79674528)
print v(xbgr.mr_n79794400)
print v(xbgr.mr_n79933664)
print v(xbgr.mr_n80238640)
print v(xbgr.mr_n80340512)
print v(xbgr.mr_n80646432)
print v(xbgr.mr_n80771152)
print v(xbgr.mr_n81976432)
print v(xbgr.mr_n82132208)
print v(xbgr.mr_n82483808)
print v(xbgr.mr_n80971264)
print v(xbgr.mr_n81063568)
print v(xbgr.mr_n81197584)
print v(xbgr.mr_n81287840)
print v(xbgr.mr_n81413952)
print v(xbgr.mr_n81514864)
print v(xbgr.mr_n81627456)
print v(xbgr.mr_n81754176)
print v(xbgr.mr_n80969296)
print v(xbgr.mr_n81057504)
print v(xbgr.mr_n81209920)
print v(xbgr.mr_n81284992)
print v(xbgr.mr_n81415120)
print v(xbgr.mr_n81522848)
print v(xbgr.mr_n81626864)
print v(xbgr.mr_n81756736)
print v(xbgr.mr_n81803024)
print v(xbgr.mr_n82039184)
print v(xbgr.mr_n82252464)
print v(xbgr.mr_n79685664)
print v(xbgr.mr_n79793680)
print v(xbgr.mr_n79964944)
print v(xbgr.mr_n80238384)
print v(xbgr.mr_n81978576)
print v(xbgr.mr_n82132096)
print v(xbgr.mr_n82484800)
print v(xbgr.mr_n80905584)
print v(xbgr.mr_n81001504)
print v(xbgr.mr_n81099344)
print v(xbgr.mr_n81227072)
print v(xbgr.mr_n81302576)
print v(xbgr.mr_n81432448)
print v(xbgr.mr_n81558752)
print v(xbgr.mr_n81693952)
print v(xbgr.mr_n81983040)
print v(xbgr.mr_n82240432)
print v(xbgr.mr_n82478688)
print v(xbgr.mr_n79628624)
print v(xbgr.mr_n80970608)
print v(xbgr.mr_n81057680)
print v(xbgr.mr_n81206752)
print v(xbgr.mr_n81286304)
print v(xbgr.mr_n81402736)
print v(xbgr.mr_n81530080)
print v(xbgr.mr_n81560064)
print v(xbgr.mr_n81688352)
print v(xbgr.mr_n80347776)
print v(xbgr.mr_n80662560)
print v(xbgr.mr_n80827504)
print v(xbgr.mr_n80348832)
print v(xbgr.mr_n80675792)
print v(xbgr.mr_n80827616)
print v(xbgr.mr_n81976608)
print v(xbgr.mr_n82124864)
print v(xbgr.mr_n82486368)
print v(xbgr.mr_n80424592)
print v(xbgr.mr_n81814224)
print v(xbgr.mr_n82036944)
print v(xbgr.mr_n82255728)
print v(xbgr.mr_n80294816)
print v(xbgr.mr_n80405712)
print v(xbgr.mr_n79482528)
print v(xbgr.mr_n80685872)
print v(xbgr.mr_n80405536)
print v(xbgr.mr_n81872672)
print v(xbgr.mr_n82108704)
print v(xbgr.mr_n82487360)
print v(xbgr.mr_n80344752)
print v(xbgr.mr_n80645104)
print v(xbgr.mr_n80824208)
print v(dvbe)
print v(iptat)
print v(pbias)
print v(pcasc)
print v(r4)
print v(vbe)
print v(vdd)
print v(vref)
print v(vdd)-v(vdd)
echo METALLIC_POINT_VOLTAGES_END
echo METALLIC_ALL_NODE_VOLTAGES_BEGIN
print v(xbgr.b1b)
print v(xbgr.c2)
print v(xbgr.d1)
print v(xbgr.d2)
print v(xbgr.d3)
print v(xbgr.d4)
print v(xbgr.d5)
print v(xbgr.det)
print v(dvbe)
print v(iptat)
print v(xbgr.kick)
print v(xbgr.mr_n66362768)
print v(xbgr.mr_n66423440)
print v(xbgr.mr_n66681360)
print v(xbgr.mr_n68868432)
print v(xbgr.mr_n69784304)
print v(xbgr.mr_n69784416)
print v(xbgr.mr_n69784736)
print v(xbgr.mr_n69787344)
print v(xbgr.mr_n69787680)
print v(xbgr.mr_n69787792)
print v(xbgr.mr_n69788112)
print v(xbgr.mr_n69788224)
print v(xbgr.mr_n69788656)
print v(xbgr.mr_n69788896)
print v(xbgr.mr_n69789008)
print v(xbgr.mr_n69789360)
print v(xbgr.mr_n69789680)
print v(xbgr.mr_n69789792)
print v(xbgr.mr_n69790224)
print v(xbgr.mr_n69790544)
print v(xbgr.mr_n69790656)
print v(xbgr.mr_n69791088)
print v(xbgr.mr_n69791408)
print v(xbgr.mr_n69791520)
print v(xbgr.mr_n69791952)
print v(xbgr.mr_n69792272)
print v(xbgr.mr_n69792384)
print v(xbgr.mr_n69792816)
print v(xbgr.mr_n69793136)
print v(xbgr.mr_n69793248)
print v(xbgr.mr_n69793680)
print v(xbgr.mr_n69794000)
print v(xbgr.mr_n69794112)
print v(xbgr.mr_n69794544)
print v(xbgr.mr_n69794864)
print v(xbgr.mr_n69794976)
print v(xbgr.mr_n69795408)
print v(xbgr.mr_n69795728)
print v(xbgr.mr_n69795840)
print v(xbgr.mr_n69796272)
print v(xbgr.mr_n69796592)
print v(xbgr.mr_n69796704)
print v(xbgr.mr_n69797136)
print v(xbgr.mr_n69797456)
print v(xbgr.mr_n69797568)
print v(xbgr.mr_n69798000)
print v(xbgr.mr_n69798320)
print v(xbgr.mr_n69798432)
print v(xbgr.mr_n69798864)
print v(xbgr.mr_n69799184)
print v(xbgr.mr_n69799296)
print v(xbgr.mr_n69799728)
print v(xbgr.mr_n69800048)
print v(xbgr.mr_n69800160)
print v(xbgr.mr_n69800592)
print v(xbgr.mr_n69800912)
print v(xbgr.mr_n69801024)
print v(xbgr.mr_n69801456)
print v(xbgr.mr_n69801776)
print v(xbgr.mr_n69801888)
print v(xbgr.mr_n69802320)
print v(xbgr.mr_n69802640)
print v(xbgr.mr_n69802752)
print v(xbgr.mr_n69803072)
print v(xbgr.mr_n69803184)
print v(xbgr.mr_n69803504)
print v(xbgr.mr_n69803616)
print v(xbgr.mr_n69803936)
print v(xbgr.mr_n69804048)
print v(xbgr.mr_n69804368)
print v(xbgr.mr_n69804480)
print v(xbgr.mr_n69804800)
print v(xbgr.mr_n69804912)
print v(xbgr.mr_n69805232)
print v(xbgr.mr_n69805344)
print v(xbgr.mr_n69805664)
print v(xbgr.mr_n69805776)
print v(xbgr.mr_n69806096)
print v(xbgr.mr_n69806208)
print v(xbgr.mr_n69806528)
print v(xbgr.mr_n69806640)
print v(xbgr.mr_n69806960)
print v(xbgr.mr_n69807072)
print v(xbgr.mr_n69807392)
print v(xbgr.mr_n69807504)
print v(xbgr.mr_n69807824)
print v(xbgr.mr_n69807936)
print v(xbgr.mr_n69808256)
print v(xbgr.mr_n69808368)
print v(xbgr.mr_n69808688)
print v(xbgr.mr_n69808800)
print v(xbgr.mr_n69809120)
print v(xbgr.mr_n69809232)
print v(xbgr.mr_n69809552)
print v(xbgr.mr_n69809664)
print v(xbgr.mr_n69809984)
print v(xbgr.mr_n69810096)
print v(xbgr.mr_n69810416)
print v(xbgr.mr_n69810528)
print v(xbgr.mr_n69810848)
print v(xbgr.mr_n69810960)
print v(xbgr.mr_n69811280)
print v(xbgr.mr_n69811392)
print v(xbgr.mr_n69811712)
print v(xbgr.mr_n69811824)
print v(xbgr.mr_n69812144)
print v(xbgr.mr_n69812256)
print v(xbgr.mr_n69812576)
print v(xbgr.mr_n69812688)
print v(xbgr.mr_n69813008)
print v(xbgr.mr_n69813120)
print v(xbgr.mr_n69813440)
print v(xbgr.mr_n69813552)
print v(xbgr.mr_n69813872)
print v(xbgr.mr_n69813984)
print v(xbgr.mr_n69814304)
print v(xbgr.mr_n69814416)
print v(xbgr.mr_n69814736)
print v(xbgr.mr_n69814848)
print v(xbgr.mr_n69815168)
print v(xbgr.mr_n69815280)
print v(xbgr.mr_n69815600)
print v(xbgr.mr_n69815712)
print v(xbgr.mr_n69816032)
print v(xbgr.mr_n69816144)
print v(xbgr.mr_n69816464)
print v(xbgr.mr_n69816576)
print v(xbgr.mr_n69816896)
print v(xbgr.mr_n69817008)
print v(xbgr.mr_n69817328)
print v(xbgr.mr_n69817440)
print v(xbgr.mr_n69817760)
print v(xbgr.mr_n69817872)
print v(xbgr.mr_n69818192)
print v(xbgr.mr_n69818304)
print v(xbgr.mr_n69818432)
print v(xbgr.mr_n69818544)
print v(xbgr.mr_n69818864)
print v(xbgr.mr_n69818976)
print v(xbgr.mr_n69819296)
print v(xbgr.mr_n69819408)
print v(xbgr.mr_n69819728)
print v(xbgr.mr_n69819840)
print v(xbgr.mr_n69820160)
print v(xbgr.mr_n69820272)
print v(xbgr.mr_n69820592)
print v(xbgr.mr_n69820704)
print v(xbgr.mr_n69821024)
print v(xbgr.mr_n69821136)
print v(xbgr.mr_n69821456)
print v(xbgr.mr_n69821568)
print v(xbgr.mr_n69821888)
print v(xbgr.mr_n69822000)
print v(xbgr.mr_n69822320)
print v(xbgr.mr_n69822432)
print v(xbgr.mr_n69822752)
print v(xbgr.mr_n69822864)
print v(xbgr.mr_n69823184)
print v(xbgr.mr_n69823296)
print v(xbgr.mr_n69823616)
print v(xbgr.mr_n69823728)
print v(xbgr.mr_n69824048)
print v(xbgr.mr_n69824160)
print v(xbgr.mr_n69824480)
print v(xbgr.mr_n69824592)
print v(xbgr.mr_n69824912)
print v(xbgr.mr_n69825024)
print v(xbgr.mr_n69825344)
print v(xbgr.mr_n69825456)
print v(xbgr.mr_n69825776)
print v(xbgr.mr_n69825888)
print v(xbgr.mr_n69826208)
print v(xbgr.mr_n69826320)
print v(xbgr.mr_n69826640)
print v(xbgr.mr_n69826752)
print v(xbgr.mr_n69827072)
print v(xbgr.mr_n69827184)
print v(xbgr.mr_n69827504)
print v(xbgr.mr_n69827616)
print v(xbgr.mr_n69827936)
print v(xbgr.mr_n69828048)
print v(xbgr.mr_n69828368)
print v(xbgr.mr_n69828480)
print v(xbgr.mr_n69828800)
print v(xbgr.mr_n69828912)
print v(xbgr.mr_n69829232)
print v(xbgr.mr_n69829344)
print v(xbgr.mr_n69829664)
print v(xbgr.mr_n69829776)
print v(xbgr.mr_n69830096)
print v(xbgr.mr_n69830208)
print v(xbgr.mr_n69830528)
print v(xbgr.mr_n69830640)
print v(xbgr.mr_n69830960)
print v(xbgr.mr_n69831072)
print v(xbgr.mr_n69831392)
print v(xbgr.mr_n69831504)
print v(xbgr.mr_n69831824)
print v(xbgr.mr_n69831936)
print v(xbgr.mr_n69832256)
print v(xbgr.mr_n69832368)
print v(xbgr.mr_n69832688)
print v(xbgr.mr_n69832800)
print v(xbgr.mr_n69833120)
print v(xbgr.mr_n69833232)
print v(xbgr.mr_n69833552)
print v(xbgr.mr_n69833664)
print v(xbgr.mr_n69833984)
print v(xbgr.mr_n69834096)
print v(xbgr.mr_n69834416)
print v(xbgr.mr_n69834528)
print v(xbgr.mr_n69834848)
print v(xbgr.mr_n69834960)
print v(xbgr.mr_n69835280)
print v(xbgr.mr_n69835392)
print v(xbgr.mr_n69835712)
print v(xbgr.mr_n69835824)
print v(xbgr.mr_n69836144)
print v(xbgr.mr_n69836256)
print v(xbgr.mr_n69836576)
print v(xbgr.mr_n69836688)
print v(xbgr.mr_n69837008)
print v(xbgr.mr_n69837120)
print v(xbgr.mr_n69837440)
print v(xbgr.mr_n69837552)
print v(xbgr.mr_n69837872)
print v(xbgr.mr_n69837984)
print v(xbgr.mr_n69838304)
print v(xbgr.mr_n69838416)
print v(xbgr.mr_n69838736)
print v(xbgr.mr_n69838848)
print v(xbgr.mr_n69839168)
print v(xbgr.mr_n69839280)
print v(xbgr.mr_n69839600)
print v(xbgr.mr_n69839712)
print v(xbgr.mr_n69840032)
print v(xbgr.mr_n69840144)
print v(xbgr.mr_n69840464)
print v(xbgr.mr_n69840576)
print v(xbgr.mr_n69840896)
print v(xbgr.mr_n69841008)
print v(xbgr.mr_n69841328)
print v(xbgr.mr_n69841440)
print v(xbgr.mr_n69841760)
print v(xbgr.mr_n69841872)
print v(xbgr.mr_n69842192)
print v(xbgr.mr_n69842304)
print v(xbgr.mr_n69842624)
print v(xbgr.mr_n69842736)
print v(xbgr.mr_n69843056)
print v(xbgr.mr_n69843168)
print v(xbgr.mr_n69843488)
print v(xbgr.mr_n69843600)
print v(xbgr.mr_n69843920)
print v(xbgr.mr_n69844032)
print v(xbgr.mr_n69844352)
print v(xbgr.mr_n69844464)
print v(xbgr.mr_n69844784)
print v(xbgr.mr_n69844896)
print v(xbgr.mr_n69845216)
print v(xbgr.mr_n69845328)
print v(xbgr.mr_n69845648)
print v(xbgr.mr_n69845760)
print v(xbgr.mr_n69846080)
print v(xbgr.mr_n69846192)
print v(xbgr.mr_n69846512)
print v(xbgr.mr_n69846624)
print v(xbgr.mr_n69846944)
print v(xbgr.mr_n69847056)
print v(xbgr.mr_n69847376)
print v(xbgr.mr_n69847488)
print v(xbgr.mr_n69847808)
print v(xbgr.mr_n69847920)
print v(xbgr.mr_n69848240)
print v(xbgr.mr_n69848352)
print v(xbgr.mr_n69848672)
print v(xbgr.mr_n69848784)
print v(xbgr.mr_n69849104)
print v(xbgr.mr_n69849216)
print v(xbgr.mr_n69849536)
print v(xbgr.mr_n69849648)
print v(xbgr.mr_n69849968)
print v(xbgr.mr_n69850080)
print v(xbgr.mr_n69850400)
print v(xbgr.mr_n69850512)
print v(xbgr.mr_n69850832)
print v(xbgr.mr_n69850944)
print v(xbgr.mr_n69851264)
print v(xbgr.mr_n69851376)
print v(xbgr.mr_n69851696)
print v(xbgr.mr_n69851808)
print v(xbgr.mr_n69852128)
print v(xbgr.mr_n69852240)
print v(xbgr.mr_n69852560)
print v(xbgr.mr_n69852672)
print v(xbgr.mr_n69852992)
print v(xbgr.mr_n69853104)
print v(xbgr.mr_n69853424)
print v(xbgr.mr_n69853536)
print v(xbgr.mr_n69853856)
print v(xbgr.mr_n69853968)
print v(xbgr.mr_n69854512)
print v(xbgr.mr_n69854624)
print v(xbgr.mr_n69854944)
print v(xbgr.mr_n69855056)
print v(xbgr.mr_n69855376)
print v(xbgr.mr_n69855488)
print v(xbgr.mr_n69855808)
print v(xbgr.mr_n69855920)
print v(xbgr.mr_n69856240)
print v(xbgr.mr_n69856352)
print v(xbgr.mr_n69856672)
print v(xbgr.mr_n69856784)
print v(xbgr.mr_n69857104)
print v(xbgr.mr_n69857216)
print v(xbgr.mr_n69857536)
print v(xbgr.mr_n69857648)
print v(xbgr.mr_n69857968)
print v(xbgr.mr_n69858080)
print v(xbgr.mr_n69858400)
print v(xbgr.mr_n69858512)
print v(xbgr.mr_n69858832)
print v(xbgr.mr_n69858944)
print v(xbgr.mr_n69859264)
print v(xbgr.mr_n69859376)
print v(xbgr.mr_n69859696)
print v(xbgr.mr_n69859808)
print v(xbgr.mr_n69860128)
print v(xbgr.mr_n69860240)
print v(xbgr.mr_n69860560)
print v(xbgr.mr_n69860672)
print v(xbgr.mr_n69860992)
print v(xbgr.mr_n69861104)
print v(xbgr.mr_n69861424)
print v(xbgr.mr_n69861536)
print v(xbgr.mr_n69861856)
print v(xbgr.mr_n69861968)
print v(xbgr.mr_n69862288)
print v(xbgr.mr_n69862400)
print v(xbgr.mr_n69862720)
print v(xbgr.mr_n69862832)
print v(xbgr.mr_n69863152)
print v(xbgr.mr_n69863264)
print v(xbgr.mr_n69863584)
print v(xbgr.mr_n69863696)
print v(xbgr.mr_n69864016)
print v(xbgr.mr_n69864128)
print v(xbgr.mr_n69864448)
print v(xbgr.mr_n69864560)
print v(xbgr.mr_n69864880)
print v(xbgr.mr_n69864992)
print v(xbgr.mr_n69865312)
print v(xbgr.mr_n69865424)
print v(xbgr.mr_n69865744)
print v(xbgr.mr_n69865856)
print v(xbgr.mr_n69866176)
print v(xbgr.mr_n69866288)
print v(xbgr.mr_n69866608)
print v(xbgr.mr_n69866720)
print v(xbgr.mr_n69867040)
print v(xbgr.mr_n69867152)
print v(xbgr.mr_n69867472)
print v(xbgr.mr_n69867584)
print v(xbgr.mr_n69867904)
print v(xbgr.mr_n69868016)
print v(xbgr.mr_n69868336)
print v(xbgr.mr_n69868448)
print v(xbgr.mr_n69868768)
print v(xbgr.mr_n69868880)
print v(xbgr.mr_n69869200)
print v(xbgr.mr_n69869312)
print v(xbgr.mr_n69869632)
print v(xbgr.mr_n69869744)
print v(xbgr.mr_n69870064)
print v(xbgr.mr_n69870176)
print v(xbgr.mr_n69870496)
print v(xbgr.mr_n69870608)
print v(xbgr.mr_n69870928)
print v(xbgr.mr_n69871040)
print v(xbgr.mr_n69871360)
print v(xbgr.mr_n69871472)
print v(xbgr.mr_n69871792)
print v(xbgr.mr_n69871904)
print v(xbgr.mr_n69872224)
print v(xbgr.mr_n69872336)
print v(xbgr.mr_n69872656)
print v(xbgr.mr_n69872768)
print v(xbgr.mr_n69873088)
print v(xbgr.mr_n69873200)
print v(xbgr.mr_n69873520)
print v(xbgr.mr_n69873632)
print v(xbgr.mr_n69873952)
print v(xbgr.mr_n69874064)
print v(xbgr.mr_n69874384)
print v(xbgr.mr_n69874496)
print v(xbgr.mr_n69874816)
print v(xbgr.mr_n69874928)
print v(xbgr.mr_n69875248)
print v(xbgr.mr_n69875360)
print v(xbgr.mr_n69875680)
print v(xbgr.mr_n69875792)
print v(xbgr.mr_n69876112)
print v(xbgr.mr_n69876224)
print v(xbgr.mr_n69876544)
print v(xbgr.mr_n69876656)
print v(xbgr.mr_n69876976)
print v(xbgr.mr_n69877088)
print v(xbgr.mr_n69877408)
print v(xbgr.mr_n69877520)
print v(xbgr.mr_n69877840)
print v(xbgr.mr_n69877952)
print v(xbgr.mr_n69878272)
print v(xbgr.mr_n69878384)
print v(xbgr.mr_n69878704)
print v(xbgr.mr_n69878816)
print v(xbgr.mr_n69879136)
print v(xbgr.mr_n69879248)
print v(xbgr.mr_n69879568)
print v(xbgr.mr_n69879680)
print v(xbgr.mr_n69880000)
print v(xbgr.mr_n69880112)
print v(xbgr.mr_n69880432)
print v(xbgr.mr_n69880544)
print v(xbgr.mr_n69880864)
print v(xbgr.mr_n69880976)
print v(xbgr.mr_n69881296)
print v(xbgr.mr_n69881408)
print v(xbgr.mr_n69881728)
print v(xbgr.mr_n69881840)
print v(xbgr.mr_n69882160)
print v(xbgr.mr_n69882272)
print v(xbgr.mr_n69882592)
print v(xbgr.mr_n69882704)
print v(xbgr.mr_n69883024)
print v(xbgr.mr_n69883136)
print v(xbgr.mr_n69883456)
print v(xbgr.mr_n69883568)
print v(xbgr.mr_n69883888)
print v(xbgr.mr_n69884000)
print v(xbgr.mr_n69884320)
print v(xbgr.mr_n69884432)
print v(xbgr.mr_n69884752)
print v(xbgr.mr_n69884864)
print v(xbgr.mr_n69885184)
print v(xbgr.mr_n69885296)
print v(xbgr.mr_n69885616)
print v(xbgr.mr_n69885728)
print v(xbgr.mr_n69886048)
print v(xbgr.mr_n69886160)
print v(xbgr.mr_n69886480)
print v(xbgr.mr_n69886592)
print v(xbgr.mr_n69886912)
print v(xbgr.mr_n69887024)
print v(xbgr.mr_n69887344)
print v(xbgr.mr_n69887456)
print v(xbgr.mr_n69887776)
print v(xbgr.mr_n69887888)
print v(xbgr.mr_n69888208)
print v(xbgr.mr_n69888320)
print v(xbgr.mr_n69888640)
print v(xbgr.mr_n69888752)
print v(xbgr.mr_n69889072)
print v(xbgr.mr_n69889184)
print v(xbgr.mr_n69889504)
print v(xbgr.mr_n69889616)
print v(xbgr.mr_n69889936)
print v(xbgr.mr_n69890048)
print v(xbgr.mr_n69890368)
print v(xbgr.mr_n69890480)
print v(xbgr.mr_n69890800)
print v(xbgr.mr_n69890912)
print v(xbgr.mr_n69891232)
print v(xbgr.mr_n69891344)
print v(xbgr.mr_n69891664)
print v(xbgr.mr_n69891776)
print v(xbgr.mr_n69892096)
print v(xbgr.mr_n69892208)
print v(xbgr.mr_n69892528)
print v(xbgr.mr_n69892640)
print v(xbgr.mr_n69892960)
print v(xbgr.mr_n69893072)
print v(xbgr.mr_n69893392)
print v(xbgr.mr_n69893504)
print v(xbgr.mr_n69893824)
print v(xbgr.mr_n69893936)
print v(xbgr.mr_n69894256)
print v(xbgr.mr_n69894368)
print v(xbgr.mr_n69894688)
print v(xbgr.mr_n69894800)
print v(xbgr.mr_n69895120)
print v(xbgr.mr_n69895232)
print v(xbgr.mr_n69895552)
print v(xbgr.mr_n69895664)
print v(xbgr.mr_n69895984)
print v(xbgr.mr_n69896096)
print v(xbgr.mr_n69896416)
print v(xbgr.mr_n69896528)
print v(xbgr.mr_n69896848)
print v(xbgr.mr_n69896960)
print v(xbgr.mr_n69897280)
print v(xbgr.mr_n69897392)
print v(xbgr.mr_n69897712)
print v(xbgr.mr_n69897824)
print v(xbgr.mr_n69898144)
print v(xbgr.mr_n69898256)
print v(xbgr.mr_n69898576)
print v(xbgr.mr_n69898688)
print v(xbgr.mr_n69899008)
print v(xbgr.mr_n69899120)
print v(xbgr.mr_n69899440)
print v(xbgr.mr_n69899552)
print v(xbgr.mr_n69899872)
print v(xbgr.mr_n69899984)
print v(xbgr.mr_n69900304)
print v(xbgr.mr_n69900416)
print v(xbgr.mr_n69900736)
print v(xbgr.mr_n69900848)
print v(xbgr.mr_n69901168)
print v(xbgr.mr_n69901280)
print v(xbgr.mr_n69901600)
print v(xbgr.mr_n69901712)
print v(xbgr.mr_n69902032)
print v(xbgr.mr_n69902144)
print v(xbgr.mr_n69902464)
print v(xbgr.mr_n69902576)
print v(xbgr.mr_n69902896)
print v(xbgr.mr_n69903008)
print v(xbgr.mr_n69903328)
print v(xbgr.mr_n69903440)
print v(xbgr.mr_n69903760)
print v(xbgr.mr_n69903872)
print v(xbgr.mr_n69904192)
print v(xbgr.mr_n69904304)
print v(xbgr.mr_n69904624)
print v(xbgr.mr_n69904736)
print v(xbgr.mr_n69905056)
print v(xbgr.mr_n69905168)
print v(xbgr.mr_n69905488)
print v(xbgr.mr_n69905600)
print v(xbgr.mr_n69905920)
print v(xbgr.mr_n69906032)
print v(xbgr.mr_n69906352)
print v(xbgr.mr_n69906464)
print v(xbgr.mr_n69906784)
print v(xbgr.mr_n69906896)
print v(xbgr.mr_n69907216)
print v(xbgr.mr_n69907328)
print v(xbgr.mr_n69907648)
print v(xbgr.mr_n69907760)
print v(xbgr.mr_n69908080)
print v(xbgr.mr_n69908192)
print v(xbgr.mr_n69908512)
print v(xbgr.mr_n69908624)
print v(xbgr.mr_n69908944)
print v(xbgr.mr_n69909056)
print v(xbgr.mr_n69909376)
print v(xbgr.mr_n69909488)
print v(xbgr.mr_n69909808)
print v(xbgr.mr_n69909920)
print v(xbgr.mr_n69910240)
print v(xbgr.mr_n69910352)
print v(xbgr.mr_n69910672)
print v(xbgr.mr_n69910784)
print v(xbgr.mr_n69911104)
print v(xbgr.mr_n69911216)
print v(xbgr.mr_n69911536)
print v(xbgr.mr_n69911648)
print v(xbgr.mr_n69911968)
print v(xbgr.mr_n69912080)
print v(xbgr.mr_n69912400)
print v(xbgr.mr_n69912512)
print v(xbgr.mr_n69912832)
print v(xbgr.mr_n69912944)
print v(xbgr.mr_n69913264)
print v(xbgr.mr_n69913376)
print v(xbgr.mr_n69913696)
print v(xbgr.mr_n69913808)
print v(xbgr.mr_n69914128)
print v(xbgr.mr_n69914240)
print v(xbgr.mr_n69914560)
print v(xbgr.mr_n69914672)
print v(xbgr.mr_n69914992)
print v(xbgr.mr_n69915104)
print v(xbgr.mr_n69915424)
print v(xbgr.mr_n69915536)
print v(xbgr.mr_n69915856)
print v(xbgr.mr_n69915968)
print v(xbgr.mr_n69916288)
print v(xbgr.mr_n69916400)
print v(xbgr.mr_n69916720)
print v(xbgr.mr_n69916832)
print v(xbgr.mr_n69917152)
print v(xbgr.mr_n69917264)
print v(xbgr.mr_n69917584)
print v(xbgr.mr_n69917696)
print v(xbgr.mr_n69918016)
print v(xbgr.mr_n69918128)
print v(xbgr.mr_n69918448)
print v(xbgr.mr_n69918560)
print v(xbgr.mr_n69918880)
print v(xbgr.mr_n69918992)
print v(xbgr.mr_n69919312)
print v(xbgr.mr_n69919424)
print v(xbgr.mr_n69919744)
print v(xbgr.mr_n69919856)
print v(xbgr.mr_n69920176)
print v(xbgr.mr_n69920288)
print v(xbgr.mr_n69920608)
print v(xbgr.mr_n69920720)
print v(xbgr.mr_n69921040)
print v(xbgr.mr_n69921152)
print v(xbgr.mr_n69921472)
print v(xbgr.mr_n69921584)
print v(xbgr.mr_n69921904)
print v(xbgr.mr_n69922016)
print v(xbgr.mr_n69922336)
print v(xbgr.mr_n69922448)
print v(xbgr.mr_n69922768)
print v(xbgr.mr_n69922880)
print v(xbgr.mr_n69923200)
print v(xbgr.mr_n69923312)
print v(xbgr.mr_n69923632)
print v(xbgr.mr_n69923744)
print v(xbgr.mr_n69924064)
print v(xbgr.mr_n69924176)
print v(xbgr.mr_n69924496)
print v(xbgr.mr_n69924608)
print v(xbgr.mr_n69924928)
print v(xbgr.mr_n69925040)
print v(xbgr.mr_n69925360)
print v(xbgr.mr_n69925472)
print v(xbgr.mr_n69925792)
print v(xbgr.mr_n69925904)
print v(xbgr.mr_n69926224)
print v(xbgr.mr_n69926336)
print v(xbgr.mr_n69926656)
print v(xbgr.mr_n69926768)
print v(xbgr.mr_n69927088)
print v(xbgr.mr_n69927200)
print v(xbgr.mr_n69927520)
print v(xbgr.mr_n69927632)
print v(xbgr.mr_n69927952)
print v(xbgr.mr_n69928064)
print v(xbgr.mr_n69928384)
print v(xbgr.mr_n69928496)
print v(xbgr.mr_n69928816)
print v(xbgr.mr_n69928928)
print v(xbgr.mr_n69929248)
print v(xbgr.mr_n69929360)
print v(xbgr.mr_n69929680)
print v(xbgr.mr_n69929792)
print v(xbgr.mr_n69930112)
print v(xbgr.mr_n69930224)
print v(xbgr.mr_n69930544)
print v(xbgr.mr_n69930656)
print v(xbgr.mr_n69930976)
print v(xbgr.mr_n69931088)
print v(xbgr.mr_n69931408)
print v(xbgr.mr_n69931520)
print v(xbgr.mr_n69931840)
print v(xbgr.mr_n69931952)
print v(xbgr.mr_n69932272)
print v(xbgr.mr_n69932384)
print v(xbgr.mr_n69932704)
print v(xbgr.mr_n69932816)
print v(xbgr.mr_n69933136)
print v(xbgr.mr_n69933248)
print v(xbgr.mr_n69933568)
print v(xbgr.mr_n69933680)
print v(xbgr.mr_n69934000)
print v(xbgr.mr_n69934112)
print v(xbgr.mr_n69934432)
print v(xbgr.mr_n69934544)
print v(xbgr.mr_n69934864)
print v(xbgr.mr_n69934976)
print v(xbgr.mr_n69935296)
print v(xbgr.mr_n69935408)
print v(xbgr.mr_n69935728)
print v(xbgr.mr_n69935840)
print v(xbgr.mr_n69936160)
print v(xbgr.mr_n69936272)
print v(xbgr.mr_n69936592)
print v(xbgr.mr_n69936704)
print v(xbgr.mr_n69937024)
print v(xbgr.mr_n69937136)
print v(xbgr.mr_n69937456)
print v(xbgr.mr_n69937568)
print v(xbgr.mr_n69937888)
print v(xbgr.mr_n69938000)
print v(xbgr.mr_n69938320)
print v(xbgr.mr_n69938432)
print v(xbgr.mr_n69938752)
print v(xbgr.mr_n69938864)
print v(xbgr.mr_n69939184)
print v(xbgr.mr_n69939296)
print v(xbgr.mr_n69939616)
print v(xbgr.mr_n69939728)
print v(xbgr.mr_n69940048)
print v(xbgr.mr_n69940160)
print v(xbgr.mr_n69940480)
print v(xbgr.mr_n69940592)
print v(xbgr.mr_n69940912)
print v(xbgr.mr_n69941024)
print v(xbgr.mr_n69941344)
print v(xbgr.mr_n69941456)
print v(xbgr.mr_n69941776)
print v(xbgr.mr_n69941888)
print v(xbgr.mr_n69942208)
print v(xbgr.mr_n69942320)
print v(xbgr.mr_n69942640)
print v(xbgr.mr_n69942752)
print v(xbgr.mr_n69943072)
print v(xbgr.mr_n69943184)
print v(xbgr.mr_n69943504)
print v(xbgr.mr_n69943616)
print v(xbgr.mr_n69943936)
print v(xbgr.mr_n69944048)
print v(xbgr.mr_n69944368)
print v(xbgr.mr_n69944480)
print v(xbgr.mr_n69944800)
print v(xbgr.mr_n69944912)
print v(xbgr.mr_n69945232)
print v(xbgr.mr_n69945344)
print v(xbgr.mr_n69945664)
print v(xbgr.mr_n69945776)
print v(xbgr.mr_n69946096)
print v(xbgr.mr_n69946208)
print v(xbgr.mr_n69946528)
print v(xbgr.mr_n69946640)
print v(xbgr.mr_n69946960)
print v(xbgr.mr_n69947072)
print v(xbgr.mr_n69947392)
print v(xbgr.mr_n69947504)
print v(xbgr.mr_n69947824)
print v(xbgr.mr_n69947936)
print v(xbgr.mr_n69948256)
print v(xbgr.mr_n69948368)
print v(xbgr.mr_n69948688)
print v(xbgr.mr_n69948800)
print v(xbgr.mr_n69949120)
print v(xbgr.mr_n69949232)
print v(xbgr.mr_n69949552)
print v(xbgr.mr_n69949664)
print v(xbgr.mr_n69949984)
print v(xbgr.mr_n69950096)
print v(xbgr.mr_n69950416)
print v(xbgr.mr_n69950528)
print v(xbgr.mr_n69950848)
print v(xbgr.mr_n69950960)
print v(xbgr.mr_n69951280)
print v(xbgr.mr_n69951392)
print v(xbgr.mr_n69951712)
print v(xbgr.mr_n69951824)
print v(xbgr.mr_n69952144)
print v(xbgr.mr_n69952256)
print v(xbgr.mr_n69952576)
print v(xbgr.mr_n69952688)
print v(xbgr.mr_n70957280)
print v(xbgr.mr_n70957392)
print v(xbgr.mr_n70957648)
print v(xbgr.mr_n70957760)
print v(xbgr.mr_n70958016)
print v(xbgr.mr_n70958128)
print v(xbgr.mr_n70958384)
print v(xbgr.mr_n70958496)
print v(xbgr.mr_n70958752)
print v(xbgr.mr_n70958864)
print v(xbgr.mr_n70959120)
print v(xbgr.mr_n70959232)
print v(xbgr.mr_n70959488)
print v(xbgr.mr_n70959600)
print v(xbgr.mr_n70959888)
print v(xbgr.mr_n70960000)
print v(xbgr.mr_n70960320)
print v(xbgr.mr_n70960432)
print v(xbgr.mr_n70960752)
print v(xbgr.mr_n70960864)
print v(xbgr.mr_n70961184)
print v(xbgr.mr_n70961296)
print v(xbgr.mr_n70961616)
print v(xbgr.mr_n70961728)
print v(xbgr.mr_n70962048)
print v(xbgr.mr_n70962160)
print v(xbgr.mr_n70962480)
print v(xbgr.mr_n70962592)
print v(xbgr.mr_n70962912)
print v(xbgr.mr_n70963024)
print v(xbgr.mr_n70963344)
print v(xbgr.mr_n70963456)
print v(xbgr.mr_n70963776)
print v(xbgr.mr_n70963888)
print v(xbgr.mr_n70964208)
print v(xbgr.mr_n70964320)
print v(xbgr.mr_n70964640)
print v(xbgr.mr_n70964752)
print v(xbgr.mr_n70965072)
print v(xbgr.mr_n70965184)
print v(xbgr.mr_n70965504)
print v(xbgr.mr_n70965616)
print v(xbgr.mr_n70965936)
print v(xbgr.mr_n70966048)
print v(xbgr.mr_n70966368)
print v(xbgr.mr_n70966480)
print v(xbgr.mr_n70966800)
print v(xbgr.mr_n70966912)
print v(xbgr.mr_n70967232)
print v(xbgr.mr_n70967344)
print v(xbgr.mr_n70967664)
print v(xbgr.mr_n70967776)
print v(xbgr.mr_n70968096)
print v(xbgr.mr_n70968208)
print v(xbgr.mr_n70968528)
print v(xbgr.mr_n70968640)
print v(xbgr.mr_n70968960)
print v(xbgr.mr_n70969072)
print v(xbgr.mr_n70969392)
print v(xbgr.mr_n70969504)
print v(xbgr.mr_n70969824)
print v(xbgr.mr_n70969936)
print v(xbgr.mr_n70970256)
print v(xbgr.mr_n70970368)
print v(xbgr.mr_n70970688)
print v(xbgr.mr_n70970800)
print v(xbgr.mr_n70971120)
print v(xbgr.mr_n70971232)
print v(xbgr.mr_n70971552)
print v(xbgr.mr_n70971664)
print v(xbgr.mr_n70971984)
print v(xbgr.mr_n70972096)
print v(xbgr.mr_n70972416)
print v(xbgr.mr_n70972528)
print v(xbgr.mr_n70972848)
print v(xbgr.mr_n70972960)
print v(xbgr.mr_n70973280)
print v(xbgr.mr_n70973392)
print v(xbgr.mr_n70973712)
print v(xbgr.mr_n70973824)
print v(xbgr.mr_n70974144)
print v(xbgr.mr_n70974256)
print v(xbgr.mr_n70974576)
print v(xbgr.mr_n70974688)
print v(xbgr.mr_n70975008)
print v(xbgr.mr_n70975120)
print v(xbgr.mr_n70975440)
print v(xbgr.mr_n70975552)
print v(xbgr.mr_n70975872)
print v(xbgr.mr_n70975984)
print v(xbgr.mr_n70976304)
print v(xbgr.mr_n70976416)
print v(xbgr.mr_n70976736)
print v(xbgr.mr_n70976848)
print v(xbgr.mr_n70977168)
print v(xbgr.mr_n70977280)
print v(xbgr.mr_n70977600)
print v(xbgr.mr_n70977712)
print v(xbgr.mr_n70978032)
print v(xbgr.mr_n70978144)
print v(xbgr.mr_n70978464)
print v(xbgr.mr_n70978576)
print v(xbgr.mr_n70978896)
print v(xbgr.mr_n70979008)
print v(xbgr.mr_n70979328)
print v(xbgr.mr_n70979440)
print v(xbgr.mr_n70979760)
print v(xbgr.mr_n70979872)
print v(xbgr.mr_n70980192)
print v(xbgr.mr_n70980304)
print v(xbgr.mr_n70980624)
print v(xbgr.mr_n70980736)
print v(xbgr.mr_n70981056)
print v(xbgr.mr_n70981168)
print v(xbgr.mr_n70981488)
print v(xbgr.mr_n70981600)
print v(xbgr.mr_n70981920)
print v(xbgr.mr_n70982032)
print v(xbgr.mr_n70982352)
print v(xbgr.mr_n70982464)
print v(xbgr.mr_n70982784)
print v(xbgr.mr_n70982896)
print v(xbgr.mr_n70983216)
print v(xbgr.mr_n70983328)
print v(xbgr.mr_n70983648)
print v(xbgr.mr_n70983760)
print v(xbgr.mr_n70984080)
print v(xbgr.mr_n70984192)
print v(xbgr.mr_n70984512)
print v(xbgr.mr_n70984624)
print v(xbgr.mr_n70984944)
print v(xbgr.mr_n70985056)
print v(xbgr.mr_n70985376)
print v(xbgr.mr_n70985488)
print v(xbgr.mr_n70985808)
print v(xbgr.mr_n70985920)
print v(xbgr.mr_n70986240)
print v(xbgr.mr_n70986352)
print v(xbgr.mr_n70986672)
print v(xbgr.mr_n70986784)
print v(xbgr.mr_n70987104)
print v(xbgr.mr_n70987216)
print v(xbgr.mr_n70987536)
print v(xbgr.mr_n70987648)
print v(xbgr.mr_n70987968)
print v(xbgr.mr_n70988080)
print v(xbgr.mr_n70988400)
print v(xbgr.mr_n70988512)
print v(xbgr.mr_n70988832)
print v(xbgr.mr_n70988944)
print v(xbgr.mr_n70989264)
print v(xbgr.mr_n70989376)
print v(xbgr.mr_n70989696)
print v(xbgr.mr_n70989808)
print v(xbgr.mr_n70990128)
print v(xbgr.mr_n70990240)
print v(xbgr.mr_n70990560)
print v(xbgr.mr_n70990672)
print v(xbgr.mr_n70990992)
print v(xbgr.mr_n70991104)
print v(xbgr.mr_n70991424)
print v(xbgr.mr_n70991536)
print v(xbgr.mr_n70991856)
print v(xbgr.mr_n70991968)
print v(xbgr.mr_n70992288)
print v(xbgr.mr_n70992400)
print v(xbgr.mr_n70992720)
print v(xbgr.mr_n70992832)
print v(xbgr.mr_n70993152)
print v(xbgr.mr_n70993264)
print v(xbgr.mr_n70993584)
print v(xbgr.mr_n70993696)
print v(xbgr.mr_n70994016)
print v(xbgr.mr_n70994128)
print v(xbgr.mr_n70994448)
print v(xbgr.mr_n70994560)
print v(xbgr.mr_n70994880)
print v(xbgr.mr_n70994992)
print v(xbgr.mr_n70995312)
print v(xbgr.mr_n70995424)
print v(xbgr.mr_n70995744)
print v(xbgr.mr_n70995856)
print v(xbgr.mr_n70996176)
print v(xbgr.mr_n70996288)
print v(xbgr.mr_n70996608)
print v(xbgr.mr_n70996720)
print v(xbgr.mr_n70997040)
print v(xbgr.mr_n70997152)
print v(xbgr.mr_n70997472)
print v(xbgr.mr_n70997584)
print v(xbgr.mr_n70997904)
print v(xbgr.mr_n70998016)
print v(xbgr.mr_n70998336)
print v(xbgr.mr_n70998448)
print v(xbgr.mr_n70998768)
print v(xbgr.mr_n70998880)
print v(xbgr.mr_n70999200)
print v(xbgr.mr_n70999312)
print v(xbgr.mr_n70999632)
print v(xbgr.mr_n70999744)
print v(xbgr.mr_n71000064)
print v(xbgr.mr_n71000176)
print v(xbgr.mr_n71000496)
print v(xbgr.mr_n71000608)
print v(xbgr.mr_n71000928)
print v(xbgr.mr_n71001040)
print v(xbgr.mr_n71001360)
print v(xbgr.mr_n71001472)
print v(xbgr.mr_n71001792)
print v(xbgr.mr_n71001904)
print v(xbgr.mr_n71002224)
print v(xbgr.mr_n71002336)
print v(xbgr.mr_n71002656)
print v(xbgr.mr_n71002768)
print v(xbgr.mr_n71003088)
print v(xbgr.mr_n71003200)
print v(xbgr.mr_n71003520)
print v(xbgr.mr_n71003632)
print v(xbgr.mr_n71003952)
print v(xbgr.mr_n71004064)
print v(xbgr.mr_n71004384)
print v(xbgr.mr_n71004496)
print v(xbgr.mr_n71004816)
print v(xbgr.mr_n71004928)
print v(xbgr.mr_n71005248)
print v(xbgr.mr_n71005360)
print v(xbgr.mr_n71005680)
print v(xbgr.mr_n71005792)
print v(xbgr.mr_n71006112)
print v(xbgr.mr_n71006224)
print v(xbgr.mr_n71006544)
print v(xbgr.mr_n71006656)
print v(xbgr.mr_n71006976)
print v(xbgr.mr_n71007088)
print v(xbgr.mr_n71007408)
print v(xbgr.mr_n71007520)
print v(xbgr.mr_n71007840)
print v(xbgr.mr_n71007952)
print v(xbgr.mr_n71008272)
print v(xbgr.mr_n71008384)
print v(xbgr.mr_n71008704)
print v(xbgr.mr_n71008816)
print v(xbgr.mr_n71009136)
print v(xbgr.mr_n71009248)
print v(xbgr.mr_n71009568)
print v(xbgr.mr_n71009680)
print v(xbgr.mr_n71010000)
print v(xbgr.mr_n71010112)
print v(xbgr.mr_n71010432)
print v(xbgr.mr_n71010544)
print v(xbgr.mr_n71010864)
print v(xbgr.mr_n71010976)
print v(xbgr.mr_n71011296)
print v(xbgr.mr_n71011408)
print v(xbgr.mr_n71011728)
print v(xbgr.mr_n71011840)
print v(xbgr.mr_n71012160)
print v(xbgr.mr_n71012272)
print v(xbgr.mr_n71012592)
print v(xbgr.mr_n71012704)
print v(xbgr.mr_n71013024)
print v(xbgr.mr_n71013136)
print v(xbgr.mr_n71013456)
print v(xbgr.mr_n71013568)
print v(xbgr.mr_n71013888)
print v(xbgr.mr_n71014000)
print v(xbgr.mr_n71014320)
print v(xbgr.mr_n71014432)
print v(xbgr.mr_n71014752)
print v(xbgr.mr_n71014864)
print v(xbgr.mr_n71015184)
print v(xbgr.mr_n71015296)
print v(xbgr.mr_n71015616)
print v(xbgr.mr_n71015728)
print v(xbgr.mr_n71016048)
print v(xbgr.mr_n71016160)
print v(xbgr.mr_n71016480)
print v(xbgr.mr_n71016592)
print v(xbgr.mr_n71016912)
print v(xbgr.mr_n71017024)
print v(xbgr.mr_n71017344)
print v(xbgr.mr_n71017456)
print v(xbgr.mr_n71017776)
print v(xbgr.mr_n71017888)
print v(xbgr.mr_n71018208)
print v(xbgr.mr_n71018320)
print v(xbgr.mr_n71018640)
print v(xbgr.mr_n71018752)
print v(xbgr.mr_n71019072)
print v(xbgr.mr_n71019184)
print v(xbgr.mr_n71019504)
print v(xbgr.mr_n71019616)
print v(xbgr.mr_n71019936)
print v(xbgr.mr_n71020048)
print v(xbgr.mr_n71020368)
print v(xbgr.mr_n71020480)
print v(xbgr.mr_n71020800)
print v(xbgr.mr_n71020912)
print v(xbgr.mr_n71021232)
print v(xbgr.mr_n71021344)
print v(xbgr.mr_n71021664)
print v(xbgr.mr_n71021776)
print v(xbgr.mr_n71022096)
print v(xbgr.mr_n71022208)
print v(xbgr.mr_n71022528)
print v(xbgr.mr_n71022640)
print v(xbgr.mr_n71022960)
print v(xbgr.mr_n71023072)
print v(xbgr.mr_n71023392)
print v(xbgr.mr_n71023504)
print v(xbgr.mr_n71023824)
print v(xbgr.mr_n71023936)
print v(xbgr.mr_n71024256)
print v(xbgr.mr_n71024368)
print v(xbgr.mr_n71024688)
print v(xbgr.mr_n71024800)
print v(xbgr.mr_n71025120)
print v(xbgr.mr_n71025232)
print v(xbgr.mr_n71025552)
print v(xbgr.mr_n71025664)
print v(xbgr.mr_n71025984)
print v(xbgr.mr_n71026096)
print v(xbgr.mr_n71026416)
print v(xbgr.mr_n71026528)
print v(xbgr.mr_n71026848)
print v(xbgr.mr_n71026960)
print v(xbgr.mr_n71027280)
print v(xbgr.mr_n71027392)
print v(xbgr.mr_n71027712)
print v(xbgr.mr_n71027824)
print v(xbgr.mr_n71028144)
print v(xbgr.mr_n71028256)
print v(xbgr.mr_n71028576)
print v(xbgr.mr_n71028688)
print v(xbgr.mr_n71029008)
print v(xbgr.mr_n71029120)
print v(xbgr.mr_n71029440)
print v(xbgr.mr_n71029552)
print v(xbgr.mr_n71029872)
print v(xbgr.mr_n71029984)
print v(xbgr.mr_n71030304)
print v(xbgr.mr_n71030416)
print v(xbgr.mr_n71030736)
print v(xbgr.mr_n71030848)
print v(xbgr.mr_n71031168)
print v(xbgr.mr_n71031280)
print v(xbgr.mr_n71031600)
print v(xbgr.mr_n71031712)
print v(xbgr.mr_n71032032)
print v(xbgr.mr_n71032144)
print v(xbgr.mr_n71032464)
print v(xbgr.mr_n71032576)
print v(xbgr.mr_n71032896)
print v(xbgr.mr_n71033008)
print v(xbgr.mr_n71033328)
print v(xbgr.mr_n71033440)
print v(xbgr.mr_n71033760)
print v(xbgr.mr_n71033872)
print v(xbgr.mr_n71034192)
print v(xbgr.mr_n71034304)
print v(xbgr.mr_n71034624)
print v(xbgr.mr_n71034736)
print v(xbgr.mr_n71035056)
print v(xbgr.mr_n71035168)
print v(xbgr.mr_n71035488)
print v(xbgr.mr_n71035600)
print v(xbgr.mr_n71035920)
print v(xbgr.mr_n71036032)
print v(xbgr.mr_n71036352)
print v(xbgr.mr_n71036464)
print v(xbgr.mr_n71036784)
print v(xbgr.mr_n71036896)
print v(xbgr.mr_n71037216)
print v(xbgr.mr_n71037328)
print v(xbgr.mr_n71037648)
print v(xbgr.mr_n71037760)
print v(xbgr.mr_n71038080)
print v(xbgr.mr_n71038192)
print v(xbgr.mr_n71038512)
print v(xbgr.mr_n71038624)
print v(xbgr.mr_n71038944)
print v(xbgr.mr_n71039056)
print v(xbgr.mr_n71039376)
print v(xbgr.mr_n71039488)
print v(xbgr.mr_n71039808)
print v(xbgr.mr_n71039920)
print v(xbgr.mr_n71040240)
print v(xbgr.mr_n71040352)
print v(xbgr.mr_n71040672)
print v(xbgr.mr_n71040784)
print v(xbgr.mr_n71041104)
print v(xbgr.mr_n71041216)
print v(xbgr.mr_n71041536)
print v(xbgr.mr_n71041648)
print v(xbgr.mr_n71041968)
print v(xbgr.mr_n71042080)
print v(xbgr.mr_n71042400)
print v(xbgr.mr_n71042512)
print v(xbgr.mr_n71042832)
print v(xbgr.mr_n71042944)
print v(xbgr.mr_n71043264)
print v(xbgr.mr_n71043376)
print v(xbgr.mr_n71043696)
print v(xbgr.mr_n71043808)
print v(xbgr.mr_n71044128)
print v(xbgr.mr_n71044240)
print v(xbgr.mr_n71044560)
print v(xbgr.mr_n71044672)
print v(xbgr.mr_n71044992)
print v(xbgr.mr_n71045104)
print v(xbgr.mr_n71045424)
print v(xbgr.mr_n71045536)
print v(xbgr.mr_n71045856)
print v(xbgr.mr_n71045968)
print v(xbgr.mr_n71046288)
print v(xbgr.mr_n71046400)
print v(xbgr.mr_n71046720)
print v(xbgr.mr_n71046832)
print v(xbgr.mr_n71047152)
print v(xbgr.mr_n71047264)
print v(xbgr.mr_n71047584)
print v(xbgr.mr_n71047696)
print v(xbgr.mr_n71048016)
print v(xbgr.mr_n71048128)
print v(xbgr.mr_n71048448)
print v(xbgr.mr_n71048560)
print v(xbgr.mr_n71048880)
print v(xbgr.mr_n71048992)
print v(xbgr.mr_n71049312)
print v(xbgr.mr_n71049424)
print v(xbgr.mr_n71049744)
print v(xbgr.mr_n71049856)
print v(xbgr.mr_n71050176)
print v(xbgr.mr_n71050288)
print v(xbgr.mr_n71050608)
print v(xbgr.mr_n71050720)
print v(xbgr.mr_n71051040)
print v(xbgr.mr_n71051152)
print v(xbgr.mr_n71051472)
print v(xbgr.mr_n71051584)
print v(xbgr.mr_n71051904)
print v(xbgr.mr_n71052016)
print v(xbgr.mr_n71052336)
print v(xbgr.mr_n71052448)
print v(xbgr.mr_n71052768)
print v(xbgr.mr_n71052880)
print v(xbgr.mr_n71053200)
print v(xbgr.mr_n71053312)
print v(xbgr.mr_n71053632)
print v(xbgr.mr_n71053744)
print v(xbgr.mr_n71054064)
print v(xbgr.mr_n71054176)
print v(xbgr.mr_n71054496)
print v(xbgr.mr_n71054608)
print v(xbgr.mr_n71054928)
print v(xbgr.mr_n71055040)
print v(xbgr.mr_n71055360)
print v(xbgr.mr_n71055472)
print v(xbgr.mr_n71055792)
print v(xbgr.mr_n71055904)
print v(xbgr.mr_n71056224)
print v(xbgr.mr_n71056336)
print v(xbgr.mr_n71056656)
print v(xbgr.mr_n71056768)
print v(xbgr.mr_n71057088)
print v(xbgr.mr_n71057200)
print v(xbgr.mr_n71057520)
print v(xbgr.mr_n71057632)
print v(xbgr.mr_n71057952)
print v(xbgr.mr_n71058064)
print v(xbgr.mr_n71058384)
print v(xbgr.mr_n71058496)
print v(xbgr.mr_n71058816)
print v(xbgr.mr_n71058928)
print v(xbgr.mr_n71059248)
print v(xbgr.mr_n71059360)
print v(xbgr.mr_n71059680)
print v(xbgr.mr_n71059792)
print v(xbgr.mr_n71060112)
print v(xbgr.mr_n71060224)
print v(xbgr.mr_n71060544)
print v(xbgr.mr_n71060656)
print v(xbgr.mr_n71060944)
print v(xbgr.mr_n71061056)
print v(xbgr.mr_n71061376)
print v(xbgr.mr_n71061488)
print v(xbgr.mr_n71061808)
print v(xbgr.mr_n71061920)
print v(xbgr.mr_n71062240)
print v(xbgr.mr_n71062352)
print v(xbgr.mr_n71062672)
print v(xbgr.mr_n71062784)
print v(xbgr.mr_n71063104)
print v(xbgr.mr_n71063216)
print v(xbgr.mr_n71063536)
print v(xbgr.mr_n71063648)
print v(xbgr.mr_n71063968)
print v(xbgr.mr_n71064080)
print v(xbgr.mr_n71064400)
print v(xbgr.mr_n71064512)
print v(xbgr.mr_n71064832)
print v(xbgr.mr_n71064944)
print v(xbgr.mr_n71065264)
print v(xbgr.mr_n71065376)
print v(xbgr.mr_n71065696)
print v(xbgr.mr_n71065808)
print v(xbgr.mr_n71066128)
print v(xbgr.mr_n71066240)
print v(xbgr.mr_n71066560)
print v(xbgr.mr_n71066672)
print v(xbgr.mr_n71066992)
print v(xbgr.mr_n71067104)
print v(xbgr.mr_n71067424)
print v(xbgr.mr_n71067536)
print v(xbgr.mr_n71067856)
print v(xbgr.mr_n71067968)
print v(xbgr.mr_n71068288)
print v(xbgr.mr_n71068400)
print v(xbgr.mr_n71068720)
print v(xbgr.mr_n71068832)
print v(xbgr.mr_n71069152)
print v(xbgr.mr_n71069264)
print v(xbgr.mr_n71069584)
print v(xbgr.mr_n71069696)
print v(xbgr.mr_n71070016)
print v(xbgr.mr_n71070128)
print v(xbgr.mr_n71070448)
print v(xbgr.mr_n71070560)
print v(xbgr.mr_n71070880)
print v(xbgr.mr_n71070992)
print v(xbgr.mr_n71071312)
print v(xbgr.mr_n71071424)
print v(xbgr.mr_n71071744)
print v(xbgr.mr_n71071856)
print v(xbgr.mr_n71072176)
print v(xbgr.mr_n71072288)
print v(xbgr.mr_n71072608)
print v(xbgr.mr_n71072720)
print v(xbgr.mr_n71073040)
print v(xbgr.mr_n71073152)
print v(xbgr.mr_n71073472)
print v(xbgr.mr_n71073584)
print v(xbgr.mr_n71073904)
print v(xbgr.mr_n71074016)
print v(xbgr.mr_n71074336)
print v(xbgr.mr_n71074448)
print v(xbgr.mr_n71074768)
print v(xbgr.mr_n71074880)
print v(xbgr.mr_n71075200)
print v(xbgr.mr_n71075312)
print v(xbgr.mr_n71075632)
print v(xbgr.mr_n71075744)
print v(xbgr.mr_n71076064)
print v(xbgr.mr_n71076176)
print v(xbgr.mr_n71076496)
print v(xbgr.mr_n71076608)
print v(xbgr.mr_n71076928)
print v(xbgr.mr_n71077040)
print v(xbgr.mr_n71077360)
print v(xbgr.mr_n71077472)
print v(xbgr.mr_n71077792)
print v(xbgr.mr_n71077904)
print v(xbgr.mr_n71078224)
print v(xbgr.mr_n71078336)
print v(xbgr.mr_n71078656)
print v(xbgr.mr_n71078768)
print v(xbgr.mr_n71079088)
print v(xbgr.mr_n71079200)
print v(xbgr.mr_n71079520)
print v(xbgr.mr_n71079632)
print v(xbgr.mr_n71079952)
print v(xbgr.mr_n71080064)
print v(xbgr.mr_n71080384)
print v(xbgr.mr_n71080496)
print v(xbgr.mr_n71080816)
print v(xbgr.mr_n71080928)
print v(xbgr.mr_n71081248)
print v(xbgr.mr_n71081360)
print v(xbgr.mr_n71081680)
print v(xbgr.mr_n71081792)
print v(xbgr.mr_n71082112)
print v(xbgr.mr_n71082224)
print v(xbgr.mr_n71082544)
print v(xbgr.mr_n71082656)
print v(xbgr.mr_n71082976)
print v(xbgr.mr_n71083088)
print v(xbgr.mr_n71083408)
print v(xbgr.mr_n71083520)
print v(xbgr.mr_n71083840)
print v(xbgr.mr_n71083952)
print v(xbgr.mr_n71084272)
print v(xbgr.mr_n71084384)
print v(xbgr.mr_n71084704)
print v(xbgr.mr_n71084816)
print v(xbgr.mr_n71085136)
print v(xbgr.mr_n71085248)
print v(xbgr.mr_n71085568)
print v(xbgr.mr_n71085680)
print v(xbgr.mr_n71086000)
print v(xbgr.mr_n71086112)
print v(xbgr.mr_n71086432)
print v(xbgr.mr_n71086544)
print v(xbgr.mr_n71086864)
print v(xbgr.mr_n71086976)
print v(xbgr.mr_n71087296)
print v(xbgr.mr_n71087408)
print v(xbgr.mr_n71087728)
print v(xbgr.mr_n71087840)
print v(xbgr.mr_n71088160)
print v(xbgr.mr_n71088272)
print v(xbgr.mr_n71088592)
print v(xbgr.mr_n71088704)
print v(xbgr.mr_n71089024)
print v(xbgr.mr_n71089136)
print v(xbgr.mr_n71089456)
print v(xbgr.mr_n71089568)
print v(xbgr.mr_n71089888)
print v(xbgr.mr_n71090000)
print v(xbgr.mr_n71090320)
print v(xbgr.mr_n71090432)
print v(xbgr.mr_n71090752)
print v(xbgr.mr_n71090864)
print v(xbgr.mr_n71091184)
print v(xbgr.mr_n71091296)
print v(xbgr.mr_n71091616)
print v(xbgr.mr_n71091728)
print v(xbgr.mr_n71092048)
print v(xbgr.mr_n71092160)
print v(xbgr.mr_n71092480)
print v(xbgr.mr_n71092592)
print v(xbgr.mr_n71092912)
print v(xbgr.mr_n71093024)
print v(xbgr.mr_n71093344)
print v(xbgr.mr_n71093456)
print v(xbgr.mr_n71093776)
print v(xbgr.mr_n71093888)
print v(xbgr.mr_n71094208)
print v(xbgr.mr_n71094320)
print v(xbgr.mr_n71094640)
print v(xbgr.mr_n71094752)
print v(xbgr.mr_n71095072)
print v(xbgr.mr_n71095184)
print v(xbgr.mr_n71095504)
print v(xbgr.mr_n71095616)
print v(xbgr.mr_n71095936)
print v(xbgr.mr_n71096048)
print v(xbgr.mr_n71096368)
print v(xbgr.mr_n71096480)
print v(xbgr.mr_n71096800)
print v(xbgr.mr_n71096912)
print v(xbgr.mr_n71097232)
print v(xbgr.mr_n71097344)
print v(xbgr.mr_n71097664)
print v(xbgr.mr_n71097776)
print v(xbgr.mr_n71098096)
print v(xbgr.mr_n71098208)
print v(xbgr.mr_n71098528)
print v(xbgr.mr_n71098640)
print v(xbgr.mr_n71098960)
print v(xbgr.mr_n71099072)
print v(xbgr.mr_n71099392)
print v(xbgr.mr_n71099504)
print v(xbgr.mr_n71099824)
print v(xbgr.mr_n71099936)
print v(xbgr.mr_n71100256)
print v(xbgr.mr_n71100368)
print v(xbgr.mr_n71100688)
print v(xbgr.mr_n71100800)
print v(xbgr.mr_n71101120)
print v(xbgr.mr_n71101232)
print v(xbgr.mr_n71101552)
print v(xbgr.mr_n71101664)
print v(xbgr.mr_n71101984)
print v(xbgr.mr_n71102096)
print v(xbgr.mr_n71102416)
print v(xbgr.mr_n71102528)
print v(xbgr.mr_n71102848)
print v(xbgr.mr_n71102960)
print v(xbgr.mr_n71103280)
print v(xbgr.mr_n71103392)
print v(xbgr.mr_n71103712)
print v(xbgr.mr_n71103824)
print v(xbgr.mr_n71104144)
print v(xbgr.mr_n71104256)
print v(xbgr.mr_n71104576)
print v(xbgr.mr_n71104688)
print v(xbgr.mr_n71105008)
print v(xbgr.mr_n71105120)
print v(xbgr.mr_n71105440)
print v(xbgr.mr_n71105552)
print v(xbgr.mr_n71105872)
print v(xbgr.mr_n71105984)
print v(xbgr.mr_n71106304)
print v(xbgr.mr_n71106416)
print v(xbgr.mr_n71106736)
print v(xbgr.mr_n71106848)
print v(xbgr.mr_n71107168)
print v(xbgr.mr_n71107280)
print v(xbgr.mr_n71107600)
print v(xbgr.mr_n71107712)
print v(xbgr.mr_n71108032)
print v(xbgr.mr_n71108144)
print v(xbgr.mr_n71108464)
print v(xbgr.mr_n71108576)
print v(xbgr.mr_n71108896)
print v(xbgr.mr_n71109008)
print v(xbgr.mr_n71109328)
print v(xbgr.mr_n71109440)
print v(xbgr.mr_n71109760)
print v(xbgr.mr_n71109872)
print v(xbgr.mr_n71110192)
print v(xbgr.mr_n71110304)
print v(xbgr.mr_n71110624)
print v(xbgr.mr_n71110736)
print v(xbgr.mr_n71111056)
print v(xbgr.mr_n71111168)
print v(xbgr.mr_n71111488)
print v(xbgr.mr_n71111600)
print v(xbgr.mr_n71111920)
print v(xbgr.mr_n71112032)
print v(xbgr.mr_n71112352)
print v(xbgr.mr_n71112464)
print v(xbgr.mr_n71112784)
print v(xbgr.mr_n71112896)
print v(xbgr.mr_n71113216)
print v(xbgr.mr_n71113328)
print v(xbgr.mr_n71113648)
print v(xbgr.mr_n71113760)
print v(xbgr.mr_n71114080)
print v(xbgr.mr_n71114192)
print v(xbgr.mr_n71114512)
print v(xbgr.mr_n71114624)
print v(xbgr.mr_n71114944)
print v(xbgr.mr_n71115056)
print v(xbgr.mr_n71115376)
print v(xbgr.mr_n71115488)
print v(xbgr.mr_n71115808)
print v(xbgr.mr_n71115920)
print v(xbgr.mr_n71116240)
print v(xbgr.mr_n71116352)
print v(xbgr.mr_n71116672)
print v(xbgr.mr_n71116784)
print v(xbgr.mr_n71117104)
print v(xbgr.mr_n71117216)
print v(xbgr.mr_n71117536)
print v(xbgr.mr_n71117648)
print v(xbgr.mr_n71117968)
print v(xbgr.mr_n71118080)
print v(xbgr.mr_n71118400)
print v(xbgr.mr_n71118512)
print v(xbgr.mr_n71118832)
print v(xbgr.mr_n71118944)
print v(xbgr.mr_n71119264)
print v(xbgr.mr_n71119376)
print v(xbgr.mr_n71119696)
print v(xbgr.mr_n71119808)
print v(xbgr.mr_n71120128)
print v(xbgr.mr_n71120240)
print v(xbgr.mr_n71120560)
print v(xbgr.mr_n71120672)
print v(xbgr.mr_n71120992)
print v(xbgr.mr_n71121104)
print v(xbgr.mr_n71121424)
print v(xbgr.mr_n71121536)
print v(xbgr.mr_n71121856)
print v(xbgr.mr_n71121968)
print v(xbgr.mr_n71122288)
print v(xbgr.mr_n71122400)
print v(xbgr.mr_n71122720)
print v(xbgr.mr_n71122832)
print v(xbgr.mr_n71123152)
print v(xbgr.mr_n71123264)
print v(xbgr.mr_n71123584)
print v(xbgr.mr_n71123696)
print v(xbgr.mr_n71124016)
print v(xbgr.mr_n71124128)
print v(xbgr.mr_n71124448)
print v(xbgr.mr_n71124560)
print v(xbgr.mr_n71124880)
print v(xbgr.mr_n71124992)
print v(xbgr.mr_n71125312)
print v(xbgr.mr_n71125424)
print v(xbgr.mr_n71125744)
print v(xbgr.mr_n71125856)
print v(xbgr.mr_n71126176)
print v(xbgr.mr_n71126288)
print v(xbgr.mr_n71126608)
print v(xbgr.mr_n71126720)
print v(xbgr.mr_n71127040)
print v(xbgr.mr_n71127152)
print v(xbgr.mr_n71127472)
print v(xbgr.mr_n71127584)
print v(xbgr.mr_n71127904)
print v(xbgr.mr_n71128016)
print v(xbgr.mr_n71128336)
print v(xbgr.mr_n71128448)
print v(xbgr.mr_n71128768)
print v(xbgr.mr_n71128880)
print v(xbgr.mr_n71129200)
print v(xbgr.mr_n71129312)
print v(xbgr.mr_n71129632)
print v(xbgr.mr_n71129744)
print v(xbgr.mr_n71130064)
print v(xbgr.mr_n71130176)
print v(xbgr.mr_n71130496)
print v(xbgr.mr_n71130608)
print v(xbgr.mr_n71130928)
print v(xbgr.mr_n71131040)
print v(xbgr.mr_n71131360)
print v(xbgr.mr_n71131472)
print v(xbgr.mr_n71131792)
print v(xbgr.mr_n71131904)
print v(xbgr.mr_n71132224)
print v(xbgr.mr_n71132336)
print v(xbgr.mr_n71132656)
print v(xbgr.mr_n71132768)
print v(xbgr.mr_n71133088)
print v(xbgr.mr_n71133200)
print v(xbgr.mr_n71133520)
print v(xbgr.mr_n71133632)
print v(xbgr.mr_n71133952)
print v(xbgr.mr_n71134064)
print v(xbgr.mr_n71134384)
print v(xbgr.mr_n71134496)
print v(xbgr.mr_n71134816)
print v(xbgr.mr_n71134928)
print v(xbgr.mr_n71135248)
print v(xbgr.mr_n71135360)
print v(xbgr.mr_n71135680)
print v(xbgr.mr_n71135792)
print v(xbgr.mr_n71136112)
print v(xbgr.mr_n71136224)
print v(xbgr.mr_n71136544)
print v(xbgr.mr_n71136656)
print v(xbgr.mr_n71136976)
print v(xbgr.mr_n71137088)
print v(xbgr.mr_n71137408)
print v(xbgr.mr_n71137520)
print v(xbgr.mr_n71137840)
print v(xbgr.mr_n71137952)
print v(xbgr.mr_n71138272)
print v(xbgr.mr_n71138384)
print v(xbgr.mr_n71138704)
print v(xbgr.mr_n71138816)
print v(xbgr.mr_n71139136)
print v(xbgr.mr_n71139248)
print v(xbgr.mr_n71139568)
print v(xbgr.mr_n71139680)
print v(xbgr.mr_n71140000)
print v(xbgr.mr_n71140112)
print v(xbgr.mr_n71140432)
print v(xbgr.mr_n71140544)
print v(xbgr.mr_n71140864)
print v(xbgr.mr_n71140976)
print v(xbgr.mr_n71141296)
print v(xbgr.mr_n71141408)
print v(xbgr.mr_n71141728)
print v(xbgr.mr_n71141840)
print v(xbgr.mr_n71142160)
print v(xbgr.mr_n71142272)
print v(xbgr.mr_n71142592)
print v(xbgr.mr_n71142704)
print v(xbgr.mr_n71143024)
print v(xbgr.mr_n71143136)
print v(xbgr.mr_n71143456)
print v(xbgr.mr_n71143568)
print v(xbgr.mr_n71143888)
print v(xbgr.mr_n71144000)
print v(xbgr.mr_n71144320)
print v(xbgr.mr_n71144432)
print v(xbgr.mr_n71144752)
print v(xbgr.mr_n71144864)
print v(xbgr.mr_n71145184)
print v(xbgr.mr_n71145296)
print v(xbgr.mr_n71145616)
print v(xbgr.mr_n71145728)
print v(xbgr.mr_n71146048)
print v(xbgr.mr_n71146160)
print v(xbgr.mr_n71146480)
print v(xbgr.mr_n71146592)
print v(xbgr.mr_n71146912)
print v(xbgr.mr_n71147024)
print v(xbgr.mr_n71147344)
print v(xbgr.mr_n71147456)
print v(xbgr.mr_n71147776)
print v(xbgr.mr_n71147888)
print v(xbgr.mr_n71148208)
print v(xbgr.mr_n71148320)
print v(xbgr.mr_n71148640)
print v(xbgr.mr_n71148752)
print v(xbgr.mr_n71149072)
print v(xbgr.mr_n71149184)
print v(xbgr.mr_n71149504)
print v(xbgr.mr_n71149616)
print v(xbgr.mr_n71149936)
print v(xbgr.mr_n71150048)
print v(xbgr.mr_n71150368)
print v(xbgr.mr_n71150480)
print v(xbgr.mr_n71150800)
print v(xbgr.mr_n71150912)
print v(xbgr.mr_n71151232)
print v(xbgr.mr_n71151344)
print v(xbgr.mr_n71151664)
print v(xbgr.mr_n71151776)
print v(xbgr.mr_n71152096)
print v(xbgr.mr_n71152208)
print v(xbgr.mr_n71152528)
print v(xbgr.mr_n71152640)
print v(xbgr.mr_n71152960)
print v(xbgr.mr_n71153072)
print v(xbgr.mr_n71153392)
print v(xbgr.mr_n71153504)
print v(xbgr.mr_n71153824)
print v(xbgr.mr_n71153936)
print v(xbgr.mr_n71154256)
print v(xbgr.mr_n71154368)
print v(xbgr.mr_n71154688)
print v(xbgr.mr_n71154800)
print v(xbgr.mr_n71155120)
print v(xbgr.mr_n71155232)
print v(xbgr.mr_n71155552)
print v(xbgr.mr_n71155664)
print v(xbgr.mr_n71155984)
print v(xbgr.mr_n71156096)
print v(xbgr.mr_n71156416)
print v(xbgr.mr_n71156528)
print v(xbgr.mr_n71156848)
print v(xbgr.mr_n71156960)
print v(xbgr.mr_n71157280)
print v(xbgr.mr_n71157392)
print v(xbgr.mr_n71157712)
print v(xbgr.mr_n71157824)
print v(xbgr.mr_n71158144)
print v(xbgr.mr_n71158256)
print v(xbgr.mr_n71158576)
print v(xbgr.mr_n71158688)
print v(xbgr.mr_n71159008)
print v(xbgr.mr_n71159120)
print v(xbgr.mr_n71159440)
print v(xbgr.mr_n71159552)
print v(xbgr.mr_n71159872)
print v(xbgr.mr_n71159984)
print v(xbgr.mr_n71160304)
print v(xbgr.mr_n71160416)
print v(xbgr.mr_n71160736)
print v(xbgr.mr_n71160848)
print v(xbgr.mr_n71161168)
print v(xbgr.mr_n71161280)
print v(xbgr.mr_n71161600)
print v(xbgr.mr_n71161712)
print v(xbgr.mr_n71162032)
print v(xbgr.mr_n71162144)
print v(xbgr.mr_n71162464)
print v(xbgr.mr_n71162576)
print v(xbgr.mr_n71162896)
print v(xbgr.mr_n71163008)
print v(xbgr.mr_n71163328)
print v(xbgr.mr_n71163440)
print v(xbgr.mr_n71163760)
print v(xbgr.mr_n71163872)
print v(xbgr.mr_n71164192)
print v(xbgr.mr_n71164304)
print v(xbgr.mr_n71164624)
print v(xbgr.mr_n71164736)
print v(xbgr.mr_n71165056)
print v(xbgr.mr_n71165168)
print v(xbgr.mr_n71165488)
print v(xbgr.mr_n71165600)
print v(xbgr.mr_n71165920)
print v(xbgr.mr_n71166032)
print v(xbgr.mr_n71166352)
print v(xbgr.mr_n71166464)
print v(xbgr.mr_n71166784)
print v(xbgr.mr_n71166896)
print v(xbgr.mr_n71167216)
print v(xbgr.mr_n71167328)
print v(xbgr.mr_n71167648)
print v(xbgr.mr_n71167760)
print v(xbgr.mr_n71168080)
print v(xbgr.mr_n71168192)
print v(xbgr.mr_n71168512)
print v(xbgr.mr_n71168624)
print v(xbgr.mr_n71168944)
print v(xbgr.mr_n71169056)
print v(xbgr.mr_n71169376)
print v(xbgr.mr_n71169488)
print v(xbgr.mr_n71169808)
print v(xbgr.mr_n71169920)
print v(xbgr.mr_n71170240)
print v(xbgr.mr_n71170352)
print v(xbgr.mr_n71170672)
print v(xbgr.mr_n71170784)
print v(xbgr.mr_n71171104)
print v(xbgr.mr_n71171216)
print v(xbgr.mr_n71171536)
print v(xbgr.mr_n71171648)
print v(xbgr.mr_n71171968)
print v(xbgr.mr_n71172080)
print v(xbgr.mr_n71172400)
print v(xbgr.mr_n71172512)
print v(xbgr.mr_n71172832)
print v(xbgr.mr_n71172944)
print v(xbgr.mr_n71173264)
print v(xbgr.mr_n71173376)
print v(xbgr.mr_n71173696)
print v(xbgr.mr_n71173808)
print v(xbgr.mr_n71174128)
print v(xbgr.mr_n71174240)
print v(xbgr.mr_n71174560)
print v(xbgr.mr_n71174672)
print v(xbgr.mr_n71174992)
print v(xbgr.mr_n71175104)
print v(xbgr.mr_n71175424)
print v(xbgr.mr_n71175536)
print v(xbgr.mr_n71175856)
print v(xbgr.mr_n71175968)
print v(xbgr.mr_n71176288)
print v(xbgr.mr_n71176400)
print v(xbgr.mr_n71176720)
print v(xbgr.mr_n71176832)
print v(xbgr.mr_n71177152)
print v(xbgr.mr_n71177264)
print v(xbgr.mr_n71177584)
print v(xbgr.mr_n71177696)
print v(xbgr.mr_n71178016)
print v(xbgr.mr_n71178128)
print v(xbgr.mr_n71178448)
print v(xbgr.mr_n71178560)
print v(xbgr.mr_n71178880)
print v(xbgr.mr_n71178992)
print v(xbgr.mr_n71179312)
print v(xbgr.mr_n71179424)
print v(xbgr.mr_n71179744)
print v(xbgr.mr_n71179856)
print v(xbgr.mr_n71180176)
print v(xbgr.mr_n71180288)
print v(xbgr.mr_n71180608)
print v(xbgr.mr_n71180720)
print v(xbgr.mr_n71181040)
print v(xbgr.mr_n71181152)
print v(xbgr.mr_n71181472)
print v(xbgr.mr_n71181584)
print v(xbgr.mr_n71181904)
print v(xbgr.mr_n71182016)
print v(xbgr.mr_n71182336)
print v(xbgr.mr_n71182448)
print v(xbgr.mr_n71182768)
print v(xbgr.mr_n71182880)
print v(xbgr.mr_n71183200)
print v(xbgr.mr_n71183312)
print v(xbgr.mr_n71183632)
print v(xbgr.mr_n71183744)
print v(xbgr.mr_n71184064)
print v(xbgr.mr_n71184176)
print v(xbgr.mr_n71184496)
print v(xbgr.mr_n71184608)
print v(xbgr.mr_n71184928)
print v(xbgr.mr_n71185040)
print v(xbgr.mr_n71185360)
print v(xbgr.mr_n71185472)
print v(xbgr.mr_n71185792)
print v(xbgr.mr_n71185904)
print v(xbgr.mr_n71186224)
print v(xbgr.mr_n71186336)
print v(xbgr.mr_n71186656)
print v(xbgr.mr_n71186768)
print v(xbgr.mr_n71187088)
print v(xbgr.mr_n71187200)
print v(xbgr.mr_n71187520)
print v(xbgr.mr_n71187632)
print v(xbgr.mr_n71187952)
print v(xbgr.mr_n71188064)
print v(xbgr.mr_n71188384)
print v(xbgr.mr_n71188496)
print v(xbgr.mr_n71188816)
print v(xbgr.mr_n71188928)
print v(xbgr.mr_n71189248)
print v(xbgr.mr_n71189360)
print v(xbgr.mr_n71189680)
print v(xbgr.mr_n71189792)
print v(xbgr.mr_n71190112)
print v(xbgr.mr_n71190224)
print v(xbgr.mr_n71190544)
print v(xbgr.mr_n71190656)
print v(xbgr.mr_n71190976)
print v(xbgr.mr_n71191088)
print v(xbgr.mr_n71191408)
print v(xbgr.mr_n71191520)
print v(xbgr.mr_n71191840)
print v(xbgr.mr_n71191952)
print v(xbgr.mr_n71192272)
print v(xbgr.mr_n71192384)
print v(xbgr.mr_n71192704)
print v(xbgr.mr_n71192816)
print v(xbgr.mr_n71193136)
print v(xbgr.mr_n71193248)
print v(xbgr.mr_n71193568)
print v(xbgr.mr_n71193680)
print v(xbgr.mr_n71194000)
print v(xbgr.mr_n71194112)
print v(xbgr.mr_n71194432)
print v(xbgr.mr_n71194544)
print v(xbgr.mr_n71194864)
print v(xbgr.mr_n71194976)
print v(xbgr.mr_n71195296)
print v(xbgr.mr_n71195408)
print v(xbgr.mr_n71195728)
print v(xbgr.mr_n71195840)
print v(xbgr.mr_n71196160)
print v(xbgr.mr_n71196272)
print v(xbgr.mr_n71196592)
print v(xbgr.mr_n71196704)
print v(xbgr.mr_n71197024)
print v(xbgr.mr_n71197136)
print v(xbgr.mr_n71197456)
print v(xbgr.mr_n71197568)
print v(xbgr.mr_n71197888)
print v(xbgr.mr_n71198000)
print v(xbgr.mr_n71198320)
print v(xbgr.mr_n71198432)
print v(xbgr.mr_n71198752)
print v(xbgr.mr_n71198864)
print v(xbgr.mr_n71199184)
print v(xbgr.mr_n71199296)
print v(xbgr.mr_n71199616)
print v(xbgr.mr_n71199728)
print v(xbgr.mr_n71200048)
print v(xbgr.mr_n71200160)
print v(xbgr.mr_n71200480)
print v(xbgr.mr_n71200592)
print v(xbgr.mr_n71200912)
print v(xbgr.mr_n71201024)
print v(xbgr.mr_n71201344)
print v(xbgr.mr_n71201456)
print v(xbgr.mr_n71201776)
print v(xbgr.mr_n71201888)
print v(xbgr.mr_n71202208)
print v(xbgr.mr_n71202320)
print v(xbgr.mr_n71202640)
print v(xbgr.mr_n71202752)
print v(xbgr.mr_n71203072)
print v(xbgr.mr_n71203184)
print v(xbgr.mr_n71203504)
print v(xbgr.mr_n71203616)
print v(xbgr.mr_n71203936)
print v(xbgr.mr_n71204048)
print v(xbgr.mr_n71204368)
print v(xbgr.mr_n71204480)
print v(xbgr.mr_n71204800)
print v(xbgr.mr_n71204912)
print v(xbgr.mr_n71205232)
print v(xbgr.mr_n71205344)
print v(xbgr.mr_n71205664)
print v(xbgr.mr_n71205776)
print v(xbgr.mr_n71206096)
print v(xbgr.mr_n71206208)
print v(xbgr.mr_n71206528)
print v(xbgr.mr_n71206640)
print v(xbgr.mr_n71206960)
print v(xbgr.mr_n71207072)
print v(xbgr.mr_n71207392)
print v(xbgr.mr_n71207504)
print v(xbgr.mr_n71207824)
print v(xbgr.mr_n71207936)
print v(xbgr.mr_n71208256)
print v(xbgr.mr_n71208368)
print v(xbgr.mr_n71208688)
print v(xbgr.mr_n71208800)
print v(xbgr.mr_n71209120)
print v(xbgr.mr_n71209232)
print v(xbgr.mr_n71209552)
print v(xbgr.mr_n71209664)
print v(xbgr.mr_n71209984)
print v(xbgr.mr_n71210096)
print v(xbgr.mr_n71210416)
print v(xbgr.mr_n71210528)
print v(xbgr.mr_n71210848)
print v(xbgr.mr_n71210960)
print v(xbgr.mr_n71211280)
print v(xbgr.mr_n71211392)
print v(xbgr.mr_n71211712)
print v(xbgr.mr_n71211824)
print v(xbgr.mr_n71212144)
print v(xbgr.mr_n71212256)
print v(xbgr.mr_n71212576)
print v(xbgr.mr_n71212688)
print v(xbgr.mr_n71213008)
print v(xbgr.mr_n71213120)
print v(xbgr.mr_n71213440)
print v(xbgr.mr_n71213552)
print v(xbgr.mr_n71213872)
print v(xbgr.mr_n71213984)
print v(xbgr.mr_n71214304)
print v(xbgr.mr_n71214416)
print v(xbgr.mr_n71214736)
print v(xbgr.mr_n71214848)
print v(xbgr.mr_n71215168)
print v(xbgr.mr_n71215280)
print v(xbgr.mr_n71215600)
print v(xbgr.mr_n71215712)
print v(xbgr.mr_n71216032)
print v(xbgr.mr_n71216144)
print v(xbgr.mr_n71216464)
print v(xbgr.mr_n71216576)
print v(xbgr.mr_n71216896)
print v(xbgr.mr_n71217008)
print v(xbgr.mr_n71217328)
print v(xbgr.mr_n71217440)
print v(xbgr.mr_n71217760)
print v(xbgr.mr_n71217872)
print v(xbgr.mr_n71218192)
print v(xbgr.mr_n71218304)
print v(xbgr.mr_n71218624)
print v(xbgr.mr_n71218736)
print v(xbgr.mr_n71219056)
print v(xbgr.mr_n71219168)
print v(xbgr.mr_n71219488)
print v(xbgr.mr_n71219600)
print v(xbgr.mr_n71219920)
print v(xbgr.mr_n71220032)
print v(xbgr.mr_n71220352)
print v(xbgr.mr_n71220464)
print v(xbgr.mr_n71220784)
print v(xbgr.mr_n71220896)
print v(xbgr.mr_n71221216)
print v(xbgr.mr_n71221328)
print v(xbgr.mr_n71221648)
print v(xbgr.mr_n71221760)
print v(xbgr.mr_n71222080)
print v(xbgr.mr_n71222192)
print v(xbgr.mr_n71222512)
print v(xbgr.mr_n71222624)
print v(xbgr.mr_n71222944)
print v(xbgr.mr_n71223056)
print v(xbgr.mr_n71223376)
print v(xbgr.mr_n71223488)
print v(xbgr.mr_n71223808)
print v(xbgr.mr_n71223920)
print v(xbgr.mr_n71224240)
print v(xbgr.mr_n71224352)
print v(xbgr.mr_n71224672)
print v(xbgr.mr_n71224784)
print v(xbgr.mr_n71225104)
print v(xbgr.mr_n71225216)
print v(xbgr.mr_n71225536)
print v(xbgr.mr_n71225648)
print v(xbgr.mr_n71225968)
print v(xbgr.mr_n71226080)
print v(xbgr.mr_n71226400)
print v(xbgr.mr_n71226512)
print v(xbgr.mr_n71226832)
print v(xbgr.mr_n71226944)
print v(xbgr.mr_n71227264)
print v(xbgr.mr_n71227376)
print v(xbgr.mr_n71227696)
print v(xbgr.mr_n71227808)
print v(xbgr.mr_n71228128)
print v(xbgr.mr_n71228240)
print v(xbgr.mr_n71228560)
print v(xbgr.mr_n71228672)
print v(xbgr.mr_n71228992)
print v(xbgr.mr_n71229104)
print v(xbgr.mr_n71229424)
print v(xbgr.mr_n71229536)
print v(xbgr.mr_n71229856)
print v(xbgr.mr_n71229968)
print v(xbgr.mr_n71230288)
print v(xbgr.mr_n71230400)
print v(xbgr.mr_n71230720)
print v(xbgr.mr_n71230832)
print v(xbgr.mr_n71231152)
print v(xbgr.mr_n71231264)
print v(xbgr.mr_n71231584)
print v(xbgr.mr_n71231696)
print v(xbgr.mr_n71232016)
print v(xbgr.mr_n71232128)
print v(xbgr.mr_n71232448)
print v(xbgr.mr_n71232560)
print v(xbgr.mr_n71232880)
print v(xbgr.mr_n71232992)
print v(xbgr.mr_n71233312)
print v(xbgr.mr_n71233424)
print v(xbgr.mr_n71233744)
print v(xbgr.mr_n71233856)
print v(xbgr.mr_n71234176)
print v(xbgr.mr_n71234288)
print v(xbgr.mr_n71234608)
print v(xbgr.mr_n71234720)
print v(xbgr.mr_n71235040)
print v(xbgr.mr_n71235152)
print v(xbgr.mr_n71235472)
print v(xbgr.mr_n71235584)
print v(xbgr.mr_n71235904)
print v(xbgr.mr_n71236016)
print v(xbgr.mr_n71236336)
print v(xbgr.mr_n71236448)
print v(xbgr.mr_n71236768)
print v(xbgr.mr_n71236880)
print v(xbgr.mr_n71237200)
print v(xbgr.mr_n71237312)
print v(xbgr.mr_n71237632)
print v(xbgr.mr_n71237744)
print v(xbgr.mr_n71238064)
print v(xbgr.mr_n71238176)
print v(xbgr.mr_n71238496)
print v(xbgr.mr_n71238608)
print v(xbgr.mr_n71238928)
print v(xbgr.mr_n71239040)
print v(xbgr.mr_n71239360)
print v(xbgr.mr_n71239472)
print v(xbgr.mr_n71239792)
print v(xbgr.mr_n71239904)
print v(xbgr.mr_n71240224)
print v(xbgr.mr_n71240336)
print v(xbgr.mr_n71240656)
print v(xbgr.mr_n71240768)
print v(xbgr.mr_n71241088)
print v(xbgr.mr_n71241200)
print v(xbgr.mr_n71241520)
print v(xbgr.mr_n71241632)
print v(xbgr.mr_n71241952)
print v(xbgr.mr_n71242064)
print v(xbgr.mr_n71242384)
print v(xbgr.mr_n71242496)
print v(xbgr.mr_n71242816)
print v(xbgr.mr_n71242928)
print v(xbgr.mr_n71243248)
print v(xbgr.mr_n71243360)
print v(xbgr.mr_n71243680)
print v(xbgr.mr_n71243792)
print v(xbgr.mr_n71244112)
print v(xbgr.mr_n71244224)
print v(xbgr.mr_n71244544)
print v(xbgr.mr_n71244656)
print v(xbgr.mr_n71244976)
print v(xbgr.mr_n71245088)
print v(xbgr.mr_n71245408)
print v(xbgr.mr_n71245520)
print v(xbgr.mr_n71245840)
print v(xbgr.mr_n71245952)
print v(xbgr.mr_n71246272)
print v(xbgr.mr_n71246384)
print v(xbgr.mr_n71246704)
print v(xbgr.mr_n71246816)
print v(xbgr.mr_n71247136)
print v(xbgr.mr_n71247248)
print v(xbgr.mr_n71247568)
print v(xbgr.mr_n71247680)
print v(xbgr.mr_n71248000)
print v(xbgr.mr_n71248112)
print v(xbgr.mr_n71248432)
print v(xbgr.mr_n71248544)
print v(xbgr.mr_n71248864)
print v(xbgr.mr_n71248976)
print v(xbgr.mr_n71249296)
print v(xbgr.mr_n71249408)
print v(xbgr.mr_n71249728)
print v(xbgr.mr_n71249840)
print v(xbgr.mr_n71250160)
print v(xbgr.mr_n71250272)
print v(xbgr.mr_n71250592)
print v(xbgr.mr_n71250704)
print v(xbgr.mr_n71251024)
print v(xbgr.mr_n71251136)
print v(xbgr.mr_n71251456)
print v(xbgr.mr_n71251568)
print v(xbgr.mr_n71251888)
print v(xbgr.mr_n71252000)
print v(xbgr.mr_n71252320)
print v(xbgr.mr_n71252432)
print v(xbgr.mr_n71252752)
print v(xbgr.mr_n71252864)
print v(xbgr.mr_n71253184)
print v(xbgr.mr_n71253296)
print v(xbgr.mr_n71253616)
print v(xbgr.mr_n71253728)
print v(xbgr.mr_n71254048)
print v(xbgr.mr_n71254160)
print v(xbgr.mr_n71254480)
print v(xbgr.mr_n71254592)
print v(xbgr.mr_n71254912)
print v(xbgr.mr_n71255024)
print v(xbgr.mr_n71255344)
print v(xbgr.mr_n71255456)
print v(xbgr.mr_n71255776)
print v(xbgr.mr_n71255888)
print v(xbgr.mr_n71256208)
print v(xbgr.mr_n71256320)
print v(xbgr.mr_n71256640)
print v(xbgr.mr_n71256752)
print v(xbgr.mr_n71257072)
print v(xbgr.mr_n71257184)
print v(xbgr.mr_n71257504)
print v(xbgr.mr_n71257616)
print v(xbgr.mr_n71257936)
print v(xbgr.mr_n71258048)
print v(xbgr.mr_n71258368)
print v(xbgr.mr_n71258480)
print v(xbgr.mr_n71258800)
print v(xbgr.mr_n71258912)
print v(xbgr.mr_n71259232)
print v(xbgr.mr_n71259344)
print v(xbgr.mr_n71259664)
print v(xbgr.mr_n71259776)
print v(xbgr.mr_n71260096)
print v(xbgr.mr_n71260208)
print v(xbgr.mr_n71260528)
print v(xbgr.mr_n71260640)
print v(xbgr.mr_n71260960)
print v(xbgr.mr_n71261072)
print v(xbgr.mr_n71261392)
print v(xbgr.mr_n71261504)
print v(xbgr.mr_n71261824)
print v(xbgr.mr_n71261936)
print v(xbgr.mr_n71262256)
print v(xbgr.mr_n71262368)
print v(xbgr.mr_n71262688)
print v(xbgr.mr_n71262800)
print v(xbgr.mr_n71263120)
print v(xbgr.mr_n71263232)
print v(xbgr.mr_n71263552)
print v(xbgr.mr_n71263664)
print v(xbgr.mr_n71263984)
print v(xbgr.mr_n71264096)
print v(xbgr.mr_n71264416)
print v(xbgr.mr_n71264528)
print v(xbgr.mr_n71264848)
print v(xbgr.mr_n71264960)
print v(xbgr.mr_n71265280)
print v(xbgr.mr_n71265392)
print v(xbgr.mr_n71265712)
print v(xbgr.mr_n71265824)
print v(xbgr.mr_n71266256)
print v(xbgr.mr_n71266576)
print v(xbgr.mr_n71266688)
print v(xbgr.mr_n71267120)
print v(xbgr.mr_n71267440)
print v(xbgr.mr_n71267552)
print v(xbgr.mr_n71267984)
print v(xbgr.mr_n71268304)
print v(xbgr.mr_n71269168)
print v(xbgr.mr_n71270032)
print v(xbgr.mr_n71270896)
print v(xbgr.mr_n71271760)
print v(xbgr.mr_n71272624)
print v(xbgr.mr_n71273488)
print v(xbgr.mr_n71273600)
print v(xbgr.mr_n71273920)
print v(xbgr.mr_n71274032)
print v(xbgr.mr_n71274352)
print v(xbgr.mr_n71274464)
print v(xbgr.mr_n71274784)
print v(xbgr.mr_n71274896)
print v(xbgr.mr_n71275216)
print v(xbgr.mr_n71276080)
print v(xbgr.mr_n71276944)
print v(xbgr.mr_n71277808)
print v(xbgr.mr_n71277920)
print v(xbgr.mr_n71278240)
print v(xbgr.mr_n71278352)
print v(xbgr.mr_n71278672)
print v(xbgr.mr_n71278784)
print v(xbgr.mr_n71279216)
print v(xbgr.mr_n71279648)
print v(xbgr.mr_n71280080)
print v(xbgr.mr_n71280400)
print v(xbgr.mr_n71280512)
print v(xbgr.mr_n71280832)
print v(xbgr.mr_n71280944)
print v(xbgr.mr_n71281264)
print v(xbgr.mr_n71281376)
print v(xbgr.mr_n71281696)
print v(xbgr.mr_n71281808)
print v(xbgr.mr_n71282128)
print v(xbgr.mr_n71282240)
print v(xbgr.mr_n71282560)
print v(xbgr.mr_n71282672)
print v(xbgr.mr_n71282992)
print v(xbgr.mr_n71283104)
print v(xbgr.mr_n71283424)
print v(xbgr.mr_n71283536)
print v(xbgr.mr_n71283856)
print v(xbgr.mr_n71283968)
print v(xbgr.mr_n71284288)
print v(xbgr.mr_n71284400)
print v(xbgr.mr_n71284720)
print v(xbgr.mr_n71284832)
print v(xbgr.mr_n71285152)
print v(xbgr.mr_n71285264)
print v(xbgr.mr_n71285584)
print v(xbgr.mr_n71285696)
print v(xbgr.mr_n71286016)
print v(xbgr.mr_n71286128)
print v(xbgr.mr_n71286448)
print v(xbgr.mr_n71286560)
print v(xbgr.mr_n71286880)
print v(xbgr.mr_n71286992)
print v(xbgr.mr_n71287312)
print v(xbgr.mr_n71287424)
print v(xbgr.mr_n71287744)
print v(xbgr.mr_n71287856)
print v(xbgr.mr_n71288176)
print v(xbgr.mr_n71288288)
print v(xbgr.mr_n71288608)
print v(xbgr.mr_n71288720)
print v(xbgr.mr_n71289040)
print v(xbgr.mr_n71289152)
print v(xbgr.mr_n71289472)
print v(xbgr.mr_n71289584)
print v(xbgr.mr_n71289904)
print v(xbgr.mr_n71290016)
print v(xbgr.mr_n71290336)
print v(xbgr.mr_n71290448)
print v(xbgr.mr_n71290768)
print v(xbgr.mr_n71290880)
print v(xbgr.mr_n71291200)
print v(xbgr.mr_n71291312)
print v(xbgr.mr_n71291632)
print v(xbgr.mr_n71291744)
print v(xbgr.mr_n71292064)
print v(xbgr.mr_n71292176)
print v(xbgr.mr_n71292496)
print v(xbgr.mr_n71292608)
print v(xbgr.mr_n71292928)
print v(xbgr.mr_n71293040)
print v(xbgr.mr_n71293360)
print v(xbgr.mr_n71293472)
print v(xbgr.mr_n71293904)
print v(xbgr.mr_n71294224)
print v(xbgr.mr_n71294336)
print v(xbgr.mr_n71294768)
print v(xbgr.mr_n71295088)
print v(xbgr.mr_n71295952)
print v(xbgr.mr_n71296816)
print v(xbgr.mr_n71297680)
print v(xbgr.mr_n71298544)
print v(xbgr.mr_n71298656)
print v(xbgr.mr_n71298976)
print v(xbgr.mr_n71299088)
print v(xbgr.mr_n71299408)
print v(xbgr.mr_n71299520)
print v(xbgr.mr_n71299840)
print v(xbgr.mr_n71299952)
print v(xbgr.mr_n71300272)
print v(xbgr.mr_n71301136)
print v(xbgr.mr_n71302000)
print v(xbgr.mr_n71302112)
print v(xbgr.mr_n71302432)
print v(xbgr.mr_n71302544)
print v(xbgr.mr_n71302864)
print v(xbgr.mr_n71302976)
print v(xbgr.mr_n71303296)
print v(xbgr.mr_n71303408)
print v(xbgr.mr_n71303728)
print v(xbgr.mr_n71303840)
print v(xbgr.mr_n71304272)
print v(xbgr.mr_n71304592)
print v(xbgr.mr_n71304704)
print v(xbgr.mr_n71305136)
print v(xbgr.mr_n71305456)
print v(xbgr.mr_n71306320)
print v(xbgr.mr_n71307184)
print v(xbgr.mr_n71308048)
print v(xbgr.mr_n71308912)
print v(xbgr.mr_n71309024)
print v(xbgr.mr_n71309344)
print v(xbgr.mr_n71309456)
print v(xbgr.mr_n71309776)
print v(xbgr.mr_n71309888)
print v(xbgr.mr_n71310208)
print v(xbgr.mr_n71310320)
print v(xbgr.mr_n71310640)
print v(xbgr.mr_n71311504)
print v(xbgr.mr_n71312368)
print v(xbgr.mr_n71312480)
print v(xbgr.mr_n71312912)
print v(xbgr.mr_n71313232)
print v(xbgr.mr_n71313344)
print v(xbgr.mr_n71313664)
print v(xbgr.mr_n71313776)
print v(xbgr.mr_n71314096)
print v(xbgr.mr_n71314208)
print v(xbgr.mr_n71314528)
print v(xbgr.mr_n71314640)
print v(xbgr.mr_n71314960)
print v(xbgr.mr_n71315072)
print v(xbgr.mr_n71315504)
print v(xbgr.mr_n71315824)
print v(xbgr.mr_n71316688)
print v(xbgr.mr_n71316800)
print v(xbgr.mr_n71317232)
print v(xbgr.mr_n71317552)
print v(xbgr.mr_n71317664)
print v(xbgr.mr_n71318096)
print v(xbgr.mr_n71318416)
print v(xbgr.mr_n71318528)
print v(xbgr.mr_n71318848)
print v(xbgr.mr_n71318960)
print v(xbgr.mr_n71319280)
print v(xbgr.mr_n71319392)
print v(xbgr.mr_n71319712)
print v(xbgr.mr_n71319824)
print v(xbgr.mr_n71320144)
print v(xbgr.mr_n71321008)
print v(xbgr.mr_n71321872)
print v(xbgr.mr_n71321984)
print v(xbgr.mr_n71322304)
print v(xbgr.mr_n71322416)
print v(xbgr.mr_n71322736)
print v(xbgr.mr_n71322848)
print v(xbgr.mr_n71323168)
print v(xbgr.mr_n71323280)
print v(xbgr.mr_n71323600)
print v(xbgr.mr_n71324464)
print v(xbgr.mr_n71325328)
print v(xbgr.mr_n71325440)
print v(xbgr.mr_n71325760)
print v(xbgr.mr_n71325872)
print v(xbgr.mr_n71326192)
print v(xbgr.mr_n71327056)
print v(xbgr.mr_n71327168)
print v(xbgr.mr_n71327488)
print v(xbgr.mr_n71327600)
print v(xbgr.mr_n71327920)
print v(xbgr.mr_n71328032)
print v(xbgr.mr_n71328352)
print v(xbgr.mr_n71328464)
print v(xbgr.mr_n71328784)
print v(xbgr.mr_n71328896)
print v(xbgr.mr_n71329216)
print v(xbgr.mr_n71329328)
print v(xbgr.mr_n71329648)
print v(xbgr.mr_n71330512)
print v(xbgr.mr_n71331312)
print v(xbgr.mr_n71331424)
print v(xbgr.mr_n71331744)
print v(xbgr.mr_n71331856)
print v(xbgr.mr_n71332176)
print v(xbgr.mr_n71332288)
print v(xbgr.mr_n71332608)
print v(xbgr.mr_n71332720)
print v(xbgr.mr_n71333040)
print v(xbgr.mr_n71333152)
print v(xbgr.mr_n71333472)
print v(xbgr.mr_n71333584)
print v(xbgr.mr_n71333904)
print v(xbgr.mr_n71334016)
print v(xbgr.mr_n71334336)
print v(xbgr.mr_n71334448)
print v(xbgr.mr_n71334768)
print v(xbgr.mr_n71334880)
print v(xbgr.mr_n71335200)
print v(xbgr.mr_n71335312)
print v(xbgr.mr_n71335632)
print v(xbgr.mr_n71335744)
print v(xbgr.mr_n71336064)
print v(xbgr.mr_n71336176)
print v(xbgr.mr_n71336496)
print v(xbgr.mr_n71336608)
print v(xbgr.mr_n71336928)
print v(xbgr.mr_n71337040)
print v(xbgr.mr_n71337360)
print v(xbgr.mr_n71337472)
print v(xbgr.mr_n71337792)
print v(xbgr.mr_n71337904)
print v(xbgr.mr_n71338224)
print v(xbgr.mr_n71338336)
print v(xbgr.mr_n71338656)
print v(xbgr.mr_n71338768)
print v(xbgr.mr_n71339088)
print v(xbgr.mr_n71339200)
print v(xbgr.mr_n71339520)
print v(xbgr.mr_n71339632)
print v(xbgr.mr_n71339952)
print v(xbgr.mr_n71340064)
print v(xbgr.mr_n71340384)
print v(xbgr.mr_n71340496)
print v(xbgr.mr_n71340816)
print v(xbgr.mr_n71340928)
print v(xbgr.mr_n71341248)
print v(xbgr.mr_n71341360)
print v(xbgr.mr_n71341680)
print v(xbgr.mr_n71341792)
print v(xbgr.mr_n71342112)
print v(xbgr.mr_n71342224)
print v(xbgr.mr_n71342544)
print v(xbgr.mr_n71342656)
print v(xbgr.mr_n71342976)
print v(xbgr.mr_n71343088)
print v(xbgr.mr_n71343408)
print v(xbgr.mr_n71343520)
print v(xbgr.mr_n71343840)
print v(xbgr.mr_n71343952)
print v(xbgr.mr_n71344272)
print v(xbgr.mr_n71344384)
print v(xbgr.mr_n71344704)
print v(xbgr.mr_n71344816)
print v(xbgr.mr_n71345136)
print v(xbgr.mr_n71345248)
print v(xbgr.mr_n71345568)
print v(xbgr.mr_n71345680)
print v(xbgr.mr_n71346000)
print v(xbgr.mr_n71346112)
print v(xbgr.mr_n71346432)
print v(xbgr.mr_n71346544)
print v(xbgr.mr_n71346864)
print v(xbgr.mr_n71346976)
print v(xbgr.mr_n71347296)
print v(xbgr.mr_n71347408)
print v(xbgr.mr_n71347728)
print v(xbgr.mr_n71347840)
print v(xbgr.mr_n71348160)
print v(xbgr.mr_n71348272)
print v(xbgr.mr_n71348592)
print v(xbgr.mr_n71348704)
print v(xbgr.mr_n71349024)
print v(xbgr.mr_n71349136)
print v(xbgr.mr_n71349456)
print v(xbgr.mr_n71349568)
print v(xbgr.mr_n71349888)
print v(xbgr.mr_n71350000)
print v(xbgr.mr_n71350320)
print v(xbgr.mr_n71350432)
print v(xbgr.mr_n71350752)
print v(xbgr.mr_n71350864)
print v(xbgr.mr_n71351184)
print v(xbgr.mr_n71351296)
print v(xbgr.mr_n71351616)
print v(xbgr.mr_n71351728)
print v(xbgr.mr_n71352048)
print v(xbgr.mr_n71352160)
print v(xbgr.mr_n71352480)
print v(xbgr.mr_n71352592)
print v(xbgr.mr_n71352912)
print v(xbgr.mr_n71353024)
print v(xbgr.mr_n71353344)
print v(xbgr.mr_n71353456)
print v(xbgr.mr_n71353776)
print v(xbgr.mr_n71353888)
print v(xbgr.mr_n71354208)
print v(xbgr.mr_n71354320)
print v(xbgr.mr_n71354640)
print v(xbgr.mr_n71354752)
print v(xbgr.mr_n71355072)
print v(xbgr.mr_n71355184)
print v(xbgr.mr_n71355504)
print v(xbgr.mr_n71355616)
print v(xbgr.mr_n71355936)
print v(xbgr.mr_n71356048)
print v(xbgr.mr_n71356368)
print v(xbgr.mr_n71356480)
print v(xbgr.mr_n71356800)
print v(xbgr.mr_n71356912)
print v(xbgr.mr_n71357232)
print v(xbgr.mr_n71357344)
print v(xbgr.mr_n71357664)
print v(xbgr.mr_n71357776)
print v(xbgr.mr_n71358096)
print v(xbgr.mr_n71358208)
print v(xbgr.mr_n71358528)
print v(xbgr.mr_n71358640)
print v(xbgr.mr_n71358960)
print v(xbgr.mr_n71359072)
print v(xbgr.mr_n71359392)
print v(xbgr.mr_n71359504)
print v(xbgr.mr_n71359824)
print v(xbgr.mr_n71359936)
print v(xbgr.mr_n71360256)
print v(xbgr.mr_n71360368)
print v(xbgr.mr_n71360688)
print v(xbgr.mr_n71360800)
print v(xbgr.mr_n71361120)
print v(xbgr.mr_n71361232)
print v(xbgr.mr_n71361552)
print v(xbgr.mr_n71361664)
print v(xbgr.mr_n71361984)
print v(xbgr.mr_n71362096)
print v(xbgr.mr_n71362416)
print v(xbgr.mr_n71362528)
print v(xbgr.mr_n71362848)
print v(xbgr.mr_n71362960)
print v(xbgr.mr_n71363280)
print v(xbgr.mr_n71363392)
print v(xbgr.mr_n71363712)
print v(xbgr.mr_n71363824)
print v(xbgr.mr_n71364144)
print v(xbgr.mr_n71364256)
print v(xbgr.mr_n71364576)
print v(xbgr.mr_n71364688)
print v(xbgr.mr_n71365008)
print v(xbgr.mr_n71365120)
print v(xbgr.mr_n71365440)
print v(xbgr.mr_n71365552)
print v(xbgr.mr_n71365872)
print v(xbgr.mr_n71365984)
print v(xbgr.mr_n71366304)
print v(xbgr.mr_n71366416)
print v(xbgr.mr_n71366736)
print v(xbgr.mr_n71366848)
print v(xbgr.mr_n71367168)
print v(xbgr.mr_n71367280)
print v(xbgr.mr_n71367600)
print v(xbgr.mr_n71367712)
print v(xbgr.mr_n71368032)
print v(xbgr.mr_n71368144)
print v(xbgr.mr_n71368464)
print v(xbgr.mr_n71368576)
print v(xbgr.mr_n71368896)
print v(xbgr.mr_n71369008)
print v(xbgr.mr_n71369328)
print v(xbgr.mr_n71369440)
print v(xbgr.mr_n71369760)
print v(xbgr.mr_n71369872)
print v(xbgr.mr_n71370192)
print v(xbgr.mr_n71370304)
print v(xbgr.mr_n71370624)
print v(xbgr.mr_n71370736)
print v(xbgr.mr_n71371056)
print v(xbgr.mr_n71371168)
print v(xbgr.mr_n71371488)
print v(xbgr.mr_n71371600)
print v(xbgr.mr_n71371920)
print v(xbgr.mr_n71372032)
print v(xbgr.mr_n71372352)
print v(xbgr.mr_n71372464)
print v(xbgr.mr_n71372784)
print v(xbgr.mr_n71372896)
print v(xbgr.mr_n71373216)
print v(xbgr.mr_n71373328)
print v(xbgr.mr_n71373648)
print v(xbgr.mr_n71373760)
print v(xbgr.mr_n71374080)
print v(xbgr.mr_n71374192)
print v(xbgr.mr_n71374512)
print v(xbgr.mr_n71374624)
print v(xbgr.mr_n71374944)
print v(xbgr.mr_n71375056)
print v(xbgr.mr_n71375376)
print v(xbgr.mr_n71375488)
print v(xbgr.mr_n71375808)
print v(xbgr.mr_n71375920)
print v(xbgr.mr_n71376240)
print v(xbgr.mr_n71376352)
print v(xbgr.mr_n71376672)
print v(xbgr.mr_n71376784)
print v(xbgr.mr_n71377104)
print v(xbgr.mr_n71377216)
print v(xbgr.mr_n71377536)
print v(xbgr.mr_n71377648)
print v(xbgr.mr_n71377968)
print v(xbgr.mr_n71378080)
print v(xbgr.mr_n71378400)
print v(xbgr.mr_n71378512)
print v(xbgr.mr_n71378832)
print v(xbgr.mr_n71378944)
print v(xbgr.mr_n71379264)
print v(xbgr.mr_n71379376)
print v(xbgr.mr_n71379696)
print v(xbgr.mr_n71379808)
print v(xbgr.mr_n71380128)
print v(xbgr.mr_n71380240)
print v(xbgr.mr_n71380560)
print v(xbgr.mr_n71380672)
print v(xbgr.mr_n71380992)
print v(xbgr.mr_n71381104)
print v(xbgr.mr_n71381424)
print v(xbgr.mr_n71381536)
print v(xbgr.mr_n71381856)
print v(xbgr.mr_n71381968)
print v(xbgr.mr_n71382288)
print v(xbgr.mr_n71382400)
print v(xbgr.mr_n71382720)
print v(xbgr.mr_n71382832)
print v(xbgr.mr_n71383152)
print v(xbgr.mr_n71383264)
print v(xbgr.mr_n71383584)
print v(xbgr.mr_n71383696)
print v(xbgr.mr_n71384016)
print v(xbgr.mr_n71384128)
print v(xbgr.mr_n71384448)
print v(xbgr.mr_n71384560)
print v(xbgr.mr_n71384880)
print v(xbgr.mr_n71384992)
print v(xbgr.mr_n71385312)
print v(xbgr.mr_n71385424)
print v(xbgr.mr_n71385744)
print v(xbgr.mr_n71385856)
print v(xbgr.mr_n71386176)
print v(xbgr.mr_n71386288)
print v(xbgr.mr_n71386608)
print v(xbgr.mr_n71386720)
print v(xbgr.mr_n71387040)
print v(xbgr.mr_n71387152)
print v(xbgr.mr_n71387472)
print v(xbgr.mr_n71387584)
print v(xbgr.mr_n71387904)
print v(xbgr.mr_n71388016)
print v(xbgr.mr_n71388336)
print v(xbgr.mr_n71388448)
print v(xbgr.mr_n71388768)
print v(xbgr.mr_n71388880)
print v(xbgr.mr_n71389200)
print v(xbgr.mr_n71389312)
print v(xbgr.mr_n71389632)
print v(xbgr.mr_n71389744)
print v(xbgr.mr_n71390064)
print v(xbgr.mr_n71390176)
print v(xbgr.mr_n71390496)
print v(xbgr.mr_n71390608)
print v(xbgr.mr_n71390928)
print v(xbgr.mr_n71391040)
print v(xbgr.mr_n71391360)
print v(xbgr.mr_n71391472)
print v(xbgr.mr_n71391792)
print v(xbgr.mr_n71391904)
print v(xbgr.mr_n71392224)
print v(xbgr.mr_n71392336)
print v(xbgr.mr_n71392656)
print v(xbgr.mr_n71392768)
print v(xbgr.mr_n71393088)
print v(xbgr.mr_n71393200)
print v(xbgr.mr_n71393520)
print v(xbgr.mr_n71393632)
print v(xbgr.mr_n71393952)
print v(xbgr.mr_n71394064)
print v(xbgr.mr_n71394384)
print v(xbgr.mr_n71394496)
print v(xbgr.mr_n71394816)
print v(xbgr.mr_n71394928)
print v(xbgr.mr_n71395248)
print v(xbgr.mr_n71395360)
print v(xbgr.mr_n71395680)
print v(xbgr.mr_n71395792)
print v(xbgr.mr_n71396112)
print v(xbgr.mr_n71396224)
print v(xbgr.mr_n71396544)
print v(xbgr.mr_n71396656)
print v(xbgr.mr_n71396976)
print v(xbgr.mr_n71397088)
print v(xbgr.mr_n71397408)
print v(xbgr.mr_n71397520)
print v(xbgr.mr_n71397840)
print v(xbgr.mr_n71397952)
print v(xbgr.mr_n71398272)
print v(xbgr.mr_n71398384)
print v(xbgr.mr_n71398704)
print v(xbgr.mr_n71398816)
print v(xbgr.mr_n71399136)
print v(xbgr.mr_n71399248)
print v(xbgr.mr_n71399568)
print v(xbgr.mr_n71399680)
print v(xbgr.mr_n71400000)
print v(xbgr.mr_n71400112)
print v(xbgr.mr_n71400432)
print v(xbgr.mr_n71400544)
print v(xbgr.mr_n71400864)
print v(xbgr.mr_n71400976)
print v(xbgr.mr_n71401296)
print v(xbgr.mr_n71401408)
print v(xbgr.mr_n71401728)
print v(xbgr.mr_n71401840)
print v(xbgr.mr_n71402160)
print v(xbgr.mr_n71402272)
print v(xbgr.mr_n71402592)
print v(xbgr.mr_n71402704)
print v(xbgr.mr_n71403024)
print v(xbgr.mr_n71403136)
print v(xbgr.mr_n71403456)
print v(xbgr.mr_n71403568)
print v(xbgr.mr_n71403888)
print v(xbgr.mr_n71404000)
print v(xbgr.mr_n71404320)
print v(xbgr.mr_n71404432)
print v(xbgr.mr_n71404752)
print v(xbgr.mr_n71404864)
print v(xbgr.mr_n71405184)
print v(xbgr.mr_n71405296)
print v(xbgr.mr_n71405616)
print v(xbgr.mr_n71405728)
print v(xbgr.mr_n71406048)
print v(xbgr.mr_n71406160)
print v(xbgr.mr_n71406480)
print v(xbgr.mr_n71406592)
print v(xbgr.mr_n71406912)
print v(xbgr.mr_n71407024)
print v(xbgr.mr_n71407344)
print v(xbgr.mr_n71407456)
print v(xbgr.mr_n71407776)
print v(xbgr.mr_n71407888)
print v(xbgr.mr_n71408208)
print v(xbgr.mr_n71408320)
print v(xbgr.mr_n71408640)
print v(xbgr.mr_n71408752)
print v(xbgr.mr_n71409072)
print v(xbgr.mr_n71409184)
print v(xbgr.mr_n71409504)
print v(xbgr.mr_n71409616)
print v(xbgr.mr_n71409936)
print v(xbgr.mr_n71410048)
print v(xbgr.mr_n71410368)
print v(xbgr.mr_n71410480)
print v(xbgr.mr_n71410800)
print v(xbgr.mr_n71410912)
print v(xbgr.mr_n71411232)
print v(xbgr.mr_n71411344)
print v(xbgr.mr_n71411664)
print v(xbgr.mr_n71411776)
print v(xbgr.mr_n71412096)
print v(xbgr.mr_n71412208)
print v(xbgr.mr_n71412528)
print v(xbgr.mr_n71412640)
print v(xbgr.mr_n71412960)
print v(xbgr.mr_n71413072)
print v(xbgr.mr_n71413392)
print v(xbgr.mr_n71413504)
print v(xbgr.mr_n71413824)
print v(xbgr.mr_n71413936)
print v(xbgr.mr_n71414256)
print v(xbgr.mr_n71414368)
print v(xbgr.mr_n71414688)
print v(xbgr.mr_n71414800)
print v(xbgr.mr_n71415120)
print v(xbgr.mr_n71415232)
print v(xbgr.mr_n71415552)
print v(xbgr.mr_n71415664)
print v(xbgr.mr_n71415984)
print v(xbgr.mr_n71416096)
print v(xbgr.mr_n71416416)
print v(xbgr.mr_n71416528)
print v(xbgr.mr_n71416848)
print v(xbgr.mr_n71416960)
print v(xbgr.mr_n71417280)
print v(xbgr.mr_n71417392)
print v(xbgr.mr_n71417712)
print v(xbgr.mr_n71417824)
print v(xbgr.mr_n71418144)
print v(xbgr.mr_n71418256)
print v(xbgr.mr_n71418576)
print v(xbgr.mr_n71418688)
print v(xbgr.mr_n71419008)
print v(xbgr.mr_n71419120)
print v(xbgr.mr_n71419440)
print v(xbgr.mr_n71419552)
print v(xbgr.mr_n71419872)
print v(xbgr.mr_n71419984)
print v(xbgr.mr_n71420304)
print v(xbgr.mr_n71420416)
print v(xbgr.mr_n71420736)
print v(xbgr.mr_n71420848)
print v(xbgr.mr_n71421168)
print v(xbgr.mr_n71421280)
print v(xbgr.mr_n71421600)
print v(xbgr.mr_n71421712)
print v(xbgr.mr_n71422032)
print v(xbgr.mr_n71422144)
print v(xbgr.mr_n71422464)
print v(xbgr.mr_n71422576)
print v(xbgr.mr_n71422896)
print v(xbgr.mr_n71423008)
print v(xbgr.mr_n71423328)
print v(xbgr.mr_n71423440)
print v(xbgr.mr_n71423760)
print v(xbgr.mr_n71423872)
print v(xbgr.mr_n71424192)
print v(xbgr.mr_n71424304)
print v(xbgr.mr_n71424624)
print v(xbgr.mr_n71424736)
print v(xbgr.mr_n71425056)
print v(xbgr.mr_n71425168)
print v(xbgr.mr_n71425488)
print v(xbgr.mr_n71425600)
print v(xbgr.mr_n71425920)
print v(xbgr.mr_n71426032)
print v(xbgr.mr_n71426352)
print v(xbgr.mr_n71426464)
print v(xbgr.mr_n71426784)
print v(xbgr.mr_n71426896)
print v(xbgr.mr_n71427216)
print v(xbgr.mr_n71427328)
print v(xbgr.mr_n71427648)
print v(xbgr.mr_n71427760)
print v(xbgr.mr_n71428080)
print v(xbgr.mr_n71428192)
print v(xbgr.mr_n71428512)
print v(xbgr.mr_n71428624)
print v(xbgr.mr_n71428944)
print v(xbgr.mr_n71429056)
print v(xbgr.mr_n71429376)
print v(xbgr.mr_n71429488)
print v(xbgr.mr_n71429808)
print v(xbgr.mr_n71429920)
print v(xbgr.mr_n71430240)
print v(xbgr.mr_n71430352)
print v(xbgr.mr_n71430672)
print v(xbgr.mr_n71430784)
print v(xbgr.mr_n71431104)
print v(xbgr.mr_n71431216)
print v(xbgr.mr_n71431536)
print v(xbgr.mr_n71431648)
print v(xbgr.mr_n71431968)
print v(xbgr.mr_n71432080)
print v(xbgr.mr_n71432400)
print v(xbgr.mr_n71432512)
print v(xbgr.mr_n71432832)
print v(xbgr.mr_n71432944)
print v(xbgr.mr_n71433264)
print v(xbgr.mr_n71433376)
print v(xbgr.mr_n71433696)
print v(xbgr.mr_n71433808)
print v(xbgr.mr_n71434128)
print v(xbgr.mr_n71434240)
print v(xbgr.mr_n71434560)
print v(xbgr.mr_n71434672)
print v(xbgr.mr_n71434992)
print v(xbgr.mr_n71435104)
print v(xbgr.mr_n71435424)
print v(xbgr.mr_n71435536)
print v(xbgr.mr_n71435856)
print v(xbgr.mr_n71435968)
print v(xbgr.mr_n71436288)
print v(xbgr.mr_n71436400)
print v(xbgr.mr_n71436720)
print v(xbgr.mr_n71436832)
print v(xbgr.mr_n71437152)
print v(xbgr.mr_n71437264)
print v(xbgr.mr_n71437584)
print v(xbgr.mr_n71437696)
print v(xbgr.mr_n71438016)
print v(xbgr.mr_n71438128)
print v(xbgr.mr_n71438448)
print v(xbgr.mr_n71438560)
print v(xbgr.mr_n71438880)
print v(xbgr.mr_n71438992)
print v(xbgr.mr_n71439312)
print v(xbgr.mr_n71439424)
print v(xbgr.mr_n71439744)
print v(xbgr.mr_n71439856)
print v(xbgr.mr_n71440176)
print v(xbgr.mr_n71440288)
print v(xbgr.mr_n71440608)
print v(xbgr.mr_n71440720)
print v(xbgr.mr_n71441040)
print v(xbgr.mr_n71441152)
print v(xbgr.mr_n71441472)
print v(xbgr.mr_n71441584)
print v(xbgr.mr_n71441904)
print v(xbgr.mr_n71442016)
print v(xbgr.mr_n71442336)
print v(xbgr.mr_n71442448)
print v(xbgr.mr_n71442768)
print v(xbgr.mr_n71442880)
print v(xbgr.mr_n71443200)
print v(xbgr.mr_n71443312)
print v(xbgr.mr_n71443632)
print v(xbgr.mr_n71443744)
print v(xbgr.mr_n71444064)
print v(xbgr.mr_n71444176)
print v(xbgr.mr_n71444496)
print v(xbgr.mr_n71444608)
print v(xbgr.mr_n71444928)
print v(xbgr.mr_n71445040)
print v(xbgr.mr_n71445360)
print v(xbgr.mr_n71445472)
print v(xbgr.mr_n71445792)
print v(xbgr.mr_n71445904)
print v(xbgr.mr_n71446224)
print v(xbgr.mr_n71446336)
print v(xbgr.mr_n71446656)
print v(xbgr.mr_n71446768)
print v(xbgr.mr_n71447088)
print v(xbgr.mr_n71447200)
print v(xbgr.mr_n71447520)
print v(xbgr.mr_n71447632)
print v(xbgr.mr_n71447952)
print v(xbgr.mr_n71448064)
print v(xbgr.mr_n71448384)
print v(xbgr.mr_n71448496)
print v(xbgr.mr_n71448816)
print v(xbgr.mr_n71448928)
print v(xbgr.mr_n71449248)
print v(xbgr.mr_n71449360)
print v(xbgr.mr_n71449680)
print v(xbgr.mr_n71449792)
print v(xbgr.mr_n71450112)
print v(xbgr.mr_n71450224)
print v(xbgr.mr_n71450544)
print v(xbgr.mr_n71450656)
print v(xbgr.mr_n71450976)
print v(xbgr.mr_n71451088)
print v(xbgr.mr_n71451408)
print v(xbgr.mr_n71451520)
print v(xbgr.mr_n71451840)
print v(xbgr.mr_n71451952)
print v(xbgr.mr_n71452272)
print v(xbgr.mr_n71452384)
print v(xbgr.mr_n71452704)
print v(xbgr.mr_n71452816)
print v(xbgr.mr_n71453136)
print v(xbgr.mr_n71453248)
print v(xbgr.mr_n71453568)
print v(xbgr.mr_n71453680)
print v(xbgr.mr_n71454000)
print v(xbgr.mr_n71454112)
print v(xbgr.mr_n71454432)
print v(xbgr.mr_n71454544)
print v(xbgr.mr_n71454864)
print v(xbgr.mr_n71454976)
print v(xbgr.mr_n71455296)
print v(xbgr.mr_n71455408)
print v(xbgr.mr_n71455728)
print v(xbgr.mr_n71455840)
print v(xbgr.mr_n71456160)
print v(xbgr.mr_n71456272)
print v(xbgr.mr_n71456592)
print v(xbgr.mr_n71456704)
print v(xbgr.mr_n71457024)
print v(xbgr.mr_n71457136)
print v(xbgr.mr_n71457456)
print v(xbgr.mr_n71457568)
print v(xbgr.mr_n71457888)
print v(xbgr.mr_n71458000)
print v(xbgr.mr_n71458320)
print v(xbgr.mr_n71458432)
print v(xbgr.mr_n71458752)
print v(xbgr.mr_n71458864)
print v(xbgr.mr_n71459184)
print v(xbgr.mr_n71459296)
print v(xbgr.mr_n71459616)
print v(xbgr.mr_n71459728)
print v(xbgr.mr_n71460048)
print v(xbgr.mr_n71460160)
print v(xbgr.mr_n71460480)
print v(xbgr.mr_n71460592)
print v(xbgr.mr_n71460912)
print v(xbgr.mr_n71461024)
print v(xbgr.mr_n71461344)
print v(xbgr.mr_n71461456)
print v(xbgr.mr_n71461776)
print v(xbgr.mr_n71461888)
print v(xbgr.mr_n71462208)
print v(xbgr.mr_n71462320)
print v(xbgr.mr_n71462640)
print v(xbgr.mr_n71462752)
print v(xbgr.mr_n71463072)
print v(xbgr.mr_n71463184)
print v(xbgr.mr_n71463504)
print v(xbgr.mr_n71463616)
print v(xbgr.mr_n71463936)
print v(xbgr.mr_n71464048)
print v(xbgr.mr_n71464368)
print v(xbgr.mr_n71464480)
print v(xbgr.mr_n71464800)
print v(xbgr.mr_n71464912)
print v(xbgr.mr_n71465232)
print v(xbgr.mr_n71465344)
print v(xbgr.mr_n71465664)
print v(xbgr.mr_n71465776)
print v(xbgr.mr_n71466096)
print v(xbgr.mr_n71466208)
print v(xbgr.mr_n71466528)
print v(xbgr.mr_n71466640)
print v(xbgr.mr_n71466960)
print v(xbgr.mr_n71467072)
print v(xbgr.mr_n71467392)
print v(xbgr.mr_n71467504)
print v(xbgr.mr_n71467824)
print v(xbgr.mr_n71467936)
print v(xbgr.mr_n71468256)
print v(xbgr.mr_n71468368)
print v(xbgr.mr_n71468688)
print v(xbgr.mr_n71468800)
print v(xbgr.mr_n71469120)
print v(xbgr.mr_n71469232)
print v(xbgr.mr_n71469552)
print v(xbgr.mr_n71469664)
print v(xbgr.mr_n71469984)
print v(xbgr.mr_n71470096)
print v(xbgr.mr_n71470416)
print v(xbgr.mr_n71470528)
print v(xbgr.mr_n71470848)
print v(xbgr.mr_n71470960)
print v(xbgr.mr_n71471280)
print v(xbgr.mr_n71471392)
print v(xbgr.mr_n71471712)
print v(xbgr.mr_n71471824)
print v(xbgr.mr_n71472144)
print v(xbgr.mr_n71472256)
print v(xbgr.mr_n71472576)
print v(xbgr.mr_n71472688)
print v(xbgr.mr_n71473008)
print v(xbgr.mr_n71473120)
print v(xbgr.mr_n71473440)
print v(xbgr.mr_n71473552)
print v(xbgr.mr_n71473872)
print v(xbgr.mr_n71473984)
print v(xbgr.mr_n71474304)
print v(xbgr.mr_n71474416)
print v(xbgr.mr_n71474736)
print v(xbgr.mr_n71474848)
print v(xbgr.mr_n71475168)
print v(xbgr.mr_n71475280)
print v(xbgr.mr_n71475600)
print v(xbgr.mr_n71475712)
print v(xbgr.mr_n71476032)
print v(xbgr.mr_n71476144)
print v(xbgr.mr_n71476464)
print v(xbgr.mr_n71476576)
print v(xbgr.mr_n71476896)
print v(xbgr.mr_n71477008)
print v(xbgr.mr_n71477328)
print v(xbgr.mr_n71477440)
print v(xbgr.mr_n71477760)
print v(xbgr.mr_n71477872)
print v(xbgr.mr_n71478192)
print v(xbgr.mr_n71478304)
print v(xbgr.mr_n71478624)
print v(xbgr.mr_n71478736)
print v(xbgr.mr_n71479056)
print v(xbgr.mr_n71479168)
print v(xbgr.mr_n71479488)
print v(xbgr.mr_n71479600)
print v(xbgr.mr_n71479920)
print v(xbgr.mr_n71480032)
print v(xbgr.mr_n71480352)
print v(xbgr.mr_n71480464)
print v(xbgr.mr_n71480784)
print v(xbgr.mr_n71480896)
print v(xbgr.mr_n71481216)
print v(xbgr.mr_n71481328)
print v(xbgr.mr_n71481648)
print v(xbgr.mr_n71481760)
print v(xbgr.mr_n71482080)
print v(xbgr.mr_n71482192)
print v(xbgr.mr_n71482512)
print v(xbgr.mr_n71482624)
print v(xbgr.mr_n71482944)
print v(xbgr.mr_n71483056)
print v(xbgr.mr_n71483376)
print v(xbgr.mr_n71483488)
print v(xbgr.mr_n71483808)
print v(xbgr.mr_n71483920)
print v(xbgr.mr_n71484240)
print v(xbgr.mr_n71484352)
print v(xbgr.mr_n71484672)
print v(xbgr.mr_n71484784)
print v(xbgr.mr_n71485104)
print v(xbgr.mr_n71485216)
print v(xbgr.mr_n71485536)
print v(xbgr.mr_n71485648)
print v(xbgr.mr_n71485968)
print v(xbgr.mr_n71486080)
print v(xbgr.mr_n71486400)
print v(xbgr.mr_n71486512)
print v(xbgr.mr_n71486832)
print v(xbgr.mr_n71486944)
print v(xbgr.mr_n71487264)
print v(xbgr.mr_n71487376)
print v(xbgr.mr_n71487696)
print v(xbgr.mr_n71487808)
print v(xbgr.mr_n71488128)
print v(xbgr.mr_n71488240)
print v(xbgr.mr_n71488560)
print v(xbgr.mr_n71488672)
print v(xbgr.mr_n71488992)
print v(xbgr.mr_n71489104)
print v(xbgr.mr_n71489424)
print v(xbgr.mr_n71489536)
print v(xbgr.mr_n71489856)
print v(xbgr.mr_n71489968)
print v(xbgr.mr_n71490288)
print v(xbgr.mr_n71490400)
print v(xbgr.mr_n71490720)
print v(xbgr.mr_n71490832)
print v(xbgr.mr_n71491152)
print v(xbgr.mr_n71491264)
print v(xbgr.mr_n71491584)
print v(xbgr.mr_n71491696)
print v(xbgr.mr_n71492016)
print v(xbgr.mr_n71492128)
print v(xbgr.mr_n71492448)
print v(xbgr.mr_n71492880)
print v(xbgr.mr_n71492992)
print v(xbgr.mr_n71493312)
print v(xbgr.mr_n71493744)
print v(xbgr.mr_n71493856)
print v(xbgr.mr_n71494176)
print v(xbgr.mr_n71494288)
print v(xbgr.mr_n71494608)
print v(xbgr.mr_n71494720)
print v(xbgr.mr_n71495040)
print v(xbgr.mr_n71495152)
print v(xbgr.mr_n71495472)
print v(xbgr.mr_n71495584)
print v(xbgr.mr_n71495904)
print v(xbgr.mr_n71496016)
print v(xbgr.mr_n71496336)
print v(xbgr.mr_n71496448)
print v(xbgr.mr_n71496768)
print v(xbgr.mr_n71496880)
print v(xbgr.mr_n71497200)
print v(xbgr.mr_n71497312)
print v(xbgr.mr_n71497632)
print v(xbgr.mr_n71497744)
print v(xbgr.mr_n71498064)
print v(xbgr.mr_n71498176)
print v(xbgr.mr_n71498496)
print v(xbgr.mr_n71498608)
print v(xbgr.mr_n71498928)
print v(xbgr.mr_n71499040)
print v(xbgr.mr_n71499360)
print v(xbgr.mr_n71499472)
print v(xbgr.mr_n71499792)
print v(xbgr.mr_n71499904)
print v(xbgr.mr_n71500224)
print v(xbgr.mr_n71500336)
print v(xbgr.mr_n71500656)
print v(xbgr.mr_n71500768)
print v(xbgr.mr_n71501088)
print v(xbgr.mr_n71501200)
print v(xbgr.mr_n71501520)
print v(xbgr.mr_n71501632)
print v(xbgr.mr_n71501952)
print v(xbgr.mr_n71502064)
print v(xbgr.mr_n71502384)
print v(xbgr.mr_n71502496)
print v(xbgr.mr_n71502816)
print v(xbgr.mr_n71502928)
print v(xbgr.mr_n71503248)
print v(xbgr.mr_n71503680)
print v(xbgr.mr_n71503792)
print v(xbgr.mr_n71504112)
print v(xbgr.mr_n71504544)
print v(xbgr.mr_n71504656)
print v(xbgr.mr_n71504976)
print v(xbgr.mr_n71505408)
print v(xbgr.mr_n71505520)
print v(xbgr.mr_n71505840)
print v(xbgr.mr_n71506272)
print v(xbgr.mr_n71506384)
print v(xbgr.mr_n71506704)
print v(xbgr.mr_n71507136)
print v(xbgr.mr_n71507248)
print v(xbgr.mr_n71507568)
print v(xbgr.mr_n71507680)
print v(xbgr.mr_n71508000)
print v(xbgr.mr_n71508112)
print v(xbgr.mr_n71508432)
print v(xbgr.mr_n71508544)
print v(xbgr.mr_n71508864)
print v(xbgr.mr_n71508976)
print v(xbgr.mr_n71509296)
print v(xbgr.mr_n71509408)
print v(xbgr.mr_n71509728)
print v(xbgr.mr_n71509840)
print v(xbgr.mr_n71510160)
print v(xbgr.mr_n71510272)
print v(xbgr.mr_n71510592)
print v(xbgr.mr_n71510704)
print v(xbgr.mr_n71511024)
print v(xbgr.mr_n71511136)
print v(xbgr.mr_n71511456)
print v(xbgr.mr_n71511568)
print v(xbgr.mr_n71511888)
print v(xbgr.mr_n71512000)
print v(xbgr.mr_n71512320)
print v(xbgr.mr_n71512432)
print v(xbgr.mr_n71512752)
print v(xbgr.mr_n71512864)
print v(xbgr.mr_n71513184)
print v(xbgr.mr_n71513296)
print v(xbgr.mr_n71513616)
print v(xbgr.mr_n71513728)
print v(xbgr.mr_n71514048)
print v(xbgr.mr_n71514160)
print v(xbgr.mr_n71514480)
print v(xbgr.mr_n71514592)
print v(xbgr.mr_n71514912)
print v(xbgr.mr_n71515024)
print v(xbgr.mr_n71515344)
print v(xbgr.mr_n71515456)
print v(xbgr.mr_n71515776)
print v(xbgr.mr_n71515888)
print v(xbgr.mr_n71516208)
print v(xbgr.mr_n71516320)
print v(xbgr.mr_n71516640)
print v(xbgr.mr_n71516752)
print v(xbgr.mr_n71517072)
print v(xbgr.mr_n71517184)
print v(xbgr.mr_n71517504)
print v(xbgr.mr_n71517616)
print v(xbgr.mr_n71517936)
print v(xbgr.mr_n71518048)
print v(xbgr.mr_n71518368)
print v(xbgr.mr_n71518480)
print v(xbgr.mr_n71518800)
print v(xbgr.mr_n71518912)
print v(xbgr.mr_n71519232)
print v(xbgr.mr_n71519344)
print v(xbgr.mr_n71519664)
print v(xbgr.mr_n71519776)
print v(xbgr.mr_n71520096)
print v(xbgr.mr_n71520208)
print v(xbgr.mr_n71520528)
print v(xbgr.mr_n71520640)
print v(xbgr.mr_n71520960)
print v(xbgr.mr_n71521072)
print v(xbgr.mr_n71521392)
print v(xbgr.mr_n71521504)
print v(xbgr.mr_n71521824)
print v(xbgr.mr_n71521936)
print v(xbgr.mr_n71522256)
print v(xbgr.mr_n71522368)
print v(xbgr.mr_n71522688)
print v(xbgr.mr_n71522800)
print v(xbgr.mr_n71523120)
print v(xbgr.mr_n71523232)
print v(xbgr.mr_n71523552)
print v(xbgr.mr_n71523664)
print v(xbgr.mr_n71523984)
print v(xbgr.mr_n71524096)
print v(xbgr.mr_n71524416)
print v(xbgr.mr_n71524528)
print v(xbgr.mr_n71524848)
print v(xbgr.mr_n71524960)
print v(xbgr.mr_n71525280)
print v(xbgr.mr_n71525392)
print v(xbgr.mr_n71525712)
print v(xbgr.mr_n71525824)
print v(xbgr.mr_n71526144)
print v(xbgr.mr_n71526256)
print v(xbgr.mr_n71526576)
print v(xbgr.mr_n71526688)
print v(xbgr.mr_n71527008)
print v(xbgr.mr_n71527440)
print v(xbgr.mr_n71527552)
print v(xbgr.mr_n71527872)
print v(xbgr.mr_n71528304)
print v(xbgr.mr_n71528416)
print v(xbgr.mr_n71528736)
print v(xbgr.mr_n71529168)
print v(xbgr.mr_n71529280)
print v(xbgr.mr_n71529600)
print v(xbgr.mr_n71529712)
print v(xbgr.mr_n71530032)
print v(xbgr.mr_n71530144)
print v(xbgr.mr_n71530464)
print v(xbgr.mr_n71530576)
print v(xbgr.mr_n71530896)
print v(xbgr.mr_n71531008)
print v(xbgr.mr_n71531328)
print v(xbgr.mr_n71531440)
print v(xbgr.mr_n71531760)
print v(xbgr.mr_n71531872)
print v(xbgr.mr_n71532192)
print v(xbgr.mr_n71532304)
print v(xbgr.mr_n71532624)
print v(xbgr.mr_n71532736)
print v(xbgr.mr_n71533056)
print v(xbgr.mr_n71533168)
print v(xbgr.mr_n71533488)
print v(xbgr.mr_n71533600)
print v(xbgr.mr_n71533920)
print v(xbgr.mr_n71534032)
print v(xbgr.mr_n71534352)
print v(xbgr.mr_n71534464)
print v(xbgr.mr_n71534784)
print v(xbgr.mr_n71534896)
print v(xbgr.mr_n71535216)
print v(xbgr.mr_n71535328)
print v(xbgr.mr_n71535648)
print v(xbgr.mr_n71535760)
print v(xbgr.mr_n71536080)
print v(xbgr.mr_n71536192)
print v(xbgr.mr_n71536512)
print v(xbgr.mr_n71536624)
print v(xbgr.mr_n71536944)
print v(xbgr.mr_n71537056)
print v(xbgr.mr_n71537376)
print v(xbgr.mr_n71537488)
print v(xbgr.mr_n71537808)
print v(xbgr.mr_n71537920)
print v(xbgr.mr_n71538240)
print v(xbgr.mr_n71538352)
print v(xbgr.mr_n71538672)
print v(xbgr.mr_n71538784)
print v(xbgr.mr_n71539104)
print v(xbgr.mr_n71539216)
print v(xbgr.mr_n71539536)
print v(xbgr.mr_n71539648)
print v(xbgr.mr_n71539968)
print v(xbgr.mr_n71540080)
print v(xbgr.mr_n71540400)
print v(xbgr.mr_n71540512)
print v(xbgr.mr_n71540832)
print v(xbgr.mr_n71540944)
print v(xbgr.mr_n71541264)
print v(xbgr.mr_n71541376)
print v(xbgr.mr_n71541696)
print v(xbgr.mr_n71541808)
print v(xbgr.mr_n71542128)
print v(xbgr.mr_n71542240)
print v(xbgr.mr_n71542560)
print v(xbgr.mr_n71542672)
print v(xbgr.mr_n71542992)
print v(xbgr.mr_n71543104)
print v(xbgr.mr_n71543424)
print v(xbgr.mr_n71543536)
print v(xbgr.mr_n71543856)
print v(xbgr.mr_n71543968)
print v(xbgr.mr_n71544288)
print v(xbgr.mr_n71544400)
print v(xbgr.mr_n71544720)
print v(xbgr.mr_n71544832)
print v(xbgr.mr_n71545152)
print v(xbgr.mr_n71545264)
print v(xbgr.mr_n71545584)
print v(xbgr.mr_n71545696)
print v(xbgr.mr_n71546016)
print v(xbgr.mr_n71546128)
print v(xbgr.mr_n71546448)
print v(xbgr.mr_n71546560)
print v(xbgr.mr_n71546880)
print v(xbgr.mr_n71546992)
print v(xbgr.mr_n71547312)
print v(xbgr.mr_n71547424)
print v(xbgr.mr_n71547744)
print v(xbgr.mr_n71547856)
print v(xbgr.mr_n71548176)
print v(xbgr.mr_n71548288)
print v(xbgr.mr_n71548608)
print v(xbgr.mr_n71548720)
print v(xbgr.mr_n71549040)
print v(xbgr.mr_n71549152)
print v(xbgr.mr_n71549472)
print v(xbgr.mr_n71549584)
print v(xbgr.mr_n71549904)
print v(xbgr.mr_n71550016)
print v(xbgr.mr_n71550336)
print v(xbgr.mr_n71550448)
print v(xbgr.mr_n71550768)
print v(xbgr.mr_n71550880)
print v(xbgr.mr_n71551200)
print v(xbgr.mr_n71551312)
print v(xbgr.mr_n71551632)
print v(xbgr.mr_n71551744)
print v(xbgr.mr_n71552064)
print v(xbgr.mr_n71552176)
print v(xbgr.mr_n71552496)
print v(xbgr.mr_n71552608)
print v(xbgr.mr_n71552928)
print v(xbgr.mr_n71553040)
print v(xbgr.mr_n71553360)
print v(xbgr.mr_n71553472)
print v(xbgr.mr_n71553792)
print v(xbgr.mr_n71553904)
print v(xbgr.mr_n71554224)
print v(xbgr.mr_n71554336)
print v(xbgr.mr_n71554656)
print v(xbgr.mr_n71554768)
print v(xbgr.mr_n71555088)
print v(xbgr.mr_n71555200)
print v(xbgr.mr_n71555520)
print v(xbgr.mr_n71555632)
print v(xbgr.mr_n71555952)
print v(xbgr.mr_n71556064)
print v(xbgr.mr_n71556384)
print v(xbgr.mr_n71556496)
print v(xbgr.mr_n71556816)
print v(xbgr.mr_n71556928)
print v(xbgr.mr_n71557248)
print v(xbgr.mr_n71557360)
print v(xbgr.mr_n71557680)
print v(xbgr.mr_n71557792)
print v(xbgr.mr_n71558112)
print v(xbgr.mr_n71558224)
print v(xbgr.mr_n71558544)
print v(xbgr.mr_n71558656)
print v(xbgr.mr_n71558976)
print v(xbgr.mr_n71559088)
print v(xbgr.mr_n71559408)
print v(xbgr.mr_n71559520)
print v(xbgr.mr_n71559840)
print v(xbgr.mr_n71559952)
print v(xbgr.mr_n71560272)
print v(xbgr.mr_n71560384)
print v(xbgr.mr_n71560704)
print v(xbgr.mr_n71560816)
print v(xbgr.mr_n71561136)
print v(xbgr.mr_n71561248)
print v(xbgr.mr_n71561568)
print v(xbgr.mr_n71561680)
print v(xbgr.mr_n71562000)
print v(xbgr.mr_n71562112)
print v(xbgr.mr_n71562432)
print v(xbgr.mr_n71562544)
print v(xbgr.mr_n71562864)
print v(xbgr.mr_n71562976)
print v(xbgr.mr_n71563296)
print v(xbgr.mr_n71563408)
print v(xbgr.mr_n71563728)
print v(xbgr.mr_n71563840)
print v(xbgr.mr_n71564160)
print v(xbgr.mr_n71564272)
print v(xbgr.mr_n71564592)
print v(xbgr.mr_n71564704)
print v(xbgr.mr_n71565024)
print v(xbgr.mr_n71565136)
print v(xbgr.mr_n71565456)
print v(xbgr.mr_n71565568)
print v(xbgr.mr_n71565888)
print v(xbgr.mr_n71566000)
print v(xbgr.mr_n71566320)
print v(xbgr.mr_n71566432)
print v(xbgr.mr_n71566752)
print v(xbgr.mr_n71566864)
print v(xbgr.mr_n71567184)
print v(xbgr.mr_n71567296)
print v(xbgr.mr_n71567616)
print v(xbgr.mr_n71567728)
print v(xbgr.mr_n71568048)
print v(xbgr.mr_n71568160)
print v(xbgr.mr_n71568480)
print v(xbgr.mr_n71568592)
print v(xbgr.mr_n71568912)
print v(xbgr.mr_n71569024)
print v(xbgr.mr_n71569344)
print v(xbgr.mr_n71569456)
print v(xbgr.mr_n71569776)
print v(xbgr.mr_n71569888)
print v(xbgr.mr_n71570208)
print v(xbgr.mr_n71570320)
print v(xbgr.mr_n71570640)
print v(xbgr.mr_n71570752)
print v(xbgr.mr_n71571072)
print v(xbgr.mr_n71571184)
print v(xbgr.mr_n71571504)
print v(xbgr.mr_n71571616)
print v(xbgr.mr_n71571936)
print v(xbgr.mr_n71572048)
print v(xbgr.mr_n71572368)
print v(xbgr.mr_n71572480)
print v(xbgr.mr_n71572800)
print v(xbgr.mr_n71572912)
print v(xbgr.mr_n71573232)
print v(xbgr.mr_n71573344)
print v(xbgr.mr_n71573664)
print v(xbgr.mr_n71573776)
print v(xbgr.mr_n71574096)
print v(xbgr.mr_n71574208)
print v(xbgr.mr_n71574528)
print v(xbgr.mr_n71574640)
print v(xbgr.mr_n71574960)
print v(xbgr.mr_n71575072)
print v(xbgr.mr_n71575392)
print v(xbgr.mr_n71575504)
print v(xbgr.mr_n71575824)
print v(xbgr.mr_n71575936)
print v(xbgr.mr_n71576256)
print v(xbgr.mr_n71576368)
print v(xbgr.mr_n71576688)
print v(xbgr.mr_n71576800)
print v(xbgr.mr_n71577120)
print v(xbgr.mr_n71577232)
print v(xbgr.mr_n71577552)
print v(xbgr.mr_n71577664)
print v(xbgr.mr_n71577984)
print v(xbgr.mr_n71578096)
print v(xbgr.mr_n71578416)
print v(xbgr.mr_n71578528)
print v(xbgr.mr_n71578848)
print v(xbgr.mr_n71578960)
print v(xbgr.mr_n71579280)
print v(xbgr.mr_n71579392)
print v(xbgr.mr_n71579712)
print v(xbgr.mr_n71579824)
print v(xbgr.mr_n71580144)
print v(xbgr.mr_n71580256)
print v(xbgr.mr_n71580576)
print v(xbgr.mr_n71580688)
print v(xbgr.mr_n71581008)
print v(xbgr.mr_n71581120)
print v(xbgr.mr_n71581440)
print v(xbgr.mr_n71581552)
print v(xbgr.mr_n71581872)
print v(xbgr.mr_n71581984)
print v(xbgr.mr_n71582304)
print v(xbgr.mr_n71582416)
print v(xbgr.mr_n71582736)
print v(xbgr.mr_n71582848)
print v(xbgr.mr_n71583168)
print v(xbgr.mr_n71583280)
print v(xbgr.mr_n71583600)
print v(xbgr.mr_n71583712)
print v(xbgr.mr_n71584032)
print v(xbgr.mr_n71584144)
print v(xbgr.mr_n71584464)
print v(xbgr.mr_n71584576)
print v(xbgr.mr_n71584896)
print v(xbgr.mr_n71585008)
print v(xbgr.mr_n71585328)
print v(xbgr.mr_n71585440)
print v(xbgr.mr_n71585760)
print v(xbgr.mr_n71585872)
print v(xbgr.mr_n71586192)
print v(xbgr.mr_n71586304)
print v(xbgr.mr_n71586624)
print v(xbgr.mr_n71586736)
print v(xbgr.mr_n71587056)
print v(xbgr.mr_n71587168)
print v(xbgr.mr_n71587488)
print v(xbgr.mr_n71587600)
print v(xbgr.mr_n71587920)
print v(xbgr.mr_n71588032)
print v(xbgr.mr_n71588352)
print v(xbgr.mr_n71588464)
print v(xbgr.mr_n71588784)
print v(xbgr.mr_n71588896)
print v(xbgr.mr_n71589216)
print v(xbgr.mr_n71589328)
print v(xbgr.mr_n71589648)
print v(xbgr.mr_n71589760)
print v(xbgr.mr_n71590080)
print v(xbgr.mr_n71590192)
print v(xbgr.mr_n71590512)
print v(xbgr.mr_n71590624)
print v(xbgr.mr_n71590944)
print v(xbgr.mr_n71591056)
print v(xbgr.mr_n71591376)
print v(xbgr.mr_n71591488)
print v(xbgr.mr_n71591808)
print v(xbgr.mr_n71591920)
print v(xbgr.mr_n71592240)
print v(xbgr.mr_n71592352)
print v(xbgr.mr_n71592672)
print v(xbgr.mr_n71592784)
print v(xbgr.mr_n71593104)
print v(xbgr.mr_n71593216)
print v(xbgr.mr_n71593536)
print v(xbgr.mr_n71593648)
print v(xbgr.mr_n71593968)
print v(xbgr.mr_n71594080)
print v(xbgr.mr_n71594400)
print v(xbgr.mr_n71594512)
print v(xbgr.mr_n71594832)
print v(xbgr.mr_n71594944)
print v(xbgr.mr_n71595264)
print v(xbgr.mr_n71595376)
print v(xbgr.mr_n71595696)
print v(xbgr.mr_n71595808)
print v(xbgr.mr_n71596128)
print v(xbgr.mr_n71596240)
print v(xbgr.mr_n71596560)
print v(xbgr.mr_n71596672)
print v(xbgr.mr_n71596992)
print v(xbgr.mr_n71597104)
print v(xbgr.mr_n71597424)
print v(xbgr.mr_n71597536)
print v(xbgr.mr_n71597856)
print v(xbgr.mr_n71597968)
print v(xbgr.mr_n71598288)
print v(xbgr.mr_n71598400)
print v(xbgr.mr_n71598720)
print v(xbgr.mr_n71598832)
print v(xbgr.mr_n71599152)
print v(xbgr.mr_n71599264)
print v(xbgr.mr_n71599584)
print v(xbgr.mr_n71599696)
print v(xbgr.mr_n71600016)
print v(xbgr.mr_n71600128)
print v(xbgr.mr_n71600448)
print v(xbgr.mr_n71600560)
print v(xbgr.mr_n71600880)
print v(xbgr.mr_n71600992)
print v(xbgr.mr_n71601312)
print v(xbgr.mr_n71601424)
print v(xbgr.mr_n71601744)
print v(xbgr.mr_n71601856)
print v(xbgr.mr_n71602176)
print v(xbgr.mr_n71602288)
print v(xbgr.mr_n71602608)
print v(xbgr.mr_n71602720)
print v(xbgr.mr_n71603040)
print v(xbgr.mr_n71603152)
print v(xbgr.mr_n71603472)
print v(xbgr.mr_n71603584)
print v(xbgr.mr_n71603904)
print v(xbgr.mr_n71604016)
print v(xbgr.mr_n71604336)
print v(xbgr.mr_n71604448)
print v(xbgr.mr_n71604768)
print v(xbgr.mr_n71604880)
print v(xbgr.mr_n71605200)
print v(xbgr.mr_n71605312)
print v(xbgr.mr_n71605632)
print v(xbgr.mr_n71605744)
print v(xbgr.mr_n71606064)
print v(xbgr.mr_n71606176)
print v(xbgr.mr_n71606496)
print v(xbgr.mr_n71606608)
print v(xbgr.mr_n71606928)
print v(xbgr.mr_n71607040)
print v(xbgr.mr_n71607360)
print v(xbgr.mr_n71607472)
print v(xbgr.mr_n71607792)
print v(xbgr.mr_n71607904)
print v(xbgr.mr_n71608224)
print v(xbgr.mr_n71608336)
print v(xbgr.mr_n71608656)
print v(xbgr.mr_n71608768)
print v(xbgr.mr_n71609088)
print v(xbgr.mr_n71609200)
print v(xbgr.mr_n71609520)
print v(xbgr.mr_n71609632)
print v(xbgr.mr_n71609952)
print v(xbgr.mr_n71610064)
print v(xbgr.mr_n71610384)
print v(xbgr.mr_n71610496)
print v(xbgr.mr_n71610816)
print v(xbgr.mr_n71610928)
print v(xbgr.mr_n71611248)
print v(xbgr.mr_n71611360)
print v(xbgr.mr_n71611680)
print v(xbgr.mr_n71611792)
print v(xbgr.mr_n71612112)
print v(xbgr.mr_n71612224)
print v(xbgr.mr_n71612544)
print v(xbgr.mr_n71612656)
print v(xbgr.mr_n71612976)
print v(xbgr.mr_n71613088)
print v(xbgr.mr_n71613408)
print v(xbgr.mr_n71613520)
print v(xbgr.mr_n71613840)
print v(xbgr.mr_n71613952)
print v(xbgr.mr_n71614272)
print v(xbgr.mr_n71614384)
print v(xbgr.mr_n71614704)
print v(xbgr.mr_n71614816)
print v(xbgr.mr_n71615136)
print v(xbgr.mr_n71615248)
print v(xbgr.mr_n71615568)
print v(xbgr.mr_n71615680)
print v(xbgr.mr_n71616000)
print v(xbgr.mr_n71616112)
print v(xbgr.mr_n71616432)
print v(xbgr.mr_n71616544)
print v(xbgr.mr_n71616864)
print v(xbgr.mr_n71616976)
print v(xbgr.mr_n71617296)
print v(xbgr.mr_n71617408)
print v(xbgr.mr_n71617728)
print v(xbgr.mr_n71617840)
print v(xbgr.mr_n71618160)
print v(xbgr.mr_n71618272)
print v(xbgr.mr_n71618592)
print v(xbgr.mr_n71618704)
print v(xbgr.mr_n71619024)
print v(xbgr.mr_n71619136)
print v(xbgr.mr_n71619456)
print v(xbgr.mr_n71619568)
print v(xbgr.mr_n71619888)
print v(xbgr.mr_n71620000)
print v(xbgr.mr_n71620320)
print v(xbgr.mr_n71620432)
print v(xbgr.mr_n71620752)
print v(xbgr.mr_n71620864)
print v(xbgr.mr_n71621184)
print v(xbgr.mr_n71621296)
print v(xbgr.mr_n71621616)
print v(xbgr.mr_n71621728)
print v(xbgr.mr_n71622048)
print v(xbgr.mr_n71622160)
print v(xbgr.mr_n71622480)
print v(xbgr.mr_n71622592)
print v(xbgr.mr_n71622912)
print v(xbgr.mr_n71623024)
print v(xbgr.mr_n71623344)
print v(xbgr.mr_n71623456)
print v(xbgr.mr_n71623776)
print v(xbgr.mr_n71623888)
print v(xbgr.mr_n71624208)
print v(xbgr.mr_n71624320)
print v(xbgr.mr_n71624640)
print v(xbgr.mr_n71624752)
print v(xbgr.mr_n71625072)
print v(xbgr.mr_n71625184)
print v(xbgr.mr_n71625504)
print v(xbgr.mr_n71625616)
print v(xbgr.mr_n71625936)
print v(xbgr.mr_n71626048)
print v(xbgr.mr_n71626368)
print v(xbgr.mr_n71626480)
print v(xbgr.mr_n71626800)
print v(xbgr.mr_n71626912)
print v(xbgr.mr_n71627232)
print v(xbgr.mr_n71627344)
print v(xbgr.mr_n71627664)
print v(xbgr.mr_n71627776)
print v(xbgr.mr_n71628096)
print v(xbgr.mr_n71628208)
print v(xbgr.mr_n71628528)
print v(xbgr.mr_n71628640)
print v(xbgr.mr_n71628960)
print v(xbgr.mr_n71629072)
print v(xbgr.mr_n71629392)
print v(xbgr.mr_n71629504)
print v(xbgr.mr_n71629824)
print v(xbgr.mr_n71629936)
print v(xbgr.mr_n71630256)
print v(xbgr.mr_n71630368)
print v(xbgr.mr_n71630688)
print v(xbgr.mr_n71630800)
print v(xbgr.mr_n71631120)
print v(xbgr.mr_n71631232)
print v(xbgr.mr_n71631552)
print v(xbgr.mr_n71631664)
print v(xbgr.mr_n71631984)
print v(xbgr.mr_n71632096)
print v(xbgr.mr_n71632416)
print v(xbgr.mr_n71632528)
print v(xbgr.mr_n71632848)
print v(xbgr.mr_n71632960)
print v(xbgr.mr_n71633280)
print v(xbgr.mr_n71633392)
print v(xbgr.mr_n71633712)
print v(xbgr.mr_n71633824)
print v(xbgr.mr_n71634144)
print v(xbgr.mr_n71634256)
print v(xbgr.mr_n71634576)
print v(xbgr.mr_n71634688)
print v(xbgr.mr_n71635008)
print v(xbgr.mr_n71635120)
print v(xbgr.mr_n71635440)
print v(xbgr.mr_n71635552)
print v(xbgr.mr_n71635872)
print v(xbgr.mr_n71635984)
print v(xbgr.mr_n71636304)
print v(xbgr.mr_n71636416)
print v(xbgr.mr_n71636736)
print v(xbgr.mr_n71636848)
print v(xbgr.mr_n71637168)
print v(xbgr.mr_n71637280)
print v(xbgr.mr_n71637600)
print v(xbgr.mr_n71637712)
print v(xbgr.mr_n71638032)
print v(xbgr.mr_n71638144)
print v(xbgr.mr_n71638464)
print v(xbgr.mr_n71638576)
print v(xbgr.mr_n71638896)
print v(xbgr.mr_n71639008)
print v(xbgr.mr_n71639328)
print v(xbgr.mr_n71639440)
print v(xbgr.mr_n71639760)
print v(xbgr.mr_n71639872)
print v(xbgr.mr_n71640192)
print v(xbgr.mr_n71640304)
print v(xbgr.mr_n71640624)
print v(xbgr.mr_n71640736)
print v(xbgr.mr_n71641056)
print v(xbgr.mr_n71641168)
print v(xbgr.mr_n71641488)
print v(xbgr.mr_n71641600)
print v(xbgr.mr_n71641920)
print v(xbgr.mr_n71642032)
print v(xbgr.mr_n71642352)
print v(xbgr.mr_n71642464)
print v(xbgr.mr_n71642784)
print v(xbgr.mr_n71642896)
print v(xbgr.mr_n71643216)
print v(xbgr.mr_n71643328)
print v(xbgr.mr_n71643648)
print v(xbgr.mr_n71643760)
print v(xbgr.mr_n71644080)
print v(xbgr.mr_n71644192)
print v(xbgr.mr_n71644512)
print v(xbgr.mr_n71644624)
print v(xbgr.mr_n71644944)
print v(xbgr.mr_n71645056)
print v(xbgr.mr_n71645376)
print v(xbgr.mr_n71645488)
print v(xbgr.mr_n71645808)
print v(xbgr.mr_n71645920)
print v(xbgr.mr_n71646240)
print v(xbgr.mr_n71646352)
print v(xbgr.mr_n71646672)
print v(xbgr.mr_n71646784)
print v(xbgr.mr_n71647104)
print v(xbgr.mr_n71647216)
print v(xbgr.mr_n71647536)
print v(xbgr.mr_n71647648)
print v(xbgr.mr_n71647968)
print v(xbgr.mr_n71648080)
print v(xbgr.mr_n71648400)
print v(xbgr.mr_n71648512)
print v(xbgr.mr_n71648832)
print v(xbgr.mr_n71648944)
print v(xbgr.mr_n71649264)
print v(xbgr.mr_n71649376)
print v(xbgr.mr_n71649696)
print v(xbgr.mr_n71649808)
print v(xbgr.mr_n71650128)
print v(xbgr.mr_n71650240)
print v(xbgr.mr_n71650560)
print v(xbgr.mr_n71650672)
print v(xbgr.mr_n71650992)
print v(xbgr.mr_n71651104)
print v(xbgr.mr_n71651424)
print v(xbgr.mr_n71651536)
print v(xbgr.mr_n71651856)
print v(xbgr.mr_n71651968)
print v(xbgr.mr_n71652288)
print v(xbgr.mr_n71652400)
print v(xbgr.mr_n71652720)
print v(xbgr.mr_n71652832)
print v(xbgr.mr_n71653152)
print v(xbgr.mr_n71653264)
print v(xbgr.mr_n71653584)
print v(xbgr.mr_n71653696)
print v(xbgr.mr_n71654016)
print v(xbgr.mr_n71654128)
print v(xbgr.mr_n71654448)
print v(xbgr.mr_n71654560)
print v(xbgr.mr_n71654880)
print v(xbgr.mr_n71654992)
print v(xbgr.mr_n71655312)
print v(xbgr.mr_n71655424)
print v(xbgr.mr_n71655744)
print v(xbgr.mr_n71655856)
print v(xbgr.mr_n71656176)
print v(xbgr.mr_n71656288)
print v(xbgr.mr_n71656608)
print v(xbgr.mr_n71656720)
print v(xbgr.mr_n71657040)
print v(xbgr.mr_n71657152)
print v(xbgr.mr_n71657472)
print v(xbgr.mr_n71657584)
print v(xbgr.mr_n71657904)
print v(xbgr.mr_n71658016)
print v(xbgr.mr_n71658336)
print v(xbgr.mr_n71658448)
print v(xbgr.mr_n71658768)
print v(xbgr.mr_n71658880)
print v(xbgr.mr_n71659200)
print v(xbgr.mr_n71659312)
print v(xbgr.mr_n71659632)
print v(xbgr.mr_n71659744)
print v(xbgr.mr_n71660064)
print v(xbgr.mr_n71660176)
print v(xbgr.mr_n71660496)
print v(xbgr.mr_n71660608)
print v(xbgr.mr_n71660928)
print v(xbgr.mr_n71661040)
print v(xbgr.mr_n71661360)
print v(xbgr.mr_n71661472)
print v(xbgr.mr_n71661792)
print v(xbgr.mr_n71661904)
print v(xbgr.mr_n71662224)
print v(xbgr.mr_n71662336)
print v(xbgr.mr_n71662656)
print v(xbgr.mr_n71662768)
print v(xbgr.mr_n71663088)
print v(xbgr.mr_n71663200)
print v(xbgr.mr_n71663520)
print v(xbgr.mr_n71663632)
print v(xbgr.mr_n71663952)
print v(xbgr.mr_n71664064)
print v(xbgr.mr_n71664384)
print v(xbgr.mr_n71664496)
print v(xbgr.mr_n71664816)
print v(xbgr.mr_n71664928)
print v(xbgr.mr_n71665248)
print v(xbgr.mr_n71665360)
print v(xbgr.mr_n71665680)
print v(xbgr.mr_n71665792)
print v(xbgr.mr_n71666112)
print v(xbgr.mr_n71666224)
print v(xbgr.mr_n71666544)
print v(xbgr.mr_n71666656)
print v(xbgr.mr_n71666976)
print v(xbgr.mr_n71667088)
print v(xbgr.mr_n71667408)
print v(xbgr.mr_n71667520)
print v(xbgr.mr_n71667840)
print v(xbgr.mr_n71667952)
print v(xbgr.mr_n71668272)
print v(xbgr.mr_n71668384)
print v(xbgr.mr_n71668704)
print v(xbgr.mr_n71668816)
print v(xbgr.mr_n71669136)
print v(xbgr.mr_n71669248)
print v(xbgr.mr_n71669568)
print v(xbgr.mr_n71669680)
print v(xbgr.mr_n71670000)
print v(xbgr.mr_n71670112)
print v(xbgr.mr_n71670432)
print v(xbgr.mr_n71670544)
print v(xbgr.mr_n71670864)
print v(xbgr.mr_n71670976)
print v(xbgr.mr_n71671296)
print v(xbgr.mr_n71671408)
print v(xbgr.mr_n71671728)
print v(xbgr.mr_n71671840)
print v(xbgr.mr_n71672160)
print v(xbgr.mr_n71672272)
print v(xbgr.mr_n71672592)
print v(xbgr.mr_n71672704)
print v(xbgr.mr_n71673024)
print v(xbgr.mr_n71673136)
print v(xbgr.mr_n71673456)
print v(xbgr.mr_n71673568)
print v(xbgr.mr_n71673888)
print v(xbgr.mr_n71674000)
print v(xbgr.mr_n71674320)
print v(xbgr.mr_n71674432)
print v(xbgr.mr_n71674752)
print v(xbgr.mr_n71674864)
print v(xbgr.mr_n71675184)
print v(xbgr.mr_n71675296)
print v(xbgr.mr_n71675616)
print v(xbgr.mr_n71675728)
print v(xbgr.mr_n71676048)
print v(xbgr.mr_n71676160)
print v(xbgr.mr_n71676480)
print v(xbgr.mr_n71676592)
print v(xbgr.mr_n71676912)
print v(xbgr.mr_n71677024)
print v(xbgr.mr_n71677344)
print v(xbgr.mr_n71677456)
print v(xbgr.mr_n71677776)
print v(xbgr.mr_n71677888)
print v(xbgr.mr_n71678208)
print v(xbgr.mr_n71678320)
print v(xbgr.mr_n71678640)
print v(xbgr.mr_n71678752)
print v(xbgr.mr_n71679072)
print v(xbgr.mr_n71679184)
print v(xbgr.mr_n71679504)
print v(xbgr.mr_n71679616)
print v(xbgr.mr_n71679936)
print v(xbgr.mr_n71680048)
print v(xbgr.mr_n71680368)
print v(xbgr.mr_n71680480)
print v(xbgr.mr_n71680800)
print v(xbgr.mr_n71680912)
print v(xbgr.mr_n71681232)
print v(xbgr.mr_n71681344)
print v(xbgr.mr_n71681664)
print v(xbgr.mr_n71681776)
print v(xbgr.mr_n71682096)
print v(xbgr.mr_n71682208)
print v(xbgr.mr_n71682528)
print v(xbgr.mr_n71682640)
print v(xbgr.mr_n71682960)
print v(xbgr.mr_n71683072)
print v(xbgr.mr_n71683392)
print v(xbgr.mr_n71683504)
print v(xbgr.mr_n71683824)
print v(xbgr.mr_n71683936)
print v(xbgr.mr_n71684256)
print v(xbgr.mr_n71684368)
print v(xbgr.mr_n71684688)
print v(xbgr.mr_n71684800)
print v(xbgr.mr_n71685120)
print v(xbgr.mr_n71685232)
print v(xbgr.mr_n71685552)
print v(xbgr.mr_n71685664)
print v(xbgr.mr_n71685984)
print v(xbgr.mr_n71686096)
print v(xbgr.mr_n71686416)
print v(xbgr.mr_n71686528)
print v(xbgr.mr_n71686848)
print v(xbgr.mr_n71686960)
print v(xbgr.mr_n71687280)
print v(xbgr.mr_n71687392)
print v(xbgr.mr_n71687712)
print v(xbgr.mr_n71687824)
print v(xbgr.mr_n71688144)
print v(xbgr.mr_n71688256)
print v(xbgr.mr_n71688576)
print v(xbgr.mr_n71688688)
print v(xbgr.mr_n71689008)
print v(xbgr.mr_n71689120)
print v(xbgr.mr_n71689440)
print v(xbgr.mr_n71689552)
print v(xbgr.mr_n71689872)
print v(xbgr.mr_n71689984)
print v(xbgr.mr_n71690304)
print v(xbgr.mr_n71690416)
print v(xbgr.mr_n71690736)
print v(xbgr.mr_n71690848)
print v(xbgr.mr_n71691168)
print v(xbgr.mr_n71691280)
print v(xbgr.mr_n71691600)
print v(xbgr.mr_n71691712)
print v(xbgr.mr_n71692032)
print v(xbgr.mr_n71692144)
print v(xbgr.mr_n71692464)
print v(xbgr.mr_n71692576)
print v(xbgr.mr_n71692896)
print v(xbgr.mr_n71693008)
print v(xbgr.mr_n71693328)
print v(xbgr.mr_n71693440)
print v(xbgr.mr_n71693760)
print v(xbgr.mr_n71693872)
print v(xbgr.mr_n71694192)
print v(xbgr.mr_n71694304)
print v(xbgr.mr_n71694736)
print v(xbgr.mr_n71695056)
print v(xbgr.mr_n71695168)
print v(xbgr.mr_n71695600)
print v(xbgr.mr_n71695920)
print v(xbgr.mr_n71696032)
print v(xbgr.mr_n71696464)
print v(xbgr.mr_n71696784)
print v(xbgr.mr_n71697648)
print v(xbgr.mr_n71698512)
print v(xbgr.mr_n71698624)
print v(xbgr.mr_n71698944)
print v(xbgr.mr_n71699056)
print v(xbgr.mr_n71699376)
print v(xbgr.mr_n71699488)
print v(xbgr.mr_n71699808)
print v(xbgr.mr_n71699920)
print v(xbgr.mr_n71700240)
print v(xbgr.mr_n71700352)
print v(xbgr.mr_n71700672)
print v(xbgr.mr_n71700784)
print v(xbgr.mr_n71701104)
print v(xbgr.mr_n71701968)
print v(xbgr.mr_n71702832)
print v(xbgr.mr_n71703696)
print v(xbgr.mr_n71703808)
print v(xbgr.mr_n71704128)
print v(xbgr.mr_n71704240)
print v(xbgr.mr_n71704560)
print v(xbgr.mr_n71704672)
print v(xbgr.mr_n71704992)
print v(xbgr.mr_n71705104)
print v(xbgr.mr_n71705424)
print v(xbgr.mr_n71706288)
print v(xbgr.mr_n71707152)
print v(xbgr.mr_n71707264)
print v(xbgr.mr_n71707584)
print v(xbgr.mr_n71707696)
print v(xbgr.mr_n71708016)
print v(xbgr.mr_n71708128)
print v(xbgr.mr_n71708448)
print v(xbgr.mr_n71708560)
print v(xbgr.mr_n71708880)
print v(xbgr.mr_n71708992)
print v(xbgr.mr_n71709312)
print v(xbgr.mr_n71709424)
print v(xbgr.mr_n71709744)
print v(xbgr.mr_n71710608)
print v(xbgr.mr_n71710720)
print v(xbgr.mr_n71711152)
print v(xbgr.mr_n71711472)
print v(xbgr.mr_n71711584)
print v(xbgr.mr_n71712016)
print v(xbgr.mr_n71712336)
print v(xbgr.mr_n71712448)
print v(xbgr.mr_n71712880)
print v(xbgr.mr_n71713200)
print v(xbgr.mr_n71714064)
print v(xbgr.mr_n71714928)
print v(xbgr.mr_n71715792)
print v(xbgr.mr_n71716656)
print v(xbgr.mr_n71717520)
print v(xbgr.mr_n71718384)
print v(xbgr.mr_n71718496)
print v(xbgr.mr_n71718816)
print v(xbgr.mr_n71718928)
print v(xbgr.mr_n71719248)
print v(xbgr.mr_n71719360)
print v(xbgr.mr_n71719680)
print v(xbgr.mr_n71719792)
print v(xbgr.mr_n71720112)
print v(xbgr.mr_n71720976)
print v(xbgr.mr_n71721840)
print v(xbgr.mr_n71722704)
print v(xbgr.mr_n71723568)
print v(xbgr.mr_n71723680)
print v(xbgr.mr_n71724112)
print v(xbgr.mr_n71724432)
print v(xbgr.mr_n71724544)
print v(xbgr.mr_n71724976)
print v(xbgr.mr_n71725296)
print v(xbgr.mr_n71725408)
print v(xbgr.mr_n71725840)
print v(xbgr.mr_n71726160)
print v(xbgr.mr_n71727024)
print v(xbgr.mr_n71727888)
print v(xbgr.mr_n71728752)
print v(xbgr.mr_n71729616)
print v(xbgr.mr_n71730480)
print v(xbgr.mr_n71731344)
print v(xbgr.mr_n71731456)
print v(xbgr.mr_n71731776)
print v(xbgr.mr_n71731888)
print v(xbgr.mr_n71732208)
print v(xbgr.mr_n71732320)
print v(xbgr.mr_n71732640)
print v(xbgr.mr_n71732752)
print v(xbgr.mr_n71733072)
print v(xbgr.mr_n71733936)
print v(xbgr.mr_n71734800)
print v(xbgr.mr_n71735664)
print v(xbgr.mr_n71735776)
print v(xbgr.mr_n71736096)
print v(xbgr.mr_n71736208)
print v(xbgr.mr_n71736528)
print v(xbgr.mr_n71736640)
print v(xbgr.mr_n71737072)
print v(xbgr.mr_n71737504)
print v(xbgr.mr_n71737936)
print v(xbgr.mr_n71738256)
print v(xbgr.mr_n71738368)
print v(xbgr.mr_n71738688)
print v(xbgr.mr_n71738800)
print v(xbgr.mr_n71739120)
print v(xbgr.mr_n71739232)
print v(xbgr.mr_n71739552)
print v(xbgr.mr_n71739664)
print v(xbgr.mr_n71739984)
print v(xbgr.mr_n71740096)
print v(xbgr.mr_n71740416)
print v(xbgr.mr_n71740528)
print v(xbgr.mr_n71740848)
print v(xbgr.mr_n71740960)
print v(xbgr.mr_n71741392)
print v(xbgr.mr_n71741712)
print v(xbgr.mr_n71742144)
print v(xbgr.mr_n71742256)
print v(xbgr.mr_n71742576)
print v(xbgr.mr_n71742688)
print v(xbgr.mr_n71743008)
print v(xbgr.mr_n71743120)
print v(xbgr.mr_n71743440)
print v(xbgr.mr_n71743552)
print v(xbgr.mr_n71743872)
print v(xbgr.mr_n71743984)
print v(xbgr.mr_n71744304)
print v(xbgr.mr_n71744416)
print v(xbgr.mr_n71744736)
print v(xbgr.mr_n71744848)
print v(xbgr.mr_n71745280)
print v(xbgr.mr_n71745600)
print v(xbgr.mr_n71745712)
print v(xbgr.mr_n71746144)
print v(xbgr.mr_n71746464)
print v(xbgr.mr_n71746576)
print v(xbgr.mr_n71746896)
print v(xbgr.mr_n71747008)
print v(xbgr.mr_n71747328)
print v(xbgr.mr_n71747440)
print v(xbgr.mr_n71747872)
print v(xbgr.mr_n71748304)
print v(xbgr.mr_n71748624)
print v(xbgr.mr_n71748736)
print v(xbgr.mr_n71749056)
print v(xbgr.mr_n71749168)
print v(xbgr.mr_n71749488)
print v(xbgr.mr_n71749600)
print v(xbgr.mr_n71749920)
print v(xbgr.mr_n71750032)
print v(xbgr.mr_n71750352)
print v(xbgr.mr_n71750464)
print v(xbgr.mr_n71750784)
print v(xbgr.mr_n71750896)
print v(xbgr.mr_n71751216)
print v(xbgr.mr_n71751328)
print v(xbgr.mr_n71751648)
print v(xbgr.mr_n71751760)
print v(xbgr.mr_n71752080)
print v(xbgr.mr_n71752192)
print v(xbgr.mr_n71752512)
print v(xbgr.mr_n71752624)
print v(xbgr.mr_n71752944)
print v(xbgr.mr_n71753056)
print v(xbgr.mr_n71753376)
print v(xbgr.mr_n71754240)
print v(xbgr.mr_n71755104)
print v(xbgr.mr_n71755216)
print v(xbgr.mr_n71755648)
print v(xbgr.mr_n71755968)
print v(xbgr.mr_n71756080)
print v(xbgr.mr_n71756832)
print v(xbgr.mr_n71757264)
print v(xbgr.mr_n71757376)
print v(xbgr.mr_n71757696)
print v(xbgr.mr_n71757808)
print v(xbgr.mr_n71758128)
print v(xbgr.mr_n71758240)
print v(xbgr.mr_n71758560)
print v(xbgr.mr_n71758672)
print v(xbgr.mr_n71758992)
print v(xbgr.mr_n71759856)
print v(xbgr.mr_n71760288)
print v(xbgr.mr_n71760400)
print v(xbgr.mr_n71760720)
print v(xbgr.mr_n71760832)
print v(xbgr.mr_n71761152)
print v(xbgr.mr_n71762016)
print v(xbgr.mr_n71763312)
print v(xbgr.mr_n71764176)
print v(xbgr.mr_n71765040)
print v(xbgr.mr_n71765152)
print v(xbgr.mr_n71765904)
print v(xbgr.mr_n71766016)
print v(xbgr.mr_n71766448)
print v(xbgr.mr_n71766880)
print v(xbgr.mr_n71767632)
print v(xbgr.mr_n71768496)
print v(xbgr.mr_n71769360)
print v(xbgr.mr_n71769472)
print v(xbgr.mr_n71769792)
print v(xbgr.mr_n71769904)
print v(xbgr.mr_n71770336)
print v(xbgr.mr_n71770656)
print v(xbgr.mr_n71770768)
print v(xbgr.mr_n71771200)
print v(xbgr.mr_n71771520)
print v(xbgr.mr_n71771632)
print v(xbgr.mr_n71771952)
print v(xbgr.mr_n71772064)
print v(xbgr.mr_n71772384)
print v(xbgr.mr_n71773248)
print v(xbgr.mr_n71773360)
print v(xbgr.mr_n71773792)
print v(xbgr.mr_n71774112)
print v(xbgr.mr_n71775088)
print v(xbgr.mr_n71775408)
print v(xbgr.mr_n71775520)
print v(xbgr.mr_n71775952)
print v(xbgr.mr_n71776272)
print v(xbgr.mr_n71776704)
print v(xbgr.mr_n71776816)
print v(xbgr.mr_n71777136)
print v(xbgr.mr_n71777248)
print v(xbgr.mr_n71777568)
print v(xbgr.mr_n71778000)
print v(xbgr.mr_n71778112)
print v(xbgr.mr_n71778432)
print v(xbgr.mr_n71778544)
print v(xbgr.mr_n71778864)
print v(xbgr.mr_n71778976)
print v(xbgr.mr_n71779296)
print v(xbgr.mr_n71779408)
print v(xbgr.mr_n71779728)
print v(xbgr.mr_n71779840)
print v(xbgr.mr_n71780272)
print v(xbgr.mr_n71780592)
print v(xbgr.mr_n71780704)
print v(xbgr.mr_n71781024)
print v(xbgr.mr_n71781136)
print v(xbgr.mr_n71781456)
print v(xbgr.mr_n71782000)
print v(xbgr.mr_n71782752)
print v(xbgr.mr_n71784048)
print v(xbgr.mr_n71784160)
print v(xbgr.mr_n71784480)
print v(xbgr.mr_n71784592)
print v(xbgr.mr_n71784912)
print v(xbgr.mr_n71785776)
print v(xbgr.mr_n71786640)
print v(xbgr.mr_n71787504)
print v(xbgr.mr_n71787616)
print v(xbgr.mr_n71787936)
print v(xbgr.mr_n71788048)
print v(xbgr.mr_n71788368)
print v(xbgr.mr_n71788480)
print v(xbgr.mr_n71788800)
print v(xbgr.mr_n71788912)
print v(xbgr.mr_n71789232)
print v(xbgr.mr_n71789344)
print v(xbgr.mr_n71789664)
print v(xbgr.mr_n71790528)
print v(xbgr.mr_n71791392)
print v(xbgr.mr_n71792256)
print v(xbgr.mr_n71792368)
print v(xbgr.mr_n71792688)
print v(xbgr.mr_n71792800)
print v(xbgr.mr_n71793120)
print v(xbgr.mr_n71793232)
print v(xbgr.mr_n71793552)
print v(xbgr.mr_n71793664)
print v(xbgr.mr_n71794096)
print v(xbgr.mr_n71794416)
print v(xbgr.mr_n71794528)
print v(xbgr.mr_n71794848)
print v(xbgr.mr_n71794960)
print v(xbgr.mr_n71795280)
print v(xbgr.mr_n71795392)
print v(xbgr.mr_n71795712)
print v(xbgr.mr_n71795824)
print v(xbgr.mr_n71796576)
print v(xbgr.mr_n71797120)
print v(xbgr.mr_n71797552)
print v(xbgr.mr_n71797984)
print v(xbgr.mr_n71798416)
print v(xbgr.mr_n71798736)
print v(xbgr.mr_n71798848)
print v(xbgr.mr_n71799600)
print v(xbgr.mr_n71800464)
print v(xbgr.mr_n71801328)
print v(xbgr.mr_n71802192)
print v(xbgr.mr_n71803056)
print v(xbgr.mr_n71803920)
print v(xbgr.mr_n71804784)
print v(xbgr.mr_n71804896)
print v(xbgr.mr_n71805216)
print v(xbgr.mr_n71805328)
print v(xbgr.mr_n71805760)
print v(xbgr.mr_n71806080)
print v(xbgr.mr_n71806192)
print v(xbgr.mr_n71806624)
print v(xbgr.mr_n71806944)
print v(xbgr.mr_n71807056)
print v(xbgr.mr_n71807376)
print v(xbgr.mr_n71807488)
print v(xbgr.mr_n71807808)
print v(xbgr.mr_n71807920)
print v(xbgr.mr_n71808240)
print v(xbgr.mr_n71808352)
print v(xbgr.mr_n71808672)
print v(xbgr.mr_n71808784)
print v(xbgr.mr_n71809104)
print v(xbgr.mr_n71809216)
print v(xbgr.mr_n71809536)
print v(xbgr.mr_n71810400)
print v(xbgr.mr_n71810832)
print v(xbgr.mr_n71811808)
print v(xbgr.mr_n71812240)
print v(xbgr.mr_n71812672)
print v(xbgr.mr_n71813104)
print v(xbgr.mr_n71813424)
print v(xbgr.mr_n71814288)
print v(xbgr.mr_n71815152)
print v(xbgr.mr_n71816016)
print v(xbgr.mr_n71816880)
print v(xbgr.mr_n71817744)
print v(xbgr.mr_n71818608)
print v(xbgr.mr_n71819904)
print v(xbgr.mr_n71820336)
print v(xbgr.mr_n71821632)
print v(xbgr.mr_n71821744)
print v(xbgr.mr_n71822064)
print v(xbgr.mr_n71822176)
print v(xbgr.mr_n71822496)
print v(xbgr.mr_n71822608)
print v(xbgr.mr_n71823040)
print v(xbgr.mr_n71823472)
print v(xbgr.mr_n71823792)
print v(xbgr.mr_n71823904)
print v(xbgr.mr_n71824224)
print v(xbgr.mr_n71824336)
print v(xbgr.mr_n71824656)
print v(xbgr.mr_n71824768)
print v(xbgr.mr_n71825088)
print v(xbgr.mr_n71825200)
print v(xbgr.mr_n71825632)
print v(xbgr.mr_n71825952)
print v(xbgr.mr_n71826816)
print v(xbgr.mr_n71826928)
print v(xbgr.mr_n71827248)
print v(xbgr.mr_n71827360)
print v(xbgr.mr_n71827680)
print v(xbgr.mr_n71827792)
print v(xbgr.mr_n71828112)
print v(xbgr.mr_n71828224)
print v(xbgr.mr_n71828544)
print v(xbgr.mr_n71829408)
print v(xbgr.mr_n71829840)
print v(xbgr.mr_n71831136)
print v(xbgr.mr_n71831248)
print v(xbgr.mr_n71831568)
print v(xbgr.mr_n71831680)
print v(xbgr.mr_n71832000)
print v(xbgr.mr_n71832112)
print v(xbgr.mr_n71832432)
print v(xbgr.mr_n71833296)
print v(xbgr.mr_n71833408)
print v(xbgr.mr_n71833840)
print v(xbgr.mr_n71834160)
print v(xbgr.mr_n71834272)
print v(xbgr.mr_n71834592)
print v(xbgr.mr_n71834704)
print v(xbgr.mr_n71835024)
print v(xbgr.mr_n71835136)
print v(xbgr.mr_n71835456)
print v(xbgr.mr_n71835568)
print v(xbgr.mr_n71836000)
print v(xbgr.mr_n71836320)
print v(xbgr.mr_n71837184)
print v(xbgr.mr_n71837296)
print v(xbgr.mr_n71837616)
print v(xbgr.mr_n71838480)
print v(xbgr.mr_n71838592)
print v(xbgr.mr_n71838912)
print v(xbgr.mr_n71839024)
print v(xbgr.mr_n71839344)
print v(xbgr.mr_n71839888)
print v(xbgr.mr_n71840320)
print v(xbgr.mr_n71840640)
print v(xbgr.mr_n71841072)
print v(xbgr.mr_n71841184)
print v(xbgr.mr_n71841504)
print v(xbgr.mr_n71841616)
print v(xbgr.mr_n71841936)
print v(xbgr.mr_n71842048)
print v(xbgr.mr_n71842368)
print v(xbgr.mr_n71842480)
print v(xbgr.mr_n71842800)
print v(xbgr.mr_n71842912)
print v(xbgr.mr_n71843664)
print v(xbgr.mr_n71843776)
print v(xbgr.mr_n71844096)
print v(xbgr.mr_n71844208)
print v(xbgr.mr_n71844528)
print v(xbgr.mr_n71845824)
print v(xbgr.mr_n71845936)
print v(xbgr.mr_n71846256)
print v(xbgr.mr_n71846368)
print v(xbgr.mr_n71846688)
print v(xbgr.mr_n71847664)
print v(xbgr.mr_n71847984)
print v(xbgr.mr_n71848848)
print v(xbgr.mr_n71849280)
print v(xbgr.mr_n71849392)
print v(xbgr.mr_n71849712)
print v(xbgr.mr_n71849824)
print v(xbgr.mr_n71850144)
print v(xbgr.mr_n71850256)
print v(xbgr.mr_n71850576)
print v(xbgr.mr_n71851440)
print v(xbgr.mr_n71852736)
print v(xbgr.mr_n71853600)
print v(xbgr.mr_n71854576)
print v(xbgr.mr_n71854896)
print v(xbgr.mr_n71855008)
print v(xbgr.mr_n71855440)
print v(xbgr.mr_n71855760)
print v(xbgr.mr_n71855872)
print v(xbgr.mr_n71856192)
print v(xbgr.mr_n71856304)
print v(xbgr.mr_n71856624)
print v(xbgr.mr_n71856736)
print v(xbgr.mr_n71857056)
print v(xbgr.mr_n71857168)
print v(xbgr.mr_n71857488)
print v(xbgr.mr_n71857600)
print v(xbgr.mr_n71857920)
print v(xbgr.mr_n71858032)
print v(xbgr.mr_n71858352)
print v(xbgr.mr_n71858464)
print v(xbgr.mr_n71858784)
print v(xbgr.mr_n71858896)
print v(xbgr.mr_n71859328)
print v(xbgr.mr_n71859648)
print v(xbgr.mr_n71859760)
print v(xbgr.mr_n71860192)
print v(xbgr.mr_n71860512)
print v(xbgr.mr_n71861376)
print v(xbgr.mr_n71862240)
print v(xbgr.mr_n71863104)
print v(xbgr.mr_n71863216)
print v(xbgr.mr_n71863536)
print v(xbgr.mr_n71863648)
print v(xbgr.mr_n71863968)
print v(xbgr.mr_n71864080)
print v(xbgr.mr_n71864400)
print v(xbgr.mr_n71864512)
print v(xbgr.mr_n71864944)
print v(xbgr.mr_n71865376)
print v(xbgr.mr_n71865808)
print v(xbgr.mr_n71866240)
print v(xbgr.mr_n71866560)
print v(xbgr.mr_n71866672)
print v(xbgr.mr_n71866992)
print v(xbgr.mr_n71867104)
print v(xbgr.mr_n71867424)
print v(xbgr.mr_n71867536)
print v(xbgr.mr_n71867856)
print v(xbgr.mr_n71867968)
print v(xbgr.mr_n71868288)
print v(xbgr.mr_n71868400)
print v(xbgr.mr_n71868720)
print v(xbgr.mr_n71868832)
print v(xbgr.mr_n71869152)
print v(xbgr.mr_n71869264)
print v(xbgr.mr_n71869696)
print v(xbgr.mr_n71870016)
print v(xbgr.mr_n71870128)
print v(xbgr.mr_n71870448)
print v(xbgr.mr_n71871312)
print v(xbgr.mr_n71872048)
print v(xbgr.mr_n71872912)
print v(xbgr.mr_n71873776)
print v(xbgr.mr_n71874640)
print v(xbgr.mr_n71875504)
print v(xbgr.mr_n71875616)
print v(xbgr.mr_n71876048)
print v(xbgr.mr_n71876368)
print v(xbgr.mr_n71876480)
print v(xbgr.mr_n71876912)
print v(xbgr.mr_n71877232)
print v(xbgr.mr_n71877344)
print v(xbgr.mr_n71877664)
print v(xbgr.mr_n71877776)
print v(xbgr.mr_n71878096)
print v(xbgr.mr_n71878208)
print v(xbgr.mr_n71878640)
print v(xbgr.mr_n71878960)
print v(xbgr.mr_n71879824)
print v(xbgr.mr_n71879936)
print v(xbgr.mr_n71880256)
print v(xbgr.mr_n71880368)
print v(xbgr.mr_n71880688)
print v(xbgr.mr_n71880800)
print v(xbgr.mr_n71881120)
print v(xbgr.mr_n71881232)
print v(xbgr.mr_n71881552)
print v(xbgr.mr_n71881664)
print v(xbgr.mr_n71881984)
print v(xbgr.mr_n71882096)
print v(xbgr.mr_n71882416)
print v(xbgr.mr_n71882528)
print v(xbgr.mr_n71882848)
print v(xbgr.mr_n71883280)
print v(xbgr.mr_n71883392)
print v(xbgr.mr_n71883712)
print v(xbgr.mr_n71883824)
print v(xbgr.mr_n71884144)
print v(xbgr.mr_n71884256)
print v(xbgr.mr_n71884576)
print v(xbgr.mr_n71884688)
print v(xbgr.mr_n71885008)
print v(xbgr.mr_n71886304)
print v(xbgr.mr_n71887168)
print v(xbgr.mr_n71887712)
print v(xbgr.mr_n71888144)
print v(xbgr.mr_n71888464)
print v(xbgr.mr_n71888576)
print v(xbgr.mr_n71888896)
print v(xbgr.mr_n71889008)
print v(xbgr.mr_n71889328)
print v(xbgr.mr_n71889440)
print v(xbgr.mr_n71889760)
print v(xbgr.mr_n71889872)
print v(xbgr.mr_n71890192)
print v(xbgr.mr_n71890304)
print v(xbgr.mr_n71890624)
print v(xbgr.mr_n71890736)
print v(xbgr.mr_n71891056)
print v(xbgr.mr_n71891168)
print v(xbgr.mr_n71891488)
print v(xbgr.mr_n71891600)
print v(xbgr.mr_n71891920)
print v(xbgr.mr_n71892032)
print v(xbgr.mr_n71892352)
print v(xbgr.mr_n71893216)
print v(xbgr.mr_n71894080)
print v(xbgr.mr_n71894192)
print v(xbgr.mr_n71894624)
print v(xbgr.mr_n71895376)
print v(xbgr.mr_n71896240)
print v(xbgr.mr_n71897104)
print v(xbgr.mr_n71898080)
print v(xbgr.mr_n71898512)
print v(xbgr.mr_n71898832)
print v(xbgr.mr_n71898944)
print v(xbgr.mr_n71899264)
print v(xbgr.mr_n71899376)
print v(xbgr.mr_n71899696)
print v(xbgr.mr_n71900560)
print v(xbgr.mr_n71901424)
print v(xbgr.mr_n71901536)
print v(xbgr.mr_n71901856)
print v(xbgr.mr_n71901968)
print v(xbgr.mr_n71902288)
print v(xbgr.mr_n71902400)
print v(xbgr.mr_n71902720)
print v(xbgr.mr_n71902832)
print v(xbgr.mr_n71903152)
print v(xbgr.mr_n71903264)
print v(xbgr.mr_n71903584)
print v(xbgr.mr_n71903696)
print v(xbgr.mr_n71904016)
print v(xbgr.mr_n71904128)
print v(xbgr.mr_n71904448)
print v(xbgr.mr_n71904560)
print v(xbgr.mr_n71904880)
print v(xbgr.mr_n71904992)
print v(xbgr.mr_n71905424)
print v(xbgr.mr_n71905744)
print v(xbgr.mr_n71906176)
print v(xbgr.mr_n71906288)
print v(xbgr.mr_n71907040)
print v(xbgr.mr_n71907152)
print v(xbgr.mr_n71907584)
print v(xbgr.mr_n71908336)
print v(xbgr.mr_n71908448)
print v(xbgr.mr_n71908768)
print v(xbgr.mr_n71908880)
print v(xbgr.mr_n71909312)
print v(xbgr.mr_n71909744)
print v(xbgr.mr_n71910176)
print v(xbgr.mr_n71910496)
print v(xbgr.mr_n71910608)
print v(xbgr.mr_n71910928)
print v(xbgr.mr_n71911040)
print v(xbgr.mr_n71911472)
print v(xbgr.mr_n71911792)
print v(xbgr.mr_n71912656)
print v(xbgr.mr_n71912768)
print v(xbgr.mr_n71913088)
print v(xbgr.mr_n71913200)
print v(xbgr.mr_n71913520)
print v(xbgr.mr_n71913632)
print v(xbgr.mr_n71913952)
print v(xbgr.mr_n71914064)
print v(xbgr.mr_n71914384)
print v(xbgr.mr_n71914496)
print v(xbgr.mr_n71914816)
print v(xbgr.mr_n71914928)
print v(xbgr.mr_n71915248)
print v(xbgr.mr_n71916112)
print v(xbgr.mr_n71916976)
print v(xbgr.mr_n71917088)
print v(xbgr.mr_n71917408)
print v(xbgr.mr_n71917520)
print v(xbgr.mr_n71917840)
print v(xbgr.mr_n71917952)
print v(xbgr.mr_n71918272)
print v(xbgr.mr_n71918384)
print v(xbgr.mr_n71918704)
print v(xbgr.mr_n71919568)
print v(xbgr.mr_n71920432)
print v(xbgr.mr_n71921296)
print v(xbgr.mr_n71922160)
print v(xbgr.mr_n71923568)
print v(xbgr.mr_n71923888)
print v(xbgr.mr_n71924752)
print v(xbgr.mr_n71925616)
print v(xbgr.mr_n71925728)
print v(xbgr.mr_n71926160)
print v(xbgr.mr_n71926480)
print v(xbgr.mr_n71926592)
print v(xbgr.mr_n71927024)
print v(xbgr.mr_n71927344)
print v(xbgr.mr_n71928208)
print v(xbgr.mr_n71929072)
print v(xbgr.mr_n71929936)
print v(xbgr.mr_n71930800)
print v(xbgr.mr_n71930912)
print v(xbgr.mr_n71931232)
print v(xbgr.mr_n71931344)
print v(xbgr.mr_n71931664)
print v(xbgr.mr_n71931776)
print v(xbgr.mr_n71932096)
print v(xbgr.mr_n71932208)
print v(xbgr.mr_n71932528)
print v(xbgr.mr_n71933392)
print v(xbgr.mr_n71934256)
print v(xbgr.mr_n71934368)
print v(xbgr.mr_n71934688)
print v(xbgr.mr_n71934800)
print v(xbgr.mr_n71935232)
print v(xbgr.mr_n71935664)
print v(xbgr.mr_n71935984)
print v(xbgr.mr_n71936096)
print v(xbgr.mr_n71936416)
print v(xbgr.mr_n71936528)
print v(xbgr.mr_n71936848)
print v(xbgr.mr_n71936960)
print v(xbgr.mr_n71937280)
print v(xbgr.mr_n71937392)
print v(xbgr.mr_n71937712)
print v(xbgr.mr_n71937824)
print v(xbgr.mr_n71938256)
print v(xbgr.mr_n71938576)
print v(xbgr.mr_n71938688)
print v(xbgr.mr_n71939120)
print v(xbgr.mr_n71939440)
print v(xbgr.mr_n71940304)
print v(xbgr.mr_n71941168)
print v(xbgr.mr_n71942032)
print v(xbgr.mr_n71942896)
print v(xbgr.mr_n71943008)
print v(xbgr.mr_n71943328)
print v(xbgr.mr_n71943440)
print v(xbgr.mr_n71943760)
print v(xbgr.mr_n71943872)
print v(xbgr.mr_n71944192)
print v(xbgr.mr_n71944304)
print v(xbgr.mr_n71944624)
print v(xbgr.mr_n71945488)
print v(xbgr.mr_n71946352)
print v(xbgr.mr_n71946464)
print v(xbgr.mr_n71946784)
print v(xbgr.mr_n71946896)
print v(xbgr.mr_n71947328)
print v(xbgr.mr_n71947760)
print v(xbgr.mr_n71948080)
print v(xbgr.mr_n71948192)
print v(xbgr.mr_n71948512)
print v(xbgr.mr_n71948624)
print v(xbgr.mr_n71948944)
print v(xbgr.mr_n71949056)
print v(xbgr.mr_n71949376)
print v(xbgr.mr_n71949488)
print v(xbgr.mr_n71949808)
print v(xbgr.mr_n71949920)
print v(xbgr.mr_n71950352)
print v(xbgr.mr_n71950672)
print v(xbgr.mr_n71950784)
print v(xbgr.mr_n71951216)
print v(xbgr.mr_n71951536)
print v(xbgr.mr_n71951648)
print v(xbgr.mr_n71952080)
print v(xbgr.mr_n71952400)
print v(xbgr.mr_n71952512)
print v(xbgr.mr_n71952944)
print v(xbgr.mr_n71953264)
print v(xbgr.mr_n71954128)
print v(xbgr.mr_n71954992)
print v(xbgr.mr_n71955856)
print v(xbgr.mr_n71956720)
print v(xbgr.mr_n71957584)
print v(xbgr.mr_n71958448)
print v(xbgr.mr_n71958560)
print v(xbgr.mr_n71958880)
print v(xbgr.mr_n71958992)
print v(xbgr.mr_n71959312)
print v(xbgr.mr_n71959424)
print v(xbgr.mr_n71959744)
print v(xbgr.mr_n71959856)
print v(xbgr.mr_n71960176)
print v(xbgr.mr_n71960288)
print v(xbgr.mr_n71960608)
print v(xbgr.mr_n71960720)
print v(xbgr.mr_n71961040)
print v(xbgr.mr_n71961152)
print v(xbgr.mr_n71961472)
print v(xbgr.mr_n71961584)
print v(xbgr.mr_n71961904)
print v(xbgr.mr_n71962016)
print v(xbgr.mr_n71962336)
print v(xbgr.mr_n71962448)
print v(xbgr.mr_n71962880)
print v(xbgr.mr_n71963312)
print v(xbgr.mr_n71963632)
print v(xbgr.mr_n71964496)
print v(xbgr.mr_n71965360)
print v(xbgr.mr_n71965472)
print v(xbgr.mr_n71965792)
print v(xbgr.mr_n71965904)
print v(xbgr.mr_n71966224)
print v(xbgr.mr_n71966336)
print v(xbgr.mr_n71966656)
print v(xbgr.mr_n71966768)
print v(xbgr.mr_n71967088)
print v(xbgr.mr_n71967200)
print v(xbgr.mr_n71967520)
print v(xbgr.mr_n71967632)
print v(xbgr.mr_n71967952)
print v(xbgr.mr_n71968064)
print v(xbgr.mr_n71968384)
print v(xbgr.mr_n71968496)
print v(xbgr.mr_n71968928)
print v(xbgr.mr_n71969360)
print v(xbgr.mr_n71969680)
print v(xbgr.mr_n71969792)
print v(xbgr.mr_n71970112)
print v(xbgr.mr_n71970224)
print v(xbgr.mr_n71970544)
print v(xbgr.mr_n71970656)
print v(xbgr.mr_n71970976)
print v(xbgr.mr_n71971088)
print v(xbgr.mr_n71971408)
print v(xbgr.mr_n71971520)
print v(xbgr.mr_n71971840)
print v(xbgr.mr_n71971952)
print v(xbgr.mr_n71972272)
print v(xbgr.mr_n71973136)
print v(xbgr.mr_n71974000)
print v(xbgr.mr_n71974864)
print v(xbgr.mr_n71975728)
print v(xbgr.mr_n71975840)
print v(xbgr.mr_n71976272)
print v(xbgr.mr_n71976592)
print v(xbgr.mr_n71976704)
print v(xbgr.mr_n71977024)
print v(xbgr.mr_n71977136)
print v(xbgr.mr_n71977456)
print v(xbgr.mr_n71977568)
print v(xbgr.mr_n71977888)
print v(xbgr.mr_n71978000)
print v(xbgr.mr_n71978320)
print v(xbgr.mr_n71978432)
print v(xbgr.mr_n71978752)
print v(xbgr.mr_n71978864)
print v(xbgr.mr_n71979184)
print v(xbgr.mr_n71979296)
print v(xbgr.mr_n71979728)
print v(xbgr.mr_n71980048)
print v(xbgr.mr_n71980912)
print v(xbgr.mr_n71981024)
print v(xbgr.mr_n71981344)
print v(xbgr.mr_n71981456)
print v(xbgr.mr_n71981776)
print v(xbgr.mr_n71981888)
print v(xbgr.mr_n71982208)
print v(xbgr.mr_n71982320)
print v(xbgr.mr_n71982640)
print v(xbgr.mr_n71982752)
print v(xbgr.mr_n71983184)
print v(xbgr.mr_n71983504)
print v(xbgr.mr_n71983616)
print v(xbgr.mr_n71984048)
print v(xbgr.mr_n71984368)
print v(xbgr.mr_n71985232)
print v(xbgr.mr_n71986096)
print v(xbgr.mr_n71986960)
print v(xbgr.mr_n71987824)
print v(xbgr.mr_n71987936)
print v(xbgr.mr_n71988256)
print v(xbgr.mr_n71988368)
print v(xbgr.mr_n71988688)
print v(xbgr.mr_n71988800)
print v(xbgr.mr_n71989120)
print v(xbgr.mr_n71989232)
print v(xbgr.mr_n71989552)
print v(xbgr.mr_n71989664)
print v(xbgr.mr_n71989984)
print v(xbgr.mr_n71990096)
print v(xbgr.mr_n71990416)
print v(xbgr.mr_n71991280)
print v(xbgr.mr_n71992144)
print v(xbgr.mr_n71992256)
print v(xbgr.mr_n71992576)
print v(xbgr.mr_n71992688)
print v(xbgr.mr_n71993120)
print v(xbgr.mr_n71993552)
print v(xbgr.mr_n71993872)
print v(xbgr.mr_n71993984)
print v(xbgr.mr_n71994304)
print v(xbgr.mr_n71994416)
print v(xbgr.mr_n71994736)
print v(xbgr.mr_n71994848)
print v(xbgr.mr_n71995168)
print v(xbgr.mr_n71995280)
print v(xbgr.mr_n71995600)
print v(xbgr.mr_n71996464)
print v(xbgr.mr_n71997328)
print v(xbgr.mr_n71998192)
print v(xbgr.mr_n71999056)
print v(xbgr.mr_n71999920)
print v(xbgr.mr_n72000032)
print v(xbgr.mr_n72000352)
print v(xbgr.mr_n72000464)
print v(xbgr.mr_n72000784)
print v(xbgr.mr_n72000896)
print v(xbgr.mr_n72001216)
print v(xbgr.mr_n72001328)
print v(xbgr.mr_n72001648)
print v(xbgr.mr_n72001760)
print v(xbgr.mr_n72002192)
print v(xbgr.mr_n72002512)
print v(xbgr.mr_n72002624)
print v(xbgr.mr_n72003056)
print v(xbgr.mr_n72003376)
print v(xbgr.mr_n72003488)
print v(xbgr.mr_n72003920)
print v(xbgr.mr_n72004240)
print v(xbgr.mr_n72004352)
print v(xbgr.mr_n72004784)
print v(xbgr.mr_n72005104)
print v(xbgr.mr_n72005968)
print v(xbgr.mr_n72006080)
print v(xbgr.mr_n72006400)
print v(xbgr.mr_n72006512)
print v(xbgr.mr_n72006832)
print v(xbgr.mr_n72006944)
print v(xbgr.mr_n72007264)
print v(xbgr.mr_n72007376)
print v(xbgr.mr_n72007696)
print v(xbgr.mr_n72008560)
print v(xbgr.mr_n72009424)
print v(xbgr.mr_n72010288)
print v(xbgr.mr_n72011152)
print v(xbgr.mr_n72012016)
print v(xbgr.mr_n72012128)
print v(xbgr.mr_n72012448)
print v(xbgr.mr_n72012560)
print v(xbgr.mr_n72012880)
print v(xbgr.mr_n72012992)
print v(xbgr.mr_n72013312)
print v(xbgr.mr_n72013424)
print v(xbgr.mr_n72013856)
print v(xbgr.mr_n72014288)
print v(xbgr.mr_n72014608)
print v(xbgr.mr_n72014720)
print v(xbgr.mr_n72015040)
print v(xbgr.mr_n72015152)
print v(xbgr.mr_n72015472)
print v(xbgr.mr_n72016336)
print v(xbgr.mr_n72016448)
print v(xbgr.mr_n72016768)
print v(xbgr.mr_n72016880)
print v(xbgr.mr_n72017200)
print v(xbgr.mr_n72018064)
print v(xbgr.mr_n72018928)
print v(xbgr.mr_n72019040)
print v(xbgr.mr_n72019360)
print v(xbgr.mr_n72019472)
print v(xbgr.mr_n72019792)
print v(xbgr.mr_n72020656)
print v(xbgr.mr_n72021520)
print v(xbgr.mr_n72022384)
print v(xbgr.mr_n72022496)
print v(xbgr.mr_n72022816)
print v(xbgr.mr_n72022928)
print v(xbgr.mr_n72023248)
print v(xbgr.mr_n72023360)
print v(xbgr.mr_n72023680)
print v(xbgr.mr_n72023792)
print v(xbgr.mr_n72024112)
print v(xbgr.mr_n72024224)
print v(xbgr.mr_n72024544)
print v(xbgr.mr_n72024656)
print v(xbgr.mr_n72024976)
print v(xbgr.mr_n72025088)
print v(xbgr.mr_n72025408)
print v(xbgr.mr_n72025520)
print v(xbgr.mr_n72025840)
print v(xbgr.mr_n72025952)
print v(xbgr.mr_n72026272)
print v(xbgr.mr_n72026384)
print v(xbgr.mr_n72026704)
print v(xbgr.mr_n72026816)
print v(xbgr.mr_n72027136)
print v(xbgr.mr_n72027248)
print v(xbgr.mr_n72027680)
print v(xbgr.mr_n72028000)
print v(xbgr.mr_n72028112)
print v(xbgr.mr_n72028544)
print v(xbgr.mr_n72028864)
print v(xbgr.mr_n72028976)
print v(xbgr.mr_n72029408)
print v(xbgr.mr_n72029728)
print v(xbgr.mr_n72030592)
print v(xbgr.mr_n72031456)
print v(xbgr.mr_n72032320)
print v(xbgr.mr_n72032432)
print v(xbgr.mr_n72032752)
print v(xbgr.mr_n72032864)
print v(xbgr.mr_n72033184)
print v(xbgr.mr_n72034048)
print v(xbgr.mr_n72034912)
print v(xbgr.mr_n72035776)
print v(xbgr.mr_n72035888)
print v(xbgr.mr_n72036208)
print v(xbgr.mr_n72036320)
print v(xbgr.mr_n72036640)
print v(xbgr.mr_n72036752)
print v(xbgr.mr_n72037072)
print v(xbgr.mr_n72037184)
print v(xbgr.mr_n72037504)
print v(xbgr.mr_n72037616)
print v(xbgr.mr_n72037936)
print v(xbgr.mr_n72038048)
print v(xbgr.mr_n72038368)
print v(xbgr.mr_n72038480)
print v(xbgr.mr_n72038800)
print v(xbgr.mr_n72038912)
print v(xbgr.mr_n72039232)
print v(xbgr.mr_n72039344)
print v(xbgr.mr_n72039664)
print v(xbgr.mr_n72039776)
print v(xbgr.mr_n72040096)
print v(xbgr.mr_n72040208)
print v(xbgr.mr_n72040528)
print v(xbgr.mr_n72040640)
print v(xbgr.mr_n72040960)
print v(xbgr.mr_n72041072)
print v(xbgr.mr_n72041504)
print v(xbgr.mr_n72041824)
print v(xbgr.mr_n72042688)
print v(xbgr.mr_n72043552)
print v(xbgr.mr_n72044416)
print v(xbgr.mr_n72044528)
print v(xbgr.mr_n72044960)
print v(xbgr.mr_n72045280)
print v(xbgr.mr_n72045392)
print v(xbgr.mr_n72045824)
print v(xbgr.mr_n72046144)
print v(xbgr.mr_n72046256)
print v(xbgr.mr_n72046576)
print v(xbgr.mr_n72046688)
print v(xbgr.mr_n72047008)
print v(xbgr.mr_n72047120)
print v(xbgr.mr_n72047552)
print v(xbgr.mr_n72047984)
print v(xbgr.mr_n72048416)
print v(xbgr.mr_n72048736)
print v(xbgr.mr_n72049600)
print v(xbgr.mr_n72050464)
print v(xbgr.mr_n72051328)
print v(xbgr.mr_n72052192)
print v(xbgr.mr_n72053056)
print v(xbgr.mr_n72053920)
print v(xbgr.mr_n72054032)
print v(xbgr.mr_n72054352)
print v(xbgr.mr_n72054464)
print v(xbgr.mr_n72054784)
print v(xbgr.mr_n72054896)
print v(xbgr.mr_n72055216)
print v(xbgr.mr_n72055328)
print v(xbgr.mr_n72055648)
print v(xbgr.mr_n72055760)
print v(xbgr.mr_n72056080)
print v(xbgr.mr_n72056192)
print v(xbgr.mr_n72056512)
print v(xbgr.mr_n72057376)
print v(xbgr.mr_n72058240)
print v(xbgr.mr_n72059216)
print v(xbgr.mr_n72059648)
print v(xbgr.mr_n72060080)
print v(xbgr.mr_n72060400)
print v(xbgr.mr_n72060512)
print v(xbgr.mr_n72060832)
print v(xbgr.mr_n72060944)
print v(xbgr.mr_n72061264)
print v(xbgr.mr_n72061376)
print v(xbgr.mr_n72061808)
print v(xbgr.mr_n72062128)
print v(xbgr.mr_n72062240)
print v(xbgr.mr_n72062560)
print v(xbgr.mr_n72062672)
print v(xbgr.mr_n72063104)
print v(xbgr.mr_n72063424)
print v(xbgr.mr_n72063536)
print v(xbgr.mr_n72063968)
print v(xbgr.mr_n72064288)
print v(xbgr.mr_n72064400)
print v(xbgr.mr_n72064832)
print v(xbgr.mr_n72065152)
print v(xbgr.mr_n72066016)
print v(xbgr.mr_n72066880)
print v(xbgr.mr_n72066992)
print v(xbgr.mr_n72067312)
print v(xbgr.mr_n72067424)
print v(xbgr.mr_n72067744)
print v(xbgr.mr_n72067856)
print v(xbgr.mr_n72068176)
print v(xbgr.mr_n72068288)
print v(xbgr.mr_n72068720)
print v(xbgr.mr_n72069040)
print v(xbgr.mr_n72069904)
print v(xbgr.mr_n72070016)
print v(xbgr.mr_n72070336)
print v(xbgr.mr_n72070448)
print v(xbgr.mr_n72070768)
print v(xbgr.mr_n72070880)
print v(xbgr.mr_n72071200)
print v(xbgr.mr_n72072064)
print v(xbgr.mr_n72072496)
print v(xbgr.mr_n72073360)
print v(xbgr.mr_n72073472)
print v(xbgr.mr_n72073792)
print v(xbgr.mr_n72073904)
print v(xbgr.mr_n72074224)
print v(xbgr.mr_n72074336)
print v(xbgr.mr_n72074656)
print v(xbgr.mr_n72074768)
print v(xbgr.mr_n72075088)
print v(xbgr.mr_n72075200)
print v(xbgr.mr_n72075632)
print v(xbgr.mr_n72076384)
print v(xbgr.mr_n72077248)
print v(xbgr.mr_n72077680)
print v(xbgr.mr_n72077792)
print v(xbgr.mr_n72078112)
print v(xbgr.mr_n72078544)
print v(xbgr.mr_n72079408)
print v(xbgr.mr_n72080272)
print v(xbgr.mr_n72081136)
print v(xbgr.mr_n72082000)
print v(xbgr.mr_n72083296)
print v(xbgr.mr_n72084160)
print v(xbgr.mr_n72085136)
print v(xbgr.mr_n72085456)
print v(xbgr.mr_n72085568)
print v(xbgr.mr_n72086000)
print v(xbgr.mr_n72086320)
print v(xbgr.mr_n72087184)
print v(xbgr.mr_n72087296)
print v(xbgr.mr_n72087616)
print v(xbgr.mr_n72087728)
print v(xbgr.mr_n72088160)
print v(xbgr.mr_n72088480)
print v(xbgr.mr_n72088592)
print v(xbgr.mr_n72088912)
print v(xbgr.mr_n72089024)
print v(xbgr.mr_n72089344)
print v(xbgr.mr_n72089456)
print v(xbgr.mr_n72089776)
print v(xbgr.mr_n72089888)
print v(xbgr.mr_n72090320)
print v(xbgr.mr_n72090640)
print v(xbgr.mr_n72090752)
print v(xbgr.mr_n72091072)
print v(xbgr.mr_n72091184)
print v(xbgr.mr_n72091504)
print v(xbgr.mr_n72092368)
print v(xbgr.mr_n72092480)
print v(xbgr.mr_n72093232)
print v(xbgr.mr_n72093344)
print v(xbgr.mr_n72093664)
print v(xbgr.mr_n72093776)
print v(xbgr.mr_n72094096)
print v(xbgr.mr_n72094208)
print v(xbgr.mr_n72094528)
print v(xbgr.mr_n72094640)
print v(xbgr.mr_n72094960)
print v(xbgr.mr_n72095072)
print v(xbgr.mr_n72095392)
print v(xbgr.mr_n72095504)
print v(xbgr.mr_n72095824)
print v(xbgr.mr_n72095936)
print v(xbgr.mr_n72096256)
print v(xbgr.mr_n72096368)
print v(xbgr.mr_n72096688)
print v(xbgr.mr_n72096800)
print v(xbgr.mr_n72097120)
print v(xbgr.mr_n72097232)
print v(xbgr.mr_n72097552)
print v(xbgr.mr_n72097664)
print v(xbgr.mr_n72097984)
print v(xbgr.mr_n72098096)
print v(xbgr.mr_n72098416)
print v(xbgr.mr_n72098528)
print v(xbgr.mr_n72098960)
print v(xbgr.mr_n72099280)
print v(xbgr.mr_n72099392)
print v(xbgr.mr_n72099824)
print v(xbgr.mr_n72100144)
print v(xbgr.mr_n72100256)
print v(xbgr.mr_n72100688)
print v(xbgr.mr_n72101008)
print v(xbgr.mr_n72101872)
print v(xbgr.mr_n72102736)
print v(xbgr.mr_n72103600)
print v(xbgr.mr_n72104464)
print v(xbgr.mr_n72105328)
print v(xbgr.mr_n72106192)
print v(xbgr.mr_n72106304)
print v(xbgr.mr_n72106624)
print v(xbgr.mr_n72106736)
print v(xbgr.mr_n72107056)
print v(xbgr.mr_n72107168)
print v(xbgr.mr_n72107488)
print v(xbgr.mr_n72107600)
print v(xbgr.mr_n72107920)
print v(xbgr.mr_n72108784)
print v(xbgr.mr_n72109648)
print v(xbgr.mr_n72110512)
print v(xbgr.mr_n72110624)
print v(xbgr.mr_n72110944)
print v(xbgr.mr_n72111056)
print v(xbgr.mr_n72111376)
print v(xbgr.mr_n72111488)
print v(xbgr.mr_n72111920)
print v(xbgr.mr_n72112352)
print v(xbgr.mr_n72112784)
print v(xbgr.mr_n72113104)
print v(xbgr.mr_n72113216)
print v(xbgr.mr_n72113536)
print v(xbgr.mr_n72113648)
print v(xbgr.mr_n72113968)
print v(xbgr.mr_n72114080)
print v(xbgr.mr_n72114400)
print v(xbgr.mr_n72114512)
print v(xbgr.mr_n72114832)
print v(xbgr.mr_n72114944)
print v(xbgr.mr_n72115264)
print v(xbgr.mr_n72115376)
print v(xbgr.mr_n72115696)
print v(xbgr.mr_n72115808)
print v(xbgr.mr_n72116240)
print v(xbgr.mr_n72116560)
print v(xbgr.mr_n72116672)
print v(xbgr.mr_n72117104)
print v(xbgr.mr_n72117424)
print v(xbgr.mr_n72117536)
print v(xbgr.mr_n72117968)
print v(xbgr.mr_n72118288)
print v(xbgr.mr_n72119152)
print v(xbgr.mr_n72120016)
print v(xbgr.mr_n72120880)
print v(xbgr.mr_n72121744)
print v(xbgr.mr_n72122608)
print v(xbgr.mr_n72123472)
print v(xbgr.mr_n72123584)
print v(xbgr.mr_n72123904)
print v(xbgr.mr_n72124016)
print v(xbgr.mr_n72124336)
print v(xbgr.mr_n72124448)
print v(xbgr.mr_n72124768)
print v(xbgr.mr_n72124880)
print v(xbgr.mr_n72125200)
print v(xbgr.mr_n72126064)
print v(xbgr.mr_n72126928)
print v(xbgr.mr_n72127792)
print v(xbgr.mr_n72127904)
print v(xbgr.mr_n72128224)
print v(xbgr.mr_n72128336)
print v(xbgr.mr_n72128656)
print v(xbgr.mr_n72128768)
print v(xbgr.mr_n72129200)
print v(xbgr.mr_n72129520)
print v(xbgr.mr_n72129632)
print v(xbgr.mr_n72130064)
print v(xbgr.mr_n72130384)
print v(xbgr.mr_n72130496)
print v(xbgr.mr_n72130928)
print v(xbgr.mr_n72131248)
print v(xbgr.mr_n72131360)
print v(xbgr.mr_n72131680)
print v(xbgr.mr_n72131792)
print v(xbgr.mr_n72132112)
print v(xbgr.mr_n72132224)
print v(xbgr.mr_n72132656)
print v(xbgr.mr_n72132976)
print v(xbgr.mr_n72133840)
print v(xbgr.mr_n72134704)
print v(xbgr.mr_n72135568)
print v(xbgr.mr_n72135680)
print v(xbgr.mr_n72136000)
print v(xbgr.mr_n72136112)
print v(xbgr.mr_n72136432)
print v(xbgr.mr_n72137296)
print v(xbgr.mr_n72138160)
print v(xbgr.mr_n72139024)
print v(xbgr.mr_n72139888)
print v(xbgr.mr_n72140000)
print v(xbgr.mr_n72140320)
print v(xbgr.mr_n72140432)
print v(xbgr.mr_n72140752)
print v(xbgr.mr_n72141616)
print v(xbgr.mr_n72142160)
print v(xbgr.mr_n72142480)
print v(xbgr.mr_n72142592)
print v(xbgr.mr_n72142912)
print v(xbgr.mr_n72143024)
print v(xbgr.mr_n72143344)
print v(xbgr.mr_n72143456)
print v(xbgr.mr_n72143776)
print v(xbgr.mr_n72143888)
print v(xbgr.mr_n72144320)
print v(xbgr.mr_n72145072)
print v(xbgr.mr_n72145936)
print v(xbgr.mr_n72146800)
print v(xbgr.mr_n72147664)
print v(xbgr.mr_n72147776)
print v(xbgr.mr_n72148096)
print v(xbgr.mr_n72148208)
print v(xbgr.mr_n72148528)
print v(xbgr.mr_n72148640)
print v(xbgr.mr_n72148960)
print v(xbgr.mr_n72149072)
print v(xbgr.mr_n72149392)
print v(xbgr.mr_n72149504)
print v(xbgr.mr_n72149824)
print v(xbgr.mr_n72149936)
print v(xbgr.mr_n72150256)
print v(xbgr.mr_n72150368)
print v(xbgr.mr_n72150800)
print v(xbgr.mr_n72151120)
print v(xbgr.mr_n72151232)
print v(xbgr.mr_n72151552)
print v(xbgr.mr_n72151664)
print v(xbgr.mr_n72151984)
print v(xbgr.mr_n72152096)
print v(xbgr.mr_n72152416)
print v(xbgr.mr_n72152528)
print v(xbgr.mr_n72152848)
print v(xbgr.mr_n72152960)
print v(xbgr.mr_n72153392)
print v(xbgr.mr_n72153712)
print v(xbgr.mr_n72154576)
print v(xbgr.mr_n72154688)
print v(xbgr.mr_n72155008)
print v(xbgr.mr_n72155120)
print v(xbgr.mr_n72155552)
print v(xbgr.mr_n72155984)
print v(xbgr.mr_n72156304)
print v(xbgr.mr_n72156416)
print v(xbgr.mr_n72156736)
print v(xbgr.mr_n72156848)
print v(xbgr.mr_n72157168)
print v(xbgr.mr_n72157280)
print v(xbgr.mr_n72157600)
print v(xbgr.mr_n72157712)
print v(xbgr.mr_n72158032)
print v(xbgr.mr_n72158144)
print v(xbgr.mr_n72158576)
print v(xbgr.mr_n72158896)
print v(xbgr.mr_n72159008)
print v(xbgr.mr_n72159440)
print v(xbgr.mr_n72159760)
print v(xbgr.mr_n72160624)
print v(xbgr.mr_n72161488)
print v(xbgr.mr_n72162352)
print v(xbgr.mr_n72163216)
print v(xbgr.mr_n72163328)
print v(xbgr.mr_n72163648)
print v(xbgr.mr_n72163760)
print v(xbgr.mr_n72164080)
print v(xbgr.mr_n72164192)
print v(xbgr.mr_n72164512)
print v(xbgr.mr_n72164624)
print v(xbgr.mr_n72164944)
print v(xbgr.mr_n72165808)
print v(xbgr.mr_n72166672)
print v(xbgr.mr_n72166784)
print v(xbgr.mr_n72167104)
print v(xbgr.mr_n72167216)
print v(xbgr.mr_n72167648)
print v(xbgr.mr_n72168080)
print v(xbgr.mr_n72168400)
print v(xbgr.mr_n72168512)
print v(xbgr.mr_n72168832)
print v(xbgr.mr_n72168944)
print v(xbgr.mr_n72169264)
print v(xbgr.mr_n72169376)
print v(xbgr.mr_n72169696)
print v(xbgr.mr_n72169808)
print v(xbgr.mr_n72170128)
print v(xbgr.mr_n72170992)
print v(xbgr.mr_n72171856)
print v(xbgr.mr_n72172720)
print v(xbgr.mr_n72173584)
print v(xbgr.mr_n72174448)
print v(xbgr.mr_n72174560)
print v(xbgr.mr_n72174992)
print v(xbgr.mr_n72175312)
print v(xbgr.mr_n72175424)
print v(xbgr.mr_n72175856)
print v(xbgr.mr_n72176176)
print v(xbgr.mr_n72176288)
print v(xbgr.mr_n72176720)
print v(xbgr.mr_n72177040)
print v(xbgr.mr_n72177152)
print v(xbgr.mr_n72177472)
print v(xbgr.mr_n72177584)
print v(xbgr.mr_n72177904)
print v(xbgr.mr_n72178016)
print v(xbgr.mr_n72178336)
print v(xbgr.mr_n72178448)
print v(xbgr.mr_n72178768)
print v(xbgr.mr_n72178880)
print v(xbgr.mr_n72179200)
print v(xbgr.mr_n72179312)
print v(xbgr.mr_n72179632)
print v(xbgr.mr_n72179744)
print v(xbgr.mr_n72180064)
print v(xbgr.mr_n72180176)
print v(xbgr.mr_n72180496)
print v(xbgr.mr_n72180608)
print v(xbgr.mr_n72180928)
print v(xbgr.mr_n72181040)
print v(xbgr.mr_n72181360)
print v(xbgr.mr_n72181472)
print v(xbgr.mr_n72181792)
print v(xbgr.mr_n72181904)
print v(xbgr.mr_n72182224)
print v(xbgr.mr_n72183088)
print v(xbgr.mr_n72183952)
print v(xbgr.mr_n72184816)
print v(xbgr.mr_n72184928)
print v(xbgr.mr_n72185360)
print v(xbgr.mr_n72185680)
print v(xbgr.mr_n72185792)
print v(xbgr.mr_n72186112)
print v(xbgr.mr_n72186224)
print v(xbgr.mr_n72186544)
print v(xbgr.mr_n72186656)
print v(xbgr.mr_n72186976)
print v(xbgr.mr_n72187088)
print v(xbgr.mr_n72187520)
print v(xbgr.mr_n72187952)
print v(xbgr.mr_n72188384)
print v(xbgr.mr_n72188816)
print v(xbgr.mr_n72189136)
print v(xbgr.mr_n72189248)
print v(xbgr.mr_n72189680)
print v(xbgr.mr_n72190000)
print v(xbgr.mr_n72190864)
print v(xbgr.mr_n72190976)
print v(xbgr.mr_n72191296)
print v(xbgr.mr_n72191408)
print v(xbgr.mr_n72191728)
print v(xbgr.mr_n72191840)
print v(xbgr.mr_n72192160)
print v(xbgr.mr_n72193136)
print v(xbgr.mr_n72193568)
print v(xbgr.mr_n72194000)
print v(xbgr.mr_n72194320)
print v(xbgr.mr_n72195184)
print v(xbgr.mr_n72195296)
print v(xbgr.mr_n72195616)
print v(xbgr.mr_n72195728)
print v(xbgr.mr_n72196048)
print v(xbgr.mr_n72196160)
print v(xbgr.mr_n72196480)
print v(xbgr.mr_n72196592)
print v(xbgr.mr_n72196912)
print v(xbgr.mr_n72197024)
print v(xbgr.mr_n72197344)
print v(xbgr.mr_n72197456)
print v(xbgr.mr_n72197776)
print v(xbgr.mr_n72197888)
print v(xbgr.mr_n72198208)
print v(xbgr.mr_n72198320)
print v(xbgr.mr_n72198640)
print v(xbgr.mr_n72199504)
print v(xbgr.mr_n72200368)
print v(xbgr.mr_n72201232)
print v(xbgr.mr_n72202096)
print v(xbgr.mr_n72202960)
print v(xbgr.mr_n72203824)
print v(xbgr.mr_n72204688)
print v(xbgr.mr_n72205552)
print v(xbgr.mr_n72206416)
print v(xbgr.mr_n72207280)
print v(xbgr.mr_n72208144)
print v(xbgr.mr_n72209008)
print v(xbgr.mr_n72209120)
print v(xbgr.mr_n72209440)
print v(xbgr.mr_n72209552)
print v(xbgr.mr_n72209872)
print v(xbgr.mr_n72209984)
print v(xbgr.mr_n72210304)
print v(xbgr.mr_n72210416)
print v(xbgr.mr_n72210736)
print v(xbgr.mr_n72210848)
print v(xbgr.mr_n72211280)
print v(xbgr.mr_n72211600)
print v(xbgr.mr_n72211712)
print v(xbgr.mr_n72212144)
print v(xbgr.mr_n72212464)
print v(xbgr.mr_n72213328)
print v(xbgr.mr_n72214192)
print v(xbgr.mr_n72215056)
print v(xbgr.mr_n72215920)
print v(xbgr.mr_n72216032)
print v(xbgr.mr_n72216352)
print v(xbgr.mr_n72216464)
print v(xbgr.mr_n72216784)
print v(xbgr.mr_n72216896)
print v(xbgr.mr_n72217216)
print v(xbgr.mr_n72217328)
print v(xbgr.mr_n72217648)
print v(xbgr.mr_n72217760)
print v(xbgr.mr_n72218080)
print v(xbgr.mr_n72218192)
print v(xbgr.mr_n72218512)
print v(xbgr.mr_n72218624)
print v(xbgr.mr_n72218944)
print v(xbgr.mr_n72219808)
print v(xbgr.mr_n72220672)
print v(xbgr.mr_n72220784)
print v(xbgr.mr_n72221104)
print v(xbgr.mr_n72221216)
print v(xbgr.mr_n72221648)
print v(xbgr.mr_n72222080)
print v(xbgr.mr_n72222400)
print v(xbgr.mr_n72222512)
print v(xbgr.mr_n72222832)
print v(xbgr.mr_n72222944)
print v(xbgr.mr_n72223264)
print v(xbgr.mr_n72223376)
print v(xbgr.mr_n72223696)
print v(xbgr.mr_n72223808)
print v(xbgr.mr_n72224128)
print v(xbgr.mr_n72224240)
print v(xbgr.mr_n72224672)
print v(xbgr.mr_n72224992)
print v(xbgr.mr_n72225104)
print v(xbgr.mr_n72225536)
print v(xbgr.mr_n72225856)
print v(xbgr.mr_n72225968)
print v(xbgr.mr_n72226288)
print v(xbgr.mr_n72227152)
print v(xbgr.mr_n72228016)
print v(xbgr.mr_n72228880)
print v(xbgr.mr_n72229744)
print v(xbgr.mr_n72229856)
print v(xbgr.mr_n72230176)
print v(xbgr.mr_n72230288)
print v(xbgr.mr_n72230608)
print v(xbgr.mr_n72230720)
print v(xbgr.mr_n72231040)
print v(xbgr.mr_n72231152)
print v(xbgr.mr_n72231472)
print v(xbgr.mr_n72231584)
print v(xbgr.mr_n72231904)
print v(xbgr.mr_n72232016)
print v(xbgr.mr_n72232336)
print v(xbgr.mr_n72233200)
print v(xbgr.mr_n72234064)
print v(xbgr.mr_n72234176)
print v(xbgr.mr_n72234608)
print v(xbgr.mr_n72234928)
print v(xbgr.mr_n72235040)
print v(xbgr.mr_n72235360)
print v(xbgr.mr_n72235472)
print v(xbgr.mr_n72235792)
print v(xbgr.mr_n72235904)
print v(xbgr.mr_n72236224)
print v(xbgr.mr_n72236336)
print v(xbgr.mr_n72236656)
print v(xbgr.mr_n72236768)
print v(xbgr.mr_n72237088)
print v(xbgr.mr_n72237200)
print v(xbgr.mr_n72237632)
print v(xbgr.mr_n72238064)
print v(xbgr.mr_n72238496)
print v(xbgr.mr_n72238928)
print v(xbgr.mr_n72239248)
print v(xbgr.mr_n72239680)
print v(xbgr.mr_n72239792)
print v(xbgr.mr_n72240112)
print v(xbgr.mr_n72240224)
print v(xbgr.mr_n72240544)
print v(xbgr.mr_n72240656)
print v(xbgr.mr_n72240976)
print v(xbgr.mr_n72241088)
print v(xbgr.mr_n72241408)
print v(xbgr.mr_n72241520)
print v(xbgr.mr_n72241840)
print v(xbgr.mr_n72241952)
print v(xbgr.mr_n72242704)
print v(xbgr.mr_n72242816)
print v(xbgr.mr_n72243248)
print v(xbgr.mr_n72243568)
print v(xbgr.mr_n72244000)
print v(xbgr.mr_n72244112)
print v(xbgr.mr_n72244544)
print v(xbgr.mr_n72244864)
print v(xbgr.mr_n72244976)
print v(xbgr.mr_n72245408)
print v(xbgr.mr_n72245728)
print v(xbgr.mr_n72245840)
print v(xbgr.mr_n72246272)
print v(xbgr.mr_n72247024)
print v(xbgr.mr_n72247888)
print v(xbgr.mr_n72248752)
print v(xbgr.mr_n72249616)
print v(xbgr.mr_n72250480)
print v(xbgr.mr_n72251344)
print v(xbgr.mr_n72251456)
print v(xbgr.mr_n72251776)
print v(xbgr.mr_n72251888)
print v(xbgr.mr_n72252208)
print v(xbgr.mr_n72252320)
print v(xbgr.mr_n72252640)
print v(xbgr.mr_n72252752)
print v(xbgr.mr_n72253072)
print v(xbgr.mr_n72253936)
print v(xbgr.mr_n72254800)
print v(xbgr.mr_n72255664)
print v(xbgr.mr_n72255776)
print v(xbgr.mr_n72256096)
print v(xbgr.mr_n72256208)
print v(xbgr.mr_n72256528)
print v(xbgr.mr_n72256640)
print v(xbgr.mr_n72256960)
print v(xbgr.mr_n72257072)
print v(xbgr.mr_n72257392)
print v(xbgr.mr_n72257504)
print v(xbgr.mr_n72257824)
print v(xbgr.mr_n72257936)
print v(xbgr.mr_n72258256)
print v(xbgr.mr_n72258368)
print v(xbgr.mr_n72258688)
print v(xbgr.mr_n72258800)
print v(xbgr.mr_n72259120)
print v(xbgr.mr_n72259984)
print v(xbgr.mr_n72260416)
print v(xbgr.mr_n72261280)
print v(xbgr.mr_n72261712)
print v(xbgr.mr_n72262576)
print v(xbgr.mr_n72263440)
print v(xbgr.mr_n72264736)
print v(xbgr.mr_n72266032)
print v(xbgr.mr_n72266144)
print v(xbgr.mr_n72266464)
print v(xbgr.mr_n72266576)
print v(xbgr.mr_n72267008)
print v(xbgr.mr_n72267328)
print v(xbgr.mr_n72267440)
print v(xbgr.mr_n72267872)
print v(xbgr.mr_n72268192)
print v(xbgr.mr_n72268304)
print v(xbgr.mr_n72268624)
print v(xbgr.mr_n72268736)
print v(xbgr.mr_n72269056)
print v(xbgr.mr_n72269168)
print v(xbgr.mr_n72269600)
print v(xbgr.mr_n72269920)
print v(xbgr.mr_n72270032)
print v(xbgr.mr_n72270464)
print v(xbgr.mr_n72270784)
print v(xbgr.mr_n72270896)
print v(xbgr.mr_n72271328)
print v(xbgr.mr_n72271648)
print v(xbgr.mr_n72271760)
print v(xbgr.mr_n72272080)
print v(xbgr.mr_n72272512)
print v(xbgr.mr_n72272624)
print v(xbgr.mr_n72272944)
print v(xbgr.mr_n72273056)
print v(xbgr.mr_n72273376)
print v(xbgr.mr_n72273488)
print v(xbgr.mr_n72273808)
print v(xbgr.mr_n72273920)
print v(xbgr.mr_n72274672)
print v(xbgr.mr_n72275536)
print v(xbgr.mr_n72276400)
print v(xbgr.mr_n72276512)
print v(xbgr.mr_n72276832)
print v(xbgr.mr_n72276944)
print v(xbgr.mr_n72277264)
print v(xbgr.mr_n72277376)
print v(xbgr.mr_n72277696)
print v(xbgr.mr_n72277808)
print v(xbgr.mr_n72278560)
print v(xbgr.mr_n72278992)
print v(xbgr.mr_n72279856)
print v(xbgr.mr_n72281152)
print v(xbgr.mr_n72281584)
print v(xbgr.mr_n72282448)
print v(xbgr.mr_n72282560)
print v(xbgr.mr_n72282880)
print v(xbgr.mr_n72282992)
print v(xbgr.mr_n72283312)
print v(xbgr.mr_n72284176)
print v(xbgr.mr_n72284608)
print v(xbgr.mr_n72284720)
print v(xbgr.mr_n72285040)
print v(xbgr.mr_n72285904)
print v(xbgr.mr_n72286768)
print v(xbgr.mr_n72287632)
print v(xbgr.mr_n72288496)
print v(xbgr.mr_n72288608)
print v(xbgr.mr_n72288928)
print v(xbgr.mr_n72289040)
print v(xbgr.mr_n72289360)
print v(xbgr.mr_n72289472)
print v(xbgr.mr_n72289792)
print v(xbgr.mr_n72289904)
print v(xbgr.mr_n72290656)
print v(xbgr.mr_n72291520)
print v(xbgr.mr_n72292384)
print v(xbgr.mr_n72292496)
print v(xbgr.mr_n72292928)
print v(xbgr.mr_n72293360)
print v(xbgr.mr_n72293792)
print v(xbgr.mr_n72294112)
print v(xbgr.mr_n72294224)
print v(xbgr.mr_n72294544)
print v(xbgr.mr_n72294656)
print v(xbgr.mr_n72294976)
print v(xbgr.mr_n72295088)
print v(xbgr.mr_n72295408)
print v(xbgr.mr_n72295520)
print v(xbgr.mr_n72295840)
print v(xbgr.mr_n72295952)
print v(xbgr.mr_n72296272)
print v(xbgr.mr_n72296384)
print v(xbgr.mr_n72296704)
print v(xbgr.mr_n72296816)
print v(xbgr.mr_n72297136)
print v(xbgr.mr_n72297248)
print v(xbgr.mr_n72298432)
print v(xbgr.mr_n72298976)
print v(xbgr.mr_n72299408)
print v(xbgr.mr_n72299840)
print v(xbgr.mr_n72300592)
print v(xbgr.mr_n72300704)
print v(xbgr.mr_n72301024)
print v(xbgr.mr_n72301136)
print v(xbgr.mr_n72301456)
print v(xbgr.mr_n72301568)
print v(xbgr.mr_n72301888)
print v(xbgr.mr_n72302000)
print v(xbgr.mr_n72302320)
print v(xbgr.mr_n72302432)
print v(xbgr.mr_n72302752)
print v(xbgr.mr_n72302864)
print v(xbgr.mr_n72303296)
print v(xbgr.mr_n72303616)
print v(xbgr.mr_n72303728)
print v(xbgr.mr_n72304048)
print v(xbgr.mr_n72304160)
print v(xbgr.mr_n72304592)
print v(xbgr.mr_n72304912)
print v(xbgr.mr_n72305024)
print v(xbgr.mr_n72305344)
print v(xbgr.mr_n72305456)
print v(xbgr.mr_n72305776)
print v(xbgr.mr_n72305888)
print v(xbgr.mr_n72306208)
print v(xbgr.mr_n72306320)
print v(xbgr.mr_n72306640)
print v(xbgr.mr_n72306752)
print v(xbgr.mr_n72307072)
print v(xbgr.mr_n72307184)
print v(xbgr.mr_n72307504)
print v(xbgr.mr_n72308368)
print v(xbgr.mr_n72308912)
print v(xbgr.mr_n72309232)
print v(xbgr.mr_n72309344)
print v(xbgr.mr_n72309776)
print v(xbgr.mr_n72310096)
print v(xbgr.mr_n72310208)
print v(xbgr.mr_n72310960)
print v(xbgr.mr_n72311824)
print v(xbgr.mr_n72311936)
print v(xbgr.mr_n72312256)
print v(xbgr.mr_n72312368)
print v(xbgr.mr_n72312688)
print v(xbgr.mr_n72312800)
print v(xbgr.mr_n72313120)
print v(xbgr.mr_n72313552)
print v(xbgr.mr_n72314416)
print v(xbgr.mr_n72315712)
print v(xbgr.mr_n72316688)
print v(xbgr.mr_n72317008)
print v(xbgr.mr_n72317120)
print v(xbgr.mr_n72317440)
print v(xbgr.mr_n72317552)
print v(xbgr.mr_n72317872)
print v(xbgr.mr_n72318736)
print v(xbgr.mr_n72318848)
print v(xbgr.mr_n72319168)
print v(xbgr.mr_n72319280)
print v(xbgr.mr_n72319600)
print v(xbgr.mr_n72319712)
print v(xbgr.mr_n72320032)
print v(xbgr.mr_n72320144)
print v(xbgr.mr_n72320464)
print v(xbgr.mr_n72320576)
print v(xbgr.mr_n72320896)
print v(xbgr.mr_n72321440)
print v(xbgr.mr_n72321760)
print v(xbgr.mr_n72323056)
print v(xbgr.mr_n72323920)
print v(xbgr.mr_n72324464)
print v(xbgr.mr_n72324896)
print v(xbgr.mr_n72325648)
print v(xbgr.mr_n72325760)
print v(xbgr.mr_n72326080)
print v(xbgr.mr_n72326192)
print v(xbgr.mr_n72326512)
print v(xbgr.mr_n72326624)
print v(xbgr.mr_n72326944)
print v(xbgr.mr_n72327056)
print v(xbgr.mr_n72327376)
print v(xbgr.mr_n72327488)
print v(xbgr.mr_n72327808)
print v(xbgr.mr_n72327920)
print v(xbgr.mr_n72328352)
print v(xbgr.mr_n72328672)
print v(xbgr.mr_n72328784)
print v(xbgr.mr_n72329104)
print v(xbgr.mr_n72329216)
print v(xbgr.mr_n72329536)
print v(xbgr.mr_n72329648)
print v(xbgr.mr_n72329968)
print v(xbgr.mr_n72330080)
print v(xbgr.mr_n72330400)
print v(xbgr.mr_n72330512)
print v(xbgr.mr_n72330832)
print v(xbgr.mr_n72330944)
print v(xbgr.mr_n72331264)
print v(xbgr.mr_n72331376)
print v(xbgr.mr_n72331696)
print v(xbgr.mr_n72331808)
print v(xbgr.mr_n72332240)
print v(xbgr.mr_n72332672)
print v(xbgr.mr_n72333104)
print v(xbgr.mr_n72333424)
print v(xbgr.mr_n72333536)
print v(xbgr.mr_n72333856)
print v(xbgr.mr_n72333968)
print v(xbgr.mr_n72334288)
print v(xbgr.mr_n72334400)
print v(xbgr.mr_n72334720)
print v(xbgr.mr_n72334832)
print v(xbgr.mr_n72335152)
print v(xbgr.mr_n72335264)
print v(xbgr.mr_n72335696)
print v(xbgr.mr_n72336016)
print v(xbgr.mr_n72336880)
print v(xbgr.mr_n72337744)
print v(xbgr.mr_n72337856)
print v(xbgr.mr_n72338176)
print v(xbgr.mr_n72338288)
print v(xbgr.mr_n72338608)
print v(xbgr.mr_n72338720)
print v(xbgr.mr_n72339040)
print v(xbgr.mr_n72339152)
print v(xbgr.mr_n72339472)
print v(xbgr.mr_n72340448)
print v(xbgr.mr_n72340768)
print v(xbgr.mr_n72340880)
print v(xbgr.mr_n72341200)
print v(xbgr.mr_n72341312)
print v(xbgr.mr_n72341632)
print v(xbgr.mr_n72341744)
print v(xbgr.mr_n72342064)
print v(xbgr.mr_n72342176)
print v(xbgr.mr_n72342496)
print v(xbgr.mr_n72342608)
print v(xbgr.mr_n72342928)
print v(xbgr.mr_n72343792)
print v(xbgr.mr_n72344656)
print v(xbgr.mr_n72345520)
print v(xbgr.mr_n72346384)
print v(xbgr.mr_n72346496)
print v(xbgr.mr_n72346816)
print v(xbgr.mr_n72346928)
print v(xbgr.mr_n72347248)
print v(xbgr.mr_n72348224)
print v(xbgr.mr_n72348656)
print v(xbgr.mr_n72348976)
print v(xbgr.mr_n72349840)
print v(xbgr.mr_n72350704)
print v(xbgr.mr_n72351568)
print v(xbgr.mr_n72352432)
print v(xbgr.mr_n72352544)
print v(xbgr.mr_n72352976)
print v(xbgr.mr_n72353296)
print v(xbgr.mr_n72353408)
print v(xbgr.mr_n72353728)
print v(xbgr.mr_n72353840)
print v(xbgr.mr_n72354160)
print v(xbgr.mr_n72354272)
print v(xbgr.mr_n72354704)
print v(xbgr.mr_n72355024)
print v(xbgr.mr_n72355136)
print v(xbgr.mr_n72355568)
print v(xbgr.mr_n72355888)
print v(xbgr.mr_n72356000)
print v(xbgr.mr_n72356320)
print v(xbgr.mr_n72356432)
print v(xbgr.mr_n72356752)
print v(xbgr.mr_n72356864)
print v(xbgr.mr_n72357184)
print v(xbgr.mr_n72357296)
print v(xbgr.mr_n72357616)
print v(xbgr.mr_n72357728)
print v(xbgr.mr_n72358048)
print v(xbgr.mr_n72358160)
print v(xbgr.mr_n72358592)
print v(xbgr.mr_n72358912)
print v(xbgr.mr_n72359776)
print v(xbgr.mr_n72360320)
print v(xbgr.mr_n72360640)
print v(xbgr.mr_n72360752)
print v(xbgr.mr_n72361072)
print v(xbgr.mr_n72361184)
print v(xbgr.mr_n72361504)
print v(xbgr.mr_n72361616)
print v(xbgr.mr_n72361936)
print v(xbgr.mr_n72362048)
print v(xbgr.mr_n72362368)
print v(xbgr.mr_n72362480)
print v(xbgr.mr_n72362800)
print v(xbgr.mr_n72362912)
print v(xbgr.mr_n72363344)
print v(xbgr.mr_n72363664)
print v(xbgr.mr_n72364528)
print v(xbgr.mr_n72364960)
print v(xbgr.mr_n72365824)
print v(xbgr.mr_n72366688)
print v(xbgr.mr_n72368096)
print v(xbgr.mr_n72368960)
print v(xbgr.mr_n72369392)
print v(xbgr.mr_n72369712)
print v(xbgr.mr_n72370576)
print v(xbgr.mr_n72370688)
print v(xbgr.mr_n72371008)
print v(xbgr.mr_n72371120)
print v(xbgr.mr_n72371440)
print v(xbgr.mr_n72371552)
print v(xbgr.mr_n72371872)
print v(xbgr.mr_n72371984)
print v(xbgr.mr_n72372304)
print v(xbgr.mr_n72372416)
print v(xbgr.mr_n72372736)
print v(xbgr.mr_n72372848)
print v(xbgr.mr_n72373168)
print v(xbgr.mr_n72373280)
print v(xbgr.mr_n72373600)
print v(xbgr.mr_n72374464)
print v(xbgr.mr_n72375440)
print v(xbgr.mr_n72375872)
print v(xbgr.mr_n72376304)
print v(xbgr.mr_n72376624)
print v(xbgr.mr_n72376736)
print v(xbgr.mr_n72377056)
print v(xbgr.mr_n72377168)
print v(xbgr.mr_n72377488)
print v(xbgr.mr_n72378352)
print v(xbgr.mr_n72379216)
print v(xbgr.mr_n72380080)
print v(xbgr.mr_n72380192)
print v(xbgr.mr_n72380512)
print v(xbgr.mr_n72380624)
print v(xbgr.mr_n72380944)
print v(xbgr.mr_n72381808)
print v(xbgr.mr_n72382672)
print v(xbgr.mr_n72383536)
print v(xbgr.mr_n72383648)
print v(xbgr.mr_n72383968)
print v(xbgr.mr_n72384080)
print v(xbgr.mr_n72384400)
print v(xbgr.mr_n72384512)
print v(xbgr.mr_n72384832)
print v(xbgr.mr_n72384944)
print v(xbgr.mr_n72385264)
print v(xbgr.mr_n72386128)
print v(xbgr.mr_n72386992)
print v(xbgr.mr_n72387104)
print v(xbgr.mr_n72387424)
print v(xbgr.mr_n72387536)
print v(xbgr.mr_n72387856)
print v(xbgr.mr_n72387968)
print v(xbgr.mr_n72388288)
print v(xbgr.mr_n72388400)
print v(xbgr.mr_n72388720)
print v(xbgr.mr_n72388832)
print v(xbgr.mr_n72389264)
print v(xbgr.mr_n72389584)
print v(xbgr.mr_n72389696)
print v(xbgr.mr_n72390016)
print v(xbgr.mr_n72390128)
print v(xbgr.mr_n72390448)
print v(xbgr.mr_n72390560)
print v(xbgr.mr_n72390880)
print v(xbgr.mr_n72390992)
print v(xbgr.mr_n72391312)
print v(xbgr.mr_n72392176)
print v(xbgr.mr_n72392288)
print v(xbgr.mr_n72392720)
print v(xbgr.mr_n72393040)
print v(xbgr.mr_n72393152)
print v(xbgr.mr_n72393472)
print v(xbgr.mr_n72393584)
print v(xbgr.mr_n72393904)
print v(xbgr.mr_n72394016)
print v(xbgr.mr_n72394336)
print v(xbgr.mr_n72394448)
print v(xbgr.mr_n72394768)
print v(xbgr.mr_n72394880)
print v(xbgr.mr_n72395200)
print v(xbgr.mr_n72395312)
print v(xbgr.mr_n72395632)
print v(xbgr.mr_n72396064)
print v(xbgr.mr_n72396176)
print v(xbgr.mr_n72396496)
print v(xbgr.mr_n72397040)
print v(xbgr.mr_n72397360)
print v(xbgr.mr_n72397472)
print v(xbgr.mr_n72397904)
print v(xbgr.mr_n72398336)
print v(xbgr.mr_n72398768)
print v(xbgr.mr_n72399200)
print v(xbgr.mr_n72399632)
print v(xbgr.mr_n72399952)
print v(xbgr.mr_n72400064)
print v(xbgr.mr_n72400496)
print v(xbgr.mr_n72400816)
print v(xbgr.mr_n72400928)
print v(xbgr.mr_n72401360)
print v(xbgr.mr_n72401680)
print v(xbgr.mr_n72402544)
print v(xbgr.mr_n72403840)
print v(xbgr.mr_n72404384)
print v(xbgr.mr_n72404704)
print v(xbgr.mr_n72405248)
print v(xbgr.mr_n72405568)
print v(xbgr.mr_n72405680)
print v(xbgr.mr_n72406432)
print v(xbgr.mr_n72406864)
print v(xbgr.mr_n72407728)
print v(xbgr.mr_n72408592)
print v(xbgr.mr_n72409888)
print v(xbgr.mr_n72410752)
print v(xbgr.mr_n72411184)
print v(xbgr.mr_n72411296)
print v(xbgr.mr_n72412048)
print v(xbgr.mr_n72412160)
print v(xbgr.mr_n72412480)
print v(xbgr.mr_n72412592)
print v(xbgr.mr_n72412912)
print v(xbgr.mr_n72413024)
print v(xbgr.mr_n72413776)
print v(xbgr.mr_n72415072)
print v(xbgr.mr_n72415936)
print v(xbgr.mr_n72416800)
print v(xbgr.mr_n72417232)
print v(xbgr.mr_n72417344)
print v(xbgr.mr_n72417664)
print v(xbgr.mr_n72417776)
print v(xbgr.mr_n72418096)
print v(xbgr.mr_n72418208)
print v(xbgr.mr_n72418528)
print v(xbgr.mr_n72418640)
print v(xbgr.mr_n72419392)
print v(xbgr.mr_n72419504)
print v(xbgr.mr_n72419824)
print v(xbgr.mr_n72419936)
print v(xbgr.mr_n72420256)
print v(xbgr.mr_n72420368)
print v(xbgr.mr_n72420688)
print v(xbgr.mr_n72421552)
print v(xbgr.mr_n72421664)
print v(xbgr.mr_n72421984)
print v(xbgr.mr_n72422096)
print v(xbgr.mr_n72422528)
print v(xbgr.mr_n72422848)
print v(xbgr.mr_n72422960)
print v(xbgr.mr_n72423280)
print v(xbgr.mr_n72423392)
print v(xbgr.mr_n72423712)
print v(xbgr.mr_n72423824)
print v(xbgr.mr_n72424256)
print v(xbgr.mr_n72424688)
print v(xbgr.mr_n72425008)
print v(xbgr.mr_n72425120)
print v(xbgr.mr_n72425440)
print v(xbgr.mr_n72425552)
print v(xbgr.mr_n72425872)
print v(xbgr.mr_n72425984)
print v(xbgr.mr_n72426416)
print v(xbgr.mr_n72426736)
print v(xbgr.mr_n72426848)
print v(xbgr.mr_n72427280)
print v(xbgr.mr_n72427600)
print v(xbgr.mr_n72427712)
print v(xbgr.mr_n72428032)
print v(xbgr.mr_n72428144)
print v(xbgr.mr_n72428464)
print v(xbgr.mr_n72428576)
print v(xbgr.mr_n72428896)
print v(xbgr.mr_n72429008)
print v(xbgr.mr_n72429328)
print v(xbgr.mr_n72430192)
print v(xbgr.mr_n72431056)
print v(xbgr.mr_n72431168)
print v(xbgr.mr_n72431488)
print v(xbgr.mr_n72432032)
print v(xbgr.mr_n72432352)
print v(xbgr.mr_n72432784)
print v(xbgr.mr_n72434080)
print v(xbgr.mr_n72435376)
print v(xbgr.mr_n72435488)
print v(xbgr.mr_n72435808)
print v(xbgr.mr_n72435920)
print v(xbgr.mr_n72436240)
print v(xbgr.mr_n72436352)
print v(xbgr.mr_n72436672)
print v(xbgr.mr_n72436784)
print v(xbgr.mr_n72437104)
print v(xbgr.mr_n72437216)
print v(xbgr.mr_n72437536)
print v(xbgr.mr_n72437648)
print v(xbgr.mr_n72437968)
print v(xbgr.mr_n72438080)
print v(xbgr.mr_n72438512)
print v(xbgr.mr_n72438832)
print v(xbgr.mr_n72439696)
print v(xbgr.mr_n72439808)
print v(xbgr.mr_n72440128)
print v(xbgr.mr_n72440240)
print v(xbgr.mr_n72440560)
print v(xbgr.mr_n72440672)
print v(xbgr.mr_n72440992)
print v(xbgr.mr_n72441104)
print v(xbgr.mr_n72441424)
print v(xbgr.mr_n72442288)
print v(xbgr.mr_n72443152)
print v(xbgr.mr_n72444016)
print v(xbgr.mr_n72444880)
print v(xbgr.mr_n72445744)
print v(xbgr.mr_n72445856)
print v(xbgr.mr_n72446176)
print v(xbgr.mr_n72446288)
print v(xbgr.mr_n72446608)
print v(xbgr.mr_n72446720)
print v(xbgr.mr_n72447040)
print v(xbgr.mr_n72447152)
print v(xbgr.mr_n72447472)
print v(xbgr.mr_n72447584)
print v(xbgr.mr_n72447904)
print v(xbgr.mr_n72448016)
print v(xbgr.mr_n72448336)
print v(xbgr.mr_n72448448)
print v(xbgr.mr_n72448768)
print v(xbgr.mr_n72448880)
print v(xbgr.mr_n72449200)
print v(xbgr.mr_n72449312)
print v(xbgr.mr_n72449632)
print v(xbgr.mr_n72449744)
print v(xbgr.mr_n72450176)
print v(xbgr.mr_n72450496)
print v(xbgr.mr_n72450608)
print v(xbgr.mr_n72450928)
print v(xbgr.mr_n72451040)
print v(xbgr.mr_n72451472)
print v(xbgr.mr_n72451792)
print v(xbgr.mr_n72451904)
print v(xbgr.mr_n72452336)
print v(xbgr.mr_n72452656)
print v(xbgr.mr_n72452768)
print v(xbgr.mr_n72453200)
print v(xbgr.mr_n72453632)
print v(xbgr.mr_n72453952)
print v(xbgr.mr_n72454064)
print v(xbgr.mr_n72454496)
print v(xbgr.mr_n72454816)
print v(xbgr.mr_n72454928)
print v(xbgr.mr_n72455248)
print v(xbgr.mr_n72455360)
print v(xbgr.mr_n72455680)
print v(xbgr.mr_n72455792)
print v(xbgr.mr_n72456112)
print v(xbgr.mr_n72456224)
print v(xbgr.mr_n72456544)
print v(xbgr.mr_n72456656)
print v(xbgr.mr_n72456976)
print v(xbgr.mr_n72457088)
print v(xbgr.mr_n72457408)
print v(xbgr.mr_n72457520)
print v(xbgr.mr_n72457840)
print v(xbgr.mr_n72457952)
print v(xbgr.mr_n72458272)
print v(xbgr.mr_n72459136)
print v(xbgr.mr_n72459248)
print v(xbgr.mr_n72459568)
print v(xbgr.mr_n72459680)
print v(xbgr.mr_n72460000)
print v(xbgr.mr_n72460864)
print v(xbgr.mr_n72461728)
print v(xbgr.mr_n72462592)
print v(xbgr.mr_n72463456)
print v(xbgr.mr_n72464320)
print v(xbgr.mr_n72464432)
print v(xbgr.mr_n72464752)
print v(xbgr.mr_n72464864)
print v(xbgr.mr_n72465184)
print v(xbgr.mr_n72465296)
print v(xbgr.mr_n72465616)
print v(xbgr.mr_n72466480)
print v(xbgr.mr_n72467344)
print v(xbgr.mr_n72468208)
print v(xbgr.mr_n72469072)
print v(xbgr.mr_n72469936)
print v(xbgr.mr_n72470800)
print v(xbgr.mr_n72471664)
print v(xbgr.mr_n72471776)
print v(xbgr.mr_n72472096)
print v(xbgr.mr_n72472208)
print v(xbgr.mr_n72472640)
print v(xbgr.mr_n72472960)
print v(xbgr.mr_n72473824)
print v(xbgr.mr_n72474368)
print v(xbgr.mr_n72474800)
print v(xbgr.mr_n72475232)
print v(xbgr.mr_n72475984)
print v(xbgr.mr_n72476848)
print v(xbgr.mr_n72477712)
print v(xbgr.mr_n72477824)
print v(xbgr.mr_n72478144)
print v(xbgr.mr_n72478256)
print v(xbgr.mr_n72478688)
print v(xbgr.mr_n72479120)
print v(xbgr.mr_n72479440)
print v(xbgr.mr_n72480304)
print v(xbgr.mr_n72480416)
print v(xbgr.mr_n72480848)
print v(xbgr.mr_n72481168)
print v(xbgr.mr_n72481280)
print v(xbgr.mr_n72481712)
print v(xbgr.mr_n72482032)
print v(xbgr.mr_n72482896)
print v(xbgr.mr_n72483008)
print v(xbgr.mr_n72483328)
print v(xbgr.mr_n72484192)
print v(xbgr.mr_n72485056)
print v(xbgr.mr_n72485168)
print v(xbgr.mr_n72485488)
print v(xbgr.mr_n72485600)
print v(xbgr.mr_n72485920)
print v(xbgr.mr_n72486784)
print v(xbgr.mr_n72487216)
print v(xbgr.mr_n72487328)
print v(xbgr.mr_n72487760)
print v(xbgr.mr_n72488080)
print v(xbgr.mr_n72488192)
print v(xbgr.mr_n72488624)
print v(xbgr.mr_n72489376)
print v(xbgr.mr_n72489488)
print v(xbgr.mr_n72489808)
print v(xbgr.mr_n72489920)
print v(xbgr.mr_n72490240)
print v(xbgr.mr_n72490352)
print v(xbgr.mr_n72490672)
print v(xbgr.mr_n72491104)
print v(xbgr.mr_n72491216)
print v(xbgr.mr_n72491968)
print v(xbgr.mr_n72492400)
print v(xbgr.mr_n72492512)
print v(xbgr.mr_n72493376)
print v(xbgr.mr_n72493696)
print v(xbgr.mr_n72493808)
print v(xbgr.mr_n72494128)
print v(xbgr.mr_n72494992)
print v(xbgr.mr_n72495856)
print v(xbgr.mr_n72496720)
print v(xbgr.mr_n72497584)
print v(xbgr.mr_n72497696)
print v(xbgr.mr_n72498016)
print v(xbgr.mr_n72498128)
print v(xbgr.mr_n72498448)
print v(xbgr.mr_n72498560)
print v(xbgr.mr_n72498880)
print v(xbgr.mr_n72498992)
print v(xbgr.mr_n72499312)
print v(xbgr.mr_n72499424)
print v(xbgr.mr_n72499744)
print v(xbgr.mr_n72499856)
print v(xbgr.mr_n72500176)
print v(xbgr.mr_n72500288)
print v(xbgr.mr_n72500608)
print v(xbgr.mr_n72500720)
print v(xbgr.mr_n72501040)
print v(xbgr.mr_n72501152)
print v(xbgr.mr_n72501472)
print v(xbgr.mr_n72501584)
print v(xbgr.mr_n72502016)
print v(xbgr.mr_n72502448)
print v(xbgr.mr_n72502880)
print v(xbgr.mr_n72503200)
print v(xbgr.mr_n72503312)
print v(xbgr.mr_n72503632)
print v(xbgr.mr_n72504496)
print v(xbgr.mr_n72504608)
print v(xbgr.mr_n72504928)
print v(xbgr.mr_n72505040)
print v(xbgr.mr_n72505360)
print v(xbgr.mr_n72505472)
print v(xbgr.mr_n72505904)
print v(xbgr.mr_n72506224)
print v(xbgr.mr_n72506336)
print v(xbgr.mr_n72506656)
print v(xbgr.mr_n72506768)
print v(xbgr.mr_n72507200)
print v(xbgr.mr_n72507520)
print v(xbgr.mr_n72507952)
print v(xbgr.mr_n72508064)
print v(xbgr.mr_n72508384)
print v(xbgr.mr_n72508496)
print v(xbgr.mr_n72508816)
print v(xbgr.mr_n72508928)
print v(xbgr.mr_n72509248)
print v(xbgr.mr_n72509360)
print v(xbgr.mr_n72509792)
print v(xbgr.mr_n72510112)
print v(xbgr.mr_n72510224)
print v(xbgr.mr_n72510544)
print v(xbgr.mr_n72510656)
print v(xbgr.mr_n72510976)
print v(xbgr.mr_n72511088)
print v(xbgr.mr_n72511408)
print v(xbgr.mr_n72511520)
print v(xbgr.mr_n72511840)
print v(xbgr.mr_n72511952)
print v(xbgr.mr_n72512272)
print v(xbgr.mr_n72512384)
print v(xbgr.mr_n72512704)
print v(xbgr.mr_n72512816)
print v(xbgr.mr_n72513568)
print v(xbgr.mr_n72514000)
print v(xbgr.mr_n72514864)
print v(xbgr.mr_n72514976)
print v(xbgr.mr_n72515296)
print v(xbgr.mr_n72515840)
print v(xbgr.mr_n72516272)
print v(xbgr.mr_n72516704)
print v(xbgr.mr_n72517024)
print v(xbgr.mr_n72517456)
print v(xbgr.mr_n72518320)
print v(xbgr.mr_n72520480)
print v(xbgr.mr_n72521344)
print v(xbgr.mr_n72521456)
print v(xbgr.mr_n72521776)
print v(xbgr.mr_n72522640)
print v(xbgr.mr_n72523504)
print v(xbgr.mr_n72523616)
print v(xbgr.mr_n72523936)
print v(xbgr.mr_n72524048)
print v(xbgr.mr_n72524368)
print v(xbgr.mr_n72524480)
print v(xbgr.mr_n72524800)
print v(xbgr.mr_n72524912)
print v(xbgr.mr_n72525232)
print v(xbgr.mr_n72526096)
print v(xbgr.mr_n72526960)
print v(xbgr.mr_n72527072)
print v(xbgr.mr_n72527392)
print v(xbgr.mr_n72527504)
print v(xbgr.mr_n72527824)
print v(xbgr.mr_n72527936)
print v(xbgr.mr_n72528256)
print v(xbgr.mr_n72528368)
print v(xbgr.mr_n72528688)
print v(xbgr.mr_n72528800)
print v(xbgr.mr_n72529120)
print v(xbgr.mr_n72529232)
print v(xbgr.mr_n72529552)
print v(xbgr.mr_n72529664)
print v(xbgr.mr_n72530096)
print v(xbgr.mr_n72530416)
print v(xbgr.mr_n72530528)
print v(xbgr.mr_n72530960)
print v(xbgr.mr_n72531280)
print v(xbgr.mr_n72531824)
print v(xbgr.mr_n72532688)
print v(xbgr.mr_n72533008)
print v(xbgr.mr_n72533120)
print v(xbgr.mr_n72534304)
print v(xbgr.mr_n72534416)
print v(xbgr.mr_n72534736)
print v(xbgr.mr_n72534848)
print v(xbgr.mr_n72535168)
print v(xbgr.mr_n72535280)
print v(xbgr.mr_n72535600)
print v(xbgr.mr_n72535712)
print v(xbgr.mr_n72536032)
print v(xbgr.mr_n72536896)
print v(xbgr.mr_n72537760)
print v(xbgr.mr_n72537872)
print v(xbgr.mr_n72538304)
print v(xbgr.mr_n72538736)
print v(xbgr.mr_n72539168)
print v(xbgr.mr_n72539488)
print v(xbgr.mr_n72539600)
print v(xbgr.mr_n72539920)
print v(xbgr.mr_n72540032)
print v(xbgr.mr_n72540352)
print v(xbgr.mr_n72540464)
print v(xbgr.mr_n72540784)
print v(xbgr.mr_n72540896)
print v(xbgr.mr_n72541216)
print v(xbgr.mr_n72541328)
print v(xbgr.mr_n72541648)
print v(xbgr.mr_n72541760)
print v(xbgr.mr_n72542080)
print v(xbgr.mr_n72542944)
print v(xbgr.mr_n72543056)
print v(xbgr.mr_n72543376)
print v(xbgr.mr_n72543488)
print v(xbgr.mr_n72543808)
print v(xbgr.mr_n72543920)
print v(xbgr.mr_n72544240)
print v(xbgr.mr_n72544352)
print v(xbgr.mr_n72544672)
print v(xbgr.mr_n72545216)
print v(xbgr.mr_n72545968)
print v(xbgr.mr_n72546832)
print v(xbgr.mr_n72547696)
print v(xbgr.mr_n72548560)
print v(xbgr.mr_n72549424)
print v(xbgr.mr_n72550288)
print v(xbgr.mr_n72550400)
print v(xbgr.mr_n72550720)
print v(xbgr.mr_n72550832)
print v(xbgr.mr_n72551152)
print v(xbgr.mr_n72551264)
print v(xbgr.mr_n72551584)
print v(xbgr.mr_n72551696)
print v(xbgr.mr_n72552016)
print v(xbgr.mr_n72552128)
print v(xbgr.mr_n72552448)
print v(xbgr.mr_n72552560)
print v(xbgr.mr_n72552880)
print v(xbgr.mr_n72553744)
print v(xbgr.mr_n72554608)
print v(xbgr.mr_n72555472)
print v(xbgr.mr_n72556336)
print v(xbgr.mr_n72557200)
print v(xbgr.mr_n72558064)
print v(xbgr.mr_n72558928)
print v(xbgr.mr_n72559040)
print v(xbgr.mr_n72559360)
print v(xbgr.mr_n72559472)
print v(xbgr.mr_n72559792)
print v(xbgr.mr_n72559904)
print v(xbgr.mr_n72560224)
print v(xbgr.mr_n72560336)
print v(xbgr.mr_n72560656)
print v(xbgr.mr_n72560768)
print v(xbgr.mr_n72561088)
print v(xbgr.mr_n72561200)
print v(xbgr.mr_n72561520)
print v(xbgr.mr_n72561632)
print v(xbgr.mr_n72562064)
print v(xbgr.mr_n72562384)
print v(xbgr.mr_n72562496)
print v(xbgr.mr_n72562928)
print v(xbgr.mr_n72563248)
print v(xbgr.mr_n72563360)
print v(xbgr.mr_n72563792)
print v(xbgr.mr_n72564112)
print v(xbgr.mr_n72564976)
print v(xbgr.mr_n72565840)
print v(xbgr.mr_n72566704)
print v(xbgr.mr_n72567568)
print v(xbgr.mr_n72568432)
print v(xbgr.mr_n72569296)
print v(xbgr.mr_n72569408)
print v(xbgr.mr_n72569728)
print v(xbgr.mr_n72569840)
print v(xbgr.mr_n72570160)
print v(xbgr.mr_n72570272)
print v(xbgr.mr_n72570592)
print v(xbgr.mr_n72570704)
print v(xbgr.mr_n72571024)
print v(xbgr.mr_n72571888)
print v(xbgr.mr_n72572752)
print v(xbgr.mr_n72573616)
print v(xbgr.mr_n72573728)
print v(xbgr.mr_n72574160)
print v(xbgr.mr_n72574480)
print v(xbgr.mr_n72574592)
print v(xbgr.mr_n72574912)
print v(xbgr.mr_n72575024)
print v(xbgr.mr_n72575344)
print v(xbgr.mr_n72575456)
print v(xbgr.mr_n72575776)
print v(xbgr.mr_n72575888)
print v(xbgr.mr_n72576208)
print v(xbgr.mr_n72576320)
print v(xbgr.mr_n72576752)
print v(xbgr.mr_n72577072)
print v(xbgr.mr_n72577184)
print v(xbgr.mr_n72577616)
print v(xbgr.mr_n72577936)
print v(xbgr.mr_n72578048)
print v(xbgr.mr_n72578368)
print v(xbgr.mr_n72578480)
print v(xbgr.mr_n72578912)
print v(xbgr.mr_n72579344)
print v(xbgr.mr_n72579664)
print v(xbgr.mr_n72579776)
print v(xbgr.mr_n72580208)
print v(xbgr.mr_n72580528)
print v(xbgr.mr_n72580640)
print v(xbgr.mr_n72581072)
print v(xbgr.mr_n72581392)
print v(xbgr.mr_n72582256)
print v(xbgr.mr_n72583120)
print v(xbgr.mr_n72583984)
print v(xbgr.mr_n72584848)
print v(xbgr.mr_n72584960)
print v(xbgr.mr_n72585280)
print v(xbgr.mr_n72585392)
print v(xbgr.mr_n72585712)
print v(xbgr.mr_n72585824)
print v(xbgr.mr_n72586144)
print v(xbgr.mr_n72586256)
print v(xbgr.mr_n72586576)
print v(xbgr.mr_n72587440)
print v(xbgr.mr_n72588304)
print v(xbgr.mr_n72589168)
print v(xbgr.mr_n72590032)
print v(xbgr.mr_n72590896)
print v(xbgr.mr_n72591760)
print v(xbgr.mr_n72592624)
print v(xbgr.mr_n72593488)
print v(xbgr.mr_n72593600)
print v(xbgr.mr_n72593920)
print v(xbgr.mr_n72594032)
print v(xbgr.mr_n72594352)
print v(xbgr.mr_n72594464)
print v(xbgr.mr_n72594784)
print v(xbgr.mr_n72594896)
print v(xbgr.mr_n72595216)
print v(xbgr.mr_n72595328)
print v(xbgr.mr_n72595648)
print v(xbgr.mr_n72595760)
print v(xbgr.mr_n72596080)
print v(xbgr.mr_n72596192)
print v(xbgr.mr_n72596512)
print v(xbgr.mr_n72596624)
print v(xbgr.mr_n72596944)
print v(xbgr.mr_n72597056)
print v(xbgr.mr_n72597376)
print v(xbgr.mr_n72597488)
print v(xbgr.mr_n72597920)
print v(xbgr.mr_n72598240)
print v(xbgr.mr_n72598352)
print v(xbgr.mr_n72598672)
print v(xbgr.mr_n72598784)
print v(xbgr.mr_n72599104)
print v(xbgr.mr_n72599216)
print v(xbgr.mr_n72599536)
print v(xbgr.mr_n72599648)
print v(xbgr.mr_n72599968)
print v(xbgr.mr_n72600080)
print v(xbgr.mr_n72600512)
print v(xbgr.mr_n72600832)
print v(xbgr.mr_n72600944)
print v(xbgr.mr_n72601376)
print v(xbgr.mr_n72601696)
print v(xbgr.mr_n72601808)
print v(xbgr.mr_n72602128)
print v(xbgr.mr_n72602992)
print v(xbgr.mr_n72603856)
print v(xbgr.mr_n72604400)
print v(xbgr.mr_n72605152)
print v(xbgr.mr_n72605584)
print v(xbgr.mr_n72605696)
print v(xbgr.mr_n72606448)
print v(xbgr.mr_n72606560)
print v(xbgr.mr_n72606992)
print v(xbgr.mr_n72607424)
print v(xbgr.mr_n72607744)
print v(xbgr.mr_n72608608)
print v(xbgr.mr_n72609040)
print v(xbgr.mr_n72609904)
print v(xbgr.mr_n72610016)
print v(xbgr.mr_n72610768)
print v(xbgr.mr_n72612064)
print v(xbgr.mr_n72612928)
print v(xbgr.mr_n72613040)
print v(xbgr.mr_n72613360)
print v(xbgr.mr_n72613472)
print v(xbgr.mr_n72613792)
print v(xbgr.mr_n72613904)
print v(xbgr.mr_n72614224)
print v(xbgr.mr_n72614336)
print v(xbgr.mr_n72614656)
print v(xbgr.mr_n72615520)
print v(xbgr.mr_n72616384)
print v(xbgr.mr_n72617248)
print v(xbgr.mr_n72617360)
print v(xbgr.mr_n72617680)
print v(xbgr.mr_n72617792)
print v(xbgr.mr_n72618112)
print v(xbgr.mr_n72618976)
print v(xbgr.mr_n72619088)
print v(xbgr.mr_n72619408)
print v(xbgr.mr_n72619520)
print v(xbgr.mr_n72619840)
print v(xbgr.mr_n72619952)
print v(xbgr.mr_n72620272)
print v(xbgr.mr_n72620384)
print v(xbgr.mr_n72620704)
print v(xbgr.mr_n72621568)
print v(xbgr.mr_n72622432)
print v(xbgr.mr_n72622544)
print v(xbgr.mr_n72622864)
print v(xbgr.mr_n72622976)
print v(xbgr.mr_n72623296)
print v(xbgr.mr_n72623408)
print v(xbgr.mr_n72623728)
print v(xbgr.mr_n72623840)
print v(xbgr.mr_n72624160)
print v(xbgr.mr_n72624272)
print v(xbgr.mr_n72624592)
print v(xbgr.mr_n72624704)
print v(xbgr.mr_n72625456)
print v(xbgr.mr_n72626320)
print v(xbgr.mr_n72627184)
print v(xbgr.mr_n72627296)
print v(xbgr.mr_n72627616)
print v(xbgr.mr_n72627728)
print v(xbgr.mr_n72628048)
print v(xbgr.mr_n72628160)
print v(xbgr.mr_n72628480)
print v(xbgr.mr_n72628592)
print v(xbgr.mr_n72629024)
print v(xbgr.mr_n72629344)
print v(xbgr.mr_n72629456)
print v(xbgr.mr_n72630208)
print v(xbgr.mr_n72631072)
print v(xbgr.mr_n72631936)
print v(xbgr.mr_n72632800)
print v(xbgr.mr_n72632912)
print v(xbgr.mr_n72633232)
print v(xbgr.mr_n72633344)
print v(xbgr.mr_n72633664)
print v(xbgr.mr_n72633776)
print v(xbgr.mr_n72634096)
print v(xbgr.mr_n72634208)
print v(xbgr.mr_n72634528)
print v(xbgr.mr_n72635392)
print v(xbgr.mr_n72636688)
print v(xbgr.mr_n72636800)
print v(xbgr.mr_n72637120)
print v(xbgr.mr_n72637232)
print v(xbgr.mr_n72637664)
print v(xbgr.mr_n72637984)
print v(xbgr.mr_n72638096)
print v(xbgr.mr_n72638528)
print v(xbgr.mr_n72638848)
print v(xbgr.mr_n72639280)
print v(xbgr.mr_n72640144)
print v(xbgr.mr_n72641008)
print v(xbgr.mr_n72641120)
print v(xbgr.mr_n72641440)
print v(xbgr.mr_n72641552)
print v(xbgr.mr_n72641984)
print v(xbgr.mr_n72642304)
print v(xbgr.mr_n72642416)
print v(xbgr.mr_n72642736)
print v(xbgr.mr_n72642848)
print v(xbgr.mr_n72643168)
print v(xbgr.mr_n72643280)
print v(xbgr.mr_n72643600)
print v(xbgr.mr_n72643712)
print v(xbgr.mr_n72644144)
print v(xbgr.mr_n72644576)
print v(xbgr.mr_n72645008)
print v(xbgr.mr_n72645440)
print v(xbgr.mr_n72645760)
print v(xbgr.mr_n72645872)
print v(xbgr.mr_n72646304)
print v(xbgr.mr_n72646624)
print v(xbgr.mr_n72647488)
print v(xbgr.mr_n72648352)
print v(xbgr.mr_n72648784)
print v(xbgr.mr_n72649648)
print v(xbgr.mr_n72650080)
print v(xbgr.mr_n72650192)
print v(xbgr.mr_n72650944)
print v(xbgr.mr_n72651808)
print v(xbgr.mr_n72652672)
print v(xbgr.mr_n72652784)
print v(xbgr.mr_n72653216)
print v(xbgr.mr_n72653536)
print v(xbgr.mr_n72654400)
print v(xbgr.mr_n72654512)
print v(xbgr.mr_n72654832)
print v(xbgr.mr_n72654944)
print v(xbgr.mr_n72655264)
print v(xbgr.mr_n72655376)
print v(xbgr.mr_n72655696)
print v(xbgr.mr_n72655808)
print v(xbgr.mr_n72656128)
print v(xbgr.mr_n72656240)
print v(xbgr.mr_n72656560)
print v(xbgr.mr_n72656672)
print v(xbgr.mr_n72656992)
print v(xbgr.mr_n72657104)
print v(xbgr.mr_n72657424)
print v(xbgr.mr_n72657536)
print v(xbgr.mr_n72657856)
print v(xbgr.mr_n72657968)
print v(xbgr.mr_n72658288)
print v(xbgr.mr_n72658400)
print v(xbgr.mr_n72659152)
print v(xbgr.mr_n72660448)
print v(xbgr.mr_n72661312)
print v(xbgr.mr_n72662608)
print v(xbgr.mr_n72662720)
print v(xbgr.mr_n72663040)
print v(xbgr.mr_n72663152)
print v(xbgr.mr_n72663472)
print v(xbgr.mr_n72663584)
print v(xbgr.mr_n72663904)
print v(xbgr.mr_n72664016)
print v(xbgr.mr_n72664768)
print v(xbgr.mr_n72665632)
print v(xbgr.mr_n72666496)
print v(xbgr.mr_n72667360)
print v(xbgr.mr_n72667472)
print v(xbgr.mr_n72667792)
print v(xbgr.mr_n72667904)
print v(xbgr.mr_n72668224)
print v(xbgr.mr_n72668336)
print v(xbgr.mr_n72668656)
print v(xbgr.mr_n72668768)
print v(xbgr.mr_n72669088)
print v(xbgr.mr_n72669200)
print v(xbgr.mr_n72669520)
print v(xbgr.mr_n72670064)
print v(xbgr.mr_n72670816)
print v(xbgr.mr_n72671680)
print v(xbgr.mr_n72671792)
print v(xbgr.mr_n72672112)
print v(xbgr.mr_n72672224)
print v(xbgr.mr_n72672656)
print v(xbgr.mr_n72672976)
print v(xbgr.mr_n72673088)
print v(xbgr.mr_n72673408)
print v(xbgr.mr_n72673520)
print v(xbgr.mr_n72673840)
print v(xbgr.mr_n72673952)
print v(xbgr.mr_n72674272)
print v(xbgr.mr_n72674384)
print v(xbgr.mr_n72674704)
print v(xbgr.mr_n72675136)
print v(xbgr.mr_n72675248)
print v(xbgr.mr_n72675568)
print v(xbgr.mr_n72675680)
print v(xbgr.mr_n72676432)
print v(xbgr.mr_n72676544)
print v(xbgr.mr_n72676864)
print v(xbgr.mr_n72676976)
print v(xbgr.mr_n72677728)
print v(xbgr.mr_n72678592)
print v(xbgr.mr_n72678704)
print v(xbgr.mr_n72679024)
print v(xbgr.mr_n72679888)
print v(xbgr.mr_n72680432)
print v(xbgr.mr_n72680752)
print v(xbgr.mr_n72681296)
print v(xbgr.mr_n72681728)
print v(xbgr.mr_n72682048)
print v(xbgr.mr_n72682160)
print v(xbgr.mr_n72682912)
print v(xbgr.mr_n72683024)
print v(xbgr.mr_n72683344)
print v(xbgr.mr_n72683456)
print v(xbgr.mr_n72683776)
print v(xbgr.mr_n72684640)
print v(xbgr.mr_n72685072)
print v(xbgr.mr_n72685184)
print v(xbgr.mr_n72685504)
print v(xbgr.mr_n72685616)
print v(xbgr.mr_n72685936)
print v(xbgr.mr_n72686048)
print v(xbgr.mr_n72686368)
print v(xbgr.mr_n72686480)
print v(xbgr.mr_n72686800)
print v(xbgr.mr_n72686912)
print v(xbgr.mr_n72688096)
print v(xbgr.mr_n72688208)
print v(xbgr.mr_n72688528)
print v(xbgr.mr_n72688640)
print v(xbgr.mr_n72688960)
print v(xbgr.mr_n72689072)
print v(xbgr.mr_n72689392)
print v(xbgr.mr_n72689824)
print v(xbgr.mr_n72822208)
print v(xbgr.mr_n72822320)
print v(xbgr.mr_n72822640)
print v(xbgr.mr_n72822752)
print v(xbgr.mr_n72823072)
print v(xbgr.mr_n72823184)
print v(xbgr.mr_n72823504)
print v(xbgr.mr_n72823616)
print v(xbgr.mr_n72823936)
print v(xbgr.mr_n72824048)
print v(xbgr.mr_n72824368)
print v(xbgr.mr_n72824480)
print v(xbgr.mr_n72824800)
print v(xbgr.mr_n72824912)
print v(xbgr.mr_n72825232)
print v(xbgr.mr_n72825344)
print v(xbgr.mr_n72825664)
print v(xbgr.mr_n72825776)
print v(xbgr.mr_n72826096)
print v(xbgr.mr_n72826208)
print v(xbgr.mr_n72826528)
print v(xbgr.mr_n72826640)
print v(xbgr.mr_n72826960)
print v(xbgr.mr_n72827072)
print v(xbgr.mr_n72827392)
print v(xbgr.mr_n72827504)
print v(xbgr.mr_n72827824)
print v(xbgr.mr_n72827936)
print v(xbgr.mr_n72828256)
print v(xbgr.mr_n72828368)
print v(xbgr.mr_n72828688)
print v(xbgr.mr_n72828800)
print v(xbgr.mr_n72829120)
print v(xbgr.mr_n72829232)
print v(xbgr.mr_n72829552)
print v(xbgr.mr_n72829664)
print v(xbgr.mr_n72829984)
print v(xbgr.mr_n72830096)
print v(xbgr.mr_n72830416)
print v(xbgr.mr_n72830528)
print v(xbgr.mr_n72830848)
print v(xbgr.mr_n72830960)
print v(xbgr.mr_n72831280)
print v(xbgr.mr_n72831392)
print v(xbgr.mr_n72831712)
print v(xbgr.mr_n72831824)
print v(xbgr.mr_n72832144)
print v(xbgr.mr_n72832256)
print v(xbgr.mr_n72832576)
print v(xbgr.mr_n72832688)
print v(xbgr.mr_n72833008)
print v(xbgr.mr_n72833120)
print v(xbgr.mr_n72833440)
print v(xbgr.mr_n72833552)
print v(xbgr.mr_n72833872)
print v(xbgr.mr_n72833984)
print v(xbgr.mr_n72834304)
print v(xbgr.mr_n72834416)
print v(xbgr.mr_n72834736)
print v(xbgr.mr_n72834848)
print v(xbgr.mr_n72835168)
print v(xbgr.mr_n72835280)
print v(xbgr.mr_n72835600)
print v(xbgr.mr_n72835712)
print v(xbgr.mr_n72836032)
print v(xbgr.mr_n72836144)
print v(xbgr.mr_n72836464)
print v(xbgr.mr_n72836576)
print v(xbgr.mr_n72836896)
print v(xbgr.mr_n72837008)
print v(xbgr.mr_n72837328)
print v(xbgr.mr_n72837440)
print v(xbgr.mr_n72837760)
print v(xbgr.mr_n72837872)
print v(xbgr.mr_n72838192)
print v(xbgr.mr_n72838304)
print v(xbgr.mr_n72838624)
print v(xbgr.mr_n72838736)
print v(xbgr.mr_n72839056)
print v(xbgr.mr_n72839168)
print v(xbgr.mr_n72839488)
print v(xbgr.mr_n72839600)
print v(xbgr.mr_n72839920)
print v(xbgr.mr_n72840032)
print v(xbgr.mr_n72840352)
print v(xbgr.mr_n72840464)
print v(xbgr.mr_n72840784)
print v(xbgr.mr_n72840896)
print v(xbgr.mr_n72841216)
print v(xbgr.mr_n72841328)
print v(xbgr.mr_n72841648)
print v(xbgr.mr_n72841760)
print v(xbgr.mr_n72842080)
print v(xbgr.mr_n72842192)
print v(xbgr.mr_n72842512)
print v(xbgr.mr_n72842624)
print v(xbgr.mr_n72842944)
print v(xbgr.mr_n72843056)
print v(xbgr.mr_n72843376)
print v(xbgr.mr_n72843488)
print v(xbgr.mr_n72843808)
print v(xbgr.mr_n72843920)
print v(xbgr.mr_n72844240)
print v(xbgr.mr_n72844352)
print v(xbgr.mr_n72844672)
print v(xbgr.mr_n72844784)
print v(xbgr.mr_n72845104)
print v(xbgr.mr_n72845216)
print v(xbgr.mr_n72845536)
print v(xbgr.mr_n72845648)
print v(xbgr.mr_n72845968)
print v(xbgr.mr_n72846080)
print v(xbgr.mr_n72846400)
print v(xbgr.mr_n72846512)
print v(xbgr.mr_n72846832)
print v(xbgr.mr_n72846944)
print v(xbgr.mr_n72847264)
print v(xbgr.mr_n72847376)
print v(xbgr.mr_n72847696)
print v(xbgr.mr_n72847808)
print v(xbgr.mr_n72848128)
print v(xbgr.mr_n72848240)
print v(xbgr.mr_n72848560)
print v(xbgr.mr_n72848672)
print v(xbgr.mr_n72848992)
print v(xbgr.mr_n72849104)
print v(xbgr.mr_n72849424)
print v(xbgr.mr_n72849536)
print v(xbgr.mr_n72849856)
print v(xbgr.mr_n72849968)
print v(xbgr.mr_n72850288)
print v(xbgr.mr_n72850400)
print v(xbgr.mr_n72850720)
print v(xbgr.mr_n72850832)
print v(xbgr.mr_n72851152)
print v(xbgr.mr_n72851264)
print v(xbgr.mr_n72851584)
print v(xbgr.mr_n72851696)
print v(xbgr.mr_n72852016)
print v(xbgr.mr_n72852128)
print v(xbgr.mr_n72852448)
print v(xbgr.mr_n72852560)
print v(xbgr.mr_n72852880)
print v(xbgr.mr_n72852992)
print v(xbgr.mr_n72853312)
print v(xbgr.mr_n72853424)
print v(xbgr.mr_n72853744)
print v(xbgr.mr_n72853856)
print v(xbgr.mr_n72854176)
print v(xbgr.mr_n72854288)
print v(xbgr.mr_n72854608)
print v(xbgr.mr_n72854720)
print v(xbgr.mr_n72855040)
print v(xbgr.mr_n72855152)
print v(xbgr.mr_n72855472)
print v(xbgr.mr_n72855584)
print v(xbgr.mr_n72855904)
print v(xbgr.mr_n72856016)
print v(xbgr.mr_n72856336)
print v(xbgr.mr_n72856448)
print v(xbgr.mr_n72856768)
print v(xbgr.mr_n72856880)
print v(xbgr.mr_n72857200)
print v(xbgr.mr_n72857312)
print v(xbgr.mr_n72857632)
print v(xbgr.mr_n72857744)
print v(xbgr.mr_n72858064)
print v(xbgr.mr_n72858176)
print v(xbgr.mr_n72858496)
print v(xbgr.mr_n72858608)
print v(xbgr.mr_n72858928)
print v(xbgr.mr_n72859040)
print v(xbgr.mr_n72859360)
print v(xbgr.mr_n72859472)
print v(xbgr.mr_n72859792)
print v(xbgr.mr_n72859904)
print v(xbgr.mr_n72860224)
print v(xbgr.mr_n72860336)
print v(xbgr.mr_n72860656)
print v(xbgr.mr_n72860768)
print v(xbgr.mr_n72861088)
print v(xbgr.mr_n72861200)
print v(xbgr.mr_n72861520)
print v(xbgr.mr_n72861632)
print v(xbgr.mr_n72861952)
print v(xbgr.mr_n72862064)
print v(xbgr.mr_n72862384)
print v(xbgr.mr_n72862496)
print v(xbgr.mr_n72862816)
print v(xbgr.mr_n72862928)
print v(xbgr.mr_n72863248)
print v(xbgr.mr_n72863360)
print v(xbgr.mr_n72863680)
print v(xbgr.mr_n72863792)
print v(xbgr.mr_n72864112)
print v(xbgr.mr_n72864224)
print v(xbgr.mr_n72864544)
print v(xbgr.mr_n72864656)
print v(xbgr.mr_n72864976)
print v(xbgr.mr_n72865088)
print v(xbgr.mr_n72865408)
print v(xbgr.mr_n72865520)
print v(xbgr.mr_n72865840)
print v(xbgr.mr_n72865952)
print v(xbgr.mr_n72866272)
print v(xbgr.mr_n72866384)
print v(xbgr.mr_n72866704)
print v(xbgr.mr_n72866816)
print v(xbgr.mr_n72867136)
print v(xbgr.mr_n72867248)
print v(xbgr.mr_n72867568)
print v(xbgr.mr_n72867680)
print v(xbgr.mr_n72868000)
print v(xbgr.mr_n72868112)
print v(xbgr.mr_n72868432)
print v(xbgr.mr_n72868544)
print v(xbgr.mr_n72868864)
print v(xbgr.mr_n72868976)
print v(xbgr.mr_n72869296)
print v(xbgr.mr_n72869408)
print v(xbgr.mr_n72869728)
print v(xbgr.mr_n72869840)
print v(xbgr.mr_n72870160)
print v(xbgr.mr_n72870272)
print v(xbgr.mr_n72870592)
print v(xbgr.mr_n72870704)
print v(xbgr.mr_n72871024)
print v(xbgr.mr_n72871136)
print v(xbgr.mr_n72871456)
print v(xbgr.mr_n72871568)
print v(xbgr.mr_n72871888)
print v(xbgr.mr_n72872000)
print v(xbgr.mr_n72872320)
print v(xbgr.mr_n72872432)
print v(xbgr.mr_n72872752)
print v(xbgr.mr_n72872864)
print v(xbgr.mr_n72873184)
print v(xbgr.mr_n72873296)
print v(xbgr.mr_n72873616)
print v(xbgr.mr_n72873728)
print v(xbgr.mr_n72874048)
print v(xbgr.mr_n72874160)
print v(xbgr.mr_n72874480)
print v(xbgr.mr_n72874592)
print v(xbgr.mr_n72874912)
print v(xbgr.mr_n72875024)
print v(xbgr.mr_n72875344)
print v(xbgr.mr_n72875456)
print v(xbgr.mr_n72875776)
print v(xbgr.mr_n72875888)
print v(xbgr.mr_n72876208)
print v(xbgr.mr_n72876320)
print v(xbgr.mr_n72876640)
print v(xbgr.mr_n72876752)
print v(xbgr.mr_n72877072)
print v(xbgr.mr_n72877184)
print v(xbgr.mr_n72877504)
print v(xbgr.mr_n72877616)
print v(xbgr.mr_n72877936)
print v(xbgr.mr_n72878048)
print v(xbgr.mr_n72878368)
print v(xbgr.mr_n72878480)
print v(xbgr.mr_n72878800)
print v(xbgr.mr_n72878912)
print v(xbgr.mr_n72879232)
print v(xbgr.mr_n72879344)
print v(xbgr.mr_n72879664)
print v(xbgr.mr_n72879776)
print v(xbgr.mr_n72880096)
print v(xbgr.mr_n72880208)
print v(xbgr.mr_n72880528)
print v(xbgr.mr_n72880640)
print v(xbgr.mr_n72880960)
print v(xbgr.mr_n72881072)
print v(xbgr.mr_n72881392)
print v(xbgr.mr_n72881504)
print v(xbgr.mr_n72881824)
print v(xbgr.mr_n72881936)
print v(xbgr.mr_n72882256)
print v(xbgr.mr_n72882368)
print v(xbgr.mr_n72882688)
print v(xbgr.mr_n72882800)
print v(xbgr.mr_n72883120)
print v(xbgr.mr_n72883232)
print v(xbgr.mr_n72883552)
print v(xbgr.mr_n72883664)
print v(xbgr.mr_n72883984)
print v(xbgr.mr_n72884096)
print v(xbgr.mr_n72884416)
print v(xbgr.mr_n72884528)
print v(xbgr.mr_n72884848)
print v(xbgr.mr_n72884960)
print v(xbgr.mr_n72885280)
print v(xbgr.mr_n72885392)
print v(xbgr.mr_n72885712)
print v(xbgr.mr_n72885824)
print v(xbgr.mr_n72886144)
print v(xbgr.mr_n72886256)
print v(xbgr.mr_n72886576)
print v(xbgr.mr_n72886688)
print v(xbgr.mr_n72887008)
print v(xbgr.mr_n72887120)
print v(xbgr.mr_n72887440)
print v(xbgr.mr_n72887552)
print v(xbgr.mr_n72887872)
print v(xbgr.mr_n72887984)
print v(xbgr.mr_n72888304)
print v(xbgr.mr_n72888416)
print v(xbgr.mr_n72888736)
print v(xbgr.mr_n72888848)
print v(xbgr.mr_n72889168)
print v(xbgr.mr_n72889280)
print v(xbgr.mr_n72889600)
print v(xbgr.mr_n72889712)
print v(xbgr.mr_n72890032)
print v(xbgr.mr_n72890144)
print v(xbgr.mr_n72890464)
print v(xbgr.mr_n72890576)
print v(xbgr.mr_n72890896)
print v(xbgr.mr_n72891008)
print v(xbgr.mr_n72891328)
print v(xbgr.mr_n72891440)
print v(xbgr.mr_n72891760)
print v(xbgr.mr_n72891872)
print v(xbgr.mr_n72892192)
print v(xbgr.mr_n72892304)
print v(xbgr.mr_n72892624)
print v(xbgr.mr_n72892736)
print v(xbgr.mr_n72893056)
print v(xbgr.mr_n72893168)
print v(xbgr.mr_n72893488)
print v(xbgr.mr_n72893600)
print v(xbgr.mr_n72893920)
print v(xbgr.mr_n72894032)
print v(xbgr.mr_n72894352)
print v(xbgr.mr_n72894464)
print v(xbgr.mr_n72894784)
print v(xbgr.mr_n72894896)
print v(xbgr.mr_n72895216)
print v(xbgr.mr_n72895328)
print v(xbgr.mr_n72895648)
print v(xbgr.mr_n72895760)
print v(xbgr.mr_n72896080)
print v(xbgr.mr_n72896192)
print v(xbgr.mr_n72896512)
print v(xbgr.mr_n72896624)
print v(xbgr.mr_n72896944)
print v(xbgr.mr_n72897056)
print v(xbgr.mr_n72897376)
print v(xbgr.mr_n72897488)
print v(xbgr.mr_n72897808)
print v(xbgr.mr_n72897920)
print v(xbgr.mr_n72898240)
print v(xbgr.mr_n72898352)
print v(xbgr.mr_n72898672)
print v(xbgr.mr_n72898784)
print v(xbgr.mr_n72899104)
print v(xbgr.mr_n72899216)
print v(xbgr.mr_n72899536)
print v(xbgr.mr_n72899648)
print v(xbgr.mr_n72899968)
print v(xbgr.mr_n72900080)
print v(xbgr.mr_n72900400)
print v(xbgr.mr_n72900512)
print v(xbgr.mr_n72900832)
print v(xbgr.mr_n72900944)
print v(xbgr.mr_n72901264)
print v(xbgr.mr_n72901376)
print v(xbgr.mr_n72901696)
print v(xbgr.mr_n72901808)
print v(xbgr.mr_n72902128)
print v(xbgr.mr_n72902240)
print v(xbgr.mr_n72902560)
print v(xbgr.mr_n72902672)
print v(xbgr.mr_n72902992)
print v(xbgr.mr_n72903104)
print v(xbgr.mr_n72903424)
print v(xbgr.mr_n72903536)
print v(xbgr.mr_n72903856)
print v(xbgr.mr_n72903968)
print v(xbgr.mr_n72904288)
print v(xbgr.mr_n72904400)
print v(xbgr.mr_n72904720)
print v(xbgr.mr_n72904832)
print v(xbgr.mr_n72905136)
print v(xbgr.mr_n72905248)
print v(xbgr.mr_n72905568)
print v(xbgr.mr_n72905680)
print v(xbgr.mr_n72906000)
print v(xbgr.mr_n72906112)
print v(xbgr.mr_n72906432)
print v(xbgr.mr_n72906544)
print v(xbgr.mr_n72906864)
print v(xbgr.mr_n72906976)
print v(xbgr.mr_n72907296)
print v(xbgr.mr_n72907408)
print v(xbgr.mr_n72907728)
print v(xbgr.mr_n72907840)
print v(xbgr.mr_n72908160)
print v(xbgr.mr_n72908272)
print v(xbgr.mr_n72908592)
print v(xbgr.mr_n72908704)
print v(xbgr.mr_n72909024)
print v(xbgr.mr_n72909136)
print v(xbgr.mr_n72909456)
print v(xbgr.mr_n72909568)
print v(xbgr.mr_n72909888)
print v(xbgr.mr_n72910000)
print v(xbgr.mr_n72910320)
print v(xbgr.mr_n72910432)
print v(xbgr.mr_n72910752)
print v(xbgr.mr_n72910864)
print v(xbgr.mr_n72911184)
print v(xbgr.mr_n72911296)
print v(xbgr.mr_n72911616)
print v(xbgr.mr_n72911728)
print v(xbgr.mr_n72912048)
print v(xbgr.mr_n72912160)
print v(xbgr.mr_n72912480)
print v(xbgr.mr_n72912592)
print v(xbgr.mr_n72912912)
print v(xbgr.mr_n72913024)
print v(xbgr.mr_n72913344)
print v(xbgr.mr_n72913456)
print v(xbgr.mr_n72913776)
print v(xbgr.mr_n72913888)
print v(xbgr.mr_n72914208)
print v(xbgr.mr_n72914320)
print v(xbgr.mr_n72914640)
print v(xbgr.mr_n72914752)
print v(xbgr.mr_n72915072)
print v(xbgr.mr_n72915184)
print v(xbgr.mr_n72915504)
print v(xbgr.mr_n72915616)
print v(xbgr.mr_n72915936)
print v(xbgr.mr_n72916048)
print v(xbgr.mr_n72916368)
print v(xbgr.mr_n72916480)
print v(xbgr.mr_n72916800)
print v(xbgr.mr_n72916912)
print v(xbgr.mr_n72917232)
print v(xbgr.mr_n72917344)
print v(xbgr.mr_n72917664)
print v(xbgr.mr_n72917776)
print v(xbgr.mr_n72918096)
print v(xbgr.mr_n72918208)
print v(xbgr.mr_n72918528)
print v(xbgr.mr_n72918640)
print v(xbgr.mr_n72918960)
print v(xbgr.mr_n72919072)
print v(xbgr.mr_n72919392)
print v(xbgr.mr_n72919504)
print v(xbgr.mr_n72919824)
print v(xbgr.mr_n72919936)
print v(xbgr.mr_n72920256)
print v(xbgr.mr_n72920368)
print v(xbgr.mr_n72920688)
print v(xbgr.mr_n72920800)
print v(xbgr.mr_n72921120)
print v(xbgr.mr_n72921232)
print v(xbgr.mr_n72921552)
print v(xbgr.mr_n72921664)
print v(xbgr.mr_n72921984)
print v(xbgr.mr_n72922096)
print v(xbgr.mr_n72922416)
print v(xbgr.mr_n72922528)
print v(xbgr.mr_n72922848)
print v(xbgr.mr_n72922960)
print v(xbgr.mr_n72923280)
print v(xbgr.mr_n72923392)
print v(xbgr.mr_n72923712)
print v(xbgr.mr_n72923824)
print v(xbgr.mr_n72924144)
print v(xbgr.mr_n72924256)
print v(xbgr.mr_n72924576)
print v(xbgr.mr_n72924688)
print v(xbgr.mr_n72925008)
print v(xbgr.mr_n72925120)
print v(xbgr.mr_n72925440)
print v(xbgr.mr_n72925552)
print v(xbgr.mr_n72925872)
print v(xbgr.mr_n72925984)
print v(xbgr.mr_n72926304)
print v(xbgr.mr_n72926416)
print v(xbgr.mr_n72926736)
print v(xbgr.mr_n72926848)
print v(xbgr.mr_n72927168)
print v(xbgr.mr_n72927280)
print v(xbgr.mr_n72927600)
print v(xbgr.mr_n72927712)
print v(xbgr.mr_n72928032)
print v(xbgr.mr_n72928144)
print v(xbgr.mr_n72928464)
print v(xbgr.mr_n72928576)
print v(xbgr.mr_n72928896)
print v(xbgr.mr_n72929008)
print v(xbgr.mr_n72929328)
print v(xbgr.mr_n72929440)
print v(xbgr.mr_n72929760)
print v(xbgr.mr_n72929872)
print v(xbgr.mr_n72930192)
print v(xbgr.mr_n72930304)
print v(xbgr.mr_n72930624)
print v(xbgr.mr_n72930736)
print v(xbgr.mr_n72931056)
print v(xbgr.mr_n72931168)
print v(xbgr.mr_n72931488)
print v(xbgr.mr_n72931600)
print v(xbgr.mr_n72931920)
print v(xbgr.mr_n72932032)
print v(xbgr.mr_n72932352)
print v(xbgr.mr_n72932464)
print v(xbgr.mr_n72932784)
print v(xbgr.mr_n72932896)
print v(xbgr.mr_n72933216)
print v(xbgr.mr_n72933328)
print v(xbgr.mr_n72933648)
print v(xbgr.mr_n72933760)
print v(xbgr.mr_n72934080)
print v(xbgr.mr_n72934192)
print v(xbgr.mr_n72934512)
print v(xbgr.mr_n72934624)
print v(xbgr.mr_n72934944)
print v(xbgr.mr_n72935056)
print v(xbgr.mr_n72935376)
print v(xbgr.mr_n72935488)
print v(xbgr.mr_n72935808)
print v(xbgr.mr_n72935920)
print v(xbgr.mr_n72936240)
print v(xbgr.mr_n72936352)
print v(xbgr.mr_n72936672)
print v(xbgr.mr_n72936784)
print v(xbgr.mr_n72937104)
print v(xbgr.mr_n72937216)
print v(xbgr.mr_n72937536)
print v(xbgr.mr_n72937648)
print v(xbgr.mr_n72937968)
print v(xbgr.mr_n72938080)
print v(xbgr.mr_n72938400)
print v(xbgr.mr_n72938512)
print v(xbgr.mr_n72938832)
print v(xbgr.mr_n72938944)
print v(xbgr.mr_n72939264)
print v(xbgr.mr_n72939376)
print v(xbgr.mr_n72939696)
print v(xbgr.mr_n72939808)
print v(xbgr.mr_n72940128)
print v(xbgr.mr_n72940240)
print v(xbgr.mr_n72940560)
print v(xbgr.mr_n72940672)
print v(xbgr.mr_n72940992)
print v(xbgr.mr_n72941104)
print v(xbgr.mr_n72941424)
print v(xbgr.mr_n72941536)
print v(xbgr.mr_n72941856)
print v(xbgr.mr_n72941968)
print v(xbgr.mr_n72942288)
print v(xbgr.mr_n72942400)
print v(xbgr.mr_n72942720)
print v(xbgr.mr_n72942832)
print v(xbgr.mr_n72943152)
print v(xbgr.mr_n72943264)
print v(xbgr.mr_n72943584)
print v(xbgr.mr_n72943696)
print v(xbgr.mr_n72944016)
print v(xbgr.mr_n72944128)
print v(xbgr.mr_n72944448)
print v(xbgr.mr_n72944560)
print v(xbgr.mr_n72944880)
print v(xbgr.mr_n72944992)
print v(xbgr.mr_n72945312)
print v(xbgr.mr_n72945424)
print v(xbgr.mr_n72945744)
print v(xbgr.mr_n72945856)
print v(xbgr.mr_n72946176)
print v(xbgr.mr_n72946288)
print v(xbgr.mr_n72946608)
print v(xbgr.mr_n72946720)
print v(xbgr.mr_n72947040)
print v(xbgr.mr_n72947152)
print v(xbgr.mr_n72947472)
print v(xbgr.mr_n72947584)
print v(xbgr.mr_n72947904)
print v(xbgr.mr_n72948016)
print v(xbgr.mr_n72948336)
print v(xbgr.mr_n72948448)
print v(xbgr.mr_n72948768)
print v(xbgr.mr_n72948880)
print v(xbgr.mr_n72949200)
print v(xbgr.mr_n72949312)
print v(xbgr.mr_n72949632)
print v(xbgr.mr_n72949744)
print v(xbgr.mr_n72950064)
print v(xbgr.mr_n72950176)
print v(xbgr.mr_n72950496)
print v(xbgr.mr_n72950608)
print v(xbgr.mr_n72950928)
print v(xbgr.mr_n72951040)
print v(xbgr.mr_n72951360)
print v(xbgr.mr_n72951472)
print v(xbgr.mr_n72951792)
print v(xbgr.mr_n72951904)
print v(xbgr.mr_n72952224)
print v(xbgr.mr_n72952336)
print v(xbgr.mr_n72952656)
print v(xbgr.mr_n72952768)
print v(xbgr.mr_n72953088)
print v(xbgr.mr_n72953296)
print v(xbgr.mr_n72953536)
print v(xbgr.mr_n72954400)
print v(xbgr.mr_n72954512)
print v(xbgr.mr_n72954832)
print v(xbgr.mr_n72954944)
print v(xbgr.mr_n72955264)
print v(xbgr.mr_n72955376)
print v(xbgr.mr_n72955696)
print v(xbgr.mr_n72955808)
print v(xbgr.mr_n72956128)
print v(xbgr.mr_n72956240)
print v(xbgr.mr_n72956560)
print v(xbgr.mr_n72956672)
print v(xbgr.mr_n72956992)
print v(xbgr.mr_n72957856)
print v(xbgr.mr_n72958720)
print v(xbgr.mr_n72959584)
print v(xbgr.mr_n72959696)
print v(xbgr.mr_n72960448)
print v(xbgr.mr_n72960560)
print v(xbgr.mr_n72960880)
print v(xbgr.mr_n72961744)
print v(xbgr.mr_n72962608)
print v(xbgr.mr_n72963472)
print v(xbgr.mr_n72964336)
print v(xbgr.mr_n72964880)
print v(xbgr.mr_n72965632)
print v(xbgr.mr_n72966176)
print v(xbgr.mr_n72966608)
print v(xbgr.mr_n72967360)
print v(xbgr.mr_n72967472)
print v(xbgr.mr_n72967792)
print v(xbgr.mr_n72967904)
print v(xbgr.mr_n72968224)
print v(xbgr.mr_n72969088)
print v(xbgr.mr_n72969952)
print v(xbgr.mr_n72970816)
print v(xbgr.mr_n72970928)
print v(xbgr.mr_n72971248)
print v(xbgr.mr_n72971360)
print v(xbgr.mr_n72971792)
print v(xbgr.mr_n72972112)
print v(xbgr.mr_n72972224)
print v(xbgr.mr_n72972544)
print v(xbgr.mr_n72973408)
print v(xbgr.mr_n72973520)
print v(xbgr.mr_n72973952)
print v(xbgr.mr_n72974272)
print v(xbgr.mr_n72974384)
print v(xbgr.mr_n72974704)
print v(xbgr.mr_n72974816)
print v(xbgr.mr_n72975136)
print v(xbgr.mr_n72975248)
print v(xbgr.mr_n72975568)
print v(xbgr.mr_n72975680)
print v(xbgr.mr_n72976000)
print v(xbgr.mr_n72976976)
print v(xbgr.mr_n72977296)
print v(xbgr.mr_n72977408)
print v(xbgr.mr_n72977728)
print v(xbgr.mr_n72977840)
print v(xbgr.mr_n72978160)
print v(xbgr.mr_n72978272)
print v(xbgr.mr_n72978592)
print v(xbgr.mr_n72978704)
print v(xbgr.mr_n72979024)
print v(xbgr.mr_n72979456)
print v(xbgr.mr_n72980432)
print v(xbgr.mr_n72980752)
print v(xbgr.mr_n72981616)
print v(xbgr.mr_n72982480)
print v(xbgr.mr_n72982592)
print v(xbgr.mr_n72983344)
print v(xbgr.mr_n72984208)
print v(xbgr.mr_n72984320)
print v(xbgr.mr_n72984640)
print v(xbgr.mr_n72985504)
print v(xbgr.mr_n72985616)
print v(xbgr.mr_n72985936)
print v(xbgr.mr_n72986048)
print v(xbgr.mr_n72986368)
print v(xbgr.mr_n72987232)
print v(xbgr.mr_n72987344)
print v(xbgr.mr_n72987664)
print v(xbgr.mr_n72987776)
print v(xbgr.mr_n72988096)
print v(xbgr.mr_n72988208)
print v(xbgr.mr_n72988528)
print v(xbgr.mr_n72988640)
print v(xbgr.mr_n72988960)
print v(xbgr.mr_n72989936)
print v(xbgr.mr_n72990368)
print v(xbgr.mr_n72990688)
print v(xbgr.mr_n72991552)
print v(xbgr.mr_n72992416)
print v(xbgr.mr_n72992528)
print v(xbgr.mr_n72992848)
print v(xbgr.mr_n72992960)
print v(xbgr.mr_n72993280)
print v(xbgr.mr_n72993392)
print v(xbgr.mr_n72993712)
print v(xbgr.mr_n72993824)
print v(xbgr.mr_n72994256)
print v(xbgr.mr_n72994688)
print v(xbgr.mr_n72995008)
print v(xbgr.mr_n72995120)
print v(xbgr.mr_n72995440)
print v(xbgr.mr_n72995552)
print v(xbgr.mr_n72995872)
print v(xbgr.mr_n72995984)
print v(xbgr.mr_n72996304)
print v(xbgr.mr_n72996416)
print v(xbgr.mr_n72996736)
print v(xbgr.mr_n72997600)
print v(xbgr.mr_n72998464)
print v(xbgr.mr_n72998576)
print v(xbgr.mr_n72998896)
print v(xbgr.mr_n72999760)
print v(xbgr.mr_n73000624)
print v(xbgr.mr_n73000736)
print v(xbgr.mr_n73001056)
print v(xbgr.mr_n73001168)
print v(xbgr.mr_n73001600)
print v(xbgr.mr_n73001920)
print v(xbgr.mr_n73002032)
print v(xbgr.mr_n73002464)
print v(xbgr.mr_n73002784)
print v(xbgr.mr_n73003216)
print v(xbgr.mr_n73003328)
print v(xbgr.mr_n73003648)
print v(xbgr.mr_n73003760)
print v(xbgr.mr_n73004080)
print v(xbgr.mr_n73004512)
print v(xbgr.mr_n73004624)
print v(xbgr.mr_n73005376)
print v(xbgr.mr_n73005488)
print v(xbgr.mr_n73005808)
print v(xbgr.mr_n73005920)
print v(xbgr.mr_n73006240)
print v(xbgr.mr_n73006672)
print v(xbgr.mr_n73006784)
print v(xbgr.mr_n73007104)
print v(xbgr.mr_n73007536)
print v(xbgr.mr_n73008400)
print v(xbgr.mr_n73010128)
print v(xbgr.mr_n73010240)
print v(xbgr.mr_n73010560)
print v(xbgr.mr_n73010672)
print v(xbgr.mr_n73010992)
print v(xbgr.mr_n73011104)
print v(xbgr.mr_n73011536)
print v(xbgr.mr_n73011968)
print v(xbgr.mr_n73012288)
print v(xbgr.mr_n73012400)
print v(xbgr.mr_n73012720)
print v(xbgr.mr_n73014128)
print v(xbgr.mr_n73014448)
print v(xbgr.mr_n73015424)
print v(xbgr.mr_n73015744)
print v(xbgr.mr_n73015856)
print v(xbgr.mr_n73016176)
print v(xbgr.mr_n73016288)
print v(xbgr.mr_n73016720)
print v(xbgr.mr_n73017040)
print v(xbgr.mr_n73017152)
print v(xbgr.mr_n73017584)
print v(xbgr.mr_n73017904)
print v(xbgr.mr_n73018016)
print v(xbgr.mr_n73018336)
print v(xbgr.mr_n73018448)
print v(xbgr.mr_n73018768)
print v(xbgr.mr_n73019632)
print v(xbgr.mr_n73020064)
print v(xbgr.mr_n73020928)
print v(xbgr.mr_n73021040)
print v(xbgr.mr_n73021360)
print v(xbgr.mr_n73021472)
print v(xbgr.mr_n73021792)
print v(xbgr.mr_n73021904)
print v(xbgr.mr_n73022656)
print v(xbgr.mr_n73023088)
print v(xbgr.mr_n73023200)
print v(xbgr.mr_n73023520)
print v(xbgr.mr_n73023952)
print v(xbgr.mr_n73024064)
print v(xbgr.mr_n73024384)
print v(xbgr.mr_n73024496)
print v(xbgr.mr_n73024816)
print v(xbgr.mr_n73024928)
print v(xbgr.mr_n73025248)
print v(xbgr.mr_n73025360)
print v(xbgr.mr_n73025680)
print v(xbgr.mr_n73025792)
print v(xbgr.mr_n73026112)
print v(xbgr.mr_n73027520)
print v(xbgr.mr_n73027840)
print v(xbgr.mr_n73027952)
print v(xbgr.mr_n73028384)
print v(xbgr.mr_n73028704)
print v(xbgr.mr_n73028816)
print v(xbgr.mr_n73029136)
print v(xbgr.mr_n73029568)
print v(xbgr.mr_n73030432)
print v(xbgr.mr_n73031296)
print v(xbgr.mr_n73032160)
print v(xbgr.mr_n73033024)
print v(xbgr.mr_n73033888)
print v(xbgr.mr_n73035184)
print v(xbgr.mr_n73035616)
print v(xbgr.mr_n73035728)
print v(xbgr.mr_n73036048)
print v(xbgr.mr_n73036480)
print v(xbgr.mr_n73036592)
print v(xbgr.mr_n73036912)
print v(xbgr.mr_n73037776)
print v(xbgr.mr_n73037888)
print v(xbgr.mr_n73038208)
print v(xbgr.mr_n73038320)
print v(xbgr.mr_n73038640)
print v(xbgr.mr_n73039504)
print v(xbgr.mr_n73039616)
print v(xbgr.mr_n73040480)
print v(xbgr.mr_n73040912)
print v(xbgr.mr_n73041344)
print v(xbgr.mr_n73042096)
print v(xbgr.mr_n73042208)
print v(xbgr.mr_n73042640)
print v(xbgr.mr_n73043392)
print v(xbgr.mr_n73043824)
print v(xbgr.mr_n73043936)
print v(xbgr.mr_n73044368)
print v(xbgr.mr_n73045120)
print v(xbgr.mr_n73045232)
print v(xbgr.mr_n73045552)
print v(xbgr.mr_n73045664)
print v(xbgr.mr_n73045984)
print v(xbgr.mr_n73046096)
print v(xbgr.mr_n73046416)
print v(xbgr.mr_n73046528)
print v(xbgr.mr_n73046848)
print v(xbgr.mr_n73046960)
print v(xbgr.mr_n73047280)
print v(xbgr.mr_n73047392)
print v(xbgr.mr_n73047712)
print v(xbgr.mr_n73047824)
print v(xbgr.mr_n73048144)
print v(xbgr.mr_n73048256)
print v(xbgr.mr_n73048576)
print v(xbgr.mr_n73048688)
print v(xbgr.mr_n73049008)
print v(xbgr.mr_n73049120)
print v(xbgr.mr_n73049440)
print v(xbgr.mr_n73049552)
print v(xbgr.mr_n73049872)
print v(xbgr.mr_n73049984)
print v(xbgr.mr_n73050304)
print v(xbgr.mr_n73050416)
print v(xbgr.mr_n73050736)
print v(xbgr.mr_n73050848)
print v(xbgr.mr_n73051280)
print v(xbgr.mr_n73051600)
print v(xbgr.mr_n73051712)
print v(xbgr.mr_n73052144)
print v(xbgr.mr_n73052464)
print v(xbgr.mr_n73052576)
print v(xbgr.mr_n73053328)
print v(xbgr.mr_n73053760)
print v(xbgr.mr_n73054624)
print v(xbgr.mr_n73055488)
print v(xbgr.mr_n73056352)
print v(xbgr.mr_n73056464)
print v(xbgr.mr_n73056784)
print v(xbgr.mr_n73056896)
print v(xbgr.mr_n73057216)
print v(xbgr.mr_n73057328)
print v(xbgr.mr_n73057648)
print v(xbgr.mr_n73057760)
print v(xbgr.mr_n73058512)
print v(xbgr.mr_n73059376)
print v(xbgr.mr_n73060240)
print v(xbgr.mr_n73061104)
print v(xbgr.mr_n73062400)
print v(xbgr.mr_n73062512)
print v(xbgr.mr_n73062832)
print v(xbgr.mr_n73062944)
print v(xbgr.mr_n73063264)
print v(xbgr.mr_n73063376)
print v(xbgr.mr_n73063808)
print v(xbgr.mr_n73064240)
print v(xbgr.mr_n73064672)
print v(xbgr.mr_n73064992)
print v(xbgr.mr_n73065104)
print v(xbgr.mr_n73065536)
print v(xbgr.mr_n73065856)
print v(xbgr.mr_n73065968)
print v(xbgr.mr_n73066288)
print v(xbgr.mr_n73066400)
print v(xbgr.mr_n73066720)
print v(xbgr.mr_n73066832)
print v(xbgr.mr_n73067152)
print v(xbgr.mr_n73067264)
print v(xbgr.mr_n73067584)
print v(xbgr.mr_n73067696)
print v(xbgr.mr_n73068128)
print v(xbgr.mr_n73068448)
print v(xbgr.mr_n73068560)
print v(xbgr.mr_n73068992)
print v(xbgr.mr_n73069312)
print v(xbgr.mr_n73069744)
print v(xbgr.mr_n73069856)
print v(xbgr.mr_n73070288)
print v(xbgr.mr_n73070608)
print v(xbgr.mr_n73070720)
print v(xbgr.mr_n73071152)
print v(xbgr.mr_n73071472)
print v(xbgr.mr_n73071584)
print v(xbgr.mr_n73072016)
print v(xbgr.mr_n73072336)
print v(xbgr.mr_n73072448)
print v(xbgr.mr_n73072768)
print v(xbgr.mr_n73072880)
print v(xbgr.mr_n73073200)
print v(xbgr.mr_n73074064)
print v(xbgr.mr_n73074928)
print v(xbgr.mr_n73075792)
print v(xbgr.mr_n73076656)
print v(xbgr.mr_n73077520)
print v(xbgr.mr_n73078384)
print v(xbgr.mr_n73078496)
print v(xbgr.mr_n73079248)
print v(xbgr.mr_n73080112)
print v(xbgr.mr_n73080976)
print v(xbgr.mr_n73081840)
print v(xbgr.mr_n73082704)
print v(xbgr.mr_n73083568)
print v(xbgr.mr_n73083680)
print v(xbgr.mr_n73084000)
print v(xbgr.mr_n73084112)
print v(xbgr.mr_n73084432)
print v(xbgr.mr_n73084544)
print v(xbgr.mr_n73084864)
print v(xbgr.mr_n73084976)
print v(xbgr.mr_n73085296)
print v(xbgr.mr_n73086160)
print v(xbgr.mr_n73087024)
print v(xbgr.mr_n73087888)
print v(xbgr.mr_n73088000)
print v(xbgr.mr_n73088320)
print v(xbgr.mr_n73088432)
print v(xbgr.mr_n73088752)
print v(xbgr.mr_n73088864)
print v(xbgr.mr_n73089184)
print v(xbgr.mr_n73090048)
print v(xbgr.mr_n73090912)
print v(xbgr.mr_n73091776)
print v(xbgr.mr_n73091888)
print v(xbgr.mr_n73092208)
print v(xbgr.mr_n73092320)
print v(xbgr.mr_n73092640)
print v(xbgr.mr_n73092752)
print v(xbgr.mr_n73093184)
print v(xbgr.mr_n73093616)
print v(xbgr.mr_n73094048)
print v(xbgr.mr_n73094368)
print v(xbgr.mr_n73094480)
print v(xbgr.mr_n73094800)
print v(xbgr.mr_n73094912)
print v(xbgr.mr_n73095232)
print v(xbgr.mr_n73095344)
print v(xbgr.mr_n73095664)
print v(xbgr.mr_n73095776)
print v(xbgr.mr_n73096096)
print v(xbgr.mr_n73096208)
print v(xbgr.mr_n73096528)
print v(xbgr.mr_n73096640)
print v(xbgr.mr_n73096960)
print v(xbgr.mr_n73097072)
print v(xbgr.mr_n73097392)
print v(xbgr.mr_n73097504)
print v(xbgr.mr_n73097824)
print v(xbgr.mr_n73097936)
print v(xbgr.mr_n73098368)
print v(xbgr.mr_n73098688)
print v(xbgr.mr_n73098800)
print v(xbgr.mr_n73099120)
print v(xbgr.mr_n73099552)
print v(xbgr.mr_n73099664)
print v(xbgr.mr_n73099984)
print v(xbgr.mr_n73100096)
print v(xbgr.mr_n73100416)
print v(xbgr.mr_n73100528)
print v(xbgr.mr_n73100848)
print v(xbgr.mr_n73100960)
print v(xbgr.mr_n73101712)
print v(xbgr.mr_n73101824)
print v(xbgr.mr_n73102576)
print v(xbgr.mr_n73103440)
print v(xbgr.mr_n73103552)
print v(xbgr.mr_n73103872)
print v(xbgr.mr_n73103984)
print v(xbgr.mr_n73104304)
print v(xbgr.mr_n73104416)
print v(xbgr.mr_n73104736)
print v(xbgr.mr_n73104848)
print v(xbgr.mr_n73105280)
print v(xbgr.mr_n73105712)
print v(xbgr.mr_n73106032)
print v(xbgr.mr_n73106144)
print v(xbgr.mr_n73106464)
print v(xbgr.mr_n73106576)
print v(xbgr.mr_n73106896)
print v(xbgr.mr_n73107760)
print v(xbgr.mr_n73109056)
print v(xbgr.mr_n73109920)
print v(xbgr.mr_n73110032)
print v(xbgr.mr_n73110352)
print v(xbgr.mr_n73110464)
print v(xbgr.mr_n73110784)
print v(xbgr.mr_n73110896)
print v(xbgr.mr_n73111216)
print v(xbgr.mr_n73111328)
print v(xbgr.mr_n73111760)
print v(xbgr.mr_n73112080)
print v(xbgr.mr_n73112192)
print v(xbgr.mr_n73112512)
print v(xbgr.mr_n73112624)
print v(xbgr.mr_n73112944)
print v(xbgr.mr_n73113056)
print v(xbgr.mr_n73113488)
print v(xbgr.mr_n73113808)
print v(xbgr.mr_n73113920)
print v(xbgr.mr_n73114240)
print v(xbgr.mr_n73114352)
print v(xbgr.mr_n73114672)
print v(xbgr.mr_n73115536)
print v(xbgr.mr_n73116400)
print v(xbgr.mr_n73117264)
print v(xbgr.mr_n73118128)
print v(xbgr.mr_n73118240)
print v(xbgr.mr_n73118560)
print v(xbgr.mr_n73118672)
print v(xbgr.mr_n73119104)
print v(xbgr.mr_n73119536)
print v(xbgr.mr_n73119856)
print v(xbgr.mr_n73119968)
print v(xbgr.mr_n73120288)
print v(xbgr.mr_n73121152)
print v(xbgr.mr_n73122016)
print v(xbgr.mr_n73122128)
print v(xbgr.mr_n73122448)
print v(xbgr.mr_n73122560)
print v(xbgr.mr_n73122880)
print v(xbgr.mr_n73122992)
print v(xbgr.mr_n73123312)
print v(xbgr.mr_n73123424)
print v(xbgr.mr_n73123744)
print v(xbgr.mr_n73123856)
print v(xbgr.mr_n73124288)
print v(xbgr.mr_n73124608)
print v(xbgr.mr_n73124720)
print v(xbgr.mr_n73125472)
print v(xbgr.mr_n73126336)
print v(xbgr.mr_n73126448)
print v(xbgr.mr_n73126768)
print v(xbgr.mr_n73126880)
print v(xbgr.mr_n73127312)
print v(xbgr.mr_n73127632)
print v(xbgr.mr_n73127744)
print v(xbgr.mr_n73128064)
print v(xbgr.mr_n73128176)
print v(xbgr.mr_n73128496)
print v(xbgr.mr_n73128608)
print v(xbgr.mr_n73128928)
print v(xbgr.mr_n73129040)
print v(xbgr.mr_n73129360)
print v(xbgr.mr_n73129472)
print v(xbgr.mr_n73129792)
print v(xbgr.mr_n73130656)
print v(xbgr.mr_n73131632)
print v(xbgr.mr_n73131952)
print v(xbgr.mr_n73132816)
print v(xbgr.mr_n73133680)
print v(xbgr.mr_n73134544)
print v(xbgr.mr_n73134976)
print v(xbgr.mr_n73135408)
print v(xbgr.mr_n73135520)
print v(xbgr.mr_n73135840)
print v(xbgr.mr_n73135952)
print v(xbgr.mr_n73136272)
print v(xbgr.mr_n73136384)
print v(xbgr.mr_n73136704)
print v(xbgr.mr_n73136816)
print v(xbgr.mr_n73137136)
print v(xbgr.mr_n73137248)
print v(xbgr.mr_n73137568)
print v(xbgr.mr_n73137680)
print v(xbgr.mr_n73138000)
print v(xbgr.mr_n73138864)
print v(xbgr.mr_n73139728)
print v(xbgr.mr_n73139840)
print v(xbgr.mr_n73140160)
print v(xbgr.mr_n73140272)
print v(xbgr.mr_n73140592)
print v(xbgr.mr_n73140704)
print v(xbgr.mr_n73141024)
print v(xbgr.mr_n73141136)
print v(xbgr.mr_n73142752)
print v(xbgr.mr_n73143616)
print v(xbgr.mr_n73143728)
print v(xbgr.mr_n73144048)
print v(xbgr.mr_n73144160)
print v(xbgr.mr_n73144480)
print v(xbgr.mr_n73144912)
print v(xbgr.mr_n73145024)
print v(xbgr.mr_n73145344)
print v(xbgr.mr_n73145456)
print v(xbgr.mr_n73145776)
print v(xbgr.mr_n73145888)
print v(xbgr.mr_n73146320)
print v(xbgr.mr_n73146640)
print v(xbgr.mr_n73146752)
print v(xbgr.mr_n73147184)
print v(xbgr.mr_n73147936)
print v(xbgr.mr_n73148800)
print v(xbgr.mr_n73150096)
print v(xbgr.mr_n73150208)
print v(xbgr.mr_n73150640)
print v(xbgr.mr_n73150960)
print v(xbgr.mr_n73151824)
print v(xbgr.mr_n73152688)
print v(xbgr.mr_n73153120)
print v(xbgr.mr_n73154416)
print v(xbgr.mr_n73155280)
print v(xbgr.mr_n73155712)
print v(xbgr.mr_n73156576)
print v(xbgr.mr_n73157872)
print v(xbgr.mr_n73157984)
print v(xbgr.mr_n73158304)
print v(xbgr.mr_n73158416)
print v(xbgr.mr_n73158736)
print v(xbgr.mr_n73158848)
print v(xbgr.mr_n73159168)
print v(xbgr.mr_n73159280)
print v(xbgr.mr_n73159600)
print v(xbgr.mr_n73159712)
print v(xbgr.mr_n73160032)
print v(xbgr.mr_n73160144)
print v(xbgr.mr_n73160464)
print v(xbgr.mr_n73160576)
print v(xbgr.mr_n73161328)
print v(xbgr.mr_n73161440)
print v(xbgr.mr_n73161872)
print v(xbgr.mr_n73162192)
print v(xbgr.mr_n73162304)
print v(xbgr.mr_n73162624)
print v(xbgr.mr_n73162736)
print v(xbgr.mr_n73163056)
print v(xbgr.mr_n73163168)
print v(xbgr.mr_n73163488)
print v(xbgr.mr_n73163600)
print v(xbgr.mr_n73163920)
print v(xbgr.mr_n73164032)
print v(xbgr.mr_n73164464)
print v(xbgr.mr_n73164784)
print v(xbgr.mr_n73165328)
print v(xbgr.mr_n73165648)
print v(xbgr.mr_n73165760)
print v(xbgr.mr_n73166192)
print v(xbgr.mr_n73166512)
print v(xbgr.mr_n73166624)
print v(xbgr.mr_n73167056)
print v(xbgr.mr_n73167376)
print v(xbgr.mr_n73167488)
print v(xbgr.mr_n73167808)
print v(xbgr.mr_n73167920)
print v(xbgr.mr_n73168240)
print v(xbgr.mr_n73168352)
print v(xbgr.mr_n73168672)
print v(xbgr.mr_n73168784)
print v(xbgr.mr_n73169104)
print v(xbgr.mr_n73169216)
print v(xbgr.mr_n73169536)
print v(xbgr.mr_n73169648)
print v(xbgr.mr_n73169968)
print v(xbgr.mr_n73170080)
print v(xbgr.mr_n73170400)
print v(xbgr.mr_n73170512)
print v(xbgr.mr_n73170832)
print v(xbgr.mr_n73171696)
print v(xbgr.mr_n73171808)
print v(xbgr.mr_n73172128)
print v(xbgr.mr_n73172240)
print v(xbgr.mr_n73172560)
print v(xbgr.mr_n73172672)
print v(xbgr.mr_n73172992)
print v(xbgr.mr_n73173104)
print v(xbgr.mr_n73173424)
print v(xbgr.mr_n73174288)
print v(xbgr.mr_n73175152)
print v(xbgr.mr_n73176016)
print v(xbgr.mr_n73176560)
print v(xbgr.mr_n73176992)
print v(xbgr.mr_n73177312)
print v(xbgr.mr_n73177424)
print v(xbgr.mr_n73177744)
print v(xbgr.mr_n73177856)
print v(xbgr.mr_n73178176)
print v(xbgr.mr_n73178288)
print v(xbgr.mr_n73178608)
print v(xbgr.mr_n73178720)
print v(xbgr.mr_n73179040)
print v(xbgr.mr_n73180336)
print v(xbgr.mr_n73181200)
print v(xbgr.mr_n73182176)
print v(xbgr.mr_n73182608)
print v(xbgr.mr_n73182928)
print v(xbgr.mr_n73183360)
print v(xbgr.mr_n73184224)
print v(xbgr.mr_n73185088)
print v(xbgr.mr_n73185200)
print v(xbgr.mr_n73185520)
print v(xbgr.mr_n73185632)
print v(xbgr.mr_n73185952)
print v(xbgr.mr_n73186064)
print v(xbgr.mr_n73186384)
print v(xbgr.mr_n73186496)
print v(xbgr.mr_n73187680)
print v(xbgr.mr_n73187792)
print v(xbgr.mr_n73188112)
print v(xbgr.mr_n73188224)
print v(xbgr.mr_n73188544)
print v(xbgr.mr_n73188656)
print v(xbgr.mr_n73189088)
print v(xbgr.mr_n73189408)
print v(xbgr.mr_n73189840)
print v(xbgr.mr_n73189952)
print v(xbgr.mr_n73190384)
print v(xbgr.mr_n73190704)
print v(xbgr.mr_n73191568)
print v(xbgr.mr_n73191680)
print v(xbgr.mr_n73192112)
print v(xbgr.mr_n73192432)
print v(xbgr.mr_n73192544)
print v(xbgr.mr_n73193296)
print v(xbgr.mr_n73193840)
print v(xbgr.mr_n73194160)
print v(xbgr.mr_n73194272)
print v(xbgr.mr_n73194592)
print v(xbgr.mr_n73194704)
print v(xbgr.mr_n73195024)
print v(xbgr.mr_n73195136)
print v(xbgr.mr_n73195456)
print v(xbgr.mr_n73195888)
print v(xbgr.mr_n73196000)
print v(xbgr.mr_n73196320)
print v(xbgr.mr_n73196432)
print v(xbgr.mr_n73196752)
print v(xbgr.mr_n73196864)
print v(xbgr.mr_n73197616)
print v(xbgr.mr_n73197728)
print v(xbgr.mr_n73198160)
print v(xbgr.mr_n73198480)
print v(xbgr.mr_n73198592)
print v(xbgr.mr_n73198912)
print v(xbgr.mr_n73199024)
print v(xbgr.mr_n73199344)
print v(xbgr.mr_n73199456)
print v(xbgr.mr_n73199776)
print v(xbgr.mr_n73200640)
print v(xbgr.mr_n73201072)
print v(xbgr.mr_n73201504)
print v(xbgr.mr_n73201616)
print v(xbgr.mr_n73201936)
print v(xbgr.mr_n73202048)
print v(xbgr.mr_n73202800)
print v(xbgr.mr_n73202912)
print v(xbgr.mr_n73203232)
print v(xbgr.mr_n73203344)
print v(xbgr.mr_n73204096)
print v(xbgr.mr_n73204960)
print v(xbgr.mr_n73205072)
print v(xbgr.mr_n73205392)
print v(xbgr.mr_n73206256)
print v(xbgr.mr_n73206368)
print v(xbgr.mr_n73206688)
print v(xbgr.mr_n73206800)
print v(xbgr.mr_n73207120)
print v(xbgr.mr_n73207232)
print v(xbgr.mr_n73207552)
print v(xbgr.mr_n73207664)
print v(xbgr.mr_n73207984)
print v(xbgr.mr_n73208096)
print v(xbgr.mr_n73208416)
print v(xbgr.mr_n73208528)
print v(xbgr.mr_n73208848)
print v(xbgr.mr_n73208960)
print v(xbgr.mr_n73209392)
print v(xbgr.mr_n73209824)
print v(xbgr.mr_n73210144)
print v(xbgr.mr_n73210576)
print v(xbgr.mr_n73210688)
print v(xbgr.mr_n73211872)
print v(xbgr.mr_n73213600)
print v(xbgr.mr_n73213712)
print v(xbgr.mr_n73214144)
print v(xbgr.mr_n73214464)
print v(xbgr.mr_n73214576)
print v(xbgr.mr_n73214896)
print v(xbgr.mr_n73215008)
print v(xbgr.mr_n73215440)
print v(xbgr.mr_n73215760)
print v(xbgr.mr_n73215872)
print v(xbgr.mr_n73216192)
print v(xbgr.mr_n73216624)
print v(xbgr.mr_n73216736)
print v(xbgr.mr_n73217488)
print v(xbgr.mr_n73217600)
print v(xbgr.mr_n73217920)
print v(xbgr.mr_n73218032)
print v(xbgr.mr_n73218352)
print v(xbgr.mr_n73218464)
print v(xbgr.mr_n73218784)
print v(xbgr.mr_n73218896)
print v(xbgr.mr_n73219216)
print v(xbgr.mr_n73219328)
print v(xbgr.mr_n73219648)
print v(xbgr.mr_n73220512)
print v(xbgr.mr_n73221376)
print v(xbgr.mr_n73222240)
print v(xbgr.mr_n73222352)
print v(xbgr.mr_n73222672)
print v(xbgr.mr_n73223104)
print v(xbgr.mr_n73223216)
print v(xbgr.mr_n73223536)
print v(xbgr.mr_n73223648)
print v(xbgr.mr_n73223968)
print v(xbgr.mr_n73224080)
print v(xbgr.mr_n73224400)
print v(xbgr.mr_n73225264)
print v(xbgr.mr_n73226240)
print v(xbgr.mr_n73226560)
print v(xbgr.mr_n73226672)
print v(xbgr.mr_n73226992)
print v(xbgr.mr_n73227104)
print v(xbgr.mr_n73227424)
print v(xbgr.mr_n73227536)
print v(xbgr.mr_n73227856)
print v(xbgr.mr_n73227968)
print v(xbgr.mr_n73228288)
print v(xbgr.mr_n73228832)
print v(xbgr.mr_n73229264)
print v(xbgr.mr_n73229696)
print v(xbgr.mr_n73230880)
print v(xbgr.mr_n73230992)
print v(xbgr.mr_n73231312)
print v(xbgr.mr_n73231424)
print v(xbgr.mr_n73231744)
print v(xbgr.mr_n73232608)
print v(xbgr.mr_n73232720)
print v(xbgr.mr_n73233040)
print v(xbgr.mr_n73233152)
print v(xbgr.mr_n73233472)
print v(xbgr.mr_n73233904)
print v(xbgr.mr_n73234768)
print v(xbgr.mr_n73236064)
print v(xbgr.mr_n73236176)
print v(xbgr.mr_n73236496)
print v(xbgr.mr_n73236608)
print v(xbgr.mr_n73236928)
print v(xbgr.mr_n73237360)
print v(xbgr.mr_n73238224)
print v(xbgr.mr_n73238656)
print v(xbgr.mr_n73238768)
print v(xbgr.mr_n73239088)
print v(xbgr.mr_n73239200)
print v(xbgr.mr_n73239520)
print v(xbgr.mr_n73239632)
print v(xbgr.mr_n73239952)
print v(xbgr.mr_n73240064)
print v(xbgr.mr_n73240816)
print v(xbgr.mr_n73240928)
print v(xbgr.mr_n73241680)
print v(xbgr.mr_n73242656)
print v(xbgr.mr_n73242976)
print v(xbgr.mr_n73243088)
print v(xbgr.mr_n73243408)
print v(xbgr.mr_n73243520)
print v(xbgr.mr_n73243840)
print v(xbgr.mr_n73244272)
print v(xbgr.mr_n73245136)
print v(xbgr.mr_n73245248)
print v(xbgr.mr_n73245568)
print v(xbgr.mr_n73245680)
print v(xbgr.mr_n73246000)
print v(xbgr.mr_n73246112)
print v(xbgr.mr_n73246432)
print v(xbgr.mr_n73246544)
print v(xbgr.mr_n73246864)
print v(xbgr.mr_n73246976)
print v(xbgr.mr_n73247408)
print v(xbgr.mr_n73248160)
print v(xbgr.mr_n73249136)
print v(xbgr.mr_n73249568)
print v(xbgr.mr_n73249888)
print v(xbgr.mr_n73250320)
print v(xbgr.mr_n73251296)
print v(xbgr.mr_n73251728)
print v(xbgr.mr_n73252048)
print v(xbgr.mr_n73252480)
print v(xbgr.mr_n73252592)
print v(xbgr.mr_n73252912)
print v(xbgr.mr_n73253024)
print v(xbgr.mr_n73253344)
print v(xbgr.mr_n73253456)
print v(xbgr.mr_n73253776)
print v(xbgr.mr_n73253888)
print v(xbgr.mr_n73254640)
print v(xbgr.mr_n73255504)
print v(xbgr.mr_n73256800)
print v(xbgr.mr_n73256912)
print v(xbgr.mr_n73257232)
print v(xbgr.mr_n73257344)
print v(xbgr.mr_n73257664)
print v(xbgr.mr_n73257776)
print v(xbgr.mr_n73258096)
print v(xbgr.mr_n73258208)
print v(xbgr.mr_n73258528)
print v(xbgr.mr_n73258640)
print v(xbgr.mr_n73258960)
print v(xbgr.mr_n73259392)
print v(xbgr.mr_n73259504)
print v(xbgr.mr_n73259824)
print v(xbgr.mr_n73259936)
print v(xbgr.mr_n73260256)
print v(xbgr.mr_n73260368)
print v(xbgr.mr_n73260688)
print v(xbgr.mr_n73260800)
print v(xbgr.mr_n73261120)
print v(xbgr.mr_n73261232)
print v(xbgr.mr_n73261552)
print v(xbgr.mr_n73261664)
print v(xbgr.mr_n73261984)
print v(xbgr.mr_n73262096)
print v(xbgr.mr_n73262416)
print v(xbgr.mr_n73262528)
print v(xbgr.mr_n73262848)
print v(xbgr.mr_n73262960)
print v(xbgr.mr_n73263392)
print v(xbgr.mr_n73263712)
print v(xbgr.mr_n73263824)
print v(xbgr.mr_n73264256)
print v(xbgr.mr_n73264688)
print v(xbgr.mr_n73265008)
print v(xbgr.mr_n73265120)
print v(xbgr.mr_n73265440)
print v(xbgr.mr_n73265552)
print v(xbgr.mr_n73265872)
print v(xbgr.mr_n73265984)
print v(xbgr.mr_n73266304)
print v(xbgr.mr_n73266416)
print v(xbgr.mr_n73267168)
print v(xbgr.mr_n73267280)
print v(xbgr.mr_n73267712)
print v(xbgr.mr_n73268032)
print v(xbgr.mr_n73268576)
print v(xbgr.mr_n73268896)
print v(xbgr.mr_n73269760)
print v(xbgr.mr_n73269872)
print v(xbgr.mr_n73270192)
print v(xbgr.mr_n73270624)
print v(xbgr.mr_n73271056)
print v(xbgr.mr_n73271488)
print v(xbgr.mr_n73271600)
print v(xbgr.mr_n73272352)
print v(xbgr.mr_n73272464)
print v(xbgr.mr_n73272784)
print v(xbgr.mr_n73272896)
print v(xbgr.mr_n73273216)
print v(xbgr.mr_n73273648)
print v(xbgr.mr_n73273760)
print v(xbgr.mr_n73274080)
print v(xbgr.mr_n73274192)
print v(xbgr.mr_n73274512)
print v(xbgr.mr_n73274624)
print v(xbgr.mr_n73274944)
print v(xbgr.mr_n73275376)
print v(xbgr.mr_n73276240)
print v(xbgr.mr_n73277104)
print v(xbgr.mr_n73278400)
print v(xbgr.mr_n73279264)
print v(xbgr.mr_n73280128)
print v(xbgr.mr_n73280992)
print v(xbgr.mr_n73281104)
print v(xbgr.mr_n73281424)
print v(xbgr.mr_n73282288)
print v(xbgr.mr_n73283152)
print v(xbgr.mr_n73284016)
print v(xbgr.mr_n73284128)
print v(xbgr.mr_n73284448)
print v(xbgr.mr_n73284560)
print v(xbgr.mr_n73284880)
print v(xbgr.mr_n73284992)
print v(xbgr.mr_n73285312)
print v(xbgr.mr_n73285424)
print v(xbgr.mr_n73285744)
print v(xbgr.mr_n73285856)
print v(xbgr.mr_n73286176)
print v(xbgr.mr_n73286288)
print v(xbgr.mr_n73287904)
print v(xbgr.mr_n73288880)
print v(xbgr.mr_n73289312)
print v(xbgr.mr_n73289744)
print v(xbgr.mr_n73290064)
print v(xbgr.mr_n73290176)
print v(xbgr.mr_n73290496)
print v(xbgr.mr_n73290608)
print v(xbgr.mr_n73290928)
print v(xbgr.mr_n73291040)
print v(xbgr.mr_n73291360)
print v(xbgr.mr_n73291472)
print v(xbgr.mr_n73291792)
print v(xbgr.mr_n73291904)
print v(xbgr.mr_n73292224)
print v(xbgr.mr_n73292336)
print v(xbgr.mr_n73292656)
print v(xbgr.mr_n73292768)
print v(xbgr.mr_n73293200)
print v(xbgr.mr_n73293520)
print v(xbgr.mr_n73293632)
print v(xbgr.mr_n73294064)
print v(xbgr.mr_n73294496)
print v(xbgr.mr_n73295680)
print v(xbgr.mr_n73295792)
print v(xbgr.mr_n73296112)
print v(xbgr.mr_n73296224)
print v(xbgr.mr_n73296544)
print v(xbgr.mr_n73296656)
print v(xbgr.mr_n73296976)
print v(xbgr.mr_n73297088)
print v(xbgr.mr_n73297408)
print v(xbgr.mr_n73297520)
print v(xbgr.mr_n73297840)
print v(xbgr.mr_n73298272)
print v(xbgr.mr_n73298384)
print v(xbgr.mr_n73298704)
print v(xbgr.mr_n73298816)
print v(xbgr.mr_n73299136)
print v(xbgr.mr_n73299248)
print v(xbgr.mr_n73299568)
print v(xbgr.mr_n73299680)
print v(xbgr.mr_n73300112)
print v(xbgr.mr_n73300432)
print v(xbgr.mr_n73300864)
print v(xbgr.mr_n73301728)
print v(xbgr.mr_n73301840)
print v(xbgr.mr_n73302160)
print v(xbgr.mr_n73302592)
print v(xbgr.mr_n73303024)
print v(xbgr.mr_n73303568)
print v(xbgr.mr_n73303888)
print v(xbgr.mr_n73304752)
print v(xbgr.mr_n73304864)
print v(xbgr.mr_n73305184)
print v(xbgr.mr_n73305296)
print v(xbgr.mr_n73305728)
print v(xbgr.mr_n73306480)
print v(xbgr.mr_n73306912)
print v(xbgr.mr_n73307344)
print v(xbgr.mr_n73307776)
print v(xbgr.mr_n73307888)
print v(xbgr.mr_n73309072)
print v(xbgr.mr_n73309936)
print v(xbgr.mr_n73310912)
print v(xbgr.mr_n73311232)
print v(xbgr.mr_n73311344)
print v(xbgr.mr_n73311776)
print v(xbgr.mr_n73312096)
print v(xbgr.mr_n73312208)
print v(xbgr.mr_n73312528)
print v(xbgr.mr_n73312640)
print v(xbgr.mr_n73312960)
print v(xbgr.mr_n73313072)
print v(xbgr.mr_n73313392)
print v(xbgr.mr_n73313504)
print v(xbgr.mr_n73313824)
print v(xbgr.mr_n73313936)
print v(xbgr.mr_n73314256)
print v(xbgr.mr_n73314368)
print v(xbgr.mr_n73314800)
print v(xbgr.mr_n73315232)
print v(xbgr.mr_n73315664)
print v(xbgr.mr_n73316416)
print v(xbgr.mr_n73316848)
print v(xbgr.mr_n73317712)
print v(xbgr.mr_n73318576)
print v(xbgr.mr_n73320304)
print v(xbgr.mr_n73321168)
print v(xbgr.mr_n73321280)
print v(xbgr.mr_n73322032)
print v(xbgr.mr_n73322144)
print v(xbgr.mr_n73322464)
print v(xbgr.mr_n73322576)
print v(xbgr.mr_n73322896)
print v(xbgr.mr_n73323008)
print v(xbgr.mr_n73325056)
print v(xbgr.mr_n73325168)
print v(xbgr.mr_n73325488)
print v(xbgr.mr_n73325600)
print v(xbgr.mr_n73325920)
print v(xbgr.mr_n73326032)
print v(xbgr.mr_n73326352)
print v(xbgr.mr_n73326464)
print v(xbgr.mr_n73326784)
print v(xbgr.mr_n73326896)
print v(xbgr.mr_n73327216)
print v(xbgr.mr_n73327328)
print v(xbgr.mr_n73327648)
print v(xbgr.mr_n73327760)
print v(xbgr.mr_n73328192)
print v(xbgr.mr_n73328512)
print v(xbgr.mr_n73328624)
print v(xbgr.mr_n73329056)
print v(xbgr.mr_n73329376)
print v(xbgr.mr_n73329488)
print v(xbgr.mr_n73329920)
print v(xbgr.mr_n73330240)
print v(xbgr.mr_n73330352)
print v(xbgr.mr_n73330672)
print v(xbgr.mr_n73330784)
print v(xbgr.mr_n73331104)
print v(xbgr.mr_n73331216)
print v(xbgr.mr_n73331536)
print v(xbgr.mr_n73331648)
print v(xbgr.mr_n73331968)
print v(xbgr.mr_n73332080)
print v(xbgr.mr_n73332400)
print v(xbgr.mr_n73332512)
print v(xbgr.mr_n73332832)
print v(xbgr.mr_n73332944)
print v(xbgr.mr_n73333264)
print v(xbgr.mr_n73333376)
print v(xbgr.mr_n73333696)
print v(xbgr.mr_n73333808)
print v(xbgr.mr_n73334128)
print v(xbgr.mr_n73334240)
print v(xbgr.mr_n73334560)
print v(xbgr.mr_n73334672)
print v(xbgr.mr_n73334992)
print v(xbgr.mr_n73335104)
print v(xbgr.mr_n73335424)
print v(xbgr.mr_n73335536)
print v(xbgr.mr_n73335856)
print v(xbgr.mr_n73335968)
print v(xbgr.mr_n73336288)
print v(xbgr.mr_n73336400)
print v(xbgr.mr_n73336720)
print v(xbgr.mr_n73336832)
print v(xbgr.mr_n73337152)
print v(xbgr.mr_n73337264)
print v(xbgr.mr_n73337584)
print v(xbgr.mr_n73337696)
print v(xbgr.mr_n73338128)
print v(xbgr.mr_n73338448)
print v(xbgr.mr_n73338560)
print v(xbgr.mr_n73338992)
print v(xbgr.mr_n73339312)
print v(xbgr.mr_n73339424)
print v(xbgr.mr_n73339856)
print v(xbgr.mr_n73340176)
print v(xbgr.mr_n73341040)
print v(xbgr.mr_n73341904)
print v(xbgr.mr_n73342768)
print v(xbgr.mr_n73343632)
print v(xbgr.mr_n73344496)
print v(xbgr.mr_n73345360)
print v(xbgr.mr_n73345472)
print v(xbgr.mr_n73345792)
print v(xbgr.mr_n73345904)
print v(xbgr.mr_n73346224)
print v(xbgr.mr_n73346336)
print v(xbgr.mr_n73346656)
print v(xbgr.mr_n73346768)
print v(xbgr.mr_n73347088)
print v(xbgr.mr_n73347200)
print v(xbgr.mr_n73347520)
print v(xbgr.mr_n73347632)
print v(xbgr.mr_n73347952)
print v(xbgr.mr_n73348816)
print v(xbgr.mr_n73349680)
print v(xbgr.mr_n73350544)
print v(xbgr.mr_n73350656)
print v(xbgr.mr_n73350976)
print v(xbgr.mr_n73351088)
print v(xbgr.mr_n73351408)
print v(xbgr.mr_n73351520)
print v(xbgr.mr_n73351952)
print v(xbgr.mr_n73352384)
print v(xbgr.mr_n73352816)
print v(xbgr.mr_n73353136)
print v(xbgr.mr_n73353248)
print v(xbgr.mr_n73353680)
print v(xbgr.mr_n73354000)
print v(xbgr.mr_n73354112)
print v(xbgr.mr_n73354432)
print v(xbgr.mr_n73354544)
print v(xbgr.mr_n73354864)
print v(xbgr.mr_n73354976)
print v(xbgr.mr_n73355296)
print v(xbgr.mr_n73355408)
print v(xbgr.mr_n73355728)
print v(xbgr.mr_n73355840)
print v(xbgr.mr_n73356160)
print v(xbgr.mr_n73356272)
print v(xbgr.mr_n73356704)
print v(xbgr.mr_n73357136)
print v(xbgr.mr_n73357456)
print v(xbgr.mr_n73357568)
print v(xbgr.mr_n73358000)
print v(xbgr.mr_n73358320)
print v(xbgr.mr_n73358432)
print v(xbgr.mr_n73358864)
print v(xbgr.mr_n73359184)
print v(xbgr.mr_n73359296)
print v(xbgr.mr_n73359728)
print v(xbgr.mr_n73360048)
print v(xbgr.mr_n73360912)
print v(xbgr.mr_n73361776)
print v(xbgr.mr_n73362640)
print v(xbgr.mr_n73363504)
print v(xbgr.mr_n73364368)
print v(xbgr.mr_n73364480)
print v(xbgr.mr_n73364800)
print v(xbgr.mr_n73364912)
print v(xbgr.mr_n73365232)
print v(xbgr.mr_n73365344)
print v(xbgr.mr_n73365664)
print v(xbgr.mr_n73365776)
print v(xbgr.mr_n73366096)
print v(xbgr.mr_n73366960)
print v(xbgr.mr_n73367824)
print v(xbgr.mr_n73368688)
print v(xbgr.mr_n73368800)
print v(xbgr.mr_n73369120)
print v(xbgr.mr_n73369232)
print v(xbgr.mr_n73369552)
print v(xbgr.mr_n73369664)
print v(xbgr.mr_n73369984)
print v(xbgr.mr_n73370096)
print v(xbgr.mr_n73370416)
print v(xbgr.mr_n73370528)
print v(xbgr.mr_n73370848)
print v(xbgr.mr_n73370960)
print v(xbgr.mr_n73371280)
print v(xbgr.mr_n73372144)
print v(xbgr.mr_n73373008)
print v(xbgr.mr_n73373872)
print v(xbgr.mr_n73374736)
print v(xbgr.mr_n73375600)
print v(xbgr.mr_n73376464)
print v(xbgr.mr_n73377328)
print v(xbgr.mr_n73378192)
print v(xbgr.mr_n73379056)
print v(xbgr.mr_n73379168)
print v(xbgr.mr_n73379488)
print v(xbgr.mr_n73379600)
print v(xbgr.mr_n73379920)
print v(xbgr.mr_n73380032)
print v(xbgr.mr_n73380352)
print v(xbgr.mr_n73380464)
print v(xbgr.mr_n73380784)
print v(xbgr.mr_n73380896)
print v(xbgr.mr_n73381216)
print v(xbgr.mr_n73381328)
print v(xbgr.mr_n73381648)
print v(xbgr.mr_n73381760)
print v(xbgr.mr_n73382080)
print v(xbgr.mr_n73382192)
print v(xbgr.mr_n73382512)
print v(xbgr.mr_n73382624)
print v(xbgr.mr_n73382944)
print v(xbgr.mr_n73383056)
print v(xbgr.mr_n73383376)
print v(xbgr.mr_n73384240)
print v(xbgr.mr_n73384352)
print v(xbgr.mr_n73384672)
print v(xbgr.mr_n73384784)
print v(xbgr.mr_n73385104)
print v(xbgr.mr_n73385216)
print v(xbgr.mr_n73385536)
print v(xbgr.mr_n73385648)
print v(xbgr.mr_n73385968)
print v(xbgr.mr_n73386080)
print v(xbgr.mr_n73386400)
print v(xbgr.mr_n73386512)
print v(xbgr.mr_n73386832)
print v(xbgr.mr_n73386944)
print v(xbgr.mr_n73387264)
print v(xbgr.mr_n73387376)
print v(xbgr.mr_n73387696)
print v(xbgr.mr_n73387808)
print v(xbgr.mr_n73388128)
print v(xbgr.mr_n73388240)
print v(xbgr.mr_n73388560)
print v(xbgr.mr_n73388672)
print v(xbgr.mr_n73389104)
print v(xbgr.mr_n73389424)
print v(xbgr.mr_n73389536)
print v(xbgr.mr_n73389968)
print v(xbgr.mr_n73390288)
print v(xbgr.mr_n73390400)
print v(xbgr.mr_n73390832)
print v(xbgr.mr_n73391152)
print v(xbgr.mr_n73391264)
print v(xbgr.mr_n73391696)
print v(xbgr.mr_n73392016)
print v(xbgr.mr_n73392128)
print v(xbgr.mr_n73392448)
print v(xbgr.mr_n73392560)
print v(xbgr.mr_n73392992)
print v(xbgr.mr_n73393424)
print v(xbgr.mr_n73393744)
print v(xbgr.mr_n73393856)
print v(xbgr.mr_n73394176)
print v(xbgr.mr_n73394288)
print v(xbgr.mr_n73394608)
print v(xbgr.mr_n73394720)
print v(xbgr.mr_n73395040)
print v(xbgr.mr_n73395152)
print v(xbgr.mr_n73395472)
print v(xbgr.mr_n73395584)
print v(xbgr.mr_n73396016)
print v(xbgr.mr_n73396336)
print v(xbgr.mr_n73396448)
print v(xbgr.mr_n73396880)
print v(xbgr.mr_n73397200)
print v(xbgr.mr_n73398064)
print v(xbgr.mr_n73398928)
print v(xbgr.mr_n73399792)
print v(xbgr.mr_n73400656)
print v(xbgr.mr_n73400768)
print v(xbgr.mr_n73401088)
print v(xbgr.mr_n73401200)
print v(xbgr.mr_n73401520)
print v(xbgr.mr_n73401632)
print v(xbgr.mr_n73401952)
print v(xbgr.mr_n73402064)
print v(xbgr.mr_n73402384)
print v(xbgr.mr_n73403248)
print v(xbgr.mr_n73404112)
print v(xbgr.mr_n73404224)
print v(xbgr.mr_n73404544)
print v(xbgr.mr_n73404656)
print v(xbgr.mr_n73405088)
print v(xbgr.mr_n73405520)
print v(xbgr.mr_n73405840)
print v(xbgr.mr_n73405952)
print v(xbgr.mr_n73406272)
print v(xbgr.mr_n73406384)
print v(xbgr.mr_n73406704)
print v(xbgr.mr_n73406816)
print v(xbgr.mr_n73407136)
print v(xbgr.mr_n73407248)
print v(xbgr.mr_n73407568)
print v(xbgr.mr_n73407680)
print v(xbgr.mr_n73408112)
print v(xbgr.mr_n73408432)
print v(xbgr.mr_n73408544)
print v(xbgr.mr_n73408976)
print v(xbgr.mr_n73409296)
print v(xbgr.mr_n73409408)
print v(xbgr.mr_n73409728)
print v(xbgr.mr_n73409840)
print v(xbgr.mr_n73410160)
print v(xbgr.mr_n73410272)
print v(xbgr.mr_n73410592)
print v(xbgr.mr_n73410704)
print v(xbgr.mr_n73411024)
print v(xbgr.mr_n73411136)
print v(xbgr.mr_n73411456)
print v(xbgr.mr_n73411568)
print v(xbgr.mr_n73411888)
print v(xbgr.mr_n73412000)
print v(xbgr.mr_n73412320)
print v(xbgr.mr_n73412432)
print v(xbgr.mr_n73412752)
print v(xbgr.mr_n73412864)
print v(xbgr.mr_n73413184)
print v(xbgr.mr_n73413296)
print v(xbgr.mr_n73413616)
print v(xbgr.mr_n73414480)
print v(xbgr.mr_n73415344)
print v(xbgr.mr_n73416208)
print v(xbgr.mr_n73417072)
print v(xbgr.mr_n73417184)
print v(xbgr.mr_n73417504)
print v(xbgr.mr_n73417616)
print v(xbgr.mr_n73417936)
print v(xbgr.mr_n73418048)
print v(xbgr.mr_n73418368)
print v(xbgr.mr_n73418480)
print v(xbgr.mr_n73418912)
print v(xbgr.mr_n73419344)
print v(xbgr.mr_n73419776)
print v(xbgr.mr_n73420208)
print v(xbgr.mr_n73420528)
print v(xbgr.mr_n73420640)
print v(xbgr.mr_n73420960)
print v(xbgr.mr_n73421072)
print v(xbgr.mr_n73421392)
print v(xbgr.mr_n73421504)
print v(xbgr.mr_n73421824)
print v(xbgr.mr_n73421936)
print v(xbgr.mr_n73422256)
print v(xbgr.mr_n73423120)
print v(xbgr.mr_n73423984)
print v(xbgr.mr_n73424096)
print v(xbgr.mr_n73424528)
print v(xbgr.mr_n73424848)
print v(xbgr.mr_n73425712)
print v(xbgr.mr_n73425824)
print v(xbgr.mr_n73426144)
print v(xbgr.mr_n73426256)
print v(xbgr.mr_n73426576)
print v(xbgr.mr_n73426688)
print v(xbgr.mr_n73427008)
print v(xbgr.mr_n73427120)
print v(xbgr.mr_n73427440)
print v(xbgr.mr_n73428304)
print v(xbgr.mr_n73428416)
print v(xbgr.mr_n73428848)
print v(xbgr.mr_n73429168)
print v(xbgr.mr_n73429280)
print v(xbgr.mr_n73429600)
print v(xbgr.mr_n73429712)
print v(xbgr.mr_n73430032)
print v(xbgr.mr_n73430144)
print v(xbgr.mr_n73430464)
print v(xbgr.mr_n73430576)
print v(xbgr.mr_n73430896)
print v(xbgr.mr_n73431760)
print v(xbgr.mr_n73432192)
print v(xbgr.mr_n73432304)
print v(xbgr.mr_n73432624)
print v(xbgr.mr_n73432736)
print v(xbgr.mr_n73433056)
print v(xbgr.mr_n73433488)
print v(xbgr.mr_n73434352)
print v(xbgr.mr_n73435216)
print v(xbgr.mr_n73435328)
print v(xbgr.mr_n73436080)
print v(xbgr.mr_n73436192)
print v(xbgr.mr_n73436512)
print v(xbgr.mr_n73436624)
print v(xbgr.mr_n73436944)
print v(xbgr.mr_n73437808)
print v(xbgr.mr_n73438672)
print v(xbgr.mr_n73438784)
print v(xbgr.mr_n73439104)
print v(xbgr.mr_n73439216)
print v(xbgr.mr_n73439536)
print v(xbgr.mr_n73440400)
print v(xbgr.mr_n73440512)
print v(xbgr.mr_n73440832)
print v(xbgr.mr_n73440944)
print v(xbgr.mr_n73441264)
print v(xbgr.mr_n73441376)
print v(xbgr.mr_n73441696)
print v(xbgr.mr_n73441808)
print v(xbgr.mr_n73442128)
print v(xbgr.mr_n73442240)
print v(xbgr.mr_n73442992)
print v(xbgr.mr_n73443856)
print v(xbgr.mr_n73444720)
print v(xbgr.mr_n73444832)
print v(xbgr.mr_n73445152)
print v(xbgr.mr_n73445264)
print v(xbgr.mr_n73445584)
print v(xbgr.mr_n73445696)
print v(xbgr.mr_n73446016)
print v(xbgr.mr_n73446128)
print v(xbgr.mr_n73446448)
print v(xbgr.mr_n73446560)
print v(xbgr.mr_n73446880)
print v(xbgr.mr_n73446992)
print v(xbgr.mr_n73447312)
print v(xbgr.mr_n73447424)
print v(xbgr.mr_n73447856)
print v(xbgr.mr_n73448176)
print v(xbgr.mr_n73448288)
print v(xbgr.mr_n73448608)
print v(xbgr.mr_n73448720)
print v(xbgr.mr_n73449040)
print v(xbgr.mr_n73449904)
print v(xbgr.mr_n73450768)
print v(xbgr.mr_n73451632)
print v(xbgr.mr_n73452496)
print v(xbgr.mr_n73452928)
print v(xbgr.mr_n73453040)
print v(xbgr.mr_n73453360)
print v(xbgr.mr_n73453472)
print v(xbgr.mr_n73453792)
print v(xbgr.mr_n73453904)
print v(xbgr.mr_n73454336)
print v(xbgr.mr_n73455088)
print v(xbgr.mr_n73455200)
print v(xbgr.mr_n73455520)
print v(xbgr.mr_n73455632)
print v(xbgr.mr_n73455952)
print v(xbgr.mr_n73456816)
print v(xbgr.mr_n73457680)
print v(xbgr.mr_n73457792)
print v(xbgr.mr_n73458112)
print v(xbgr.mr_n73458224)
print v(xbgr.mr_n73458544)
print v(xbgr.mr_n73459408)
print v(xbgr.mr_n73460272)
print v(xbgr.mr_n73461136)
print v(xbgr.mr_n73461248)
print v(xbgr.mr_n73461568)
print v(xbgr.mr_n73461680)
print v(xbgr.mr_n73462000)
print v(xbgr.mr_n73462864)
print v(xbgr.mr_n73463728)
print v(xbgr.mr_n73463840)
print v(xbgr.mr_n73464160)
print v(xbgr.mr_n73464272)
print v(xbgr.mr_n73464592)
print v(xbgr.mr_n73464704)
print v(xbgr.mr_n73465024)
print v(xbgr.mr_n73465136)
print v(xbgr.mr_n73465456)
print v(xbgr.mr_n73465568)
print v(xbgr.mr_n73465888)
print v(xbgr.mr_n73466000)
print v(xbgr.mr_n73466320)
print v(xbgr.mr_n73466432)
print v(xbgr.mr_n73466752)
print v(xbgr.mr_n73466864)
print v(xbgr.mr_n73467184)
print v(xbgr.mr_n73467296)
print v(xbgr.mr_n73467616)
print v(xbgr.mr_n73467728)
print v(xbgr.mr_n73468048)
print v(xbgr.mr_n73468160)
print v(xbgr.mr_n73468480)
print v(xbgr.mr_n73468592)
print v(xbgr.mr_n73468912)
print v(xbgr.mr_n73469024)
print v(xbgr.mr_n73469344)
print v(xbgr.mr_n73469456)
print v(xbgr.mr_n73469776)
print v(xbgr.mr_n73469888)
print v(xbgr.mr_n73470208)
print v(xbgr.mr_n73470320)
print v(xbgr.mr_n73470640)
print v(xbgr.mr_n73470752)
print v(xbgr.mr_n73471072)
print v(xbgr.mr_n73471184)
print v(xbgr.mr_n73471504)
print v(xbgr.mr_n73471616)
print v(xbgr.mr_n73471936)
print v(xbgr.mr_n73472048)
print v(xbgr.mr_n73472368)
print v(xbgr.mr_n73472480)
print v(xbgr.mr_n73472800)
print v(xbgr.mr_n73472912)
print v(xbgr.mr_n73473232)
print v(xbgr.mr_n73473344)
print v(xbgr.mr_n73473664)
print v(xbgr.mr_n73473776)
print v(xbgr.mr_n73474096)
print v(xbgr.mr_n73474208)
print v(xbgr.mr_n73474528)
print v(xbgr.mr_n73474640)
print v(xbgr.mr_n73475072)
print v(xbgr.mr_n73475504)
print v(xbgr.mr_n73475936)
print v(xbgr.mr_n73476368)
print v(xbgr.mr_n73476800)
print v(xbgr.mr_n73477232)
print v(xbgr.mr_n73477664)
print v(xbgr.mr_n73478096)
print v(xbgr.mr_n73478528)
print v(xbgr.mr_n73478960)
print v(xbgr.mr_n73479392)
print v(xbgr.mr_n73479824)
print v(xbgr.mr_n73480256)
print v(xbgr.mr_n73480688)
print v(xbgr.mr_n73481120)
print v(xbgr.mr_n73481552)
print v(xbgr.mr_n73481984)
print v(xbgr.mr_n73482416)
print v(xbgr.mr_n73482848)
print v(xbgr.mr_n73483280)
print v(xbgr.mr_n73483712)
print v(xbgr.mr_n73484144)
print v(xbgr.mr_n73484576)
print v(xbgr.mr_n73485008)
print v(xbgr.mr_n73485440)
print v(xbgr.mr_n73485872)
print v(xbgr.mr_n73486192)
print v(xbgr.mr_n73486304)
print v(xbgr.mr_n73486624)
print v(xbgr.mr_n73486736)
print v(xbgr.mr_n73487056)
print v(xbgr.mr_n73487168)
print v(xbgr.mr_n73487488)
print v(xbgr.mr_n73487600)
print v(xbgr.mr_n73487920)
print v(xbgr.mr_n73488032)
print v(xbgr.mr_n73488352)
print v(xbgr.mr_n73488464)
print v(xbgr.mr_n73488784)
print v(xbgr.mr_n73488896)
print v(xbgr.mr_n73489216)
print v(xbgr.mr_n73489328)
print v(xbgr.mr_n73489648)
print v(xbgr.mr_n73489760)
print v(xbgr.mr_n73490080)
print v(xbgr.mr_n73490192)
print v(xbgr.mr_n73490512)
print v(xbgr.mr_n73490624)
print v(xbgr.mr_n73490944)
print v(xbgr.mr_n73491056)
print v(xbgr.mr_n73491376)
print v(xbgr.mr_n73491488)
print v(xbgr.mr_n73491808)
print v(xbgr.mr_n73491920)
print v(xbgr.mr_n73492240)
print v(xbgr.mr_n73492352)
print v(xbgr.mr_n73492672)
print v(xbgr.mr_n73492784)
print v(xbgr.mr_n73493104)
print v(xbgr.mr_n73493216)
print v(xbgr.mr_n73493536)
print v(xbgr.mr_n73493648)
print v(xbgr.mr_n73493968)
print v(xbgr.mr_n73494080)
print v(xbgr.mr_n73494400)
print v(xbgr.mr_n73494512)
print v(xbgr.mr_n73494832)
print v(xbgr.mr_n73494944)
print v(xbgr.mr_n73495264)
print v(xbgr.mr_n73495376)
print v(xbgr.mr_n73495696)
print v(xbgr.mr_n73495808)
print v(xbgr.mr_n73496128)
print v(xbgr.mr_n73496240)
print v(xbgr.mr_n73496672)
print v(xbgr.mr_n73497104)
print v(xbgr.mr_n73497536)
print v(xbgr.mr_n73497968)
print v(xbgr.mr_n73498288)
print v(xbgr.mr_n73498400)
print v(xbgr.mr_n73498720)
print v(xbgr.mr_n73498832)
print v(xbgr.mr_n73499264)
print v(xbgr.mr_n73499696)
print v(xbgr.mr_n73500128)
print v(xbgr.mr_n73500560)
print v(xbgr.mr_n73500992)
print v(xbgr.mr_n73501424)
print v(xbgr.mr_n73501856)
print v(xbgr.mr_n73502288)
print v(xbgr.mr_n73502720)
print v(xbgr.mr_n73503152)
print v(xbgr.mr_n73503584)
print v(xbgr.mr_n73504016)
print v(xbgr.mr_n73504448)
print v(xbgr.mr_n73504880)
print v(xbgr.mr_n73505312)
print v(xbgr.mr_n73505744)
print v(xbgr.mr_n73506176)
print v(xbgr.mr_n73506608)
print v(xbgr.mr_n73507040)
print v(xbgr.mr_n73507472)
print v(xbgr.mr_n73507904)
print v(xbgr.mr_n73508336)
print v(xbgr.mr_n73508656)
print v(xbgr.mr_n73508768)
print v(xbgr.mr_n73509200)
print v(xbgr.mr_n73509520)
print v(xbgr.mr_n73509632)
print v(xbgr.mr_n73510064)
print v(xbgr.mr_n73510384)
print v(xbgr.mr_n73510496)
print v(xbgr.mr_n73510928)
print v(xbgr.mr_n73511248)
print v(xbgr.mr_n73511360)
print v(xbgr.mr_n73511792)
print v(xbgr.mr_n73512112)
print v(xbgr.mr_n73512224)
print v(xbgr.mr_n73512656)
print v(xbgr.mr_n73512976)
print v(xbgr.mr_n73513088)
print v(xbgr.mr_n73513408)
print v(xbgr.mr_n73513520)
print v(xbgr.mr_n73513840)
print v(xbgr.mr_n73513952)
print v(xbgr.mr_n73514384)
print v(xbgr.mr_n73514816)
print v(xbgr.mr_n73515248)
print v(xbgr.mr_n73515568)
print v(xbgr.mr_n73515680)
print v(xbgr.mr_n73516000)
print v(xbgr.mr_n73516112)
print v(xbgr.mr_n73516432)
print v(xbgr.mr_n73516544)
print v(xbgr.mr_n73516864)
print v(xbgr.mr_n73516976)
print v(xbgr.mr_n73517296)
print v(xbgr.mr_n73517408)
print v(xbgr.mr_n73517728)
print v(xbgr.mr_n73517840)
print v(xbgr.mr_n73518160)
print v(xbgr.mr_n73518272)
print v(xbgr.mr_n73518704)
print v(xbgr.mr_n73519024)
print v(xbgr.mr_n73519136)
print v(xbgr.mr_n73519568)
print v(xbgr.mr_n73519888)
print v(xbgr.mr_n73520000)
print v(xbgr.mr_n73520432)
print v(xbgr.mr_n73520752)
print v(xbgr.mr_n73521616)
print v(xbgr.mr_n73522480)
print v(xbgr.mr_n73523344)
print v(xbgr.mr_n73524208)
print v(xbgr.mr_n73525072)
print v(xbgr.mr_n73525936)
print v(xbgr.mr_n73526048)
print v(xbgr.mr_n73526368)
print v(xbgr.mr_n73526480)
print v(xbgr.mr_n73526800)
print v(xbgr.mr_n73526912)
print v(xbgr.mr_n73527232)
print v(xbgr.mr_n73527344)
print v(xbgr.mr_n73527664)
print v(xbgr.mr_n73528528)
print v(xbgr.mr_n73529392)
print v(xbgr.mr_n73530256)
print v(xbgr.mr_n73530368)
print v(xbgr.mr_n73530688)
print v(xbgr.mr_n73530800)
print v(xbgr.mr_n73531120)
print v(xbgr.mr_n73531232)
print v(xbgr.mr_n73531664)
print v(xbgr.mr_n73532096)
print v(xbgr.mr_n73532528)
print v(xbgr.mr_n73532848)
print v(xbgr.mr_n73532960)
print v(xbgr.mr_n73533280)
print v(xbgr.mr_n73533392)
print v(xbgr.mr_n73533712)
print v(xbgr.mr_n73533824)
print v(xbgr.mr_n73534144)
print v(xbgr.mr_n73534256)
print v(xbgr.mr_n73534576)
print v(xbgr.mr_n73534688)
print v(xbgr.mr_n73535008)
print v(xbgr.mr_n73535120)
print v(xbgr.mr_n73535440)
print v(xbgr.mr_n73535552)
print v(xbgr.mr_n73535872)
print v(xbgr.mr_n73535984)
print v(xbgr.mr_n73536304)
print v(xbgr.mr_n73536416)
print v(xbgr.mr_n73536848)
print v(xbgr.mr_n73537168)
print v(xbgr.mr_n73537280)
print v(xbgr.mr_n73537712)
print v(xbgr.mr_n73538032)
print v(xbgr.mr_n73538144)
print v(xbgr.mr_n73538464)
print v(xbgr.mr_n73538576)
print v(xbgr.mr_n73538896)
print v(xbgr.mr_n73539760)
print v(xbgr.mr_n73540624)
print v(xbgr.mr_n73540736)
print v(xbgr.mr_n73541056)
print v(xbgr.mr_n73541168)
print v(xbgr.mr_n73541488)
print v(xbgr.mr_n73542352)
print v(xbgr.mr_n73542896)
print v(xbgr.mr_n73543328)
print v(xbgr.mr_n73544080)
print v(xbgr.mr_n73544944)
print v(xbgr.mr_n73545056)
print v(xbgr.mr_n73545376)
print v(xbgr.mr_n73545488)
print v(xbgr.mr_n73545808)
print v(xbgr.mr_n73545920)
print v(xbgr.mr_n73546240)
print v(xbgr.mr_n73546352)
print v(xbgr.mr_n73546672)
print v(xbgr.mr_n73546784)
print v(xbgr.mr_n73547104)
print v(xbgr.mr_n73547216)
print v(xbgr.mr_n73547536)
print v(xbgr.mr_n73547648)
print v(xbgr.mr_n73547968)
print v(xbgr.mr_n73548080)
print v(xbgr.mr_n73548400)
print v(xbgr.mr_n73549264)
print v(xbgr.mr_n73549376)
print v(xbgr.mr_n73549696)
print v(xbgr.mr_n73549808)
print v(xbgr.mr_n73550128)
print v(xbgr.mr_n73550992)
print v(xbgr.mr_n73551856)
print v(xbgr.mr_n73551968)
print v(xbgr.mr_n73552288)
print v(xbgr.mr_n73552400)
print v(xbgr.mr_n73552720)
print v(xbgr.mr_n73552832)
print v(xbgr.mr_n73553264)
print v(xbgr.mr_n73553584)
print v(xbgr.mr_n73554016)
print v(xbgr.mr_n73555312)
print v(xbgr.mr_n73555424)
print v(xbgr.mr_n73555744)
print v(xbgr.mr_n73555856)
print v(xbgr.mr_n73556176)
print v(xbgr.mr_n73556288)
print v(xbgr.mr_n73556608)
print v(xbgr.mr_n73556720)
print v(xbgr.mr_n73557040)
print v(xbgr.mr_n73557152)
print v(xbgr.mr_n73557584)
print v(xbgr.mr_n73557904)
print v(xbgr.mr_n73558016)
print v(xbgr.mr_n73558336)
print v(xbgr.mr_n73558448)
print v(xbgr.mr_n73558768)
print v(xbgr.mr_n73558880)
print v(xbgr.mr_n73559200)
print v(xbgr.mr_n73559312)
print v(xbgr.mr_n73559632)
print v(xbgr.mr_n73560496)
print v(xbgr.mr_n73561360)
print v(xbgr.mr_n73562224)
print v(xbgr.mr_n73563088)
print v(xbgr.mr_n73563200)
print v(xbgr.mr_n73563520)
print v(xbgr.mr_n73563632)
print v(xbgr.mr_n73563952)
print v(xbgr.mr_n73564064)
print v(xbgr.mr_n73564384)
print v(xbgr.mr_n73564496)
print v(xbgr.mr_n73564816)
print v(xbgr.mr_n73565680)
print v(xbgr.mr_n73566544)
print v(xbgr.mr_n73567408)
print v(xbgr.mr_n73568272)
print v(xbgr.mr_n73568704)
print v(xbgr.mr_n73568816)
print v(xbgr.mr_n73569136)
print v(xbgr.mr_n73569248)
print v(xbgr.mr_n73569568)
print v(xbgr.mr_n73569680)
print v(xbgr.mr_n73570000)
print v(xbgr.mr_n73570112)
print v(xbgr.mr_n73570432)
print v(xbgr.mr_n73570544)
print v(xbgr.mr_n73570864)
print v(xbgr.mr_n73570976)
print v(xbgr.mr_n73571296)
print v(xbgr.mr_n73571408)
print v(xbgr.mr_n73571728)
print v(xbgr.mr_n73571840)
print v(xbgr.mr_n73572272)
print v(xbgr.mr_n73572592)
print v(xbgr.mr_n73572704)
print v(xbgr.mr_n73573136)
print v(xbgr.mr_n73573456)
print v(xbgr.mr_n73573568)
print v(xbgr.mr_n73574000)
print v(xbgr.mr_n73574320)
print v(xbgr.mr_n73574432)
print v(xbgr.mr_n73574752)
print v(xbgr.mr_n73574864)
print v(xbgr.mr_n73575184)
print v(xbgr.mr_n73576048)
print v(xbgr.mr_n73576912)
print v(xbgr.mr_n73577776)
print v(xbgr.mr_n73578640)
print v(xbgr.mr_n73579504)
print v(xbgr.mr_n73580368)
print v(xbgr.mr_n73581232)
print v(xbgr.mr_n73582096)
print v(xbgr.mr_n73582960)
print v(xbgr.mr_n73583072)
print v(xbgr.mr_n73583392)
print v(xbgr.mr_n73583504)
print v(xbgr.mr_n73583824)
print v(xbgr.mr_n73584688)
print v(xbgr.mr_n73584800)
print v(xbgr.mr_n73585120)
print v(xbgr.mr_n73585232)
print v(xbgr.mr_n73585552)
print v(xbgr.mr_n73585664)
print v(xbgr.mr_n73585984)
print v(xbgr.mr_n73586096)
print v(xbgr.mr_n73586416)
print v(xbgr.mr_n73586528)
print v(xbgr.mr_n73586848)
print v(xbgr.mr_n73586960)
print v(xbgr.mr_n73587280)
print v(xbgr.mr_n73587392)
print v(xbgr.mr_n73587712)
print v(xbgr.mr_n73587824)
print v(xbgr.mr_n73588144)
print v(xbgr.mr_n73589008)
print v(xbgr.mr_n73589872)
print v(xbgr.mr_n73590736)
print v(xbgr.mr_n73590848)
print v(xbgr.mr_n73591168)
print v(xbgr.mr_n73592464)
print v(xbgr.mr_n73593328)
print v(xbgr.mr_n73594192)
print v(xbgr.mr_n73595056)
print v(xbgr.mr_n73595168)
print v(xbgr.mr_n73595488)
print v(xbgr.mr_n73595600)
print v(xbgr.mr_n73596032)
print v(xbgr.mr_n73596352)
print v(xbgr.mr_n73596464)
print v(xbgr.mr_n73596896)
print v(xbgr.mr_n73597216)
print v(xbgr.mr_n73597328)
print v(xbgr.mr_n73597760)
print v(xbgr.mr_n73598080)
print v(xbgr.mr_n73598192)
print v(xbgr.mr_n73598624)
print v(xbgr.mr_n73598944)
print v(xbgr.mr_n73599056)
print v(xbgr.mr_n73599488)
print v(xbgr.mr_n73599808)
print v(xbgr.mr_n73599920)
print v(xbgr.mr_n73600240)
print v(xbgr.mr_n73600352)
print v(xbgr.mr_n73600672)
print v(xbgr.mr_n73600784)
print v(xbgr.mr_n73601216)
print v(xbgr.mr_n73601536)
print v(xbgr.mr_n73601648)
print v(xbgr.mr_n73601968)
print v(xbgr.mr_n73602080)
print v(xbgr.mr_n73602400)
print v(xbgr.mr_n73602512)
print v(xbgr.mr_n73602832)
print v(xbgr.mr_n73602944)
print v(xbgr.mr_n73603264)
print v(xbgr.mr_n73603376)
print v(xbgr.mr_n73603696)
print v(xbgr.mr_n73603808)
print v(xbgr.mr_n73604128)
print v(xbgr.mr_n73604240)
print v(xbgr.mr_n73604560)
print v(xbgr.mr_n73604672)
print v(xbgr.mr_n73605104)
print v(xbgr.mr_n73605424)
print v(xbgr.mr_n73606400)
print v(xbgr.mr_n73606832)
print v(xbgr.mr_n73607152)
print v(xbgr.mr_n73608016)
print v(xbgr.mr_n73608128)
print v(xbgr.mr_n73608448)
print v(xbgr.mr_n73608560)
print v(xbgr.mr_n73608880)
print v(xbgr.mr_n73608992)
print v(xbgr.mr_n73609312)
print v(xbgr.mr_n73609424)
print v(xbgr.mr_n73609744)
print v(xbgr.mr_n73610608)
print v(xbgr.mr_n73611040)
print v(xbgr.mr_n73611904)
print v(xbgr.mr_n73612768)
print v(xbgr.mr_n73612880)
print v(xbgr.mr_n73613200)
print v(xbgr.mr_n73613312)
print v(xbgr.mr_n73613632)
print v(xbgr.mr_n73613744)
print v(xbgr.mr_n73614064)
print v(xbgr.mr_n73614176)
print v(xbgr.mr_n73614928)
print v(xbgr.mr_n73615040)
print v(xbgr.mr_n73615360)
print v(xbgr.mr_n73615472)
print v(xbgr.mr_n73615792)
print v(xbgr.mr_n73615904)
print v(xbgr.mr_n73616224)
print v(xbgr.mr_n73616336)
print v(xbgr.mr_n73616656)
print v(xbgr.mr_n73617200)
print v(xbgr.mr_n73617520)
print v(xbgr.mr_n73617632)
print v(xbgr.mr_n73618064)
print v(xbgr.mr_n73618384)
print v(xbgr.mr_n73618496)
print v(xbgr.mr_n73619680)
print v(xbgr.mr_n73620112)
print v(xbgr.mr_n73620224)
print v(xbgr.mr_n73620544)
print v(xbgr.mr_n73620656)
print v(xbgr.mr_n73620976)
print v(xbgr.mr_n73621088)
print v(xbgr.mr_n73621408)
print v(xbgr.mr_n73621520)
print v(xbgr.mr_n73621840)
print v(xbgr.mr_n73621952)
print v(xbgr.mr_n73622272)
print v(xbgr.mr_n73622384)
print v(xbgr.mr_n73623136)
print v(xbgr.mr_n73624000)
print v(xbgr.mr_n73624112)
print v(xbgr.mr_n73624432)
print v(xbgr.mr_n73624544)
print v(xbgr.mr_n73624864)
print v(xbgr.mr_n73624976)
print v(xbgr.mr_n73625296)
print v(xbgr.mr_n73625408)
print v(xbgr.mr_n73625728)
print v(xbgr.mr_n73625840)
print v(xbgr.mr_n73626160)
print v(xbgr.mr_n73626272)
print v(xbgr.mr_n73626592)
print v(xbgr.mr_n73626704)
print v(xbgr.mr_n73627024)
print v(xbgr.mr_n73627136)
print v(xbgr.mr_n73627456)
print v(xbgr.mr_n73628320)
print v(xbgr.mr_n73629184)
print v(xbgr.mr_n73630048)
print v(xbgr.mr_n73630160)
print v(xbgr.mr_n73630592)
print v(xbgr.mr_n73631024)
print v(xbgr.mr_n73631344)
print v(xbgr.mr_n73631776)
print v(xbgr.mr_n73631888)
print v(xbgr.mr_n73632208)
print v(xbgr.mr_n73632320)
print v(xbgr.mr_n73633072)
print v(xbgr.mr_n73634480)
print v(xbgr.mr_n73634800)
print v(xbgr.mr_n73634912)
print v(xbgr.mr_n73635232)
print v(xbgr.mr_n73635344)
print v(xbgr.mr_n73635664)
print v(xbgr.mr_n73635776)
print v(xbgr.mr_n73636208)
print v(xbgr.mr_n73636528)
print v(xbgr.mr_n73636640)
print v(xbgr.mr_n73637072)
print v(xbgr.mr_n73637392)
print v(xbgr.mr_n73637824)
print v(xbgr.mr_n73638256)
print v(xbgr.mr_n73638368)
print v(xbgr.mr_n73638688)
print v(xbgr.mr_n73638800)
print v(xbgr.mr_n73639120)
print v(xbgr.mr_n73639232)
print v(xbgr.mr_n73639984)
print v(xbgr.mr_n73640848)
print v(xbgr.mr_n73640960)
print v(xbgr.mr_n73641392)
print v(xbgr.mr_n73641712)
print v(xbgr.mr_n73642576)
print v(xbgr.mr_n73643440)
print v(xbgr.mr_n73644736)
print v(xbgr.mr_n73645168)
print v(xbgr.mr_n73645280)
print v(xbgr.mr_n73645600)
print v(xbgr.mr_n73645712)
print v(xbgr.mr_n73646032)
print v(xbgr.mr_n73646144)
print v(xbgr.mr_n73646464)
print v(xbgr.mr_n73646576)
print v(xbgr.mr_n73646896)
print v(xbgr.mr_n73647008)
print v(xbgr.mr_n73647328)
print v(xbgr.mr_n73647440)
print v(xbgr.mr_n73647760)
print v(xbgr.mr_n73647872)
print v(xbgr.mr_n73648192)
print v(xbgr.mr_n73648304)
print v(xbgr.mr_n73649056)
print v(xbgr.mr_n73649920)
print v(xbgr.mr_n73650784)
print v(xbgr.mr_n73650896)
print v(xbgr.mr_n73651216)
print v(xbgr.mr_n73651328)
print v(xbgr.mr_n73651648)
print v(xbgr.mr_n73651760)
print v(xbgr.mr_n73652080)
print v(xbgr.mr_n73652944)
print v(xbgr.mr_n73653808)
print v(xbgr.mr_n73654672)
print v(xbgr.mr_n73655536)
print v(xbgr.mr_n73656400)
print v(xbgr.mr_n73657264)
print v(xbgr.mr_n73657376)
print v(xbgr.mr_n73657696)
print v(xbgr.mr_n73658560)
print v(xbgr.mr_n73658672)
print v(xbgr.mr_n73658992)
print v(xbgr.mr_n73659104)
print v(xbgr.mr_n73659424)
print v(xbgr.mr_n73660288)
print v(xbgr.mr_n73660720)
print v(xbgr.mr_n73660832)
print v(xbgr.mr_n73661584)
print v(xbgr.mr_n73661696)
print v(xbgr.mr_n73662016)
print v(xbgr.mr_n73662128)
print v(xbgr.mr_n73662448)
print v(xbgr.mr_n73662560)
print v(xbgr.mr_n73662880)
print v(xbgr.mr_n73662992)
print v(xbgr.mr_n73663312)
print v(xbgr.mr_n73663424)
print v(xbgr.mr_n73663744)
print v(xbgr.mr_n73663856)
print v(xbgr.mr_n73664176)
print v(xbgr.mr_n73664288)
print v(xbgr.mr_n73664608)
print v(xbgr.mr_n73664720)
print v(xbgr.mr_n73665040)
print v(xbgr.mr_n73665152)
print v(xbgr.mr_n73665472)
print v(xbgr.mr_n73666016)
print v(xbgr.mr_n73666768)
print v(xbgr.mr_n73667632)
print v(xbgr.mr_n73668496)
print v(xbgr.mr_n73668608)
print v(xbgr.mr_n73669040)
print v(xbgr.mr_n73669360)
print v(xbgr.mr_n73670224)
print v(xbgr.mr_n73671088)
print v(xbgr.mr_n73671952)
print v(xbgr.mr_n73672816)
print v(xbgr.mr_n73673680)
print v(xbgr.mr_n73674544)
print v(xbgr.mr_n73674656)
print v(xbgr.mr_n73674976)
print v(xbgr.mr_n73675088)
print v(xbgr.mr_n73675408)
print v(xbgr.mr_n73676272)
print v(xbgr.mr_n73677136)
print v(xbgr.mr_n73677248)
print v(xbgr.mr_n73677568)
print v(xbgr.mr_n73677680)
print v(xbgr.mr_n73678000)
print v(xbgr.mr_n73678112)
print v(xbgr.mr_n73678432)
print v(xbgr.mr_n73678544)
print v(xbgr.mr_n73678864)
print v(xbgr.mr_n73678976)
print v(xbgr.mr_n73679296)
print v(xbgr.mr_n73679408)
print v(xbgr.mr_n73679728)
print v(xbgr.mr_n73679840)
print v(xbgr.mr_n73680160)
print v(xbgr.mr_n73681024)
print v(xbgr.mr_n73681136)
print v(xbgr.mr_n73681456)
print v(xbgr.mr_n73681568)
print v(xbgr.mr_n73681888)
print v(xbgr.mr_n73682000)
print v(xbgr.mr_n73682320)
print v(xbgr.mr_n73682432)
print v(xbgr.mr_n73682752)
print v(xbgr.mr_n73682864)
print v(xbgr.mr_n73683184)
print v(xbgr.mr_n73683296)
print v(xbgr.mr_n73683616)
print v(xbgr.mr_n73683728)
print v(xbgr.mr_n73684048)
print v(xbgr.mr_n73684160)
print v(xbgr.mr_n73684592)
print v(xbgr.mr_n73685024)
print v(xbgr.mr_n73685456)
print v(xbgr.mr_n73685776)
print v(xbgr.mr_n73685888)
print v(xbgr.mr_n73686208)
print v(xbgr.mr_n73686320)
print v(xbgr.mr_n73686640)
print v(xbgr.mr_n73686752)
print v(xbgr.mr_n73687072)
print v(xbgr.mr_n73687184)
print v(xbgr.mr_n73687504)
print v(xbgr.mr_n73687616)
print v(xbgr.mr_n73687936)
print v(xbgr.mr_n73688048)
print v(xbgr.mr_n73688368)
print v(xbgr.mr_n73688480)
print v(xbgr.mr_n73688800)
print v(xbgr.mr_n73688912)
print v(xbgr.mr_n73689232)
print v(xbgr.mr_n73689344)
print v(xbgr.mr_n73689664)
print v(xbgr.mr_n73689776)
print v(xbgr.mr_n73690096)
print v(xbgr.mr_n73690208)
print v(xbgr.mr_n73690528)
print v(xbgr.mr_n73690640)
print v(xbgr.mr_n73690960)
print v(xbgr.mr_n73691072)
print v(xbgr.mr_n73691392)
print v(xbgr.mr_n73691504)
print v(xbgr.mr_n73691824)
print v(xbgr.mr_n73691936)
print v(xbgr.mr_n73692256)
print v(xbgr.mr_n73692368)
print v(xbgr.mr_n73692800)
print v(xbgr.mr_n73693120)
print v(xbgr.mr_n73693232)
print v(xbgr.mr_n73693664)
print v(xbgr.mr_n73694096)
print v(xbgr.mr_n73694416)
print v(xbgr.mr_n73694528)
print v(xbgr.mr_n73694848)
print v(xbgr.mr_n73694960)
print v(xbgr.mr_n73695280)
print v(xbgr.mr_n73695392)
print v(xbgr.mr_n73695712)
print v(xbgr.mr_n73695824)
print v(xbgr.mr_n73696256)
print v(xbgr.mr_n73696688)
print v(xbgr.mr_n73697120)
print v(xbgr.mr_n73697552)
print v(xbgr.mr_n73697984)
print v(xbgr.mr_n73698416)
print v(xbgr.mr_n73698848)
print v(xbgr.mr_n73699280)
print v(xbgr.mr_n73699600)
print v(xbgr.mr_n73699712)
print v(xbgr.mr_n73700032)
print v(xbgr.mr_n73700144)
print v(xbgr.mr_n73700464)
print v(xbgr.mr_n73700576)
print v(xbgr.mr_n73700896)
print v(xbgr.mr_n73701008)
print v(xbgr.mr_n73701328)
print v(xbgr.mr_n73701440)
print v(xbgr.mr_n73701760)
print v(xbgr.mr_n73701872)
print v(xbgr.mr_n73702192)
print v(xbgr.mr_n73702304)
print v(xbgr.mr_n73702624)
print v(xbgr.mr_n73702736)
print v(xbgr.mr_n73703056)
print v(xbgr.mr_n73703168)
print v(xbgr.mr_n73703488)
print v(xbgr.mr_n73703600)
print v(xbgr.mr_n73703920)
print v(xbgr.mr_n73704032)
print v(xbgr.mr_n73704352)
print v(xbgr.mr_n73704464)
print v(xbgr.mr_n73704784)
print v(xbgr.mr_n73704896)
print v(xbgr.mr_n73705216)
print v(xbgr.mr_n73705328)
print v(xbgr.mr_n73705648)
print v(xbgr.mr_n73705760)
print v(xbgr.mr_n73706080)
print v(xbgr.mr_n73706192)
print v(xbgr.mr_n73706512)
print v(xbgr.mr_n73706624)
print v(xbgr.mr_n73706944)
print v(xbgr.mr_n73707056)
print v(xbgr.mr_n73707376)
print v(xbgr.mr_n73707488)
print v(xbgr.mr_n73707808)
print v(xbgr.mr_n73707920)
print v(xbgr.mr_n73708240)
print v(xbgr.mr_n73708352)
print v(xbgr.mr_n73708672)
print v(xbgr.mr_n73708784)
print v(xbgr.mr_n73709104)
print v(xbgr.mr_n73709216)
print v(xbgr.mr_n73709536)
print v(xbgr.mr_n73709648)
print v(xbgr.mr_n73710080)
print v(xbgr.mr_n73710512)
print v(xbgr.mr_n73710832)
print v(xbgr.mr_n73710944)
print v(xbgr.mr_n73711264)
print v(xbgr.mr_n73711376)
print v(xbgr.mr_n73711808)
print v(xbgr.mr_n73712240)
print v(xbgr.mr_n73712672)
print v(xbgr.mr_n73713104)
print v(xbgr.mr_n73713536)
print v(xbgr.mr_n73713968)
print v(xbgr.mr_n73714400)
print v(xbgr.mr_n73714832)
print v(xbgr.mr_n73715264)
print v(xbgr.mr_n73715696)
print v(xbgr.mr_n73716128)
print v(xbgr.mr_n73716560)
print v(xbgr.mr_n73716992)
print v(xbgr.mr_n73717424)
print v(xbgr.mr_n73717856)
print v(xbgr.mr_n73718288)
print v(xbgr.mr_n73718720)
print v(xbgr.mr_n73719152)
print v(xbgr.mr_n73719584)
print v(xbgr.mr_n73720016)
print v(xbgr.mr_n73720448)
print v(xbgr.mr_n73720880)
print v(xbgr.mr_n73721312)
print v(xbgr.mr_n73721744)
print v(xbgr.mr_n73722064)
print v(xbgr.mr_n73722176)
print v(xbgr.mr_n73722496)
print v(xbgr.mr_n73722608)
print v(xbgr.mr_n73722928)
print v(xbgr.mr_n73723040)
print v(xbgr.mr_n73723360)
print v(xbgr.mr_n73723472)
print v(xbgr.mr_n73723792)
print v(xbgr.mr_n73723904)
print v(xbgr.mr_n73724224)
print v(xbgr.mr_n73724336)
print v(xbgr.mr_n73724656)
print v(xbgr.mr_n73724768)
print v(xbgr.mr_n73725088)
print v(xbgr.mr_n73725200)
print v(xbgr.mr_n73725520)
print v(xbgr.mr_n73725632)
print v(xbgr.mr_n73725952)
print v(xbgr.mr_n73726064)
print v(xbgr.mr_n73726384)
print v(xbgr.mr_n73726496)
print v(xbgr.mr_n73726816)
print v(xbgr.mr_n73726928)
print v(xbgr.mr_n73727248)
print v(xbgr.mr_n73727360)
print v(xbgr.mr_n73727792)
print v(xbgr.mr_n73728224)
print v(xbgr.mr_n73728656)
print v(xbgr.mr_n73729088)
print v(xbgr.mr_n73729520)
print v(xbgr.mr_n73729952)
print v(xbgr.mr_n73730384)
print v(xbgr.mr_n73730816)
print v(xbgr.mr_n73731248)
print v(xbgr.mr_n73731680)
print v(xbgr.mr_n73732112)
print v(xbgr.mr_n73732544)
print v(xbgr.mr_n73732976)
print v(xbgr.mr_n73733296)
print v(xbgr.mr_n73733408)
print v(xbgr.mr_n73733728)
print v(xbgr.mr_n73733840)
print v(xbgr.mr_n73734160)
print v(xbgr.mr_n73734272)
print v(xbgr.mr_n73734592)
print v(xbgr.mr_n73734704)
print v(xbgr.mr_n73735024)
print v(xbgr.mr_n73735136)
print v(xbgr.mr_n73735456)
print v(xbgr.mr_n73735568)
print v(xbgr.mr_n73735888)
print v(xbgr.mr_n73736000)
print v(xbgr.mr_n73736320)
print v(xbgr.mr_n73736432)
print v(xbgr.mr_n73736752)
print v(xbgr.mr_n73736864)
print v(xbgr.mr_n73737184)
print v(xbgr.mr_n73737296)
print v(xbgr.mr_n73737616)
print v(xbgr.mr_n73737728)
print v(xbgr.mr_n73738048)
print v(xbgr.mr_n73738160)
print v(xbgr.mr_n73738480)
print v(xbgr.mr_n73738592)
print v(xbgr.mr_n73739024)
print v(xbgr.mr_n73739456)
print v(xbgr.mr_n73739888)
print v(xbgr.mr_n73740320)
print v(xbgr.mr_n73740752)
print v(xbgr.mr_n73741184)
print v(xbgr.mr_n73741616)
print v(xbgr.mr_n73742048)
print v(xbgr.mr_n73742480)
print v(xbgr.mr_n73742912)
print v(xbgr.mr_n73743344)
print v(xbgr.mr_n73743776)
print v(xbgr.mr_n73744208)
print v(xbgr.mr_n73744528)
print v(xbgr.mr_n73744640)
print v(xbgr.mr_n73744960)
print v(xbgr.mr_n73745072)
print v(xbgr.mr_n73745392)
print v(xbgr.mr_n73745504)
print v(xbgr.mr_n73745824)
print v(xbgr.mr_n73745936)
print v(xbgr.mr_n73746256)
print v(xbgr.mr_n73746368)
print v(xbgr.mr_n73746688)
print v(xbgr.mr_n73746800)
print v(xbgr.mr_n73747120)
print v(xbgr.mr_n73747232)
print v(xbgr.mr_n73747552)
print v(xbgr.mr_n73747664)
print v(xbgr.mr_n73747984)
print v(xbgr.mr_n73748096)
print v(xbgr.mr_n73748416)
print v(xbgr.mr_n73748528)
print v(xbgr.mr_n73748848)
print v(xbgr.mr_n73748960)
print v(xbgr.mr_n73749280)
print v(xbgr.mr_n73749392)
print v(xbgr.mr_n73749712)
print v(xbgr.mr_n73749824)
print v(xbgr.mr_n73750256)
print v(xbgr.mr_n73750688)
print v(xbgr.mr_n73751120)
print v(xbgr.mr_n73751552)
print v(xbgr.mr_n73751984)
print v(xbgr.mr_n73752416)
print v(xbgr.mr_n73752848)
print v(xbgr.mr_n73753280)
print v(xbgr.mr_n73753712)
print v(xbgr.mr_n73754144)
print v(xbgr.mr_n73754576)
print v(xbgr.mr_n73755008)
print v(xbgr.mr_n73755440)
print v(xbgr.mr_n73755760)
print v(xbgr.mr_n73755872)
print v(xbgr.mr_n73756192)
print v(xbgr.mr_n73756304)
print v(xbgr.mr_n73756624)
print v(xbgr.mr_n73756736)
print v(xbgr.mr_n73757056)
print v(xbgr.mr_n73757168)
print v(xbgr.mr_n73757488)
print v(xbgr.mr_n73757600)
print v(xbgr.mr_n73757920)
print v(xbgr.mr_n73758032)
print v(xbgr.mr_n73758352)
print v(xbgr.mr_n73758464)
print v(xbgr.mr_n73758896)
print v(xbgr.mr_n73759328)
print v(xbgr.mr_n73759760)
print v(xbgr.mr_n73760192)
print v(xbgr.mr_n73760512)
print v(xbgr.mr_n73760624)
print v(xbgr.mr_n73760944)
print v(xbgr.mr_n73761056)
print v(xbgr.mr_n73761376)
print v(xbgr.mr_n73761488)
print v(xbgr.mr_n73761808)
print v(xbgr.mr_n73761920)
print v(xbgr.mr_n73762240)
print v(xbgr.mr_n73762352)
print v(xbgr.mr_n73762672)
print v(xbgr.mr_n73762784)
print v(xbgr.mr_n73763216)
print v(xbgr.mr_n73763648)
print v(xbgr.mr_n73764080)
print v(xbgr.mr_n73764512)
print v(xbgr.mr_n73764944)
print v(xbgr.mr_n73765376)
print v(xbgr.mr_n73765808)
print v(xbgr.mr_n73766240)
print v(xbgr.mr_n73766672)
print v(xbgr.mr_n73766992)
print v(xbgr.mr_n73767104)
print v(xbgr.mr_n73767424)
print v(xbgr.mr_n73767536)
print v(xbgr.mr_n73767856)
print v(xbgr.mr_n73767968)
print v(xbgr.mr_n73768288)
print v(xbgr.mr_n73768400)
print v(xbgr.mr_n73768720)
print v(xbgr.mr_n73768832)
print v(xbgr.mr_n73769152)
print v(xbgr.mr_n73769264)
print v(xbgr.mr_n73769584)
print v(xbgr.mr_n73769696)
print v(xbgr.mr_n73770016)
print v(xbgr.mr_n73770128)
print v(xbgr.mr_n73770448)
print v(xbgr.mr_n73770560)
print v(xbgr.mr_n73770880)
print v(xbgr.mr_n73770992)
print v(xbgr.mr_n73771312)
print v(xbgr.mr_n73771424)
print v(xbgr.mr_n73771744)
print v(xbgr.mr_n73771856)
print v(xbgr.mr_n73772176)
print v(xbgr.mr_n73772288)
print v(xbgr.mr_n73772608)
print v(xbgr.mr_n73772720)
print v(xbgr.mr_n73773152)
print v(xbgr.mr_n73773584)
print v(xbgr.mr_n73774016)
print v(xbgr.mr_n73774448)
print v(xbgr.mr_n73774768)
print v(xbgr.mr_n73774880)
print v(xbgr.mr_n73775200)
print v(xbgr.mr_n73775312)
print v(xbgr.mr_n73775744)
print v(xbgr.mr_n73776176)
print v(xbgr.mr_n73776608)
print v(xbgr.mr_n73777040)
print v(xbgr.mr_n73777472)
print v(xbgr.mr_n73777904)
print v(xbgr.mr_n73778336)
print v(xbgr.mr_n73778768)
print v(xbgr.mr_n73779088)
print v(xbgr.mr_n73779200)
print v(xbgr.mr_n73779520)
print v(xbgr.mr_n73779632)
print v(xbgr.mr_n73779952)
print v(xbgr.mr_n73780064)
print v(xbgr.mr_n73780384)
print v(xbgr.mr_n73780496)
print v(xbgr.mr_n73780816)
print v(xbgr.mr_n73780928)
print v(xbgr.mr_n73781248)
print v(xbgr.mr_n73781360)
print v(xbgr.mr_n73781680)
print v(xbgr.mr_n73781792)
print v(xbgr.mr_n73782112)
print v(xbgr.mr_n73782224)
print v(xbgr.mr_n73782544)
print v(xbgr.mr_n73782656)
print v(xbgr.mr_n73782976)
print v(xbgr.mr_n73783088)
print v(xbgr.mr_n73783408)
print v(xbgr.mr_n73783520)
print v(xbgr.mr_n73783840)
print v(xbgr.mr_n73783952)
print v(xbgr.mr_n73784384)
print v(xbgr.mr_n73784816)
print v(xbgr.mr_n73785248)
print v(xbgr.mr_n73785680)
print v(xbgr.mr_n73786112)
print v(xbgr.mr_n73786544)
print v(xbgr.mr_n73786864)
print v(xbgr.mr_n73786976)
print v(xbgr.mr_n73787296)
print v(xbgr.mr_n73787408)
print v(xbgr.mr_n73787728)
print v(xbgr.mr_n73787840)
print v(xbgr.mr_n73788160)
print v(xbgr.mr_n73788272)
print v(xbgr.mr_n73788592)
print v(xbgr.mr_n73788704)
print v(xbgr.mr_n73789024)
print v(xbgr.mr_n73789136)
print v(xbgr.mr_n73789456)
print v(xbgr.mr_n73789568)
print v(xbgr.mr_n73789888)
print v(xbgr.mr_n73790000)
print v(xbgr.mr_n73790320)
print v(xbgr.mr_n73790432)
print v(xbgr.mr_n73790752)
print v(xbgr.mr_n73790864)
print v(xbgr.mr_n73791184)
print v(xbgr.mr_n73791296)
print v(xbgr.mr_n73791616)
print v(xbgr.mr_n73791728)
print v(xbgr.mr_n73792048)
print v(xbgr.mr_n73792160)
print v(xbgr.mr_n73792480)
print v(xbgr.mr_n73792592)
print v(xbgr.mr_n73792912)
print v(xbgr.mr_n73793024)
print v(xbgr.mr_n73793344)
print v(xbgr.mr_n73793456)
print v(xbgr.mr_n73793776)
print v(xbgr.mr_n73793888)
print v(xbgr.mr_n73794208)
print v(xbgr.mr_n73794320)
print v(xbgr.mr_n73794752)
print v(xbgr.mr_n73795184)
print v(xbgr.mr_n73795504)
print v(xbgr.mr_n73795616)
print v(xbgr.mr_n73795936)
print v(xbgr.mr_n73796048)
print v(xbgr.mr_n73796368)
print v(xbgr.mr_n73796480)
print v(xbgr.mr_n73796800)
print v(xbgr.mr_n73796912)
print v(xbgr.mr_n73797344)
print v(xbgr.mr_n73797776)
print v(xbgr.mr_n73798208)
print v(xbgr.mr_n73798640)
print v(xbgr.mr_n73799072)
print v(xbgr.mr_n73799504)
print v(xbgr.mr_n73799936)
print v(xbgr.mr_n73800368)
print v(xbgr.mr_n73800800)
print v(xbgr.mr_n73801232)
print v(xbgr.mr_n73801664)
print v(xbgr.mr_n73802096)
print v(xbgr.mr_n73802528)
print v(xbgr.mr_n73802960)
print v(xbgr.mr_n73803392)
print v(xbgr.mr_n73803824)
print v(xbgr.mr_n73804144)
print v(xbgr.mr_n73804256)
print v(xbgr.mr_n73804576)
print v(xbgr.mr_n73804688)
print v(xbgr.mr_n73805008)
print v(xbgr.mr_n73805120)
print v(xbgr.mr_n73805440)
print v(xbgr.mr_n73805552)
print v(xbgr.mr_n73805872)
print v(xbgr.mr_n73805984)
print v(xbgr.mr_n73806304)
print v(xbgr.mr_n73806416)
print v(xbgr.mr_n73806736)
print v(xbgr.mr_n73806848)
print v(xbgr.mr_n73807168)
print v(xbgr.mr_n73807280)
print v(xbgr.mr_n73807600)
print v(xbgr.mr_n73807712)
print v(xbgr.mr_n73808032)
print v(xbgr.mr_n73808144)
print v(xbgr.mr_n73808576)
print v(xbgr.mr_n73809008)
print v(xbgr.mr_n73809440)
print v(xbgr.mr_n73809872)
print v(xbgr.mr_n73810304)
print v(xbgr.mr_n73810736)
print v(xbgr.mr_n73811168)
print v(xbgr.mr_n73811600)
print v(xbgr.mr_n73811920)
print v(xbgr.mr_n73812032)
print v(xbgr.mr_n73812352)
print v(xbgr.mr_n73812464)
print v(xbgr.mr_n73812784)
print v(xbgr.mr_n73812896)
print v(xbgr.mr_n73813216)
print v(xbgr.mr_n73813328)
print v(xbgr.mr_n73813648)
print v(xbgr.mr_n73813760)
print v(xbgr.mr_n73814080)
print v(xbgr.mr_n73814192)
print v(xbgr.mr_n73814512)
print v(xbgr.mr_n73814624)
print v(xbgr.mr_n73814944)
print v(xbgr.mr_n73815056)
print v(xbgr.mr_n73815376)
print v(xbgr.mr_n73815488)
print v(xbgr.mr_n73815808)
print v(xbgr.mr_n73815920)
print v(xbgr.mr_n73816240)
print v(xbgr.mr_n73816352)
print v(xbgr.mr_n73816672)
print v(xbgr.mr_n73816784)
print v(xbgr.mr_n73817104)
print v(xbgr.mr_n73817216)
print v(xbgr.mr_n73817536)
print v(xbgr.mr_n73817648)
print v(xbgr.mr_n73818080)
print v(xbgr.mr_n73818512)
print v(xbgr.mr_n73818944)
print v(xbgr.mr_n73819376)
print v(xbgr.mr_n73819808)
print v(xbgr.mr_n73820240)
print v(xbgr.mr_n73820672)
print v(xbgr.mr_n73821104)
print v(xbgr.mr_n73821536)
print v(xbgr.mr_n73821968)
print v(xbgr.mr_n73822400)
print v(xbgr.mr_n73822832)
print v(xbgr.mr_n73823264)
print v(xbgr.mr_n73823696)
print v(xbgr.mr_n73824016)
print v(xbgr.mr_n73824128)
print v(xbgr.mr_n73824448)
print v(xbgr.mr_n73824560)
print v(xbgr.mr_n73824880)
print v(xbgr.mr_n73824992)
print v(xbgr.mr_n73825312)
print v(xbgr.mr_n73825424)
print v(xbgr.mr_n73825744)
print v(xbgr.mr_n73825856)
print v(xbgr.mr_n73826176)
print v(xbgr.mr_n73826288)
print v(xbgr.mr_n73826608)
print v(xbgr.mr_n73826720)
print v(xbgr.mr_n73827040)
print v(xbgr.mr_n73827152)
print v(xbgr.mr_n73827472)
print v(xbgr.mr_n73827584)
print v(xbgr.mr_n73827904)
print v(xbgr.mr_n73828016)
print v(xbgr.mr_n73828336)
print v(xbgr.mr_n73828448)
print v(xbgr.mr_n73828768)
print v(xbgr.mr_n73828880)
print v(xbgr.mr_n73829200)
print v(xbgr.mr_n73829312)
print v(xbgr.mr_n73829632)
print v(xbgr.mr_n73829744)
print v(xbgr.mr_n73830064)
print v(xbgr.mr_n73830176)
print v(xbgr.mr_n73830496)
print v(xbgr.mr_n73830608)
print v(xbgr.mr_n73830928)
print v(xbgr.mr_n73831040)
print v(xbgr.mr_n73831360)
print v(xbgr.mr_n73831472)
print v(xbgr.mr_n73831792)
print v(xbgr.mr_n73831904)
print v(xbgr.mr_n73832224)
print v(xbgr.mr_n73832336)
print v(xbgr.mr_n73832656)
print v(xbgr.mr_n73832768)
print v(xbgr.mr_n73833088)
print v(xbgr.mr_n73833200)
print v(xbgr.mr_n73833520)
print v(xbgr.mr_n73833632)
print v(xbgr.mr_n73833952)
print v(xbgr.mr_n73834064)
print v(xbgr.mr_n73834496)
print v(xbgr.mr_n73834928)
print v(xbgr.mr_n73835360)
print v(xbgr.mr_n73835792)
print v(xbgr.mr_n73836224)
print v(xbgr.mr_n73836656)
print v(xbgr.mr_n73837088)
print v(xbgr.mr_n73837520)
print v(xbgr.mr_n73837952)
print v(xbgr.mr_n73838384)
print v(xbgr.mr_n73838816)
print v(xbgr.mr_n73839248)
print v(xbgr.mr_n73839680)
print v(xbgr.mr_n73840112)
print v(xbgr.mr_n73840544)
print v(xbgr.mr_n73840976)
print v(xbgr.mr_n73841296)
print v(xbgr.mr_n73841408)
print v(xbgr.mr_n73841728)
print v(xbgr.mr_n73841840)
print v(xbgr.mr_n73842272)
print v(xbgr.mr_n73842704)
print v(xbgr.mr_n73843136)
print v(xbgr.mr_n73843568)
print v(xbgr.mr_n73844000)
print v(xbgr.mr_n73844432)
print v(xbgr.mr_n73844864)
print v(xbgr.mr_n73845296)
print v(xbgr.mr_n73845728)
print v(xbgr.mr_n73846160)
print v(xbgr.mr_n73846480)
print v(xbgr.mr_n73846592)
print v(xbgr.mr_n73846912)
print v(xbgr.mr_n73847024)
print v(xbgr.mr_n73847344)
print v(xbgr.mr_n73847456)
print v(xbgr.mr_n73847776)
print v(xbgr.mr_n73847888)
print v(xbgr.mr_n73848208)
print v(xbgr.mr_n73848320)
print v(xbgr.mr_n73848640)
print v(xbgr.mr_n73848752)
print v(xbgr.mr_n73849072)
print v(xbgr.mr_n73849184)
print v(xbgr.mr_n73849504)
print v(xbgr.mr_n73849616)
print v(xbgr.mr_n73849936)
print v(xbgr.mr_n73850048)
print v(xbgr.mr_n73850368)
print v(xbgr.mr_n73850480)
print v(xbgr.mr_n73850800)
print v(xbgr.mr_n73850912)
print v(xbgr.mr_n73851232)
print v(xbgr.mr_n73851344)
print v(xbgr.mr_n73851664)
print v(xbgr.mr_n73851776)
print v(xbgr.mr_n73852208)
print v(xbgr.mr_n73852640)
print v(xbgr.mr_n73853072)
print v(xbgr.mr_n73853504)
print v(xbgr.mr_n73853936)
print v(xbgr.mr_n73854368)
print v(xbgr.mr_n73854800)
print v(xbgr.mr_n73855232)
print v(xbgr.mr_n73855664)
print v(xbgr.mr_n73856096)
print v(xbgr.mr_n73856528)
print v(xbgr.mr_n73856960)
print v(xbgr.mr_n73857392)
print v(xbgr.mr_n73857712)
print v(xbgr.mr_n73857824)
print v(xbgr.mr_n73858144)
print v(xbgr.mr_n73858256)
print v(xbgr.mr_n73858576)
print v(xbgr.mr_n73858688)
print v(xbgr.mr_n73859008)
print v(xbgr.mr_n73859120)
print v(xbgr.mr_n73859440)
print v(xbgr.mr_n73859552)
print v(xbgr.mr_n73859872)
print v(xbgr.mr_n73859984)
print v(xbgr.mr_n73860304)
print v(xbgr.mr_n73860416)
print v(xbgr.mr_n73860736)
print v(xbgr.mr_n73860848)
print v(xbgr.mr_n73861168)
print v(xbgr.mr_n73861280)
print v(xbgr.mr_n73861600)
print v(xbgr.mr_n73861712)
print v(xbgr.mr_n73862032)
print v(xbgr.mr_n73862144)
print v(xbgr.mr_n73862464)
print v(xbgr.mr_n73862576)
print v(xbgr.mr_n73862896)
print v(xbgr.mr_n73863008)
print v(xbgr.mr_n73863440)
print v(xbgr.mr_n73863872)
print v(xbgr.mr_n73864304)
print v(xbgr.mr_n73864736)
print v(xbgr.mr_n73865168)
print v(xbgr.mr_n73865600)
print v(xbgr.mr_n73866032)
print v(xbgr.mr_n73866464)
print v(xbgr.mr_n73866896)
print v(xbgr.mr_n73867328)
print v(xbgr.mr_n73867760)
print v(xbgr.mr_n73868192)
print v(xbgr.mr_n73868624)
print v(xbgr.mr_n73868944)
print v(xbgr.mr_n73869056)
print v(xbgr.mr_n73869376)
print v(xbgr.mr_n73869488)
print v(xbgr.mr_n73869808)
print v(xbgr.mr_n73869920)
print v(xbgr.mr_n73870240)
print v(xbgr.mr_n73870352)
print v(xbgr.mr_n73870672)
print v(xbgr.mr_n73870784)
print v(xbgr.mr_n73871104)
print v(xbgr.mr_n73871216)
print v(xbgr.mr_n73871536)
print v(xbgr.mr_n73871648)
print v(xbgr.mr_n73871968)
print v(xbgr.mr_n73872080)
print v(xbgr.mr_n73872400)
print v(xbgr.mr_n73872512)
print v(xbgr.mr_n73872832)
print v(xbgr.mr_n73872944)
print v(xbgr.mr_n73873264)
print v(xbgr.mr_n73873376)
print v(xbgr.mr_n73873696)
print v(xbgr.mr_n73873808)
print v(xbgr.mr_n73874128)
print v(xbgr.mr_n73874240)
print v(xbgr.mr_n73874672)
print v(xbgr.mr_n73875104)
print v(xbgr.mr_n73875536)
print v(xbgr.mr_n73875968)
print v(xbgr.mr_n73876400)
print v(xbgr.mr_n73876832)
print v(xbgr.mr_n73877264)
print v(xbgr.mr_n73877696)
print v(xbgr.mr_n73878128)
print v(xbgr.mr_n73878560)
print v(xbgr.mr_n73878992)
print v(xbgr.mr_n73879424)
print v(xbgr.mr_n73879856)
print v(xbgr.mr_n73880176)
print v(xbgr.mr_n73880288)
print v(xbgr.mr_n73880608)
print v(xbgr.mr_n73880720)
print v(xbgr.mr_n73881040)
print v(xbgr.mr_n73881152)
print v(xbgr.mr_n73881472)
print v(xbgr.mr_n73881584)
print v(xbgr.mr_n73881904)
print v(xbgr.mr_n73882016)
print v(xbgr.mr_n73882336)
print v(xbgr.mr_n73882448)
print v(xbgr.mr_n73882768)
print v(xbgr.mr_n73882880)
print v(xbgr.mr_n73883200)
print v(xbgr.mr_n73883312)
print v(xbgr.mr_n73883632)
print v(xbgr.mr_n73883744)
print v(xbgr.mr_n73884064)
print v(xbgr.mr_n73884176)
print v(xbgr.mr_n73884496)
print v(xbgr.mr_n73884608)
print v(xbgr.mr_n73884928)
print v(xbgr.mr_n73885040)
print v(xbgr.mr_n73885360)
print v(xbgr.mr_n73885472)
print v(xbgr.mr_n73885904)
print v(xbgr.mr_n73886336)
print v(xbgr.mr_n73886768)
print v(xbgr.mr_n73887200)
print v(xbgr.mr_n73887632)
print v(xbgr.mr_n73888064)
print v(xbgr.mr_n73888496)
print v(xbgr.mr_n73888928)
print v(xbgr.mr_n73889360)
print v(xbgr.mr_n73889792)
print v(xbgr.mr_n73890224)
print v(xbgr.mr_n73890656)
print v(xbgr.mr_n73891088)
print v(xbgr.mr_n73891408)
print v(xbgr.mr_n73891520)
print v(xbgr.mr_n73891840)
print v(xbgr.mr_n73891952)
print v(xbgr.mr_n73892272)
print v(xbgr.mr_n73892384)
print v(xbgr.mr_n73892704)
print v(xbgr.mr_n73892816)
print v(xbgr.mr_n73893136)
print v(xbgr.mr_n73893248)
print v(xbgr.mr_n73893680)
print v(xbgr.mr_n73894112)
print v(xbgr.mr_n73894544)
print v(xbgr.mr_n73894976)
print v(xbgr.mr_n73895408)
print v(xbgr.mr_n73895728)
print v(xbgr.mr_n73895840)
print v(xbgr.mr_n73896160)
print v(xbgr.mr_n73896272)
print v(xbgr.mr_n73896592)
print v(xbgr.mr_n73896704)
print v(xbgr.mr_n73897024)
print v(xbgr.mr_n73897136)
print v(xbgr.mr_n73897456)
print v(xbgr.mr_n73897568)
print v(xbgr.mr_n73897888)
print v(xbgr.mr_n73898000)
print v(xbgr.mr_n73898320)
print v(xbgr.mr_n73898432)
print v(xbgr.mr_n73898752)
print v(xbgr.mr_n73898864)
print v(xbgr.mr_n73899296)
print v(xbgr.mr_n73899728)
print v(xbgr.mr_n73900160)
print v(xbgr.mr_n73900592)
print v(xbgr.mr_n73901024)
print v(xbgr.mr_n73901456)
print v(xbgr.mr_n73901888)
print v(xbgr.mr_n73902320)
print v(xbgr.mr_n73902640)
print v(xbgr.mr_n73902752)
print v(xbgr.mr_n73903072)
print v(xbgr.mr_n73903184)
print v(xbgr.mr_n73903504)
print v(xbgr.mr_n73903616)
print v(xbgr.mr_n73903936)
print v(xbgr.mr_n73904048)
print v(xbgr.mr_n73904368)
print v(xbgr.mr_n73904480)
print v(xbgr.mr_n73904800)
print v(xbgr.mr_n73904912)
print v(xbgr.mr_n73905232)
print v(xbgr.mr_n73905344)
print v(xbgr.mr_n73905664)
print v(xbgr.mr_n73905776)
print v(xbgr.mr_n73906208)
print v(xbgr.mr_n73906640)
print v(xbgr.mr_n73907072)
print v(xbgr.mr_n73907504)
print v(xbgr.mr_n73907936)
print v(xbgr.mr_n73908256)
print v(xbgr.mr_n73908368)
print v(xbgr.mr_n73908688)
print v(xbgr.mr_n73908800)
print v(xbgr.mr_n73909120)
print v(xbgr.mr_n73909232)
print v(xbgr.mr_n73909552)
print v(xbgr.mr_n73909664)
print v(xbgr.mr_n73909984)
print v(xbgr.mr_n73910096)
print v(xbgr.mr_n73910528)
print v(xbgr.mr_n73910960)
print v(xbgr.mr_n73911392)
print v(xbgr.mr_n73911824)
print v(xbgr.mr_n73912256)
print v(xbgr.mr_n73912688)
print v(xbgr.mr_n73913120)
print v(xbgr.mr_n73913552)
print v(xbgr.mr_n73913872)
print v(xbgr.mr_n73913984)
print v(xbgr.mr_n73914304)
print v(xbgr.mr_n73914416)
print v(xbgr.mr_n73914736)
print v(xbgr.mr_n73914848)
print v(xbgr.mr_n73915168)
print v(xbgr.mr_n73915280)
print v(xbgr.mr_n73915600)
print v(xbgr.mr_n73915712)
print v(xbgr.mr_n73916032)
print v(xbgr.mr_n73916144)
print v(xbgr.mr_n73916464)
print v(xbgr.mr_n73916576)
print v(xbgr.mr_n73917008)
print v(xbgr.mr_n73917440)
print v(xbgr.mr_n73917872)
print v(xbgr.mr_n73918304)
print v(xbgr.mr_n73918624)
print v(xbgr.mr_n73918736)
print v(xbgr.mr_n73919168)
print v(xbgr.mr_n73919600)
print v(xbgr.mr_n73919920)
print v(xbgr.mr_n73920032)
print v(xbgr.mr_n73920352)
print v(xbgr.mr_n73920464)
print v(xbgr.mr_n73920784)
print v(xbgr.mr_n73920896)
print v(xbgr.mr_n73921216)
print v(xbgr.mr_n73921328)
print v(xbgr.mr_n73921648)
print v(xbgr.mr_n73921760)
print v(xbgr.mr_n73922192)
print v(xbgr.mr_n73922624)
print v(xbgr.mr_n73923056)
print v(xbgr.mr_n73923488)
print v(xbgr.mr_n73923920)
print v(xbgr.mr_n73924352)
print v(xbgr.mr_n73924784)
print v(xbgr.mr_n73925104)
print v(xbgr.mr_n73925216)
print v(xbgr.mr_n73925536)
print v(xbgr.mr_n73925648)
print v(xbgr.mr_n73925968)
print v(xbgr.mr_n73926080)
print v(xbgr.mr_n73926400)
print v(xbgr.mr_n73926512)
print v(xbgr.mr_n73926832)
print v(xbgr.mr_n73926944)
print v(xbgr.mr_n73927264)
print v(xbgr.mr_n73927376)
print v(xbgr.mr_n73927696)
print v(xbgr.mr_n73927808)
print v(xbgr.mr_n73928128)
print v(xbgr.mr_n73928240)
print v(xbgr.mr_n73928560)
print v(xbgr.mr_n73928672)
print v(xbgr.mr_n73928992)
print v(xbgr.mr_n73929104)
print v(xbgr.mr_n73929424)
print v(xbgr.mr_n73929536)
print v(xbgr.mr_n73929856)
print v(xbgr.mr_n73929968)
print v(xbgr.mr_n73930288)
print v(xbgr.mr_n73930400)
print v(xbgr.mr_n73930832)
print v(xbgr.mr_n73931264)
print v(xbgr.mr_n73931696)
print v(xbgr.mr_n73932128)
print v(xbgr.mr_n73932560)
print v(xbgr.mr_n73932992)
print v(xbgr.mr_n73933424)
print v(xbgr.mr_n73933856)
print v(xbgr.mr_n73934288)
print v(xbgr.mr_n73934720)
print v(xbgr.mr_n73935152)
print v(xbgr.mr_n73935584)
print v(xbgr.mr_n73936016)
print v(xbgr.mr_n73936336)
print v(xbgr.mr_n73936448)
print v(xbgr.mr_n73936768)
print v(xbgr.mr_n73936880)
print v(xbgr.mr_n73937200)
print v(xbgr.mr_n73937312)
print v(xbgr.mr_n73937632)
print v(xbgr.mr_n73937744)
print v(xbgr.mr_n73938064)
print v(xbgr.mr_n73938176)
print v(xbgr.mr_n73938496)
print v(xbgr.mr_n73938608)
print v(xbgr.mr_n73938928)
print v(xbgr.mr_n73939040)
print v(xbgr.mr_n73939360)
print v(xbgr.mr_n73939472)
print v(xbgr.mr_n73939792)
print v(xbgr.mr_n73939904)
print v(xbgr.mr_n73940224)
print v(xbgr.mr_n73940336)
print v(xbgr.mr_n73940656)
print v(xbgr.mr_n73940768)
print v(xbgr.mr_n73941088)
print v(xbgr.mr_n73941200)
print v(xbgr.mr_n73941520)
print v(xbgr.mr_n73941632)
print v(xbgr.mr_n73941952)
print v(xbgr.mr_n73942064)
print v(xbgr.mr_n73942384)
print v(xbgr.mr_n73942496)
print v(xbgr.mr_n73942816)
print v(xbgr.mr_n73942928)
print v(xbgr.mr_n73943360)
print v(xbgr.mr_n73943792)
print v(xbgr.mr_n73944224)
print v(xbgr.mr_n73944656)
print v(xbgr.mr_n73945088)
print v(xbgr.mr_n73945520)
print v(xbgr.mr_n73945840)
print v(xbgr.mr_n73945952)
print v(xbgr.mr_n73946272)
print v(xbgr.mr_n73946384)
print v(xbgr.mr_n73946704)
print v(xbgr.mr_n73946816)
print v(xbgr.mr_n73947136)
print v(xbgr.mr_n73947248)
print v(xbgr.mr_n73947568)
print v(xbgr.mr_n73947680)
print v(xbgr.mr_n73948000)
print v(xbgr.mr_n73948112)
print v(xbgr.mr_n73948432)
print v(xbgr.mr_n73948544)
print v(xbgr.mr_n73948864)
print v(xbgr.mr_n73948976)
print v(xbgr.mr_n73949296)
print v(xbgr.mr_n73949408)
print v(xbgr.mr_n73949728)
print v(xbgr.mr_n73949840)
print v(xbgr.mr_n73950272)
print v(xbgr.mr_n73950704)
print v(xbgr.mr_n73951136)
print v(xbgr.mr_n73951568)
print v(xbgr.mr_n73952000)
print v(xbgr.mr_n73952432)
print v(xbgr.mr_n73952864)
print v(xbgr.mr_n73953296)
print v(xbgr.mr_n73953728)
print v(xbgr.mr_n73954160)
print v(xbgr.mr_n73954592)
print v(xbgr.mr_n73955024)
print v(xbgr.mr_n73955456)
print v(xbgr.mr_n73955888)
print v(xbgr.mr_n73956320)
print v(xbgr.mr_n73956752)
print v(xbgr.mr_n73957184)
print v(xbgr.mr_n73957616)
print v(xbgr.mr_n73958048)
print v(xbgr.mr_n73958480)
print v(xbgr.mr_n73958800)
print v(xbgr.mr_n73958912)
print v(xbgr.mr_n73959232)
print v(xbgr.mr_n73959344)
print v(xbgr.mr_n73959664)
print v(xbgr.mr_n73959776)
print v(xbgr.mr_n73960096)
print v(xbgr.mr_n73960208)
print v(xbgr.mr_n73960528)
print v(xbgr.mr_n73960640)
print v(xbgr.mr_n73960960)
print v(xbgr.mr_n73961072)
print v(xbgr.mr_n73961392)
print v(xbgr.mr_n73961504)
print v(xbgr.mr_n73961824)
print v(xbgr.mr_n73961936)
print v(xbgr.mr_n73962256)
print v(xbgr.mr_n73962368)
print v(xbgr.mr_n73962688)
print v(xbgr.mr_n73962800)
print v(xbgr.mr_n73963120)
print v(xbgr.mr_n73963232)
print v(xbgr.mr_n73963552)
print v(xbgr.mr_n73963664)
print v(xbgr.mr_n73963984)
print v(xbgr.mr_n73964096)
print v(xbgr.mr_n73964416)
print v(xbgr.mr_n73964528)
print v(xbgr.mr_n73964960)
print v(xbgr.mr_n73965392)
print v(xbgr.mr_n73965824)
print v(xbgr.mr_n73966256)
print v(xbgr.mr_n73966576)
print v(xbgr.mr_n73966688)
print v(xbgr.mr_n73967008)
print v(xbgr.mr_n73967120)
print v(xbgr.mr_n73967440)
print v(xbgr.mr_n73967552)
print v(xbgr.mr_n73967872)
print v(xbgr.mr_n73967984)
print v(xbgr.mr_n73968304)
print v(xbgr.mr_n73968416)
print v(xbgr.mr_n73968736)
print v(xbgr.mr_n73968848)
print v(xbgr.mr_n73969280)
print v(xbgr.mr_n73969712)
print v(xbgr.mr_n73970144)
print v(xbgr.mr_n73970576)
print v(xbgr.mr_n73971008)
print v(xbgr.mr_n73971440)
print v(xbgr.mr_n73971872)
print v(xbgr.mr_n73972304)
print v(xbgr.mr_n73972736)
print v(xbgr.mr_n73973168)
print v(xbgr.mr_n73973488)
print v(xbgr.mr_n73973600)
print v(xbgr.mr_n73973920)
print v(xbgr.mr_n73974032)
print v(xbgr.mr_n73974464)
print v(xbgr.mr_n73974896)
print v(xbgr.mr_n73975216)
print v(xbgr.mr_n73975328)
print v(xbgr.mr_n73975648)
print v(xbgr.mr_n73975760)
print v(xbgr.mr_n73976080)
print v(xbgr.mr_n73976192)
print v(xbgr.mr_n73976512)
print v(xbgr.mr_n73976624)
print v(xbgr.mr_n73977056)
print v(xbgr.mr_n73977488)
print v(xbgr.mr_n73977920)
print v(xbgr.mr_n73978352)
print v(xbgr.mr_n73978784)
print v(xbgr.mr_n73979216)
print v(xbgr.mr_n73979648)
print v(xbgr.mr_n73980080)
print v(xbgr.mr_n73980512)
print v(xbgr.mr_n73980944)
print v(xbgr.mr_n73981264)
print v(xbgr.mr_n73981376)
print v(xbgr.mr_n73981696)
print v(xbgr.mr_n73981808)
print v(xbgr.mr_n73982128)
print v(xbgr.mr_n73982240)
print v(xbgr.mr_n73982560)
print v(xbgr.mr_n73982672)
print v(xbgr.mr_n73982992)
print v(xbgr.mr_n73983104)
print v(xbgr.mr_n73983424)
print v(xbgr.mr_n73983536)
print v(xbgr.mr_n73983856)
print v(xbgr.mr_n73983968)
print v(xbgr.mr_n73984288)
print v(xbgr.mr_n73984400)
print v(xbgr.mr_n73984720)
print v(xbgr.mr_n73984832)
print v(xbgr.mr_n73985152)
print v(xbgr.mr_n73985264)
print v(xbgr.mr_n73985584)
print v(xbgr.mr_n73985696)
print v(xbgr.mr_n73986016)
print v(xbgr.mr_n73986128)
print v(xbgr.mr_n73986448)
print v(xbgr.mr_n73986560)
print v(xbgr.mr_n73986880)
print v(xbgr.mr_n73986992)
print v(xbgr.mr_n73987312)
print v(xbgr.mr_n73987424)
print v(xbgr.mr_n73987744)
print v(xbgr.mr_n73987856)
print v(xbgr.mr_n73988176)
print v(xbgr.mr_n73988288)
print v(xbgr.mr_n73988608)
print v(xbgr.mr_n73988720)
print v(xbgr.mr_n73989040)
print v(xbgr.mr_n73989152)
print v(xbgr.mr_n73989472)
print v(xbgr.mr_n73989584)
print v(xbgr.mr_n73989904)
print v(xbgr.mr_n73990016)
print v(xbgr.mr_n73990336)
print v(xbgr.mr_n73990768)
print v(xbgr.mr_n73990880)
print v(xbgr.mr_n73991200)
print v(xbgr.mr_n73991632)
print v(xbgr.mr_n73991744)
print v(xbgr.mr_n73992064)
print v(xbgr.mr_n73992496)
print v(xbgr.mr_n73992608)
print v(xbgr.mr_n73992928)
print v(xbgr.mr_n73993360)
print v(xbgr.mr_n73993472)
print v(xbgr.mr_n73993792)
print v(xbgr.mr_n73994224)
print v(xbgr.mr_n73994336)
print v(xbgr.mr_n73994656)
print v(xbgr.mr_n73994768)
print v(xbgr.mr_n73995088)
print v(xbgr.mr_n73995200)
print v(xbgr.mr_n73995520)
print v(xbgr.mr_n73995632)
print v(xbgr.mr_n73995952)
print v(xbgr.mr_n73996064)
print v(xbgr.mr_n73996384)
print v(xbgr.mr_n73996496)
print v(xbgr.mr_n73996816)
print v(xbgr.mr_n73996928)
print v(xbgr.mr_n73997248)
print v(xbgr.mr_n73997360)
print v(xbgr.mr_n73997680)
print v(xbgr.mr_n73997792)
print v(xbgr.mr_n73998112)
print v(xbgr.mr_n73998224)
print v(xbgr.mr_n73998544)
print v(xbgr.mr_n73998656)
print v(xbgr.mr_n73998976)
print v(xbgr.mr_n73999088)
print v(xbgr.mr_n73999408)
print v(xbgr.mr_n73999520)
print v(xbgr.mr_n73999840)
print v(xbgr.mr_n73999952)
print v(xbgr.mr_n74000272)
print v(xbgr.mr_n74000384)
print v(xbgr.mr_n74000704)
print v(xbgr.mr_n74000816)
print v(xbgr.mr_n74001136)
print v(xbgr.mr_n74001248)
print v(xbgr.mr_n74001568)
print v(xbgr.mr_n74001680)
print v(xbgr.mr_n74002000)
print v(xbgr.mr_n74002112)
print v(xbgr.mr_n74002432)
print v(xbgr.mr_n74002544)
print v(xbgr.mr_n74002864)
print v(xbgr.mr_n74002976)
print v(xbgr.mr_n74003296)
print v(xbgr.mr_n74003408)
print v(xbgr.mr_n74003728)
print v(xbgr.mr_n74003840)
print v(xbgr.mr_n74004160)
print v(xbgr.mr_n74004272)
print v(xbgr.mr_n74004592)
print v(xbgr.mr_n74004704)
print v(xbgr.mr_n74005024)
print v(xbgr.mr_n74005136)
print v(xbgr.mr_n74005456)
print v(xbgr.mr_n74005568)
print v(xbgr.mr_n74005888)
print v(xbgr.mr_n74006000)
print v(xbgr.mr_n74006320)
print v(xbgr.mr_n74006432)
print v(xbgr.mr_n74006752)
print v(xbgr.mr_n74006864)
print v(xbgr.mr_n74007184)
print v(xbgr.mr_n74007296)
print v(xbgr.mr_n74007616)
print v(xbgr.mr_n74007728)
print v(xbgr.mr_n74008048)
print v(xbgr.mr_n74008160)
print v(xbgr.mr_n74008480)
print v(xbgr.mr_n74008592)
print v(xbgr.mr_n74008912)
print v(xbgr.mr_n74009024)
print v(xbgr.mr_n74009344)
print v(xbgr.mr_n74009456)
print v(xbgr.mr_n74009776)
print v(xbgr.mr_n74009888)
print v(xbgr.mr_n74010208)
print v(xbgr.mr_n74010320)
print v(xbgr.mr_n74010640)
print v(xbgr.mr_n74010752)
print v(xbgr.mr_n74011072)
print v(xbgr.mr_n74011184)
print v(xbgr.mr_n74011504)
print v(xbgr.mr_n74011616)
print v(xbgr.mr_n74011936)
print v(xbgr.mr_n74012048)
print v(xbgr.mr_n74012368)
print v(xbgr.mr_n74012480)
print v(xbgr.mr_n74012800)
print v(xbgr.mr_n74012912)
print v(xbgr.mr_n74013232)
print v(xbgr.mr_n74013344)
print v(xbgr.mr_n74013664)
print v(xbgr.mr_n74013776)
print v(xbgr.mr_n74014096)
print v(xbgr.mr_n74014208)
print v(xbgr.mr_n74014528)
print v(xbgr.mr_n74014640)
print v(xbgr.mr_n74014960)
print v(xbgr.mr_n74015072)
print v(xbgr.mr_n74015392)
print v(xbgr.mr_n74015504)
print v(xbgr.mr_n74015824)
print v(xbgr.mr_n74015936)
print v(xbgr.mr_n74016256)
print v(xbgr.mr_n74016368)
print v(xbgr.mr_n74016688)
print v(xbgr.mr_n74016800)
print v(xbgr.mr_n74017120)
print v(xbgr.mr_n74017232)
print v(xbgr.mr_n74017552)
print v(xbgr.mr_n74017664)
print v(xbgr.mr_n74017984)
print v(xbgr.mr_n74018096)
print v(xbgr.mr_n74018416)
print v(xbgr.mr_n74018528)
print v(xbgr.mr_n74018848)
print v(xbgr.mr_n74018960)
print v(xbgr.mr_n74019280)
print v(xbgr.mr_n74019392)
print v(xbgr.mr_n74019712)
print v(xbgr.mr_n74019824)
print v(xbgr.mr_n74020144)
print v(xbgr.mr_n74020256)
print v(xbgr.mr_n74020576)
print v(xbgr.mr_n74020688)
print v(xbgr.mr_n74021008)
print v(xbgr.mr_n74021120)
print v(xbgr.mr_n74021440)
print v(xbgr.mr_n74021552)
print v(xbgr.mr_n74021872)
print v(xbgr.mr_n74021984)
print v(xbgr.mr_n74022304)
print v(xbgr.mr_n74022416)
print v(xbgr.mr_n74022736)
print v(xbgr.mr_n74022848)
print v(xbgr.mr_n74023168)
print v(xbgr.mr_n74023280)
print v(xbgr.mr_n74023600)
print v(xbgr.mr_n74023712)
print v(xbgr.mr_n74024032)
print v(xbgr.mr_n74024144)
print v(xbgr.mr_n74024464)
print v(xbgr.mr_n74024576)
print v(xbgr.mr_n74024896)
print v(xbgr.mr_n74025008)
print v(xbgr.mr_n74025328)
print v(xbgr.mr_n74025760)
print v(xbgr.mr_n74025872)
print v(xbgr.mr_n74026192)
print v(xbgr.mr_n74026624)
print v(xbgr.mr_n74026736)
print v(xbgr.mr_n74027056)
print v(xbgr.mr_n74027488)
print v(xbgr.mr_n74027600)
print v(xbgr.mr_n74027920)
print v(xbgr.mr_n74028352)
print v(xbgr.mr_n74028464)
print v(xbgr.mr_n74028784)
print v(xbgr.mr_n74028896)
print v(xbgr.mr_n74029216)
print v(xbgr.mr_n74029328)
print v(xbgr.mr_n74029648)
print v(xbgr.mr_n74029760)
print v(xbgr.mr_n74030080)
print v(xbgr.mr_n74030512)
print v(xbgr.mr_n74030624)
print v(xbgr.mr_n74030944)
print v(xbgr.mr_n74031376)
print v(xbgr.mr_n74031488)
print v(xbgr.mr_n74031808)
print v(xbgr.mr_n74032240)
print v(xbgr.mr_n74032352)
print v(xbgr.mr_n74032672)
print v(xbgr.mr_n74033104)
print v(xbgr.mr_n74033216)
print v(xbgr.mr_n74033536)
print v(xbgr.mr_n74033648)
print v(xbgr.mr_n74033968)
print v(xbgr.mr_n74034080)
print v(xbgr.mr_n74034400)
print v(xbgr.mr_n74034512)
print v(xbgr.mr_n74034832)
print v(xbgr.mr_n74034944)
print v(xbgr.mr_n74035264)
print v(xbgr.mr_n74035376)
print v(xbgr.mr_n74035696)
print v(xbgr.mr_n74035808)
print v(xbgr.mr_n74036128)
print v(xbgr.mr_n74036240)
print v(xbgr.mr_n74036560)
print v(xbgr.mr_n74036672)
print v(xbgr.mr_n74036992)
print v(xbgr.mr_n74037104)
print v(xbgr.mr_n74037424)
print v(xbgr.mr_n74037536)
print v(xbgr.mr_n74037856)
print v(xbgr.mr_n74037968)
print v(xbgr.mr_n74038288)
print v(xbgr.mr_n74038400)
print v(xbgr.mr_n74038720)
print v(xbgr.mr_n74038832)
print v(xbgr.mr_n74039152)
print v(xbgr.mr_n74039264)
print v(xbgr.mr_n74039584)
print v(xbgr.mr_n74039696)
print v(xbgr.mr_n74040016)
print v(xbgr.mr_n74040128)
print v(xbgr.mr_n74040448)
print v(xbgr.mr_n74040560)
print v(xbgr.mr_n74040880)
print v(xbgr.mr_n74040992)
print v(xbgr.mr_n74041312)
print v(xbgr.mr_n74041424)
print v(xbgr.mr_n74041744)
print v(xbgr.mr_n74041856)
print v(xbgr.mr_n74042176)
print v(xbgr.mr_n74042288)
print v(xbgr.mr_n74042608)
print v(xbgr.mr_n74042720)
print v(xbgr.mr_n74043040)
print v(xbgr.mr_n74043152)
print v(xbgr.mr_n74043472)
print v(xbgr.mr_n74043584)
print v(xbgr.mr_n74043904)
print v(xbgr.mr_n74044016)
print v(xbgr.mr_n74044336)
print v(xbgr.mr_n74044448)
print v(xbgr.mr_n74044768)
print v(xbgr.mr_n74044880)
print v(xbgr.mr_n74045312)
print v(xbgr.mr_n74045744)
print v(xbgr.mr_n74046176)
print v(xbgr.mr_n74046608)
print v(xbgr.mr_n74047040)
print v(xbgr.mr_n74047472)
print v(xbgr.mr_n74047904)
print v(xbgr.mr_n74048336)
print v(xbgr.mr_n74048768)
print v(xbgr.mr_n74049200)
print v(xbgr.mr_n74049632)
print v(xbgr.mr_n74050064)
print v(xbgr.mr_n74050496)
print v(xbgr.mr_n74050928)
print v(xbgr.mr_n74051360)
print v(xbgr.mr_n74051792)
print v(xbgr.mr_n74052224)
print v(xbgr.mr_n74052656)
print v(xbgr.mr_n74053088)
print v(xbgr.mr_n74053520)
print v(xbgr.mr_n74053952)
print v(xbgr.mr_n74054384)
print v(xbgr.mr_n74054816)
print v(xbgr.mr_n74055248)
print v(xbgr.mr_n74055680)
print v(xbgr.mr_n74056112)
print v(xbgr.mr_n74056432)
print v(xbgr.mr_n74056544)
print v(xbgr.mr_n74056864)
print v(xbgr.mr_n74056976)
print v(xbgr.mr_n74057296)
print v(xbgr.mr_n74057408)
print v(xbgr.mr_n74057728)
print v(xbgr.mr_n74057840)
print v(xbgr.mr_n74058160)
print v(xbgr.mr_n74058272)
print v(xbgr.mr_n74058592)
print v(xbgr.mr_n74058704)
print v(xbgr.mr_n74059024)
print v(xbgr.mr_n74059136)
print v(xbgr.mr_n74059456)
print v(xbgr.mr_n74059568)
print v(xbgr.mr_n74059888)
print v(xbgr.mr_n74060000)
print v(xbgr.mr_n74060320)
print v(xbgr.mr_n74060432)
print v(xbgr.mr_n74060752)
print v(xbgr.mr_n74060864)
print v(xbgr.mr_n74061184)
print v(xbgr.mr_n74061296)
print v(xbgr.mr_n74061616)
print v(xbgr.mr_n74061728)
print v(xbgr.mr_n74062048)
print v(xbgr.mr_n74062160)
print v(xbgr.mr_n74062480)
print v(xbgr.mr_n74062592)
print v(xbgr.mr_n74062912)
print v(xbgr.mr_n74063024)
print v(xbgr.mr_n74063344)
print v(xbgr.mr_n74063456)
print v(xbgr.mr_n74063776)
print v(xbgr.mr_n74063888)
print v(xbgr.mr_n74064208)
print v(xbgr.mr_n74064320)
print v(xbgr.mr_n74064640)
print v(xbgr.mr_n74064752)
print v(xbgr.mr_n74065184)
print v(xbgr.mr_n74065616)
print v(xbgr.mr_n74066048)
print v(xbgr.mr_n74066480)
print v(xbgr.mr_n74066912)
print v(xbgr.mr_n74067344)
print v(xbgr.mr_n74067776)
print v(xbgr.mr_n74068208)
print v(xbgr.mr_n74068640)
print v(xbgr.mr_n74069072)
print v(xbgr.mr_n74069504)
print v(xbgr.mr_n74069936)
print v(xbgr.mr_n74070256)
print v(xbgr.mr_n74070368)
print v(xbgr.mr_n74070688)
print v(xbgr.mr_n74070800)
print v(xbgr.mr_n74071232)
print v(xbgr.mr_n74071664)
print v(xbgr.mr_n74072096)
print v(xbgr.mr_n74072528)
print v(xbgr.mr_n74072960)
print v(xbgr.mr_n74073392)
print v(xbgr.mr_n74073824)
print v(xbgr.mr_n74074256)
print v(xbgr.mr_n74074688)
print v(xbgr.mr_n74075120)
print v(xbgr.mr_n74075440)
print v(xbgr.mr_n74075552)
print v(xbgr.mr_n74075872)
print v(xbgr.mr_n74075984)
print v(xbgr.mr_n74076304)
print v(xbgr.mr_n74076416)
print v(xbgr.mr_n74076736)
print v(xbgr.mr_n74076848)
print v(xbgr.mr_n74077168)
print v(xbgr.mr_n74077280)
print v(xbgr.mr_n74077600)
print v(xbgr.mr_n74077712)
print v(xbgr.mr_n74078032)
print v(xbgr.mr_n74078144)
print v(xbgr.mr_n74078464)
print v(xbgr.mr_n74078576)
print v(xbgr.mr_n74078896)
print v(xbgr.mr_n74079008)
print v(xbgr.mr_n74079328)
print v(xbgr.mr_n74079440)
print v(xbgr.mr_n74079760)
print v(xbgr.mr_n74079872)
print v(xbgr.mr_n74080192)
print v(xbgr.mr_n74080304)
print v(xbgr.mr_n74080624)
print v(xbgr.mr_n74080736)
print v(xbgr.mr_n74081056)
print v(xbgr.mr_n74081168)
print v(xbgr.mr_n74081488)
print v(xbgr.mr_n74081600)
print v(xbgr.mr_n74081920)
print v(xbgr.mr_n74082032)
print v(xbgr.mr_n74082352)
print v(xbgr.mr_n74082464)
print v(xbgr.mr_n74082784)
print v(xbgr.mr_n74082896)
print v(xbgr.mr_n74083216)
print v(xbgr.mr_n74083328)
print v(xbgr.mr_n74083648)
print v(xbgr.mr_n74083760)
print v(xbgr.mr_n74084080)
print v(xbgr.mr_n74084192)
print v(xbgr.mr_n74084512)
print v(xbgr.mr_n74084624)
print v(xbgr.mr_n74084944)
print v(xbgr.mr_n74085056)
print v(xbgr.mr_n74085376)
print v(xbgr.mr_n74085488)
print v(xbgr.mr_n74085808)
print v(xbgr.mr_n74085920)
print v(xbgr.mr_n74086240)
print v(xbgr.mr_n74086352)
print v(xbgr.mr_n74086672)
print v(xbgr.mr_n74087104)
print v(xbgr.mr_n74087216)
print v(xbgr.mr_n74087536)
print v(xbgr.mr_n74087968)
print v(xbgr.mr_n74088080)
print v(xbgr.mr_n74088400)
print v(xbgr.mr_n74088832)
print v(xbgr.mr_n74088944)
print v(xbgr.mr_n74089264)
print v(xbgr.mr_n74089696)
print v(xbgr.mr_n74089808)
print v(xbgr.mr_n74090128)
print v(xbgr.mr_n74090560)
print v(xbgr.mr_n74090672)
print v(xbgr.mr_n74090992)
print v(xbgr.mr_n74091104)
print v(xbgr.mr_n74091424)
print v(xbgr.mr_n74091536)
print v(xbgr.mr_n74091856)
print v(xbgr.mr_n74091968)
print v(xbgr.mr_n74092288)
print v(xbgr.mr_n74092400)
print v(xbgr.mr_n74092720)
print v(xbgr.mr_n74092832)
print v(xbgr.mr_n74093152)
print v(xbgr.mr_n74093264)
print v(xbgr.mr_n74093584)
print v(xbgr.mr_n74093696)
print v(xbgr.mr_n74094016)
print v(xbgr.mr_n74094128)
print v(xbgr.mr_n74094448)
print v(xbgr.mr_n74094560)
print v(xbgr.mr_n74094880)
print v(xbgr.mr_n74094992)
print v(xbgr.mr_n74095312)
print v(xbgr.mr_n74095424)
print v(xbgr.mr_n74095744)
print v(xbgr.mr_n74095856)
print v(xbgr.mr_n74096176)
print v(xbgr.mr_n74096288)
print v(xbgr.mr_n74096608)
print v(xbgr.mr_n74096720)
print v(xbgr.mr_n74097040)
print v(xbgr.mr_n74097152)
print v(xbgr.mr_n74097472)
print v(xbgr.mr_n74097584)
print v(xbgr.mr_n74097904)
print v(xbgr.mr_n74098016)
print v(xbgr.mr_n74098336)
print v(xbgr.mr_n74098448)
print v(xbgr.mr_n74098768)
print v(xbgr.mr_n74098880)
print v(xbgr.mr_n74099200)
print v(xbgr.mr_n74099312)
print v(xbgr.mr_n74099632)
print v(xbgr.mr_n74099744)
print v(xbgr.mr_n74100064)
print v(xbgr.mr_n74100176)
print v(xbgr.mr_n74100496)
print v(xbgr.mr_n74100608)
print v(xbgr.mr_n74100928)
print v(xbgr.mr_n74101040)
print v(xbgr.mr_n74101360)
print v(xbgr.mr_n74101472)
print v(xbgr.mr_n74101792)
print v(xbgr.mr_n74101904)
print v(xbgr.mr_n74102224)
print v(xbgr.mr_n74102336)
print v(xbgr.mr_n74102656)
print v(xbgr.mr_n74102768)
print v(xbgr.mr_n74103088)
print v(xbgr.mr_n74103200)
print v(xbgr.mr_n74103520)
print v(xbgr.mr_n74103632)
print v(xbgr.mr_n74103952)
print v(xbgr.mr_n74104064)
print v(xbgr.mr_n74104384)
print v(xbgr.mr_n74104496)
print v(xbgr.mr_n74104816)
print v(xbgr.mr_n74104928)
print v(xbgr.mr_n74105248)
print v(xbgr.mr_n74105360)
print v(xbgr.mr_n74105680)
print v(xbgr.mr_n74105792)
print v(xbgr.mr_n74106112)
print v(xbgr.mr_n74106224)
print v(xbgr.mr_n74106544)
print v(xbgr.mr_n74106656)
print v(xbgr.mr_n74106976)
print v(xbgr.mr_n74107088)
print v(xbgr.mr_n74107408)
print v(xbgr.mr_n74107520)
print v(xbgr.mr_n74107840)
print v(xbgr.mr_n74107952)
print v(xbgr.mr_n74108272)
print v(xbgr.mr_n74108384)
print v(xbgr.mr_n74108704)
print v(xbgr.mr_n74108816)
print v(xbgr.mr_n74109136)
print v(xbgr.mr_n74109568)
print v(xbgr.mr_n74109680)
print v(xbgr.mr_n74110000)
print v(xbgr.mr_n74110112)
print v(xbgr.mr_n74110432)
print v(xbgr.mr_n74110544)
print v(xbgr.mr_n74110864)
print v(xbgr.mr_n74111296)
print v(xbgr.mr_n74111408)
print v(xbgr.mr_n74111728)
print v(xbgr.mr_n74112160)
print v(xbgr.mr_n74112272)
print v(xbgr.mr_n74112592)
print v(xbgr.mr_n74112704)
print v(xbgr.mr_n74113024)
print v(xbgr.mr_n74113136)
print v(xbgr.mr_n74113456)
print v(xbgr.mr_n74113568)
print v(xbgr.mr_n74113888)
print v(xbgr.mr_n74114000)
print v(xbgr.mr_n74114320)
print v(xbgr.mr_n74114432)
print v(xbgr.mr_n74114752)
print v(xbgr.mr_n74114864)
print v(xbgr.mr_n74115184)
print v(xbgr.mr_n74115296)
print v(xbgr.mr_n74115616)
print v(xbgr.mr_n74115728)
print v(xbgr.mr_n74116048)
print v(xbgr.mr_n74116160)
print v(xbgr.mr_n74116480)
print v(xbgr.mr_n74116592)
print v(xbgr.mr_n74116912)
print v(xbgr.mr_n74117024)
print v(xbgr.mr_n74117344)
print v(xbgr.mr_n74117456)
print v(xbgr.mr_n74117776)
print v(xbgr.mr_n74118208)
print v(xbgr.mr_n74118320)
print v(xbgr.mr_n74118640)
print v(xbgr.mr_n74118752)
print v(xbgr.mr_n74119072)
print v(xbgr.mr_n74119184)
print v(xbgr.mr_n74119504)
print v(xbgr.mr_n74119616)
print v(xbgr.mr_n74119936)
print v(xbgr.mr_n74120048)
print v(xbgr.mr_n74120368)
print v(xbgr.mr_n74120480)
print v(xbgr.mr_n74120800)
print v(xbgr.mr_n74120912)
print v(xbgr.mr_n74121232)
print v(xbgr.mr_n74121344)
print v(xbgr.mr_n74121664)
print v(xbgr.mr_n74121776)
print v(xbgr.mr_n74122096)
print v(xbgr.mr_n74122208)
print v(xbgr.mr_n74122528)
print v(xbgr.mr_n74122640)
print v(xbgr.mr_n74122960)
print v(xbgr.mr_n74123072)
print v(xbgr.mr_n74123392)
print v(xbgr.mr_n74123504)
print v(xbgr.mr_n74123824)
print v(xbgr.mr_n74123936)
print v(xbgr.mr_n74124256)
print v(xbgr.mr_n74124368)
print v(xbgr.mr_n74124688)
print v(xbgr.mr_n74124800)
print v(xbgr.mr_n74125120)
print v(xbgr.mr_n74125232)
print v(xbgr.mr_n74125552)
print v(xbgr.mr_n74125664)
print v(xbgr.mr_n74125984)
print v(xbgr.mr_n74126096)
print v(xbgr.mr_n74126416)
print v(xbgr.mr_n74126528)
print v(xbgr.mr_n74126848)
print v(xbgr.mr_n74126960)
print v(xbgr.mr_n74127280)
print v(xbgr.mr_n74127392)
print v(xbgr.mr_n74127712)
print v(xbgr.mr_n74127824)
print v(xbgr.mr_n74128144)
print v(xbgr.mr_n74128256)
print v(xbgr.mr_n74128576)
print v(xbgr.mr_n74128688)
print v(xbgr.mr_n74129008)
print v(xbgr.mr_n74129120)
print v(xbgr.mr_n74129440)
print v(xbgr.mr_n74129552)
print v(xbgr.mr_n74129872)
print v(xbgr.mr_n74129984)
print v(xbgr.mr_n74130304)
print v(xbgr.mr_n74130416)
print v(xbgr.mr_n74130736)
print v(xbgr.mr_n74130848)
print v(xbgr.mr_n74131168)
print v(xbgr.mr_n74131280)
print v(xbgr.mr_n74131600)
print v(xbgr.mr_n74131712)
print v(xbgr.mr_n74132032)
print v(xbgr.mr_n74132144)
print v(xbgr.mr_n74132464)
print v(xbgr.mr_n74132576)
print v(xbgr.mr_n74132896)
print v(xbgr.mr_n74133008)
print v(xbgr.mr_n74133328)
print v(xbgr.mr_n74133440)
print v(xbgr.mr_n74133760)
print v(xbgr.mr_n74133872)
print v(xbgr.mr_n74134192)
print v(xbgr.mr_n74134304)
print v(xbgr.mr_n74134624)
print v(xbgr.mr_n74134736)
print v(xbgr.mr_n74135056)
print v(xbgr.mr_n74135168)
print v(xbgr.mr_n74135488)
print v(xbgr.mr_n74135600)
print v(xbgr.mr_n74135920)
print v(xbgr.mr_n74136032)
print v(xbgr.mr_n74136352)
print v(xbgr.mr_n74136464)
print v(xbgr.mr_n74136784)
print v(xbgr.mr_n74136896)
print v(xbgr.mr_n74137216)
print v(xbgr.mr_n74137328)
print v(xbgr.mr_n74137648)
print v(xbgr.mr_n74137760)
print v(xbgr.mr_n74138080)
print v(xbgr.mr_n74138192)
print v(xbgr.mr_n74138512)
print v(xbgr.mr_n74138624)
print v(xbgr.mr_n74138944)
print v(xbgr.mr_n74139056)
print v(xbgr.mr_n74139376)
print v(xbgr.mr_n74139488)
print v(xbgr.mr_n74139920)
print v(xbgr.mr_n74140352)
print v(xbgr.mr_n74140784)
print v(xbgr.mr_n74141216)
print v(xbgr.mr_n74141648)
print v(xbgr.mr_n74142080)
print v(xbgr.mr_n74142512)
print v(xbgr.mr_n74142944)
print v(xbgr.mr_n74143264)
print v(xbgr.mr_n74143376)
print v(xbgr.mr_n74143696)
print v(xbgr.mr_n74143808)
print v(xbgr.mr_n74144128)
print v(xbgr.mr_n74144240)
print v(xbgr.mr_n74144560)
print v(xbgr.mr_n74144672)
print v(xbgr.mr_n74144992)
print v(xbgr.mr_n74145104)
print v(xbgr.mr_n74145424)
print v(xbgr.mr_n74145536)
print v(xbgr.mr_n74145856)
print v(xbgr.mr_n74145968)
print v(xbgr.mr_n74146288)
print v(xbgr.mr_n74146400)
print v(xbgr.mr_n74146832)
print v(xbgr.mr_n74147264)
print v(xbgr.mr_n74147696)
print v(xbgr.mr_n74148128)
print v(xbgr.mr_n74148560)
print v(xbgr.mr_n74148992)
print v(xbgr.mr_n74149312)
print v(xbgr.mr_n74149424)
print v(xbgr.mr_n74149856)
print v(xbgr.mr_n74150288)
print v(xbgr.mr_n74150720)
print v(xbgr.mr_n74151152)
print v(xbgr.mr_n74151584)
print v(xbgr.mr_n74152016)
print v(xbgr.mr_n74152448)
print v(xbgr.mr_n74152880)
print v(xbgr.mr_n74153312)
print v(xbgr.mr_n74153744)
print v(xbgr.mr_n74154176)
print v(xbgr.mr_n74154608)
print v(xbgr.mr_n74154928)
print v(xbgr.mr_n74155040)
print v(xbgr.mr_n74155360)
print v(xbgr.mr_n74155472)
print v(xbgr.mr_n74155792)
print v(xbgr.mr_n74155904)
print v(xbgr.mr_n74156224)
print v(xbgr.mr_n74156336)
print v(xbgr.mr_n74156656)
print v(xbgr.mr_n74156768)
print v(xbgr.mr_n74157088)
print v(xbgr.mr_n74157200)
print v(xbgr.mr_n74157520)
print v(xbgr.mr_n74157632)
print v(xbgr.mr_n74157952)
print v(xbgr.mr_n74158064)
print v(xbgr.mr_n74158384)
print v(xbgr.mr_n74158496)
print v(xbgr.mr_n74158816)
print v(xbgr.mr_n74158928)
print v(xbgr.mr_n74159248)
print v(xbgr.mr_n74159360)
print v(xbgr.mr_n74159680)
print v(xbgr.mr_n74159792)
print v(xbgr.mr_n74160112)
print v(xbgr.mr_n74160224)
print v(xbgr.mr_n74160544)
print v(xbgr.mr_n74160656)
print v(xbgr.mr_n74160976)
print v(xbgr.mr_n74161088)
print v(xbgr.mr_n74161408)
print v(xbgr.mr_n74161520)
print v(xbgr.mr_n74161840)
print v(xbgr.mr_n74161952)
print v(xbgr.mr_n74162272)
print v(xbgr.mr_n74162384)
print v(xbgr.mr_n74162704)
print v(xbgr.mr_n74162816)
print v(xbgr.mr_n74163136)
print v(xbgr.mr_n74163248)
print v(xbgr.mr_n74163568)
print v(xbgr.mr_n74163680)
print v(xbgr.mr_n74164112)
print v(xbgr.mr_n74164544)
print v(xbgr.mr_n74164976)
print v(xbgr.mr_n74165408)
print v(xbgr.mr_n74165840)
print v(xbgr.mr_n74166272)
print v(xbgr.mr_n74166704)
print v(xbgr.mr_n74167136)
print v(xbgr.mr_n74167568)
print v(xbgr.mr_n74168000)
print v(xbgr.mr_n74168432)
print v(xbgr.mr_n74168864)
print v(xbgr.mr_n74169296)
print v(xbgr.mr_n74169728)
print v(xbgr.mr_n74170160)
print v(xbgr.mr_n74170592)
print v(xbgr.mr_n74171024)
print v(xbgr.mr_n74171456)
print v(xbgr.mr_n74171888)
print v(xbgr.mr_n74172208)
print v(xbgr.mr_n74172320)
print v(xbgr.mr_n74172640)
print v(xbgr.mr_n74172752)
print v(xbgr.mr_n74173072)
print v(xbgr.mr_n74173184)
print v(xbgr.mr_n74173504)
print v(xbgr.mr_n74173616)
print v(xbgr.mr_n74173936)
print v(xbgr.mr_n74174048)
print v(xbgr.mr_n74174480)
print v(xbgr.mr_n74174912)
print v(xbgr.mr_n74175344)
print v(xbgr.mr_n74175776)
print v(xbgr.mr_n74176208)
print v(xbgr.mr_n74176640)
print v(xbgr.mr_n74177072)
print v(xbgr.mr_n74177392)
print v(xbgr.mr_n74177504)
print v(xbgr.mr_n74177824)
print v(xbgr.mr_n74177936)
print v(xbgr.mr_n74178256)
print v(xbgr.mr_n74178368)
print v(xbgr.mr_n74178688)
print v(xbgr.mr_n74178800)
print v(xbgr.mr_n74179120)
print v(xbgr.mr_n74179232)
print v(xbgr.mr_n74179552)
print v(xbgr.mr_n74179664)
print v(xbgr.mr_n74179984)
print v(xbgr.mr_n74180096)
print v(xbgr.mr_n74180416)
print v(xbgr.mr_n74180528)
print v(xbgr.mr_n74180848)
print v(xbgr.mr_n74180960)
print v(xbgr.mr_n74181280)
print v(xbgr.mr_n74181392)
print v(xbgr.mr_n74181712)
print v(xbgr.mr_n74181824)
print v(xbgr.mr_n74182144)
print v(xbgr.mr_n74182256)
print v(xbgr.mr_n74182576)
print v(xbgr.mr_n74182688)
print v(xbgr.mr_n74183120)
print v(xbgr.mr_n74183552)
print v(xbgr.mr_n74183984)
print v(xbgr.mr_n74184416)
print v(xbgr.mr_n74184848)
print v(xbgr.mr_n74185280)
print v(xbgr.mr_n74185712)
print v(xbgr.mr_n74186144)
print v(xbgr.mr_n74186576)
print v(xbgr.mr_n74187008)
print v(xbgr.mr_n74187440)
print v(xbgr.mr_n74187872)
print v(xbgr.mr_n74188304)
print v(xbgr.mr_n74188624)
print v(xbgr.mr_n74188736)
print v(xbgr.mr_n74189056)
print v(xbgr.mr_n74189168)
print v(xbgr.mr_n74189488)
print v(xbgr.mr_n74189600)
print v(xbgr.mr_n74189920)
print v(xbgr.mr_n74190032)
print v(xbgr.mr_n74190352)
print v(xbgr.mr_n74190464)
print v(xbgr.mr_n74190784)
print v(xbgr.mr_n74190896)
print v(xbgr.mr_n74191216)
print v(xbgr.mr_n74191328)
print v(xbgr.mr_n74191648)
print v(xbgr.mr_n74191760)
print v(xbgr.mr_n74192080)
print v(xbgr.mr_n74192192)
print v(xbgr.mr_n74192512)
print v(xbgr.mr_n74192624)
print v(xbgr.mr_n74192944)
print v(xbgr.mr_n74193056)
print v(xbgr.mr_n74193376)
print v(xbgr.mr_n74193488)
print v(xbgr.mr_n74193920)
print v(xbgr.mr_n74194352)
print v(xbgr.mr_n74194784)
print v(xbgr.mr_n74195216)
print v(xbgr.mr_n74195648)
print v(xbgr.mr_n74196080)
print v(xbgr.mr_n74196512)
print v(xbgr.mr_n74196944)
print v(xbgr.mr_n74197376)
print v(xbgr.mr_n74197808)
print v(xbgr.mr_n74198240)
print v(xbgr.mr_n74198672)
print v(xbgr.mr_n74198992)
print v(xbgr.mr_n74199104)
print v(xbgr.mr_n74199536)
print v(xbgr.mr_n74199856)
print v(xbgr.mr_n74199968)
print v(xbgr.mr_n74200288)
print v(xbgr.mr_n74200400)
print v(xbgr.mr_n74200720)
print v(xbgr.mr_n74200832)
print v(xbgr.mr_n74201152)
print v(xbgr.mr_n74201264)
print v(xbgr.mr_n74201584)
print v(xbgr.mr_n74201696)
print v(xbgr.mr_n74202128)
print v(xbgr.mr_n74202560)
print v(xbgr.mr_n74202880)
print v(xbgr.mr_n74202992)
print v(xbgr.mr_n74203312)
print v(xbgr.mr_n74203424)
print v(xbgr.mr_n74203744)
print v(xbgr.mr_n74203856)
print v(xbgr.mr_n74204176)
print v(xbgr.mr_n74204288)
print v(xbgr.mr_n74204608)
print v(xbgr.mr_n74204720)
print v(xbgr.mr_n74205040)
print v(xbgr.mr_n74205152)
print v(xbgr.mr_n74205472)
print v(xbgr.mr_n74205584)
print v(xbgr.mr_n74205904)
print v(xbgr.mr_n74206016)
print v(xbgr.mr_n74206448)
print v(xbgr.mr_n74206880)
print v(xbgr.mr_n74207312)
print v(xbgr.mr_n74207744)
print v(xbgr.mr_n74208176)
print v(xbgr.mr_n74208608)
print v(xbgr.mr_n74209040)
print v(xbgr.mr_n74209472)
print v(xbgr.mr_n74209904)
print v(xbgr.mr_n74210336)
print v(xbgr.mr_n74210768)
print v(xbgr.mr_n74211088)
print v(xbgr.mr_n74211200)
print v(xbgr.mr_n74211520)
print v(xbgr.mr_n74211632)
print v(xbgr.mr_n74211952)
print v(xbgr.mr_n74212064)
print v(xbgr.mr_n74212496)
print v(xbgr.mr_n74212928)
print v(xbgr.mr_n74213248)
print v(xbgr.mr_n74213360)
print v(xbgr.mr_n74213680)
print v(xbgr.mr_n74213792)
print v(xbgr.mr_n74214112)
print v(xbgr.mr_n74214224)
print v(xbgr.mr_n74214544)
print v(xbgr.mr_n74214656)
print v(xbgr.mr_n74215088)
print v(xbgr.mr_n74215408)
print v(xbgr.mr_n74215520)
print v(xbgr.mr_n74215840)
print v(xbgr.mr_n74215952)
print v(xbgr.mr_n74216272)
print v(xbgr.mr_n74216384)
print v(xbgr.mr_n74216704)
print v(xbgr.mr_n74216816)
print v(xbgr.mr_n74217136)
print v(xbgr.mr_n74217248)
print v(xbgr.mr_n74217568)
print v(xbgr.mr_n74217680)
print v(xbgr.mr_n74218112)
print v(xbgr.mr_n74218544)
print v(xbgr.mr_n74218976)
print v(xbgr.mr_n74219408)
print v(xbgr.mr_n74219840)
print v(xbgr.mr_n74220272)
print v(xbgr.mr_n74220704)
print v(xbgr.mr_n74221136)
print v(xbgr.mr_n74221568)
print v(xbgr.mr_n74222000)
print v(xbgr.mr_n74222320)
print v(xbgr.mr_n74222432)
print v(xbgr.mr_n74222752)
print v(xbgr.mr_n74222864)
print v(xbgr.mr_n74223184)
print v(xbgr.mr_n74223296)
print v(xbgr.mr_n74223616)
print v(xbgr.mr_n74223728)
print v(xbgr.mr_n74224048)
print v(xbgr.mr_n74224160)
print v(xbgr.mr_n74224480)
print v(xbgr.mr_n74224592)
print v(xbgr.mr_n74224912)
print v(xbgr.mr_n74225024)
print v(xbgr.mr_n74225344)
print v(xbgr.mr_n74225456)
print v(xbgr.mr_n74225776)
print v(xbgr.mr_n74225888)
print v(xbgr.mr_n74226208)
print v(xbgr.mr_n74226320)
print v(xbgr.mr_n74226640)
print v(xbgr.mr_n74226752)
print v(xbgr.mr_n74227072)
print v(xbgr.mr_n74227184)
print v(xbgr.mr_n74227504)
print v(xbgr.mr_n74227616)
print v(xbgr.mr_n74228048)
print v(xbgr.mr_n74228480)
print v(xbgr.mr_n74228912)
print v(xbgr.mr_n74229344)
print v(xbgr.mr_n74229776)
print v(xbgr.mr_n74230208)
print v(xbgr.mr_n74230640)
print v(xbgr.mr_n74231072)
print v(xbgr.mr_n74231504)
print v(xbgr.mr_n74231936)
print v(xbgr.mr_n74232368)
print v(xbgr.mr_n74232800)
print v(xbgr.mr_n74233232)
print v(xbgr.mr_n74233552)
print v(xbgr.mr_n74233664)
print v(xbgr.mr_n74233984)
print v(xbgr.mr_n74234096)
print v(xbgr.mr_n74234416)
print v(xbgr.mr_n74234528)
print v(xbgr.mr_n74234848)
print v(xbgr.mr_n74234960)
print v(xbgr.mr_n74235280)
print v(xbgr.mr_n74235392)
print v(xbgr.mr_n74235712)
print v(xbgr.mr_n74235824)
print v(xbgr.mr_n74236144)
print v(xbgr.mr_n74236256)
print v(xbgr.mr_n74236576)
print v(xbgr.mr_n74236688)
print v(xbgr.mr_n74237008)
print v(xbgr.mr_n74237120)
print v(xbgr.mr_n74237440)
print v(xbgr.mr_n74237552)
print v(xbgr.mr_n74237872)
print v(xbgr.mr_n74237984)
print v(xbgr.mr_n74238304)
print v(xbgr.mr_n74238416)
print v(xbgr.mr_n74238736)
print v(xbgr.mr_n74238848)
print v(xbgr.mr_n74239280)
print v(xbgr.mr_n74239712)
print v(xbgr.mr_n74240144)
print v(xbgr.mr_n74240576)
print v(xbgr.mr_n74241008)
print v(xbgr.mr_n74241440)
print v(xbgr.mr_n74241872)
print v(xbgr.mr_n74242304)
print v(xbgr.mr_n74242736)
print v(xbgr.mr_n74243168)
print v(xbgr.mr_n74243600)
print v(xbgr.mr_n74244032)
print v(xbgr.mr_n74244464)
print v(xbgr.mr_n74244784)
print v(xbgr.mr_n74244896)
print v(xbgr.mr_n74245216)
print v(xbgr.mr_n74245328)
print v(xbgr.mr_n74245648)
print v(xbgr.mr_n74245760)
print v(xbgr.mr_n74246080)
print v(xbgr.mr_n74246192)
print v(xbgr.mr_n74246512)
print v(xbgr.mr_n74246624)
print v(xbgr.mr_n74246944)
print v(xbgr.mr_n74247056)
print v(xbgr.mr_n74247376)
print v(xbgr.mr_n74247488)
print v(xbgr.mr_n74247808)
print v(xbgr.mr_n74247920)
print v(xbgr.mr_n74248240)
print v(xbgr.mr_n74248352)
print v(xbgr.mr_n74248672)
print v(xbgr.mr_n74248784)
print v(xbgr.mr_n74249104)
print v(xbgr.mr_n74249216)
print v(xbgr.mr_n74249536)
print v(xbgr.mr_n74249648)
print v(xbgr.mr_n74249968)
print v(xbgr.mr_n74250080)
print v(xbgr.mr_n74250512)
print v(xbgr.mr_n74250944)
print v(xbgr.mr_n74251376)
print v(xbgr.mr_n74251808)
print v(xbgr.mr_n74252240)
print v(xbgr.mr_n74252672)
print v(xbgr.mr_n74253104)
print v(xbgr.mr_n74253536)
print v(xbgr.mr_n74253968)
print v(xbgr.mr_n74254400)
print v(xbgr.mr_n74254832)
print v(xbgr.mr_n74255264)
print v(xbgr.mr_n74255696)
print v(xbgr.mr_n74256016)
print v(xbgr.mr_n74256128)
print v(xbgr.mr_n74256448)
print v(xbgr.mr_n74256560)
print v(xbgr.mr_n74256992)
print v(xbgr.mr_n74257312)
print v(xbgr.mr_n74257424)
print v(xbgr.mr_n74257744)
print v(xbgr.mr_n74257856)
print v(xbgr.mr_n74258176)
print v(xbgr.mr_n74258288)
print v(xbgr.mr_n74258608)
print v(xbgr.mr_n74258720)
print v(xbgr.mr_n74259152)
print v(xbgr.mr_n74259584)
print v(xbgr.mr_n74260016)
print v(xbgr.mr_n74260448)
print v(xbgr.mr_n74260768)
print v(xbgr.mr_n74260880)
print v(xbgr.mr_n74261200)
print v(xbgr.mr_n74261312)
print v(xbgr.mr_n74261744)
print v(xbgr.mr_n74262176)
print v(xbgr.mr_n74262496)
print v(xbgr.mr_n74262608)
print v(xbgr.mr_n74262928)
print v(xbgr.mr_n74263040)
print v(xbgr.mr_n74263360)
print v(xbgr.mr_n74263472)
print v(xbgr.mr_n74263792)
print v(xbgr.mr_n74263904)
print v(xbgr.mr_n74264224)
print v(xbgr.mr_n74264336)
print v(xbgr.mr_n74264768)
print v(xbgr.mr_n74265200)
print v(xbgr.mr_n74265632)
print v(xbgr.mr_n74266064)
print v(xbgr.mr_n74266496)
print v(xbgr.mr_n74266928)
print v(xbgr.mr_n74267248)
print v(xbgr.mr_n74267360)
print v(xbgr.mr_n74267680)
print v(xbgr.mr_n74267792)
print v(xbgr.mr_n74268112)
print v(xbgr.mr_n74268224)
print v(xbgr.mr_n74268544)
print v(xbgr.mr_n74268656)
print v(xbgr.mr_n74268976)
print v(xbgr.mr_n74269088)
print v(xbgr.mr_n74269408)
print v(xbgr.mr_n74269520)
print v(xbgr.mr_n74269840)
print v(xbgr.mr_n74269952)
print v(xbgr.mr_n74270272)
print v(xbgr.mr_n74270384)
print v(xbgr.mr_n74270704)
print v(xbgr.mr_n74270816)
print v(xbgr.mr_n74271136)
print v(xbgr.mr_n74271248)
print v(xbgr.mr_n74271568)
print v(xbgr.mr_n74271680)
print v(xbgr.mr_n74272000)
print v(xbgr.mr_n74272112)
print v(xbgr.mr_n74272544)
print v(xbgr.mr_n74272976)
print v(xbgr.mr_n74273408)
print v(xbgr.mr_n74273840)
print v(xbgr.mr_n74274272)
print v(xbgr.mr_n74274704)
print v(xbgr.mr_n74275136)
print v(xbgr.mr_n74275568)
print v(xbgr.mr_n74275888)
print v(xbgr.mr_n74276000)
print v(xbgr.mr_n74276320)
print v(xbgr.mr_n74276432)
print v(xbgr.mr_n74276752)
print v(xbgr.mr_n74276864)
print v(xbgr.mr_n74277184)
print v(xbgr.mr_n74277296)
print v(xbgr.mr_n74277616)
print v(xbgr.mr_n74277728)
print v(xbgr.mr_n74278048)
print v(xbgr.mr_n74278160)
print v(xbgr.mr_n74278480)
print v(xbgr.mr_n74278592)
print v(xbgr.mr_n74278912)
print v(xbgr.mr_n74279024)
print v(xbgr.mr_n74279456)
print v(xbgr.mr_n74279888)
print v(xbgr.mr_n74280208)
print v(xbgr.mr_n74280320)
print v(xbgr.mr_n74280640)
print v(xbgr.mr_n74280752)
print v(xbgr.mr_n74281072)
print v(xbgr.mr_n74281184)
print v(xbgr.mr_n74281504)
print v(xbgr.mr_n74281616)
print v(xbgr.mr_n74281936)
print v(xbgr.mr_n74282048)
print v(xbgr.mr_n74282368)
print v(xbgr.mr_n74282480)
print v(xbgr.mr_n74282912)
print v(xbgr.mr_n74283344)
print v(xbgr.mr_n74283776)
print v(xbgr.mr_n74284208)
print v(xbgr.mr_n74284640)
print v(xbgr.mr_n74285072)
print v(xbgr.mr_n74285504)
print v(xbgr.mr_n74285936)
print v(xbgr.mr_n74286368)
print v(xbgr.mr_n74286800)
print v(xbgr.mr_n74287232)
print v(xbgr.mr_n74287664)
print v(xbgr.mr_n74288096)
print v(xbgr.mr_n74288528)
print v(xbgr.mr_n74288960)
print v(xbgr.mr_n74289392)
print v(xbgr.mr_n74289712)
print v(xbgr.mr_n74289824)
print v(xbgr.mr_n74290144)
print v(xbgr.mr_n74290256)
print v(xbgr.mr_n74290576)
print v(xbgr.mr_n74290688)
print v(xbgr.mr_n74291008)
print v(xbgr.mr_n74291120)
print v(xbgr.mr_n74291440)
print v(xbgr.mr_n74291552)
print v(xbgr.mr_n74291872)
print v(xbgr.mr_n74291984)
print v(xbgr.mr_n74292304)
print v(xbgr.mr_n74292416)
print v(xbgr.mr_n74292736)
print v(xbgr.mr_n74292848)
print v(xbgr.mr_n74293168)
print v(xbgr.mr_n74293280)
print v(xbgr.mr_n74293600)
print v(xbgr.mr_n74293712)
print v(xbgr.mr_n74294032)
print v(xbgr.mr_n74294144)
print v(xbgr.mr_n74294464)
print v(xbgr.mr_n74294576)
print v(xbgr.mr_n74294896)
print v(xbgr.mr_n74295008)
print v(xbgr.mr_n74295328)
print v(xbgr.mr_n74295440)
print v(xbgr.mr_n74295760)
print v(xbgr.mr_n74295872)
print v(xbgr.mr_n74296192)
print v(xbgr.mr_n74296304)
print v(xbgr.mr_n74296624)
print v(xbgr.mr_n74296736)
print v(xbgr.mr_n74297056)
print v(xbgr.mr_n74297168)
print v(xbgr.mr_n74297488)
print v(xbgr.mr_n74297600)
print v(xbgr.mr_n74297920)
print v(xbgr.mr_n74298032)
print v(xbgr.mr_n74298464)
print v(xbgr.mr_n74298896)
print v(xbgr.mr_n74299328)
print v(xbgr.mr_n74299760)
print v(xbgr.mr_n74300192)
print v(xbgr.mr_n74300624)
print v(xbgr.mr_n74300944)
print v(xbgr.mr_n74301056)
print v(xbgr.mr_n74301376)
print v(xbgr.mr_n74301488)
print v(xbgr.mr_n74301808)
print v(xbgr.mr_n74301920)
print v(xbgr.mr_n74302240)
print v(xbgr.mr_n74302352)
print v(xbgr.mr_n74302672)
print v(xbgr.mr_n74302784)
print v(xbgr.mr_n74303104)
print v(xbgr.mr_n74303216)
print v(xbgr.mr_n74303648)
print v(xbgr.mr_n74304080)
print v(xbgr.mr_n74304512)
print v(xbgr.mr_n74304944)
print v(xbgr.mr_n74305376)
print v(xbgr.mr_n74305808)
print v(xbgr.mr_n74306240)
print v(xbgr.mr_n74306672)
print v(xbgr.mr_n74307104)
print v(xbgr.mr_n74307536)
print v(xbgr.mr_n74307968)
print v(xbgr.mr_n74308400)
print v(xbgr.mr_n74308832)
print v(xbgr.mr_n74309264)
print v(xbgr.mr_n74309696)
print v(xbgr.mr_n74310128)
print v(xbgr.mr_n74310560)
print v(xbgr.mr_n74310992)
print v(xbgr.mr_n74311424)
print v(xbgr.mr_n74311856)
print v(xbgr.mr_n74312176)
print v(xbgr.mr_n74312288)
print v(xbgr.mr_n74312608)
print v(xbgr.mr_n74312720)
print v(xbgr.mr_n74313040)
print v(xbgr.mr_n74313152)
print v(xbgr.mr_n74313472)
print v(xbgr.mr_n74313584)
print v(xbgr.mr_n74313904)
print v(xbgr.mr_n74314016)
print v(xbgr.mr_n74314336)
print v(xbgr.mr_n74314448)
print v(xbgr.mr_n74314768)
print v(xbgr.mr_n74314880)
print v(xbgr.mr_n74315200)
print v(xbgr.mr_n74315312)
print v(xbgr.mr_n74315632)
print v(xbgr.mr_n74315744)
print v(xbgr.mr_n74316064)
print v(xbgr.mr_n74316176)
print v(xbgr.mr_n74316496)
print v(xbgr.mr_n74316608)
print v(xbgr.mr_n74316928)
print v(xbgr.mr_n74317040)
print v(xbgr.mr_n74317360)
print v(xbgr.mr_n74317472)
print v(xbgr.mr_n74317792)
print v(xbgr.mr_n74317904)
print v(xbgr.mr_n74318224)
print v(xbgr.mr_n74318336)
print v(xbgr.mr_n74318656)
print v(xbgr.mr_n74318768)
print v(xbgr.mr_n74319088)
print v(xbgr.mr_n74319200)
print v(xbgr.mr_n74319520)
print v(xbgr.mr_n74319632)
print v(xbgr.mr_n74319952)
print v(xbgr.mr_n74320064)
print v(xbgr.mr_n74320384)
print v(xbgr.mr_n74320496)
print v(xbgr.mr_n74320816)
print v(xbgr.mr_n74320928)
print v(xbgr.mr_n74321248)
print v(xbgr.mr_n74321360)
print v(xbgr.mr_n74321680)
print v(xbgr.mr_n74321792)
print v(xbgr.mr_n74322112)
print v(xbgr.mr_n74322224)
print v(xbgr.mr_n74322544)
print v(xbgr.mr_n74322656)
print v(xbgr.mr_n74322976)
print v(xbgr.mr_n74323088)
print v(xbgr.mr_n74323408)
print v(xbgr.mr_n74323520)
print v(xbgr.mr_n74323840)
print v(xbgr.mr_n74323952)
print v(xbgr.mr_n74324272)
print v(xbgr.mr_n74324384)
print v(xbgr.mr_n74324704)
print v(xbgr.mr_n74324816)
print v(xbgr.mr_n74325136)
print v(xbgr.mr_n74325248)
print v(xbgr.mr_n74325568)
print v(xbgr.mr_n74325680)
print v(xbgr.mr_n74326112)
print v(xbgr.mr_n74326544)
print v(xbgr.mr_n74326864)
print v(xbgr.mr_n74326976)
print v(xbgr.mr_n74327296)
print v(xbgr.mr_n74327408)
print v(xbgr.mr_n74327728)
print v(xbgr.mr_n74327840)
print v(xbgr.mr_n74328160)
print v(xbgr.mr_n74328272)
print v(xbgr.mr_n74328592)
print v(xbgr.mr_n74328704)
print v(xbgr.mr_n74329024)
print v(xbgr.mr_n74329136)
print v(xbgr.mr_n74329456)
print v(xbgr.mr_n74329568)
print v(xbgr.mr_n74329888)
print v(xbgr.mr_n74330000)
print v(xbgr.mr_n74330320)
print v(xbgr.mr_n74330432)
print v(xbgr.mr_n74330752)
print v(xbgr.mr_n74330864)
print v(xbgr.mr_n74331296)
print v(xbgr.mr_n74331728)
print v(xbgr.mr_n74332160)
print v(xbgr.mr_n74332480)
print v(xbgr.mr_n74332592)
print v(xbgr.mr_n74332912)
print v(xbgr.mr_n74333024)
print v(xbgr.mr_n74333456)
print v(xbgr.mr_n74333888)
print v(xbgr.mr_n74334320)
print v(xbgr.mr_n74334752)
print v(xbgr.mr_n74335184)
print v(xbgr.mr_n74335616)
print v(xbgr.mr_n74336048)
print v(xbgr.mr_n74336480)
print v(xbgr.mr_n74336912)
print v(xbgr.mr_n74337344)
print v(xbgr.mr_n74337776)
print v(xbgr.mr_n74338096)
print v(xbgr.mr_n74338208)
print v(xbgr.mr_n74338528)
print v(xbgr.mr_n74338640)
print v(xbgr.mr_n74338960)
print v(xbgr.mr_n74339072)
print v(xbgr.mr_n74339392)
print v(xbgr.mr_n74339504)
print v(xbgr.mr_n74339824)
print v(xbgr.mr_n74339936)
print v(xbgr.mr_n74340256)
print v(xbgr.mr_n74340368)
print v(xbgr.mr_n74340688)
print v(xbgr.mr_n74340800)
print v(xbgr.mr_n74341120)
print v(xbgr.mr_n74341232)
print v(xbgr.mr_n74341664)
print v(xbgr.mr_n74342096)
print v(xbgr.mr_n74342528)
print v(xbgr.mr_n74342960)
print v(xbgr.mr_n74343392)
print v(xbgr.mr_n74343824)
print v(xbgr.mr_n74344256)
print v(xbgr.mr_n74344688)
print v(xbgr.mr_n74345120)
print v(xbgr.mr_n74345552)
print v(xbgr.mr_n74345984)
print v(xbgr.mr_n74346416)
print v(xbgr.mr_n74346848)
print v(xbgr.mr_n74347280)
print v(xbgr.mr_n74347712)
print v(xbgr.mr_n74348144)
print v(xbgr.mr_n74348576)
print v(xbgr.mr_n74349008)
print v(xbgr.mr_n74349440)
print v(xbgr.mr_n74349872)
print v(xbgr.mr_n74350192)
print v(xbgr.mr_n74350304)
print v(xbgr.mr_n74350624)
print v(xbgr.mr_n74350736)
print v(xbgr.mr_n74351056)
print v(xbgr.mr_n74351168)
print v(xbgr.mr_n74351488)
print v(xbgr.mr_n74351600)
print v(xbgr.mr_n74351920)
print v(xbgr.mr_n74352032)
print v(xbgr.mr_n74352352)
print v(xbgr.mr_n74352464)
print v(xbgr.mr_n74352784)
print v(xbgr.mr_n74352896)
print v(xbgr.mr_n74353216)
print v(xbgr.mr_n74353328)
print v(xbgr.mr_n74353648)
print v(xbgr.mr_n74353760)
print v(xbgr.mr_n74354080)
print v(xbgr.mr_n74354192)
print v(xbgr.mr_n74354512)
print v(xbgr.mr_n74354624)
print v(xbgr.mr_n74354944)
print v(xbgr.mr_n74355056)
print v(xbgr.mr_n74355376)
print v(xbgr.mr_n74355488)
print v(xbgr.mr_n74355920)
print v(xbgr.mr_n74356352)
print v(xbgr.mr_n74356784)
print v(xbgr.mr_n74357216)
print v(xbgr.mr_n74357648)
print v(xbgr.mr_n74358080)
print v(xbgr.mr_n74358512)
print v(xbgr.mr_n74358944)
print v(xbgr.mr_n74359376)
print v(xbgr.mr_n74359808)
print v(xbgr.mr_n74360240)
print v(xbgr.mr_n74360672)
print v(xbgr.mr_n74361104)
print v(xbgr.mr_n74361424)
print v(xbgr.mr_n74361536)
print v(xbgr.mr_n74361856)
print v(xbgr.mr_n74361968)
print v(xbgr.mr_n74362288)
print v(xbgr.mr_n74362400)
print v(xbgr.mr_n74362720)
print v(xbgr.mr_n74362832)
print v(xbgr.mr_n74363152)
print v(xbgr.mr_n74363264)
print v(xbgr.mr_n74363584)
print v(xbgr.mr_n74363696)
print v(xbgr.mr_n74364016)
print v(xbgr.mr_n74364128)
print v(xbgr.mr_n74364448)
print v(xbgr.mr_n74364560)
print v(xbgr.mr_n74364880)
print v(xbgr.mr_n74364992)
print v(xbgr.mr_n74365312)
print v(xbgr.mr_n74365424)
print v(xbgr.mr_n74365744)
print v(xbgr.mr_n74365856)
print v(xbgr.mr_n74366176)
print v(xbgr.mr_n74366288)
print v(xbgr.mr_n74366720)
print v(xbgr.mr_n74367040)
print v(xbgr.mr_n74367152)
print v(xbgr.mr_n74367584)
print v(xbgr.mr_n74368016)
print v(xbgr.mr_n74368448)
print v(xbgr.mr_n74368880)
print v(xbgr.mr_n74369312)
print v(xbgr.mr_n74369744)
print v(xbgr.mr_n74370176)
print v(xbgr.mr_n74370608)
print v(xbgr.mr_n74371040)
print v(xbgr.mr_n74371472)
print v(xbgr.mr_n74371904)
print v(xbgr.mr_n74372336)
print v(xbgr.mr_n74372656)
print v(xbgr.mr_n74372768)
print v(xbgr.mr_n74373088)
print v(xbgr.mr_n74373200)
print v(xbgr.mr_n74373520)
print v(xbgr.mr_n74373632)
print v(xbgr.mr_n74373952)
print v(xbgr.mr_n74374064)
print v(xbgr.mr_n74374384)
print v(xbgr.mr_n74374496)
print v(xbgr.mr_n74374816)
print v(xbgr.mr_n74374928)
print v(xbgr.mr_n74375248)
print v(xbgr.mr_n74375360)
print v(xbgr.mr_n74375680)
print v(xbgr.mr_n74375792)
print v(xbgr.mr_n74376112)
print v(xbgr.mr_n74376224)
print v(xbgr.mr_n74376544)
print v(xbgr.mr_n74376656)
print v(xbgr.mr_n74376976)
print v(xbgr.mr_n74377088)
print v(xbgr.mr_n74377520)
print v(xbgr.mr_n74377952)
print v(xbgr.mr_n74378384)
print v(xbgr.mr_n74378704)
print v(xbgr.mr_n74378816)
print v(xbgr.mr_n74379136)
print v(xbgr.mr_n74379248)
print v(xbgr.mr_n74379680)
print v(xbgr.mr_n74380112)
print v(xbgr.mr_n74380544)
print v(xbgr.mr_n74380976)
print v(xbgr.mr_n74381408)
print v(xbgr.mr_n74381840)
print v(xbgr.mr_n74382272)
print v(xbgr.mr_n74382704)
print v(xbgr.mr_n74383136)
print v(xbgr.mr_n74383568)
print v(xbgr.mr_n74383888)
print v(xbgr.mr_n74384000)
print v(xbgr.mr_n74384320)
print v(xbgr.mr_n74384432)
print v(xbgr.mr_n74384752)
print v(xbgr.mr_n74384864)
print v(xbgr.mr_n74385184)
print v(xbgr.mr_n74385296)
print v(xbgr.mr_n74385616)
print v(xbgr.mr_n74385728)
print v(xbgr.mr_n74386048)
print v(xbgr.mr_n74386160)
print v(xbgr.mr_n74386480)
print v(xbgr.mr_n74386592)
print v(xbgr.mr_n74386912)
print v(xbgr.mr_n74387024)
print v(xbgr.mr_n74387344)
print v(xbgr.mr_n74387456)
print v(xbgr.mr_n74387776)
print v(xbgr.mr_n74387888)
print v(xbgr.mr_n74388208)
print v(xbgr.mr_n74388320)
print v(xbgr.mr_n74388640)
print v(xbgr.mr_n74388752)
print v(xbgr.mr_n74389184)
print v(xbgr.mr_n74389616)
print v(xbgr.mr_n74390048)
print v(xbgr.mr_n74390480)
print v(xbgr.mr_n74390912)
print v(xbgr.mr_n74391344)
print v(xbgr.mr_n74391776)
print v(xbgr.mr_n74392096)
print v(xbgr.mr_n74392208)
print v(xbgr.mr_n74392640)
print v(xbgr.mr_n74393072)
print v(xbgr.mr_n74393504)
print v(xbgr.mr_n74393936)
print v(xbgr.mr_n74394368)
print v(xbgr.mr_n74394800)
print v(xbgr.mr_n74395120)
print v(xbgr.mr_n74395232)
print v(xbgr.mr_n74395552)
print v(xbgr.mr_n74395664)
print v(xbgr.mr_n74395984)
print v(xbgr.mr_n74396096)
print v(xbgr.mr_n74396416)
print v(xbgr.mr_n74396528)
print v(xbgr.mr_n74396848)
print v(xbgr.mr_n74396960)
print v(xbgr.mr_n74397280)
print v(xbgr.mr_n74397392)
print v(xbgr.mr_n74397712)
print v(xbgr.mr_n74397824)
print v(xbgr.mr_n74398144)
print v(xbgr.mr_n74398256)
print v(xbgr.mr_n74398576)
print v(xbgr.mr_n74398688)
print v(xbgr.mr_n74399008)
print v(xbgr.mr_n74399120)
print v(xbgr.mr_n74399440)
print v(xbgr.mr_n74399552)
print v(xbgr.mr_n74399872)
print v(xbgr.mr_n74399984)
print v(xbgr.mr_n74400304)
print v(xbgr.mr_n74400416)
print v(xbgr.mr_n74400736)
print v(xbgr.mr_n74400848)
print v(xbgr.mr_n74401168)
print v(xbgr.mr_n74401280)
print v(xbgr.mr_n74401600)
print v(xbgr.mr_n74401712)
print v(xbgr.mr_n74402032)
print v(xbgr.mr_n74402144)
print v(xbgr.mr_n74402464)
print v(xbgr.mr_n74402576)
print v(xbgr.mr_n74402896)
print v(xbgr.mr_n74403008)
print v(xbgr.mr_n74403328)
print v(xbgr.mr_n74403440)
print v(xbgr.mr_n74403760)
print v(xbgr.mr_n74403872)
print v(xbgr.mr_n74404192)
print v(xbgr.mr_n74404304)
print v(xbgr.mr_n74404624)
print v(xbgr.mr_n74404736)
print v(xbgr.mr_n74405056)
print v(xbgr.mr_n74405168)
print v(xbgr.mr_n74405600)
print v(xbgr.mr_n74406032)
print v(xbgr.mr_n74406464)
print v(xbgr.mr_n74406784)
print v(xbgr.mr_n74406896)
print v(xbgr.mr_n74407216)
print v(xbgr.mr_n74407328)
print v(xbgr.mr_n74407760)
print v(xbgr.mr_n74408192)
print v(xbgr.mr_n74408624)
print v(xbgr.mr_n74409056)
print v(xbgr.mr_n74409488)
print v(xbgr.mr_n74409920)
print v(xbgr.mr_n74410352)
print v(xbgr.mr_n74410784)
print v(xbgr.mr_n74411216)
print v(xbgr.mr_n74411648)
print v(xbgr.mr_n74412080)
print v(xbgr.mr_n74412512)
print v(xbgr.mr_n74412944)
print v(xbgr.mr_n74413376)
print v(xbgr.mr_n74413808)
print v(xbgr.mr_n74414240)
print v(xbgr.mr_n74414672)
print v(xbgr.mr_n74415104)
print v(xbgr.mr_n74415536)
print v(xbgr.mr_n74415968)
print v(xbgr.mr_n74416400)
print v(xbgr.mr_n74416832)
print v(xbgr.mr_n74417264)
print v(xbgr.mr_n74417584)
print v(xbgr.mr_n74417696)
print v(xbgr.mr_n74418016)
print v(xbgr.mr_n74418128)
print v(xbgr.mr_n74418448)
print v(xbgr.mr_n74418560)
print v(xbgr.mr_n74418880)
print v(xbgr.mr_n74418992)
print v(xbgr.mr_n74419312)
print v(xbgr.mr_n74419424)
print v(xbgr.mr_n74419744)
print v(xbgr.mr_n74419856)
print v(xbgr.mr_n74420176)
print v(xbgr.mr_n74420288)
print v(xbgr.mr_n74420608)
print v(xbgr.mr_n74420720)
print v(xbgr.mr_n74421040)
print v(xbgr.mr_n74421152)
print v(xbgr.mr_n74421472)
print v(xbgr.mr_n74421584)
print v(xbgr.mr_n74421904)
print v(xbgr.mr_n74422016)
print v(xbgr.mr_n74422336)
print v(xbgr.mr_n74422448)
print v(xbgr.mr_n74422768)
print v(xbgr.mr_n74422880)
print v(xbgr.mr_n74423200)
print v(xbgr.mr_n74423312)
print v(xbgr.mr_n74423744)
print v(xbgr.mr_n74424176)
print v(xbgr.mr_n74424496)
print v(xbgr.mr_n74424608)
print v(xbgr.mr_n74424928)
print v(xbgr.mr_n74425040)
print v(xbgr.mr_n74425360)
print v(xbgr.mr_n74425472)
print v(xbgr.mr_n74425792)
print v(xbgr.mr_n74425904)
print v(xbgr.mr_n74426336)
print v(xbgr.mr_n74426768)
print v(xbgr.mr_n74427088)
print v(xbgr.mr_n74427200)
print v(xbgr.mr_n74427520)
print v(xbgr.mr_n74427632)
print v(xbgr.mr_n74427952)
print v(xbgr.mr_n74428064)
print v(xbgr.mr_n74428384)
print v(xbgr.mr_n74428496)
print v(xbgr.mr_n74428816)
print v(xbgr.mr_n74428928)
print v(xbgr.mr_n74429248)
print v(xbgr.mr_n74429360)
print v(xbgr.mr_n74429680)
print v(xbgr.mr_n74429792)
print v(xbgr.mr_n74430112)
print v(xbgr.mr_n74430224)
print v(xbgr.mr_n74430656)
print v(xbgr.mr_n74431088)
print v(xbgr.mr_n74431520)
print v(xbgr.mr_n74431952)
print v(xbgr.mr_n74432384)
print v(xbgr.mr_n74432816)
print v(xbgr.mr_n74433248)
print v(xbgr.mr_n74433680)
print v(xbgr.mr_n74434112)
print v(xbgr.mr_n74434544)
print v(xbgr.mr_n74434864)
print v(xbgr.mr_n74434976)
print v(xbgr.mr_n74435296)
print v(xbgr.mr_n74435408)
print v(xbgr.mr_n74435728)
print v(xbgr.mr_n74435840)
print v(xbgr.mr_n74436160)
print v(xbgr.mr_n74436272)
print v(xbgr.mr_n74441456)
print v(xbgr.mr_n74441568)
print v(xbgr.mr_n74441904)
print v(xbgr.mr_n74442016)
print v(xbgr.mr_n74442336)
print v(xbgr.mr_n74442448)
print v(xbgr.mr_n74442816)
print v(xbgr.mr_n74442928)
print v(xbgr.mr_n74443248)
print v(xbgr.mr_n74443360)
print v(xbgr.mr_n74443680)
print v(xbgr.mr_n74443792)
print v(xbgr.mr_n74444032)
print v(xbgr.mr_n74444144)
print v(xbgr.mr_n74444464)
print v(xbgr.mr_n74444576)
print v(xbgr.mr_n74444896)
print v(xbgr.mr_n74445008)
print v(xbgr.mr_n74445328)
print v(xbgr.mr_n74445440)
print v(xbgr.mr_n74445760)
print v(xbgr.mr_n74445872)
print v(xbgr.mr_n74446192)
print v(xbgr.mr_n74446304)
print v(xbgr.mr_n74446624)
print v(xbgr.mr_n74446736)
print v(xbgr.mr_n74447056)
print v(xbgr.mr_n74447168)
print v(xbgr.mr_n74447488)
print v(xbgr.mr_n74447600)
print v(xbgr.mr_n74447920)
print v(xbgr.mr_n74448032)
print v(xbgr.mr_n74448352)
print v(xbgr.mr_n74448464)
print v(xbgr.mr_n74448784)
print v(xbgr.mr_n74448896)
print v(xbgr.mr_n74449216)
print v(xbgr.mr_n74449328)
print v(xbgr.mr_n74449648)
print v(xbgr.mr_n74449760)
print v(xbgr.mr_n74450080)
print v(xbgr.mr_n74450192)
print v(xbgr.mr_n74450512)
print v(xbgr.mr_n74450624)
print v(xbgr.mr_n74450944)
print v(xbgr.mr_n74451056)
print v(xbgr.mr_n74451376)
print v(xbgr.mr_n74451488)
print v(xbgr.mr_n74451808)
print v(xbgr.mr_n74451920)
print v(xbgr.mr_n74452240)
print v(xbgr.mr_n74452352)
print v(xbgr.mr_n74452672)
print v(xbgr.mr_n74452784)
print v(xbgr.mr_n74453104)
print v(xbgr.mr_n74453216)
print v(xbgr.mr_n74453536)
print v(xbgr.mr_n74453648)
print v(xbgr.mr_n74453968)
print v(xbgr.mr_n74454080)
print v(xbgr.mr_n74454400)
print v(xbgr.mr_n74454512)
print v(xbgr.mr_n74454832)
print v(xbgr.mr_n74454944)
print v(xbgr.mr_n74455264)
print v(xbgr.mr_n74455376)
print v(xbgr.mr_n74455696)
print v(xbgr.mr_n74455808)
print v(xbgr.mr_n74456128)
print v(xbgr.mr_n74456240)
print v(xbgr.mr_n74456560)
print v(xbgr.mr_n74456672)
print v(xbgr.mr_n74456992)
print v(xbgr.mr_n74457104)
print v(xbgr.mr_n74457424)
print v(xbgr.mr_n74457536)
print v(xbgr.mr_n74457856)
print v(xbgr.mr_n74457968)
print v(xbgr.mr_n74458288)
print v(xbgr.mr_n74458400)
print v(xbgr.mr_n74458720)
print v(xbgr.mr_n74458832)
print v(xbgr.mr_n74459152)
print v(xbgr.mr_n74459264)
print v(xbgr.mr_n74459584)
print v(xbgr.mr_n74459696)
print v(xbgr.mr_n74460016)
print v(xbgr.mr_n74460128)
print v(xbgr.mr_n74460448)
print v(xbgr.mr_n74460560)
print v(xbgr.mr_n74460880)
print v(xbgr.mr_n74460992)
print v(xbgr.mr_n74461312)
print v(xbgr.mr_n74461424)
print v(xbgr.mr_n74461744)
print v(xbgr.mr_n74461856)
print v(xbgr.mr_n74462176)
print v(xbgr.mr_n74462288)
print v(xbgr.mr_n74462608)
print v(xbgr.mr_n74462720)
print v(xbgr.mr_n74463040)
print v(xbgr.mr_n74463152)
print v(xbgr.mr_n74463472)
print v(xbgr.mr_n74463584)
print v(xbgr.mr_n74463904)
print v(xbgr.mr_n74464016)
print v(xbgr.mr_n74464336)
print v(xbgr.mr_n74464448)
print v(xbgr.mr_n74464768)
print v(xbgr.mr_n74464880)
print v(xbgr.mr_n74465200)
print v(xbgr.mr_n74465312)
print v(xbgr.mr_n74465632)
print v(xbgr.mr_n74465744)
print v(xbgr.mr_n74466064)
print v(xbgr.mr_n74466176)
print v(xbgr.mr_n74466496)
print v(xbgr.mr_n74466608)
print v(xbgr.mr_n74466928)
print v(xbgr.mr_n74467040)
print v(xbgr.mr_n74467360)
print v(xbgr.mr_n74467472)
print v(xbgr.mr_n74467792)
print v(xbgr.mr_n74467904)
print v(xbgr.mr_n74468224)
print v(xbgr.mr_n74468336)
print v(xbgr.mr_n74468656)
print v(xbgr.mr_n74468768)
print v(xbgr.mr_n74469088)
print v(xbgr.mr_n74469200)
print v(xbgr.mr_n74469520)
print v(xbgr.mr_n74469632)
print v(xbgr.mr_n74469952)
print v(xbgr.mr_n74470064)
print v(xbgr.mr_n74470384)
print v(xbgr.mr_n74470496)
print v(xbgr.mr_n74470816)
print v(xbgr.mr_n74470928)
print v(xbgr.mr_n74471248)
print v(xbgr.mr_n74471360)
print v(xbgr.mr_n74471584)
print v(xbgr.mr_n74471696)
print v(xbgr.mr_n74471952)
print v(xbgr.mr_n74472064)
print v(xbgr.mr_n74472320)
print v(xbgr.mr_n74472432)
print v(xbgr.mr_n74472688)
print v(xbgr.mr_n74472800)
print v(xbgr.mr_n74473056)
print v(xbgr.mr_n74473168)
print v(xbgr.mr_n74473424)
print v(xbgr.mr_n74473536)
print v(xbgr.mr_n74473792)
print v(xbgr.mr_n74473904)
print v(xbgr.mr_n74474160)
print v(xbgr.mr_n74474272)
print v(xbgr.mr_n74474528)
print v(xbgr.mr_n74474640)
print v(xbgr.mr_n74474896)
print v(xbgr.mr_n74475008)
print v(xbgr.mr_n74475264)
print v(xbgr.mr_n74475376)
print v(xbgr.mr_n74475632)
print v(xbgr.mr_n74475744)
print v(xbgr.mr_n74476064)
print v(xbgr.mr_n74476176)
print v(xbgr.mr_n74476496)
print v(xbgr.mr_n74476608)
print v(xbgr.mr_n74476928)
print v(xbgr.mr_n74477040)
print v(xbgr.mr_n74477360)
print v(xbgr.mr_n74477472)
print v(xbgr.mr_n74477792)
print v(xbgr.mr_n74477904)
print v(xbgr.mr_n74478224)
print v(xbgr.mr_n74478336)
print v(xbgr.mr_n74478656)
print v(xbgr.mr_n74478768)
print v(xbgr.mr_n74479088)
print v(xbgr.mr_n74479200)
print v(xbgr.mr_n74479520)
print v(xbgr.mr_n74479632)
print v(xbgr.mr_n74479952)
print v(xbgr.mr_n74480064)
print v(xbgr.mr_n74480384)
print v(xbgr.mr_n74480496)
print v(xbgr.mr_n74480816)
print v(xbgr.mr_n74480928)
print v(xbgr.mr_n74481248)
print v(xbgr.mr_n74481360)
print v(xbgr.mr_n74481680)
print v(xbgr.mr_n74481792)
print v(xbgr.mr_n74482112)
print v(xbgr.mr_n74482224)
print v(xbgr.mr_n74482544)
print v(xbgr.mr_n74482656)
print v(xbgr.mr_n74482976)
print v(xbgr.mr_n74483088)
print v(xbgr.mr_n74483408)
print v(xbgr.mr_n74483520)
print v(xbgr.mr_n74483840)
print v(xbgr.mr_n74483952)
print v(xbgr.mr_n74484272)
print v(xbgr.mr_n74484384)
print v(xbgr.mr_n74484704)
print v(xbgr.mr_n74484816)
print v(xbgr.mr_n74485136)
print v(xbgr.mr_n74485248)
print v(xbgr.mr_n74485568)
print v(xbgr.mr_n74485680)
print v(xbgr.mr_n74486000)
print v(xbgr.mr_n74486112)
print v(xbgr.mr_n74486432)
print v(xbgr.mr_n74486544)
print v(xbgr.mr_n74486864)
print v(xbgr.mr_n74486976)
print v(xbgr.mr_n74487296)
print v(xbgr.mr_n74487408)
print v(xbgr.mr_n74487728)
print v(xbgr.mr_n74487840)
print v(xbgr.mr_n74488160)
print v(xbgr.mr_n74488272)
print v(xbgr.mr_n74488592)
print v(xbgr.mr_n74488704)
print v(xbgr.mr_n74489024)
print v(xbgr.mr_n74489136)
print v(xbgr.mr_n74489456)
print v(xbgr.mr_n74489568)
print v(xbgr.mr_n74489888)
print v(xbgr.mr_n74490000)
print v(xbgr.mr_n74490320)
print v(xbgr.mr_n74490432)
print v(xbgr.mr_n74490752)
print v(xbgr.mr_n74490864)
print v(xbgr.mr_n74491184)
print v(xbgr.mr_n74491296)
print v(xbgr.mr_n74491616)
print v(xbgr.mr_n74491728)
print v(xbgr.mr_n74492048)
print v(xbgr.mr_n74492160)
print v(xbgr.mr_n74492480)
print v(xbgr.mr_n74492592)
print v(xbgr.mr_n74492912)
print v(xbgr.mr_n74493024)
print v(xbgr.mr_n74493344)
print v(xbgr.mr_n74493456)
print v(xbgr.mr_n74493776)
print v(xbgr.mr_n74493888)
print v(xbgr.mr_n74494208)
print v(xbgr.mr_n74494320)
print v(xbgr.mr_n74494640)
print v(xbgr.mr_n74494752)
print v(xbgr.mr_n74495072)
print v(xbgr.mr_n74495184)
print v(xbgr.mr_n74495504)
print v(xbgr.mr_n74495616)
print v(xbgr.mr_n74495936)
print v(xbgr.mr_n74496048)
print v(xbgr.mr_n74496368)
print v(xbgr.mr_n74496480)
print v(xbgr.mr_n74496800)
print v(xbgr.mr_n74496912)
print v(xbgr.mr_n74497232)
print v(xbgr.mr_n74497344)
print v(xbgr.mr_n74497664)
print v(xbgr.mr_n74497776)
print v(xbgr.mr_n74498096)
print v(xbgr.mr_n74498208)
print v(xbgr.mr_n74498528)
print v(xbgr.mr_n74498640)
print v(xbgr.mr_n74498960)
print v(xbgr.mr_n74499072)
print v(xbgr.mr_n74499392)
print v(xbgr.mr_n74499504)
print v(xbgr.mr_n74499824)
print v(xbgr.mr_n74499936)
print v(xbgr.mr_n74500256)
print v(xbgr.mr_n74500368)
print v(xbgr.mr_n74500688)
print v(xbgr.mr_n74500800)
print v(xbgr.mr_n74501120)
print v(xbgr.mr_n74501232)
print v(xbgr.mr_n74501552)
print v(xbgr.mr_n74501664)
print v(xbgr.mr_n74501984)
print v(xbgr.mr_n74502096)
print v(xbgr.mr_n74502416)
print v(xbgr.mr_n74502528)
print v(xbgr.mr_n74502736)
print v(xbgr.mr_n74502848)
print v(xbgr.mr_n74503168)
print v(xbgr.mr_n74503280)
print v(xbgr.mr_n74503600)
print v(xbgr.mr_n74503712)
print v(xbgr.mr_n74504032)
print v(xbgr.mr_n74504144)
print v(xbgr.mr_n74504464)
print v(xbgr.mr_n74504576)
print v(xbgr.mr_n74504896)
print v(xbgr.mr_n74505008)
print v(xbgr.mr_n74505328)
print v(xbgr.mr_n74505440)
print v(xbgr.mr_n74505760)
print v(xbgr.mr_n74505872)
print v(xbgr.mr_n74506192)
print v(xbgr.mr_n74506304)
print v(xbgr.mr_n74506624)
print v(xbgr.mr_n74506736)
print v(xbgr.mr_n74507056)
print v(xbgr.mr_n74507168)
print v(xbgr.mr_n74507488)
print v(xbgr.mr_n74507600)
print v(xbgr.mr_n74507920)
print v(xbgr.mr_n74508032)
print v(xbgr.mr_n74508352)
print v(xbgr.mr_n74508464)
print v(xbgr.mr_n74508784)
print v(xbgr.mr_n74508896)
print v(xbgr.mr_n74509216)
print v(xbgr.mr_n74509328)
print v(xbgr.mr_n74509648)
print v(xbgr.mr_n74509760)
print v(xbgr.mr_n74510080)
print v(xbgr.mr_n74510192)
print v(xbgr.mr_n74510512)
print v(xbgr.mr_n74510624)
print v(xbgr.mr_n74510944)
print v(xbgr.mr_n74511056)
print v(xbgr.mr_n74511376)
print v(xbgr.mr_n74511488)
print v(xbgr.mr_n74511808)
print v(xbgr.mr_n74511920)
print v(xbgr.mr_n74512240)
print v(xbgr.mr_n74512352)
print v(xbgr.mr_n74512672)
print v(xbgr.mr_n74512784)
print v(xbgr.mr_n74513104)
print v(xbgr.mr_n74513216)
print v(xbgr.mr_n74513536)
print v(xbgr.mr_n74513648)
print v(xbgr.mr_n74513968)
print v(xbgr.mr_n74514080)
print v(xbgr.mr_n74514400)
print v(xbgr.mr_n74514512)
print v(xbgr.mr_n74514832)
print v(xbgr.mr_n74514944)
print v(xbgr.mr_n74515264)
print v(xbgr.mr_n74515376)
print v(xbgr.mr_n74515696)
print v(xbgr.mr_n74515808)
print v(xbgr.mr_n74516128)
print v(xbgr.mr_n74516240)
print v(xbgr.mr_n74516560)
print v(xbgr.mr_n74516672)
print v(xbgr.mr_n74516992)
print v(xbgr.mr_n74517104)
print v(xbgr.mr_n74517424)
print v(xbgr.mr_n74517536)
print v(xbgr.mr_n74517856)
print v(xbgr.mr_n74517968)
print v(xbgr.mr_n74518288)
print v(xbgr.mr_n74518400)
print v(xbgr.mr_n74518720)
print v(xbgr.mr_n74518832)
print v(xbgr.mr_n74519152)
print v(xbgr.mr_n74519264)
print v(xbgr.mr_n74519584)
print v(xbgr.mr_n74519696)
print v(xbgr.mr_n74520016)
print v(xbgr.mr_n74520128)
print v(xbgr.mr_n74520448)
print v(xbgr.mr_n74520560)
print v(xbgr.mr_n74520880)
print v(xbgr.mr_n74520992)
print v(xbgr.mr_n74521312)
print v(xbgr.mr_n74521424)
print v(xbgr.mr_n74521744)
print v(xbgr.mr_n74521856)
print v(xbgr.mr_n74522176)
print v(xbgr.mr_n74522288)
print v(xbgr.mr_n74522608)
print v(xbgr.mr_n74522720)
print v(xbgr.mr_n74523040)
print v(xbgr.mr_n74523152)
print v(xbgr.mr_n74523472)
print v(xbgr.mr_n74523584)
print v(xbgr.mr_n74523904)
print v(xbgr.mr_n74524016)
print v(xbgr.mr_n74524336)
print v(xbgr.mr_n74524448)
print v(xbgr.mr_n74524768)
print v(xbgr.mr_n74524880)
print v(xbgr.mr_n74525200)
print v(xbgr.mr_n74525312)
print v(xbgr.mr_n74525632)
print v(xbgr.mr_n74525744)
print v(xbgr.mr_n74526064)
print v(xbgr.mr_n74526176)
print v(xbgr.mr_n74526496)
print v(xbgr.mr_n74526608)
print v(xbgr.mr_n74526928)
print v(xbgr.mr_n74527040)
print v(xbgr.mr_n74527360)
print v(xbgr.mr_n74527472)
print v(xbgr.mr_n74527792)
print v(xbgr.mr_n74527904)
print v(xbgr.mr_n74528224)
print v(xbgr.mr_n74528336)
print v(xbgr.mr_n74528656)
print v(xbgr.mr_n74528768)
print v(xbgr.mr_n74529088)
print v(xbgr.mr_n74529200)
print v(xbgr.mr_n74529520)
print v(xbgr.mr_n74529632)
print v(xbgr.mr_n74529952)
print v(xbgr.mr_n74530064)
print v(xbgr.mr_n74530384)
print v(xbgr.mr_n74530496)
print v(xbgr.mr_n74530816)
print v(xbgr.mr_n74530928)
print v(xbgr.mr_n74531248)
print v(xbgr.mr_n74531360)
print v(xbgr.mr_n74531680)
print v(xbgr.mr_n74531792)
print v(xbgr.mr_n74532112)
print v(xbgr.mr_n74532224)
print v(xbgr.mr_n74532544)
print v(xbgr.mr_n74532656)
print v(xbgr.mr_n74532976)
print v(xbgr.mr_n74533088)
print v(xbgr.mr_n74533408)
print v(xbgr.mr_n74533520)
print v(xbgr.mr_n74533840)
print v(xbgr.mr_n74533952)
print v(xbgr.mr_n74534272)
print v(xbgr.mr_n74534384)
print v(xbgr.mr_n74534704)
print v(xbgr.mr_n74534816)
print v(xbgr.mr_n74535136)
print v(xbgr.mr_n74535248)
print v(xbgr.mr_n74535568)
print v(xbgr.mr_n74535680)
print v(xbgr.mr_n74536000)
print v(xbgr.mr_n74536112)
print v(xbgr.mr_n74536432)
print v(xbgr.mr_n74536544)
print v(xbgr.mr_n74536864)
print v(xbgr.mr_n74536976)
print v(xbgr.mr_n74537296)
print v(xbgr.mr_n74537408)
print v(xbgr.mr_n74537728)
print v(xbgr.mr_n74537840)
print v(xbgr.mr_n74538160)
print v(xbgr.mr_n74538272)
print v(xbgr.mr_n74538592)
print v(xbgr.mr_n74538704)
print v(xbgr.mr_n74539024)
print v(xbgr.mr_n74539136)
print v(xbgr.mr_n74539456)
print v(xbgr.mr_n74539568)
print v(xbgr.mr_n74539888)
print v(xbgr.mr_n74540000)
print v(xbgr.mr_n74540320)
print v(xbgr.mr_n74540432)
print v(xbgr.mr_n74540752)
print v(xbgr.mr_n74540864)
print v(xbgr.mr_n74541184)
print v(xbgr.mr_n74541296)
print v(xbgr.mr_n74541616)
print v(xbgr.mr_n74541728)
print v(xbgr.mr_n74542048)
print v(xbgr.mr_n74542160)
print v(xbgr.mr_n74542480)
print v(xbgr.mr_n74542592)
print v(xbgr.mr_n74542912)
print v(xbgr.mr_n74543024)
print v(xbgr.mr_n74543344)
print v(xbgr.mr_n74543456)
print v(xbgr.mr_n74543776)
print v(xbgr.mr_n74543888)
print v(xbgr.mr_n74544208)
print v(xbgr.mr_n74544320)
print v(xbgr.mr_n74544640)
print v(xbgr.mr_n74544752)
print v(xbgr.mr_n74545072)
print v(xbgr.mr_n74545184)
print v(xbgr.mr_n74545504)
print v(xbgr.mr_n74545616)
print v(xbgr.mr_n74545936)
print v(xbgr.mr_n74546048)
print v(xbgr.mr_n74546368)
print v(xbgr.mr_n74546480)
print v(xbgr.mr_n74546800)
print v(xbgr.mr_n74546912)
print v(xbgr.mr_n74547232)
print v(xbgr.mr_n74547344)
print v(xbgr.mr_n74547664)
print v(xbgr.mr_n74547776)
print v(xbgr.mr_n74548096)
print v(xbgr.mr_n74548208)
print v(xbgr.mr_n74548528)
print v(xbgr.mr_n74548640)
print v(xbgr.mr_n74548960)
print v(xbgr.mr_n74549072)
print v(xbgr.mr_n74549392)
print v(xbgr.mr_n74549504)
print v(xbgr.mr_n74549824)
print v(xbgr.mr_n74549936)
print v(xbgr.mr_n74550256)
print v(xbgr.mr_n74550368)
print v(xbgr.mr_n74550688)
print v(xbgr.mr_n74550800)
print v(xbgr.mr_n74551120)
print v(xbgr.mr_n74551232)
print v(xbgr.mr_n74551552)
print v(xbgr.mr_n74551664)
print v(xbgr.mr_n74551984)
print v(xbgr.mr_n74552096)
print v(xbgr.mr_n74552416)
print v(xbgr.mr_n74552528)
print v(xbgr.mr_n74552848)
print v(xbgr.mr_n74552960)
print v(xbgr.mr_n74553280)
print v(xbgr.mr_n74553392)
print v(xbgr.mr_n74553712)
print v(xbgr.mr_n74553824)
print v(xbgr.mr_n74554144)
print v(xbgr.mr_n74554256)
print v(xbgr.mr_n74554576)
print v(xbgr.mr_n74554688)
print v(xbgr.mr_n74555008)
print v(xbgr.mr_n74555120)
print v(xbgr.mr_n74555440)
print v(xbgr.mr_n74555552)
print v(xbgr.mr_n74555872)
print v(xbgr.mr_n74555984)
print v(xbgr.mr_n74556304)
print v(xbgr.mr_n74556416)
print v(xbgr.mr_n74556736)
print v(xbgr.mr_n74556848)
print v(xbgr.mr_n74557168)
print v(xbgr.mr_n74557280)
print v(xbgr.mr_n74557600)
print v(xbgr.mr_n74557712)
print v(xbgr.mr_n74558032)
print v(xbgr.mr_n74558144)
print v(xbgr.mr_n74558464)
print v(xbgr.mr_n74558576)
print v(xbgr.mr_n74558896)
print v(xbgr.mr_n74559008)
print v(xbgr.mr_n74559328)
print v(xbgr.mr_n74559440)
print v(xbgr.mr_n74559760)
print v(xbgr.mr_n74559872)
print v(xbgr.mr_n74560192)
print v(xbgr.mr_n74560304)
print v(xbgr.mr_n74560624)
print v(xbgr.mr_n74560736)
print v(xbgr.mr_n74561056)
print v(xbgr.mr_n74561168)
print v(xbgr.mr_n74561488)
print v(xbgr.mr_n74561600)
print v(xbgr.mr_n74561920)
print v(xbgr.mr_n74562032)
print v(xbgr.mr_n74562352)
print v(xbgr.mr_n74562464)
print v(xbgr.mr_n74562784)
print v(xbgr.mr_n74562896)
print v(xbgr.mr_n74563216)
print v(xbgr.mr_n74563328)
print v(xbgr.mr_n74563648)
print v(xbgr.mr_n74563760)
print v(xbgr.mr_n74564288)
print v(xbgr.mr_n74564400)
print v(xbgr.mr_n74564720)
print v(xbgr.mr_n74564832)
print v(xbgr.mr_n74565152)
print v(xbgr.mr_n74565264)
print v(xbgr.mr_n74565584)
print v(xbgr.mr_n74565696)
print v(xbgr.mr_n74566016)
print v(xbgr.mr_n74566128)
print v(xbgr.mr_n74566448)
print v(xbgr.mr_n74566560)
print v(xbgr.mr_n74566880)
print v(xbgr.mr_n74566992)
print v(xbgr.mr_n74567312)
print v(xbgr.mr_n74567424)
print v(xbgr.mr_n74567744)
print v(xbgr.mr_n74567856)
print v(xbgr.mr_n74568176)
print v(xbgr.mr_n74568288)
print v(xbgr.mr_n74568608)
print v(xbgr.mr_n74568720)
print v(xbgr.mr_n74569040)
print v(xbgr.mr_n74569152)
print v(xbgr.mr_n74569472)
print v(xbgr.mr_n74569584)
print v(xbgr.mr_n74569904)
print v(xbgr.mr_n74570016)
print v(xbgr.mr_n74570336)
print v(xbgr.mr_n74570448)
print v(xbgr.mr_n74570768)
print v(xbgr.mr_n74570880)
print v(xbgr.mr_n74571200)
print v(xbgr.mr_n74571312)
print v(xbgr.mr_n74571632)
print v(xbgr.mr_n74571744)
print v(xbgr.mr_n74572064)
print v(xbgr.mr_n74572176)
print v(xbgr.mr_n74572496)
print v(xbgr.mr_n74572608)
print v(xbgr.mr_n74572928)
print v(xbgr.mr_n74573040)
print v(xbgr.mr_n74573360)
print v(xbgr.mr_n74573472)
print v(xbgr.mr_n74573792)
print v(xbgr.mr_n74573904)
print v(xbgr.mr_n74574224)
print v(xbgr.mr_n74574336)
print v(xbgr.mr_n74574656)
print v(xbgr.mr_n74574768)
print v(xbgr.mr_n74575088)
print v(xbgr.mr_n74575200)
print v(xbgr.mr_n74575520)
print v(xbgr.mr_n74575632)
print v(xbgr.mr_n74575952)
print v(xbgr.mr_n74576064)
print v(xbgr.mr_n74576384)
print v(xbgr.mr_n74576496)
print v(xbgr.mr_n74576816)
print v(xbgr.mr_n74576928)
print v(xbgr.mr_n74577248)
print v(xbgr.mr_n74577360)
print v(xbgr.mr_n74577680)
print v(xbgr.mr_n74577792)
print v(xbgr.mr_n74578112)
print v(xbgr.mr_n74578224)
print v(xbgr.mr_n74578544)
print v(xbgr.mr_n74578656)
print v(xbgr.mr_n74578976)
print v(xbgr.mr_n74579088)
print v(xbgr.mr_n74579408)
print v(xbgr.mr_n74579520)
print v(xbgr.mr_n74579840)
print v(xbgr.mr_n74579952)
print v(xbgr.mr_n74580272)
print v(xbgr.mr_n74580384)
print v(xbgr.mr_n74580704)
print v(xbgr.mr_n74580816)
print v(xbgr.mr_n74581136)
print v(xbgr.mr_n74581248)
print v(xbgr.mr_n74581568)
print v(xbgr.mr_n74581680)
print v(xbgr.mr_n74582000)
print v(xbgr.mr_n74582112)
print v(xbgr.mr_n74582432)
print v(xbgr.mr_n74582544)
print v(xbgr.mr_n74582864)
print v(xbgr.mr_n74582976)
print v(xbgr.mr_n74583296)
print v(xbgr.mr_n74583408)
print v(xbgr.mr_n74583728)
print v(xbgr.mr_n74583840)
print v(xbgr.mr_n74584160)
print v(xbgr.mr_n74584272)
print v(xbgr.mr_n74584592)
print v(xbgr.mr_n74584704)
print v(xbgr.mr_n74585024)
print v(xbgr.mr_n74585136)
print v(xbgr.mr_n74585456)
print v(xbgr.mr_n74585568)
print v(xbgr.mr_n74585888)
print v(xbgr.mr_n74586000)
print v(xbgr.mr_n74586320)
print v(xbgr.mr_n74586432)
print v(xbgr.mr_n74586752)
print v(xbgr.mr_n74586864)
print v(xbgr.mr_n74587184)
print v(xbgr.mr_n74587296)
print v(xbgr.mr_n74587616)
print v(xbgr.mr_n74587728)
print v(xbgr.mr_n74588048)
print v(xbgr.mr_n74588160)
print v(xbgr.mr_n74588480)
print v(xbgr.mr_n74588592)
print v(xbgr.mr_n74588912)
print v(xbgr.mr_n74589024)
print v(xbgr.mr_n74589344)
print v(xbgr.mr_n74589456)
print v(xbgr.mr_n74589776)
print v(xbgr.mr_n74589888)
print v(xbgr.mr_n74590208)
print v(xbgr.mr_n74590320)
print v(xbgr.mr_n74590640)
print v(xbgr.mr_n74590752)
print v(xbgr.mr_n74591072)
print v(xbgr.mr_n74591184)
print v(xbgr.mr_n74591504)
print v(xbgr.mr_n74591616)
print v(xbgr.mr_n74591936)
print v(xbgr.mr_n74592048)
print v(xbgr.mr_n74592368)
print v(xbgr.mr_n74592480)
print v(xbgr.mr_n74592800)
print v(xbgr.mr_n74592912)
print v(xbgr.mr_n74593232)
print v(xbgr.mr_n74593344)
print v(xbgr.mr_n74593664)
print v(xbgr.mr_n74593776)
print v(xbgr.mr_n74594096)
print v(xbgr.mr_n74594208)
print v(xbgr.mr_n74594528)
print v(xbgr.mr_n74594640)
print v(xbgr.mr_n74594960)
print v(xbgr.mr_n74595072)
print v(xbgr.mr_n74595392)
print v(xbgr.mr_n74595504)
print v(xbgr.mr_n74595824)
print v(xbgr.mr_n74595936)
print v(xbgr.mr_n74596256)
print v(xbgr.mr_n74596368)
print v(xbgr.mr_n74596688)
print v(xbgr.mr_n74596800)
print v(xbgr.mr_n74597120)
print v(xbgr.mr_n74597232)
print v(xbgr.mr_n74597552)
print v(xbgr.mr_n74597664)
print v(xbgr.mr_n74597984)
print v(xbgr.mr_n74598096)
print v(xbgr.mr_n74598416)
print v(xbgr.mr_n74598528)
print v(xbgr.mr_n74598848)
print v(xbgr.mr_n74598960)
print v(xbgr.mr_n74599280)
print v(xbgr.mr_n74599392)
print v(xbgr.mr_n74599712)
print v(xbgr.mr_n74599824)
print v(xbgr.mr_n74600144)
print v(xbgr.mr_n74600256)
print v(xbgr.mr_n74600576)
print v(xbgr.mr_n74600688)
print v(xbgr.mr_n74601008)
print v(xbgr.mr_n74601120)
print v(xbgr.mr_n74601440)
print v(xbgr.mr_n74601552)
print v(xbgr.mr_n74601872)
print v(xbgr.mr_n74601984)
print v(xbgr.mr_n74602304)
print v(xbgr.mr_n74602416)
print v(xbgr.mr_n74602736)
print v(xbgr.mr_n74602848)
print v(xbgr.mr_n74603168)
print v(xbgr.mr_n74603280)
print v(xbgr.mr_n74603600)
print v(xbgr.mr_n74603712)
print v(xbgr.mr_n74866192)
print v(xbgr.mr_n74866432)
print v(xbgr.mr_n74866544)
print v(xbgr.mr_n74866864)
print v(xbgr.mr_n74866976)
print v(xbgr.mr_n74867296)
print v(xbgr.mr_n74867408)
print v(xbgr.mr_n74867728)
print v(xbgr.mr_n74867840)
print v(xbgr.mr_n74868160)
print v(xbgr.mr_n74868272)
print v(xbgr.mr_n74868592)
print v(xbgr.mr_n74868704)
print v(xbgr.mr_n74869024)
print v(xbgr.mr_n74869136)
print v(xbgr.mr_n74869456)
print v(xbgr.mr_n74869568)
print v(xbgr.mr_n74869888)
print v(xbgr.mr_n74870000)
print v(xbgr.mr_n74870320)
print v(xbgr.mr_n74870432)
print v(xbgr.mr_n74870752)
print v(xbgr.mr_n74870864)
print v(xbgr.mr_n74871184)
print v(xbgr.mr_n74871296)
print v(xbgr.mr_n74871616)
print v(xbgr.mr_n74871728)
print v(xbgr.mr_n74872048)
print v(xbgr.mr_n74872160)
print v(xbgr.mr_n74872480)
print v(xbgr.mr_n74872592)
print v(xbgr.mr_n74872912)
print v(xbgr.mr_n74873024)
print v(xbgr.mr_n74873344)
print v(xbgr.mr_n74873456)
print v(xbgr.mr_n74873776)
print v(xbgr.mr_n74873888)
print v(xbgr.mr_n74874208)
print v(xbgr.mr_n74874320)
print v(xbgr.mr_n74874640)
print v(xbgr.mr_n74874752)
print v(xbgr.mr_n74875072)
print v(xbgr.mr_n74875184)
print v(xbgr.mr_n74875504)
print v(xbgr.mr_n74875616)
print v(xbgr.mr_n74875936)
print v(xbgr.mr_n74876048)
print v(xbgr.mr_n74876368)
print v(xbgr.mr_n74876480)
print v(xbgr.mr_n74876800)
print v(xbgr.mr_n74876912)
print v(xbgr.mr_n74877232)
print v(xbgr.mr_n74877344)
print v(xbgr.mr_n74877664)
print v(xbgr.mr_n74877776)
print v(xbgr.mr_n74878096)
print v(xbgr.mr_n74878208)
print v(xbgr.mr_n74878528)
print v(xbgr.mr_n74878640)
print v(xbgr.mr_n74878960)
print v(xbgr.mr_n74879072)
print v(xbgr.mr_n74879392)
print v(xbgr.mr_n74879504)
print v(xbgr.mr_n74879824)
print v(xbgr.mr_n74879936)
print v(xbgr.mr_n74880256)
print v(xbgr.mr_n74880368)
print v(xbgr.mr_n74880688)
print v(xbgr.mr_n74880800)
print v(xbgr.mr_n74881120)
print v(xbgr.mr_n74881232)
print v(xbgr.mr_n74881552)
print v(xbgr.mr_n74881664)
print v(xbgr.mr_n74881984)
print v(xbgr.mr_n74882096)
print v(xbgr.mr_n74882416)
print v(xbgr.mr_n74882528)
print v(xbgr.mr_n74882848)
print v(xbgr.mr_n74882960)
print v(xbgr.mr_n74883280)
print v(xbgr.mr_n74883392)
print v(xbgr.mr_n74883712)
print v(xbgr.mr_n74883824)
print v(xbgr.mr_n74884144)
print v(xbgr.mr_n74884256)
print v(xbgr.mr_n74884576)
print v(xbgr.mr_n74884688)
print v(xbgr.mr_n74885008)
print v(xbgr.mr_n74885120)
print v(xbgr.mr_n74885440)
print v(xbgr.mr_n74885552)
print v(xbgr.mr_n74885872)
print v(xbgr.mr_n74885984)
print v(xbgr.mr_n74886304)
print v(xbgr.mr_n74886416)
print v(xbgr.mr_n74886736)
print v(xbgr.mr_n74886848)
print v(xbgr.mr_n74887168)
print v(xbgr.mr_n74887280)
print v(xbgr.mr_n74887600)
print v(xbgr.mr_n74887712)
print v(xbgr.mr_n74888032)
print v(xbgr.mr_n74888144)
print v(xbgr.mr_n74888464)
print v(xbgr.mr_n74888576)
print v(xbgr.mr_n74888896)
print v(xbgr.mr_n74889008)
print v(xbgr.mr_n74889328)
print v(xbgr.mr_n74889440)
print v(xbgr.mr_n74889760)
print v(xbgr.mr_n74889872)
print v(xbgr.mr_n74890192)
print v(xbgr.mr_n74890304)
print v(xbgr.mr_n74890624)
print v(xbgr.mr_n74890736)
print v(xbgr.mr_n74891056)
print v(xbgr.mr_n74891168)
print v(xbgr.mr_n74891488)
print v(xbgr.mr_n74891600)
print v(xbgr.mr_n74891920)
print v(xbgr.mr_n74892032)
print v(xbgr.mr_n74892352)
print v(xbgr.mr_n74892464)
print v(xbgr.mr_n74892784)
print v(xbgr.mr_n74892896)
print v(xbgr.mr_n74893216)
print v(xbgr.mr_n74893328)
print v(xbgr.mr_n74893648)
print v(xbgr.mr_n74893760)
print v(xbgr.mr_n74894080)
print v(xbgr.mr_n74894192)
print v(xbgr.mr_n74894512)
print v(xbgr.mr_n74894624)
print v(xbgr.mr_n74894944)
print v(xbgr.mr_n74895056)
print v(xbgr.mr_n74895376)
print v(xbgr.mr_n74895488)
print v(xbgr.mr_n74895808)
print v(xbgr.mr_n74895920)
print v(xbgr.mr_n74896240)
print v(xbgr.mr_n74896352)
print v(xbgr.mr_n74896672)
print v(xbgr.mr_n74896784)
print v(xbgr.mr_n74897104)
print v(xbgr.mr_n74897216)
print v(xbgr.mr_n74897536)
print v(xbgr.mr_n74897648)
print v(xbgr.mr_n74897968)
print v(xbgr.mr_n74898080)
print v(xbgr.mr_n74898400)
print v(xbgr.mr_n74898512)
print v(xbgr.mr_n74898832)
print v(xbgr.mr_n74898944)
print v(xbgr.mr_n74899264)
print v(xbgr.mr_n74899376)
print v(xbgr.mr_n74899696)
print v(xbgr.mr_n74899808)
print v(xbgr.mr_n74900128)
print v(xbgr.mr_n74900240)
print v(xbgr.mr_n74900560)
print v(xbgr.mr_n74900672)
print v(xbgr.mr_n74900992)
print v(xbgr.mr_n74901104)
print v(xbgr.mr_n74901424)
print v(xbgr.mr_n74901536)
print v(xbgr.mr_n74901856)
print v(xbgr.mr_n74901968)
print v(xbgr.mr_n74902288)
print v(xbgr.mr_n74902400)
print v(xbgr.mr_n74902720)
print v(xbgr.mr_n74902832)
print v(xbgr.mr_n74903152)
print v(xbgr.mr_n74903264)
print v(xbgr.mr_n74903584)
print v(xbgr.mr_n74903696)
print v(xbgr.mr_n74904016)
print v(xbgr.mr_n74904128)
print v(xbgr.mr_n74904448)
print v(xbgr.mr_n74904560)
print v(xbgr.mr_n74904880)
print v(xbgr.mr_n74904992)
print v(xbgr.mr_n74905312)
print v(xbgr.mr_n74905424)
print v(xbgr.mr_n74905744)
print v(xbgr.mr_n74905856)
print v(xbgr.mr_n74906176)
print v(xbgr.mr_n74906288)
print v(xbgr.mr_n74906608)
print v(xbgr.mr_n74906720)
print v(xbgr.mr_n74907040)
print v(xbgr.mr_n74907152)
print v(xbgr.mr_n74907472)
print v(xbgr.mr_n74907584)
print v(xbgr.mr_n74907904)
print v(xbgr.mr_n74908016)
print v(xbgr.mr_n74908336)
print v(xbgr.mr_n74908448)
print v(xbgr.mr_n74908768)
print v(xbgr.mr_n74908880)
print v(xbgr.mr_n74909200)
print v(xbgr.mr_n74909312)
print v(xbgr.mr_n74909632)
print v(xbgr.mr_n74909744)
print v(xbgr.mr_n74910064)
print v(xbgr.mr_n74910176)
print v(xbgr.mr_n74910496)
print v(xbgr.mr_n74910608)
print v(xbgr.mr_n74910928)
print v(xbgr.mr_n74911040)
print v(xbgr.mr_n74911360)
print v(xbgr.mr_n74911472)
print v(xbgr.mr_n74911792)
print v(xbgr.mr_n74911904)
print v(xbgr.mr_n74912224)
print v(xbgr.mr_n74912336)
print v(xbgr.mr_n74912656)
print v(xbgr.mr_n74912768)
print v(xbgr.mr_n74913088)
print v(xbgr.mr_n74913200)
print v(xbgr.mr_n74913520)
print v(xbgr.mr_n74913632)
print v(xbgr.mr_n74913952)
print v(xbgr.mr_n74914064)
print v(xbgr.mr_n74914384)
print v(xbgr.mr_n74914496)
print v(xbgr.mr_n74914816)
print v(xbgr.mr_n74914928)
print v(xbgr.mr_n74915248)
print v(xbgr.mr_n74915360)
print v(xbgr.mr_n74915680)
print v(xbgr.mr_n74915792)
print v(xbgr.mr_n74916112)
print v(xbgr.mr_n74916224)
print v(xbgr.mr_n74916544)
print v(xbgr.mr_n74916656)
print v(xbgr.mr_n74916976)
print v(xbgr.mr_n74917088)
print v(xbgr.mr_n74917408)
print v(xbgr.mr_n74917520)
print v(xbgr.mr_n74917840)
print v(xbgr.mr_n74917952)
print v(xbgr.mr_n74918272)
print v(xbgr.mr_n74918384)
print v(xbgr.mr_n74918704)
print v(xbgr.mr_n74918816)
print v(xbgr.mr_n74919136)
print v(xbgr.mr_n74919248)
print v(xbgr.mr_n74919568)
print v(xbgr.mr_n74919680)
print v(xbgr.mr_n74920000)
print v(xbgr.mr_n74920112)
print v(xbgr.mr_n74920432)
print v(xbgr.mr_n74920544)
print v(xbgr.mr_n74920864)
print v(xbgr.mr_n74920976)
print v(xbgr.mr_n74921296)
print v(xbgr.mr_n74921408)
print v(xbgr.mr_n74921728)
print v(xbgr.mr_n74921840)
print v(xbgr.mr_n74922160)
print v(xbgr.mr_n74922272)
print v(xbgr.mr_n74922592)
print v(xbgr.mr_n74922704)
print v(xbgr.mr_n74923024)
print v(xbgr.mr_n74923136)
print v(xbgr.mr_n74923456)
print v(xbgr.mr_n74923568)
print v(xbgr.mr_n74923888)
print v(xbgr.mr_n74924000)
print v(xbgr.mr_n74924320)
print v(xbgr.mr_n74924432)
print v(xbgr.mr_n74924752)
print v(xbgr.mr_n74924864)
print v(xbgr.mr_n74925184)
print v(xbgr.mr_n74925296)
print v(xbgr.mr_n74925616)
print v(xbgr.mr_n74925728)
print v(xbgr.mr_n74926048)
print v(xbgr.mr_n74926160)
print v(xbgr.mr_n74926480)
print v(xbgr.mr_n74926592)
print v(xbgr.mr_n74926912)
print v(xbgr.mr_n74927024)
print v(xbgr.mr_n74927344)
print v(xbgr.mr_n74927456)
print v(xbgr.mr_n74927776)
print v(xbgr.mr_n74927888)
print v(xbgr.mr_n74928208)
print v(xbgr.mr_n74928320)
print v(xbgr.mr_n74928640)
print v(xbgr.mr_n74928752)
print v(xbgr.mr_n74929072)
print v(xbgr.mr_n74929184)
print v(xbgr.mr_n74929504)
print v(xbgr.mr_n74929616)
print v(xbgr.mr_n74929936)
print v(xbgr.mr_n74930048)
print v(xbgr.mr_n74930368)
print v(xbgr.mr_n74930480)
print v(xbgr.mr_n74930800)
print v(xbgr.mr_n74930912)
print v(xbgr.mr_n74931232)
print v(xbgr.mr_n74931344)
print v(xbgr.mr_n74931664)
print v(xbgr.mr_n74931776)
print v(xbgr.mr_n74932096)
print v(xbgr.mr_n74932208)
print v(xbgr.mr_n74932528)
print v(xbgr.mr_n74932640)
print v(xbgr.mr_n74932960)
print v(xbgr.mr_n74933072)
print v(xbgr.mr_n74933392)
print v(xbgr.mr_n74933504)
print v(xbgr.mr_n74933824)
print v(xbgr.mr_n74933936)
print v(xbgr.mr_n74934256)
print v(xbgr.mr_n74934368)
print v(xbgr.mr_n74934688)
print v(xbgr.mr_n74934800)
print v(xbgr.mr_n74935120)
print v(xbgr.mr_n74935232)
print v(xbgr.mr_n74935552)
print v(xbgr.mr_n74935664)
print v(xbgr.mr_n74935984)
print v(xbgr.mr_n74936096)
print v(xbgr.mr_n74936416)
print v(xbgr.mr_n74936528)
print v(xbgr.mr_n74936848)
print v(xbgr.mr_n74936960)
print v(xbgr.mr_n74937280)
print v(xbgr.mr_n74937392)
print v(xbgr.mr_n74937712)
print v(xbgr.mr_n74937824)
print v(xbgr.mr_n74938144)
print v(xbgr.mr_n74938256)
print v(xbgr.mr_n74938576)
print v(xbgr.mr_n74938688)
print v(xbgr.mr_n74939008)
print v(xbgr.mr_n74939120)
print v(xbgr.mr_n74939440)
print v(xbgr.mr_n74939552)
print v(xbgr.mr_n74939872)
print v(xbgr.mr_n74939984)
print v(xbgr.mr_n74940304)
print v(xbgr.mr_n74940416)
print v(xbgr.mr_n74940736)
print v(xbgr.mr_n74940848)
print v(xbgr.mr_n74941168)
print v(xbgr.mr_n74941280)
print v(xbgr.mr_n74941600)
print v(xbgr.mr_n74941712)
print v(xbgr.mr_n74942032)
print v(xbgr.mr_n74942144)
print v(xbgr.mr_n74942464)
print v(xbgr.mr_n74942576)
print v(xbgr.mr_n74942896)
print v(xbgr.mr_n74943008)
print v(xbgr.mr_n74943328)
print v(xbgr.mr_n74943440)
print v(xbgr.mr_n74943760)
print v(xbgr.mr_n74943872)
print v(xbgr.mr_n74944192)
print v(xbgr.mr_n74944304)
print v(xbgr.mr_n74944624)
print v(xbgr.mr_n74944736)
print v(xbgr.mr_n74945056)
print v(xbgr.mr_n74945168)
print v(xbgr.mr_n74945488)
print v(xbgr.mr_n74945600)
print v(xbgr.mr_n74945920)
print v(xbgr.mr_n74946032)
print v(xbgr.mr_n74946352)
print v(xbgr.mr_n74946464)
print v(xbgr.mr_n74946784)
print v(xbgr.mr_n74946896)
print v(xbgr.mr_n74947216)
print v(xbgr.mr_n74947328)
print v(xbgr.mr_n74947648)
print v(xbgr.mr_n74947760)
print v(xbgr.mr_n74948080)
print v(xbgr.mr_n74948192)
print v(xbgr.mr_n74948512)
print v(xbgr.mr_n74948624)
print v(xbgr.mr_n74948944)
print v(xbgr.mr_n74949056)
print v(xbgr.mr_n74949376)
print v(xbgr.mr_n74949488)
print v(xbgr.mr_n74949808)
print v(xbgr.mr_n74949920)
print v(xbgr.mr_n74950240)
print v(xbgr.mr_n74950352)
print v(xbgr.mr_n74950672)
print v(xbgr.mr_n74950784)
print v(xbgr.mr_n74951104)
print v(xbgr.mr_n74951216)
print v(xbgr.mr_n74951536)
print v(xbgr.mr_n74951648)
print v(xbgr.mr_n74951968)
print v(xbgr.mr_n74952080)
print v(xbgr.mr_n74952400)
print v(xbgr.mr_n74952512)
print v(xbgr.mr_n74952832)
print v(xbgr.mr_n74952944)
print v(xbgr.mr_n74953264)
print v(xbgr.mr_n74953376)
print v(xbgr.mr_n74953696)
print v(xbgr.mr_n74953808)
print v(xbgr.mr_n74954128)
print v(xbgr.mr_n74954240)
print v(xbgr.mr_n74954560)
print v(xbgr.mr_n74954672)
print v(xbgr.mr_n74954992)
print v(xbgr.mr_n74955104)
print v(xbgr.mr_n74955424)
print v(xbgr.mr_n74955536)
print v(xbgr.mr_n74955856)
print v(xbgr.mr_n74955968)
print v(xbgr.mr_n74956288)
print v(xbgr.mr_n74956400)
print v(xbgr.mr_n74956720)
print v(xbgr.mr_n74956832)
print v(xbgr.mr_n74957152)
print v(xbgr.mr_n74957264)
print v(xbgr.mr_n74957584)
print v(xbgr.mr_n74957696)
print v(xbgr.mr_n74958016)
print v(xbgr.mr_n74958128)
print v(xbgr.mr_n74958448)
print v(xbgr.mr_n74958560)
print v(xbgr.mr_n74958880)
print v(xbgr.mr_n74958992)
print v(xbgr.mr_n74959312)
print v(xbgr.mr_n74959424)
print v(xbgr.mr_n74959744)
print v(xbgr.mr_n74959856)
print v(xbgr.mr_n74960176)
print v(xbgr.mr_n74960288)
print v(xbgr.mr_n74960608)
print v(xbgr.mr_n74960720)
print v(xbgr.mr_n74961040)
print v(xbgr.mr_n74961152)
print v(xbgr.mr_n74961472)
print v(xbgr.mr_n74961584)
print v(xbgr.mr_n74961904)
print v(xbgr.mr_n74962016)
print v(xbgr.mr_n74962336)
print v(xbgr.mr_n74962448)
print v(xbgr.mr_n74962768)
print v(xbgr.mr_n74962880)
print v(xbgr.mr_n74963200)
print v(xbgr.mr_n74963312)
print v(xbgr.mr_n74963632)
print v(xbgr.mr_n74963744)
print v(xbgr.mr_n74964064)
print v(xbgr.mr_n74964176)
print v(xbgr.mr_n74964496)
print v(xbgr.mr_n74964608)
print v(xbgr.mr_n74964928)
print v(xbgr.mr_n74965040)
print v(xbgr.mr_n74965360)
print v(xbgr.mr_n74965472)
print v(xbgr.mr_n74965792)
print v(xbgr.mr_n74965904)
print v(xbgr.mr_n74966224)
print v(xbgr.mr_n74966336)
print v(xbgr.mr_n74966656)
print v(xbgr.mr_n74966768)
print v(xbgr.mr_n74967088)
print v(xbgr.mr_n74967200)
print v(xbgr.mr_n74967520)
print v(xbgr.mr_n74967632)
print v(xbgr.mr_n74967952)
print v(xbgr.mr_n74968064)
print v(xbgr.mr_n74968384)
print v(xbgr.mr_n74968496)
print v(xbgr.mr_n74968816)
print v(xbgr.mr_n74968928)
print v(xbgr.mr_n74969248)
print v(xbgr.mr_n74969360)
print v(xbgr.mr_n74969680)
print v(xbgr.mr_n74969792)
print v(xbgr.mr_n74970112)
print v(xbgr.mr_n74970224)
print v(xbgr.mr_n74970544)
print v(xbgr.mr_n74970656)
print v(xbgr.mr_n74970976)
print v(xbgr.mr_n74971088)
print v(xbgr.mr_n74971408)
print v(xbgr.mr_n74971520)
print v(xbgr.mr_n74971840)
print v(xbgr.mr_n74971952)
print v(xbgr.mr_n74972272)
print v(xbgr.mr_n74972384)
print v(xbgr.mr_n74972704)
print v(xbgr.mr_n74972816)
print v(xbgr.mr_n74973136)
print v(xbgr.mr_n74973248)
print v(xbgr.mr_n74973568)
print v(xbgr.mr_n74973680)
print v(xbgr.mr_n74974000)
print v(xbgr.mr_n74974112)
print v(xbgr.mr_n74974432)
print v(xbgr.mr_n74974544)
print v(xbgr.mr_n74974864)
print v(xbgr.mr_n74974976)
print v(xbgr.mr_n74975296)
print v(xbgr.mr_n74975408)
print v(xbgr.mr_n74975728)
print v(xbgr.mr_n74975840)
print v(xbgr.mr_n74976160)
print v(xbgr.mr_n74976272)
print v(xbgr.mr_n74976592)
print v(xbgr.mr_n74976704)
print v(xbgr.mr_n74977024)
print v(xbgr.mr_n74977136)
print v(xbgr.mr_n74977456)
print v(xbgr.mr_n74977568)
print v(xbgr.mr_n74977888)
print v(xbgr.mr_n74978000)
print v(xbgr.mr_n74978320)
print v(xbgr.mr_n74978432)
print v(xbgr.mr_n74978752)
print v(xbgr.mr_n74978864)
print v(xbgr.mr_n74979184)
print v(xbgr.mr_n74979296)
print v(xbgr.mr_n74979616)
print v(xbgr.mr_n74979728)
print v(xbgr.mr_n74980048)
print v(xbgr.mr_n74980160)
print v(xbgr.mr_n74980480)
print v(xbgr.mr_n74980592)
print v(xbgr.mr_n74980912)
print v(xbgr.mr_n74981024)
print v(xbgr.mr_n74981344)
print v(xbgr.mr_n74981456)
print v(xbgr.mr_n74981776)
print v(xbgr.mr_n74981888)
print v(xbgr.mr_n74982208)
print v(xbgr.mr_n74982320)
print v(xbgr.mr_n74982640)
print v(xbgr.mr_n74982752)
print v(xbgr.mr_n74983072)
print v(xbgr.mr_n74983184)
print v(xbgr.mr_n74983504)
print v(xbgr.mr_n74983616)
print v(xbgr.mr_n74983936)
print v(xbgr.mr_n74984048)
print v(xbgr.mr_n74984368)
print v(xbgr.mr_n74984480)
print v(xbgr.mr_n74984800)
print v(xbgr.mr_n74984912)
print v(xbgr.mr_n74985232)
print v(xbgr.mr_n74985344)
print v(xbgr.mr_n74985664)
print v(xbgr.mr_n74985776)
print v(xbgr.mr_n74986096)
print v(xbgr.mr_n74986208)
print v(xbgr.mr_n74986528)
print v(xbgr.mr_n74986640)
print v(xbgr.mr_n74986960)
print v(xbgr.mr_n74987072)
print v(xbgr.mr_n74987392)
print v(xbgr.mr_n74987504)
print v(xbgr.mr_n74987824)
print v(xbgr.mr_n74987936)
print v(xbgr.mr_n74988256)
print v(xbgr.mr_n74988368)
print v(xbgr.mr_n74988688)
print v(xbgr.mr_n74988800)
print v(xbgr.mr_n74989120)
print v(xbgr.mr_n74989232)
print v(xbgr.mr_n74989552)
print v(xbgr.mr_n74989664)
print v(xbgr.mr_n74989984)
print v(xbgr.mr_n74990096)
print v(xbgr.mr_n74990416)
print v(xbgr.mr_n74990528)
print v(xbgr.mr_n74990848)
print v(xbgr.mr_n74990960)
print v(xbgr.mr_n74991280)
print v(xbgr.mr_n74991392)
print v(xbgr.mr_n74991712)
print v(xbgr.mr_n74991824)
print v(xbgr.mr_n74992144)
print v(xbgr.mr_n74992256)
print v(xbgr.mr_n74992576)
print v(xbgr.mr_n74992688)
print v(xbgr.mr_n74993008)
print v(xbgr.mr_n74993120)
print v(xbgr.mr_n74993440)
print v(xbgr.mr_n74993552)
print v(xbgr.mr_n74993872)
print v(xbgr.mr_n74993984)
print v(xbgr.mr_n74994304)
print v(xbgr.mr_n74994416)
print v(xbgr.mr_n74994736)
print v(xbgr.mr_n74994848)
print v(xbgr.mr_n74995168)
print v(xbgr.mr_n74995280)
print v(xbgr.mr_n74995600)
print v(xbgr.mr_n74995712)
print v(xbgr.mr_n74996032)
print v(xbgr.mr_n74996144)
print v(xbgr.mr_n74996464)
print v(xbgr.mr_n74996576)
print v(xbgr.mr_n74996896)
print v(xbgr.mr_n74997008)
print v(xbgr.mr_n74997328)
print v(xbgr.mr_n74997440)
print v(xbgr.mr_n74997760)
print v(xbgr.mr_n74997872)
print v(xbgr.mr_n74998192)
print v(xbgr.mr_n74998304)
print v(xbgr.mr_n74998624)
print v(xbgr.mr_n74998736)
print v(xbgr.mr_n74999056)
print v(xbgr.mr_n74999168)
print v(xbgr.mr_n74999488)
print v(xbgr.mr_n74999600)
print v(xbgr.mr_n74999920)
print v(xbgr.mr_n75000032)
print v(xbgr.mr_n75000352)
print v(xbgr.mr_n75000464)
print v(xbgr.mr_n75000784)
print v(xbgr.mr_n75000896)
print v(xbgr.mr_n75001216)
print v(xbgr.mr_n75001328)
print v(xbgr.mr_n75001648)
print v(xbgr.mr_n75001760)
print v(xbgr.mr_n75002080)
print v(xbgr.mr_n75002192)
print v(xbgr.mr_n75002512)
print v(xbgr.mr_n75002624)
print v(xbgr.mr_n75002944)
print v(xbgr.mr_n75003056)
print v(xbgr.mr_n75003376)
print v(xbgr.mr_n75003488)
print v(xbgr.mr_n75003808)
print v(xbgr.mr_n75003920)
print v(xbgr.mr_n75004240)
print v(xbgr.mr_n75004352)
print v(xbgr.mr_n75004672)
print v(xbgr.mr_n75004784)
print v(xbgr.mr_n75005104)
print v(xbgr.mr_n75005216)
print v(xbgr.mr_n75005536)
print v(xbgr.mr_n75005648)
print v(xbgr.mr_n75005968)
print v(xbgr.mr_n75006080)
print v(xbgr.mr_n75006400)
print v(xbgr.mr_n75006512)
print v(xbgr.mr_n75006832)
print v(xbgr.mr_n75006944)
print v(xbgr.mr_n75007264)
print v(xbgr.mr_n75007376)
print v(xbgr.mr_n75007696)
print v(xbgr.mr_n75007808)
print v(xbgr.mr_n75008128)
print v(xbgr.mr_n75008240)
print v(xbgr.mr_n75008560)
print v(xbgr.mr_n75008672)
print v(xbgr.mr_n75008992)
print v(xbgr.mr_n75009104)
print v(xbgr.mr_n75009424)
print v(xbgr.mr_n75009536)
print v(xbgr.mr_n75009856)
print v(xbgr.mr_n75009968)
print v(xbgr.mr_n75010288)
print v(xbgr.mr_n75010400)
print v(xbgr.mr_n75010720)
print v(xbgr.mr_n75010832)
print v(xbgr.mr_n75011152)
print v(xbgr.mr_n75011264)
print v(xbgr.mr_n75011584)
print v(xbgr.mr_n75011696)
print v(xbgr.mr_n75012016)
print v(xbgr.mr_n75012128)
print v(xbgr.mr_n75012448)
print v(xbgr.mr_n75012560)
print v(xbgr.mr_n75012880)
print v(xbgr.mr_n75012992)
print v(xbgr.mr_n75013312)
print v(xbgr.mr_n75013424)
print v(xbgr.mr_n75013744)
print v(xbgr.mr_n75013856)
print v(xbgr.mr_n75014176)
print v(xbgr.mr_n75014288)
print v(xbgr.mr_n75014608)
print v(xbgr.mr_n75014720)
print v(xbgr.mr_n75015040)
print v(xbgr.mr_n75015152)
print v(xbgr.mr_n75015472)
print v(xbgr.mr_n75015584)
print v(xbgr.mr_n75015904)
print v(xbgr.mr_n75016016)
print v(xbgr.mr_n75016336)
print v(xbgr.mr_n75016448)
print v(xbgr.mr_n75016768)
print v(xbgr.mr_n75016880)
print v(xbgr.mr_n75017200)
print v(xbgr.mr_n75017312)
print v(xbgr.mr_n75017632)
print v(xbgr.mr_n75017744)
print v(xbgr.mr_n75018064)
print v(xbgr.mr_n75018176)
print v(xbgr.mr_n75018496)
print v(xbgr.mr_n75018608)
print v(xbgr.mr_n75018928)
print v(xbgr.mr_n75019040)
print v(xbgr.mr_n75019360)
print v(xbgr.mr_n75019472)
print v(xbgr.mr_n75019792)
print v(xbgr.mr_n75019904)
print v(xbgr.mr_n75020224)
print v(xbgr.mr_n75020336)
print v(xbgr.mr_n75020656)
print v(xbgr.mr_n75020768)
print v(xbgr.mr_n75021088)
print v(xbgr.mr_n75021200)
print v(xbgr.mr_n75021520)
print v(xbgr.mr_n75021632)
print v(xbgr.mr_n75021952)
print v(xbgr.mr_n75022064)
print v(xbgr.mr_n75022384)
print v(xbgr.mr_n75022496)
print v(xbgr.mr_n75022816)
print v(xbgr.mr_n75022928)
print v(xbgr.mr_n75023248)
print v(xbgr.mr_n75023360)
print v(xbgr.mr_n75023680)
print v(xbgr.mr_n75023792)
print v(xbgr.mr_n75024112)
print v(xbgr.mr_n75024224)
print v(xbgr.mr_n75024544)
print v(xbgr.mr_n75024656)
print v(xbgr.mr_n75024976)
print v(xbgr.mr_n75025088)
print v(xbgr.mr_n75025408)
print v(xbgr.mr_n75025520)
print v(xbgr.mr_n75025840)
print v(xbgr.mr_n75025952)
print v(xbgr.mr_n75026272)
print v(xbgr.mr_n75026384)
print v(xbgr.mr_n75026704)
print v(xbgr.mr_n75026816)
print v(xbgr.mr_n75027136)
print v(xbgr.mr_n75027248)
print v(xbgr.mr_n75027568)
print v(xbgr.mr_n75027680)
print v(xbgr.mr_n75028000)
print v(xbgr.mr_n75028112)
print v(xbgr.mr_n75028432)
print v(xbgr.mr_n75028544)
print v(xbgr.mr_n75028864)
print v(xbgr.mr_n75028976)
print v(xbgr.mr_n75029296)
print v(xbgr.mr_n75029408)
print v(xbgr.mr_n75029728)
print v(xbgr.mr_n75029840)
print v(xbgr.mr_n75030160)
print v(xbgr.mr_n75030272)
print v(xbgr.mr_n75030592)
print v(xbgr.mr_n75030704)
print v(xbgr.mr_n75031024)
print v(xbgr.mr_n75031136)
print v(xbgr.mr_n75031456)
print v(xbgr.mr_n75031568)
print v(xbgr.mr_n75031888)
print v(xbgr.mr_n75032000)
print v(xbgr.mr_n75032320)
print v(xbgr.mr_n75032432)
print v(xbgr.mr_n75032752)
print v(xbgr.mr_n75032864)
print v(xbgr.mr_n75033184)
print v(xbgr.mr_n75033296)
print v(xbgr.mr_n75033616)
print v(xbgr.mr_n75033728)
print v(xbgr.mr_n75034048)
print v(xbgr.mr_n75034160)
print v(xbgr.mr_n75034480)
print v(xbgr.mr_n75034592)
print v(xbgr.mr_n75034912)
print v(xbgr.mr_n75035024)
print v(xbgr.mr_n75035344)
print v(xbgr.mr_n75035456)
print v(xbgr.mr_n75035776)
print v(xbgr.mr_n75035888)
print v(xbgr.mr_n75036208)
print v(xbgr.mr_n75036320)
print v(xbgr.mr_n75036640)
print v(xbgr.mr_n75036752)
print v(xbgr.mr_n75037072)
print v(xbgr.mr_n75037184)
print v(xbgr.mr_n75037504)
print v(xbgr.mr_n75037616)
print v(xbgr.mr_n75037936)
print v(xbgr.mr_n75038048)
print v(xbgr.mr_n75038368)
print v(xbgr.mr_n75038480)
print v(xbgr.mr_n75038800)
print v(xbgr.mr_n75038912)
print v(xbgr.mr_n75039232)
print v(xbgr.mr_n75039344)
print v(xbgr.mr_n75039664)
print v(xbgr.mr_n75039776)
print v(xbgr.mr_n75040096)
print v(xbgr.mr_n75040208)
print v(xbgr.mr_n75040528)
print v(xbgr.mr_n75040640)
print v(xbgr.mr_n75040960)
print v(xbgr.mr_n75041072)
print v(xbgr.mr_n75041392)
print v(xbgr.mr_n75041504)
print v(xbgr.mr_n75041824)
print v(xbgr.mr_n75041936)
print v(xbgr.mr_n75042256)
print v(xbgr.mr_n75042368)
print v(xbgr.mr_n75042688)
print v(xbgr.mr_n75042800)
print v(xbgr.mr_n75043120)
print v(xbgr.mr_n75043232)
print v(xbgr.mr_n75043552)
print v(xbgr.mr_n75043664)
print v(xbgr.mr_n75043984)
print v(xbgr.mr_n75044096)
print v(xbgr.mr_n75044416)
print v(xbgr.mr_n75044528)
print v(xbgr.mr_n75044848)
print v(xbgr.mr_n75044960)
print v(xbgr.mr_n75045280)
print v(xbgr.mr_n75045392)
print v(xbgr.mr_n75045712)
print v(xbgr.mr_n75045824)
print v(xbgr.mr_n75046144)
print v(xbgr.mr_n75046256)
print v(xbgr.mr_n75046576)
print v(xbgr.mr_n75046688)
print v(xbgr.mr_n75047008)
print v(xbgr.mr_n75047120)
print v(xbgr.mr_n75047440)
print v(xbgr.mr_n75047552)
print v(xbgr.mr_n75047872)
print v(xbgr.mr_n75047984)
print v(xbgr.mr_n75048304)
print v(xbgr.mr_n75048416)
print v(xbgr.mr_n75048736)
print v(xbgr.mr_n75048848)
print v(xbgr.mr_n75049168)
print v(xbgr.mr_n75049280)
print v(xbgr.mr_n75049600)
print v(xbgr.mr_n75049712)
print v(xbgr.mr_n75050032)
print v(xbgr.mr_n75050144)
print v(xbgr.mr_n75050464)
print v(xbgr.mr_n75050576)
print v(xbgr.mr_n75050896)
print v(xbgr.mr_n75051008)
print v(xbgr.mr_n75051328)
print v(xbgr.mr_n75051440)
print v(xbgr.mr_n75051760)
print v(xbgr.mr_n75051872)
print v(xbgr.mr_n75052192)
print v(xbgr.mr_n75052304)
print v(xbgr.mr_n75052624)
print v(xbgr.mr_n75052736)
print v(xbgr.mr_n75053056)
print v(xbgr.mr_n75053168)
print v(xbgr.mr_n75053488)
print v(xbgr.mr_n75053600)
print v(xbgr.mr_n75053920)
print v(xbgr.mr_n75054032)
print v(xbgr.mr_n75054352)
print v(xbgr.mr_n75054464)
print v(xbgr.mr_n75054784)
print v(xbgr.mr_n75054896)
print v(xbgr.mr_n75055216)
print v(xbgr.mr_n75055328)
print v(xbgr.mr_n75055648)
print v(xbgr.mr_n75055760)
print v(xbgr.mr_n75056080)
print v(xbgr.mr_n75056192)
print v(xbgr.mr_n75056512)
print v(xbgr.mr_n75056624)
print v(xbgr.mr_n75056944)
print v(xbgr.mr_n75057056)
print v(xbgr.mr_n75057376)
print v(xbgr.mr_n75057488)
print v(xbgr.mr_n75057808)
print v(xbgr.mr_n75057920)
print v(xbgr.mr_n75058240)
print v(xbgr.mr_n75058352)
print v(xbgr.mr_n75058672)
print v(xbgr.mr_n75058784)
print v(xbgr.mr_n75059104)
print v(xbgr.mr_n75059216)
print v(xbgr.mr_n75059536)
print v(xbgr.mr_n75059648)
print v(xbgr.mr_n75059968)
print v(xbgr.mr_n75060080)
print v(xbgr.mr_n75060400)
print v(xbgr.mr_n75060512)
print v(xbgr.mr_n75060832)
print v(xbgr.mr_n75060944)
print v(xbgr.mr_n75061264)
print v(xbgr.mr_n75061376)
print v(xbgr.mr_n75061696)
print v(xbgr.mr_n75061808)
print v(xbgr.mr_n75062128)
print v(xbgr.mr_n75062240)
print v(xbgr.mr_n75062560)
print v(xbgr.mr_n75062672)
print v(xbgr.mr_n75062992)
print v(xbgr.mr_n75063104)
print v(xbgr.mr_n75063424)
print v(xbgr.mr_n75063536)
print v(xbgr.mr_n75063840)
print v(xbgr.mr_n75063952)
print v(xbgr.mr_n75064272)
print v(xbgr.mr_n75064384)
print v(xbgr.mr_n75064704)
print v(xbgr.mr_n75064816)
print v(xbgr.mr_n75065136)
print v(xbgr.mr_n75065248)
print v(xbgr.mr_n75065568)
print v(xbgr.mr_n75065680)
print v(xbgr.mr_n75066000)
print v(xbgr.mr_n75066112)
print v(xbgr.mr_n75066432)
print v(xbgr.mr_n75066544)
print v(xbgr.mr_n75066864)
print v(xbgr.mr_n75066976)
print v(xbgr.mr_n75067296)
print v(xbgr.mr_n75067408)
print v(xbgr.mr_n75067728)
print v(xbgr.mr_n75067840)
print v(xbgr.mr_n75068160)
print v(xbgr.mr_n75068272)
print v(xbgr.mr_n75068592)
print v(xbgr.mr_n75068704)
print v(xbgr.mr_n75069024)
print v(xbgr.mr_n75069136)
print v(xbgr.mr_n75069456)
print v(xbgr.mr_n75069568)
print v(xbgr.mr_n75069888)
print v(xbgr.mr_n75070000)
print v(xbgr.mr_n75070320)
print v(xbgr.mr_n75070432)
print v(xbgr.mr_n75070752)
print v(xbgr.mr_n75070864)
print v(xbgr.mr_n75071184)
print v(xbgr.mr_n75071296)
print v(xbgr.mr_n75071616)
print v(xbgr.mr_n75071728)
print v(xbgr.mr_n75072048)
print v(xbgr.mr_n75072160)
print v(xbgr.mr_n75072480)
print v(xbgr.mr_n75072592)
print v(xbgr.mr_n75072912)
print v(xbgr.mr_n75073024)
print v(xbgr.mr_n75073344)
print v(xbgr.mr_n75073456)
print v(xbgr.mr_n75073776)
print v(xbgr.mr_n75073888)
print v(xbgr.mr_n75074208)
print v(xbgr.mr_n75074320)
print v(xbgr.mr_n75074640)
print v(xbgr.mr_n75074752)
print v(xbgr.mr_n75075072)
print v(xbgr.mr_n75075184)
print v(xbgr.mr_n75075504)
print v(xbgr.mr_n75075616)
print v(xbgr.mr_n75075936)
print v(xbgr.mr_n75076048)
print v(xbgr.mr_n75076368)
print v(xbgr.mr_n75076480)
print v(xbgr.mr_n75076800)
print v(xbgr.mr_n75076912)
print v(xbgr.mr_n75077232)
print v(xbgr.mr_n75077344)
print v(xbgr.mr_n75077664)
print v(xbgr.mr_n75077776)
print v(xbgr.mr_n75078096)
print v(xbgr.mr_n75078208)
print v(xbgr.mr_n75078528)
print v(xbgr.mr_n75078640)
print v(xbgr.mr_n75078960)
print v(xbgr.mr_n75079072)
print v(xbgr.mr_n75079392)
print v(xbgr.mr_n75079504)
print v(xbgr.mr_n75079824)
print v(xbgr.mr_n75079936)
print v(xbgr.mr_n75080256)
print v(xbgr.mr_n75080368)
print v(xbgr.mr_n75080688)
print v(xbgr.mr_n75080800)
print v(xbgr.mr_n75081120)
print v(xbgr.mr_n75081232)
print v(xbgr.mr_n75081552)
print v(xbgr.mr_n75081664)
print v(xbgr.mr_n75081984)
print v(xbgr.mr_n75082096)
print v(xbgr.mr_n75082416)
print v(xbgr.mr_n75082528)
print v(xbgr.mr_n75082848)
print v(xbgr.mr_n75082960)
print v(xbgr.mr_n75083280)
print v(xbgr.mr_n75083392)
print v(xbgr.mr_n75083712)
print v(xbgr.mr_n75083824)
print v(xbgr.mr_n75084144)
print v(xbgr.mr_n75084256)
print v(xbgr.mr_n75084576)
print v(xbgr.mr_n75084688)
print v(xbgr.mr_n75085008)
print v(xbgr.mr_n75085120)
print v(xbgr.mr_n75085440)
print v(xbgr.mr_n75085552)
print v(xbgr.mr_n75085872)
print v(xbgr.mr_n75085984)
print v(xbgr.mr_n75086304)
print v(xbgr.mr_n75086416)
print v(xbgr.mr_n75086736)
print v(xbgr.mr_n75086848)
print v(xbgr.mr_n75087168)
print v(xbgr.mr_n75087280)
print v(xbgr.mr_n75087600)
print v(xbgr.mr_n75087712)
print v(xbgr.mr_n75088032)
print v(xbgr.mr_n75088144)
print v(xbgr.mr_n75088464)
print v(xbgr.mr_n75088576)
print v(xbgr.mr_n75088896)
print v(xbgr.mr_n75089008)
print v(xbgr.mr_n75089328)
print v(xbgr.mr_n75089440)
print v(xbgr.mr_n75089760)
print v(xbgr.mr_n75089872)
print v(xbgr.mr_n75090192)
print v(xbgr.mr_n75090304)
print v(xbgr.mr_n75090624)
print v(xbgr.mr_n75090736)
print v(xbgr.mr_n75091056)
print v(xbgr.mr_n75091168)
print v(xbgr.mr_n75091488)
print v(xbgr.mr_n75091600)
print v(xbgr.mr_n75091920)
print v(xbgr.mr_n75092032)
print v(xbgr.mr_n75092352)
print v(xbgr.mr_n75092464)
print v(xbgr.mr_n75092784)
print v(xbgr.mr_n75092896)
print v(xbgr.mr_n75093216)
print v(xbgr.mr_n75093328)
print v(xbgr.mr_n75093648)
print v(xbgr.mr_n75093760)
print v(xbgr.mr_n75094080)
print v(xbgr.mr_n75094192)
print v(xbgr.mr_n75094512)
print v(xbgr.mr_n75094624)
print v(xbgr.mr_n75094944)
print v(xbgr.mr_n75095056)
print v(xbgr.mr_n75095376)
print v(xbgr.mr_n75095488)
print v(xbgr.mr_n75095808)
print v(xbgr.mr_n75095920)
print v(xbgr.mr_n75096240)
print v(xbgr.mr_n75096352)
print v(xbgr.mr_n75096672)
print v(xbgr.mr_n75096784)
print v(xbgr.mr_n75097104)
print v(xbgr.mr_n75097216)
print v(xbgr.mr_n75097536)
print v(xbgr.mr_n75097648)
print v(xbgr.mr_n75097968)
print v(xbgr.mr_n75098080)
print v(xbgr.mr_n75098400)
print v(xbgr.mr_n75098512)
print v(xbgr.mr_n75098832)
print v(xbgr.mr_n75098944)
print v(xbgr.mr_n75099264)
print v(xbgr.mr_n75099376)
print v(xbgr.mr_n75099696)
print v(xbgr.mr_n75099808)
print v(xbgr.mr_n75100128)
print v(xbgr.mr_n75100240)
print v(xbgr.mr_n75100560)
print v(xbgr.mr_n75100672)
print v(xbgr.mr_n75100992)
print v(xbgr.mr_n75101104)
print v(xbgr.mr_n75101424)
print v(xbgr.mr_n75101536)
print v(xbgr.mr_n75101856)
print v(xbgr.mr_n75101968)
print v(xbgr.mr_n75102288)
print v(xbgr.mr_n75102400)
print v(xbgr.mr_n75102720)
print v(xbgr.mr_n75102832)
print v(xbgr.mr_n75103152)
print v(xbgr.mr_n75103264)
print v(xbgr.mr_n75103584)
print v(xbgr.mr_n75103696)
print v(xbgr.mr_n75104016)
print v(xbgr.mr_n75104128)
print v(xbgr.mr_n75104448)
print v(xbgr.mr_n75104560)
print v(xbgr.mr_n75104880)
print v(xbgr.mr_n75104992)
print v(xbgr.mr_n75105312)
print v(xbgr.mr_n75105424)
print v(xbgr.mr_n75105744)
print v(xbgr.mr_n75105856)
print v(xbgr.mr_n75106176)
print v(xbgr.mr_n75106288)
print v(xbgr.mr_n75106608)
print v(xbgr.mr_n75106720)
print v(xbgr.mr_n75107040)
print v(xbgr.mr_n75107152)
print v(xbgr.mr_n75107472)
print v(xbgr.mr_n75107584)
print v(xbgr.mr_n75107904)
print v(xbgr.mr_n75108016)
print v(xbgr.mr_n75108336)
print v(xbgr.mr_n75108448)
print v(xbgr.mr_n75108768)
print v(xbgr.mr_n75108880)
print v(xbgr.mr_n75109200)
print v(xbgr.mr_n75109312)
print v(xbgr.mr_n75109632)
print v(xbgr.mr_n75109744)
print v(xbgr.mr_n75110064)
print v(xbgr.mr_n75110176)
print v(xbgr.mr_n75110496)
print v(xbgr.mr_n75110608)
print v(xbgr.mr_n75110928)
print v(xbgr.mr_n75111040)
print v(xbgr.mr_n75111360)
print v(xbgr.mr_n75111472)
print v(xbgr.mr_n75111792)
print v(xbgr.mr_n75111904)
print v(xbgr.mr_n75112224)
print v(xbgr.mr_n75112336)
print v(xbgr.mr_n75112656)
print v(xbgr.mr_n75112768)
print v(xbgr.mr_n75113088)
print v(xbgr.mr_n75113200)
print v(xbgr.mr_n75113520)
print v(xbgr.mr_n75113632)
print v(xbgr.mr_n75113952)
print v(xbgr.mr_n75114064)
print v(xbgr.mr_n75114384)
print v(xbgr.mr_n75114496)
print v(xbgr.mr_n75114816)
print v(xbgr.mr_n75114928)
print v(xbgr.mr_n75115248)
print v(xbgr.mr_n75115360)
print v(xbgr.mr_n75115680)
print v(xbgr.mr_n75115792)
print v(xbgr.mr_n75116112)
print v(xbgr.mr_n75116224)
print v(xbgr.mr_n75116544)
print v(xbgr.mr_n75116656)
print v(xbgr.mr_n75116976)
print v(xbgr.mr_n75117088)
print v(xbgr.mr_n75117408)
print v(xbgr.mr_n75117520)
print v(xbgr.mr_n75117840)
print v(xbgr.mr_n75117952)
print v(xbgr.mr_n75118272)
print v(xbgr.mr_n75118384)
print v(xbgr.mr_n75118704)
print v(xbgr.mr_n75118816)
print v(xbgr.mr_n75119136)
print v(xbgr.mr_n75119248)
print v(xbgr.mr_n75119568)
print v(xbgr.mr_n75119680)
print v(xbgr.mr_n75120000)
print v(xbgr.mr_n75120112)
print v(xbgr.mr_n75120432)
print v(xbgr.mr_n75120544)
print v(xbgr.mr_n75120864)
print v(xbgr.mr_n75120976)
print v(xbgr.mr_n75121296)
print v(xbgr.mr_n75121408)
print v(xbgr.mr_n75121728)
print v(xbgr.mr_n75121840)
print v(xbgr.mr_n75122160)
print v(xbgr.mr_n75122272)
print v(xbgr.mr_n75122592)
print v(xbgr.mr_n75122704)
print v(xbgr.mr_n75123024)
print v(xbgr.mr_n75123136)
print v(xbgr.mr_n75123456)
print v(xbgr.mr_n75123568)
print v(xbgr.mr_n75123888)
print v(xbgr.mr_n75124000)
print v(xbgr.mr_n75124320)
print v(xbgr.mr_n75124432)
print v(xbgr.mr_n75124752)
print v(xbgr.mr_n75124864)
print v(xbgr.mr_n75125184)
print v(xbgr.mr_n75125296)
print v(xbgr.mr_n75125616)
print v(xbgr.mr_n75125728)
print v(xbgr.mr_n75126048)
print v(xbgr.mr_n75126160)
print v(xbgr.mr_n75126480)
print v(xbgr.mr_n75126592)
print v(xbgr.mr_n75126912)
print v(xbgr.mr_n75127024)
print v(xbgr.mr_n75127344)
print v(xbgr.mr_n75127456)
print v(xbgr.mr_n75127776)
print v(xbgr.mr_n75127888)
print v(xbgr.mr_n75128208)
print v(xbgr.mr_n75128320)
print v(xbgr.mr_n75128640)
print v(xbgr.mr_n75128752)
print v(xbgr.mr_n75129072)
print v(xbgr.mr_n75129184)
print v(xbgr.mr_n75129504)
print v(xbgr.mr_n75129616)
print v(xbgr.mr_n75129936)
print v(xbgr.mr_n75130048)
print v(xbgr.mr_n75130368)
print v(xbgr.mr_n75130480)
print v(xbgr.mr_n75130800)
print v(xbgr.mr_n75130912)
print v(xbgr.mr_n75131232)
print v(xbgr.mr_n75131344)
print v(xbgr.mr_n75131664)
print v(xbgr.mr_n75131776)
print v(xbgr.mr_n75132096)
print v(xbgr.mr_n75132208)
print v(xbgr.mr_n75132528)
print v(xbgr.mr_n75132640)
print v(xbgr.mr_n75132960)
print v(xbgr.mr_n75133072)
print v(xbgr.mr_n75133392)
print v(xbgr.mr_n75133504)
print v(xbgr.mr_n75133824)
print v(xbgr.mr_n75133936)
print v(xbgr.mr_n75134256)
print v(xbgr.mr_n75134368)
print v(xbgr.mr_n75134688)
print v(xbgr.mr_n75134800)
print v(xbgr.mr_n75135120)
print v(xbgr.mr_n75135232)
print v(xbgr.mr_n75135552)
print v(xbgr.mr_n75135664)
print v(xbgr.mr_n75135984)
print v(xbgr.mr_n75136096)
print v(xbgr.mr_n75136416)
print v(xbgr.mr_n75136528)
print v(xbgr.mr_n75136848)
print v(xbgr.mr_n75136960)
print v(xbgr.mr_n75137280)
print v(xbgr.mr_n75137392)
print v(xbgr.mr_n75137712)
print v(xbgr.mr_n75137824)
print v(xbgr.mr_n75138144)
print v(xbgr.mr_n75138256)
print v(xbgr.mr_n75138576)
print v(xbgr.mr_n75138688)
print v(xbgr.mr_n75139008)
print v(xbgr.mr_n75139120)
print v(xbgr.mr_n75139440)
print v(xbgr.mr_n75139552)
print v(xbgr.mr_n75139872)
print v(xbgr.mr_n75139984)
print v(xbgr.mr_n75140304)
print v(xbgr.mr_n75140416)
print v(xbgr.mr_n75140736)
print v(xbgr.mr_n75140848)
print v(xbgr.mr_n75141168)
print v(xbgr.mr_n75141280)
print v(xbgr.mr_n75141600)
print v(xbgr.mr_n75141712)
print v(xbgr.mr_n75142032)
print v(xbgr.mr_n75142144)
print v(xbgr.mr_n75142464)
print v(xbgr.mr_n75142576)
print v(xbgr.mr_n75142896)
print v(xbgr.mr_n75143008)
print v(xbgr.mr_n75143328)
print v(xbgr.mr_n75143440)
print v(xbgr.mr_n75143760)
print v(xbgr.mr_n75143872)
print v(xbgr.mr_n75144192)
print v(xbgr.mr_n75144304)
print v(xbgr.mr_n75144624)
print v(xbgr.mr_n75144736)
print v(xbgr.mr_n75145056)
print v(xbgr.mr_n75145168)
print v(xbgr.mr_n75145488)
print v(xbgr.mr_n75145600)
print v(xbgr.mr_n75145920)
print v(xbgr.mr_n75146032)
print v(xbgr.mr_n75146352)
print v(xbgr.mr_n75146464)
print v(xbgr.mr_n75146784)
print v(xbgr.mr_n75146896)
print v(xbgr.mr_n75147216)
print v(xbgr.mr_n75147328)
print v(xbgr.mr_n75147648)
print v(xbgr.mr_n75147760)
print v(xbgr.mr_n75148080)
print v(xbgr.mr_n75148192)
print v(xbgr.mr_n75148512)
print v(xbgr.mr_n75148624)
print v(xbgr.mr_n75148944)
print v(xbgr.mr_n75149056)
print v(xbgr.mr_n75149376)
print v(xbgr.mr_n75149488)
print v(xbgr.mr_n75149808)
print v(xbgr.mr_n75149920)
print v(xbgr.mr_n75150240)
print v(xbgr.mr_n75150352)
print v(xbgr.mr_n75150672)
print v(xbgr.mr_n75150784)
print v(xbgr.mr_n75151104)
print v(xbgr.mr_n75151216)
print v(xbgr.mr_n75151536)
print v(xbgr.mr_n75151648)
print v(xbgr.mr_n75151968)
print v(xbgr.mr_n75152080)
print v(xbgr.mr_n75152400)
print v(xbgr.mr_n75152512)
print v(xbgr.mr_n75152832)
print v(xbgr.mr_n75152944)
print v(xbgr.mr_n75153264)
print v(xbgr.mr_n75153376)
print v(xbgr.mr_n75153696)
print v(xbgr.mr_n75153808)
print v(xbgr.mr_n75154128)
print v(xbgr.mr_n75154240)
print v(xbgr.mr_n75154560)
print v(xbgr.mr_n75154672)
print v(xbgr.mr_n75154992)
print v(xbgr.mr_n75155104)
print v(xbgr.mr_n75155424)
print v(xbgr.mr_n75155536)
print v(xbgr.mr_n75155856)
print v(xbgr.mr_n75155968)
print v(xbgr.mr_n75156288)
print v(xbgr.mr_n75156400)
print v(xbgr.mr_n75156720)
print v(xbgr.mr_n75156832)
print v(xbgr.mr_n75157152)
print v(xbgr.mr_n75157264)
print v(xbgr.mr_n75157584)
print v(xbgr.mr_n75157696)
print v(xbgr.mr_n75158016)
print v(xbgr.mr_n75158128)
print v(xbgr.mr_n75158448)
print v(xbgr.mr_n75158560)
print v(xbgr.mr_n75158880)
print v(xbgr.mr_n75158992)
print v(xbgr.mr_n75159312)
print v(xbgr.mr_n75159424)
print v(xbgr.mr_n75159744)
print v(xbgr.mr_n75159856)
print v(xbgr.mr_n75160176)
print v(xbgr.mr_n75160288)
print v(xbgr.mr_n75160608)
print v(xbgr.mr_n75160720)
print v(xbgr.mr_n75161040)
print v(xbgr.mr_n75161152)
print v(xbgr.mr_n75161472)
print v(xbgr.mr_n75161584)
print v(xbgr.mr_n75161904)
print v(xbgr.mr_n75162016)
print v(xbgr.mr_n75162336)
print v(xbgr.mr_n75162448)
print v(xbgr.mr_n75162768)
print v(xbgr.mr_n75162880)
print v(xbgr.mr_n75163200)
print v(xbgr.mr_n75163312)
print v(xbgr.mr_n75163632)
print v(xbgr.mr_n75163744)
print v(xbgr.mr_n75164064)
print v(xbgr.mr_n75164176)
print v(xbgr.mr_n75164496)
print v(xbgr.mr_n75164608)
print v(xbgr.mr_n75164928)
print v(xbgr.mr_n75165040)
print v(xbgr.mr_n75165360)
print v(xbgr.mr_n75165472)
print v(xbgr.mr_n75165792)
print v(xbgr.mr_n75165904)
print v(xbgr.mr_n75166224)
print v(xbgr.mr_n75166336)
print v(xbgr.mr_n75166656)
print v(xbgr.mr_n75166768)
print v(xbgr.mr_n75167088)
print v(xbgr.mr_n75167200)
print v(xbgr.mr_n75167520)
print v(xbgr.mr_n75167632)
print v(xbgr.mr_n75167952)
print v(xbgr.mr_n75168064)
print v(xbgr.mr_n75168384)
print v(xbgr.mr_n75168496)
print v(xbgr.mr_n75168816)
print v(xbgr.mr_n75168928)
print v(xbgr.mr_n75169248)
print v(xbgr.mr_n75169360)
print v(xbgr.mr_n75169680)
print v(xbgr.mr_n75169792)
print v(xbgr.mr_n75170112)
print v(xbgr.mr_n75170224)
print v(xbgr.mr_n75170544)
print v(xbgr.mr_n75170656)
print v(xbgr.mr_n75170976)
print v(xbgr.mr_n75171088)
print v(xbgr.mr_n75171408)
print v(xbgr.mr_n75171520)
print v(xbgr.mr_n75171840)
print v(xbgr.mr_n75171952)
print v(xbgr.mr_n75172272)
print v(xbgr.mr_n75172384)
print v(xbgr.mr_n75172704)
print v(xbgr.mr_n75172816)
print v(xbgr.mr_n75173136)
print v(xbgr.mr_n75173248)
print v(xbgr.mr_n75173568)
print v(xbgr.mr_n75173680)
print v(xbgr.mr_n75174000)
print v(xbgr.mr_n75174112)
print v(xbgr.mr_n75174432)
print v(xbgr.mr_n75174544)
print v(xbgr.mr_n75174864)
print v(xbgr.mr_n75174976)
print v(xbgr.mr_n75175296)
print v(xbgr.mr_n75175408)
print v(xbgr.mr_n75175728)
print v(xbgr.mr_n75175840)
print v(xbgr.mr_n75176160)
print v(xbgr.mr_n75176272)
print v(xbgr.mr_n75176592)
print v(xbgr.mr_n75176704)
print v(xbgr.mr_n75177024)
print v(xbgr.mr_n75177136)
print v(xbgr.mr_n75177456)
print v(xbgr.mr_n75177568)
print v(xbgr.mr_n75177888)
print v(xbgr.mr_n75178000)
print v(xbgr.mr_n75178320)
print v(xbgr.mr_n75178432)
print v(xbgr.mr_n75178752)
print v(xbgr.mr_n75178864)
print v(xbgr.mr_n75179184)
print v(xbgr.mr_n75179296)
print v(xbgr.mr_n75179616)
print v(xbgr.mr_n75179728)
print v(xbgr.mr_n75180048)
print v(xbgr.mr_n75180160)
print v(xbgr.mr_n75180480)
print v(xbgr.mr_n75180592)
print v(xbgr.mr_n75180912)
print v(xbgr.mr_n75181024)
print v(xbgr.mr_n75181344)
print v(xbgr.mr_n75181456)
print v(xbgr.mr_n75181776)
print v(xbgr.mr_n75181888)
print v(xbgr.mr_n75182208)
print v(xbgr.mr_n75182320)
print v(xbgr.mr_n75182640)
print v(xbgr.mr_n75182752)
print v(xbgr.mr_n75183072)
print v(xbgr.mr_n75183184)
print v(xbgr.mr_n75183504)
print v(xbgr.mr_n75183616)
print v(xbgr.mr_n75183936)
print v(xbgr.mr_n75184048)
print v(xbgr.mr_n75184368)
print v(xbgr.mr_n75184480)
print v(xbgr.mr_n75184800)
print v(xbgr.mr_n75184912)
print v(xbgr.mr_n75185232)
print v(xbgr.mr_n75185344)
print v(xbgr.mr_n75185664)
print v(xbgr.mr_n75185776)
print v(xbgr.mr_n75186096)
print v(xbgr.mr_n75186208)
print v(xbgr.mr_n75186528)
print v(xbgr.mr_n75186640)
print v(xbgr.mr_n75186960)
print v(xbgr.mr_n75187072)
print v(xbgr.mr_n75187392)
print v(xbgr.mr_n75187504)
print v(xbgr.mr_n75187824)
print v(xbgr.mr_n75187936)
print v(xbgr.mr_n75188256)
print v(xbgr.mr_n75188368)
print v(xbgr.mr_n75188688)
print v(xbgr.mr_n75188800)
print v(xbgr.mr_n75189120)
print v(xbgr.mr_n75189232)
print v(xbgr.mr_n75189552)
print v(xbgr.mr_n75189664)
print v(xbgr.mr_n75189984)
print v(xbgr.mr_n75190096)
print v(xbgr.mr_n75190416)
print v(xbgr.mr_n75190528)
print v(xbgr.mr_n75190848)
print v(xbgr.mr_n75190960)
print v(xbgr.mr_n75191280)
print v(xbgr.mr_n75191392)
print v(xbgr.mr_n75191712)
print v(xbgr.mr_n75191824)
print v(xbgr.mr_n75192144)
print v(xbgr.mr_n75192256)
print v(xbgr.mr_n75192576)
print v(xbgr.mr_n75192688)
print v(xbgr.mr_n75193008)
print v(xbgr.mr_n75193120)
print v(xbgr.mr_n75193440)
print v(xbgr.mr_n75193552)
print v(xbgr.mr_n75193872)
print v(xbgr.mr_n75193984)
print v(xbgr.mr_n75194304)
print v(xbgr.mr_n75194416)
print v(xbgr.mr_n75194736)
print v(xbgr.mr_n75194848)
print v(xbgr.mr_n75195168)
print v(xbgr.mr_n75195280)
print v(xbgr.mr_n75195600)
print v(xbgr.mr_n75195712)
print v(xbgr.mr_n75196032)
print v(xbgr.mr_n75196144)
print v(xbgr.mr_n75196464)
print v(xbgr.mr_n75196576)
print v(xbgr.mr_n75196896)
print v(xbgr.mr_n75197008)
print v(xbgr.mr_n75197328)
print v(xbgr.mr_n75197440)
print v(xbgr.mr_n75197760)
print v(xbgr.mr_n75197872)
print v(xbgr.mr_n75198192)
print v(xbgr.mr_n75198304)
print v(xbgr.mr_n75198624)
print v(xbgr.mr_n75198736)
print v(xbgr.mr_n75199056)
print v(xbgr.mr_n75199168)
print v(xbgr.mr_n75199488)
print v(xbgr.mr_n75199600)
print v(xbgr.mr_n75199920)
print v(xbgr.mr_n75200032)
print v(xbgr.mr_n75200352)
print v(xbgr.mr_n75200464)
print v(xbgr.mr_n75200784)
print v(xbgr.mr_n75200896)
print v(xbgr.mr_n75201216)
print v(xbgr.mr_n75201328)
print v(xbgr.mr_n75201648)
print v(xbgr.mr_n75201760)
print v(xbgr.mr_n75202080)
print v(xbgr.mr_n75202192)
print v(xbgr.mr_n75202512)
print v(xbgr.mr_n75202624)
print v(xbgr.mr_n75202944)
print v(xbgr.mr_n75203056)
print v(xbgr.mr_n75203376)
print v(xbgr.mr_n75203488)
print v(xbgr.mr_n75203808)
print v(xbgr.mr_n75203920)
print v(xbgr.mr_n75204240)
print v(xbgr.mr_n75204352)
print v(xbgr.mr_n75204672)
print v(xbgr.mr_n75204784)
print v(xbgr.mr_n75205104)
print v(xbgr.mr_n75205216)
print v(xbgr.mr_n75205536)
print v(xbgr.mr_n75205648)
print v(xbgr.mr_n75205968)
print v(xbgr.mr_n75206080)
print v(xbgr.mr_n75206400)
print v(xbgr.mr_n75206512)
print v(xbgr.mr_n75206832)
print v(xbgr.mr_n75206944)
print v(xbgr.mr_n75207264)
print v(xbgr.mr_n75207376)
print v(xbgr.mr_n75207696)
print v(xbgr.mr_n75207808)
print v(xbgr.mr_n75208128)
print v(xbgr.mr_n75208240)
print v(xbgr.mr_n75208560)
print v(xbgr.mr_n75208672)
print v(xbgr.mr_n75208992)
print v(xbgr.mr_n75209104)
print v(xbgr.mr_n75209424)
print v(xbgr.mr_n75209536)
print v(xbgr.mr_n75209856)
print v(xbgr.mr_n75209968)
print v(xbgr.mr_n75210288)
print v(xbgr.mr_n75210400)
print v(xbgr.mr_n75210720)
print v(xbgr.mr_n75210832)
print v(xbgr.mr_n75211152)
print v(xbgr.mr_n75211264)
print v(xbgr.mr_n75211584)
print v(xbgr.mr_n75211696)
print v(xbgr.mr_n75212016)
print v(xbgr.mr_n75212128)
print v(xbgr.mr_n75212448)
print v(xbgr.mr_n75212560)
print v(xbgr.mr_n75212880)
print v(xbgr.mr_n75212992)
print v(xbgr.mr_n75213312)
print v(xbgr.mr_n75213424)
print v(xbgr.mr_n75213744)
print v(xbgr.mr_n75213856)
print v(xbgr.mr_n75214176)
print v(xbgr.mr_n75214288)
print v(xbgr.mr_n75214608)
print v(xbgr.mr_n75214720)
print v(xbgr.mr_n75215040)
print v(xbgr.mr_n75215152)
print v(xbgr.mr_n75215472)
print v(xbgr.mr_n75215584)
print v(xbgr.mr_n75215904)
print v(xbgr.mr_n75216016)
print v(xbgr.mr_n75216336)
print v(xbgr.mr_n75216448)
print v(xbgr.mr_n75216768)
print v(xbgr.mr_n75216880)
print v(xbgr.mr_n75217200)
print v(xbgr.mr_n75217312)
print v(xbgr.mr_n75217632)
print v(xbgr.mr_n75217744)
print v(xbgr.mr_n75218064)
print v(xbgr.mr_n75218176)
print v(xbgr.mr_n75218496)
print v(xbgr.mr_n75218608)
print v(xbgr.mr_n75218928)
print v(xbgr.mr_n75219040)
print v(xbgr.mr_n75219360)
print v(xbgr.mr_n75219472)
print v(xbgr.mr_n75219792)
print v(xbgr.mr_n75219904)
print v(xbgr.mr_n75220224)
print v(xbgr.mr_n75220336)
print v(xbgr.mr_n75220656)
print v(xbgr.mr_n75220768)
print v(xbgr.mr_n75221088)
print v(xbgr.mr_n75221200)
print v(xbgr.mr_n75221520)
print v(xbgr.mr_n75221632)
print v(xbgr.mr_n75221952)
print v(xbgr.mr_n75222064)
print v(xbgr.mr_n75222384)
print v(xbgr.mr_n75222496)
print v(xbgr.mr_n75222816)
print v(xbgr.mr_n75222928)
print v(xbgr.mr_n75223248)
print v(xbgr.mr_n75223360)
print v(xbgr.mr_n75223680)
print v(xbgr.mr_n75223792)
print v(xbgr.mr_n75224112)
print v(xbgr.mr_n75224224)
print v(xbgr.mr_n75224544)
print v(xbgr.mr_n75224656)
print v(xbgr.mr_n75224976)
print v(xbgr.mr_n75225088)
print v(xbgr.mr_n75225408)
print v(xbgr.mr_n75225520)
print v(xbgr.mr_n75225840)
print v(xbgr.mr_n75225952)
print v(xbgr.mr_n75226272)
print v(xbgr.mr_n75226384)
print v(xbgr.mr_n75226704)
print v(xbgr.mr_n75226816)
print v(xbgr.mr_n75227136)
print v(xbgr.mr_n75227248)
print v(xbgr.mr_n75227568)
print v(xbgr.mr_n75227680)
print v(xbgr.mr_n75228000)
print v(xbgr.mr_n75228112)
print v(xbgr.mr_n75228432)
print v(xbgr.mr_n75228544)
print v(xbgr.mr_n75228864)
print v(xbgr.mr_n75228976)
print v(xbgr.mr_n75229296)
print v(xbgr.mr_n75229408)
print v(xbgr.mr_n75229728)
print v(xbgr.mr_n75229840)
print v(xbgr.mr_n75230160)
print v(xbgr.mr_n75230272)
print v(xbgr.mr_n75230592)
print v(xbgr.mr_n75230704)
print v(xbgr.mr_n75231024)
print v(xbgr.mr_n75231136)
print v(xbgr.mr_n75231456)
print v(xbgr.mr_n75231568)
print v(xbgr.mr_n75231888)
print v(xbgr.mr_n75232000)
print v(xbgr.mr_n75232320)
print v(xbgr.mr_n75232432)
print v(xbgr.mr_n75232752)
print v(xbgr.mr_n75232864)
print v(xbgr.mr_n75233184)
print v(xbgr.mr_n75233296)
print v(xbgr.mr_n75233616)
print v(xbgr.mr_n75233728)
print v(xbgr.mr_n75234048)
print v(xbgr.mr_n75234160)
print v(xbgr.mr_n75234480)
print v(xbgr.mr_n75234592)
print v(xbgr.mr_n75234912)
print v(xbgr.mr_n75235024)
print v(xbgr.mr_n75235344)
print v(xbgr.mr_n75235456)
print v(xbgr.mr_n75235776)
print v(xbgr.mr_n75235888)
print v(xbgr.mr_n75236208)
print v(xbgr.mr_n75236320)
print v(xbgr.mr_n75236640)
print v(xbgr.mr_n75236752)
print v(xbgr.mr_n75237072)
print v(xbgr.mr_n75237184)
print v(xbgr.mr_n75237504)
print v(xbgr.mr_n75237616)
print v(xbgr.mr_n75237936)
print v(xbgr.mr_n75238048)
print v(xbgr.mr_n75238368)
print v(xbgr.mr_n75238480)
print v(xbgr.mr_n75238800)
print v(xbgr.mr_n75238912)
print v(xbgr.mr_n75239232)
print v(xbgr.mr_n75239344)
print v(xbgr.mr_n75239664)
print v(xbgr.mr_n75239776)
print v(xbgr.mr_n75240096)
print v(xbgr.mr_n75240208)
print v(xbgr.mr_n75240528)
print v(xbgr.mr_n75240640)
print v(xbgr.mr_n75240960)
print v(xbgr.mr_n75241072)
print v(xbgr.mr_n75241392)
print v(xbgr.mr_n75241504)
print v(xbgr.mr_n75241824)
print v(xbgr.mr_n75241936)
print v(xbgr.mr_n75242256)
print v(xbgr.mr_n75242368)
print v(xbgr.mr_n75242688)
print v(xbgr.mr_n75242800)
print v(xbgr.mr_n75243120)
print v(xbgr.mr_n75243232)
print v(xbgr.mr_n75243552)
print v(xbgr.mr_n75243664)
print v(xbgr.mr_n75243984)
print v(xbgr.mr_n75244096)
print v(xbgr.mr_n75244416)
print v(xbgr.mr_n75244528)
print v(xbgr.mr_n75244848)
print v(xbgr.mr_n75244960)
print v(xbgr.mr_n75245280)
print v(xbgr.mr_n75245392)
print v(xbgr.mr_n75245712)
print v(xbgr.mr_n75245824)
print v(xbgr.mr_n75246144)
print v(xbgr.mr_n75246256)
print v(xbgr.mr_n75246576)
print v(xbgr.mr_n75246688)
print v(xbgr.mr_n75247008)
print v(xbgr.mr_n75247120)
print v(xbgr.mr_n75247440)
print v(xbgr.mr_n75247552)
print v(xbgr.mr_n75247872)
print v(xbgr.mr_n75247984)
print v(xbgr.mr_n75248304)
print v(xbgr.mr_n75248416)
print v(xbgr.mr_n75248736)
print v(xbgr.mr_n75248848)
print v(xbgr.mr_n75249168)
print v(xbgr.mr_n75249280)
print v(xbgr.mr_n75249600)
print v(xbgr.mr_n75249712)
print v(xbgr.mr_n75250032)
print v(xbgr.mr_n75250144)
print v(xbgr.mr_n75250464)
print v(xbgr.mr_n75250576)
print v(xbgr.mr_n75250896)
print v(xbgr.mr_n75251008)
print v(xbgr.mr_n75251328)
print v(xbgr.mr_n75251440)
print v(xbgr.mr_n75251760)
print v(xbgr.mr_n75251872)
print v(xbgr.mr_n75252192)
print v(xbgr.mr_n75252304)
print v(xbgr.mr_n75252624)
print v(xbgr.mr_n75252736)
print v(xbgr.mr_n75253056)
print v(xbgr.mr_n75253168)
print v(xbgr.mr_n75253488)
print v(xbgr.mr_n75253600)
print v(xbgr.mr_n75253920)
print v(xbgr.mr_n75254032)
print v(xbgr.mr_n75254352)
print v(xbgr.mr_n75254464)
print v(xbgr.mr_n75254784)
print v(xbgr.mr_n75254896)
print v(xbgr.mr_n75255216)
print v(xbgr.mr_n75255328)
print v(xbgr.mr_n75255648)
print v(xbgr.mr_n75255760)
print v(xbgr.mr_n75256080)
print v(xbgr.mr_n75256192)
print v(xbgr.mr_n75256512)
print v(xbgr.mr_n75256624)
print v(xbgr.mr_n75256944)
print v(xbgr.mr_n75257056)
print v(xbgr.mr_n75257376)
print v(xbgr.mr_n75257488)
print v(xbgr.mr_n75257808)
print v(xbgr.mr_n75257920)
print v(xbgr.mr_n75258240)
print v(xbgr.mr_n75258352)
print v(xbgr.mr_n75258672)
print v(xbgr.mr_n75258784)
print v(xbgr.mr_n75259104)
print v(xbgr.mr_n75259216)
print v(xbgr.mr_n75259536)
print v(xbgr.mr_n75259648)
print v(xbgr.mr_n75259968)
print v(xbgr.mr_n75260080)
print v(xbgr.mr_n75260400)
print v(xbgr.mr_n75260512)
print v(xbgr.mr_n75260832)
print v(xbgr.mr_n75260944)
print v(xbgr.mr_n75261264)
print v(xbgr.mr_n75261376)
print v(xbgr.mr_n75261696)
print v(xbgr.mr_n75261808)
print v(xbgr.mr_n75262128)
print v(xbgr.mr_n75262240)
print v(xbgr.mr_n75262560)
print v(xbgr.mr_n75262672)
print v(xbgr.mr_n75262992)
print v(xbgr.mr_n75263104)
print v(xbgr.mr_n75263424)
print v(xbgr.mr_n75263536)
print v(xbgr.mr_n75263856)
print v(xbgr.mr_n75263968)
print v(xbgr.mr_n75264288)
print v(xbgr.mr_n75264400)
print v(xbgr.mr_n75264720)
print v(xbgr.mr_n75264832)
print v(xbgr.mr_n75265152)
print v(xbgr.mr_n75265264)
print v(xbgr.mr_n75265584)
print v(xbgr.mr_n75265696)
print v(xbgr.mr_n75266016)
print v(xbgr.mr_n75266128)
print v(xbgr.mr_n75266448)
print v(xbgr.mr_n75266560)
print v(xbgr.mr_n75266880)
print v(xbgr.mr_n75266992)
print v(xbgr.mr_n75267312)
print v(xbgr.mr_n75267424)
print v(xbgr.mr_n75267744)
print v(xbgr.mr_n75267856)
print v(xbgr.mr_n75268176)
print v(xbgr.mr_n75268288)
print v(xbgr.mr_n75268608)
print v(xbgr.mr_n75268720)
print v(xbgr.mr_n75269040)
print v(xbgr.mr_n75269152)
print v(xbgr.mr_n75269472)
print v(xbgr.mr_n75269584)
print v(xbgr.mr_n75269904)
print v(xbgr.mr_n75270016)
print v(xbgr.mr_n75270336)
print v(xbgr.mr_n75270448)
print v(xbgr.mr_n75270768)
print v(xbgr.mr_n75270880)
print v(xbgr.mr_n75271200)
print v(xbgr.mr_n75271312)
print v(xbgr.mr_n75271632)
print v(xbgr.mr_n75271744)
print v(xbgr.mr_n75272064)
print v(xbgr.mr_n75272176)
print v(xbgr.mr_n75272496)
print v(xbgr.mr_n75272608)
print v(xbgr.mr_n75272928)
print v(xbgr.mr_n75273040)
print v(xbgr.mr_n75273360)
print v(xbgr.mr_n75273472)
print v(xbgr.mr_n75273792)
print v(xbgr.mr_n75273904)
print v(xbgr.mr_n75274224)
print v(xbgr.mr_n75274336)
print v(xbgr.mr_n75274656)
print v(xbgr.mr_n75274768)
print v(xbgr.mr_n75275088)
print v(xbgr.mr_n75275200)
print v(xbgr.mr_n75275520)
print v(xbgr.mr_n75275632)
print v(xbgr.mr_n75275952)
print v(xbgr.mr_n75276064)
print v(xbgr.mr_n75276384)
print v(xbgr.mr_n75276496)
print v(xbgr.mr_n75276816)
print v(xbgr.mr_n75276928)
print v(xbgr.mr_n75277248)
print v(xbgr.mr_n75277360)
print v(xbgr.mr_n75277680)
print v(xbgr.mr_n75277792)
print v(xbgr.mr_n75278112)
print v(xbgr.mr_n75278224)
print v(xbgr.mr_n75278544)
print v(xbgr.mr_n75278656)
print v(xbgr.mr_n75278976)
print v(xbgr.mr_n75279088)
print v(xbgr.mr_n75279408)
print v(xbgr.mr_n75279520)
print v(xbgr.mr_n75279840)
print v(xbgr.mr_n75279952)
print v(xbgr.mr_n75280272)
print v(xbgr.mr_n75280384)
print v(xbgr.mr_n75280704)
print v(xbgr.mr_n75280816)
print v(xbgr.mr_n75281136)
print v(xbgr.mr_n75281248)
print v(xbgr.mr_n75281568)
print v(xbgr.mr_n75281680)
print v(xbgr.mr_n75282000)
print v(xbgr.mr_n75282112)
print v(xbgr.mr_n75282432)
print v(xbgr.mr_n75282544)
print v(xbgr.mr_n75282864)
print v(xbgr.mr_n75282976)
print v(xbgr.mr_n75283296)
print v(xbgr.mr_n75283408)
print v(xbgr.mr_n75283728)
print v(xbgr.mr_n75283840)
print v(xbgr.mr_n75284160)
print v(xbgr.mr_n75284272)
print v(xbgr.mr_n75284592)
print v(xbgr.mr_n75284704)
print v(xbgr.mr_n75285024)
print v(xbgr.mr_n75285136)
print v(xbgr.mr_n75285456)
print v(xbgr.mr_n75285568)
print v(xbgr.mr_n75285888)
print v(xbgr.mr_n75286000)
print v(xbgr.mr_n75286320)
print v(xbgr.mr_n75286432)
print v(xbgr.mr_n75286752)
print v(xbgr.mr_n75286864)
print v(xbgr.mr_n75287184)
print v(xbgr.mr_n75287296)
print v(xbgr.mr_n75287616)
print v(xbgr.mr_n75287728)
print v(xbgr.mr_n75288048)
print v(xbgr.mr_n75288160)
print v(xbgr.mr_n75288480)
print v(xbgr.mr_n75288592)
print v(xbgr.mr_n75288912)
print v(xbgr.mr_n75289024)
print v(xbgr.mr_n75289344)
print v(xbgr.mr_n75289456)
print v(xbgr.mr_n75289776)
print v(xbgr.mr_n75289888)
print v(xbgr.mr_n75290208)
print v(xbgr.mr_n75290320)
print v(xbgr.mr_n75290640)
print v(xbgr.mr_n75290752)
print v(xbgr.mr_n75291072)
print v(xbgr.mr_n75291184)
print v(xbgr.mr_n75291504)
print v(xbgr.mr_n75291616)
print v(xbgr.mr_n75291936)
print v(xbgr.mr_n75292048)
print v(xbgr.mr_n75292368)
print v(xbgr.mr_n75292480)
print v(xbgr.mr_n75292800)
print v(xbgr.mr_n75292912)
print v(xbgr.mr_n75293232)
print v(xbgr.mr_n75293344)
print v(xbgr.mr_n75293664)
print v(xbgr.mr_n75293776)
print v(xbgr.mr_n75294096)
print v(xbgr.mr_n75294208)
print v(xbgr.mr_n75294528)
print v(xbgr.mr_n75294640)
print v(xbgr.mr_n75294960)
print v(xbgr.mr_n75295072)
print v(xbgr.mr_n75295392)
print v(xbgr.mr_n75295504)
print v(xbgr.mr_n75295824)
print v(xbgr.mr_n75295936)
print v(xbgr.mr_n75296256)
print v(xbgr.mr_n75296368)
print v(xbgr.mr_n75296688)
print v(xbgr.mr_n75296800)
print v(xbgr.mr_n75297120)
print v(xbgr.mr_n75297232)
print v(xbgr.mr_n75297552)
print v(xbgr.mr_n75297664)
print v(xbgr.mr_n75297984)
print v(xbgr.mr_n75298096)
print v(xbgr.mr_n75298416)
print v(xbgr.mr_n75298528)
print v(xbgr.mr_n75298848)
print v(xbgr.mr_n75298960)
print v(xbgr.mr_n75299280)
print v(xbgr.mr_n75299392)
print v(xbgr.mr_n75299712)
print v(xbgr.mr_n75299824)
print v(xbgr.mr_n75300144)
print v(xbgr.mr_n75300256)
print v(xbgr.mr_n75300576)
print v(xbgr.mr_n75300688)
print v(xbgr.mr_n75301008)
print v(xbgr.mr_n75301120)
print v(xbgr.mr_n75301440)
print v(xbgr.mr_n75301552)
print v(xbgr.mr_n75301872)
print v(xbgr.mr_n75301984)
print v(xbgr.mr_n75302304)
print v(xbgr.mr_n75302416)
print v(xbgr.mr_n75302736)
print v(xbgr.mr_n75302848)
print v(xbgr.mr_n75303168)
print v(xbgr.mr_n75303280)
print v(xbgr.mr_n75303600)
print v(xbgr.mr_n75303712)
print v(xbgr.mr_n75304032)
print v(xbgr.mr_n75304144)
print v(xbgr.mr_n75304464)
print v(xbgr.mr_n75304576)
print v(xbgr.mr_n75304896)
print v(xbgr.mr_n75305008)
print v(xbgr.mr_n75305328)
print v(xbgr.mr_n75305440)
print v(xbgr.mr_n75305760)
print v(xbgr.mr_n75305872)
print v(xbgr.mr_n75306192)
print v(xbgr.mr_n75306304)
print v(xbgr.mr_n75306624)
print v(xbgr.mr_n75306736)
print v(xbgr.mr_n75307056)
print v(xbgr.mr_n75307168)
print v(xbgr.mr_n75307488)
print v(xbgr.mr_n75307600)
print v(xbgr.mr_n75307920)
print v(xbgr.mr_n75308032)
print v(xbgr.mr_n75308352)
print v(xbgr.mr_n75308464)
print v(xbgr.mr_n75308784)
print v(xbgr.mr_n75308896)
print v(xbgr.mr_n75309216)
print v(xbgr.mr_n75309328)
print v(xbgr.mr_n75309648)
print v(xbgr.mr_n75309760)
print v(xbgr.mr_n75310080)
print v(xbgr.mr_n75310192)
print v(xbgr.mr_n75310512)
print v(xbgr.mr_n75310624)
print v(xbgr.mr_n75310944)
print v(xbgr.mr_n75311056)
print v(xbgr.mr_n75311376)
print v(xbgr.mr_n75311488)
print v(xbgr.mr_n75311808)
print v(xbgr.mr_n75311920)
print v(xbgr.mr_n75312240)
print v(xbgr.mr_n75312352)
print v(xbgr.mr_n75312672)
print v(xbgr.mr_n75312784)
print v(xbgr.mr_n75313104)
print v(xbgr.mr_n75313216)
print v(xbgr.mr_n75313536)
print v(xbgr.mr_n75313648)
print v(xbgr.mr_n75313968)
print v(xbgr.mr_n75314080)
print v(xbgr.mr_n75314400)
print v(xbgr.mr_n75314512)
print v(xbgr.mr_n75314832)
print v(xbgr.mr_n75314944)
print v(xbgr.mr_n75315264)
print v(xbgr.mr_n75315376)
print v(xbgr.mr_n75315696)
print v(xbgr.mr_n75315808)
print v(xbgr.mr_n75316128)
print v(xbgr.mr_n75316240)
print v(xbgr.mr_n75316560)
print v(xbgr.mr_n75316672)
print v(xbgr.mr_n75316992)
print v(xbgr.mr_n75317104)
print v(xbgr.mr_n75317424)
print v(xbgr.mr_n75317536)
print v(xbgr.mr_n75317856)
print v(xbgr.mr_n75317968)
print v(xbgr.mr_n75318288)
print v(xbgr.mr_n75318400)
print v(xbgr.mr_n75318720)
print v(xbgr.mr_n75318832)
print v(xbgr.mr_n75319152)
print v(xbgr.mr_n75319264)
print v(xbgr.mr_n75319584)
print v(xbgr.mr_n75319696)
print v(xbgr.mr_n75320016)
print v(xbgr.mr_n75320128)
print v(xbgr.mr_n75320448)
print v(xbgr.mr_n75320560)
print v(xbgr.mr_n75320880)
print v(xbgr.mr_n75320992)
print v(xbgr.mr_n75321312)
print v(xbgr.mr_n75321424)
print v(xbgr.mr_n75321744)
print v(xbgr.mr_n75321856)
print v(xbgr.mr_n75322176)
print v(xbgr.mr_n75322288)
print v(xbgr.mr_n75322608)
print v(xbgr.mr_n75322720)
print v(xbgr.mr_n75323040)
print v(xbgr.mr_n75323152)
print v(xbgr.mr_n75323472)
print v(xbgr.mr_n75323584)
print v(xbgr.mr_n75323904)
print v(xbgr.mr_n75324016)
print v(xbgr.mr_n75324336)
print v(xbgr.mr_n75324448)
print v(xbgr.mr_n75324768)
print v(xbgr.mr_n75324880)
print v(xbgr.mr_n75325200)
print v(xbgr.mr_n75325312)
print v(xbgr.mr_n75325632)
print v(xbgr.mr_n75325744)
print v(xbgr.mr_n75326064)
print v(xbgr.mr_n75326176)
print v(xbgr.mr_n75326496)
print v(xbgr.mr_n75326608)
print v(xbgr.mr_n75326928)
print v(xbgr.mr_n75327040)
print v(xbgr.mr_n75327360)
print v(xbgr.mr_n75327472)
print v(xbgr.mr_n75327792)
print v(xbgr.mr_n75327904)
print v(xbgr.mr_n75328224)
print v(xbgr.mr_n75328336)
print v(xbgr.mr_n75328656)
print v(xbgr.mr_n75328768)
print v(xbgr.mr_n75329088)
print v(xbgr.mr_n75329200)
print v(xbgr.mr_n75329520)
print v(xbgr.mr_n75329632)
print v(xbgr.mr_n75329952)
print v(xbgr.mr_n75330064)
print v(xbgr.mr_n75330384)
print v(xbgr.mr_n75330496)
print v(xbgr.mr_n75330816)
print v(xbgr.mr_n75330928)
print v(xbgr.mr_n75331248)
print v(xbgr.mr_n75331360)
print v(xbgr.mr_n75331680)
print v(xbgr.mr_n75331792)
print v(xbgr.mr_n75332112)
print v(xbgr.mr_n75332224)
print v(xbgr.mr_n75332544)
print v(xbgr.mr_n75332656)
print v(xbgr.mr_n75332976)
print v(xbgr.mr_n75333088)
print v(xbgr.mr_n75333408)
print v(xbgr.mr_n75333520)
print v(xbgr.mr_n75333840)
print v(xbgr.mr_n75333952)
print v(xbgr.mr_n75334272)
print v(xbgr.mr_n75334384)
print v(xbgr.mr_n75334704)
print v(xbgr.mr_n75334816)
print v(xbgr.mr_n75335136)
print v(xbgr.mr_n75335248)
print v(xbgr.mr_n75335568)
print v(xbgr.mr_n75335680)
print v(xbgr.mr_n75336000)
print v(xbgr.mr_n75336112)
print v(xbgr.mr_n75336432)
print v(xbgr.mr_n75336544)
print v(xbgr.mr_n75336864)
print v(xbgr.mr_n75336976)
print v(xbgr.mr_n75337296)
print v(xbgr.mr_n75337408)
print v(xbgr.mr_n75337728)
print v(xbgr.mr_n75337840)
print v(xbgr.mr_n75338160)
print v(xbgr.mr_n75338272)
print v(xbgr.mr_n75338592)
print v(xbgr.mr_n75338704)
print v(xbgr.mr_n75339024)
print v(xbgr.mr_n75339136)
print v(xbgr.mr_n75339456)
print v(xbgr.mr_n75339568)
print v(xbgr.mr_n75339888)
print v(xbgr.mr_n75340000)
print v(xbgr.mr_n75340320)
print v(xbgr.mr_n75340432)
print v(xbgr.mr_n75340752)
print v(xbgr.mr_n75340864)
print v(xbgr.mr_n75341184)
print v(xbgr.mr_n75341296)
print v(xbgr.mr_n75341616)
print v(xbgr.mr_n75341728)
print v(xbgr.mr_n75342048)
print v(xbgr.mr_n75342160)
print v(xbgr.mr_n75342480)
print v(xbgr.mr_n75342592)
print v(xbgr.mr_n75342912)
print v(xbgr.mr_n75343024)
print v(xbgr.mr_n75343344)
print v(xbgr.mr_n75343456)
print v(xbgr.mr_n75343776)
print v(xbgr.mr_n75343888)
print v(xbgr.mr_n75344208)
print v(xbgr.mr_n75344320)
print v(xbgr.mr_n75344640)
print v(xbgr.mr_n75344752)
print v(xbgr.mr_n75345072)
print v(xbgr.mr_n75345184)
print v(xbgr.mr_n75345504)
print v(xbgr.mr_n75345616)
print v(xbgr.mr_n75345936)
print v(xbgr.mr_n75346048)
print v(xbgr.mr_n75346368)
print v(xbgr.mr_n75346480)
print v(xbgr.mr_n75346800)
print v(xbgr.mr_n75346912)
print v(xbgr.mr_n75347232)
print v(xbgr.mr_n75347344)
print v(xbgr.mr_n75347664)
print v(xbgr.mr_n75347776)
print v(xbgr.mr_n75348096)
print v(xbgr.mr_n75348208)
print v(xbgr.mr_n75348528)
print v(xbgr.mr_n75348640)
print v(xbgr.mr_n75348960)
print v(xbgr.mr_n75349072)
print v(xbgr.mr_n75349392)
print v(xbgr.mr_n75349504)
print v(xbgr.mr_n75349824)
print v(xbgr.mr_n75349936)
print v(xbgr.mr_n75350256)
print v(xbgr.mr_n75350368)
print v(xbgr.mr_n75350688)
print v(xbgr.mr_n75350800)
print v(xbgr.mr_n75351120)
print v(xbgr.mr_n75351232)
print v(xbgr.mr_n75351552)
print v(xbgr.mr_n75351664)
print v(xbgr.mr_n75351984)
print v(xbgr.mr_n75352096)
print v(xbgr.mr_n75352416)
print v(xbgr.mr_n75352528)
print v(xbgr.mr_n75352848)
print v(xbgr.mr_n75352960)
print v(xbgr.mr_n75353280)
print v(xbgr.mr_n75353392)
print v(xbgr.mr_n75353712)
print v(xbgr.mr_n75353824)
print v(xbgr.mr_n75354144)
print v(xbgr.mr_n75354256)
print v(xbgr.mr_n75354576)
print v(xbgr.mr_n75354688)
print v(xbgr.mr_n75355008)
print v(xbgr.mr_n75355120)
print v(xbgr.mr_n75355440)
print v(xbgr.mr_n75355552)
print v(xbgr.mr_n75355872)
print v(xbgr.mr_n75355984)
print v(xbgr.mr_n75356304)
print v(xbgr.mr_n75356416)
print v(xbgr.mr_n75356736)
print v(xbgr.mr_n75356848)
print v(xbgr.mr_n75357168)
print v(xbgr.mr_n75357280)
print v(xbgr.mr_n75357600)
print v(xbgr.mr_n75357712)
print v(xbgr.mr_n75358032)
print v(xbgr.mr_n75358144)
print v(xbgr.mr_n75358464)
print v(xbgr.mr_n75358576)
print v(xbgr.mr_n75358896)
print v(xbgr.mr_n75359008)
print v(xbgr.mr_n75359328)
print v(xbgr.mr_n75359440)
print v(xbgr.mr_n75359760)
print v(xbgr.mr_n75359872)
print v(xbgr.mr_n75360192)
print v(xbgr.mr_n75360304)
print v(xbgr.mr_n75360624)
print v(xbgr.mr_n75360736)
print v(xbgr.mr_n75361056)
print v(xbgr.mr_n75361168)
print v(xbgr.mr_n75361488)
print v(xbgr.mr_n75361600)
print v(xbgr.mr_n75361920)
print v(xbgr.mr_n75362032)
print v(xbgr.mr_n75362352)
print v(xbgr.mr_n75362464)
print v(xbgr.mr_n75362784)
print v(xbgr.mr_n75362896)
print v(xbgr.mr_n75363216)
print v(xbgr.mr_n75363328)
print v(xbgr.mr_n75363648)
print v(xbgr.mr_n75363760)
print v(xbgr.mr_n75364080)
print v(xbgr.mr_n75364192)
print v(xbgr.mr_n75364512)
print v(xbgr.mr_n75364624)
print v(xbgr.mr_n75364944)
print v(xbgr.mr_n75365056)
print v(xbgr.mr_n75365376)
print v(xbgr.mr_n75365488)
print v(xbgr.mr_n75365808)
print v(xbgr.mr_n75365920)
print v(xbgr.mr_n75366240)
print v(xbgr.mr_n75366352)
print v(xbgr.mr_n75366672)
print v(xbgr.mr_n75366784)
print v(xbgr.mr_n75367104)
print v(xbgr.mr_n75367216)
print v(xbgr.mr_n75367536)
print v(xbgr.mr_n75367648)
print v(xbgr.mr_n75367968)
print v(xbgr.mr_n75368080)
print v(xbgr.mr_n75368400)
print v(xbgr.mr_n75368512)
print v(xbgr.mr_n75368832)
print v(xbgr.mr_n75368944)
print v(xbgr.mr_n75369264)
print v(xbgr.mr_n75369376)
print v(xbgr.mr_n75369696)
print v(xbgr.mr_n75369808)
print v(xbgr.mr_n75370128)
print v(xbgr.mr_n75370240)
print v(xbgr.mr_n75370560)
print v(xbgr.mr_n75370672)
print v(xbgr.mr_n75370992)
print v(xbgr.mr_n75371104)
print v(xbgr.mr_n75371424)
print v(xbgr.mr_n75371536)
print v(xbgr.mr_n75371856)
print v(xbgr.mr_n75371968)
print v(xbgr.mr_n75372288)
print v(xbgr.mr_n75372400)
print v(xbgr.mr_n75372720)
print v(xbgr.mr_n75372832)
print v(xbgr.mr_n75373152)
print v(xbgr.mr_n75373264)
print v(xbgr.mr_n75373584)
print v(xbgr.mr_n75373696)
print v(xbgr.mr_n75374016)
print v(xbgr.mr_n75374128)
print v(xbgr.mr_n75374448)
print v(xbgr.mr_n75374560)
print v(xbgr.mr_n75374880)
print v(xbgr.mr_n75374992)
print v(xbgr.mr_n75375312)
print v(xbgr.mr_n75375424)
print v(xbgr.mr_n75375744)
print v(xbgr.mr_n75375856)
print v(xbgr.mr_n75376176)
print v(xbgr.mr_n75376288)
print v(xbgr.mr_n75376608)
print v(xbgr.mr_n75376720)
print v(xbgr.mr_n75377040)
print v(xbgr.mr_n75377152)
print v(xbgr.mr_n75377472)
print v(xbgr.mr_n75377584)
print v(xbgr.mr_n75377904)
print v(xbgr.mr_n75378016)
print v(xbgr.mr_n75378336)
print v(xbgr.mr_n75378448)
print v(xbgr.mr_n75378768)
print v(xbgr.mr_n75378880)
print v(xbgr.mr_n75379200)
print v(xbgr.mr_n75379312)
print v(xbgr.mr_n75379632)
print v(xbgr.mr_n75379744)
print v(xbgr.mr_n75380064)
print v(xbgr.mr_n75380176)
print v(xbgr.mr_n75380496)
print v(xbgr.mr_n75380608)
print v(xbgr.mr_n75380928)
print v(xbgr.mr_n75381040)
print v(xbgr.mr_n75381360)
print v(xbgr.mr_n75381472)
print v(xbgr.mr_n75381792)
print v(xbgr.mr_n75381904)
print v(xbgr.mr_n75382224)
print v(xbgr.mr_n75382336)
print v(xbgr.mr_n75382656)
print v(xbgr.mr_n75382768)
print v(xbgr.mr_n75383088)
print v(xbgr.mr_n75383200)
print v(xbgr.mr_n75383520)
print v(xbgr.mr_n75383632)
print v(xbgr.mr_n75383952)
print v(xbgr.mr_n75384064)
print v(xbgr.mr_n75384384)
print v(xbgr.mr_n75384496)
print v(xbgr.mr_n75384816)
print v(xbgr.mr_n75384928)
print v(xbgr.mr_n75385248)
print v(xbgr.mr_n75385360)
print v(xbgr.mr_n75385680)
print v(xbgr.mr_n75385792)
print v(xbgr.mr_n75386112)
print v(xbgr.mr_n75386224)
print v(xbgr.mr_n75386544)
print v(xbgr.mr_n75386656)
print v(xbgr.mr_n75386976)
print v(xbgr.mr_n75387088)
print v(xbgr.mr_n75387408)
print v(xbgr.mr_n75387520)
print v(xbgr.mr_n75387840)
print v(xbgr.mr_n75387952)
print v(xbgr.mr_n75388272)
print v(xbgr.mr_n75388384)
print v(xbgr.mr_n75388704)
print v(xbgr.mr_n75388816)
print v(xbgr.mr_n75389136)
print v(xbgr.mr_n75389248)
print v(xbgr.mr_n75389568)
print v(xbgr.mr_n75389680)
print v(xbgr.mr_n75390000)
print v(xbgr.mr_n75390112)
print v(xbgr.mr_n75390432)
print v(xbgr.mr_n75390544)
print v(xbgr.mr_n75390864)
print v(xbgr.mr_n75390976)
print v(xbgr.mr_n75391296)
print v(xbgr.mr_n75391408)
print v(xbgr.mr_n75391728)
print v(xbgr.mr_n75391840)
print v(xbgr.mr_n75392160)
print v(xbgr.mr_n75392272)
print v(xbgr.mr_n75392592)
print v(xbgr.mr_n75392704)
print v(xbgr.mr_n75393024)
print v(xbgr.mr_n75393136)
print v(xbgr.mr_n75393456)
print v(xbgr.mr_n75393568)
print v(xbgr.mr_n75393888)
print v(xbgr.mr_n75394000)
print v(xbgr.mr_n75394320)
print v(xbgr.mr_n75394432)
print v(xbgr.mr_n75394752)
print v(xbgr.mr_n75394864)
print v(xbgr.mr_n75395184)
print v(xbgr.mr_n75395296)
print v(xbgr.mr_n75395616)
print v(xbgr.mr_n75395728)
print v(xbgr.mr_n75396048)
print v(xbgr.mr_n75396160)
print v(xbgr.mr_n75396480)
print v(xbgr.mr_n75396592)
print v(xbgr.mr_n75396912)
print v(xbgr.mr_n75397024)
print v(xbgr.mr_n75397344)
print v(xbgr.mr_n75397456)
print v(xbgr.mr_n75397776)
print v(xbgr.mr_n75397888)
print v(xbgr.mr_n75398208)
print v(xbgr.mr_n75398320)
print v(xbgr.mr_n75398640)
print v(xbgr.mr_n75398752)
print v(xbgr.mr_n75399072)
print v(xbgr.mr_n75399184)
print v(xbgr.mr_n75399504)
print v(xbgr.mr_n75399616)
print v(xbgr.mr_n75399936)
print v(xbgr.mr_n75400048)
print v(xbgr.mr_n75400368)
print v(xbgr.mr_n75400480)
print v(xbgr.mr_n75400800)
print v(xbgr.mr_n75400912)
print v(xbgr.mr_n75401232)
print v(xbgr.mr_n75401344)
print v(xbgr.mr_n75401664)
print v(xbgr.mr_n75401776)
print v(xbgr.mr_n75402096)
print v(xbgr.mr_n75402208)
print v(xbgr.mr_n75402528)
print v(xbgr.mr_n75402640)
print v(xbgr.mr_n75402960)
print v(xbgr.mr_n75403072)
print v(xbgr.mr_n75403392)
print v(xbgr.mr_n75403504)
print v(xbgr.mr_n75403824)
print v(xbgr.mr_n75403936)
print v(xbgr.mr_n75404256)
print v(xbgr.mr_n75404368)
print v(xbgr.mr_n75404688)
print v(xbgr.mr_n75404800)
print v(xbgr.mr_n75405120)
print v(xbgr.mr_n75405232)
print v(xbgr.mr_n75405552)
print v(xbgr.mr_n75405664)
print v(xbgr.mr_n75405984)
print v(xbgr.mr_n75406096)
print v(xbgr.mr_n75406416)
print v(xbgr.mr_n75406528)
print v(xbgr.mr_n75406848)
print v(xbgr.mr_n75406960)
print v(xbgr.mr_n75407280)
print v(xbgr.mr_n75407392)
print v(xbgr.mr_n75407712)
print v(xbgr.mr_n75407824)
print v(xbgr.mr_n75408144)
print v(xbgr.mr_n75408256)
print v(xbgr.mr_n75408576)
print v(xbgr.mr_n75408688)
print v(xbgr.mr_n75409008)
print v(xbgr.mr_n75409120)
print v(xbgr.mr_n75409440)
print v(xbgr.mr_n75409552)
print v(xbgr.mr_n75409872)
print v(xbgr.mr_n75409984)
print v(xbgr.mr_n75410304)
print v(xbgr.mr_n75410416)
print v(xbgr.mr_n75410736)
print v(xbgr.mr_n75410848)
print v(xbgr.mr_n75411168)
print v(xbgr.mr_n75411280)
print v(xbgr.mr_n75411600)
print v(xbgr.mr_n75411712)
print v(xbgr.mr_n75412032)
print v(xbgr.mr_n75412144)
print v(xbgr.mr_n75412464)
print v(xbgr.mr_n75412576)
print v(xbgr.mr_n75412896)
print v(xbgr.mr_n75413008)
print v(xbgr.mr_n75413328)
print v(xbgr.mr_n75413440)
print v(xbgr.mr_n75413760)
print v(xbgr.mr_n75413872)
print v(xbgr.mr_n75414192)
print v(xbgr.mr_n75414304)
print v(xbgr.mr_n75414624)
print v(xbgr.mr_n75414736)
print v(xbgr.mr_n75415056)
print v(xbgr.mr_n75415168)
print v(xbgr.mr_n75415488)
print v(xbgr.mr_n75415600)
print v(xbgr.mr_n75415920)
print v(xbgr.mr_n75416032)
print v(xbgr.mr_n75416352)
print v(xbgr.mr_n75416464)
print v(xbgr.mr_n75416784)
print v(xbgr.mr_n75416896)
print v(xbgr.mr_n75417216)
print v(xbgr.mr_n75417328)
print v(xbgr.mr_n75417648)
print v(xbgr.mr_n75417760)
print v(xbgr.mr_n75418080)
print v(xbgr.mr_n75418192)
print v(xbgr.mr_n75418512)
print v(xbgr.mr_n75418624)
print v(xbgr.mr_n75418944)
print v(xbgr.mr_n75419056)
print v(xbgr.mr_n75419376)
print v(xbgr.mr_n75419488)
print v(xbgr.mr_n75419808)
print v(xbgr.mr_n75419920)
print v(xbgr.mr_n75420240)
print v(xbgr.mr_n75420352)
print v(xbgr.mr_n75420672)
print v(xbgr.mr_n75420784)
print v(xbgr.mr_n75421104)
print v(xbgr.mr_n75421216)
print v(xbgr.mr_n75421536)
print v(xbgr.mr_n75421648)
print v(xbgr.mr_n75421968)
print v(xbgr.mr_n75422080)
print v(xbgr.mr_n75422400)
print v(xbgr.mr_n75422512)
print v(xbgr.mr_n75422832)
print v(xbgr.mr_n75422944)
print v(xbgr.mr_n75423264)
print v(xbgr.mr_n75423376)
print v(xbgr.mr_n75423696)
print v(xbgr.mr_n75423808)
print v(xbgr.mr_n75424128)
print v(xbgr.mr_n75424240)
print v(xbgr.mr_n75424560)
print v(xbgr.mr_n75424672)
print v(xbgr.mr_n75424992)
print v(xbgr.mr_n75425104)
print v(xbgr.mr_n75425424)
print v(xbgr.mr_n75425536)
print v(xbgr.mr_n75425856)
print v(xbgr.mr_n75425968)
print v(xbgr.mr_n75426288)
print v(xbgr.mr_n75426400)
print v(xbgr.mr_n75426720)
print v(xbgr.mr_n75426832)
print v(xbgr.mr_n75427152)
print v(xbgr.mr_n75427264)
print v(xbgr.mr_n75427584)
print v(xbgr.mr_n75427696)
print v(xbgr.mr_n75428016)
print v(xbgr.mr_n75428128)
print v(xbgr.mr_n75428448)
print v(xbgr.mr_n75428560)
print v(xbgr.mr_n75428880)
print v(xbgr.mr_n75428992)
print v(xbgr.mr_n75429312)
print v(xbgr.mr_n75429424)
print v(xbgr.mr_n75429744)
print v(xbgr.mr_n75429856)
print v(xbgr.mr_n75430176)
print v(xbgr.mr_n75430288)
print v(xbgr.mr_n75430608)
print v(xbgr.mr_n75430720)
print v(xbgr.mr_n75431040)
print v(xbgr.mr_n75431152)
print v(xbgr.mr_n75431472)
print v(xbgr.mr_n75431584)
print v(xbgr.mr_n75431904)
print v(xbgr.mr_n75432016)
print v(xbgr.mr_n75432336)
print v(xbgr.mr_n75432448)
print v(xbgr.mr_n75432768)
print v(xbgr.mr_n75432880)
print v(xbgr.mr_n75433200)
print v(xbgr.mr_n75433312)
print v(xbgr.mr_n75433632)
print v(xbgr.mr_n75433744)
print v(xbgr.mr_n75434064)
print v(xbgr.mr_n75434176)
print v(xbgr.mr_n75434496)
print v(xbgr.mr_n75434608)
print v(xbgr.mr_n75434928)
print v(xbgr.mr_n75435040)
print v(xbgr.mr_n75435360)
print v(xbgr.mr_n75435472)
print v(xbgr.mr_n75435792)
print v(xbgr.mr_n75435904)
print v(xbgr.mr_n75436224)
print v(xbgr.mr_n75436336)
print v(xbgr.mr_n75436656)
print v(xbgr.mr_n75436768)
print v(xbgr.mr_n75437088)
print v(xbgr.mr_n75437200)
print v(xbgr.mr_n75437520)
print v(xbgr.mr_n75437632)
print v(xbgr.mr_n75437952)
print v(xbgr.mr_n75438064)
print v(xbgr.mr_n75438384)
print v(xbgr.mr_n75438496)
print v(xbgr.mr_n75438816)
print v(xbgr.mr_n75438928)
print v(xbgr.mr_n75439248)
print v(xbgr.mr_n75439360)
print v(xbgr.mr_n75439680)
print v(xbgr.mr_n75439792)
print v(xbgr.mr_n75440112)
print v(xbgr.mr_n75440224)
print v(xbgr.mr_n75440544)
print v(xbgr.mr_n75440656)
print v(xbgr.mr_n75440976)
print v(xbgr.mr_n75441088)
print v(xbgr.mr_n75441520)
print v(xbgr.mr_n75441840)
print v(xbgr.mr_n75441952)
print v(xbgr.mr_n75442272)
print v(xbgr.mr_n75442384)
print v(xbgr.mr_n75442704)
print v(xbgr.mr_n75442816)
print v(xbgr.mr_n75443136)
print v(xbgr.mr_n75443248)
print v(xbgr.mr_n75443568)
print v(xbgr.mr_n75443680)
print v(xbgr.mr_n75444000)
print v(xbgr.mr_n75444112)
print v(xbgr.mr_n75444432)
print v(xbgr.mr_n75444544)
print v(xbgr.mr_n75444864)
print v(xbgr.mr_n75444976)
print v(xbgr.mr_n75445296)
print v(xbgr.mr_n75445408)
print v(xbgr.mr_n75445728)
print v(xbgr.mr_n75445840)
print v(xbgr.mr_n75446160)
print v(xbgr.mr_n75446272)
print v(xbgr.mr_n75446592)
print v(xbgr.mr_n75446704)
print v(xbgr.mr_n75447024)
print v(xbgr.mr_n75447136)
print v(xbgr.mr_n75447568)
print v(xbgr.mr_n75447888)
print v(xbgr.mr_n75448000)
print v(xbgr.mr_n75448320)
print v(xbgr.mr_n75448432)
print v(xbgr.mr_n75448752)
print v(xbgr.mr_n75448864)
print v(xbgr.mr_n75449184)
print v(xbgr.mr_n75449296)
print v(xbgr.mr_n75449616)
print v(xbgr.mr_n75449728)
print v(xbgr.mr_n75450048)
print v(xbgr.mr_n75450160)
print v(xbgr.mr_n75450480)
print v(xbgr.mr_n75450592)
print v(xbgr.mr_n75450912)
print v(xbgr.mr_n75451024)
print v(xbgr.mr_n75451344)
print v(xbgr.mr_n75451456)
print v(xbgr.mr_n75451776)
print v(xbgr.mr_n75451888)
print v(xbgr.mr_n75452208)
print v(xbgr.mr_n75452320)
print v(xbgr.mr_n75452640)
print v(xbgr.mr_n75452752)
print v(xbgr.mr_n75453072)
print v(xbgr.mr_n75453184)
print v(xbgr.mr_n75453504)
print v(xbgr.mr_n75453616)
print v(xbgr.mr_n75453936)
print v(xbgr.mr_n75454048)
print v(xbgr.mr_n75454368)
print v(xbgr.mr_n75454480)
print v(xbgr.mr_n75454800)
print v(xbgr.mr_n75454912)
print v(xbgr.mr_n75455232)
print v(xbgr.mr_n75455344)
print v(xbgr.mr_n75455664)
print v(xbgr.mr_n75455776)
print v(xbgr.mr_n75456096)
print v(xbgr.mr_n75456208)
print v(xbgr.mr_n75456528)
print v(xbgr.mr_n75456640)
print v(xbgr.mr_n75456960)
print v(xbgr.mr_n75457072)
print v(xbgr.mr_n75457392)
print v(xbgr.mr_n75457504)
print v(xbgr.mr_n75457824)
print v(xbgr.mr_n75457936)
print v(xbgr.mr_n75458256)
print v(xbgr.mr_n75458368)
print v(xbgr.mr_n75458688)
print v(xbgr.mr_n75458800)
print v(xbgr.mr_n75459120)
print v(xbgr.mr_n75459232)
print v(xbgr.mr_n75459552)
print v(xbgr.mr_n75459664)
print v(xbgr.mr_n75459984)
print v(xbgr.mr_n75460096)
print v(xbgr.mr_n75460416)
print v(xbgr.mr_n75460528)
print v(xbgr.mr_n75460848)
print v(xbgr.mr_n75460960)
print v(xbgr.mr_n75461280)
print v(xbgr.mr_n75461392)
print v(xbgr.mr_n75461712)
print v(xbgr.mr_n75461824)
print v(xbgr.mr_n75462144)
print v(xbgr.mr_n75462256)
print v(xbgr.mr_n75462576)
print v(xbgr.mr_n75462688)
print v(xbgr.mr_n75463008)
print v(xbgr.mr_n75463120)
print v(xbgr.mr_n75463440)
print v(xbgr.mr_n75463552)
print v(xbgr.mr_n75463872)
print v(xbgr.mr_n75463984)
print v(xbgr.mr_n75464304)
print v(xbgr.mr_n75464416)
print v(xbgr.mr_n75464736)
print v(xbgr.mr_n75464848)
print v(xbgr.mr_n75465168)
print v(xbgr.mr_n75465280)
print v(xbgr.mr_n75465600)
print v(xbgr.mr_n75465712)
print v(xbgr.mr_n75466032)
print v(xbgr.mr_n75466144)
print v(xbgr.mr_n75466464)
print v(xbgr.mr_n75466576)
print v(xbgr.mr_n75466896)
print v(xbgr.mr_n75467008)
print v(xbgr.mr_n75467328)
print v(xbgr.mr_n75467440)
print v(xbgr.mr_n75467760)
print v(xbgr.mr_n75467872)
print v(xbgr.mr_n75468192)
print v(xbgr.mr_n75468304)
print v(xbgr.mr_n75468624)
print v(xbgr.mr_n75468736)
print v(xbgr.mr_n75469056)
print v(xbgr.mr_n75469168)
print v(xbgr.mr_n75469488)
print v(xbgr.mr_n75469600)
print v(xbgr.mr_n75469920)
print v(xbgr.mr_n75470032)
print v(xbgr.mr_n75470352)
print v(xbgr.mr_n75470464)
print v(xbgr.mr_n75470784)
print v(xbgr.mr_n75470896)
print v(xbgr.mr_n75471216)
print v(xbgr.mr_n75471328)
print v(xbgr.mr_n75471648)
print v(xbgr.mr_n75471760)
print v(xbgr.mr_n75472080)
print v(xbgr.mr_n75472192)
print v(xbgr.mr_n75472512)
print v(xbgr.mr_n75472624)
print v(xbgr.mr_n75472944)
print v(xbgr.mr_n75473056)
print v(xbgr.mr_n75473376)
print v(xbgr.mr_n75473488)
print v(xbgr.mr_n75473808)
print v(xbgr.mr_n75473920)
print v(xbgr.mr_n75474240)
print v(xbgr.mr_n75474352)
print v(xbgr.mr_n75474672)
print v(xbgr.mr_n75474784)
print v(xbgr.mr_n75475104)
print v(xbgr.mr_n75475216)
print v(xbgr.mr_n75475536)
print v(xbgr.mr_n75475648)
print v(xbgr.mr_n75475968)
print v(xbgr.mr_n75476080)
print v(xbgr.mr_n75476400)
print v(xbgr.mr_n75476512)
print v(xbgr.mr_n75476832)
print v(xbgr.mr_n75476944)
print v(xbgr.mr_n75477264)
print v(xbgr.mr_n75477376)
print v(xbgr.mr_n75477696)
print v(xbgr.mr_n75477808)
print v(xbgr.mr_n75478128)
print v(xbgr.mr_n75478240)
print v(xbgr.mr_n75478560)
print v(xbgr.mr_n75478672)
print v(xbgr.mr_n75478992)
print v(xbgr.mr_n75479104)
print v(xbgr.mr_n75479424)
print v(xbgr.mr_n75479536)
print v(xbgr.mr_n75479856)
print v(xbgr.mr_n75479968)
print v(xbgr.mr_n75480400)
print v(xbgr.mr_n75480720)
print v(xbgr.mr_n75480832)
print v(xbgr.mr_n75481152)
print v(xbgr.mr_n75481264)
print v(xbgr.mr_n75481584)
print v(xbgr.mr_n75481696)
print v(xbgr.mr_n75482128)
print v(xbgr.mr_n75482448)
print v(xbgr.mr_n75482560)
print v(xbgr.mr_n75482880)
print v(xbgr.mr_n75482992)
print v(xbgr.mr_n75483312)
print v(xbgr.mr_n75483424)
print v(xbgr.mr_n75483856)
print v(xbgr.mr_n75484176)
print v(xbgr.mr_n75484288)
print v(xbgr.mr_n75484608)
print v(xbgr.mr_n75484720)
print v(xbgr.mr_n75485040)
print v(xbgr.mr_n75485152)
print v(xbgr.mr_n75485472)
print v(xbgr.mr_n75485584)
print v(xbgr.mr_n75485904)
print v(xbgr.mr_n75486016)
print v(xbgr.mr_n75486336)
print v(xbgr.mr_n75486448)
print v(xbgr.mr_n75486768)
print v(xbgr.mr_n75486880)
print v(xbgr.mr_n75487200)
print v(xbgr.mr_n75487312)
print v(xbgr.mr_n75487632)
print v(xbgr.mr_n75487744)
print v(xbgr.mr_n75488064)
print v(xbgr.mr_n75488176)
print v(xbgr.mr_n75488496)
print v(xbgr.mr_n75488608)
print v(xbgr.mr_n75488928)
print v(xbgr.mr_n75489040)
print v(xbgr.mr_n75489360)
print v(xbgr.mr_n75489472)
print v(xbgr.mr_n75489792)
print v(xbgr.mr_n75489904)
print v(xbgr.mr_n75490224)
print v(xbgr.mr_n75490336)
print v(xbgr.mr_n75490656)
print v(xbgr.mr_n75490768)
print v(xbgr.mr_n75491088)
print v(xbgr.mr_n75491200)
print v(xbgr.mr_n75491520)
print v(xbgr.mr_n75491632)
print v(xbgr.mr_n75491952)
print v(xbgr.mr_n75492064)
print v(xbgr.mr_n75492384)
print v(xbgr.mr_n75492496)
print v(xbgr.mr_n75492816)
print v(xbgr.mr_n75492928)
print v(xbgr.mr_n75493248)
print v(xbgr.mr_n75493360)
print v(xbgr.mr_n75493680)
print v(xbgr.mr_n75493792)
print v(xbgr.mr_n75494112)
print v(xbgr.mr_n75494224)
print v(xbgr.mr_n75494544)
print v(xbgr.mr_n75494656)
print v(xbgr.mr_n75494976)
print v(xbgr.mr_n75495088)
print v(xbgr.mr_n75495408)
print v(xbgr.mr_n75495520)
print v(xbgr.mr_n75495840)
print v(xbgr.mr_n75495952)
print v(xbgr.mr_n75496272)
print v(xbgr.mr_n75496384)
print v(xbgr.mr_n75496704)
print v(xbgr.mr_n75496816)
print v(xbgr.mr_n75497136)
print v(xbgr.mr_n75497248)
print v(xbgr.mr_n75497568)
print v(xbgr.mr_n75497680)
print v(xbgr.mr_n75498000)
print v(xbgr.mr_n75498112)
print v(xbgr.mr_n75498432)
print v(xbgr.mr_n75498544)
print v(xbgr.mr_n75498864)
print v(xbgr.mr_n75498976)
print v(xbgr.mr_n75499296)
print v(xbgr.mr_n75499408)
print v(xbgr.mr_n75499728)
print v(xbgr.mr_n75499840)
print v(xbgr.mr_n75500160)
print v(xbgr.mr_n75500272)
print v(xbgr.mr_n75500592)
print v(xbgr.mr_n75500704)
print v(xbgr.mr_n75501024)
print v(xbgr.mr_n75501136)
print v(xbgr.mr_n75501456)
print v(xbgr.mr_n75501568)
print v(xbgr.mr_n75501888)
print v(xbgr.mr_n75502000)
print v(xbgr.mr_n75502320)
print v(xbgr.mr_n75502432)
print v(xbgr.mr_n75502752)
print v(xbgr.mr_n75502864)
print v(xbgr.mr_n75503184)
print v(xbgr.mr_n75503296)
print v(xbgr.mr_n75503616)
print v(xbgr.mr_n75503728)
print v(xbgr.mr_n75504160)
print v(xbgr.mr_n75504592)
print v(xbgr.mr_n75505024)
print v(xbgr.mr_n75505456)
print v(xbgr.mr_n75505888)
print v(xbgr.mr_n75506320)
print v(xbgr.mr_n75506752)
print v(xbgr.mr_n75507184)
print v(xbgr.mr_n75507616)
print v(xbgr.mr_n75508048)
print v(xbgr.mr_n75508480)
print v(xbgr.mr_n75508912)
print v(xbgr.mr_n75509344)
print v(xbgr.mr_n75509776)
print v(xbgr.mr_n75510208)
print v(xbgr.mr_n75510640)
print v(xbgr.mr_n75511072)
print v(xbgr.mr_n75511504)
print v(xbgr.mr_n75511936)
print v(xbgr.mr_n75512368)
print v(xbgr.mr_n75512800)
print v(xbgr.mr_n75513232)
print v(xbgr.mr_n75513664)
print v(xbgr.mr_n75514096)
print v(xbgr.mr_n75514528)
print v(xbgr.mr_n75514960)
print v(xbgr.mr_n75515392)
print v(xbgr.mr_n75515824)
print v(xbgr.mr_n75516256)
print v(xbgr.mr_n75516688)
print v(xbgr.mr_n75517120)
print v(xbgr.mr_n75517552)
print v(xbgr.mr_n75517984)
print v(xbgr.mr_n75518416)
print v(xbgr.mr_n75518848)
print v(xbgr.mr_n75519280)
print v(xbgr.mr_n75519712)
print v(xbgr.mr_n75520144)
print v(xbgr.mr_n75520576)
print v(xbgr.mr_n75521008)
print v(xbgr.mr_n75521440)
print v(xbgr.mr_n75521872)
print v(xbgr.mr_n75522304)
print v(xbgr.mr_n75522736)
print v(xbgr.mr_n75523168)
print v(xbgr.mr_n75523600)
print v(xbgr.mr_n75524032)
print v(xbgr.mr_n75524464)
print v(xbgr.mr_n75524896)
print v(xbgr.mr_n75525328)
print v(xbgr.mr_n75525760)
print v(xbgr.mr_n75526192)
print v(xbgr.mr_n75526624)
print v(xbgr.mr_n75527056)
print v(xbgr.mr_n75527488)
print v(xbgr.mr_n75527920)
print v(xbgr.mr_n75528352)
print v(xbgr.mr_n75528784)
print v(xbgr.mr_n75529216)
print v(xbgr.mr_n75529648)
print v(xbgr.mr_n75530080)
print v(xbgr.mr_n75530512)
print v(xbgr.mr_n75530944)
print v(xbgr.mr_n75531376)
print v(xbgr.mr_n75531808)
print v(xbgr.mr_n75532240)
print v(xbgr.mr_n75532672)
print v(xbgr.mr_n75533104)
print v(xbgr.mr_n75533536)
print v(xbgr.mr_n75533968)
print v(xbgr.mr_n75534400)
print v(xbgr.mr_n75534832)
print v(xbgr.mr_n75535264)
print v(xbgr.mr_n75535696)
print v(xbgr.mr_n75536128)
print v(xbgr.mr_n75536560)
print v(xbgr.mr_n75536992)
print v(xbgr.mr_n75537424)
print v(xbgr.mr_n75537856)
print v(xbgr.mr_n75538288)
print v(xbgr.mr_n75538608)
print v(xbgr.mr_n75538720)
print v(xbgr.mr_n75539152)
print v(xbgr.mr_n75539472)
print v(xbgr.mr_n75539584)
print v(xbgr.mr_n75539904)
print v(xbgr.mr_n75540016)
print v(xbgr.mr_n75540336)
print v(xbgr.mr_n75540448)
print v(xbgr.mr_n75540768)
print v(xbgr.mr_n75540880)
print v(xbgr.mr_n75541200)
print v(xbgr.mr_n75541312)
print v(xbgr.mr_n75541632)
print v(xbgr.mr_n75541744)
print v(xbgr.mr_n75542064)
print v(xbgr.mr_n75542176)
print v(xbgr.mr_n75542496)
print v(xbgr.mr_n75542608)
print v(xbgr.mr_n75542928)
print v(xbgr.mr_n75543040)
print v(xbgr.mr_n75543360)
print v(xbgr.mr_n75543472)
print v(xbgr.mr_n75543904)
print v(xbgr.mr_n75544336)
print v(xbgr.mr_n75544768)
print v(xbgr.mr_n75545200)
print v(xbgr.mr_n75545632)
print v(xbgr.mr_n75546064)
print v(xbgr.mr_n75546496)
print v(xbgr.mr_n75546928)
print v(xbgr.mr_n75547360)
print v(xbgr.mr_n75547792)
print v(xbgr.mr_n75548224)
print v(xbgr.mr_n75548656)
print v(xbgr.mr_n75549088)
print v(xbgr.mr_n75549520)
print v(xbgr.mr_n75549952)
print v(xbgr.mr_n75550384)
print v(xbgr.mr_n75550816)
print v(xbgr.mr_n75551248)
print v(xbgr.mr_n75551680)
print v(xbgr.mr_n75552112)
print v(xbgr.mr_n75552544)
print v(xbgr.mr_n75552976)
print v(xbgr.mr_n75553408)
print v(xbgr.mr_n75553840)
print v(xbgr.mr_n75554272)
print v(xbgr.mr_n75554704)
print v(xbgr.mr_n75555136)
print v(xbgr.mr_n75555408)
print v(xbgr.mr_n75555520)
print v(xbgr.mr_n75555840)
print v(xbgr.mr_n75555952)
print v(xbgr.mr_n75556272)
print v(xbgr.mr_n75556384)
print v(xbgr.mr_n75556704)
print v(xbgr.mr_n75556816)
print v(xbgr.mr_n75557136)
print v(xbgr.mr_n75557248)
print v(xbgr.mr_n75557568)
print v(xbgr.mr_n75557680)
print v(xbgr.mr_n75558000)
print v(xbgr.mr_n75558112)
print v(xbgr.mr_n75558432)
print v(xbgr.mr_n75558544)
print v(xbgr.mr_n75558864)
print v(xbgr.mr_n75558976)
print v(xbgr.mr_n75559296)
print v(xbgr.mr_n75559408)
print v(xbgr.mr_n75559728)
print v(xbgr.mr_n75559840)
print v(xbgr.mr_n75560160)
print v(xbgr.mr_n75560272)
print v(xbgr.mr_n75560592)
print v(xbgr.mr_n75560704)
print v(xbgr.mr_n75561024)
print v(xbgr.mr_n75561136)
print v(xbgr.mr_n75561456)
print v(xbgr.mr_n75561568)
print v(xbgr.mr_n75561888)
print v(xbgr.mr_n75562000)
print v(xbgr.mr_n75562320)
print v(xbgr.mr_n75562432)
print v(xbgr.mr_n75562752)
print v(xbgr.mr_n75562864)
print v(xbgr.mr_n75563184)
print v(xbgr.mr_n75563296)
print v(xbgr.mr_n75563616)
print v(xbgr.mr_n75563728)
print v(xbgr.mr_n75564048)
print v(xbgr.mr_n75564160)
print v(xbgr.mr_n75564480)
print v(xbgr.mr_n75564592)
print v(xbgr.mr_n75564912)
print v(xbgr.mr_n75565024)
print v(xbgr.mr_n75565344)
print v(xbgr.mr_n75565456)
print v(xbgr.mr_n75565776)
print v(xbgr.mr_n75565888)
print v(xbgr.mr_n75566208)
print v(xbgr.mr_n75566320)
print v(xbgr.mr_n75566640)
print v(xbgr.mr_n75566752)
print v(xbgr.mr_n75567072)
print v(xbgr.mr_n75567184)
print v(xbgr.mr_n75567504)
print v(xbgr.mr_n75567616)
print v(xbgr.mr_n75567936)
print v(xbgr.mr_n75568048)
print v(xbgr.mr_n75568368)
print v(xbgr.mr_n75568480)
print v(xbgr.mr_n75568800)
print v(xbgr.mr_n75568912)
print v(xbgr.mr_n75569232)
print v(xbgr.mr_n75569344)
print v(xbgr.mr_n75569664)
print v(xbgr.mr_n75569776)
print v(xbgr.mr_n75570096)
print v(xbgr.mr_n75570208)
print v(xbgr.mr_n75570528)
print v(xbgr.mr_n75570640)
print v(xbgr.mr_n75570960)
print v(xbgr.mr_n75571072)
print v(xbgr.mr_n75571392)
print v(xbgr.mr_n75571504)
print v(xbgr.mr_n75571824)
print v(xbgr.mr_n75571936)
print v(xbgr.mr_n75572256)
print v(xbgr.mr_n75572368)
print v(xbgr.mr_n75572688)
print v(xbgr.mr_n75572800)
print v(xbgr.mr_n75573120)
print v(xbgr.mr_n75573232)
print v(xbgr.mr_n75573552)
print v(xbgr.mr_n75573664)
print v(xbgr.mr_n75573984)
print v(xbgr.mr_n75574096)
print v(xbgr.mr_n75574416)
print v(xbgr.mr_n75574528)
print v(xbgr.mr_n75574848)
print v(xbgr.mr_n75574960)
print v(xbgr.mr_n75575280)
print v(xbgr.mr_n75575392)
print v(xbgr.mr_n75575712)
print v(xbgr.mr_n75575824)
print v(xbgr.mr_n75576144)
print v(xbgr.mr_n75576256)
print v(xbgr.mr_n75576576)
print v(xbgr.mr_n75576688)
print v(xbgr.mr_n75577008)
print v(xbgr.mr_n75577120)
print v(xbgr.mr_n75577440)
print v(xbgr.mr_n75577552)
print v(xbgr.mr_n75577872)
print v(xbgr.mr_n75577984)
print v(xbgr.mr_n75578304)
print v(xbgr.mr_n75578416)
print v(xbgr.mr_n75578736)
print v(xbgr.mr_n75578848)
print v(xbgr.mr_n75579168)
print v(xbgr.mr_n75579280)
print v(xbgr.mr_n75579600)
print v(xbgr.mr_n75579712)
print v(xbgr.mr_n75580032)
print v(xbgr.mr_n75580144)
print v(xbgr.mr_n75580464)
print v(xbgr.mr_n75580576)
print v(xbgr.mr_n75580896)
print v(xbgr.mr_n75581008)
print v(xbgr.mr_n75581328)
print v(xbgr.mr_n75581440)
print v(xbgr.mr_n75581760)
print v(xbgr.mr_n75581872)
print v(xbgr.mr_n75582192)
print v(xbgr.mr_n75582304)
print v(xbgr.mr_n75582624)
print v(xbgr.mr_n75582736)
print v(xbgr.mr_n75583056)
print v(xbgr.mr_n75583168)
print v(xbgr.mr_n75583488)
print v(xbgr.mr_n75583600)
print v(xbgr.mr_n75583920)
print v(xbgr.mr_n75584032)
print v(xbgr.mr_n75584352)
print v(xbgr.mr_n75584464)
print v(xbgr.mr_n75584784)
print v(xbgr.mr_n75584896)
print v(xbgr.mr_n75585216)
print v(xbgr.mr_n75585328)
print v(xbgr.mr_n75585648)
print v(xbgr.mr_n75585760)
print v(xbgr.mr_n75586080)
print v(xbgr.mr_n75586192)
print v(xbgr.mr_n75586512)
print v(xbgr.mr_n75586624)
print v(xbgr.mr_n75586944)
print v(xbgr.mr_n75587056)
print v(xbgr.mr_n75587376)
print v(xbgr.mr_n75587488)
print v(xbgr.mr_n75587808)
print v(xbgr.mr_n75587920)
print v(xbgr.mr_n75588240)
print v(xbgr.mr_n75588352)
print v(xbgr.mr_n75588672)
print v(xbgr.mr_n75588784)
print v(xbgr.mr_n75589104)
print v(xbgr.mr_n75589216)
print v(xbgr.mr_n75589536)
print v(xbgr.mr_n75589648)
print v(xbgr.mr_n75589968)
print v(xbgr.mr_n75590080)
print v(xbgr.mr_n75590400)
print v(xbgr.mr_n75590512)
print v(xbgr.mr_n75590832)
print v(xbgr.mr_n75590944)
print v(xbgr.mr_n75591264)
print v(xbgr.mr_n75591376)
print v(xbgr.mr_n75591696)
print v(xbgr.mr_n75591808)
print v(xbgr.mr_n75592128)
print v(xbgr.mr_n75592240)
print v(xbgr.mr_n75592560)
print v(xbgr.mr_n75592672)
print v(xbgr.mr_n75592992)
print v(xbgr.mr_n75593104)
print v(xbgr.mr_n75593424)
print v(xbgr.mr_n75593536)
print v(xbgr.mr_n75593856)
print v(xbgr.mr_n75593968)
print v(xbgr.mr_n75594288)
print v(xbgr.mr_n75594400)
print v(xbgr.mr_n75594720)
print v(xbgr.mr_n75594832)
print v(xbgr.mr_n75595152)
print v(xbgr.mr_n75595264)
print v(xbgr.mr_n75595584)
print v(xbgr.mr_n75595696)
print v(xbgr.mr_n75596016)
print v(xbgr.mr_n75596128)
print v(xbgr.mr_n75596448)
print v(xbgr.mr_n75596560)
print v(xbgr.mr_n75596880)
print v(xbgr.mr_n75596992)
print v(xbgr.mr_n75597312)
print v(xbgr.mr_n75597424)
print v(xbgr.mr_n75597744)
print v(xbgr.mr_n75597856)
print v(xbgr.mr_n75598176)
print v(xbgr.mr_n75598288)
print v(xbgr.mr_n75598608)
print v(xbgr.mr_n75598720)
print v(xbgr.mr_n75599040)
print v(xbgr.mr_n75599152)
print v(xbgr.mr_n75599472)
print v(xbgr.mr_n75599584)
print v(xbgr.mr_n75599904)
print v(xbgr.mr_n75600016)
print v(xbgr.mr_n75600336)
print v(xbgr.mr_n75600448)
print v(xbgr.mr_n75600768)
print v(xbgr.mr_n75600880)
print v(xbgr.mr_n75601200)
print v(xbgr.mr_n75601312)
print v(xbgr.mr_n75601632)
print v(xbgr.mr_n75601744)
print v(xbgr.mr_n75602064)
print v(xbgr.mr_n75602176)
print v(xbgr.mr_n75602496)
print v(xbgr.mr_n75602608)
print v(xbgr.mr_n75602928)
print v(xbgr.mr_n75603040)
print v(xbgr.mr_n75603360)
print v(xbgr.mr_n75603472)
print v(xbgr.mr_n75603792)
print v(xbgr.mr_n75603904)
print v(xbgr.mr_n75604224)
print v(xbgr.mr_n75604336)
print v(xbgr.mr_n75604656)
print v(xbgr.mr_n75604768)
print v(xbgr.mr_n75605088)
print v(xbgr.mr_n75605200)
print v(xbgr.mr_n75605520)
print v(xbgr.mr_n75605632)
print v(xbgr.mr_n75605952)
print v(xbgr.mr_n75606064)
print v(xbgr.mr_n75606384)
print v(xbgr.mr_n75606496)
print v(xbgr.mr_n75606816)
print v(xbgr.mr_n75606928)
print v(xbgr.mr_n75607248)
print v(xbgr.mr_n75607360)
print v(xbgr.mr_n75607680)
print v(xbgr.mr_n75607792)
print v(xbgr.mr_n75608112)
print v(xbgr.mr_n75608224)
print v(xbgr.mr_n75608544)
print v(xbgr.mr_n75608656)
print v(xbgr.mr_n75608976)
print v(xbgr.mr_n75609088)
print v(xbgr.mr_n75609408)
print v(xbgr.mr_n75609520)
print v(xbgr.mr_n75609840)
print v(xbgr.mr_n75609952)
print v(xbgr.mr_n75610272)
print v(xbgr.mr_n75610384)
print v(xbgr.mr_n75610704)
print v(xbgr.mr_n75610816)
print v(xbgr.mr_n75611136)
print v(xbgr.mr_n75611248)
print v(xbgr.mr_n75611568)
print v(xbgr.mr_n75611680)
print v(xbgr.mr_n75612000)
print v(xbgr.mr_n75612112)
print v(xbgr.mr_n75612432)
print v(xbgr.mr_n75612544)
print v(xbgr.mr_n75612864)
print v(xbgr.mr_n75612976)
print v(xbgr.mr_n75613296)
print v(xbgr.mr_n75613408)
print v(xbgr.mr_n75613728)
print v(xbgr.mr_n75613840)
print v(xbgr.mr_n75614160)
print v(xbgr.mr_n75614272)
print v(xbgr.mr_n75614592)
print v(xbgr.mr_n75614704)
print v(xbgr.mr_n75615024)
print v(xbgr.mr_n75615136)
print v(xbgr.mr_n75615456)
print v(xbgr.mr_n75615568)
print v(xbgr.mr_n75615888)
print v(xbgr.mr_n75616000)
print v(xbgr.mr_n75616320)
print v(xbgr.mr_n75616432)
print v(xbgr.mr_n75616752)
print v(xbgr.mr_n75616864)
print v(xbgr.mr_n75617184)
print v(xbgr.mr_n75617296)
print v(xbgr.mr_n75617616)
print v(xbgr.mr_n75617728)
print v(xbgr.mr_n75618048)
print v(xbgr.mr_n75618160)
print v(xbgr.mr_n75618480)
print v(xbgr.mr_n75618592)
print v(xbgr.mr_n75618912)
print v(xbgr.mr_n75619024)
print v(xbgr.mr_n75619344)
print v(xbgr.mr_n75619456)
print v(xbgr.mr_n75619776)
print v(xbgr.mr_n75619888)
print v(xbgr.mr_n75620208)
print v(xbgr.mr_n75620320)
print v(xbgr.mr_n75620640)
print v(xbgr.mr_n75620752)
print v(xbgr.mr_n75621072)
print v(xbgr.mr_n75621184)
print v(xbgr.mr_n75621504)
print v(xbgr.mr_n75621616)
print v(xbgr.mr_n75621936)
print v(xbgr.mr_n75622048)
print v(xbgr.mr_n75622368)
print v(xbgr.mr_n75622480)
print v(xbgr.mr_n75622800)
print v(xbgr.mr_n75622912)
print v(xbgr.mr_n75623232)
print v(xbgr.mr_n75623344)
print v(xbgr.mr_n75623664)
print v(xbgr.mr_n75623776)
print v(xbgr.mr_n75624096)
print v(xbgr.mr_n75624208)
print v(xbgr.mr_n75624528)
print v(xbgr.mr_n75624640)
print v(xbgr.mr_n75624960)
print v(xbgr.mr_n75625072)
print v(xbgr.mr_n75625392)
print v(xbgr.mr_n75625504)
print v(xbgr.mr_n75625824)
print v(xbgr.mr_n75625936)
print v(xbgr.mr_n75626256)
print v(xbgr.mr_n75626368)
print v(xbgr.mr_n75626688)
print v(xbgr.mr_n75626800)
print v(xbgr.mr_n75627120)
print v(xbgr.mr_n75627232)
print v(xbgr.mr_n75627552)
print v(xbgr.mr_n75627664)
print v(xbgr.mr_n75627984)
print v(xbgr.mr_n75628096)
print v(xbgr.mr_n75628416)
print v(xbgr.mr_n75628528)
print v(xbgr.mr_n75628848)
print v(xbgr.mr_n75628960)
print v(xbgr.mr_n75629280)
print v(xbgr.mr_n75629392)
print v(xbgr.mr_n75629712)
print v(xbgr.mr_n75629824)
print v(xbgr.mr_n75630144)
print v(xbgr.mr_n75630256)
print v(xbgr.mr_n75630576)
print v(xbgr.mr_n75630688)
print v(xbgr.mr_n75631008)
print v(xbgr.mr_n75631120)
print v(xbgr.mr_n75631440)
print v(xbgr.mr_n75631552)
print v(xbgr.mr_n75631872)
print v(xbgr.mr_n75631984)
print v(xbgr.mr_n75632304)
print v(xbgr.mr_n75632416)
print v(xbgr.mr_n75632736)
print v(xbgr.mr_n75632848)
print v(xbgr.mr_n75633168)
print v(xbgr.mr_n75633280)
print v(xbgr.mr_n75633600)
print v(xbgr.mr_n75633712)
print v(xbgr.mr_n75634032)
print v(xbgr.mr_n75634144)
print v(xbgr.mr_n75634464)
print v(xbgr.mr_n75634576)
print v(xbgr.mr_n75634896)
print v(xbgr.mr_n75635008)
print v(xbgr.mr_n75635328)
print v(xbgr.mr_n75635440)
print v(xbgr.mr_n75635760)
print v(xbgr.mr_n75635872)
print v(xbgr.mr_n75636192)
print v(xbgr.mr_n75636304)
print v(xbgr.mr_n75636624)
print v(xbgr.mr_n75636736)
print v(xbgr.mr_n75637056)
print v(xbgr.mr_n75637168)
print v(xbgr.mr_n75637488)
print v(xbgr.mr_n75637600)
print v(xbgr.mr_n75637920)
print v(xbgr.mr_n75638032)
print v(xbgr.mr_n75638352)
print v(xbgr.mr_n75638464)
print v(xbgr.mr_n75638784)
print v(xbgr.mr_n75638896)
print v(xbgr.mr_n75639216)
print v(xbgr.mr_n75639328)
print v(xbgr.mr_n75639648)
print v(xbgr.mr_n75639760)
print v(xbgr.mr_n75640192)
print v(xbgr.mr_n75640512)
print v(xbgr.mr_n75640624)
print v(xbgr.mr_n75640944)
print v(xbgr.mr_n75641056)
print v(xbgr.mr_n75641376)
print v(xbgr.mr_n75641488)
print v(xbgr.mr_n75641920)
print v(xbgr.mr_n75642240)
print v(xbgr.mr_n75642352)
print v(xbgr.mr_n75642672)
print v(xbgr.mr_n75642784)
print v(xbgr.mr_n75643104)
print v(xbgr.mr_n75643216)
print v(xbgr.mr_n75643648)
print v(xbgr.mr_n75643968)
print v(xbgr.mr_n75644080)
print v(xbgr.mr_n75644400)
print v(xbgr.mr_n75644512)
print v(xbgr.mr_n75644832)
print v(xbgr.mr_n75644944)
print v(xbgr.mr_n75645376)
print v(xbgr.mr_n75645696)
print v(xbgr.mr_n75645808)
print v(xbgr.mr_n75646128)
print v(xbgr.mr_n75646240)
print v(xbgr.mr_n75646560)
print v(xbgr.mr_n75646672)
print v(xbgr.mr_n75647104)
print v(xbgr.mr_n75647424)
print v(xbgr.mr_n75647536)
print v(xbgr.mr_n75647856)
print v(xbgr.mr_n75647968)
print v(xbgr.mr_n75648288)
print v(xbgr.mr_n75648400)
print v(xbgr.mr_n75648832)
print v(xbgr.mr_n75649152)
print v(xbgr.mr_n75649264)
print v(xbgr.mr_n75649584)
print v(xbgr.mr_n75649696)
print v(xbgr.mr_n75650016)
print v(xbgr.mr_n75650128)
print v(xbgr.mr_n75650560)
print v(xbgr.mr_n75650880)
print v(xbgr.mr_n75650992)
print v(xbgr.mr_n75651312)
print v(xbgr.mr_n75651424)
print v(xbgr.mr_n75651744)
print v(xbgr.mr_n75651856)
print v(xbgr.mr_n75652288)
print v(xbgr.mr_n75652608)
print v(xbgr.mr_n75652720)
print v(xbgr.mr_n75653040)
print v(xbgr.mr_n75653152)
print v(xbgr.mr_n75653472)
print v(xbgr.mr_n75653584)
print v(xbgr.mr_n75653904)
print v(xbgr.mr_n75654016)
print v(xbgr.mr_n75654336)
print v(xbgr.mr_n75654448)
print v(xbgr.mr_n75654768)
print v(xbgr.mr_n75654880)
print v(xbgr.mr_n75655200)
print v(xbgr.mr_n75655312)
print v(xbgr.mr_n75655632)
print v(xbgr.mr_n75655744)
print v(xbgr.mr_n75656064)
print v(xbgr.mr_n75656176)
print v(xbgr.mr_n75656496)
print v(xbgr.mr_n75656608)
print v(xbgr.mr_n75656928)
print v(xbgr.mr_n75657040)
print v(xbgr.mr_n75657360)
print v(xbgr.mr_n75657472)
print v(xbgr.mr_n75657792)
print v(xbgr.mr_n75657904)
print v(xbgr.mr_n75658224)
print v(xbgr.mr_n75658336)
print v(xbgr.mr_n75658656)
print v(xbgr.mr_n75658768)
print v(xbgr.mr_n75659088)
print v(xbgr.mr_n75659200)
print v(xbgr.mr_n75659520)
print v(xbgr.mr_n75659632)
print v(xbgr.mr_n75659952)
print v(xbgr.mr_n75660064)
print v(xbgr.mr_n75660384)
print v(xbgr.mr_n75660496)
print v(xbgr.mr_n75660816)
print v(xbgr.mr_n75660928)
print v(xbgr.mr_n75661248)
print v(xbgr.mr_n75661360)
print v(xbgr.mr_n75661680)
print v(xbgr.mr_n75661792)
print v(xbgr.mr_n75662112)
print v(xbgr.mr_n75662224)
print v(xbgr.mr_n75662544)
print v(xbgr.mr_n75662656)
print v(xbgr.mr_n75662976)
print v(xbgr.mr_n75663088)
print v(xbgr.mr_n75663408)
print v(xbgr.mr_n75663520)
print v(xbgr.mr_n75663840)
print v(xbgr.mr_n75663952)
print v(xbgr.mr_n75664272)
print v(xbgr.mr_n75664384)
print v(xbgr.mr_n75664704)
print v(xbgr.mr_n75664816)
print v(xbgr.mr_n75665136)
print v(xbgr.mr_n75665248)
print v(xbgr.mr_n75665568)
print v(xbgr.mr_n75665680)
print v(xbgr.mr_n75666000)
print v(xbgr.mr_n75666112)
print v(xbgr.mr_n75666432)
print v(xbgr.mr_n75666544)
print v(xbgr.mr_n75666864)
print v(xbgr.mr_n75666976)
print v(xbgr.mr_n75667296)
print v(xbgr.mr_n75667408)
print v(xbgr.mr_n75667728)
print v(xbgr.mr_n75667840)
print v(xbgr.mr_n75668160)
print v(xbgr.mr_n75668272)
print v(xbgr.mr_n75668592)
print v(xbgr.mr_n75668704)
print v(xbgr.mr_n75669024)
print v(xbgr.mr_n75669136)
print v(xbgr.mr_n75669456)
print v(xbgr.mr_n75669568)
print v(xbgr.mr_n75669888)
print v(xbgr.mr_n75670000)
print v(xbgr.mr_n75670320)
print v(xbgr.mr_n75670432)
print v(xbgr.mr_n75670752)
print v(xbgr.mr_n75670864)
print v(xbgr.mr_n75671184)
print v(xbgr.mr_n75671296)
print v(xbgr.mr_n75671616)
print v(xbgr.mr_n75671728)
print v(xbgr.mr_n75672048)
print v(xbgr.mr_n75672160)
print v(xbgr.mr_n75672480)
print v(xbgr.mr_n75672592)
print v(xbgr.mr_n75672912)
print v(xbgr.mr_n75673024)
print v(xbgr.mr_n75673344)
print v(xbgr.mr_n75673456)
print v(xbgr.mr_n75673776)
print v(xbgr.mr_n75673888)
print v(xbgr.mr_n75674208)
print v(xbgr.mr_n75674320)
print v(xbgr.mr_n75674640)
print v(xbgr.mr_n75674752)
print v(xbgr.mr_n75675072)
print v(xbgr.mr_n75675184)
print v(xbgr.mr_n75675504)
print v(xbgr.mr_n75675616)
print v(xbgr.mr_n75675936)
print v(xbgr.mr_n75676048)
print v(xbgr.mr_n75676368)
print v(xbgr.mr_n75676480)
print v(xbgr.mr_n75676800)
print v(xbgr.mr_n75676912)
print v(xbgr.mr_n75677232)
print v(xbgr.mr_n75677344)
print v(xbgr.mr_n75677664)
print v(xbgr.mr_n75677776)
print v(xbgr.mr_n75678096)
print v(xbgr.mr_n75678208)
print v(xbgr.mr_n75678528)
print v(xbgr.mr_n75678640)
print v(xbgr.mr_n75678960)
print v(xbgr.mr_n75679072)
print v(xbgr.mr_n75679392)
print v(xbgr.mr_n75679504)
print v(xbgr.mr_n75679824)
print v(xbgr.mr_n75679936)
print v(xbgr.mr_n75680256)
print v(xbgr.mr_n75680368)
print v(xbgr.mr_n75680688)
print v(xbgr.mr_n75680800)
print v(xbgr.mr_n75681120)
print v(xbgr.mr_n75681232)
print v(xbgr.mr_n75681552)
print v(xbgr.mr_n75681664)
print v(xbgr.mr_n75681984)
print v(xbgr.mr_n75682096)
print v(xbgr.mr_n75682528)
print v(xbgr.mr_n75682848)
print v(xbgr.mr_n75682960)
print v(xbgr.mr_n75683280)
print v(xbgr.mr_n75683392)
print v(xbgr.mr_n75683712)
print v(xbgr.mr_n75683824)
print v(xbgr.mr_n75684256)
print v(xbgr.mr_n75684576)
print v(xbgr.mr_n75684688)
print v(xbgr.mr_n75685008)
print v(xbgr.mr_n75685120)
print v(xbgr.mr_n75685440)
print v(xbgr.mr_n75685552)
print v(xbgr.mr_n75685984)
print v(xbgr.mr_n75686304)
print v(xbgr.mr_n75686416)
print v(xbgr.mr_n75686736)
print v(xbgr.mr_n75686848)
print v(xbgr.mr_n75687168)
print v(xbgr.mr_n75687280)
print v(xbgr.mr_n75687600)
print v(xbgr.mr_n75687712)
print v(xbgr.mr_n75688032)
print v(xbgr.mr_n75688144)
print v(xbgr.mr_n75688464)
print v(xbgr.mr_n75688576)
print v(xbgr.mr_n75688896)
print v(xbgr.mr_n75689008)
print v(xbgr.mr_n75689328)
print v(xbgr.mr_n75689440)
print v(xbgr.mr_n75689760)
print v(xbgr.mr_n75689872)
print v(xbgr.mr_n75690304)
print v(xbgr.mr_n75690624)
print v(xbgr.mr_n75690736)
print v(xbgr.mr_n75691168)
print v(xbgr.mr_n75691488)
print v(xbgr.mr_n75691600)
print v(xbgr.mr_n75692032)
print v(xbgr.mr_n75692352)
print v(xbgr.mr_n75692464)
print v(xbgr.mr_n75692784)
print v(xbgr.mr_n75692896)
print v(xbgr.mr_n75693216)
print v(xbgr.mr_n75693328)
print v(xbgr.mr_n75693760)
print v(xbgr.mr_n75694080)
print v(xbgr.mr_n75694192)
print v(xbgr.mr_n75694512)
print v(xbgr.mr_n75694624)
print v(xbgr.mr_n75694944)
print v(xbgr.mr_n75695056)
print v(xbgr.mr_n75695376)
print v(xbgr.mr_n75695488)
print v(xbgr.mr_n75695808)
print v(xbgr.mr_n75695920)
print v(xbgr.mr_n75696352)
print v(xbgr.mr_n75696672)
print v(xbgr.mr_n75696784)
print v(xbgr.mr_n75697104)
print v(xbgr.mr_n75697216)
print v(xbgr.mr_n75697536)
print v(xbgr.mr_n75697648)
print v(xbgr.mr_n75697968)
print v(xbgr.mr_n75698080)
print v(xbgr.mr_n75698400)
print v(xbgr.mr_n75698512)
print v(xbgr.mr_n75698832)
print v(xbgr.mr_n75698944)
print v(xbgr.mr_n75699264)
print v(xbgr.mr_n75699376)
print v(xbgr.mr_n75699696)
print v(xbgr.mr_n75699808)
print v(xbgr.mr_n75700128)
print v(xbgr.mr_n75700240)
print v(xbgr.mr_n75700560)
print v(xbgr.mr_n75700672)
print v(xbgr.mr_n75700992)
print v(xbgr.mr_n75701104)
print v(xbgr.mr_n75701424)
print v(xbgr.mr_n75701536)
print v(xbgr.mr_n75701856)
print v(xbgr.mr_n75701968)
print v(xbgr.mr_n75702288)
print v(xbgr.mr_n75702400)
print v(xbgr.mr_n75702720)
print v(xbgr.mr_n75702832)
print v(xbgr.mr_n75703152)
print v(xbgr.mr_n75703264)
print v(xbgr.mr_n75703584)
print v(xbgr.mr_n75703696)
print v(xbgr.mr_n75704016)
print v(xbgr.mr_n75704128)
print v(xbgr.mr_n75704448)
print v(xbgr.mr_n75704560)
print v(xbgr.mr_n75704880)
print v(xbgr.mr_n75704992)
print v(xbgr.mr_n75705312)
print v(xbgr.mr_n75705424)
print v(xbgr.mr_n75705744)
print v(xbgr.mr_n75705856)
print v(xbgr.mr_n75706176)
print v(xbgr.mr_n75706288)
print v(xbgr.mr_n75706608)
print v(xbgr.mr_n75706720)
print v(xbgr.mr_n75707040)
print v(xbgr.mr_n75707152)
print v(xbgr.mr_n75707472)
print v(xbgr.mr_n75707584)
print v(xbgr.mr_n75707904)
print v(xbgr.mr_n75708016)
print v(xbgr.mr_n75708336)
print v(xbgr.mr_n75708448)
print v(xbgr.mr_n75708768)
print v(xbgr.mr_n75708880)
print v(xbgr.mr_n75709200)
print v(xbgr.mr_n75709312)
print v(xbgr.mr_n75709632)
print v(xbgr.mr_n75709744)
print v(xbgr.mr_n75710064)
print v(xbgr.mr_n75710176)
print v(xbgr.mr_n75710496)
print v(xbgr.mr_n75710608)
print v(xbgr.mr_n75710928)
print v(xbgr.mr_n75711040)
print v(xbgr.mr_n75711360)
print v(xbgr.mr_n75711472)
print v(xbgr.mr_n75711792)
print v(xbgr.mr_n75711904)
print v(xbgr.mr_n75712224)
print v(xbgr.mr_n75712336)
print v(xbgr.mr_n75712656)
print v(xbgr.mr_n75712768)
print v(xbgr.mr_n75713088)
print v(xbgr.mr_n75713200)
print v(xbgr.mr_n75713520)
print v(xbgr.mr_n75713632)
print v(xbgr.mr_n75713952)
print v(xbgr.mr_n75714064)
print v(xbgr.mr_n75714384)
print v(xbgr.mr_n75714496)
print v(xbgr.mr_n75714816)
print v(xbgr.mr_n75714928)
print v(xbgr.mr_n75715248)
print v(xbgr.mr_n75715360)
print v(xbgr.mr_n75715680)
print v(xbgr.mr_n75715792)
print v(xbgr.mr_n75716112)
print v(xbgr.mr_n75716224)
print v(xbgr.mr_n75716544)
print v(xbgr.mr_n75716656)
print v(xbgr.mr_n75716976)
print v(xbgr.mr_n75717088)
print v(xbgr.mr_n75717408)
print v(xbgr.mr_n75717520)
print v(xbgr.mr_n75717840)
print v(xbgr.mr_n75717952)
print v(xbgr.mr_n75718272)
print v(xbgr.mr_n75718384)
print v(xbgr.mr_n75718704)
print v(xbgr.mr_n75718816)
print v(xbgr.mr_n75719136)
print v(xbgr.mr_n75719248)
print v(xbgr.mr_n75719568)
print v(xbgr.mr_n75719680)
print v(xbgr.mr_n75720000)
print v(xbgr.mr_n75720112)
print v(xbgr.mr_n75720432)
print v(xbgr.mr_n75720544)
print v(xbgr.mr_n75720864)
print v(xbgr.mr_n75720976)
print v(xbgr.mr_n75721296)
print v(xbgr.mr_n75721408)
print v(xbgr.mr_n75721728)
print v(xbgr.mr_n75721840)
print v(xbgr.mr_n75722160)
print v(xbgr.mr_n75722272)
print v(xbgr.mr_n75722592)
print v(xbgr.mr_n75722704)
print v(xbgr.mr_n75723024)
print v(xbgr.mr_n75723136)
print v(xbgr.mr_n75723456)
print v(xbgr.mr_n75723568)
print v(xbgr.mr_n75723888)
print v(xbgr.mr_n75724000)
print v(xbgr.mr_n75724320)
print v(xbgr.mr_n75724432)
print v(xbgr.mr_n75724752)
print v(xbgr.mr_n75724864)
print v(xbgr.mr_n75725184)
print v(xbgr.mr_n75725296)
print v(xbgr.mr_n75725616)
print v(xbgr.mr_n75725728)
print v(xbgr.mr_n75726048)
print v(xbgr.mr_n75726160)
print v(xbgr.mr_n75726480)
print v(xbgr.mr_n75726592)
print v(xbgr.mr_n75726912)
print v(xbgr.mr_n75727024)
print v(xbgr.mr_n75727344)
print v(xbgr.mr_n75727456)
print v(xbgr.mr_n75727776)
print v(xbgr.mr_n75727888)
print v(xbgr.mr_n75728208)
print v(xbgr.mr_n75728320)
print v(xbgr.mr_n75728640)
print v(xbgr.mr_n75728752)
print v(xbgr.mr_n75729072)
print v(xbgr.mr_n75729184)
print v(xbgr.mr_n75729504)
print v(xbgr.mr_n75729616)
print v(xbgr.mr_n75729936)
print v(xbgr.mr_n75730048)
print v(xbgr.mr_n75730368)
print v(xbgr.mr_n75730480)
print v(xbgr.mr_n75730800)
print v(xbgr.mr_n75730912)
print v(xbgr.mr_n75731232)
print v(xbgr.mr_n75731344)
print v(xbgr.mr_n75731664)
print v(xbgr.mr_n75731776)
print v(xbgr.mr_n75732096)
print v(xbgr.mr_n75732208)
print v(xbgr.mr_n75732528)
print v(xbgr.mr_n75732640)
print v(xbgr.mr_n75732960)
print v(xbgr.mr_n75733072)
print v(xbgr.mr_n75733392)
print v(xbgr.mr_n75733504)
print v(xbgr.mr_n75733824)
print v(xbgr.mr_n75733936)
print v(xbgr.mr_n75734256)
print v(xbgr.mr_n75734368)
print v(xbgr.mr_n75734688)
print v(xbgr.mr_n75734800)
print v(xbgr.mr_n75735120)
print v(xbgr.mr_n75735232)
print v(xbgr.mr_n75735552)
print v(xbgr.mr_n75735664)
print v(xbgr.mr_n75735984)
print v(xbgr.mr_n75736096)
print v(xbgr.mr_n75736416)
print v(xbgr.mr_n75736528)
print v(xbgr.mr_n75736848)
print v(xbgr.mr_n75736960)
print v(xbgr.mr_n75737280)
print v(xbgr.mr_n75737392)
print v(xbgr.mr_n75737712)
print v(xbgr.mr_n75737824)
print v(xbgr.mr_n75738144)
print v(xbgr.mr_n75738256)
print v(xbgr.mr_n75738576)
print v(xbgr.mr_n75738688)
print v(xbgr.mr_n75739008)
print v(xbgr.mr_n75739120)
print v(xbgr.mr_n75739440)
print v(xbgr.mr_n75739552)
print v(xbgr.mr_n75739872)
print v(xbgr.mr_n75739984)
print v(xbgr.mr_n75740304)
print v(xbgr.mr_n75740416)
print v(xbgr.mr_n75740736)
print v(xbgr.mr_n75740848)
print v(xbgr.mr_n75741168)
print v(xbgr.mr_n75741280)
print v(xbgr.mr_n75741600)
print v(xbgr.mr_n75741712)
print v(xbgr.mr_n75742032)
print v(xbgr.mr_n75742144)
print v(xbgr.mr_n75742464)
print v(xbgr.mr_n75742576)
print v(xbgr.mr_n75742896)
print v(xbgr.mr_n75743008)
print v(xbgr.mr_n75743328)
print v(xbgr.mr_n75743440)
print v(xbgr.mr_n75743760)
print v(xbgr.mr_n75743872)
print v(xbgr.mr_n75744192)
print v(xbgr.mr_n75744304)
print v(xbgr.mr_n75744624)
print v(xbgr.mr_n75744736)
print v(xbgr.mr_n75745056)
print v(xbgr.mr_n75745168)
print v(xbgr.mr_n75745488)
print v(xbgr.mr_n75745600)
print v(xbgr.mr_n75745920)
print v(xbgr.mr_n75746032)
print v(xbgr.mr_n75746352)
print v(xbgr.mr_n75746464)
print v(xbgr.mr_n75746784)
print v(xbgr.mr_n75746896)
print v(xbgr.mr_n75747216)
print v(xbgr.mr_n75747328)
print v(xbgr.mr_n75747648)
print v(xbgr.mr_n75747760)
print v(xbgr.mr_n75748080)
print v(xbgr.mr_n75748192)
print v(xbgr.mr_n75748512)
print v(xbgr.mr_n75748624)
print v(xbgr.mr_n75748944)
print v(xbgr.mr_n75749056)
print v(xbgr.mr_n75749376)
print v(xbgr.mr_n75749488)
print v(xbgr.mr_n75749808)
print v(xbgr.mr_n75749920)
print v(xbgr.mr_n75750240)
print v(xbgr.mr_n75750352)
print v(xbgr.mr_n75750672)
print v(xbgr.mr_n75750784)
print v(xbgr.mr_n75751104)
print v(xbgr.mr_n75751216)
print v(xbgr.mr_n75751536)
print v(xbgr.mr_n75751648)
print v(xbgr.mr_n75751968)
print v(xbgr.mr_n75752080)
print v(xbgr.mr_n75752400)
print v(xbgr.mr_n75752512)
print v(xbgr.mr_n75752832)
print v(xbgr.mr_n75752944)
print v(xbgr.mr_n75753264)
print v(xbgr.mr_n75753376)
print v(xbgr.mr_n75753696)
print v(xbgr.mr_n75753808)
print v(xbgr.mr_n75754128)
print v(xbgr.mr_n75754240)
print v(xbgr.mr_n75754560)
print v(xbgr.mr_n75754672)
print v(xbgr.mr_n75754992)
print v(xbgr.mr_n75755104)
print v(xbgr.mr_n75755424)
print v(xbgr.mr_n75755536)
print v(xbgr.mr_n75755856)
print v(xbgr.mr_n75755968)
print v(xbgr.mr_n75756288)
print v(xbgr.mr_n75756400)
print v(xbgr.mr_n75756720)
print v(xbgr.mr_n75756832)
print v(xbgr.mr_n75757152)
print v(xbgr.mr_n75757264)
print v(xbgr.mr_n75757584)
print v(xbgr.mr_n75757696)
print v(xbgr.mr_n75758016)
print v(xbgr.mr_n75758128)
print v(xbgr.mr_n75758448)
print v(xbgr.mr_n75758560)
print v(xbgr.mr_n75758880)
print v(xbgr.mr_n75758992)
print v(xbgr.mr_n75759312)
print v(xbgr.mr_n75759424)
print v(xbgr.mr_n75759744)
print v(xbgr.mr_n75759856)
print v(xbgr.mr_n75760176)
print v(xbgr.mr_n75760288)
print v(xbgr.mr_n75760608)
print v(xbgr.mr_n75760720)
print v(xbgr.mr_n75761040)
print v(xbgr.mr_n75761152)
print v(xbgr.mr_n75761472)
print v(xbgr.mr_n75761584)
print v(xbgr.mr_n75761904)
print v(xbgr.mr_n75762016)
print v(xbgr.mr_n75762336)
print v(xbgr.mr_n75762448)
print v(xbgr.mr_n75762768)
print v(xbgr.mr_n75762880)
print v(xbgr.mr_n75763200)
print v(xbgr.mr_n75763312)
print v(xbgr.mr_n75763632)
print v(xbgr.mr_n75763744)
print v(xbgr.mr_n75764064)
print v(xbgr.mr_n75764176)
print v(xbgr.mr_n75764496)
print v(xbgr.mr_n75764608)
print v(xbgr.mr_n75764928)
print v(xbgr.mr_n75765040)
print v(xbgr.mr_n75765360)
print v(xbgr.mr_n75765472)
print v(xbgr.mr_n75765792)
print v(xbgr.mr_n75765904)
print v(xbgr.mr_n75766224)
print v(xbgr.mr_n75766336)
print v(xbgr.mr_n75766656)
print v(xbgr.mr_n75766768)
print v(xbgr.mr_n75767088)
print v(xbgr.mr_n75767200)
print v(xbgr.mr_n75767520)
print v(xbgr.mr_n75767632)
print v(xbgr.mr_n75767952)
print v(xbgr.mr_n75768064)
print v(xbgr.mr_n75768384)
print v(xbgr.mr_n75768496)
print v(xbgr.mr_n75768816)
print v(xbgr.mr_n75768928)
print v(xbgr.mr_n75769248)
print v(xbgr.mr_n75769360)
print v(xbgr.mr_n75769680)
print v(xbgr.mr_n75769792)
print v(xbgr.mr_n75770112)
print v(xbgr.mr_n75770224)
print v(xbgr.mr_n75770544)
print v(xbgr.mr_n75770656)
print v(xbgr.mr_n75770976)
print v(xbgr.mr_n75771088)
print v(xbgr.mr_n75771520)
print v(xbgr.mr_n75771840)
print v(xbgr.mr_n75771952)
print v(xbgr.mr_n75772384)
print v(xbgr.mr_n75772704)
print v(xbgr.mr_n75772816)
print v(xbgr.mr_n75773248)
print v(xbgr.mr_n75773568)
print v(xbgr.mr_n75774432)
print v(xbgr.mr_n75774544)
print v(xbgr.mr_n75774976)
print v(xbgr.mr_n75775296)
print v(xbgr.mr_n75775408)
print v(xbgr.mr_n75775728)
print v(xbgr.mr_n75775840)
print v(xbgr.mr_n75776160)
print v(xbgr.mr_n75776272)
print v(xbgr.mr_n75776592)
print v(xbgr.mr_n75776704)
print v(xbgr.mr_n75777024)
print v(xbgr.mr_n75777136)
print v(xbgr.mr_n75777456)
print v(xbgr.mr_n75777568)
print v(xbgr.mr_n75777888)
print v(xbgr.mr_n75778000)
print v(xbgr.mr_n75778320)
print v(xbgr.mr_n75778432)
print v(xbgr.mr_n75778752)
print v(xbgr.mr_n75779616)
print v(xbgr.mr_n75780480)
print v(xbgr.mr_n75780592)
print v(xbgr.mr_n75780912)
print v(xbgr.mr_n75781024)
print v(xbgr.mr_n75781344)
print v(xbgr.mr_n75782208)
print v(xbgr.mr_n75782320)
print v(xbgr.mr_n75782640)
print v(xbgr.mr_n75782752)
print v(xbgr.mr_n75783072)
print v(xbgr.mr_n75783184)
print v(xbgr.mr_n75783504)
print v(xbgr.mr_n75783616)
print v(xbgr.mr_n75783936)
print v(xbgr.mr_n75784048)
print v(xbgr.mr_n75784368)
print v(xbgr.mr_n75784480)
print v(xbgr.mr_n75784800)
print v(xbgr.mr_n75784912)
print v(xbgr.mr_n75785232)
print v(xbgr.mr_n75785344)
print v(xbgr.mr_n75785664)
print v(xbgr.mr_n75785776)
print v(xbgr.mr_n75786096)
print v(xbgr.mr_n75786208)
print v(xbgr.mr_n75786528)
print v(xbgr.mr_n75786640)
print v(xbgr.mr_n75786960)
print v(xbgr.mr_n75787072)
print v(xbgr.mr_n75787392)
print v(xbgr.mr_n75787504)
print v(xbgr.mr_n75787824)
print v(xbgr.mr_n75787936)
print v(xbgr.mr_n75788256)
print v(xbgr.mr_n75788368)
print v(xbgr.mr_n75788688)
print v(xbgr.mr_n75788800)
print v(xbgr.mr_n75789120)
print v(xbgr.mr_n75789232)
print v(xbgr.mr_n75789552)
print v(xbgr.mr_n75789664)
print v(xbgr.mr_n75789984)
print v(xbgr.mr_n75790096)
print v(xbgr.mr_n75790416)
print v(xbgr.mr_n75790528)
print v(xbgr.mr_n75790848)
print v(xbgr.mr_n75790960)
print v(xbgr.mr_n75791280)
print v(xbgr.mr_n75791392)
print v(xbgr.mr_n75791712)
print v(xbgr.mr_n75791824)
print v(xbgr.mr_n75792144)
print v(xbgr.mr_n75792256)
print v(xbgr.mr_n75792576)
print v(xbgr.mr_n75792688)
print v(xbgr.mr_n75793120)
print v(xbgr.mr_n75793440)
print v(xbgr.mr_n75793552)
print v(xbgr.mr_n75793872)
print v(xbgr.mr_n75793984)
print v(xbgr.mr_n75794304)
print v(xbgr.mr_n75794416)
print v(xbgr.mr_n75794736)
print v(xbgr.mr_n75794848)
print v(xbgr.mr_n75795168)
print v(xbgr.mr_n75795280)
print v(xbgr.mr_n75795600)
print v(xbgr.mr_n75795712)
print v(xbgr.mr_n75796032)
print v(xbgr.mr_n75796144)
print v(xbgr.mr_n75796464)
print v(xbgr.mr_n75796576)
print v(xbgr.mr_n75796896)
print v(xbgr.mr_n75797008)
print v(xbgr.mr_n75797328)
print v(xbgr.mr_n75797440)
print v(xbgr.mr_n75797760)
print v(xbgr.mr_n75797872)
print v(xbgr.mr_n75798192)
print v(xbgr.mr_n75798304)
print v(xbgr.mr_n75798624)
print v(xbgr.mr_n75798736)
print v(xbgr.mr_n75799056)
print v(xbgr.mr_n75799168)
print v(xbgr.mr_n75799488)
print v(xbgr.mr_n75800352)
print v(xbgr.mr_n75800464)
print v(xbgr.mr_n75800784)
print v(xbgr.mr_n75800896)
print v(xbgr.mr_n75801216)
print v(xbgr.mr_n75801328)
print v(xbgr.mr_n75801648)
print v(xbgr.mr_n75801760)
print v(xbgr.mr_n75802080)
print v(xbgr.mr_n75802192)
print v(xbgr.mr_n75802512)
print v(xbgr.mr_n75802624)
print v(xbgr.mr_n75802944)
print v(xbgr.mr_n75803056)
print v(xbgr.mr_n75803376)
print v(xbgr.mr_n75803488)
print v(xbgr.mr_n75803808)
print v(xbgr.mr_n75803920)
print v(xbgr.mr_n75804240)
print v(xbgr.mr_n75804352)
print v(xbgr.mr_n75804672)
print v(xbgr.mr_n75804784)
print v(xbgr.mr_n75805104)
print v(xbgr.mr_n75805216)
print v(xbgr.mr_n75805536)
print v(xbgr.mr_n75805648)
print v(xbgr.mr_n75805968)
print v(xbgr.mr_n75806080)
print v(xbgr.mr_n75806400)
print v(xbgr.mr_n75806512)
print v(xbgr.mr_n75806832)
print v(xbgr.mr_n75806944)
print v(xbgr.mr_n75807264)
print v(xbgr.mr_n75807376)
print v(xbgr.mr_n75807696)
print v(xbgr.mr_n75807808)
print v(xbgr.mr_n75808128)
print v(xbgr.mr_n75808240)
print v(xbgr.mr_n75808560)
print v(xbgr.mr_n75808672)
print v(xbgr.mr_n75808992)
print v(xbgr.mr_n75809104)
print v(xbgr.mr_n75809424)
print v(xbgr.mr_n75809536)
print v(xbgr.mr_n75809856)
print v(xbgr.mr_n75809968)
print v(xbgr.mr_n75810288)
print v(xbgr.mr_n75810400)
print v(xbgr.mr_n75810720)
print v(xbgr.mr_n75810832)
print v(xbgr.mr_n75811152)
print v(xbgr.mr_n75811264)
print v(xbgr.mr_n75811584)
print v(xbgr.mr_n75811696)
print v(xbgr.mr_n75812016)
print v(xbgr.mr_n75812128)
print v(xbgr.mr_n75812448)
print v(xbgr.mr_n75812560)
print v(xbgr.mr_n75812880)
print v(xbgr.mr_n75812992)
print v(xbgr.mr_n75813312)
print v(xbgr.mr_n75813424)
print v(xbgr.mr_n75813744)
print v(xbgr.mr_n75813856)
print v(xbgr.mr_n75814176)
print v(xbgr.mr_n75814288)
print v(xbgr.mr_n75814608)
print v(xbgr.mr_n75814720)
print v(xbgr.mr_n75815040)
print v(xbgr.mr_n75815152)
print v(xbgr.mr_n75815472)
print v(xbgr.mr_n75815584)
print v(xbgr.mr_n75815904)
print v(xbgr.mr_n75816016)
print v(xbgr.mr_n75816336)
print v(xbgr.mr_n75816448)
print v(xbgr.mr_n75816768)
print v(xbgr.mr_n75816880)
print v(xbgr.mr_n75817200)
print v(xbgr.mr_n75817312)
print v(xbgr.mr_n75817632)
print v(xbgr.mr_n75817744)
print v(xbgr.mr_n75818064)
print v(xbgr.mr_n75818176)
print v(xbgr.mr_n75818496)
print v(xbgr.mr_n75818608)
print v(xbgr.mr_n75818928)
print v(xbgr.mr_n75819040)
print v(xbgr.mr_n75819360)
print v(xbgr.mr_n75819472)
print v(xbgr.mr_n75819792)
print v(xbgr.mr_n75819904)
print v(xbgr.mr_n75820224)
print v(xbgr.mr_n75820336)
print v(xbgr.mr_n75820656)
print v(xbgr.mr_n75820768)
print v(xbgr.mr_n75821088)
print v(xbgr.mr_n75821200)
print v(xbgr.mr_n75821520)
print v(xbgr.mr_n75821632)
print v(xbgr.mr_n75821952)
print v(xbgr.mr_n75822064)
print v(xbgr.mr_n75822384)
print v(xbgr.mr_n75822496)
print v(xbgr.mr_n75822816)
print v(xbgr.mr_n75822928)
print v(xbgr.mr_n75823248)
print v(xbgr.mr_n75823360)
print v(xbgr.mr_n75823680)
print v(xbgr.mr_n75823792)
print v(xbgr.mr_n75824112)
print v(xbgr.mr_n75824224)
print v(xbgr.mr_n75824544)
print v(xbgr.mr_n75824656)
print v(xbgr.mr_n75824976)
print v(xbgr.mr_n75825088)
print v(xbgr.mr_n75825408)
print v(xbgr.mr_n75825520)
print v(xbgr.mr_n75825840)
print v(xbgr.mr_n75825952)
print v(xbgr.mr_n75826272)
print v(xbgr.mr_n75826384)
print v(xbgr.mr_n75826704)
print v(xbgr.mr_n75826816)
print v(xbgr.mr_n75827136)
print v(xbgr.mr_n75827248)
print v(xbgr.mr_n75827568)
print v(xbgr.mr_n75827680)
print v(xbgr.mr_n75828000)
print v(xbgr.mr_n75828112)
print v(xbgr.mr_n75828432)
print v(xbgr.mr_n75828544)
print v(xbgr.mr_n75828864)
print v(xbgr.mr_n75828976)
print v(xbgr.mr_n75829296)
print v(xbgr.mr_n75829408)
print v(xbgr.mr_n75829728)
print v(xbgr.mr_n75829840)
print v(xbgr.mr_n75830160)
print v(xbgr.mr_n75830272)
print v(xbgr.mr_n75830592)
print v(xbgr.mr_n75830704)
print v(xbgr.mr_n75831024)
print v(xbgr.mr_n75831136)
print v(xbgr.mr_n75831456)
print v(xbgr.mr_n75831568)
print v(xbgr.mr_n75831888)
print v(xbgr.mr_n75832000)
print v(xbgr.mr_n75832320)
print v(xbgr.mr_n75832432)
print v(xbgr.mr_n75832752)
print v(xbgr.mr_n75832864)
print v(xbgr.mr_n75833184)
print v(xbgr.mr_n75833296)
print v(xbgr.mr_n75833616)
print v(xbgr.mr_n75833728)
print v(xbgr.mr_n75834048)
print v(xbgr.mr_n75834160)
print v(xbgr.mr_n75834480)
print v(xbgr.mr_n75834592)
print v(xbgr.mr_n75834912)
print v(xbgr.mr_n75835024)
print v(xbgr.mr_n75835344)
print v(xbgr.mr_n75835456)
print v(xbgr.mr_n75835776)
print v(xbgr.mr_n75835888)
print v(xbgr.mr_n75836208)
print v(xbgr.mr_n75836320)
print v(xbgr.mr_n75836640)
print v(xbgr.mr_n75836752)
print v(xbgr.mr_n75837072)
print v(xbgr.mr_n75837184)
print v(xbgr.mr_n75837504)
print v(xbgr.mr_n75837616)
print v(xbgr.mr_n75837936)
print v(xbgr.mr_n75838048)
print v(xbgr.mr_n75838368)
print v(xbgr.mr_n75838480)
print v(xbgr.mr_n75838800)
print v(xbgr.mr_n75838912)
print v(xbgr.mr_n75839232)
print v(xbgr.mr_n75839344)
print v(xbgr.mr_n75839664)
print v(xbgr.mr_n75839776)
print v(xbgr.mr_n75840096)
print v(xbgr.mr_n75840208)
print v(xbgr.mr_n75840528)
print v(xbgr.mr_n75840640)
print v(xbgr.mr_n75840960)
print v(xbgr.mr_n75841072)
print v(xbgr.mr_n75841392)
print v(xbgr.mr_n75841504)
print v(xbgr.mr_n75841824)
print v(xbgr.mr_n75841936)
print v(xbgr.mr_n75842256)
print v(xbgr.mr_n75842368)
print v(xbgr.mr_n75842688)
print v(xbgr.mr_n75842800)
print v(xbgr.mr_n75843120)
print v(xbgr.mr_n75843232)
print v(xbgr.mr_n75843552)
print v(xbgr.mr_n75843664)
print v(xbgr.mr_n75843984)
print v(xbgr.mr_n75844096)
print v(xbgr.mr_n75844416)
print v(xbgr.mr_n75844528)
print v(xbgr.mr_n75844848)
print v(xbgr.mr_n75844960)
print v(xbgr.mr_n75845280)
print v(xbgr.mr_n75845392)
print v(xbgr.mr_n75845712)
print v(xbgr.mr_n75845824)
print v(xbgr.mr_n75846144)
print v(xbgr.mr_n75846256)
print v(xbgr.mr_n75846576)
print v(xbgr.mr_n75846688)
print v(xbgr.mr_n75847008)
print v(xbgr.mr_n75847120)
print v(xbgr.mr_n75847440)
print v(xbgr.mr_n75847552)
print v(xbgr.mr_n75847872)
print v(xbgr.mr_n75847984)
print v(xbgr.mr_n75848304)
print v(xbgr.mr_n75848416)
print v(xbgr.mr_n75848736)
print v(xbgr.mr_n75848848)
print v(xbgr.mr_n75849168)
print v(xbgr.mr_n75849280)
print v(xbgr.mr_n75849600)
print v(xbgr.mr_n75849712)
print v(xbgr.mr_n75850032)
print v(xbgr.mr_n75850144)
print v(xbgr.mr_n75850464)
print v(xbgr.mr_n75850576)
print v(xbgr.mr_n75850896)
print v(xbgr.mr_n75851008)
print v(xbgr.mr_n75851328)
print v(xbgr.mr_n75851440)
print v(xbgr.mr_n75851760)
print v(xbgr.mr_n75851872)
print v(xbgr.mr_n75852192)
print v(xbgr.mr_n75852304)
print v(xbgr.mr_n75852624)
print v(xbgr.mr_n75852736)
print v(xbgr.mr_n75853056)
print v(xbgr.mr_n75853168)
print v(xbgr.mr_n75853488)
print v(xbgr.mr_n75853600)
print v(xbgr.mr_n75853920)
print v(xbgr.mr_n75854032)
print v(xbgr.mr_n75854352)
print v(xbgr.mr_n75854464)
print v(xbgr.mr_n75854784)
print v(xbgr.mr_n75854896)
print v(xbgr.mr_n75855216)
print v(xbgr.mr_n75855328)
print v(xbgr.mr_n75855648)
print v(xbgr.mr_n75855760)
print v(xbgr.mr_n75856080)
print v(xbgr.mr_n75856192)
print v(xbgr.mr_n75856512)
print v(xbgr.mr_n75856624)
print v(xbgr.mr_n75856944)
print v(xbgr.mr_n75857056)
print v(xbgr.mr_n75857376)
print v(xbgr.mr_n75857488)
print v(xbgr.mr_n75857808)
print v(xbgr.mr_n75857920)
print v(xbgr.mr_n75858240)
print v(xbgr.mr_n75858352)
print v(xbgr.mr_n75858672)
print v(xbgr.mr_n75858784)
print v(xbgr.mr_n75859104)
print v(xbgr.mr_n75859216)
print v(xbgr.mr_n75859536)
print v(xbgr.mr_n75859648)
print v(xbgr.mr_n75859968)
print v(xbgr.mr_n75860080)
print v(xbgr.mr_n75860400)
print v(xbgr.mr_n75860512)
print v(xbgr.mr_n75860832)
print v(xbgr.mr_n75860944)
print v(xbgr.mr_n75861264)
print v(xbgr.mr_n75861376)
print v(xbgr.mr_n75861696)
print v(xbgr.mr_n75861808)
print v(xbgr.mr_n75862128)
print v(xbgr.mr_n75862240)
print v(xbgr.mr_n75862560)
print v(xbgr.mr_n75862672)
print v(xbgr.mr_n75862992)
print v(xbgr.mr_n75863104)
print v(xbgr.mr_n75863424)
print v(xbgr.mr_n75863536)
print v(xbgr.mr_n75863856)
print v(xbgr.mr_n75863968)
print v(xbgr.mr_n75864288)
print v(xbgr.mr_n75864400)
print v(xbgr.mr_n75864720)
print v(xbgr.mr_n75864832)
print v(xbgr.mr_n75865152)
print v(xbgr.mr_n75865264)
print v(xbgr.mr_n75865584)
print v(xbgr.mr_n75865696)
print v(xbgr.mr_n75866016)
print v(xbgr.mr_n75866128)
print v(xbgr.mr_n75866448)
print v(xbgr.mr_n75866560)
print v(xbgr.mr_n75866880)
print v(xbgr.mr_n75866992)
print v(xbgr.mr_n75867312)
print v(xbgr.mr_n75867424)
print v(xbgr.mr_n75867744)
print v(xbgr.mr_n75867856)
print v(xbgr.mr_n75868176)
print v(xbgr.mr_n75868288)
print v(xbgr.mr_n75868608)
print v(xbgr.mr_n75868720)
print v(xbgr.mr_n75869040)
print v(xbgr.mr_n75869152)
print v(xbgr.mr_n75869472)
print v(xbgr.mr_n75869584)
print v(xbgr.mr_n75869904)
print v(xbgr.mr_n75870016)
print v(xbgr.mr_n75870336)
print v(xbgr.mr_n75870448)
print v(xbgr.mr_n75870768)
print v(xbgr.mr_n75870880)
print v(xbgr.mr_n75871200)
print v(xbgr.mr_n75871312)
print v(xbgr.mr_n75871632)
print v(xbgr.mr_n75871744)
print v(xbgr.mr_n75872064)
print v(xbgr.mr_n75872176)
print v(xbgr.mr_n75872496)
print v(xbgr.mr_n75872608)
print v(xbgr.mr_n75872928)
print v(xbgr.mr_n75873040)
print v(xbgr.mr_n75873360)
print v(xbgr.mr_n75873472)
print v(xbgr.mr_n75873792)
print v(xbgr.mr_n75873904)
print v(xbgr.mr_n75874224)
print v(xbgr.mr_n75874336)
print v(xbgr.mr_n75874656)
print v(xbgr.mr_n75874768)
print v(xbgr.mr_n75875088)
print v(xbgr.mr_n75875200)
print v(xbgr.mr_n75875520)
print v(xbgr.mr_n75875632)
print v(xbgr.mr_n75875952)
print v(xbgr.mr_n75876064)
print v(xbgr.mr_n75876384)
print v(xbgr.mr_n75876496)
print v(xbgr.mr_n75876816)
print v(xbgr.mr_n75876928)
print v(xbgr.mr_n75877248)
print v(xbgr.mr_n75877360)
print v(xbgr.mr_n75877680)
print v(xbgr.mr_n75877792)
print v(xbgr.mr_n75878112)
print v(xbgr.mr_n75878224)
print v(xbgr.mr_n75878544)
print v(xbgr.mr_n75878656)
print v(xbgr.mr_n75878976)
print v(xbgr.mr_n75879088)
print v(xbgr.mr_n75879408)
print v(xbgr.mr_n75879520)
print v(xbgr.mr_n75879840)
print v(xbgr.mr_n75879952)
print v(xbgr.mr_n75880272)
print v(xbgr.mr_n75880384)
print v(xbgr.mr_n75880704)
print v(xbgr.mr_n75880816)
print v(xbgr.mr_n75881136)
print v(xbgr.mr_n75881248)
print v(xbgr.mr_n75881568)
print v(xbgr.mr_n75881680)
print v(xbgr.mr_n75882000)
print v(xbgr.mr_n75882112)
print v(xbgr.mr_n75882432)
print v(xbgr.mr_n75882544)
print v(xbgr.mr_n75882864)
print v(xbgr.mr_n75882976)
print v(xbgr.mr_n75883296)
print v(xbgr.mr_n75883408)
print v(xbgr.mr_n75883728)
print v(xbgr.mr_n75883840)
print v(xbgr.mr_n75884160)
print v(xbgr.mr_n75884272)
print v(xbgr.mr_n75884592)
print v(xbgr.mr_n75884704)
print v(xbgr.mr_n75885024)
print v(xbgr.mr_n75885136)
print v(xbgr.mr_n75885456)
print v(xbgr.mr_n75885568)
print v(xbgr.mr_n75885888)
print v(xbgr.mr_n75886000)
print v(xbgr.mr_n75886320)
print v(xbgr.mr_n75886432)
print v(xbgr.mr_n75886752)
print v(xbgr.mr_n75886864)
print v(xbgr.mr_n75887184)
print v(xbgr.mr_n75887296)
print v(xbgr.mr_n75887616)
print v(xbgr.mr_n75887728)
print v(xbgr.mr_n75888048)
print v(xbgr.mr_n75888160)
print v(xbgr.mr_n75888480)
print v(xbgr.mr_n75888592)
print v(xbgr.mr_n75888912)
print v(xbgr.mr_n75889024)
print v(xbgr.mr_n75889344)
print v(xbgr.mr_n75889456)
print v(xbgr.mr_n75889776)
print v(xbgr.mr_n75889888)
print v(xbgr.mr_n75890208)
print v(xbgr.mr_n75890320)
print v(xbgr.mr_n75890640)
print v(xbgr.mr_n75890752)
print v(xbgr.mr_n75891072)
print v(xbgr.mr_n75891184)
print v(xbgr.mr_n75891504)
print v(xbgr.mr_n75891616)
print v(xbgr.mr_n75891936)
print v(xbgr.mr_n75892048)
print v(xbgr.mr_n75892368)
print v(xbgr.mr_n75892480)
print v(xbgr.mr_n75892800)
print v(xbgr.mr_n75892912)
print v(xbgr.mr_n75893232)
print v(xbgr.mr_n75893344)
print v(xbgr.mr_n75893664)
print v(xbgr.mr_n75893776)
print v(xbgr.mr_n75894096)
print v(xbgr.mr_n75894208)
print v(xbgr.mr_n75894528)
print v(xbgr.mr_n75894640)
print v(xbgr.mr_n75894960)
print v(xbgr.mr_n75895072)
print v(xbgr.mr_n75895392)
print v(xbgr.mr_n75895504)
print v(xbgr.mr_n75895824)
print v(xbgr.mr_n75895936)
print v(xbgr.mr_n75896256)
print v(xbgr.mr_n75896368)
print v(xbgr.mr_n75896688)
print v(xbgr.mr_n75896800)
print v(xbgr.mr_n75897120)
print v(xbgr.mr_n75897232)
print v(xbgr.mr_n75897552)
print v(xbgr.mr_n75897664)
print v(xbgr.mr_n75897984)
print v(xbgr.mr_n75898096)
print v(xbgr.mr_n75898416)
print v(xbgr.mr_n75898528)
print v(xbgr.mr_n75898848)
print v(xbgr.mr_n75898960)
print v(xbgr.mr_n75899280)
print v(xbgr.mr_n75899392)
print v(xbgr.mr_n75899712)
print v(xbgr.mr_n75899824)
print v(xbgr.mr_n75900144)
print v(xbgr.mr_n75900256)
print v(xbgr.mr_n75900576)
print v(xbgr.mr_n75900688)
print v(xbgr.mr_n75901008)
print v(xbgr.mr_n75901120)
print v(xbgr.mr_n75901440)
print v(xbgr.mr_n75901552)
print v(xbgr.mr_n75901872)
print v(xbgr.mr_n75901984)
print v(xbgr.mr_n75902304)
print v(xbgr.mr_n75902416)
print v(xbgr.mr_n75902736)
print v(xbgr.mr_n75902848)
print v(xbgr.mr_n75903168)
print v(xbgr.mr_n75903280)
print v(xbgr.mr_n75903600)
print v(xbgr.mr_n75903712)
print v(xbgr.mr_n75904032)
print v(xbgr.mr_n75904144)
print v(xbgr.mr_n75904464)
print v(xbgr.mr_n75904576)
print v(xbgr.mr_n75904896)
print v(xbgr.mr_n75905008)
print v(xbgr.mr_n75905328)
print v(xbgr.mr_n75905440)
print v(xbgr.mr_n75905760)
print v(xbgr.mr_n75905872)
print v(xbgr.mr_n75906192)
print v(xbgr.mr_n75906304)
print v(xbgr.mr_n75906624)
print v(xbgr.mr_n75906736)
print v(xbgr.mr_n75907056)
print v(xbgr.mr_n75907168)
print v(xbgr.mr_n75907488)
print v(xbgr.mr_n75907600)
print v(xbgr.mr_n75907920)
print v(xbgr.mr_n75908032)
print v(xbgr.mr_n75908352)
print v(xbgr.mr_n75908464)
print v(xbgr.mr_n75908784)
print v(xbgr.mr_n75908896)
print v(xbgr.mr_n75909216)
print v(xbgr.mr_n75909328)
print v(xbgr.mr_n75909648)
print v(xbgr.mr_n75909760)
print v(xbgr.mr_n75910080)
print v(xbgr.mr_n75910192)
print v(xbgr.mr_n75910512)
print v(xbgr.mr_n75910624)
print v(xbgr.mr_n75910944)
print v(xbgr.mr_n75911056)
print v(xbgr.mr_n75911376)
print v(xbgr.mr_n75911488)
print v(xbgr.mr_n75911808)
print v(xbgr.mr_n75911920)
print v(xbgr.mr_n75912240)
print v(xbgr.mr_n75912352)
print v(xbgr.mr_n75912672)
print v(xbgr.mr_n75912784)
print v(xbgr.mr_n75913104)
print v(xbgr.mr_n75913216)
print v(xbgr.mr_n75913536)
print v(xbgr.mr_n75913648)
print v(xbgr.mr_n75913968)
print v(xbgr.mr_n75914080)
print v(xbgr.mr_n75914400)
print v(xbgr.mr_n75914512)
print v(xbgr.mr_n75914832)
print v(xbgr.mr_n75914944)
print v(xbgr.mr_n75915264)
print v(xbgr.mr_n75915376)
print v(xbgr.mr_n75915696)
print v(xbgr.mr_n75915808)
print v(xbgr.mr_n75916128)
print v(xbgr.mr_n75916240)
print v(xbgr.mr_n75916560)
print v(xbgr.mr_n75916672)
print v(xbgr.mr_n75916992)
print v(xbgr.mr_n75917104)
print v(xbgr.mr_n75917424)
print v(xbgr.mr_n75917536)
print v(xbgr.mr_n75917856)
print v(xbgr.mr_n75917968)
print v(xbgr.mr_n75918288)
print v(xbgr.mr_n75918400)
print v(xbgr.mr_n75918720)
print v(xbgr.mr_n75918832)
print v(xbgr.mr_n75919152)
print v(xbgr.mr_n75919264)
print v(xbgr.mr_n75919584)
print v(xbgr.mr_n75919696)
print v(xbgr.mr_n75920016)
print v(xbgr.mr_n75920128)
print v(xbgr.mr_n75920448)
print v(xbgr.mr_n75920560)
print v(xbgr.mr_n75920880)
print v(xbgr.mr_n75920992)
print v(xbgr.mr_n75921312)
print v(xbgr.mr_n75921424)
print v(xbgr.mr_n75921744)
print v(xbgr.mr_n75921856)
print v(xbgr.mr_n75922176)
print v(xbgr.mr_n75922288)
print v(xbgr.mr_n75922608)
print v(xbgr.mr_n75922720)
print v(xbgr.mr_n75923040)
print v(xbgr.mr_n75923152)
print v(xbgr.mr_n75923472)
print v(xbgr.mr_n75923584)
print v(xbgr.mr_n75923904)
print v(xbgr.mr_n75924016)
print v(xbgr.mr_n75924336)
print v(xbgr.mr_n75924448)
print v(xbgr.mr_n75924768)
print v(xbgr.mr_n75924880)
print v(xbgr.mr_n75925200)
print v(xbgr.mr_n75925312)
print v(xbgr.mr_n75925632)
print v(xbgr.mr_n75925744)
print v(xbgr.mr_n75926064)
print v(xbgr.mr_n75926176)
print v(xbgr.mr_n75926496)
print v(xbgr.mr_n75926608)
print v(xbgr.mr_n75926928)
print v(xbgr.mr_n75927040)
print v(xbgr.mr_n75927360)
print v(xbgr.mr_n75927472)
print v(xbgr.mr_n75927792)
print v(xbgr.mr_n75927904)
print v(xbgr.mr_n75928224)
print v(xbgr.mr_n75928336)
print v(xbgr.mr_n75928656)
print v(xbgr.mr_n75928768)
print v(xbgr.mr_n75929088)
print v(xbgr.mr_n75929200)
print v(xbgr.mr_n75929520)
print v(xbgr.mr_n75929632)
print v(xbgr.mr_n75929952)
print v(xbgr.mr_n75930064)
print v(xbgr.mr_n75930384)
print v(xbgr.mr_n75930496)
print v(xbgr.mr_n75930816)
print v(xbgr.mr_n75930928)
print v(xbgr.mr_n75931248)
print v(xbgr.mr_n75931360)
print v(xbgr.mr_n75931680)
print v(xbgr.mr_n75931792)
print v(xbgr.mr_n75932112)
print v(xbgr.mr_n75932224)
print v(xbgr.mr_n75932544)
print v(xbgr.mr_n75932656)
print v(xbgr.mr_n75932976)
print v(xbgr.mr_n75933088)
print v(xbgr.mr_n75933408)
print v(xbgr.mr_n75933520)
print v(xbgr.mr_n75933840)
print v(xbgr.mr_n75933952)
print v(xbgr.mr_n75934272)
print v(xbgr.mr_n75934384)
print v(xbgr.mr_n75934704)
print v(xbgr.mr_n75934816)
print v(xbgr.mr_n75935136)
print v(xbgr.mr_n75935248)
print v(xbgr.mr_n75935568)
print v(xbgr.mr_n75935680)
print v(xbgr.mr_n75936000)
print v(xbgr.mr_n75936112)
print v(xbgr.mr_n75936432)
print v(xbgr.mr_n75936544)
print v(xbgr.mr_n75936864)
print v(xbgr.mr_n75936976)
print v(xbgr.mr_n75937296)
print v(xbgr.mr_n75937408)
print v(xbgr.mr_n75937728)
print v(xbgr.mr_n75937840)
print v(xbgr.mr_n75938160)
print v(xbgr.mr_n75938272)
print v(xbgr.mr_n75938592)
print v(xbgr.mr_n75938704)
print v(xbgr.mr_n75939024)
print v(xbgr.mr_n75939136)
print v(xbgr.mr_n75939456)
print v(xbgr.mr_n75939568)
print v(xbgr.mr_n75939888)
print v(xbgr.mr_n75940000)
print v(xbgr.mr_n75940320)
print v(xbgr.mr_n75940432)
print v(xbgr.mr_n75940752)
print v(xbgr.mr_n75940864)
print v(xbgr.mr_n75941184)
print v(xbgr.mr_n75941296)
print v(xbgr.mr_n75941616)
print v(xbgr.mr_n75941728)
print v(xbgr.mr_n75942048)
print v(xbgr.mr_n75942160)
print v(xbgr.mr_n75942480)
print v(xbgr.mr_n75942592)
print v(xbgr.mr_n75942912)
print v(xbgr.mr_n75943024)
print v(xbgr.mr_n75943344)
print v(xbgr.mr_n75943456)
print v(xbgr.mr_n75943776)
print v(xbgr.mr_n75943888)
print v(xbgr.mr_n75944208)
print v(xbgr.mr_n75944320)
print v(xbgr.mr_n75944640)
print v(xbgr.mr_n75944752)
print v(xbgr.mr_n75945072)
print v(xbgr.mr_n75945184)
print v(xbgr.mr_n75945504)
print v(xbgr.mr_n75945616)
print v(xbgr.mr_n75945936)
print v(xbgr.mr_n75946048)
print v(xbgr.mr_n75946368)
print v(xbgr.mr_n75946480)
print v(xbgr.mr_n75946800)
print v(xbgr.mr_n75946912)
print v(xbgr.mr_n75947232)
print v(xbgr.mr_n75947344)
print v(xbgr.mr_n75947664)
print v(xbgr.mr_n75947776)
print v(xbgr.mr_n75948096)
print v(xbgr.mr_n75948208)
print v(xbgr.mr_n75948528)
print v(xbgr.mr_n75948640)
print v(xbgr.mr_n75948960)
print v(xbgr.mr_n75949072)
print v(xbgr.mr_n75949392)
print v(xbgr.mr_n75949504)
print v(xbgr.mr_n75949824)
print v(xbgr.mr_n75949936)
print v(xbgr.mr_n75950256)
print v(xbgr.mr_n75950368)
print v(xbgr.mr_n75950688)
print v(xbgr.mr_n75950800)
print v(xbgr.mr_n75951120)
print v(xbgr.mr_n75951232)
print v(xbgr.mr_n75951552)
print v(xbgr.mr_n75951664)
print v(xbgr.mr_n75951984)
print v(xbgr.mr_n75952096)
print v(xbgr.mr_n75952416)
print v(xbgr.mr_n75952528)
print v(xbgr.mr_n75952848)
print v(xbgr.mr_n75952960)
print v(xbgr.mr_n75953280)
print v(xbgr.mr_n75953392)
print v(xbgr.mr_n75953712)
print v(xbgr.mr_n75953824)
print v(xbgr.mr_n75954144)
print v(xbgr.mr_n75954256)
print v(xbgr.mr_n75954576)
print v(xbgr.mr_n75954688)
print v(xbgr.mr_n75955008)
print v(xbgr.mr_n75955120)
print v(xbgr.mr_n75955440)
print v(xbgr.mr_n75955552)
print v(xbgr.mr_n75955872)
print v(xbgr.mr_n75955984)
print v(xbgr.mr_n75956304)
print v(xbgr.mr_n75956416)
print v(xbgr.mr_n75956736)
print v(xbgr.mr_n75956848)
print v(xbgr.mr_n75957168)
print v(xbgr.mr_n75957280)
print v(xbgr.mr_n75957600)
print v(xbgr.mr_n75957712)
print v(xbgr.mr_n75958032)
print v(xbgr.mr_n75958144)
print v(xbgr.mr_n75958464)
print v(xbgr.mr_n75958576)
print v(xbgr.mr_n75958896)
print v(xbgr.mr_n75959008)
print v(xbgr.mr_n75959328)
print v(xbgr.mr_n75959440)
print v(xbgr.mr_n75959760)
print v(xbgr.mr_n75959872)
print v(xbgr.mr_n75960192)
print v(xbgr.mr_n75960304)
print v(xbgr.mr_n75960624)
print v(xbgr.mr_n75960736)
print v(xbgr.mr_n75961056)
print v(xbgr.mr_n75961168)
print v(xbgr.mr_n75961488)
print v(xbgr.mr_n75961600)
print v(xbgr.mr_n75961920)
print v(xbgr.mr_n75962032)
print v(xbgr.mr_n75962352)
print v(xbgr.mr_n75962464)
print v(xbgr.mr_n75962784)
print v(xbgr.mr_n75962896)
print v(xbgr.mr_n75963216)
print v(xbgr.mr_n75963328)
print v(xbgr.mr_n75963648)
print v(xbgr.mr_n75963760)
print v(xbgr.mr_n75964080)
print v(xbgr.mr_n75964192)
print v(xbgr.mr_n75964512)
print v(xbgr.mr_n75964624)
print v(xbgr.mr_n75964944)
print v(xbgr.mr_n75965056)
print v(xbgr.mr_n75965376)
print v(xbgr.mr_n75965488)
print v(xbgr.mr_n75965808)
print v(xbgr.mr_n75965920)
print v(xbgr.mr_n75966240)
print v(xbgr.mr_n75966352)
print v(xbgr.mr_n75966672)
print v(xbgr.mr_n75966784)
print v(xbgr.mr_n75967104)
print v(xbgr.mr_n75967216)
print v(xbgr.mr_n75967536)
print v(xbgr.mr_n75967648)
print v(xbgr.mr_n75967968)
print v(xbgr.mr_n75968080)
print v(xbgr.mr_n75968400)
print v(xbgr.mr_n75968512)
print v(xbgr.mr_n75968832)
print v(xbgr.mr_n75968944)
print v(xbgr.mr_n75969264)
print v(xbgr.mr_n75969376)
print v(xbgr.mr_n75969696)
print v(xbgr.mr_n75969808)
print v(xbgr.mr_n75970128)
print v(xbgr.mr_n75970240)
print v(xbgr.mr_n75970560)
print v(xbgr.mr_n75970672)
print v(xbgr.mr_n75970992)
print v(xbgr.mr_n75971104)
print v(xbgr.mr_n75971424)
print v(xbgr.mr_n75971536)
print v(xbgr.mr_n75971968)
print v(xbgr.mr_n75972288)
print v(xbgr.mr_n75972400)
print v(xbgr.mr_n75972720)
print v(xbgr.mr_n75972832)
print v(xbgr.mr_n75973152)
print v(xbgr.mr_n75973264)
print v(xbgr.mr_n75973584)
print v(xbgr.mr_n75973696)
print v(xbgr.mr_n75974016)
print v(xbgr.mr_n75974880)
print v(xbgr.mr_n75974992)
print v(xbgr.mr_n75975312)
print v(xbgr.mr_n75975424)
print v(xbgr.mr_n75975744)
print v(xbgr.mr_n75975856)
print v(xbgr.mr_n75976176)
print v(xbgr.mr_n75976288)
print v(xbgr.mr_n75976608)
print v(xbgr.mr_n75976720)
print v(xbgr.mr_n75977040)
print v(xbgr.mr_n75977152)
print v(xbgr.mr_n75977472)
print v(xbgr.mr_n75977584)
print v(xbgr.mr_n75977904)
print v(xbgr.mr_n75978016)
print v(xbgr.mr_n75978336)
print v(xbgr.mr_n75978448)
print v(xbgr.mr_n75978768)
print v(xbgr.mr_n75978880)
print v(xbgr.mr_n75979200)
print v(xbgr.mr_n75979312)
print v(xbgr.mr_n75979744)
print v(xbgr.mr_n75980064)
print v(xbgr.mr_n75980176)
print v(xbgr.mr_n75980496)
print v(xbgr.mr_n75980608)
print v(xbgr.mr_n75980928)
print v(xbgr.mr_n75981040)
print v(xbgr.mr_n75981360)
print v(xbgr.mr_n75981472)
print v(xbgr.mr_n75981792)
print v(xbgr.mr_n75981904)
print v(xbgr.mr_n75982224)
print v(xbgr.mr_n75982336)
print v(xbgr.mr_n75982656)
print v(xbgr.mr_n75982768)
print v(xbgr.mr_n75983088)
print v(xbgr.mr_n75983200)
print v(xbgr.mr_n75983520)
print v(xbgr.mr_n75983632)
print v(xbgr.mr_n75983952)
print v(xbgr.mr_n75984064)
print v(xbgr.mr_n75984384)
print v(xbgr.mr_n75984496)
print v(xbgr.mr_n75984816)
print v(xbgr.mr_n75984928)
print v(xbgr.mr_n75985248)
print v(xbgr.mr_n75985360)
print v(xbgr.mr_n75985680)
print v(xbgr.mr_n75985792)
print v(xbgr.mr_n75986112)
print v(xbgr.mr_n75986224)
print v(xbgr.mr_n75986544)
print v(xbgr.mr_n75986656)
print v(xbgr.mr_n75986976)
print v(xbgr.mr_n75987088)
print v(xbgr.mr_n75987408)
print v(xbgr.mr_n75987520)
print v(xbgr.mr_n75987840)
print v(xbgr.mr_n75987952)
print v(xbgr.mr_n75988272)
print v(xbgr.mr_n75988384)
print v(xbgr.mr_n75988704)
print v(xbgr.mr_n75988816)
print v(xbgr.mr_n75989136)
print v(xbgr.mr_n75989248)
print v(xbgr.mr_n75989568)
print v(xbgr.mr_n75989680)
print v(xbgr.mr_n75990000)
print v(xbgr.mr_n75990112)
print v(xbgr.mr_n75990432)
print v(xbgr.mr_n75990544)
print v(xbgr.mr_n75990864)
print v(xbgr.mr_n75990976)
print v(xbgr.mr_n75991296)
print v(xbgr.mr_n75991408)
print v(xbgr.mr_n75991728)
print v(xbgr.mr_n75991840)
print v(xbgr.mr_n75992160)
print v(xbgr.mr_n75992272)
print v(xbgr.mr_n75992592)
print v(xbgr.mr_n75992704)
print v(xbgr.mr_n75993024)
print v(xbgr.mr_n75993136)
print v(xbgr.mr_n75993456)
print v(xbgr.mr_n75993568)
print v(xbgr.mr_n75993888)
print v(xbgr.mr_n75994000)
print v(xbgr.mr_n75994320)
print v(xbgr.mr_n75994432)
print v(xbgr.mr_n75994752)
print v(xbgr.mr_n75994864)
print v(xbgr.mr_n75995184)
print v(xbgr.mr_n75995296)
print v(xbgr.mr_n75995616)
print v(xbgr.mr_n75995728)
print v(xbgr.mr_n75996048)
print v(xbgr.mr_n75996160)
print v(xbgr.mr_n75996480)
print v(xbgr.mr_n75997344)
print v(xbgr.mr_n75997456)
print v(xbgr.mr_n75997776)
print v(xbgr.mr_n75997888)
print v(xbgr.mr_n75998208)
print v(xbgr.mr_n75998320)
print v(xbgr.mr_n75998640)
print v(xbgr.mr_n75998752)
print v(xbgr.mr_n75999072)
print v(xbgr.mr_n75999184)
print v(xbgr.mr_n75999504)
print v(xbgr.mr_n75999616)
print v(xbgr.mr_n75999936)
print v(xbgr.mr_n76000048)
print v(xbgr.mr_n76000368)
print v(xbgr.mr_n76000480)
print v(xbgr.mr_n76000800)
print v(xbgr.mr_n76000912)
print v(xbgr.mr_n76001232)
print v(xbgr.mr_n76001344)
print v(xbgr.mr_n76001664)
print v(xbgr.mr_n76001776)
print v(xbgr.mr_n76002096)
print v(xbgr.mr_n76002208)
print v(xbgr.mr_n76002528)
print v(xbgr.mr_n76002640)
print v(xbgr.mr_n76002960)
print v(xbgr.mr_n76003072)
print v(xbgr.mr_n76003392)
print v(xbgr.mr_n76003504)
print v(xbgr.mr_n76003824)
print v(xbgr.mr_n76003936)
print v(xbgr.mr_n76004256)
print v(xbgr.mr_n76004368)
print v(xbgr.mr_n76004688)
print v(xbgr.mr_n76004800)
print v(xbgr.mr_n76005120)
print v(xbgr.mr_n76005232)
print v(xbgr.mr_n76005552)
print v(xbgr.mr_n76005664)
print v(xbgr.mr_n76005984)
print v(xbgr.mr_n76006096)
print v(xbgr.mr_n76006416)
print v(xbgr.mr_n76006528)
print v(xbgr.mr_n76006848)
print v(xbgr.mr_n76006960)
print v(xbgr.mr_n76007280)
print v(xbgr.mr_n76007392)
print v(xbgr.mr_n76007712)
print v(xbgr.mr_n76007824)
print v(xbgr.mr_n76008144)
print v(xbgr.mr_n76008256)
print v(xbgr.mr_n76008576)
print v(xbgr.mr_n76008688)
print v(xbgr.mr_n76009008)
print v(xbgr.mr_n76009120)
print v(xbgr.mr_n76009440)
print v(xbgr.mr_n76009552)
print v(xbgr.mr_n76009872)
print v(xbgr.mr_n76009984)
print v(xbgr.mr_n76010304)
print v(xbgr.mr_n76010416)
print v(xbgr.mr_n76010736)
print v(xbgr.mr_n76010848)
print v(xbgr.mr_n76011168)
print v(xbgr.mr_n76011280)
print v(xbgr.mr_n76011600)
print v(xbgr.mr_n76011712)
print v(xbgr.mr_n76012032)
print v(xbgr.mr_n76012144)
print v(xbgr.mr_n76012464)
print v(xbgr.mr_n76012576)
print v(xbgr.mr_n76012896)
print v(xbgr.mr_n76013008)
print v(xbgr.mr_n76013328)
print v(xbgr.mr_n76013440)
print v(xbgr.mr_n76013760)
print v(xbgr.mr_n76013872)
print v(xbgr.mr_n76014192)
print v(xbgr.mr_n76014304)
print v(xbgr.mr_n76014624)
print v(xbgr.mr_n76014736)
print v(xbgr.mr_n76015056)
print v(xbgr.mr_n76015168)
print v(xbgr.mr_n76015488)
print v(xbgr.mr_n76015600)
print v(xbgr.mr_n76015920)
print v(xbgr.mr_n76016032)
print v(xbgr.mr_n76016352)
print v(xbgr.mr_n76016464)
print v(xbgr.mr_n76016784)
print v(xbgr.mr_n76016896)
print v(xbgr.mr_n76017216)
print v(xbgr.mr_n76017328)
print v(xbgr.mr_n76017648)
print v(xbgr.mr_n76017760)
print v(xbgr.mr_n76018080)
print v(xbgr.mr_n76018192)
print v(xbgr.mr_n76018512)
print v(xbgr.mr_n76018624)
print v(xbgr.mr_n76018944)
print v(xbgr.mr_n76019056)
print v(xbgr.mr_n76019376)
print v(xbgr.mr_n76019488)
print v(xbgr.mr_n76019808)
print v(xbgr.mr_n76019920)
print v(xbgr.mr_n76020240)
print v(xbgr.mr_n76020352)
print v(xbgr.mr_n76020672)
print v(xbgr.mr_n76020784)
print v(xbgr.mr_n76021104)
print v(xbgr.mr_n76021216)
print v(xbgr.mr_n76021536)
print v(xbgr.mr_n76021648)
print v(xbgr.mr_n76021968)
print v(xbgr.mr_n76022080)
print v(xbgr.mr_n76022400)
print v(xbgr.mr_n76022512)
print v(xbgr.mr_n76022832)
print v(xbgr.mr_n76022944)
print v(xbgr.mr_n76023264)
print v(xbgr.mr_n76023376)
print v(xbgr.mr_n76023696)
print v(xbgr.mr_n76023808)
print v(xbgr.mr_n76024128)
print v(xbgr.mr_n76024240)
print v(xbgr.mr_n76024560)
print v(xbgr.mr_n76024672)
print v(xbgr.mr_n76024992)
print v(xbgr.mr_n76025104)
print v(xbgr.mr_n76025424)
print v(xbgr.mr_n76025536)
print v(xbgr.mr_n76025856)
print v(xbgr.mr_n76025968)
print v(xbgr.mr_n76026288)
print v(xbgr.mr_n76026400)
print v(xbgr.mr_n76026720)
print v(xbgr.mr_n76026832)
print v(xbgr.mr_n76027152)
print v(xbgr.mr_n76027264)
print v(xbgr.mr_n76027584)
print v(xbgr.mr_n76027696)
print v(xbgr.mr_n76028016)
print v(xbgr.mr_n76028128)
print v(xbgr.mr_n76028448)
print v(xbgr.mr_n76028560)
print v(xbgr.mr_n76028880)
print v(xbgr.mr_n76028992)
print v(xbgr.mr_n76029312)
print v(xbgr.mr_n76029424)
print v(xbgr.mr_n76029744)
print v(xbgr.mr_n76029856)
print v(xbgr.mr_n76030176)
print v(xbgr.mr_n76030288)
print v(xbgr.mr_n76030608)
print v(xbgr.mr_n76030720)
print v(xbgr.mr_n76031040)
print v(xbgr.mr_n76031152)
print v(xbgr.mr_n76031472)
print v(xbgr.mr_n76031584)
print v(xbgr.mr_n76031904)
print v(xbgr.mr_n76032016)
print v(xbgr.mr_n76032336)
print v(xbgr.mr_n76032448)
print v(xbgr.mr_n76032768)
print v(xbgr.mr_n76032880)
print v(xbgr.mr_n76033200)
print v(xbgr.mr_n76033312)
print v(xbgr.mr_n76033632)
print v(xbgr.mr_n76033744)
print v(xbgr.mr_n76034064)
print v(xbgr.mr_n76034176)
print v(xbgr.mr_n76034496)
print v(xbgr.mr_n76034608)
print v(xbgr.mr_n76034928)
print v(xbgr.mr_n76035040)
print v(xbgr.mr_n76035360)
print v(xbgr.mr_n76035472)
print v(xbgr.mr_n76035792)
print v(xbgr.mr_n76035904)
print v(xbgr.mr_n76036224)
print v(xbgr.mr_n76036336)
print v(xbgr.mr_n76036656)
print v(xbgr.mr_n76036768)
print v(xbgr.mr_n76037088)
print v(xbgr.mr_n76037200)
print v(xbgr.mr_n76037520)
print v(xbgr.mr_n76037632)
print v(xbgr.mr_n76037952)
print v(xbgr.mr_n76038064)
print v(xbgr.mr_n76038384)
print v(xbgr.mr_n76038496)
print v(xbgr.mr_n76038816)
print v(xbgr.mr_n76038928)
print v(xbgr.mr_n76039248)
print v(xbgr.mr_n76039360)
print v(xbgr.mr_n76039680)
print v(xbgr.mr_n76039792)
print v(xbgr.mr_n76040112)
print v(xbgr.mr_n76040224)
print v(xbgr.mr_n76040544)
print v(xbgr.mr_n76040656)
print v(xbgr.mr_n76040976)
print v(xbgr.mr_n76041088)
print v(xbgr.mr_n76041408)
print v(xbgr.mr_n76041520)
print v(xbgr.mr_n76041840)
print v(xbgr.mr_n76041952)
print v(xbgr.mr_n76042272)
print v(xbgr.mr_n76042384)
print v(xbgr.mr_n76042704)
print v(xbgr.mr_n76042816)
print v(xbgr.mr_n76043136)
print v(xbgr.mr_n76043248)
print v(xbgr.mr_n76043568)
print v(xbgr.mr_n76043680)
print v(xbgr.mr_n76044000)
print v(xbgr.mr_n76044112)
print v(xbgr.mr_n76044432)
print v(xbgr.mr_n76044544)
print v(xbgr.mr_n76044864)
print v(xbgr.mr_n76044976)
print v(xbgr.mr_n76045296)
print v(xbgr.mr_n76045408)
print v(xbgr.mr_n76045728)
print v(xbgr.mr_n76045840)
print v(xbgr.mr_n76046160)
print v(xbgr.mr_n76046272)
print v(xbgr.mr_n76046592)
print v(xbgr.mr_n76046704)
print v(xbgr.mr_n76047024)
print v(xbgr.mr_n76047136)
print v(xbgr.mr_n76047456)
print v(xbgr.mr_n76047568)
print v(xbgr.mr_n76047888)
print v(xbgr.mr_n76048000)
print v(xbgr.mr_n76048320)
print v(xbgr.mr_n76048432)
print v(xbgr.mr_n76048752)
print v(xbgr.mr_n76048864)
print v(xbgr.mr_n76049184)
print v(xbgr.mr_n76049296)
print v(xbgr.mr_n76049616)
print v(xbgr.mr_n76049728)
print v(xbgr.mr_n76050048)
print v(xbgr.mr_n76050160)
print v(xbgr.mr_n76050480)
print v(xbgr.mr_n76050592)
print v(xbgr.mr_n76050912)
print v(xbgr.mr_n76051024)
print v(xbgr.mr_n76051344)
print v(xbgr.mr_n76051456)
print v(xbgr.mr_n76051776)
print v(xbgr.mr_n76051888)
print v(xbgr.mr_n76052208)
print v(xbgr.mr_n76052320)
print v(xbgr.mr_n76052640)
print v(xbgr.mr_n76052752)
print v(xbgr.mr_n76053072)
print v(xbgr.mr_n76053184)
print v(xbgr.mr_n76053504)
print v(xbgr.mr_n76053616)
print v(xbgr.mr_n76053936)
print v(xbgr.mr_n76054048)
print v(xbgr.mr_n76054368)
print v(xbgr.mr_n76054480)
print v(xbgr.mr_n76054800)
print v(xbgr.mr_n76054912)
print v(xbgr.mr_n76055232)
print v(xbgr.mr_n76055344)
print v(xbgr.mr_n76055664)
print v(xbgr.mr_n76055776)
print v(xbgr.mr_n76056096)
print v(xbgr.mr_n76056208)
print v(xbgr.mr_n76056528)
print v(xbgr.mr_n76056640)
print v(xbgr.mr_n76056960)
print v(xbgr.mr_n76057072)
print v(xbgr.mr_n76057392)
print v(xbgr.mr_n76057504)
print v(xbgr.mr_n76057824)
print v(xbgr.mr_n76057936)
print v(xbgr.mr_n76058256)
print v(xbgr.mr_n76058368)
print v(xbgr.mr_n76058688)
print v(xbgr.mr_n76058800)
print v(xbgr.mr_n76059120)
print v(xbgr.mr_n76059232)
print v(xbgr.mr_n76059552)
print v(xbgr.mr_n76059664)
print v(xbgr.mr_n76059984)
print v(xbgr.mr_n76060096)
print v(xbgr.mr_n76060416)
print v(xbgr.mr_n76060528)
print v(xbgr.mr_n76060848)
print v(xbgr.mr_n76060960)
print v(xbgr.mr_n76061280)
print v(xbgr.mr_n76061392)
print v(xbgr.mr_n76061712)
print v(xbgr.mr_n76061824)
print v(xbgr.mr_n76062144)
print v(xbgr.mr_n76062256)
print v(xbgr.mr_n76062576)
print v(xbgr.mr_n76062688)
print v(xbgr.mr_n76063008)
print v(xbgr.mr_n76063120)
print v(xbgr.mr_n76063440)
print v(xbgr.mr_n76063552)
print v(xbgr.mr_n76063872)
print v(xbgr.mr_n76063984)
print v(xbgr.mr_n76064304)
print v(xbgr.mr_n76064416)
print v(xbgr.mr_n76064736)
print v(xbgr.mr_n76064848)
print v(xbgr.mr_n76065168)
print v(xbgr.mr_n76065280)
print v(xbgr.mr_n76065600)
print v(xbgr.mr_n76065712)
print v(xbgr.mr_n76066032)
print v(xbgr.mr_n76066144)
print v(xbgr.mr_n76066464)
print v(xbgr.mr_n76066576)
print v(xbgr.mr_n76066896)
print v(xbgr.mr_n76067008)
print v(xbgr.mr_n76067328)
print v(xbgr.mr_n76067440)
print v(xbgr.mr_n76067760)
print v(xbgr.mr_n76067872)
print v(xbgr.mr_n76068192)
print v(xbgr.mr_n76068304)
print v(xbgr.mr_n76068624)
print v(xbgr.mr_n76068736)
print v(xbgr.mr_n76069056)
print v(xbgr.mr_n76069168)
print v(xbgr.mr_n76069488)
print v(xbgr.mr_n76069600)
print v(xbgr.mr_n76069920)
print v(xbgr.mr_n76070032)
print v(xbgr.mr_n76070352)
print v(xbgr.mr_n76070464)
print v(xbgr.mr_n76070784)
print v(xbgr.mr_n76070896)
print v(xbgr.mr_n76071216)
print v(xbgr.mr_n76071328)
print v(xbgr.mr_n76071648)
print v(xbgr.mr_n76071760)
print v(xbgr.mr_n76072080)
print v(xbgr.mr_n76072192)
print v(xbgr.mr_n76072512)
print v(xbgr.mr_n76072624)
print v(xbgr.mr_n76072944)
print v(xbgr.mr_n76073056)
print v(xbgr.mr_n76073376)
print v(xbgr.mr_n76073488)
print v(xbgr.mr_n76073808)
print v(xbgr.mr_n76073920)
print v(xbgr.mr_n76074240)
print v(xbgr.mr_n76074352)
print v(xbgr.mr_n76074672)
print v(xbgr.mr_n76074784)
print v(xbgr.mr_n76075104)
print v(xbgr.mr_n76075216)
print v(xbgr.mr_n76075536)
print v(xbgr.mr_n76075648)
print v(xbgr.mr_n76075968)
print v(xbgr.mr_n76076080)
print v(xbgr.mr_n76076400)
print v(xbgr.mr_n76076512)
print v(xbgr.mr_n76076832)
print v(xbgr.mr_n76076944)
print v(xbgr.mr_n76077264)
print v(xbgr.mr_n76077376)
print v(xbgr.mr_n76077696)
print v(xbgr.mr_n76077808)
print v(xbgr.mr_n76078128)
print v(xbgr.mr_n76078240)
print v(xbgr.mr_n76078560)
print v(xbgr.mr_n76078672)
print v(xbgr.mr_n76078992)
print v(xbgr.mr_n76079104)
print v(xbgr.mr_n76079424)
print v(xbgr.mr_n76079536)
print v(xbgr.mr_n76079856)
print v(xbgr.mr_n76079968)
print v(xbgr.mr_n76080288)
print v(xbgr.mr_n76080400)
print v(xbgr.mr_n76080720)
print v(xbgr.mr_n76080832)
print v(xbgr.mr_n76081152)
print v(xbgr.mr_n76081264)
print v(xbgr.mr_n76081584)
print v(xbgr.mr_n76081696)
print v(xbgr.mr_n76082016)
print v(xbgr.mr_n76082128)
print v(xbgr.mr_n76082448)
print v(xbgr.mr_n76082560)
print v(xbgr.mr_n76082880)
print v(xbgr.mr_n76082992)
print v(xbgr.mr_n76083312)
print v(xbgr.mr_n76083424)
print v(xbgr.mr_n76083744)
print v(xbgr.mr_n76083856)
print v(xbgr.mr_n76084176)
print v(xbgr.mr_n76084288)
print v(xbgr.mr_n76084608)
print v(xbgr.mr_n76084720)
print v(xbgr.mr_n76085040)
print v(xbgr.mr_n76085152)
print v(xbgr.mr_n76085472)
print v(xbgr.mr_n76085584)
print v(xbgr.mr_n76085904)
print v(xbgr.mr_n76086016)
print v(xbgr.mr_n76086336)
print v(xbgr.mr_n76086448)
print v(xbgr.mr_n76086768)
print v(xbgr.mr_n76086880)
print v(xbgr.mr_n76087200)
print v(xbgr.mr_n76087312)
print v(xbgr.mr_n76087632)
print v(xbgr.mr_n76087744)
print v(xbgr.mr_n76088064)
print v(xbgr.mr_n76088176)
print v(xbgr.mr_n76088496)
print v(xbgr.mr_n76088608)
print v(xbgr.mr_n76088928)
print v(xbgr.mr_n76089040)
print v(xbgr.mr_n76089360)
print v(xbgr.mr_n76089472)
print v(xbgr.mr_n76089792)
print v(xbgr.mr_n76089904)
print v(xbgr.mr_n76090224)
print v(xbgr.mr_n76090336)
print v(xbgr.mr_n76090656)
print v(xbgr.mr_n76090768)
print v(xbgr.mr_n76091088)
print v(xbgr.mr_n76091200)
print v(xbgr.mr_n76091520)
print v(xbgr.mr_n76091632)
print v(xbgr.mr_n76091952)
print v(xbgr.mr_n76092064)
print v(xbgr.mr_n76092384)
print v(xbgr.mr_n76092496)
print v(xbgr.mr_n76092816)
print v(xbgr.mr_n76092928)
print v(xbgr.mr_n76093248)
print v(xbgr.mr_n76093360)
print v(xbgr.mr_n76093680)
print v(xbgr.mr_n76093792)
print v(xbgr.mr_n76094112)
print v(xbgr.mr_n76094224)
print v(xbgr.mr_n76094544)
print v(xbgr.mr_n76094656)
print v(xbgr.mr_n76094976)
print v(xbgr.mr_n76095088)
print v(xbgr.mr_n76095408)
print v(xbgr.mr_n76095520)
print v(xbgr.mr_n76095840)
print v(xbgr.mr_n76095952)
print v(xbgr.mr_n76096272)
print v(xbgr.mr_n76096384)
print v(xbgr.mr_n76096704)
print v(xbgr.mr_n76096816)
print v(xbgr.mr_n76097136)
print v(xbgr.mr_n76097248)
print v(xbgr.mr_n76097568)
print v(xbgr.mr_n76097680)
print v(xbgr.mr_n76098000)
print v(xbgr.mr_n76098112)
print v(xbgr.mr_n76098432)
print v(xbgr.mr_n76098544)
print v(xbgr.mr_n76098864)
print v(xbgr.mr_n76098976)
print v(xbgr.mr_n76099296)
print v(xbgr.mr_n76099408)
print v(xbgr.mr_n76099728)
print v(xbgr.mr_n76099840)
print v(xbgr.mr_n76100160)
print v(xbgr.mr_n76100272)
print v(xbgr.mr_n76100592)
print v(xbgr.mr_n76100704)
print v(xbgr.mr_n76101024)
print v(xbgr.mr_n76101136)
print v(xbgr.mr_n76101456)
print v(xbgr.mr_n76101568)
print v(xbgr.mr_n76101888)
print v(xbgr.mr_n76102000)
print v(xbgr.mr_n76102320)
print v(xbgr.mr_n76102432)
print v(xbgr.mr_n76102752)
print v(xbgr.mr_n76102864)
print v(xbgr.mr_n76103184)
print v(xbgr.mr_n76103296)
print v(xbgr.mr_n76103616)
print v(xbgr.mr_n76103728)
print v(xbgr.mr_n76104048)
print v(xbgr.mr_n76104160)
print v(xbgr.mr_n76104480)
print v(xbgr.mr_n76104592)
print v(xbgr.mr_n76104912)
print v(xbgr.mr_n76105024)
print v(xbgr.mr_n76105344)
print v(xbgr.mr_n76105456)
print v(xbgr.mr_n76105776)
print v(xbgr.mr_n76105888)
print v(xbgr.mr_n76106208)
print v(xbgr.mr_n76106320)
print v(xbgr.mr_n76106640)
print v(xbgr.mr_n76106752)
print v(xbgr.mr_n76107072)
print v(xbgr.mr_n76107184)
print v(xbgr.mr_n76107504)
print v(xbgr.mr_n76107616)
print v(xbgr.mr_n76107936)
print v(xbgr.mr_n76108048)
print v(xbgr.mr_n76108368)
print v(xbgr.mr_n76108480)
print v(xbgr.mr_n76108800)
print v(xbgr.mr_n76108912)
print v(xbgr.mr_n76109232)
print v(xbgr.mr_n76109344)
print v(xbgr.mr_n76109664)
print v(xbgr.mr_n76109776)
print v(xbgr.mr_n76110096)
print v(xbgr.mr_n76110208)
print v(xbgr.mr_n76110528)
print v(xbgr.mr_n76110640)
print v(xbgr.mr_n76110960)
print v(xbgr.mr_n76111072)
print v(xbgr.mr_n76111392)
print v(xbgr.mr_n76111504)
print v(xbgr.mr_n76111824)
print v(xbgr.mr_n76111936)
print v(xbgr.mr_n76112256)
print v(xbgr.mr_n76112368)
print v(xbgr.mr_n76112688)
print v(xbgr.mr_n76112800)
print v(xbgr.mr_n76113120)
print v(xbgr.mr_n76113232)
print v(xbgr.mr_n76113552)
print v(xbgr.mr_n76113664)
print v(xbgr.mr_n76113984)
print v(xbgr.mr_n76114096)
print v(xbgr.mr_n76114416)
print v(xbgr.mr_n76114528)
print v(xbgr.mr_n76114848)
print v(xbgr.mr_n76114960)
print v(xbgr.mr_n76115280)
print v(xbgr.mr_n76115392)
print v(xbgr.mr_n76115712)
print v(xbgr.mr_n76115824)
print v(xbgr.mr_n76116144)
print v(xbgr.mr_n76116256)
print v(xbgr.mr_n76116576)
print v(xbgr.mr_n76116688)
print v(xbgr.mr_n76117008)
print v(xbgr.mr_n76117120)
print v(xbgr.mr_n76117440)
print v(xbgr.mr_n76117552)
print v(xbgr.mr_n76117872)
print v(xbgr.mr_n76117984)
print v(xbgr.mr_n76118304)
print v(xbgr.mr_n76118416)
print v(xbgr.mr_n76118736)
print v(xbgr.mr_n76118848)
print v(xbgr.mr_n76119168)
print v(xbgr.mr_n76119280)
print v(xbgr.mr_n76119600)
print v(xbgr.mr_n76119712)
print v(xbgr.mr_n76120032)
print v(xbgr.mr_n76120144)
print v(xbgr.mr_n76120464)
print v(xbgr.mr_n76120576)
print v(xbgr.mr_n76120896)
print v(xbgr.mr_n76121008)
print v(xbgr.mr_n76121328)
print v(xbgr.mr_n76121440)
print v(xbgr.mr_n76121760)
print v(xbgr.mr_n76121872)
print v(xbgr.mr_n76122192)
print v(xbgr.mr_n76122304)
print v(xbgr.mr_n76122624)
print v(xbgr.mr_n76122736)
print v(xbgr.mr_n76123056)
print v(xbgr.mr_n76123168)
print v(xbgr.mr_n76123488)
print v(xbgr.mr_n76123600)
print v(xbgr.mr_n76124032)
print v(xbgr.mr_n76124352)
print v(xbgr.mr_n76124464)
print v(xbgr.mr_n76124784)
print v(xbgr.mr_n76124896)
print v(xbgr.mr_n76125216)
print v(xbgr.mr_n76125328)
print v(xbgr.mr_n76125760)
print v(xbgr.mr_n76126080)
print v(xbgr.mr_n76126192)
print v(xbgr.mr_n76126512)
print v(xbgr.mr_n76126624)
print v(xbgr.mr_n76126944)
print v(xbgr.mr_n76127056)
print v(xbgr.mr_n76127376)
print v(xbgr.mr_n76127488)
print v(xbgr.mr_n76127808)
print v(xbgr.mr_n76127920)
print v(xbgr.mr_n76128240)
print v(xbgr.mr_n76128352)
print v(xbgr.mr_n76128672)
print v(xbgr.mr_n76128784)
print v(xbgr.mr_n76129104)
print v(xbgr.mr_n76129216)
print v(xbgr.mr_n76129536)
print v(xbgr.mr_n76129648)
print v(xbgr.mr_n76129968)
print v(xbgr.mr_n76130080)
print v(xbgr.mr_n76130400)
print v(xbgr.mr_n76130512)
print v(xbgr.mr_n76130832)
print v(xbgr.mr_n76130944)
print v(xbgr.mr_n76131264)
print v(xbgr.mr_n76131376)
print v(xbgr.mr_n76131696)
print v(xbgr.mr_n76131808)
print v(xbgr.mr_n76132128)
print v(xbgr.mr_n76132240)
print v(xbgr.mr_n76132672)
print v(xbgr.mr_n76132992)
print v(xbgr.mr_n76133104)
print v(xbgr.mr_n76133424)
print v(xbgr.mr_n76133536)
print v(xbgr.mr_n76133856)
print v(xbgr.mr_n76133968)
print v(xbgr.mr_n76134288)
print v(xbgr.mr_n76134400)
print v(xbgr.mr_n76134720)
print v(xbgr.mr_n76134832)
print v(xbgr.mr_n76135152)
print v(xbgr.mr_n76135264)
print v(xbgr.mr_n76135584)
print v(xbgr.mr_n76135696)
print v(xbgr.mr_n76136128)
print v(xbgr.mr_n76136448)
print v(xbgr.mr_n76136560)
print v(xbgr.mr_n76136880)
print v(xbgr.mr_n76136992)
print v(xbgr.mr_n76137312)
print v(xbgr.mr_n76137424)
print v(xbgr.mr_n76137744)
print v(xbgr.mr_n76137856)
print v(xbgr.mr_n76138176)
print v(xbgr.mr_n76138288)
print v(xbgr.mr_n76138608)
print v(xbgr.mr_n76138720)
print v(xbgr.mr_n76139040)
print v(xbgr.mr_n76139152)
print v(xbgr.mr_n76139472)
print v(xbgr.mr_n76139584)
print v(xbgr.mr_n76139904)
print v(xbgr.mr_n76140016)
print v(xbgr.mr_n76140336)
print v(xbgr.mr_n76140448)
print v(xbgr.mr_n76140768)
print v(xbgr.mr_n76140880)
print v(xbgr.mr_n76141200)
print v(xbgr.mr_n76141312)
print v(xbgr.mr_n76141632)
print v(xbgr.mr_n76141744)
print v(xbgr.mr_n76142176)
print v(xbgr.mr_n76142496)
print v(xbgr.mr_n76142608)
print v(xbgr.mr_n76142928)
print v(xbgr.mr_n76143040)
print v(xbgr.mr_n76143360)
print v(xbgr.mr_n76143472)
print v(xbgr.mr_n76143904)
print v(xbgr.mr_n76144224)
print v(xbgr.mr_n76144336)
print v(xbgr.mr_n76144656)
print v(xbgr.mr_n76144768)
print v(xbgr.mr_n76145088)
print v(xbgr.mr_n76145200)
print v(xbgr.mr_n76145520)
print v(xbgr.mr_n76145632)
print v(xbgr.mr_n76145952)
print v(xbgr.mr_n76146064)
print v(xbgr.mr_n76146496)
print v(xbgr.mr_n76146816)
print v(xbgr.mr_n76146928)
print v(xbgr.mr_n76147248)
print v(xbgr.mr_n76147360)
print v(xbgr.mr_n76147680)
print v(xbgr.mr_n76147792)
print v(xbgr.mr_n76148112)
print v(xbgr.mr_n76148224)
print v(xbgr.mr_n76148544)
print v(xbgr.mr_n76148656)
print v(xbgr.mr_n76148976)
print v(xbgr.mr_n76149088)
print v(xbgr.mr_n76149408)
print v(xbgr.mr_n76149520)
print v(xbgr.mr_n76149840)
print v(xbgr.mr_n76149952)
print v(xbgr.mr_n76150272)
print v(xbgr.mr_n76150384)
print v(xbgr.mr_n76150704)
print v(xbgr.mr_n76150816)
print v(xbgr.mr_n76151136)
print v(xbgr.mr_n76151248)
print v(xbgr.mr_n76151568)
print v(xbgr.mr_n76151680)
print v(xbgr.mr_n76152000)
print v(xbgr.mr_n76152112)
print v(xbgr.mr_n76152544)
print v(xbgr.mr_n76152864)
print v(xbgr.mr_n76152976)
print v(xbgr.mr_n76153296)
print v(xbgr.mr_n76153408)
print v(xbgr.mr_n76153728)
print v(xbgr.mr_n76153840)
print v(xbgr.mr_n76154272)
print v(xbgr.mr_n76154592)
print v(xbgr.mr_n76154704)
print v(xbgr.mr_n76155136)
print v(xbgr.mr_n76155456)
print v(xbgr.mr_n76155568)
print v(xbgr.mr_n76155888)
print v(xbgr.mr_n76156000)
print v(xbgr.mr_n76156320)
print v(xbgr.mr_n76156432)
print v(xbgr.mr_n76156864)
print v(xbgr.mr_n76157184)
print v(xbgr.mr_n76157296)
print v(xbgr.mr_n76157616)
print v(xbgr.mr_n76157728)
print v(xbgr.mr_n76158048)
print v(xbgr.mr_n76158160)
print v(xbgr.mr_n76158480)
print v(xbgr.mr_n76158592)
print v(xbgr.mr_n76158912)
print v(xbgr.mr_n76159024)
print v(xbgr.mr_n76159344)
print v(xbgr.mr_n76159456)
print v(xbgr.mr_n76159776)
print v(xbgr.mr_n76159888)
print v(xbgr.mr_n76160208)
print v(xbgr.mr_n76160320)
print v(xbgr.mr_n76160640)
print v(xbgr.mr_n76160752)
print v(xbgr.mr_n76161184)
print v(xbgr.mr_n76161504)
print v(xbgr.mr_n76161616)
print v(xbgr.mr_n76161936)
print v(xbgr.mr_n76162048)
print v(xbgr.mr_n76162368)
print v(xbgr.mr_n76162480)
print v(xbgr.mr_n76162800)
print v(xbgr.mr_n76162912)
print v(xbgr.mr_n76163232)
print v(xbgr.mr_n76163344)
print v(xbgr.mr_n76163664)
print v(xbgr.mr_n76163776)
print v(xbgr.mr_n76164096)
print v(xbgr.mr_n76164208)
print v(xbgr.mr_n76164528)
print v(xbgr.mr_n76164640)
print v(xbgr.mr_n76164960)
print v(xbgr.mr_n76165072)
print v(xbgr.mr_n76165392)
print v(xbgr.mr_n76165504)
print v(xbgr.mr_n76165824)
print v(xbgr.mr_n76165936)
print v(xbgr.mr_n76166256)
print v(xbgr.mr_n76166368)
print v(xbgr.mr_n76166688)
print v(xbgr.mr_n76166800)
print v(xbgr.mr_n76167120)
print v(xbgr.mr_n76167232)
print v(xbgr.mr_n76167552)
print v(xbgr.mr_n76167664)
print v(xbgr.mr_n76167984)
print v(xbgr.mr_n76168096)
print v(xbgr.mr_n76168416)
print v(xbgr.mr_n76168528)
print v(xbgr.mr_n76168848)
print v(xbgr.mr_n76168960)
print v(xbgr.mr_n76169280)
print v(xbgr.mr_n76169392)
print v(xbgr.mr_n76169712)
print v(xbgr.mr_n76169824)
print v(xbgr.mr_n76170144)
print v(xbgr.mr_n76170256)
print v(xbgr.mr_n76170576)
print v(xbgr.mr_n76170688)
print v(xbgr.mr_n76171008)
print v(xbgr.mr_n76171120)
print v(xbgr.mr_n76171440)
print v(xbgr.mr_n76171552)
print v(xbgr.mr_n76171872)
print v(xbgr.mr_n76171984)
print v(xbgr.mr_n76172304)
print v(xbgr.mr_n76172416)
print v(xbgr.mr_n76172736)
print v(xbgr.mr_n76172848)
print v(xbgr.mr_n76173168)
print v(xbgr.mr_n76173280)
print v(xbgr.mr_n76173600)
print v(xbgr.mr_n76173712)
print v(xbgr.mr_n76174032)
print v(xbgr.mr_n76174144)
print v(xbgr.mr_n76174464)
print v(xbgr.mr_n76174576)
print v(xbgr.mr_n76174896)
print v(xbgr.mr_n76175008)
print v(xbgr.mr_n76175328)
print v(xbgr.mr_n76175440)
print v(xbgr.mr_n76175760)
print v(xbgr.mr_n76175872)
print v(xbgr.mr_n76176192)
print v(xbgr.mr_n76176304)
print v(xbgr.mr_n76176624)
print v(xbgr.mr_n76176736)
print v(xbgr.mr_n76177056)
print v(xbgr.mr_n76177168)
print v(xbgr.mr_n76177488)
print v(xbgr.mr_n76177600)
print v(xbgr.mr_n76177920)
print v(xbgr.mr_n76178032)
print v(xbgr.mr_n76178352)
print v(xbgr.mr_n76178464)
print v(xbgr.mr_n76178784)
print v(xbgr.mr_n76178896)
print v(xbgr.mr_n76179216)
print v(xbgr.mr_n76179328)
print v(xbgr.mr_n76179648)
print v(xbgr.mr_n76179760)
print v(xbgr.mr_n76180080)
print v(xbgr.mr_n76180192)
print v(xbgr.mr_n76180512)
print v(xbgr.mr_n76180624)
print v(xbgr.mr_n76180944)
print v(xbgr.mr_n76181056)
print v(xbgr.mr_n76181376)
print v(xbgr.mr_n76181488)
print v(xbgr.mr_n76181808)
print v(xbgr.mr_n76181920)
print v(xbgr.mr_n76182240)
print v(xbgr.mr_n76182352)
print v(xbgr.mr_n76182672)
print v(xbgr.mr_n76182784)
print v(xbgr.mr_n76183104)
print v(xbgr.mr_n76183216)
print v(xbgr.mr_n76183536)
print v(xbgr.mr_n76183648)
print v(xbgr.mr_n76183968)
print v(xbgr.mr_n76184080)
print v(xbgr.mr_n76184400)
print v(xbgr.mr_n76184512)
print v(xbgr.mr_n76184832)
print v(xbgr.mr_n76184944)
print v(xbgr.mr_n76185264)
print v(xbgr.mr_n76185376)
print v(xbgr.mr_n76185696)
print v(xbgr.mr_n76185808)
print v(xbgr.mr_n76186128)
print v(xbgr.mr_n76186240)
print v(xbgr.mr_n76186560)
print v(xbgr.mr_n76186672)
print v(xbgr.mr_n76186992)
print v(xbgr.mr_n76187104)
print v(xbgr.mr_n76187424)
print v(xbgr.mr_n76187536)
print v(xbgr.mr_n76187856)
print v(xbgr.mr_n76187968)
print v(xbgr.mr_n76188288)
print v(xbgr.mr_n76188400)
print v(xbgr.mr_n76188720)
print v(xbgr.mr_n76188832)
print v(xbgr.mr_n76189152)
print v(xbgr.mr_n76189264)
print v(xbgr.mr_n76189584)
print v(xbgr.mr_n76189696)
print v(xbgr.mr_n76190016)
print v(xbgr.mr_n76190128)
print v(xbgr.mr_n76190448)
print v(xbgr.mr_n76190560)
print v(xbgr.mr_n76190880)
print v(xbgr.mr_n76190992)
print v(xbgr.mr_n76191312)
print v(xbgr.mr_n76191424)
print v(xbgr.mr_n76191744)
print v(xbgr.mr_n76191856)
print v(xbgr.mr_n76192176)
print v(xbgr.mr_n76192288)
print v(xbgr.mr_n76192608)
print v(xbgr.mr_n76192720)
print v(xbgr.mr_n76193040)
print v(xbgr.mr_n76193152)
print v(xbgr.mr_n76193472)
print v(xbgr.mr_n76193584)
print v(xbgr.mr_n76193904)
print v(xbgr.mr_n76194016)
print v(xbgr.mr_n76194336)
print v(xbgr.mr_n76194448)
print v(xbgr.mr_n76194768)
print v(xbgr.mr_n76194880)
print v(xbgr.mr_n76195200)
print v(xbgr.mr_n76195312)
print v(xbgr.mr_n76195632)
print v(xbgr.mr_n76195744)
print v(xbgr.mr_n76196064)
print v(xbgr.mr_n76196176)
print v(xbgr.mr_n76196496)
print v(xbgr.mr_n76196608)
print v(xbgr.mr_n76196928)
print v(xbgr.mr_n76197040)
print v(xbgr.mr_n76197360)
print v(xbgr.mr_n76197472)
print v(xbgr.mr_n76197792)
print v(xbgr.mr_n76197904)
print v(xbgr.mr_n76198224)
print v(xbgr.mr_n76198336)
print v(xbgr.mr_n76198656)
print v(xbgr.mr_n76198768)
print v(xbgr.mr_n76199088)
print v(xbgr.mr_n76199200)
print v(xbgr.mr_n76199520)
print v(xbgr.mr_n76199632)
print v(xbgr.mr_n76199952)
print v(xbgr.mr_n76200064)
print v(xbgr.mr_n76200384)
print v(xbgr.mr_n76200496)
print v(xbgr.mr_n76200816)
print v(xbgr.mr_n76200928)
print v(xbgr.mr_n76201248)
print v(xbgr.mr_n76201360)
print v(xbgr.mr_n76201680)
print v(xbgr.mr_n76201792)
print v(xbgr.mr_n76202112)
print v(xbgr.mr_n76202224)
print v(xbgr.mr_n76202544)
print v(xbgr.mr_n76202656)
print v(xbgr.mr_n76202976)
print v(xbgr.mr_n76203088)
print v(xbgr.mr_n76203408)
print v(xbgr.mr_n76203520)
print v(xbgr.mr_n76203840)
print v(xbgr.mr_n76203952)
print v(xbgr.mr_n76204272)
print v(xbgr.mr_n76204384)
print v(xbgr.mr_n76204704)
print v(xbgr.mr_n76204816)
print v(xbgr.mr_n76205136)
print v(xbgr.mr_n76205248)
print v(xbgr.mr_n76205568)
print v(xbgr.mr_n76205680)
print v(xbgr.mr_n76206000)
print v(xbgr.mr_n76206112)
print v(xbgr.mr_n76206432)
print v(xbgr.mr_n76206544)
print v(xbgr.mr_n76206864)
print v(xbgr.mr_n76206976)
print v(xbgr.mr_n76207296)
print v(xbgr.mr_n76207408)
print v(xbgr.mr_n76207728)
print v(xbgr.mr_n76207840)
print v(xbgr.mr_n76208160)
print v(xbgr.mr_n76208272)
print v(xbgr.mr_n76208592)
print v(xbgr.mr_n76208704)
print v(xbgr.mr_n76209024)
print v(xbgr.mr_n76209136)
print v(xbgr.mr_n76209456)
print v(xbgr.mr_n76209568)
print v(xbgr.mr_n76209888)
print v(xbgr.mr_n76210000)
print v(xbgr.mr_n76210320)
print v(xbgr.mr_n76210432)
print v(xbgr.mr_n76210752)
print v(xbgr.mr_n76210864)
print v(xbgr.mr_n76211184)
print v(xbgr.mr_n76211296)
print v(xbgr.mr_n76211616)
print v(xbgr.mr_n76211728)
print v(xbgr.mr_n76212048)
print v(xbgr.mr_n76212160)
print v(xbgr.mr_n76212480)
print v(xbgr.mr_n76212592)
print v(xbgr.mr_n76212912)
print v(xbgr.mr_n76213024)
print v(xbgr.mr_n76213344)
print v(xbgr.mr_n76213456)
print v(xbgr.mr_n76213776)
print v(xbgr.mr_n76213888)
print v(xbgr.mr_n76214208)
print v(xbgr.mr_n76214320)
print v(xbgr.mr_n76214640)
print v(xbgr.mr_n76214752)
print v(xbgr.mr_n76215072)
print v(xbgr.mr_n76215184)
print v(xbgr.mr_n76215504)
print v(xbgr.mr_n76215616)
print v(xbgr.mr_n76215936)
print v(xbgr.mr_n76216048)
print v(xbgr.mr_n76216368)
print v(xbgr.mr_n76216480)
print v(xbgr.mr_n76216800)
print v(xbgr.mr_n76216912)
print v(xbgr.mr_n76217232)
print v(xbgr.mr_n76217344)
print v(xbgr.mr_n76217664)
print v(xbgr.mr_n76217776)
print v(xbgr.mr_n76218096)
print v(xbgr.mr_n76218208)
print v(xbgr.mr_n76218528)
print v(xbgr.mr_n76218640)
print v(xbgr.mr_n76218960)
print v(xbgr.mr_n76219072)
print v(xbgr.mr_n76219392)
print v(xbgr.mr_n76219504)
print v(xbgr.mr_n76219824)
print v(xbgr.mr_n76219936)
print v(xbgr.mr_n76220256)
print v(xbgr.mr_n76220368)
print v(xbgr.mr_n76220688)
print v(xbgr.mr_n76220800)
print v(xbgr.mr_n76221120)
print v(xbgr.mr_n76221232)
print v(xbgr.mr_n76221552)
print v(xbgr.mr_n76221664)
print v(xbgr.mr_n76221984)
print v(xbgr.mr_n76222096)
print v(xbgr.mr_n76222416)
print v(xbgr.mr_n76222528)
print v(xbgr.mr_n76222848)
print v(xbgr.mr_n76222960)
print v(xbgr.mr_n76223280)
print v(xbgr.mr_n76223392)
print v(xbgr.mr_n76223712)
print v(xbgr.mr_n76223824)
print v(xbgr.mr_n76224144)
print v(xbgr.mr_n76224256)
print v(xbgr.mr_n76224576)
print v(xbgr.mr_n76224688)
print v(xbgr.mr_n76225008)
print v(xbgr.mr_n76225120)
print v(xbgr.mr_n76225440)
print v(xbgr.mr_n76225552)
print v(xbgr.mr_n76225872)
print v(xbgr.mr_n76225984)
print v(xbgr.mr_n76226304)
print v(xbgr.mr_n76226416)
print v(xbgr.mr_n76226736)
print v(xbgr.mr_n76226848)
print v(xbgr.mr_n76227168)
print v(xbgr.mr_n76227280)
print v(xbgr.mr_n76227600)
print v(xbgr.mr_n76227712)
print v(xbgr.mr_n76228032)
print v(xbgr.mr_n76228144)
print v(xbgr.mr_n76228464)
print v(xbgr.mr_n76228576)
print v(xbgr.mr_n76228896)
print v(xbgr.mr_n76229008)
print v(xbgr.mr_n76229328)
print v(xbgr.mr_n76229440)
print v(xbgr.mr_n76229760)
print v(xbgr.mr_n76229872)
print v(xbgr.mr_n76230192)
print v(xbgr.mr_n76230304)
print v(xbgr.mr_n76230624)
print v(xbgr.mr_n76230736)
print v(xbgr.mr_n76231056)
print v(xbgr.mr_n76231168)
print v(xbgr.mr_n76231488)
print v(xbgr.mr_n76231600)
print v(xbgr.mr_n76231920)
print v(xbgr.mr_n76232032)
print v(xbgr.mr_n76232352)
print v(xbgr.mr_n76232464)
print v(xbgr.mr_n76232784)
print v(xbgr.mr_n76232896)
print v(xbgr.mr_n76233216)
print v(xbgr.mr_n76233328)
print v(xbgr.mr_n76233648)
print v(xbgr.mr_n76233760)
print v(xbgr.mr_n76234080)
print v(xbgr.mr_n76234192)
print v(xbgr.mr_n76234512)
print v(xbgr.mr_n76234624)
print v(xbgr.mr_n76234944)
print v(xbgr.mr_n76235056)
print v(xbgr.mr_n76235376)
print v(xbgr.mr_n76235488)
print v(xbgr.mr_n76235808)
print v(xbgr.mr_n76235920)
print v(xbgr.mr_n76236240)
print v(xbgr.mr_n76236352)
print v(xbgr.mr_n76236672)
print v(xbgr.mr_n76236784)
print v(xbgr.mr_n76237104)
print v(xbgr.mr_n76237216)
print v(xbgr.mr_n76237536)
print v(xbgr.mr_n76237648)
print v(xbgr.mr_n76237968)
print v(xbgr.mr_n76238080)
print v(xbgr.mr_n76238400)
print v(xbgr.mr_n76238512)
print v(xbgr.mr_n76238832)
print v(xbgr.mr_n76238944)
print v(xbgr.mr_n76239264)
print v(xbgr.mr_n76239376)
print v(xbgr.mr_n76239696)
print v(xbgr.mr_n76239808)
print v(xbgr.mr_n76240128)
print v(xbgr.mr_n76240240)
print v(xbgr.mr_n76240560)
print v(xbgr.mr_n76240672)
print v(xbgr.mr_n76240992)
print v(xbgr.mr_n76241104)
print v(xbgr.mr_n76241424)
print v(xbgr.mr_n76241536)
print v(xbgr.mr_n76241856)
print v(xbgr.mr_n76241968)
print v(xbgr.mr_n76242288)
print v(xbgr.mr_n76242400)
print v(xbgr.mr_n76242720)
print v(xbgr.mr_n76242832)
print v(xbgr.mr_n76243152)
print v(xbgr.mr_n76243264)
print v(xbgr.mr_n76243584)
print v(xbgr.mr_n76243696)
print v(xbgr.mr_n76244016)
print v(xbgr.mr_n76244128)
print v(xbgr.mr_n76244448)
print v(xbgr.mr_n76244560)
print v(xbgr.mr_n76244880)
print v(xbgr.mr_n76244992)
print v(xbgr.mr_n76245312)
print v(xbgr.mr_n76245424)
print v(xbgr.mr_n76245744)
print v(xbgr.mr_n76245856)
print v(xbgr.mr_n76246176)
print v(xbgr.mr_n76246288)
print v(xbgr.mr_n76246608)
print v(xbgr.mr_n76246720)
print v(xbgr.mr_n76247040)
print v(xbgr.mr_n76247152)
print v(xbgr.mr_n76247472)
print v(xbgr.mr_n76247584)
print v(xbgr.mr_n76247904)
print v(xbgr.mr_n76248016)
print v(xbgr.mr_n76248336)
print v(xbgr.mr_n76248448)
print v(xbgr.mr_n76248768)
print v(xbgr.mr_n76248880)
print v(xbgr.mr_n76249200)
print v(xbgr.mr_n76249312)
print v(xbgr.mr_n76249632)
print v(xbgr.mr_n76249744)
print v(xbgr.mr_n76250064)
print v(xbgr.mr_n76250176)
print v(xbgr.mr_n76250496)
print v(xbgr.mr_n76250608)
print v(xbgr.mr_n76250928)
print v(xbgr.mr_n76251040)
print v(xbgr.mr_n76251360)
print v(xbgr.mr_n76251472)
print v(xbgr.mr_n76251792)
print v(xbgr.mr_n76251904)
print v(xbgr.mr_n76252224)
print v(xbgr.mr_n76252336)
print v(xbgr.mr_n76252656)
print v(xbgr.mr_n76252768)
print v(xbgr.mr_n76253088)
print v(xbgr.mr_n76253200)
print v(xbgr.mr_n76253520)
print v(xbgr.mr_n76253632)
print v(xbgr.mr_n76253952)
print v(xbgr.mr_n76254064)
print v(xbgr.mr_n76254384)
print v(xbgr.mr_n76254496)
print v(xbgr.mr_n76254816)
print v(xbgr.mr_n76254928)
print v(xbgr.mr_n76255248)
print v(xbgr.mr_n76255360)
print v(xbgr.mr_n76255680)
print v(xbgr.mr_n76255792)
print v(xbgr.mr_n76256112)
print v(xbgr.mr_n76256224)
print v(xbgr.mr_n76256544)
print v(xbgr.mr_n76256656)
print v(xbgr.mr_n76256976)
print v(xbgr.mr_n76257088)
print v(xbgr.mr_n76257408)
print v(xbgr.mr_n76257520)
print v(xbgr.mr_n76257840)
print v(xbgr.mr_n76257952)
print v(xbgr.mr_n76258272)
print v(xbgr.mr_n76258384)
print v(xbgr.mr_n76258704)
print v(xbgr.mr_n76258816)
print v(xbgr.mr_n76259136)
print v(xbgr.mr_n76259248)
print v(xbgr.mr_n76259568)
print v(xbgr.mr_n76259680)
print v(xbgr.mr_n76260000)
print v(xbgr.mr_n76260112)
print v(xbgr.mr_n76260432)
print v(xbgr.mr_n76260544)
print v(xbgr.mr_n76260864)
print v(xbgr.mr_n76260976)
print v(xbgr.mr_n76261296)
print v(xbgr.mr_n76261408)
print v(xbgr.mr_n76261728)
print v(xbgr.mr_n76261840)
print v(xbgr.mr_n76262160)
print v(xbgr.mr_n76262272)
print v(xbgr.mr_n76262592)
print v(xbgr.mr_n76262704)
print v(xbgr.mr_n76263024)
print v(xbgr.mr_n76263136)
print v(xbgr.mr_n76263456)
print v(xbgr.mr_n76263568)
print v(xbgr.mr_n76263888)
print v(xbgr.mr_n76264000)
print v(xbgr.mr_n76264320)
print v(xbgr.mr_n76264432)
print v(xbgr.mr_n76264752)
print v(xbgr.mr_n76264864)
print v(xbgr.mr_n76265184)
print v(xbgr.mr_n76265296)
print v(xbgr.mr_n76265728)
print v(xbgr.mr_n76266048)
print v(xbgr.mr_n76266160)
print v(xbgr.mr_n76266480)
print v(xbgr.mr_n76266592)
print v(xbgr.mr_n76266912)
print v(xbgr.mr_n76267024)
print v(xbgr.mr_n76267344)
print v(xbgr.mr_n76267456)
print v(xbgr.mr_n76267776)
print v(xbgr.mr_n76267888)
print v(xbgr.mr_n76268320)
print v(xbgr.mr_n76268640)
print v(xbgr.mr_n76268752)
print v(xbgr.mr_n76269072)
print v(xbgr.mr_n76269184)
print v(xbgr.mr_n76269504)
print v(xbgr.mr_n76269616)
print v(xbgr.mr_n76269936)
print v(xbgr.mr_n76270048)
print v(xbgr.mr_n76270368)
print v(xbgr.mr_n76270480)
print v(xbgr.mr_n76270912)
print v(xbgr.mr_n76271232)
print v(xbgr.mr_n76271344)
print v(xbgr.mr_n76271664)
print v(xbgr.mr_n76271776)
print v(xbgr.mr_n76272096)
print v(xbgr.mr_n76272208)
print v(xbgr.mr_n76272528)
print v(xbgr.mr_n76272640)
print v(xbgr.mr_n76272960)
print v(xbgr.mr_n76273072)
print v(xbgr.mr_n76273392)
print v(xbgr.mr_n76273504)
print v(xbgr.mr_n76273824)
print v(xbgr.mr_n76273936)
print v(xbgr.mr_n76274368)
print v(xbgr.mr_n76274688)
print v(xbgr.mr_n76274800)
print v(xbgr.mr_n76275232)
print v(xbgr.mr_n76275552)
print v(xbgr.mr_n76275664)
print v(xbgr.mr_n76275984)
print v(xbgr.mr_n76276096)
print v(xbgr.mr_n76276416)
print v(xbgr.mr_n76276528)
print v(xbgr.mr_n76276848)
print v(xbgr.mr_n76276960)
print v(xbgr.mr_n76277280)
print v(xbgr.mr_n76277392)
print v(xbgr.mr_n76277824)
print v(xbgr.mr_n76278144)
print v(xbgr.mr_n76278256)
print v(xbgr.mr_n76278688)
print v(xbgr.mr_n76279008)
print v(xbgr.mr_n76279120)
print v(xbgr.mr_n76279440)
print v(xbgr.mr_n76279552)
print v(xbgr.mr_n76279872)
print v(xbgr.mr_n76279984)
print v(xbgr.mr_n76280304)
print v(xbgr.mr_n76280416)
print v(xbgr.mr_n76280736)
print v(xbgr.mr_n76280848)
print v(xbgr.mr_n76281168)
print v(xbgr.mr_n76281280)
print v(xbgr.mr_n76281600)
print v(xbgr.mr_n76281712)
print v(xbgr.mr_n76282032)
print v(xbgr.mr_n76282144)
print v(xbgr.mr_n76282464)
print v(xbgr.mr_n76282576)
print v(xbgr.mr_n76282896)
print v(xbgr.mr_n76283008)
print v(xbgr.mr_n76283328)
print v(xbgr.mr_n76283440)
print v(xbgr.mr_n76283760)
print v(xbgr.mr_n76283872)
print v(xbgr.mr_n76284192)
print v(xbgr.mr_n76284304)
print v(xbgr.mr_n76284624)
print v(xbgr.mr_n76284736)
print v(xbgr.mr_n76285056)
print v(xbgr.mr_n76285168)
print v(xbgr.mr_n76285488)
print v(xbgr.mr_n76285600)
print v(xbgr.mr_n76285920)
print v(xbgr.mr_n76286032)
print v(xbgr.mr_n76286352)
print v(xbgr.mr_n76286464)
print v(xbgr.mr_n76286784)
print v(xbgr.mr_n76286896)
print v(xbgr.mr_n76287216)
print v(xbgr.mr_n76287328)
print v(xbgr.mr_n76287648)
print v(xbgr.mr_n76287760)
print v(xbgr.mr_n76288080)
print v(xbgr.mr_n76288192)
print v(xbgr.mr_n76288512)
print v(xbgr.mr_n76288624)
print v(xbgr.mr_n76288944)
print v(xbgr.mr_n76289056)
print v(xbgr.mr_n76289376)
print v(xbgr.mr_n76289488)
print v(xbgr.mr_n76289808)
print v(xbgr.mr_n76289920)
print v(xbgr.mr_n76290240)
print v(xbgr.mr_n76290352)
print v(xbgr.mr_n76290672)
print v(xbgr.mr_n76290784)
print v(xbgr.mr_n76291104)
print v(xbgr.mr_n76291216)
print v(xbgr.mr_n76291536)
print v(xbgr.mr_n76291648)
print v(xbgr.mr_n76291968)
print v(xbgr.mr_n76292080)
print v(xbgr.mr_n76292400)
print v(xbgr.mr_n76292512)
print v(xbgr.mr_n76292832)
print v(xbgr.mr_n76292944)
print v(xbgr.mr_n76293264)
print v(xbgr.mr_n76293376)
print v(xbgr.mr_n76293696)
print v(xbgr.mr_n76293808)
print v(xbgr.mr_n76294128)
print v(xbgr.mr_n76294240)
print v(xbgr.mr_n76294560)
print v(xbgr.mr_n76294672)
print v(xbgr.mr_n76294992)
print v(xbgr.mr_n76295104)
print v(xbgr.mr_n76295424)
print v(xbgr.mr_n76295536)
print v(xbgr.mr_n76295856)
print v(xbgr.mr_n76295968)
print v(xbgr.mr_n76296288)
print v(xbgr.mr_n76296400)
print v(xbgr.mr_n76296720)
print v(xbgr.mr_n76296832)
print v(xbgr.mr_n76297152)
print v(xbgr.mr_n76297264)
print v(xbgr.mr_n76297584)
print v(xbgr.mr_n76297696)
print v(xbgr.mr_n76298016)
print v(xbgr.mr_n76298128)
print v(xbgr.mr_n76298448)
print v(xbgr.mr_n76298560)
print v(xbgr.mr_n76298880)
print v(xbgr.mr_n76298992)
print v(xbgr.mr_n76299312)
print v(xbgr.mr_n76299424)
print v(xbgr.mr_n76299744)
print v(xbgr.mr_n76299856)
print v(xbgr.mr_n76300176)
print v(xbgr.mr_n76300288)
print v(xbgr.mr_n76300608)
print v(xbgr.mr_n76300720)
print v(xbgr.mr_n76301040)
print v(xbgr.mr_n76301152)
print v(xbgr.mr_n76301472)
print v(xbgr.mr_n76301584)
print v(xbgr.mr_n76301904)
print v(xbgr.mr_n76302016)
print v(xbgr.mr_n76302336)
print v(xbgr.mr_n76302448)
print v(xbgr.mr_n76302768)
print v(xbgr.mr_n76302880)
print v(xbgr.mr_n76303200)
print v(xbgr.mr_n76303312)
print v(xbgr.mr_n76303632)
print v(xbgr.mr_n76303744)
print v(xbgr.mr_n76304064)
print v(xbgr.mr_n76304176)
print v(xbgr.mr_n76304496)
print v(xbgr.mr_n76304608)
print v(xbgr.mr_n76304928)
print v(xbgr.mr_n76305040)
print v(xbgr.mr_n76305360)
print v(xbgr.mr_n76305472)
print v(xbgr.mr_n76305792)
print v(xbgr.mr_n76305904)
print v(xbgr.mr_n76306224)
print v(xbgr.mr_n76306336)
print v(xbgr.mr_n76306656)
print v(xbgr.mr_n76306768)
print v(xbgr.mr_n76307088)
print v(xbgr.mr_n76307200)
print v(xbgr.mr_n76307520)
print v(xbgr.mr_n76307632)
print v(xbgr.mr_n76307952)
print v(xbgr.mr_n76308064)
print v(xbgr.mr_n76308384)
print v(xbgr.mr_n76308496)
print v(xbgr.mr_n76308816)
print v(xbgr.mr_n76308928)
print v(xbgr.mr_n76309248)
print v(xbgr.mr_n76309360)
print v(xbgr.mr_n76309680)
print v(xbgr.mr_n76309792)
print v(xbgr.mr_n76310112)
print v(xbgr.mr_n76310224)
print v(xbgr.mr_n76310544)
print v(xbgr.mr_n76310656)
print v(xbgr.mr_n76310976)
print v(xbgr.mr_n76311088)
print v(xbgr.mr_n76311408)
print v(xbgr.mr_n76311520)
print v(xbgr.mr_n76311840)
print v(xbgr.mr_n76311952)
print v(xbgr.mr_n76312384)
print v(xbgr.mr_n76312704)
print v(xbgr.mr_n76312816)
print v(xbgr.mr_n76313136)
print v(xbgr.mr_n76313248)
print v(xbgr.mr_n76313568)
print v(xbgr.mr_n76313680)
print v(xbgr.mr_n76314112)
print v(xbgr.mr_n76314432)
print v(xbgr.mr_n76314544)
print v(xbgr.mr_n76314976)
print v(xbgr.mr_n76315296)
print v(xbgr.mr_n76315408)
print v(xbgr.mr_n76315728)
print v(xbgr.mr_n76315840)
print v(xbgr.mr_n76316160)
print v(xbgr.mr_n76316272)
print v(xbgr.mr_n76316592)
print v(xbgr.mr_n76316704)
print v(xbgr.mr_n76317024)
print v(xbgr.mr_n76317136)
print v(xbgr.mr_n76317456)
print v(xbgr.mr_n76317568)
print v(xbgr.mr_n76317888)
print v(xbgr.mr_n76318000)
print v(xbgr.mr_n76318320)
print v(xbgr.mr_n76318432)
print v(xbgr.mr_n76318752)
print v(xbgr.mr_n76318864)
print v(xbgr.mr_n76319184)
print v(xbgr.mr_n76319296)
print v(xbgr.mr_n76319616)
print v(xbgr.mr_n76319728)
print v(xbgr.mr_n76320048)
print v(xbgr.mr_n76320160)
print v(xbgr.mr_n76320480)
print v(xbgr.mr_n76320592)
print v(xbgr.mr_n76320912)
print v(xbgr.mr_n76321024)
print v(xbgr.mr_n76321344)
print v(xbgr.mr_n76321456)
print v(xbgr.mr_n76321776)
print v(xbgr.mr_n76321888)
print v(xbgr.mr_n76322208)
print v(xbgr.mr_n76322320)
print v(xbgr.mr_n76322640)
print v(xbgr.mr_n76322752)
print v(xbgr.mr_n76323072)
print v(xbgr.mr_n76323184)
print v(xbgr.mr_n76323504)
print v(xbgr.mr_n76323616)
print v(xbgr.mr_n76323936)
print v(xbgr.mr_n76324048)
print v(xbgr.mr_n76324368)
print v(xbgr.mr_n76324480)
print v(xbgr.mr_n76324800)
print v(xbgr.mr_n76324912)
print v(xbgr.mr_n76325232)
print v(xbgr.mr_n76325344)
print v(xbgr.mr_n76325664)
print v(xbgr.mr_n76325776)
print v(xbgr.mr_n76326096)
print v(xbgr.mr_n76326208)
print v(xbgr.mr_n76326528)
print v(xbgr.mr_n76326640)
print v(xbgr.mr_n76327072)
print v(xbgr.mr_n76327392)
print v(xbgr.mr_n76327504)
print v(xbgr.mr_n76327824)
print v(xbgr.mr_n76327936)
print v(xbgr.mr_n76328256)
print v(xbgr.mr_n76328368)
print v(xbgr.mr_n76328688)
print v(xbgr.mr_n76328800)
print v(xbgr.mr_n76329120)
print v(xbgr.mr_n76329232)
print v(xbgr.mr_n76329552)
print v(xbgr.mr_n76329664)
print v(xbgr.mr_n76329984)
print v(xbgr.mr_n76330096)
print v(xbgr.mr_n76330416)
print v(xbgr.mr_n76330528)
print v(xbgr.mr_n76330848)
print v(xbgr.mr_n76330960)
print v(xbgr.mr_n76331392)
print v(xbgr.mr_n76331712)
print v(xbgr.mr_n76331824)
print v(xbgr.mr_n76332144)
print v(xbgr.mr_n76332256)
print v(xbgr.mr_n76332576)
print v(xbgr.mr_n76332688)
print v(xbgr.mr_n76333120)
print v(xbgr.mr_n76333440)
print v(xbgr.mr_n76333552)
print v(xbgr.mr_n76333872)
print v(xbgr.mr_n76333984)
print v(xbgr.mr_n76334304)
print v(xbgr.mr_n76334416)
print v(xbgr.mr_n76334736)
print v(xbgr.mr_n76334848)
print v(xbgr.mr_n76335168)
print v(xbgr.mr_n76335280)
print v(xbgr.mr_n76335712)
print v(xbgr.mr_n76336032)
print v(xbgr.mr_n76336144)
print v(xbgr.mr_n76336464)
print v(xbgr.mr_n76336576)
print v(xbgr.mr_n76336896)
print v(xbgr.mr_n76337008)
print v(xbgr.mr_n76337328)
print v(xbgr.mr_n76337440)
print v(xbgr.mr_n76337760)
print v(xbgr.mr_n76337872)
print v(xbgr.mr_n76338192)
print v(xbgr.mr_n76338304)
print v(xbgr.mr_n76338624)
print v(xbgr.mr_n76338736)
print v(xbgr.mr_n76339056)
print v(xbgr.mr_n76339168)
print v(xbgr.mr_n76339488)
print v(xbgr.mr_n76339600)
print v(xbgr.mr_n76339920)
print v(xbgr.mr_n76340032)
print v(xbgr.mr_n76340352)
print v(xbgr.mr_n76340464)
print v(xbgr.mr_n76340784)
print v(xbgr.mr_n76340896)
print v(xbgr.mr_n76341216)
print v(xbgr.mr_n76341328)
print v(xbgr.mr_n76341648)
print v(xbgr.mr_n76341760)
print v(xbgr.mr_n76342080)
print v(xbgr.mr_n76342192)
print v(xbgr.mr_n76342512)
print v(xbgr.mr_n76342624)
print v(xbgr.mr_n76342944)
print v(xbgr.mr_n76343056)
print v(xbgr.mr_n76343376)
print v(xbgr.mr_n76343488)
print v(xbgr.mr_n76343808)
print v(xbgr.mr_n76343920)
print v(xbgr.mr_n76344240)
print v(xbgr.mr_n76344352)
print v(xbgr.mr_n76344672)
print v(xbgr.mr_n76344784)
print v(xbgr.mr_n76345104)
print v(xbgr.mr_n76345216)
print v(xbgr.mr_n76345536)
print v(xbgr.mr_n76345648)
print v(xbgr.mr_n76345968)
print v(xbgr.mr_n76346080)
print v(xbgr.mr_n76346400)
print v(xbgr.mr_n76346512)
print v(xbgr.mr_n76346832)
print v(xbgr.mr_n76346944)
print v(xbgr.mr_n76347264)
print v(xbgr.mr_n76347376)
print v(xbgr.mr_n76347696)
print v(xbgr.mr_n76347808)
print v(xbgr.mr_n76348128)
print v(xbgr.mr_n76348240)
print v(xbgr.mr_n76348560)
print v(xbgr.mr_n76348672)
print v(xbgr.mr_n76348992)
print v(xbgr.mr_n76349104)
print v(xbgr.mr_n76349424)
print v(xbgr.mr_n76349536)
print v(xbgr.mr_n76349856)
print v(xbgr.mr_n76349968)
print v(xbgr.mr_n76350288)
print v(xbgr.mr_n76350400)
print v(xbgr.mr_n76350720)
print v(xbgr.mr_n76350832)
print v(xbgr.mr_n76351152)
print v(xbgr.mr_n76351264)
print v(xbgr.mr_n76351584)
print v(xbgr.mr_n76351696)
print v(xbgr.mr_n76352016)
print v(xbgr.mr_n76352128)
print v(xbgr.mr_n76352448)
print v(xbgr.mr_n76352560)
print v(xbgr.mr_n76352880)
print v(xbgr.mr_n76352992)
print v(xbgr.mr_n76353312)
print v(xbgr.mr_n76353424)
print v(xbgr.mr_n76353744)
print v(xbgr.mr_n76353856)
print v(xbgr.mr_n76354176)
print v(xbgr.mr_n76354288)
print v(xbgr.mr_n76354608)
print v(xbgr.mr_n76354720)
print v(xbgr.mr_n76355040)
print v(xbgr.mr_n76355152)
print v(xbgr.mr_n76355472)
print v(xbgr.mr_n76355584)
print v(xbgr.mr_n76355904)
print v(xbgr.mr_n76356016)
print v(xbgr.mr_n76356336)
print v(xbgr.mr_n76356448)
print v(xbgr.mr_n76356768)
print v(xbgr.mr_n76356880)
print v(xbgr.mr_n76357200)
print v(xbgr.mr_n76357312)
print v(xbgr.mr_n76357632)
print v(xbgr.mr_n76357744)
print v(xbgr.mr_n76358064)
print v(xbgr.mr_n76358176)
print v(xbgr.mr_n76358496)
print v(xbgr.mr_n76358608)
print v(xbgr.mr_n76358928)
print v(xbgr.mr_n76359040)
print v(xbgr.mr_n76359360)
print v(xbgr.mr_n76359472)
print v(xbgr.mr_n76359792)
print v(xbgr.mr_n76359904)
print v(xbgr.mr_n76360224)
print v(xbgr.mr_n76360336)
print v(xbgr.mr_n76360656)
print v(xbgr.mr_n76360768)
print v(xbgr.mr_n76361088)
print v(xbgr.mr_n76361200)
print v(xbgr.mr_n76361520)
print v(xbgr.mr_n76361632)
print v(xbgr.mr_n76361952)
print v(xbgr.mr_n76362064)
print v(xbgr.mr_n76362384)
print v(xbgr.mr_n76362496)
print v(xbgr.mr_n76362816)
print v(xbgr.mr_n76362928)
print v(xbgr.mr_n76363248)
print v(xbgr.mr_n76363360)
print v(xbgr.mr_n76363680)
print v(xbgr.mr_n76363792)
print v(xbgr.mr_n76364112)
print v(xbgr.mr_n76364224)
print v(xbgr.mr_n76364544)
print v(xbgr.mr_n76364656)
print v(xbgr.mr_n76364976)
print v(xbgr.mr_n76365088)
print v(xbgr.mr_n76365408)
print v(xbgr.mr_n76365520)
print v(xbgr.mr_n76365952)
print v(xbgr.mr_n76366272)
print v(xbgr.mr_n76366384)
print v(xbgr.mr_n76366704)
print v(xbgr.mr_n76366816)
print v(xbgr.mr_n76367136)
print v(xbgr.mr_n76367248)
print v(xbgr.mr_n76367680)
print v(xbgr.mr_n76368000)
print v(xbgr.mr_n76368112)
print v(xbgr.mr_n76368544)
print v(xbgr.mr_n76368864)
print v(xbgr.mr_n76368976)
print v(xbgr.mr_n76369296)
print v(xbgr.mr_n76369408)
print v(xbgr.mr_n76369728)
print v(xbgr.mr_n76369840)
print v(xbgr.mr_n76370160)
print v(xbgr.mr_n76370272)
print v(xbgr.mr_n76370592)
print v(xbgr.mr_n76370704)
print v(xbgr.mr_n76371024)
print v(xbgr.mr_n76371136)
print v(xbgr.mr_n76371456)
print v(xbgr.mr_n76371568)
print v(xbgr.mr_n76371888)
print v(xbgr.mr_n76372000)
print v(xbgr.mr_n76372320)
print v(xbgr.mr_n76372432)
print v(xbgr.mr_n76372752)
print v(xbgr.mr_n76372864)
print v(xbgr.mr_n76373184)
print v(xbgr.mr_n76373296)
print v(xbgr.mr_n76373616)
print v(xbgr.mr_n76373728)
print v(xbgr.mr_n76374048)
print v(xbgr.mr_n76374160)
print v(xbgr.mr_n76374480)
print v(xbgr.mr_n76374592)
print v(xbgr.mr_n76374912)
print v(xbgr.mr_n76375024)
print v(xbgr.mr_n76375344)
print v(xbgr.mr_n76375456)
print v(xbgr.mr_n76375776)
print v(xbgr.mr_n76375888)
print v(xbgr.mr_n76376208)
print v(xbgr.mr_n76376320)
print v(xbgr.mr_n76376640)
print v(xbgr.mr_n76376752)
print v(xbgr.mr_n76377072)
print v(xbgr.mr_n76377184)
print v(xbgr.mr_n76377504)
print v(xbgr.mr_n76377616)
print v(xbgr.mr_n76377936)
print v(xbgr.mr_n76378048)
print v(xbgr.mr_n76378368)
print v(xbgr.mr_n76378480)
print v(xbgr.mr_n76378800)
print v(xbgr.mr_n76378912)
print v(xbgr.mr_n76379232)
print v(xbgr.mr_n76379344)
print v(xbgr.mr_n76379664)
print v(xbgr.mr_n76379776)
print v(xbgr.mr_n76380096)
print v(xbgr.mr_n76380208)
print v(xbgr.mr_n76380528)
print v(xbgr.mr_n76380640)
print v(xbgr.mr_n76380960)
print v(xbgr.mr_n76381072)
print v(xbgr.mr_n76381392)
print v(xbgr.mr_n76381504)
print v(xbgr.mr_n76381824)
print v(xbgr.mr_n76381936)
print v(xbgr.mr_n76382256)
print v(xbgr.mr_n76382368)
print v(xbgr.mr_n76382688)
print v(xbgr.mr_n76382800)
print v(xbgr.mr_n76383120)
print v(xbgr.mr_n76383232)
print v(xbgr.mr_n76383552)
print v(xbgr.mr_n76383664)
print v(xbgr.mr_n76383984)
print v(xbgr.mr_n76384096)
print v(xbgr.mr_n76384416)
print v(xbgr.mr_n76384528)
print v(xbgr.mr_n76384848)
print v(xbgr.mr_n76384960)
print v(xbgr.mr_n76385280)
print v(xbgr.mr_n76385392)
print v(xbgr.mr_n76385712)
print v(xbgr.mr_n76385824)
print v(xbgr.mr_n76386144)
print v(xbgr.mr_n76386256)
print v(xbgr.mr_n76386576)
print v(xbgr.mr_n76386688)
print v(xbgr.mr_n76387008)
print v(xbgr.mr_n76387120)
print v(xbgr.mr_n76387440)
print v(xbgr.mr_n76387552)
print v(xbgr.mr_n76387872)
print v(xbgr.mr_n76387984)
print v(xbgr.mr_n76388304)
print v(xbgr.mr_n76388416)
print v(xbgr.mr_n76388736)
print v(xbgr.mr_n76388848)
print v(xbgr.mr_n76389168)
print v(xbgr.mr_n76389280)
print v(xbgr.mr_n76389600)
print v(xbgr.mr_n76389712)
print v(xbgr.mr_n76390032)
print v(xbgr.mr_n76390144)
print v(xbgr.mr_n76390464)
print v(xbgr.mr_n76390576)
print v(xbgr.mr_n76390896)
print v(xbgr.mr_n76391008)
print v(xbgr.mr_n76391328)
print v(xbgr.mr_n76391440)
print v(xbgr.mr_n76391760)
print v(xbgr.mr_n76391872)
print v(xbgr.mr_n76392192)
print v(xbgr.mr_n76392304)
print v(xbgr.mr_n76392624)
print v(xbgr.mr_n76392736)
print v(xbgr.mr_n76393056)
print v(xbgr.mr_n76393168)
print v(xbgr.mr_n76393488)
print v(xbgr.mr_n76393600)
print v(xbgr.mr_n76393920)
print v(xbgr.mr_n76394032)
print v(xbgr.mr_n76394352)
print v(xbgr.mr_n76394464)
print v(xbgr.mr_n76394784)
print v(xbgr.mr_n76394896)
print v(xbgr.mr_n76395216)
print v(xbgr.mr_n76395328)
print v(xbgr.mr_n76395648)
print v(xbgr.mr_n76395760)
print v(xbgr.mr_n76396080)
print v(xbgr.mr_n76396192)
print v(xbgr.mr_n76396512)
print v(xbgr.mr_n76396624)
print v(xbgr.mr_n76396944)
print v(xbgr.mr_n76397056)
print v(xbgr.mr_n76397376)
print v(xbgr.mr_n76397488)
print v(xbgr.mr_n76397808)
print v(xbgr.mr_n76397920)
print v(xbgr.mr_n76398240)
print v(xbgr.mr_n76398352)
print v(xbgr.mr_n76398672)
print v(xbgr.mr_n76398784)
print v(xbgr.mr_n76399104)
print v(xbgr.mr_n76399216)
print v(xbgr.mr_n76399536)
print v(xbgr.mr_n76399648)
print v(xbgr.mr_n76399968)
print v(xbgr.mr_n76400080)
print v(xbgr.mr_n76400400)
print v(xbgr.mr_n76400512)
print v(xbgr.mr_n76400832)
print v(xbgr.mr_n76400944)
print v(xbgr.mr_n76401264)
print v(xbgr.mr_n76401376)
print v(xbgr.mr_n76401696)
print v(xbgr.mr_n76401808)
print v(xbgr.mr_n76402128)
print v(xbgr.mr_n76402240)
print v(xbgr.mr_n76402560)
print v(xbgr.mr_n76402672)
print v(xbgr.mr_n76402992)
print v(xbgr.mr_n76403104)
print v(xbgr.mr_n76403424)
print v(xbgr.mr_n76403536)
print v(xbgr.mr_n76403856)
print v(xbgr.mr_n76403968)
print v(xbgr.mr_n76404288)
print v(xbgr.mr_n76404400)
print v(xbgr.mr_n76404720)
print v(xbgr.mr_n76404832)
print v(xbgr.mr_n76405152)
print v(xbgr.mr_n76405264)
print v(xbgr.mr_n76405584)
print v(xbgr.mr_n76405696)
print v(xbgr.mr_n76406016)
print v(xbgr.mr_n76406128)
print v(xbgr.mr_n76406448)
print v(xbgr.mr_n76406560)
print v(xbgr.mr_n76406880)
print v(xbgr.mr_n76406992)
print v(xbgr.mr_n76407312)
print v(xbgr.mr_n76407424)
print v(xbgr.mr_n76407744)
print v(xbgr.mr_n76407856)
print v(xbgr.mr_n76408176)
print v(xbgr.mr_n76408288)
print v(xbgr.mr_n76408608)
print v(xbgr.mr_n76408720)
print v(xbgr.mr_n76409040)
print v(xbgr.mr_n76409152)
print v(xbgr.mr_n76409472)
print v(xbgr.mr_n76409584)
print v(xbgr.mr_n76409904)
print v(xbgr.mr_n76410016)
print v(xbgr.mr_n76410336)
print v(xbgr.mr_n76410448)
print v(xbgr.mr_n76410768)
print v(xbgr.mr_n76410880)
print v(xbgr.mr_n76411200)
print v(xbgr.mr_n76411312)
print v(xbgr.mr_n76411632)
print v(xbgr.mr_n76411744)
print v(xbgr.mr_n76412064)
print v(xbgr.mr_n76412176)
print v(xbgr.mr_n76412496)
print v(xbgr.mr_n76412608)
print v(xbgr.mr_n76412928)
print v(xbgr.mr_n76413040)
print v(xbgr.mr_n76413360)
print v(xbgr.mr_n76413472)
print v(xbgr.mr_n76413792)
print v(xbgr.mr_n76413904)
print v(xbgr.mr_n76414224)
print v(xbgr.mr_n76414336)
print v(xbgr.mr_n76414656)
print v(xbgr.mr_n76414768)
print v(xbgr.mr_n76415088)
print v(xbgr.mr_n76415200)
print v(xbgr.mr_n76415520)
print v(xbgr.mr_n76415632)
print v(xbgr.mr_n76415952)
print v(xbgr.mr_n76416064)
print v(xbgr.mr_n76416384)
print v(xbgr.mr_n76416496)
print v(xbgr.mr_n76416816)
print v(xbgr.mr_n76416928)
print v(xbgr.mr_n76417248)
print v(xbgr.mr_n76417360)
print v(xbgr.mr_n76417680)
print v(xbgr.mr_n76417792)
print v(xbgr.mr_n76418112)
print v(xbgr.mr_n76418224)
print v(xbgr.mr_n76418544)
print v(xbgr.mr_n76418656)
print v(xbgr.mr_n76418976)
print v(xbgr.mr_n76419088)
print v(xbgr.mr_n76419408)
print v(xbgr.mr_n76419520)
print v(xbgr.mr_n76419840)
print v(xbgr.mr_n76419952)
print v(xbgr.mr_n76420272)
print v(xbgr.mr_n76420384)
print v(xbgr.mr_n76420704)
print v(xbgr.mr_n76420816)
print v(xbgr.mr_n76421136)
print v(xbgr.mr_n76421248)
print v(xbgr.mr_n76421568)
print v(xbgr.mr_n76421680)
print v(xbgr.mr_n76422000)
print v(xbgr.mr_n76422112)
print v(xbgr.mr_n76422432)
print v(xbgr.mr_n76422544)
print v(xbgr.mr_n76422864)
print v(xbgr.mr_n76422976)
print v(xbgr.mr_n76423296)
print v(xbgr.mr_n76423408)
print v(xbgr.mr_n76423728)
print v(xbgr.mr_n76423840)
print v(xbgr.mr_n76424160)
print v(xbgr.mr_n76424272)
print v(xbgr.mr_n76424592)
print v(xbgr.mr_n76424704)
print v(xbgr.mr_n76425024)
print v(xbgr.mr_n76425136)
print v(xbgr.mr_n76425456)
print v(xbgr.mr_n76425568)
print v(xbgr.mr_n76425888)
print v(xbgr.mr_n76426000)
print v(xbgr.mr_n76426320)
print v(xbgr.mr_n76426432)
print v(xbgr.mr_n76426752)
print v(xbgr.mr_n76426864)
print v(xbgr.mr_n76427184)
print v(xbgr.mr_n76427296)
print v(xbgr.mr_n76427616)
print v(xbgr.mr_n76427728)
print v(xbgr.mr_n76428048)
print v(xbgr.mr_n76428160)
print v(xbgr.mr_n76428480)
print v(xbgr.mr_n76428592)
print v(xbgr.mr_n76428912)
print v(xbgr.mr_n76429024)
print v(xbgr.mr_n76429344)
print v(xbgr.mr_n76429456)
print v(xbgr.mr_n76429776)
print v(xbgr.mr_n76429888)
print v(xbgr.mr_n76430208)
print v(xbgr.mr_n76430320)
print v(xbgr.mr_n76430640)
print v(xbgr.mr_n76430752)
print v(xbgr.mr_n76431072)
print v(xbgr.mr_n76431184)
print v(xbgr.mr_n76431504)
print v(xbgr.mr_n76431616)
print v(xbgr.mr_n76431936)
print v(xbgr.mr_n76432048)
print v(xbgr.mr_n76432368)
print v(xbgr.mr_n76432480)
print v(xbgr.mr_n76432800)
print v(xbgr.mr_n76432912)
print v(xbgr.mr_n76433232)
print v(xbgr.mr_n76433344)
print v(xbgr.mr_n76433664)
print v(xbgr.mr_n76433776)
print v(xbgr.mr_n76434096)
print v(xbgr.mr_n76434208)
print v(xbgr.mr_n76434528)
print v(xbgr.mr_n76434640)
print v(xbgr.mr_n76434960)
print v(xbgr.mr_n76435072)
print v(xbgr.mr_n76435392)
print v(xbgr.mr_n76435504)
print v(xbgr.mr_n76435824)
print v(xbgr.mr_n76435936)
print v(xbgr.mr_n76436256)
print v(xbgr.mr_n76436368)
print v(xbgr.mr_n76436688)
print v(xbgr.mr_n76436800)
print v(xbgr.mr_n76437120)
print v(xbgr.mr_n76437232)
print v(xbgr.mr_n76437552)
print v(xbgr.mr_n76437664)
print v(xbgr.mr_n76437984)
print v(xbgr.mr_n76438096)
print v(xbgr.mr_n76438416)
print v(xbgr.mr_n76438528)
print v(xbgr.mr_n76438848)
print v(xbgr.mr_n76438960)
print v(xbgr.mr_n76439280)
print v(xbgr.mr_n76439392)
print v(xbgr.mr_n76439712)
print v(xbgr.mr_n76439824)
print v(xbgr.mr_n76440144)
print v(xbgr.mr_n76440256)
print v(xbgr.mr_n76440576)
print v(xbgr.mr_n76440688)
print v(xbgr.mr_n76441008)
print v(xbgr.mr_n76441120)
print v(xbgr.mr_n76441440)
print v(xbgr.mr_n76441552)
print v(xbgr.mr_n76441872)
print v(xbgr.mr_n76441984)
print v(xbgr.mr_n76442304)
print v(xbgr.mr_n76442416)
print v(xbgr.mr_n76442736)
print v(xbgr.mr_n76442848)
print v(xbgr.mr_n76443168)
print v(xbgr.mr_n76443280)
print v(xbgr.mr_n76443600)
print v(xbgr.mr_n76443712)
print v(xbgr.mr_n76444032)
print v(xbgr.mr_n76444144)
print v(xbgr.mr_n76444464)
print v(xbgr.mr_n76444576)
print v(xbgr.mr_n76444896)
print v(xbgr.mr_n76445008)
print v(xbgr.mr_n76445328)
print v(xbgr.mr_n76445440)
print v(xbgr.mr_n76445760)
print v(xbgr.mr_n76445872)
print v(xbgr.mr_n76446192)
print v(xbgr.mr_n76446304)
print v(xbgr.mr_n76446624)
print v(xbgr.mr_n76446736)
print v(xbgr.mr_n76447056)
print v(xbgr.mr_n76447168)
print v(xbgr.mr_n76447488)
print v(xbgr.mr_n76447600)
print v(xbgr.mr_n76447920)
print v(xbgr.mr_n76448032)
print v(xbgr.mr_n76448352)
print v(xbgr.mr_n76448464)
print v(xbgr.mr_n76448784)
print v(xbgr.mr_n76448896)
print v(xbgr.mr_n76449216)
print v(xbgr.mr_n76449328)
print v(xbgr.mr_n76449648)
print v(xbgr.mr_n76449760)
print v(xbgr.mr_n76450080)
print v(xbgr.mr_n76450192)
print v(xbgr.mr_n76450512)
print v(xbgr.mr_n76450624)
print v(xbgr.mr_n76450944)
print v(xbgr.mr_n76451056)
print v(xbgr.mr_n76451376)
print v(xbgr.mr_n76451488)
print v(xbgr.mr_n76451808)
print v(xbgr.mr_n76451920)
print v(xbgr.mr_n76452240)
print v(xbgr.mr_n76452352)
print v(xbgr.mr_n76452672)
print v(xbgr.mr_n76452784)
print v(xbgr.mr_n76453104)
print v(xbgr.mr_n76453216)
print v(xbgr.mr_n76453536)
print v(xbgr.mr_n76453648)
print v(xbgr.mr_n76453968)
print v(xbgr.mr_n76454080)
print v(xbgr.mr_n76454400)
print v(xbgr.mr_n76454512)
print v(xbgr.mr_n76454832)
print v(xbgr.mr_n76454944)
print v(xbgr.mr_n76455264)
print v(xbgr.mr_n76455376)
print v(xbgr.mr_n76455696)
print v(xbgr.mr_n76455808)
print v(xbgr.mr_n76456128)
print v(xbgr.mr_n76456240)
print v(xbgr.mr_n76456560)
print v(xbgr.mr_n76456672)
print v(xbgr.mr_n76456992)
print v(xbgr.mr_n76457104)
print v(xbgr.mr_n76457424)
print v(xbgr.mr_n76457536)
print v(xbgr.mr_n76457856)
print v(xbgr.mr_n76457968)
print v(xbgr.mr_n76458288)
print v(xbgr.mr_n76458400)
print v(xbgr.mr_n76458720)
print v(xbgr.mr_n76458832)
print v(xbgr.mr_n76524704)
print v(xbgr.mr_n76524816)
print v(xbgr.mr_n76525136)
print v(xbgr.mr_n76525248)
print v(xbgr.mr_n76525568)
print v(xbgr.mr_n76525680)
print v(xbgr.mr_n76526112)
print v(xbgr.mr_n76526432)
print v(xbgr.mr_n76526544)
print v(xbgr.mr_n76526864)
print v(xbgr.mr_n76526976)
print v(xbgr.mr_n76527408)
print v(xbgr.mr_n76527840)
print v(xbgr.mr_n76528160)
print v(xbgr.mr_n76528272)
print v(xbgr.mr_n76528592)
print v(xbgr.mr_n76528704)
print v(xbgr.mr_n76529024)
print v(xbgr.mr_n76529136)
print v(xbgr.mr_n76529456)
print v(xbgr.mr_n76529568)
print v(xbgr.mr_n76529888)
print v(xbgr.mr_n76530000)
print v(xbgr.mr_n76530320)
print v(xbgr.mr_n76530432)
print v(xbgr.mr_n76530752)
print v(xbgr.mr_n76530864)
print v(xbgr.mr_n76531184)
print v(xbgr.mr_n76531296)
print v(xbgr.mr_n76531616)
print v(xbgr.mr_n76531728)
print v(xbgr.mr_n76532048)
print v(xbgr.mr_n76532160)
print v(xbgr.mr_n76532480)
print v(xbgr.mr_n76532592)
print v(xbgr.mr_n76532912)
print v(xbgr.mr_n76533024)
print v(xbgr.mr_n76533456)
print v(xbgr.mr_n76533776)
print v(xbgr.mr_n76533888)
print v(xbgr.mr_n76534208)
print v(xbgr.mr_n76534320)
print v(xbgr.mr_n76534640)
print v(xbgr.mr_n76534752)
print v(xbgr.mr_n76535072)
print v(xbgr.mr_n76535184)
print v(xbgr.mr_n76535504)
print v(xbgr.mr_n76535616)
print v(xbgr.mr_n76535936)
print v(xbgr.mr_n76536048)
print v(xbgr.mr_n76536368)
print v(xbgr.mr_n76536480)
print v(xbgr.mr_n76536800)
print v(xbgr.mr_n76536912)
print v(xbgr.mr_n76537232)
print v(xbgr.mr_n76537344)
print v(xbgr.mr_n76537664)
print v(xbgr.mr_n76537776)
print v(xbgr.mr_n76538208)
print v(xbgr.mr_n76538640)
print v(xbgr.mr_n76538960)
print v(xbgr.mr_n76539072)
print v(xbgr.mr_n76539392)
print v(xbgr.mr_n76539504)
print v(xbgr.mr_n76539824)
print v(xbgr.mr_n76539936)
print v(xbgr.mr_n76540256)
print v(xbgr.mr_n76540368)
print v(xbgr.mr_n76540688)
print v(xbgr.mr_n76540800)
print v(xbgr.mr_n76541120)
print v(xbgr.mr_n76541232)
print v(xbgr.mr_n76541552)
print v(xbgr.mr_n76541664)
print v(xbgr.mr_n76541984)
print v(xbgr.mr_n76542096)
print v(xbgr.mr_n76542416)
print v(xbgr.mr_n76542528)
print v(xbgr.mr_n76542848)
print v(xbgr.mr_n76542960)
print v(xbgr.mr_n76543280)
print v(xbgr.mr_n76543392)
print v(xbgr.mr_n76543712)
print v(xbgr.mr_n76543824)
print v(xbgr.mr_n76544144)
print v(xbgr.mr_n76544256)
print v(xbgr.mr_n76544576)
print v(xbgr.mr_n76544688)
print v(xbgr.mr_n76545008)
print v(xbgr.mr_n76545120)
print v(xbgr.mr_n76545440)
print v(xbgr.mr_n76545552)
print v(xbgr.mr_n76545872)
print v(xbgr.mr_n76545984)
print v(xbgr.mr_n76546304)
print v(xbgr.mr_n76546416)
print v(xbgr.mr_n76546736)
print v(xbgr.mr_n76546848)
print v(xbgr.mr_n76547168)
print v(xbgr.mr_n76547280)
print v(xbgr.mr_n76547600)
print v(xbgr.mr_n76547712)
print v(xbgr.mr_n76548032)
print v(xbgr.mr_n76548144)
print v(xbgr.mr_n76548464)
print v(xbgr.mr_n76548576)
print v(xbgr.mr_n76548896)
print v(xbgr.mr_n76549008)
print v(xbgr.mr_n76549328)
print v(xbgr.mr_n76549440)
print v(xbgr.mr_n76549760)
print v(xbgr.mr_n76549872)
print v(xbgr.mr_n76550192)
print v(xbgr.mr_n76550304)
print v(xbgr.mr_n76550624)
print v(xbgr.mr_n76550736)
print v(xbgr.mr_n76551056)
print v(xbgr.mr_n76551168)
print v(xbgr.mr_n76551488)
print v(xbgr.mr_n76551600)
print v(xbgr.mr_n76551920)
print v(xbgr.mr_n76552032)
print v(xbgr.mr_n76552352)
print v(xbgr.mr_n76552464)
print v(xbgr.mr_n76552784)
print v(xbgr.mr_n76552896)
print v(xbgr.mr_n76553216)
print v(xbgr.mr_n76553328)
print v(xbgr.mr_n76553648)
print v(xbgr.mr_n76553760)
print v(xbgr.mr_n76554080)
print v(xbgr.mr_n76554192)
print v(xbgr.mr_n76554512)
print v(xbgr.mr_n76554624)
print v(xbgr.mr_n76554944)
print v(xbgr.mr_n76555056)
print v(xbgr.mr_n76555376)
print v(xbgr.mr_n76555488)
print v(xbgr.mr_n76555808)
print v(xbgr.mr_n76555920)
print v(xbgr.mr_n76556240)
print v(xbgr.mr_n76556352)
print v(xbgr.mr_n76556672)
print v(xbgr.mr_n76556784)
print v(xbgr.mr_n76557104)
print v(xbgr.mr_n76557216)
print v(xbgr.mr_n76557536)
print v(xbgr.mr_n76557648)
print v(xbgr.mr_n76557968)
print v(xbgr.mr_n76558080)
print v(xbgr.mr_n76558400)
print v(xbgr.mr_n76558512)
print v(xbgr.mr_n76558832)
print v(xbgr.mr_n76558944)
print v(xbgr.mr_n76559264)
print v(xbgr.mr_n76559376)
print v(xbgr.mr_n76559696)
print v(xbgr.mr_n76559808)
print v(xbgr.mr_n76560128)
print v(xbgr.mr_n76560240)
print v(xbgr.mr_n76560560)
print v(xbgr.mr_n76560672)
print v(xbgr.mr_n76560992)
print v(xbgr.mr_n76561104)
print v(xbgr.mr_n76561424)
print v(xbgr.mr_n76561536)
print v(xbgr.mr_n76561856)
print v(xbgr.mr_n76561968)
print v(xbgr.mr_n76562288)
print v(xbgr.mr_n76562400)
print v(xbgr.mr_n76562720)
print v(xbgr.mr_n76562832)
print v(xbgr.mr_n76563152)
print v(xbgr.mr_n76563264)
print v(xbgr.mr_n76563584)
print v(xbgr.mr_n76563696)
print v(xbgr.mr_n76564016)
print v(xbgr.mr_n76564128)
print v(xbgr.mr_n76564448)
print v(xbgr.mr_n76564560)
print v(xbgr.mr_n76564880)
print v(xbgr.mr_n76564992)
print v(xbgr.mr_n76565312)
print v(xbgr.mr_n76565424)
print v(xbgr.mr_n76565744)
print v(xbgr.mr_n76565856)
print v(xbgr.mr_n76566176)
print v(xbgr.mr_n76566288)
print v(xbgr.mr_n76566608)
print v(xbgr.mr_n76566720)
print v(xbgr.mr_n76567040)
print v(xbgr.mr_n76567152)
print v(xbgr.mr_n76567472)
print v(xbgr.mr_n76567584)
print v(xbgr.mr_n76567904)
print v(xbgr.mr_n76568016)
print v(xbgr.mr_n76568336)
print v(xbgr.mr_n76568448)
print v(xbgr.mr_n76568768)
print v(xbgr.mr_n76568880)
print v(xbgr.mr_n76569200)
print v(xbgr.mr_n76569312)
print v(xbgr.mr_n76569632)
print v(xbgr.mr_n76569744)
print v(xbgr.mr_n76570064)
print v(xbgr.mr_n76570176)
print v(xbgr.mr_n76570496)
print v(xbgr.mr_n76570608)
print v(xbgr.mr_n76570928)
print v(xbgr.mr_n76571040)
print v(xbgr.mr_n76571360)
print v(xbgr.mr_n76571472)
print v(xbgr.mr_n76571792)
print v(xbgr.mr_n76571904)
print v(xbgr.mr_n76572224)
print v(xbgr.mr_n76572336)
print v(xbgr.mr_n76572656)
print v(xbgr.mr_n76572768)
print v(xbgr.mr_n76573088)
print v(xbgr.mr_n76573200)
print v(xbgr.mr_n76573520)
print v(xbgr.mr_n76573632)
print v(xbgr.mr_n76573952)
print v(xbgr.mr_n76574064)
print v(xbgr.mr_n76574384)
print v(xbgr.mr_n76574496)
print v(xbgr.mr_n76574816)
print v(xbgr.mr_n76574928)
print v(xbgr.mr_n76575248)
print v(xbgr.mr_n76575360)
print v(xbgr.mr_n76575680)
print v(xbgr.mr_n76575792)
print v(xbgr.mr_n76576112)
print v(xbgr.mr_n76576224)
print v(xbgr.mr_n76576544)
print v(xbgr.mr_n76576656)
print v(xbgr.mr_n76576976)
print v(xbgr.mr_n76577088)
print v(xbgr.mr_n76577408)
print v(xbgr.mr_n76577520)
print v(xbgr.mr_n76577840)
print v(xbgr.mr_n76577952)
print v(xbgr.mr_n76578272)
print v(xbgr.mr_n76578384)
print v(xbgr.mr_n76578704)
print v(xbgr.mr_n76578816)
print v(xbgr.mr_n76579136)
print v(xbgr.mr_n76579248)
print v(xbgr.mr_n76579568)
print v(xbgr.mr_n76579680)
print v(xbgr.mr_n76580000)
print v(xbgr.mr_n76580112)
print v(xbgr.mr_n76580432)
print v(xbgr.mr_n76580544)
print v(xbgr.mr_n76580864)
print v(xbgr.mr_n76580976)
print v(xbgr.mr_n76581296)
print v(xbgr.mr_n76581408)
print v(xbgr.mr_n76581728)
print v(xbgr.mr_n76581840)
print v(xbgr.mr_n76582160)
print v(xbgr.mr_n76582272)
print v(xbgr.mr_n76582592)
print v(xbgr.mr_n76582704)
print v(xbgr.mr_n76583024)
print v(xbgr.mr_n76583136)
print v(xbgr.mr_n76583456)
print v(xbgr.mr_n76583568)
print v(xbgr.mr_n76583888)
print v(xbgr.mr_n76584000)
print v(xbgr.mr_n76584320)
print v(xbgr.mr_n76584432)
print v(xbgr.mr_n76584752)
print v(xbgr.mr_n76584864)
print v(xbgr.mr_n76585184)
print v(xbgr.mr_n76585296)
print v(xbgr.mr_n76585616)
print v(xbgr.mr_n76585728)
print v(xbgr.mr_n76586048)
print v(xbgr.mr_n76586160)
print v(xbgr.mr_n76586480)
print v(xbgr.mr_n76586592)
print v(xbgr.mr_n76586912)
print v(xbgr.mr_n76587024)
print v(xbgr.mr_n76587344)
print v(xbgr.mr_n76587456)
print v(xbgr.mr_n76587776)
print v(xbgr.mr_n76587888)
print v(xbgr.mr_n76588208)
print v(xbgr.mr_n76588320)
print v(xbgr.mr_n76588640)
print v(xbgr.mr_n76588752)
print v(xbgr.mr_n76589072)
print v(xbgr.mr_n76589184)
print v(xbgr.mr_n76589504)
print v(xbgr.mr_n76589616)
print v(xbgr.mr_n76589936)
print v(xbgr.mr_n76590048)
print v(xbgr.mr_n76590368)
print v(xbgr.mr_n76590480)
print v(xbgr.mr_n76590800)
print v(xbgr.mr_n76590912)
print v(xbgr.mr_n76591232)
print v(xbgr.mr_n76591344)
print v(xbgr.mr_n76591664)
print v(xbgr.mr_n76591776)
print v(xbgr.mr_n76592096)
print v(xbgr.mr_n76592208)
print v(xbgr.mr_n76592528)
print v(xbgr.mr_n76592640)
print v(xbgr.mr_n76592960)
print v(xbgr.mr_n76593072)
print v(xbgr.mr_n76593392)
print v(xbgr.mr_n76593504)
print v(xbgr.mr_n76593824)
print v(xbgr.mr_n76593936)
print v(xbgr.mr_n76594256)
print v(xbgr.mr_n76594368)
print v(xbgr.mr_n76594688)
print v(xbgr.mr_n76594800)
print v(xbgr.mr_n76595120)
print v(xbgr.mr_n76595232)
print v(xbgr.mr_n76595552)
print v(xbgr.mr_n76595664)
print v(xbgr.mr_n76595984)
print v(xbgr.mr_n76596096)
print v(xbgr.mr_n76596416)
print v(xbgr.mr_n76596528)
print v(xbgr.mr_n76596848)
print v(xbgr.mr_n76596960)
print v(xbgr.mr_n76597280)
print v(xbgr.mr_n76597392)
print v(xbgr.mr_n76597712)
print v(xbgr.mr_n76597824)
print v(xbgr.mr_n76598144)
print v(xbgr.mr_n76598256)
print v(xbgr.mr_n76598576)
print v(xbgr.mr_n76598688)
print v(xbgr.mr_n76599008)
print v(xbgr.mr_n76599120)
print v(xbgr.mr_n76599440)
print v(xbgr.mr_n76599552)
print v(xbgr.mr_n76599872)
print v(xbgr.mr_n76599984)
print v(xbgr.mr_n76600304)
print v(xbgr.mr_n76600416)
print v(xbgr.mr_n76600736)
print v(xbgr.mr_n76600848)
print v(xbgr.mr_n76601168)
print v(xbgr.mr_n76601280)
print v(xbgr.mr_n76601600)
print v(xbgr.mr_n76601712)
print v(xbgr.mr_n76602032)
print v(xbgr.mr_n76602144)
print v(xbgr.mr_n76602464)
print v(xbgr.mr_n76602576)
print v(xbgr.mr_n76602896)
print v(xbgr.mr_n76603008)
print v(xbgr.mr_n76603328)
print v(xbgr.mr_n76603440)
print v(xbgr.mr_n76603760)
print v(xbgr.mr_n76603872)
print v(xbgr.mr_n76604192)
print v(xbgr.mr_n76604304)
print v(xbgr.mr_n76604624)
print v(xbgr.mr_n76604736)
print v(xbgr.mr_n76605056)
print v(xbgr.mr_n76605168)
print v(xbgr.mr_n76605488)
print v(xbgr.mr_n76605600)
print v(xbgr.mr_n76605920)
print v(xbgr.mr_n76606032)
print v(xbgr.mr_n76606352)
print v(xbgr.mr_n76606464)
print v(xbgr.mr_n76606896)
print v(xbgr.mr_n76607216)
print v(xbgr.mr_n76607328)
print v(xbgr.mr_n76607648)
print v(xbgr.mr_n76607760)
print v(xbgr.mr_n76608080)
print v(xbgr.mr_n76608192)
print v(xbgr.mr_n76608512)
print v(xbgr.mr_n76608624)
print v(xbgr.mr_n76608944)
print v(xbgr.mr_n76609808)
print v(xbgr.mr_n76609920)
print v(xbgr.mr_n76610240)
print v(xbgr.mr_n76610352)
print v(xbgr.mr_n76610672)
print v(xbgr.mr_n76610784)
print v(xbgr.mr_n76611104)
print v(xbgr.mr_n76611216)
print v(xbgr.mr_n76611536)
print v(xbgr.mr_n76611648)
print v(xbgr.mr_n76612080)
print v(xbgr.mr_n76612400)
print v(xbgr.mr_n76612512)
print v(xbgr.mr_n76612832)
print v(xbgr.mr_n76612944)
print v(xbgr.mr_n76613264)
print v(xbgr.mr_n76613376)
print v(xbgr.mr_n76613696)
print v(xbgr.mr_n76613808)
print v(xbgr.mr_n76614128)
print v(xbgr.mr_n76614240)
print v(xbgr.mr_n76614672)
print v(xbgr.mr_n76614992)
print v(xbgr.mr_n76615856)
print v(xbgr.mr_n76615968)
print v(xbgr.mr_n76616400)
print v(xbgr.mr_n76616720)
print v(xbgr.mr_n76617584)
print v(xbgr.mr_n76617696)
print v(xbgr.mr_n76618128)
print v(xbgr.mr_n76618448)
print v(xbgr.mr_n76618560)
print v(xbgr.mr_n76618880)
print v(xbgr.mr_n76618992)
print v(xbgr.mr_n76619312)
print v(xbgr.mr_n76619424)
print v(xbgr.mr_n76619744)
print v(xbgr.mr_n76619856)
print v(xbgr.mr_n76620176)
print v(xbgr.mr_n76620288)
print v(xbgr.mr_n76620608)
print v(xbgr.mr_n76620720)
print v(xbgr.mr_n76621040)
print v(xbgr.mr_n76621904)
print v(xbgr.mr_n76622016)
print v(xbgr.mr_n76622336)
print v(xbgr.mr_n76622448)
print v(xbgr.mr_n76622768)
print v(xbgr.mr_n76623632)
print v(xbgr.mr_n76623744)
print v(xbgr.mr_n76624064)
print v(xbgr.mr_n76624176)
print v(xbgr.mr_n76624496)
print v(xbgr.mr_n76624608)
print v(xbgr.mr_n76624928)
print v(xbgr.mr_n76625040)
print v(xbgr.mr_n76625360)
print v(xbgr.mr_n76625472)
print v(xbgr.mr_n76625792)
print v(xbgr.mr_n76625904)
print v(xbgr.mr_n76626224)
print v(xbgr.mr_n76626336)
print v(xbgr.mr_n76626656)
print v(xbgr.mr_n76626768)
print v(xbgr.mr_n76627088)
print v(xbgr.mr_n76627200)
print v(xbgr.mr_n76627520)
print v(xbgr.mr_n76627632)
print v(xbgr.mr_n76627952)
print v(xbgr.mr_n76628064)
print v(xbgr.mr_n76628384)
print v(xbgr.mr_n76628496)
print v(xbgr.mr_n76628816)
print v(xbgr.mr_n76628928)
print v(xbgr.mr_n76629248)
print v(xbgr.mr_n76629360)
print v(xbgr.mr_n76629680)
print v(xbgr.mr_n76629792)
print v(xbgr.mr_n76630112)
print v(xbgr.mr_n76630224)
print v(xbgr.mr_n76630544)
print v(xbgr.mr_n76630656)
print v(xbgr.mr_n76630976)
print v(xbgr.mr_n76631088)
print v(xbgr.mr_n76631408)
print v(xbgr.mr_n76631520)
print v(xbgr.mr_n76631840)
print v(xbgr.mr_n76631952)
print v(xbgr.mr_n76632272)
print v(xbgr.mr_n76632384)
print v(xbgr.mr_n76632704)
print v(xbgr.mr_n76632816)
print v(xbgr.mr_n76633136)
print v(xbgr.mr_n76633248)
print v(xbgr.mr_n76633568)
print v(xbgr.mr_n76633680)
print v(xbgr.mr_n76634000)
print v(xbgr.mr_n76634112)
print v(xbgr.mr_n76634432)
print v(xbgr.mr_n76634544)
print v(xbgr.mr_n76634976)
print v(xbgr.mr_n76635408)
print v(xbgr.mr_n76635840)
print v(xbgr.mr_n76636272)
print v(xbgr.mr_n76636704)
print v(xbgr.mr_n76637136)
print v(xbgr.mr_n76637568)
print v(xbgr.mr_n76638000)
print v(xbgr.mr_n76638432)
print v(xbgr.mr_n76638864)
print v(xbgr.mr_n76639296)
print v(xbgr.mr_n76639728)
print v(xbgr.mr_n76640160)
print v(xbgr.mr_n76640592)
print v(xbgr.mr_n76641024)
print v(xbgr.mr_n76641456)
print v(xbgr.mr_n76641888)
print v(xbgr.mr_n76642320)
print v(xbgr.mr_n76642752)
print v(xbgr.mr_n76643184)
print v(xbgr.mr_n76643616)
print v(xbgr.mr_n76644048)
print v(xbgr.mr_n76644368)
print v(xbgr.mr_n76644480)
print v(xbgr.mr_n76644912)
print v(xbgr.mr_n76645344)
print v(xbgr.mr_n76645776)
print v(xbgr.mr_n76646208)
print v(xbgr.mr_n76646640)
print v(xbgr.mr_n76647072)
print v(xbgr.mr_n76647504)
print v(xbgr.mr_n76647936)
print v(xbgr.mr_n76648368)
print v(xbgr.mr_n76648800)
print v(xbgr.mr_n76649232)
print v(xbgr.mr_n76649664)
print v(xbgr.mr_n76650096)
print v(xbgr.mr_n76650528)
print v(xbgr.mr_n76650960)
print v(xbgr.mr_n76651392)
print v(xbgr.mr_n76651824)
print v(xbgr.mr_n76652256)
print v(xbgr.mr_n76652688)
print v(xbgr.mr_n76653120)
print v(xbgr.mr_n76653552)
print v(xbgr.mr_n76653984)
print v(xbgr.mr_n76654416)
print v(xbgr.mr_n76654848)
print v(xbgr.mr_n76655280)
print v(xbgr.mr_n76655712)
print v(xbgr.mr_n76656144)
print v(xbgr.mr_n76656576)
print v(xbgr.mr_n76657008)
print v(xbgr.mr_n76657440)
print v(xbgr.mr_n76657872)
print v(xbgr.mr_n76658304)
print v(xbgr.mr_n76658736)
print v(xbgr.mr_n76659168)
print v(xbgr.mr_n76659600)
print v(xbgr.mr_n76660032)
print v(xbgr.mr_n76660464)
print v(xbgr.mr_n76660896)
print v(xbgr.mr_n76661328)
print v(xbgr.mr_n76661760)
print v(xbgr.mr_n76662192)
print v(xbgr.mr_n76662624)
print v(xbgr.mr_n76663056)
print v(xbgr.mr_n76663488)
print v(xbgr.mr_n76663920)
print v(xbgr.mr_n76664352)
print v(xbgr.mr_n76664784)
print v(xbgr.mr_n76665216)
print v(xbgr.mr_n76665648)
print v(xbgr.mr_n76666080)
print v(xbgr.mr_n76666512)
print v(xbgr.mr_n76666944)
print v(xbgr.mr_n76667376)
print v(xbgr.mr_n76667808)
print v(xbgr.mr_n76668240)
print v(xbgr.mr_n76668672)
print v(xbgr.mr_n76669104)
print v(xbgr.mr_n76669536)
print v(xbgr.mr_n76669968)
print v(xbgr.mr_n76670400)
print v(xbgr.mr_n76670832)
print v(xbgr.mr_n76671264)
print v(xbgr.mr_n76671696)
print v(xbgr.mr_n76672016)
print v(xbgr.mr_n76672128)
print v(xbgr.mr_n76672448)
print v(xbgr.mr_n76672560)
print v(xbgr.mr_n76672880)
print v(xbgr.mr_n76672992)
print v(xbgr.mr_n76673312)
print v(xbgr.mr_n76673424)
print v(xbgr.mr_n76673744)
print v(xbgr.mr_n76673856)
print v(xbgr.mr_n76674176)
print v(xbgr.mr_n76674288)
print v(xbgr.mr_n76674608)
print v(xbgr.mr_n76674720)
print v(xbgr.mr_n76675040)
print v(xbgr.mr_n76675152)
print v(xbgr.mr_n76675472)
print v(xbgr.mr_n76675584)
print v(xbgr.mr_n76675904)
print v(xbgr.mr_n76676016)
print v(xbgr.mr_n76676336)
print v(xbgr.mr_n76676448)
print v(xbgr.mr_n76676768)
print v(xbgr.mr_n76676880)
print v(xbgr.mr_n76677200)
print v(xbgr.mr_n76677632)
print v(xbgr.mr_n76677744)
print v(xbgr.mr_n76678064)
print v(xbgr.mr_n76678176)
print v(xbgr.mr_n76678496)
print v(xbgr.mr_n76678608)
print v(xbgr.mr_n76678928)
print v(xbgr.mr_n76679040)
print v(xbgr.mr_n76679360)
print v(xbgr.mr_n76679472)
print v(xbgr.mr_n76679792)
print v(xbgr.mr_n76679904)
print v(xbgr.mr_n76680224)
print v(xbgr.mr_n76680336)
print v(xbgr.mr_n76680656)
print v(xbgr.mr_n76680768)
print v(xbgr.mr_n76681088)
print v(xbgr.mr_n76681200)
print v(xbgr.mr_n76681520)
print v(xbgr.mr_n76681632)
print v(xbgr.mr_n76681952)
print v(xbgr.mr_n76682064)
print v(xbgr.mr_n76682496)
print v(xbgr.mr_n76682928)
print v(xbgr.mr_n76683360)
print v(xbgr.mr_n76683792)
print v(xbgr.mr_n76684224)
print v(xbgr.mr_n76684656)
print v(xbgr.mr_n76685088)
print v(xbgr.mr_n76685520)
print v(xbgr.mr_n76685952)
print v(xbgr.mr_n76686384)
print v(xbgr.mr_n76686816)
print v(xbgr.mr_n76687248)
print v(xbgr.mr_n76687680)
print v(xbgr.mr_n76688112)
print v(xbgr.mr_n76688544)
print v(xbgr.mr_n76688976)
print v(xbgr.mr_n76689408)
print v(xbgr.mr_n76689840)
print v(xbgr.mr_n76690272)
print v(xbgr.mr_n76690704)
print v(xbgr.mr_n76691136)
print v(xbgr.mr_n76691568)
print v(xbgr.mr_n76692000)
print v(xbgr.mr_n76692432)
print v(xbgr.mr_n76692864)
print v(xbgr.mr_n76693296)
print v(xbgr.mr_n76693728)
print v(xbgr.mr_n76694160)
print v(xbgr.mr_n76694592)
print v(xbgr.mr_n76695024)
print v(xbgr.mr_n76695456)
print v(xbgr.mr_n76695888)
print v(xbgr.mr_n76696320)
print v(xbgr.mr_n76696752)
print v(xbgr.mr_n76697184)
print v(xbgr.mr_n76697616)
print v(xbgr.mr_n76698048)
print v(xbgr.mr_n76698480)
print v(xbgr.mr_n76698912)
print v(xbgr.mr_n76699344)
print v(xbgr.mr_n76699776)
print v(xbgr.mr_n76700208)
print v(xbgr.mr_n76700640)
print v(xbgr.mr_n76701072)
print v(xbgr.mr_n76701504)
print v(xbgr.mr_n76701936)
print v(xbgr.mr_n76702368)
print v(xbgr.mr_n76702800)
print v(xbgr.mr_n76703232)
print v(xbgr.mr_n76703664)
print v(xbgr.mr_n76704096)
print v(xbgr.mr_n76704528)
print v(xbgr.mr_n76704960)
print v(xbgr.mr_n76705392)
print v(xbgr.mr_n76705824)
print v(xbgr.mr_n76706256)
print v(xbgr.mr_n76706688)
print v(xbgr.mr_n76707120)
print v(xbgr.mr_n76707552)
print v(xbgr.mr_n76707984)
print v(xbgr.mr_n76708416)
print v(xbgr.mr_n76708848)
print v(xbgr.mr_n76709280)
print v(xbgr.mr_n76709712)
print v(xbgr.mr_n76710144)
print v(xbgr.mr_n76710576)
print v(xbgr.mr_n76711008)
print v(xbgr.mr_n76711440)
print v(xbgr.mr_n76711872)
print v(xbgr.mr_n76712304)
print v(xbgr.mr_n76712736)
print v(xbgr.mr_n76713168)
print v(xbgr.mr_n76713600)
print v(xbgr.mr_n76714032)
print v(xbgr.mr_n76714464)
print v(xbgr.mr_n76714896)
print v(xbgr.mr_n76715328)
print v(xbgr.mr_n76715760)
print v(xbgr.mr_n76716192)
print v(xbgr.mr_n76716624)
print v(xbgr.mr_n76717056)
print v(xbgr.mr_n76717488)
print v(xbgr.mr_n76717920)
print v(xbgr.mr_n76718352)
print v(xbgr.mr_n76718784)
print v(xbgr.mr_n76719216)
print v(xbgr.mr_n76719536)
print v(xbgr.mr_n76719648)
print v(xbgr.mr_n76719968)
print v(xbgr.mr_n76720080)
print v(xbgr.mr_n76720400)
print v(xbgr.mr_n76720512)
print v(xbgr.mr_n76720832)
print v(xbgr.mr_n76720944)
print v(xbgr.mr_n76721264)
print v(xbgr.mr_n76721376)
print v(xbgr.mr_n76721696)
print v(xbgr.mr_n76721808)
print v(xbgr.mr_n76722128)
print v(xbgr.mr_n76722240)
print v(xbgr.mr_n76722560)
print v(xbgr.mr_n76722672)
print v(xbgr.mr_n76722992)
print v(xbgr.mr_n76723104)
print v(xbgr.mr_n76723424)
print v(xbgr.mr_n76723536)
print v(xbgr.mr_n76723856)
print v(xbgr.mr_n76723968)
print v(xbgr.mr_n76724288)
print v(xbgr.mr_n76724400)
print v(xbgr.mr_n76724720)
print v(xbgr.mr_n76724832)
print v(xbgr.mr_n76725152)
print v(xbgr.mr_n76725264)
print v(xbgr.mr_n76725584)
print v(xbgr.mr_n76725696)
print v(xbgr.mr_n76726016)
print v(xbgr.mr_n76726128)
print v(xbgr.mr_n76726448)
print v(xbgr.mr_n76726560)
print v(xbgr.mr_n76726880)
print v(xbgr.mr_n76726992)
print v(xbgr.mr_n76727312)
print v(xbgr.mr_n76727856)
print v(xbgr.mr_n76728176)
print v(xbgr.mr_n76728608)
print v(xbgr.mr_n76728720)
print v(xbgr.mr_n76729040)
print v(xbgr.mr_n76729152)
print v(xbgr.mr_n76729584)
print v(xbgr.mr_n76729904)
print v(xbgr.mr_n76730768)
print v(xbgr.mr_n76730880)
print v(xbgr.mr_n76731312)
print v(xbgr.mr_n76731632)
print v(xbgr.mr_n76732496)
print v(xbgr.mr_n76732608)
print v(xbgr.mr_n76733040)
print v(xbgr.mr_n76733360)
print v(xbgr.mr_n76733472)
print v(xbgr.mr_n76733904)
print v(xbgr.mr_n76734336)
print v(xbgr.mr_n76734656)
print v(xbgr.mr_n76735520)
print v(xbgr.mr_n76736496)
print v(xbgr.mr_n76736816)
print v(xbgr.mr_n76736928)
print v(xbgr.mr_n76737360)
print v(xbgr.mr_n76737680)
print v(xbgr.mr_n76737792)
print v(xbgr.mr_n76738224)
print v(xbgr.mr_n76738544)
print v(xbgr.mr_n76738656)
print v(xbgr.mr_n76738976)
print v(xbgr.mr_n76739088)
print v(xbgr.mr_n76739408)
print v(xbgr.mr_n76739520)
print v(xbgr.mr_n76739840)
print v(xbgr.mr_n76739952)
print v(xbgr.mr_n76740272)
print v(xbgr.mr_n76740384)
print v(xbgr.mr_n76740704)
print v(xbgr.mr_n76740816)
print v(xbgr.mr_n76741136)
print v(xbgr.mr_n76741248)
print v(xbgr.mr_n76741568)
print v(xbgr.mr_n76741680)
print v(xbgr.mr_n76742000)
print v(xbgr.mr_n76742112)
print v(xbgr.mr_n76742432)
print v(xbgr.mr_n76742544)
print v(xbgr.mr_n76742864)
print v(xbgr.mr_n76742976)
print v(xbgr.mr_n76743296)
print v(xbgr.mr_n76743408)
print v(xbgr.mr_n76743728)
print v(xbgr.mr_n76744592)
print v(xbgr.mr_n76745456)
print v(xbgr.mr_n76745888)
print v(xbgr.mr_n76746320)
print v(xbgr.mr_n76746752)
print v(xbgr.mr_n76747184)
print v(xbgr.mr_n76747616)
print v(xbgr.mr_n76748048)
print v(xbgr.mr_n76748480)
print v(xbgr.mr_n76748912)
print v(xbgr.mr_n76749344)
print v(xbgr.mr_n76749776)
print v(xbgr.mr_n76750208)
print v(xbgr.mr_n76750640)
print v(xbgr.mr_n76750752)
print v(xbgr.mr_n76751072)
print v(xbgr.mr_n76751184)
print v(xbgr.mr_n76751504)
print v(xbgr.mr_n76751616)
print v(xbgr.mr_n76751936)
print v(xbgr.mr_n76752048)
print v(xbgr.mr_n76752368)
print v(xbgr.mr_n76752480)
print v(xbgr.mr_n76752800)
print v(xbgr.mr_n76752912)
print v(xbgr.mr_n76753232)
print v(xbgr.mr_n76753344)
print v(xbgr.mr_n76753664)
print v(xbgr.mr_n76753776)
print v(xbgr.mr_n76754096)
print v(xbgr.mr_n76754208)
print v(xbgr.mr_n76754528)
print v(xbgr.mr_n76754640)
print v(xbgr.mr_n76754960)
print v(xbgr.mr_n76755072)
print v(xbgr.mr_n76755392)
print v(xbgr.mr_n76755504)
print v(xbgr.mr_n76755824)
print v(xbgr.mr_n76756256)
print v(xbgr.mr_n76756368)
print v(xbgr.mr_n76756688)
print v(xbgr.mr_n76756800)
print v(xbgr.mr_n76757120)
print v(xbgr.mr_n76757232)
print v(xbgr.mr_n76757552)
print v(xbgr.mr_n76757664)
print v(xbgr.mr_n76757984)
print v(xbgr.mr_n76758096)
print v(xbgr.mr_n76758416)
print v(xbgr.mr_n76758528)
print v(xbgr.mr_n76758848)
print v(xbgr.mr_n76758960)
print v(xbgr.mr_n76759280)
print v(xbgr.mr_n76759392)
print v(xbgr.mr_n76759712)
print v(xbgr.mr_n76759824)
print v(xbgr.mr_n76760144)
print v(xbgr.mr_n76760256)
print v(xbgr.mr_n76760576)
print v(xbgr.mr_n76760688)
print v(xbgr.mr_n76761008)
print v(xbgr.mr_n76761120)
print v(xbgr.mr_n76761440)
print v(xbgr.mr_n76761552)
print v(xbgr.mr_n76761872)
print v(xbgr.mr_n76761984)
print v(xbgr.mr_n76762304)
print v(xbgr.mr_n76762416)
print v(xbgr.mr_n76762736)
print v(xbgr.mr_n76762848)
print v(xbgr.mr_n76763168)
print v(xbgr.mr_n76763280)
print v(xbgr.mr_n76763600)
print v(xbgr.mr_n76763712)
print v(xbgr.mr_n76764032)
print v(xbgr.mr_n76764144)
print v(xbgr.mr_n76764464)
print v(xbgr.mr_n76764576)
print v(xbgr.mr_n76764896)
print v(xbgr.mr_n76765008)
print v(xbgr.mr_n76765328)
print v(xbgr.mr_n76765440)
print v(xbgr.mr_n76765760)
print v(xbgr.mr_n76765872)
print v(xbgr.mr_n76766192)
print v(xbgr.mr_n76766304)
print v(xbgr.mr_n76766624)
print v(xbgr.mr_n76766736)
print v(xbgr.mr_n76767056)
print v(xbgr.mr_n76767168)
print v(xbgr.mr_n76767488)
print v(xbgr.mr_n76767600)
print v(xbgr.mr_n76767920)
print v(xbgr.mr_n76768032)
print v(xbgr.mr_n76768352)
print v(xbgr.mr_n76768464)
print v(xbgr.mr_n76768784)
print v(xbgr.mr_n76768896)
print v(xbgr.mr_n76769216)
print v(xbgr.mr_n76769328)
print v(xbgr.mr_n76769648)
print v(xbgr.mr_n76769760)
print v(xbgr.mr_n76770080)
print v(xbgr.mr_n76770192)
print v(xbgr.mr_n76770512)
print v(xbgr.mr_n76770624)
print v(xbgr.mr_n76770944)
print v(xbgr.mr_n76771056)
print v(xbgr.mr_n76771376)
print v(xbgr.mr_n76771488)
print v(xbgr.mr_n76771808)
print v(xbgr.mr_n76771920)
print v(xbgr.mr_n76772240)
print v(xbgr.mr_n76772352)
print v(xbgr.mr_n76772672)
print v(xbgr.mr_n76772784)
print v(xbgr.mr_n76773104)
print v(xbgr.mr_n76773216)
print v(xbgr.mr_n76773536)
print v(xbgr.mr_n76773648)
print v(xbgr.mr_n76773968)
print v(xbgr.mr_n76774080)
print v(xbgr.mr_n76774400)
print v(xbgr.mr_n76774512)
print v(xbgr.mr_n76774832)
print v(xbgr.mr_n76774944)
print v(xbgr.mr_n76775264)
print v(xbgr.mr_n76775376)
print v(xbgr.mr_n76775696)
print v(xbgr.mr_n76775808)
print v(xbgr.mr_n76776128)
print v(xbgr.mr_n76776240)
print v(xbgr.mr_n76776560)
print v(xbgr.mr_n76776672)
print v(xbgr.mr_n76776992)
print v(xbgr.mr_n76777104)
print v(xbgr.mr_n76777424)
print v(xbgr.mr_n76777536)
print v(xbgr.mr_n76777856)
print v(xbgr.mr_n76777968)
print v(xbgr.mr_n76778288)
print v(xbgr.mr_n76778400)
print v(xbgr.mr_n76778720)
print v(xbgr.mr_n76778832)
print v(xbgr.mr_n76779152)
print v(xbgr.mr_n76779264)
print v(xbgr.mr_n76779584)
print v(xbgr.mr_n76779696)
print v(xbgr.mr_n76780016)
print v(xbgr.mr_n76780128)
print v(xbgr.mr_n76780448)
print v(xbgr.mr_n76780560)
print v(xbgr.mr_n76780880)
print v(xbgr.mr_n76780992)
print v(xbgr.mr_n76781312)
print v(xbgr.mr_n76781424)
print v(xbgr.mr_n76781744)
print v(xbgr.mr_n76781856)
print v(xbgr.mr_n76782176)
print v(xbgr.mr_n76782288)
print v(xbgr.mr_n76782608)
print v(xbgr.mr_n76782720)
print v(xbgr.mr_n76783040)
print v(xbgr.mr_n76783152)
print v(xbgr.mr_n76783472)
print v(xbgr.mr_n76783584)
print v(xbgr.mr_n76783904)
print v(xbgr.mr_n76784016)
print v(xbgr.mr_n76784336)
print v(xbgr.mr_n76784448)
print v(xbgr.mr_n76784768)
print v(xbgr.mr_n76784880)
print v(xbgr.mr_n76785200)
print v(xbgr.mr_n76785312)
print v(xbgr.mr_n76785632)
print v(xbgr.mr_n76785744)
print v(xbgr.mr_n76786064)
print v(xbgr.mr_n76786176)
print v(xbgr.mr_n76786496)
print v(xbgr.mr_n76786608)
print v(xbgr.mr_n76786928)
print v(xbgr.mr_n76787040)
print v(xbgr.mr_n76787360)
print v(xbgr.mr_n76787472)
print v(xbgr.mr_n76787792)
print v(xbgr.mr_n76788224)
print v(xbgr.mr_n76788336)
print v(xbgr.mr_n76788656)
print v(xbgr.mr_n76788768)
print v(xbgr.mr_n76789088)
print v(xbgr.mr_n76789200)
print v(xbgr.mr_n76789520)
print v(xbgr.mr_n76789632)
print v(xbgr.mr_n76789952)
print v(xbgr.mr_n76790064)
print v(xbgr.mr_n76790384)
print v(xbgr.mr_n76790496)
print v(xbgr.mr_n76790816)
print v(xbgr.mr_n76790928)
print v(xbgr.mr_n76791248)
print v(xbgr.mr_n76791360)
print v(xbgr.mr_n76791680)
print v(xbgr.mr_n76791792)
print v(xbgr.mr_n76792112)
print v(xbgr.mr_n76792224)
print v(xbgr.mr_n76792544)
print v(xbgr.mr_n76792656)
print v(xbgr.mr_n76792976)
print v(xbgr.mr_n76793088)
print v(xbgr.mr_n76793408)
print v(xbgr.mr_n76793520)
print v(xbgr.mr_n76793840)
print v(xbgr.mr_n76793952)
print v(xbgr.mr_n76794272)
print v(xbgr.mr_n76794384)
print v(xbgr.mr_n76794704)
print v(xbgr.mr_n76794816)
print v(xbgr.mr_n76795136)
print v(xbgr.mr_n76795248)
print v(xbgr.mr_n76795568)
print v(xbgr.mr_n76795680)
print v(xbgr.mr_n76796000)
print v(xbgr.mr_n76796544)
print v(xbgr.mr_n76796864)
print v(xbgr.mr_n76796976)
print v(xbgr.mr_n76797296)
print v(xbgr.mr_n76797408)
print v(xbgr.mr_n76797840)
print v(xbgr.mr_n76798272)
print v(xbgr.mr_n76798704)
print v(xbgr.mr_n76799136)
print v(xbgr.mr_n76799568)
print v(xbgr.mr_n76800000)
print v(xbgr.mr_n76800432)
print v(xbgr.mr_n76800864)
print v(xbgr.mr_n76801296)
print v(xbgr.mr_n76801728)
print v(xbgr.mr_n76802160)
print v(xbgr.mr_n76802592)
print v(xbgr.mr_n76803024)
print v(xbgr.mr_n76803456)
print v(xbgr.mr_n76803888)
print v(xbgr.mr_n76804320)
print v(xbgr.mr_n76804752)
print v(xbgr.mr_n76805184)
print v(xbgr.mr_n76805616)
print v(xbgr.mr_n76806048)
print v(xbgr.mr_n76806480)
print v(xbgr.mr_n76806912)
print v(xbgr.mr_n76807344)
print v(xbgr.mr_n76807776)
print v(xbgr.mr_n76808208)
print v(xbgr.mr_n76808640)
print v(xbgr.mr_n76809072)
print v(xbgr.mr_n76809504)
print v(xbgr.mr_n76809936)
print v(xbgr.mr_n76810368)
print v(xbgr.mr_n76810800)
print v(xbgr.mr_n76811232)
print v(xbgr.mr_n76811664)
print v(xbgr.mr_n76812096)
print v(xbgr.mr_n76812528)
print v(xbgr.mr_n76812960)
print v(xbgr.mr_n76813392)
print v(xbgr.mr_n76813824)
print v(xbgr.mr_n76814256)
print v(xbgr.mr_n76814688)
print v(xbgr.mr_n76815120)
print v(xbgr.mr_n76815552)
print v(xbgr.mr_n76815984)
print v(xbgr.mr_n76816416)
print v(xbgr.mr_n76816848)
print v(xbgr.mr_n76817280)
print v(xbgr.mr_n76817712)
print v(xbgr.mr_n76818144)
print v(xbgr.mr_n76818576)
print v(xbgr.mr_n76819008)
print v(xbgr.mr_n76819440)
print v(xbgr.mr_n76819872)
print v(xbgr.mr_n76820304)
print v(xbgr.mr_n76820736)
print v(xbgr.mr_n76821168)
print v(xbgr.mr_n76821600)
print v(xbgr.mr_n76822032)
print v(xbgr.mr_n76822464)
print v(xbgr.mr_n76822896)
print v(xbgr.mr_n76823328)
print v(xbgr.mr_n76823760)
print v(xbgr.mr_n76824192)
print v(xbgr.mr_n76824624)
print v(xbgr.mr_n76825056)
print v(xbgr.mr_n76825488)
print v(xbgr.mr_n76825920)
print v(xbgr.mr_n76826352)
print v(xbgr.mr_n76826784)
print v(xbgr.mr_n76827216)
print v(xbgr.mr_n76827648)
print v(xbgr.mr_n76828080)
print v(xbgr.mr_n76828512)
print v(xbgr.mr_n76828944)
print v(xbgr.mr_n76829376)
print v(xbgr.mr_n76829808)
print v(xbgr.mr_n76830240)
print v(xbgr.mr_n76830672)
print v(xbgr.mr_n76831104)
print v(xbgr.mr_n76831536)
print v(xbgr.mr_n76831968)
print v(xbgr.mr_n76832400)
print v(xbgr.mr_n76832832)
print v(xbgr.mr_n76833264)
print v(xbgr.mr_n76833696)
print v(xbgr.mr_n76834128)
print v(xbgr.mr_n76834560)
print v(xbgr.mr_n76834992)
print v(xbgr.mr_n76835424)
print v(xbgr.mr_n76835856)
print v(xbgr.mr_n76836288)
print v(xbgr.mr_n76836720)
print v(xbgr.mr_n76837152)
print v(xbgr.mr_n76837584)
print v(xbgr.mr_n76838016)
print v(xbgr.mr_n76838448)
print v(xbgr.mr_n76838880)
print v(xbgr.mr_n76839312)
print v(xbgr.mr_n76839744)
print v(xbgr.mr_n76840176)
print v(xbgr.mr_n76840608)
print v(xbgr.mr_n76841040)
print v(xbgr.mr_n76841472)
print v(xbgr.mr_n76841904)
print v(xbgr.mr_n76842336)
print v(xbgr.mr_n76842768)
print v(xbgr.mr_n76843088)
print v(xbgr.mr_n76843200)
print v(xbgr.mr_n76843520)
print v(xbgr.mr_n76843632)
print v(xbgr.mr_n76843952)
print v(xbgr.mr_n76844064)
print v(xbgr.mr_n76844384)
print v(xbgr.mr_n76844496)
print v(xbgr.mr_n76844816)
print v(xbgr.mr_n76844928)
print v(xbgr.mr_n76845248)
print v(xbgr.mr_n76845360)
print v(xbgr.mr_n76845680)
print v(xbgr.mr_n76845792)
print v(xbgr.mr_n76846112)
print v(xbgr.mr_n76846224)
print v(xbgr.mr_n76846544)
print v(xbgr.mr_n76846656)
print v(xbgr.mr_n76846976)
print v(xbgr.mr_n76847088)
print v(xbgr.mr_n76847408)
print v(xbgr.mr_n76847520)
print v(xbgr.mr_n76847840)
print v(xbgr.mr_n76847952)
print v(xbgr.mr_n76848272)
print v(xbgr.mr_n76848384)
print v(xbgr.mr_n76848704)
print v(xbgr.mr_n76848816)
print v(xbgr.mr_n76849136)
print v(xbgr.mr_n76849248)
print v(xbgr.mr_n76849568)
print v(xbgr.mr_n76849680)
print v(xbgr.mr_n76850000)
print v(xbgr.mr_n76850112)
print v(xbgr.mr_n76850432)
print v(xbgr.mr_n76850544)
print v(xbgr.mr_n76850864)
print v(xbgr.mr_n76850976)
print v(xbgr.mr_n76851296)
print v(xbgr.mr_n76851408)
print v(xbgr.mr_n76851728)
print v(xbgr.mr_n76851840)
print v(xbgr.mr_n76852160)
print v(xbgr.mr_n76852272)
print v(xbgr.mr_n76852592)
print v(xbgr.mr_n76852704)
print v(xbgr.mr_n76853024)
print v(xbgr.mr_n76853136)
print v(xbgr.mr_n76853456)
print v(xbgr.mr_n76853568)
print v(xbgr.mr_n76853888)
print v(xbgr.mr_n76854000)
print v(xbgr.mr_n76854320)
print v(xbgr.mr_n76854432)
print v(xbgr.mr_n76854752)
print v(xbgr.mr_n76854864)
print v(xbgr.mr_n76855184)
print v(xbgr.mr_n76855296)
print v(xbgr.mr_n76855616)
print v(xbgr.mr_n76855728)
print v(xbgr.mr_n76856048)
print v(xbgr.mr_n76856160)
print v(xbgr.mr_n76856480)
print v(xbgr.mr_n76856592)
print v(xbgr.mr_n76856912)
print v(xbgr.mr_n76857024)
print v(xbgr.mr_n76857344)
print v(xbgr.mr_n76857456)
print v(xbgr.mr_n76857776)
print v(xbgr.mr_n76857888)
print v(xbgr.mr_n76858208)
print v(xbgr.mr_n76858320)
print v(xbgr.mr_n76858640)
print v(xbgr.mr_n76858752)
print v(xbgr.mr_n76859072)
print v(xbgr.mr_n76859184)
print v(xbgr.mr_n76859504)
print v(xbgr.mr_n76859616)
print v(xbgr.mr_n76859936)
print v(xbgr.mr_n76860048)
print v(xbgr.mr_n76860368)
print v(xbgr.mr_n76860480)
print v(xbgr.mr_n76860800)
print v(xbgr.mr_n76860912)
print v(xbgr.mr_n76861232)
print v(xbgr.mr_n76861664)
print v(xbgr.mr_n76861776)
print v(xbgr.mr_n76862096)
print v(xbgr.mr_n76862208)
print v(xbgr.mr_n76862528)
print v(xbgr.mr_n76862640)
print v(xbgr.mr_n76862960)
print v(xbgr.mr_n76863072)
print v(xbgr.mr_n76863392)
print v(xbgr.mr_n76863504)
print v(xbgr.mr_n76863824)
print v(xbgr.mr_n76863936)
print v(xbgr.mr_n76864256)
print v(xbgr.mr_n76864368)
print v(xbgr.mr_n76864688)
print v(xbgr.mr_n76864800)
print v(xbgr.mr_n76865120)
print v(xbgr.mr_n76865232)
print v(xbgr.mr_n76865552)
print v(xbgr.mr_n76865664)
print v(xbgr.mr_n76865984)
print v(xbgr.mr_n76866096)
print v(xbgr.mr_n76866416)
print v(xbgr.mr_n76866528)
print v(xbgr.mr_n76866848)
print v(xbgr.mr_n76866960)
print v(xbgr.mr_n76867280)
print v(xbgr.mr_n76867392)
print v(xbgr.mr_n76867712)
print v(xbgr.mr_n76867824)
print v(xbgr.mr_n76868144)
print v(xbgr.mr_n76868256)
print v(xbgr.mr_n76868576)
print v(xbgr.mr_n76868688)
print v(xbgr.mr_n76869008)
print v(xbgr.mr_n76869120)
print v(xbgr.mr_n76869440)
print v(xbgr.mr_n76869552)
print v(xbgr.mr_n76869872)
print v(xbgr.mr_n76869984)
print v(xbgr.mr_n76870304)
print v(xbgr.mr_n76870416)
print v(xbgr.mr_n76870736)
print v(xbgr.mr_n76870848)
print v(xbgr.mr_n76871168)
print v(xbgr.mr_n76871280)
print v(xbgr.mr_n76871600)
print v(xbgr.mr_n76871712)
print v(xbgr.mr_n76872032)
print v(xbgr.mr_n76872144)
print v(xbgr.mr_n76872464)
print v(xbgr.mr_n76872576)
print v(xbgr.mr_n76872896)
print v(xbgr.mr_n76873008)
print v(xbgr.mr_n76873328)
print v(xbgr.mr_n76873440)
print v(xbgr.mr_n76873760)
print v(xbgr.mr_n76873872)
print v(xbgr.mr_n76874192)
print v(xbgr.mr_n76874304)
print v(xbgr.mr_n76874624)
print v(xbgr.mr_n76874736)
print v(xbgr.mr_n76875056)
print v(xbgr.mr_n76875168)
print v(xbgr.mr_n76875488)
print v(xbgr.mr_n76875600)
print v(xbgr.mr_n76875920)
print v(xbgr.mr_n76876032)
print v(xbgr.mr_n76876352)
print v(xbgr.mr_n76876464)
print v(xbgr.mr_n76876784)
print v(xbgr.mr_n76876896)
print v(xbgr.mr_n76877216)
print v(xbgr.mr_n76877328)
print v(xbgr.mr_n76877648)
print v(xbgr.mr_n76877760)
print v(xbgr.mr_n76878080)
print v(xbgr.mr_n76878192)
print v(xbgr.mr_n76878512)
print v(xbgr.mr_n76878624)
print v(xbgr.mr_n76878944)
print v(xbgr.mr_n76879056)
print v(xbgr.mr_n76879376)
print v(xbgr.mr_n76879488)
print v(xbgr.mr_n76879808)
print v(xbgr.mr_n76879920)
print v(xbgr.mr_n76880240)
print v(xbgr.mr_n76880352)
print v(xbgr.mr_n76880672)
print v(xbgr.mr_n76880784)
print v(xbgr.mr_n76881104)
print v(xbgr.mr_n76881216)
print v(xbgr.mr_n76881536)
print v(xbgr.mr_n76881648)
print v(xbgr.mr_n76881968)
print v(xbgr.mr_n76882080)
print v(xbgr.mr_n76882400)
print v(xbgr.mr_n76882512)
print v(xbgr.mr_n76882832)
print v(xbgr.mr_n76882944)
print v(xbgr.mr_n76883264)
print v(xbgr.mr_n76883376)
print v(xbgr.mr_n76883696)
print v(xbgr.mr_n76883808)
print v(xbgr.mr_n76884128)
print v(xbgr.mr_n76884240)
print v(xbgr.mr_n76884560)
print v(xbgr.mr_n76884672)
print v(xbgr.mr_n76884992)
print v(xbgr.mr_n76885104)
print v(xbgr.mr_n76885424)
print v(xbgr.mr_n76885536)
print v(xbgr.mr_n76885856)
print v(xbgr.mr_n76885968)
print v(xbgr.mr_n76886288)
print v(xbgr.mr_n76886400)
print v(xbgr.mr_n76886720)
print v(xbgr.mr_n76886832)
print v(xbgr.mr_n76887152)
print v(xbgr.mr_n76887264)
print v(xbgr.mr_n76887584)
print v(xbgr.mr_n76887696)
print v(xbgr.mr_n76888016)
print v(xbgr.mr_n76888128)
print v(xbgr.mr_n76888448)
print v(xbgr.mr_n76888560)
print v(xbgr.mr_n76888880)
print v(xbgr.mr_n76888992)
print v(xbgr.mr_n76889312)
print v(xbgr.mr_n76889424)
print v(xbgr.mr_n76889744)
print v(xbgr.mr_n76889856)
print v(xbgr.mr_n76890176)
print v(xbgr.mr_n76890288)
print v(xbgr.mr_n76890608)
print v(xbgr.mr_n76890720)
print v(xbgr.mr_n76891040)
print v(xbgr.mr_n76891152)
print v(xbgr.mr_n76891472)
print v(xbgr.mr_n76891584)
print v(xbgr.mr_n76891904)
print v(xbgr.mr_n76892016)
print v(xbgr.mr_n76892336)
print v(xbgr.mr_n76892448)
print v(xbgr.mr_n76892768)
print v(xbgr.mr_n76892880)
print v(xbgr.mr_n76893200)
print v(xbgr.mr_n76893312)
print v(xbgr.mr_n76893632)
print v(xbgr.mr_n76893744)
print v(xbgr.mr_n76894064)
print v(xbgr.mr_n76894176)
print v(xbgr.mr_n76894496)
print v(xbgr.mr_n76894608)
print v(xbgr.mr_n76894928)
print v(xbgr.mr_n76895040)
print v(xbgr.mr_n76895360)
print v(xbgr.mr_n76895472)
print v(xbgr.mr_n76895792)
print v(xbgr.mr_n76895904)
print v(xbgr.mr_n76896224)
print v(xbgr.mr_n76896336)
print v(xbgr.mr_n76896656)
print v(xbgr.mr_n76896768)
print v(xbgr.mr_n76897088)
print v(xbgr.mr_n76897200)
print v(xbgr.mr_n76897520)
print v(xbgr.mr_n76897632)
print v(xbgr.mr_n76897952)
print v(xbgr.mr_n76898064)
print v(xbgr.mr_n76898384)
print v(xbgr.mr_n76898496)
print v(xbgr.mr_n76898816)
print v(xbgr.mr_n76898928)
print v(xbgr.mr_n76899248)
print v(xbgr.mr_n76899360)
print v(xbgr.mr_n76899680)
print v(xbgr.mr_n76899792)
print v(xbgr.mr_n76900112)
print v(xbgr.mr_n76900224)
print v(xbgr.mr_n76900544)
print v(xbgr.mr_n76900656)
print v(xbgr.mr_n76900976)
print v(xbgr.mr_n76901088)
print v(xbgr.mr_n76901408)
print v(xbgr.mr_n76901520)
print v(xbgr.mr_n76901840)
print v(xbgr.mr_n76901952)
print v(xbgr.mr_n76902272)
print v(xbgr.mr_n76902384)
print v(xbgr.mr_n76902704)
print v(xbgr.mr_n76902816)
print v(xbgr.mr_n76903136)
print v(xbgr.mr_n76903248)
print v(xbgr.mr_n76903568)
print v(xbgr.mr_n76903680)
print v(xbgr.mr_n76904000)
print v(xbgr.mr_n76904112)
print v(xbgr.mr_n76904432)
print v(xbgr.mr_n76904544)
print v(xbgr.mr_n76904864)
print v(xbgr.mr_n76904976)
print v(xbgr.mr_n76905296)
print v(xbgr.mr_n76905408)
print v(xbgr.mr_n76905728)
print v(xbgr.mr_n76905840)
print v(xbgr.mr_n76906160)
print v(xbgr.mr_n76906272)
print v(xbgr.mr_n76906592)
print v(xbgr.mr_n76906704)
print v(xbgr.mr_n76907024)
print v(xbgr.mr_n76907136)
print v(xbgr.mr_n76907456)
print v(xbgr.mr_n76907568)
print v(xbgr.mr_n76907888)
print v(xbgr.mr_n76908000)
print v(xbgr.mr_n76908320)
print v(xbgr.mr_n76908432)
print v(xbgr.mr_n76908752)
print v(xbgr.mr_n76908864)
print v(xbgr.mr_n76909184)
print v(xbgr.mr_n76909296)
print v(xbgr.mr_n76909616)
print v(xbgr.mr_n76909728)
print v(xbgr.mr_n76910048)
print v(xbgr.mr_n76910160)
print v(xbgr.mr_n76910480)
print v(xbgr.mr_n76910592)
print v(xbgr.mr_n76910912)
print v(xbgr.mr_n76911024)
print v(xbgr.mr_n76911344)
print v(xbgr.mr_n76911776)
print v(xbgr.mr_n76911888)
print v(xbgr.mr_n76912208)
print v(xbgr.mr_n76912320)
print v(xbgr.mr_n76912640)
print v(xbgr.mr_n76912752)
print v(xbgr.mr_n76913072)
print v(xbgr.mr_n76913184)
print v(xbgr.mr_n76913504)
print v(xbgr.mr_n76913616)
print v(xbgr.mr_n76913936)
print v(xbgr.mr_n76914048)
print v(xbgr.mr_n76914368)
print v(xbgr.mr_n76914480)
print v(xbgr.mr_n76914800)
print v(xbgr.mr_n76914912)
print v(xbgr.mr_n76915232)
print v(xbgr.mr_n76915344)
print v(xbgr.mr_n76915664)
print v(xbgr.mr_n76915776)
print v(xbgr.mr_n76916096)
print v(xbgr.mr_n76916208)
print v(xbgr.mr_n76916528)
print v(xbgr.mr_n76916640)
print v(xbgr.mr_n76916960)
print v(xbgr.mr_n76917072)
print v(xbgr.mr_n76917392)
print v(xbgr.mr_n76917504)
print v(xbgr.mr_n76917824)
print v(xbgr.mr_n76917936)
print v(xbgr.mr_n76918256)
print v(xbgr.mr_n76918368)
print v(xbgr.mr_n76918688)
print v(xbgr.mr_n76918800)
print v(xbgr.mr_n76919120)
print v(xbgr.mr_n76919232)
print v(xbgr.mr_n76919552)
print v(xbgr.mr_n76919664)
print v(xbgr.mr_n76919984)
print v(xbgr.mr_n76920096)
print v(xbgr.mr_n76920416)
print v(xbgr.mr_n76920528)
print v(xbgr.mr_n76920848)
print v(xbgr.mr_n76920960)
print v(xbgr.mr_n76921280)
print v(xbgr.mr_n76921392)
print v(xbgr.mr_n76921712)
print v(xbgr.mr_n76921824)
print v(xbgr.mr_n76922144)
print v(xbgr.mr_n76922256)
print v(xbgr.mr_n76922576)
print v(xbgr.mr_n76922688)
print v(xbgr.mr_n76923008)
print v(xbgr.mr_n76923120)
print v(xbgr.mr_n76923440)
print v(xbgr.mr_n76923552)
print v(xbgr.mr_n76923872)
print v(xbgr.mr_n76923984)
print v(xbgr.mr_n76924304)
print v(xbgr.mr_n76924416)
print v(xbgr.mr_n76924736)
print v(xbgr.mr_n76924848)
print v(xbgr.mr_n76925168)
print v(xbgr.mr_n76925280)
print v(xbgr.mr_n76925600)
print v(xbgr.mr_n76925712)
print v(xbgr.mr_n76926032)
print v(xbgr.mr_n76926144)
print v(xbgr.mr_n76926464)
print v(xbgr.mr_n76926576)
print v(xbgr.mr_n76926896)
print v(xbgr.mr_n76927008)
print v(xbgr.mr_n76927328)
print v(xbgr.mr_n76927440)
print v(xbgr.mr_n76927760)
print v(xbgr.mr_n76927872)
print v(xbgr.mr_n76928192)
print v(xbgr.mr_n76928304)
print v(xbgr.mr_n76928624)
print v(xbgr.mr_n76928736)
print v(xbgr.mr_n76929056)
print v(xbgr.mr_n76929168)
print v(xbgr.mr_n76929488)
print v(xbgr.mr_n76929600)
print v(xbgr.mr_n76929920)
print v(xbgr.mr_n76930032)
print v(xbgr.mr_n76930352)
print v(xbgr.mr_n76930464)
print v(xbgr.mr_n76930784)
print v(xbgr.mr_n76930896)
print v(xbgr.mr_n76931216)
print v(xbgr.mr_n76931328)
print v(xbgr.mr_n76931648)
print v(xbgr.mr_n76931760)
print v(xbgr.mr_n76932080)
print v(xbgr.mr_n76932512)
print v(xbgr.mr_n76932624)
print v(xbgr.mr_n76932944)
print v(xbgr.mr_n76933056)
print v(xbgr.mr_n76933376)
print v(xbgr.mr_n76933488)
print v(xbgr.mr_n76933808)
print v(xbgr.mr_n76933920)
print v(xbgr.mr_n76934240)
print v(xbgr.mr_n76934352)
print v(xbgr.mr_n76934672)
print v(xbgr.mr_n76934784)
print v(xbgr.mr_n76935216)
print v(xbgr.mr_n76935648)
print v(xbgr.mr_n76935968)
print v(xbgr.mr_n76936080)
print v(xbgr.mr_n76936400)
print v(xbgr.mr_n76936512)
print v(xbgr.mr_n76936832)
print v(xbgr.mr_n76936944)
print v(xbgr.mr_n76937264)
print v(xbgr.mr_n76937376)
print v(xbgr.mr_n76937696)
print v(xbgr.mr_n76937808)
print v(xbgr.mr_n76938128)
print v(xbgr.mr_n76938240)
print v(xbgr.mr_n76938560)
print v(xbgr.mr_n76938672)
print v(xbgr.mr_n76938992)
print v(xbgr.mr_n76939104)
print v(xbgr.mr_n76939424)
print v(xbgr.mr_n76939536)
print v(xbgr.mr_n76939856)
print v(xbgr.mr_n76939968)
print v(xbgr.mr_n76940288)
print v(xbgr.mr_n76940400)
print v(xbgr.mr_n76940720)
print v(xbgr.mr_n76940832)
print v(xbgr.mr_n76941152)
print v(xbgr.mr_n76941264)
print v(xbgr.mr_n76941584)
print v(xbgr.mr_n76941696)
print v(xbgr.mr_n76942016)
print v(xbgr.mr_n76942128)
print v(xbgr.mr_n76942448)
print v(xbgr.mr_n76942560)
print v(xbgr.mr_n76942880)
print v(xbgr.mr_n76942992)
print v(xbgr.mr_n76943312)
print v(xbgr.mr_n76943424)
print v(xbgr.mr_n76943744)
print v(xbgr.mr_n76943856)
print v(xbgr.mr_n76944176)
print v(xbgr.mr_n76944288)
print v(xbgr.mr_n76944608)
print v(xbgr.mr_n76944720)
print v(xbgr.mr_n76945040)
print v(xbgr.mr_n76945152)
print v(xbgr.mr_n76945472)
print v(xbgr.mr_n76945584)
print v(xbgr.mr_n76945904)
print v(xbgr.mr_n76946016)
print v(xbgr.mr_n76946336)
print v(xbgr.mr_n76946448)
print v(xbgr.mr_n76946768)
print v(xbgr.mr_n76946880)
print v(xbgr.mr_n76947200)
print v(xbgr.mr_n76947312)
print v(xbgr.mr_n76947632)
print v(xbgr.mr_n76947744)
print v(xbgr.mr_n76948064)
print v(xbgr.mr_n76948176)
print v(xbgr.mr_n76948496)
print v(xbgr.mr_n76948608)
print v(xbgr.mr_n76948928)
print v(xbgr.mr_n76949040)
print v(xbgr.mr_n76949360)
print v(xbgr.mr_n76949472)
print v(xbgr.mr_n76949792)
print v(xbgr.mr_n76949904)
print v(xbgr.mr_n76950224)
print v(xbgr.mr_n76950336)
print v(xbgr.mr_n76950656)
print v(xbgr.mr_n76950768)
print v(xbgr.mr_n76951088)
print v(xbgr.mr_n76951200)
print v(xbgr.mr_n76951520)
print v(xbgr.mr_n76951632)
print v(xbgr.mr_n76951952)
print v(xbgr.mr_n76952064)
print v(xbgr.mr_n76952384)
print v(xbgr.mr_n76952496)
print v(xbgr.mr_n76952816)
print v(xbgr.mr_n76952928)
print v(xbgr.mr_n76953248)
print v(xbgr.mr_n76953360)
print v(xbgr.mr_n76953680)
print v(xbgr.mr_n76953792)
print v(xbgr.mr_n76954112)
print v(xbgr.mr_n76954224)
print v(xbgr.mr_n76954544)
print v(xbgr.mr_n76954656)
print v(xbgr.mr_n76954976)
print v(xbgr.mr_n76955088)
print v(xbgr.mr_n76955408)
print v(xbgr.mr_n76955520)
print v(xbgr.mr_n76955840)
print v(xbgr.mr_n76955952)
print v(xbgr.mr_n76956272)
print v(xbgr.mr_n76956384)
print v(xbgr.mr_n76956704)
print v(xbgr.mr_n76956816)
print v(xbgr.mr_n76957136)
print v(xbgr.mr_n76957248)
print v(xbgr.mr_n76957568)
print v(xbgr.mr_n76957680)
print v(xbgr.mr_n76958000)
print v(xbgr.mr_n76958112)
print v(xbgr.mr_n76958432)
print v(xbgr.mr_n76958544)
print v(xbgr.mr_n76958864)
print v(xbgr.mr_n76958976)
print v(xbgr.mr_n76959296)
print v(xbgr.mr_n76959408)
print v(xbgr.mr_n76959728)
print v(xbgr.mr_n76959840)
print v(xbgr.mr_n76960160)
print v(xbgr.mr_n76960272)
print v(xbgr.mr_n76960592)
print v(xbgr.mr_n76960704)
print v(xbgr.mr_n76961024)
print v(xbgr.mr_n76961136)
print v(xbgr.mr_n76961456)
print v(xbgr.mr_n76961568)
print v(xbgr.mr_n76961888)
print v(xbgr.mr_n76962000)
print v(xbgr.mr_n76962320)
print v(xbgr.mr_n76962432)
print v(xbgr.mr_n76962752)
print v(xbgr.mr_n76962864)
print v(xbgr.mr_n76963184)
print v(xbgr.mr_n76963296)
print v(xbgr.mr_n76963616)
print v(xbgr.mr_n76963728)
print v(xbgr.mr_n76964048)
print v(xbgr.mr_n76964160)
print v(xbgr.mr_n76964480)
print v(xbgr.mr_n76964592)
print v(xbgr.mr_n76964912)
print v(xbgr.mr_n76965024)
print v(xbgr.mr_n76965344)
print v(xbgr.mr_n76965456)
print v(xbgr.mr_n76965776)
print v(xbgr.mr_n76965888)
print v(xbgr.mr_n76966208)
print v(xbgr.mr_n76966320)
print v(xbgr.mr_n76966640)
print v(xbgr.mr_n76966752)
print v(xbgr.mr_n76967072)
print v(xbgr.mr_n76967184)
print v(xbgr.mr_n76967504)
print v(xbgr.mr_n76967616)
print v(xbgr.mr_n76967936)
print v(xbgr.mr_n76968048)
print v(xbgr.mr_n76968368)
print v(xbgr.mr_n76968480)
print v(xbgr.mr_n76968800)
print v(xbgr.mr_n76968912)
print v(xbgr.mr_n76969232)
print v(xbgr.mr_n76969344)
print v(xbgr.mr_n76969664)
print v(xbgr.mr_n76969776)
print v(xbgr.mr_n76970096)
print v(xbgr.mr_n76970208)
print v(xbgr.mr_n76970528)
print v(xbgr.mr_n76970640)
print v(xbgr.mr_n76970960)
print v(xbgr.mr_n76971072)
print v(xbgr.mr_n76971392)
print v(xbgr.mr_n76971504)
print v(xbgr.mr_n76971824)
print v(xbgr.mr_n76971936)
print v(xbgr.mr_n76972256)
print v(xbgr.mr_n76972368)
print v(xbgr.mr_n76972688)
print v(xbgr.mr_n76972800)
print v(xbgr.mr_n76973120)
print v(xbgr.mr_n76973232)
print v(xbgr.mr_n76973552)
print v(xbgr.mr_n76973664)
print v(xbgr.mr_n76973984)
print v(xbgr.mr_n76974096)
print v(xbgr.mr_n76974416)
print v(xbgr.mr_n76974528)
print v(xbgr.mr_n76974848)
print v(xbgr.mr_n76974960)
print v(xbgr.mr_n76975280)
print v(xbgr.mr_n76975392)
print v(xbgr.mr_n76975712)
print v(xbgr.mr_n76975824)
print v(xbgr.mr_n76976144)
print v(xbgr.mr_n76976256)
print v(xbgr.mr_n76976576)
print v(xbgr.mr_n76976688)
print v(xbgr.mr_n76977008)
print v(xbgr.mr_n76977120)
print v(xbgr.mr_n76977440)
print v(xbgr.mr_n76977552)
print v(xbgr.mr_n76977872)
print v(xbgr.mr_n76977984)
print v(xbgr.mr_n76978304)
print v(xbgr.mr_n76978416)
print v(xbgr.mr_n76978736)
print v(xbgr.mr_n76978848)
print v(xbgr.mr_n76979168)
print v(xbgr.mr_n76979280)
print v(xbgr.mr_n76979600)
print v(xbgr.mr_n76979712)
print v(xbgr.mr_n76980032)
print v(xbgr.mr_n76980144)
print v(xbgr.mr_n76980464)
print v(xbgr.mr_n76980576)
print v(xbgr.mr_n76980896)
print v(xbgr.mr_n76981008)
print v(xbgr.mr_n76981328)
print v(xbgr.mr_n76981440)
print v(xbgr.mr_n76981760)
print v(xbgr.mr_n76981872)
print v(xbgr.mr_n76982192)
print v(xbgr.mr_n76982304)
print v(xbgr.mr_n76982624)
print v(xbgr.mr_n76982736)
print v(xbgr.mr_n76983056)
print v(xbgr.mr_n76983168)
print v(xbgr.mr_n76983488)
print v(xbgr.mr_n76983600)
print v(xbgr.mr_n76983920)
print v(xbgr.mr_n76984032)
print v(xbgr.mr_n76984352)
print v(xbgr.mr_n76984464)
print v(xbgr.mr_n76984784)
print v(xbgr.mr_n76984896)
print v(xbgr.mr_n76985216)
print v(xbgr.mr_n76985328)
print v(xbgr.mr_n76985648)
print v(xbgr.mr_n76985760)
print v(xbgr.mr_n76986080)
print v(xbgr.mr_n76986192)
print v(xbgr.mr_n76986512)
print v(xbgr.mr_n76986624)
print v(xbgr.mr_n76986944)
print v(xbgr.mr_n76987056)
print v(xbgr.mr_n76987376)
print v(xbgr.mr_n76987488)
print v(xbgr.mr_n76987808)
print v(xbgr.mr_n76987920)
print v(xbgr.mr_n76988240)
print v(xbgr.mr_n76988352)
print v(xbgr.mr_n76988672)
print v(xbgr.mr_n76988784)
print v(xbgr.mr_n76989104)
print v(xbgr.mr_n76989216)
print v(xbgr.mr_n76989536)
print v(xbgr.mr_n76989648)
print v(xbgr.mr_n76989968)
print v(xbgr.mr_n76990080)
print v(xbgr.mr_n76990400)
print v(xbgr.mr_n76990512)
print v(xbgr.mr_n76990832)
print v(xbgr.mr_n76990944)
print v(xbgr.mr_n76991264)
print v(xbgr.mr_n76991376)
print v(xbgr.mr_n76991808)
print v(xbgr.mr_n76992240)
print v(xbgr.mr_n76992672)
print v(xbgr.mr_n76993104)
print v(xbgr.mr_n76993536)
print v(xbgr.mr_n76993968)
print v(xbgr.mr_n76994400)
print v(xbgr.mr_n76994832)
print v(xbgr.mr_n76995264)
print v(xbgr.mr_n76995696)
print v(xbgr.mr_n76996128)
print v(xbgr.mr_n76996560)
print v(xbgr.mr_n76996992)
print v(xbgr.mr_n76997424)
print v(xbgr.mr_n76997856)
print v(xbgr.mr_n76998288)
print v(xbgr.mr_n76998720)
print v(xbgr.mr_n76999152)
print v(xbgr.mr_n76999584)
print v(xbgr.mr_n77000016)
print v(xbgr.mr_n77000448)
print v(xbgr.mr_n77000880)
print v(xbgr.mr_n77001312)
print v(xbgr.mr_n77001744)
print v(xbgr.mr_n77002176)
print v(xbgr.mr_n77002608)
print v(xbgr.mr_n77003040)
print v(xbgr.mr_n77003472)
print v(xbgr.mr_n77003904)
print v(xbgr.mr_n77004336)
print v(xbgr.mr_n77004768)
print v(xbgr.mr_n77005200)
print v(xbgr.mr_n77005632)
print v(xbgr.mr_n77006064)
print v(xbgr.mr_n77006496)
print v(xbgr.mr_n77006928)
print v(xbgr.mr_n77007360)
print v(xbgr.mr_n77007792)
print v(xbgr.mr_n77008224)
print v(xbgr.mr_n77008656)
print v(xbgr.mr_n77009088)
print v(xbgr.mr_n77009520)
print v(xbgr.mr_n77009952)
print v(xbgr.mr_n77010384)
print v(xbgr.mr_n77010816)
print v(xbgr.mr_n77011248)
print v(xbgr.mr_n77011680)
print v(xbgr.mr_n77012112)
print v(xbgr.mr_n77012544)
print v(xbgr.mr_n77012976)
print v(xbgr.mr_n77013408)
print v(xbgr.mr_n77013840)
print v(xbgr.mr_n77014272)
print v(xbgr.mr_n77014704)
print v(xbgr.mr_n77015136)
print v(xbgr.mr_n77015568)
print v(xbgr.mr_n77016000)
print v(xbgr.mr_n77016432)
print v(xbgr.mr_n77016864)
print v(xbgr.mr_n77017296)
print v(xbgr.mr_n77017728)
print v(xbgr.mr_n77018160)
print v(xbgr.mr_n77018592)
print v(xbgr.mr_n77019024)
print v(xbgr.mr_n77019456)
print v(xbgr.mr_n77019888)
print v(xbgr.mr_n77020320)
print v(xbgr.mr_n77020752)
print v(xbgr.mr_n77021184)
print v(xbgr.mr_n77021616)
print v(xbgr.mr_n77022048)
print v(xbgr.mr_n77022480)
print v(xbgr.mr_n77022912)
print v(xbgr.mr_n77023344)
print v(xbgr.mr_n77023776)
print v(xbgr.mr_n77024208)
print v(xbgr.mr_n77024640)
print v(xbgr.mr_n77025072)
print v(xbgr.mr_n77025504)
print v(xbgr.mr_n77025936)
print v(xbgr.mr_n77026368)
print v(xbgr.mr_n77026800)
print v(xbgr.mr_n77027232)
print v(xbgr.mr_n77027664)
print v(xbgr.mr_n77028096)
print v(xbgr.mr_n77028528)
print v(xbgr.mr_n77028960)
print v(xbgr.mr_n77029392)
print v(xbgr.mr_n77029824)
print v(xbgr.mr_n77030256)
print v(xbgr.mr_n77030688)
print v(xbgr.mr_n77031120)
print v(xbgr.mr_n77031552)
print v(xbgr.mr_n77031984)
print v(xbgr.mr_n77032416)
print v(xbgr.mr_n77032848)
print v(xbgr.mr_n77033280)
print v(xbgr.mr_n77033712)
print v(xbgr.mr_n77034032)
print v(xbgr.mr_n77034144)
print v(xbgr.mr_n77034464)
print v(xbgr.mr_n77034576)
print v(xbgr.mr_n77034896)
print v(xbgr.mr_n77035008)
print v(xbgr.mr_n77035328)
print v(xbgr.mr_n77035440)
print v(xbgr.mr_n77035760)
print v(xbgr.mr_n77035872)
print v(xbgr.mr_n77036192)
print v(xbgr.mr_n77036304)
print v(xbgr.mr_n77036624)
print v(xbgr.mr_n77036736)
print v(xbgr.mr_n77037056)
print v(xbgr.mr_n77037168)
print v(xbgr.mr_n77037488)
print v(xbgr.mr_n77037600)
print v(xbgr.mr_n77037920)
print v(xbgr.mr_n77038032)
print v(xbgr.mr_n77038352)
print v(xbgr.mr_n77038464)
print v(xbgr.mr_n77038784)
print v(xbgr.mr_n77038896)
print v(xbgr.mr_n77039216)
print v(xbgr.mr_n77039328)
print v(xbgr.mr_n77039648)
print v(xbgr.mr_n77039760)
print v(xbgr.mr_n77040080)
print v(xbgr.mr_n77040192)
print v(xbgr.mr_n77040512)
print v(xbgr.mr_n77040624)
print v(xbgr.mr_n77040944)
print v(xbgr.mr_n77041056)
print v(xbgr.mr_n77041376)
print v(xbgr.mr_n77041488)
print v(xbgr.mr_n77041808)
print v(xbgr.mr_n77041920)
print v(xbgr.mr_n77042240)
print v(xbgr.mr_n77042352)
print v(xbgr.mr_n77042672)
print v(xbgr.mr_n77042784)
print v(xbgr.mr_n77043104)
print v(xbgr.mr_n77043216)
print v(xbgr.mr_n77043536)
print v(xbgr.mr_n77043648)
print v(xbgr.mr_n77043968)
print v(xbgr.mr_n77044080)
print v(xbgr.mr_n77044400)
print v(xbgr.mr_n77044512)
print v(xbgr.mr_n77044832)
print v(xbgr.mr_n77044944)
print v(xbgr.mr_n77045264)
print v(xbgr.mr_n77045376)
print v(xbgr.mr_n77045696)
print v(xbgr.mr_n77045808)
print v(xbgr.mr_n77046128)
print v(xbgr.mr_n77046240)
print v(xbgr.mr_n77046560)
print v(xbgr.mr_n77046672)
print v(xbgr.mr_n77046992)
print v(xbgr.mr_n77047104)
print v(xbgr.mr_n77047424)
print v(xbgr.mr_n77047536)
print v(xbgr.mr_n77047856)
print v(xbgr.mr_n77047968)
print v(xbgr.mr_n77048288)
print v(xbgr.mr_n77048400)
print v(xbgr.mr_n77048720)
print v(xbgr.mr_n77048832)
print v(xbgr.mr_n77049152)
print v(xbgr.mr_n77049264)
print v(xbgr.mr_n77049584)
print v(xbgr.mr_n77049696)
print v(xbgr.mr_n77050016)
print v(xbgr.mr_n77050128)
print v(xbgr.mr_n77050448)
print v(xbgr.mr_n77050560)
print v(xbgr.mr_n77050880)
print v(xbgr.mr_n77050992)
print v(xbgr.mr_n77051312)
print v(xbgr.mr_n77051424)
print v(xbgr.mr_n77051744)
print v(xbgr.mr_n77051856)
print v(xbgr.mr_n77052176)
print v(xbgr.mr_n77052288)
print v(xbgr.mr_n77052608)
print v(xbgr.mr_n77052720)
print v(xbgr.mr_n77053040)
print v(xbgr.mr_n77053152)
print v(xbgr.mr_n77053472)
print v(xbgr.mr_n77053584)
print v(xbgr.mr_n77053904)
print v(xbgr.mr_n77054016)
print v(xbgr.mr_n77054336)
print v(xbgr.mr_n77054448)
print v(xbgr.mr_n77054768)
print v(xbgr.mr_n77054880)
print v(xbgr.mr_n77055200)
print v(xbgr.mr_n77055312)
print v(xbgr.mr_n77055632)
print v(xbgr.mr_n77055744)
print v(xbgr.mr_n77056064)
print v(xbgr.mr_n77056176)
print v(xbgr.mr_n77056496)
print v(xbgr.mr_n77056608)
print v(xbgr.mr_n77056928)
print v(xbgr.mr_n77057040)
print v(xbgr.mr_n77057360)
print v(xbgr.mr_n77057472)
print v(xbgr.mr_n77057792)
print v(xbgr.mr_n77057904)
print v(xbgr.mr_n77058224)
print v(xbgr.mr_n77058336)
print v(xbgr.mr_n77058656)
print v(xbgr.mr_n77058768)
print v(xbgr.mr_n77059088)
print v(xbgr.mr_n77059200)
print v(xbgr.mr_n77059520)
print v(xbgr.mr_n77059632)
print v(xbgr.mr_n77059952)
print v(xbgr.mr_n77060064)
print v(xbgr.mr_n77060384)
print v(xbgr.mr_n77060496)
print v(xbgr.mr_n77060816)
print v(xbgr.mr_n77060928)
print v(xbgr.mr_n77061248)
print v(xbgr.mr_n77061360)
print v(xbgr.mr_n77061680)
print v(xbgr.mr_n77061792)
print v(xbgr.mr_n77062112)
print v(xbgr.mr_n77062224)
print v(xbgr.mr_n77062544)
print v(xbgr.mr_n77062656)
print v(xbgr.mr_n77062976)
print v(xbgr.mr_n77063088)
print v(xbgr.mr_n77063408)
print v(xbgr.mr_n77063520)
print v(xbgr.mr_n77063840)
print v(xbgr.mr_n77063952)
print v(xbgr.mr_n77064272)
print v(xbgr.mr_n77064384)
print v(xbgr.mr_n77064704)
print v(xbgr.mr_n77064816)
print v(xbgr.mr_n77065136)
print v(xbgr.mr_n77065248)
print v(xbgr.mr_n77065568)
print v(xbgr.mr_n77065680)
print v(xbgr.mr_n77066000)
print v(xbgr.mr_n77066112)
print v(xbgr.mr_n77066432)
print v(xbgr.mr_n77066544)
print v(xbgr.mr_n77066864)
print v(xbgr.mr_n77066976)
print v(xbgr.mr_n77067296)
print v(xbgr.mr_n77067408)
print v(xbgr.mr_n77067728)
print v(xbgr.mr_n77067840)
print v(xbgr.mr_n77068160)
print v(xbgr.mr_n77068272)
print v(xbgr.mr_n77068592)
print v(xbgr.mr_n77068704)
print v(xbgr.mr_n77069024)
print v(xbgr.mr_n77069136)
print v(xbgr.mr_n77069456)
print v(xbgr.mr_n77069568)
print v(xbgr.mr_n77069888)
print v(xbgr.mr_n77070000)
print v(xbgr.mr_n77070320)
print v(xbgr.mr_n77070432)
print v(xbgr.mr_n77070752)
print v(xbgr.mr_n77070864)
print v(xbgr.mr_n77071184)
print v(xbgr.mr_n77071296)
print v(xbgr.mr_n77071616)
print v(xbgr.mr_n77071728)
print v(xbgr.mr_n77072048)
print v(xbgr.mr_n77072160)
print v(xbgr.mr_n77072480)
print v(xbgr.mr_n77072592)
print v(xbgr.mr_n77072912)
print v(xbgr.mr_n77073024)
print v(xbgr.mr_n77073344)
print v(xbgr.mr_n77073456)
print v(xbgr.mr_n77073776)
print v(xbgr.mr_n77073888)
print v(xbgr.mr_n77074208)
print v(xbgr.mr_n77074320)
print v(xbgr.mr_n77074640)
print v(xbgr.mr_n77074752)
print v(xbgr.mr_n77075072)
print v(xbgr.mr_n77075184)
print v(xbgr.mr_n77075504)
print v(xbgr.mr_n77075616)
print v(xbgr.mr_n77075936)
print v(xbgr.mr_n77076048)
print v(xbgr.mr_n77076368)
print v(xbgr.mr_n77076480)
print v(xbgr.mr_n77076800)
print v(xbgr.mr_n77076912)
print v(xbgr.mr_n77077232)
print v(xbgr.mr_n77077344)
print v(xbgr.mr_n77077664)
print v(xbgr.mr_n77077776)
print v(xbgr.mr_n77078096)
print v(xbgr.mr_n77078208)
print v(xbgr.mr_n77078528)
print v(xbgr.mr_n77078640)
print v(xbgr.mr_n77078960)
print v(xbgr.mr_n77079072)
print v(xbgr.mr_n77079392)
print v(xbgr.mr_n77079504)
print v(xbgr.mr_n77079824)
print v(xbgr.mr_n77079936)
print v(xbgr.mr_n77080256)
print v(xbgr.mr_n77080368)
print v(xbgr.mr_n77080688)
print v(xbgr.mr_n77080800)
print v(xbgr.mr_n77081120)
print v(xbgr.mr_n77081232)
print v(xbgr.mr_n77081552)
print v(xbgr.mr_n77081664)
print v(xbgr.mr_n77081984)
print v(xbgr.mr_n77082096)
print v(xbgr.mr_n77082416)
print v(xbgr.mr_n77082528)
print v(xbgr.mr_n77082848)
print v(xbgr.mr_n77082960)
print v(xbgr.mr_n77083280)
print v(xbgr.mr_n77083392)
print v(xbgr.mr_n77083712)
print v(xbgr.mr_n77083824)
print v(xbgr.mr_n77084144)
print v(xbgr.mr_n77084256)
print v(xbgr.mr_n77084576)
print v(xbgr.mr_n77084688)
print v(xbgr.mr_n77085008)
print v(xbgr.mr_n77085120)
print v(xbgr.mr_n77085440)
print v(xbgr.mr_n77085552)
print v(xbgr.mr_n77085872)
print v(xbgr.mr_n77085984)
print v(xbgr.mr_n77086304)
print v(xbgr.mr_n77086416)
print v(xbgr.mr_n77086736)
print v(xbgr.mr_n77086848)
print v(xbgr.mr_n77087168)
print v(xbgr.mr_n77087280)
print v(xbgr.mr_n77087600)
print v(xbgr.mr_n77087712)
print v(xbgr.mr_n77088032)
print v(xbgr.mr_n77088144)
print v(xbgr.mr_n77088464)
print v(xbgr.mr_n77088576)
print v(xbgr.mr_n77088896)
print v(xbgr.mr_n77089008)
print v(xbgr.mr_n77089328)
print v(xbgr.mr_n77089440)
print v(xbgr.mr_n77089760)
print v(xbgr.mr_n77089872)
print v(xbgr.mr_n77090192)
print v(xbgr.mr_n77090304)
print v(xbgr.mr_n77090624)
print v(xbgr.mr_n77090736)
print v(xbgr.mr_n77091056)
print v(xbgr.mr_n77091168)
print v(xbgr.mr_n77091488)
print v(xbgr.mr_n77091600)
print v(xbgr.mr_n77091920)
print v(xbgr.mr_n77092032)
print v(xbgr.mr_n77092352)
print v(xbgr.mr_n77092464)
print v(xbgr.mr_n77092784)
print v(xbgr.mr_n77092896)
print v(xbgr.mr_n77093216)
print v(xbgr.mr_n77093328)
print v(xbgr.mr_n77093648)
print v(xbgr.mr_n77093760)
print v(xbgr.mr_n77094080)
print v(xbgr.mr_n77094192)
print v(xbgr.mr_n77094512)
print v(xbgr.mr_n77094624)
print v(xbgr.mr_n77094944)
print v(xbgr.mr_n77095056)
print v(xbgr.mr_n77095376)
print v(xbgr.mr_n77095488)
print v(xbgr.mr_n77095808)
print v(xbgr.mr_n77095920)
print v(xbgr.mr_n77096240)
print v(xbgr.mr_n77096352)
print v(xbgr.mr_n77096672)
print v(xbgr.mr_n77096784)
print v(xbgr.mr_n77097216)
print v(xbgr.mr_n77097648)
print v(xbgr.mr_n77098080)
print v(xbgr.mr_n77098512)
print v(xbgr.mr_n77098944)
print v(xbgr.mr_n77099376)
print v(xbgr.mr_n77099808)
print v(xbgr.mr_n77100240)
print v(xbgr.mr_n77100672)
print v(xbgr.mr_n77101104)
print v(xbgr.mr_n77101536)
print v(xbgr.mr_n77101968)
print v(xbgr.mr_n77102400)
print v(xbgr.mr_n77102832)
print v(xbgr.mr_n77103264)
print v(xbgr.mr_n77103696)
print v(xbgr.mr_n77104128)
print v(xbgr.mr_n77104560)
print v(xbgr.mr_n77104992)
print v(xbgr.mr_n77105424)
print v(xbgr.mr_n77105856)
print v(xbgr.mr_n77106288)
print v(xbgr.mr_n77106720)
print v(xbgr.mr_n77107152)
print v(xbgr.mr_n77107584)
print v(xbgr.mr_n77108016)
print v(xbgr.mr_n77108448)
print v(xbgr.mr_n77108880)
print v(xbgr.mr_n77109312)
print v(xbgr.mr_n77109744)
print v(xbgr.mr_n77110176)
print v(xbgr.mr_n77110608)
print v(xbgr.mr_n77111040)
print v(xbgr.mr_n77111472)
print v(xbgr.mr_n77111904)
print v(xbgr.mr_n77112336)
print v(xbgr.mr_n77112768)
print v(xbgr.mr_n77113200)
print v(xbgr.mr_n77113632)
print v(xbgr.mr_n77114064)
print v(xbgr.mr_n77114496)
print v(xbgr.mr_n77114928)
print v(xbgr.mr_n77115360)
print v(xbgr.mr_n77115792)
print v(xbgr.mr_n77116224)
print v(xbgr.mr_n77116656)
print v(xbgr.mr_n77117088)
print v(xbgr.mr_n77117520)
print v(xbgr.mr_n77117952)
print v(xbgr.mr_n77118384)
print v(xbgr.mr_n77118816)
print v(xbgr.mr_n77119248)
print v(xbgr.mr_n77119680)
print v(xbgr.mr_n77120112)
print v(xbgr.mr_n77120544)
print v(xbgr.mr_n77120976)
print v(xbgr.mr_n77121408)
print v(xbgr.mr_n77121840)
print v(xbgr.mr_n77122272)
print v(xbgr.mr_n77122704)
print v(xbgr.mr_n77123136)
print v(xbgr.mr_n77123568)
print v(xbgr.mr_n77124000)
print v(xbgr.mr_n77124432)
print v(xbgr.mr_n77124864)
print v(xbgr.mr_n77125296)
print v(xbgr.mr_n77125728)
print v(xbgr.mr_n77126160)
print v(xbgr.mr_n77126592)
print v(xbgr.mr_n77127024)
print v(xbgr.mr_n77127456)
print v(xbgr.mr_n77127888)
print v(xbgr.mr_n77128320)
print v(xbgr.mr_n77128752)
print v(xbgr.mr_n77129184)
print v(xbgr.mr_n77129616)
print v(xbgr.mr_n77130048)
print v(xbgr.mr_n77130480)
print v(xbgr.mr_n77130912)
print v(xbgr.mr_n77131344)
print v(xbgr.mr_n77131776)
print v(xbgr.mr_n77132208)
print v(xbgr.mr_n77132640)
print v(xbgr.mr_n77133072)
print v(xbgr.mr_n77133504)
print v(xbgr.mr_n77133936)
print v(xbgr.mr_n77134368)
print v(xbgr.mr_n77134800)
print v(xbgr.mr_n77135232)
print v(xbgr.mr_n77135664)
print v(xbgr.mr_n77136096)
print v(xbgr.mr_n77136528)
print v(xbgr.mr_n77136960)
print v(xbgr.mr_n77137392)
print v(xbgr.mr_n77137824)
print v(xbgr.mr_n77138256)
print v(xbgr.mr_n77138688)
print v(xbgr.mr_n77139120)
print v(xbgr.mr_n77139552)
print v(xbgr.mr_n77139984)
print v(xbgr.mr_n77140416)
print v(xbgr.mr_n77140848)
print v(xbgr.mr_n77141280)
print v(xbgr.mr_n77141712)
print v(xbgr.mr_n77142144)
print v(xbgr.mr_n77142576)
print v(xbgr.mr_n77143008)
print v(xbgr.mr_n77143440)
print v(xbgr.mr_n77143872)
print v(xbgr.mr_n77144304)
print v(xbgr.mr_n77144736)
print v(xbgr.mr_n77145168)
print v(xbgr.mr_n77145600)
print v(xbgr.mr_n77146032)
print v(xbgr.mr_n77146464)
print v(xbgr.mr_n77146896)
print v(xbgr.mr_n77147328)
print v(xbgr.mr_n77147760)
print v(xbgr.mr_n77148192)
print v(xbgr.mr_n77148624)
print v(xbgr.mr_n77149056)
print v(xbgr.mr_n77149488)
print v(xbgr.mr_n77149920)
print v(xbgr.mr_n77150352)
print v(xbgr.mr_n77150784)
print v(xbgr.mr_n77151216)
print v(xbgr.mr_n77151648)
print v(xbgr.mr_n77152080)
print v(xbgr.mr_n77152512)
print v(xbgr.mr_n77152944)
print v(xbgr.mr_n77153376)
print v(xbgr.mr_n77153808)
print v(xbgr.mr_n77154240)
print v(xbgr.mr_n77154672)
print v(xbgr.mr_n77155104)
print v(xbgr.mr_n77155536)
print v(xbgr.mr_n77155968)
print v(xbgr.mr_n77156400)
print v(xbgr.mr_n77156832)
print v(xbgr.mr_n77157264)
print v(xbgr.mr_n77157696)
print v(xbgr.mr_n77158128)
print v(xbgr.mr_n77158560)
print v(xbgr.mr_n77158992)
print v(xbgr.mr_n77159424)
print v(xbgr.mr_n77159856)
print v(xbgr.mr_n77160288)
print v(xbgr.mr_n77160720)
print v(xbgr.mr_n77161152)
print v(xbgr.mr_n77161584)
print v(xbgr.mr_n77162016)
print v(xbgr.mr_n77162448)
print v(xbgr.mr_n77162880)
print v(xbgr.mr_n77163312)
print v(xbgr.mr_n77163744)
print v(xbgr.mr_n77164176)
print v(xbgr.mr_n77164608)
print v(xbgr.mr_n77165040)
print v(xbgr.mr_n77165472)
print v(xbgr.mr_n77165904)
print v(xbgr.mr_n77166336)
print v(xbgr.mr_n77166768)
print v(xbgr.mr_n77167200)
print v(xbgr.mr_n77167632)
print v(xbgr.mr_n77168064)
print v(xbgr.mr_n77168496)
print v(xbgr.mr_n77168928)
print v(xbgr.mr_n77169360)
print v(xbgr.mr_n77169792)
print v(xbgr.mr_n77170224)
print v(xbgr.mr_n77170656)
print v(xbgr.mr_n77171088)
print v(xbgr.mr_n77171520)
print v(xbgr.mr_n77171952)
print v(xbgr.mr_n77172384)
print v(xbgr.mr_n77172816)
print v(xbgr.mr_n77173248)
print v(xbgr.mr_n77173680)
print v(xbgr.mr_n77174112)
print v(xbgr.mr_n77174544)
print v(xbgr.mr_n77174976)
print v(xbgr.mr_n77175408)
print v(xbgr.mr_n77175840)
print v(xbgr.mr_n77176272)
print v(xbgr.mr_n77176704)
print v(xbgr.mr_n77177136)
print v(xbgr.mr_n77177568)
print v(xbgr.mr_n77178000)
print v(xbgr.mr_n77178432)
print v(xbgr.mr_n77178864)
print v(xbgr.mr_n77179296)
print v(xbgr.mr_n77179728)
print v(xbgr.mr_n77180160)
print v(xbgr.mr_n77180592)
print v(xbgr.mr_n77181024)
print v(xbgr.mr_n77181456)
print v(xbgr.mr_n77181888)
print v(xbgr.mr_n77182320)
print v(xbgr.mr_n77182752)
print v(xbgr.mr_n77183184)
print v(xbgr.mr_n77183616)
print v(xbgr.mr_n77184048)
print v(xbgr.mr_n77184480)
print v(xbgr.mr_n77184912)
print v(xbgr.mr_n77185344)
print v(xbgr.mr_n77185776)
print v(xbgr.mr_n77186208)
print v(xbgr.mr_n77186640)
print v(xbgr.mr_n77187072)
print v(xbgr.mr_n77187504)
print v(xbgr.mr_n77187936)
print v(xbgr.mr_n77188368)
print v(xbgr.mr_n77188800)
print v(xbgr.mr_n77189232)
print v(xbgr.mr_n77189552)
print v(xbgr.mr_n77189664)
print v(xbgr.mr_n77189984)
print v(xbgr.mr_n77190096)
print v(xbgr.mr_n77190416)
print v(xbgr.mr_n77190528)
print v(xbgr.mr_n77190848)
print v(xbgr.mr_n77190960)
print v(xbgr.mr_n77191280)
print v(xbgr.mr_n77191392)
print v(xbgr.mr_n77191712)
print v(xbgr.mr_n77191824)
print v(xbgr.mr_n77192144)
print v(xbgr.mr_n77192256)
print v(xbgr.mr_n77192576)
print v(xbgr.mr_n77192688)
print v(xbgr.mr_n77193008)
print v(xbgr.mr_n77193120)
print v(xbgr.mr_n77193440)
print v(xbgr.mr_n77193552)
print v(xbgr.mr_n77193872)
print v(xbgr.mr_n77193984)
print v(xbgr.mr_n77194304)
print v(xbgr.mr_n77194416)
print v(xbgr.mr_n77194736)
print v(xbgr.mr_n77194848)
print v(xbgr.mr_n77195168)
print v(xbgr.mr_n77195280)
print v(xbgr.mr_n77195600)
print v(xbgr.mr_n77195712)
print v(xbgr.mr_n77196032)
print v(xbgr.mr_n77196144)
print v(xbgr.mr_n77196464)
print v(xbgr.mr_n77196576)
print v(xbgr.mr_n77196896)
print v(xbgr.mr_n77197008)
print v(xbgr.mr_n77197328)
print v(xbgr.mr_n77197440)
print v(xbgr.mr_n77197760)
print v(xbgr.mr_n77197872)
print v(xbgr.mr_n77198192)
print v(xbgr.mr_n77198304)
print v(xbgr.mr_n77198624)
print v(xbgr.mr_n77198736)
print v(xbgr.mr_n77199056)
print v(xbgr.mr_n77199168)
print v(xbgr.mr_n77199488)
print v(xbgr.mr_n77199600)
print v(xbgr.mr_n77199920)
print v(xbgr.mr_n77200032)
print v(xbgr.mr_n77200352)
print v(xbgr.mr_n77200464)
print v(xbgr.mr_n77200784)
print v(xbgr.mr_n77200896)
print v(xbgr.mr_n77201216)
print v(xbgr.mr_n77201328)
print v(xbgr.mr_n77201648)
print v(xbgr.mr_n77201760)
print v(xbgr.mr_n77202080)
print v(xbgr.mr_n77202192)
print v(xbgr.mr_n77202512)
print v(xbgr.mr_n77202624)
print v(xbgr.mr_n77202944)
print v(xbgr.mr_n77203056)
print v(xbgr.mr_n77203376)
print v(xbgr.mr_n77203488)
print v(xbgr.mr_n77203808)
print v(xbgr.mr_n77203920)
print v(xbgr.mr_n77204240)
print v(xbgr.mr_n77204352)
print v(xbgr.mr_n77204672)
print v(xbgr.mr_n77204784)
print v(xbgr.mr_n77205104)
print v(xbgr.mr_n77205216)
print v(xbgr.mr_n77205536)
print v(xbgr.mr_n77205648)
print v(xbgr.mr_n77205968)
print v(xbgr.mr_n77206080)
print v(xbgr.mr_n77206400)
print v(xbgr.mr_n77206512)
print v(xbgr.mr_n77206832)
print v(xbgr.mr_n77206944)
print v(xbgr.mr_n77207264)
print v(xbgr.mr_n77207376)
print v(xbgr.mr_n77207696)
print v(xbgr.mr_n77207808)
print v(xbgr.mr_n77208128)
print v(xbgr.mr_n77208240)
print v(xbgr.mr_n77208560)
print v(xbgr.mr_n77208672)
print v(xbgr.mr_n77208992)
print v(xbgr.mr_n77209104)
print v(xbgr.mr_n77209424)
print v(xbgr.mr_n77209536)
print v(xbgr.mr_n77209856)
print v(xbgr.mr_n77209968)
print v(xbgr.mr_n77210288)
print v(xbgr.mr_n77210400)
print v(xbgr.mr_n77210720)
print v(xbgr.mr_n77210832)
print v(xbgr.mr_n77211152)
print v(xbgr.mr_n77211264)
print v(xbgr.mr_n77211584)
print v(xbgr.mr_n77211696)
print v(xbgr.mr_n77212016)
print v(xbgr.mr_n77212128)
print v(xbgr.mr_n77212448)
print v(xbgr.mr_n77212560)
print v(xbgr.mr_n77212880)
print v(xbgr.mr_n77212992)
print v(xbgr.mr_n77213312)
print v(xbgr.mr_n77213424)
print v(xbgr.mr_n77213744)
print v(xbgr.mr_n77213856)
print v(xbgr.mr_n77214176)
print v(xbgr.mr_n77214288)
print v(xbgr.mr_n77214608)
print v(xbgr.mr_n77214720)
print v(xbgr.mr_n77215040)
print v(xbgr.mr_n77215152)
print v(xbgr.mr_n77215472)
print v(xbgr.mr_n77215584)
print v(xbgr.mr_n77215904)
print v(xbgr.mr_n77216016)
print v(xbgr.mr_n77216336)
print v(xbgr.mr_n77216448)
print v(xbgr.mr_n77216768)
print v(xbgr.mr_n77216880)
print v(xbgr.mr_n77217200)
print v(xbgr.mr_n77217312)
print v(xbgr.mr_n77217632)
print v(xbgr.mr_n77217744)
print v(xbgr.mr_n77218064)
print v(xbgr.mr_n77218176)
print v(xbgr.mr_n77218496)
print v(xbgr.mr_n77218608)
print v(xbgr.mr_n77218928)
print v(xbgr.mr_n77219040)
print v(xbgr.mr_n77219360)
print v(xbgr.mr_n77219472)
print v(xbgr.mr_n77219792)
print v(xbgr.mr_n77219904)
print v(xbgr.mr_n77220224)
print v(xbgr.mr_n77220336)
print v(xbgr.mr_n77220656)
print v(xbgr.mr_n77220768)
print v(xbgr.mr_n77221088)
print v(xbgr.mr_n77221200)
print v(xbgr.mr_n77221520)
print v(xbgr.mr_n77221632)
print v(xbgr.mr_n77221952)
print v(xbgr.mr_n77222064)
print v(xbgr.mr_n77222384)
print v(xbgr.mr_n77222496)
print v(xbgr.mr_n77222816)
print v(xbgr.mr_n77222928)
print v(xbgr.mr_n77223248)
print v(xbgr.mr_n77223360)
print v(xbgr.mr_n77223680)
print v(xbgr.mr_n77223792)
print v(xbgr.mr_n77224112)
print v(xbgr.mr_n77224224)
print v(xbgr.mr_n77224544)
print v(xbgr.mr_n77224656)
print v(xbgr.mr_n77224976)
print v(xbgr.mr_n77225088)
print v(xbgr.mr_n77225408)
print v(xbgr.mr_n77225520)
print v(xbgr.mr_n77225840)
print v(xbgr.mr_n77225952)
print v(xbgr.mr_n77226272)
print v(xbgr.mr_n77226384)
print v(xbgr.mr_n77226704)
print v(xbgr.mr_n77226816)
print v(xbgr.mr_n77227136)
print v(xbgr.mr_n77227248)
print v(xbgr.mr_n77227568)
print v(xbgr.mr_n77227680)
print v(xbgr.mr_n77228000)
print v(xbgr.mr_n77228112)
print v(xbgr.mr_n77228432)
print v(xbgr.mr_n77228544)
print v(xbgr.mr_n77228864)
print v(xbgr.mr_n77228976)
print v(xbgr.mr_n77229296)
print v(xbgr.mr_n77229408)
print v(xbgr.mr_n77229728)
print v(xbgr.mr_n77229840)
print v(xbgr.mr_n77230160)
print v(xbgr.mr_n77230272)
print v(xbgr.mr_n77230592)
print v(xbgr.mr_n77230704)
print v(xbgr.mr_n77231024)
print v(xbgr.mr_n77231136)
print v(xbgr.mr_n77231456)
print v(xbgr.mr_n77231568)
print v(xbgr.mr_n77231888)
print v(xbgr.mr_n77232000)
print v(xbgr.mr_n77232320)
print v(xbgr.mr_n77232432)
print v(xbgr.mr_n77232752)
print v(xbgr.mr_n77232864)
print v(xbgr.mr_n77233184)
print v(xbgr.mr_n77233296)
print v(xbgr.mr_n77233616)
print v(xbgr.mr_n77233728)
print v(xbgr.mr_n77234048)
print v(xbgr.mr_n77234160)
print v(xbgr.mr_n77234480)
print v(xbgr.mr_n77234592)
print v(xbgr.mr_n77234912)
print v(xbgr.mr_n77235024)
print v(xbgr.mr_n77235344)
print v(xbgr.mr_n77235456)
print v(xbgr.mr_n77235776)
print v(xbgr.mr_n77235888)
print v(xbgr.mr_n77236208)
print v(xbgr.mr_n77236320)
print v(xbgr.mr_n77236640)
print v(xbgr.mr_n77236752)
print v(xbgr.mr_n77237072)
print v(xbgr.mr_n77237184)
print v(xbgr.mr_n77237504)
print v(xbgr.mr_n77237616)
print v(xbgr.mr_n77237936)
print v(xbgr.mr_n77238048)
print v(xbgr.mr_n77238368)
print v(xbgr.mr_n77238480)
print v(xbgr.mr_n77238800)
print v(xbgr.mr_n77238912)
print v(xbgr.mr_n77239232)
print v(xbgr.mr_n77239344)
print v(xbgr.mr_n77239664)
print v(xbgr.mr_n77239776)
print v(xbgr.mr_n77240096)
print v(xbgr.mr_n77240208)
print v(xbgr.mr_n77240528)
print v(xbgr.mr_n77240640)
print v(xbgr.mr_n77240960)
print v(xbgr.mr_n77241072)
print v(xbgr.mr_n77241392)
print v(xbgr.mr_n77241504)
print v(xbgr.mr_n77241824)
print v(xbgr.mr_n77241936)
print v(xbgr.mr_n77242256)
print v(xbgr.mr_n77242368)
print v(xbgr.mr_n77242688)
print v(xbgr.mr_n77242800)
print v(xbgr.mr_n77243120)
print v(xbgr.mr_n77243232)
print v(xbgr.mr_n77243552)
print v(xbgr.mr_n77243664)
print v(xbgr.mr_n77243984)
print v(xbgr.mr_n77244096)
print v(xbgr.mr_n77244416)
print v(xbgr.mr_n77244528)
print v(xbgr.mr_n77244848)
print v(xbgr.mr_n77244960)
print v(xbgr.mr_n77245280)
print v(xbgr.mr_n77245392)
print v(xbgr.mr_n77245712)
print v(xbgr.mr_n77245824)
print v(xbgr.mr_n77246144)
print v(xbgr.mr_n77246256)
print v(xbgr.mr_n77246576)
print v(xbgr.mr_n77246688)
print v(xbgr.mr_n77247008)
print v(xbgr.mr_n77247120)
print v(xbgr.mr_n77247440)
print v(xbgr.mr_n77247552)
print v(xbgr.mr_n77247872)
print v(xbgr.mr_n77247984)
print v(xbgr.mr_n77248304)
print v(xbgr.mr_n77248416)
print v(xbgr.mr_n77248736)
print v(xbgr.mr_n77248848)
print v(xbgr.mr_n77249168)
print v(xbgr.mr_n77249280)
print v(xbgr.mr_n77249600)
print v(xbgr.mr_n77249712)
print v(xbgr.mr_n77250032)
print v(xbgr.mr_n77250144)
print v(xbgr.mr_n77250464)
print v(xbgr.mr_n77250576)
print v(xbgr.mr_n77250896)
print v(xbgr.mr_n77251008)
print v(xbgr.mr_n77251328)
print v(xbgr.mr_n77251440)
print v(xbgr.mr_n77251760)
print v(xbgr.mr_n77251872)
print v(xbgr.mr_n77252192)
print v(xbgr.mr_n77252304)
print v(xbgr.mr_n77252624)
print v(xbgr.mr_n77252736)
print v(xbgr.mr_n77253056)
print v(xbgr.mr_n77253168)
print v(xbgr.mr_n77253488)
print v(xbgr.mr_n77253600)
print v(xbgr.mr_n77253920)
print v(xbgr.mr_n77254032)
print v(xbgr.mr_n77254352)
print v(xbgr.mr_n77254464)
print v(xbgr.mr_n77254784)
print v(xbgr.mr_n77254896)
print v(xbgr.mr_n77255216)
print v(xbgr.mr_n77255328)
print v(xbgr.mr_n77255648)
print v(xbgr.mr_n77255760)
print v(xbgr.mr_n77256080)
print v(xbgr.mr_n77256192)
print v(xbgr.mr_n77256512)
print v(xbgr.mr_n77256624)
print v(xbgr.mr_n77256944)
print v(xbgr.mr_n77257056)
print v(xbgr.mr_n77257376)
print v(xbgr.mr_n77257488)
print v(xbgr.mr_n77257808)
print v(xbgr.mr_n77257920)
print v(xbgr.mr_n77258240)
print v(xbgr.mr_n77258352)
print v(xbgr.mr_n77258672)
print v(xbgr.mr_n77258784)
print v(xbgr.mr_n77259104)
print v(xbgr.mr_n77259216)
print v(xbgr.mr_n77259536)
print v(xbgr.mr_n77259648)
print v(xbgr.mr_n77259968)
print v(xbgr.mr_n77260080)
print v(xbgr.mr_n77260400)
print v(xbgr.mr_n77260512)
print v(xbgr.mr_n77260832)
print v(xbgr.mr_n77260944)
print v(xbgr.mr_n77261264)
print v(xbgr.mr_n77261376)
print v(xbgr.mr_n77261696)
print v(xbgr.mr_n77261808)
print v(xbgr.mr_n77262128)
print v(xbgr.mr_n77262240)
print v(xbgr.mr_n77262560)
print v(xbgr.mr_n77262672)
print v(xbgr.mr_n77262992)
print v(xbgr.mr_n77263104)
print v(xbgr.mr_n77263424)
print v(xbgr.mr_n77263536)
print v(xbgr.mr_n77263856)
print v(xbgr.mr_n77263968)
print v(xbgr.mr_n77264288)
print v(xbgr.mr_n77264400)
print v(xbgr.mr_n77264720)
print v(xbgr.mr_n77264832)
print v(xbgr.mr_n77265152)
print v(xbgr.mr_n77265264)
print v(xbgr.mr_n77265584)
print v(xbgr.mr_n77265696)
print v(xbgr.mr_n77266016)
print v(xbgr.mr_n77266128)
print v(xbgr.mr_n77266448)
print v(xbgr.mr_n77266560)
print v(xbgr.mr_n77266880)
print v(xbgr.mr_n77266992)
print v(xbgr.mr_n77267312)
print v(xbgr.mr_n77267424)
print v(xbgr.mr_n77267744)
print v(xbgr.mr_n77267856)
print v(xbgr.mr_n77268176)
print v(xbgr.mr_n77268288)
print v(xbgr.mr_n77268608)
print v(xbgr.mr_n77268720)
print v(xbgr.mr_n77269040)
print v(xbgr.mr_n77269152)
print v(xbgr.mr_n77269472)
print v(xbgr.mr_n77269584)
print v(xbgr.mr_n77269904)
print v(xbgr.mr_n77270016)
print v(xbgr.mr_n77270336)
print v(xbgr.mr_n77270448)
print v(xbgr.mr_n77270768)
print v(xbgr.mr_n77270880)
print v(xbgr.mr_n77271200)
print v(xbgr.mr_n77271312)
print v(xbgr.mr_n77271632)
print v(xbgr.mr_n77271744)
print v(xbgr.mr_n77272064)
print v(xbgr.mr_n77272176)
print v(xbgr.mr_n77272496)
print v(xbgr.mr_n77272608)
print v(xbgr.mr_n77272928)
print v(xbgr.mr_n77273040)
print v(xbgr.mr_n77273360)
print v(xbgr.mr_n77273472)
print v(xbgr.mr_n77273792)
print v(xbgr.mr_n77273904)
print v(xbgr.mr_n77274224)
print v(xbgr.mr_n77274336)
print v(xbgr.mr_n77274656)
print v(xbgr.mr_n77274768)
print v(xbgr.mr_n77275088)
print v(xbgr.mr_n77275200)
print v(xbgr.mr_n77275520)
print v(xbgr.mr_n77275632)
print v(xbgr.mr_n77275952)
print v(xbgr.mr_n77276064)
print v(xbgr.mr_n77276384)
print v(xbgr.mr_n77276496)
print v(xbgr.mr_n77276816)
print v(xbgr.mr_n77276928)
print v(xbgr.mr_n77277248)
print v(xbgr.mr_n77277360)
print v(xbgr.mr_n77277680)
print v(xbgr.mr_n77277792)
print v(xbgr.mr_n77278112)
print v(xbgr.mr_n77278224)
print v(xbgr.mr_n77278544)
print v(xbgr.mr_n77278656)
print v(xbgr.mr_n77278976)
print v(xbgr.mr_n77279088)
print v(xbgr.mr_n77279408)
print v(xbgr.mr_n77279520)
print v(xbgr.mr_n77279840)
print v(xbgr.mr_n77279952)
print v(xbgr.mr_n77280272)
print v(xbgr.mr_n77280384)
print v(xbgr.mr_n77280704)
print v(xbgr.mr_n77280816)
print v(xbgr.mr_n77281136)
print v(xbgr.mr_n77281248)
print v(xbgr.mr_n77281568)
print v(xbgr.mr_n77281680)
print v(xbgr.mr_n77282000)
print v(xbgr.mr_n77282112)
print v(xbgr.mr_n77282432)
print v(xbgr.mr_n77282544)
print v(xbgr.mr_n77282864)
print v(xbgr.mr_n77282976)
print v(xbgr.mr_n77283296)
print v(xbgr.mr_n77283408)
print v(xbgr.mr_n77284272)
print v(xbgr.mr_n77284704)
print v(xbgr.mr_n77285136)
print v(xbgr.mr_n77285568)
print v(xbgr.mr_n77286000)
print v(xbgr.mr_n77286432)
print v(xbgr.mr_n77286864)
print v(xbgr.mr_n77287296)
print v(xbgr.mr_n77287728)
print v(xbgr.mr_n77288160)
print v(xbgr.mr_n77288592)
print v(xbgr.mr_n77289024)
print v(xbgr.mr_n77289456)
print v(xbgr.mr_n77289888)
print v(xbgr.mr_n77290320)
print v(xbgr.mr_n77290752)
print v(xbgr.mr_n77291184)
print v(xbgr.mr_n77291616)
print v(xbgr.mr_n77292048)
print v(xbgr.mr_n77292480)
print v(xbgr.mr_n77292912)
print v(xbgr.mr_n77293344)
print v(xbgr.mr_n77293776)
print v(xbgr.mr_n77294208)
print v(xbgr.mr_n77296368)
print v(xbgr.mr_n77296800)
print v(xbgr.mr_n77297232)
print v(xbgr.mr_n77297664)
print v(xbgr.mr_n77298096)
print v(xbgr.mr_n77298528)
print v(xbgr.mr_n77298960)
print v(xbgr.mr_n77299392)
print v(xbgr.mr_n77299824)
print v(xbgr.mr_n77300256)
print v(xbgr.mr_n77300688)
print v(xbgr.mr_n77301120)
print v(xbgr.mr_n77301552)
print v(xbgr.mr_n77301984)
print v(xbgr.mr_n77302416)
print v(xbgr.mr_n77302848)
print v(xbgr.mr_n77303280)
print v(xbgr.mr_n77303712)
print v(xbgr.mr_n77304144)
print v(xbgr.mr_n77304576)
print v(xbgr.mr_n77305008)
print v(xbgr.mr_n77305440)
print v(xbgr.mr_n77305872)
print v(xbgr.mr_n77306304)
print v(xbgr.mr_n77310192)
print v(xbgr.mr_n77310624)
print v(xbgr.mr_n77311056)
print v(xbgr.mr_n77311488)
print v(xbgr.mr_n77311920)
print v(xbgr.mr_n77312352)
print v(xbgr.mr_n77312784)
print v(xbgr.mr_n77313216)
print v(xbgr.mr_n77313648)
print v(xbgr.mr_n77314080)
print v(xbgr.mr_n77314512)
print v(xbgr.mr_n77314944)
print v(xbgr.mr_n77315376)
print v(xbgr.mr_n77315808)
print v(xbgr.mr_n77316240)
print v(xbgr.mr_n77317536)
print v(xbgr.mr_n77317968)
print v(xbgr.mr_n77318400)
print v(xbgr.mr_n77318832)
print v(xbgr.mr_n77319264)
print v(xbgr.mr_n77319696)
print v(xbgr.mr_n77320128)
print v(xbgr.mr_n77320560)
print v(xbgr.mr_n77320992)
print v(xbgr.mr_n77321424)
print v(xbgr.mr_n77322720)
print v(xbgr.mr_n77323152)
print v(xbgr.mr_n77323584)
print v(xbgr.mr_n77324016)
print v(xbgr.mr_n77324448)
print v(xbgr.mr_n77324880)
print v(xbgr.mr_n77325312)
print v(xbgr.mr_n77325744)
print v(xbgr.mr_n77326064)
print v(xbgr.mr_n77326176)
print v(xbgr.mr_n77326496)
print v(xbgr.mr_n77326608)
print v(xbgr.mr_n77326928)
print v(xbgr.mr_n77327040)
print v(xbgr.mr_n77327360)
print v(xbgr.mr_n77327472)
print v(xbgr.mr_n77327792)
print v(xbgr.mr_n77327904)
print v(xbgr.mr_n77328224)
print v(xbgr.mr_n77328336)
print v(xbgr.mr_n77328656)
print v(xbgr.mr_n77328768)
print v(xbgr.mr_n77329088)
print v(xbgr.mr_n77329200)
print v(xbgr.mr_n77329520)
print v(xbgr.mr_n77329632)
print v(xbgr.mr_n77329952)
print v(xbgr.mr_n77330064)
print v(xbgr.mr_n77330384)
print v(xbgr.mr_n77330496)
print v(xbgr.mr_n77330816)
print v(xbgr.mr_n77330928)
print v(xbgr.mr_n77331248)
print v(xbgr.mr_n77331360)
print v(xbgr.mr_n77331680)
print v(xbgr.mr_n77331792)
print v(xbgr.mr_n77332112)
print v(xbgr.mr_n77332224)
print v(xbgr.mr_n77332544)
print v(xbgr.mr_n77332656)
print v(xbgr.mr_n77332976)
print v(xbgr.mr_n77333088)
print v(xbgr.mr_n77333408)
print v(xbgr.mr_n77333520)
print v(xbgr.mr_n77333840)
print v(xbgr.mr_n77333952)
print v(xbgr.mr_n77334272)
print v(xbgr.mr_n77334384)
print v(xbgr.mr_n77334704)
print v(xbgr.mr_n77334816)
print v(xbgr.mr_n77335136)
print v(xbgr.mr_n77335248)
print v(xbgr.mr_n77335568)
print v(xbgr.mr_n77335680)
print v(xbgr.mr_n77336000)
print v(xbgr.mr_n77336112)
print v(xbgr.mr_n77336432)
print v(xbgr.mr_n77336544)
print v(xbgr.mr_n77336864)
print v(xbgr.mr_n77336976)
print v(xbgr.mr_n77337296)
print v(xbgr.mr_n77337408)
print v(xbgr.mr_n77337728)
print v(xbgr.mr_n77337840)
print v(xbgr.mr_n77338160)
print v(xbgr.mr_n77338272)
print v(xbgr.mr_n77338592)
print v(xbgr.mr_n77338704)
print v(xbgr.mr_n77339024)
print v(xbgr.mr_n77339136)
print v(xbgr.mr_n77339456)
print v(xbgr.mr_n77339568)
print v(xbgr.mr_n77339888)
print v(xbgr.mr_n77340000)
print v(xbgr.mr_n77340320)
print v(xbgr.mr_n77340432)
print v(xbgr.mr_n77340752)
print v(xbgr.mr_n77340864)
print v(xbgr.mr_n77341184)
print v(xbgr.mr_n77341296)
print v(xbgr.mr_n77341616)
print v(xbgr.mr_n77341728)
print v(xbgr.mr_n77342048)
print v(xbgr.mr_n77342160)
print v(xbgr.mr_n77342480)
print v(xbgr.mr_n77342592)
print v(xbgr.mr_n77342912)
print v(xbgr.mr_n77343024)
print v(xbgr.mr_n77343344)
print v(xbgr.mr_n77343456)
print v(xbgr.mr_n77343776)
print v(xbgr.mr_n77343888)
print v(xbgr.mr_n77344208)
print v(xbgr.mr_n77344320)
print v(xbgr.mr_n77344640)
print v(xbgr.mr_n77344752)
print v(xbgr.mr_n77345072)
print v(xbgr.mr_n77345184)
print v(xbgr.mr_n77345504)
print v(xbgr.mr_n77345616)
print v(xbgr.mr_n77345936)
print v(xbgr.mr_n77346048)
print v(xbgr.mr_n77346368)
print v(xbgr.mr_n77346480)
print v(xbgr.mr_n77346800)
print v(xbgr.mr_n77346912)
print v(xbgr.mr_n77347232)
print v(xbgr.mr_n77347344)
print v(xbgr.mr_n77347664)
print v(xbgr.mr_n77347776)
print v(xbgr.mr_n77348096)
print v(xbgr.mr_n77348208)
print v(xbgr.mr_n77348528)
print v(xbgr.mr_n77348640)
print v(xbgr.mr_n77348960)
print v(xbgr.mr_n77349072)
print v(xbgr.mr_n77349392)
print v(xbgr.mr_n77349504)
print v(xbgr.mr_n77349824)
print v(xbgr.mr_n77349936)
print v(xbgr.mr_n77350256)
print v(xbgr.mr_n77350368)
print v(xbgr.mr_n77350688)
print v(xbgr.mr_n77350800)
print v(xbgr.mr_n77351120)
print v(xbgr.mr_n77351232)
print v(xbgr.mr_n77351552)
print v(xbgr.mr_n77351664)
print v(xbgr.mr_n77351984)
print v(xbgr.mr_n77352096)
print v(xbgr.mr_n77352416)
print v(xbgr.mr_n77352528)
print v(xbgr.mr_n77352848)
print v(xbgr.mr_n77352960)
print v(xbgr.mr_n77353280)
print v(xbgr.mr_n77353392)
print v(xbgr.mr_n77353712)
print v(xbgr.mr_n77353824)
print v(xbgr.mr_n77354144)
print v(xbgr.mr_n77354256)
print v(xbgr.mr_n77354576)
print v(xbgr.mr_n77354688)
print v(xbgr.mr_n77355008)
print v(xbgr.mr_n77355120)
print v(xbgr.mr_n77355440)
print v(xbgr.mr_n77355552)
print v(xbgr.mr_n77355872)
print v(xbgr.mr_n77355984)
print v(xbgr.mr_n77356304)
print v(xbgr.mr_n77356416)
print v(xbgr.mr_n77356736)
print v(xbgr.mr_n77356848)
print v(xbgr.mr_n77357168)
print v(xbgr.mr_n77357280)
print v(xbgr.mr_n77357600)
print v(xbgr.mr_n77357712)
print v(xbgr.mr_n77358032)
print v(xbgr.mr_n77358144)
print v(xbgr.mr_n77358464)
print v(xbgr.mr_n77358576)
print v(xbgr.mr_n77358896)
print v(xbgr.mr_n77359008)
print v(xbgr.mr_n77359328)
print v(xbgr.mr_n77359440)
print v(xbgr.mr_n77359760)
print v(xbgr.mr_n77359872)
print v(xbgr.mr_n77360192)
print v(xbgr.mr_n77360304)
print v(xbgr.mr_n77360624)
print v(xbgr.mr_n77360736)
print v(xbgr.mr_n77361056)
print v(xbgr.mr_n77361168)
print v(xbgr.mr_n77361488)
print v(xbgr.mr_n77361600)
print v(xbgr.mr_n77361920)
print v(xbgr.mr_n77362032)
print v(xbgr.mr_n77362352)
print v(xbgr.mr_n77362464)
print v(xbgr.mr_n77362784)
print v(xbgr.mr_n77362896)
print v(xbgr.mr_n77363216)
print v(xbgr.mr_n77363328)
print v(xbgr.mr_n77363648)
print v(xbgr.mr_n77363760)
print v(xbgr.mr_n77364080)
print v(xbgr.mr_n77364192)
print v(xbgr.mr_n77364512)
print v(xbgr.mr_n77364624)
print v(xbgr.mr_n77364944)
print v(xbgr.mr_n77365056)
print v(xbgr.mr_n77365376)
print v(xbgr.mr_n77365488)
print v(xbgr.mr_n77365808)
print v(xbgr.mr_n77365920)
print v(xbgr.mr_n77366240)
print v(xbgr.mr_n77366352)
print v(xbgr.mr_n77366672)
print v(xbgr.mr_n77366784)
print v(xbgr.mr_n77367104)
print v(xbgr.mr_n77367216)
print v(xbgr.mr_n77367536)
print v(xbgr.mr_n77367648)
print v(xbgr.mr_n77367968)
print v(xbgr.mr_n77368080)
print v(xbgr.mr_n77368400)
print v(xbgr.mr_n77368512)
print v(xbgr.mr_n77368832)
print v(xbgr.mr_n77368944)
print v(xbgr.mr_n77369264)
print v(xbgr.mr_n77369376)
print v(xbgr.mr_n77369696)
print v(xbgr.mr_n77369808)
print v(xbgr.mr_n77370128)
print v(xbgr.mr_n77370240)
print v(xbgr.mr_n77370560)
print v(xbgr.mr_n77370672)
print v(xbgr.mr_n77370992)
print v(xbgr.mr_n77371104)
print v(xbgr.mr_n77371424)
print v(xbgr.mr_n77371536)
print v(xbgr.mr_n77371856)
print v(xbgr.mr_n77371968)
print v(xbgr.mr_n77372288)
print v(xbgr.mr_n77372400)
print v(xbgr.mr_n77372720)
print v(xbgr.mr_n77373152)
print v(xbgr.mr_n77373264)
print v(xbgr.mr_n77373584)
print v(xbgr.mr_n77373696)
print v(xbgr.mr_n77374016)
print v(xbgr.mr_n77374128)
print v(xbgr.mr_n77374448)
print v(xbgr.mr_n77374560)
print v(xbgr.mr_n77374880)
print v(xbgr.mr_n77374992)
print v(xbgr.mr_n77375312)
print v(xbgr.mr_n77375424)
print v(xbgr.mr_n77375744)
print v(xbgr.mr_n77375856)
print v(xbgr.mr_n77376176)
print v(xbgr.mr_n77376288)
print v(xbgr.mr_n77376608)
print v(xbgr.mr_n77376720)
print v(xbgr.mr_n77377040)
print v(xbgr.mr_n77377152)
print v(xbgr.mr_n77377472)
print v(xbgr.mr_n77377584)
print v(xbgr.mr_n77377904)
print v(xbgr.mr_n77378016)
print v(xbgr.mr_n77378336)
print v(xbgr.mr_n77378448)
print v(xbgr.mr_n77378768)
print v(xbgr.mr_n77378880)
print v(xbgr.mr_n77379200)
print v(xbgr.mr_n77379312)
print v(xbgr.mr_n77379632)
print v(xbgr.mr_n77379744)
print v(xbgr.mr_n77380064)
print v(xbgr.mr_n77380176)
print v(xbgr.mr_n77380496)
print v(xbgr.mr_n77380608)
print v(xbgr.mr_n77380928)
print v(xbgr.mr_n77381040)
print v(xbgr.mr_n77381360)
print v(xbgr.mr_n77381472)
print v(xbgr.mr_n77381792)
print v(xbgr.mr_n77381904)
print v(xbgr.mr_n77382224)
print v(xbgr.mr_n77382336)
print v(xbgr.mr_n77382656)
print v(xbgr.mr_n77382768)
print v(xbgr.mr_n77383088)
print v(xbgr.mr_n77383200)
print v(xbgr.mr_n77383520)
print v(xbgr.mr_n77383632)
print v(xbgr.mr_n77383952)
print v(xbgr.mr_n77384064)
print v(xbgr.mr_n77384384)
print v(xbgr.mr_n77384496)
print v(xbgr.mr_n77384816)
print v(xbgr.mr_n77384928)
print v(xbgr.mr_n77385248)
print v(xbgr.mr_n77385360)
print v(xbgr.mr_n77385680)
print v(xbgr.mr_n77385792)
print v(xbgr.mr_n77386112)
print v(xbgr.mr_n77386224)
print v(xbgr.mr_n77386544)
print v(xbgr.mr_n77386656)
print v(xbgr.mr_n77386976)
print v(xbgr.mr_n77387088)
print v(xbgr.mr_n77387408)
print v(xbgr.mr_n77387520)
print v(xbgr.mr_n77387840)
print v(xbgr.mr_n77387952)
print v(xbgr.mr_n77388272)
print v(xbgr.mr_n77388704)
print v(xbgr.mr_n77388816)
print v(xbgr.mr_n77389136)
print v(xbgr.mr_n77389248)
print v(xbgr.mr_n77389568)
print v(xbgr.mr_n77389680)
print v(xbgr.mr_n77390000)
print v(xbgr.mr_n77390432)
print v(xbgr.mr_n77390544)
print v(xbgr.mr_n77390864)
print v(xbgr.mr_n77390976)
print v(xbgr.mr_n77391296)
print v(xbgr.mr_n77391408)
print v(xbgr.mr_n77391728)
print v(xbgr.mr_n77392160)
print v(xbgr.mr_n77392272)
print v(xbgr.mr_n77392592)
print v(xbgr.mr_n77392704)
print v(xbgr.mr_n77393024)
print v(xbgr.mr_n77393136)
print v(xbgr.mr_n77393456)
print v(xbgr.mr_n77393568)
print v(xbgr.mr_n77393888)
print v(xbgr.mr_n77394000)
print v(xbgr.mr_n77394320)
print v(xbgr.mr_n77394432)
print v(xbgr.mr_n77394752)
print v(xbgr.mr_n77394864)
print v(xbgr.mr_n77395184)
print v(xbgr.mr_n77395296)
print v(xbgr.mr_n77395616)
print v(xbgr.mr_n77395728)
print v(xbgr.mr_n77396048)
print v(xbgr.mr_n77396160)
print v(xbgr.mr_n77396480)
print v(xbgr.mr_n77396592)
print v(xbgr.mr_n77396912)
print v(xbgr.mr_n77397024)
print v(xbgr.mr_n77397344)
print v(xbgr.mr_n77397456)
print v(xbgr.mr_n77397776)
print v(xbgr.mr_n77397888)
print v(xbgr.mr_n77398208)
print v(xbgr.mr_n77398320)
print v(xbgr.mr_n77398640)
print v(xbgr.mr_n77398752)
print v(xbgr.mr_n77399072)
print v(xbgr.mr_n77399504)
print v(xbgr.mr_n77399616)
print v(xbgr.mr_n77399936)
print v(xbgr.mr_n77400048)
print v(xbgr.mr_n77400368)
print v(xbgr.mr_n77400480)
print v(xbgr.mr_n77400800)
print v(xbgr.mr_n77400912)
print v(xbgr.mr_n77401232)
print v(xbgr.mr_n77401344)
print v(xbgr.mr_n77401664)
print v(xbgr.mr_n77401776)
print v(xbgr.mr_n77402096)
print v(xbgr.mr_n77402208)
print v(xbgr.mr_n77402528)
print v(xbgr.mr_n77402640)
print v(xbgr.mr_n77402960)
print v(xbgr.mr_n77403072)
print v(xbgr.mr_n77403392)
print v(xbgr.mr_n77403504)
print v(xbgr.mr_n77403824)
print v(xbgr.mr_n77404256)
print v(xbgr.mr_n77404368)
print v(xbgr.mr_n77404688)
print v(xbgr.mr_n77405120)
print v(xbgr.mr_n77405232)
print v(xbgr.mr_n77405552)
print v(xbgr.mr_n77405664)
print v(xbgr.mr_n77405984)
print v(xbgr.mr_n77406096)
print v(xbgr.mr_n77406416)
print v(xbgr.mr_n77406528)
print v(xbgr.mr_n77406848)
print v(xbgr.mr_n77406960)
print v(xbgr.mr_n77407280)
print v(xbgr.mr_n77407712)
print v(xbgr.mr_n77407824)
print v(xbgr.mr_n77408144)
print v(xbgr.mr_n77408256)
print v(xbgr.mr_n77408576)
print v(xbgr.mr_n77408688)
print v(xbgr.mr_n77413456)
print v(xbgr.mr_n77413568)
print v(xbgr.mr_n77413904)
print v(xbgr.mr_n77414016)
print v(xbgr.mr_n77414336)
print v(xbgr.mr_n77414448)
print v(xbgr.mr_n77414816)
print v(xbgr.mr_n77414928)
print v(xbgr.mr_n77415248)
print v(xbgr.mr_n77415360)
print v(xbgr.mr_n77415680)
print v(xbgr.mr_n77416032)
print v(xbgr.mr_n77416144)
print v(xbgr.mr_n77416464)
print v(xbgr.mr_n77416896)
print v(xbgr.mr_n77417008)
print v(xbgr.mr_n77417328)
print v(xbgr.mr_n77417440)
print v(xbgr.mr_n77417760)
print v(xbgr.mr_n77417872)
print v(xbgr.mr_n77418192)
print v(xbgr.mr_n77418304)
print v(xbgr.mr_n77418624)
print v(xbgr.mr_n77418736)
print v(xbgr.mr_n77419056)
print v(xbgr.mr_n77419488)
print v(xbgr.mr_n77419600)
print v(xbgr.mr_n77419920)
print v(xbgr.mr_n77420352)
print v(xbgr.mr_n77420464)
print v(xbgr.mr_n77420784)
print v(xbgr.mr_n77420896)
print v(xbgr.mr_n77421216)
print v(xbgr.mr_n77421328)
print v(xbgr.mr_n77421648)
print v(xbgr.mr_n77421760)
print v(xbgr.mr_n77422080)
print v(xbgr.mr_n77422192)
print v(xbgr.mr_n77422512)
print v(xbgr.mr_n77422624)
print v(xbgr.mr_n77422944)
print v(xbgr.mr_n77423056)
print v(xbgr.mr_n77423376)
print v(xbgr.mr_n77423808)
print v(xbgr.mr_n77423920)
print v(xbgr.mr_n77424240)
print v(xbgr.mr_n77424352)
print v(xbgr.mr_n77424672)
print v(xbgr.mr_n77424784)
print v(xbgr.mr_n77425104)
print v(xbgr.mr_n77425216)
print v(xbgr.mr_n77425536)
print v(xbgr.mr_n77425648)
print v(xbgr.mr_n77425968)
print v(xbgr.mr_n77426080)
print v(xbgr.mr_n77426400)
print v(xbgr.mr_n77426512)
print v(xbgr.mr_n77426832)
print v(xbgr.mr_n77427264)
print v(xbgr.mr_n77427376)
print v(xbgr.mr_n77427696)
print v(xbgr.mr_n77428128)
print v(xbgr.mr_n77428240)
print v(xbgr.mr_n77428560)
print v(xbgr.mr_n77428672)
print v(xbgr.mr_n77428992)
print v(xbgr.mr_n77429104)
print v(xbgr.mr_n77429424)
print v(xbgr.mr_n77429536)
print v(xbgr.mr_n77429856)
print v(xbgr.mr_n77429968)
print v(xbgr.mr_n77430288)
print v(xbgr.mr_n77430400)
print v(xbgr.mr_n77430720)
print v(xbgr.mr_n77430832)
print v(xbgr.mr_n77431152)
print v(xbgr.mr_n77431584)
print v(xbgr.mr_n77431696)
print v(xbgr.mr_n77432016)
print v(xbgr.mr_n77432128)
print v(xbgr.mr_n77432448)
print v(xbgr.mr_n77432560)
print v(xbgr.mr_n77432880)
print v(xbgr.mr_n77433312)
print v(xbgr.mr_n77433424)
print v(xbgr.mr_n77433744)
print v(xbgr.mr_n77433856)
print v(xbgr.mr_n77434176)
print v(xbgr.mr_n77434288)
print v(xbgr.mr_n77434608)
print v(xbgr.mr_n77434720)
print v(xbgr.mr_n77435040)
print v(xbgr.mr_n77435152)
print v(xbgr.mr_n77435472)
print v(xbgr.mr_n77435584)
print v(xbgr.mr_n77435904)
print v(xbgr.mr_n77436016)
print v(xbgr.mr_n77436336)
print v(xbgr.mr_n77436768)
print v(xbgr.mr_n77436880)
print v(xbgr.mr_n77437200)
print v(xbgr.mr_n77437312)
print v(xbgr.mr_n77437632)
print v(xbgr.mr_n77437744)
print v(xbgr.mr_n77438064)
print v(xbgr.mr_n77438496)
print v(xbgr.mr_n77438608)
print v(xbgr.mr_n77438928)
print v(xbgr.mr_n77439040)
print v(xbgr.mr_n77439360)
print v(xbgr.mr_n77439472)
print v(xbgr.mr_n77439792)
print v(xbgr.mr_n77439904)
print v(xbgr.mr_n77440224)
print v(xbgr.mr_n77440336)
print v(xbgr.mr_n77440656)
print v(xbgr.mr_n77440768)
print v(xbgr.mr_n77441088)
print v(xbgr.mr_n77441200)
print v(xbgr.mr_n77441520)
print v(xbgr.mr_n77441632)
print v(xbgr.mr_n77441952)
print v(xbgr.mr_n77442064)
print v(xbgr.mr_n77442384)
print v(xbgr.mr_n77442816)
print v(xbgr.mr_n77442928)
print v(xbgr.mr_n77443248)
print v(xbgr.mr_n77443360)
print v(xbgr.mr_n77443584)
print v(xbgr.mr_n77443952)
print v(xbgr.mr_n77444064)
print v(xbgr.mr_n77444320)
print v(xbgr.mr_n77444432)
print v(xbgr.mr_n77444688)
print v(xbgr.mr_n77444800)
print v(xbgr.mr_n77445056)
print v(xbgr.mr_n77445168)
print v(xbgr.mr_n77445424)
print v(xbgr.mr_n77445536)
print v(xbgr.mr_n77445792)
print v(xbgr.mr_n77446160)
print v(xbgr.mr_n77446272)
print v(xbgr.mr_n77446528)
print v(xbgr.mr_n77446896)
print v(xbgr.mr_n77447008)
print v(xbgr.mr_n77447264)
print v(xbgr.mr_n77447632)
print v(xbgr.mr_n77447744)
print v(xbgr.mr_n77448000)
print v(xbgr.mr_n77448112)
print v(xbgr.mr_n77448368)
print v(xbgr.mr_n77448480)
print v(xbgr.mr_n77448736)
print v(xbgr.mr_n77449104)
print v(xbgr.mr_n77449216)
print v(xbgr.mr_n77449472)
print v(xbgr.mr_n77449840)
print v(xbgr.mr_n77449952)
print v(xbgr.mr_n77450208)
print v(xbgr.mr_n77450576)
print v(xbgr.mr_n77450688)
print v(xbgr.mr_n77450944)
print v(xbgr.mr_n77451056)
print v(xbgr.mr_n77451312)
print v(xbgr.mr_n77451424)
print v(xbgr.mr_n77451680)
print v(xbgr.mr_n77451792)
print v(xbgr.mr_n77452048)
print v(xbgr.mr_n77452160)
print v(xbgr.mr_n77452416)
print v(xbgr.mr_n77452784)
print v(xbgr.mr_n77452896)
print v(xbgr.mr_n77453152)
print v(xbgr.mr_n77453264)
print v(xbgr.mr_n77453520)
print v(xbgr.mr_n77453632)
print v(xbgr.mr_n77453888)
print v(xbgr.mr_n77454000)
print v(xbgr.mr_n77454256)
print v(xbgr.mr_n77454368)
print v(xbgr.mr_n77454624)
print v(xbgr.mr_n77454992)
print v(xbgr.mr_n77455104)
print v(xbgr.mr_n77455360)
print v(xbgr.mr_n77455728)
print v(xbgr.mr_n77455840)
print v(xbgr.mr_n77456096)
print v(xbgr.mr_n77456208)
print v(xbgr.mr_n77456464)
print v(xbgr.mr_n77456576)
print v(xbgr.mr_n77456832)
print v(xbgr.mr_n77457200)
print v(xbgr.mr_n77457312)
print v(xbgr.mr_n77457568)
print v(xbgr.mr_n77457936)
print v(xbgr.mr_n77458048)
print v(xbgr.mr_n77458304)
print v(xbgr.mr_n77458416)
print v(xbgr.mr_n77458672)
print v(xbgr.mr_n77458784)
print v(xbgr.mr_n77459040)
print v(xbgr.mr_n77459152)
print v(xbgr.mr_n77459408)
print v(xbgr.mr_n77459520)
print v(xbgr.mr_n77459776)
print v(xbgr.mr_n77459888)
print v(xbgr.mr_n77460144)
print v(xbgr.mr_n77460256)
print v(xbgr.mr_n77460544)
print v(xbgr.mr_n77460976)
print v(xbgr.mr_n77461088)
print v(xbgr.mr_n77461408)
print v(xbgr.mr_n77461520)
print v(xbgr.mr_n77461840)
print v(xbgr.mr_n77461952)
print v(xbgr.mr_n77462272)
print v(xbgr.mr_n77462384)
print v(xbgr.mr_n77462704)
print v(xbgr.mr_n77462816)
print v(xbgr.mr_n77463136)
print v(xbgr.mr_n77463568)
print v(xbgr.mr_n77463680)
print v(xbgr.mr_n77464000)
print v(xbgr.mr_n77464432)
print v(xbgr.mr_n77464544)
print v(xbgr.mr_n77464864)
print v(xbgr.mr_n77464976)
print v(xbgr.mr_n77465296)
print v(xbgr.mr_n77465408)
print v(xbgr.mr_n77465728)
print v(xbgr.mr_n77465840)
print v(xbgr.mr_n77466160)
print v(xbgr.mr_n77466272)
print v(xbgr.mr_n77466592)
print v(xbgr.mr_n77466704)
print v(xbgr.mr_n77467024)
print v(xbgr.mr_n77467136)
print v(xbgr.mr_n77467456)
print v(xbgr.mr_n77467568)
print v(xbgr.mr_n77467888)
print v(xbgr.mr_n77468432)
print v(xbgr.mr_n77468864)
print v(xbgr.mr_n77469296)
print v(xbgr.mr_n77469728)
print v(xbgr.mr_n77470160)
print v(xbgr.mr_n77470592)
print v(xbgr.mr_n77471024)
print v(xbgr.mr_n77471456)
print v(xbgr.mr_n77471888)
print v(xbgr.mr_n77472320)
print v(xbgr.mr_n77472640)
print v(xbgr.mr_n77473072)
print v(xbgr.mr_n77473504)
print v(xbgr.mr_n77473936)
print v(xbgr.mr_n77474368)
print v(xbgr.mr_n77474800)
print v(xbgr.mr_n77475232)
print v(xbgr.mr_n77475664)
print v(xbgr.mr_n77476096)
print v(xbgr.mr_n77476528)
print v(xbgr.mr_n77476960)
print v(xbgr.mr_n77477392)
print v(xbgr.mr_n77477824)
print v(xbgr.mr_n77478256)
print v(xbgr.mr_n77478688)
print v(xbgr.mr_n77479120)
print v(xbgr.mr_n77479552)
print v(xbgr.mr_n77479984)
print v(xbgr.mr_n77480416)
print v(xbgr.mr_n77480848)
print v(xbgr.mr_n77481280)
print v(xbgr.mr_n77481712)
print v(xbgr.mr_n77482144)
print v(xbgr.mr_n77482576)
print v(xbgr.mr_n77483008)
print v(xbgr.mr_n77483440)
print v(xbgr.mr_n77483872)
print v(xbgr.mr_n77484304)
print v(xbgr.mr_n77484736)
print v(xbgr.mr_n77485168)
print v(xbgr.mr_n77485600)
print v(xbgr.mr_n77486032)
print v(xbgr.mr_n77486464)
print v(xbgr.mr_n77486896)
print v(xbgr.mr_n77487328)
print v(xbgr.mr_n77487760)
print v(xbgr.mr_n77488192)
print v(xbgr.mr_n77488624)
print v(xbgr.mr_n77489056)
print v(xbgr.mr_n77489488)
print v(xbgr.mr_n77489920)
print v(xbgr.mr_n77490352)
print v(xbgr.mr_n77490784)
print v(xbgr.mr_n77491216)
print v(xbgr.mr_n77491648)
print v(xbgr.mr_n77492080)
print v(xbgr.mr_n77492512)
print v(xbgr.mr_n77492944)
print v(xbgr.mr_n77494240)
print v(xbgr.mr_n77494672)
print v(xbgr.mr_n77495104)
print v(xbgr.mr_n77495536)
print v(xbgr.mr_n77495968)
print v(xbgr.mr_n77496400)
print v(xbgr.mr_n77496832)
print v(xbgr.mr_n77497264)
print v(xbgr.mr_n77497696)
print v(xbgr.mr_n77498128)
print v(xbgr.mr_n77498560)
print v(xbgr.mr_n77498992)
print v(xbgr.mr_n77501152)
print v(xbgr.mr_n77501584)
print v(xbgr.mr_n77502016)
print v(xbgr.mr_n77502448)
print v(xbgr.mr_n77502880)
print v(xbgr.mr_n77503312)
print v(xbgr.mr_n77503744)
print v(xbgr.mr_n77504176)
print v(xbgr.mr_n77504608)
print v(xbgr.mr_n77505040)
print v(xbgr.mr_n77506336)
print v(xbgr.mr_n77506768)
print v(xbgr.mr_n77507200)
print v(xbgr.mr_n77507632)
print v(xbgr.mr_n77508064)
print v(xbgr.mr_n77508496)
print v(xbgr.mr_n77508928)
print v(xbgr.mr_n77509360)
print v(xbgr.mr_n77509792)
print v(xbgr.mr_n77510224)
print v(xbgr.mr_n77510656)
print v(xbgr.mr_n77511088)
print v(xbgr.mr_n77512384)
print v(xbgr.mr_n77512816)
print v(xbgr.mr_n77514112)
print v(xbgr.mr_n77514544)
print v(xbgr.mr_n77514976)
print v(xbgr.mr_n77515408)
print v(xbgr.mr_n77515840)
print v(xbgr.mr_n77516272)
print v(xbgr.mr_n77516704)
print v(xbgr.mr_n77517136)
print v(xbgr.mr_n77518432)
print v(xbgr.mr_n77518864)
print v(xbgr.mr_n77519184)
print v(xbgr.mr_n77519296)
print v(xbgr.mr_n77519616)
print v(xbgr.mr_n77519728)
print v(xbgr.mr_n77520048)
print v(xbgr.mr_n77520160)
print v(xbgr.mr_n77520480)
print v(xbgr.mr_n77520592)
print v(xbgr.mr_n77520912)
print v(xbgr.mr_n77521024)
print v(xbgr.mr_n77521344)
print v(xbgr.mr_n77521456)
print v(xbgr.mr_n77521776)
print v(xbgr.mr_n77521888)
print v(xbgr.mr_n77522208)
print v(xbgr.mr_n77522320)
print v(xbgr.mr_n77522752)
print v(xbgr.mr_n77523184)
print v(xbgr.mr_n77523616)
print v(xbgr.mr_n77524048)
print v(xbgr.mr_n77524480)
print v(xbgr.mr_n77524912)
print v(xbgr.mr_n77525344)
print v(xbgr.mr_n77525776)
print v(xbgr.mr_n77526208)
print v(xbgr.mr_n77526640)
print v(xbgr.mr_n77527072)
print v(xbgr.mr_n77527504)
print v(xbgr.mr_n77527936)
print v(xbgr.mr_n77528368)
print v(xbgr.mr_n77528800)
print v(xbgr.mr_n77529232)
print v(xbgr.mr_n77529664)
print v(xbgr.mr_n77530096)
print v(xbgr.mr_n77530528)
print v(xbgr.mr_n77530960)
print v(xbgr.mr_n77531392)
print v(xbgr.mr_n77531824)
print v(xbgr.mr_n77532256)
print v(xbgr.mr_n77532688)
print v(xbgr.mr_n77533120)
print v(xbgr.mr_n77533552)
print v(xbgr.mr_n77534192)
print v(xbgr.mr_n77534624)
print v(xbgr.mr_n77535056)
print v(xbgr.mr_n77535488)
print v(xbgr.mr_n77535920)
print v(xbgr.mr_n77536352)
print v(xbgr.mr_n77536784)
print v(xbgr.mr_n77537216)
print v(xbgr.mr_n77537648)
print v(xbgr.mr_n77538080)
print v(xbgr.mr_n77538512)
print v(xbgr.mr_n77538944)
print v(xbgr.mr_n77539376)
print v(xbgr.mr_n77539808)
print v(xbgr.mr_n77540240)
print v(xbgr.mr_n77540672)
print v(xbgr.mr_n77541104)
print v(xbgr.mr_n77541536)
print v(xbgr.mr_n77541968)
print v(xbgr.mr_n77542400)
print v(xbgr.mr_n77542832)
print v(xbgr.mr_n77543264)
print v(xbgr.mr_n77543696)
print v(xbgr.mr_n77544128)
print v(xbgr.mr_n77544560)
print v(xbgr.mr_n77544992)
print v(xbgr.mr_n77545424)
print v(xbgr.mr_n77545856)
print v(xbgr.mr_n77546288)
print v(xbgr.mr_n77546720)
print v(xbgr.mr_n77547152)
print v(xbgr.mr_n77547584)
print v(xbgr.mr_n77548016)
print v(xbgr.mr_n77548448)
print v(xbgr.mr_n77548880)
print v(xbgr.mr_n77549312)
print v(xbgr.mr_n77549744)
print v(xbgr.mr_n77550176)
print v(xbgr.mr_n77550608)
print v(xbgr.mr_n77551040)
print v(xbgr.mr_n77551472)
print v(xbgr.mr_n77551904)
print v(xbgr.mr_n77552336)
print v(xbgr.mr_n77552768)
print v(xbgr.mr_n77553200)
print v(xbgr.mr_n77553632)
print v(xbgr.mr_n77554064)
print v(xbgr.mr_n77554496)
print v(xbgr.mr_n77554928)
print v(xbgr.mr_n77555360)
print v(xbgr.mr_n77555792)
print v(xbgr.mr_n77556224)
print v(xbgr.mr_n77556656)
print v(xbgr.mr_n77557088)
print v(xbgr.mr_n77557520)
print v(xbgr.mr_n77557952)
print v(xbgr.mr_n77558384)
print v(xbgr.mr_n77558816)
print v(xbgr.mr_n77559248)
print v(xbgr.mr_n77559680)
print v(xbgr.mr_n77560112)
print v(xbgr.mr_n77560544)
print v(xbgr.mr_n77560976)
print v(xbgr.mr_n77561408)
print v(xbgr.mr_n77561840)
print v(xbgr.mr_n77562272)
print v(xbgr.mr_n77562704)
print v(xbgr.mr_n77563136)
print v(xbgr.mr_n77563568)
print v(xbgr.mr_n77564000)
print v(xbgr.mr_n77564432)
print v(xbgr.mr_n77564864)
print v(xbgr.mr_n77565296)
print v(xbgr.mr_n77565728)
print v(xbgr.mr_n77566160)
print v(xbgr.mr_n77566592)
print v(xbgr.mr_n77567024)
print v(xbgr.mr_n77567456)
print v(xbgr.mr_n77567888)
print v(xbgr.mr_n77568320)
print v(xbgr.mr_n77568752)
print v(xbgr.mr_n77569184)
print v(xbgr.mr_n77569616)
print v(xbgr.mr_n77570048)
print v(xbgr.mr_n77570480)
print v(xbgr.mr_n77570800)
print v(xbgr.mr_n77570912)
print v(xbgr.mr_n77571232)
print v(xbgr.mr_n77571344)
print v(xbgr.mr_n77571664)
print v(xbgr.mr_n77571776)
print v(xbgr.mr_n77572096)
print v(xbgr.mr_n77572208)
print v(xbgr.mr_n77572640)
print v(xbgr.mr_n77573072)
print v(xbgr.mr_n77573504)
print v(xbgr.mr_n77573936)
print v(xbgr.mr_n77574368)
print v(xbgr.mr_n77574800)
print v(xbgr.mr_n77575232)
print v(xbgr.mr_n77575664)
print v(xbgr.mr_n77576096)
print v(xbgr.mr_n77576528)
print v(xbgr.mr_n77576960)
print v(xbgr.mr_n77577392)
print v(xbgr.mr_n77577824)
print v(xbgr.mr_n77578256)
print v(xbgr.mr_n77578688)
print v(xbgr.mr_n77579120)
print v(xbgr.mr_n77579552)
print v(xbgr.mr_n77579984)
print v(xbgr.mr_n77580416)
print v(xbgr.mr_n77580848)
print v(xbgr.mr_n77581280)
print v(xbgr.mr_n77581712)
print v(xbgr.mr_n77582144)
print v(xbgr.mr_n77582576)
print v(xbgr.mr_n77583008)
print v(xbgr.mr_n77583440)
print v(xbgr.mr_n77583872)
print v(xbgr.mr_n77584304)
print v(xbgr.mr_n77584736)
print v(xbgr.mr_n77585168)
print v(xbgr.mr_n77585600)
print v(xbgr.mr_n77586032)
print v(xbgr.mr_n77586464)
print v(xbgr.mr_n77586896)
print v(xbgr.mr_n77587328)
print v(xbgr.mr_n77587760)
print v(xbgr.mr_n77588192)
print v(xbgr.mr_n77588624)
print v(xbgr.mr_n77589056)
print v(xbgr.mr_n77589488)
print v(xbgr.mr_n77589920)
print v(xbgr.mr_n77590352)
print v(xbgr.mr_n77590784)
print v(xbgr.mr_n77591216)
print v(xbgr.mr_n77591648)
print v(xbgr.mr_n77592080)
print v(xbgr.mr_n77592512)
print v(xbgr.mr_n77592944)
print v(xbgr.mr_n77593376)
print v(xbgr.mr_n77593808)
print v(xbgr.mr_n77594240)
print v(xbgr.mr_n77594672)
print v(xbgr.mr_n77595104)
print v(xbgr.mr_n77595536)
print v(xbgr.mr_n77595968)
print v(xbgr.mr_n77596400)
print v(xbgr.mr_n77596832)
print v(xbgr.mr_n77597264)
print v(xbgr.mr_n77597696)
print v(xbgr.mr_n77598128)
print v(xbgr.mr_n77598560)
print v(xbgr.mr_n77598992)
print v(xbgr.mr_n77599424)
print v(xbgr.mr_n77599856)
print v(xbgr.mr_n77601152)
print v(xbgr.mr_n77601584)
print v(xbgr.mr_n77602880)
print v(xbgr.mr_n77603312)
print v(xbgr.mr_n77604608)
print v(xbgr.mr_n77605040)
print v(xbgr.mr_n77605472)
print v(xbgr.mr_n77605904)
print v(xbgr.mr_n77606336)
print v(xbgr.mr_n77606768)
print v(xbgr.mr_n77607200)
print v(xbgr.mr_n77607632)
print v(xbgr.mr_n77608064)
print v(xbgr.mr_n77608496)
print v(xbgr.mr_n77608928)
print v(xbgr.mr_n77609360)
print v(xbgr.mr_n77609792)
print v(xbgr.mr_n77610224)
print v(xbgr.mr_n77610656)
print v(xbgr.mr_n77611088)
print v(xbgr.mr_n77612384)
print v(xbgr.mr_n77612816)
print v(xbgr.mr_n77613248)
print v(xbgr.mr_n77613680)
print v(xbgr.mr_n77614112)
print v(xbgr.mr_n77614544)
print v(xbgr.mr_n77615840)
print v(xbgr.mr_n77616272)
print v(xbgr.mr_n77616704)
print v(xbgr.mr_n77617136)
print v(xbgr.mr_n77617568)
print v(xbgr.mr_n77618000)
print v(xbgr.mr_n77618432)
print v(xbgr.mr_n77618864)
print v(xbgr.mr_n77619296)
print v(xbgr.mr_n77619728)
print v(xbgr.mr_n77620160)
print v(xbgr.mr_n77620592)
print v(xbgr.mr_n77621024)
print v(xbgr.mr_n77621456)
print v(xbgr.mr_n77621888)
print v(xbgr.mr_n77622320)
print v(xbgr.mr_n77622752)
print v(xbgr.mr_n77623184)
print v(xbgr.mr_n77623616)
print v(xbgr.mr_n77624048)
print v(xbgr.mr_n77624480)
print v(xbgr.mr_n77624912)
print v(xbgr.mr_n77625344)
print v(xbgr.mr_n77625776)
print v(xbgr.mr_n77626208)
print v(xbgr.mr_n77626640)
print v(xbgr.mr_n77627072)
print v(xbgr.mr_n77627504)
print v(xbgr.mr_n77627936)
print v(xbgr.mr_n77628368)
print v(xbgr.mr_n77628800)
print v(xbgr.mr_n77629232)
print v(xbgr.mr_n77629664)
print v(xbgr.mr_n77630096)
print v(xbgr.mr_n77630528)
print v(xbgr.mr_n77630960)
print v(xbgr.mr_n77631392)
print v(xbgr.mr_n77631824)
print v(xbgr.mr_n77632256)
print v(xbgr.mr_n77632688)
print v(xbgr.mr_n77633120)
print v(xbgr.mr_n77633552)
print v(xbgr.mr_n77633984)
print v(xbgr.mr_n77634416)
print v(xbgr.mr_n77634848)
print v(xbgr.mr_n77635280)
print v(xbgr.mr_n77635712)
print v(xbgr.mr_n77636144)
print v(xbgr.mr_n77636576)
print v(xbgr.mr_n77637008)
print v(xbgr.mr_n77637440)
print v(xbgr.mr_n77637872)
print v(xbgr.mr_n77638304)
print v(xbgr.mr_n77638736)
print v(xbgr.mr_n77639168)
print v(xbgr.mr_n77639600)
print v(xbgr.mr_n77640032)
print v(xbgr.mr_n77640352)
print v(xbgr.mr_n77640464)
print v(xbgr.mr_n77640784)
print v(xbgr.mr_n77640896)
print v(xbgr.mr_n77641216)
print v(xbgr.mr_n77641328)
print v(xbgr.mr_n77641648)
print v(xbgr.mr_n77641760)
print v(xbgr.mr_n77642080)
print v(xbgr.mr_n77642192)
print v(xbgr.mr_n77642512)
print v(xbgr.mr_n77642624)
print v(xbgr.mr_n77642944)
print v(xbgr.mr_n77643056)
print v(xbgr.mr_n77643376)
print v(xbgr.mr_n77643488)
print v(xbgr.mr_n77643808)
print v(xbgr.mr_n77643920)
print v(xbgr.mr_n77644240)
print v(xbgr.mr_n77644352)
print v(xbgr.mr_n77644672)
print v(xbgr.mr_n77644784)
print v(xbgr.mr_n77645104)
print v(xbgr.mr_n77645216)
print v(xbgr.mr_n77645536)
print v(xbgr.mr_n77645648)
print v(xbgr.mr_n77645968)
print v(xbgr.mr_n77646080)
print v(xbgr.mr_n77646400)
print v(xbgr.mr_n77646512)
print v(xbgr.mr_n77646832)
print v(xbgr.mr_n77646944)
print v(xbgr.mr_n77647264)
print v(xbgr.mr_n77647376)
print v(xbgr.mr_n77647696)
print v(xbgr.mr_n77647808)
print v(xbgr.mr_n77648128)
print v(xbgr.mr_n77648240)
print v(xbgr.mr_n77648560)
print v(xbgr.mr_n77648672)
print v(xbgr.mr_n77648992)
print v(xbgr.mr_n77649104)
print v(xbgr.mr_n77649424)
print v(xbgr.mr_n77649536)
print v(xbgr.mr_n77649856)
print v(xbgr.mr_n77649968)
print v(xbgr.mr_n77650288)
print v(xbgr.mr_n77650400)
print v(xbgr.mr_n77650720)
print v(xbgr.mr_n77650832)
print v(xbgr.mr_n77651152)
print v(xbgr.mr_n77651264)
print v(xbgr.mr_n77651584)
print v(xbgr.mr_n77651696)
print v(xbgr.mr_n77652016)
print v(xbgr.mr_n77652128)
print v(xbgr.mr_n77652448)
print v(xbgr.mr_n77652560)
print v(xbgr.mr_n77652880)
print v(xbgr.mr_n77652992)
print v(xbgr.mr_n77653312)
print v(xbgr.mr_n77653424)
print v(xbgr.mr_n77653744)
print v(xbgr.mr_n77653856)
print v(xbgr.mr_n77654176)
print v(xbgr.mr_n77654288)
print v(xbgr.mr_n77654608)
print v(xbgr.mr_n77654720)
print v(xbgr.mr_n77655040)
print v(xbgr.mr_n77655152)
print v(xbgr.mr_n77655472)
print v(xbgr.mr_n77655584)
print v(xbgr.mr_n77655904)
print v(xbgr.mr_n77656016)
print v(xbgr.mr_n77656336)
print v(xbgr.mr_n77656448)
print v(xbgr.mr_n77656864)
print v(xbgr.mr_n77657296)
print v(xbgr.mr_n77657728)
print v(xbgr.mr_n77658160)
print v(xbgr.mr_n77658592)
print v(xbgr.mr_n77659024)
print v(xbgr.mr_n77659456)
print v(xbgr.mr_n77659888)
print v(xbgr.mr_n77660320)
print v(xbgr.mr_n77660752)
print v(xbgr.mr_n77661184)
print v(xbgr.mr_n77661616)
print v(xbgr.mr_n77661936)
print v(xbgr.mr_n77662048)
print v(xbgr.mr_n77662368)
print v(xbgr.mr_n77662480)
print v(xbgr.mr_n77662912)
print v(xbgr.mr_n77663344)
print v(xbgr.mr_n77663776)
print v(xbgr.mr_n77664208)
print v(xbgr.mr_n77664640)
print v(xbgr.mr_n77665072)
print v(xbgr.mr_n77665504)
print v(xbgr.mr_n77665936)
print v(xbgr.mr_n77666368)
print v(xbgr.mr_n77666800)
print v(xbgr.mr_n77667232)
print v(xbgr.mr_n77667664)
print v(xbgr.mr_n77668096)
print v(xbgr.mr_n77668528)
print v(xbgr.mr_n77668960)
print v(xbgr.mr_n77669392)
print v(xbgr.mr_n77669824)
print v(xbgr.mr_n77670256)
print v(xbgr.mr_n77670688)
print v(xbgr.mr_n77671120)
print v(xbgr.mr_n77671552)
print v(xbgr.mr_n77671984)
print v(xbgr.mr_n77672416)
print v(xbgr.mr_n77672848)
print v(xbgr.mr_n77673280)
print v(xbgr.mr_n77673712)
print v(xbgr.mr_n77674144)
print v(xbgr.mr_n77674576)
print v(xbgr.mr_n77675008)
print v(xbgr.mr_n77675440)
print v(xbgr.mr_n77675872)
print v(xbgr.mr_n77676304)
print v(xbgr.mr_n77676736)
print v(xbgr.mr_n77677168)
print v(xbgr.mr_n77677600)
print v(xbgr.mr_n77678032)
print v(xbgr.mr_n77678464)
print v(xbgr.mr_n77678896)
print v(xbgr.mr_n77679328)
print v(xbgr.mr_n77679760)
print v(xbgr.mr_n77680080)
print v(xbgr.mr_n77680192)
print v(xbgr.mr_n77680512)
print v(xbgr.mr_n77680624)
print v(xbgr.mr_n77681056)
print v(xbgr.mr_n77681376)
print v(xbgr.mr_n77681488)
print v(xbgr.mr_n77681920)
print v(xbgr.mr_n77682352)
print v(xbgr.mr_n77682784)
print v(xbgr.mr_n77683216)
print v(xbgr.mr_n77683648)
print v(xbgr.mr_n77684080)
print v(xbgr.mr_n77684512)
print v(xbgr.mr_n77684944)
print v(xbgr.mr_n77685376)
print v(xbgr.mr_n77685808)
print v(xbgr.mr_n77686240)
print v(xbgr.mr_n77686672)
print v(xbgr.mr_n77687104)
print v(xbgr.mr_n77687536)
print v(xbgr.mr_n77687968)
print v(xbgr.mr_n77688400)
print v(xbgr.mr_n77688832)
print v(xbgr.mr_n77689264)
print v(xbgr.mr_n77689696)
print v(xbgr.mr_n77690128)
print v(xbgr.mr_n77690560)
print v(xbgr.mr_n77690992)
print v(xbgr.mr_n77691424)
print v(xbgr.mr_n77691856)
print v(xbgr.mr_n77692288)
print v(xbgr.mr_n77692720)
print v(xbgr.mr_n77693152)
print v(xbgr.mr_n77693584)
print v(xbgr.mr_n77694016)
print v(xbgr.mr_n77694448)
print v(xbgr.mr_n77694880)
print v(xbgr.mr_n77695312)
print v(xbgr.mr_n77695744)
print v(xbgr.mr_n77696176)
print v(xbgr.mr_n77696608)
print v(xbgr.mr_n77697040)
print v(xbgr.mr_n77697472)
print v(xbgr.mr_n77697904)
print v(xbgr.mr_n77698336)
print v(xbgr.mr_n77698768)
print v(xbgr.mr_n77699200)
print v(xbgr.mr_n77699632)
print v(xbgr.mr_n77700064)
print v(xbgr.mr_n77700496)
print v(xbgr.mr_n77700928)
print v(xbgr.mr_n77701360)
print v(xbgr.mr_n77701792)
print v(xbgr.mr_n77702112)
print v(xbgr.mr_n77702224)
print v(xbgr.mr_n77702656)
print v(xbgr.mr_n77703088)
print v(xbgr.mr_n77703408)
print v(xbgr.mr_n77703520)
print v(xbgr.mr_n77703840)
print v(xbgr.mr_n77703952)
print v(xbgr.mr_n77704272)
print v(xbgr.mr_n77704384)
print v(xbgr.mr_n77704704)
print v(xbgr.mr_n77704816)
print v(xbgr.mr_n77705136)
print v(xbgr.mr_n77705248)
print v(xbgr.mr_n77705568)
print v(xbgr.mr_n77705680)
print v(xbgr.mr_n77706112)
print v(xbgr.mr_n77706432)
print v(xbgr.mr_n77706544)
print v(xbgr.mr_n77706864)
print v(xbgr.mr_n77706976)
print v(xbgr.mr_n77707296)
print v(xbgr.mr_n77707408)
print v(xbgr.mr_n77707728)
print v(xbgr.mr_n77707840)
print v(xbgr.mr_n77708160)
print v(xbgr.mr_n77708272)
print v(xbgr.mr_n77708592)
print v(xbgr.mr_n77708704)
print v(xbgr.mr_n77709136)
print v(xbgr.mr_n77709456)
print v(xbgr.mr_n77709568)
print v(xbgr.mr_n77709888)
print v(xbgr.mr_n77710000)
print v(xbgr.mr_n77710320)
print v(xbgr.mr_n77710432)
print v(xbgr.mr_n77710752)
print v(xbgr.mr_n77710864)
print v(xbgr.mr_n77711184)
print v(xbgr.mr_n77711296)
print v(xbgr.mr_n77711616)
print v(xbgr.mr_n77711728)
print v(xbgr.mr_n77712160)
print v(xbgr.mr_n77712480)
print v(xbgr.mr_n77712592)
print v(xbgr.mr_n77712912)
print v(xbgr.mr_n77713024)
print v(xbgr.mr_n77713344)
print v(xbgr.mr_n77713456)
print v(xbgr.mr_n77713888)
print v(xbgr.mr_n77714208)
print v(xbgr.mr_n77714320)
print v(xbgr.mr_n77714752)
print v(xbgr.mr_n77715184)
print v(xbgr.mr_n77715616)
print v(xbgr.mr_n77716048)
print v(xbgr.mr_n77717344)
print v(xbgr.mr_n77717776)
print v(xbgr.mr_n77719072)
print v(xbgr.mr_n77719504)
print v(xbgr.mr_n77719824)
print v(xbgr.mr_n77719936)
print v(xbgr.mr_n77720256)
print v(xbgr.mr_n77720368)
print v(xbgr.mr_n77720688)
print v(xbgr.mr_n77720800)
print v(xbgr.mr_n77721120)
print v(xbgr.mr_n77721664)
print v(xbgr.mr_n77722416)
print v(xbgr.mr_n77722528)
print v(xbgr.mr_n77722848)
print v(xbgr.mr_n77725120)
print v(xbgr.mr_n77725984)
print v(xbgr.mr_n77726848)
print v(xbgr.mr_n77727280)
print v(xbgr.mr_n77727712)
print v(xbgr.mr_n77728144)
print v(xbgr.mr_n77730192)
print v(xbgr.mr_n77730304)
print v(xbgr.mr_n77730736)
print v(xbgr.mr_n77731056)
print v(xbgr.mr_n77731168)
print v(xbgr.mr_n77731488)
print v(xbgr.mr_n77731600)
print v(xbgr.mr_n77732032)
print v(xbgr.mr_n77732352)
print v(xbgr.mr_n77732464)
print v(xbgr.mr_n77732784)
print v(xbgr.mr_n77732896)
print v(xbgr.mr_n77733216)
print v(xbgr.mr_n77733328)
print v(xbgr.mr_n77733760)
print v(xbgr.mr_n77734080)
print v(xbgr.mr_n77734192)
print v(xbgr.mr_n77734512)
print v(xbgr.mr_n77734624)
print v(xbgr.mr_n77734944)
print v(xbgr.mr_n77735056)
print v(xbgr.mr_n77735488)
print v(xbgr.mr_n77735808)
print v(xbgr.mr_n77735920)
print v(xbgr.mr_n77736240)
print v(xbgr.mr_n77736352)
print v(xbgr.mr_n77736672)
print v(xbgr.mr_n77736784)
print v(xbgr.mr_n77737104)
print v(xbgr.mr_n77737216)
print v(xbgr.mr_n77737536)
print v(xbgr.mr_n77737648)
print v(xbgr.mr_n77738080)
print v(xbgr.mr_n77738400)
print v(xbgr.mr_n77738512)
print v(xbgr.mr_n77738832)
print v(xbgr.mr_n77738944)
print v(xbgr.mr_n77739264)
print v(xbgr.mr_n77739376)
print v(xbgr.mr_n77739696)
print v(xbgr.mr_n77739808)
print v(xbgr.mr_n77740240)
print v(xbgr.mr_n77740560)
print v(xbgr.mr_n77740672)
print v(xbgr.mr_n77740992)
print v(xbgr.mr_n77741104)
print v(xbgr.mr_n77741536)
print v(xbgr.mr_n77741856)
print v(xbgr.mr_n77741968)
print v(xbgr.mr_n77742288)
print v(xbgr.mr_n77742400)
print v(xbgr.mr_n77742720)
print v(xbgr.mr_n77742832)
print v(xbgr.mr_n77743264)
print v(xbgr.mr_n77743584)
print v(xbgr.mr_n77743696)
print v(xbgr.mr_n77744016)
print v(xbgr.mr_n77744128)
print v(xbgr.mr_n77744448)
print v(xbgr.mr_n77744560)
print v(xbgr.mr_n77744992)
print v(xbgr.mr_n77745312)
print v(xbgr.mr_n77745424)
print v(xbgr.mr_n77745744)
print v(xbgr.mr_n77745856)
print v(xbgr.mr_n77746176)
print v(xbgr.mr_n77746288)
print v(xbgr.mr_n77746608)
print v(xbgr.mr_n77746720)
print v(xbgr.mr_n77747040)
print v(xbgr.mr_n77747152)
print v(xbgr.mr_n77747472)
print v(xbgr.mr_n77747584)
print v(xbgr.mr_n77747904)
print v(xbgr.mr_n77748016)
print v(xbgr.mr_n77748336)
print v(xbgr.mr_n77748448)
print v(xbgr.mr_n77748768)
print v(xbgr.mr_n77748880)
print v(xbgr.mr_n77749200)
print v(xbgr.mr_n77749312)
print v(xbgr.mr_n77749632)
print v(xbgr.mr_n77749744)
print v(xbgr.mr_n77750064)
print v(xbgr.mr_n77750176)
print v(xbgr.mr_n77750496)
print v(xbgr.mr_n77750608)
print v(xbgr.mr_n77751040)
print v(xbgr.mr_n77751360)
print v(xbgr.mr_n77751472)
print v(xbgr.mr_n77751792)
print v(xbgr.mr_n77751904)
print v(xbgr.mr_n77752224)
print v(xbgr.mr_n77752336)
print v(xbgr.mr_n77752656)
print v(xbgr.mr_n77752768)
print v(xbgr.mr_n77753088)
print v(xbgr.mr_n77753200)
print v(xbgr.mr_n77753520)
print v(xbgr.mr_n77753632)
print v(xbgr.mr_n77753952)
print v(xbgr.mr_n77754064)
print v(xbgr.mr_n77754384)
print v(xbgr.mr_n77754496)
print v(xbgr.mr_n77754816)
print v(xbgr.mr_n77754928)
print v(xbgr.mr_n77755248)
print v(xbgr.mr_n77755360)
print v(xbgr.mr_n77755792)
print v(xbgr.mr_n77756112)
print v(xbgr.mr_n77756224)
print v(xbgr.mr_n77756544)
print v(xbgr.mr_n77756656)
print v(xbgr.mr_n77756976)
print v(xbgr.mr_n77757088)
print v(xbgr.mr_n77757408)
print v(xbgr.mr_n77757520)
print v(xbgr.mr_n77757840)
print v(xbgr.mr_n77757952)
print v(xbgr.mr_n77758272)
print v(xbgr.mr_n77758384)
print v(xbgr.mr_n77758704)
print v(xbgr.mr_n77758816)
print v(xbgr.mr_n77759136)
print v(xbgr.mr_n77759248)
print v(xbgr.mr_n77759568)
print v(xbgr.mr_n77759680)
print v(xbgr.mr_n77760000)
print v(xbgr.mr_n77760112)
print v(xbgr.mr_n77760432)
print v(xbgr.mr_n77760544)
print v(xbgr.mr_n77760864)
print v(xbgr.mr_n77760976)
print v(xbgr.mr_n77761296)
print v(xbgr.mr_n77761408)
print v(xbgr.mr_n77761728)
print v(xbgr.mr_n77761840)
print v(xbgr.mr_n77762160)
print v(xbgr.mr_n77762272)
print v(xbgr.mr_n77762592)
print v(xbgr.mr_n77762704)
print v(xbgr.mr_n77763136)
print v(xbgr.mr_n77763456)
print v(xbgr.mr_n77763568)
print v(xbgr.mr_n77763888)
print v(xbgr.mr_n77764000)
print v(xbgr.mr_n77764320)
print v(xbgr.mr_n77764432)
print v(xbgr.mr_n77764752)
print v(xbgr.mr_n77764864)
print v(xbgr.mr_n77765184)
print v(xbgr.mr_n77765296)
print v(xbgr.mr_n77765616)
print v(xbgr.mr_n77765728)
print v(xbgr.mr_n77766048)
print v(xbgr.mr_n77766160)
print v(xbgr.mr_n77766480)
print v(xbgr.mr_n77766592)
print v(xbgr.mr_n77766912)
print v(xbgr.mr_n77767024)
print v(xbgr.mr_n77767344)
print v(xbgr.mr_n77767456)
print v(xbgr.mr_n77767776)
print v(xbgr.mr_n77767888)
print v(xbgr.mr_n77768208)
print v(xbgr.mr_n77768320)
print v(xbgr.mr_n77768752)
print v(xbgr.mr_n77769072)
print v(xbgr.mr_n77769184)
print v(xbgr.mr_n77769504)
print v(xbgr.mr_n77769616)
print v(xbgr.mr_n77769936)
print v(xbgr.mr_n77770048)
print v(xbgr.mr_n77770368)
print v(xbgr.mr_n77770480)
print v(xbgr.mr_n77770800)
print v(xbgr.mr_n77770912)
print v(xbgr.mr_n77771232)
print v(xbgr.mr_n77771344)
print v(xbgr.mr_n77771664)
print v(xbgr.mr_n77771776)
print v(xbgr.mr_n77772096)
print v(xbgr.mr_n77772208)
print v(xbgr.mr_n77772528)
print v(xbgr.mr_n77772640)
print v(xbgr.mr_n77772960)
print v(xbgr.mr_n77773072)
print v(xbgr.mr_n77773392)
print v(xbgr.mr_n77773504)
print v(xbgr.mr_n77773824)
print v(xbgr.mr_n77773936)
print v(xbgr.mr_n77774256)
print v(xbgr.mr_n77774368)
print v(xbgr.mr_n77774688)
print v(xbgr.mr_n77774800)
print v(xbgr.mr_n77775120)
print v(xbgr.mr_n77775232)
print v(xbgr.mr_n77775552)
print v(xbgr.mr_n77775664)
print v(xbgr.mr_n77775984)
print v(xbgr.mr_n77776096)
print v(xbgr.mr_n77776416)
print v(xbgr.mr_n77776528)
print v(xbgr.mr_n77776848)
print v(xbgr.mr_n77776960)
print v(xbgr.mr_n77777280)
print v(xbgr.mr_n77777392)
print v(xbgr.mr_n77777824)
print v(xbgr.mr_n77778144)
print v(xbgr.mr_n77778256)
print v(xbgr.mr_n77778576)
print v(xbgr.mr_n77778688)
print v(xbgr.mr_n77779008)
print v(xbgr.mr_n77779120)
print v(xbgr.mr_n77779440)
print v(xbgr.mr_n77779552)
print v(xbgr.mr_n77779872)
print v(xbgr.mr_n77779984)
print v(xbgr.mr_n77780304)
print v(xbgr.mr_n77780416)
print v(xbgr.mr_n77780736)
print v(xbgr.mr_n77780848)
print v(xbgr.mr_n77781168)
print v(xbgr.mr_n77781280)
print v(xbgr.mr_n77781600)
print v(xbgr.mr_n77781712)
print v(xbgr.mr_n77782032)
print v(xbgr.mr_n77782144)
print v(xbgr.mr_n77782464)
print v(xbgr.mr_n77782576)
print v(xbgr.mr_n77782896)
print v(xbgr.mr_n77783008)
print v(xbgr.mr_n77783328)
print v(xbgr.mr_n77783440)
print v(xbgr.mr_n77783760)
print v(xbgr.mr_n77783872)
print v(xbgr.mr_n77784192)
print v(xbgr.mr_n77784304)
print v(xbgr.mr_n77784624)
print v(xbgr.mr_n77784736)
print v(xbgr.mr_n77785056)
print v(xbgr.mr_n77785168)
print v(xbgr.mr_n77785488)
print v(xbgr.mr_n77785600)
print v(xbgr.mr_n77785920)
print v(xbgr.mr_n77786032)
print v(xbgr.mr_n77786352)
print v(xbgr.mr_n77786464)
print v(xbgr.mr_n77786784)
print v(xbgr.mr_n77786896)
print v(xbgr.mr_n77787216)
print v(xbgr.mr_n77787328)
print v(xbgr.mr_n77787760)
print v(xbgr.mr_n77788080)
print v(xbgr.mr_n77788192)
print v(xbgr.mr_n77788512)
print v(xbgr.mr_n77788624)
print v(xbgr.mr_n77788944)
print v(xbgr.mr_n77789056)
print v(xbgr.mr_n77789376)
print v(xbgr.mr_n77789488)
print v(xbgr.mr_n77789808)
print v(xbgr.mr_n77789920)
print v(xbgr.mr_n77790240)
print v(xbgr.mr_n77790352)
print v(xbgr.mr_n77790672)
print v(xbgr.mr_n77790784)
print v(xbgr.mr_n77791104)
print v(xbgr.mr_n77791216)
print v(xbgr.mr_n77791536)
print v(xbgr.mr_n77791648)
print v(xbgr.mr_n77791968)
print v(xbgr.mr_n77792080)
print v(xbgr.mr_n77792400)
print v(xbgr.mr_n77792512)
print v(xbgr.mr_n77792832)
print v(xbgr.mr_n77792944)
print v(xbgr.mr_n77793376)
print v(xbgr.mr_n77793808)
print v(xbgr.mr_n77794240)
print v(xbgr.mr_n77794672)
print v(xbgr.mr_n77795104)
print v(xbgr.mr_n77795536)
print v(xbgr.mr_n77795968)
print v(xbgr.mr_n77796400)
print v(xbgr.mr_n77796832)
print v(xbgr.mr_n77797264)
print v(xbgr.mr_n77797696)
print v(xbgr.mr_n77798128)
print v(xbgr.mr_n77798560)
print v(xbgr.mr_n77798992)
print v(xbgr.mr_n77799424)
print v(xbgr.mr_n77799856)
print v(xbgr.mr_n77800288)
print v(xbgr.mr_n77800720)
print v(xbgr.mr_n77801152)
print v(xbgr.mr_n77801584)
print v(xbgr.mr_n77802016)
print v(xbgr.mr_n77802448)
print v(xbgr.mr_n77802880)
print v(xbgr.mr_n77803312)
print v(xbgr.mr_n77803744)
print v(xbgr.mr_n77804176)
print v(xbgr.mr_n77804608)
print v(xbgr.mr_n77805040)
print v(xbgr.mr_n77805472)
print v(xbgr.mr_n77805904)
print v(xbgr.mr_n77806336)
print v(xbgr.mr_n77806768)
print v(xbgr.mr_n77807200)
print v(xbgr.mr_n77807632)
print v(xbgr.mr_n77808064)
print v(xbgr.mr_n77808496)
print v(xbgr.mr_n77808928)
print v(xbgr.mr_n77809360)
print v(xbgr.mr_n77809792)
print v(xbgr.mr_n77810224)
print v(xbgr.mr_n77810656)
print v(xbgr.mr_n77811088)
print v(xbgr.mr_n77811520)
print v(xbgr.mr_n77811952)
print v(xbgr.mr_n77812384)
print v(xbgr.mr_n77812816)
print v(xbgr.mr_n77813248)
print v(xbgr.mr_n77813680)
print v(xbgr.mr_n77814112)
print v(xbgr.mr_n77814544)
print v(xbgr.mr_n77814976)
print v(xbgr.mr_n77815408)
print v(xbgr.mr_n77815840)
print v(xbgr.mr_n77816272)
print v(xbgr.mr_n77816704)
print v(xbgr.mr_n77817136)
print v(xbgr.mr_n77817568)
print v(xbgr.mr_n77818000)
print v(xbgr.mr_n77818432)
print v(xbgr.mr_n77818864)
print v(xbgr.mr_n77819296)
print v(xbgr.mr_n77819728)
print v(xbgr.mr_n77820160)
print v(xbgr.mr_n77820592)
print v(xbgr.mr_n77821024)
print v(xbgr.mr_n77821456)
print v(xbgr.mr_n77821888)
print v(xbgr.mr_n77822320)
print v(xbgr.mr_n77822752)
print v(xbgr.mr_n77823184)
print v(xbgr.mr_n77823616)
print v(xbgr.mr_n77824048)
print v(xbgr.mr_n77824480)
print v(xbgr.mr_n77824912)
print v(xbgr.mr_n77825344)
print v(xbgr.mr_n77825776)
print v(xbgr.mr_n77826208)
print v(xbgr.mr_n77826640)
print v(xbgr.mr_n77827072)
print v(xbgr.mr_n77827504)
print v(xbgr.mr_n77827936)
print v(xbgr.mr_n77828368)
print v(xbgr.mr_n77828800)
print v(xbgr.mr_n77829232)
print v(xbgr.mr_n77829664)
print v(xbgr.mr_n77830096)
print v(xbgr.mr_n77830528)
print v(xbgr.mr_n77830960)
print v(xbgr.mr_n77831392)
print v(xbgr.mr_n77831824)
print v(xbgr.mr_n77832256)
print v(xbgr.mr_n77832688)
print v(xbgr.mr_n77833120)
print v(xbgr.mr_n77833552)
print v(xbgr.mr_n77833984)
print v(xbgr.mr_n77834416)
print v(xbgr.mr_n77834848)
print v(xbgr.mr_n77835280)
print v(xbgr.mr_n77835712)
print v(xbgr.mr_n77836144)
print v(xbgr.mr_n77836576)
print v(xbgr.mr_n77837008)
print v(xbgr.mr_n77837440)
print v(xbgr.mr_n77837872)
print v(xbgr.mr_n77838304)
print v(xbgr.mr_n77838736)
print v(xbgr.mr_n77839168)
print v(xbgr.mr_n77839600)
print v(xbgr.mr_n77840032)
print v(xbgr.mr_n77840464)
print v(xbgr.mr_n77840784)
print v(xbgr.mr_n77840896)
print v(xbgr.mr_n77841216)
print v(xbgr.mr_n77841328)
print v(xbgr.mr_n77841648)
print v(xbgr.mr_n77841760)
print v(xbgr.mr_n77842080)
print v(xbgr.mr_n77842192)
print v(xbgr.mr_n77842512)
print v(xbgr.mr_n77842624)
print v(xbgr.mr_n77842944)
print v(xbgr.mr_n77843056)
print v(xbgr.mr_n77843376)
print v(xbgr.mr_n77843488)
print v(xbgr.mr_n77843808)
print v(xbgr.mr_n77843920)
print v(xbgr.mr_n77844240)
print v(xbgr.mr_n77844352)
print v(xbgr.mr_n77844672)
print v(xbgr.mr_n77844784)
print v(xbgr.mr_n77845104)
print v(xbgr.mr_n77845216)
print v(xbgr.mr_n77845536)
print v(xbgr.mr_n77845648)
print v(xbgr.mr_n77845968)
print v(xbgr.mr_n77846080)
print v(xbgr.mr_n77846400)
print v(xbgr.mr_n77846512)
print v(xbgr.mr_n77846832)
print v(xbgr.mr_n77846944)
print v(xbgr.mr_n77847264)
print v(xbgr.mr_n77847376)
print v(xbgr.mr_n77847696)
print v(xbgr.mr_n77847808)
print v(xbgr.mr_n77848128)
print v(xbgr.mr_n77848240)
print v(xbgr.mr_n77848560)
print v(xbgr.mr_n77848672)
print v(xbgr.mr_n77848992)
print v(xbgr.mr_n77849104)
print v(xbgr.mr_n77849424)
print v(xbgr.mr_n77849536)
print v(xbgr.mr_n77849856)
print v(xbgr.mr_n77849968)
print v(xbgr.mr_n77850288)
print v(xbgr.mr_n77850400)
print v(xbgr.mr_n77850720)
print v(xbgr.mr_n77850832)
print v(xbgr.mr_n77851152)
print v(xbgr.mr_n77851264)
print v(xbgr.mr_n77851584)
print v(xbgr.mr_n77851696)
print v(xbgr.mr_n77852016)
print v(xbgr.mr_n77852128)
print v(xbgr.mr_n77852448)
print v(xbgr.mr_n77852560)
print v(xbgr.mr_n77852880)
print v(xbgr.mr_n77852992)
print v(xbgr.mr_n77853312)
print v(xbgr.mr_n77853424)
print v(xbgr.mr_n77853744)
print v(xbgr.mr_n77853856)
print v(xbgr.mr_n77854176)
print v(xbgr.mr_n77854288)
print v(xbgr.mr_n77854608)
print v(xbgr.mr_n77854720)
print v(xbgr.mr_n77855040)
print v(xbgr.mr_n77855152)
print v(xbgr.mr_n77855472)
print v(xbgr.mr_n77855584)
print v(xbgr.mr_n77855904)
print v(xbgr.mr_n77856016)
print v(xbgr.mr_n77856336)
print v(xbgr.mr_n77856448)
print v(xbgr.mr_n77856768)
print v(xbgr.mr_n77856880)
print v(xbgr.mr_n77857200)
print v(xbgr.mr_n77857312)
print v(xbgr.mr_n77857632)
print v(xbgr.mr_n77857744)
print v(xbgr.mr_n77858064)
print v(xbgr.mr_n77858176)
print v(xbgr.mr_n77858496)
print v(xbgr.mr_n77858608)
print v(xbgr.mr_n77858928)
print v(xbgr.mr_n77859040)
print v(xbgr.mr_n77859360)
print v(xbgr.mr_n77859472)
print v(xbgr.mr_n77859792)
print v(xbgr.mr_n77859904)
print v(xbgr.mr_n77860224)
print v(xbgr.mr_n77860336)
print v(xbgr.mr_n77860656)
print v(xbgr.mr_n77860768)
print v(xbgr.mr_n77861088)
print v(xbgr.mr_n77861200)
print v(xbgr.mr_n77861520)
print v(xbgr.mr_n77861632)
print v(xbgr.mr_n77861952)
print v(xbgr.mr_n77862064)
print v(xbgr.mr_n77862496)
print v(xbgr.mr_n77862816)
print v(xbgr.mr_n77862928)
print v(xbgr.mr_n77863248)
print v(xbgr.mr_n77863360)
print v(xbgr.mr_n77863680)
print v(xbgr.mr_n77863792)
print v(xbgr.mr_n77864112)
print v(xbgr.mr_n77864224)
print v(xbgr.mr_n77864544)
print v(xbgr.mr_n77864656)
print v(xbgr.mr_n77864976)
print v(xbgr.mr_n77865088)
print v(xbgr.mr_n77865408)
print v(xbgr.mr_n77865520)
print v(xbgr.mr_n77865840)
print v(xbgr.mr_n77865952)
print v(xbgr.mr_n77866272)
print v(xbgr.mr_n77866384)
print v(xbgr.mr_n77866704)
print v(xbgr.mr_n77866816)
print v(xbgr.mr_n77867136)
print v(xbgr.mr_n77867248)
print v(xbgr.mr_n77867568)
print v(xbgr.mr_n77867680)
print v(xbgr.mr_n77868000)
print v(xbgr.mr_n77868112)
print v(xbgr.mr_n77868432)
print v(xbgr.mr_n77868544)
print v(xbgr.mr_n77868864)
print v(xbgr.mr_n77868976)
print v(xbgr.mr_n77869296)
print v(xbgr.mr_n77869408)
print v(xbgr.mr_n77869856)
print v(xbgr.mr_n77869968)
print v(xbgr.mr_n77870288)
print v(xbgr.mr_n77870400)
print v(xbgr.mr_n77870720)
print v(xbgr.mr_n77870832)
print v(xbgr.mr_n77871152)
print v(xbgr.mr_n77871264)
print v(xbgr.mr_n77871584)
print v(xbgr.mr_n77871696)
print v(xbgr.mr_n77872016)
print v(xbgr.mr_n77872128)
print v(xbgr.mr_n77872448)
print v(xbgr.mr_n77872560)
print v(xbgr.mr_n77872880)
print v(xbgr.mr_n77872992)
print v(xbgr.mr_n77873312)
print v(xbgr.mr_n77873424)
print v(xbgr.mr_n77873744)
print v(xbgr.mr_n77873856)
print v(xbgr.mr_n77874176)
print v(xbgr.mr_n77874288)
print v(xbgr.mr_n77874608)
print v(xbgr.mr_n77874720)
print v(xbgr.mr_n77875040)
print v(xbgr.mr_n77875152)
print v(xbgr.mr_n77875472)
print v(xbgr.mr_n77875584)
print v(xbgr.mr_n77875904)
print v(xbgr.mr_n77876016)
print v(xbgr.mr_n77876336)
print v(xbgr.mr_n77876448)
print v(xbgr.mr_n77876880)
print v(xbgr.mr_n77877312)
print v(xbgr.mr_n77877632)
print v(xbgr.mr_n77877744)
print v(xbgr.mr_n77878064)
print v(xbgr.mr_n77878176)
print v(xbgr.mr_n77878496)
print v(xbgr.mr_n77878608)
print v(xbgr.mr_n77878928)
print v(xbgr.mr_n77879040)
print v(xbgr.mr_n77879360)
print v(xbgr.mr_n77879472)
print v(xbgr.mr_n77879792)
print v(xbgr.mr_n77879904)
print v(xbgr.mr_n77880336)
print v(xbgr.mr_n77880656)
print v(xbgr.mr_n77880768)
print v(xbgr.mr_n77881088)
print v(xbgr.mr_n77881200)
print v(xbgr.mr_n77881520)
print v(xbgr.mr_n77881632)
print v(xbgr.mr_n77881952)
print v(xbgr.mr_n77882064)
print v(xbgr.mr_n77882384)
print v(xbgr.mr_n77882496)
print v(xbgr.mr_n77882816)
print v(xbgr.mr_n77882928)
print v(xbgr.mr_n77883248)
print v(xbgr.mr_n77883360)
print v(xbgr.mr_n77883680)
print v(xbgr.mr_n77883792)
print v(xbgr.mr_n77884112)
print v(xbgr.mr_n77884224)
print v(xbgr.mr_n77884544)
print v(xbgr.mr_n77884656)
print v(xbgr.mr_n77884976)
print v(xbgr.mr_n77885088)
print v(xbgr.mr_n77885408)
print v(xbgr.mr_n77885520)
print v(xbgr.mr_n77885952)
print v(xbgr.mr_n77886384)
print v(xbgr.mr_n77886816)
print v(xbgr.mr_n77887248)
print v(xbgr.mr_n77887744)
print v(xbgr.mr_n77887856)
print v(xbgr.mr_n77888192)
print v(xbgr.mr_n77888304)
print v(xbgr.mr_n77888624)
print v(xbgr.mr_n77888736)
print v(xbgr.mr_n77889104)
print v(xbgr.mr_n77889216)
print v(xbgr.mr_n77889536)
print v(xbgr.mr_n77889648)
print v(xbgr.mr_n77889968)
print v(xbgr.mr_n77890080)
print v(xbgr.mr_n77890320)
print v(xbgr.mr_n77890432)
print v(xbgr.mr_n77890752)
print v(xbgr.mr_n77890864)
print v(xbgr.mr_n77891184)
print v(xbgr.mr_n77891296)
print v(xbgr.mr_n77891616)
print v(xbgr.mr_n77891728)
print v(xbgr.mr_n77892048)
print v(xbgr.mr_n77892160)
print v(xbgr.mr_n77892480)
print v(xbgr.mr_n77892592)
print v(xbgr.mr_n77892912)
print v(xbgr.mr_n77893024)
print v(xbgr.mr_n77893344)
print v(xbgr.mr_n77893456)
print v(xbgr.mr_n77893776)
print v(xbgr.mr_n77893888)
print v(xbgr.mr_n77894208)
print v(xbgr.mr_n77894320)
print v(xbgr.mr_n77894640)
print v(xbgr.mr_n77894752)
print v(xbgr.mr_n77895072)
print v(xbgr.mr_n77895184)
print v(xbgr.mr_n77895504)
print v(xbgr.mr_n77895616)
print v(xbgr.mr_n77895936)
print v(xbgr.mr_n77896048)
print v(xbgr.mr_n77896368)
print v(xbgr.mr_n77896480)
print v(xbgr.mr_n77896800)
print v(xbgr.mr_n77896912)
print v(xbgr.mr_n77897232)
print v(xbgr.mr_n77897344)
print v(xbgr.mr_n77897664)
print v(xbgr.mr_n77897776)
print v(xbgr.mr_n77898096)
print v(xbgr.mr_n77898208)
print v(xbgr.mr_n77898528)
print v(xbgr.mr_n77898640)
print v(xbgr.mr_n77898960)
print v(xbgr.mr_n77899072)
print v(xbgr.mr_n77899392)
print v(xbgr.mr_n77899504)
print v(xbgr.mr_n77899824)
print v(xbgr.mr_n77899936)
print v(xbgr.mr_n77900256)
print v(xbgr.mr_n77900368)
print v(xbgr.mr_n77900688)
print v(xbgr.mr_n77900800)
print v(xbgr.mr_n77901232)
print v(xbgr.mr_n77901552)
print v(xbgr.mr_n77902544)
print v(xbgr.mr_n77902656)
print v(xbgr.mr_n77902976)
print v(xbgr.mr_n77903088)
print v(xbgr.mr_n77903408)
print v(xbgr.mr_n77903520)
print v(xbgr.mr_n77903952)
print v(xbgr.mr_n77904272)
print v(xbgr.mr_n77904384)
print v(xbgr.mr_n77904704)
print v(xbgr.mr_n77904816)
print v(xbgr.mr_n77905136)
print v(xbgr.mr_n77905248)
print v(xbgr.mr_n77905568)
print v(xbgr.mr_n77905680)
print v(xbgr.mr_n77906000)
print v(xbgr.mr_n77906112)
print v(xbgr.mr_n77906544)
print v(xbgr.mr_n77906976)
print v(xbgr.mr_n77907408)
print v(xbgr.mr_n77907840)
print v(xbgr.mr_n77908160)
print v(xbgr.mr_n77908272)
print v(xbgr.mr_n77908592)
print v(xbgr.mr_n77908704)
print v(xbgr.mr_n77909024)
print v(xbgr.mr_n77909136)
print v(xbgr.mr_n77909568)
print v(xbgr.mr_n77910000)
print v(xbgr.mr_n77910320)
print v(xbgr.mr_n77910432)
print v(xbgr.mr_n77910752)
print v(xbgr.mr_n77910864)
print v(xbgr.mr_n77911184)
print v(xbgr.mr_n77911296)
print v(xbgr.mr_n77911616)
print v(xbgr.mr_n77911728)
print v(xbgr.mr_n77912160)
print v(xbgr.mr_n77912592)
print v(xbgr.mr_n77913024)
print v(xbgr.mr_n77913456)
print v(xbgr.mr_n77913888)
print v(xbgr.mr_n77914208)
print v(xbgr.mr_n77914320)
print v(xbgr.mr_n77914640)
print v(xbgr.mr_n77914752)
print v(xbgr.mr_n77915072)
print v(xbgr.mr_n77915184)
print v(xbgr.mr_n77915504)
print v(xbgr.mr_n77915616)
print v(xbgr.mr_n77915936)
print v(xbgr.mr_n77916048)
print v(xbgr.mr_n77916368)
print v(xbgr.mr_n77916480)
print v(xbgr.mr_n77916800)
print v(xbgr.mr_n77916912)
print v(xbgr.mr_n77917232)
print v(xbgr.mr_n77917344)
print v(xbgr.mr_n77917664)
print v(xbgr.mr_n77917776)
print v(xbgr.mr_n77918096)
print v(xbgr.mr_n77918208)
print v(xbgr.mr_n77918528)
print v(xbgr.mr_n77918640)
print v(xbgr.mr_n77918960)
print v(xbgr.mr_n77919072)
print v(xbgr.mr_n77919504)
print v(xbgr.mr_n77919824)
print v(xbgr.mr_n77919936)
print v(xbgr.mr_n77920256)
print v(xbgr.mr_n77920368)
print v(xbgr.mr_n77920688)
print v(xbgr.mr_n77920800)
print v(xbgr.mr_n77921120)
print v(xbgr.mr_n77921232)
print v(xbgr.mr_n77921552)
print v(xbgr.mr_n77921664)
print v(xbgr.mr_n77922096)
print v(xbgr.mr_n77922528)
print v(xbgr.mr_n77922960)
print v(xbgr.mr_n77923392)
print v(xbgr.mr_n77923712)
print v(xbgr.mr_n77923824)
print v(xbgr.mr_n77924144)
print v(xbgr.mr_n77924256)
print v(xbgr.mr_n77924576)
print v(xbgr.mr_n77924688)
print v(xbgr.mr_n77925008)
print v(xbgr.mr_n77925120)
print v(xbgr.mr_n77925440)
print v(xbgr.mr_n77925552)
print v(xbgr.mr_n77925872)
print v(xbgr.mr_n77925984)
print v(xbgr.mr_n77926304)
print v(xbgr.mr_n77926416)
print v(xbgr.mr_n77926736)
print v(xbgr.mr_n77926848)
print v(xbgr.mr_n77927168)
print v(xbgr.mr_n77927280)
print v(xbgr.mr_n77927600)
print v(xbgr.mr_n77927712)
print v(xbgr.mr_n77928032)
print v(xbgr.mr_n77928144)
print v(xbgr.mr_n77928464)
print v(xbgr.mr_n77928576)
print v(xbgr.mr_n77928896)
print v(xbgr.mr_n77929008)
print v(xbgr.mr_n77929328)
print v(xbgr.mr_n77929440)
print v(xbgr.mr_n77929760)
print v(xbgr.mr_n77929872)
print v(xbgr.mr_n77930192)
print v(xbgr.mr_n77930304)
print v(xbgr.mr_n77930624)
print v(xbgr.mr_n77930736)
print v(xbgr.mr_n77931056)
print v(xbgr.mr_n77931168)
print v(xbgr.mr_n77931488)
print v(xbgr.mr_n77931600)
print v(xbgr.mr_n77931920)
print v(xbgr.mr_n77932032)
print v(xbgr.mr_n77932352)
print v(xbgr.mr_n77932464)
print v(xbgr.mr_n77932784)
print v(xbgr.mr_n77932896)
print v(xbgr.mr_n77933216)
print v(xbgr.mr_n77933328)
print v(xbgr.mr_n77933648)
print v(xbgr.mr_n77933760)
print v(xbgr.mr_n77934080)
print v(xbgr.mr_n77934192)
print v(xbgr.mr_n77934512)
print v(xbgr.mr_n77934624)
print v(xbgr.mr_n77934944)
print v(xbgr.mr_n77935056)
print v(xbgr.mr_n77935376)
print v(xbgr.mr_n77935488)
print v(xbgr.mr_n77935808)
print v(xbgr.mr_n77935920)
print v(xbgr.mr_n77936240)
print v(xbgr.mr_n77936352)
print v(xbgr.mr_n77936672)
print v(xbgr.mr_n77936784)
print v(xbgr.mr_n77937104)
print v(xbgr.mr_n77937216)
print v(xbgr.mr_n77937536)
print v(xbgr.mr_n77937648)
print v(xbgr.mr_n77937968)
print v(xbgr.mr_n77938080)
print v(xbgr.mr_n77938400)
print v(xbgr.mr_n77938512)
print v(xbgr.mr_n77938832)
print v(xbgr.mr_n77938944)
print v(xbgr.mr_n77939264)
print v(xbgr.mr_n77939376)
print v(xbgr.mr_n77939696)
print v(xbgr.mr_n77939808)
print v(xbgr.mr_n77940128)
print v(xbgr.mr_n77940240)
print v(xbgr.mr_n77940560)
print v(xbgr.mr_n77940672)
print v(xbgr.mr_n77940992)
print v(xbgr.mr_n77941104)
print v(xbgr.mr_n77941424)
print v(xbgr.mr_n77941536)
print v(xbgr.mr_n77941856)
print v(xbgr.mr_n77941968)
print v(xbgr.mr_n77942288)
print v(xbgr.mr_n77942400)
print v(xbgr.mr_n77942832)
print v(xbgr.mr_n77943264)
print v(xbgr.mr_n77943584)
print v(xbgr.mr_n77943696)
print v(xbgr.mr_n77944016)
print v(xbgr.mr_n77944128)
print v(xbgr.mr_n77944448)
print v(xbgr.mr_n77944560)
print v(xbgr.mr_n77944880)
print v(xbgr.mr_n77944992)
print v(xbgr.mr_n77945424)
print v(xbgr.mr_n77945856)
print v(xbgr.mr_n77946176)
print v(xbgr.mr_n77946288)
print v(xbgr.mr_n77946608)
print v(xbgr.mr_n77946720)
print v(xbgr.mr_n77947040)
print v(xbgr.mr_n77947152)
print v(xbgr.mr_n77947472)
print v(xbgr.mr_n77947584)
print v(xbgr.mr_n77948016)
print v(xbgr.mr_n77948448)
print v(xbgr.mr_n77948880)
print v(xbgr.mr_n77949312)
print v(xbgr.mr_n77949744)
print v(xbgr.mr_n77950176)
print v(xbgr.mr_n77950608)
print v(xbgr.mr_n77951040)
print v(xbgr.mr_n77951472)
print v(xbgr.mr_n77951904)
print v(xbgr.mr_n77952336)
print v(xbgr.mr_n77952768)
print v(xbgr.mr_n77953088)
print v(xbgr.mr_n77953520)
print v(xbgr.mr_n77953952)
print v(xbgr.mr_n77954384)
print v(xbgr.mr_n77954816)
print v(xbgr.mr_n77955248)
print v(xbgr.mr_n77955680)
print v(xbgr.mr_n77956112)
print v(xbgr.mr_n77956544)
print v(xbgr.mr_n77956656)
print v(xbgr.mr_n77956976)
print v(xbgr.mr_n77957088)
print v(xbgr.mr_n77957408)
print v(xbgr.mr_n77957520)
print v(xbgr.mr_n77957840)
print v(xbgr.mr_n77957952)
print v(xbgr.mr_n77958272)
print v(xbgr.mr_n77958384)
print v(xbgr.mr_n77958704)
print v(xbgr.mr_n77958816)
print v(xbgr.mr_n77959136)
print v(xbgr.mr_n77959248)
print v(xbgr.mr_n77959568)
print v(xbgr.mr_n77959680)
print v(xbgr.mr_n77960000)
print v(xbgr.mr_n77960432)
print v(xbgr.mr_n77960864)
print v(xbgr.mr_n77961296)
print v(xbgr.mr_n77961728)
print v(xbgr.mr_n77962160)
print v(xbgr.mr_n77962592)
print v(xbgr.mr_n77963024)
print v(xbgr.mr_n77963456)
print v(xbgr.mr_n77963888)
print v(xbgr.mr_n77964432)
print v(xbgr.mr_n77964864)
print v(xbgr.mr_n77965296)
print v(xbgr.mr_n77965728)
print v(xbgr.mr_n77966160)
print v(xbgr.mr_n77966592)
print v(xbgr.mr_n77967024)
print v(xbgr.mr_n77967456)
print v(xbgr.mr_n77967888)
print v(xbgr.mr_n77968320)
print v(xbgr.mr_n77968752)
print v(xbgr.mr_n77969184)
print v(xbgr.mr_n77969616)
print v(xbgr.mr_n77970048)
print v(xbgr.mr_n77970480)
print v(xbgr.mr_n77970912)
print v(xbgr.mr_n77971344)
print v(xbgr.mr_n77971776)
print v(xbgr.mr_n77972208)
print v(xbgr.mr_n77972640)
print v(xbgr.mr_n77973072)
print v(xbgr.mr_n77973504)
print v(xbgr.mr_n77973936)
print v(xbgr.mr_n77974368)
print v(xbgr.mr_n77974800)
print v(xbgr.mr_n77975232)
print v(xbgr.mr_n77975664)
print v(xbgr.mr_n77976096)
print v(xbgr.mr_n77976528)
print v(xbgr.mr_n77976960)
print v(xbgr.mr_n77977392)
print v(xbgr.mr_n77977824)
print v(xbgr.mr_n77978256)
print v(xbgr.mr_n77978688)
print v(xbgr.mr_n77979120)
print v(xbgr.mr_n77979552)
print v(xbgr.mr_n77979984)
print v(xbgr.mr_n77980416)
print v(xbgr.mr_n77980848)
print v(xbgr.mr_n77981280)
print v(xbgr.mr_n77981712)
print v(xbgr.mr_n77982144)
print v(xbgr.mr_n77982576)
print v(xbgr.mr_n77983008)
print v(xbgr.mr_n77983440)
print v(xbgr.mr_n77983872)
print v(xbgr.mr_n77984304)
print v(xbgr.mr_n77984736)
print v(xbgr.mr_n77985168)
print v(xbgr.mr_n77985600)
print v(xbgr.mr_n77986032)
print v(xbgr.mr_n77986464)
print v(xbgr.mr_n77986896)
print v(xbgr.mr_n77987328)
print v(xbgr.mr_n77987760)
print v(xbgr.mr_n77988192)
print v(xbgr.mr_n77988624)
print v(xbgr.mr_n77989056)
print v(xbgr.mr_n77989488)
print v(xbgr.mr_n77989920)
print v(xbgr.mr_n77990352)
print v(xbgr.mr_n77990784)
print v(xbgr.mr_n77991216)
print v(xbgr.mr_n77991648)
print v(xbgr.mr_n77991968)
print v(xbgr.mr_n77992400)
print v(xbgr.mr_n77992832)
print v(xbgr.mr_n77993264)
print v(xbgr.mr_n77993696)
print v(xbgr.mr_n77994128)
print v(xbgr.mr_n77994672)
print v(xbgr.mr_n77995104)
print v(xbgr.mr_n77995536)
print v(xbgr.mr_n77995968)
print v(xbgr.mr_n77996400)
print v(xbgr.mr_n77996832)
print v(xbgr.mr_n77997264)
print v(xbgr.mr_n77997696)
print v(xbgr.mr_n77998128)
print v(xbgr.mr_n77998560)
print v(xbgr.mr_n77998992)
print v(xbgr.mr_n77999424)
print v(xbgr.mr_n77999856)
print v(xbgr.mr_n78000288)
print v(xbgr.mr_n78000720)
print v(xbgr.mr_n78001152)
print v(xbgr.mr_n78001584)
print v(xbgr.mr_n78002016)
print v(xbgr.mr_n78002448)
print v(xbgr.mr_n78002880)
print v(xbgr.mr_n78003312)
print v(xbgr.mr_n78003744)
print v(xbgr.mr_n78004176)
print v(xbgr.mr_n78004608)
print v(xbgr.mr_n78005040)
print v(xbgr.mr_n78005472)
print v(xbgr.mr_n78005792)
print v(xbgr.mr_n78005904)
print v(xbgr.mr_n78006224)
print v(xbgr.mr_n78006336)
print v(xbgr.mr_n78006656)
print v(xbgr.mr_n78006768)
print v(xbgr.mr_n78007088)
print v(xbgr.mr_n78007200)
print v(xbgr.mr_n78007520)
print v(xbgr.mr_n78007632)
print v(xbgr.mr_n78007952)
print v(xbgr.mr_n78008064)
print v(xbgr.mr_n78008384)
print v(xbgr.mr_n78008496)
print v(xbgr.mr_n78008816)
print v(xbgr.mr_n78008928)
print v(xbgr.mr_n78009248)
print v(xbgr.mr_n78009360)
print v(xbgr.mr_n78009680)
print v(xbgr.mr_n78009792)
print v(xbgr.mr_n78010112)
print v(xbgr.mr_n78010224)
print v(xbgr.mr_n78010544)
print v(xbgr.mr_n78010656)
print v(xbgr.mr_n78010976)
print v(xbgr.mr_n78011088)
print v(xbgr.mr_n78011408)
print v(xbgr.mr_n78011520)
print v(xbgr.mr_n78011840)
print v(xbgr.mr_n78011952)
print v(xbgr.mr_n78012272)
print v(xbgr.mr_n78012704)
print v(xbgr.mr_n78012816)
print v(xbgr.mr_n78013136)
print v(xbgr.mr_n78013568)
print v(xbgr.mr_n78013680)
print v(xbgr.mr_n78014000)
print v(xbgr.mr_n78014112)
print v(xbgr.mr_n78014432)
print v(xbgr.mr_n78014544)
print v(xbgr.mr_n78014864)
print v(xbgr.mr_n78014976)
print v(xbgr.mr_n78015296)
print v(xbgr.mr_n78015408)
print v(xbgr.mr_n78015728)
print v(xbgr.mr_n78015840)
print v(xbgr.mr_n78016160)
print v(xbgr.mr_n78016272)
print v(xbgr.mr_n78016592)
print v(xbgr.mr_n78017024)
print v(xbgr.mr_n78017136)
print v(xbgr.mr_n78017456)
print v(xbgr.mr_n78017568)
print v(xbgr.mr_n78017888)
print v(xbgr.mr_n78018000)
print v(xbgr.mr_n78018320)
print v(xbgr.mr_n78018432)
print v(xbgr.mr_n78018752)
print v(xbgr.mr_n78018864)
print v(xbgr.mr_n78019184)
print v(xbgr.mr_n78019296)
print v(xbgr.mr_n78019616)
print v(xbgr.mr_n78019728)
print v(xbgr.mr_n78020048)
print v(xbgr.mr_n78020160)
print v(xbgr.mr_n78020480)
print v(xbgr.mr_n78020592)
print v(xbgr.mr_n78020912)
print v(xbgr.mr_n78021024)
print v(xbgr.mr_n78021344)
print v(xbgr.mr_n78021456)
print v(xbgr.mr_n78021776)
print v(xbgr.mr_n78022208)
print v(xbgr.mr_n78022320)
print v(xbgr.mr_n78022640)
print v(xbgr.mr_n78022752)
print v(xbgr.mr_n78023072)
print v(xbgr.mr_n78023184)
print v(xbgr.mr_n78023504)
print v(xbgr.mr_n78023616)
print v(xbgr.mr_n78023936)
print v(xbgr.mr_n78024048)
print v(xbgr.mr_n78024368)
print v(xbgr.mr_n78024480)
print v(xbgr.mr_n78024800)
print v(xbgr.mr_n78024912)
print v(xbgr.mr_n78025232)
print v(xbgr.mr_n78025344)
print v(xbgr.mr_n78025664)
print v(xbgr.mr_n78025776)
print v(xbgr.mr_n78026096)
print v(xbgr.mr_n78026208)
print v(xbgr.mr_n78026528)
print v(xbgr.mr_n78026640)
print v(xbgr.mr_n78026960)
print v(xbgr.mr_n78027072)
print v(xbgr.mr_n78027392)
print v(xbgr.mr_n78027504)
print v(xbgr.mr_n78027824)
print v(xbgr.mr_n78028256)
print v(xbgr.mr_n78028368)
print v(xbgr.mr_n78028688)
print v(xbgr.mr_n78028800)
print v(xbgr.mr_n78029120)
print v(xbgr.mr_n78029232)
print v(xbgr.mr_n78029552)
print v(xbgr.mr_n78029664)
print v(xbgr.mr_n78029984)
print v(xbgr.mr_n78030096)
print v(xbgr.mr_n78030416)
print v(xbgr.mr_n78030528)
print v(xbgr.mr_n78030848)
print v(xbgr.mr_n78030960)
print v(xbgr.mr_n78031280)
print v(xbgr.mr_n78031712)
print v(xbgr.mr_n78031824)
print v(xbgr.mr_n78032144)
print v(xbgr.mr_n78032576)
print v(xbgr.mr_n78032688)
print v(xbgr.mr_n78033008)
print v(xbgr.mr_n78033120)
print v(xbgr.mr_n78033440)
print v(xbgr.mr_n78033552)
print v(xbgr.mr_n78033872)
print v(xbgr.mr_n78033984)
print v(xbgr.mr_n78034304)
print v(xbgr.mr_n78034416)
print v(xbgr.mr_n78034736)
print v(xbgr.mr_n78034848)
print v(xbgr.mr_n78035168)
print v(xbgr.mr_n78035280)
print v(xbgr.mr_n78035600)
print v(xbgr.mr_n78035712)
print v(xbgr.mr_n78036032)
print v(xbgr.mr_n78036144)
print v(xbgr.mr_n78036464)
print v(xbgr.mr_n78036576)
print v(xbgr.mr_n78036896)
print v(xbgr.mr_n78037008)
print v(xbgr.mr_n78037328)
print v(xbgr.mr_n78037440)
print v(xbgr.mr_n78037872)
print v(xbgr.mr_n78038304)
print v(xbgr.mr_n78038736)
print v(xbgr.mr_n78039168)
print v(xbgr.mr_n78039600)
print v(xbgr.mr_n78040032)
print v(xbgr.mr_n78040464)
print v(xbgr.mr_n78040896)
print v(xbgr.mr_n78041328)
print v(xbgr.mr_n78041760)
print v(xbgr.mr_n78042192)
print v(xbgr.mr_n78042624)
print v(xbgr.mr_n78043056)
print v(xbgr.mr_n78043488)
print v(xbgr.mr_n78043920)
print v(xbgr.mr_n78044352)
print v(xbgr.mr_n78044784)
print v(xbgr.mr_n78045216)
print v(xbgr.mr_n78045648)
print v(xbgr.mr_n78046080)
print v(xbgr.mr_n78046512)
print v(xbgr.mr_n78046944)
print v(xbgr.mr_n78047376)
print v(xbgr.mr_n78047808)
print v(xbgr.mr_n78048240)
print v(xbgr.mr_n78048672)
print v(xbgr.mr_n78049104)
print v(xbgr.mr_n78049536)
print v(xbgr.mr_n78049968)
print v(xbgr.mr_n78050400)
print v(xbgr.mr_n78050832)
print v(xbgr.mr_n78051264)
print v(xbgr.mr_n78051696)
print v(xbgr.mr_n78052128)
print v(xbgr.mr_n78052560)
print v(xbgr.mr_n78052992)
print v(xbgr.mr_n78053424)
print v(xbgr.mr_n78053856)
print v(xbgr.mr_n78054288)
print v(xbgr.mr_n78054720)
print v(xbgr.mr_n78055152)
print v(xbgr.mr_n78055584)
print v(xbgr.mr_n78056016)
print v(xbgr.mr_n78056448)
print v(xbgr.mr_n78056880)
print v(xbgr.mr_n78057312)
print v(xbgr.mr_n78057744)
print v(xbgr.mr_n78058176)
print v(xbgr.mr_n78058608)
print v(xbgr.mr_n78059040)
print v(xbgr.mr_n78059472)
print v(xbgr.mr_n78059904)
print v(xbgr.mr_n78060336)
print v(xbgr.mr_n78060768)
print v(xbgr.mr_n78061200)
print v(xbgr.mr_n78061632)
print v(xbgr.mr_n78062064)
print v(xbgr.mr_n78062496)
print v(xbgr.mr_n78062928)
print v(xbgr.mr_n78063360)
print v(xbgr.mr_n78063792)
print v(xbgr.mr_n78064224)
print v(xbgr.mr_n78064656)
print v(xbgr.mr_n78065088)
print v(xbgr.mr_n78065520)
print v(xbgr.mr_n78065952)
print v(xbgr.mr_n78066384)
print v(xbgr.mr_n78066816)
print v(xbgr.mr_n78067248)
print v(xbgr.mr_n78067680)
print v(xbgr.mr_n78068112)
print v(xbgr.mr_n78068544)
print v(xbgr.mr_n78068976)
print v(xbgr.mr_n78069408)
print v(xbgr.mr_n78069840)
print v(xbgr.mr_n78070272)
print v(xbgr.mr_n78070704)
print v(xbgr.mr_n78071136)
print v(xbgr.mr_n78071456)
print v(xbgr.mr_n78071568)
print v(xbgr.mr_n78071888)
print v(xbgr.mr_n78072000)
print v(xbgr.mr_n78072432)
print v(xbgr.mr_n78072864)
print v(xbgr.mr_n78073184)
print v(xbgr.mr_n78073296)
print v(xbgr.mr_n78073616)
print v(xbgr.mr_n78074160)
print v(xbgr.mr_n78074592)
print v(xbgr.mr_n78074912)
print v(xbgr.mr_n78075024)
print v(xbgr.mr_n78075344)
print v(xbgr.mr_n78075456)
print v(xbgr.mr_n78075776)
print v(xbgr.mr_n78075888)
print v(xbgr.mr_n78076208)
print v(xbgr.mr_n78076320)
print v(xbgr.mr_n78076640)
print v(xbgr.mr_n78076752)
print v(xbgr.mr_n78077072)
print v(xbgr.mr_n78077184)
print v(xbgr.mr_n78077504)
print v(xbgr.mr_n78077616)
print v(xbgr.mr_n78077936)
print v(xbgr.mr_n78078048)
print v(xbgr.mr_n78078368)
print v(xbgr.mr_n78078480)
print v(xbgr.mr_n78078800)
print v(xbgr.mr_n78078912)
print v(xbgr.mr_n78079232)
print v(xbgr.mr_n78079344)
print v(xbgr.mr_n78079664)
print v(xbgr.mr_n78079776)
print v(xbgr.mr_n78080208)
print v(xbgr.mr_n78080640)
print v(xbgr.mr_n78080960)
print v(xbgr.mr_n78081072)
print v(xbgr.mr_n78081392)
print v(xbgr.mr_n78081504)
print v(xbgr.mr_n78081936)
print v(xbgr.mr_n78082368)
print v(xbgr.mr_n78082800)
print v(xbgr.mr_n78083232)
print v(xbgr.mr_n78083664)
print v(xbgr.mr_n78084096)
print v(xbgr.mr_n78084528)
print v(xbgr.mr_n78084960)
print v(xbgr.mr_n78085392)
print v(xbgr.mr_n78085824)
print v(xbgr.mr_n78086256)
print v(xbgr.mr_n78086688)
print v(xbgr.mr_n78087120)
print v(xbgr.mr_n78087552)
print v(xbgr.mr_n78087984)
print v(xbgr.mr_n78088416)
print v(xbgr.mr_n78088848)
print v(xbgr.mr_n78089280)
print v(xbgr.mr_n78089712)
print v(xbgr.mr_n78090144)
print v(xbgr.mr_n78090576)
print v(xbgr.mr_n78091008)
print v(xbgr.mr_n78091440)
print v(xbgr.mr_n78091872)
print v(xbgr.mr_n78092304)
print v(xbgr.mr_n78092736)
print v(xbgr.mr_n78093168)
print v(xbgr.mr_n78093600)
print v(xbgr.mr_n78094032)
print v(xbgr.mr_n78094464)
print v(xbgr.mr_n78094896)
print v(xbgr.mr_n78095328)
print v(xbgr.mr_n78095760)
print v(xbgr.mr_n78096192)
print v(xbgr.mr_n78096624)
print v(xbgr.mr_n78097056)
print v(xbgr.mr_n78097488)
print v(xbgr.mr_n78097920)
print v(xbgr.mr_n78098352)
print v(xbgr.mr_n78098784)
print v(xbgr.mr_n78099216)
print v(xbgr.mr_n78099648)
print v(xbgr.mr_n78100080)
print v(xbgr.mr_n78100512)
print v(xbgr.mr_n78100944)
print v(xbgr.mr_n78101376)
print v(xbgr.mr_n78101808)
print v(xbgr.mr_n78102240)
print v(xbgr.mr_n78102672)
print v(xbgr.mr_n78103104)
print v(xbgr.mr_n78103536)
print v(xbgr.mr_n78103968)
print v(xbgr.mr_n78104400)
print v(xbgr.mr_n78104832)
print v(xbgr.mr_n78105264)
print v(xbgr.mr_n78105696)
print v(xbgr.mr_n78106128)
print v(xbgr.mr_n78106560)
print v(xbgr.mr_n78106992)
print v(xbgr.mr_n78107424)
print v(xbgr.mr_n78107856)
print v(xbgr.mr_n78108288)
print v(xbgr.mr_n78108720)
print v(xbgr.mr_n78109152)
print v(xbgr.mr_n78109584)
print v(xbgr.mr_n78110016)
print v(xbgr.mr_n78110448)
print v(xbgr.mr_n78110880)
print v(xbgr.mr_n78111312)
print v(xbgr.mr_n78111744)
print v(xbgr.mr_n78112176)
print v(xbgr.mr_n78112608)
print v(xbgr.mr_n78113040)
print v(xbgr.mr_n78113472)
print v(xbgr.mr_n78113904)
print v(xbgr.mr_n78114336)
print v(xbgr.mr_n78114768)
print v(xbgr.mr_n78115200)
print v(xbgr.mr_n78115632)
print v(xbgr.mr_n78116064)
print v(xbgr.mr_n78116496)
print v(xbgr.mr_n78116928)
print v(xbgr.mr_n78117360)
print v(xbgr.mr_n78117792)
print v(xbgr.mr_n78118224)
print v(xbgr.mr_n78118656)
print v(xbgr.mr_n78119088)
print v(xbgr.mr_n78119520)
print v(xbgr.mr_n78119952)
print v(xbgr.mr_n78120384)
print v(xbgr.mr_n78120816)
print v(xbgr.mr_n78121248)
print v(xbgr.mr_n78121680)
print v(xbgr.mr_n78122112)
print v(xbgr.mr_n78122544)
print v(xbgr.mr_n78122976)
print v(xbgr.mr_n78123408)
print v(xbgr.mr_n78123840)
print v(xbgr.mr_n78124272)
print v(xbgr.mr_n78124704)
print v(xbgr.mr_n78125136)
print v(xbgr.mr_n78125568)
print v(xbgr.mr_n78126000)
print v(xbgr.mr_n78126432)
print v(xbgr.mr_n78126864)
print v(xbgr.mr_n78127296)
print v(xbgr.mr_n78127728)
print v(xbgr.mr_n78128160)
print v(xbgr.mr_n78128592)
print v(xbgr.mr_n78129024)
print v(xbgr.mr_n78129456)
print v(xbgr.mr_n78129888)
print v(xbgr.mr_n78130320)
print v(xbgr.mr_n78130752)
print v(xbgr.mr_n78131184)
print v(xbgr.mr_n78131616)
print v(xbgr.mr_n78132048)
print v(xbgr.mr_n78132480)
print v(xbgr.mr_n78132912)
print v(xbgr.mr_n78133344)
print v(xbgr.mr_n78133776)
print v(xbgr.mr_n78134208)
print v(xbgr.mr_n78134640)
print v(xbgr.mr_n78135072)
print v(xbgr.mr_n78135504)
print v(xbgr.mr_n78135936)
print v(xbgr.mr_n78136368)
print v(xbgr.mr_n78136800)
print v(xbgr.mr_n78137232)
print v(xbgr.mr_n78137664)
print v(xbgr.mr_n78138096)
print v(xbgr.mr_n78138528)
print v(xbgr.mr_n78138960)
print v(xbgr.mr_n78139392)
print v(xbgr.mr_n78139824)
print v(xbgr.mr_n78140256)
print v(xbgr.mr_n78140576)
print v(xbgr.mr_n78140688)
print v(xbgr.mr_n78141008)
print v(xbgr.mr_n78141120)
print v(xbgr.mr_n78141440)
print v(xbgr.mr_n78141552)
print v(xbgr.mr_n78141872)
print v(xbgr.mr_n78141984)
print v(xbgr.mr_n78142304)
print v(xbgr.mr_n78142416)
print v(xbgr.mr_n78142736)
print v(xbgr.mr_n78142848)
print v(xbgr.mr_n78143168)
print v(xbgr.mr_n78143280)
print v(xbgr.mr_n78143600)
print v(xbgr.mr_n78143712)
print v(xbgr.mr_n78144032)
print v(xbgr.mr_n78144144)
print v(xbgr.mr_n78144464)
print v(xbgr.mr_n78144576)
print v(xbgr.mr_n78144896)
print v(xbgr.mr_n78145008)
print v(xbgr.mr_n78145328)
print v(xbgr.mr_n78145440)
print v(xbgr.mr_n78145760)
print v(xbgr.mr_n78145872)
print v(xbgr.mr_n78146192)
print v(xbgr.mr_n78146304)
print v(xbgr.mr_n78146624)
print v(xbgr.mr_n78146736)
print v(xbgr.mr_n78147056)
print v(xbgr.mr_n78147168)
print v(xbgr.mr_n78147488)
print v(xbgr.mr_n78147600)
print v(xbgr.mr_n78147920)
print v(xbgr.mr_n78148032)
print v(xbgr.mr_n78148352)
print v(xbgr.mr_n78148464)
print v(xbgr.mr_n78148784)
print v(xbgr.mr_n78148896)
print v(xbgr.mr_n78149216)
print v(xbgr.mr_n78149328)
print v(xbgr.mr_n78149648)
print v(xbgr.mr_n78149760)
print v(xbgr.mr_n78150080)
print v(xbgr.mr_n78150192)
print v(xbgr.mr_n78150512)
print v(xbgr.mr_n78150624)
print v(xbgr.mr_n78150944)
print v(xbgr.mr_n78151056)
print v(xbgr.mr_n78151376)
print v(xbgr.mr_n78151488)
print v(xbgr.mr_n78151808)
print v(xbgr.mr_n78151920)
print v(xbgr.mr_n78152240)
print v(xbgr.mr_n78152352)
print v(xbgr.mr_n78152672)
print v(xbgr.mr_n78152784)
print v(xbgr.mr_n78153104)
print v(xbgr.mr_n78153216)
print v(xbgr.mr_n78153648)
print v(xbgr.mr_n78154080)
print v(xbgr.mr_n78154512)
print v(xbgr.mr_n78154944)
print v(xbgr.mr_n78155264)
print v(xbgr.mr_n78155376)
print v(xbgr.mr_n78155696)
print v(xbgr.mr_n78155808)
print v(xbgr.mr_n78156128)
print v(xbgr.mr_n78156240)
print v(xbgr.mr_n78156560)
print v(xbgr.mr_n78156672)
print v(xbgr.mr_n78156992)
print v(xbgr.mr_n78157104)
print v(xbgr.mr_n78157424)
print v(xbgr.mr_n78157536)
print v(xbgr.mr_n78157968)
print v(xbgr.mr_n78158400)
print v(xbgr.mr_n78158832)
print v(xbgr.mr_n78159152)
print v(xbgr.mr_n78159264)
print v(xbgr.mr_n78159584)
print v(xbgr.mr_n78159696)
print v(xbgr.mr_n78160016)
print v(xbgr.mr_n78160128)
print v(xbgr.mr_n78160448)
print v(xbgr.mr_n78160560)
print v(xbgr.mr_n78160880)
print v(xbgr.mr_n78160992)
print v(xbgr.mr_n78161312)
print v(xbgr.mr_n78161424)
print v(xbgr.mr_n78161744)
print v(xbgr.mr_n78161856)
print v(xbgr.mr_n78162176)
print v(xbgr.mr_n78162288)
print v(xbgr.mr_n78162608)
print v(xbgr.mr_n78162720)
print v(xbgr.mr_n78163040)
print v(xbgr.mr_n78163152)
print v(xbgr.mr_n78163584)
print v(xbgr.mr_n78164016)
print v(xbgr.mr_n78164448)
print v(xbgr.mr_n78164880)
print v(xbgr.mr_n78165312)
print v(xbgr.mr_n78165744)
print v(xbgr.mr_n78166176)
print v(xbgr.mr_n78166608)
print v(xbgr.mr_n78167040)
print v(xbgr.mr_n78167472)
print v(xbgr.mr_n78167904)
print v(xbgr.mr_n78168336)
print v(xbgr.mr_n78168768)
print v(xbgr.mr_n78169088)
print v(xbgr.mr_n78169200)
print v(xbgr.mr_n78169520)
print v(xbgr.mr_n78169632)
print v(xbgr.mr_n78169952)
print v(xbgr.mr_n78170064)
print v(xbgr.mr_n78170384)
print v(xbgr.mr_n78170496)
print v(xbgr.mr_n78170816)
print v(xbgr.mr_n78170928)
print v(xbgr.mr_n78171360)
print v(xbgr.mr_n78171792)
print v(xbgr.mr_n78172224)
print v(xbgr.mr_n78172656)
print v(xbgr.mr_n78173088)
print v(xbgr.mr_n78173520)
print v(xbgr.mr_n78173840)
print v(xbgr.mr_n78173952)
print v(xbgr.mr_n78174272)
print v(xbgr.mr_n78174384)
print v(xbgr.mr_n78174816)
print v(xbgr.mr_n78175248)
print v(xbgr.mr_n78175568)
print v(xbgr.mr_n78175680)
print v(xbgr.mr_n78176000)
print v(xbgr.mr_n78176112)
print v(xbgr.mr_n78176432)
print v(xbgr.mr_n78176544)
print v(xbgr.mr_n78176864)
print v(xbgr.mr_n78176976)
print v(xbgr.mr_n78177296)
print v(xbgr.mr_n78177408)
print v(xbgr.mr_n78177728)
print v(xbgr.mr_n78177840)
print v(xbgr.mr_n78178160)
print v(xbgr.mr_n78178272)
print v(xbgr.mr_n78178592)
print v(xbgr.mr_n78178704)
print v(xbgr.mr_n78179024)
print v(xbgr.mr_n78179136)
print v(xbgr.mr_n78179456)
print v(xbgr.mr_n78179568)
print v(xbgr.mr_n78179888)
print v(xbgr.mr_n78180000)
print v(xbgr.mr_n78180320)
print v(xbgr.mr_n78180432)
print v(xbgr.mr_n78180752)
print v(xbgr.mr_n78180864)
print v(xbgr.mr_n78181184)
print v(xbgr.mr_n78181296)
print v(xbgr.mr_n78181728)
print v(xbgr.mr_n78182160)
print v(xbgr.mr_n78182480)
print v(xbgr.mr_n78182592)
print v(xbgr.mr_n78182912)
print v(xbgr.mr_n78183024)
print v(xbgr.mr_n78183344)
print v(xbgr.mr_n78183456)
print v(xbgr.mr_n78183776)
print v(xbgr.mr_n78183888)
print v(xbgr.mr_n78184208)
print v(xbgr.mr_n78184320)
print v(xbgr.mr_n78184640)
print v(xbgr.mr_n78184752)
print v(xbgr.mr_n78185184)
print v(xbgr.mr_n78185616)
print v(xbgr.mr_n78185936)
print v(xbgr.mr_n78186048)
print v(xbgr.mr_n78186368)
print v(xbgr.mr_n78186480)
print v(xbgr.mr_n78186800)
print v(xbgr.mr_n78186912)
print v(xbgr.mr_n78187232)
print v(xbgr.mr_n78187344)
print v(xbgr.mr_n78187664)
print v(xbgr.mr_n78187776)
print v(xbgr.mr_n78188096)
print v(xbgr.mr_n78188208)
print v(xbgr.mr_n78188528)
print v(xbgr.mr_n78188640)
print v(xbgr.mr_n78188960)
print v(xbgr.mr_n78189072)
print v(xbgr.mr_n78189392)
print v(xbgr.mr_n78189504)
print v(xbgr.mr_n78189824)
print v(xbgr.mr_n78189936)
print v(xbgr.mr_n78190256)
print v(xbgr.mr_n78190368)
print v(xbgr.mr_n78190688)
print v(xbgr.mr_n78190800)
print v(xbgr.mr_n78191120)
print v(xbgr.mr_n78191232)
print v(xbgr.mr_n78191552)
print v(xbgr.mr_n78191664)
print v(xbgr.mr_n78191984)
print v(xbgr.mr_n78192096)
print v(xbgr.mr_n78192416)
print v(xbgr.mr_n78192528)
print v(xbgr.mr_n78192848)
print v(xbgr.mr_n78192960)
print v(xbgr.mr_n78193280)
print v(xbgr.mr_n78193392)
print v(xbgr.mr_n78193712)
print v(xbgr.mr_n78193824)
print v(xbgr.mr_n78194144)
print v(xbgr.mr_n78194256)
print v(xbgr.mr_n78194576)
print v(xbgr.mr_n78194688)
print v(xbgr.mr_n78195008)
print v(xbgr.mr_n78195120)
print v(xbgr.mr_n78195440)
print v(xbgr.mr_n78195552)
print v(xbgr.mr_n78195872)
print v(xbgr.mr_n78195984)
print v(xbgr.mr_n78196304)
print v(xbgr.mr_n78196416)
print v(xbgr.mr_n78196736)
print v(xbgr.mr_n78196848)
print v(xbgr.mr_n78197168)
print v(xbgr.mr_n78197280)
print v(xbgr.mr_n78197600)
print v(xbgr.mr_n78197712)
print v(xbgr.mr_n78198032)
print v(xbgr.mr_n78198144)
print v(xbgr.mr_n78198464)
print v(xbgr.mr_n78198576)
print v(xbgr.mr_n78198896)
print v(xbgr.mr_n78199008)
print v(xbgr.mr_n78199328)
print v(xbgr.mr_n78199440)
print v(xbgr.mr_n78199760)
print v(xbgr.mr_n78199872)
print v(xbgr.mr_n78200192)
print v(xbgr.mr_n78200304)
print v(xbgr.mr_n78200624)
print v(xbgr.mr_n78200736)
print v(xbgr.mr_n78201056)
print v(xbgr.mr_n78201168)
print v(xbgr.mr_n78201488)
print v(xbgr.mr_n78201600)
print v(xbgr.mr_n78201920)
print v(xbgr.mr_n78202032)
print v(xbgr.mr_n78202352)
print v(xbgr.mr_n78202464)
print v(xbgr.mr_n78202784)
print v(xbgr.mr_n78202896)
print v(xbgr.mr_n78203216)
print v(xbgr.mr_n78203328)
print v(xbgr.mr_n78203648)
print v(xbgr.mr_n78203760)
print v(xbgr.mr_n78204080)
print v(xbgr.mr_n78204192)
print v(xbgr.mr_n78204512)
print v(xbgr.mr_n78204624)
print v(xbgr.mr_n78204944)
print v(xbgr.mr_n78205056)
print v(xbgr.mr_n78205376)
print v(xbgr.mr_n78205488)
print v(xbgr.mr_n78205808)
print v(xbgr.mr_n78205920)
print v(xbgr.mr_n78206240)
print v(xbgr.mr_n78206352)
print v(xbgr.mr_n78206672)
print v(xbgr.mr_n78206784)
print v(xbgr.mr_n78207104)
print v(xbgr.mr_n78207216)
print v(xbgr.mr_n78207536)
print v(xbgr.mr_n78207648)
print v(xbgr.mr_n78207968)
print v(xbgr.mr_n78208080)
print v(xbgr.mr_n78208400)
print v(xbgr.mr_n78208512)
print v(xbgr.mr_n78208832)
print v(xbgr.mr_n78208944)
print v(xbgr.mr_n78209264)
print v(xbgr.mr_n78209376)
print v(xbgr.mr_n78209696)
print v(xbgr.mr_n78209808)
print v(xbgr.mr_n78210128)
print v(xbgr.mr_n78210240)
print v(xbgr.mr_n78210560)
print v(xbgr.mr_n78210672)
print v(xbgr.mr_n78210992)
print v(xbgr.mr_n78211104)
print v(xbgr.mr_n78211424)
print v(xbgr.mr_n78211536)
print v(xbgr.mr_n78211856)
print v(xbgr.mr_n78211968)
print v(xbgr.mr_n78212288)
print v(xbgr.mr_n78212400)
print v(xbgr.mr_n78212720)
print v(xbgr.mr_n78212832)
print v(xbgr.mr_n78213152)
print v(xbgr.mr_n78213264)
print v(xbgr.mr_n78213584)
print v(xbgr.mr_n78213696)
print v(xbgr.mr_n78214016)
print v(xbgr.mr_n78214128)
print v(xbgr.mr_n78214448)
print v(xbgr.mr_n78214560)
print v(xbgr.mr_n78214880)
print v(xbgr.mr_n78214992)
print v(xbgr.mr_n78215312)
print v(xbgr.mr_n78215424)
print v(xbgr.mr_n78215744)
print v(xbgr.mr_n78215856)
print v(xbgr.mr_n78216176)
print v(xbgr.mr_n78216288)
print v(xbgr.mr_n78216608)
print v(xbgr.mr_n78216720)
print v(xbgr.mr_n78217040)
print v(xbgr.mr_n78217152)
print v(xbgr.mr_n78217472)
print v(xbgr.mr_n78217584)
print v(xbgr.mr_n78217904)
print v(xbgr.mr_n78218016)
print v(xbgr.mr_n78218336)
print v(xbgr.mr_n78218448)
print v(xbgr.mr_n78218768)
print v(xbgr.mr_n78218880)
print v(xbgr.mr_n78219200)
print v(xbgr.mr_n78219312)
print v(xbgr.mr_n78219632)
print v(xbgr.mr_n78219744)
print v(xbgr.mr_n78220064)
print v(xbgr.mr_n78220176)
print v(xbgr.mr_n78220496)
print v(xbgr.mr_n78220608)
print v(xbgr.mr_n78220928)
print v(xbgr.mr_n78221040)
print v(xbgr.mr_n78221360)
print v(xbgr.mr_n78221472)
print v(xbgr.mr_n78221792)
print v(xbgr.mr_n78221904)
print v(xbgr.mr_n78222224)
print v(xbgr.mr_n78222336)
print v(xbgr.mr_n78222656)
print v(xbgr.mr_n78222768)
print v(xbgr.mr_n78223088)
print v(xbgr.mr_n78223200)
print v(xbgr.mr_n78223520)
print v(xbgr.mr_n78223632)
print v(xbgr.mr_n78223952)
print v(xbgr.mr_n78224064)
print v(xbgr.mr_n78224384)
print v(xbgr.mr_n78224496)
print v(xbgr.mr_n78224816)
print v(xbgr.mr_n78224928)
print v(xbgr.mr_n78225248)
print v(xbgr.mr_n78225360)
print v(xbgr.mr_n78225680)
print v(xbgr.mr_n78225792)
print v(xbgr.mr_n78226112)
print v(xbgr.mr_n78226224)
print v(xbgr.mr_n78226544)
print v(xbgr.mr_n78226656)
print v(xbgr.mr_n78226976)
print v(xbgr.mr_n78227088)
print v(xbgr.mr_n78227408)
print v(xbgr.mr_n78227520)
print v(xbgr.mr_n78227840)
print v(xbgr.mr_n78227952)
print v(xbgr.mr_n78228272)
print v(xbgr.mr_n78228384)
print v(xbgr.mr_n78228704)
print v(xbgr.mr_n78228816)
print v(xbgr.mr_n78229136)
print v(xbgr.mr_n78229248)
print v(xbgr.mr_n78229568)
print v(xbgr.mr_n78229680)
print v(xbgr.mr_n78230000)
print v(xbgr.mr_n78230112)
print v(xbgr.mr_n78230432)
print v(xbgr.mr_n78230544)
print v(xbgr.mr_n78230864)
print v(xbgr.mr_n78230976)
print v(xbgr.mr_n78231296)
print v(xbgr.mr_n78231408)
print v(xbgr.mr_n78231728)
print v(xbgr.mr_n78231840)
print v(xbgr.mr_n78232160)
print v(xbgr.mr_n78232272)
print v(xbgr.mr_n78232592)
print v(xbgr.mr_n78232704)
print v(xbgr.mr_n78233024)
print v(xbgr.mr_n78233136)
print v(xbgr.mr_n78233456)
print v(xbgr.mr_n78233568)
print v(xbgr.mr_n78233888)
print v(xbgr.mr_n78234000)
print v(xbgr.mr_n78234320)
print v(xbgr.mr_n78234432)
print v(xbgr.mr_n78234752)
print v(xbgr.mr_n78234864)
print v(xbgr.mr_n78235184)
print v(xbgr.mr_n78235296)
print v(xbgr.mr_n78235616)
print v(xbgr.mr_n78235728)
print v(xbgr.mr_n78236048)
print v(xbgr.mr_n78236160)
print v(xbgr.mr_n78236592)
print v(xbgr.mr_n78237024)
print v(xbgr.mr_n78237456)
print v(xbgr.mr_n78237888)
print v(xbgr.mr_n78238320)
print v(xbgr.mr_n78238752)
print v(xbgr.mr_n78239184)
print v(xbgr.mr_n78239616)
print v(xbgr.mr_n78240048)
print v(xbgr.mr_n78240480)
print v(xbgr.mr_n78240912)
print v(xbgr.mr_n78241344)
print v(xbgr.mr_n78241776)
print v(xbgr.mr_n78242208)
print v(xbgr.mr_n78242640)
print v(xbgr.mr_n78243072)
print v(xbgr.mr_n78243504)
print v(xbgr.mr_n78243936)
print v(xbgr.mr_n78244368)
print v(xbgr.mr_n78244800)
print v(xbgr.mr_n78245232)
print v(xbgr.mr_n78245664)
print v(xbgr.mr_n78246096)
print v(xbgr.mr_n78246528)
print v(xbgr.mr_n78246960)
print v(xbgr.mr_n78247392)
print v(xbgr.mr_n78247824)
print v(xbgr.mr_n78248256)
print v(xbgr.mr_n78248688)
print v(xbgr.mr_n78249120)
print v(xbgr.mr_n78249552)
print v(xbgr.mr_n78249984)
print v(xbgr.mr_n78250416)
print v(xbgr.mr_n78250848)
print v(xbgr.mr_n78251168)
print v(xbgr.mr_n78251280)
print v(xbgr.mr_n78251600)
print v(xbgr.mr_n78251712)
print v(xbgr.mr_n78252144)
print v(xbgr.mr_n78252464)
print v(xbgr.mr_n78252576)
print v(xbgr.mr_n78252896)
print v(xbgr.mr_n78253008)
print v(xbgr.mr_n78253328)
print v(xbgr.mr_n78253440)
print v(xbgr.mr_n78253760)
print v(xbgr.mr_n78253872)
print v(xbgr.mr_n78254192)
print v(xbgr.mr_n78254304)
print v(xbgr.mr_n78254624)
print v(xbgr.mr_n78254736)
print v(xbgr.mr_n78255056)
print v(xbgr.mr_n78255168)
print v(xbgr.mr_n78255488)
print v(xbgr.mr_n78255600)
print v(xbgr.mr_n78256032)
print v(xbgr.mr_n78256464)
print v(xbgr.mr_n78256896)
print v(xbgr.mr_n78257328)
print v(xbgr.mr_n78257760)
print v(xbgr.mr_n78258192)
print v(xbgr.mr_n78258624)
print v(xbgr.mr_n78259056)
print v(xbgr.mr_n78259488)
print v(xbgr.mr_n78259808)
print v(xbgr.mr_n78259920)
print v(xbgr.mr_n78260240)
print v(xbgr.mr_n78260352)
print v(xbgr.mr_n78260672)
print v(xbgr.mr_n78260784)
print v(xbgr.mr_n78261104)
print v(xbgr.mr_n78261216)
print v(xbgr.mr_n78261648)
print v(xbgr.mr_n78262080)
print v(xbgr.mr_n78262512)
print v(xbgr.mr_n78262944)
print v(xbgr.mr_n78263376)
print v(xbgr.mr_n78263808)
print v(xbgr.mr_n78264240)
print v(xbgr.mr_n78264672)
print v(xbgr.mr_n78265104)
print v(xbgr.mr_n78265536)
print v(xbgr.mr_n78265968)
print v(xbgr.mr_n78266400)
print v(xbgr.mr_n78266832)
print v(xbgr.mr_n78267264)
print v(xbgr.mr_n78267696)
print v(xbgr.mr_n78268128)
print v(xbgr.mr_n78268560)
print v(xbgr.mr_n78268992)
print v(xbgr.mr_n78269424)
print v(xbgr.mr_n78269856)
print v(xbgr.mr_n78270288)
print v(xbgr.mr_n78270720)
print v(xbgr.mr_n78271152)
print v(xbgr.mr_n78271584)
print v(xbgr.mr_n78272016)
print v(xbgr.mr_n78272448)
print v(xbgr.mr_n78272880)
print v(xbgr.mr_n78273312)
print v(xbgr.mr_n78273744)
print v(xbgr.mr_n78274064)
print v(xbgr.mr_n78274176)
print v(xbgr.mr_n78274496)
print v(xbgr.mr_n78274608)
print v(xbgr.mr_n78274928)
print v(xbgr.mr_n78275040)
print v(xbgr.mr_n78275360)
print v(xbgr.mr_n78275472)
print v(xbgr.mr_n78275792)
print v(xbgr.mr_n78275904)
print v(xbgr.mr_n78276224)
print v(xbgr.mr_n78276336)
print v(xbgr.mr_n78538816)
print v(xbgr.mr_n78539600)
print v(xbgr.mr_n78540464)
print v(xbgr.mr_n78540576)
print v(xbgr.mr_n78540896)
print v(xbgr.mr_n78541328)
print v(xbgr.mr_n78541760)
print v(xbgr.mr_n78542192)
print v(xbgr.mr_n78542304)
print v(xbgr.mr_n78542624)
print v(xbgr.mr_n78543056)
print v(xbgr.mr_n78543488)
print v(xbgr.mr_n78543920)
print v(xbgr.mr_n78544032)
print v(xbgr.mr_n78544352)
print v(xbgr.mr_n78544464)
print v(xbgr.mr_n78544784)
print v(xbgr.mr_n78544896)
print v(xbgr.mr_n78545328)
print v(xbgr.mr_n78545760)
print v(xbgr.mr_n78546192)
print v(xbgr.mr_n78546512)
print v(xbgr.mr_n78547376)
print v(xbgr.mr_n78547488)
print v(xbgr.mr_n78547808)
print v(xbgr.mr_n78547920)
print v(xbgr.mr_n78548240)
print v(xbgr.mr_n78549216)
print v(xbgr.mr_n78549648)
print v(xbgr.mr_n78549968)
print v(xbgr.mr_n78550832)
print v(xbgr.mr_n78550944)
print v(xbgr.mr_n78551264)
print v(xbgr.mr_n78551376)
print v(xbgr.mr_n78551696)
print v(xbgr.mr_n78551808)
print v(xbgr.mr_n78554304)
print v(xbgr.mr_n78554736)
print v(xbgr.mr_n78555056)
print v(xbgr.mr_n78556032)
print v(xbgr.mr_n78556352)
print v(xbgr.mr_n78557328)
print v(xbgr.mr_n78557648)
print v(xbgr.mr_n78558624)
print v(xbgr.mr_n78558944)
print v(xbgr.mr_n78559056)
print v(xbgr.mr_n78559488)
print v(xbgr.mr_n78559920)
print v(xbgr.mr_n78560240)
print v(xbgr.mr_n78561216)
print v(xbgr.mr_n78561536)
print v(xbgr.mr_n78562512)
print v(xbgr.mr_n78562832)
print v(xbgr.mr_n78563808)
print v(xbgr.mr_n78564240)
print v(xbgr.mr_n78564672)
print v(xbgr.mr_n78565104)
print v(xbgr.mr_n78565536)
print v(xbgr.mr_n78565968)
print v(xbgr.mr_n78566400)
print v(xbgr.mr_n78566832)
print v(xbgr.mr_n78567264)
print v(xbgr.mr_n78567696)
print v(xbgr.mr_n78568128)
print v(xbgr.mr_n78568560)
print v(xbgr.mr_n78568992)
print v(xbgr.mr_n78569424)
print v(xbgr.mr_n78569856)
print v(xbgr.mr_n78570288)
print v(xbgr.mr_n78570720)
print v(xbgr.mr_n78571152)
print v(xbgr.mr_n78571584)
print v(xbgr.mr_n78572016)
print v(xbgr.mr_n78572448)
print v(xbgr.mr_n78572880)
print v(xbgr.mr_n78573312)
print v(xbgr.mr_n78573744)
print v(xbgr.mr_n78574176)
print v(xbgr.mr_n78633392)
print v(xbgr.mr_n78634912)
print v(xbgr.mr_n78635120)
print v(xbgr.mr_n78637152)
print v(xbgr.mr_n78640592)
print v(xbgr.mr_n78643600)
print v(xbgr.mr_n78644496)
print v(xbgr.mr_n78647312)
print v(xbgr.mr_n78647520)
print v(xbgr.mr_n78647968)
print v(xbgr.mr_n78648144)
print v(xbgr.mr_n78648320)
print v(xbgr.mr_n78648592)
print v(xbgr.mr_n78649872)
print v(xbgr.mr_n78652432)
print v(xbgr.mr_n78653872)
print v(xbgr.mr_n78654592)
print v(xbgr.mr_n78655408)
print v(xbgr.mr_n78657040)
print v(xbgr.mr_n78657904)
print v(xbgr.mr_n78659424)
print v(xbgr.mr_n78660768)
print v(xbgr.mr_n78661328)
print v(xbgr.mr_n78661744)
print v(xbgr.mr_n78664080)
print v(xbgr.mr_n78664912)
print v(xbgr.mr_n78666048)
print v(xbgr.mr_n78666496)
print v(xbgr.mr_n78668560)
print v(xbgr.mr_n78669728)
print v(xbgr.mr_n78670624)
print v(xbgr.mr_n78670976)
print v(xbgr.mr_n78671312)
print v(xbgr.mr_n78671424)
print v(xbgr.mr_n78671632)
print v(xbgr.mr_n78672320)
print v(xbgr.mr_n78672592)
print v(xbgr.mr_n78673312)
print v(xbgr.mr_n78673664)
print v(xbgr.mr_n78673904)
print v(xbgr.mr_n78783296)
print v(xbgr.mr_n78786192)
print v(xbgr.mr_n78787520)
print v(xbgr.mr_n78788288)
print v(xbgr.mr_n78793792)
print v(xbgr.mr_n78796432)
print v(xbgr.mr_n78798032)
print v(xbgr.mr_n78799744)
print v(xbgr.mr_n78802960)
print v(xbgr.mr_n78803728)
print v(xbgr.mr_n78806720)
print v(xbgr.mr_n78811344)
print v(xbgr.mr_n78819456)
print v(xbgr.mr_n78822592)
print v(xbgr.mr_n78824912)
print v(xbgr.mr_n78825408)
print v(xbgr.mr_n78890288)
print v(xbgr.mr_n78890560)
print v(xbgr.mr_n78891248)
print v(xbgr.mr_n78891568)
print v(xbgr.mr_n78892256)
print v(xbgr.mr_n78894496)
print v(xbgr.mr_n78894768)
print v(xbgr.mr_n78895392)
print v(xbgr.mr_n78895728)
print v(xbgr.mr_n78896288)
print v(xbgr.mr_n78897456)
print v(xbgr.mr_n78899632)
print v(xbgr.mr_n78901424)
print v(xbgr.mr_n78903008)
print v(xbgr.mr_n78903456)
print v(xbgr.mr_n78904176)
print v(xbgr.mr_n78904624)
print v(xbgr.mr_n78905248)
print v(xbgr.mr_n78905520)
print v(xbgr.mr_n78905696)
print v(xbgr.mr_n78906000)
print v(xbgr.mr_n78906144)
print v(xbgr.mr_n78907248)
print v(xbgr.mr_n78910624)
print v(xbgr.mr_n78915200)
print v(xbgr.mr_n78915648)
print v(xbgr.mr_n78918064)
print v(xbgr.mr_n78919344)
print v(xbgr.mr_n78934896)
print v(xbgr.mr_n78935888)
print v(xbgr.mr_n78936304)
print v(xbgr.mr_n78937936)
print v(xbgr.mr_n78942448)
print v(xbgr.mr_n78949920)
print v(xbgr.mr_n78988944)
print v(xbgr.mr_n78991632)
print v(xbgr.mr_n78992512)
print v(xbgr.mr_n78993216)
print v(xbgr.mr_n78993744)
print v(xbgr.mr_n78994448)
print v(xbgr.mr_n78995392)
print v(xbgr.mr_n78996416)
print v(xbgr.mr_n78998384)
print v(xbgr.mr_n78999072)
print v(xbgr.mr_n79000240)
print v(xbgr.mr_n79001920)
print v(xbgr.mr_n79005072)
print v(xbgr.mr_n79007600)
print v(xbgr.mr_n79007856)
print v(xbgr.mr_n79013008)
print v(xbgr.mr_n79013440)
print v(xbgr.mr_n79014208)
print v(xbgr.mr_n79014400)
print v(xbgr.mr_n79015120)
print v(xbgr.mr_n79015360)
print v(xbgr.mr_n79015792)
print v(xbgr.mr_n79015904)
print v(xbgr.mr_n79016016)
print v(xbgr.mr_n79016432)
print v(xbgr.mr_n79017008)
print v(xbgr.mr_n79017600)
print v(xbgr.mr_n79018592)
print v(xbgr.mr_n79021936)
print v(xbgr.mr_n79022528)
print v(xbgr.mr_n79024432)
print v(xbgr.mr_n79024720)
print v(xbgr.mr_n79053168)
print v(xbgr.mr_n79055568)
print v(xbgr.mr_n79073120)
print v(xbgr.mr_n79075936)
print v(xbgr.mr_n79079136)
print v(xbgr.mr_n79084304)
print v(xbgr.mr_n79084912)
print v(xbgr.mr_n79085120)
print v(xbgr.mr_n79348880)
print v(xbgr.mr_n79350000)
print v(xbgr.mr_n79350176)
print v(xbgr.mr_n79350800)
print v(xbgr.mr_n79410864)
print v(xbgr.mr_n79414736)
print v(xbgr.mr_n79415600)
print v(xbgr.mr_n79418704)
print v(xbgr.mr_n79420336)
print v(xbgr.mr_n79449520)
print v(xbgr.mr_n79458352)
print v(xbgr.mr_n79462032)
print v(xbgr.mr_n79470368)
print v(xbgr.mr_n79470752)
print v(xbgr.mr_n79482528)
print v(xbgr.mr_n79484368)
print v(xbgr.mr_n79485344)
print v(xbgr.mr_n79485936)
print v(xbgr.mr_n79486832)
print v(xbgr.mr_n79490208)
print v(xbgr.mr_n79493488)
print v(xbgr.mr_n79495664)
print v(xbgr.mr_n79497136)
print v(xbgr.mr_n79497248)
print v(xbgr.mr_n79497360)
print v(xbgr.mr_n79497472)
print v(xbgr.mr_n79497584)
print v(xbgr.mr_n79497776)
print v(xbgr.mr_n79498048)
print v(xbgr.mr_n79498320)
print v(xbgr.mr_n79500432)
print v(xbgr.mr_n79500896)
print v(xbgr.mr_n79501360)
print v(xbgr.mr_n79501824)
print v(xbgr.mr_n79502288)
print v(xbgr.mr_n79502752)
print v(xbgr.mr_n79503216)
print v(xbgr.mr_n79503680)
print v(xbgr.mr_n79504144)
print v(xbgr.mr_n79504608)
print v(xbgr.mr_n79505072)
print v(xbgr.mr_n79510880)
print v(xbgr.mr_n79511488)
print v(xbgr.mr_n79511728)
print v(xbgr.mr_n79512512)
print v(xbgr.mr_n79515376)
print v(xbgr.mr_n79516352)
print v(xbgr.mr_n79517744)
print v(xbgr.mr_n79520176)
print v(xbgr.mr_n79522496)
print v(xbgr.mr_n79522608)
print v(xbgr.mr_n79523888)
print v(xbgr.mr_n79525472)
print v(xbgr.mr_n79528704)
print v(xbgr.mr_n79529664)
print v(xbgr.mr_n79530576)
print v(xbgr.mr_n79531392)
print v(xbgr.mr_n79531808)
print v(xbgr.mr_n79531984)
print v(xbgr.mr_n79533280)
print v(xbgr.mr_n79534096)
print v(xbgr.mr_n79535440)
print v(xbgr.mr_n79537408)
print v(xbgr.mr_n79537616)
print v(xbgr.mr_n79538384)
print v(xbgr.mr_n79539184)
print v(xbgr.mr_n79541024)
print v(xbgr.mr_n79544656)
print v(xbgr.mr_n79546656)
print v(xbgr.mr_n79548176)
print v(xbgr.mr_n79549056)
print v(xbgr.mr_n79550080)
print v(xbgr.mr_n79552896)
print v(xbgr.mr_n79555008)
print v(xbgr.mr_n79557328)
print v(xbgr.mr_n79560944)
print v(xbgr.mr_n79563024)
print v(xbgr.mr_n79564160)
print v(xbgr.mr_n79565376)
print v(xbgr.mr_n79566976)
print v(xbgr.mr_n79568384)
print v(xbgr.mr_n79570064)
print v(xbgr.mr_n79572176)
print v(xbgr.mr_n79572608)
print v(xbgr.mr_n79573408)
print v(xbgr.mr_n79573584)
print v(xbgr.mr_n79574288)
print v(xbgr.mr_n79574928)
print v(xbgr.mr_n79576128)
print v(xbgr.mr_n79576704)
print v(xbgr.mr_n79577536)
print v(xbgr.mr_n79578512)
print v(xbgr.mr_n79580496)
print v(xbgr.mr_n79583504)
print v(xbgr.mr_n79585152)
print v(xbgr.mr_n79585344)
print v(xbgr.mr_n79587216)
print v(xbgr.mr_n79588144)
print v(xbgr.mr_n79588608)
print v(xbgr.mr_n79589072)
print v(xbgr.mr_n79589536)
print v(xbgr.mr_n79590000)
print v(xbgr.mr_n79590464)
print v(xbgr.mr_n79590928)
print v(xbgr.mr_n79591392)
print v(xbgr.mr_n79591856)
print v(xbgr.mr_n79592416)
print v(xbgr.mr_n79594240)
print v(xbgr.mr_n79595088)
print v(xbgr.mr_n79595696)
print v(xbgr.mr_n79596912)
print v(xbgr.mr_n79597024)
print v(xbgr.mr_n79597520)
print v(xbgr.mr_n79598128)
print v(xbgr.mr_n79600016)
print v(xbgr.mr_n79600624)
print v(xbgr.mr_n79601776)
print v(xbgr.mr_n79602032)
print v(xbgr.mr_n79602384)
print v(xbgr.mr_n79602992)
print v(xbgr.mr_n79604816)
print v(xbgr.mr_n79605424)
print v(xbgr.mr_n79606336)
print v(xbgr.mr_n79607248)
print v(xbgr.mr_n79607744)
print v(xbgr.mr_n79611200)
print v(xbgr.mr_n79612416)
print v(xbgr.mr_n79613024)
print v(xbgr.mr_n79615520)
print v(xbgr.mr_n79616736)
print v(xbgr.mr_n79618560)
print v(xbgr.mr_n79618800)
print v(xbgr.mr_n79621600)
print v(xbgr.mr_n79624080)
print v(xbgr.mr_n79625088)
print v(xbgr.mr_n79625328)
print v(xbgr.mr_n79625600)
print v(xbgr.mr_n79627824)
print v(xbgr.mr_n79628624)
print v(xbgr.mr_n79629120)
print v(xbgr.mr_n79629632)
print v(xbgr.mr_n79629808)
print v(xbgr.mr_n79630128)
print v(xbgr.mr_n79630640)
print v(xbgr.mr_n79631280)
print v(xbgr.mr_n79631664)
print v(xbgr.mr_n79636112)
print v(xbgr.mr_n79636304)
print v(xbgr.mr_n79638416)
print v(xbgr.mr_n79638880)
print v(xbgr.mr_n79639344)
print v(xbgr.mr_n79639872)
print v(xbgr.mr_n79640272)
print v(xbgr.mr_n79640736)
print v(xbgr.mr_n79641200)
print v(xbgr.mr_n79641664)
print v(xbgr.mr_n79642128)
print v(xbgr.mr_n79642592)
print v(xbgr.mr_n79643056)
print v(xbgr.mr_n79643520)
print v(xbgr.mr_n79643984)
print v(xbgr.mr_n79644512)
print v(xbgr.mr_n79644912)
print v(xbgr.mr_n79645376)
print v(xbgr.mr_n79645840)
print v(xbgr.mr_n79646304)
print v(xbgr.mr_n79646768)
print v(xbgr.mr_n79647232)
print v(xbgr.mr_n79647696)
print v(xbgr.mr_n79648160)
print v(xbgr.mr_n79648624)
print v(xbgr.mr_n79649152)
print v(xbgr.mr_n79649552)
print v(xbgr.mr_n79650016)
print v(xbgr.mr_n79650480)
print v(xbgr.mr_n79650944)
print v(xbgr.mr_n79651408)
print v(xbgr.mr_n79651680)
print v(xbgr.mr_n79651872)
print v(xbgr.mr_n79652336)
print v(xbgr.mr_n79652784)
print v(xbgr.mr_n79653248)
print v(xbgr.mr_n79653712)
print v(xbgr.mr_n79654112)
print v(xbgr.mr_n79654576)
print v(xbgr.mr_n79655040)
print v(xbgr.mr_n79655504)
print v(xbgr.mr_n79655968)
print v(xbgr.mr_n79656432)
print v(xbgr.mr_n79656896)
print v(xbgr.mr_n79657360)
print v(xbgr.mr_n79657824)
print v(xbgr.mr_n79658352)
print v(xbgr.mr_n79658752)
print v(xbgr.mr_n79659216)
print v(xbgr.mr_n79659680)
print v(xbgr.mr_n79660144)
print v(xbgr.mr_n79660608)
print v(xbgr.mr_n79661072)
print v(xbgr.mr_n79661536)
print v(xbgr.mr_n79662000)
print v(xbgr.mr_n79662464)
print v(xbgr.mr_n79662992)
print v(xbgr.mr_n79663392)
print v(xbgr.mr_n79663664)
print v(xbgr.mr_n79663856)
print v(xbgr.mr_n79664320)
print v(xbgr.mr_n79664784)
print v(xbgr.mr_n79665248)
print v(xbgr.mr_n79665712)
print v(xbgr.mr_n79666176)
print v(xbgr.mr_n79666640)
print v(xbgr.mr_n79667104)
print v(xbgr.mr_n79667632)
print v(xbgr.mr_n79668032)
print v(xbgr.mr_n79668496)
print v(xbgr.mr_n79668960)
print v(xbgr.mr_n79669424)
print v(xbgr.mr_n79669888)
print v(xbgr.mr_n79670352)
print v(xbgr.mr_n79670816)
print v(xbgr.mr_n79671280)
print v(xbgr.mr_n79671744)
print v(xbgr.mr_n79672272)
print v(xbgr.mr_n79672672)
print v(xbgr.mr_n79673136)
print v(xbgr.mr_n79673600)
print v(xbgr.mr_n79674064)
print v(xbgr.mr_n79674528)
print v(xbgr.mr_n79674992)
print v(xbgr.mr_n79675456)
print v(xbgr.mr_n79675920)
print v(xbgr.mr_n79676384)
print v(xbgr.mr_n79676912)
print v(xbgr.mr_n79677312)
print v(xbgr.mr_n79677776)
print v(xbgr.mr_n79678240)
print v(xbgr.mr_n79678704)
print v(xbgr.mr_n79679168)
print v(xbgr.mr_n79679632)
print v(xbgr.mr_n79680096)
print v(xbgr.mr_n79680560)
print v(xbgr.mr_n79681024)
print v(xbgr.mr_n79681552)
print v(xbgr.mr_n79681952)
print v(xbgr.mr_n79682416)
print v(xbgr.mr_n79682880)
print v(xbgr.mr_n79683344)
print v(xbgr.mr_n79683808)
print v(xbgr.mr_n79684272)
print v(xbgr.mr_n79684736)
print v(xbgr.mr_n79685008)
print v(xbgr.mr_n79685200)
print v(xbgr.mr_n79685664)
print v(xbgr.mr_n79686192)
print v(xbgr.mr_n79686592)
print v(xbgr.mr_n79687056)
print v(xbgr.mr_n79687520)
print v(xbgr.mr_n79687984)
print v(xbgr.mr_n79688448)
print v(xbgr.mr_n79688912)
print v(xbgr.mr_n79689376)
print v(xbgr.mr_n79689840)
print v(xbgr.mr_n79690304)
print v(xbgr.mr_n79690832)
print v(xbgr.mr_n79691232)
print v(xbgr.mr_n79691696)
print v(xbgr.mr_n79692160)
print v(xbgr.mr_n79692624)
print v(xbgr.mr_n79693088)
print v(xbgr.mr_n79693552)
print v(xbgr.mr_n79693664)
print v(xbgr.mr_n79694048)
print v(xbgr.mr_n79694272)
print v(xbgr.mr_n79694784)
print v(xbgr.mr_n79695008)
print v(xbgr.mr_n79695520)
print v(xbgr.mr_n79695632)
print v(xbgr.mr_n79696256)
print v(xbgr.mr_n79696368)
print v(xbgr.mr_n79696480)
print v(xbgr.mr_n79696992)
print v(xbgr.mr_n79697104)
print v(xbgr.mr_n79697216)
print v(xbgr.mr_n79697728)
print v(xbgr.mr_n79697840)
print v(xbgr.mr_n79697952)
print v(xbgr.mr_n79698464)
print v(xbgr.mr_n79698736)
print v(xbgr.mr_n79699008)
print v(xbgr.mr_n79699280)
print v(xbgr.mr_n79699392)
print v(xbgr.mr_n79699504)
print v(xbgr.mr_n79700016)
print v(xbgr.mr_n79700288)
print v(xbgr.mr_n79700560)
print v(xbgr.mr_n79700832)
print v(xbgr.mr_n79701104)
print v(xbgr.mr_n79701648)
print v(xbgr.mr_n79701920)
print v(xbgr.mr_n79702192)
print v(xbgr.mr_n79702464)
print v(xbgr.mr_n79702736)
print v(xbgr.mr_n79703008)
print v(xbgr.mr_n79703280)
print v(xbgr.mr_n79703552)
print v(xbgr.mr_n79703824)
print v(xbgr.mr_n79704096)
print v(xbgr.mr_n79704368)
print v(xbgr.mr_n79704640)
print v(xbgr.mr_n79704912)
print v(xbgr.mr_n79705184)
print v(xbgr.mr_n79705728)
print v(xbgr.mr_n79706000)
print v(xbgr.mr_n79706272)
print v(xbgr.mr_n79706544)
print v(xbgr.mr_n79707008)
print v(xbgr.mr_n79707472)
print v(xbgr.mr_n79707872)
print v(xbgr.mr_n79708400)
print v(xbgr.mr_n79708864)
print v(xbgr.mr_n79709328)
print v(xbgr.mr_n79709792)
print v(xbgr.mr_n79710256)
print v(xbgr.mr_n79710720)
print v(xbgr.mr_n79711184)
print v(xbgr.mr_n79711648)
print v(xbgr.mr_n79712112)
print v(xbgr.mr_n79715472)
print v(xbgr.mr_n79719552)
print v(xbgr.mr_n79722896)
print v(xbgr.mr_n79724944)
print v(xbgr.mr_n79727376)
print v(xbgr.mr_n79729296)
print v(xbgr.mr_n79729856)
print v(xbgr.mr_n79730448)
print v(xbgr.mr_n79731040)
print v(xbgr.mr_n79731632)
print v(xbgr.mr_n79732224)
print v(xbgr.mr_n79732816)
print v(xbgr.mr_n79733408)
print v(xbgr.mr_n79734000)
print v(xbgr.mr_n79734592)
print v(xbgr.mr_n79735184)
print v(xbgr.mr_n79735776)
print v(xbgr.mr_n79736368)
print v(xbgr.mr_n79736960)
print v(xbgr.mr_n79737552)
print v(xbgr.mr_n79738144)
print v(xbgr.mr_n79738736)
print v(xbgr.mr_n79739328)
print v(xbgr.mr_n79739920)
print v(xbgr.mr_n79740512)
print v(xbgr.mr_n79740880)
print v(xbgr.mr_n79741104)
print v(xbgr.mr_n79741696)
print v(xbgr.mr_n79742288)
print v(xbgr.mr_n79743472)
print v(xbgr.mr_n79743984)
print v(xbgr.mr_n79744656)
print v(xbgr.mr_n79745248)
print v(xbgr.mr_n79745840)
print v(xbgr.mr_n79746368)
print v(xbgr.mr_n79747024)
print v(xbgr.mr_n79747616)
print v(xbgr.mr_n79748208)
print v(xbgr.mr_n79748800)
print v(xbgr.mr_n79753248)
print v(xbgr.mr_n79761904)
print v(xbgr.mr_n79771744)
print v(xbgr.mr_n79773712)
print v(xbgr.mr_n79776432)
print v(xbgr.mr_n79782640)
print v(xbgr.mr_n79782816)
print v(xbgr.mr_n79792160)
print v(xbgr.mr_n79793680)
print v(xbgr.mr_n79794288)
print v(xbgr.mr_n79794400)
print v(xbgr.mr_n79795008)
print v(xbgr.mr_n79795120)
print v(xbgr.mr_n79795728)
print v(xbgr.mr_n79795840)
print v(xbgr.mr_n79796448)
print v(xbgr.mr_n79797168)
print v(xbgr.mr_n79797280)
print v(xbgr.mr_n79798304)
print v(xbgr.mr_n79799280)
print v(xbgr.mr_n79800144)
print v(xbgr.mr_n79800784)
print v(xbgr.mr_n79802560)
print v(xbgr.mr_n79803072)
print v(xbgr.mr_n79807056)
print v(xbgr.mr_n79807360)
print v(xbgr.mr_n79815264)
print v(xbgr.mr_n79815632)
print v(xbgr.mr_n79817472)
print v(xbgr.mr_n79819216)
print v(xbgr.mr_n79820800)
print v(xbgr.mr_n79823536)
print v(xbgr.mr_n79825600)
print v(xbgr.mr_n79827488)
print v(xbgr.mr_n79829616)
print v(xbgr.mr_n79835344)
print v(xbgr.mr_n79838576)
print v(xbgr.mr_n79838752)
print v(xbgr.mr_n79839376)
print v(xbgr.mr_n79840592)
print v(xbgr.mr_n79842400)
print v(xbgr.mr_n79843408)
print v(xbgr.mr_n79843792)
print v(xbgr.mr_n79844416)
print v(xbgr.mr_n79846304)
print v(xbgr.mr_n79847248)
print v(xbgr.mr_n79850992)
print v(xbgr.mr_n79851168)
print v(xbgr.mr_n79851424)
print v(xbgr.mr_n79853728)
print v(xbgr.mr_n79854320)
print v(xbgr.mr_n79854912)
print v(xbgr.mr_n79855504)
print v(xbgr.mr_n79856160)
print v(xbgr.mr_n79856752)
print v(xbgr.mr_n79857280)
print v(xbgr.mr_n79857792)
print v(xbgr.mr_n79858464)
print v(xbgr.mr_n79859056)
print v(xbgr.mr_n79859648)
print v(xbgr.mr_n79860240)
print v(xbgr.mr_n79860832)
print v(xbgr.mr_n79861424)
print v(xbgr.mr_n79862016)
print v(xbgr.mr_n79862528)
print v(xbgr.mr_n79863200)
print v(xbgr.mr_n79863712)
print v(xbgr.mr_n79864384)
print v(xbgr.mr_n79865040)
print v(xbgr.mr_n79865568)
print v(xbgr.mr_n79866160)
print v(xbgr.mr_n79866752)
print v(xbgr.mr_n79867344)
print v(xbgr.mr_n79867936)
print v(xbgr.mr_n79868592)
print v(xbgr.mr_n79869120)
print v(xbgr.mr_n79869712)
print v(xbgr.mr_n79870304)
print v(xbgr.mr_n79870896)
print v(xbgr.mr_n79871488)
print v(xbgr.mr_n79872000)
print v(xbgr.mr_n79872736)
print v(xbgr.mr_n79873264)
print v(xbgr.mr_n79873856)
print v(xbgr.mr_n79875040)
print v(xbgr.mr_n79875632)
print v(xbgr.mr_n79876224)
print v(xbgr.mr_n79876880)
print v(xbgr.mr_n79877408)
print v(xbgr.mr_n79878000)
print v(xbgr.mr_n79878592)
print v(xbgr.mr_n79879184)
print v(xbgr.mr_n79879776)
print v(xbgr.mr_n79880368)
print v(xbgr.mr_n79880960)
print v(xbgr.mr_n79881616)
print v(xbgr.mr_n79882144)
print v(xbgr.mr_n79882736)
print v(xbgr.mr_n79883328)
print v(xbgr.mr_n79883920)
print v(xbgr.mr_n79884256)
print v(xbgr.mr_n79884368)
print v(xbgr.mr_n79884912)
print v(xbgr.mr_n79885440)
print v(xbgr.mr_n79885840)
print v(xbgr.mr_n79887168)
print v(xbgr.mr_n79887760)
print v(xbgr.mr_n79888352)
print v(xbgr.mr_n79889008)
print v(xbgr.mr_n79889600)
print v(xbgr.mr_n79890128)
print v(xbgr.mr_n79890720)
print v(xbgr.mr_n79891296)
print v(xbgr.mr_n79891888)
print v(xbgr.mr_n79892400)
print v(xbgr.mr_n79893072)
print v(xbgr.mr_n79893664)
print v(xbgr.mr_n79894176)
print v(xbgr.mr_n79894848)
print v(xbgr.mr_n79895440)
print v(xbgr.mr_n79896032)
print v(xbgr.mr_n79896624)
print v(xbgr.mr_n79897216)
print v(xbgr.mr_n79897808)
print v(xbgr.mr_n79898400)
print v(xbgr.mr_n79898992)
print v(xbgr.mr_n79899584)
print v(xbgr.mr_n79900176)
print v(xbgr.mr_n79900832)
print v(xbgr.mr_n79901360)
print v(xbgr.mr_n79901952)
print v(xbgr.mr_n79902544)
print v(xbgr.mr_n79903136)
print v(xbgr.mr_n79903648)
print v(xbgr.mr_n79904320)
print v(xbgr.mr_n79904912)
print v(xbgr.mr_n79905568)
print v(xbgr.mr_n79906032)
print v(xbgr.mr_n79906688)
print v(xbgr.mr_n79907280)
print v(xbgr.mr_n79907872)
print v(xbgr.mr_n79908464)
print v(xbgr.mr_n79909056)
print v(xbgr.mr_n79909488)
print v(xbgr.mr_n79909712)
print v(xbgr.mr_n79910304)
print v(xbgr.mr_n79910832)
print v(xbgr.mr_n79911424)
print v(xbgr.mr_n79912016)
print v(xbgr.mr_n79912608)
print v(xbgr.mr_n79913200)
print v(xbgr.mr_n79913792)
print v(xbgr.mr_n79914384)
print v(xbgr.mr_n79914976)
print v(xbgr.mr_n79915504)
print v(xbgr.mr_n79916160)
print v(xbgr.mr_n79916752)
print v(xbgr.mr_n79917344)
print v(xbgr.mr_n79917936)
print v(xbgr.mr_n79918528)
print v(xbgr.mr_n79919040)
print v(xbgr.mr_n79919712)
print v(xbgr.mr_n79920304)
print v(xbgr.mr_n79920896)
print v(xbgr.mr_n79921488)
print v(xbgr.mr_n79922080)
print v(xbgr.mr_n79922608)
print v(xbgr.mr_n79923264)
print v(xbgr.mr_n79923856)
print v(xbgr.mr_n79924960)
print v(xbgr.mr_n79925632)
print v(xbgr.mr_n79926288)
print v(xbgr.mr_n79926816)
print v(xbgr.mr_n79927408)
print v(xbgr.mr_n79928000)
print v(xbgr.mr_n79928592)
print v(xbgr.mr_n79929184)
print v(xbgr.mr_n79929776)
print v(xbgr.mr_n79930432)
print v(xbgr.mr_n79931264)
print v(xbgr.mr_n79931664)
print v(xbgr.mr_n79932064)
print v(xbgr.mr_n79932464)
print v(xbgr.mr_n79932864)
print v(xbgr.mr_n79933664)
print v(xbgr.mr_n79934064)
print v(xbgr.mr_n79934464)
print v(xbgr.mr_n79934864)
print v(xbgr.mr_n79935264)
print v(xbgr.mr_n79941168)
print v(xbgr.mr_n79948944)
print v(xbgr.mr_n79951280)
print v(xbgr.mr_n79953072)
print v(xbgr.mr_n79954416)
print v(xbgr.mr_n79955568)
print v(xbgr.mr_n79958224)
print v(xbgr.mr_n79959312)
print v(xbgr.mr_n79959664)
print v(xbgr.mr_n79960752)
print v(xbgr.mr_n79964944)
print v(xbgr.mr_n79965392)
print v(xbgr.mr_n79966848)
print v(xbgr.mr_n79967376)
print v(xbgr.mr_n79968096)
print v(xbgr.mr_n79968560)
print v(xbgr.mr_n79969216)
print v(xbgr.mr_n79969744)
print v(xbgr.mr_n79970400)
print v(xbgr.mr_n79971056)
print v(xbgr.mr_n79971584)
print v(xbgr.mr_n79972176)
print v(xbgr.mr_n79972768)
print v(xbgr.mr_n79983296)
print v(xbgr.mr_n79988400)
print v(xbgr.mr_n79997184)
print v(xbgr.mr_n79999728)
print v(xbgr.mr_n80006032)
print v(xbgr.mr_n80006800)
print v(xbgr.mr_n80007216)
print v(xbgr.mr_n80009200)
print v(xbgr.mr_n80010080)
print v(xbgr.mr_n80011168)
print v(xbgr.mr_n80011632)
print v(xbgr.mr_n80012288)
print v(xbgr.mr_n80012816)
print v(xbgr.mr_n80013472)
print v(xbgr.mr_n80014128)
print v(xbgr.mr_n80015248)
print v(xbgr.mr_n80015840)
print v(xbgr.mr_n80017552)
print v(xbgr.mr_n80018208)
print v(xbgr.mr_n80018736)
print v(xbgr.mr_n80019520)
print v(xbgr.mr_n80019632)
print v(xbgr.mr_n80020160)
print v(xbgr.mr_n80020832)
print v(xbgr.mr_n80022304)
print v(xbgr.mr_n80022896)
print v(xbgr.mr_n80023488)
print v(xbgr.mr_n80024080)
print v(xbgr.mr_n80024608)
print v(xbgr.mr_n80025264)
print v(xbgr.mr_n80025856)
print v(xbgr.mr_n80026448)
print v(xbgr.mr_n80026976)
print v(xbgr.mr_n80027632)
print v(xbgr.mr_n80028224)
print v(xbgr.mr_n80028816)
print v(xbgr.mr_n80029408)
print v(xbgr.mr_n80030000)
print v(xbgr.mr_n80030528)
print v(xbgr.mr_n80031184)
print v(xbgr.mr_n80031776)
print v(xbgr.mr_n80032368)
print v(xbgr.mr_n80032960)
print v(xbgr.mr_n80033552)
print v(xbgr.mr_n80034144)
print v(xbgr.mr_n80035328)
print v(xbgr.mr_n80035856)
print v(xbgr.mr_n80036512)
print v(xbgr.mr_n80037104)
print v(xbgr.mr_n80037632)
print v(xbgr.mr_n80038288)
print v(xbgr.mr_n80038880)
print v(xbgr.mr_n80039408)
print v(xbgr.mr_n80040656)
print v(xbgr.mr_n80041248)
print v(xbgr.mr_n80041840)
print v(xbgr.mr_n80042432)
print v(xbgr.mr_n80043024)
print v(xbgr.mr_n80043616)
print v(xbgr.mr_n80044208)
print v(xbgr.mr_n80044736)
print v(xbgr.mr_n80045392)
print v(xbgr.mr_n80045984)
print v(xbgr.mr_n80046512)
print v(xbgr.mr_n80047168)
print v(xbgr.mr_n80047696)
print v(xbgr.mr_n80048288)
print v(xbgr.mr_n80048944)
print v(xbgr.mr_n80049536)
print v(xbgr.mr_n80050128)
print v(xbgr.mr_n80050720)
print v(xbgr.mr_n80051312)
print v(xbgr.mr_n80051904)
print v(xbgr.mr_n80052496)
print v(xbgr.mr_n80053088)
print v(xbgr.mr_n80053616)
print v(xbgr.mr_n80054272)
print v(xbgr.mr_n80054864)
print v(xbgr.mr_n80055392)
print v(xbgr.mr_n80056048)
print v(xbgr.mr_n80056640)
print v(xbgr.mr_n80057168)
print v(xbgr.mr_n80057824)
print v(xbgr.mr_n80058416)
print v(xbgr.mr_n80059008)
print v(xbgr.mr_n80059600)
print v(xbgr.mr_n80060192)
print v(xbgr.mr_n80060784)
print v(xbgr.mr_n80061376)
print v(xbgr.mr_n80061968)
print v(xbgr.mr_n80062496)
print v(xbgr.mr_n80063152)
print v(xbgr.mr_n80063744)
print v(xbgr.mr_n80064272)
print v(xbgr.mr_n80064928)
print v(xbgr.mr_n80065520)
print v(xbgr.mr_n80066048)
print v(xbgr.mr_n80066704)
print v(xbgr.mr_n80067232)
print v(xbgr.mr_n80067888)
print v(xbgr.mr_n80068480)
print v(xbgr.mr_n80069072)
print v(xbgr.mr_n80069664)
print v(xbgr.mr_n80070256)
print v(xbgr.mr_n80070848)
print v(xbgr.mr_n80071376)
print v(xbgr.mr_n80072032)
print v(xbgr.mr_n80072624)
print v(xbgr.mr_n80073152)
print v(xbgr.mr_n80073808)
print v(xbgr.mr_n80074144)
print v(xbgr.mr_n80074400)
print v(xbgr.mr_n80074928)
print v(xbgr.mr_n80075584)
print v(xbgr.mr_n80076112)
print v(xbgr.mr_n80076768)
print v(xbgr.mr_n80077952)
print v(xbgr.mr_n80078544)
print v(xbgr.mr_n80079136)
print v(xbgr.mr_n80079728)
print v(xbgr.mr_n80080544)
print v(xbgr.mr_n80081008)
print v(xbgr.mr_n80081120)
print v(xbgr.mr_n80081472)
print v(xbgr.mr_n80081936)
print v(xbgr.mr_n80082048)
print v(xbgr.mr_n80082400)
print v(xbgr.mr_n80082512)
print v(xbgr.mr_n80084000)
print v(xbgr.mr_n80084256)
print v(xbgr.mr_n80084592)
print v(xbgr.mr_n80085232)
print v(xbgr.mr_n80085632)
print v(xbgr.mr_n80086032)
print v(xbgr.mr_n80086432)
print v(xbgr.mr_n80086832)
print v(xbgr.mr_n80087232)
print v(xbgr.mr_n80087632)
print v(xbgr.mr_n80088032)
print v(xbgr.mr_n80088432)
print v(xbgr.mr_n80088832)
print v(xbgr.mr_n80089232)
print v(xbgr.mr_n80089632)
print v(xbgr.mr_n80090032)
print v(xbgr.mr_n80090432)
print v(xbgr.mr_n80090832)
print v(xbgr.mr_n80091232)
print v(xbgr.mr_n80091632)
print v(xbgr.mr_n80092032)
print v(xbgr.mr_n80092432)
print v(xbgr.mr_n80092832)
print v(xbgr.mr_n80093232)
print v(xbgr.mr_n80093632)
print v(xbgr.mr_n80094032)
print v(xbgr.mr_n80094432)
print v(xbgr.mr_n80094832)
print v(xbgr.mr_n80095232)
print v(xbgr.mr_n80095632)
print v(xbgr.mr_n80096032)
print v(xbgr.mr_n80096432)
print v(xbgr.mr_n80096832)
print v(xbgr.mr_n80097232)
print v(xbgr.mr_n80097632)
print v(xbgr.mr_n80098032)
print v(xbgr.mr_n80098432)
print v(xbgr.mr_n80098832)
print v(xbgr.mr_n80099232)
print v(xbgr.mr_n80099760)
print v(xbgr.mr_n80100352)
print v(xbgr.mr_n80100944)
print v(xbgr.mr_n80101472)
print v(xbgr.mr_n80102128)
print v(xbgr.mr_n80102720)
print v(xbgr.mr_n80103312)
print v(xbgr.mr_n80103904)
print v(xbgr.mr_n80104496)
print v(xbgr.mr_n80105088)
print v(xbgr.mr_n80105680)
print v(xbgr.mr_n80106864)
print v(xbgr.mr_n80112608)
print v(xbgr.mr_n80115424)
print v(xbgr.mr_n80121056)
print v(xbgr.mr_n80122736)
print v(xbgr.mr_n80123328)
print v(xbgr.mr_n80123920)
print v(xbgr.mr_n80124448)
print v(xbgr.mr_n80125104)
print v(xbgr.mr_n80125696)
print v(xbgr.mr_n80126288)
print v(xbgr.mr_n80126880)
print v(xbgr.mr_n80127216)
print v(xbgr.mr_n80127472)
print v(xbgr.mr_n80128064)
print v(xbgr.mr_n80128656)
print v(xbgr.mr_n80129184)
print v(xbgr.mr_n80129840)
print v(xbgr.mr_n80130432)
print v(xbgr.mr_n80131024)
print v(xbgr.mr_n80131552)
print v(xbgr.mr_n80132208)
print v(xbgr.mr_n80132800)
print v(xbgr.mr_n80133392)
print v(xbgr.mr_n80133984)
print v(xbgr.mr_n80134576)
print v(xbgr.mr_n80135168)
print v(xbgr.mr_n80135760)
print v(xbgr.mr_n80136288)
print v(xbgr.mr_n80136944)
print v(xbgr.mr_n80137536)
print v(xbgr.mr_n80138128)
print v(xbgr.mr_n80138720)
print v(xbgr.mr_n80139312)
print v(xbgr.mr_n80139904)
print v(xbgr.mr_n80140496)
print v(xbgr.mr_n80141024)
print v(xbgr.mr_n80141680)
print v(xbgr.mr_n80142272)
print v(xbgr.mr_n80142864)
print v(xbgr.mr_n80143456)
print v(xbgr.mr_n80144048)
print v(xbgr.mr_n80144640)
print v(xbgr.mr_n80145232)
print v(xbgr.mr_n80145824)
print v(xbgr.mr_n80146416)
print v(xbgr.mr_n80146944)
print v(xbgr.mr_n80147344)
print v(xbgr.mr_n80148128)
print v(xbgr.mr_n80148784)
print v(xbgr.mr_n80149184)
print v(xbgr.mr_n80149376)
print v(xbgr.mr_n80149968)
print v(xbgr.mr_n80157088)
print v(xbgr.mr_n80158048)
print v(xbgr.mr_n80158560)
print v(xbgr.mr_n80159408)
print v(xbgr.mr_n80159600)
print v(xbgr.mr_n80162688)
print v(xbgr.mr_n80165856)
print v(xbgr.mr_n80168896)
print v(xbgr.mr_n80169504)
print v(xbgr.mr_n80169616)
print v(xbgr.mr_n80170208)
print v(xbgr.mr_n80172496)
print v(xbgr.mr_n80174176)
print v(xbgr.mr_n80176064)
print v(xbgr.mr_n80176960)
print v(xbgr.mr_n80191808)
print v(xbgr.mr_n80195024)
print v(xbgr.mr_n80195888)
print v(xbgr.mr_n80196000)
print v(xbgr.mr_n80196608)
print v(xbgr.mr_n80197328)
print v(xbgr.mr_n80197440)
print v(xbgr.mr_n80198048)
print v(xbgr.mr_n80198768)
print v(xbgr.mr_n80198880)
print v(xbgr.mr_n80199488)
print v(xbgr.mr_n80201744)
print v(xbgr.mr_n80203056)
print v(xbgr.mr_n80204960)
print v(xbgr.mr_n80206240)
print v(xbgr.mr_n80212192)
print v(xbgr.mr_n80215392)
print v(xbgr.mr_n80220768)
print v(xbgr.mr_n80221664)
print v(xbgr.mr_n80222560)
print v(xbgr.mr_n80229952)
print v(xbgr.mr_n80234160)
print v(xbgr.mr_n80235664)
print v(xbgr.mr_n80236224)
print v(xbgr.mr_n80237280)
print v(xbgr.mr_n80237776)
print v(xbgr.mr_n80238384)
print v(xbgr.mr_n80238640)
print v(xbgr.mr_n80239328)
print v(xbgr.mr_n80239472)
print v(xbgr.mr_n80240960)
print v(xbgr.mr_n80241376)
print v(xbgr.mr_n80241664)
print v(xbgr.mr_n80241776)
print v(xbgr.mr_n80242768)
print v(xbgr.mr_n80243904)
print v(xbgr.mr_n80244960)
print v(xbgr.mr_n80245552)
print v(xbgr.mr_n80246144)
print v(xbgr.mr_n80247328)
print v(xbgr.mr_n80247920)
print v(xbgr.mr_n80248512)
print v(xbgr.mr_n80249104)
print v(xbgr.mr_n80249696)
print v(xbgr.mr_n80250288)
print v(xbgr.mr_n80250880)
print v(xbgr.mr_n80251984)
print v(xbgr.mr_n80252656)
print v(xbgr.mr_n80253248)
print v(xbgr.mr_n80253840)
print v(xbgr.mr_n80254432)
print v(xbgr.mr_n80255024)
print v(xbgr.mr_n80255616)
print v(xbgr.mr_n80256208)
print v(xbgr.mr_n80256720)
print v(xbgr.mr_n80257392)
print v(xbgr.mr_n80257904)
print v(xbgr.mr_n80258576)
print v(xbgr.mr_n80259232)
print v(xbgr.mr_n80259680)
print v(xbgr.mr_n80260352)
print v(xbgr.mr_n80260944)
print v(xbgr.mr_n80261536)
print v(xbgr.mr_n80261872)
print v(xbgr.mr_n80262128)
print v(xbgr.mr_n80263312)
print v(xbgr.mr_n80263904)
print v(xbgr.mr_n80264496)
print v(xbgr.mr_n80265152)
print v(xbgr.mr_n80265680)
print v(xbgr.mr_n80266272)
print v(xbgr.mr_n80266864)
print v(xbgr.mr_n80267280)
print v(xbgr.mr_n80267456)
print v(xbgr.mr_n80268048)
print v(xbgr.mr_n80268640)
print v(xbgr.mr_n80269232)
print v(xbgr.mr_n80269824)
print v(xbgr.mr_n80270416)
print v(xbgr.mr_n80271008)
print v(xbgr.mr_n80271600)
print v(xbgr.mr_n80272192)
print v(xbgr.mr_n80272784)
print v(xbgr.mr_n80273376)
print v(xbgr.mr_n80273952)
print v(xbgr.mr_n80274544)
print v(xbgr.mr_n80275136)
print v(xbgr.mr_n80275792)
print v(xbgr.mr_n80276320)
print v(xbgr.mr_n80276912)
print v(xbgr.mr_n80277504)
print v(xbgr.mr_n80278096)
print v(xbgr.mr_n80279280)
print v(xbgr.mr_n80279872)
print v(xbgr.mr_n80280464)
print v(xbgr.mr_n80281056)
print v(xbgr.mr_n80281568)
print v(xbgr.mr_n80282240)
print v(xbgr.mr_n80282832)
print v(xbgr.mr_n80283424)
print v(xbgr.mr_n80284016)
print v(xbgr.mr_n80284608)
print v(xbgr.mr_n80285200)
print v(xbgr.mr_n80285856)
print v(xbgr.mr_n80286384)
print v(xbgr.mr_n80286976)
print v(xbgr.mr_n80287568)
print v(xbgr.mr_n80288160)
print v(xbgr.mr_n80288752)
print v(xbgr.mr_n80289344)
print v(xbgr.mr_n80289744)
print v(xbgr.mr_n80290240)
print v(xbgr.mr_n80290944)
print v(xbgr.mr_n80291408)
print v(xbgr.mr_n80291872)
print v(xbgr.mr_n80292464)
print v(xbgr.mr_n80293120)
print v(xbgr.mr_n80294816)
print v(xbgr.mr_n80296432)
print v(xbgr.mr_n80296544)
print v(xbgr.mr_n80296656)
print v(xbgr.mr_n80296800)
print v(xbgr.mr_n80297040)
print v(xbgr.mr_n80297280)
print v(xbgr.mr_n80297520)
print v(xbgr.mr_n80297760)
print v(xbgr.mr_n80298000)
print v(xbgr.mr_n80298240)
print v(xbgr.mr_n80298480)
print v(xbgr.mr_n80298720)
print v(xbgr.mr_n80298960)
print v(xbgr.mr_n80299280)
print v(xbgr.mr_n80299600)
print v(xbgr.mr_n80300080)
print v(xbgr.mr_n80300480)
print v(xbgr.mr_n80300880)
print v(xbgr.mr_n80301200)
print v(xbgr.mr_n80301680)
print v(xbgr.mr_n80302080)
print v(xbgr.mr_n80302480)
print v(xbgr.mr_n80302880)
print v(xbgr.mr_n80303280)
print v(xbgr.mr_n80303600)
print v(xbgr.mr_n80304080)
print v(xbgr.mr_n80304480)
print v(xbgr.mr_n80304880)
print v(xbgr.mr_n80305200)
print v(xbgr.mr_n80305680)
print v(xbgr.mr_n80306080)
print v(xbgr.mr_n80306480)
print v(xbgr.mr_n80306880)
print v(xbgr.mr_n80307200)
print v(xbgr.mr_n80307600)
print v(xbgr.mr_n80308080)
print v(xbgr.mr_n80308480)
print v(xbgr.mr_n80308880)
print v(xbgr.mr_n80309200)
print v(xbgr.mr_n80309680)
print v(xbgr.mr_n80310080)
print v(xbgr.mr_n80310480)
print v(xbgr.mr_n80310880)
print v(xbgr.mr_n80311200)
print v(xbgr.mr_n80311600)
print v(xbgr.mr_n80312016)
print v(xbgr.mr_n80312128)
print v(xbgr.mr_n80312240)
print v(xbgr.mr_n80312512)
print v(xbgr.mr_n80312784)
print v(xbgr.mr_n80313056)
print v(xbgr.mr_n80313328)
print v(xbgr.mr_n80313600)
print v(xbgr.mr_n80313872)
print v(xbgr.mr_n80314144)
print v(xbgr.mr_n80314416)
print v(xbgr.mr_n80314688)
print v(xbgr.mr_n80314960)
print v(xbgr.mr_n80315232)
print v(xbgr.mr_n80315504)
print v(xbgr.mr_n80315776)
print v(xbgr.mr_n80316048)
print v(xbgr.mr_n80316320)
print v(xbgr.mr_n80316768)
print v(xbgr.mr_n80316960)
print v(xbgr.mr_n80317152)
print v(xbgr.mr_n80317344)
print v(xbgr.mr_n80318288)
print v(xbgr.mr_n80322816)
print v(xbgr.mr_n80322928)
print v(xbgr.mr_n80323120)
print v(xbgr.mr_n80323872)
print v(xbgr.mr_n80324784)
print v(xbgr.mr_n80325536)
print v(xbgr.mr_n80327808)
print v(xbgr.mr_n80327920)
print v(xbgr.mr_n80328112)
print v(xbgr.mr_n80328864)
print v(xbgr.mr_n80329776)
print v(xbgr.mr_n80330528)
print v(xbgr.mr_n80332800)
print v(xbgr.mr_n80332912)
print v(xbgr.mr_n80333104)
print v(xbgr.mr_n80333856)
print v(xbgr.mr_n80334768)
print v(xbgr.mr_n80335520)
print v(xbgr.mr_n80337792)
print v(xbgr.mr_n80337904)
print v(xbgr.mr_n80338096)
print v(xbgr.mr_n80338848)
print v(xbgr.mr_n80339760)
print v(xbgr.mr_n80340512)
print v(xbgr.mr_n80342784)
print v(xbgr.mr_n80342896)
print v(xbgr.mr_n80343088)
print v(xbgr.mr_n80343840)
print v(xbgr.mr_n80344752)
print v(xbgr.mr_n80345504)
print v(xbgr.mr_n80347776)
print v(xbgr.mr_n80347888)
print v(xbgr.mr_n80348080)
print v(xbgr.mr_n80348832)
print v(xbgr.mr_n80352352)
print v(xbgr.mr_n80352864)
print v(xbgr.mr_n80353296)
print v(xbgr.mr_n80353472)
print v(xbgr.mr_n80353648)
print v(xbgr.mr_n80354320)
print v(xbgr.mr_n80354752)
print v(xbgr.mr_n80354928)
print v(xbgr.mr_n80355264)
print v(xbgr.mr_n80355968)
print v(xbgr.mr_n80356144)
print v(xbgr.mr_n80356320)
print v(xbgr.mr_n80356832)
print v(xbgr.mr_n80356944)
print v(xbgr.mr_n80357504)
print v(xbgr.mr_n80357680)
print v(xbgr.mr_n80358176)
print v(xbgr.mr_n80358880)
print v(xbgr.mr_n80359056)
print v(xbgr.mr_n80359232)
print v(xbgr.mr_n80359744)
print v(xbgr.mr_n80359856)
print v(xbgr.mr_n80360416)
print v(xbgr.mr_n80360592)
print v(xbgr.mr_n80361008)
print v(xbgr.mr_n80361600)
print v(xbgr.mr_n80362032)
print v(xbgr.mr_n80362208)
print v(xbgr.mr_n80362544)
print v(xbgr.mr_n80363248)
print v(xbgr.mr_n80363424)
print v(xbgr.mr_n80363600)
print v(xbgr.mr_n80364112)
print v(xbgr.mr_n80364224)
print v(xbgr.mr_n80364784)
print v(xbgr.mr_n80364960)
print v(xbgr.mr_n80365376)
print v(xbgr.mr_n80365968)
print v(xbgr.mr_n80366400)
print v(xbgr.mr_n80366576)
print v(xbgr.mr_n80366832)
print v(xbgr.mr_n80367424)
print v(xbgr.mr_n80367856)
print v(xbgr.mr_n80368032)
print v(xbgr.mr_n80368368)
print v(xbgr.mr_n80369072)
print v(xbgr.mr_n80369248)
print v(xbgr.mr_n80369424)
print v(xbgr.mr_n80369936)
print v(xbgr.mr_n80370368)
print v(xbgr.mr_n80370544)
print v(xbgr.mr_n80370880)
print v(xbgr.mr_n80371392)
print v(xbgr.mr_n80371824)
print v(xbgr.mr_n80372256)
print v(xbgr.mr_n80372848)
print v(xbgr.mr_n80372960)
print v(xbgr.mr_n80373520)
print v(xbgr.mr_n80373696)
print v(xbgr.mr_n80374192)
print v(xbgr.mr_n80374896)
print v(xbgr.mr_n80375072)
print v(xbgr.mr_n80375248)
print v(xbgr.mr_n80375760)
print v(xbgr.mr_n80375872)
print v(xbgr.mr_n80375984)
print v(xbgr.mr_n80376096)
print v(xbgr.mr_n80376208)
print v(xbgr.mr_n80376480)
print v(xbgr.mr_n80376832)
print v(xbgr.mr_n80376944)
print v(xbgr.mr_n80377216)
print v(xbgr.mr_n80377568)
print v(xbgr.mr_n80377808)
print v(xbgr.mr_n80378144)
print v(xbgr.mr_n80378496)
print v(xbgr.mr_n80378608)
print v(xbgr.mr_n80378800)
print v(xbgr.mr_n80379072)
print v(xbgr.mr_n80379344)
print v(xbgr.mr_n80379616)
print v(xbgr.mr_n80379888)
print v(xbgr.mr_n80380160)
print v(xbgr.mr_n80380784)
print v(xbgr.mr_n80380976)
print v(xbgr.mr_n80381168)
print v(xbgr.mr_n80381360)
print v(xbgr.mr_n80382112)
print v(xbgr.mr_n80400256)
print v(xbgr.mr_n80400432)
print v(xbgr.mr_n80401136)
print v(xbgr.mr_n80401312)
print v(xbgr.mr_n80401488)
print v(xbgr.mr_n80402192)
print v(xbgr.mr_n80402368)
print v(xbgr.mr_n80402544)
print v(xbgr.mr_n80403248)
print v(xbgr.mr_n80403424)
print v(xbgr.mr_n80403600)
print v(xbgr.mr_n80404304)
print v(xbgr.mr_n80404480)
print v(xbgr.mr_n80404656)
print v(xbgr.mr_n80405360)
print v(xbgr.mr_n80405536)
print v(xbgr.mr_n80405712)
print v(xbgr.mr_n80406288)
print v(xbgr.mr_n80406480)
print v(xbgr.mr_n80406752)
print v(xbgr.mr_n80407024)
print v(xbgr.mr_n80407296)
print v(xbgr.mr_n80407568)
print v(xbgr.mr_n80407840)
print v(xbgr.mr_n80408112)
print v(xbgr.mr_n80408384)
print v(xbgr.mr_n80408656)
print v(xbgr.mr_n80412192)
print v(xbgr.mr_n80412528)
print v(xbgr.mr_n80412864)
print v(xbgr.mr_n80413200)
print v(xbgr.mr_n80413776)
print v(xbgr.mr_n80414496)
print v(xbgr.mr_n80414896)
print v(xbgr.mr_n80415296)
print v(xbgr.mr_n80415696)
print v(xbgr.mr_n80416096)
print v(xbgr.mr_n80416496)
print v(xbgr.mr_n80416896)
print v(xbgr.mr_n80417360)
print v(xbgr.mr_n80417536)
print v(xbgr.mr_n80418336)
print v(xbgr.mr_n80418960)
print v(xbgr.mr_n80419136)
print v(xbgr.mr_n80419760)
print v(xbgr.mr_n80419936)
print v(xbgr.mr_n80420560)
print v(xbgr.mr_n80420736)
print v(xbgr.mr_n80421360)
print v(xbgr.mr_n80421536)
print v(xbgr.mr_n80422160)
print v(xbgr.mr_n80422336)
print v(xbgr.mr_n80422960)
print v(xbgr.mr_n80423136)
print v(xbgr.mr_n80423760)
print v(xbgr.mr_n80423936)
print v(xbgr.mr_n80424368)
print v(xbgr.mr_n80424480)
print v(xbgr.mr_n80424592)
print v(xbgr.mr_n80424704)
print v(xbgr.mr_n80424816)
print v(xbgr.mr_n80424928)
print v(xbgr.mr_n80425520)
print v(xbgr.mr_n80425712)
print v(xbgr.mr_n80426304)
print v(xbgr.mr_n80429184)
print v(xbgr.mr_n80429696)
print v(xbgr.mr_n80431664)
print v(xbgr.mr_n80432176)
print v(xbgr.mr_n80433472)
print v(xbgr.mr_n80433984)
print v(xbgr.mr_n80435200)
print v(xbgr.mr_n80435792)
print v(xbgr.mr_n80437008)
print v(xbgr.mr_n80437600)
print v(xbgr.mr_n80438896)
print v(xbgr.mr_n80439408)
print v(xbgr.mr_n80440704)
print v(xbgr.mr_n80441216)
print v(xbgr.mr_n80442512)
print v(xbgr.mr_n80443024)
print v(xbgr.mr_n80444320)
print v(xbgr.mr_n80444832)
print v(xbgr.mr_n80446048)
print v(xbgr.mr_n80447936)
print v(xbgr.mr_n80448448)
print v(xbgr.mr_n80448560)
print v(xbgr.mr_n80448672)
print v(xbgr.mr_n80448784)
print v(xbgr.mr_n80449056)
print v(xbgr.mr_n80449168)
print v(xbgr.mr_n80449520)
print v(xbgr.mr_n80449632)
print v(xbgr.mr_n80449904)
print v(xbgr.mr_n80450256)
print v(xbgr.mr_n80450368)
print v(xbgr.mr_n80450736)
print v(xbgr.mr_n80451296)
print v(xbgr.mr_n80451776)
print v(xbgr.mr_n80452272)
print v(xbgr.mr_n80452624)
print v(xbgr.mr_n80453312)
print v(xbgr.mr_n80453776)
print v(xbgr.mr_n80454192)
print v(xbgr.mr_n80454880)
print v(xbgr.mr_n80455408)
print v(xbgr.mr_n80455760)
print v(xbgr.mr_n80456448)
print v(xbgr.mr_n80456976)
print v(xbgr.mr_n80457328)
print v(xbgr.mr_n80458016)
print v(xbgr.mr_n80458480)
print v(xbgr.mr_n80458896)
print v(xbgr.mr_n80459584)
print v(xbgr.mr_n80460112)
print v(xbgr.mr_n80460464)
print v(xbgr.mr_n80461152)
print v(xbgr.mr_n80461616)
print v(xbgr.mr_n80462032)
print v(xbgr.mr_n80462720)
print v(xbgr.mr_n80463184)
print v(xbgr.mr_n80463600)
print v(xbgr.mr_n80464288)
print v(xbgr.mr_n80464752)
print v(xbgr.mr_n80465168)
print v(xbgr.mr_n80465856)
print v(xbgr.mr_n80466320)
print v(xbgr.mr_n80466736)
print v(xbgr.mr_n80467424)
print v(xbgr.mr_n80467952)
print v(xbgr.mr_n80468304)
print v(xbgr.mr_n80468992)
print v(xbgr.mr_n80469456)
print v(xbgr.mr_n80469872)
print v(xbgr.mr_n80470560)
print v(xbgr.mr_n80471088)
print v(xbgr.mr_n80472512)
print v(xbgr.mr_n80473408)
print v(xbgr.mr_n80476800)
print v(xbgr.mr_n80477504)
print v(xbgr.mr_n80478096)
print v(xbgr.mr_n80478208)
print v(xbgr.mr_n80478464)
print v(xbgr.mr_n80478576)
print v(xbgr.mr_n80484032)
print v(xbgr.mr_n80484640)
print v(xbgr.mr_n80485008)
print v(xbgr.mr_n80486208)
print v(xbgr.mr_n80488832)
print v(xbgr.mr_n80492352)
print v(xbgr.mr_n80493568)
print v(xbgr.mr_n80494496)
print v(xbgr.mr_n80494960)
print v(xbgr.mr_n80495424)
print v(xbgr.mr_n80495888)
print v(xbgr.mr_n80496352)
print v(xbgr.mr_n80496816)
print v(xbgr.mr_n80497280)
print v(xbgr.mr_n80497744)
print v(xbgr.mr_n80498208)
print v(xbgr.mr_n80498672)
print v(xbgr.mr_n80499136)
print v(xbgr.mr_n80499600)
print v(xbgr.mr_n80500064)
print v(xbgr.mr_n80500528)
print v(xbgr.mr_n80500992)
print v(xbgr.mr_n80501456)
print v(xbgr.mr_n80502544)
print v(xbgr.mr_n80505312)
print v(xbgr.mr_n80505856)
print v(xbgr.mr_n80506112)
print v(xbgr.mr_n80506528)
print v(xbgr.mr_n80506992)
print v(xbgr.mr_n80508256)
print v(xbgr.mr_n80508848)
print v(xbgr.mr_n80509440)
print v(xbgr.mr_n80510128)
print v(xbgr.mr_n80510448)
print v(xbgr.mr_n80510704)
print v(xbgr.mr_n80510912)
print v(xbgr.mr_n80515056)
print v(xbgr.mr_n80515248)
print v(xbgr.mr_n80516336)
print v(xbgr.mr_n80517296)
print v(xbgr.mr_n80519984)
print v(xbgr.mr_n80523328)
print v(xbgr.mr_n80523584)
print v(xbgr.mr_n80528432)
print v(xbgr.mr_n80529904)
print v(xbgr.mr_n80530960)
print v(xbgr.mr_n80531152)
print v(xbgr.mr_n80531664)
print v(xbgr.mr_n80532288)
print v(xbgr.mr_n80532480)
print v(xbgr.mr_n80532800)
print v(xbgr.mr_n80533728)
print v(xbgr.mr_n80533920)
print v(xbgr.mr_n80534640)
print v(xbgr.mr_n80553392)
print v(xbgr.mr_n80554448)
print v(xbgr.mr_n80555152)
print v(xbgr.mr_n80555328)
print v(xbgr.mr_n80555888)
print v(xbgr.mr_n80556416)
print v(xbgr.mr_n80556592)
print v(xbgr.mr_n80556848)
print v(xbgr.mr_n80557552)
print v(xbgr.mr_n80557728)
print v(xbgr.mr_n80558288)
print v(xbgr.mr_n80558752)
print v(xbgr.mr_n80558928)
print v(xbgr.mr_n80559360)
print v(xbgr.mr_n80559616)
print v(xbgr.mr_n80559792)
print v(xbgr.mr_n80565104)
print v(xbgr.mr_n80565568)
print v(xbgr.mr_n80566032)
print v(xbgr.mr_n80566496)
print v(xbgr.mr_n80566960)
print v(xbgr.mr_n80567424)
print v(xbgr.mr_n80567888)
print v(xbgr.mr_n80568352)
print v(xbgr.mr_n80568816)
print v(xbgr.mr_n80569280)
print v(xbgr.mr_n80569744)
print v(xbgr.mr_n80570208)
print v(xbgr.mr_n80570672)
print v(xbgr.mr_n80571136)
print v(xbgr.mr_n80571600)
print v(xbgr.mr_n80572064)
print v(xbgr.mr_n80572528)
print v(xbgr.mr_n80572928)
print v(xbgr.mr_n80578288)
print v(xbgr.mr_n80583584)
print v(xbgr.mr_n80589424)
print v(xbgr.mr_n80591776)
print v(xbgr.mr_n80599168)
print v(xbgr.mr_n80600576)
print v(xbgr.mr_n80601312)
print v(xbgr.mr_n80607328)
print v(xbgr.mr_n80608000)
print v(xbgr.mr_n80608192)
print v(xbgr.mr_n80608448)
print v(xbgr.mr_n80608704)
print v(xbgr.mr_n80610672)
print v(xbgr.mr_n80611456)
print v(xbgr.mr_n80611568)
print v(xbgr.mr_n80611680)
print v(xbgr.mr_n80614384)
print v(xbgr.mr_n80615712)
print v(xbgr.mr_n80617760)
print v(xbgr.mr_n80620528)
print v(xbgr.mr_n80621856)
print v(xbgr.mr_n80623904)
print v(xbgr.mr_n80626672)
print v(xbgr.mr_n80628000)
print v(xbgr.mr_n80630048)
print v(xbgr.mr_n80632816)
print v(xbgr.mr_n80634144)
print v(xbgr.mr_n80636192)
print v(xbgr.mr_n80638960)
print v(xbgr.mr_n80640288)
print v(xbgr.mr_n80642336)
print v(xbgr.mr_n80645104)
print v(xbgr.mr_n80646432)
print v(xbgr.mr_n80647280)
print v(xbgr.mr_n80651120)
print v(xbgr.mr_n80653744)
print v(xbgr.mr_n80654144)
print v(xbgr.mr_n80654544)
print v(xbgr.mr_n80654944)
print v(xbgr.mr_n80655344)
print v(xbgr.mr_n80655744)
print v(xbgr.mr_n80656144)
print v(xbgr.mr_n80656544)
print v(xbgr.mr_n80656944)
print v(xbgr.mr_n80657344)
print v(xbgr.mr_n80657744)
print v(xbgr.mr_n80658144)
print v(xbgr.mr_n80658544)
print v(xbgr.mr_n80658944)
print v(xbgr.mr_n80659344)
print v(xbgr.mr_n80659744)
print v(xbgr.mr_n80660016)
print v(xbgr.mr_n80660128)
print v(xbgr.mr_n80660240)
print v(xbgr.mr_n80660352)
print v(xbgr.mr_n80660464)
print v(xbgr.mr_n80660656)
print v(xbgr.mr_n80660928)
print v(xbgr.mr_n80661200)
print v(xbgr.mr_n80661472)
print v(xbgr.mr_n80661744)
print v(xbgr.mr_n80662016)
print v(xbgr.mr_n80662288)
print v(xbgr.mr_n80662560)
print v(xbgr.mr_n80662896)
print v(xbgr.mr_n80663296)
print v(xbgr.mr_n80675792)
print v(xbgr.mr_n80677520)
print v(xbgr.mr_n80678064)
print v(xbgr.mr_n80678240)
print v(xbgr.mr_n80679088)
print v(xbgr.mr_n80679440)
print v(xbgr.mr_n80679568)
print v(xbgr.mr_n80680064)
print v(xbgr.mr_n80680480)
print v(xbgr.mr_n80680608)
print v(xbgr.mr_n80680784)
print v(xbgr.mr_n80681632)
print v(xbgr.mr_n80682112)
print v(xbgr.mr_n80682608)
print v(xbgr.mr_n80683152)
print v(xbgr.mr_n80683328)
print v(xbgr.mr_n80684176)
print v(xbgr.mr_n80684656)
print v(xbgr.mr_n80685088)
print v(xbgr.mr_n80685696)
print v(xbgr.mr_n80685872)
print v(xbgr.mr_n80686656)
print v(xbgr.mr_n80687200)
print v(xbgr.mr_n80687696)
print v(xbgr.mr_n80688240)
print v(xbgr.mr_n80688416)
print v(xbgr.mr_n80689264)
print v(xbgr.mr_n80689744)
print v(xbgr.mr_n80690176)
print v(xbgr.mr_n80690784)
print v(xbgr.mr_n80690960)
print v(xbgr.mr_n80691808)
print v(xbgr.mr_n80692288)
print v(xbgr.mr_n80692720)
print v(xbgr.mr_n80693328)
print v(xbgr.mr_n80693504)
print v(xbgr.mr_n80694288)
print v(xbgr.mr_n80694832)
print v(xbgr.mr_n80697376)
print v(xbgr.mr_n80699136)
print v(xbgr.mr_n80699696)
print v(xbgr.mr_n80703312)
print v(xbgr.mr_n80705936)
print v(xbgr.mr_n80706128)
print v(xbgr.mr_n80706384)
print v(xbgr.mr_n80706640)
print v(xbgr.mr_n80708608)
print v(xbgr.mr_n80729488)
print v(xbgr.mr_n80733200)
print v(xbgr.mr_n80733696)
print v(xbgr.mr_n80734000)
print v(xbgr.mr_n80734496)
print v(xbgr.mr_n80734800)
print v(xbgr.mr_n80735360)
print v(xbgr.mr_n80735664)
print v(xbgr.mr_n80736544)
print v(xbgr.mr_n80736848)
print v(xbgr.mr_n80737728)
print v(xbgr.mr_n80738032)
print v(xbgr.mr_n80738912)
print v(xbgr.mr_n80739216)
print v(xbgr.mr_n80740096)
print v(xbgr.mr_n80740400)
print v(xbgr.mr_n80741280)
print v(xbgr.mr_n80741584)
print v(xbgr.mr_n80742464)
print v(xbgr.mr_n80742768)
print v(xbgr.mr_n80743648)
print v(xbgr.mr_n80743952)
print v(xbgr.mr_n80744832)
print v(xbgr.mr_n80745136)
print v(xbgr.mr_n80746016)
print v(xbgr.mr_n80746320)
print v(xbgr.mr_n80747200)
print v(xbgr.mr_n80747504)
print v(xbgr.mr_n80748384)
print v(xbgr.mr_n80748688)
print v(xbgr.mr_n80749568)
print v(xbgr.mr_n80749760)
print v(xbgr.mr_n80750032)
print v(xbgr.mr_n80750496)
print v(xbgr.mr_n80762736)
print v(xbgr.mr_n80765344)
print v(xbgr.mr_n80766544)
print v(xbgr.mr_n80766880)
print v(xbgr.mr_n80767216)
print v(xbgr.mr_n80767552)
print v(xbgr.mr_n80769440)
print v(xbgr.mr_n80770352)
print v(xbgr.mr_n80770752)
print v(xbgr.mr_n80771152)
print v(xbgr.mr_n80771552)
print v(xbgr.mr_n80771952)
print v(xbgr.mr_n80772352)
print v(xbgr.mr_n80772752)
print v(xbgr.mr_n80773152)
print v(xbgr.mr_n80773552)
print v(xbgr.mr_n80773952)
print v(xbgr.mr_n80774352)
print v(xbgr.mr_n80774752)
print v(xbgr.mr_n80775152)
print v(xbgr.mr_n80775552)
print v(xbgr.mr_n80775952)
print v(xbgr.mr_n80776352)
print v(xbgr.mr_n80802880)
print v(xbgr.mr_n80803888)
print v(xbgr.mr_n80806768)
print v(xbgr.mr_n80807072)
print v(xbgr.mr_n80807376)
print v(xbgr.mr_n80807680)
print v(xbgr.mr_n80808064)
print v(xbgr.mr_n80808528)
print v(xbgr.mr_n80808992)
print v(xbgr.mr_n80809456)
print v(xbgr.mr_n80809920)
print v(xbgr.mr_n80810384)
print v(xbgr.mr_n80810848)
print v(xbgr.mr_n80811312)
print v(xbgr.mr_n80811776)
print v(xbgr.mr_n80815936)
print v(xbgr.mr_n80816112)
print v(xbgr.mr_n80816448)
print v(xbgr.mr_n80817312)
print v(xbgr.mr_n80817952)
print v(xbgr.mr_n80818128)
print v(xbgr.mr_n80818624)
print v(xbgr.mr_n80819328)
print v(xbgr.mr_n80821584)
print v(xbgr.mr_n80822256)
print v(xbgr.mr_n80823536)
print v(xbgr.mr_n80823872)
print v(xbgr.mr_n80824208)
print v(xbgr.mr_n80824544)
print v(xbgr.mr_n80826800)
print v(xbgr.mr_n80827504)
print v(xbgr.mr_n80827616)
print v(xbgr.mr_n80827808)
print v(xbgr.mr_n80829840)
print v(xbgr.mr_n80830560)
print v(xbgr.mr_n80832160)
print v(xbgr.mr_n80832800)
print v(xbgr.mr_n80832912)
print v(xbgr.mr_n80833184)
print v(xbgr.mr_n80834944)
print v(xbgr.mr_n80836064)
print v(xbgr.mr_n80836176)
print v(xbgr.mr_n80838480)
print v(xbgr.mr_n80838592)
print v(xbgr.mr_n80838704)
print v(xbgr.mr_n80838976)
print v(xbgr.mr_n80841088)
print v(xbgr.mr_n80841728)
print v(xbgr.mr_n80841840)
print v(xbgr.mr_n80843104)
print v(xbgr.mr_n80843744)
print v(xbgr.mr_n80844448)
print v(xbgr.mr_n80844560)
print v(xbgr.mr_n80846144)
print v(xbgr.mr_n80846784)
print v(xbgr.mr_n80846896)
print v(xbgr.mr_n80848592)
print v(xbgr.mr_n80848704)
print v(xbgr.mr_n80848816)
print v(xbgr.mr_n80849088)
print v(xbgr.mr_n80851248)
print v(xbgr.mr_n80851360)
print v(xbgr.mr_n80851552)
print v(xbgr.mr_n80853024)
print v(xbgr.mr_n80853712)
print v(xbgr.mr_n80854560)
print v(xbgr.mr_n80854672)
print v(xbgr.mr_n80856256)
print v(xbgr.mr_n80856896)
print v(xbgr.mr_n80857008)
print v(xbgr.mr_n80858704)
print v(xbgr.mr_n80858816)
print v(xbgr.mr_n80858928)
print v(xbgr.mr_n80859200)
print v(xbgr.mr_n80861360)
print v(xbgr.mr_n80861472)
print v(xbgr.mr_n80861664)
print v(xbgr.mr_n80863696)
print v(xbgr.mr_n80863808)
print v(xbgr.mr_n80863920)
print v(xbgr.mr_n80864192)
print v(xbgr.mr_n80866416)
print v(xbgr.mr_n80866528)
print v(xbgr.mr_n80866720)
print v(xbgr.mr_n80867232)
print v(xbgr.mr_n80867568)
print v(xbgr.mr_n80867920)
print v(xbgr.mr_n80868544)
print v(xbgr.mr_n80869008)
print v(xbgr.mr_n80869424)
print v(xbgr.mr_n80870112)
print v(xbgr.mr_n80870640)
print v(xbgr.mr_n80870992)
print v(xbgr.mr_n80871680)
print v(xbgr.mr_n80872144)
print v(xbgr.mr_n80872560)
print v(xbgr.mr_n80873248)
print v(xbgr.mr_n80873712)
print v(xbgr.mr_n80874128)
print v(xbgr.mr_n80874816)
print v(xbgr.mr_n80875280)
print v(xbgr.mr_n80875696)
print v(xbgr.mr_n80876384)
print v(xbgr.mr_n80876912)
print v(xbgr.mr_n80877264)
print v(xbgr.mr_n80877952)
print v(xbgr.mr_n80878480)
print v(xbgr.mr_n80878832)
print v(xbgr.mr_n80879520)
print v(xbgr.mr_n80880048)
print v(xbgr.mr_n80880400)
print v(xbgr.mr_n80881088)
print v(xbgr.mr_n80881616)
print v(xbgr.mr_n80881968)
print v(xbgr.mr_n80882656)
print v(xbgr.mr_n80883120)
print v(xbgr.mr_n80883536)
print v(xbgr.mr_n80884224)
print v(xbgr.mr_n80884688)
print v(xbgr.mr_n80885168)
print v(xbgr.mr_n80889968)
print v(xbgr.mr_n80890272)
print v(xbgr.mr_n80890656)
print v(xbgr.mr_n80905584)
print v(xbgr.mr_n80906048)
print v(xbgr.mr_n80906512)
print v(xbgr.mr_n80906976)
print v(xbgr.mr_n80907440)
print v(xbgr.mr_n80907904)
print v(xbgr.mr_n80908368)
print v(xbgr.mr_n80908832)
print v(xbgr.mr_n80909296)
print v(xbgr.mr_n80909760)
print v(xbgr.mr_n80910224)
print v(xbgr.mr_n80910688)
print v(xbgr.mr_n80911152)
print v(xbgr.mr_n80911616)
print v(xbgr.mr_n80912080)
print v(xbgr.mr_n80912544)
print v(xbgr.mr_n80913008)
print v(xbgr.mr_n80913472)
print v(xbgr.mr_n80913936)
print v(xbgr.mr_n80915600)
print v(xbgr.mr_n80918544)
print v(xbgr.mr_n80920848)
print v(xbgr.mr_n80920960)
print v(xbgr.mr_n80922528)
print v(xbgr.mr_n80929632)
print v(xbgr.mr_n80933520)
print v(xbgr.mr_n80937472)
print v(xbgr.mr_n80937664)
print v(xbgr.mr_n80937920)
print v(xbgr.mr_n80938176)
print v(xbgr.mr_n80940144)
print v(xbgr.mr_n80965600)
print v(xbgr.mr_n80965712)
print v(xbgr.mr_n80966064)
print v(xbgr.mr_n80966336)
print v(xbgr.mr_n80967008)
print v(xbgr.mr_n80967184)
print v(xbgr.mr_n80967984)
print v(xbgr.mr_n80968160)
print v(xbgr.mr_n80968640)
print v(xbgr.mr_n80968816)
print v(xbgr.mr_n80969296)
print v(xbgr.mr_n80969472)
print v(xbgr.mr_n80969952)
print v(xbgr.mr_n80970128)
print v(xbgr.mr_n80970608)
print v(xbgr.mr_n80970784)
print v(xbgr.mr_n80971264)
print v(xbgr.mr_n80971440)
print v(xbgr.mr_n80971920)
print v(xbgr.mr_n80972096)
print v(xbgr.mr_n80972352)
print v(xbgr.mr_n80973312)
print v(xbgr.mr_n80975456)
print v(xbgr.mr_n80975792)
print v(xbgr.mr_n80976640)
print v(xbgr.mr_n80977472)
print v(xbgr.mr_n80977648)
print v(xbgr.mr_n80977824)
print v(xbgr.mr_n80978528)
print v(xbgr.mr_n80978704)
print v(xbgr.mr_n80979264)
print v(xbgr.mr_n80979728)
print v(xbgr.mr_n80979904)
print v(xbgr.mr_n80980080)
print v(xbgr.mr_n80980784)
print v(xbgr.mr_n80980960)
print v(xbgr.mr_n80981584)
print v(xbgr.mr_n80981760)
print v(xbgr.mr_n80981936)
print v(xbgr.mr_n80982448)
print v(xbgr.mr_n80982880)
print v(xbgr.mr_n80983056)
print v(xbgr.mr_n80983312)
print v(xbgr.mr_n80984096)
print v(xbgr.mr_n80984272)
print v(xbgr.mr_n80984896)
print v(xbgr.mr_n80985072)
print v(xbgr.mr_n80985248)
print v(xbgr.mr_n80985952)
print v(xbgr.mr_n80986128)
print v(xbgr.mr_n80986752)
print v(xbgr.mr_n80986928)
print v(xbgr.mr_n80987104)
print v(xbgr.mr_n80987744)
print v(xbgr.mr_n80988016)
print v(xbgr.mr_n80988448)
print v(xbgr.mr_n80988624)
print v(xbgr.mr_n80988960)
print v(xbgr.mr_n80989664)
print v(xbgr.mr_n80989840)
print v(xbgr.mr_n80990464)
print v(xbgr.mr_n80990640)
print v(xbgr.mr_n80990816)
print v(xbgr.mr_n80991456)
print v(xbgr.mr_n80991728)
print v(xbgr.mr_n80991840)
print v(xbgr.mr_n80991952)
print v(xbgr.mr_n80992064)
print v(xbgr.mr_n80992176)
print v(xbgr.mr_n80992448)
print v(xbgr.mr_n80992800)
print v(xbgr.mr_n80992912)
print v(xbgr.mr_n80993024)
print v(xbgr.mr_n80993456)
print v(xbgr.mr_n80993936)
print v(xbgr.mr_n80994112)
print v(xbgr.mr_n80994464)
print v(xbgr.mr_n80994832)
print v(xbgr.mr_n80995168)
print v(xbgr.mr_n80995520)
print v(xbgr.mr_n80995632)
print v(xbgr.mr_n80996128)
print v(xbgr.mr_n80996624)
print v(xbgr.mr_n80997104)
print v(xbgr.mr_n80997280)
print v(xbgr.mr_n80997632)
print v(xbgr.mr_n80998000)
print v(xbgr.mr_n80998336)
print v(xbgr.mr_n80998688)
print v(xbgr.mr_n80998800)
print v(xbgr.mr_n80999296)
print v(xbgr.mr_n80999792)
print v(xbgr.mr_n81000272)
print v(xbgr.mr_n81000448)
print v(xbgr.mr_n81000800)
print v(xbgr.mr_n81001168)
print v(xbgr.mr_n81001504)
print v(xbgr.mr_n81001856)
print v(xbgr.mr_n81012528)
print v(xbgr.mr_n81013744)
print v(xbgr.mr_n81014128)
print v(xbgr.mr_n81014592)
print v(xbgr.mr_n81015056)
print v(xbgr.mr_n81015520)
print v(xbgr.mr_n81015984)
print v(xbgr.mr_n81016448)
print v(xbgr.mr_n81016912)
print v(xbgr.mr_n81017376)
print v(xbgr.mr_n81017840)
print v(xbgr.mr_n81018304)
print v(xbgr.mr_n81018768)
print v(xbgr.mr_n81019232)
print v(xbgr.mr_n81019696)
print v(xbgr.mr_n81020160)
print v(xbgr.mr_n81020624)
print v(xbgr.mr_n81021088)
print v(xbgr.mr_n81021552)
print v(xbgr.mr_n81022016)
print v(xbgr.mr_n81022480)
print v(xbgr.mr_n81022944)
print v(xbgr.mr_n81023408)
print v(xbgr.mr_n81023872)
print v(xbgr.mr_n81024336)
print v(xbgr.mr_n81024864)
print v(xbgr.mr_n81025456)
print v(xbgr.mr_n81037344)
print v(xbgr.mr_n81041664)
print v(xbgr.mr_n81045232)
print v(xbgr.mr_n81047728)
print v(xbgr.mr_n81049520)
print v(xbgr.mr_n81057504)
print v(xbgr.mr_n81057680)
print v(xbgr.mr_n81058016)
print v(xbgr.mr_n81059888)
print v(xbgr.mr_n81060000)
print v(xbgr.mr_n81060192)
print v(xbgr.mr_n81060944)
print v(xbgr.mr_n81063568)
print v(xbgr.mr_n81064320)
print v(xbgr.mr_n81073904)
print v(xbgr.mr_n81074272)
print v(xbgr.mr_n81075728)
print v(xbgr.mr_n81080048)
print v(xbgr.mr_n81080688)
print v(xbgr.mr_n81081120)
print v(xbgr.mr_n81081296)
print v(xbgr.mr_n81081632)
print v(xbgr.mr_n81082336)
print v(xbgr.mr_n81082512)
print v(xbgr.mr_n81083136)
print v(xbgr.mr_n81083312)
print v(xbgr.mr_n81083936)
print v(xbgr.mr_n81084112)
print v(xbgr.mr_n81084736)
print v(xbgr.mr_n81084912)
print v(xbgr.mr_n81085536)
print v(xbgr.mr_n81085712)
print v(xbgr.mr_n81086336)
print v(xbgr.mr_n81086512)
print v(xbgr.mr_n81087136)
print v(xbgr.mr_n81087312)
print v(xbgr.mr_n81087872)
print v(xbgr.mr_n81087984)
print v(xbgr.mr_n81088320)
print v(xbgr.mr_n81088976)
print v(xbgr.mr_n81089840)
print v(xbgr.mr_n81091536)
print v(xbgr.mr_n81091744)
print v(xbgr.mr_n81093488)
print v(xbgr.mr_n81094032)
print v(xbgr.mr_n81095376)
print v(xbgr.mr_n81095984)
print v(xbgr.mr_n81096208)
print v(xbgr.mr_n81097840)
print v(xbgr.mr_n81099344)
print v(xbgr.mr_n81100032)
print v(xbgr.mr_n81100800)
print v(xbgr.mr_n81101232)
print v(xbgr.mr_n81101504)
print v(xbgr.mr_n81101776)
print v(xbgr.mr_n81101888)
print v(xbgr.mr_n81102320)
print v(xbgr.mr_n81102592)
print v(xbgr.mr_n81102832)
print v(xbgr.mr_n81104096)
print v(xbgr.mr_n81104576)
print v(xbgr.mr_n81104768)
print v(xbgr.mr_n81104960)
print v(xbgr.mr_n81105264)
print v(xbgr.mr_n81105504)
print v(xbgr.mr_n81105616)
print v(xbgr.mr_n81105728)
print v(xbgr.mr_n81108160)
print v(xbgr.mr_n81108448)
print v(xbgr.mr_n81109216)
print v(xbgr.mr_n81109536)
print v(xbgr.mr_n81110048)
print v(xbgr.mr_n81110208)
print v(xbgr.mr_n81110352)
print v(xbgr.mr_n81110544)
print v(xbgr.mr_n81111904)
print v(xbgr.mr_n81112128)
print v(xbgr.mr_n81112400)
print v(xbgr.mr_n81112784)
print v(xbgr.mr_n81112896)
print v(xbgr.mr_n81113088)
print v(xbgr.mr_n81113280)
print v(xbgr.mr_n81114688)
print v(xbgr.mr_n81115888)
print v(xbgr.mr_n81116032)
print v(xbgr.mr_n81117136)
print v(xbgr.mr_n81117408)
print v(xbgr.mr_n81117520)
print v(xbgr.mr_n81118368)
print v(xbgr.mr_n81119264)
print v(xbgr.mr_n81119424)
print v(xbgr.mr_n81120192)
print v(xbgr.mr_n81120528)
print v(xbgr.mr_n81120672)
print v(xbgr.mr_n81121760)
print v(xbgr.mr_n81122256)
print v(xbgr.mr_n81122448)
print v(xbgr.mr_n81122832)
print v(xbgr.mr_n81122992)
print v(xbgr.mr_n81124720)
print v(xbgr.mr_n81125584)
print v(xbgr.mr_n81125856)
print v(xbgr.mr_n81126368)
print v(xbgr.mr_n81126720)
print v(xbgr.mr_n81127232)
print v(xbgr.mr_n81128464)
print v(xbgr.mr_n81129888)
print v(xbgr.mr_n81130096)
print v(xbgr.mr_n81130352)
print v(xbgr.mr_n81130544)
print v(xbgr.mr_n81130880)
print v(xbgr.mr_n81131072)
print v(xbgr.mr_n81131936)
print v(xbgr.mr_n81132336)
print v(xbgr.mr_n81132448)
print v(xbgr.mr_n81133440)
print v(xbgr.mr_n81133632)
print v(xbgr.mr_n81134192)
print v(xbgr.mr_n81134624)
print v(xbgr.mr_n81134816)
print v(xbgr.mr_n81134928)
print v(xbgr.mr_n81136400)
print v(xbgr.mr_n81136512)
print v(xbgr.mr_n81137584)
print v(xbgr.mr_n81137824)
print v(xbgr.mr_n81138080)
print v(xbgr.mr_n81138976)
print v(xbgr.mr_n81139168)
print v(xbgr.mr_n81139360)
print v(xbgr.mr_n81139552)
print v(xbgr.mr_n81139936)
print v(xbgr.mr_n81140192)
print v(xbgr.mr_n81140592)
print v(xbgr.mr_n81141840)
print v(xbgr.mr_n81142368)
print v(xbgr.mr_n81142640)
print v(xbgr.mr_n81142912)
print v(xbgr.mr_n81143248)
print v(xbgr.mr_n81143440)
print v(xbgr.mr_n81143632)
print v(xbgr.mr_n81143984)
print v(xbgr.mr_n81144720)
print v(xbgr.mr_n81145776)
print v(xbgr.mr_n81146048)
print v(xbgr.mr_n81146320)
print v(xbgr.mr_n81146592)
print v(xbgr.mr_n81146864)
print v(xbgr.mr_n81147136)
print v(xbgr.mr_n81147408)
print v(xbgr.mr_n81147680)
print v(xbgr.mr_n81147952)
print v(xbgr.mr_n81148224)
print v(xbgr.mr_n81148496)
print v(xbgr.mr_n81148768)
print v(xbgr.mr_n81149104)
print v(xbgr.mr_n81149568)
print v(xbgr.mr_n81150032)
print v(xbgr.mr_n81158464)
print v(xbgr.mr_n81161344)
print v(xbgr.mr_n81162640)
print v(xbgr.mr_n81166688)
print v(xbgr.mr_n81174112)
print v(xbgr.mr_n81176080)
print v(xbgr.mr_n81187680)
print v(xbgr.mr_n81191968)
print v(xbgr.mr_n81192864)
print v(xbgr.mr_n81195936)
print v(xbgr.mr_n81196576)
print v(xbgr.mr_n81196912)
print v(xbgr.mr_n81197248)
print v(xbgr.mr_n81197584)
print v(xbgr.mr_n81197920)
print v(xbgr.mr_n81198096)
print v(xbgr.mr_n81198208)
print v(xbgr.mr_n81198320)
print v(xbgr.mr_n81198432)
print v(xbgr.mr_n81198544)
print v(xbgr.mr_n81198656)
print v(xbgr.mr_n81198768)
print v(xbgr.mr_n81198880)
print v(xbgr.mr_n81198992)
print v(xbgr.mr_n81199344)
print v(xbgr.mr_n81199696)
print v(xbgr.mr_n81199808)
print v(xbgr.mr_n81201184)
print v(xbgr.mr_n81204320)
print v(xbgr.mr_n81204688)
print v(xbgr.mr_n81205840)
print v(xbgr.mr_n81206032)
print v(xbgr.mr_n81206224)
print v(xbgr.mr_n81206416)
print v(xbgr.mr_n81206528)
print v(xbgr.mr_n81206640)
print v(xbgr.mr_n81206752)
print v(xbgr.mr_n81206864)
print v(xbgr.mr_n81207392)
print v(xbgr.mr_n81207584)
print v(xbgr.mr_n81208480)
print v(xbgr.mr_n81208672)
print v(xbgr.mr_n81208944)
print v(xbgr.mr_n81209136)
print v(xbgr.mr_n81209328)
print v(xbgr.mr_n81209920)
print v(xbgr.mr_n81211920)
print v(xbgr.mr_n81212464)
print v(xbgr.mr_n81212656)
print v(xbgr.mr_n81213648)
print v(xbgr.mr_n81214544)
print v(xbgr.mr_n81214656)
print v(xbgr.mr_n81215056)
print v(xbgr.mr_n81215408)
print v(xbgr.mr_n81215840)
print v(xbgr.mr_n81216144)
print v(xbgr.mr_n81216768)
print v(xbgr.mr_n81217120)
print v(xbgr.mr_n81217552)
print v(xbgr.mr_n81217904)
print v(xbgr.mr_n81218336)
print v(xbgr.mr_n81218736)
print v(xbgr.mr_n81219152)
print v(xbgr.mr_n81219584)
print v(xbgr.mr_n81219888)
print v(xbgr.mr_n81220512)
print v(xbgr.mr_n81220864)
print v(xbgr.mr_n81221296)
print v(xbgr.mr_n81221648)
print v(xbgr.mr_n81222080)
print v(xbgr.mr_n81222544)
print v(xbgr.mr_n81222896)
print v(xbgr.mr_n81223328)
print v(xbgr.mr_n81223632)
print v(xbgr.mr_n81224256)
print v(xbgr.mr_n81224608)
print v(xbgr.mr_n81225040)
print v(xbgr.mr_n81225392)
print v(xbgr.mr_n81225824)
print v(xbgr.mr_n81226288)
print v(xbgr.mr_n81226640)
print v(xbgr.mr_n81227072)
print v(xbgr.mr_n81227376)
print v(xbgr.mr_n81228000)
print v(xbgr.mr_n81228352)
print v(xbgr.mr_n81228464)
print v(xbgr.mr_n81228656)
print v(xbgr.mr_n81228928)
print v(xbgr.mr_n81229200)
print v(xbgr.mr_n81229472)
print v(xbgr.mr_n81229744)
print v(xbgr.mr_n81230016)
print v(xbgr.mr_n81230288)
print v(xbgr.mr_n81230560)
print v(xbgr.mr_n81230832)
print v(xbgr.mr_n81231104)
print v(xbgr.mr_n81231376)
print v(xbgr.mr_n81231648)
print v(xbgr.mr_n81231920)
print v(xbgr.mr_n81232192)
print v(xbgr.mr_n81232464)
print v(xbgr.mr_n81232928)
print v(xbgr.mr_n81234704)
print v(xbgr.mr_n81236816)
print v(xbgr.mr_n81244240)
print v(xbgr.mr_n81250448)
print v(xbgr.mr_n81252912)
print v(xbgr.mr_n81253936)
print v(xbgr.mr_n81254128)
print v(xbgr.mr_n81254320)
print v(xbgr.mr_n81254576)
print v(xbgr.mr_n81254832)
print v(xbgr.mr_n81256800)
print v(xbgr.mr_n81257184)
print v(xbgr.mr_n81257296)
print v(xbgr.mr_n81258128)
print v(xbgr.mr_n81258672)
print v(xbgr.mr_n81261200)
print v(xbgr.mr_n81262640)
print v(xbgr.mr_n81264304)
print v(xbgr.mr_n81265232)
print v(xbgr.mr_n81266016)
print v(xbgr.mr_n81268288)
print v(xbgr.mr_n81268944)
print v(xbgr.mr_n81269456)
print v(xbgr.mr_n81270672)
print v(xbgr.mr_n81271264)
print v(xbgr.mr_n81272480)
print v(xbgr.mr_n81273072)
print v(xbgr.mr_n81274368)
print v(xbgr.mr_n81274880)
print v(xbgr.mr_n81276176)
print v(xbgr.mr_n81276688)
print v(xbgr.mr_n81277904)
print v(xbgr.mr_n81278496)
print v(xbgr.mr_n81279712)
print v(xbgr.mr_n81280304)
print v(xbgr.mr_n81281600)
print v(xbgr.mr_n81282112)
print v(xbgr.mr_n81283328)
print v(xbgr.mr_n81283920)
print v(xbgr.mr_n81284032)
print v(xbgr.mr_n81284144)
print v(xbgr.mr_n81284256)
print v(xbgr.mr_n81284368)
print v(xbgr.mr_n81284560)
print v(xbgr.mr_n81284992)
print v(xbgr.mr_n81285104)
print v(xbgr.mr_n81285376)
print v(xbgr.mr_n81285728)
print v(xbgr.mr_n81285968)
print v(xbgr.mr_n81286304)
print v(xbgr.mr_n81286720)
print v(xbgr.mr_n81287152)
print v(xbgr.mr_n81287840)
print v(xbgr.mr_n81288464)
print v(xbgr.mr_n81289008)
print v(xbgr.mr_n81289184)
print v(xbgr.mr_n81289440)
print v(xbgr.mr_n81289856)
print v(xbgr.mr_n81290176)
print v(xbgr.mr_n81290544)
print v(xbgr.mr_n81291008)
print v(xbgr.mr_n81291424)
print v(xbgr.mr_n81291856)
print v(xbgr.mr_n81292544)
print v(xbgr.mr_n81293168)
print v(xbgr.mr_n81293712)
print v(xbgr.mr_n81294096)
print v(xbgr.mr_n81294208)
print v(xbgr.mr_n81294560)
print v(xbgr.mr_n81295248)
print v(xbgr.mr_n81295776)
print v(xbgr.mr_n81296128)
print v(xbgr.mr_n81297248)
print v(xbgr.mr_n81297936)
print v(xbgr.mr_n81298416)
print v(xbgr.mr_n81298912)
print v(xbgr.mr_n81299264)
print v(xbgr.mr_n81299952)
print v(xbgr.mr_n81300480)
print v(xbgr.mr_n81300832)
print v(xbgr.mr_n81301152)
print v(xbgr.mr_n81301264)
print v(xbgr.mr_n81301952)
print v(xbgr.mr_n81302576)
print v(xbgr.mr_n81303120)
print v(xbgr.mr_n81303552)
print v(xbgr.mr_n81303968)
print v(xbgr.mr_n81304656)
print v(xbgr.mr_n81305184)
print v(xbgr.mr_n81305536)
print v(xbgr.mr_n81305968)
print v(xbgr.mr_n81306656)
print v(xbgr.mr_n81307280)
print v(xbgr.mr_n81307824)
print v(xbgr.mr_n81308256)
print v(xbgr.mr_n81308672)
print v(xbgr.mr_n81309360)
print v(xbgr.mr_n81309824)
print v(xbgr.mr_n81310240)
print v(xbgr.mr_n81310672)
print v(xbgr.mr_n81310864)
print v(xbgr.mr_n81311136)
print v(xbgr.mr_n81311408)
print v(xbgr.mr_n81311680)
print v(xbgr.mr_n81311952)
print v(xbgr.mr_n81312224)
print v(xbgr.mr_n81312496)
print v(xbgr.mr_n81312768)
print v(xbgr.mr_n81313040)
print v(xbgr.mr_n81313312)
print v(xbgr.mr_n81313584)
print v(xbgr.mr_n81313856)
print v(xbgr.mr_n81314128)
print v(xbgr.mr_n81321408)
print v(xbgr.mr_n81321984)
print v(xbgr.mr_n81323152)
print v(xbgr.mr_n81325248)
print v(xbgr.mr_n81338848)
print v(xbgr.mr_n81339312)
print v(xbgr.mr_n81339776)
print v(xbgr.mr_n81340240)
print v(xbgr.mr_n81340704)
print v(xbgr.mr_n81350688)
print v(xbgr.mr_n81353680)
print v(xbgr.mr_n81358544)
print v(xbgr.mr_n81361952)
print v(xbgr.mr_n81363056)
print v(xbgr.mr_n81366288)
print v(xbgr.mr_n81368080)
print v(xbgr.mr_n81371952)
print v(xbgr.mr_n81372256)
print v(xbgr.mr_n81372448)
print v(xbgr.mr_n81375968)
print v(xbgr.mr_n81383664)
print v(xbgr.mr_n81384928)
print v(xbgr.mr_n81386224)
print v(xbgr.mr_n81386736)
print v(xbgr.mr_n81388032)
print v(xbgr.mr_n81388544)
print v(xbgr.mr_n81389840)
print v(xbgr.mr_n81390352)
print v(xbgr.mr_n81391248)
print v(xbgr.mr_n81391824)
print v(xbgr.mr_n81392416)
print v(xbgr.mr_n81393312)
print v(xbgr.mr_n81393728)
print v(xbgr.mr_n81394480)
print v(xbgr.mr_n81395376)
print v(xbgr.mr_n81396032)
print v(xbgr.mr_n81396544)
print v(xbgr.mr_n81397440)
print v(xbgr.mr_n81397936)
print v(xbgr.mr_n81398608)
print v(xbgr.mr_n81399504)
print v(xbgr.mr_n81400160)
print v(xbgr.mr_n81400672)
print v(xbgr.mr_n81401568)
print v(xbgr.mr_n81402144)
print v(xbgr.mr_n81402736)
print v(xbgr.mr_n81403632)
print v(xbgr.mr_n81404208)
print v(xbgr.mr_n81404800)
print v(xbgr.mr_n81405696)
print v(xbgr.mr_n81406352)
print v(xbgr.mr_n81406864)
print v(xbgr.mr_n81407760)
print v(xbgr.mr_n81408336)
print v(xbgr.mr_n81408928)
print v(xbgr.mr_n81409824)
print v(xbgr.mr_n81410480)
print v(xbgr.mr_n81410992)
print v(xbgr.mr_n81411888)
print v(xbgr.mr_n81412544)
print v(xbgr.mr_n81413056)
print v(xbgr.mr_n81413952)
print v(xbgr.mr_n81414528)
print v(xbgr.mr_n81415120)
print v(xbgr.mr_n81416416)
print v(xbgr.mr_n81416928)
print v(xbgr.mr_n81417040)
print v(xbgr.mr_n81417152)
print v(xbgr.mr_n81417264)
print v(xbgr.mr_n81417536)
print v(xbgr.mr_n81417648)
print v(xbgr.mr_n81418000)
print v(xbgr.mr_n81418112)
print v(xbgr.mr_n81418224)
print v(xbgr.mr_n81418656)
print v(xbgr.mr_n81419136)
print v(xbgr.mr_n81419312)
print v(xbgr.mr_n81419664)
print v(xbgr.mr_n81420032)
print v(xbgr.mr_n81420368)
print v(xbgr.mr_n81420720)
print v(xbgr.mr_n81420832)
print v(xbgr.mr_n81421328)
print v(xbgr.mr_n81421824)
print v(xbgr.mr_n81422304)
print v(xbgr.mr_n81422480)
print v(xbgr.mr_n81422832)
print v(xbgr.mr_n81423200)
print v(xbgr.mr_n81423536)
print v(xbgr.mr_n81423888)
print v(xbgr.mr_n81424000)
print v(xbgr.mr_n81424496)
print v(xbgr.mr_n81424992)
print v(xbgr.mr_n81425472)
print v(xbgr.mr_n81425648)
print v(xbgr.mr_n81426000)
print v(xbgr.mr_n81426432)
print v(xbgr.mr_n81426896)
print v(xbgr.mr_n81427312)
print v(xbgr.mr_n81427744)
print v(xbgr.mr_n81428432)
print v(xbgr.mr_n81429120)
print v(xbgr.mr_n81429600)
print v(xbgr.mr_n81430032)
print v(xbgr.mr_n81430448)
print v(xbgr.mr_n81431136)
print v(xbgr.mr_n81431664)
print v(xbgr.mr_n81432016)
print v(xbgr.mr_n81432448)
print v(xbgr.mr_n81433136)
print v(xbgr.mr_n81433760)
print v(xbgr.mr_n81434176)
print v(xbgr.mr_n81434288)
print v(xbgr.mr_n81434480)
print v(xbgr.mr_n81434752)
print v(xbgr.mr_n81435024)
print v(xbgr.mr_n81435296)
print v(xbgr.mr_n81435568)
print v(xbgr.mr_n81435840)
print v(xbgr.mr_n81436112)
print v(xbgr.mr_n81436384)
print v(xbgr.mr_n81436656)
print v(xbgr.mr_n81436928)
print v(xbgr.mr_n81437200)
print v(xbgr.mr_n81437472)
print v(xbgr.mr_n81437744)
print v(xbgr.mr_n81438016)
print v(xbgr.mr_n81438288)
print v(xbgr.mr_n81438560)
print v(xbgr.mr_n81447440)
print v(xbgr.mr_n81447984)
print v(xbgr.mr_n81451280)
print v(xbgr.mr_n81456432)
print v(xbgr.mr_n81456896)
print v(xbgr.mr_n81457360)
print v(xbgr.mr_n81457824)
print v(xbgr.mr_n81458288)
print v(xbgr.mr_n81458752)
print v(xbgr.mr_n81459216)
print v(xbgr.mr_n81459744)
print v(xbgr.mr_n81460336)
print v(xbgr.mr_n81460928)
print v(xbgr.mr_n81461520)
print v(xbgr.mr_n81462112)
print v(xbgr.mr_n81462704)
print v(xbgr.mr_n81463296)
print v(xbgr.mr_n81463888)
print v(xbgr.mr_n81464480)
print v(xbgr.mr_n81465072)
print v(xbgr.mr_n81466816)
print v(xbgr.mr_n81472816)
print v(xbgr.mr_n81479008)
print v(xbgr.mr_n81481840)
print v(xbgr.mr_n81483488)
print v(xbgr.mr_n81483936)
print v(xbgr.mr_n81490608)
print v(xbgr.mr_n81493760)
print v(xbgr.mr_n81494032)
print v(xbgr.mr_n81494224)
print v(xbgr.mr_n81494480)
print v(xbgr.mr_n81494736)
print v(xbgr.mr_n81496896)
print v(xbgr.mr_n81504128)
print v(xbgr.mr_n81504768)
print v(xbgr.mr_n81504880)
print v(xbgr.mr_n81506064)
print v(xbgr.mr_n81506320)
print v(xbgr.mr_n81506512)
print v(xbgr.mr_n81506768)
print v(xbgr.mr_n81506880)
print v(xbgr.mr_n81507312)
print v(xbgr.mr_n81508128)
print v(xbgr.mr_n81511488)
print v(xbgr.mr_n81512000)
print v(xbgr.mr_n81513296)
print v(xbgr.mr_n81513808)
print v(xbgr.mr_n81514864)
print v(xbgr.mr_n81515616)
print v(xbgr.mr_n81516912)
print v(xbgr.mr_n81517424)
print v(xbgr.mr_n81518640)
print v(xbgr.mr_n81519232)
print v(xbgr.mr_n81520528)
print v(xbgr.mr_n81521040)
print v(xbgr.mr_n81522336)
print v(xbgr.mr_n81522848)
print v(xbgr.mr_n81524064)
print v(xbgr.mr_n81524656)
print v(xbgr.mr_n81525872)
print v(xbgr.mr_n81526464)
print v(xbgr.mr_n81527760)
print v(xbgr.mr_n81528272)
print v(xbgr.mr_n81529488)
print v(xbgr.mr_n81530080)
print v(xbgr.mr_n81531296)
print v(xbgr.mr_n81531888)
print v(xbgr.mr_n81533184)
print v(xbgr.mr_n81533696)
print v(xbgr.mr_n81533808)
print v(xbgr.mr_n81533920)
print v(xbgr.mr_n81534032)
print v(xbgr.mr_n81534304)
print v(xbgr.mr_n81534416)
print v(xbgr.mr_n81534768)
print v(xbgr.mr_n81534880)
print v(xbgr.mr_n81535152)
print v(xbgr.mr_n81535504)
print v(xbgr.mr_n81535616)
print v(xbgr.mr_n81535984)
print v(xbgr.mr_n81536544)
print v(xbgr.mr_n81537088)
print v(xbgr.mr_n81537520)
print v(xbgr.mr_n81537936)
print v(xbgr.mr_n81538624)
print v(xbgr.mr_n81539152)
print v(xbgr.mr_n81539504)
print v(xbgr.mr_n81539824)
print v(xbgr.mr_n81539936)
print v(xbgr.mr_n81540624)
print v(xbgr.mr_n81541248)
print v(xbgr.mr_n81541792)
print v(xbgr.mr_n81542288)
print v(xbgr.mr_n81542640)
print v(xbgr.mr_n81543328)
print v(xbgr.mr_n81543792)
print v(xbgr.mr_n81544208)
print v(xbgr.mr_n81544640)
print v(xbgr.mr_n81545328)
print v(xbgr.mr_n81546016)
print v(xbgr.mr_n81546496)
print v(xbgr.mr_n81546928)
print v(xbgr.mr_n81547344)
print v(xbgr.mr_n81548032)
print v(xbgr.mr_n81548496)
print v(xbgr.mr_n81548912)
print v(xbgr.mr_n81549344)
print v(xbgr.mr_n81550032)
print v(xbgr.mr_n81550720)
print v(xbgr.mr_n81551200)
print v(xbgr.mr_n81551440)
print v(xbgr.mr_n81551632)
print v(xbgr.mr_n81552048)
print v(xbgr.mr_n81552736)
print v(xbgr.mr_n81553264)
print v(xbgr.mr_n81553616)
print v(xbgr.mr_n81554048)
print v(xbgr.mr_n81554736)
print v(xbgr.mr_n81555424)
print v(xbgr.mr_n81555904)
print v(xbgr.mr_n81556400)
print v(xbgr.mr_n81556752)
print v(xbgr.mr_n81557440)
print v(xbgr.mr_n81557968)
print v(xbgr.mr_n81558320)
print v(xbgr.mr_n81558752)
print v(xbgr.mr_n81559440)
print v(xbgr.mr_n81560064)
print v(xbgr.mr_n81560480)
print v(xbgr.mr_n81560592)
print v(xbgr.mr_n81560784)
print v(xbgr.mr_n81561056)
print v(xbgr.mr_n81561328)
print v(xbgr.mr_n81561600)
print v(xbgr.mr_n81561872)
print v(xbgr.mr_n81562144)
print v(xbgr.mr_n81562416)
print v(xbgr.mr_n81562688)
print v(xbgr.mr_n81562960)
print v(xbgr.mr_n81563232)
print v(xbgr.mr_n81563504)
print v(xbgr.mr_n81563776)
print v(xbgr.mr_n81564048)
print v(xbgr.mr_n81564320)
print v(xbgr.mr_n81564592)
print v(xbgr.mr_n81564864)
print v(xbgr.mr_n81567024)
print v(xbgr.mr_n81572272)
print v(xbgr.mr_n81576880)
print v(xbgr.mr_n81577024)
print v(xbgr.mr_n81587200)
print v(xbgr.mr_n81588624)
print v(xbgr.mr_n81589088)
print v(xbgr.mr_n81589552)
print v(xbgr.mr_n81590016)
print v(xbgr.mr_n81590480)
print v(xbgr.mr_n81590944)
print v(xbgr.mr_n81591408)
print v(xbgr.mr_n81591936)
print v(xbgr.mr_n81592528)
print v(xbgr.mr_n81593120)
print v(xbgr.mr_n81593712)
print v(xbgr.mr_n81594304)
print v(xbgr.mr_n81594896)
print v(xbgr.mr_n81595488)
print v(xbgr.mr_n81596080)
print v(xbgr.mr_n81596672)
print v(xbgr.mr_n81597264)
print v(xbgr.mr_n81604432)
print v(xbgr.mr_n81609600)
print v(xbgr.mr_n81615104)
print v(xbgr.mr_n81615280)
print v(xbgr.mr_n81615616)
print v(xbgr.mr_n81617392)
print v(xbgr.mr_n81617984)
print v(xbgr.mr_n81618576)
print v(xbgr.mr_n81619168)
print v(xbgr.mr_n81619760)
print v(xbgr.mr_n81620352)
print v(xbgr.mr_n81620944)
print v(xbgr.mr_n81621536)
print v(xbgr.mr_n81622128)
print v(xbgr.mr_n81622720)
print v(xbgr.mr_n81623312)
print v(xbgr.mr_n81623904)
print v(xbgr.mr_n81624496)
print v(xbgr.mr_n81625088)
print v(xbgr.mr_n81625680)
print v(xbgr.mr_n81626272)
print v(xbgr.mr_n81626864)
print v(xbgr.mr_n81627456)
print v(xbgr.mr_n81628048)
print v(xbgr.mr_n81635296)
print v(xbgr.mr_n81636960)
print v(xbgr.mr_n81637504)
print v(xbgr.mr_n81638000)
print v(xbgr.mr_n81638352)
print v(xbgr.mr_n81638464)
print v(xbgr.mr_n81639168)
print v(xbgr.mr_n81641440)
print v(xbgr.mr_n81641552)
print v(xbgr.mr_n81642144)
print v(xbgr.mr_n81642336)
print v(xbgr.mr_n81643280)
print v(xbgr.mr_n81643456)
print v(xbgr.mr_n81645712)
print v(xbgr.mr_n81646064)
print v(xbgr.mr_n81646176)
print v(xbgr.mr_n81646880)
print v(xbgr.mr_n81649792)
print v(xbgr.mr_n81650144)
print v(xbgr.mr_n81650256)
print v(xbgr.mr_n81650960)
print v(xbgr.mr_n81653136)
print v(xbgr.mr_n81653552)
print v(xbgr.mr_n81653664)
print v(xbgr.mr_n81654368)
print v(xbgr.mr_n81656608)
print v(xbgr.mr_n81656960)
print v(xbgr.mr_n81657072)
print v(xbgr.mr_n81657776)
print v(xbgr.mr_n81660016)
print v(xbgr.mr_n81660368)
print v(xbgr.mr_n81660480)
print v(xbgr.mr_n81661184)
print v(xbgr.mr_n81663360)
print v(xbgr.mr_n81663776)
print v(xbgr.mr_n81663888)
print v(xbgr.mr_n81664592)
print v(xbgr.mr_n81666832)
print v(xbgr.mr_n81667184)
print v(xbgr.mr_n81667296)
print v(xbgr.mr_n81668000)
print v(xbgr.mr_n81681952)
print v(xbgr.mr_n81682128)
print v(xbgr.mr_n81682752)
print v(xbgr.mr_n81682928)
print v(xbgr.mr_n81683552)
print v(xbgr.mr_n81683728)
print v(xbgr.mr_n81684352)
print v(xbgr.mr_n81684528)
print v(xbgr.mr_n81685152)
print v(xbgr.mr_n81685328)
print v(xbgr.mr_n81685952)
print v(xbgr.mr_n81686128)
print v(xbgr.mr_n81686752)
print v(xbgr.mr_n81686928)
print v(xbgr.mr_n81687552)
print v(xbgr.mr_n81687728)
print v(xbgr.mr_n81688352)
print v(xbgr.mr_n81688528)
print v(xbgr.mr_n81689152)
print v(xbgr.mr_n81689328)
print v(xbgr.mr_n81689952)
print v(xbgr.mr_n81690128)
print v(xbgr.mr_n81690752)
print v(xbgr.mr_n81690928)
print v(xbgr.mr_n81691552)
print v(xbgr.mr_n81691728)
print v(xbgr.mr_n81692352)
print v(xbgr.mr_n81692528)
print v(xbgr.mr_n81693152)
print v(xbgr.mr_n81693328)
print v(xbgr.mr_n81693952)
print v(xbgr.mr_n81694128)
print v(xbgr.mr_n81694560)
print v(xbgr.mr_n81694672)
print v(xbgr.mr_n81694784)
print v(xbgr.mr_n81694896)
print v(xbgr.mr_n81695088)
print v(xbgr.mr_n81695360)
print v(xbgr.mr_n81695632)
print v(xbgr.mr_n81695904)
print v(xbgr.mr_n81696176)
print v(xbgr.mr_n81696448)
print v(xbgr.mr_n81696720)
print v(xbgr.mr_n81696992)
print v(xbgr.mr_n81697264)
print v(xbgr.mr_n81697536)
print v(xbgr.mr_n81697808)
print v(xbgr.mr_n81698080)
print v(xbgr.mr_n81698352)
print v(xbgr.mr_n81720288)
print v(xbgr.mr_n81724320)
print v(xbgr.mr_n81727216)
print v(xbgr.mr_n81727456)
print v(xbgr.mr_n81730880)
print v(xbgr.mr_n81732720)
print v(xbgr.mr_n81735840)
print v(xbgr.mr_n81736016)
print v(xbgr.mr_n81736352)
print v(xbgr.mr_n81736656)
print v(xbgr.mr_n81738192)
print v(xbgr.mr_n81738368)
print v(xbgr.mr_n81739312)
print v(xbgr.mr_n81739968)
print v(xbgr.mr_n81740144)
print v(xbgr.mr_n81741088)
print v(xbgr.mr_n81741744)
print v(xbgr.mr_n81741920)
print v(xbgr.mr_n81742864)
print v(xbgr.mr_n81743520)
print v(xbgr.mr_n81743696)
print v(xbgr.mr_n81744640)
print v(xbgr.mr_n81745296)
print v(xbgr.mr_n81745472)
print v(xbgr.mr_n81746416)
print v(xbgr.mr_n81747072)
print v(xbgr.mr_n81747248)
print v(xbgr.mr_n81748192)
print v(xbgr.mr_n81748848)
print v(xbgr.mr_n81749024)
print v(xbgr.mr_n81749968)
print v(xbgr.mr_n81750624)
print v(xbgr.mr_n81750800)
print v(xbgr.mr_n81751744)
print v(xbgr.mr_n81752400)
print v(xbgr.mr_n81752576)
print v(xbgr.mr_n81753520)
print v(xbgr.mr_n81754176)
print v(xbgr.mr_n81754352)
print v(xbgr.mr_n81755392)
print v(xbgr.mr_n81755664)
print v(xbgr.mr_n81755936)
print v(xbgr.mr_n81756272)
print v(xbgr.mr_n81756736)
print v(xbgr.mr_n81757088)
print v(xbgr.mr_n81757280)
print v(xbgr.mr_n81757472)
print v(xbgr.mr_n81757664)
print v(xbgr.mr_n81758416)
print v(xbgr.mr_n81762000)
print v(xbgr.mr_n81762416)
print v(xbgr.mr_n81762528)
print v(xbgr.mr_n81763232)
print v(xbgr.mr_n81765472)
print v(xbgr.mr_n81765824)
print v(xbgr.mr_n81765936)
print v(xbgr.mr_n81766640)
print v(xbgr.mr_n81768880)
print v(xbgr.mr_n81769232)
print v(xbgr.mr_n81769344)
print v(xbgr.mr_n81770048)
print v(xbgr.mr_n81772224)
print v(xbgr.mr_n81772640)
print v(xbgr.mr_n81772752)
print v(xbgr.mr_n81773456)
print v(xbgr.mr_n81775632)
print v(xbgr.mr_n81776048)
print v(xbgr.mr_n81776160)
print v(xbgr.mr_n81776864)
print v(xbgr.mr_n81776976)
print v(xbgr.mr_n81777088)
print v(xbgr.mr_n81777200)
print v(xbgr.mr_n81777312)
print v(xbgr.mr_n81779856)
print v(xbgr.mr_n81780688)
print v(xbgr.mr_n81781104)
print v(xbgr.mr_n81781216)
print v(xbgr.mr_n81781920)
print v(xbgr.mr_n81785088)
print v(xbgr.mr_n81785440)
print v(xbgr.mr_n81785552)
print v(xbgr.mr_n81786256)
print v(xbgr.mr_n81788496)
print v(xbgr.mr_n81788848)
print v(xbgr.mr_n81788960)
print v(xbgr.mr_n81789664)
print v(xbgr.mr_n81802224)
print v(xbgr.mr_n81802400)
print v(xbgr.mr_n81803024)
print v(xbgr.mr_n81803200)
print v(xbgr.mr_n81803824)
print v(xbgr.mr_n81804000)
print v(xbgr.mr_n81804624)
print v(xbgr.mr_n81804800)
print v(xbgr.mr_n81805424)
print v(xbgr.mr_n81805600)
print v(xbgr.mr_n81806224)
print v(xbgr.mr_n81806400)
print v(xbgr.mr_n81807024)
print v(xbgr.mr_n81807200)
print v(xbgr.mr_n81807824)
print v(xbgr.mr_n81808000)
print v(xbgr.mr_n81808624)
print v(xbgr.mr_n81808800)
print v(xbgr.mr_n81809424)
print v(xbgr.mr_n81809600)
print v(xbgr.mr_n81810224)
print v(xbgr.mr_n81810400)
print v(xbgr.mr_n81811024)
print v(xbgr.mr_n81811200)
print v(xbgr.mr_n81811824)
print v(xbgr.mr_n81812000)
print v(xbgr.mr_n81812624)
print v(xbgr.mr_n81812800)
print v(xbgr.mr_n81813424)
print v(xbgr.mr_n81813600)
print v(xbgr.mr_n81814224)
print v(xbgr.mr_n81814400)
print v(xbgr.mr_n81821200)
print v(xbgr.mr_n81822000)
print v(xbgr.mr_n81824768)
print v(xbgr.mr_n81826032)
print v(xbgr.mr_n81826336)
print v(xbgr.mr_n81826640)
print v(xbgr.mr_n81826944)
print v(xbgr.mr_n81827328)
print v(xbgr.mr_n81827792)
print v(xbgr.mr_n81828256)
print v(xbgr.mr_n81828720)
print v(xbgr.mr_n81829184)
print v(xbgr.mr_n81829648)
print v(xbgr.mr_n81830112)
print v(xbgr.mr_n81830576)
print v(xbgr.mr_n81831040)
print v(xbgr.mr_n81831504)
print v(xbgr.mr_n81831968)
print v(xbgr.mr_n81832432)
print v(xbgr.mr_n81832896)
print v(xbgr.mr_n81833360)
print v(xbgr.mr_n81833824)
print v(xbgr.mr_n81834288)
print v(xbgr.mr_n81834752)
print v(xbgr.mr_n81835216)
print v(xbgr.mr_n81835680)
print v(xbgr.mr_n81836144)
print v(xbgr.mr_n81836608)
print v(xbgr.mr_n81837072)
print v(xbgr.mr_n81837536)
print v(xbgr.mr_n81838000)
print v(xbgr.mr_n81838464)
print v(xbgr.mr_n81838928)
print v(xbgr.mr_n81840576)
print v(xbgr.mr_n81844240)
print v(xbgr.mr_n81845776)
print v(xbgr.mr_n81848448)
print v(xbgr.mr_n81863520)
print v(xbgr.mr_n81863984)
print v(xbgr.mr_n81864448)
print v(xbgr.mr_n81864976)
print v(xbgr.mr_n81865568)
print v(xbgr.mr_n81866160)
print v(xbgr.mr_n81866752)
print v(xbgr.mr_n81867344)
print v(xbgr.mr_n81867936)
print v(xbgr.mr_n81868528)
print v(xbgr.mr_n81869120)
print v(xbgr.mr_n81869712)
print v(xbgr.mr_n81870304)
print v(xbgr.mr_n81870896)
print v(xbgr.mr_n81871488)
print v(xbgr.mr_n81872080)
print v(xbgr.mr_n81872672)
print v(xbgr.mr_n81874512)
print v(xbgr.mr_n81874912)
print v(xbgr.mr_n81876816)
print v(xbgr.mr_n81886160)
print v(xbgr.mr_n81888720)
print v(xbgr.mr_n81895392)
print v(xbgr.mr_n81895584)
print v(xbgr.mr_n81895840)
print v(xbgr.mr_n81896096)
print v(xbgr.mr_n81898256)
print v(xbgr.mr_n81919600)
print v(xbgr.mr_n81923728)
print v(xbgr.mr_n81926976)
print v(xbgr.mr_n81936128)
print v(xbgr.mr_n81936432)
print v(xbgr.mr_n81949040)
print v(xbgr.mr_n81950448)
print v(xbgr.mr_n81957648)
print v(xbgr.mr_n81963552)
print v(xbgr.mr_n81964144)
print v(xbgr.mr_n81964736)
print v(xbgr.mr_n81965328)
print v(xbgr.mr_n81965920)
print v(xbgr.mr_n81966512)
print v(xbgr.mr_n81967104)
print v(xbgr.mr_n81967696)
print v(xbgr.mr_n81968288)
print v(xbgr.mr_n81968880)
print v(xbgr.mr_n81969472)
print v(xbgr.mr_n81970064)
print v(xbgr.mr_n81970720)
print v(xbgr.mr_n81971184)
print v(xbgr.mr_n81971648)
print v(xbgr.mr_n81972112)
print v(xbgr.mr_n81972576)
print v(xbgr.mr_n81975712)
print v(xbgr.mr_n81976432)
print v(xbgr.mr_n81976608)
print v(xbgr.mr_n81976784)
print v(xbgr.mr_n81978576)
print v(xbgr.mr_n81980288)
print v(xbgr.mr_n81983040)
print v(xbgr.mr_n81983376)
print v(xbgr.mr_n81983712)
print v(xbgr.mr_n81985296)
print v(xbgr.mr_n81986192)
print v(xbgr.mr_n81986368)
print v(xbgr.mr_n81986880)
print v(xbgr.mr_n81987376)
print v(xbgr.mr_n81987552)
print v(xbgr.mr_n81987888)
print v(xbgr.mr_n81988480)
print v(xbgr.mr_n81988976)
print v(xbgr.mr_n81989312)
print v(xbgr.mr_n81989824)
print v(xbgr.mr_n81989936)
print v(xbgr.mr_n81990048)
print v(xbgr.mr_n81991040)
print v(xbgr.mr_n81991456)
print v(xbgr.mr_n81991968)
print v(xbgr.mr_n81992464)
print v(xbgr.mr_n81992640)
print v(xbgr.mr_n81993056)
print v(xbgr.mr_n81993568)
print v(xbgr.mr_n81994128)
print v(xbgr.mr_n81994304)
print v(xbgr.mr_n81994800)
print v(xbgr.mr_n81995568)
print v(xbgr.mr_n81995744)
print v(xbgr.mr_n81996000)
print v(xbgr.mr_n81996512)
print v(xbgr.mr_n81996624)
print v(xbgr.mr_n81996736)
print v(xbgr.mr_n81996848)
print v(xbgr.mr_n81998336)
print v(xbgr.mr_n81998512)
print v(xbgr.mr_n81999088)
print v(xbgr.mr_n81999792)
print v(xbgr.mr_n81999968)
print v(xbgr.mr_n82000400)
print v(xbgr.mr_n82000512)
print v(xbgr.mr_n82001344)
print v(xbgr.mr_n82001520)
print v(xbgr.mr_n82001776)
print v(xbgr.mr_n82002432)
print v(xbgr.mr_n82003136)
print v(xbgr.mr_n82003312)
print v(xbgr.mr_n82003744)
print v(xbgr.mr_n82004304)
print v(xbgr.mr_n82004480)
print v(xbgr.mr_n82004736)
print v(xbgr.mr_n82005488)
print v(xbgr.mr_n82005600)
print v(xbgr.mr_n82006304)
print v(xbgr.mr_n82006720)
print v(xbgr.mr_n82007232)
print v(xbgr.mr_n82007728)
print v(xbgr.mr_n82007904)
print v(xbgr.mr_n82008080)
print v(xbgr.mr_n82008832)
print v(xbgr.mr_n82009328)
print v(xbgr.mr_n82009664)
print v(xbgr.mr_n82010176)
print v(xbgr.mr_n82010288)
print v(xbgr.mr_n82010400)
print v(xbgr.mr_n82011520)
print v(xbgr.mr_n82011696)
print v(xbgr.mr_n82011952)
print v(xbgr.mr_n82012448)
print v(xbgr.mr_n82013120)
print v(xbgr.mr_n82013232)
print v(xbgr.mr_n82013424)
print v(xbgr.mr_n82013776)
print v(xbgr.mr_n82013888)
print v(xbgr.mr_n82014400)
print v(xbgr.mr_n82014512)
print v(xbgr.mr_n82014624)
print v(xbgr.mr_n82014976)
print v(xbgr.mr_n82015312)
print v(xbgr.mr_n82016256)
print v(xbgr.mr_n82016672)
print v(xbgr.mr_n82016784)
print v(xbgr.mr_n82017344)
print v(xbgr.mr_n82017600)
print v(xbgr.mr_n82018416)
print v(xbgr.mr_n82018848)
print v(xbgr.mr_n82019024)
print v(xbgr.mr_n82019952)
print v(xbgr.mr_n82020128)
print v(xbgr.mr_n82020704)
print v(xbgr.mr_n82020816)
print v(xbgr.mr_n82020928)
print v(xbgr.mr_n82021696)
print v(xbgr.mr_n82022032)
print v(xbgr.mr_n82022976)
print v(xbgr.mr_n82023392)
print v(xbgr.mr_n82023504)
print v(xbgr.mr_n82024064)
print v(xbgr.mr_n82024320)
print v(xbgr.mr_n82025264)
print v(xbgr.mr_n82025680)
print v(xbgr.mr_n82025792)
print v(xbgr.mr_n82025904)
print v(xbgr.mr_n82026672)
print v(xbgr.mr_n82027008)
print v(xbgr.mr_n82028016)
print v(xbgr.mr_n82028192)
print v(xbgr.mr_n82028768)
print v(xbgr.mr_n82029200)
print v(xbgr.mr_n82029376)
print v(xbgr.mr_n82030112)
print v(xbgr.mr_n82030224)
print v(xbgr.mr_n82030784)
print v(xbgr.mr_n82031040)
print v(xbgr.mr_n82031984)
print v(xbgr.mr_n82032400)
print v(xbgr.mr_n82032512)
print v(xbgr.mr_n82032624)
print v(xbgr.mr_n82033392)
print v(xbgr.mr_n82033728)
print v(xbgr.mr_n82034544)
print v(xbgr.mr_n82034656)
print v(xbgr.mr_n82035216)
print v(xbgr.mr_n82035472)
print v(xbgr.mr_n82036416)
print v(xbgr.mr_n82036832)
print v(xbgr.mr_n82036944)
print v(xbgr.mr_n82037504)
print v(xbgr.mr_n82037760)
print v(xbgr.mr_n82038576)
print v(xbgr.mr_n82039008)
print v(xbgr.mr_n82039184)
print v(xbgr.mr_n82040496)
print v(xbgr.mr_n82046960)
print v(xbgr.mr_n82047072)
print v(xbgr.mr_n82047616)
print v(xbgr.mr_n82048160)
print v(xbgr.mr_n82048608)
print v(xbgr.mr_n82049072)
print v(xbgr.mr_n82049536)
print v(xbgr.mr_n82050000)
print v(xbgr.mr_n82050464)
print v(xbgr.mr_n82050928)
print v(xbgr.mr_n82051392)
print v(xbgr.mr_n82051856)
print v(xbgr.mr_n82052320)
print v(xbgr.mr_n82052784)
print v(xbgr.mr_n82053248)
print v(xbgr.mr_n82053712)
print v(xbgr.mr_n82054176)
print v(xbgr.mr_n82054640)
print v(xbgr.mr_n82055104)
print v(xbgr.mr_n82055568)
print v(xbgr.mr_n82064016)
print v(xbgr.mr_n82070624)
print v(xbgr.mr_n82083552)
print v(xbgr.mr_n82086784)
print v(xbgr.mr_n82087008)
print v(xbgr.mr_n82087424)
print v(xbgr.mr_n82087808)
print v(xbgr.mr_n82091328)
print v(xbgr.mr_n82091616)
print v(xbgr.mr_n82092576)
print v(xbgr.mr_n82094528)
print v(xbgr.mr_n82099200)
print v(xbgr.mr_n82099536)
print v(xbgr.mr_n82099872)
print v(xbgr.mr_n82100208)
print v(xbgr.mr_n82101552)
print v(xbgr.mr_n82102880)
print v(xbgr.mr_n82102992)
print v(xbgr.mr_n82104976)
print v(xbgr.mr_n82105088)
print v(xbgr.mr_n82106784)
print v(xbgr.mr_n82106896)
print v(xbgr.mr_n82108592)
print v(xbgr.mr_n82108704)
print v(xbgr.mr_n82110400)
print v(xbgr.mr_n82110512)
print v(xbgr.mr_n82112208)
print v(xbgr.mr_n82112320)
print v(xbgr.mr_n82114016)
print v(xbgr.mr_n82114128)
print v(xbgr.mr_n82115824)
print v(xbgr.mr_n82115936)
print v(xbgr.mr_n82117632)
print v(xbgr.mr_n82117744)
print v(xbgr.mr_n82119440)
print v(xbgr.mr_n82119552)
print v(xbgr.mr_n82121248)
print v(xbgr.mr_n82121360)
print v(xbgr.mr_n82123056)
print v(xbgr.mr_n82123168)
print v(xbgr.mr_n82124864)
print v(xbgr.mr_n82124976)
print v(xbgr.mr_n82126672)
print v(xbgr.mr_n82126784)
print v(xbgr.mr_n82128480)
print v(xbgr.mr_n82128592)
print v(xbgr.mr_n82130288)
print v(xbgr.mr_n82130400)
print v(xbgr.mr_n82132096)
print v(xbgr.mr_n82132208)
print v(xbgr.mr_n82133472)
print v(xbgr.mr_n82138096)
print v(xbgr.mr_n82142176)
print v(xbgr.mr_n82143200)
print v(xbgr.mr_n82158208)
print v(xbgr.mr_n82158672)
print v(xbgr.mr_n82158784)
print v(xbgr.mr_n82159600)
print v(xbgr.mr_n82160064)
print v(xbgr.mr_n82160176)
print v(xbgr.mr_n82160992)
print v(xbgr.mr_n82161520)
print v(xbgr.mr_n82161696)
print v(xbgr.mr_n82162640)
print v(xbgr.mr_n82163296)
print v(xbgr.mr_n82163472)
print v(xbgr.mr_n82164416)
print v(xbgr.mr_n82165072)
print v(xbgr.mr_n82165248)
print v(xbgr.mr_n82166192)
print v(xbgr.mr_n82166848)
print v(xbgr.mr_n82167024)
print v(xbgr.mr_n82167968)
print v(xbgr.mr_n82168624)
print v(xbgr.mr_n82168800)
print v(xbgr.mr_n82169744)
print v(xbgr.mr_n82170400)
print v(xbgr.mr_n82170576)
print v(xbgr.mr_n82171520)
print v(xbgr.mr_n82172176)
print v(xbgr.mr_n82172352)
print v(xbgr.mr_n82173296)
print v(xbgr.mr_n82173888)
print v(xbgr.mr_n82174480)
print v(xbgr.mr_n82175072)
print v(xbgr.mr_n82175664)
print v(xbgr.mr_n82176256)
print v(xbgr.mr_n82176848)
print v(xbgr.mr_n82177440)
print v(xbgr.mr_n82178032)
print v(xbgr.mr_n82178624)
print v(xbgr.mr_n82179216)
print v(xbgr.mr_n82179808)
print v(xbgr.mr_n82180400)
print v(xbgr.mr_n82181136)
print v(xbgr.mr_n82181376)
print v(xbgr.mr_n82181584)
print v(xbgr.mr_n82182112)
print v(xbgr.mr_n82182224)
print v(xbgr.mr_n82182336)
print v(xbgr.mr_n82182448)
print v(xbgr.mr_n82182800)
print v(xbgr.mr_n82183072)
print v(xbgr.mr_n82183776)
print v(xbgr.mr_n82184848)
print v(xbgr.mr_n82185760)
print v(xbgr.mr_n82186352)
print v(xbgr.mr_n82186944)
print v(xbgr.mr_n82187536)
print v(xbgr.mr_n82188128)
print v(xbgr.mr_n82188720)
print v(xbgr.mr_n82189312)
print v(xbgr.mr_n82189904)
print v(xbgr.mr_n82190496)
print v(xbgr.mr_n82191088)
print v(xbgr.mr_n82191680)
print v(xbgr.mr_n82198816)
print v(xbgr.mr_n82202144)
print v(xbgr.mr_n82205648)
print v(xbgr.mr_n82208240)
print v(xbgr.mr_n82208576)
print v(xbgr.mr_n82209152)
print v(xbgr.mr_n82209744)
print v(xbgr.mr_n82209856)
print v(xbgr.mr_n82211552)
print v(xbgr.mr_n82211664)
print v(xbgr.mr_n82213360)
print v(xbgr.mr_n82213472)
print v(xbgr.mr_n82215168)
print v(xbgr.mr_n82215280)
print v(xbgr.mr_n82216976)
print v(xbgr.mr_n82217088)
print v(xbgr.mr_n82218784)
print v(xbgr.mr_n82218896)
print v(xbgr.mr_n82220592)
print v(xbgr.mr_n82220704)
print v(xbgr.mr_n82222400)
print v(xbgr.mr_n82222512)
print v(xbgr.mr_n82224208)
print v(xbgr.mr_n82224320)
print v(xbgr.mr_n82226016)
print v(xbgr.mr_n82226128)
print v(xbgr.mr_n82227824)
print v(xbgr.mr_n82227936)
print v(xbgr.mr_n82228048)
print v(xbgr.mr_n82229888)
print v(xbgr.mr_n82230000)
print v(xbgr.mr_n82230112)
print v(xbgr.mr_n82231952)
print v(xbgr.mr_n82232064)
print v(xbgr.mr_n82232176)
print v(xbgr.mr_n82234016)
print v(xbgr.mr_n82234128)
print v(xbgr.mr_n82234240)
print v(xbgr.mr_n82236080)
print v(xbgr.mr_n82236192)
print v(xbgr.mr_n82236304)
print v(xbgr.mr_n82238144)
print v(xbgr.mr_n82238256)
print v(xbgr.mr_n82238368)
print v(xbgr.mr_n82240208)
print v(xbgr.mr_n82240320)
print v(xbgr.mr_n82240432)
print v(xbgr.mr_n82241344)
print v(xbgr.mr_n82241696)
print v(xbgr.mr_n82242208)
print v(xbgr.mr_n82242752)
print v(xbgr.mr_n82243296)
print v(xbgr.mr_n82243840)
print v(xbgr.mr_n82244384)
print v(xbgr.mr_n82244928)
print v(xbgr.mr_n82245472)
print v(xbgr.mr_n82246016)
print v(xbgr.mr_n82246560)
print v(xbgr.mr_n82247104)
print v(xbgr.mr_n82247648)
print v(xbgr.mr_n82248192)
print v(xbgr.mr_n82248736)
print v(xbgr.mr_n82249280)
print v(xbgr.mr_n82249824)
print v(xbgr.mr_n82250368)
print v(xbgr.mr_n82250832)
print v(xbgr.mr_n82251376)
print v(xbgr.mr_n82251920)
print v(xbgr.mr_n82252464)
print v(xbgr.mr_n82253008)
print v(xbgr.mr_n82253552)
print v(xbgr.mr_n82254096)
print v(xbgr.mr_n82254640)
print v(xbgr.mr_n82255184)
print v(xbgr.mr_n82255728)
print v(xbgr.mr_n82256400)
print v(xbgr.mr_n82256704)
print v(xbgr.mr_n82257088)
print v(xbgr.mr_n82257552)
print v(xbgr.mr_n82258016)
print v(xbgr.mr_n82258480)
print v(xbgr.mr_n82258944)
print v(xbgr.mr_n82259408)
print v(xbgr.mr_n82259872)
print v(xbgr.mr_n82260336)
print v(xbgr.mr_n82260800)
print v(xbgr.mr_n82261264)
print v(xbgr.mr_n82261728)
print v(xbgr.mr_n82262192)
print v(xbgr.mr_n82262656)
print v(xbgr.mr_n82263120)
print v(xbgr.mr_n82263584)
print v(xbgr.mr_n82264048)
print v(xbgr.mr_n82264512)
print v(xbgr.mr_n82264976)
print v(xbgr.mr_n82265440)
print v(xbgr.mr_n82265904)
print v(xbgr.mr_n82266368)
print v(xbgr.mr_n82266864)
print v(xbgr.mr_n82267456)
print v(xbgr.mr_n82268048)
print v(xbgr.mr_n82268640)
print v(xbgr.mr_n82269232)
print v(xbgr.mr_n82269824)
print v(xbgr.mr_n82270416)
print v(xbgr.mr_n82271232)
print v(xbgr.mr_n82273792)
print v(xbgr.mr_n82274240)
print v(xbgr.mr_n82276176)
print v(xbgr.mr_n82279520)
print v(xbgr.mr_n82290784)
print v(xbgr.mr_n82290992)
print v(xbgr.mr_n82291440)
print v(xbgr.mr_n82292080)
print v(xbgr.mr_n82292432)
print v(xbgr.mr_n82296880)
print v(xbgr.mr_n82297920)
print v(xbgr.mr_n82324288)
print v(xbgr.mr_n82327584)
print v(xbgr.mr_n82334544)
print v(xbgr.mr_n82334896)
print v(xbgr.mr_n82335584)
print v(xbgr.mr_n82336032)
print v(xbgr.mr_n82341072)
print v(xbgr.mr_n82342624)
print v(xbgr.mr_n82343936)
print v(xbgr.mr_n82345072)
print v(xbgr.mr_n82345248)
print v(xbgr.mr_n82348112)
print v(xbgr.mr_n82348384)
print v(xbgr.mr_n82349424)
print v(xbgr.mr_n82349600)
print v(xbgr.mr_n82349776)
print v(xbgr.mr_n82350080)
print v(xbgr.mr_n82350976)
print v(xbgr.mr_n82353952)
print v(xbgr.mr_n82360736)
print v(xbgr.mr_n82360912)
print v(xbgr.mr_n82363504)
print v(xbgr.mr_n82363728)
print v(xbgr.mr_n82365088)
print v(xbgr.mr_n82367632)
print v(xbgr.mr_n82367872)
print v(xbgr.mr_n82368880)
print v(xbgr.mr_n82369552)
print v(xbgr.mr_n82370096)
print v(xbgr.mr_n82378976)
print v(xbgr.mr_n82379312)
print v(xbgr.mr_n82379648)
print v(xbgr.mr_n82379984)
print v(xbgr.mr_n82380400)
print v(xbgr.mr_n82380640)
print v(xbgr.mr_n82381024)
print v(xbgr.mr_n82381536)
print v(xbgr.mr_n82381648)
print v(xbgr.mr_n82381760)
print v(xbgr.mr_n82383600)
print v(xbgr.mr_n82383712)
print v(xbgr.mr_n82383824)
print v(xbgr.mr_n82385664)
print v(xbgr.mr_n82385776)
print v(xbgr.mr_n82385888)
print v(xbgr.mr_n82387728)
print v(xbgr.mr_n82387840)
print v(xbgr.mr_n82387952)
print v(xbgr.mr_n82389792)
print v(xbgr.mr_n82389904)
print v(xbgr.mr_n82390016)
print v(xbgr.mr_n82391856)
print v(xbgr.mr_n82391968)
print v(xbgr.mr_n82392080)
print v(xbgr.mr_n82393920)
print v(xbgr.mr_n82394032)
print v(xbgr.mr_n82394144)
print v(xbgr.mr_n82395984)
print v(xbgr.mr_n82396096)
print v(xbgr.mr_n82396208)
print v(xbgr.mr_n82398048)
print v(xbgr.mr_n82398160)
print v(xbgr.mr_n82398272)
print v(xbgr.mr_n82400112)
print v(xbgr.mr_n82400224)
print v(xbgr.mr_n82400336)
print v(xbgr.mr_n82402176)
print v(xbgr.mr_n82402288)
print v(xbgr.mr_n82402400)
print v(xbgr.mr_n82404240)
print v(xbgr.mr_n82404352)
print v(xbgr.mr_n82404464)
print v(xbgr.mr_n82406304)
print v(xbgr.mr_n82406416)
print v(xbgr.mr_n82406528)
print v(xbgr.mr_n82409072)
print v(xbgr.mr_n82409184)
print v(xbgr.mr_n82409552)
print v(xbgr.mr_n82413056)
print v(xbgr.mr_n82413168)
print v(xbgr.mr_n82413536)
print v(xbgr.mr_n82417040)
print v(xbgr.mr_n82417152)
print v(xbgr.mr_n82417344)
print v(xbgr.mr_n82417520)
print v(xbgr.mr_n82417632)
print v(xbgr.mr_n82421024)
print v(xbgr.mr_n82421136)
print v(xbgr.mr_n82421392)
print v(xbgr.mr_n82421504)
print v(xbgr.mr_n82424096)
print v(xbgr.mr_n82424208)
print v(xbgr.mr_n82425712)
print v(xbgr.mr_n82426432)
print v(xbgr.mr_n82426608)
print v(xbgr.mr_n82428176)
print v(xbgr.mr_n82428992)
print v(xbgr.mr_n82429168)
print v(xbgr.mr_n82429728)
print v(xbgr.mr_n82430736)
print v(xbgr.mr_n82431552)
print v(xbgr.mr_n82431728)
print v(xbgr.mr_n82433296)
print v(xbgr.mr_n82434112)
print v(xbgr.mr_n82434288)
print v(xbgr.mr_n82435856)
print v(xbgr.mr_n82436672)
print v(xbgr.mr_n82436848)
print v(xbgr.mr_n82438416)
print v(xbgr.mr_n82439232)
print v(xbgr.mr_n82439408)
print v(xbgr.mr_n82440976)
print v(xbgr.mr_n82441792)
print v(xbgr.mr_n82441968)
print v(xbgr.mr_n82443536)
print v(xbgr.mr_n82444352)
print v(xbgr.mr_n82444528)
print v(xbgr.mr_n82446096)
print v(xbgr.mr_n82446912)
print v(xbgr.mr_n82447088)
print v(xbgr.mr_n82448656)
print v(xbgr.mr_n82449472)
print v(xbgr.mr_n82449648)
print v(xbgr.mr_n82451216)
print v(xbgr.mr_n82451456)
print v(xbgr.mr_n82452032)
print v(xbgr.mr_n82452208)
print v(xbgr.mr_n82452448)
print v(xbgr.mr_n82452560)
print v(xbgr.mr_n82452672)
print v(xbgr.mr_n82453248)
print v(xbgr.mr_n82453520)
print v(xbgr.mr_n82455040)
print v(xbgr.mr_n82455536)
print v(xbgr.mr_n82455648)
print v(xbgr.mr_n82457152)
print v(xbgr.mr_n82457648)
print v(xbgr.mr_n82457760)
print v(xbgr.mr_n82460416)
print v(xbgr.mr_n82461584)
print v(xbgr.mr_n82461760)
print v(xbgr.mr_n82463328)
print v(xbgr.mr_n82464144)
print v(xbgr.mr_n82464320)
print v(xbgr.mr_n82465888)
print v(xbgr.mr_n82466704)
print v(xbgr.mr_n82466880)
print v(xbgr.mr_n82468448)
print v(xbgr.mr_n82469264)
print v(xbgr.mr_n82469440)
print v(xbgr.mr_n82471008)
print v(xbgr.mr_n82471824)
print v(xbgr.mr_n82472000)
print v(xbgr.mr_n82473568)
print v(xbgr.mr_n82473888)
print v(xbgr.mr_n82474384)
print v(xbgr.mr_n82474560)
print v(xbgr.mr_n82476128)
print v(xbgr.mr_n82476944)
print v(xbgr.mr_n82477120)
print v(xbgr.mr_n82478688)
print v(xbgr.mr_n82479504)
print v(xbgr.mr_n82479680)
print v(xbgr.mr_n82481248)
print v(xbgr.mr_n82482064)
print v(xbgr.mr_n82482240)
print v(xbgr.mr_n82482928)
print v(xbgr.mr_n82483808)
print v(xbgr.mr_n82484624)
print v(xbgr.mr_n82484800)
print v(xbgr.mr_n82486368)
print v(xbgr.mr_n82487184)
print v(xbgr.mr_n82487360)
print v(xbgr.mr_n82488928)
print v(xbgr.mr_n82489744)
print v(xbgr.mr_n82489920)
print v(xbgr.mr_n82490512)
print v(xbgr.mr_n82491488)
print v(xbgr.mr_n82569440)
print v(xbgr.mr_n82570032)
print v(xbgr.mr_n82571056)
print v(xbgr.mr_n82576096)
print v(xbgr.mr_n82579120)
print v(xbgr.mr_n82585392)
print v(xbgr.mr_n82595568)
print v(xbgr.mr_n82598944)
print v(xbgr.mr_n82603792)
print v(xbgr.mr_n82604272)
print v(xbgr.mr_n82607728)
print v(xbgr.mr_n82608592)
print v(xbgr.mr_n82609072)
print v(xbgr.mr_n82609216)
print v(xbgr.mr_n82609920)
print v(xbgr.mr_n82612064)
print v(xbgr.mr_n82710608)
print v(xbgr.mr_n82710720)
print v(xbgr.mr_n82711152)
print v(xbgr.mr_n82711264)
print v(xbgr.mr_n82711696)
print v(xbgr.mr_n82711808)
print v(xbgr.mr_n82712240)
print v(xbgr.mr_n82712352)
print v(xbgr.mr_n82712784)
print v(xbgr.mr_n82712896)
print v(xbgr.mr_n82713328)
print v(xbgr.mr_n82713440)
print v(xbgr.mr_n82713872)
print v(xbgr.mr_n82713984)
print v(xbgr.mr_n82714416)
print v(xbgr.mr_n82714528)
print v(xbgr.mr_n82714960)
print v(xbgr.mr_n82715072)
print v(xbgr.mr_n82715504)
print v(xbgr.mr_n82715616)
print v(xbgr.mr_n82716048)
print v(xbgr.mr_n82716160)
print v(xbgr.mr_n82716592)
print v(xbgr.mr_n82716704)
print v(xbgr.mr_n82717456)
print v(xbgr.mr_n82717568)
print v(xbgr.mr_n82718400)
print v(xbgr.mr_n82718512)
print v(xbgr.mr_n82718784)
print v(xbgr.mr_n82719344)
print v(xbgr.mr_n82719456)
print v(xbgr.mr_n82720288)
print v(xbgr.mr_n82720400)
print v(xbgr.mr_n82720656)
print v(xbgr.mr_n82721232)
print v(xbgr.mr_n82721344)
print v(xbgr.mr_n82722608)
print v(xbgr.mr_n82724096)
print v(xbgr.mr_n82724432)
print v(xbgr.mr_n82725632)
print v(xbgr.mr_n82727760)
print v(xbgr.mr_n82730064)
print v(xbgr.mr_n82731168)
print v(xbgr.mr_n82735488)
print v(xbgr.mr_n82735680)
print v(xbgr.mr_n82738224)
print v(xbgr.mr_n82739840)
print v(xbgr.mr_n82741520)
print v(xbgr.mr_n82743776)
print v(xbgr.mr_n82746032)
print v(xbgr.mr_n82748288)
print v(xbgr.mr_n82750544)
print v(xbgr.mr_n82752800)
print v(xbgr.mr_n82755056)
print v(xbgr.mr_n82757312)
print v(xbgr.mr_n82767728)
print v(xbgr.mr_n82770032)
print v(xbgr.mr_n82775376)
print v(xbgr.mr_n82782368)
print v(xbgr.mr_n82783520)
print v(xbgr.mr_n82783632)
print v(xbgr.mr_n82784256)
print v(xbgr.mr_n82785792)
print v(xbgr.mr_n82786656)
print v(xbgr.mr_n82787616)
print v(xbgr.mr_n82787728)
print v(xbgr.mr_n82788672)
print v(xbgr.mr_n82789824)
print v(xbgr.mr_n82789936)
print v(xbgr.mr_n82790560)
print v(xbgr.mr_n82792096)
print v(xbgr.mr_n82792960)
print v(xbgr.mr_n82793920)
print v(xbgr.mr_n82794032)
print v(xbgr.mr_n82794976)
print v(xbgr.mr_n82796128)
print v(xbgr.mr_n82796240)
print v(xbgr.mr_n82796864)
print v(xbgr.mr_n82798336)
print v(xbgr.mr_n82799200)
print v(xbgr.mr_n82800224)
print v(xbgr.mr_n82800336)
print v(xbgr.mr_n82801280)
print v(xbgr.mr_n82802432)
print v(xbgr.mr_n82802544)
print v(xbgr.mr_n82803168)
print v(xbgr.mr_n82804704)
print v(xbgr.mr_n82805568)
print v(xbgr.mr_n82806528)
print v(xbgr.mr_n82806640)
print v(xbgr.mr_n82807584)
print v(xbgr.mr_n82808736)
print v(xbgr.mr_n82808848)
print v(xbgr.mr_n82809472)
print v(xbgr.mr_n82811008)
print v(xbgr.mr_n82811872)
print v(xbgr.mr_n82812832)
print v(xbgr.mr_n82812944)
print v(xbgr.mr_n82813888)
print v(xbgr.mr_n82815040)
print v(xbgr.mr_n82815152)
print v(xbgr.mr_n82815776)
print v(xbgr.mr_n82817024)
print v(xbgr.mr_n82817952)
print v(xbgr.mr_n82818288)
print v(xbgr.mr_n82820208)
print v(xbgr.mr_n82820768)
print v(xbgr.mr_n82821456)
print v(xbgr.mr_n82822208)
print v(xbgr.mr_n82823152)
print v(xbgr.mr_n82824096)
print v(xbgr.mr_n82825040)
print v(xbgr.mr_n82825984)
print v(xbgr.mr_n82826928)
print v(xbgr.mr_n82827872)
print v(xbgr.mr_n82828816)
print v(xbgr.mr_n82829760)
print v(xbgr.mr_n82830704)
print v(xbgr.mr_n82831648)
print v(xbgr.mr_n82832592)
print v(xbgr.mr_n82833536)
print v(xbgr.mr_n82834480)
print v(xbgr.mr_n82835424)
print v(xbgr.mr_n82836368)
print v(xbgr.mr_n82837312)
print v(xbgr.mr_n82838256)
print v(xbgr.mr_n82839200)
print v(xbgr.mr_n82840144)
print v(xbgr.mr_n82841088)
print v(xbgr.mr_n82842032)
print v(xbgr.mr_n82842976)
print v(xbgr.mr_n82843920)
print v(xbgr.mr_n82844864)
print v(xbgr.mr_n82845808)
print v(xbgr.mr_n82846752)
print v(xbgr.mr_n82847696)
print v(xbgr.mr_n82848640)
print v(xbgr.mr_n82849584)
print v(xbgr.mr_n82850528)
print v(xbgr.mr_n82851472)
print v(xbgr.mr_n82851712)
print v(xbgr.mr_n82852416)
print v(xbgr.mr_n82853360)
print v(xbgr.mr_n82856432)
print v(xbgr.mr_n82857680)
print v(xbgr.mr_n82858160)
print v(xbgr.mr_n82858848)
print v(xbgr.mr_n82858960)
print v(xbgr.mr_n82859088)
print v(xbgr.mr_n82859344)
print v(xbgr.mr_n82860576)
print v(xbgr.mr_n82860688)
print v(xbgr.mr_n82863984)
print v(xbgr.mr_n82864096)
print v(xbgr.mr_n82865248)
print v(xbgr.mr_n82865360)
print v(xbgr.mr_n82866512)
print v(xbgr.mr_n82866624)
print v(xbgr.mr_n82867776)
print v(xbgr.mr_n82867888)
print v(xbgr.mr_n82869040)
print v(xbgr.mr_n82869152)
print v(xbgr.mr_n82870304)
print v(xbgr.mr_n82870416)
print v(xbgr.mr_n82874896)
print v(xbgr.mr_n82883104)
print v(xbgr.mr_n82888448)
print v(xbgr.mr_n82888704)
print v(xbgr.mr_n82888960)
print v(xbgr.mr_n82889216)
print v(xbgr.mr_n82891808)
print v(xbgr.mr_n82891920)
print v(xbgr.mr_n82893072)
print v(xbgr.mr_n82893792)
print v(xbgr.mr_n82894176)
print v(xbgr.mr_n82900160)
print v(xbgr.mr_n82901408)
print v(xbgr.mr_n82901520)
print v(xbgr.mr_n82903520)
print v(xbgr.mr_n82905264)
print v(xbgr.mr_n82905536)
print v(xbgr.mr_n82905728)
print v(xbgr.mr_n82908960)
print v(xbgr.mr_n82909152)
print v(xbgr.mr_n82911984)
print v(xbgr.mr_n82912176)
print v(xbgr.mr_n82912368)
print v(xbgr.mr_n82916912)
print v(xbgr.mr_n82917104)
print v(xbgr.mr_n82920064)
print v(xbgr.mr_n82921328)
print v(xbgr.mr_n82921600)
print v(xbgr.mr_n82921792)
print v(xbgr.mr_n82923616)
print v(xbgr.mr_n82925024)
print v(xbgr.mr_n82925216)
print v(xbgr.mr_n82929360)
print v(xbgr.mr_n82929632)
print v(xbgr.mr_n82929824)
print v(xbgr.mr_n82932656)
print v(xbgr.mr_n82933552)
print v(xbgr.mr_n82934800)
print v(xbgr.mr_n82934912)
print v(xbgr.mr_n82937952)
print v(xbgr.mr_n82938144)
print v(xbgr.mr_n82938336)
print v(xbgr.mr_n82939584)
print v(xbgr.mr_n82939696)
print v(xbgr.mr_n82941312)
print v(xbgr.mr_n82944112)
print v(xbgr.mr_n82945360)
print v(xbgr.mr_n82945472)
print v(xbgr.mr_n82949024)
print v(xbgr.mr_n82949520)
print v(xbgr.mr_n82953840)
print v(xbgr.mr_n82957408)
print v(xbgr.mr_n82958240)
print v(xbgr.mr_n82958352)
print v(xbgr.mr_n82959184)
print v(xbgr.mr_n82959296)
print v(xbgr.mr_n82960128)
print v(xbgr.mr_n82960240)
print v(xbgr.mr_n82961328)
print v(xbgr.mr_n82961440)
print v(xbgr.mr_n82962592)
print v(xbgr.mr_n82962704)
print v(xbgr.mr_n82963856)
print v(xbgr.mr_n82963968)
print v(xbgr.mr_n82965120)
print v(xbgr.mr_n82965232)
print v(xbgr.mr_n82966384)
print v(xbgr.mr_n82966496)
print v(xbgr.mr_n82967648)
print v(xbgr.mr_n82967760)
print v(xbgr.mr_n82968912)
print v(xbgr.mr_n82969024)
print v(xbgr.mr_n82970176)
print v(xbgr.mr_n82970288)
print v(xbgr.mr_n82971440)
print v(xbgr.mr_n82971552)
print v(xbgr.mr_n82972704)
print v(xbgr.mr_n82972816)
print v(xbgr.mr_n82973968)
print v(xbgr.mr_n82974080)
print v(xbgr.mr_n82975232)
print v(xbgr.mr_n82975344)
print v(xbgr.mr_n82975984)
print v(xbgr.mr_n82982752)
print v(xbgr.mr_n82983440)
print v(xbgr.mr_n82984128)
print v(xbgr.mr_n82984848)
print v(xbgr.mr_n82986464)
print v(xbgr.mr_n82987744)
print v(xbgr.mr_n82987856)
print v(xbgr.mr_n82988800)
print v(xbgr.mr_n82989952)
print v(xbgr.mr_n82990064)
print v(xbgr.mr_n82990688)
print v(xbgr.mr_n82992224)
print v(xbgr.mr_n82992768)
print v(xbgr.mr_n82993104)
print v(xbgr.mr_n82994032)
print v(xbgr.mr_n82994304)
print v(xbgr.mr_n82996192)
print v(xbgr.mr_n82997312)
print v(xbgr.mr_n82998656)
print v(xbgr.mr_n82999200)
print v(xbgr.mr_n83000544)
print v(xbgr.mr_n83001088)
print v(xbgr.mr_n83002432)
print v(xbgr.mr_n83002976)
print v(xbgr.mr_n83004320)
print v(xbgr.mr_n83004864)
print v(xbgr.mr_n83006208)
print v(xbgr.mr_n83006752)
print v(xbgr.mr_n83008096)
print v(xbgr.mr_n83008640)
print v(xbgr.mr_n83009920)
print v(xbgr.mr_n83010464)
print v(xbgr.mr_n83011872)
print v(xbgr.mr_n83012736)
print v(xbgr.mr_n83013696)
print v(xbgr.mr_n83013808)
print v(xbgr.mr_n83014752)
print v(xbgr.mr_n83015904)
print v(xbgr.mr_n83016016)
print v(xbgr.mr_n83016960)
print v(xbgr.mr_n83018112)
print v(xbgr.mr_n83018224)
print v(xbgr.mr_n83023648)
print v(xbgr.mr_n83028080)
print v(xbgr.mr_n83028528)
print v(xbgr.mr_n83033664)
print v(xbgr.mr_n83034352)
print v(xbgr.mr_n83035040)
print v(xbgr.mr_n83035760)
print v(xbgr.mr_n83036704)
print v(xbgr.mr_n83036896)
print v(xbgr.mr_n83037088)
print v(xbgr.mr_n83037280)
print v(xbgr.mr_n83037472)
print v(xbgr.mr_n83037664)
print v(xbgr.mr_n83039808)
print v(xbgr.mr_n83039920)
print v(xbgr.mr_n83041936)
print v(xbgr.mr_n83043952)
print v(xbgr.mr_n83044064)
print v(xbgr.mr_n83049712)
print v(xbgr.mr_n83050656)
print v(xbgr.mr_n83051168)
print v(xbgr.mr_n83054240)
print v(xbgr.mr_n83065680)
print v(xbgr.mr_n83066624)
print v(xbgr.mr_n83067568)
print v(xbgr.mr_n83068512)
print v(xbgr.mr_n83069456)
print v(xbgr.mr_n83070400)
print v(xbgr.mr_n83071344)
print v(xbgr.mr_n83072288)
print v(xbgr.mr_n83077264)
print v(xbgr.mr_n83077792)
print v(xbgr.mr_n83078352)
print v(xbgr.mr_n83078864)
print v(xbgr.mr_n83080480)
print v(xbgr.mr_n83080672)
print v(xbgr.mr_n83081504)
print v(xbgr.mr_n83082016)
print v(xbgr.mr_n83083776)
print v(xbgr.mr_n83083968)
print v(xbgr.mr_n83084656)
print v(xbgr.mr_n83085168)
print v(xbgr.mr_n83086624)
print v(xbgr.mr_n83086928)
print v(xbgr.mr_n83087120)
print v(xbgr.mr_n83087808)
print v(xbgr.mr_n83088320)
print v(xbgr.mr_n83090080)
print v(xbgr.mr_n83090272)
print v(xbgr.mr_n83090960)
print v(xbgr.mr_n83091472)
print v(xbgr.mr_n83093232)
print v(xbgr.mr_n83093424)
print v(xbgr.mr_n83094112)
print v(xbgr.mr_n83094624)
print v(xbgr.mr_n83096384)
print v(xbgr.mr_n83096576)
print v(xbgr.mr_n83097264)
print v(xbgr.mr_n83097776)
print v(xbgr.mr_n83099536)
print v(xbgr.mr_n83099728)
print v(xbgr.mr_n83100416)
print v(xbgr.mr_n83100848)
print v(xbgr.mr_n83101680)
print v(xbgr.mr_n83102384)
print v(xbgr.mr_n83102944)
print v(xbgr.mr_n83103520)
print v(xbgr.mr_n83104208)
print v(xbgr.mr_n83104640)
print v(xbgr.mr_n83105472)
print v(xbgr.mr_n83106048)
print v(xbgr.mr_n83106736)
print v(xbgr.mr_n83107168)
print v(xbgr.mr_n83108000)
print v(xbgr.mr_n83108576)
print v(xbgr.mr_n83109264)
print v(xbgr.mr_n83110672)
print v(xbgr.mr_n83111696)
print v(xbgr.mr_n83112384)
print v(xbgr.mr_n83113072)
print v(xbgr.mr_n83114784)
print v(xbgr.mr_n83115376)
print v(xbgr.mr_n83115728)
print v(xbgr.mr_n83115920)
print v(xbgr.mr_n83116608)
print v(xbgr.mr_n83116800)
print v(xbgr.mr_n83117376)
print v(xbgr.mr_n83117488)
print v(xbgr.mr_n83119248)
print v(xbgr.mr_n83120080)
print v(xbgr.mr_n83120352)
print v(xbgr.mr_n83120464)
print v(xbgr.mr_n83121104)
print v(xbgr.mr_n83121216)
print v(xbgr.mr_n83121328)
print v(xbgr.mr_n83121520)
print v(xbgr.mr_n83121712)
print v(xbgr.mr_n83121904)
print v(xbgr.mr_n83124160)
print v(xbgr.mr_n83124432)
print v(xbgr.mr_n83124624)
print v(xbgr.mr_n83125136)
print v(xbgr.mr_n83126624)
print v(xbgr.mr_n83127136)
print v(xbgr.mr_n83128304)
print v(xbgr.mr_n83128416)
print v(xbgr.mr_n83128528)
print v(xbgr.mr_n83129088)
print v(xbgr.mr_n83129584)
print v(xbgr.mr_n83132592)
print v(xbgr.mr_n83132784)
print v(xbgr.mr_n83133296)
print v(xbgr.mr_n83135776)
print v(xbgr.mr_n83137648)
print v(xbgr.mr_n83137840)
print v(xbgr.mr_n83138352)
print v(xbgr.mr_n83139968)
print v(xbgr.mr_n83140160)
print v(xbgr.mr_n83142288)
print v(xbgr.mr_n83142560)
print v(xbgr.mr_n83142752)
print v(xbgr.mr_n83143264)
print v(xbgr.mr_n83145200)
print v(xbgr.mr_n83145712)
print v(xbgr.mr_n83148448)
print v(xbgr.mr_n83148720)
print v(xbgr.mr_n83148912)
print v(xbgr.mr_n83149424)
print v(xbgr.mr_n83151040)
print v(xbgr.mr_n83151232)
print v(xbgr.mr_n83153424)
print v(xbgr.mr_n83153696)
print v(xbgr.mr_n83153888)
print v(xbgr.mr_n83154400)
print v(xbgr.mr_n83155296)
print v(xbgr.mr_n83156336)
print v(xbgr.mr_n83156848)
print v(xbgr.mr_n83159584)
print v(xbgr.mr_n83159856)
print v(xbgr.mr_n83160048)
print v(xbgr.mr_n83160560)
print v(xbgr.mr_n83162176)
print v(xbgr.mr_n83162368)
print v(xbgr.mr_n83164560)
print v(xbgr.mr_n83164832)
print v(xbgr.mr_n83165024)
print v(xbgr.mr_n83165536)
print v(xbgr.mr_n83167536)
print v(xbgr.mr_n83168048)
print v(xbgr.mr_n83170720)
print v(xbgr.mr_n83170992)
print v(xbgr.mr_n83171184)
print v(xbgr.mr_n83171696)
print v(xbgr.mr_n83175408)
print v(xbgr.mr_n83176560)
print v(xbgr.mr_n83176672)
print v(xbgr.mr_n83177824)
print v(xbgr.mr_n83177936)
print v(xbgr.mr_n83179088)
print v(xbgr.mr_n83179200)
print v(xbgr.mr_n83180352)
print v(xbgr.mr_n83180464)
print v(xbgr.mr_n83181616)
print v(xbgr.mr_n83181728)
print v(xbgr.mr_n83182880)
print v(xbgr.mr_n83182992)
print v(xbgr.mr_n83184144)
print v(xbgr.mr_n83184256)
print v(xbgr.mr_n83185408)
print v(xbgr.mr_n83185520)
print v(xbgr.mr_n83186672)
print v(xbgr.mr_n83186784)
print v(xbgr.mr_n83187936)
print v(xbgr.mr_n83188048)
print v(xbgr.mr_n83189200)
print v(xbgr.mr_n83189312)
print v(xbgr.mr_n83190464)
print v(xbgr.mr_n83190576)
print v(xbgr.mr_n83191728)
print v(xbgr.mr_n83191840)
print v(xbgr.mr_n83192992)
print v(xbgr.mr_n83193104)
print v(xbgr.mr_n83194256)
print v(xbgr.mr_n83194368)
print v(xbgr.mr_n83196480)
print v(xbgr.mr_n83202128)
print v(xbgr.mr_n83202464)
print v(xbgr.mr_n83207104)
print v(xbgr.mr_n83208464)
print v(xbgr.mr_n83209728)
print v(xbgr.mr_n83212112)
print v(xbgr.mr_n83218784)
print v(xbgr.mr_n83228048)
print v(xbgr.mr_n83228736)
print v(xbgr.mr_n83229488)
print v(xbgr.mr_n83230432)
print v(xbgr.mr_n83232336)
print v(xbgr.mr_n83233744)
print v(xbgr.mr_n83236720)
print v(xbgr.mr_n83237248)
print v(xbgr.mr_n83237808)
print v(xbgr.mr_n83237920)
print v(xbgr.mr_n83238032)
print v(xbgr.mr_n83238144)
print v(xbgr.mr_n83238256)
print v(xbgr.mr_n83240000)
print v(xbgr.mr_n83240272)
print v(xbgr.mr_n83240464)
print v(xbgr.mr_n83240976)
print v(xbgr.mr_n83242912)
print v(xbgr.mr_n83244656)
print v(xbgr.mr_n83244848)
print v(xbgr.mr_n83245040)
print v(xbgr.mr_n83245632)
print v(xbgr.mr_n83247568)
print v(xbgr.mr_n83249312)
print v(xbgr.mr_n83249584)
print v(xbgr.mr_n83249776)
print v(xbgr.mr_n83250288)
print v(xbgr.mr_n83251520)
print v(xbgr.mr_n83252032)
print v(xbgr.mr_n83254000)
print v(xbgr.mr_n83255472)
print v(xbgr.mr_n83255744)
print v(xbgr.mr_n83255936)
print v(xbgr.mr_n83256448)
print v(xbgr.mr_n83260048)
print v(xbgr.mr_n83260448)
print v(xbgr.mr_n83260720)
print v(xbgr.mr_n83260912)
print v(xbgr.mr_n83261424)
print v(xbgr.mr_n83262304)
print v(xbgr.mr_n83262720)
print v(xbgr.mr_n83263232)
print v(xbgr.mr_n83263984)
print v(xbgr.mr_n83267152)
print v(xbgr.mr_n83267984)
print v(xbgr.mr_n83268096)
print v(xbgr.mr_n83268288)
print v(xbgr.mr_n83268480)
print v(xbgr.mr_n83268672)
print v(xbgr.mr_n83268864)
print v(xbgr.mr_n83269056)
print v(xbgr.mr_n83269248)
print v(xbgr.mr_n83269824)
print v(xbgr.mr_n83271472)
print v(xbgr.mr_n83272384)
print v(xbgr.mr_n83272896)
print v(xbgr.mr_n83274896)
print v(xbgr.mr_n83276704)
print v(xbgr.mr_n83276896)
print v(xbgr.mr_n83277408)
print v(xbgr.mr_n83279488)
print v(xbgr.mr_n83279680)
print v(xbgr.mr_n83279872)
print v(xbgr.mr_n83281680)
print v(xbgr.mr_n83281872)
print v(xbgr.mr_n83282384)
print v(xbgr.mr_n83282640)
print v(xbgr.mr_n83283552)
print v(xbgr.mr_n83284064)
print v(xbgr.mr_n83287504)
print v(xbgr.mr_n83287776)
print v(xbgr.mr_n83287968)
print v(xbgr.mr_n83288480)
print v(xbgr.mr_n83290624)
print v(xbgr.mr_n83290816)
print v(xbgr.mr_n83291008)
print v(xbgr.mr_n83292816)
print v(xbgr.mr_n83293008)
print v(xbgr.mr_n83293520)
print v(xbgr.mr_n83293760)
print v(xbgr.mr_n83294688)
print v(xbgr.mr_n83295200)
print v(xbgr.mr_n83298640)
print v(xbgr.mr_n83298912)
print v(xbgr.mr_n83299104)
print v(xbgr.mr_n83299616)
print v(xbgr.mr_n83301680)
print v(xbgr.mr_n83301792)
print v(xbgr.mr_n83302304)
print v(xbgr.mr_n83302416)
print v(xbgr.mr_n83302928)
print v(xbgr.mr_n83303040)
print v(xbgr.mr_n83303808)
print v(xbgr.mr_n83303920)
print v(xbgr.mr_n83304752)
print v(xbgr.mr_n83304864)
print v(xbgr.mr_n83305696)
print v(xbgr.mr_n83305808)
print v(xbgr.mr_n83306640)
print v(xbgr.mr_n83306752)
print v(xbgr.mr_n83307584)
print v(xbgr.mr_n83307696)
print v(xbgr.mr_n83308592)
print v(xbgr.mr_n83308704)
print v(xbgr.mr_n83309856)
print v(xbgr.mr_n83309968)
print v(xbgr.mr_n83311120)
print v(xbgr.mr_n83311232)
print v(xbgr.mr_n83312384)
print v(xbgr.mr_n83312496)
print v(xbgr.mr_n83313648)
print v(xbgr.mr_n83313760)
print v(xbgr.mr_n83314912)
print v(xbgr.mr_n83315024)
print v(xbgr.mr_n83316176)
print v(xbgr.mr_n83316288)
print v(xbgr.mr_n83318672)
print v(xbgr.mr_n83322192)
print v(xbgr.mr_n83325248)
print v(xbgr.mr_n83328064)
print v(xbgr.mr_n83328176)
print v(xbgr.mr_n83329328)
print v(xbgr.mr_n83329440)
print v(xbgr.mr_n83330592)
print v(xbgr.mr_n83330704)
print v(xbgr.mr_n83331856)
print v(xbgr.mr_n83331968)
print v(xbgr.mr_n83333120)
print v(xbgr.mr_n83333232)
print v(xbgr.mr_n83334384)
print v(xbgr.mr_n83334496)
print v(xbgr.mr_n83335648)
print v(xbgr.mr_n83335760)
print v(xbgr.mr_n83336912)
print v(xbgr.mr_n83337024)
print v(xbgr.mr_n83338176)
print v(xbgr.mr_n83338288)
print v(xbgr.mr_n83339440)
print v(xbgr.mr_n83339552)
print v(xbgr.mr_n83340704)
print v(xbgr.mr_n83340816)
print v(xbgr.mr_n83341968)
print v(xbgr.mr_n83342080)
print v(xbgr.mr_n83343232)
print v(xbgr.mr_n83343344)
print v(xbgr.mr_n83344496)
print v(xbgr.mr_n83344608)
print v(xbgr.mr_n83345760)
print v(xbgr.mr_n83345872)
print v(xbgr.mr_n83347024)
print v(xbgr.mr_n83347136)
print v(xbgr.mr_n83348288)
print v(xbgr.mr_n83348400)
print v(xbgr.mr_n83351968)
print v(xbgr.mr_n83353760)
print v(xbgr.mr_n83355680)
print v(xbgr.mr_n83364448)
print v(xbgr.mr_n83365504)
print v(xbgr.mr_n83368784)
print v(xbgr.mr_n83373472)
print v(xbgr.mr_n83374992)
print v(xbgr.mr_n83375232)
print v(xbgr.mr_n83375344)
print v(xbgr.mr_n83375872)
print v(xbgr.mr_n83378160)
print v(xbgr.mr_n83378512)
print v(xbgr.mr_n83381040)
print v(xbgr.mr_n83381568)
print v(xbgr.mr_n83381776)
print v(xbgr.mr_n83382448)
print v(xbgr.mr_n83382736)
print v(xbgr.mr_n83384144)
print v(xbgr.mr_n83384320)
print v(xbgr.mr_n83386432)
print v(xbgr.mr_n83386784)
print v(xbgr.mr_n83386960)
print v(xbgr.mr_n83387312)
print v(xbgr.mr_n83388080)
print v(xbgr.mr_n83388192)
print v(xbgr.mr_n83389952)
print v(xbgr.mr_n83390368)
print v(xbgr.mr_n83391200)
print v(xbgr.mr_n83391440)
print v(xbgr.mr_n83392032)
print v(xbgr.mr_n83392144)
print v(xbgr.mr_n83395184)
print v(xbgr.mr_n83395872)
print v(xbgr.mr_n83396560)
print v(xbgr.mr_n83399008)
print v(xbgr.mr_n83402320)
print v(xbgr.mr_n83402512)
print v(xbgr.mr_n83403344)
print v(xbgr.mr_n83403456)
print v(xbgr.mr_n83403568)
print v(xbgr.mr_n83403680)
print v(xbgr.mr_n83403792)
print v(xbgr.mr_n83405536)
print v(xbgr.mr_n83405728)
print v(xbgr.mr_n83405920)
print v(xbgr.mr_n83406512)
print v(xbgr.mr_n83408640)
print v(xbgr.mr_n83410384)
print v(xbgr.mr_n83410656)
print v(xbgr.mr_n83410848)
print v(xbgr.mr_n83411360)
print v(xbgr.mr_n83413296)
print v(xbgr.mr_n83415040)
print v(xbgr.mr_n83415312)
print v(xbgr.mr_n83415504)
print v(xbgr.mr_n83416016)
print v(xbgr.mr_n83417952)
print v(xbgr.mr_n83419696)
print v(xbgr.mr_n83419968)
print v(xbgr.mr_n83420160)
print v(xbgr.mr_n83420672)
print v(xbgr.mr_n83422608)
print v(xbgr.mr_n83424352)
print v(xbgr.mr_n83424624)
print v(xbgr.mr_n83424816)
print v(xbgr.mr_n83425328)
print v(xbgr.mr_n83427264)
print v(xbgr.mr_n83429008)
print v(xbgr.mr_n83429280)
print v(xbgr.mr_n83429472)
print v(xbgr.mr_n83429984)
print v(xbgr.mr_n83431920)
print v(xbgr.mr_n83433664)
print v(xbgr.mr_n83433936)
print v(xbgr.mr_n83434128)
print v(xbgr.mr_n83434640)
print v(xbgr.mr_n83436576)
print v(xbgr.mr_n83438320)
print v(xbgr.mr_n83438592)
print v(xbgr.mr_n83438784)
print v(xbgr.mr_n83439296)
print v(xbgr.mr_n83441232)
print v(xbgr.mr_n83442976)
print v(xbgr.mr_n83443168)
print v(xbgr.mr_n83443360)
print v(xbgr.mr_n83443952)
print v(xbgr.mr_n83445888)
print v(xbgr.mr_n83447632)
print v(xbgr.mr_n83447824)
print v(xbgr.mr_n83448016)
print v(xbgr.mr_n83448608)
print v(xbgr.mr_n83450544)
print v(xbgr.mr_n83452288)
print v(xbgr.mr_n83452560)
print v(xbgr.mr_n83452752)
print v(xbgr.mr_n83453264)
print v(xbgr.mr_n83455200)
print v(xbgr.mr_n83455392)
print v(xbgr.mr_n83456944)
print v(xbgr.mr_n83457216)
print v(xbgr.mr_n83457408)
print v(xbgr.mr_n83457920)
print v(xbgr.mr_n83459936)
print v(xbgr.mr_n83460128)
print v(xbgr.mr_n83461936)
print v(xbgr.mr_n83462128)
print v(xbgr.mr_n83462640)
print v(xbgr.mr_n83464512)
print v(xbgr.mr_n83466256)
print v(xbgr.mr_n83466528)
print v(xbgr.mr_n83466720)
print v(xbgr.mr_n83467232)
print v(xbgr.mr_n83469168)
print v(xbgr.mr_n83469504)
print v(xbgr.mr_n83470912)
print v(xbgr.mr_n83471184)
print v(xbgr.mr_n83471376)
print v(xbgr.mr_n83471888)
print v(xbgr.mr_n83473824)
print v(xbgr.mr_n83475568)
print v(xbgr.mr_n83475840)
print v(xbgr.mr_n83476032)
print v(xbgr.mr_n83476544)
print v(xbgr.mr_n83478560)
print v(xbgr.mr_n83478752)
print v(xbgr.mr_n83480560)
print v(xbgr.mr_n83480752)
print v(xbgr.mr_n83481264)
print v(xbgr.mr_n83484032)
print v(xbgr.mr_n83484816)
print v(xbgr.mr_n83486464)
print v(xbgr.mr_n83486800)
print v(xbgr.mr_n83489008)
print v(xbgr.mr_n83490608)
print v(xbgr.mr_n83491040)
print v(xbgr.mr_n83491472)
print v(xbgr.mr_n83492896)
print v(xbgr.mr_n83493472)
print v(xbgr.mr_n83493584)
print v(xbgr.mr_n83494528)
print v(xbgr.mr_n83495424)
print v(xbgr.mr_n83495536)
print v(xbgr.mr_n83496480)
print v(xbgr.mr_n83497568)
print v(xbgr.mr_n83497680)
print v(xbgr.mr_n83498624)
print v(xbgr.mr_n83499840)
print v(xbgr.mr_n83499952)
print v(xbgr.mr_n83500896)
print v(xbgr.mr_n83502048)
print v(xbgr.mr_n83502160)
print v(xbgr.mr_n83503104)
print v(xbgr.mr_n83504256)
print v(xbgr.mr_n83504368)
print v(xbgr.mr_n83505312)
print v(xbgr.mr_n83506400)
print v(xbgr.mr_n83506512)
print v(xbgr.mr_n83507456)
print v(xbgr.mr_n83508672)
print v(xbgr.mr_n83508784)
print v(xbgr.mr_n83509728)
print v(xbgr.mr_n83510816)
print v(xbgr.mr_n83510928)
print v(xbgr.mr_n83511872)
print v(xbgr.mr_n83513024)
print v(xbgr.mr_n83513136)
print v(xbgr.mr_n83514080)
print v(xbgr.mr_n83515296)
print v(xbgr.mr_n83515408)
print v(xbgr.mr_n83516352)
print v(xbgr.mr_n83517504)
print v(xbgr.mr_n83517616)
print v(xbgr.mr_n83518560)
print v(xbgr.mr_n83519712)
print v(xbgr.mr_n83519824)
print v(xbgr.mr_n83520768)
print v(xbgr.mr_n83521920)
print v(xbgr.mr_n83522032)
print v(xbgr.mr_n83522976)
print v(xbgr.mr_n83524128)
print v(xbgr.mr_n83524240)
print v(xbgr.mr_n83525392)
print v(xbgr.mr_n83525504)
print v(xbgr.mr_n83526656)
print v(xbgr.mr_n83526768)
print v(xbgr.mr_n83531760)
print v(xbgr.mr_n83531872)
print v(xbgr.mr_n83533024)
print v(xbgr.mr_n83533136)
print v(xbgr.mr_n83534064)
print v(xbgr.mr_n83535936)
print v(xbgr.mr_n83537600)
print v(xbgr.mr_n83537712)
print v(xbgr.mr_n83540176)
print v(xbgr.mr_n83540288)
print v(xbgr.mr_n83541440)
print v(xbgr.mr_n83541552)
print v(xbgr.mr_n83542704)
print v(xbgr.mr_n83542816)
print v(xbgr.mr_n83543696)
print v(xbgr.mr_n83553936)
print v(xbgr.mr_n83563888)
print v(xbgr.mr_n83565104)
print v(xbgr.mr_n83568800)
print v(xbgr.mr_n83572656)
print v(xbgr.mr_n83572848)
print v(xbgr.mr_n83573040)
print v(xbgr.mr_n83573232)
print v(xbgr.mr_n83575552)
print v(xbgr.mr_n83575824)
print v(xbgr.mr_n83576016)
print v(xbgr.mr_n83576528)
print v(xbgr.mr_n83580672)
print v(xbgr.mr_n83582208)
print v(xbgr.mr_n83582400)
print v(xbgr.mr_n83582592)
print v(xbgr.mr_n83583184)
print v(xbgr.mr_n83585408)
print v(xbgr.mr_n83585600)
print v(xbgr.mr_n83585792)
print v(xbgr.mr_n83585984)
print v(xbgr.mr_n83586176)
print v(xbgr.mr_n83588416)
print v(xbgr.mr_n83589392)
print v(xbgr.mr_n83589904)
print v(xbgr.mr_n83593344)
print v(xbgr.mr_n83593616)
print v(xbgr.mr_n83593808)
print v(xbgr.mr_n83594320)
print v(xbgr.mr_n83596624)
print v(xbgr.mr_n83596816)
print v(xbgr.mr_n83597008)
print v(xbgr.mr_n83597200)
print v(xbgr.mr_n83597392)
print v(xbgr.mr_n83599616)
print v(xbgr.mr_n83600592)
print v(xbgr.mr_n83601104)
print v(xbgr.mr_n83604480)
print v(xbgr.mr_n83604752)
print v(xbgr.mr_n83604944)
print v(xbgr.mr_n83605456)
print v(xbgr.mr_n83607600)
print v(xbgr.mr_n83607792)
print v(xbgr.mr_n83607984)
print v(xbgr.mr_n83609792)
print v(xbgr.mr_n83609984)
print v(xbgr.mr_n83610496)
print v(xbgr.mr_n83611664)
print v(xbgr.mr_n83612176)
print v(xbgr.mr_n83615616)
print v(xbgr.mr_n83615888)
print v(xbgr.mr_n83616080)
print v(xbgr.mr_n83616592)
print v(xbgr.mr_n83618736)
print v(xbgr.mr_n83618928)
print v(xbgr.mr_n83619120)
print v(xbgr.mr_n83620928)
print v(xbgr.mr_n83621120)
print v(xbgr.mr_n83621632)
print v(xbgr.mr_n83622800)
print v(xbgr.mr_n83623312)
print v(xbgr.mr_n83626752)
print v(xbgr.mr_n83627024)
print v(xbgr.mr_n83627216)
print v(xbgr.mr_n83627728)
print v(xbgr.mr_n83629872)
print v(xbgr.mr_n83629984)
print v(xbgr.mr_n83631728)
print v(xbgr.mr_n83632000)
print v(xbgr.mr_n83632192)
print v(xbgr.mr_n83632704)
print v(xbgr.mr_n83633936)
print v(xbgr.mr_n83634448)
print v(xbgr.mr_n83636416)
print v(xbgr.mr_n83638224)
print v(xbgr.mr_n83638416)
print v(xbgr.mr_n83638928)
print v(xbgr.mr_n83644064)
print v(xbgr.mr_n83644176)
print v(xbgr.mr_n83644944)
print v(xbgr.mr_n83645056)
print v(xbgr.mr_n83645952)
print v(xbgr.mr_n83646064)
print v(xbgr.mr_n83647152)
print v(xbgr.mr_n83647264)
print v(xbgr.mr_n83648416)
print v(xbgr.mr_n83648528)
print v(xbgr.mr_n83649616)
print v(xbgr.mr_n83649728)
print v(xbgr.mr_n83650944)
print v(xbgr.mr_n83651056)
print v(xbgr.mr_n83652208)
print v(xbgr.mr_n83652320)
print v(xbgr.mr_n83653472)
print v(xbgr.mr_n83653584)
print v(xbgr.mr_n83654672)
print v(xbgr.mr_n83654784)
print v(xbgr.mr_n83656000)
print v(xbgr.mr_n83656112)
print v(xbgr.mr_n83657264)
print v(xbgr.mr_n83657376)
print v(xbgr.mr_n83658528)
print v(xbgr.mr_n83658640)
print v(xbgr.mr_n83659728)
print v(xbgr.mr_n83659840)
print v(xbgr.mr_n83661056)
print v(xbgr.mr_n83661168)
print v(xbgr.mr_n83661664)
print v(xbgr.mr_n83669152)
print v(xbgr.mr_n83671136)
print v(xbgr.mr_n83671824)
print v(xbgr.mr_n83672512)
print v(xbgr.mr_n83673616)
print v(xbgr.mr_n83675264)
print v(xbgr.mr_n83676208)
print v(xbgr.mr_n83677152)
print v(xbgr.mr_n83678096)
print v(xbgr.mr_n83679040)
print v(xbgr.mr_n83679984)
print v(xbgr.mr_n83680928)
print v(xbgr.mr_n83683344)
print v(xbgr.mr_n83683680)
print v(xbgr.mr_n83685888)
print v(xbgr.mr_n83687456)
print v(xbgr.mr_n83689024)
print v(xbgr.mr_n83690592)
print v(xbgr.mr_n83692160)
print v(xbgr.mr_n83693728)
print v(xbgr.mr_n83695296)
print v(xbgr.mr_n83696864)
print v(xbgr.mr_n83698784)
print v(xbgr.mr_n83701344)
print v(xbgr.mr_n83702032)
print v(xbgr.mr_n83702720)
print v(xbgr.mr_n83703472)
print v(xbgr.mr_n83705088)
print v(xbgr.mr_n83706368)
print v(xbgr.mr_n83706480)
print v(xbgr.mr_n83707424)
print v(xbgr.mr_n83707744)
print v(xbgr.mr_n83708576)
print v(xbgr.mr_n83708688)
print v(xbgr.mr_n83709632)
print v(xbgr.mr_n83710784)
print v(xbgr.mr_n83710896)
print v(xbgr.mr_n83711840)
print v(xbgr.mr_n83712928)
print v(xbgr.mr_n83713040)
print v(xbgr.mr_n83713984)
print v(xbgr.mr_n83715200)
print v(xbgr.mr_n83715312)
print v(xbgr.mr_n83716256)
print v(xbgr.mr_n83717408)
print v(xbgr.mr_n83717520)
print v(xbgr.mr_n83718464)
print v(xbgr.mr_n83719616)
print v(xbgr.mr_n83719728)
print v(xbgr.mr_n83720672)
print v(xbgr.mr_n83720848)
print v(xbgr.mr_n83721824)
print v(xbgr.mr_n83721936)
print v(xbgr.mr_n83722880)
print v(xbgr.mr_n83724032)
print v(xbgr.mr_n83724144)
print v(xbgr.mr_n83725088)
print v(xbgr.mr_n83726240)
print v(xbgr.mr_n83726352)
print v(xbgr.mr_n83727296)
print v(xbgr.mr_n83727472)
print v(xbgr.mr_n83728448)
print v(xbgr.mr_n83728560)
print v(xbgr.mr_n83729504)
print v(xbgr.mr_n83730656)
print v(xbgr.mr_n83730768)
print v(xbgr.mr_n83731712)
print v(xbgr.mr_n83732864)
print v(xbgr.mr_n83732976)
print v(xbgr.mr_n83733920)
print v(xbgr.mr_n83735072)
print v(xbgr.mr_n83735184)
print v(xbgr.mr_n83736128)
print v(xbgr.mr_n83737280)
print v(xbgr.mr_n83737392)
print v(xbgr.mr_n83738336)
print v(xbgr.mr_n83739488)
print v(xbgr.mr_n83739600)
print v(xbgr.mr_n83740544)
print v(xbgr.mr_n83741696)
print v(xbgr.mr_n83741808)
print v(xbgr.mr_n83742688)
print v(xbgr.mr_n83743376)
print v(xbgr.mr_n83744064)
print v(xbgr.mr_n83744784)
print v(xbgr.mr_n83745728)
print v(xbgr.mr_n83746672)
print v(xbgr.mr_n83747616)
print v(xbgr.mr_n83748560)
print v(xbgr.mr_n83749504)
print v(xbgr.mr_n83750448)
print v(xbgr.mr_n83751392)
print v(xbgr.mr_n83752560)
print v(xbgr.mr_n83754656)
print v(xbgr.mr_n83761248)
print v(xbgr.mr_n83762000)
print v(xbgr.mr_n83765792)
print v(xbgr.mr_n83771408)
print v(xbgr.mr_n83774512)
print v(xbgr.mr_n83775584)
print v(xbgr.mr_n83775776)
print v(xbgr.mr_n83775968)
print v(xbgr.mr_n83776160)
print v(xbgr.mr_n83778480)
print v(xbgr.mr_n83778752)
print v(xbgr.mr_n83778944)
print v(xbgr.mr_n83779456)
print v(xbgr.mr_n83782000)
print v(xbgr.mr_n83784176)
print v(xbgr.mr_n83784448)
print v(xbgr.mr_n83784640)
print v(xbgr.mr_n83785152)
print v(xbgr.mr_n83787296)
print v(xbgr.mr_n83787408)
print v(xbgr.mr_n83789424)
print v(xbgr.mr_n83789616)
print v(xbgr.mr_n83790128)
print v(xbgr.mr_n83791360)
print v(xbgr.mr_n83791872)
print v(xbgr.mr_n83795312)
print v(xbgr.mr_n83795584)
print v(xbgr.mr_n83795776)
print v(xbgr.mr_n83796288)
print v(xbgr.mr_n83800288)
print v(xbgr.mr_n83800560)
print v(xbgr.mr_n83800752)
print v(xbgr.mr_n83801264)
print v(xbgr.mr_n83801568)
print v(xbgr.mr_n83802496)
print v(xbgr.mr_n83803008)
print v(xbgr.mr_n83804640)
print v(xbgr.mr_n83805328)
print v(xbgr.mr_n83805520)
print v(xbgr.mr_n83805712)
print v(xbgr.mr_n83805904)
print v(xbgr.mr_n83806096)
print v(xbgr.mr_n83807840)
print v(xbgr.mr_n83808112)
print v(xbgr.mr_n83808304)
print v(xbgr.mr_n83808976)
print v(xbgr.mr_n83811728)
print v(xbgr.mr_n83812320)
print v(xbgr.mr_n83816144)
print v(xbgr.mr_n83816416)
print v(xbgr.mr_n83816608)
print v(xbgr.mr_n83817120)
print v(xbgr.mr_n83819264)
print v(xbgr.mr_n83819376)
print v(xbgr.mr_n83821120)
print v(xbgr.mr_n83821392)
print v(xbgr.mr_n83821584)
print v(xbgr.mr_n83822096)
print v(xbgr.mr_n83823328)
print v(xbgr.mr_n83823840)
print v(xbgr.mr_n83827280)
print v(xbgr.mr_n83827552)
print v(xbgr.mr_n83827744)
print v(xbgr.mr_n83828256)
print v(xbgr.mr_n83830400)
print v(xbgr.mr_n83830512)
print v(xbgr.mr_n83832256)
print v(xbgr.mr_n83832528)
print v(xbgr.mr_n83832720)
print v(xbgr.mr_n83833232)
print v(xbgr.mr_n83834464)
print v(xbgr.mr_n83834976)
print v(xbgr.mr_n83838416)
print v(xbgr.mr_n83838688)
print v(xbgr.mr_n83838880)
print v(xbgr.mr_n83839392)
print v(xbgr.mr_n83844336)
print v(xbgr.mr_n83844448)
print v(xbgr.mr_n83845280)
print v(xbgr.mr_n83845392)
print v(xbgr.mr_n83846224)
print v(xbgr.mr_n83846336)
print v(xbgr.mr_n83847424)
print v(xbgr.mr_n83847536)
print v(xbgr.mr_n83848688)
print v(xbgr.mr_n83848800)
print v(xbgr.mr_n83849952)
print v(xbgr.mr_n83850064)
print v(xbgr.mr_n83851216)
print v(xbgr.mr_n83851328)
print v(xbgr.mr_n83852480)
print v(xbgr.mr_n83852592)
print v(xbgr.mr_n83853744)
print v(xbgr.mr_n83853856)
print v(xbgr.mr_n83855008)
print v(xbgr.mr_n83855120)
print v(xbgr.mr_n83856272)
print v(xbgr.mr_n83856384)
print v(xbgr.mr_n83857472)
print v(xbgr.mr_n83857584)
print v(xbgr.mr_n83858800)
print v(xbgr.mr_n83858912)
print v(xbgr.mr_n83860064)
print v(xbgr.mr_n83860176)
print v(xbgr.mr_n83861328)
print v(xbgr.mr_n83861440)
print v(xbgr.mr_n83862976)
print v(xbgr.mr_n83863088)
print v(xbgr.mr_n83864240)
print v(xbgr.mr_n83864352)
print v(xbgr.mr_n83865504)
print v(xbgr.mr_n83865616)
print v(xbgr.mr_n83866768)
print v(xbgr.mr_n83866880)
print v(xbgr.mr_n83868032)
print v(xbgr.mr_n83868144)
print v(xbgr.mr_n83869296)
print v(xbgr.mr_n83869408)
print v(xbgr.mr_n83870560)
print v(xbgr.mr_n83870672)
print v(xbgr.mr_n83871824)
print v(xbgr.mr_n83871936)
print v(xbgr.mr_n83873024)
print v(xbgr.mr_n83873136)
print v(xbgr.mr_n83874352)
print v(xbgr.mr_n83874464)
print v(xbgr.mr_n83875616)
print v(xbgr.mr_n83875728)
print v(xbgr.mr_n83876880)
print v(xbgr.mr_n83876992)
print v(xbgr.mr_n83878144)
print v(xbgr.mr_n83878256)
print v(xbgr.mr_n83879408)
print v(xbgr.mr_n83879520)
print v(xbgr.mr_n83880672)
print v(xbgr.mr_n83880784)
print v(xbgr.mr_n83881936)
print v(xbgr.mr_n83882048)
print v(xbgr.mr_n83883200)
print v(xbgr.mr_n83883312)
print v(xbgr.mr_n83884768)
print v(xbgr.mr_n83885152)
print v(xbgr.mr_n83889792)
print v(xbgr.mr_n83891104)
print v(xbgr.mr_n83897440)
print v(xbgr.mr_n83898464)
print v(xbgr.mr_n83899184)
print v(xbgr.mr_n83900064)
print v(xbgr.mr_n83909088)
print v(xbgr.mr_n83914464)
print v(xbgr.mr_n83920480)
print v(xbgr.mr_n83921168)
print v(xbgr.mr_n83921856)
print v(xbgr.mr_n83922576)
print v(xbgr.mr_n83923520)
print v(xbgr.mr_n83924464)
print v(xbgr.mr_n83925408)
print v(xbgr.mr_n83926352)
print v(xbgr.mr_n83927296)
print v(xbgr.mr_n83928240)
print v(xbgr.mr_n83929184)
print v(xbgr.mr_n83930128)
print v(xbgr.mr_n83931072)
print v(xbgr.mr_n83932016)
print v(xbgr.mr_n83932960)
print v(xbgr.mr_n83933904)
print v(xbgr.mr_n83934848)
print v(xbgr.mr_n83935792)
print v(xbgr.mr_n83936736)
print v(xbgr.mr_n83937488)
print v(xbgr.mr_n83939344)
print v(xbgr.mr_n83941680)
print v(xbgr.mr_n83950528)
print v(xbgr.mr_n83950640)
print v(xbgr.mr_n83951472)
print v(xbgr.mr_n83951584)
print v(xbgr.mr_n83951696)
print v(xbgr.mr_n83951808)
print v(xbgr.mr_n83951920)
print v(xbgr.mr_n83953664)
print v(xbgr.mr_n83953936)
print v(xbgr.mr_n83954128)
print v(xbgr.mr_n83954640)
print v(xbgr.mr_n83955104)
print v(xbgr.mr_n83957232)
print v(xbgr.mr_n83957504)
print v(xbgr.mr_n83957696)
print v(xbgr.mr_n83958208)
print v(xbgr.mr_n83961696)
print v(xbgr.mr_n83961968)
print v(xbgr.mr_n83962160)
print v(xbgr.mr_n83962672)
print v(xbgr.mr_n83964224)
print v(xbgr.mr_n83966480)
print v(xbgr.mr_n83966752)
print v(xbgr.mr_n83966944)
print v(xbgr.mr_n83967456)
print v(xbgr.mr_n83970944)
print v(xbgr.mr_n83971216)
print v(xbgr.mr_n83971408)
print v(xbgr.mr_n83971920)
print v(xbgr.mr_n83973472)
print v(xbgr.mr_n83975728)
print v(xbgr.mr_n83976000)
print v(xbgr.mr_n83976192)
print v(xbgr.mr_n83976704)
print v(xbgr.mr_n83980192)
print v(xbgr.mr_n83980464)
print v(xbgr.mr_n83980656)
print v(xbgr.mr_n83981168)
print v(xbgr.mr_n83982800)
print v(xbgr.mr_n83982992)
print v(xbgr.mr_n83985312)
print v(xbgr.mr_n83985504)
print v(xbgr.mr_n83986016)
print v(xbgr.mr_n83989440)
print v(xbgr.mr_n83989712)
print v(xbgr.mr_n83989904)
print v(xbgr.mr_n83990416)
print v(xbgr.mr_n83991968)
print v(xbgr.mr_n83994224)
print v(xbgr.mr_n83994496)
print v(xbgr.mr_n83994688)
print v(xbgr.mr_n83995200)
print v(xbgr.mr_n83998688)
print v(xbgr.mr_n83998960)
print v(xbgr.mr_n83999152)
print v(xbgr.mr_n83999664)
print v(xbgr.mr_n84001120)
print v(xbgr.mr_n84002528)
print v(xbgr.mr_n84002800)
print v(xbgr.mr_n84002992)
print v(xbgr.mr_n84003504)
print v(xbgr.mr_n84006368)
print v(xbgr.mr_n84006640)
print v(xbgr.mr_n84006832)
print v(xbgr.mr_n84007344)
print v(xbgr.mr_n84010704)
print v(xbgr.mr_n84010816)
print v(xbgr.mr_n84012560)
print v(xbgr.mr_n84012832)
print v(xbgr.mr_n84013024)
print v(xbgr.mr_n84013536)
print v(xbgr.mr_n84015680)
print v(xbgr.mr_n84015792)
print v(xbgr.mr_n84017536)
print v(xbgr.mr_n84017808)
print v(xbgr.mr_n84018000)
print v(xbgr.mr_n84018512)
print v(xbgr.mr_n84020656)
print v(xbgr.mr_n84020768)
print v(xbgr.mr_n84022512)
print v(xbgr.mr_n84022784)
print v(xbgr.mr_n84022976)
print v(xbgr.mr_n84023488)
print v(xbgr.mr_n84025632)
print v(xbgr.mr_n84025744)
print v(xbgr.mr_n84027488)
print v(xbgr.mr_n84027760)
print v(xbgr.mr_n84027952)
print v(xbgr.mr_n84028464)
print v(xbgr.mr_n84033632)
print v(xbgr.mr_n84035824)
print v(xbgr.mr_n84037392)
print v(xbgr.mr_n84038336)
print v(xbgr.mr_n84040528)
print v(xbgr.mr_n84042096)
print v(xbgr.mr_n84043040)
print v(xbgr.mr_n84045232)
print v(xbgr.mr_n84046848)
print v(xbgr.mr_n84047424)
print v(xbgr.mr_n84047536)
print v(xbgr.mr_n84048368)
print v(xbgr.mr_n84048480)
print v(xbgr.mr_n84049312)
print v(xbgr.mr_n84049424)
print v(xbgr.mr_n84050256)
print v(xbgr.mr_n84050368)
print v(xbgr.mr_n84051200)
print v(xbgr.mr_n84051312)
print v(xbgr.mr_n84052144)
print v(xbgr.mr_n84052256)
print v(xbgr.mr_n84053088)
print v(xbgr.mr_n84053200)
print v(xbgr.mr_n84054032)
print v(xbgr.mr_n84054144)
print v(xbgr.mr_n84054976)
print v(xbgr.mr_n84055088)
print v(xbgr.mr_n84055328)
print v(xbgr.mr_n84056048)
print v(xbgr.mr_n84056160)
print v(xbgr.mr_n84060368)
print v(xbgr.mr_n84061216)
print v(xbgr.mr_n84063392)
print v(xbgr.mr_n84063760)
print v(xbgr.mr_n84068240)
print v(xbgr.mr_n84068944)
print v(xbgr.mr_n84075792)
print v(xbgr.mr_n84081072)
print v(xbgr.mr_n84081760)
print v(xbgr.mr_n84082448)
print v(xbgr.mr_n84083136)
print v(xbgr.mr_n84083824)
print v(xbgr.mr_n84084512)
print v(xbgr.mr_n84086128)
print v(xbgr.mr_n84087104)
print v(xbgr.mr_n84088048)
print v(xbgr.mr_n84088992)
print v(xbgr.mr_n84089936)
print v(xbgr.mr_n84090880)
print v(xbgr.mr_n84091824)
print v(xbgr.mr_n84092768)
print v(xbgr.mr_n84093712)
print v(xbgr.mr_n84094656)
print v(xbgr.mr_n84095600)
print v(xbgr.mr_n84096544)
print v(xbgr.mr_n84097488)
print v(xbgr.mr_n84097680)
print v(xbgr.mr_n84097872)
print v(xbgr.mr_n84098064)
print v(xbgr.mr_n84098256)
print v(xbgr.mr_n84098448)
print v(xbgr.mr_n84100592)
print v(xbgr.mr_n84100704)
print v(xbgr.mr_n84104016)
print v(xbgr.mr_n84104128)
print v(xbgr.mr_n84109008)
print v(xbgr.mr_n84110848)
print v(xbgr.mr_n84112688)
print v(xbgr.mr_n84114528)
print v(xbgr.mr_n84116624)
print v(xbgr.mr_n84122960)
print v(xbgr.mr_n84131696)
print v(xbgr.mr_n84133264)
print v(xbgr.mr_n84134832)
print v(xbgr.mr_n84136400)
print v(xbgr.mr_n84137968)
print v(xbgr.mr_n84139536)
print v(xbgr.mr_n84141104)
print v(xbgr.mr_n84142672)
print v(xbgr.mr_n84144240)
print v(xbgr.mr_n84145808)
print v(xbgr.mr_n84147376)
print v(xbgr.mr_n84148944)
print v(xbgr.mr_n84150512)
print v(xbgr.mr_n84152080)
print v(xbgr.mr_n84153648)
print v(xbgr.mr_n84155216)
print v(xbgr.mr_n84158464)
print v(xbgr.mr_n84158800)
print v(xbgr.mr_n84158912)
print v(xbgr.mr_n84159744)
print v(xbgr.mr_n84159856)
print v(xbgr.mr_n84160688)
print v(xbgr.mr_n84160800)
print v(xbgr.mr_n84161632)
print v(xbgr.mr_n84161744)
print v(xbgr.mr_n84165232)
print v(xbgr.mr_n84165744)
print v(xbgr.mr_n84165856)
print v(xbgr.mr_n84165968)
print v(xbgr.mr_n84166080)
print v(xbgr.mr_n84166192)
print v(xbgr.mr_n84167616)
print v(xbgr.mr_n84167888)
print v(xbgr.mr_n84168080)
print v(xbgr.mr_n84168592)
print v(xbgr.mr_n84170736)
print v(xbgr.mr_n84170848)
print v(xbgr.mr_n84172592)
print v(xbgr.mr_n84172864)
print v(xbgr.mr_n84173056)
print v(xbgr.mr_n84173568)
print v(xbgr.mr_n84175712)
print v(xbgr.mr_n84175904)
print v(xbgr.mr_n84176096)
print v(xbgr.mr_n84177904)
print v(xbgr.mr_n84178096)
print v(xbgr.mr_n84178608)
print v(xbgr.mr_n84180688)
print v(xbgr.mr_n84180800)
print v(xbgr.mr_n84182544)
print v(xbgr.mr_n84182736)
print v(xbgr.mr_n84182928)
print v(xbgr.mr_n84183520)
print v(xbgr.mr_n84185664)
print v(xbgr.mr_n84185776)
print v(xbgr.mr_n84187520)
print v(xbgr.mr_n84187792)
print v(xbgr.mr_n84187984)
print v(xbgr.mr_n84188496)
print v(xbgr.mr_n84190640)
print v(xbgr.mr_n84190832)
print v(xbgr.mr_n84191024)
print v(xbgr.mr_n84191344)
print v(xbgr.mr_n84192832)
print v(xbgr.mr_n84193024)
print v(xbgr.mr_n84193536)
print v(xbgr.mr_n84195776)
print v(xbgr.mr_n84195968)
print v(xbgr.mr_n84196160)
print v(xbgr.mr_n84196352)
print v(xbgr.mr_n84196544)
print v(xbgr.mr_n84198768)
print v(xbgr.mr_n84200592)
print v(xbgr.mr_n84200704)
print v(xbgr.mr_n84202448)
print v(xbgr.mr_n84202720)
print v(xbgr.mr_n84202912)
print v(xbgr.mr_n84203424)
print v(xbgr.mr_n84205232)
print v(xbgr.mr_n84205344)
print v(xbgr.mr_n84206496)
print v(xbgr.mr_n84206608)
print v(xbgr.mr_n84207760)
print v(xbgr.mr_n84207872)
print v(xbgr.mr_n84209456)
print v(xbgr.mr_n84211024)
print v(xbgr.mr_n84211712)
print v(xbgr.mr_n84212400)
print v(xbgr.mr_n84213088)
print v(xbgr.mr_n84213776)
print v(xbgr.mr_n84214464)
print v(xbgr.mr_n84215152)
print v(xbgr.mr_n84215840)
print v(xbgr.mr_n84216528)
print v(xbgr.mr_n84217632)
print v(xbgr.mr_n84219568)
print v(xbgr.mr_n84220512)
print v(xbgr.mr_n84221456)
print v(xbgr.mr_n84222400)
print v(xbgr.mr_n84223344)
print v(xbgr.mr_n84224288)
print v(xbgr.mr_n84225232)
print v(xbgr.mr_n84226176)
print v(xbgr.mr_n84228848)
print v(xbgr.mr_n84232496)
print v(xbgr.mr_n84233072)
print v(xbgr.mr_n84234480)
print v(xbgr.mr_n84238592)
print v(xbgr.mr_n84239248)
print v(xbgr.mr_n84240560)
print v(xbgr.mr_n84243024)
print v(xbgr.mr_n84244592)
print v(xbgr.mr_n84245632)
print v(xbgr.mr_n84245744)
print v(xbgr.mr_n84245856)
print v(xbgr.mr_n84247456)
print v(xbgr.mr_n84247568)
print v(xbgr.mr_n84251776)
print v(xbgr.mr_n84252992)
print v(xbgr.mr_n84253104)
print v(xbgr.mr_n84256848)
print v(xbgr.mr_n84258320)
print v(xbgr.mr_n84259888)
print v(xbgr.mr_n84261456)
print v(xbgr.mr_n84263024)
print v(xbgr.mr_n84265312)
print v(xbgr.mr_n84267392)
print v(xbgr.mr_n84268080)
print v(xbgr.mr_n84269104)
print v(xbgr.mr_n84269376)
print v(xbgr.mr_n84271680)
print v(xbgr.mr_n84271872)
print v(xbgr.mr_n84272496)
print v(xbgr.mr_n84273248)
print v(xbgr.mr_n84273360)
print v(xbgr.mr_n84275520)
print v(xbgr.mr_n84277072)
print v(xbgr.mr_n84278192)
print v(xbgr.mr_n84278880)
print v(xbgr.mr_n84280080)
print v(xbgr.mr_n84281776)
print v(xbgr.mr_n84283344)
print v(xbgr.mr_n84284288)
print v(xbgr.mr_n84288400)
print v(xbgr.mr_n84291440)
print v(xbgr.mr_n84291872)
print v(xbgr.mr_n84293056)
print v(xbgr.mr_n84293168)
print v(xbgr.mr_n84294320)
print v(xbgr.mr_n84294432)
print v(xbgr.mr_n84295584)
print v(xbgr.mr_n84295696)
print v(xbgr.mr_n84296848)
print v(xbgr.mr_n84296960)
print v(xbgr.mr_n84298112)
print v(xbgr.mr_n84298224)
print v(xbgr.mr_n84299376)
print v(xbgr.mr_n84299488)
print v(xbgr.mr_n84300640)
print v(xbgr.mr_n84300752)
print v(xbgr.mr_n84301840)
print v(xbgr.mr_n84301952)
print v(xbgr.mr_n84303168)
print v(xbgr.mr_n84303280)
print v(xbgr.mr_n84304432)
print v(xbgr.mr_n84304544)
print v(xbgr.mr_n84308240)
print v(xbgr.mr_n84310240)
print v(xbgr.mr_n84313616)
print v(xbgr.mr_n84314224)
print v(xbgr.mr_n84314448)
print v(xbgr.mr_n84317248)
print v(xbgr.mr_n84318096)
print v(xbgr.mr_n84324048)
print v(xbgr.mr_n84324160)
print v(xbgr.mr_n84324352)
print v(xbgr.mr_n84324544)
print v(xbgr.mr_n84324736)
print v(xbgr.mr_n84327152)
print v(xbgr.mr_n84332992)
print v(xbgr.mr_n84333936)
print v(xbgr.mr_n84334880)
print v(xbgr.mr_n84335824)
print v(xbgr.mr_n84336768)
print v(xbgr.mr_n84337712)
print v(xbgr.mr_n84338656)
print v(xbgr.mr_n84339600)
print v(xbgr.mr_n84340544)
print v(xbgr.mr_n84341488)
print v(xbgr.mr_n84342432)
print v(xbgr.mr_n84343376)
print v(xbgr.mr_n84344320)
print v(xbgr.mr_n84344768)
print v(xbgr.mr_n84344880)
print v(xbgr.mr_n84345072)
print v(xbgr.mr_n84345680)
print v(xbgr.mr_n84346608)
print v(xbgr.mr_n84347712)
print v(xbgr.mr_n84350064)
print v(xbgr.mr_n84351008)
print v(xbgr.mr_n84351952)
print v(xbgr.mr_n84352896)
print v(xbgr.mr_n84353840)
print v(xbgr.mr_n84354784)
print v(xbgr.mr_n84355728)
print v(xbgr.mr_n84356672)
print v(xbgr.mr_n84357616)
print v(xbgr.mr_n84359328)
print v(xbgr.mr_n84360640)
print v(xbgr.mr_n84361376)
print v(xbgr.mr_n84362320)
print v(xbgr.mr_n84363264)
print v(xbgr.mr_n84363456)
print v(xbgr.mr_n84363648)
print v(xbgr.mr_n84363840)
print v(xbgr.mr_n84364032)
print v(xbgr.mr_n84364224)
print v(xbgr.mr_n84366368)
print v(xbgr.mr_n84366480)
print v(xbgr.mr_n84369568)
print v(xbgr.mr_n84369680)
print v(xbgr.mr_n84375328)
print v(xbgr.mr_n84376272)
print v(xbgr.mr_n84377216)
print v(xbgr.mr_n84378160)
print v(xbgr.mr_n84379104)
print v(xbgr.mr_n84380048)
print v(xbgr.mr_n84380992)
print v(xbgr.mr_n84381936)
print v(xbgr.mr_n84382880)
print v(xbgr.mr_n84383824)
print v(xbgr.mr_n84384448)
print v(xbgr.mr_n84385952)
print v(xbgr.mr_n84386528)
print v(xbgr.mr_n84386640)
print v(xbgr.mr_n84387584)
print v(xbgr.mr_n84387776)
print v(xbgr.mr_n84387968)
print v(xbgr.mr_n84388160)
print v(xbgr.mr_n84390352)
print v(xbgr.mr_n84390624)
print v(xbgr.mr_n84391328)
print v(xbgr.mr_n84392944)
print v(xbgr.mr_n84396816)
print v(xbgr.mr_n84397648)
print v(xbgr.mr_n84397760)
print v(xbgr.mr_n84397872)
print v(xbgr.mr_n84397984)
print v(xbgr.mr_n84398096)
print v(xbgr.mr_n84399840)
print v(xbgr.mr_n84400112)
print v(xbgr.mr_n84400304)
print v(xbgr.mr_n84400816)
print v(xbgr.mr_n84402960)
print v(xbgr.mr_n84403072)
print v(xbgr.mr_n84404816)
print v(xbgr.mr_n84405088)
print v(xbgr.mr_n84405280)
print v(xbgr.mr_n84405792)
print v(xbgr.mr_n84407936)
print v(xbgr.mr_n84408048)
print v(xbgr.mr_n84409792)
print v(xbgr.mr_n84410064)
print v(xbgr.mr_n84410256)
print v(xbgr.mr_n84410768)
print v(xbgr.mr_n84412912)
print v(xbgr.mr_n84413024)
print v(xbgr.mr_n84414768)
print v(xbgr.mr_n84415040)
print v(xbgr.mr_n84415232)
print v(xbgr.mr_n84415744)
print v(xbgr.mr_n84417888)
print v(xbgr.mr_n84418000)
print v(xbgr.mr_n84419744)
print v(xbgr.mr_n84420016)
print v(xbgr.mr_n84420208)
print v(xbgr.mr_n84420720)
print v(xbgr.mr_n84422864)
print v(xbgr.mr_n84423312)
print v(xbgr.mr_n84424720)
print v(xbgr.mr_n84424992)
print v(xbgr.mr_n84425696)
print v(xbgr.mr_n84427840)
print v(xbgr.mr_n84427952)
print v(xbgr.mr_n84429696)
print v(xbgr.mr_n84429968)
print v(xbgr.mr_n84430160)
print v(xbgr.mr_n84430672)
print v(xbgr.mr_n84435424)
print v(xbgr.mr_n84437824)
print v(xbgr.mr_n84441056)
print v(xbgr.mr_n84441248)
print v(xbgr.mr_n84441440)
print v(xbgr.mr_n84442336)
print v(xbgr.mr_n84442448)
print v(xbgr.mr_n84444672)
print v(xbgr.mr_n84448848)
print v(xbgr.mr_n84449536)
print v(xbgr.mr_n84450224)
print v(xbgr.mr_n84450912)
print v(xbgr.mr_n84451600)
print v(xbgr.mr_n84452288)
print v(xbgr.mr_n84452976)
print v(xbgr.mr_n84453664)
print v(xbgr.mr_n84454352)
print v(xbgr.mr_n84455040)
print v(xbgr.mr_n84455728)
print v(xbgr.mr_n84456416)
print v(xbgr.mr_n84457488)
print v(xbgr.mr_n84459216)
print v(xbgr.mr_n84462928)
print v(xbgr.mr_n84467536)
print v(xbgr.mr_n84469392)
print v(xbgr.mr_n84469504)
print v(xbgr.mr_n84471648)
print v(xbgr.mr_n84471760)
print v(xbgr.mr_n84472912)
print v(xbgr.mr_n84473024)
print v(xbgr.mr_n84474176)
print v(xbgr.mr_n84474288)
print v(xbgr.mr_n84475440)
print v(xbgr.mr_n84475552)
print v(xbgr.mr_n84476704)
print v(xbgr.mr_n84476816)
print v(xbgr.mr_n84477968)
print v(xbgr.mr_n84478080)
print v(xbgr.mr_n84479232)
print v(xbgr.mr_n84479344)
print v(xbgr.mr_n84480192)
print v(xbgr.mr_n84480304)
print v(xbgr.mr_n84481072)
print v(xbgr.mr_n84481184)
print v(xbgr.mr_n84482256)
print v(xbgr.mr_n84482368)
print v(xbgr.mr_n84483904)
print v(xbgr.mr_n84484016)
print v(xbgr.mr_n84486256)
print v(xbgr.mr_n84486368)
print v(xbgr.mr_n84487520)
print v(xbgr.mr_n84487632)
print v(xbgr.mr_n84488512)
print v(xbgr.mr_n84491376)
print v(xbgr.mr_n84492496)
print v(xbgr.mr_n84493968)
print v(xbgr.mr_n84495536)
print v(xbgr.mr_n84497104)
print v(xbgr.mr_n84498672)
print v(xbgr.mr_n84500240)
print v(xbgr.mr_n84501808)
print v(xbgr.mr_n84503376)
print v(xbgr.mr_n84504944)
print v(xbgr.mr_n84506512)
print v(xbgr.mr_n84508080)
print v(xbgr.mr_n84510272)
print v(xbgr.mr_n84511840)
print v(xbgr.mr_n84513408)
print v(xbgr.mr_n84514928)
print v(xbgr.mr_n84518208)
print v(xbgr.mr_n84518784)
print v(xbgr.mr_n84521264)
print v(xbgr.mr_n84525136)
print v(xbgr.mr_n84526208)
print v(xbgr.mr_n84526400)
print v(xbgr.mr_n84526592)
print v(xbgr.mr_n84526784)
print v(xbgr.mr_n84529104)
print v(xbgr.mr_n84529376)
print v(xbgr.mr_n84529568)
print v(xbgr.mr_n84530080)
print v(xbgr.mr_n84535280)
print v(xbgr.mr_n84535472)
print v(xbgr.mr_n84535664)
print v(xbgr.mr_n84536256)
print v(xbgr.mr_n84538992)
print v(xbgr.mr_n84539264)
print v(xbgr.mr_n84539456)
print v(xbgr.mr_n84539968)
print v(xbgr.mr_n84542112)
print v(xbgr.mr_n84542304)
print v(xbgr.mr_n84542496)
print v(xbgr.mr_n84544304)
print v(xbgr.mr_n84544496)
print v(xbgr.mr_n84545008)
print v(xbgr.mr_n84546176)
print v(xbgr.mr_n84546688)
print v(xbgr.mr_n84550512)
print v(xbgr.mr_n84552432)
print v(xbgr.mr_n84554816)
print v(xbgr.mr_n84555008)
print v(xbgr.mr_n84555520)
print v(xbgr.mr_n84556816)
print v(xbgr.mr_n84557328)
print v(xbgr.mr_n84559008)
print v(xbgr.mr_n84559520)
print v(xbgr.mr_n84560480)
print v(xbgr.mr_n84560736)
print v(xbgr.mr_n84561648)
print v(xbgr.mr_n84562160)
print v(xbgr.mr_n84564160)
print v(xbgr.mr_n84564672)
print v(xbgr.mr_n84566736)
print v(xbgr.mr_n84567248)
print v(xbgr.mr_n84569376)
print v(xbgr.mr_n84569888)
print v(xbgr.mr_n84571888)
print v(xbgr.mr_n84572400)
print v(xbgr.mr_n84574528)
print v(xbgr.mr_n84575040)
print v(xbgr.mr_n84576960)
print v(xbgr.mr_n84577552)
print v(xbgr.mr_n84579616)
print v(xbgr.mr_n84580128)
print v(xbgr.mr_n84581008)
print v(xbgr.mr_n84582192)
print v(xbgr.mr_n84582704)
print v(xbgr.mr_n84587312)
print v(xbgr.mr_n84591040)
print v(xbgr.mr_n84591152)
print v(xbgr.mr_n84592304)
print v(xbgr.mr_n84592416)
print v(xbgr.mr_n84593568)
print v(xbgr.mr_n84593680)
print v(xbgr.mr_n84594832)
print v(xbgr.mr_n84594944)
print v(xbgr.mr_n84596096)
print v(xbgr.mr_n84596208)
print v(xbgr.mr_n84597360)
print v(xbgr.mr_n84597472)
print v(xbgr.mr_n84598624)
print v(xbgr.mr_n84598736)
print v(xbgr.mr_n84599888)
print v(xbgr.mr_n84600000)
print v(xbgr.mr_n84601152)
print v(xbgr.mr_n84601264)
print v(xbgr.mr_n84602416)
print v(xbgr.mr_n84602528)
print v(xbgr.mr_n84603680)
print v(xbgr.mr_n84603792)
print v(xbgr.mr_n84604944)
print v(xbgr.mr_n84605056)
print v(xbgr.mr_n84606208)
print v(xbgr.mr_n84606320)
print v(xbgr.mr_n84607472)
print v(xbgr.mr_n84607584)
print v(xbgr.mr_n84612560)
print v(xbgr.mr_n84613264)
print v(xbgr.mr_n84614736)
print v(xbgr.mr_n84618768)
print v(xbgr.mr_n84620512)
print v(xbgr.mr_n84622896)
print v(xbgr.mr_n84623584)
print v(xbgr.mr_n84624528)
print v(xbgr.mr_n84626208)
print v(xbgr.mr_n84627152)
print v(xbgr.mr_n84628096)
print v(xbgr.mr_n84629040)
print v(xbgr.mr_n84629984)
print v(xbgr.mr_n84630928)
print v(xbgr.mr_n84631872)
print v(xbgr.mr_n84632816)
print v(xbgr.mr_n84633760)
print v(xbgr.mr_n84634704)
print v(xbgr.mr_n84635648)
print v(xbgr.mr_n84636592)
print v(xbgr.mr_n84637536)
print v(xbgr.mr_n84638480)
print v(xbgr.mr_n84639424)
print v(xbgr.mr_n84640368)
print v(xbgr.mr_n84641696)
print v(xbgr.mr_n84646688)
print v(xbgr.mr_n84648256)
print v(xbgr.mr_n84651600)
print v(xbgr.mr_n84652832)
print v(xbgr.mr_n84652944)
print v(xbgr.mr_n84653888)
print v(xbgr.mr_n84654976)
print v(xbgr.mr_n84655088)
print v(xbgr.mr_n84656928)
print v(xbgr.mr_n84657040)
print v(xbgr.mr_n84657984)
print v(xbgr.mr_n84659136)
print v(xbgr.mr_n84659248)
print v(xbgr.mr_n84661024)
print v(xbgr.mr_n84661136)
print v(xbgr.mr_n84662080)
print v(xbgr.mr_n84663216)
print v(xbgr.mr_n84663328)
print v(xbgr.mr_n84664496)
print v(xbgr.mr_n84665104)
print v(xbgr.mr_n84665216)
print v(xbgr.mr_n84666160)
print v(xbgr.mr_n84667312)
print v(xbgr.mr_n84667424)
print v(xbgr.mr_n84669200)
print v(xbgr.mr_n84669312)
print v(xbgr.mr_n84670256)
print v(xbgr.mr_n84671408)
print v(xbgr.mr_n84671520)
print v(xbgr.mr_n84672688)
print v(xbgr.mr_n84673296)
print v(xbgr.mr_n84673408)
print v(xbgr.mr_n84674352)
print v(xbgr.mr_n84675504)
print v(xbgr.mr_n84675616)
print v(xbgr.mr_n84677392)
print v(xbgr.mr_n84677504)
print v(xbgr.mr_n84678448)
print v(xbgr.mr_n84679600)
print v(xbgr.mr_n84679712)
print v(xbgr.mr_n84681424)
print v(xbgr.mr_n84681536)
print v(xbgr.mr_n84682480)
print v(xbgr.mr_n84683696)
print v(xbgr.mr_n84683808)
print v(xbgr.mr_n84685584)
print v(xbgr.mr_n84685696)
print v(xbgr.mr_n84687008)
print v(xbgr.mr_n84688128)
print v(xbgr.mr_n84689264)
print v(xbgr.mr_n84690224)
print v(xbgr.mr_n84691792)
print v(xbgr.mr_n84693360)
print v(xbgr.mr_n84694928)
print v(xbgr.mr_n84696496)
print v(xbgr.mr_n84698064)
print v(xbgr.mr_n84699632)
print v(xbgr.mr_n84701936)
print v(xbgr.mr_n84708320)
print v(xbgr.mr_n84712288)
print v(xbgr.mr_n84713440)
print v(xbgr.mr_n84713824)
print v(xbgr.mr_n84714656)
print v(xbgr.mr_n84718496)
print v(xbgr.mr_n84719568)
print v(xbgr.mr_n84719840)
print v(xbgr.mr_n84720032)
print v(xbgr.mr_n84720224)
print v(xbgr.mr_n84720416)
print v(xbgr.mr_n84720608)
print v(xbgr.mr_n84721584)
print v(xbgr.mr_n84722992)
print v(xbgr.mr_n84723184)
print v(xbgr.mr_n84723696)
print v(xbgr.mr_n84727552)
print v(xbgr.mr_n84729312)
print v(xbgr.mr_n84729584)
print v(xbgr.mr_n84729776)
print v(xbgr.mr_n84730288)
print v(xbgr.mr_n84733024)
print v(xbgr.mr_n84733296)
print v(xbgr.mr_n84733488)
print v(xbgr.mr_n84734000)
print v(xbgr.mr_n84736144)
print v(xbgr.mr_n84736256)
print v(xbgr.mr_n84738000)
print v(xbgr.mr_n84738272)
print v(xbgr.mr_n84738464)
print v(xbgr.mr_n84738976)
print v(xbgr.mr_n84740208)
print v(xbgr.mr_n84740720)
print v(xbgr.mr_n84742336)
print v(xbgr.mr_n84744160)
print v(xbgr.mr_n84744432)
print v(xbgr.mr_n84744624)
print v(xbgr.mr_n84745136)
print v(xbgr.mr_n84749136)
print v(xbgr.mr_n84749408)
print v(xbgr.mr_n84749600)
print v(xbgr.mr_n84750112)
print v(xbgr.mr_n84750528)
print v(xbgr.mr_n84751040)
print v(xbgr.mr_n84752192)
print v(xbgr.mr_n84753776)
print v(xbgr.mr_n84756256)
print v(xbgr.mr_n84757088)
print v(xbgr.mr_n84757200)
print v(xbgr.mr_n84757312)
print v(xbgr.mr_n84757424)
print v(xbgr.mr_n84757536)
print v(xbgr.mr_n84759280)
print v(xbgr.mr_n84759552)
print v(xbgr.mr_n84759744)
print v(xbgr.mr_n84760256)
print v(xbgr.mr_n84761488)
print v(xbgr.mr_n84762000)
print v(xbgr.mr_n84765440)
print v(xbgr.mr_n84765712)
print v(xbgr.mr_n84765904)
print v(xbgr.mr_n84766416)
print v(xbgr.mr_n84768560)
print v(xbgr.mr_n84768672)
print v(xbgr.mr_n84770416)
print v(xbgr.mr_n84770688)
print v(xbgr.mr_n84770880)
print v(xbgr.mr_n84771392)
print v(xbgr.mr_n84772624)
print v(xbgr.mr_n84773136)
print v(xbgr.mr_n84776576)
print v(xbgr.mr_n84776848)
print v(xbgr.mr_n84777040)
print v(xbgr.mr_n84777552)
print v(xbgr.mr_n84779696)
print v(xbgr.mr_n84779808)
print v(xbgr.mr_n84780000)
print v(xbgr.mr_n84781552)
print v(xbgr.mr_n84781824)
print v(xbgr.mr_n84782016)
print v(xbgr.mr_n84782528)
print v(xbgr.mr_n84783760)
print v(xbgr.mr_n84784272)
print v(xbgr.mr_n84791328)
print v(xbgr.mr_n84791440)
print v(xbgr.mr_n84792272)
print v(xbgr.mr_n84792384)
print v(xbgr.mr_n84793216)
print v(xbgr.mr_n84793328)
print v(xbgr.mr_n84794416)
print v(xbgr.mr_n84794528)
print v(xbgr.mr_n84795680)
print v(xbgr.mr_n84795792)
print v(xbgr.mr_n84796944)
print v(xbgr.mr_n84797056)
print v(xbgr.mr_n84798208)
print v(xbgr.mr_n84798320)
print v(xbgr.mr_n84799472)
print v(xbgr.mr_n84799584)
print v(xbgr.mr_n84800736)
print v(xbgr.mr_n84800848)
print v(xbgr.mr_n84802000)
print v(xbgr.mr_n84802112)
print v(xbgr.mr_n84803264)
print v(xbgr.mr_n84803376)
print v(xbgr.mr_n84804528)
print v(xbgr.mr_n84804640)
print v(xbgr.mr_n84805792)
print v(xbgr.mr_n84805904)
print v(xbgr.mr_n84807056)
print v(xbgr.mr_n84807168)
print v(xbgr.mr_n84808320)
print v(xbgr.mr_n84808432)
print v(xbgr.mr_n84813040)
print v(xbgr.mr_n84814944)
print v(xbgr.mr_n84815632)
print v(xbgr.mr_n84816320)
print v(xbgr.mr_n84817040)
print v(xbgr.mr_n84817984)
print v(xbgr.mr_n84818928)
print v(xbgr.mr_n84819872)
print v(xbgr.mr_n84820816)
print v(xbgr.mr_n84821760)
print v(xbgr.mr_n84822704)
print v(xbgr.mr_n84823648)
print v(xbgr.mr_n84824592)
print v(xbgr.mr_n84825536)
print v(xbgr.mr_n84826480)
print v(xbgr.mr_n84827424)
print v(xbgr.mr_n84828368)
print v(xbgr.mr_n84829312)
print v(xbgr.mr_n84830256)
print v(xbgr.mr_n84831200)
print v(xbgr.mr_n84837840)
print v(xbgr.mr_n84841104)
print v(xbgr.mr_n84845328)
print v(xbgr.mr_n84845840)
print v(xbgr.mr_n84846736)
print v(xbgr.mr_n84848304)
print v(xbgr.mr_n84850880)
print v(xbgr.mr_n84852112)
print v(xbgr.mr_n84852224)
print v(xbgr.mr_n84853168)
print v(xbgr.mr_n84854320)
print v(xbgr.mr_n84854432)
print v(xbgr.mr_n84855600)
print v(xbgr.mr_n84856208)
print v(xbgr.mr_n84856320)
print v(xbgr.mr_n84857264)
print v(xbgr.mr_n84858416)
print v(xbgr.mr_n84858528)
print v(xbgr.mr_n84860304)
print v(xbgr.mr_n84860416)
print v(xbgr.mr_n84861360)
print v(xbgr.mr_n84862512)
print v(xbgr.mr_n84862624)
print v(xbgr.mr_n84863792)
print v(xbgr.mr_n84864400)
print v(xbgr.mr_n84864512)
print v(xbgr.mr_n84865456)
print v(xbgr.mr_n84866608)
print v(xbgr.mr_n84866720)
print v(xbgr.mr_n84867888)
print v(xbgr.mr_n84868496)
print v(xbgr.mr_n84868608)
print v(xbgr.mr_n84869552)
print v(xbgr.mr_n84870704)
print v(xbgr.mr_n84870816)
print v(xbgr.mr_n84872592)
print v(xbgr.mr_n84872704)
print v(xbgr.mr_n84873648)
print v(xbgr.mr_n84874800)
print v(xbgr.mr_n84874912)
print v(xbgr.mr_n84876688)
print v(xbgr.mr_n84876800)
print v(xbgr.mr_n84877744)
print v(xbgr.mr_n84878896)
print v(xbgr.mr_n84879008)
print v(xbgr.mr_n84880784)
print v(xbgr.mr_n84880896)
print v(xbgr.mr_n84881840)
print v(xbgr.mr_n84882992)
print v(xbgr.mr_n84883104)
print v(xbgr.mr_n84884272)
print v(xbgr.mr_n84884880)
print v(xbgr.mr_n84884992)
print v(xbgr.mr_n84886256)
print v(xbgr.mr_n84887344)
print v(xbgr.mr_n84889552)
print v(xbgr.mr_n84891888)
print v(xbgr.mr_n84893456)
print v(xbgr.mr_n84896384)
print v(xbgr.mr_n84896720)
print v(xbgr.mr_n84898080)
print v(xbgr.mr_n84902528)
print v(xbgr.mr_n84906208)
print v(xbgr.mr_n84910336)
print v(xbgr.mr_n84910592)
print v(xbgr.mr_n84912096)
print v(xbgr.mr_n84920576)
print v(xbgr.mr_n84921344)
print v(xbgr.mr_n84921536)
print v(xbgr.mr_n84922368)
print v(xbgr.mr_n84922944)
print v(xbgr.mr_n84923632)
print v(xbgr.mr_n84924208)
print v(xbgr.mr_n84924896)
print v(xbgr.mr_n84925472)
print v(xbgr.mr_n84926160)
print v(xbgr.mr_n84926736)
print v(xbgr.mr_n84927424)
print v(xbgr.mr_n84928128)
print v(xbgr.mr_n84928688)
print v(xbgr.mr_n84929264)
print v(xbgr.mr_n84929952)
print v(xbgr.mr_n84930528)
print v(xbgr.mr_n84931216)
print v(xbgr.mr_n84931648)
print v(xbgr.mr_n84932480)
print v(xbgr.mr_n84932912)
print v(xbgr.mr_n84933744)
print v(xbgr.mr_n84934320)
print v(xbgr.mr_n84935008)
print v(xbgr.mr_n84935712)
print v(xbgr.mr_n84936272)
print v(xbgr.mr_n84936704)
print v(xbgr.mr_n84937536)
print v(xbgr.mr_n84938112)
print v(xbgr.mr_n84938800)
print v(xbgr.mr_n84939376)
print v(xbgr.mr_n84940064)
print v(xbgr.mr_n84940640)
print v(xbgr.mr_n84941328)
print v(xbgr.mr_n84941904)
print v(xbgr.mr_n84942592)
print v(xbgr.mr_n84944176)
print v(xbgr.mr_n84946096)
print v(xbgr.mr_n84946208)
print v(xbgr.mr_n84946320)
print v(xbgr.mr_n84946432)
print v(xbgr.mr_n84948752)
print v(xbgr.mr_n84949024)
print v(xbgr.mr_n84949216)
print v(xbgr.mr_n84949728)
print v(xbgr.mr_n84950960)
print v(xbgr.mr_n84951472)
print v(xbgr.mr_n84953024)
print v(xbgr.mr_n84953536)
print v(xbgr.mr_n84955472)
print v(xbgr.mr_n84955984)
print v(xbgr.mr_n84957920)
print v(xbgr.mr_n84958432)
print v(xbgr.mr_n84960368)
print v(xbgr.mr_n84960880)
print v(xbgr.mr_n84962816)
print v(xbgr.mr_n84963328)
print v(xbgr.mr_n84965328)
print v(xbgr.mr_n84965840)
print v(xbgr.mr_n84967712)
print v(xbgr.mr_n84968224)
print v(xbgr.mr_n84970160)
print v(xbgr.mr_n84970672)
print v(xbgr.mr_n84972528)
print v(xbgr.mr_n84973120)
print v(xbgr.mr_n84975056)
print v(xbgr.mr_n84975568)
print v(xbgr.mr_n84977504)
print v(xbgr.mr_n84978016)
print v(xbgr.mr_n84979952)
print v(xbgr.mr_n84980464)
print v(xbgr.mr_n84982400)
print v(xbgr.mr_n84982912)
print v(xbgr.mr_n84984848)
print v(xbgr.mr_n84985360)
print v(xbgr.mr_n84987360)
print v(xbgr.mr_n84987872)
print v(xbgr.mr_n84989856)
print v(xbgr.mr_n84991264)
print v(xbgr.mr_n84995728)
print v(xbgr.mr_n84996880)
print v(xbgr.mr_n84996992)
print v(xbgr.mr_n84998144)
print v(xbgr.mr_n84998256)
print v(xbgr.mr_n84999408)
print v(xbgr.mr_n84999520)
print v(xbgr.mr_n85000672)
print v(xbgr.mr_n85000784)
print v(xbgr.mr_n85001936)
print v(xbgr.mr_n85002048)
print v(xbgr.mr_n85003200)
print v(xbgr.mr_n85003312)
print v(xbgr.mr_n85004464)
print v(xbgr.mr_n85004576)
print v(xbgr.mr_n85005728)
print v(xbgr.mr_n85005840)
print v(xbgr.mr_n85006992)
print v(xbgr.mr_n85007104)
print v(xbgr.mr_n85008256)
print v(xbgr.mr_n85008368)
print v(xbgr.mr_n85009520)
print v(xbgr.mr_n85009632)
print v(xbgr.mr_n85010784)
print v(xbgr.mr_n85010896)
print v(xbgr.mr_n85012048)
print v(xbgr.mr_n85012160)
print v(xbgr.mr_n85013312)
print v(xbgr.mr_n85013424)
print v(xbgr.mr_n85014576)
print v(xbgr.mr_n85014688)
print v(xbgr.mr_n85015568)
print v(xbgr.mr_n85016256)
print v(xbgr.mr_n85016944)
print v(xbgr.mr_n85017664)
print v(xbgr.mr_n85018608)
print v(xbgr.mr_n85019552)
print v(xbgr.mr_n85020496)
print v(xbgr.mr_n85024608)
print v(xbgr.mr_n85027104)
print v(xbgr.mr_n85028064)
print v(xbgr.mr_n85029536)
print v(xbgr.mr_n85040064)
print v(xbgr.mr_n85040448)
print v(xbgr.mr_n85040800)
print v(xbgr.mr_n85042608)
print v(xbgr.mr_n85043168)
print v(xbgr.mr_n85043280)
print v(xbgr.mr_n85043552)
print v(xbgr.mr_n85044848)
print v(xbgr.mr_n85045456)
print v(xbgr.mr_n85048144)
print v(xbgr.mr_n85051776)
print v(xbgr.mr_n85053008)
print v(xbgr.mr_n85053120)
print v(xbgr.mr_n85054064)
print v(xbgr.mr_n85055216)
print v(xbgr.mr_n85055328)
print v(xbgr.mr_n85056576)
print v(xbgr.mr_n85057104)
print v(xbgr.mr_n85057216)
print v(xbgr.mr_n85058160)
print v(xbgr.mr_n85059312)
print v(xbgr.mr_n85059424)
print v(xbgr.mr_n85061200)
print v(xbgr.mr_n85061312)
print v(xbgr.mr_n85062256)
print v(xbgr.mr_n85063408)
print v(xbgr.mr_n85063520)
print v(xbgr.mr_n85064768)
print v(xbgr.mr_n85065296)
print v(xbgr.mr_n85065408)
print v(xbgr.mr_n85066352)
print v(xbgr.mr_n85067504)
print v(xbgr.mr_n85067616)
print v(xbgr.mr_n85069392)
print v(xbgr.mr_n85069504)
print v(xbgr.mr_n85070448)
print v(xbgr.mr_n85071600)
print v(xbgr.mr_n85071712)
print v(xbgr.mr_n85072960)
print v(xbgr.mr_n85073488)
print v(xbgr.mr_n85073600)
print v(xbgr.mr_n85074544)
print v(xbgr.mr_n85075696)
print v(xbgr.mr_n85075808)
print v(xbgr.mr_n85077584)
print v(xbgr.mr_n85077696)
print v(xbgr.mr_n85078640)
print v(xbgr.mr_n85079792)
print v(xbgr.mr_n85079904)
print v(xbgr.mr_n85081680)
print v(xbgr.mr_n85081792)
print v(xbgr.mr_n85082736)
print v(xbgr.mr_n85083888)
print v(xbgr.mr_n85084000)
print v(xbgr.mr_n85085168)
print v(xbgr.mr_n85085776)
print v(xbgr.mr_n85085888)
print v(xbgr.mr_n85087200)
print v(xbgr.mr_n85088320)
print v(xbgr.mr_n85090416)
print v(xbgr.mr_n85091984)
print v(xbgr.mr_n85093552)
print v(xbgr.mr_n85095120)
print v(xbgr.mr_n85096688)
print v(xbgr.mr_n85098256)
print v(xbgr.mr_n85099824)
print v(xbgr.mr_n85103344)
print v(xbgr.mr_n85104096)
print v(xbgr.mr_n85111264)
print v(xbgr.mr_n85117568)
print v(xbgr.mr_n85119424)
print v(xbgr.mr_n85119536)
print v(xbgr.mr_n85120480)
print v(xbgr.mr_n85120672)
print v(xbgr.mr_n85120864)
print v(xbgr.mr_n85121056)
print v(xbgr.mr_n85123312)
print v(xbgr.mr_n85123584)
print v(xbgr.mr_n85123776)
print v(xbgr.mr_n85124288)
print v(xbgr.mr_n85126832)
print v(xbgr.mr_n85128416)
print v(xbgr.mr_n85128528)
print v(xbgr.mr_n85130272)
print v(xbgr.mr_n85130544)
print v(xbgr.mr_n85130736)
print v(xbgr.mr_n85131248)
print v(xbgr.mr_n85133392)
print v(xbgr.mr_n85133504)
print v(xbgr.mr_n85135248)
print v(xbgr.mr_n85135520)
print v(xbgr.mr_n85135712)
print v(xbgr.mr_n85136224)
print v(xbgr.mr_n85138368)
print v(xbgr.mr_n85138480)
print v(xbgr.mr_n85140224)
print v(xbgr.mr_n85140496)
print v(xbgr.mr_n85140688)
print v(xbgr.mr_n85141200)
print v(xbgr.mr_n85143344)
print v(xbgr.mr_n85143456)
print v(xbgr.mr_n85145200)
print v(xbgr.mr_n85145472)
print v(xbgr.mr_n85145664)
print v(xbgr.mr_n85146176)
print v(xbgr.mr_n85148320)
print v(xbgr.mr_n85148432)
print v(xbgr.mr_n85150176)
print v(xbgr.mr_n85150448)
print v(xbgr.mr_n85150640)
print v(xbgr.mr_n85151152)
print v(xbgr.mr_n85153296)
print v(xbgr.mr_n85153408)
print v(xbgr.mr_n85155152)
print v(xbgr.mr_n85155424)
print v(xbgr.mr_n85155616)
print v(xbgr.mr_n85156320)
print v(xbgr.mr_n85156880)
print v(xbgr.mr_n85157712)
print v(xbgr.mr_n85159424)
print v(xbgr.mr_n85159616)
print v(xbgr.mr_n85159808)
print v(xbgr.mr_n85160000)
print v(xbgr.mr_n85161744)
print v(xbgr.mr_n85162016)
print v(xbgr.mr_n85162208)
print v(xbgr.mr_n85162720)
print v(xbgr.mr_n85166336)
print v(xbgr.mr_n85166448)
print v(xbgr.mr_n85168192)
print v(xbgr.mr_n85168464)
print v(xbgr.mr_n85168656)
print v(xbgr.mr_n85169168)
print v(xbgr.mr_n85171312)
print v(xbgr.mr_n85171424)
print v(xbgr.mr_n85173168)
print v(xbgr.mr_n85173440)
print v(xbgr.mr_n85173632)
print v(xbgr.mr_n85174144)
print v(xbgr.mr_n85176288)
print v(xbgr.mr_n85176400)
print v(xbgr.mr_n85178144)
print v(xbgr.mr_n85178416)
print v(xbgr.mr_n85178608)
print v(xbgr.mr_n85179120)
print v(xbgr.mr_n85181264)
print v(xbgr.mr_n85181456)
print v(xbgr.mr_n85181648)
print v(xbgr.mr_n85183456)
print v(xbgr.mr_n85183648)
print v(xbgr.mr_n85184160)
print v(xbgr.mr_n85186240)
print v(xbgr.mr_n85186352)
print v(xbgr.mr_n85188096)
print v(xbgr.mr_n85188368)
print v(xbgr.mr_n85188560)
print v(xbgr.mr_n85189072)
print v(xbgr.mr_n85191216)
print v(xbgr.mr_n85191328)
print v(xbgr.mr_n85193072)
print v(xbgr.mr_n85193344)
print v(xbgr.mr_n85193536)
print v(xbgr.mr_n85194048)
print v(xbgr.mr_n85196192)
print v(xbgr.mr_n85196304)
print v(xbgr.mr_n85198048)
print v(xbgr.mr_n85198320)
print v(xbgr.mr_n85198512)
print v(xbgr.mr_n85199024)
print v(xbgr.mr_n85201168)
print v(xbgr.mr_n85201280)
print v(xbgr.mr_n85203024)
print v(xbgr.mr_n85203296)
print v(xbgr.mr_n85203488)
print v(xbgr.mr_n85204000)
print v(xbgr.mr_n85205776)
print v(xbgr.mr_n85207520)
print v(xbgr.mr_n85209584)
print v(xbgr.mr_n85213616)
print v(xbgr.mr_n85224240)
print v(xbgr.mr_n85224720)
print v(xbgr.mr_n85233040)
print v(xbgr.mr_n85233296)
print v(xbgr.mr_n85236656)
print v(xbgr.mr_n85237376)
print v(xbgr.mr_n85238080)
print v(xbgr.mr_n85241488)
print v(xbgr.mr_n85241600)
print v(xbgr.mr_n85242752)
print v(xbgr.mr_n85242864)
print v(xbgr.mr_n85244016)
print v(xbgr.mr_n85244128)
print v(xbgr.mr_n85245280)
print v(xbgr.mr_n85245392)
print v(xbgr.mr_n85246544)
print v(xbgr.mr_n85246656)
print v(xbgr.mr_n85247808)
print v(xbgr.mr_n85247920)
print v(xbgr.mr_n85249072)
print v(xbgr.mr_n85249184)
print v(xbgr.mr_n85250336)
print v(xbgr.mr_n85250448)
print v(xbgr.mr_n85251600)
print v(xbgr.mr_n85251712)
print v(xbgr.mr_n85252864)
print v(xbgr.mr_n85252976)
print v(xbgr.mr_n85254128)
print v(xbgr.mr_n85254240)
print v(xbgr.mr_n85255392)
print v(xbgr.mr_n85255504)
print v(xbgr.mr_n85256656)
print v(xbgr.mr_n85256768)
print v(xbgr.mr_n85257920)
print v(xbgr.mr_n85258032)
print v(xbgr.mr_n85259184)
print v(xbgr.mr_n85259296)
print v(xbgr.mr_n85259600)
print v(xbgr.mr_n85260832)
print v(xbgr.mr_n85262160)
print v(xbgr.mr_n85263120)
print v(xbgr.mr_n85267088)
print v(xbgr.mr_n85269456)
print v(xbgr.mr_n85270144)
print v(xbgr.mr_n85270832)
print v(xbgr.mr_n85271552)
print v(xbgr.mr_n85272496)
print v(xbgr.mr_n85273440)
print v(xbgr.mr_n85274384)
print v(xbgr.mr_n85275328)
print v(xbgr.mr_n85276272)
print v(xbgr.mr_n85277216)
print v(xbgr.mr_n85278160)
print v(xbgr.mr_n85279104)
print v(xbgr.mr_n85280048)
print v(xbgr.mr_n85280992)
print v(xbgr.mr_n85281936)
print v(xbgr.mr_n85282880)
print v(xbgr.mr_n85283824)
print v(xbgr.mr_n85284768)
print v(xbgr.mr_n85285712)
print v(xbgr.mr_n85286656)
print v(xbgr.mr_n85287600)
print v(xbgr.mr_n85288544)
print v(xbgr.mr_n85289488)
print v(xbgr.mr_n85290432)
print v(xbgr.mr_n85295344)
print v(xbgr.mr_n85296176)
print v(xbgr.mr_n85298640)
print v(xbgr.mr_n85302592)
print v(xbgr.mr_n85305216)
print v(xbgr.mr_n85305776)
print v(xbgr.mr_n85306272)
print v(xbgr.mr_n85306480)
print v(xbgr.mr_n85306656)
print v(xbgr.mr_n85307328)
print v(xbgr.mr_n85309024)
print v(xbgr.mr_n85310080)
print v(xbgr.mr_n85310320)
print v(xbgr.mr_n85310960)
print v(xbgr.mr_n85311200)
print v(xbgr.mr_n85313600)
print v(xbgr.mr_n85314304)
print v(xbgr.mr_n85315248)
print v(xbgr.mr_n85315360)
print v(xbgr.mr_n85316656)
print v(xbgr.mr_n85317008)
print v(xbgr.mr_n85317120)
print v(xbgr.mr_n85319712)
print v(xbgr.mr_n85319936)
print v(xbgr.mr_n85323344)
print v(xbgr.mr_n85323808)
print v(xbgr.mr_n85324336)
print v(xbgr.mr_n85325280)
print v(xbgr.mr_n85325392)
print v(xbgr.mr_n85325984)
print v(xbgr.mr_n85326272)
print v(xbgr.mr_n85326624)
print v(xbgr.mr_n85328208)
print v(xbgr.mr_n85330032)
print v(xbgr.mr_n85332896)
print v(xbgr.mr_n85333472)
print v(xbgr.mr_n85335712)
print v(xbgr.mr_n85335984)
print v(xbgr.mr_n85336320)
print v(xbgr.mr_n85337680)
print v(xbgr.mr_n85338288)
print v(xbgr.mr_n85339232)
print v(xbgr.mr_n85340176)
print v(xbgr.mr_n85341120)
print v(xbgr.mr_n85342064)
print v(xbgr.mr_n85343008)
print v(xbgr.mr_n85343952)
print v(xbgr.mr_n85344896)
print v(xbgr.mr_n85345840)
print v(xbgr.mr_n85346784)
print v(xbgr.mr_n85347728)
print v(xbgr.mr_n85348672)
print v(xbgr.mr_n85349616)
print v(xbgr.mr_n85350560)
print v(xbgr.mr_n85351504)
print v(xbgr.mr_n85352448)
print v(xbgr.mr_n85353392)
print v(xbgr.mr_n85354336)
print v(xbgr.mr_n85355280)
print v(xbgr.mr_n85356224)
print v(xbgr.mr_n85357168)
print v(xbgr.mr_n85358112)
print v(xbgr.mr_n85359056)
print v(xbgr.mr_n85360000)
print v(xbgr.mr_n85360944)
print v(xbgr.mr_n85361888)
print v(xbgr.mr_n85362832)
print v(xbgr.mr_n85363776)
print v(xbgr.mr_n85364720)
print v(xbgr.mr_n85365664)
print v(xbgr.mr_n85366608)
print v(xbgr.mr_n85367552)
print v(xbgr.mr_n85368496)
print v(xbgr.mr_n85369440)
print v(xbgr.mr_n85370384)
print v(xbgr.mr_n85371328)
print v(xbgr.mr_n85372272)
print v(xbgr.mr_n85373216)
print v(xbgr.mr_n85374160)
print v(xbgr.mr_n85375104)
print v(xbgr.mr_n85376048)
print v(xbgr.mr_n85376992)
print v(xbgr.mr_n85377936)
print v(xbgr.mr_n85378880)
print v(xbgr.mr_n85379824)
print v(xbgr.mr_n85380768)
print v(xbgr.mr_n85381712)
print v(xbgr.mr_n85382656)
print v(xbgr.mr_n85383600)
print v(xbgr.mr_n85384544)
print v(xbgr.mr_n85385488)
print v(xbgr.mr_n85386432)
print v(xbgr.mr_n85387376)
print v(xbgr.mr_n85388320)
print v(xbgr.mr_n85389264)
print v(xbgr.mr_n85390208)
print v(xbgr.mr_n85391152)
print v(xbgr.mr_n85392096)
print v(xbgr.mr_n85393040)
print v(xbgr.mr_n85393984)
print v(xbgr.mr_n85394928)
print v(xbgr.mr_n85395872)
print v(xbgr.mr_n85396816)
print v(xbgr.mr_n85397760)
print v(xbgr.mr_n85398704)
print v(xbgr.mr_n85399648)
print v(xbgr.mr_n85400592)
print v(xbgr.mr_n85401536)
print v(xbgr.mr_n85402480)
print v(xbgr.mr_n85403424)
print v(xbgr.mr_n85404368)
print v(xbgr.mr_n85405312)
print v(xbgr.mr_n85406256)
print v(xbgr.mr_n85407200)
print v(xbgr.mr_n85408144)
print v(xbgr.mr_n85409088)
print v(xbgr.mr_n85410032)
print v(xbgr.mr_n85410960)
print v(xbgr.mr_n85411904)
print v(xbgr.mr_n85412848)
print v(xbgr.mr_n85413792)
print v(xbgr.mr_n85414736)
print v(xbgr.mr_n85415680)
print v(xbgr.mr_n85416624)
print v(xbgr.mr_n85417568)
print v(xbgr.mr_n85418512)
print v(xbgr.mr_n85419456)
print v(xbgr.mr_n85420400)
print v(xbgr.mr_n85421344)
print v(xbgr.mr_n85422288)
print v(xbgr.mr_n85422400)
print v(xbgr.mr_n85423232)
print v(xbgr.mr_n85424176)
print v(xbgr.mr_n85425120)
print v(xbgr.mr_n85426144)
print v(xbgr.mr_n85426256)
print v(xbgr.mr_n85426368)
print v(xbgr.mr_n85427216)
print v(xbgr.mr_n85427408)
print v(xbgr.mr_n85427600)
print v(xbgr.mr_n85427792)
print v(xbgr.mr_n85428704)
print v(xbgr.mr_n85428976)
print v(xbgr.mr_n85429168)
print v(xbgr.mr_n85429680)
print v(xbgr.mr_n85431264)
print v(xbgr.mr_n85433120)
print v(xbgr.mr_n85434640)
print v(xbgr.mr_n85434752)
print v(xbgr.mr_n85436496)
print v(xbgr.mr_n85436768)
print v(xbgr.mr_n85436960)
print v(xbgr.mr_n85437472)
print v(xbgr.mr_n85440656)
print v(xbgr.mr_n85440768)
print v(xbgr.mr_n85440880)
print v(xbgr.mr_n85440992)
print v(xbgr.mr_n85442736)
print v(xbgr.mr_n85443008)
print v(xbgr.mr_n85443200)
print v(xbgr.mr_n85443712)
print v(xbgr.mr_n85444944)
print v(xbgr.mr_n85445456)
print v(xbgr.mr_n85448304)
print v(xbgr.mr_n85448416)
print v(xbgr.mr_n85450160)
print v(xbgr.mr_n85450432)
print v(xbgr.mr_n85450624)
print v(xbgr.mr_n85451136)
print v(xbgr.mr_n85454320)
print v(xbgr.mr_n85454432)
print v(xbgr.mr_n85454544)
print v(xbgr.mr_n85454656)
print v(xbgr.mr_n85456400)
print v(xbgr.mr_n85456672)
print v(xbgr.mr_n85456864)
print v(xbgr.mr_n85457376)
print v(xbgr.mr_n85460560)
print v(xbgr.mr_n85460672)
print v(xbgr.mr_n85460784)
print v(xbgr.mr_n85460896)
print v(xbgr.mr_n85462640)
print v(xbgr.mr_n85462912)
print v(xbgr.mr_n85463104)
print v(xbgr.mr_n85463616)
print v(xbgr.mr_n85464848)
print v(xbgr.mr_n85465360)
print v(xbgr.mr_n85468208)
print v(xbgr.mr_n85468320)
print v(xbgr.mr_n85470064)
print v(xbgr.mr_n85470336)
print v(xbgr.mr_n85470528)
print v(xbgr.mr_n85471040)
print v(xbgr.mr_n85474224)
print v(xbgr.mr_n85474336)
print v(xbgr.mr_n85474448)
print v(xbgr.mr_n85474560)
print v(xbgr.mr_n85476304)
print v(xbgr.mr_n85476576)
print v(xbgr.mr_n85476768)
print v(xbgr.mr_n85477280)
print v(xbgr.mr_n85480464)
print v(xbgr.mr_n85480576)
print v(xbgr.mr_n85480688)
print v(xbgr.mr_n85480800)
print v(xbgr.mr_n85482544)
print v(xbgr.mr_n85482736)
print v(xbgr.mr_n85482928)
print v(xbgr.mr_n85483520)
print v(xbgr.mr_n85484752)
print v(xbgr.mr_n85485264)
print v(xbgr.mr_n85488112)
print v(xbgr.mr_n85488224)
print v(xbgr.mr_n85489968)
print v(xbgr.mr_n85490240)
print v(xbgr.mr_n85490432)
print v(xbgr.mr_n85490944)
print v(xbgr.mr_n85494128)
print v(xbgr.mr_n85494240)
print v(xbgr.mr_n85494352)
print v(xbgr.mr_n85494464)
print v(xbgr.mr_n85496208)
print v(xbgr.mr_n85496480)
print v(xbgr.mr_n85496672)
print v(xbgr.mr_n85497184)
print v(xbgr.mr_n85500368)
print v(xbgr.mr_n85500480)
print v(xbgr.mr_n85500592)
print v(xbgr.mr_n85500704)
print v(xbgr.mr_n85501040)
print v(xbgr.mr_n85502448)
print v(xbgr.mr_n85502720)
print v(xbgr.mr_n85502912)
print v(xbgr.mr_n85503424)
print v(xbgr.mr_n85504656)
print v(xbgr.mr_n85505168)
print v(xbgr.mr_n85508016)
print v(xbgr.mr_n85508208)
print v(xbgr.mr_n85508400)
print v(xbgr.mr_n85510208)
print v(xbgr.mr_n85510400)
print v(xbgr.mr_n85510912)
print v(xbgr.mr_n85512912)
print v(xbgr.mr_n85513024)
print v(xbgr.mr_n85513536)
print v(xbgr.mr_n85513648)
print v(xbgr.mr_n85514160)
print v(xbgr.mr_n85514272)
print v(xbgr.mr_n85515040)
print v(xbgr.mr_n85515152)
print v(xbgr.mr_n85515984)
print v(xbgr.mr_n85516096)
print v(xbgr.mr_n85517184)
print v(xbgr.mr_n85517296)
print v(xbgr.mr_n85518448)
print v(xbgr.mr_n85518560)
print v(xbgr.mr_n85519712)
print v(xbgr.mr_n85519824)
print v(xbgr.mr_n85520976)
print v(xbgr.mr_n85521088)
print v(xbgr.mr_n85522240)
print v(xbgr.mr_n85522352)
print v(xbgr.mr_n85523504)
print v(xbgr.mr_n85523616)
print v(xbgr.mr_n85524768)
print v(xbgr.mr_n85524880)
print v(xbgr.mr_n85526032)
print v(xbgr.mr_n85526144)
print v(xbgr.mr_n85527296)
print v(xbgr.mr_n85527408)
print v(xbgr.mr_n85528560)
print v(xbgr.mr_n85528672)
print v(xbgr.mr_n85529936)
print v(xbgr.mr_n85535632)
print v(xbgr.mr_n85537152)
print v(xbgr.mr_n85537792)
print v(xbgr.mr_n85543760)
print v(xbgr.mr_n85552256)
print v(xbgr.mr_n85557984)
print v(xbgr.mr_n85558240)
print v(xbgr.mr_n85558640)
print v(xbgr.mr_n85560832)
print v(xbgr.mr_n85560944)
print v(xbgr.mr_n85565552)
print v(xbgr.mr_n85565936)
print v(xbgr.mr_n85567312)
print v(xbgr.mr_n85568384)
print v(xbgr.mr_n85571344)
print v(xbgr.mr_n85572272)
print v(xbgr.mr_n85572880)
print v(xbgr.mr_n85574720)
print v(xbgr.mr_n85576816)
print v(xbgr.mr_n85577504)
print v(xbgr.mr_n85579568)
print v(xbgr.mr_n85581872)
print v(xbgr.mr_n85583568)
print v(xbgr.mr_n85583680)
print v(xbgr.mr_n85584448)
print v(xbgr.mr_n85584736)
print v(xbgr.mr_n85589984)
print v(xbgr.mr_n85590992)
print v(xbgr.mr_n85591936)
print v(xbgr.mr_n85592880)
print v(xbgr.mr_n85593824)
print v(xbgr.mr_n85594768)
print v(xbgr.mr_n85595712)
print v(xbgr.mr_n85596656)
print v(xbgr.mr_n85597600)
print v(xbgr.mr_n85598544)
print v(xbgr.mr_n85599488)
print v(xbgr.mr_n85600432)
print v(xbgr.mr_n85601376)
print v(xbgr.mr_n85602320)
print v(xbgr.mr_n85603264)
print v(xbgr.mr_n85604208)
print v(xbgr.mr_n85605152)
print v(xbgr.mr_n85606096)
print v(xbgr.mr_n85607040)
print v(xbgr.mr_n85607984)
print v(xbgr.mr_n85608928)
print v(xbgr.mr_n85609872)
print v(xbgr.mr_n85610816)
print v(xbgr.mr_n85611760)
print v(xbgr.mr_n85612704)
print v(xbgr.mr_n85613648)
print v(xbgr.mr_n85614592)
print v(xbgr.mr_n85615536)
print v(xbgr.mr_n85616480)
print v(xbgr.mr_n85619216)
print v(xbgr.mr_n85619472)
print v(xbgr.mr_n85622416)
print v(xbgr.mr_n85623360)
print v(xbgr.mr_n85624304)
print v(xbgr.mr_n85625440)
print v(xbgr.mr_n85630768)
print v(xbgr.mr_n85630960)
print v(xbgr.mr_n85631648)
print v(xbgr.mr_n85631760)
print v(xbgr.mr_n85631872)
print v(xbgr.mr_n85631984)
print v(xbgr.mr_n85632096)
print v(xbgr.mr_n85633840)
print v(xbgr.mr_n85634112)
print v(xbgr.mr_n85634304)
print v(xbgr.mr_n85634816)
print v(xbgr.mr_n85636752)
print v(xbgr.mr_n85638496)
print v(xbgr.mr_n85638768)
print v(xbgr.mr_n85638960)
print v(xbgr.mr_n85639472)
print v(xbgr.mr_n85641408)
print v(xbgr.mr_n85643152)
print v(xbgr.mr_n85643424)
print v(xbgr.mr_n85643616)
print v(xbgr.mr_n85644128)
print v(xbgr.mr_n85646144)
print v(xbgr.mr_n85646336)
print v(xbgr.mr_n85648144)
print v(xbgr.mr_n85648336)
print v(xbgr.mr_n85648848)
print v(xbgr.mr_n85650720)
print v(xbgr.mr_n85652464)
print v(xbgr.mr_n85652736)
print v(xbgr.mr_n85652928)
print v(xbgr.mr_n85653440)
print v(xbgr.mr_n85655376)
print v(xbgr.mr_n85657120)
print v(xbgr.mr_n85657392)
print v(xbgr.mr_n85657584)
print v(xbgr.mr_n85658096)
print v(xbgr.mr_n85660032)
print v(xbgr.mr_n85661776)
print v(xbgr.mr_n85662048)
print v(xbgr.mr_n85662240)
print v(xbgr.mr_n85662752)
print v(xbgr.mr_n85664688)
print v(xbgr.mr_n85664880)
print v(xbgr.mr_n85666432)
print v(xbgr.mr_n85666704)
print v(xbgr.mr_n85666896)
print v(xbgr.mr_n85667408)
print v(xbgr.mr_n85669344)
print v(xbgr.mr_n85671088)
print v(xbgr.mr_n85671360)
print v(xbgr.mr_n85671552)
print v(xbgr.mr_n85672064)
print v(xbgr.mr_n85674000)
print v(xbgr.mr_n85675744)
print v(xbgr.mr_n85676016)
print v(xbgr.mr_n85676208)
print v(xbgr.mr_n85676720)
print v(xbgr.mr_n85678656)
print v(xbgr.mr_n85680400)
print v(xbgr.mr_n85680592)
print v(xbgr.mr_n85680784)
print v(xbgr.mr_n85681376)
print v(xbgr.mr_n85683312)
print v(xbgr.mr_n85685056)
print v(xbgr.mr_n85685328)
print v(xbgr.mr_n85685520)
print v(xbgr.mr_n85686032)
print v(xbgr.mr_n85687968)
print v(xbgr.mr_n85689712)
print v(xbgr.mr_n85689984)
print v(xbgr.mr_n85690176)
print v(xbgr.mr_n85690688)
print v(xbgr.mr_n85692624)
print v(xbgr.mr_n85694304)
print v(xbgr.mr_n85694640)
print v(xbgr.mr_n85694832)
print v(xbgr.mr_n85695344)
print v(xbgr.mr_n85698352)
print v(xbgr.mr_n85699312)
print v(xbgr.mr_n85699952)
print v(xbgr.mr_n85702320)
print v(xbgr.mr_n85705280)
print v(xbgr.mr_n85705824)
print v(xbgr.mr_n85706800)
print v(xbgr.mr_n85707264)
print v(xbgr.mr_n85707728)
print v(xbgr.mr_n85709360)
print v(xbgr.mr_n85709744)
print v(xbgr.mr_n85710128)
print v(xbgr.mr_n85712672)
print v(xbgr.mr_n85713072)
print v(xbgr.mr_n85714272)
print v(xbgr.mr_n85714864)
print v(xbgr.mr_n85716064)
print v(xbgr.mr_n85717600)
print v(xbgr.mr_n85718624)
print v(xbgr.mr_n85719504)
print v(xbgr.mr_n85721200)
print v(xbgr.mr_n85722720)
print v(xbgr.mr_n85722960)
print v(xbgr.mr_n85727136)
print v(xbgr.mr_n85729072)
print v(xbgr.mr_n85731344)
print v(xbgr.mr_n85733376)
print v(xbgr.mr_n85734320)
print v(xbgr.mr_n85735456)
print v(xbgr.mr_n85735600)
print v(xbgr.mr_n85737328)
print v(xbgr.mr_n85741104)
print v(xbgr.mr_n85743152)
print v(xbgr.mr_n85743376)
print v(xbgr.mr_n85744368)
print v(xbgr.mr_n85746064)
print v(xbgr.mr_n85747120)
print v(xbgr.mr_n85748688)
print v(xbgr.mr_n85752112)
print v(xbgr.mr_n85752224)
print v(xbgr.mr_n85753648)
print v(xbgr.mr_n85754192)
print v(xbgr.mr_n85754384)
print v(xbgr.mr_n85758416)
print v(xbgr.mr_n85760096)
print v(xbgr.mr_n85760208)
print v(xbgr.mr_n85760640)
print v(xbgr.mr_n85761152)
print v(xbgr.mr_n85761264)
print v(xbgr.mr_n85761696)
print v(xbgr.mr_n85762208)
print v(xbgr.mr_n85762320)
print v(xbgr.mr_n85762752)
print v(xbgr.mr_n85763264)
print v(xbgr.mr_n85763376)
print v(xbgr.mr_n85763808)
print v(xbgr.mr_n85765072)
print v(xbgr.mr_n85765664)
print v(xbgr.mr_n85767136)
print v(xbgr.mr_n85771008)
print v(xbgr.mr_n85771120)
print v(xbgr.mr_n85771552)
print v(xbgr.mr_n85771744)
print v(xbgr.mr_n85773344)
print v(xbgr.mr_n85773968)
print v(xbgr.mr_n85774816)
print v(xbgr.mr_n85775312)
print v(xbgr.mr_n85775760)
print v(xbgr.mr_n85776400)
print v(xbgr.mr_n85778016)
print v(xbgr.mr_n85778912)
print v(xbgr.mr_n85780576)
print v(xbgr.mr_n85781040)
print v(xbgr.mr_n85781616)
print v(xbgr.mr_n85782080)
print v(xbgr.mr_n85782880)
print v(xbgr.mr_n85784048)
print v(xbgr.mr_n85785136)
print v(xbgr.mr_n85785632)
print v(xbgr.mr_n85788448)
print v(xbgr.mr_n85788896)
print v(xbgr.mr_n85789168)
print v(xbgr.mr_n85789360)
print v(xbgr.mr_n85789616)
print v(xbgr.mr_n85789760)
print v(xbgr.mr_n85790480)
print v(xbgr.mr_n85790800)
print v(xbgr.mr_n85792160)
print v(xbgr.mr_n85793408)
print v(xbgr.mr_n85796208)
print v(xbgr.mr_n85799760)
print v(xbgr.mr_n85800224)
print v(xbgr.mr_n85800416)
print v(xbgr.mr_n85800880)
print v(xbgr.mr_n85801072)
print v(xbgr.mr_n85802016)
print v(xbgr.mr_n85802208)
print v(xbgr.mr_n85802544)
print v(xbgr.mr_n85803008)
print v(xbgr.mr_n85803472)
print v(xbgr.mr_n85803872)
print v(xbgr.mr_n85805568)
print v(xbgr.mr_n85805968)
print v(xbgr.mr_n85806368)
print v(xbgr.mr_n85807120)
print v(xbgr.mr_n85807392)
print v(xbgr.mr_n85807584)
print v(xbgr.mr_n85808832)
print v(xbgr.mr_n85810000)
print v(xbgr.mr_n85811664)
print v(xbgr.mr_n85816352)
print v(xbgr.mr_n85816464)
print v(xbgr.mr_n85817344)
print v(xbgr.mr_n85818032)
print v(xbgr.mr_n85818720)
print v(xbgr.mr_n85819408)
print v(xbgr.mr_n85820096)
print v(xbgr.mr_n85820784)
print v(xbgr.mr_n85821472)
print v(xbgr.mr_n85822160)
print v(xbgr.mr_n85822848)
print v(xbgr.mr_n85823536)
print v(xbgr.mr_n85824224)
print v(xbgr.mr_n85824912)
print v(xbgr.mr_n85825600)
print v(xbgr.mr_n85826288)
print v(xbgr.mr_n85826976)
print v(xbgr.mr_n85827664)
print v(xbgr.mr_n85828352)
print v(xbgr.mr_n85829040)
print v(xbgr.mr_n85829728)
print v(xbgr.mr_n85830416)
print v(xbgr.mr_n85831104)
print v(xbgr.mr_n85831808)
print v(xbgr.mr_n85831920)
print v(xbgr.mr_n85832512)
print v(xbgr.mr_n85832624)
print v(xbgr.mr_n85833136)
print v(xbgr.mr_n85833248)
print v(xbgr.mr_n85833760)
print v(xbgr.mr_n85833872)
print v(xbgr.mr_n85834384)
print v(xbgr.mr_n85834496)
print v(xbgr.mr_n85835008)
print v(xbgr.mr_n85835120)
print v(xbgr.mr_n85835632)
print v(xbgr.mr_n85835744)
print v(xbgr.mr_n85836256)
print v(xbgr.mr_n85836368)
print v(xbgr.mr_n85836880)
print v(xbgr.mr_n85836992)
print v(xbgr.mr_n85837504)
print v(xbgr.mr_n85837616)
print v(xbgr.mr_n85839920)
print v(xbgr.mr_n85840032)
print v(xbgr.mr_n85840864)
print v(xbgr.mr_n85840976)
print v(xbgr.mr_n85842064)
print v(xbgr.mr_n85842176)
print v(xbgr.mr_n85843328)
print v(xbgr.mr_n85843440)
print v(xbgr.mr_n85844592)
print v(xbgr.mr_n85844704)
print v(xbgr.mr_n85845856)
print v(xbgr.mr_n85845968)
print v(xbgr.mr_n85849280)
print v(xbgr.mr_n85854016)
print v(xbgr.mr_n85856896)
print v(xbgr.mr_n85862528)
print v(xbgr.mr_n85864208)
print v(xbgr.mr_n85864576)
print v(xbgr.mr_n85864768)
print v(xbgr.mr_n85864960)
print v(xbgr.mr_n85865152)
print v(xbgr.mr_n85867472)
print v(xbgr.mr_n85867744)
print v(xbgr.mr_n85867936)
print v(xbgr.mr_n85868448)
print v(xbgr.mr_n85868560)
print v(xbgr.mr_n85868672)
print v(xbgr.mr_n85868784)
print v(xbgr.mr_n85868976)
print v(xbgr.mr_n85869168)
print v(xbgr.mr_n85869360)
print v(xbgr.mr_n85872928)
print v(xbgr.mr_n85892480)
print v(xbgr.mr_n85894096)
print v(xbgr.mr_n85895776)
print v(xbgr.mr_n85898032)
print v(xbgr.mr_n85900288)
print v(xbgr.mr_n85902544)
print v(xbgr.mr_n85904800)
print v(xbgr.mr_n85917136)
print v(xbgr.mr_n85922320)
print v(xbgr.mr_n85926096)
print v(xbgr.mr_n85926672)
print v(xbgr.mr_n85927360)
print v(xbgr.mr_n85927936)
print v(xbgr.mr_n85928624)
print v(xbgr.mr_n85929200)
print v(xbgr.mr_n85929888)
print v(xbgr.mr_n85930464)
print v(xbgr.mr_n85931152)
print v(xbgr.mr_n85931856)
print v(xbgr.mr_n85932416)
print v(xbgr.mr_n85932848)
print v(xbgr.mr_n85933680)
print v(xbgr.mr_n85934112)
print v(xbgr.mr_n85934944)
print v(xbgr.mr_n85936656)
print v(xbgr.mr_n85943392)
print v(xbgr.mr_n85945696)
print v(xbgr.mr_n85946400)
print v(xbgr.mr_n85955344)
print v(xbgr.mr_n85965680)
print v(xbgr.mr_n85968528)
print v(xbgr.mr_n85969488)
print v(xbgr.mr_n85970400)
print v(xbgr.mr_n85970512)
print v(xbgr.mr_n85970624)
print v(xbgr.mr_n85970736)
print v(xbgr.mr_n85970848)
print v(xbgr.mr_n85970960)
print v(xbgr.mr_n85971072)
print v(xbgr.mr_n85971184)
print v(xbgr.mr_n85971296)
print v(xbgr.mr_n85971408)
print v(xbgr.mr_n85971840)
print v(xbgr.mr_n85972320)
print v(xbgr.mr_n85972512)
print v(xbgr.mr_n85972704)
print v(xbgr.mr_n85973344)
print v(xbgr.mr_n85975008)
print v(xbgr.mr_n85975200)
print v(xbgr.mr_n85975952)
print v(xbgr.mr_n85976224)
print v(xbgr.mr_n85976624)
print v(xbgr.mr_n85977024)
print v(xbgr.mr_n85977920)
print v(xbgr.mr_n85980304)
print v(xbgr.mr_n85980816)
print v(xbgr.mr_n85980928)
print v(xbgr.mr_n85981440)
print v(xbgr.mr_n85981552)
print v(xbgr.mr_n85982064)
print v(xbgr.mr_n85982176)
print v(xbgr.mr_n85982688)
print v(xbgr.mr_n85982800)
print v(xbgr.mr_n85983312)
print v(xbgr.mr_n85983424)
print v(xbgr.mr_n85983936)
print v(xbgr.mr_n85984048)
print v(xbgr.mr_n85984560)
print v(xbgr.mr_n85984672)
print v(xbgr.mr_n85985184)
print v(xbgr.mr_n85985296)
print v(xbgr.mr_n85991872)
print v(xbgr.mr_n85998720)
print v(xbgr.mr_n85999408)
print v(xbgr.mr_n86000096)
print v(xbgr.mr_n86000784)
print v(xbgr.mr_n86001472)
print v(xbgr.mr_n86002160)
print v(xbgr.mr_n86002848)
print v(xbgr.mr_n86003536)
print v(xbgr.mr_n86004224)
print v(xbgr.mr_n86004912)
print v(xbgr.mr_n86006336)
print v(xbgr.mr_n86007920)
print v(xbgr.mr_n86008864)
print v(xbgr.mr_n86009808)
print v(xbgr.mr_n86010752)
print v(xbgr.mr_n86011696)
print v(xbgr.mr_n86012640)
print v(xbgr.mr_n86012976)
print v(xbgr.mr_n86013584)
print v(xbgr.mr_n86021536)
print v(xbgr.mr_n86021920)
print v(xbgr.mr_n86023456)
print v(xbgr.mr_n86024224)
print v(xbgr.mr_n86026144)
print v(xbgr.mr_n86026528)
print v(xbgr.mr_n86026912)
print v(xbgr.mr_n86027296)
print v(xbgr.mr_n86027760)
print v(xbgr.mr_n86028144)
print v(xbgr.mr_n86028832)
print v(xbgr.mr_n86029216)
print v(xbgr.mr_n86029600)
print v(xbgr.mr_n86030752)
print v(xbgr.mr_n86031136)
print v(xbgr.mr_n86033744)
print v(xbgr.mr_n86034224)
print v(xbgr.mr_n86034512)
print v(xbgr.mr_n86035728)
print v(xbgr.mr_n86037792)
print v(xbgr.mr_n86038240)
print v(xbgr.mr_n86039008)
print v(xbgr.mr_n86040128)
print v(xbgr.mr_n86042368)
print v(xbgr.mr_n86044048)
print v(xbgr.mr_n86046624)
print v(xbgr.mr_n86048128)
print v(xbgr.mr_n86048272)
print v(xbgr.mr_n86056528)
print v(xbgr.mr_n86056752)
print v(xbgr.mr_n86058704)
print v(xbgr.mr_n86058960)
print v(xbgr.mr_n86059328)
print v(xbgr.mr_n86060528)
print v(xbgr.mr_n86060720)
print v(xbgr.mr_n86062336)
print v(xbgr.mr_n86067472)
print v(xbgr.mr_n86067984)
print v(xbgr.mr_n86068288)
print v(xbgr.mr_n86068560)
print v(xbgr.mr_n86069200)
print v(xbgr.mr_n86069632)
print v(xbgr.mr_n86070144)
print v(xbgr.mr_n86070256)
print v(xbgr.mr_n86070688)
print v(xbgr.mr_n86071200)
print v(xbgr.mr_n86071312)
print v(xbgr.mr_n86071744)
print v(xbgr.mr_n86072256)
print v(xbgr.mr_n86072368)
print v(xbgr.mr_n86072800)
print v(xbgr.mr_n86078832)
print v(xbgr.mr_n86079936)
print v(xbgr.mr_n86081472)
print v(xbgr.mr_n86082752)
print v(xbgr.mr_n86083936)
print v(xbgr.mr_n86084480)
print v(xbgr.mr_n86085760)
print v(xbgr.mr_n86085952)
print v(xbgr.mr_n86087280)
print v(xbgr.mr_n86087792)
print v(xbgr.mr_n86087968)
print v(xbgr.mr_n86090944)
print v(xbgr.mr_n86094512)
print v(xbgr.mr_n86094624)
print v(xbgr.mr_n86097792)
print v(xbgr.mr_n86098816)
print v(xbgr.mr_n86102640)
print v(xbgr.mr_n86102752)
print v(xbgr.mr_n86103536)
print v(xbgr.mr_n86104640)
print v(xbgr.mr_n86107360)
print v(xbgr.mr_n86110016)
print v(xbgr.mr_n86110240)
print v(xbgr.mr_n86110752)
print v(xbgr.mr_n86112000)
print v(xbgr.mr_n86117232)
print v(xbgr.mr_n86117424)
print v(xbgr.mr_n86117632)
print v(xbgr.mr_n86122768)
print v(xbgr.mr_n86123232)
print v(xbgr.mr_n86123424)
print v(xbgr.mr_n86123888)
print v(xbgr.mr_n86124080)
print v(xbgr.mr_n86124544)
print v(xbgr.mr_n86124992)
print v(xbgr.mr_n86125184)
print v(xbgr.mr_n86125664)
print v(xbgr.mr_n86125856)
print v(xbgr.mr_n86126256)
print v(xbgr.mr_n86126928)
print v(xbgr.mr_n86127872)
print v(xbgr.mr_n86128688)
print v(xbgr.mr_n86129024)
print v(xbgr.mr_n86129968)
print v(xbgr.mr_n86130304)
print v(xbgr.mr_n86130768)
print v(xbgr.mr_n86131232)
print v(xbgr.mr_n86131696)
print v(xbgr.mr_n86132640)
print v(xbgr.mr_n86132976)
print v(xbgr.mr_n86133440)
print v(xbgr.mr_n86133904)
print v(xbgr.mr_n86134368)
print v(xbgr.mr_n86135376)
print v(xbgr.mr_n86135712)
print v(xbgr.mr_n86136336)
print v(xbgr.mr_n86140832)
print v(xbgr.mr_n86141440)
print v(xbgr.mr_n86141904)
print v(xbgr.mr_n86142096)
print v(xbgr.mr_n86143184)
print v(xbgr.mr_n86143584)
print v(xbgr.mr_n86143776)
print v(xbgr.mr_n86144240)
print v(xbgr.mr_n86144672)
print v(xbgr.mr_n86144864)
print v(xbgr.mr_n86145488)
print v(xbgr.mr_n86146976)
print v(xbgr.mr_n86148144)
print v(xbgr.mr_n86150912)
print v(xbgr.mr_n86154752)
print v(xbgr.mr_n86154864)
print v(xbgr.mr_n86155296)
print v(xbgr.mr_n86155808)
print v(xbgr.mr_n86155920)
print v(xbgr.mr_n86156352)
print v(xbgr.mr_n86156864)
print v(xbgr.mr_n86156976)
print v(xbgr.mr_n86157408)
print v(xbgr.mr_n86157920)
print v(xbgr.mr_n86158032)
print v(xbgr.mr_n86158464)
print v(xbgr.mr_n86158976)
print v(xbgr.mr_n86159088)
print v(xbgr.mr_n86159520)
print v(xbgr.mr_n86160032)
print v(xbgr.mr_n86160144)
print v(xbgr.mr_n86160576)
print v(xbgr.mr_n86161088)
print v(xbgr.mr_n86161200)
print v(xbgr.mr_n86161632)
print v(xbgr.mr_n86162144)
print v(xbgr.mr_n86162256)
print v(xbgr.mr_n86162688)
print v(xbgr.mr_n86163200)
print v(xbgr.mr_n86163312)
print v(xbgr.mr_n86163744)
print v(xbgr.mr_n86164832)
print v(xbgr.mr_n86164944)
print v(xbgr.mr_n86165824)
print v(xbgr.mr_n86166512)
print v(xbgr.mr_n86167200)
print v(xbgr.mr_n86167888)
print v(xbgr.mr_n86168576)
print v(xbgr.mr_n86169264)
print v(xbgr.mr_n86169952)
print v(xbgr.mr_n86170640)
print v(xbgr.mr_n86171328)
print v(xbgr.mr_n86172016)
print v(xbgr.mr_n86172704)
print v(xbgr.mr_n86173392)
print v(xbgr.mr_n86174080)
print v(xbgr.mr_n86174768)
print v(xbgr.mr_n86175456)
print v(xbgr.mr_n86176144)
print v(xbgr.mr_n86176832)
print v(xbgr.mr_n86177520)
print v(xbgr.mr_n86178208)
print v(xbgr.mr_n86179312)
print v(xbgr.mr_n86180544)
print v(xbgr.mr_n86181488)
print v(xbgr.mr_n86182432)
print v(xbgr.mr_n86183376)
print v(xbgr.mr_n86184320)
print v(xbgr.mr_n86185264)
print v(xbgr.mr_n86186208)
print v(xbgr.mr_n86187152)
print v(xbgr.mr_n86188096)
print v(xbgr.mr_n86189040)
print v(xbgr.mr_n86189984)
print v(xbgr.mr_n86190928)
print v(xbgr.mr_n86191872)
print v(xbgr.mr_n86192816)
print v(xbgr.mr_n86193760)
print v(xbgr.mr_n86194704)
print v(xbgr.mr_n86195648)
print v(xbgr.mr_n86196592)
print v(xbgr.mr_n86197536)
print v(xbgr.mr_n86198480)
print v(xbgr.mr_n86199424)
print v(xbgr.mr_n86200368)
print v(xbgr.mr_n86201312)
print v(xbgr.mr_n86202256)
print v(xbgr.mr_n86203200)
print v(xbgr.mr_n86204144)
print v(xbgr.mr_n86208944)
print v(xbgr.mr_n86209200)
print v(xbgr.mr_n86209456)
print v(xbgr.mr_n86209712)
print v(xbgr.mr_n86209968)
print v(xbgr.mr_n86210224)
print v(xbgr.mr_n86213024)
print v(xbgr.mr_n86213472)
print v(xbgr.mr_n86213664)
print v(xbgr.mr_n86213856)
print v(xbgr.mr_n86214048)
print v(xbgr.mr_n86214240)
print v(xbgr.mr_n86214432)
print v(xbgr.mr_n86214688)
print v(xbgr.mr_n86219696)
print v(xbgr.mr_n86231088)
print v(xbgr.mr_n86235440)
print v(xbgr.mr_n86236720)
print v(xbgr.mr_n86236912)
print v(xbgr.mr_n86254048)
print v(xbgr.mr_n86254192)
print v(xbgr.mr_n86254336)
print v(xbgr.mr_n86254928)
print v(xbgr.mr_n86256208)
print v(xbgr.mr_n86256816)
print v(xbgr.mr_n86257616)
print v(xbgr.mr_n86261472)
print v(xbgr.mr_n86262304)
print v(xbgr.mr_n86263488)
print v(xbgr.mr_n86265632)
print v(xbgr.mr_n86265984)
print v(xbgr.mr_n86266320)
print v(xbgr.mr_n86266512)
print v(xbgr.mr_n86269024)
print v(xbgr.mr_n86269360)
print v(xbgr.mr_n86269696)
print v(xbgr.mr_n86269840)
print v(xbgr.mr_n86270032)
print v(xbgr.mr_n86270224)
print v(xbgr.mr_n86273040)
print v(xbgr.mr_n86551488)
print v(xbgr.mr_n86640768)
print v(xbgr.mr_n86653008)
print v(xbgr.mr_n86658736)
print v(xbgr.mr_n86659296)
print v(xbgr.mr_n86682160)
print v(xbgr.mr_n86685488)
print v(xbgr.mr_n86687152)
print v(xbgr.mr_n86702928)
print v(xbgr.mr_n86703248)
print v(xbgr.mr_n86703744)
print v(xbgr.mr_n86773264)
print v(xbgr.mr_n86773456)
print v(xbgr.mr_n86803136)
print v(xbgr.mr_n86805632)
print v(xbgr.mr_n86805840)
print v(xbgr.mr_n86806064)
print v(xbgr.mr_n86806432)
print v(xbgr.mr_n86806896)
print v(xbgr.mr_n86807376)
print v(xbgr.mr_n86875072)
print v(xbgr.mr_n86915088)
print v(xbgr.mr_n86936976)
print v(xbgr.mr_n86937168)
print v(xbgr.mr_n86937680)
print v(xbgr.mr_n87021840)
print v(xbgr.mr_n87026512)
print v(xbgr.mr_n87027728)
print v(xbgr.mr_n87035328)
print v(xbgr.mr_n87036224)
print v(xbgr.mr_n87036416)
print v(xbgr.mr_n87070352)
print v(xbgr.mr_n87070576)
print v(xbgr.mr_n87071376)
print v(xbgr.mr_n87072240)
print v(xbgr.mr_n87081136)
print v(xbgr.mr_n87097200)
print v(xbgr.mr_n87098848)
print v(xbgr.mr_n87099072)
print v(xbgr.mr_n87123200)
print v(xbgr.mr_n87124256)
print v(xbgr.mr_n87124432)
print v(xbgr.mr_n87125648)
print v(xbgr.mr_n87129920)
print v(xbgr.mr_n87140832)
print v(xbgr.mr_n87142512)
print v(xbgr.mr_n87172400)
print v(xbgr.mr_n87182368)
print v(xbgr.mr_n87187392)
print v(xbgr.mr_n87207376)
print v(xbgr.mr_n87211456)
print v(xbgr.mr_n87216864)
print v(xbgr.mr_n87220352)
print v(xbgr.mr_n87260688)
print v(xbgr.mr_n87260880)
print v(xbgr.mr_n87272288)
print v(xbgr.mr_n87276576)
print v(xbgr.mr_n87276912)
print v(xbgr.mr_n87301808)
print v(xbgr.mr_n87304192)
print v(xbgr.mr_n87313104)
print v(xbgr.mr_n87316560)
print v(xbgr.mr_n87320992)
print v(xbgr.mr_n87321760)
print v(xbgr.mr_n87322464)
print v(xbgr.mr_n87338704)
print v(xbgr.mr_n87347120)
print v(xbgr.mr_n87357648)
print v(xbgr.mr_n87357840)
print v(xbgr.mr_n87358544)
print v(xbgr.mr_n87358656)
print v(xbgr.mr_n87359008)
print v(xbgr.mr_n87359280)
print v(xbgr.n1)
print v(xbgr.n_10)
print v(xbgr.n_11)
print v(xbgr.n_12)
print v(xbgr.n_13)
print v(xbgr.n_14)
print v(xbgr.n_15)
print v(xbgr.n_16)
print v(xbgr.n_17)
print v(xbgr.n_18)
print v(xbgr.n_19)
print v(xbgr.n_2)
print v(xbgr.n_21)
print v(xbgr.n_22)
print v(xbgr.n_23)
print v(xbgr.n_24)
print v(xbgr.n_25)
print v(xbgr.n_26)
print v(xbgr.n_27)
print v(xbgr.n_3)
print v(xbgr.n_30)
print v(xbgr.n_31)
print v(xbgr.n_33)
print v(xbgr.n_34)
print v(xbgr.n_36)
print v(xbgr.n_37)
print v(xbgr.n_4)
print v(xbgr.n_5)
print v(xbgr.n_6)
print v(xbgr.n_7)
print v(xbgr.n_8)
print v(xbgr.n_9)
print v(pbias)
print v(pcasc)
print v(r4)
print v(xbgr.r4n)
print v(xbgr.vb2)
print v(vbe)
print v(xbgr.vbe3)
print v(xbgr.vd1)
print v(xbgr.vd2)
print v(vdd)
print v(vref)
print v(vdd)-v(vdd)
echo METALLIC_ALL_NODE_VOLTAGES_END
quit
.endc
.end
