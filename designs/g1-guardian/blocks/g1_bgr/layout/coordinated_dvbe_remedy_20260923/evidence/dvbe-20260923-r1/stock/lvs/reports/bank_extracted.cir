* Extracted by KLayout with SG13G2 LVS runset on : 23/09/2026 09:16

* cell g1_bgr
* pin dvbe
* pin iptat
* pin pbias
* pin pcasc
* pin r4
* pin vbe
* pin vdd
* pin vref
* pin vss
.SUBCKT g1_bgr dvbe iptat pbias pcasc r4 vbe vdd vref vss
* device instance $1 r0 *1 362.445,10.605 rppd
R$1 \$16 vref vss rppd w=1u l=320.79u ps=0u b=0 m=4
* device instance $25 r0 *1 385.495,12.835 rhigh
R$25 vss \$10 vss rhigh w=0.5u l=735u ps=0u b=0 m=1
* device instance $40 r0 *1 20.445,11.585 rppd
R$40 vss dvbe vss rppd w=1u l=51.5u ps=0u b=0 m=24
* device instance $64 r0 *1 43.245,13.335 rppd
R$64 \$18 \$17 vss rppd w=1u l=192u ps=0u b=0 m=24
* device instance $209 r0 *1 261.745,74.34 rppd
R$209 pcasc pbias vss rppd w=1u l=500u ps=0u b=0 m=24
* device instance $400 r0 *1 395.44,162.86 sg13_hv_pmos
M$400 vdd r4 \$I11 vdd sg13_hv_pmos L=0.5u W=2u AS=0.68p AD=0.68p PS=4.68u
+ PD=4.68u rfmode=0
* device instance $401 r0 *1 405.36,162.86 sg13_hv_nmos
M$401 \$20 r4 vbe vss sg13_hv_nmos L=0.5u W=2u AS=0.68p AD=0.68p PS=4.68u
+ PD=4.68u rfmode=0
* device instance $402 r0 *1 375.6,162.86 sg13_hv_pmos
M$402 \$I6 pcasc iptat \$I6 sg13_hv_pmos L=4u W=10u AS=3.4p AD=3.4p PS=20.68u
+ PD=20.68u rfmode=0
* device instance $403 r0 *1 385.52,162.86 sg13_hv_pmos
M$403 vdd \$10 \$I10 vdd sg13_hv_pmos L=0.5u W=2u AS=0.68p AD=0.68p PS=4.68u
+ PD=4.68u rfmode=0
* device instance $404 r0 *1 385.52,147.62 sg13_hv_pmos
M$404 \$I4 pcasc \$I7 \$I4 sg13_hv_pmos L=4u W=240u AS=81.6p AD=81.6p
+ PS=496.32u PD=496.32u rfmode=0
* device instance $428 r0 *1 236.77,178.1 sg13_hv_nmos
M$428 vss \$I11 \$20 vss sg13_hv_nmos L=0.6u W=1u AS=0.34p AD=0.34p PS=2.68u
+ PD=2.68u rfmode=0
* device instance $429 r0 *1 365.68,162.86 sg13_hv_pmos
M$429 \$I5 pcasc vref \$I5 sg13_hv_pmos L=4u W=40u AS=13.6p AD=13.6p PS=82.72u
+ PD=82.72u rfmode=0
* device instance $433 r0 *1 206.96,178.1 sg13_hv_nmos
M$433 vss \$I10 pbias vss sg13_hv_nmos L=4u W=1u AS=0.34p AD=0.34p PS=2.68u
+ PD=2.68u rfmode=0
* device instance $434 r0 *1 216.93,178.1 sg13_hv_nmos
M$434 vss \$10 \$I10 vss sg13_hv_nmos L=0.6u W=1u AS=0.34p AD=0.34p PS=2.68u
+ PD=2.68u rfmode=0
* device instance $435 r0 *1 226.8,178.1 sg13_hv_nmos
M$435 vss r4 \$I11 vss sg13_hv_nmos L=0.5u W=1u AS=0.34p AD=0.34p PS=2.68u
+ PD=2.68u rfmode=0
* device instance $436 r0 *1 249.65,343.72 sg13_hv_nmos
M$436 \$I7 \$17 vbe vss sg13_hv_nmos L=1u W=480u AS=163.2p AD=163.2p PS=992.64u
+ PD=992.64u rfmode=0
* device instance $460 r0 *1 360.76,256.04 sg13_hv_pmos
M$460 vdd pbias \$I5 vdd sg13_hv_pmos L=4u W=40u AS=13.6p AD=13.6p PS=85.44u
+ PD=85.44u rfmode=0
* device instance $468 r0 *1 390.52,256.04 sg13_hv_pmos
M$468 vdd pbias \$I6 vdd sg13_hv_pmos L=4u W=10u AS=3.4p AD=3.4p PS=21.36u
+ PD=21.36u rfmode=0
* device instance $470 r0 *1 400.44,256.04 sg13_hv_pmos
M$470 vdd pbias \$10 vdd sg13_hv_pmos L=4u W=10u AS=3.4p AD=3.4p PS=21.36u
+ PD=21.36u rfmode=0
* device instance $496 r0 *1 255.87,328.68 sg13_hv_nmos
M$496 \$21 \$17 pcasc vss sg13_hv_nmos L=1u W=480u AS=163.2p AD=163.2p
+ PS=992.64u PD=992.64u rfmode=0
* device instance $520 r0 *1 246.64,147.62 sg13_hv_pmos
M$520 \$I8 pcasc \$17 \$I8 sg13_hv_pmos L=4u W=240u AS=81.6p AD=81.6p
+ PS=496.32u PD=496.32u rfmode=0
* device instance $544 r0 *1 345.84,162.86 sg13_hv_pmos
M$544 \$I9 pcasc pbias \$I9 sg13_hv_pmos L=4u W=240u AS=81.6p AD=81.6p
+ PS=496.32u PD=496.32u rfmode=0
* device instance $568 r0 *1 211.96,225.32 sg13_hv_pmos
M$568 vdd pbias \$I4 vdd sg13_hv_pmos L=4u W=240u AS=81.6p AD=81.6p PS=512.64u
+ PD=512.64u rfmode=0
* device instance $616 r0 *1 211.96,235.56 sg13_hv_pmos
M$616 vdd pbias \$I9 vdd sg13_hv_pmos L=4u W=240u AS=81.6p AD=81.6p PS=512.64u
+ PD=512.64u rfmode=0
* device instance $664 r0 *1 321.08,286.76 sg13_hv_pmos
M$664 vdd pbias \$I8 vdd sg13_hv_pmos L=4u W=240u AS=81.6p AD=81.6p PS=512.64u
+ PD=512.64u rfmode=0
* device instance $736 r0 *1 160.7,142.9 npn13G2
Q$736 \$I12 \$I12 vss vss npn13G2 we=70n le=900n Nx=1 m=24
* device instance $760 r0 *1 85.8,142.9 npn13G2
Q$760 vbe vbe vss vss npn13G2 we=70n le=900n Nx=1 m=24
* device instance $784 r0 *1 182.1,154.01 npn13G2
Q$784 vbe \$20 vss vss npn13G2 we=70n le=900n Nx=1 m=24
* device instance $808 r0 *1 53.7,287.33 npn13G2
Q$808 \$21 vbe dvbe vss npn13G2 we=70n le=900n Nx=1 m=192
* device instance $1000 r0 *1 96.5,220.67 npn13G2
Q$1000 \$18 \$18 \$I12 vss npn13G2 we=70n le=900n Nx=1 m=24
* device instance $1024 r0 *1 107.2,231.78 npn13G2
Q$1024 \$16 \$16 vss vss npn13G2 we=70n le=900n Nx=1 m=4
* device instance $1028 r0 *1 182.1,231.78 npn13G2
Q$1028 vss vss vss vss npn13G2 we=70n le=900n Nx=1 m=9
.ENDS g1_bgr
