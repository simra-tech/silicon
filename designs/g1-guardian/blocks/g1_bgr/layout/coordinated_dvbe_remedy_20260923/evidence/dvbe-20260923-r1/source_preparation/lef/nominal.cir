* G1_BGR standalone capacitance-PEX qualification
.lib /foss/pdks/ihp-sg13g2/libs.tech/ngspice/models/cornerHBT.lib hbt_typ
.lib /foss/pdks/ihp-sg13g2/libs.tech/ngspice/models/cornerMOShv.lib mos_tt
.lib /foss/pdks/ihp-sg13g2/libs.tech/ngspice/models/cornerRES.lib res_typ
.include conditional_metal.spice
.option seed=44001 gmin=1e-15 abstol=1e-14 reltol=1e-5 vntol=1e-7
.global sub!
Vsub sub! 0 0
Vdd vdd 0 3.3
Vr4 r4 0 0
Xbgr vdd 0 r4 vref iptat pbias pcasc vbe dvbe g1_bgr
Vload iptat 0 1
Cload vref 0 1e-12
.control
set num_threads=1
set numdgt=15
set wr_singlescale
set wr_vecnames
op
echo RAW_CURRENT_LEDGER_BEGIN
print @n.xbgr.xr1.nr1[ibody]
print @n.xbgr.xr2.nr1[ibody]
print @n.xbgr.xr3.nr1[ibody]
print @n.xbgr.xr4.nr1[ibody]
print @n.xbgr.xr5.nr1[ibody]
print @n.xbgr.xr6.nr1[ibody]
print @n.xbgr.xr7.nr1[ibody]
print @n.xbgr.xr8.nr1[ibody]
print @n.xbgr.xr9.nr1[ibody]
print @n.xbgr.xr10.nr1[ibody]
print @n.xbgr.xr11.nr1[ibody]
print @n.xbgr.xr12.nr1[ibody]
print @n.xbgr.xr13.nr1[ibody]
print @n.xbgr.xr14.nr1[ibody]
print @n.xbgr.xr15.nr1[ibody]
print @n.xbgr.xr16.nr1[ibody]
print @n.xbgr.xr17.nr1[ibody]
print @n.xbgr.xr18.nr1[ibody]
print @n.xbgr.xr19.nr1[ibody]
print @n.xbgr.xr20.nr1[ibody]
print @n.xbgr.xr21.nr1[ibody]
print @n.xbgr.xr22.nr1[ibody]
print @n.xbgr.xr23.nr1[ibody]
print @n.xbgr.xr24.nr1[ibody]
print @n.xbgr.xr25.nr1[ibody]
print @n.xbgr.xr26.nr1[ibody]
print @n.xbgr.xm27.nsg13_hv_pmos[ide]
print @n.xbgr.xm27.nsg13_hv_pmos[ige]
print @n.xbgr.xm27.nsg13_hv_pmos[ise]
print @n.xbgr.xm27.nsg13_hv_pmos[ibe]
print @n.xbgr.xm27.nsg13_hv_pmos[ctype]
print @n.xbgr.xm28.nsg13_hv_pmos[ide]
print @n.xbgr.xm28.nsg13_hv_pmos[ige]
print @n.xbgr.xm28.nsg13_hv_pmos[ise]
print @n.xbgr.xm28.nsg13_hv_pmos[ibe]
print @n.xbgr.xm28.nsg13_hv_pmos[ctype]
print @n.xbgr.xm29.nsg13_hv_nmos[ide]
print @n.xbgr.xm29.nsg13_hv_nmos[ige]
print @n.xbgr.xm29.nsg13_hv_nmos[ise]
print @n.xbgr.xm29.nsg13_hv_nmos[ibe]
print @n.xbgr.xm29.nsg13_hv_nmos[ctype]
print @n.xbgr.xm30.nsg13_hv_nmos[ide]
print @n.xbgr.xm30.nsg13_hv_nmos[ige]
print @n.xbgr.xm30.nsg13_hv_nmos[ise]
print @n.xbgr.xm30.nsg13_hv_nmos[ibe]
print @n.xbgr.xm30.nsg13_hv_nmos[ctype]
print @n.xbgr.xm31.nsg13_hv_nmos[ide]
print @n.xbgr.xm31.nsg13_hv_nmos[ige]
print @n.xbgr.xm31.nsg13_hv_nmos[ise]
print @n.xbgr.xm31.nsg13_hv_nmos[ibe]
print @n.xbgr.xm31.nsg13_hv_nmos[ctype]
print @n.xbgr.xm32.nsg13_hv_nmos[ide]
print @n.xbgr.xm32.nsg13_hv_nmos[ige]
print @n.xbgr.xm32.nsg13_hv_nmos[ise]
print @n.xbgr.xm32.nsg13_hv_nmos[ibe]
print @n.xbgr.xm32.nsg13_hv_nmos[ctype]
print @n.xbgr.xm33.nsg13_hv_nmos[ide]
print @n.xbgr.xm33.nsg13_hv_nmos[ige]
print @n.xbgr.xm33.nsg13_hv_nmos[ise]
print @n.xbgr.xm33.nsg13_hv_nmos[ibe]
print @n.xbgr.xm33.nsg13_hv_nmos[ctype]
print @n.xbgr.xm34.nsg13_hv_nmos[ide]
print @n.xbgr.xm34.nsg13_hv_nmos[ige]
print @n.xbgr.xm34.nsg13_hv_nmos[ise]
print @n.xbgr.xm34.nsg13_hv_nmos[ibe]
print @n.xbgr.xm34.nsg13_hv_nmos[ctype]
print @n.xbgr.xm35.nsg13_hv_nmos[ide]
print @n.xbgr.xm35.nsg13_hv_nmos[ige]
print @n.xbgr.xm35.nsg13_hv_nmos[ise]
print @n.xbgr.xm35.nsg13_hv_nmos[ibe]
print @n.xbgr.xm35.nsg13_hv_nmos[ctype]
print @n.xbgr.xm36.nsg13_hv_nmos[ide]
print @n.xbgr.xm36.nsg13_hv_nmos[ige]
print @n.xbgr.xm36.nsg13_hv_nmos[ise]
print @n.xbgr.xm36.nsg13_hv_nmos[ibe]
print @n.xbgr.xm36.nsg13_hv_nmos[ctype]
print @n.xbgr.xm37.nsg13_hv_nmos[ide]
print @n.xbgr.xm37.nsg13_hv_nmos[ige]
print @n.xbgr.xm37.nsg13_hv_nmos[ise]
print @n.xbgr.xm37.nsg13_hv_nmos[ibe]
print @n.xbgr.xm37.nsg13_hv_nmos[ctype]
print @n.xbgr.xm38.nsg13_hv_pmos[ide]
print @n.xbgr.xm38.nsg13_hv_pmos[ige]
print @n.xbgr.xm38.nsg13_hv_pmos[ise]
print @n.xbgr.xm38.nsg13_hv_pmos[ibe]
print @n.xbgr.xm38.nsg13_hv_pmos[ctype]
print @n.xbgr.xm39.nsg13_hv_pmos[ide]
print @n.xbgr.xm39.nsg13_hv_pmos[ige]
print @n.xbgr.xm39.nsg13_hv_pmos[ise]
print @n.xbgr.xm39.nsg13_hv_pmos[ibe]
print @n.xbgr.xm39.nsg13_hv_pmos[ctype]
print @n.xbgr.xm40.nsg13_hv_pmos[ide]
print @n.xbgr.xm40.nsg13_hv_pmos[ige]
print @n.xbgr.xm40.nsg13_hv_pmos[ise]
print @n.xbgr.xm40.nsg13_hv_pmos[ibe]
print @n.xbgr.xm40.nsg13_hv_pmos[ctype]
print @n.xbgr.xm41.nsg13_hv_pmos[ide]
print @n.xbgr.xm41.nsg13_hv_pmos[ige]
print @n.xbgr.xm41.nsg13_hv_pmos[ise]
print @n.xbgr.xm41.nsg13_hv_pmos[ibe]
print @n.xbgr.xm41.nsg13_hv_pmos[ctype]
print @n.xbgr.xm42.nsg13_hv_pmos[ide]
print @n.xbgr.xm42.nsg13_hv_pmos[ige]
print @n.xbgr.xm42.nsg13_hv_pmos[ise]
print @n.xbgr.xm42.nsg13_hv_pmos[ibe]
print @n.xbgr.xm42.nsg13_hv_pmos[ctype]
print @n.xbgr.xm43.nsg13_hv_pmos[ide]
print @n.xbgr.xm43.nsg13_hv_pmos[ige]
print @n.xbgr.xm43.nsg13_hv_pmos[ise]
print @n.xbgr.xm43.nsg13_hv_pmos[ibe]
print @n.xbgr.xm43.nsg13_hv_pmos[ctype]
print @n.xbgr.xm44.nsg13_hv_pmos[ide]
print @n.xbgr.xm44.nsg13_hv_pmos[ige]
print @n.xbgr.xm44.nsg13_hv_pmos[ise]
print @n.xbgr.xm44.nsg13_hv_pmos[ibe]
print @n.xbgr.xm44.nsg13_hv_pmos[ctype]
print @n.xbgr.xm45.nsg13_hv_pmos[ide]
print @n.xbgr.xm45.nsg13_hv_pmos[ige]
print @n.xbgr.xm45.nsg13_hv_pmos[ise]
print @n.xbgr.xm45.nsg13_hv_pmos[ibe]
print @n.xbgr.xm45.nsg13_hv_pmos[ctype]
print @n.xbgr.xm46.nsg13_hv_pmos[ide]
print @n.xbgr.xm46.nsg13_hv_pmos[ige]
print @n.xbgr.xm46.nsg13_hv_pmos[ise]
print @n.xbgr.xm46.nsg13_hv_pmos[ibe]
print @n.xbgr.xm46.nsg13_hv_pmos[ctype]
print @n.xbgr.xm47.nsg13_hv_pmos[ide]
print @n.xbgr.xm47.nsg13_hv_pmos[ige]
print @n.xbgr.xm47.nsg13_hv_pmos[ise]
print @n.xbgr.xm47.nsg13_hv_pmos[ibe]
print @n.xbgr.xm47.nsg13_hv_pmos[ctype]
print @n.xbgr.xm48.nsg13_hv_pmos[ide]
print @n.xbgr.xm48.nsg13_hv_pmos[ige]
print @n.xbgr.xm48.nsg13_hv_pmos[ise]
print @n.xbgr.xm48.nsg13_hv_pmos[ibe]
print @n.xbgr.xm48.nsg13_hv_pmos[ctype]
print @n.xbgr.xm49.nsg13_hv_pmos[ide]
print @n.xbgr.xm49.nsg13_hv_pmos[ige]
print @n.xbgr.xm49.nsg13_hv_pmos[ise]
print @n.xbgr.xm49.nsg13_hv_pmos[ibe]
print @n.xbgr.xm49.nsg13_hv_pmos[ctype]
print @n.xbgr.xm50.nsg13_hv_pmos[ide]
print @n.xbgr.xm50.nsg13_hv_pmos[ige]
print @n.xbgr.xm50.nsg13_hv_pmos[ise]
print @n.xbgr.xm50.nsg13_hv_pmos[ibe]
print @n.xbgr.xm50.nsg13_hv_pmos[ctype]
print @n.xbgr.xm51.nsg13_hv_pmos[ide]
print @n.xbgr.xm51.nsg13_hv_pmos[ige]
print @n.xbgr.xm51.nsg13_hv_pmos[ise]
print @n.xbgr.xm51.nsg13_hv_pmos[ibe]
print @n.xbgr.xm51.nsg13_hv_pmos[ctype]
print @n.xbgr.xm52.nsg13_hv_pmos[ide]
print @n.xbgr.xm52.nsg13_hv_pmos[ige]
print @n.xbgr.xm52.nsg13_hv_pmos[ise]
print @n.xbgr.xm52.nsg13_hv_pmos[ibe]
print @n.xbgr.xm52.nsg13_hv_pmos[ctype]
print @n.xbgr.xm53.nsg13_hv_pmos[ide]
print @n.xbgr.xm53.nsg13_hv_pmos[ige]
print @n.xbgr.xm53.nsg13_hv_pmos[ise]
print @n.xbgr.xm53.nsg13_hv_pmos[ibe]
print @n.xbgr.xm53.nsg13_hv_pmos[ctype]
print @n.xbgr.xm54.nsg13_hv_pmos[ide]
print @n.xbgr.xm54.nsg13_hv_pmos[ige]
print @n.xbgr.xm54.nsg13_hv_pmos[ise]
print @n.xbgr.xm54.nsg13_hv_pmos[ibe]
print @n.xbgr.xm54.nsg13_hv_pmos[ctype]
print @q.xbgr.xq55.qnpn13g2[ic]
print @q.xbgr.xq55.qnpn13g2[ib]
print @q.xbgr.xq55.qnpn13g2[ie]
print @q.xbgr.xq55.qnpn13g2[is]
print @r.xbgr.xq55.rsub[i]
print @c.xbgr.xq55.csub[i]
print @q.xbgr.xq56.qnpn13g2[ic]
print @q.xbgr.xq56.qnpn13g2[ib]
print @q.xbgr.xq56.qnpn13g2[ie]
print @q.xbgr.xq56.qnpn13g2[is]
print @r.xbgr.xq56.rsub[i]
print @c.xbgr.xq56.csub[i]
print @q.xbgr.xq57.qnpn13g2[ic]
print @q.xbgr.xq57.qnpn13g2[ib]
print @q.xbgr.xq57.qnpn13g2[ie]
print @q.xbgr.xq57.qnpn13g2[is]
print @r.xbgr.xq57.rsub[i]
print @c.xbgr.xq57.csub[i]
print @q.xbgr.xq58.qnpn13g2[ic]
print @q.xbgr.xq58.qnpn13g2[ib]
print @q.xbgr.xq58.qnpn13g2[ie]
print @q.xbgr.xq58.qnpn13g2[is]
print @r.xbgr.xq58.rsub[i]
print @c.xbgr.xq58.csub[i]
print @q.xbgr.xq59.qnpn13g2[ic]
print @q.xbgr.xq59.qnpn13g2[ib]
print @q.xbgr.xq59.qnpn13g2[ie]
print @q.xbgr.xq59.qnpn13g2[is]
print @r.xbgr.xq59.rsub[i]
print @c.xbgr.xq59.csub[i]
print @q.xbgr.xq60.qnpn13g2[ic]
print @q.xbgr.xq60.qnpn13g2[ib]
print @q.xbgr.xq60.qnpn13g2[ie]
print @q.xbgr.xq60.qnpn13g2[is]
print @r.xbgr.xq60.rsub[i]
print @c.xbgr.xq60.csub[i]
print @q.xbgr.xq61.qnpn13g2[ic]
print @q.xbgr.xq61.qnpn13g2[ib]
print @q.xbgr.xq61.qnpn13g2[ie]
print @q.xbgr.xq61.qnpn13g2[is]
print @r.xbgr.xq61.rsub[i]
print @c.xbgr.xq61.csub[i]
print @q.xbgr.xq62.qnpn13g2[ic]
print @q.xbgr.xq62.qnpn13g2[ib]
print @q.xbgr.xq62.qnpn13g2[ie]
print @q.xbgr.xq62.qnpn13g2[is]
print @r.xbgr.xq62.rsub[i]
print @c.xbgr.xq62.csub[i]
print @q.xbgr.xq63.qnpn13g2[ic]
print @q.xbgr.xq63.qnpn13g2[ib]
print @q.xbgr.xq63.qnpn13g2[ie]
print @q.xbgr.xq63.qnpn13g2[is]
print @r.xbgr.xq63.rsub[i]
print @c.xbgr.xq63.csub[i]
print @q.xbgr.xq64.qnpn13g2[ic]
print @q.xbgr.xq64.qnpn13g2[ib]
print @q.xbgr.xq64.qnpn13g2[ie]
print @q.xbgr.xq64.qnpn13g2[is]
print @r.xbgr.xq64.rsub[i]
print @c.xbgr.xq64.csub[i]
print @q.xbgr.xq65.qnpn13g2[ic]
print @q.xbgr.xq65.qnpn13g2[ib]
print @q.xbgr.xq65.qnpn13g2[ie]
print @q.xbgr.xq65.qnpn13g2[is]
print @r.xbgr.xq65.rsub[i]
print @c.xbgr.xq65.csub[i]
print @q.xbgr.xq66.qnpn13g2[ic]
print @q.xbgr.xq66.qnpn13g2[ib]
print @q.xbgr.xq66.qnpn13g2[ie]
print @q.xbgr.xq66.qnpn13g2[is]
print @r.xbgr.xq66.rsub[i]
print @c.xbgr.xq66.csub[i]
print @q.xbgr.xq67.qnpn13g2[ic]
print @q.xbgr.xq67.qnpn13g2[ib]
print @q.xbgr.xq67.qnpn13g2[ie]
print @q.xbgr.xq67.qnpn13g2[is]
print @r.xbgr.xq67.rsub[i]
print @c.xbgr.xq67.csub[i]
print @q.xbgr.xq68.qnpn13g2[ic]
print @q.xbgr.xq68.qnpn13g2[ib]
print @q.xbgr.xq68.qnpn13g2[ie]
print @q.xbgr.xq68.qnpn13g2[is]
print @r.xbgr.xq68.rsub[i]
print @c.xbgr.xq68.csub[i]
print @q.xbgr.xq69.qnpn13g2[ic]
print @q.xbgr.xq69.qnpn13g2[ib]
print @q.xbgr.xq69.qnpn13g2[ie]
print @q.xbgr.xq69.qnpn13g2[is]
print @r.xbgr.xq69.rsub[i]
print @c.xbgr.xq69.csub[i]
print @q.xbgr.xq70.qnpn13g2[ic]
print @q.xbgr.xq70.qnpn13g2[ib]
print @q.xbgr.xq70.qnpn13g2[ie]
print @q.xbgr.xq70.qnpn13g2[is]
print @r.xbgr.xq70.rsub[i]
print @c.xbgr.xq70.csub[i]
print @q.xbgr.xq71.qnpn13g2[ic]
print @q.xbgr.xq71.qnpn13g2[ib]
print @q.xbgr.xq71.qnpn13g2[ie]
print @q.xbgr.xq71.qnpn13g2[is]
print @r.xbgr.xq71.rsub[i]
print @c.xbgr.xq71.csub[i]
print @q.xbgr.xq72.qnpn13g2[ic]
print @q.xbgr.xq72.qnpn13g2[ib]
print @q.xbgr.xq72.qnpn13g2[ie]
print @q.xbgr.xq72.qnpn13g2[is]
print @r.xbgr.xq72.rsub[i]
print @c.xbgr.xq72.csub[i]
print @q.xbgr.xq73.qnpn13g2[ic]
print @q.xbgr.xq73.qnpn13g2[ib]
print @q.xbgr.xq73.qnpn13g2[ie]
print @q.xbgr.xq73.qnpn13g2[is]
print @r.xbgr.xq73.rsub[i]
print @c.xbgr.xq73.csub[i]
print @q.xbgr.xq74.qnpn13g2[ic]
print @q.xbgr.xq74.qnpn13g2[ib]
print @q.xbgr.xq74.qnpn13g2[ie]
print @q.xbgr.xq74.qnpn13g2[is]
print @r.xbgr.xq74.rsub[i]
print @c.xbgr.xq74.csub[i]
print @q.xbgr.xq75.qnpn13g2[ic]
print @q.xbgr.xq75.qnpn13g2[ib]
print @q.xbgr.xq75.qnpn13g2[ie]
print @q.xbgr.xq75.qnpn13g2[is]
print @r.xbgr.xq75.rsub[i]
print @c.xbgr.xq75.csub[i]
print @q.xbgr.xq76.qnpn13g2[ic]
print @q.xbgr.xq76.qnpn13g2[ib]
print @q.xbgr.xq76.qnpn13g2[ie]
print @q.xbgr.xq76.qnpn13g2[is]
print @r.xbgr.xq76.rsub[i]
print @c.xbgr.xq76.csub[i]
print @n.xbgr.xr77.nr1[ibody]
print @n.xbgr.xr78.nr1[ibody]
print @n.xbgr.xr79.nr1[ibody]
print @n.xbgr.xr80.nr1[ibody]
print @n.xbgr.xr81.nr1[ibody]
print @n.xbgr.xr82.nr1[ibody]
print @n.xbgr.xr83.nr1[ibody]
print @n.xbgr.xr84.nr1[ibody]
print @n.xbgr.xr85.nr1[ibody]
print @n.xbgr.xr86.nr1[ibody]
print @n.xbgr.xr16_u2.nr1[ibody]
print @n.xbgr.xr16_u3.nr1[ibody]
print @n.xbgr.xr16_u4.nr1[ibody]
print @n.xbgr.xr16_u5.nr1[ibody]
print @n.xbgr.xr16_u6.nr1[ibody]
print @n.xbgr.xr16_u7.nr1[ibody]
print @n.xbgr.xr16_u8.nr1[ibody]
print @n.xbgr.xr16_u9.nr1[ibody]
print @n.xbgr.xr16_u10.nr1[ibody]
print @n.xbgr.xr16_u11.nr1[ibody]
print @n.xbgr.xr16_u12.nr1[ibody]
print @n.xbgr.xr16_u13.nr1[ibody]
print @n.xbgr.xr16_u14.nr1[ibody]
print @n.xbgr.xr16_u15.nr1[ibody]
print @n.xbgr.xr16_u16.nr1[ibody]
print @n.xbgr.xr16_u17.nr1[ibody]
print @n.xbgr.xr16_u18.nr1[ibody]
print @n.xbgr.xr16_u19.nr1[ibody]
print @n.xbgr.xr16_u20.nr1[ibody]
print @n.xbgr.xr16_u21.nr1[ibody]
print @n.xbgr.xr16_u22.nr1[ibody]
print @n.xbgr.xr16_u23.nr1[ibody]
print @n.xbgr.xr16_u24.nr1[ibody]
print @n.xbgr.xr17_u2.nr1[ibody]
print @n.xbgr.xr17_u3.nr1[ibody]
print @n.xbgr.xr17_u4.nr1[ibody]
print @n.xbgr.xr18_u2.nr1[ibody]
print @n.xbgr.xr18_u3.nr1[ibody]
print @n.xbgr.xr18_u4.nr1[ibody]
print @n.xbgr.xr19_u2.nr1[ibody]
print @n.xbgr.xr19_u3.nr1[ibody]
print @n.xbgr.xr19_u4.nr1[ibody]
print @n.xbgr.xr20_u2.nr1[ibody]
print @n.xbgr.xr20_u3.nr1[ibody]
print @n.xbgr.xr20_u4.nr1[ibody]
print @n.xbgr.xr21_u2.nr1[ibody]
print @n.xbgr.xr21_u3.nr1[ibody]
print @n.xbgr.xr21_u4.nr1[ibody]
print @n.xbgr.xr22_u2.nr1[ibody]
print @n.xbgr.xr22_u3.nr1[ibody]
print @n.xbgr.xr22_u4.nr1[ibody]
print @n.xbgr.xr23_u2.nr1[ibody]
print @n.xbgr.xr23_u3.nr1[ibody]
print @n.xbgr.xr23_u4.nr1[ibody]
print @n.xbgr.xr23_u5.nr1[ibody]
print @n.xbgr.xr23_u6.nr1[ibody]
print @n.xbgr.xr23_u7.nr1[ibody]
print @n.xbgr.xr23_u8.nr1[ibody]
print @n.xbgr.xr23_u9.nr1[ibody]
print @n.xbgr.xr23_u10.nr1[ibody]
print @n.xbgr.xr23_u11.nr1[ibody]
print @n.xbgr.xr23_u12.nr1[ibody]
print @n.xbgr.xr23_u13.nr1[ibody]
print @n.xbgr.xr23_u14.nr1[ibody]
print @n.xbgr.xr23_u15.nr1[ibody]
print @n.xbgr.xr23_u16.nr1[ibody]
print @n.xbgr.xr23_u17.nr1[ibody]
print @n.xbgr.xr23_u18.nr1[ibody]
print @n.xbgr.xr23_u19.nr1[ibody]
print @n.xbgr.xr23_u20.nr1[ibody]
print @n.xbgr.xr23_u21.nr1[ibody]
print @n.xbgr.xr23_u22.nr1[ibody]
print @n.xbgr.xr23_u23.nr1[ibody]
print @n.xbgr.xr23_u24.nr1[ibody]
print @n.xbgr.xr24_u2.nr1[ibody]
print @n.xbgr.xr24_u3.nr1[ibody]
print @n.xbgr.xr24_u4.nr1[ibody]
print @n.xbgr.xr24_u5.nr1[ibody]
print @n.xbgr.xr24_u6.nr1[ibody]
print @n.xbgr.xr24_u7.nr1[ibody]
print @n.xbgr.xr24_u8.nr1[ibody]
print @n.xbgr.xr24_u9.nr1[ibody]
print @n.xbgr.xr24_u10.nr1[ibody]
print @n.xbgr.xr24_u11.nr1[ibody]
print @n.xbgr.xr24_u12.nr1[ibody]
print @n.xbgr.xr24_u13.nr1[ibody]
print @n.xbgr.xr24_u14.nr1[ibody]
print @n.xbgr.xr24_u15.nr1[ibody]
print @n.xbgr.xr24_u16.nr1[ibody]
print @n.xbgr.xr24_u17.nr1[ibody]
print @n.xbgr.xr24_u18.nr1[ibody]
print @n.xbgr.xr24_u19.nr1[ibody]
print @n.xbgr.xr24_u20.nr1[ibody]
print @n.xbgr.xr24_u21.nr1[ibody]
print @n.xbgr.xr24_u22.nr1[ibody]
print @n.xbgr.xr24_u23.nr1[ibody]
print @n.xbgr.xr24_u24.nr1[ibody]
print @n.xbgr.xr25_u2.nr1[ibody]
print @n.xbgr.xr25_u3.nr1[ibody]
print @n.xbgr.xr25_u4.nr1[ibody]
print @n.xbgr.xr25_u5.nr1[ibody]
print @n.xbgr.xr25_u6.nr1[ibody]
print @n.xbgr.xr25_u7.nr1[ibody]
print @n.xbgr.xr25_u8.nr1[ibody]
print @n.xbgr.xr25_u9.nr1[ibody]
print @n.xbgr.xr25_u10.nr1[ibody]
print @n.xbgr.xr25_u11.nr1[ibody]
print @n.xbgr.xr25_u12.nr1[ibody]
print @n.xbgr.xr25_u13.nr1[ibody]
print @n.xbgr.xr25_u14.nr1[ibody]
print @n.xbgr.xr25_u15.nr1[ibody]
print @n.xbgr.xr25_u16.nr1[ibody]
print @n.xbgr.xr25_u17.nr1[ibody]
print @n.xbgr.xr25_u18.nr1[ibody]
print @n.xbgr.xr25_u19.nr1[ibody]
print @n.xbgr.xr25_u20.nr1[ibody]
print @n.xbgr.xr25_u21.nr1[ibody]
print @n.xbgr.xr25_u22.nr1[ibody]
print @n.xbgr.xr25_u23.nr1[ibody]
print @n.xbgr.xr25_u24.nr1[ibody]
print @n.xbgr.xr26_u2.nr1[ibody]
print @n.xbgr.xr26_u3.nr1[ibody]
print @n.xbgr.xr26_u4.nr1[ibody]
print @n.xbgr.xr26_u5.nr1[ibody]
print @n.xbgr.xr26_u6.nr1[ibody]
print @n.xbgr.xr26_u7.nr1[ibody]
print @n.xbgr.xr26_u8.nr1[ibody]
print @n.xbgr.xr26_u9.nr1[ibody]
print @n.xbgr.xr26_u10.nr1[ibody]
print @n.xbgr.xr26_u11.nr1[ibody]
print @n.xbgr.xr26_u12.nr1[ibody]
print @n.xbgr.xr26_u13.nr1[ibody]
print @n.xbgr.xr26_u14.nr1[ibody]
print @n.xbgr.xr26_u15.nr1[ibody]
print @n.xbgr.xr26_u16.nr1[ibody]
print @n.xbgr.xr26_u17.nr1[ibody]
print @n.xbgr.xr26_u18.nr1[ibody]
print @n.xbgr.xr26_u19.nr1[ibody]
print @n.xbgr.xr26_u20.nr1[ibody]
print @n.xbgr.xr26_u21.nr1[ibody]
print @n.xbgr.xr26_u22.nr1[ibody]
print @n.xbgr.xr26_u23.nr1[ibody]
print @n.xbgr.xr26_u24.nr1[ibody]
print @n.xbgr.xm34_u2.nsg13_hv_nmos[ide]
print @n.xbgr.xm34_u2.nsg13_hv_nmos[ige]
print @n.xbgr.xm34_u2.nsg13_hv_nmos[ise]
print @n.xbgr.xm34_u2.nsg13_hv_nmos[ibe]
print @n.xbgr.xm34_u2.nsg13_hv_nmos[ctype]
print @n.xbgr.xm34_u3.nsg13_hv_nmos[ide]
print @n.xbgr.xm34_u3.nsg13_hv_nmos[ige]
print @n.xbgr.xm34_u3.nsg13_hv_nmos[ise]
print @n.xbgr.xm34_u3.nsg13_hv_nmos[ibe]
print @n.xbgr.xm34_u3.nsg13_hv_nmos[ctype]
print @n.xbgr.xm34_u4.nsg13_hv_nmos[ide]
print @n.xbgr.xm34_u4.nsg13_hv_nmos[ige]
print @n.xbgr.xm34_u4.nsg13_hv_nmos[ise]
print @n.xbgr.xm34_u4.nsg13_hv_nmos[ibe]
print @n.xbgr.xm34_u4.nsg13_hv_nmos[ctype]
print @n.xbgr.xm34_u5.nsg13_hv_nmos[ide]
print @n.xbgr.xm34_u5.nsg13_hv_nmos[ige]
print @n.xbgr.xm34_u5.nsg13_hv_nmos[ise]
print @n.xbgr.xm34_u5.nsg13_hv_nmos[ibe]
print @n.xbgr.xm34_u5.nsg13_hv_nmos[ctype]
print @n.xbgr.xm34_u6.nsg13_hv_nmos[ide]
print @n.xbgr.xm34_u6.nsg13_hv_nmos[ige]
print @n.xbgr.xm34_u6.nsg13_hv_nmos[ise]
print @n.xbgr.xm34_u6.nsg13_hv_nmos[ibe]
print @n.xbgr.xm34_u6.nsg13_hv_nmos[ctype]
print @n.xbgr.xm34_u7.nsg13_hv_nmos[ide]
print @n.xbgr.xm34_u7.nsg13_hv_nmos[ige]
print @n.xbgr.xm34_u7.nsg13_hv_nmos[ise]
print @n.xbgr.xm34_u7.nsg13_hv_nmos[ibe]
print @n.xbgr.xm34_u7.nsg13_hv_nmos[ctype]
print @n.xbgr.xm34_u8.nsg13_hv_nmos[ide]
print @n.xbgr.xm34_u8.nsg13_hv_nmos[ige]
print @n.xbgr.xm34_u8.nsg13_hv_nmos[ise]
print @n.xbgr.xm34_u8.nsg13_hv_nmos[ibe]
print @n.xbgr.xm34_u8.nsg13_hv_nmos[ctype]
print @n.xbgr.xm34_u9.nsg13_hv_nmos[ide]
print @n.xbgr.xm34_u9.nsg13_hv_nmos[ige]
print @n.xbgr.xm34_u9.nsg13_hv_nmos[ise]
print @n.xbgr.xm34_u9.nsg13_hv_nmos[ibe]
print @n.xbgr.xm34_u9.nsg13_hv_nmos[ctype]
print @n.xbgr.xm34_u10.nsg13_hv_nmos[ide]
print @n.xbgr.xm34_u10.nsg13_hv_nmos[ige]
print @n.xbgr.xm34_u10.nsg13_hv_nmos[ise]
print @n.xbgr.xm34_u10.nsg13_hv_nmos[ibe]
print @n.xbgr.xm34_u10.nsg13_hv_nmos[ctype]
print @n.xbgr.xm34_u11.nsg13_hv_nmos[ide]
print @n.xbgr.xm34_u11.nsg13_hv_nmos[ige]
print @n.xbgr.xm34_u11.nsg13_hv_nmos[ise]
print @n.xbgr.xm34_u11.nsg13_hv_nmos[ibe]
print @n.xbgr.xm34_u11.nsg13_hv_nmos[ctype]
print @n.xbgr.xm34_u12.nsg13_hv_nmos[ide]
print @n.xbgr.xm34_u12.nsg13_hv_nmos[ige]
print @n.xbgr.xm34_u12.nsg13_hv_nmos[ise]
print @n.xbgr.xm34_u12.nsg13_hv_nmos[ibe]
print @n.xbgr.xm34_u12.nsg13_hv_nmos[ctype]
print @n.xbgr.xm34_u13.nsg13_hv_nmos[ide]
print @n.xbgr.xm34_u13.nsg13_hv_nmos[ige]
print @n.xbgr.xm34_u13.nsg13_hv_nmos[ise]
print @n.xbgr.xm34_u13.nsg13_hv_nmos[ibe]
print @n.xbgr.xm34_u13.nsg13_hv_nmos[ctype]
print @n.xbgr.xm34_u14.nsg13_hv_nmos[ide]
print @n.xbgr.xm34_u14.nsg13_hv_nmos[ige]
print @n.xbgr.xm34_u14.nsg13_hv_nmos[ise]
print @n.xbgr.xm34_u14.nsg13_hv_nmos[ibe]
print @n.xbgr.xm34_u14.nsg13_hv_nmos[ctype]
print @n.xbgr.xm34_u15.nsg13_hv_nmos[ide]
print @n.xbgr.xm34_u15.nsg13_hv_nmos[ige]
print @n.xbgr.xm34_u15.nsg13_hv_nmos[ise]
print @n.xbgr.xm34_u15.nsg13_hv_nmos[ibe]
print @n.xbgr.xm34_u15.nsg13_hv_nmos[ctype]
print @n.xbgr.xm34_u16.nsg13_hv_nmos[ide]
print @n.xbgr.xm34_u16.nsg13_hv_nmos[ige]
print @n.xbgr.xm34_u16.nsg13_hv_nmos[ise]
print @n.xbgr.xm34_u16.nsg13_hv_nmos[ibe]
print @n.xbgr.xm34_u16.nsg13_hv_nmos[ctype]
print @n.xbgr.xm34_u17.nsg13_hv_nmos[ide]
print @n.xbgr.xm34_u17.nsg13_hv_nmos[ige]
print @n.xbgr.xm34_u17.nsg13_hv_nmos[ise]
print @n.xbgr.xm34_u17.nsg13_hv_nmos[ibe]
print @n.xbgr.xm34_u17.nsg13_hv_nmos[ctype]
print @n.xbgr.xm34_u18.nsg13_hv_nmos[ide]
print @n.xbgr.xm34_u18.nsg13_hv_nmos[ige]
print @n.xbgr.xm34_u18.nsg13_hv_nmos[ise]
print @n.xbgr.xm34_u18.nsg13_hv_nmos[ibe]
print @n.xbgr.xm34_u18.nsg13_hv_nmos[ctype]
print @n.xbgr.xm34_u19.nsg13_hv_nmos[ide]
print @n.xbgr.xm34_u19.nsg13_hv_nmos[ige]
print @n.xbgr.xm34_u19.nsg13_hv_nmos[ise]
print @n.xbgr.xm34_u19.nsg13_hv_nmos[ibe]
print @n.xbgr.xm34_u19.nsg13_hv_nmos[ctype]
print @n.xbgr.xm34_u20.nsg13_hv_nmos[ide]
print @n.xbgr.xm34_u20.nsg13_hv_nmos[ige]
print @n.xbgr.xm34_u20.nsg13_hv_nmos[ise]
print @n.xbgr.xm34_u20.nsg13_hv_nmos[ibe]
print @n.xbgr.xm34_u20.nsg13_hv_nmos[ctype]
print @n.xbgr.xm34_u21.nsg13_hv_nmos[ide]
print @n.xbgr.xm34_u21.nsg13_hv_nmos[ige]
print @n.xbgr.xm34_u21.nsg13_hv_nmos[ise]
print @n.xbgr.xm34_u21.nsg13_hv_nmos[ibe]
print @n.xbgr.xm34_u21.nsg13_hv_nmos[ctype]
print @n.xbgr.xm34_u22.nsg13_hv_nmos[ide]
print @n.xbgr.xm34_u22.nsg13_hv_nmos[ige]
print @n.xbgr.xm34_u22.nsg13_hv_nmos[ise]
print @n.xbgr.xm34_u22.nsg13_hv_nmos[ibe]
print @n.xbgr.xm34_u22.nsg13_hv_nmos[ctype]
print @n.xbgr.xm34_u23.nsg13_hv_nmos[ide]
print @n.xbgr.xm34_u23.nsg13_hv_nmos[ige]
print @n.xbgr.xm34_u23.nsg13_hv_nmos[ise]
print @n.xbgr.xm34_u23.nsg13_hv_nmos[ibe]
print @n.xbgr.xm34_u23.nsg13_hv_nmos[ctype]
print @n.xbgr.xm34_u24.nsg13_hv_nmos[ide]
print @n.xbgr.xm34_u24.nsg13_hv_nmos[ige]
print @n.xbgr.xm34_u24.nsg13_hv_nmos[ise]
print @n.xbgr.xm34_u24.nsg13_hv_nmos[ibe]
print @n.xbgr.xm34_u24.nsg13_hv_nmos[ctype]
print @n.xbgr.xm35_u2.nsg13_hv_nmos[ide]
print @n.xbgr.xm35_u2.nsg13_hv_nmos[ige]
print @n.xbgr.xm35_u2.nsg13_hv_nmos[ise]
print @n.xbgr.xm35_u2.nsg13_hv_nmos[ibe]
print @n.xbgr.xm35_u2.nsg13_hv_nmos[ctype]
print @n.xbgr.xm35_u3.nsg13_hv_nmos[ide]
print @n.xbgr.xm35_u3.nsg13_hv_nmos[ige]
print @n.xbgr.xm35_u3.nsg13_hv_nmos[ise]
print @n.xbgr.xm35_u3.nsg13_hv_nmos[ibe]
print @n.xbgr.xm35_u3.nsg13_hv_nmos[ctype]
print @n.xbgr.xm35_u4.nsg13_hv_nmos[ide]
print @n.xbgr.xm35_u4.nsg13_hv_nmos[ige]
print @n.xbgr.xm35_u4.nsg13_hv_nmos[ise]
print @n.xbgr.xm35_u4.nsg13_hv_nmos[ibe]
print @n.xbgr.xm35_u4.nsg13_hv_nmos[ctype]
print @n.xbgr.xm35_u5.nsg13_hv_nmos[ide]
print @n.xbgr.xm35_u5.nsg13_hv_nmos[ige]
print @n.xbgr.xm35_u5.nsg13_hv_nmos[ise]
print @n.xbgr.xm35_u5.nsg13_hv_nmos[ibe]
print @n.xbgr.xm35_u5.nsg13_hv_nmos[ctype]
print @n.xbgr.xm35_u6.nsg13_hv_nmos[ide]
print @n.xbgr.xm35_u6.nsg13_hv_nmos[ige]
print @n.xbgr.xm35_u6.nsg13_hv_nmos[ise]
print @n.xbgr.xm35_u6.nsg13_hv_nmos[ibe]
print @n.xbgr.xm35_u6.nsg13_hv_nmos[ctype]
print @n.xbgr.xm35_u7.nsg13_hv_nmos[ide]
print @n.xbgr.xm35_u7.nsg13_hv_nmos[ige]
print @n.xbgr.xm35_u7.nsg13_hv_nmos[ise]
print @n.xbgr.xm35_u7.nsg13_hv_nmos[ibe]
print @n.xbgr.xm35_u7.nsg13_hv_nmos[ctype]
print @n.xbgr.xm35_u8.nsg13_hv_nmos[ide]
print @n.xbgr.xm35_u8.nsg13_hv_nmos[ige]
print @n.xbgr.xm35_u8.nsg13_hv_nmos[ise]
print @n.xbgr.xm35_u8.nsg13_hv_nmos[ibe]
print @n.xbgr.xm35_u8.nsg13_hv_nmos[ctype]
print @n.xbgr.xm35_u9.nsg13_hv_nmos[ide]
print @n.xbgr.xm35_u9.nsg13_hv_nmos[ige]
print @n.xbgr.xm35_u9.nsg13_hv_nmos[ise]
print @n.xbgr.xm35_u9.nsg13_hv_nmos[ibe]
print @n.xbgr.xm35_u9.nsg13_hv_nmos[ctype]
print @n.xbgr.xm35_u10.nsg13_hv_nmos[ide]
print @n.xbgr.xm35_u10.nsg13_hv_nmos[ige]
print @n.xbgr.xm35_u10.nsg13_hv_nmos[ise]
print @n.xbgr.xm35_u10.nsg13_hv_nmos[ibe]
print @n.xbgr.xm35_u10.nsg13_hv_nmos[ctype]
print @n.xbgr.xm35_u11.nsg13_hv_nmos[ide]
print @n.xbgr.xm35_u11.nsg13_hv_nmos[ige]
print @n.xbgr.xm35_u11.nsg13_hv_nmos[ise]
print @n.xbgr.xm35_u11.nsg13_hv_nmos[ibe]
print @n.xbgr.xm35_u11.nsg13_hv_nmos[ctype]
print @n.xbgr.xm35_u12.nsg13_hv_nmos[ide]
print @n.xbgr.xm35_u12.nsg13_hv_nmos[ige]
print @n.xbgr.xm35_u12.nsg13_hv_nmos[ise]
print @n.xbgr.xm35_u12.nsg13_hv_nmos[ibe]
print @n.xbgr.xm35_u12.nsg13_hv_nmos[ctype]
print @n.xbgr.xm35_u13.nsg13_hv_nmos[ide]
print @n.xbgr.xm35_u13.nsg13_hv_nmos[ige]
print @n.xbgr.xm35_u13.nsg13_hv_nmos[ise]
print @n.xbgr.xm35_u13.nsg13_hv_nmos[ibe]
print @n.xbgr.xm35_u13.nsg13_hv_nmos[ctype]
print @n.xbgr.xm35_u14.nsg13_hv_nmos[ide]
print @n.xbgr.xm35_u14.nsg13_hv_nmos[ige]
print @n.xbgr.xm35_u14.nsg13_hv_nmos[ise]
print @n.xbgr.xm35_u14.nsg13_hv_nmos[ibe]
print @n.xbgr.xm35_u14.nsg13_hv_nmos[ctype]
print @n.xbgr.xm35_u15.nsg13_hv_nmos[ide]
print @n.xbgr.xm35_u15.nsg13_hv_nmos[ige]
print @n.xbgr.xm35_u15.nsg13_hv_nmos[ise]
print @n.xbgr.xm35_u15.nsg13_hv_nmos[ibe]
print @n.xbgr.xm35_u15.nsg13_hv_nmos[ctype]
print @n.xbgr.xm35_u16.nsg13_hv_nmos[ide]
print @n.xbgr.xm35_u16.nsg13_hv_nmos[ige]
print @n.xbgr.xm35_u16.nsg13_hv_nmos[ise]
print @n.xbgr.xm35_u16.nsg13_hv_nmos[ibe]
print @n.xbgr.xm35_u16.nsg13_hv_nmos[ctype]
print @n.xbgr.xm35_u17.nsg13_hv_nmos[ide]
print @n.xbgr.xm35_u17.nsg13_hv_nmos[ige]
print @n.xbgr.xm35_u17.nsg13_hv_nmos[ise]
print @n.xbgr.xm35_u17.nsg13_hv_nmos[ibe]
print @n.xbgr.xm35_u17.nsg13_hv_nmos[ctype]
print @n.xbgr.xm35_u18.nsg13_hv_nmos[ide]
print @n.xbgr.xm35_u18.nsg13_hv_nmos[ige]
print @n.xbgr.xm35_u18.nsg13_hv_nmos[ise]
print @n.xbgr.xm35_u18.nsg13_hv_nmos[ibe]
print @n.xbgr.xm35_u18.nsg13_hv_nmos[ctype]
print @n.xbgr.xm35_u19.nsg13_hv_nmos[ide]
print @n.xbgr.xm35_u19.nsg13_hv_nmos[ige]
print @n.xbgr.xm35_u19.nsg13_hv_nmos[ise]
print @n.xbgr.xm35_u19.nsg13_hv_nmos[ibe]
print @n.xbgr.xm35_u19.nsg13_hv_nmos[ctype]
print @n.xbgr.xm35_u20.nsg13_hv_nmos[ide]
print @n.xbgr.xm35_u20.nsg13_hv_nmos[ige]
print @n.xbgr.xm35_u20.nsg13_hv_nmos[ise]
print @n.xbgr.xm35_u20.nsg13_hv_nmos[ibe]
print @n.xbgr.xm35_u20.nsg13_hv_nmos[ctype]
print @n.xbgr.xm35_u21.nsg13_hv_nmos[ide]
print @n.xbgr.xm35_u21.nsg13_hv_nmos[ige]
print @n.xbgr.xm35_u21.nsg13_hv_nmos[ise]
print @n.xbgr.xm35_u21.nsg13_hv_nmos[ibe]
print @n.xbgr.xm35_u21.nsg13_hv_nmos[ctype]
print @n.xbgr.xm35_u22.nsg13_hv_nmos[ide]
print @n.xbgr.xm35_u22.nsg13_hv_nmos[ige]
print @n.xbgr.xm35_u22.nsg13_hv_nmos[ise]
print @n.xbgr.xm35_u22.nsg13_hv_nmos[ibe]
print @n.xbgr.xm35_u22.nsg13_hv_nmos[ctype]
print @n.xbgr.xm35_u23.nsg13_hv_nmos[ide]
print @n.xbgr.xm35_u23.nsg13_hv_nmos[ige]
print @n.xbgr.xm35_u23.nsg13_hv_nmos[ise]
print @n.xbgr.xm35_u23.nsg13_hv_nmos[ibe]
print @n.xbgr.xm35_u23.nsg13_hv_nmos[ctype]
print @n.xbgr.xm35_u24.nsg13_hv_nmos[ide]
print @n.xbgr.xm35_u24.nsg13_hv_nmos[ige]
print @n.xbgr.xm35_u24.nsg13_hv_nmos[ise]
print @n.xbgr.xm35_u24.nsg13_hv_nmos[ibe]
print @n.xbgr.xm35_u24.nsg13_hv_nmos[ctype]
print @n.xbgr.xm36_u2.nsg13_hv_nmos[ide]
print @n.xbgr.xm36_u2.nsg13_hv_nmos[ige]
print @n.xbgr.xm36_u2.nsg13_hv_nmos[ise]
print @n.xbgr.xm36_u2.nsg13_hv_nmos[ibe]
print @n.xbgr.xm36_u2.nsg13_hv_nmos[ctype]
print @n.xbgr.xm36_u3.nsg13_hv_nmos[ide]
print @n.xbgr.xm36_u3.nsg13_hv_nmos[ige]
print @n.xbgr.xm36_u3.nsg13_hv_nmos[ise]
print @n.xbgr.xm36_u3.nsg13_hv_nmos[ibe]
print @n.xbgr.xm36_u3.nsg13_hv_nmos[ctype]
print @n.xbgr.xm36_u4.nsg13_hv_nmos[ide]
print @n.xbgr.xm36_u4.nsg13_hv_nmos[ige]
print @n.xbgr.xm36_u4.nsg13_hv_nmos[ise]
print @n.xbgr.xm36_u4.nsg13_hv_nmos[ibe]
print @n.xbgr.xm36_u4.nsg13_hv_nmos[ctype]
print @n.xbgr.xm36_u5.nsg13_hv_nmos[ide]
print @n.xbgr.xm36_u5.nsg13_hv_nmos[ige]
print @n.xbgr.xm36_u5.nsg13_hv_nmos[ise]
print @n.xbgr.xm36_u5.nsg13_hv_nmos[ibe]
print @n.xbgr.xm36_u5.nsg13_hv_nmos[ctype]
print @n.xbgr.xm36_u6.nsg13_hv_nmos[ide]
print @n.xbgr.xm36_u6.nsg13_hv_nmos[ige]
print @n.xbgr.xm36_u6.nsg13_hv_nmos[ise]
print @n.xbgr.xm36_u6.nsg13_hv_nmos[ibe]
print @n.xbgr.xm36_u6.nsg13_hv_nmos[ctype]
print @n.xbgr.xm36_u7.nsg13_hv_nmos[ide]
print @n.xbgr.xm36_u7.nsg13_hv_nmos[ige]
print @n.xbgr.xm36_u7.nsg13_hv_nmos[ise]
print @n.xbgr.xm36_u7.nsg13_hv_nmos[ibe]
print @n.xbgr.xm36_u7.nsg13_hv_nmos[ctype]
print @n.xbgr.xm36_u8.nsg13_hv_nmos[ide]
print @n.xbgr.xm36_u8.nsg13_hv_nmos[ige]
print @n.xbgr.xm36_u8.nsg13_hv_nmos[ise]
print @n.xbgr.xm36_u8.nsg13_hv_nmos[ibe]
print @n.xbgr.xm36_u8.nsg13_hv_nmos[ctype]
print @n.xbgr.xm36_u9.nsg13_hv_nmos[ide]
print @n.xbgr.xm36_u9.nsg13_hv_nmos[ige]
print @n.xbgr.xm36_u9.nsg13_hv_nmos[ise]
print @n.xbgr.xm36_u9.nsg13_hv_nmos[ibe]
print @n.xbgr.xm36_u9.nsg13_hv_nmos[ctype]
print @n.xbgr.xm36_u10.nsg13_hv_nmos[ide]
print @n.xbgr.xm36_u10.nsg13_hv_nmos[ige]
print @n.xbgr.xm36_u10.nsg13_hv_nmos[ise]
print @n.xbgr.xm36_u10.nsg13_hv_nmos[ibe]
print @n.xbgr.xm36_u10.nsg13_hv_nmos[ctype]
print @n.xbgr.xm36_u11.nsg13_hv_nmos[ide]
print @n.xbgr.xm36_u11.nsg13_hv_nmos[ige]
print @n.xbgr.xm36_u11.nsg13_hv_nmos[ise]
print @n.xbgr.xm36_u11.nsg13_hv_nmos[ibe]
print @n.xbgr.xm36_u11.nsg13_hv_nmos[ctype]
print @n.xbgr.xm36_u12.nsg13_hv_nmos[ide]
print @n.xbgr.xm36_u12.nsg13_hv_nmos[ige]
print @n.xbgr.xm36_u12.nsg13_hv_nmos[ise]
print @n.xbgr.xm36_u12.nsg13_hv_nmos[ibe]
print @n.xbgr.xm36_u12.nsg13_hv_nmos[ctype]
print @n.xbgr.xm36_u13.nsg13_hv_nmos[ide]
print @n.xbgr.xm36_u13.nsg13_hv_nmos[ige]
print @n.xbgr.xm36_u13.nsg13_hv_nmos[ise]
print @n.xbgr.xm36_u13.nsg13_hv_nmos[ibe]
print @n.xbgr.xm36_u13.nsg13_hv_nmos[ctype]
print @n.xbgr.xm36_u14.nsg13_hv_nmos[ide]
print @n.xbgr.xm36_u14.nsg13_hv_nmos[ige]
print @n.xbgr.xm36_u14.nsg13_hv_nmos[ise]
print @n.xbgr.xm36_u14.nsg13_hv_nmos[ibe]
print @n.xbgr.xm36_u14.nsg13_hv_nmos[ctype]
print @n.xbgr.xm36_u15.nsg13_hv_nmos[ide]
print @n.xbgr.xm36_u15.nsg13_hv_nmos[ige]
print @n.xbgr.xm36_u15.nsg13_hv_nmos[ise]
print @n.xbgr.xm36_u15.nsg13_hv_nmos[ibe]
print @n.xbgr.xm36_u15.nsg13_hv_nmos[ctype]
print @n.xbgr.xm36_u16.nsg13_hv_nmos[ide]
print @n.xbgr.xm36_u16.nsg13_hv_nmos[ige]
print @n.xbgr.xm36_u16.nsg13_hv_nmos[ise]
print @n.xbgr.xm36_u16.nsg13_hv_nmos[ibe]
print @n.xbgr.xm36_u16.nsg13_hv_nmos[ctype]
print @n.xbgr.xm36_u17.nsg13_hv_nmos[ide]
print @n.xbgr.xm36_u17.nsg13_hv_nmos[ige]
print @n.xbgr.xm36_u17.nsg13_hv_nmos[ise]
print @n.xbgr.xm36_u17.nsg13_hv_nmos[ibe]
print @n.xbgr.xm36_u17.nsg13_hv_nmos[ctype]
print @n.xbgr.xm36_u18.nsg13_hv_nmos[ide]
print @n.xbgr.xm36_u18.nsg13_hv_nmos[ige]
print @n.xbgr.xm36_u18.nsg13_hv_nmos[ise]
print @n.xbgr.xm36_u18.nsg13_hv_nmos[ibe]
print @n.xbgr.xm36_u18.nsg13_hv_nmos[ctype]
print @n.xbgr.xm36_u19.nsg13_hv_nmos[ide]
print @n.xbgr.xm36_u19.nsg13_hv_nmos[ige]
print @n.xbgr.xm36_u19.nsg13_hv_nmos[ise]
print @n.xbgr.xm36_u19.nsg13_hv_nmos[ibe]
print @n.xbgr.xm36_u19.nsg13_hv_nmos[ctype]
print @n.xbgr.xm36_u20.nsg13_hv_nmos[ide]
print @n.xbgr.xm36_u20.nsg13_hv_nmos[ige]
print @n.xbgr.xm36_u20.nsg13_hv_nmos[ise]
print @n.xbgr.xm36_u20.nsg13_hv_nmos[ibe]
print @n.xbgr.xm36_u20.nsg13_hv_nmos[ctype]
print @n.xbgr.xm36_u21.nsg13_hv_nmos[ide]
print @n.xbgr.xm36_u21.nsg13_hv_nmos[ige]
print @n.xbgr.xm36_u21.nsg13_hv_nmos[ise]
print @n.xbgr.xm36_u21.nsg13_hv_nmos[ibe]
print @n.xbgr.xm36_u21.nsg13_hv_nmos[ctype]
print @n.xbgr.xm36_u22.nsg13_hv_nmos[ide]
print @n.xbgr.xm36_u22.nsg13_hv_nmos[ige]
print @n.xbgr.xm36_u22.nsg13_hv_nmos[ise]
print @n.xbgr.xm36_u22.nsg13_hv_nmos[ibe]
print @n.xbgr.xm36_u22.nsg13_hv_nmos[ctype]
print @n.xbgr.xm36_u23.nsg13_hv_nmos[ide]
print @n.xbgr.xm36_u23.nsg13_hv_nmos[ige]
print @n.xbgr.xm36_u23.nsg13_hv_nmos[ise]
print @n.xbgr.xm36_u23.nsg13_hv_nmos[ibe]
print @n.xbgr.xm36_u23.nsg13_hv_nmos[ctype]
print @n.xbgr.xm36_u24.nsg13_hv_nmos[ide]
print @n.xbgr.xm36_u24.nsg13_hv_nmos[ige]
print @n.xbgr.xm36_u24.nsg13_hv_nmos[ise]
print @n.xbgr.xm36_u24.nsg13_hv_nmos[ibe]
print @n.xbgr.xm36_u24.nsg13_hv_nmos[ctype]
print @n.xbgr.xm37_u2.nsg13_hv_nmos[ide]
print @n.xbgr.xm37_u2.nsg13_hv_nmos[ige]
print @n.xbgr.xm37_u2.nsg13_hv_nmos[ise]
print @n.xbgr.xm37_u2.nsg13_hv_nmos[ibe]
print @n.xbgr.xm37_u2.nsg13_hv_nmos[ctype]
print @n.xbgr.xm37_u3.nsg13_hv_nmos[ide]
print @n.xbgr.xm37_u3.nsg13_hv_nmos[ige]
print @n.xbgr.xm37_u3.nsg13_hv_nmos[ise]
print @n.xbgr.xm37_u3.nsg13_hv_nmos[ibe]
print @n.xbgr.xm37_u3.nsg13_hv_nmos[ctype]
print @n.xbgr.xm37_u4.nsg13_hv_nmos[ide]
print @n.xbgr.xm37_u4.nsg13_hv_nmos[ige]
print @n.xbgr.xm37_u4.nsg13_hv_nmos[ise]
print @n.xbgr.xm37_u4.nsg13_hv_nmos[ibe]
print @n.xbgr.xm37_u4.nsg13_hv_nmos[ctype]
print @n.xbgr.xm37_u5.nsg13_hv_nmos[ide]
print @n.xbgr.xm37_u5.nsg13_hv_nmos[ige]
print @n.xbgr.xm37_u5.nsg13_hv_nmos[ise]
print @n.xbgr.xm37_u5.nsg13_hv_nmos[ibe]
print @n.xbgr.xm37_u5.nsg13_hv_nmos[ctype]
print @n.xbgr.xm37_u6.nsg13_hv_nmos[ide]
print @n.xbgr.xm37_u6.nsg13_hv_nmos[ige]
print @n.xbgr.xm37_u6.nsg13_hv_nmos[ise]
print @n.xbgr.xm37_u6.nsg13_hv_nmos[ibe]
print @n.xbgr.xm37_u6.nsg13_hv_nmos[ctype]
print @n.xbgr.xm37_u7.nsg13_hv_nmos[ide]
print @n.xbgr.xm37_u7.nsg13_hv_nmos[ige]
print @n.xbgr.xm37_u7.nsg13_hv_nmos[ise]
print @n.xbgr.xm37_u7.nsg13_hv_nmos[ibe]
print @n.xbgr.xm37_u7.nsg13_hv_nmos[ctype]
print @n.xbgr.xm37_u8.nsg13_hv_nmos[ide]
print @n.xbgr.xm37_u8.nsg13_hv_nmos[ige]
print @n.xbgr.xm37_u8.nsg13_hv_nmos[ise]
print @n.xbgr.xm37_u8.nsg13_hv_nmos[ibe]
print @n.xbgr.xm37_u8.nsg13_hv_nmos[ctype]
print @n.xbgr.xm37_u9.nsg13_hv_nmos[ide]
print @n.xbgr.xm37_u9.nsg13_hv_nmos[ige]
print @n.xbgr.xm37_u9.nsg13_hv_nmos[ise]
print @n.xbgr.xm37_u9.nsg13_hv_nmos[ibe]
print @n.xbgr.xm37_u9.nsg13_hv_nmos[ctype]
print @n.xbgr.xm37_u10.nsg13_hv_nmos[ide]
print @n.xbgr.xm37_u10.nsg13_hv_nmos[ige]
print @n.xbgr.xm37_u10.nsg13_hv_nmos[ise]
print @n.xbgr.xm37_u10.nsg13_hv_nmos[ibe]
print @n.xbgr.xm37_u10.nsg13_hv_nmos[ctype]
print @n.xbgr.xm37_u11.nsg13_hv_nmos[ide]
print @n.xbgr.xm37_u11.nsg13_hv_nmos[ige]
print @n.xbgr.xm37_u11.nsg13_hv_nmos[ise]
print @n.xbgr.xm37_u11.nsg13_hv_nmos[ibe]
print @n.xbgr.xm37_u11.nsg13_hv_nmos[ctype]
print @n.xbgr.xm37_u12.nsg13_hv_nmos[ide]
print @n.xbgr.xm37_u12.nsg13_hv_nmos[ige]
print @n.xbgr.xm37_u12.nsg13_hv_nmos[ise]
print @n.xbgr.xm37_u12.nsg13_hv_nmos[ibe]
print @n.xbgr.xm37_u12.nsg13_hv_nmos[ctype]
print @n.xbgr.xm37_u13.nsg13_hv_nmos[ide]
print @n.xbgr.xm37_u13.nsg13_hv_nmos[ige]
print @n.xbgr.xm37_u13.nsg13_hv_nmos[ise]
print @n.xbgr.xm37_u13.nsg13_hv_nmos[ibe]
print @n.xbgr.xm37_u13.nsg13_hv_nmos[ctype]
print @n.xbgr.xm37_u14.nsg13_hv_nmos[ide]
print @n.xbgr.xm37_u14.nsg13_hv_nmos[ige]
print @n.xbgr.xm37_u14.nsg13_hv_nmos[ise]
print @n.xbgr.xm37_u14.nsg13_hv_nmos[ibe]
print @n.xbgr.xm37_u14.nsg13_hv_nmos[ctype]
print @n.xbgr.xm37_u15.nsg13_hv_nmos[ide]
print @n.xbgr.xm37_u15.nsg13_hv_nmos[ige]
print @n.xbgr.xm37_u15.nsg13_hv_nmos[ise]
print @n.xbgr.xm37_u15.nsg13_hv_nmos[ibe]
print @n.xbgr.xm37_u15.nsg13_hv_nmos[ctype]
print @n.xbgr.xm37_u16.nsg13_hv_nmos[ide]
print @n.xbgr.xm37_u16.nsg13_hv_nmos[ige]
print @n.xbgr.xm37_u16.nsg13_hv_nmos[ise]
print @n.xbgr.xm37_u16.nsg13_hv_nmos[ibe]
print @n.xbgr.xm37_u16.nsg13_hv_nmos[ctype]
print @n.xbgr.xm37_u17.nsg13_hv_nmos[ide]
print @n.xbgr.xm37_u17.nsg13_hv_nmos[ige]
print @n.xbgr.xm37_u17.nsg13_hv_nmos[ise]
print @n.xbgr.xm37_u17.nsg13_hv_nmos[ibe]
print @n.xbgr.xm37_u17.nsg13_hv_nmos[ctype]
print @n.xbgr.xm37_u18.nsg13_hv_nmos[ide]
print @n.xbgr.xm37_u18.nsg13_hv_nmos[ige]
print @n.xbgr.xm37_u18.nsg13_hv_nmos[ise]
print @n.xbgr.xm37_u18.nsg13_hv_nmos[ibe]
print @n.xbgr.xm37_u18.nsg13_hv_nmos[ctype]
print @n.xbgr.xm37_u19.nsg13_hv_nmos[ide]
print @n.xbgr.xm37_u19.nsg13_hv_nmos[ige]
print @n.xbgr.xm37_u19.nsg13_hv_nmos[ise]
print @n.xbgr.xm37_u19.nsg13_hv_nmos[ibe]
print @n.xbgr.xm37_u19.nsg13_hv_nmos[ctype]
print @n.xbgr.xm37_u20.nsg13_hv_nmos[ide]
print @n.xbgr.xm37_u20.nsg13_hv_nmos[ige]
print @n.xbgr.xm37_u20.nsg13_hv_nmos[ise]
print @n.xbgr.xm37_u20.nsg13_hv_nmos[ibe]
print @n.xbgr.xm37_u20.nsg13_hv_nmos[ctype]
print @n.xbgr.xm37_u21.nsg13_hv_nmos[ide]
print @n.xbgr.xm37_u21.nsg13_hv_nmos[ige]
print @n.xbgr.xm37_u21.nsg13_hv_nmos[ise]
print @n.xbgr.xm37_u21.nsg13_hv_nmos[ibe]
print @n.xbgr.xm37_u21.nsg13_hv_nmos[ctype]
print @n.xbgr.xm37_u22.nsg13_hv_nmos[ide]
print @n.xbgr.xm37_u22.nsg13_hv_nmos[ige]
print @n.xbgr.xm37_u22.nsg13_hv_nmos[ise]
print @n.xbgr.xm37_u22.nsg13_hv_nmos[ibe]
print @n.xbgr.xm37_u22.nsg13_hv_nmos[ctype]
print @n.xbgr.xm37_u23.nsg13_hv_nmos[ide]
print @n.xbgr.xm37_u23.nsg13_hv_nmos[ige]
print @n.xbgr.xm37_u23.nsg13_hv_nmos[ise]
print @n.xbgr.xm37_u23.nsg13_hv_nmos[ibe]
print @n.xbgr.xm37_u23.nsg13_hv_nmos[ctype]
print @n.xbgr.xm37_u24.nsg13_hv_nmos[ide]
print @n.xbgr.xm37_u24.nsg13_hv_nmos[ige]
print @n.xbgr.xm37_u24.nsg13_hv_nmos[ise]
print @n.xbgr.xm37_u24.nsg13_hv_nmos[ibe]
print @n.xbgr.xm37_u24.nsg13_hv_nmos[ctype]
print @n.xbgr.xm38_u2.nsg13_hv_pmos[ide]
print @n.xbgr.xm38_u2.nsg13_hv_pmos[ige]
print @n.xbgr.xm38_u2.nsg13_hv_pmos[ise]
print @n.xbgr.xm38_u2.nsg13_hv_pmos[ibe]
print @n.xbgr.xm38_u2.nsg13_hv_pmos[ctype]
print @n.xbgr.xm38_u3.nsg13_hv_pmos[ide]
print @n.xbgr.xm38_u3.nsg13_hv_pmos[ige]
print @n.xbgr.xm38_u3.nsg13_hv_pmos[ise]
print @n.xbgr.xm38_u3.nsg13_hv_pmos[ibe]
print @n.xbgr.xm38_u3.nsg13_hv_pmos[ctype]
print @n.xbgr.xm38_u4.nsg13_hv_pmos[ide]
print @n.xbgr.xm38_u4.nsg13_hv_pmos[ige]
print @n.xbgr.xm38_u4.nsg13_hv_pmos[ise]
print @n.xbgr.xm38_u4.nsg13_hv_pmos[ibe]
print @n.xbgr.xm38_u4.nsg13_hv_pmos[ctype]
print @n.xbgr.xm38_u5.nsg13_hv_pmos[ide]
print @n.xbgr.xm38_u5.nsg13_hv_pmos[ige]
print @n.xbgr.xm38_u5.nsg13_hv_pmos[ise]
print @n.xbgr.xm38_u5.nsg13_hv_pmos[ibe]
print @n.xbgr.xm38_u5.nsg13_hv_pmos[ctype]
print @n.xbgr.xm38_u6.nsg13_hv_pmos[ide]
print @n.xbgr.xm38_u6.nsg13_hv_pmos[ige]
print @n.xbgr.xm38_u6.nsg13_hv_pmos[ise]
print @n.xbgr.xm38_u6.nsg13_hv_pmos[ibe]
print @n.xbgr.xm38_u6.nsg13_hv_pmos[ctype]
print @n.xbgr.xm38_u7.nsg13_hv_pmos[ide]
print @n.xbgr.xm38_u7.nsg13_hv_pmos[ige]
print @n.xbgr.xm38_u7.nsg13_hv_pmos[ise]
print @n.xbgr.xm38_u7.nsg13_hv_pmos[ibe]
print @n.xbgr.xm38_u7.nsg13_hv_pmos[ctype]
print @n.xbgr.xm38_u8.nsg13_hv_pmos[ide]
print @n.xbgr.xm38_u8.nsg13_hv_pmos[ige]
print @n.xbgr.xm38_u8.nsg13_hv_pmos[ise]
print @n.xbgr.xm38_u8.nsg13_hv_pmos[ibe]
print @n.xbgr.xm38_u8.nsg13_hv_pmos[ctype]
print @n.xbgr.xm38_u9.nsg13_hv_pmos[ide]
print @n.xbgr.xm38_u9.nsg13_hv_pmos[ige]
print @n.xbgr.xm38_u9.nsg13_hv_pmos[ise]
print @n.xbgr.xm38_u9.nsg13_hv_pmos[ibe]
print @n.xbgr.xm38_u9.nsg13_hv_pmos[ctype]
print @n.xbgr.xm38_u10.nsg13_hv_pmos[ide]
print @n.xbgr.xm38_u10.nsg13_hv_pmos[ige]
print @n.xbgr.xm38_u10.nsg13_hv_pmos[ise]
print @n.xbgr.xm38_u10.nsg13_hv_pmos[ibe]
print @n.xbgr.xm38_u10.nsg13_hv_pmos[ctype]
print @n.xbgr.xm38_u11.nsg13_hv_pmos[ide]
print @n.xbgr.xm38_u11.nsg13_hv_pmos[ige]
print @n.xbgr.xm38_u11.nsg13_hv_pmos[ise]
print @n.xbgr.xm38_u11.nsg13_hv_pmos[ibe]
print @n.xbgr.xm38_u11.nsg13_hv_pmos[ctype]
print @n.xbgr.xm38_u12.nsg13_hv_pmos[ide]
print @n.xbgr.xm38_u12.nsg13_hv_pmos[ige]
print @n.xbgr.xm38_u12.nsg13_hv_pmos[ise]
print @n.xbgr.xm38_u12.nsg13_hv_pmos[ibe]
print @n.xbgr.xm38_u12.nsg13_hv_pmos[ctype]
print @n.xbgr.xm38_u13.nsg13_hv_pmos[ide]
print @n.xbgr.xm38_u13.nsg13_hv_pmos[ige]
print @n.xbgr.xm38_u13.nsg13_hv_pmos[ise]
print @n.xbgr.xm38_u13.nsg13_hv_pmos[ibe]
print @n.xbgr.xm38_u13.nsg13_hv_pmos[ctype]
print @n.xbgr.xm38_u14.nsg13_hv_pmos[ide]
print @n.xbgr.xm38_u14.nsg13_hv_pmos[ige]
print @n.xbgr.xm38_u14.nsg13_hv_pmos[ise]
print @n.xbgr.xm38_u14.nsg13_hv_pmos[ibe]
print @n.xbgr.xm38_u14.nsg13_hv_pmos[ctype]
print @n.xbgr.xm38_u15.nsg13_hv_pmos[ide]
print @n.xbgr.xm38_u15.nsg13_hv_pmos[ige]
print @n.xbgr.xm38_u15.nsg13_hv_pmos[ise]
print @n.xbgr.xm38_u15.nsg13_hv_pmos[ibe]
print @n.xbgr.xm38_u15.nsg13_hv_pmos[ctype]
print @n.xbgr.xm38_u16.nsg13_hv_pmos[ide]
print @n.xbgr.xm38_u16.nsg13_hv_pmos[ige]
print @n.xbgr.xm38_u16.nsg13_hv_pmos[ise]
print @n.xbgr.xm38_u16.nsg13_hv_pmos[ibe]
print @n.xbgr.xm38_u16.nsg13_hv_pmos[ctype]
print @n.xbgr.xm38_u17.nsg13_hv_pmos[ide]
print @n.xbgr.xm38_u17.nsg13_hv_pmos[ige]
print @n.xbgr.xm38_u17.nsg13_hv_pmos[ise]
print @n.xbgr.xm38_u17.nsg13_hv_pmos[ibe]
print @n.xbgr.xm38_u17.nsg13_hv_pmos[ctype]
print @n.xbgr.xm38_u18.nsg13_hv_pmos[ide]
print @n.xbgr.xm38_u18.nsg13_hv_pmos[ige]
print @n.xbgr.xm38_u18.nsg13_hv_pmos[ise]
print @n.xbgr.xm38_u18.nsg13_hv_pmos[ibe]
print @n.xbgr.xm38_u18.nsg13_hv_pmos[ctype]
print @n.xbgr.xm38_u19.nsg13_hv_pmos[ide]
print @n.xbgr.xm38_u19.nsg13_hv_pmos[ige]
print @n.xbgr.xm38_u19.nsg13_hv_pmos[ise]
print @n.xbgr.xm38_u19.nsg13_hv_pmos[ibe]
print @n.xbgr.xm38_u19.nsg13_hv_pmos[ctype]
print @n.xbgr.xm38_u20.nsg13_hv_pmos[ide]
print @n.xbgr.xm38_u20.nsg13_hv_pmos[ige]
print @n.xbgr.xm38_u20.nsg13_hv_pmos[ise]
print @n.xbgr.xm38_u20.nsg13_hv_pmos[ibe]
print @n.xbgr.xm38_u20.nsg13_hv_pmos[ctype]
print @n.xbgr.xm38_u21.nsg13_hv_pmos[ide]
print @n.xbgr.xm38_u21.nsg13_hv_pmos[ige]
print @n.xbgr.xm38_u21.nsg13_hv_pmos[ise]
print @n.xbgr.xm38_u21.nsg13_hv_pmos[ibe]
print @n.xbgr.xm38_u21.nsg13_hv_pmos[ctype]
print @n.xbgr.xm38_u22.nsg13_hv_pmos[ide]
print @n.xbgr.xm38_u22.nsg13_hv_pmos[ige]
print @n.xbgr.xm38_u22.nsg13_hv_pmos[ise]
print @n.xbgr.xm38_u22.nsg13_hv_pmos[ibe]
print @n.xbgr.xm38_u22.nsg13_hv_pmos[ctype]
print @n.xbgr.xm38_u23.nsg13_hv_pmos[ide]
print @n.xbgr.xm38_u23.nsg13_hv_pmos[ige]
print @n.xbgr.xm38_u23.nsg13_hv_pmos[ise]
print @n.xbgr.xm38_u23.nsg13_hv_pmos[ibe]
print @n.xbgr.xm38_u23.nsg13_hv_pmos[ctype]
print @n.xbgr.xm38_u24.nsg13_hv_pmos[ide]
print @n.xbgr.xm38_u24.nsg13_hv_pmos[ige]
print @n.xbgr.xm38_u24.nsg13_hv_pmos[ise]
print @n.xbgr.xm38_u24.nsg13_hv_pmos[ibe]
print @n.xbgr.xm38_u24.nsg13_hv_pmos[ctype]
print @n.xbgr.xm39_u2.nsg13_hv_pmos[ide]
print @n.xbgr.xm39_u2.nsg13_hv_pmos[ige]
print @n.xbgr.xm39_u2.nsg13_hv_pmos[ise]
print @n.xbgr.xm39_u2.nsg13_hv_pmos[ibe]
print @n.xbgr.xm39_u2.nsg13_hv_pmos[ctype]
print @n.xbgr.xm39_u3.nsg13_hv_pmos[ide]
print @n.xbgr.xm39_u3.nsg13_hv_pmos[ige]
print @n.xbgr.xm39_u3.nsg13_hv_pmos[ise]
print @n.xbgr.xm39_u3.nsg13_hv_pmos[ibe]
print @n.xbgr.xm39_u3.nsg13_hv_pmos[ctype]
print @n.xbgr.xm39_u4.nsg13_hv_pmos[ide]
print @n.xbgr.xm39_u4.nsg13_hv_pmos[ige]
print @n.xbgr.xm39_u4.nsg13_hv_pmos[ise]
print @n.xbgr.xm39_u4.nsg13_hv_pmos[ibe]
print @n.xbgr.xm39_u4.nsg13_hv_pmos[ctype]
print @n.xbgr.xm39_u5.nsg13_hv_pmos[ide]
print @n.xbgr.xm39_u5.nsg13_hv_pmos[ige]
print @n.xbgr.xm39_u5.nsg13_hv_pmos[ise]
print @n.xbgr.xm39_u5.nsg13_hv_pmos[ibe]
print @n.xbgr.xm39_u5.nsg13_hv_pmos[ctype]
print @n.xbgr.xm39_u6.nsg13_hv_pmos[ide]
print @n.xbgr.xm39_u6.nsg13_hv_pmos[ige]
print @n.xbgr.xm39_u6.nsg13_hv_pmos[ise]
print @n.xbgr.xm39_u6.nsg13_hv_pmos[ibe]
print @n.xbgr.xm39_u6.nsg13_hv_pmos[ctype]
print @n.xbgr.xm39_u7.nsg13_hv_pmos[ide]
print @n.xbgr.xm39_u7.nsg13_hv_pmos[ige]
print @n.xbgr.xm39_u7.nsg13_hv_pmos[ise]
print @n.xbgr.xm39_u7.nsg13_hv_pmos[ibe]
print @n.xbgr.xm39_u7.nsg13_hv_pmos[ctype]
print @n.xbgr.xm39_u8.nsg13_hv_pmos[ide]
print @n.xbgr.xm39_u8.nsg13_hv_pmos[ige]
print @n.xbgr.xm39_u8.nsg13_hv_pmos[ise]
print @n.xbgr.xm39_u8.nsg13_hv_pmos[ibe]
print @n.xbgr.xm39_u8.nsg13_hv_pmos[ctype]
print @n.xbgr.xm39_u9.nsg13_hv_pmos[ide]
print @n.xbgr.xm39_u9.nsg13_hv_pmos[ige]
print @n.xbgr.xm39_u9.nsg13_hv_pmos[ise]
print @n.xbgr.xm39_u9.nsg13_hv_pmos[ibe]
print @n.xbgr.xm39_u9.nsg13_hv_pmos[ctype]
print @n.xbgr.xm39_u10.nsg13_hv_pmos[ide]
print @n.xbgr.xm39_u10.nsg13_hv_pmos[ige]
print @n.xbgr.xm39_u10.nsg13_hv_pmos[ise]
print @n.xbgr.xm39_u10.nsg13_hv_pmos[ibe]
print @n.xbgr.xm39_u10.nsg13_hv_pmos[ctype]
print @n.xbgr.xm39_u11.nsg13_hv_pmos[ide]
print @n.xbgr.xm39_u11.nsg13_hv_pmos[ige]
print @n.xbgr.xm39_u11.nsg13_hv_pmos[ise]
print @n.xbgr.xm39_u11.nsg13_hv_pmos[ibe]
print @n.xbgr.xm39_u11.nsg13_hv_pmos[ctype]
print @n.xbgr.xm39_u12.nsg13_hv_pmos[ide]
print @n.xbgr.xm39_u12.nsg13_hv_pmos[ige]
print @n.xbgr.xm39_u12.nsg13_hv_pmos[ise]
print @n.xbgr.xm39_u12.nsg13_hv_pmos[ibe]
print @n.xbgr.xm39_u12.nsg13_hv_pmos[ctype]
print @n.xbgr.xm39_u13.nsg13_hv_pmos[ide]
print @n.xbgr.xm39_u13.nsg13_hv_pmos[ige]
print @n.xbgr.xm39_u13.nsg13_hv_pmos[ise]
print @n.xbgr.xm39_u13.nsg13_hv_pmos[ibe]
print @n.xbgr.xm39_u13.nsg13_hv_pmos[ctype]
print @n.xbgr.xm39_u14.nsg13_hv_pmos[ide]
print @n.xbgr.xm39_u14.nsg13_hv_pmos[ige]
print @n.xbgr.xm39_u14.nsg13_hv_pmos[ise]
print @n.xbgr.xm39_u14.nsg13_hv_pmos[ibe]
print @n.xbgr.xm39_u14.nsg13_hv_pmos[ctype]
print @n.xbgr.xm39_u15.nsg13_hv_pmos[ide]
print @n.xbgr.xm39_u15.nsg13_hv_pmos[ige]
print @n.xbgr.xm39_u15.nsg13_hv_pmos[ise]
print @n.xbgr.xm39_u15.nsg13_hv_pmos[ibe]
print @n.xbgr.xm39_u15.nsg13_hv_pmos[ctype]
print @n.xbgr.xm39_u16.nsg13_hv_pmos[ide]
print @n.xbgr.xm39_u16.nsg13_hv_pmos[ige]
print @n.xbgr.xm39_u16.nsg13_hv_pmos[ise]
print @n.xbgr.xm39_u16.nsg13_hv_pmos[ibe]
print @n.xbgr.xm39_u16.nsg13_hv_pmos[ctype]
print @n.xbgr.xm39_u17.nsg13_hv_pmos[ide]
print @n.xbgr.xm39_u17.nsg13_hv_pmos[ige]
print @n.xbgr.xm39_u17.nsg13_hv_pmos[ise]
print @n.xbgr.xm39_u17.nsg13_hv_pmos[ibe]
print @n.xbgr.xm39_u17.nsg13_hv_pmos[ctype]
print @n.xbgr.xm39_u18.nsg13_hv_pmos[ide]
print @n.xbgr.xm39_u18.nsg13_hv_pmos[ige]
print @n.xbgr.xm39_u18.nsg13_hv_pmos[ise]
print @n.xbgr.xm39_u18.nsg13_hv_pmos[ibe]
print @n.xbgr.xm39_u18.nsg13_hv_pmos[ctype]
print @n.xbgr.xm39_u19.nsg13_hv_pmos[ide]
print @n.xbgr.xm39_u19.nsg13_hv_pmos[ige]
print @n.xbgr.xm39_u19.nsg13_hv_pmos[ise]
print @n.xbgr.xm39_u19.nsg13_hv_pmos[ibe]
print @n.xbgr.xm39_u19.nsg13_hv_pmos[ctype]
print @n.xbgr.xm39_u20.nsg13_hv_pmos[ide]
print @n.xbgr.xm39_u20.nsg13_hv_pmos[ige]
print @n.xbgr.xm39_u20.nsg13_hv_pmos[ise]
print @n.xbgr.xm39_u20.nsg13_hv_pmos[ibe]
print @n.xbgr.xm39_u20.nsg13_hv_pmos[ctype]
print @n.xbgr.xm39_u21.nsg13_hv_pmos[ide]
print @n.xbgr.xm39_u21.nsg13_hv_pmos[ige]
print @n.xbgr.xm39_u21.nsg13_hv_pmos[ise]
print @n.xbgr.xm39_u21.nsg13_hv_pmos[ibe]
print @n.xbgr.xm39_u21.nsg13_hv_pmos[ctype]
print @n.xbgr.xm39_u22.nsg13_hv_pmos[ide]
print @n.xbgr.xm39_u22.nsg13_hv_pmos[ige]
print @n.xbgr.xm39_u22.nsg13_hv_pmos[ise]
print @n.xbgr.xm39_u22.nsg13_hv_pmos[ibe]
print @n.xbgr.xm39_u22.nsg13_hv_pmos[ctype]
print @n.xbgr.xm39_u23.nsg13_hv_pmos[ide]
print @n.xbgr.xm39_u23.nsg13_hv_pmos[ige]
print @n.xbgr.xm39_u23.nsg13_hv_pmos[ise]
print @n.xbgr.xm39_u23.nsg13_hv_pmos[ibe]
print @n.xbgr.xm39_u23.nsg13_hv_pmos[ctype]
print @n.xbgr.xm39_u24.nsg13_hv_pmos[ide]
print @n.xbgr.xm39_u24.nsg13_hv_pmos[ige]
print @n.xbgr.xm39_u24.nsg13_hv_pmos[ise]
print @n.xbgr.xm39_u24.nsg13_hv_pmos[ibe]
print @n.xbgr.xm39_u24.nsg13_hv_pmos[ctype]
print @n.xbgr.xm41_u2.nsg13_hv_pmos[ide]
print @n.xbgr.xm41_u2.nsg13_hv_pmos[ige]
print @n.xbgr.xm41_u2.nsg13_hv_pmos[ise]
print @n.xbgr.xm41_u2.nsg13_hv_pmos[ibe]
print @n.xbgr.xm41_u2.nsg13_hv_pmos[ctype]
print @n.xbgr.xm41_u3.nsg13_hv_pmos[ide]
print @n.xbgr.xm41_u3.nsg13_hv_pmos[ige]
print @n.xbgr.xm41_u3.nsg13_hv_pmos[ise]
print @n.xbgr.xm41_u3.nsg13_hv_pmos[ibe]
print @n.xbgr.xm41_u3.nsg13_hv_pmos[ctype]
print @n.xbgr.xm41_u4.nsg13_hv_pmos[ide]
print @n.xbgr.xm41_u4.nsg13_hv_pmos[ige]
print @n.xbgr.xm41_u4.nsg13_hv_pmos[ise]
print @n.xbgr.xm41_u4.nsg13_hv_pmos[ibe]
print @n.xbgr.xm41_u4.nsg13_hv_pmos[ctype]
print @n.xbgr.xm41_u5.nsg13_hv_pmos[ide]
print @n.xbgr.xm41_u5.nsg13_hv_pmos[ige]
print @n.xbgr.xm41_u5.nsg13_hv_pmos[ise]
print @n.xbgr.xm41_u5.nsg13_hv_pmos[ibe]
print @n.xbgr.xm41_u5.nsg13_hv_pmos[ctype]
print @n.xbgr.xm41_u6.nsg13_hv_pmos[ide]
print @n.xbgr.xm41_u6.nsg13_hv_pmos[ige]
print @n.xbgr.xm41_u6.nsg13_hv_pmos[ise]
print @n.xbgr.xm41_u6.nsg13_hv_pmos[ibe]
print @n.xbgr.xm41_u6.nsg13_hv_pmos[ctype]
print @n.xbgr.xm41_u7.nsg13_hv_pmos[ide]
print @n.xbgr.xm41_u7.nsg13_hv_pmos[ige]
print @n.xbgr.xm41_u7.nsg13_hv_pmos[ise]
print @n.xbgr.xm41_u7.nsg13_hv_pmos[ibe]
print @n.xbgr.xm41_u7.nsg13_hv_pmos[ctype]
print @n.xbgr.xm41_u8.nsg13_hv_pmos[ide]
print @n.xbgr.xm41_u8.nsg13_hv_pmos[ige]
print @n.xbgr.xm41_u8.nsg13_hv_pmos[ise]
print @n.xbgr.xm41_u8.nsg13_hv_pmos[ibe]
print @n.xbgr.xm41_u8.nsg13_hv_pmos[ctype]
print @n.xbgr.xm41_u9.nsg13_hv_pmos[ide]
print @n.xbgr.xm41_u9.nsg13_hv_pmos[ige]
print @n.xbgr.xm41_u9.nsg13_hv_pmos[ise]
print @n.xbgr.xm41_u9.nsg13_hv_pmos[ibe]
print @n.xbgr.xm41_u9.nsg13_hv_pmos[ctype]
print @n.xbgr.xm41_u10.nsg13_hv_pmos[ide]
print @n.xbgr.xm41_u10.nsg13_hv_pmos[ige]
print @n.xbgr.xm41_u10.nsg13_hv_pmos[ise]
print @n.xbgr.xm41_u10.nsg13_hv_pmos[ibe]
print @n.xbgr.xm41_u10.nsg13_hv_pmos[ctype]
print @n.xbgr.xm41_u11.nsg13_hv_pmos[ide]
print @n.xbgr.xm41_u11.nsg13_hv_pmos[ige]
print @n.xbgr.xm41_u11.nsg13_hv_pmos[ise]
print @n.xbgr.xm41_u11.nsg13_hv_pmos[ibe]
print @n.xbgr.xm41_u11.nsg13_hv_pmos[ctype]
print @n.xbgr.xm41_u12.nsg13_hv_pmos[ide]
print @n.xbgr.xm41_u12.nsg13_hv_pmos[ige]
print @n.xbgr.xm41_u12.nsg13_hv_pmos[ise]
print @n.xbgr.xm41_u12.nsg13_hv_pmos[ibe]
print @n.xbgr.xm41_u12.nsg13_hv_pmos[ctype]
print @n.xbgr.xm41_u13.nsg13_hv_pmos[ide]
print @n.xbgr.xm41_u13.nsg13_hv_pmos[ige]
print @n.xbgr.xm41_u13.nsg13_hv_pmos[ise]
print @n.xbgr.xm41_u13.nsg13_hv_pmos[ibe]
print @n.xbgr.xm41_u13.nsg13_hv_pmos[ctype]
print @n.xbgr.xm41_u14.nsg13_hv_pmos[ide]
print @n.xbgr.xm41_u14.nsg13_hv_pmos[ige]
print @n.xbgr.xm41_u14.nsg13_hv_pmos[ise]
print @n.xbgr.xm41_u14.nsg13_hv_pmos[ibe]
print @n.xbgr.xm41_u14.nsg13_hv_pmos[ctype]
print @n.xbgr.xm41_u15.nsg13_hv_pmos[ide]
print @n.xbgr.xm41_u15.nsg13_hv_pmos[ige]
print @n.xbgr.xm41_u15.nsg13_hv_pmos[ise]
print @n.xbgr.xm41_u15.nsg13_hv_pmos[ibe]
print @n.xbgr.xm41_u15.nsg13_hv_pmos[ctype]
print @n.xbgr.xm41_u16.nsg13_hv_pmos[ide]
print @n.xbgr.xm41_u16.nsg13_hv_pmos[ige]
print @n.xbgr.xm41_u16.nsg13_hv_pmos[ise]
print @n.xbgr.xm41_u16.nsg13_hv_pmos[ibe]
print @n.xbgr.xm41_u16.nsg13_hv_pmos[ctype]
print @n.xbgr.xm41_u17.nsg13_hv_pmos[ide]
print @n.xbgr.xm41_u17.nsg13_hv_pmos[ige]
print @n.xbgr.xm41_u17.nsg13_hv_pmos[ise]
print @n.xbgr.xm41_u17.nsg13_hv_pmos[ibe]
print @n.xbgr.xm41_u17.nsg13_hv_pmos[ctype]
print @n.xbgr.xm41_u18.nsg13_hv_pmos[ide]
print @n.xbgr.xm41_u18.nsg13_hv_pmos[ige]
print @n.xbgr.xm41_u18.nsg13_hv_pmos[ise]
print @n.xbgr.xm41_u18.nsg13_hv_pmos[ibe]
print @n.xbgr.xm41_u18.nsg13_hv_pmos[ctype]
print @n.xbgr.xm41_u19.nsg13_hv_pmos[ide]
print @n.xbgr.xm41_u19.nsg13_hv_pmos[ige]
print @n.xbgr.xm41_u19.nsg13_hv_pmos[ise]
print @n.xbgr.xm41_u19.nsg13_hv_pmos[ibe]
print @n.xbgr.xm41_u19.nsg13_hv_pmos[ctype]
print @n.xbgr.xm41_u20.nsg13_hv_pmos[ide]
print @n.xbgr.xm41_u20.nsg13_hv_pmos[ige]
print @n.xbgr.xm41_u20.nsg13_hv_pmos[ise]
print @n.xbgr.xm41_u20.nsg13_hv_pmos[ibe]
print @n.xbgr.xm41_u20.nsg13_hv_pmos[ctype]
print @n.xbgr.xm41_u21.nsg13_hv_pmos[ide]
print @n.xbgr.xm41_u21.nsg13_hv_pmos[ige]
print @n.xbgr.xm41_u21.nsg13_hv_pmos[ise]
print @n.xbgr.xm41_u21.nsg13_hv_pmos[ibe]
print @n.xbgr.xm41_u21.nsg13_hv_pmos[ctype]
print @n.xbgr.xm41_u22.nsg13_hv_pmos[ide]
print @n.xbgr.xm41_u22.nsg13_hv_pmos[ige]
print @n.xbgr.xm41_u22.nsg13_hv_pmos[ise]
print @n.xbgr.xm41_u22.nsg13_hv_pmos[ibe]
print @n.xbgr.xm41_u22.nsg13_hv_pmos[ctype]
print @n.xbgr.xm41_u23.nsg13_hv_pmos[ide]
print @n.xbgr.xm41_u23.nsg13_hv_pmos[ige]
print @n.xbgr.xm41_u23.nsg13_hv_pmos[ise]
print @n.xbgr.xm41_u23.nsg13_hv_pmos[ibe]
print @n.xbgr.xm41_u23.nsg13_hv_pmos[ctype]
print @n.xbgr.xm41_u24.nsg13_hv_pmos[ide]
print @n.xbgr.xm41_u24.nsg13_hv_pmos[ige]
print @n.xbgr.xm41_u24.nsg13_hv_pmos[ise]
print @n.xbgr.xm41_u24.nsg13_hv_pmos[ibe]
print @n.xbgr.xm41_u24.nsg13_hv_pmos[ctype]
print @n.xbgr.xm43_u2.nsg13_hv_pmos[ide]
print @n.xbgr.xm43_u2.nsg13_hv_pmos[ige]
print @n.xbgr.xm43_u2.nsg13_hv_pmos[ise]
print @n.xbgr.xm43_u2.nsg13_hv_pmos[ibe]
print @n.xbgr.xm43_u2.nsg13_hv_pmos[ctype]
print @n.xbgr.xm43_u3.nsg13_hv_pmos[ide]
print @n.xbgr.xm43_u3.nsg13_hv_pmos[ige]
print @n.xbgr.xm43_u3.nsg13_hv_pmos[ise]
print @n.xbgr.xm43_u3.nsg13_hv_pmos[ibe]
print @n.xbgr.xm43_u3.nsg13_hv_pmos[ctype]
print @n.xbgr.xm43_u4.nsg13_hv_pmos[ide]
print @n.xbgr.xm43_u4.nsg13_hv_pmos[ige]
print @n.xbgr.xm43_u4.nsg13_hv_pmos[ise]
print @n.xbgr.xm43_u4.nsg13_hv_pmos[ibe]
print @n.xbgr.xm43_u4.nsg13_hv_pmos[ctype]
print @n.xbgr.xm44_u2.nsg13_hv_pmos[ide]
print @n.xbgr.xm44_u2.nsg13_hv_pmos[ige]
print @n.xbgr.xm44_u2.nsg13_hv_pmos[ise]
print @n.xbgr.xm44_u2.nsg13_hv_pmos[ibe]
print @n.xbgr.xm44_u2.nsg13_hv_pmos[ctype]
print @n.xbgr.xm44_u3.nsg13_hv_pmos[ide]
print @n.xbgr.xm44_u3.nsg13_hv_pmos[ige]
print @n.xbgr.xm44_u3.nsg13_hv_pmos[ise]
print @n.xbgr.xm44_u3.nsg13_hv_pmos[ibe]
print @n.xbgr.xm44_u3.nsg13_hv_pmos[ctype]
print @n.xbgr.xm44_u4.nsg13_hv_pmos[ide]
print @n.xbgr.xm44_u4.nsg13_hv_pmos[ige]
print @n.xbgr.xm44_u4.nsg13_hv_pmos[ise]
print @n.xbgr.xm44_u4.nsg13_hv_pmos[ibe]
print @n.xbgr.xm44_u4.nsg13_hv_pmos[ctype]
print @n.xbgr.xm45_u2.nsg13_hv_pmos[ide]
print @n.xbgr.xm45_u2.nsg13_hv_pmos[ige]
print @n.xbgr.xm45_u2.nsg13_hv_pmos[ise]
print @n.xbgr.xm45_u2.nsg13_hv_pmos[ibe]
print @n.xbgr.xm45_u2.nsg13_hv_pmos[ctype]
print @n.xbgr.xm45_u3.nsg13_hv_pmos[ide]
print @n.xbgr.xm45_u3.nsg13_hv_pmos[ige]
print @n.xbgr.xm45_u3.nsg13_hv_pmos[ise]
print @n.xbgr.xm45_u3.nsg13_hv_pmos[ibe]
print @n.xbgr.xm45_u3.nsg13_hv_pmos[ctype]
print @n.xbgr.xm45_u4.nsg13_hv_pmos[ide]
print @n.xbgr.xm45_u4.nsg13_hv_pmos[ige]
print @n.xbgr.xm45_u4.nsg13_hv_pmos[ise]
print @n.xbgr.xm45_u4.nsg13_hv_pmos[ibe]
print @n.xbgr.xm45_u4.nsg13_hv_pmos[ctype]
print @n.xbgr.xm45_u5.nsg13_hv_pmos[ide]
print @n.xbgr.xm45_u5.nsg13_hv_pmos[ige]
print @n.xbgr.xm45_u5.nsg13_hv_pmos[ise]
print @n.xbgr.xm45_u5.nsg13_hv_pmos[ibe]
print @n.xbgr.xm45_u5.nsg13_hv_pmos[ctype]
print @n.xbgr.xm45_u6.nsg13_hv_pmos[ide]
print @n.xbgr.xm45_u6.nsg13_hv_pmos[ige]
print @n.xbgr.xm45_u6.nsg13_hv_pmos[ise]
print @n.xbgr.xm45_u6.nsg13_hv_pmos[ibe]
print @n.xbgr.xm45_u6.nsg13_hv_pmos[ctype]
print @n.xbgr.xm45_u7.nsg13_hv_pmos[ide]
print @n.xbgr.xm45_u7.nsg13_hv_pmos[ige]
print @n.xbgr.xm45_u7.nsg13_hv_pmos[ise]
print @n.xbgr.xm45_u7.nsg13_hv_pmos[ibe]
print @n.xbgr.xm45_u7.nsg13_hv_pmos[ctype]
print @n.xbgr.xm45_u8.nsg13_hv_pmos[ide]
print @n.xbgr.xm45_u8.nsg13_hv_pmos[ige]
print @n.xbgr.xm45_u8.nsg13_hv_pmos[ise]
print @n.xbgr.xm45_u8.nsg13_hv_pmos[ibe]
print @n.xbgr.xm45_u8.nsg13_hv_pmos[ctype]
print @n.xbgr.xm45_u9.nsg13_hv_pmos[ide]
print @n.xbgr.xm45_u9.nsg13_hv_pmos[ige]
print @n.xbgr.xm45_u9.nsg13_hv_pmos[ise]
print @n.xbgr.xm45_u9.nsg13_hv_pmos[ibe]
print @n.xbgr.xm45_u9.nsg13_hv_pmos[ctype]
print @n.xbgr.xm45_u10.nsg13_hv_pmos[ide]
print @n.xbgr.xm45_u10.nsg13_hv_pmos[ige]
print @n.xbgr.xm45_u10.nsg13_hv_pmos[ise]
print @n.xbgr.xm45_u10.nsg13_hv_pmos[ibe]
print @n.xbgr.xm45_u10.nsg13_hv_pmos[ctype]
print @n.xbgr.xm45_u11.nsg13_hv_pmos[ide]
print @n.xbgr.xm45_u11.nsg13_hv_pmos[ige]
print @n.xbgr.xm45_u11.nsg13_hv_pmos[ise]
print @n.xbgr.xm45_u11.nsg13_hv_pmos[ibe]
print @n.xbgr.xm45_u11.nsg13_hv_pmos[ctype]
print @n.xbgr.xm45_u12.nsg13_hv_pmos[ide]
print @n.xbgr.xm45_u12.nsg13_hv_pmos[ige]
print @n.xbgr.xm45_u12.nsg13_hv_pmos[ise]
print @n.xbgr.xm45_u12.nsg13_hv_pmos[ibe]
print @n.xbgr.xm45_u12.nsg13_hv_pmos[ctype]
print @n.xbgr.xm45_u13.nsg13_hv_pmos[ide]
print @n.xbgr.xm45_u13.nsg13_hv_pmos[ige]
print @n.xbgr.xm45_u13.nsg13_hv_pmos[ise]
print @n.xbgr.xm45_u13.nsg13_hv_pmos[ibe]
print @n.xbgr.xm45_u13.nsg13_hv_pmos[ctype]
print @n.xbgr.xm45_u14.nsg13_hv_pmos[ide]
print @n.xbgr.xm45_u14.nsg13_hv_pmos[ige]
print @n.xbgr.xm45_u14.nsg13_hv_pmos[ise]
print @n.xbgr.xm45_u14.nsg13_hv_pmos[ibe]
print @n.xbgr.xm45_u14.nsg13_hv_pmos[ctype]
print @n.xbgr.xm45_u15.nsg13_hv_pmos[ide]
print @n.xbgr.xm45_u15.nsg13_hv_pmos[ige]
print @n.xbgr.xm45_u15.nsg13_hv_pmos[ise]
print @n.xbgr.xm45_u15.nsg13_hv_pmos[ibe]
print @n.xbgr.xm45_u15.nsg13_hv_pmos[ctype]
print @n.xbgr.xm45_u16.nsg13_hv_pmos[ide]
print @n.xbgr.xm45_u16.nsg13_hv_pmos[ige]
print @n.xbgr.xm45_u16.nsg13_hv_pmos[ise]
print @n.xbgr.xm45_u16.nsg13_hv_pmos[ibe]
print @n.xbgr.xm45_u16.nsg13_hv_pmos[ctype]
print @n.xbgr.xm45_u17.nsg13_hv_pmos[ide]
print @n.xbgr.xm45_u17.nsg13_hv_pmos[ige]
print @n.xbgr.xm45_u17.nsg13_hv_pmos[ise]
print @n.xbgr.xm45_u17.nsg13_hv_pmos[ibe]
print @n.xbgr.xm45_u17.nsg13_hv_pmos[ctype]
print @n.xbgr.xm45_u18.nsg13_hv_pmos[ide]
print @n.xbgr.xm45_u18.nsg13_hv_pmos[ige]
print @n.xbgr.xm45_u18.nsg13_hv_pmos[ise]
print @n.xbgr.xm45_u18.nsg13_hv_pmos[ibe]
print @n.xbgr.xm45_u18.nsg13_hv_pmos[ctype]
print @n.xbgr.xm45_u19.nsg13_hv_pmos[ide]
print @n.xbgr.xm45_u19.nsg13_hv_pmos[ige]
print @n.xbgr.xm45_u19.nsg13_hv_pmos[ise]
print @n.xbgr.xm45_u19.nsg13_hv_pmos[ibe]
print @n.xbgr.xm45_u19.nsg13_hv_pmos[ctype]
print @n.xbgr.xm45_u20.nsg13_hv_pmos[ide]
print @n.xbgr.xm45_u20.nsg13_hv_pmos[ige]
print @n.xbgr.xm45_u20.nsg13_hv_pmos[ise]
print @n.xbgr.xm45_u20.nsg13_hv_pmos[ibe]
print @n.xbgr.xm45_u20.nsg13_hv_pmos[ctype]
print @n.xbgr.xm45_u21.nsg13_hv_pmos[ide]
print @n.xbgr.xm45_u21.nsg13_hv_pmos[ige]
print @n.xbgr.xm45_u21.nsg13_hv_pmos[ise]
print @n.xbgr.xm45_u21.nsg13_hv_pmos[ibe]
print @n.xbgr.xm45_u21.nsg13_hv_pmos[ctype]
print @n.xbgr.xm45_u22.nsg13_hv_pmos[ide]
print @n.xbgr.xm45_u22.nsg13_hv_pmos[ige]
print @n.xbgr.xm45_u22.nsg13_hv_pmos[ise]
print @n.xbgr.xm45_u22.nsg13_hv_pmos[ibe]
print @n.xbgr.xm45_u22.nsg13_hv_pmos[ctype]
print @n.xbgr.xm45_u23.nsg13_hv_pmos[ide]
print @n.xbgr.xm45_u23.nsg13_hv_pmos[ige]
print @n.xbgr.xm45_u23.nsg13_hv_pmos[ise]
print @n.xbgr.xm45_u23.nsg13_hv_pmos[ibe]
print @n.xbgr.xm45_u23.nsg13_hv_pmos[ctype]
print @n.xbgr.xm45_u24.nsg13_hv_pmos[ide]
print @n.xbgr.xm45_u24.nsg13_hv_pmos[ige]
print @n.xbgr.xm45_u24.nsg13_hv_pmos[ise]
print @n.xbgr.xm45_u24.nsg13_hv_pmos[ibe]
print @n.xbgr.xm45_u24.nsg13_hv_pmos[ctype]
print @n.xbgr.xm47_u2.nsg13_hv_pmos[ide]
print @n.xbgr.xm47_u2.nsg13_hv_pmos[ige]
print @n.xbgr.xm47_u2.nsg13_hv_pmos[ise]
print @n.xbgr.xm47_u2.nsg13_hv_pmos[ibe]
print @n.xbgr.xm47_u2.nsg13_hv_pmos[ctype]
print @n.xbgr.xm47_u3.nsg13_hv_pmos[ide]
print @n.xbgr.xm47_u3.nsg13_hv_pmos[ige]
print @n.xbgr.xm47_u3.nsg13_hv_pmos[ise]
print @n.xbgr.xm47_u3.nsg13_hv_pmos[ibe]
print @n.xbgr.xm47_u3.nsg13_hv_pmos[ctype]
print @n.xbgr.xm47_u4.nsg13_hv_pmos[ide]
print @n.xbgr.xm47_u4.nsg13_hv_pmos[ige]
print @n.xbgr.xm47_u4.nsg13_hv_pmos[ise]
print @n.xbgr.xm47_u4.nsg13_hv_pmos[ibe]
print @n.xbgr.xm47_u4.nsg13_hv_pmos[ctype]
print @n.xbgr.xm47_u5.nsg13_hv_pmos[ide]
print @n.xbgr.xm47_u5.nsg13_hv_pmos[ige]
print @n.xbgr.xm47_u5.nsg13_hv_pmos[ise]
print @n.xbgr.xm47_u5.nsg13_hv_pmos[ibe]
print @n.xbgr.xm47_u5.nsg13_hv_pmos[ctype]
print @n.xbgr.xm47_u6.nsg13_hv_pmos[ide]
print @n.xbgr.xm47_u6.nsg13_hv_pmos[ige]
print @n.xbgr.xm47_u6.nsg13_hv_pmos[ise]
print @n.xbgr.xm47_u6.nsg13_hv_pmos[ibe]
print @n.xbgr.xm47_u6.nsg13_hv_pmos[ctype]
print @n.xbgr.xm47_u7.nsg13_hv_pmos[ide]
print @n.xbgr.xm47_u7.nsg13_hv_pmos[ige]
print @n.xbgr.xm47_u7.nsg13_hv_pmos[ise]
print @n.xbgr.xm47_u7.nsg13_hv_pmos[ibe]
print @n.xbgr.xm47_u7.nsg13_hv_pmos[ctype]
print @n.xbgr.xm47_u8.nsg13_hv_pmos[ide]
print @n.xbgr.xm47_u8.nsg13_hv_pmos[ige]
print @n.xbgr.xm47_u8.nsg13_hv_pmos[ise]
print @n.xbgr.xm47_u8.nsg13_hv_pmos[ibe]
print @n.xbgr.xm47_u8.nsg13_hv_pmos[ctype]
print @n.xbgr.xm47_u9.nsg13_hv_pmos[ide]
print @n.xbgr.xm47_u9.nsg13_hv_pmos[ige]
print @n.xbgr.xm47_u9.nsg13_hv_pmos[ise]
print @n.xbgr.xm47_u9.nsg13_hv_pmos[ibe]
print @n.xbgr.xm47_u9.nsg13_hv_pmos[ctype]
print @n.xbgr.xm47_u10.nsg13_hv_pmos[ide]
print @n.xbgr.xm47_u10.nsg13_hv_pmos[ige]
print @n.xbgr.xm47_u10.nsg13_hv_pmos[ise]
print @n.xbgr.xm47_u10.nsg13_hv_pmos[ibe]
print @n.xbgr.xm47_u10.nsg13_hv_pmos[ctype]
print @n.xbgr.xm47_u11.nsg13_hv_pmos[ide]
print @n.xbgr.xm47_u11.nsg13_hv_pmos[ige]
print @n.xbgr.xm47_u11.nsg13_hv_pmos[ise]
print @n.xbgr.xm47_u11.nsg13_hv_pmos[ibe]
print @n.xbgr.xm47_u11.nsg13_hv_pmos[ctype]
print @n.xbgr.xm47_u12.nsg13_hv_pmos[ide]
print @n.xbgr.xm47_u12.nsg13_hv_pmos[ige]
print @n.xbgr.xm47_u12.nsg13_hv_pmos[ise]
print @n.xbgr.xm47_u12.nsg13_hv_pmos[ibe]
print @n.xbgr.xm47_u12.nsg13_hv_pmos[ctype]
print @n.xbgr.xm47_u13.nsg13_hv_pmos[ide]
print @n.xbgr.xm47_u13.nsg13_hv_pmos[ige]
print @n.xbgr.xm47_u13.nsg13_hv_pmos[ise]
print @n.xbgr.xm47_u13.nsg13_hv_pmos[ibe]
print @n.xbgr.xm47_u13.nsg13_hv_pmos[ctype]
print @n.xbgr.xm47_u14.nsg13_hv_pmos[ide]
print @n.xbgr.xm47_u14.nsg13_hv_pmos[ige]
print @n.xbgr.xm47_u14.nsg13_hv_pmos[ise]
print @n.xbgr.xm47_u14.nsg13_hv_pmos[ibe]
print @n.xbgr.xm47_u14.nsg13_hv_pmos[ctype]
print @n.xbgr.xm47_u15.nsg13_hv_pmos[ide]
print @n.xbgr.xm47_u15.nsg13_hv_pmos[ige]
print @n.xbgr.xm47_u15.nsg13_hv_pmos[ise]
print @n.xbgr.xm47_u15.nsg13_hv_pmos[ibe]
print @n.xbgr.xm47_u15.nsg13_hv_pmos[ctype]
print @n.xbgr.xm47_u16.nsg13_hv_pmos[ide]
print @n.xbgr.xm47_u16.nsg13_hv_pmos[ige]
print @n.xbgr.xm47_u16.nsg13_hv_pmos[ise]
print @n.xbgr.xm47_u16.nsg13_hv_pmos[ibe]
print @n.xbgr.xm47_u16.nsg13_hv_pmos[ctype]
print @n.xbgr.xm47_u17.nsg13_hv_pmos[ide]
print @n.xbgr.xm47_u17.nsg13_hv_pmos[ige]
print @n.xbgr.xm47_u17.nsg13_hv_pmos[ise]
print @n.xbgr.xm47_u17.nsg13_hv_pmos[ibe]
print @n.xbgr.xm47_u17.nsg13_hv_pmos[ctype]
print @n.xbgr.xm47_u18.nsg13_hv_pmos[ide]
print @n.xbgr.xm47_u18.nsg13_hv_pmos[ige]
print @n.xbgr.xm47_u18.nsg13_hv_pmos[ise]
print @n.xbgr.xm47_u18.nsg13_hv_pmos[ibe]
print @n.xbgr.xm47_u18.nsg13_hv_pmos[ctype]
print @n.xbgr.xm47_u19.nsg13_hv_pmos[ide]
print @n.xbgr.xm47_u19.nsg13_hv_pmos[ige]
print @n.xbgr.xm47_u19.nsg13_hv_pmos[ise]
print @n.xbgr.xm47_u19.nsg13_hv_pmos[ibe]
print @n.xbgr.xm47_u19.nsg13_hv_pmos[ctype]
print @n.xbgr.xm47_u20.nsg13_hv_pmos[ide]
print @n.xbgr.xm47_u20.nsg13_hv_pmos[ige]
print @n.xbgr.xm47_u20.nsg13_hv_pmos[ise]
print @n.xbgr.xm47_u20.nsg13_hv_pmos[ibe]
print @n.xbgr.xm47_u20.nsg13_hv_pmos[ctype]
print @n.xbgr.xm47_u21.nsg13_hv_pmos[ide]
print @n.xbgr.xm47_u21.nsg13_hv_pmos[ige]
print @n.xbgr.xm47_u21.nsg13_hv_pmos[ise]
print @n.xbgr.xm47_u21.nsg13_hv_pmos[ibe]
print @n.xbgr.xm47_u21.nsg13_hv_pmos[ctype]
print @n.xbgr.xm47_u22.nsg13_hv_pmos[ide]
print @n.xbgr.xm47_u22.nsg13_hv_pmos[ige]
print @n.xbgr.xm47_u22.nsg13_hv_pmos[ise]
print @n.xbgr.xm47_u22.nsg13_hv_pmos[ibe]
print @n.xbgr.xm47_u22.nsg13_hv_pmos[ctype]
print @n.xbgr.xm47_u23.nsg13_hv_pmos[ide]
print @n.xbgr.xm47_u23.nsg13_hv_pmos[ige]
print @n.xbgr.xm47_u23.nsg13_hv_pmos[ise]
print @n.xbgr.xm47_u23.nsg13_hv_pmos[ibe]
print @n.xbgr.xm47_u23.nsg13_hv_pmos[ctype]
print @n.xbgr.xm47_u24.nsg13_hv_pmos[ide]
print @n.xbgr.xm47_u24.nsg13_hv_pmos[ige]
print @n.xbgr.xm47_u24.nsg13_hv_pmos[ise]
print @n.xbgr.xm47_u24.nsg13_hv_pmos[ibe]
print @n.xbgr.xm47_u24.nsg13_hv_pmos[ctype]
print @n.xbgr.xm48_u2.nsg13_hv_pmos[ide]
print @n.xbgr.xm48_u2.nsg13_hv_pmos[ige]
print @n.xbgr.xm48_u2.nsg13_hv_pmos[ise]
print @n.xbgr.xm48_u2.nsg13_hv_pmos[ibe]
print @n.xbgr.xm48_u2.nsg13_hv_pmos[ctype]
print @n.xbgr.xm48_u3.nsg13_hv_pmos[ide]
print @n.xbgr.xm48_u3.nsg13_hv_pmos[ige]
print @n.xbgr.xm48_u3.nsg13_hv_pmos[ise]
print @n.xbgr.xm48_u3.nsg13_hv_pmos[ibe]
print @n.xbgr.xm48_u3.nsg13_hv_pmos[ctype]
print @n.xbgr.xm48_u4.nsg13_hv_pmos[ide]
print @n.xbgr.xm48_u4.nsg13_hv_pmos[ige]
print @n.xbgr.xm48_u4.nsg13_hv_pmos[ise]
print @n.xbgr.xm48_u4.nsg13_hv_pmos[ibe]
print @n.xbgr.xm48_u4.nsg13_hv_pmos[ctype]
print @n.xbgr.xm48_u5.nsg13_hv_pmos[ide]
print @n.xbgr.xm48_u5.nsg13_hv_pmos[ige]
print @n.xbgr.xm48_u5.nsg13_hv_pmos[ise]
print @n.xbgr.xm48_u5.nsg13_hv_pmos[ibe]
print @n.xbgr.xm48_u5.nsg13_hv_pmos[ctype]
print @n.xbgr.xm48_u6.nsg13_hv_pmos[ide]
print @n.xbgr.xm48_u6.nsg13_hv_pmos[ige]
print @n.xbgr.xm48_u6.nsg13_hv_pmos[ise]
print @n.xbgr.xm48_u6.nsg13_hv_pmos[ibe]
print @n.xbgr.xm48_u6.nsg13_hv_pmos[ctype]
print @n.xbgr.xm48_u7.nsg13_hv_pmos[ide]
print @n.xbgr.xm48_u7.nsg13_hv_pmos[ige]
print @n.xbgr.xm48_u7.nsg13_hv_pmos[ise]
print @n.xbgr.xm48_u7.nsg13_hv_pmos[ibe]
print @n.xbgr.xm48_u7.nsg13_hv_pmos[ctype]
print @n.xbgr.xm48_u8.nsg13_hv_pmos[ide]
print @n.xbgr.xm48_u8.nsg13_hv_pmos[ige]
print @n.xbgr.xm48_u8.nsg13_hv_pmos[ise]
print @n.xbgr.xm48_u8.nsg13_hv_pmos[ibe]
print @n.xbgr.xm48_u8.nsg13_hv_pmos[ctype]
print @n.xbgr.xm48_u9.nsg13_hv_pmos[ide]
print @n.xbgr.xm48_u9.nsg13_hv_pmos[ige]
print @n.xbgr.xm48_u9.nsg13_hv_pmos[ise]
print @n.xbgr.xm48_u9.nsg13_hv_pmos[ibe]
print @n.xbgr.xm48_u9.nsg13_hv_pmos[ctype]
print @n.xbgr.xm48_u10.nsg13_hv_pmos[ide]
print @n.xbgr.xm48_u10.nsg13_hv_pmos[ige]
print @n.xbgr.xm48_u10.nsg13_hv_pmos[ise]
print @n.xbgr.xm48_u10.nsg13_hv_pmos[ibe]
print @n.xbgr.xm48_u10.nsg13_hv_pmos[ctype]
print @n.xbgr.xm48_u11.nsg13_hv_pmos[ide]
print @n.xbgr.xm48_u11.nsg13_hv_pmos[ige]
print @n.xbgr.xm48_u11.nsg13_hv_pmos[ise]
print @n.xbgr.xm48_u11.nsg13_hv_pmos[ibe]
print @n.xbgr.xm48_u11.nsg13_hv_pmos[ctype]
print @n.xbgr.xm48_u12.nsg13_hv_pmos[ide]
print @n.xbgr.xm48_u12.nsg13_hv_pmos[ige]
print @n.xbgr.xm48_u12.nsg13_hv_pmos[ise]
print @n.xbgr.xm48_u12.nsg13_hv_pmos[ibe]
print @n.xbgr.xm48_u12.nsg13_hv_pmos[ctype]
print @n.xbgr.xm48_u13.nsg13_hv_pmos[ide]
print @n.xbgr.xm48_u13.nsg13_hv_pmos[ige]
print @n.xbgr.xm48_u13.nsg13_hv_pmos[ise]
print @n.xbgr.xm48_u13.nsg13_hv_pmos[ibe]
print @n.xbgr.xm48_u13.nsg13_hv_pmos[ctype]
print @n.xbgr.xm48_u14.nsg13_hv_pmos[ide]
print @n.xbgr.xm48_u14.nsg13_hv_pmos[ige]
print @n.xbgr.xm48_u14.nsg13_hv_pmos[ise]
print @n.xbgr.xm48_u14.nsg13_hv_pmos[ibe]
print @n.xbgr.xm48_u14.nsg13_hv_pmos[ctype]
print @n.xbgr.xm48_u15.nsg13_hv_pmos[ide]
print @n.xbgr.xm48_u15.nsg13_hv_pmos[ige]
print @n.xbgr.xm48_u15.nsg13_hv_pmos[ise]
print @n.xbgr.xm48_u15.nsg13_hv_pmos[ibe]
print @n.xbgr.xm48_u15.nsg13_hv_pmos[ctype]
print @n.xbgr.xm48_u16.nsg13_hv_pmos[ide]
print @n.xbgr.xm48_u16.nsg13_hv_pmos[ige]
print @n.xbgr.xm48_u16.nsg13_hv_pmos[ise]
print @n.xbgr.xm48_u16.nsg13_hv_pmos[ibe]
print @n.xbgr.xm48_u16.nsg13_hv_pmos[ctype]
print @n.xbgr.xm48_u17.nsg13_hv_pmos[ide]
print @n.xbgr.xm48_u17.nsg13_hv_pmos[ige]
print @n.xbgr.xm48_u17.nsg13_hv_pmos[ise]
print @n.xbgr.xm48_u17.nsg13_hv_pmos[ibe]
print @n.xbgr.xm48_u17.nsg13_hv_pmos[ctype]
print @n.xbgr.xm48_u18.nsg13_hv_pmos[ide]
print @n.xbgr.xm48_u18.nsg13_hv_pmos[ige]
print @n.xbgr.xm48_u18.nsg13_hv_pmos[ise]
print @n.xbgr.xm48_u18.nsg13_hv_pmos[ibe]
print @n.xbgr.xm48_u18.nsg13_hv_pmos[ctype]
print @n.xbgr.xm48_u19.nsg13_hv_pmos[ide]
print @n.xbgr.xm48_u19.nsg13_hv_pmos[ige]
print @n.xbgr.xm48_u19.nsg13_hv_pmos[ise]
print @n.xbgr.xm48_u19.nsg13_hv_pmos[ibe]
print @n.xbgr.xm48_u19.nsg13_hv_pmos[ctype]
print @n.xbgr.xm48_u20.nsg13_hv_pmos[ide]
print @n.xbgr.xm48_u20.nsg13_hv_pmos[ige]
print @n.xbgr.xm48_u20.nsg13_hv_pmos[ise]
print @n.xbgr.xm48_u20.nsg13_hv_pmos[ibe]
print @n.xbgr.xm48_u20.nsg13_hv_pmos[ctype]
print @n.xbgr.xm48_u21.nsg13_hv_pmos[ide]
print @n.xbgr.xm48_u21.nsg13_hv_pmos[ige]
print @n.xbgr.xm48_u21.nsg13_hv_pmos[ise]
print @n.xbgr.xm48_u21.nsg13_hv_pmos[ibe]
print @n.xbgr.xm48_u21.nsg13_hv_pmos[ctype]
print @n.xbgr.xm48_u22.nsg13_hv_pmos[ide]
print @n.xbgr.xm48_u22.nsg13_hv_pmos[ige]
print @n.xbgr.xm48_u22.nsg13_hv_pmos[ise]
print @n.xbgr.xm48_u22.nsg13_hv_pmos[ibe]
print @n.xbgr.xm48_u22.nsg13_hv_pmos[ctype]
print @n.xbgr.xm48_u23.nsg13_hv_pmos[ide]
print @n.xbgr.xm48_u23.nsg13_hv_pmos[ige]
print @n.xbgr.xm48_u23.nsg13_hv_pmos[ise]
print @n.xbgr.xm48_u23.nsg13_hv_pmos[ibe]
print @n.xbgr.xm48_u23.nsg13_hv_pmos[ctype]
print @n.xbgr.xm48_u24.nsg13_hv_pmos[ide]
print @n.xbgr.xm48_u24.nsg13_hv_pmos[ige]
print @n.xbgr.xm48_u24.nsg13_hv_pmos[ise]
print @n.xbgr.xm48_u24.nsg13_hv_pmos[ibe]
print @n.xbgr.xm48_u24.nsg13_hv_pmos[ctype]
print @n.xbgr.xm50_u2.nsg13_hv_pmos[ide]
print @n.xbgr.xm50_u2.nsg13_hv_pmos[ige]
print @n.xbgr.xm50_u2.nsg13_hv_pmos[ise]
print @n.xbgr.xm50_u2.nsg13_hv_pmos[ibe]
print @n.xbgr.xm50_u2.nsg13_hv_pmos[ctype]
print @n.xbgr.xm50_u3.nsg13_hv_pmos[ide]
print @n.xbgr.xm50_u3.nsg13_hv_pmos[ige]
print @n.xbgr.xm50_u3.nsg13_hv_pmos[ise]
print @n.xbgr.xm50_u3.nsg13_hv_pmos[ibe]
print @n.xbgr.xm50_u3.nsg13_hv_pmos[ctype]
print @n.xbgr.xm50_u4.nsg13_hv_pmos[ide]
print @n.xbgr.xm50_u4.nsg13_hv_pmos[ige]
print @n.xbgr.xm50_u4.nsg13_hv_pmos[ise]
print @n.xbgr.xm50_u4.nsg13_hv_pmos[ibe]
print @n.xbgr.xm50_u4.nsg13_hv_pmos[ctype]
print @n.xbgr.xm50_u5.nsg13_hv_pmos[ide]
print @n.xbgr.xm50_u5.nsg13_hv_pmos[ige]
print @n.xbgr.xm50_u5.nsg13_hv_pmos[ise]
print @n.xbgr.xm50_u5.nsg13_hv_pmos[ibe]
print @n.xbgr.xm50_u5.nsg13_hv_pmos[ctype]
print @n.xbgr.xm50_u6.nsg13_hv_pmos[ide]
print @n.xbgr.xm50_u6.nsg13_hv_pmos[ige]
print @n.xbgr.xm50_u6.nsg13_hv_pmos[ise]
print @n.xbgr.xm50_u6.nsg13_hv_pmos[ibe]
print @n.xbgr.xm50_u6.nsg13_hv_pmos[ctype]
print @n.xbgr.xm50_u7.nsg13_hv_pmos[ide]
print @n.xbgr.xm50_u7.nsg13_hv_pmos[ige]
print @n.xbgr.xm50_u7.nsg13_hv_pmos[ise]
print @n.xbgr.xm50_u7.nsg13_hv_pmos[ibe]
print @n.xbgr.xm50_u7.nsg13_hv_pmos[ctype]
print @n.xbgr.xm50_u8.nsg13_hv_pmos[ide]
print @n.xbgr.xm50_u8.nsg13_hv_pmos[ige]
print @n.xbgr.xm50_u8.nsg13_hv_pmos[ise]
print @n.xbgr.xm50_u8.nsg13_hv_pmos[ibe]
print @n.xbgr.xm50_u8.nsg13_hv_pmos[ctype]
print @n.xbgr.xm50_u9.nsg13_hv_pmos[ide]
print @n.xbgr.xm50_u9.nsg13_hv_pmos[ige]
print @n.xbgr.xm50_u9.nsg13_hv_pmos[ise]
print @n.xbgr.xm50_u9.nsg13_hv_pmos[ibe]
print @n.xbgr.xm50_u9.nsg13_hv_pmos[ctype]
print @n.xbgr.xm50_u10.nsg13_hv_pmos[ide]
print @n.xbgr.xm50_u10.nsg13_hv_pmos[ige]
print @n.xbgr.xm50_u10.nsg13_hv_pmos[ise]
print @n.xbgr.xm50_u10.nsg13_hv_pmos[ibe]
print @n.xbgr.xm50_u10.nsg13_hv_pmos[ctype]
print @n.xbgr.xm50_u11.nsg13_hv_pmos[ide]
print @n.xbgr.xm50_u11.nsg13_hv_pmos[ige]
print @n.xbgr.xm50_u11.nsg13_hv_pmos[ise]
print @n.xbgr.xm50_u11.nsg13_hv_pmos[ibe]
print @n.xbgr.xm50_u11.nsg13_hv_pmos[ctype]
print @n.xbgr.xm50_u12.nsg13_hv_pmos[ide]
print @n.xbgr.xm50_u12.nsg13_hv_pmos[ige]
print @n.xbgr.xm50_u12.nsg13_hv_pmos[ise]
print @n.xbgr.xm50_u12.nsg13_hv_pmos[ibe]
print @n.xbgr.xm50_u12.nsg13_hv_pmos[ctype]
print @n.xbgr.xm50_u13.nsg13_hv_pmos[ide]
print @n.xbgr.xm50_u13.nsg13_hv_pmos[ige]
print @n.xbgr.xm50_u13.nsg13_hv_pmos[ise]
print @n.xbgr.xm50_u13.nsg13_hv_pmos[ibe]
print @n.xbgr.xm50_u13.nsg13_hv_pmos[ctype]
print @n.xbgr.xm50_u14.nsg13_hv_pmos[ide]
print @n.xbgr.xm50_u14.nsg13_hv_pmos[ige]
print @n.xbgr.xm50_u14.nsg13_hv_pmos[ise]
print @n.xbgr.xm50_u14.nsg13_hv_pmos[ibe]
print @n.xbgr.xm50_u14.nsg13_hv_pmos[ctype]
print @n.xbgr.xm50_u15.nsg13_hv_pmos[ide]
print @n.xbgr.xm50_u15.nsg13_hv_pmos[ige]
print @n.xbgr.xm50_u15.nsg13_hv_pmos[ise]
print @n.xbgr.xm50_u15.nsg13_hv_pmos[ibe]
print @n.xbgr.xm50_u15.nsg13_hv_pmos[ctype]
print @n.xbgr.xm50_u16.nsg13_hv_pmos[ide]
print @n.xbgr.xm50_u16.nsg13_hv_pmos[ige]
print @n.xbgr.xm50_u16.nsg13_hv_pmos[ise]
print @n.xbgr.xm50_u16.nsg13_hv_pmos[ibe]
print @n.xbgr.xm50_u16.nsg13_hv_pmos[ctype]
print @n.xbgr.xm50_u17.nsg13_hv_pmos[ide]
print @n.xbgr.xm50_u17.nsg13_hv_pmos[ige]
print @n.xbgr.xm50_u17.nsg13_hv_pmos[ise]
print @n.xbgr.xm50_u17.nsg13_hv_pmos[ibe]
print @n.xbgr.xm50_u17.nsg13_hv_pmos[ctype]
print @n.xbgr.xm50_u18.nsg13_hv_pmos[ide]
print @n.xbgr.xm50_u18.nsg13_hv_pmos[ige]
print @n.xbgr.xm50_u18.nsg13_hv_pmos[ise]
print @n.xbgr.xm50_u18.nsg13_hv_pmos[ibe]
print @n.xbgr.xm50_u18.nsg13_hv_pmos[ctype]
print @n.xbgr.xm50_u19.nsg13_hv_pmos[ide]
print @n.xbgr.xm50_u19.nsg13_hv_pmos[ige]
print @n.xbgr.xm50_u19.nsg13_hv_pmos[ise]
print @n.xbgr.xm50_u19.nsg13_hv_pmos[ibe]
print @n.xbgr.xm50_u19.nsg13_hv_pmos[ctype]
print @n.xbgr.xm50_u20.nsg13_hv_pmos[ide]
print @n.xbgr.xm50_u20.nsg13_hv_pmos[ige]
print @n.xbgr.xm50_u20.nsg13_hv_pmos[ise]
print @n.xbgr.xm50_u20.nsg13_hv_pmos[ibe]
print @n.xbgr.xm50_u20.nsg13_hv_pmos[ctype]
print @n.xbgr.xm50_u21.nsg13_hv_pmos[ide]
print @n.xbgr.xm50_u21.nsg13_hv_pmos[ige]
print @n.xbgr.xm50_u21.nsg13_hv_pmos[ise]
print @n.xbgr.xm50_u21.nsg13_hv_pmos[ibe]
print @n.xbgr.xm50_u21.nsg13_hv_pmos[ctype]
print @n.xbgr.xm50_u22.nsg13_hv_pmos[ide]
print @n.xbgr.xm50_u22.nsg13_hv_pmos[ige]
print @n.xbgr.xm50_u22.nsg13_hv_pmos[ise]
print @n.xbgr.xm50_u22.nsg13_hv_pmos[ibe]
print @n.xbgr.xm50_u22.nsg13_hv_pmos[ctype]
print @n.xbgr.xm50_u23.nsg13_hv_pmos[ide]
print @n.xbgr.xm50_u23.nsg13_hv_pmos[ige]
print @n.xbgr.xm50_u23.nsg13_hv_pmos[ise]
print @n.xbgr.xm50_u23.nsg13_hv_pmos[ibe]
print @n.xbgr.xm50_u23.nsg13_hv_pmos[ctype]
print @n.xbgr.xm50_u24.nsg13_hv_pmos[ide]
print @n.xbgr.xm50_u24.nsg13_hv_pmos[ige]
print @n.xbgr.xm50_u24.nsg13_hv_pmos[ise]
print @n.xbgr.xm50_u24.nsg13_hv_pmos[ibe]
print @n.xbgr.xm50_u24.nsg13_hv_pmos[ctype]
print @n.xbgr.xm51_u2.nsg13_hv_pmos[ide]
print @n.xbgr.xm51_u2.nsg13_hv_pmos[ige]
print @n.xbgr.xm51_u2.nsg13_hv_pmos[ise]
print @n.xbgr.xm51_u2.nsg13_hv_pmos[ibe]
print @n.xbgr.xm51_u2.nsg13_hv_pmos[ctype]
print @n.xbgr.xm51_u3.nsg13_hv_pmos[ide]
print @n.xbgr.xm51_u3.nsg13_hv_pmos[ige]
print @n.xbgr.xm51_u3.nsg13_hv_pmos[ise]
print @n.xbgr.xm51_u3.nsg13_hv_pmos[ibe]
print @n.xbgr.xm51_u3.nsg13_hv_pmos[ctype]
print @n.xbgr.xm51_u4.nsg13_hv_pmos[ide]
print @n.xbgr.xm51_u4.nsg13_hv_pmos[ige]
print @n.xbgr.xm51_u4.nsg13_hv_pmos[ise]
print @n.xbgr.xm51_u4.nsg13_hv_pmos[ibe]
print @n.xbgr.xm51_u4.nsg13_hv_pmos[ctype]
print @n.xbgr.xm52_u2.nsg13_hv_pmos[ide]
print @n.xbgr.xm52_u2.nsg13_hv_pmos[ige]
print @n.xbgr.xm52_u2.nsg13_hv_pmos[ise]
print @n.xbgr.xm52_u2.nsg13_hv_pmos[ibe]
print @n.xbgr.xm52_u2.nsg13_hv_pmos[ctype]
print @n.xbgr.xm52_u3.nsg13_hv_pmos[ide]
print @n.xbgr.xm52_u3.nsg13_hv_pmos[ige]
print @n.xbgr.xm52_u3.nsg13_hv_pmos[ise]
print @n.xbgr.xm52_u3.nsg13_hv_pmos[ibe]
print @n.xbgr.xm52_u3.nsg13_hv_pmos[ctype]
print @n.xbgr.xm52_u4.nsg13_hv_pmos[ide]
print @n.xbgr.xm52_u4.nsg13_hv_pmos[ige]
print @n.xbgr.xm52_u4.nsg13_hv_pmos[ise]
print @n.xbgr.xm52_u4.nsg13_hv_pmos[ibe]
print @n.xbgr.xm52_u4.nsg13_hv_pmos[ctype]
print @n.xbgr.xm52_u5.nsg13_hv_pmos[ide]
print @n.xbgr.xm52_u5.nsg13_hv_pmos[ige]
print @n.xbgr.xm52_u5.nsg13_hv_pmos[ise]
print @n.xbgr.xm52_u5.nsg13_hv_pmos[ibe]
print @n.xbgr.xm52_u5.nsg13_hv_pmos[ctype]
print @n.xbgr.xm52_u6.nsg13_hv_pmos[ide]
print @n.xbgr.xm52_u6.nsg13_hv_pmos[ige]
print @n.xbgr.xm52_u6.nsg13_hv_pmos[ise]
print @n.xbgr.xm52_u6.nsg13_hv_pmos[ibe]
print @n.xbgr.xm52_u6.nsg13_hv_pmos[ctype]
print @n.xbgr.xm52_u7.nsg13_hv_pmos[ide]
print @n.xbgr.xm52_u7.nsg13_hv_pmos[ige]
print @n.xbgr.xm52_u7.nsg13_hv_pmos[ise]
print @n.xbgr.xm52_u7.nsg13_hv_pmos[ibe]
print @n.xbgr.xm52_u7.nsg13_hv_pmos[ctype]
print @n.xbgr.xm52_u8.nsg13_hv_pmos[ide]
print @n.xbgr.xm52_u8.nsg13_hv_pmos[ige]
print @n.xbgr.xm52_u8.nsg13_hv_pmos[ise]
print @n.xbgr.xm52_u8.nsg13_hv_pmos[ibe]
print @n.xbgr.xm52_u8.nsg13_hv_pmos[ctype]
print @n.xbgr.xm52_u9.nsg13_hv_pmos[ide]
print @n.xbgr.xm52_u9.nsg13_hv_pmos[ige]
print @n.xbgr.xm52_u9.nsg13_hv_pmos[ise]
print @n.xbgr.xm52_u9.nsg13_hv_pmos[ibe]
print @n.xbgr.xm52_u9.nsg13_hv_pmos[ctype]
print @n.xbgr.xm52_u10.nsg13_hv_pmos[ide]
print @n.xbgr.xm52_u10.nsg13_hv_pmos[ige]
print @n.xbgr.xm52_u10.nsg13_hv_pmos[ise]
print @n.xbgr.xm52_u10.nsg13_hv_pmos[ibe]
print @n.xbgr.xm52_u10.nsg13_hv_pmos[ctype]
print @n.xbgr.xm52_u11.nsg13_hv_pmos[ide]
print @n.xbgr.xm52_u11.nsg13_hv_pmos[ige]
print @n.xbgr.xm52_u11.nsg13_hv_pmos[ise]
print @n.xbgr.xm52_u11.nsg13_hv_pmos[ibe]
print @n.xbgr.xm52_u11.nsg13_hv_pmos[ctype]
print @n.xbgr.xm52_u12.nsg13_hv_pmos[ide]
print @n.xbgr.xm52_u12.nsg13_hv_pmos[ige]
print @n.xbgr.xm52_u12.nsg13_hv_pmos[ise]
print @n.xbgr.xm52_u12.nsg13_hv_pmos[ibe]
print @n.xbgr.xm52_u12.nsg13_hv_pmos[ctype]
print @n.xbgr.xm52_u13.nsg13_hv_pmos[ide]
print @n.xbgr.xm52_u13.nsg13_hv_pmos[ige]
print @n.xbgr.xm52_u13.nsg13_hv_pmos[ise]
print @n.xbgr.xm52_u13.nsg13_hv_pmos[ibe]
print @n.xbgr.xm52_u13.nsg13_hv_pmos[ctype]
print @n.xbgr.xm52_u14.nsg13_hv_pmos[ide]
print @n.xbgr.xm52_u14.nsg13_hv_pmos[ige]
print @n.xbgr.xm52_u14.nsg13_hv_pmos[ise]
print @n.xbgr.xm52_u14.nsg13_hv_pmos[ibe]
print @n.xbgr.xm52_u14.nsg13_hv_pmos[ctype]
print @n.xbgr.xm52_u15.nsg13_hv_pmos[ide]
print @n.xbgr.xm52_u15.nsg13_hv_pmos[ige]
print @n.xbgr.xm52_u15.nsg13_hv_pmos[ise]
print @n.xbgr.xm52_u15.nsg13_hv_pmos[ibe]
print @n.xbgr.xm52_u15.nsg13_hv_pmos[ctype]
print @n.xbgr.xm52_u16.nsg13_hv_pmos[ide]
print @n.xbgr.xm52_u16.nsg13_hv_pmos[ige]
print @n.xbgr.xm52_u16.nsg13_hv_pmos[ise]
print @n.xbgr.xm52_u16.nsg13_hv_pmos[ibe]
print @n.xbgr.xm52_u16.nsg13_hv_pmos[ctype]
print @n.xbgr.xm52_u17.nsg13_hv_pmos[ide]
print @n.xbgr.xm52_u17.nsg13_hv_pmos[ige]
print @n.xbgr.xm52_u17.nsg13_hv_pmos[ise]
print @n.xbgr.xm52_u17.nsg13_hv_pmos[ibe]
print @n.xbgr.xm52_u17.nsg13_hv_pmos[ctype]
print @n.xbgr.xm52_u18.nsg13_hv_pmos[ide]
print @n.xbgr.xm52_u18.nsg13_hv_pmos[ige]
print @n.xbgr.xm52_u18.nsg13_hv_pmos[ise]
print @n.xbgr.xm52_u18.nsg13_hv_pmos[ibe]
print @n.xbgr.xm52_u18.nsg13_hv_pmos[ctype]
print @n.xbgr.xm52_u19.nsg13_hv_pmos[ide]
print @n.xbgr.xm52_u19.nsg13_hv_pmos[ige]
print @n.xbgr.xm52_u19.nsg13_hv_pmos[ise]
print @n.xbgr.xm52_u19.nsg13_hv_pmos[ibe]
print @n.xbgr.xm52_u19.nsg13_hv_pmos[ctype]
print @n.xbgr.xm52_u20.nsg13_hv_pmos[ide]
print @n.xbgr.xm52_u20.nsg13_hv_pmos[ige]
print @n.xbgr.xm52_u20.nsg13_hv_pmos[ise]
print @n.xbgr.xm52_u20.nsg13_hv_pmos[ibe]
print @n.xbgr.xm52_u20.nsg13_hv_pmos[ctype]
print @n.xbgr.xm52_u21.nsg13_hv_pmos[ide]
print @n.xbgr.xm52_u21.nsg13_hv_pmos[ige]
print @n.xbgr.xm52_u21.nsg13_hv_pmos[ise]
print @n.xbgr.xm52_u21.nsg13_hv_pmos[ibe]
print @n.xbgr.xm52_u21.nsg13_hv_pmos[ctype]
print @n.xbgr.xm52_u22.nsg13_hv_pmos[ide]
print @n.xbgr.xm52_u22.nsg13_hv_pmos[ige]
print @n.xbgr.xm52_u22.nsg13_hv_pmos[ise]
print @n.xbgr.xm52_u22.nsg13_hv_pmos[ibe]
print @n.xbgr.xm52_u22.nsg13_hv_pmos[ctype]
print @n.xbgr.xm52_u23.nsg13_hv_pmos[ide]
print @n.xbgr.xm52_u23.nsg13_hv_pmos[ige]
print @n.xbgr.xm52_u23.nsg13_hv_pmos[ise]
print @n.xbgr.xm52_u23.nsg13_hv_pmos[ibe]
print @n.xbgr.xm52_u23.nsg13_hv_pmos[ctype]
print @n.xbgr.xm52_u24.nsg13_hv_pmos[ide]
print @n.xbgr.xm52_u24.nsg13_hv_pmos[ige]
print @n.xbgr.xm52_u24.nsg13_hv_pmos[ise]
print @n.xbgr.xm52_u24.nsg13_hv_pmos[ibe]
print @n.xbgr.xm52_u24.nsg13_hv_pmos[ctype]
print @n.xbgr.xm54_u2.nsg13_hv_pmos[ide]
print @n.xbgr.xm54_u2.nsg13_hv_pmos[ige]
print @n.xbgr.xm54_u2.nsg13_hv_pmos[ise]
print @n.xbgr.xm54_u2.nsg13_hv_pmos[ibe]
print @n.xbgr.xm54_u2.nsg13_hv_pmos[ctype]
print @n.xbgr.xm54_u3.nsg13_hv_pmos[ide]
print @n.xbgr.xm54_u3.nsg13_hv_pmos[ige]
print @n.xbgr.xm54_u3.nsg13_hv_pmos[ise]
print @n.xbgr.xm54_u3.nsg13_hv_pmos[ibe]
print @n.xbgr.xm54_u3.nsg13_hv_pmos[ctype]
print @n.xbgr.xm54_u4.nsg13_hv_pmos[ide]
print @n.xbgr.xm54_u4.nsg13_hv_pmos[ige]
print @n.xbgr.xm54_u4.nsg13_hv_pmos[ise]
print @n.xbgr.xm54_u4.nsg13_hv_pmos[ibe]
print @n.xbgr.xm54_u4.nsg13_hv_pmos[ctype]
print @n.xbgr.xm54_u5.nsg13_hv_pmos[ide]
print @n.xbgr.xm54_u5.nsg13_hv_pmos[ige]
print @n.xbgr.xm54_u5.nsg13_hv_pmos[ise]
print @n.xbgr.xm54_u5.nsg13_hv_pmos[ibe]
print @n.xbgr.xm54_u5.nsg13_hv_pmos[ctype]
print @n.xbgr.xm54_u6.nsg13_hv_pmos[ide]
print @n.xbgr.xm54_u6.nsg13_hv_pmos[ige]
print @n.xbgr.xm54_u6.nsg13_hv_pmos[ise]
print @n.xbgr.xm54_u6.nsg13_hv_pmos[ibe]
print @n.xbgr.xm54_u6.nsg13_hv_pmos[ctype]
print @n.xbgr.xm54_u7.nsg13_hv_pmos[ide]
print @n.xbgr.xm54_u7.nsg13_hv_pmos[ige]
print @n.xbgr.xm54_u7.nsg13_hv_pmos[ise]
print @n.xbgr.xm54_u7.nsg13_hv_pmos[ibe]
print @n.xbgr.xm54_u7.nsg13_hv_pmos[ctype]
print @n.xbgr.xm54_u8.nsg13_hv_pmos[ide]
print @n.xbgr.xm54_u8.nsg13_hv_pmos[ige]
print @n.xbgr.xm54_u8.nsg13_hv_pmos[ise]
print @n.xbgr.xm54_u8.nsg13_hv_pmos[ibe]
print @n.xbgr.xm54_u8.nsg13_hv_pmos[ctype]
print @n.xbgr.xm54_u9.nsg13_hv_pmos[ide]
print @n.xbgr.xm54_u9.nsg13_hv_pmos[ige]
print @n.xbgr.xm54_u9.nsg13_hv_pmos[ise]
print @n.xbgr.xm54_u9.nsg13_hv_pmos[ibe]
print @n.xbgr.xm54_u9.nsg13_hv_pmos[ctype]
print @n.xbgr.xm54_u10.nsg13_hv_pmos[ide]
print @n.xbgr.xm54_u10.nsg13_hv_pmos[ige]
print @n.xbgr.xm54_u10.nsg13_hv_pmos[ise]
print @n.xbgr.xm54_u10.nsg13_hv_pmos[ibe]
print @n.xbgr.xm54_u10.nsg13_hv_pmos[ctype]
print @n.xbgr.xm54_u11.nsg13_hv_pmos[ide]
print @n.xbgr.xm54_u11.nsg13_hv_pmos[ige]
print @n.xbgr.xm54_u11.nsg13_hv_pmos[ise]
print @n.xbgr.xm54_u11.nsg13_hv_pmos[ibe]
print @n.xbgr.xm54_u11.nsg13_hv_pmos[ctype]
print @n.xbgr.xm54_u12.nsg13_hv_pmos[ide]
print @n.xbgr.xm54_u12.nsg13_hv_pmos[ige]
print @n.xbgr.xm54_u12.nsg13_hv_pmos[ise]
print @n.xbgr.xm54_u12.nsg13_hv_pmos[ibe]
print @n.xbgr.xm54_u12.nsg13_hv_pmos[ctype]
print @n.xbgr.xm54_u13.nsg13_hv_pmos[ide]
print @n.xbgr.xm54_u13.nsg13_hv_pmos[ige]
print @n.xbgr.xm54_u13.nsg13_hv_pmos[ise]
print @n.xbgr.xm54_u13.nsg13_hv_pmos[ibe]
print @n.xbgr.xm54_u13.nsg13_hv_pmos[ctype]
print @n.xbgr.xm54_u14.nsg13_hv_pmos[ide]
print @n.xbgr.xm54_u14.nsg13_hv_pmos[ige]
print @n.xbgr.xm54_u14.nsg13_hv_pmos[ise]
print @n.xbgr.xm54_u14.nsg13_hv_pmos[ibe]
print @n.xbgr.xm54_u14.nsg13_hv_pmos[ctype]
print @n.xbgr.xm54_u15.nsg13_hv_pmos[ide]
print @n.xbgr.xm54_u15.nsg13_hv_pmos[ige]
print @n.xbgr.xm54_u15.nsg13_hv_pmos[ise]
print @n.xbgr.xm54_u15.nsg13_hv_pmos[ibe]
print @n.xbgr.xm54_u15.nsg13_hv_pmos[ctype]
print @n.xbgr.xm54_u16.nsg13_hv_pmos[ide]
print @n.xbgr.xm54_u16.nsg13_hv_pmos[ige]
print @n.xbgr.xm54_u16.nsg13_hv_pmos[ise]
print @n.xbgr.xm54_u16.nsg13_hv_pmos[ibe]
print @n.xbgr.xm54_u16.nsg13_hv_pmos[ctype]
print @n.xbgr.xm54_u17.nsg13_hv_pmos[ide]
print @n.xbgr.xm54_u17.nsg13_hv_pmos[ige]
print @n.xbgr.xm54_u17.nsg13_hv_pmos[ise]
print @n.xbgr.xm54_u17.nsg13_hv_pmos[ibe]
print @n.xbgr.xm54_u17.nsg13_hv_pmos[ctype]
print @n.xbgr.xm54_u18.nsg13_hv_pmos[ide]
print @n.xbgr.xm54_u18.nsg13_hv_pmos[ige]
print @n.xbgr.xm54_u18.nsg13_hv_pmos[ise]
print @n.xbgr.xm54_u18.nsg13_hv_pmos[ibe]
print @n.xbgr.xm54_u18.nsg13_hv_pmos[ctype]
print @n.xbgr.xm54_u19.nsg13_hv_pmos[ide]
print @n.xbgr.xm54_u19.nsg13_hv_pmos[ige]
print @n.xbgr.xm54_u19.nsg13_hv_pmos[ise]
print @n.xbgr.xm54_u19.nsg13_hv_pmos[ibe]
print @n.xbgr.xm54_u19.nsg13_hv_pmos[ctype]
print @n.xbgr.xm54_u20.nsg13_hv_pmos[ide]
print @n.xbgr.xm54_u20.nsg13_hv_pmos[ige]
print @n.xbgr.xm54_u20.nsg13_hv_pmos[ise]
print @n.xbgr.xm54_u20.nsg13_hv_pmos[ibe]
print @n.xbgr.xm54_u20.nsg13_hv_pmos[ctype]
print @n.xbgr.xm54_u21.nsg13_hv_pmos[ide]
print @n.xbgr.xm54_u21.nsg13_hv_pmos[ige]
print @n.xbgr.xm54_u21.nsg13_hv_pmos[ise]
print @n.xbgr.xm54_u21.nsg13_hv_pmos[ibe]
print @n.xbgr.xm54_u21.nsg13_hv_pmos[ctype]
print @n.xbgr.xm54_u22.nsg13_hv_pmos[ide]
print @n.xbgr.xm54_u22.nsg13_hv_pmos[ige]
print @n.xbgr.xm54_u22.nsg13_hv_pmos[ise]
print @n.xbgr.xm54_u22.nsg13_hv_pmos[ibe]
print @n.xbgr.xm54_u22.nsg13_hv_pmos[ctype]
print @n.xbgr.xm54_u23.nsg13_hv_pmos[ide]
print @n.xbgr.xm54_u23.nsg13_hv_pmos[ige]
print @n.xbgr.xm54_u23.nsg13_hv_pmos[ise]
print @n.xbgr.xm54_u23.nsg13_hv_pmos[ibe]
print @n.xbgr.xm54_u23.nsg13_hv_pmos[ctype]
print @n.xbgr.xm54_u24.nsg13_hv_pmos[ide]
print @n.xbgr.xm54_u24.nsg13_hv_pmos[ige]
print @n.xbgr.xm54_u24.nsg13_hv_pmos[ise]
print @n.xbgr.xm54_u24.nsg13_hv_pmos[ibe]
print @n.xbgr.xm54_u24.nsg13_hv_pmos[ctype]
print @q.xbgr.xq56_u2.qnpn13g2[ic]
print @q.xbgr.xq56_u2.qnpn13g2[ib]
print @q.xbgr.xq56_u2.qnpn13g2[ie]
print @q.xbgr.xq56_u2.qnpn13g2[is]
print @r.xbgr.xq56_u2.rsub[i]
print @c.xbgr.xq56_u2.csub[i]
print @q.xbgr.xq56_u3.qnpn13g2[ic]
print @q.xbgr.xq56_u3.qnpn13g2[ib]
print @q.xbgr.xq56_u3.qnpn13g2[ie]
print @q.xbgr.xq56_u3.qnpn13g2[is]
print @r.xbgr.xq56_u3.rsub[i]
print @c.xbgr.xq56_u3.csub[i]
print @q.xbgr.xq56_u4.qnpn13g2[ic]
print @q.xbgr.xq56_u4.qnpn13g2[ib]
print @q.xbgr.xq56_u4.qnpn13g2[ie]
print @q.xbgr.xq56_u4.qnpn13g2[is]
print @r.xbgr.xq56_u4.rsub[i]
print @c.xbgr.xq56_u4.csub[i]
print @q.xbgr.xq56_u5.qnpn13g2[ic]
print @q.xbgr.xq56_u5.qnpn13g2[ib]
print @q.xbgr.xq56_u5.qnpn13g2[ie]
print @q.xbgr.xq56_u5.qnpn13g2[is]
print @r.xbgr.xq56_u5.rsub[i]
print @c.xbgr.xq56_u5.csub[i]
print @q.xbgr.xq56_u6.qnpn13g2[ic]
print @q.xbgr.xq56_u6.qnpn13g2[ib]
print @q.xbgr.xq56_u6.qnpn13g2[ie]
print @q.xbgr.xq56_u6.qnpn13g2[is]
print @r.xbgr.xq56_u6.rsub[i]
print @c.xbgr.xq56_u6.csub[i]
print @q.xbgr.xq56_u7.qnpn13g2[ic]
print @q.xbgr.xq56_u7.qnpn13g2[ib]
print @q.xbgr.xq56_u7.qnpn13g2[ie]
print @q.xbgr.xq56_u7.qnpn13g2[is]
print @r.xbgr.xq56_u7.rsub[i]
print @c.xbgr.xq56_u7.csub[i]
print @q.xbgr.xq56_u8.qnpn13g2[ic]
print @q.xbgr.xq56_u8.qnpn13g2[ib]
print @q.xbgr.xq56_u8.qnpn13g2[ie]
print @q.xbgr.xq56_u8.qnpn13g2[is]
print @r.xbgr.xq56_u8.rsub[i]
print @c.xbgr.xq56_u8.csub[i]
print @q.xbgr.xq56_u9.qnpn13g2[ic]
print @q.xbgr.xq56_u9.qnpn13g2[ib]
print @q.xbgr.xq56_u9.qnpn13g2[ie]
print @q.xbgr.xq56_u9.qnpn13g2[is]
print @r.xbgr.xq56_u9.rsub[i]
print @c.xbgr.xq56_u9.csub[i]
print @q.xbgr.xq56_u10.qnpn13g2[ic]
print @q.xbgr.xq56_u10.qnpn13g2[ib]
print @q.xbgr.xq56_u10.qnpn13g2[ie]
print @q.xbgr.xq56_u10.qnpn13g2[is]
print @r.xbgr.xq56_u10.rsub[i]
print @c.xbgr.xq56_u10.csub[i]
print @q.xbgr.xq56_u11.qnpn13g2[ic]
print @q.xbgr.xq56_u11.qnpn13g2[ib]
print @q.xbgr.xq56_u11.qnpn13g2[ie]
print @q.xbgr.xq56_u11.qnpn13g2[is]
print @r.xbgr.xq56_u11.rsub[i]
print @c.xbgr.xq56_u11.csub[i]
print @q.xbgr.xq56_u12.qnpn13g2[ic]
print @q.xbgr.xq56_u12.qnpn13g2[ib]
print @q.xbgr.xq56_u12.qnpn13g2[ie]
print @q.xbgr.xq56_u12.qnpn13g2[is]
print @r.xbgr.xq56_u12.rsub[i]
print @c.xbgr.xq56_u12.csub[i]
print @q.xbgr.xq56_u13.qnpn13g2[ic]
print @q.xbgr.xq56_u13.qnpn13g2[ib]
print @q.xbgr.xq56_u13.qnpn13g2[ie]
print @q.xbgr.xq56_u13.qnpn13g2[is]
print @r.xbgr.xq56_u13.rsub[i]
print @c.xbgr.xq56_u13.csub[i]
print @q.xbgr.xq56_u14.qnpn13g2[ic]
print @q.xbgr.xq56_u14.qnpn13g2[ib]
print @q.xbgr.xq56_u14.qnpn13g2[ie]
print @q.xbgr.xq56_u14.qnpn13g2[is]
print @r.xbgr.xq56_u14.rsub[i]
print @c.xbgr.xq56_u14.csub[i]
print @q.xbgr.xq56_u15.qnpn13g2[ic]
print @q.xbgr.xq56_u15.qnpn13g2[ib]
print @q.xbgr.xq56_u15.qnpn13g2[ie]
print @q.xbgr.xq56_u15.qnpn13g2[is]
print @r.xbgr.xq56_u15.rsub[i]
print @c.xbgr.xq56_u15.csub[i]
print @q.xbgr.xq56_u16.qnpn13g2[ic]
print @q.xbgr.xq56_u16.qnpn13g2[ib]
print @q.xbgr.xq56_u16.qnpn13g2[ie]
print @q.xbgr.xq56_u16.qnpn13g2[is]
print @r.xbgr.xq56_u16.rsub[i]
print @c.xbgr.xq56_u16.csub[i]
print @q.xbgr.xq56_u17.qnpn13g2[ic]
print @q.xbgr.xq56_u17.qnpn13g2[ib]
print @q.xbgr.xq56_u17.qnpn13g2[ie]
print @q.xbgr.xq56_u17.qnpn13g2[is]
print @r.xbgr.xq56_u17.rsub[i]
print @c.xbgr.xq56_u17.csub[i]
print @q.xbgr.xq56_u18.qnpn13g2[ic]
print @q.xbgr.xq56_u18.qnpn13g2[ib]
print @q.xbgr.xq56_u18.qnpn13g2[ie]
print @q.xbgr.xq56_u18.qnpn13g2[is]
print @r.xbgr.xq56_u18.rsub[i]
print @c.xbgr.xq56_u18.csub[i]
print @q.xbgr.xq56_u19.qnpn13g2[ic]
print @q.xbgr.xq56_u19.qnpn13g2[ib]
print @q.xbgr.xq56_u19.qnpn13g2[ie]
print @q.xbgr.xq56_u19.qnpn13g2[is]
print @r.xbgr.xq56_u19.rsub[i]
print @c.xbgr.xq56_u19.csub[i]
print @q.xbgr.xq56_u20.qnpn13g2[ic]
print @q.xbgr.xq56_u20.qnpn13g2[ib]
print @q.xbgr.xq56_u20.qnpn13g2[ie]
print @q.xbgr.xq56_u20.qnpn13g2[is]
print @r.xbgr.xq56_u20.rsub[i]
print @c.xbgr.xq56_u20.csub[i]
print @q.xbgr.xq56_u21.qnpn13g2[ic]
print @q.xbgr.xq56_u21.qnpn13g2[ib]
print @q.xbgr.xq56_u21.qnpn13g2[ie]
print @q.xbgr.xq56_u21.qnpn13g2[is]
print @r.xbgr.xq56_u21.rsub[i]
print @c.xbgr.xq56_u21.csub[i]
print @q.xbgr.xq56_u22.qnpn13g2[ic]
print @q.xbgr.xq56_u22.qnpn13g2[ib]
print @q.xbgr.xq56_u22.qnpn13g2[ie]
print @q.xbgr.xq56_u22.qnpn13g2[is]
print @r.xbgr.xq56_u22.rsub[i]
print @c.xbgr.xq56_u22.csub[i]
print @q.xbgr.xq56_u23.qnpn13g2[ic]
print @q.xbgr.xq56_u23.qnpn13g2[ib]
print @q.xbgr.xq56_u23.qnpn13g2[ie]
print @q.xbgr.xq56_u23.qnpn13g2[is]
print @r.xbgr.xq56_u23.rsub[i]
print @c.xbgr.xq56_u23.csub[i]
print @q.xbgr.xq56_u24.qnpn13g2[ic]
print @q.xbgr.xq56_u24.qnpn13g2[ib]
print @q.xbgr.xq56_u24.qnpn13g2[ie]
print @q.xbgr.xq56_u24.qnpn13g2[is]
print @r.xbgr.xq56_u24.rsub[i]
print @c.xbgr.xq56_u24.csub[i]
print @q.xbgr.xq60_u2.qnpn13g2[ic]
print @q.xbgr.xq60_u2.qnpn13g2[ib]
print @q.xbgr.xq60_u2.qnpn13g2[ie]
print @q.xbgr.xq60_u2.qnpn13g2[is]
print @r.xbgr.xq60_u2.rsub[i]
print @c.xbgr.xq60_u2.csub[i]
print @q.xbgr.xq60_u3.qnpn13g2[ic]
print @q.xbgr.xq60_u3.qnpn13g2[ib]
print @q.xbgr.xq60_u3.qnpn13g2[ie]
print @q.xbgr.xq60_u3.qnpn13g2[is]
print @r.xbgr.xq60_u3.rsub[i]
print @c.xbgr.xq60_u3.csub[i]
print @q.xbgr.xq60_u4.qnpn13g2[ic]
print @q.xbgr.xq60_u4.qnpn13g2[ib]
print @q.xbgr.xq60_u4.qnpn13g2[ie]
print @q.xbgr.xq60_u4.qnpn13g2[is]
print @r.xbgr.xq60_u4.rsub[i]
print @c.xbgr.xq60_u4.csub[i]
print @q.xbgr.xq62_u2.qnpn13g2[ic]
print @q.xbgr.xq62_u2.qnpn13g2[ib]
print @q.xbgr.xq62_u2.qnpn13g2[ie]
print @q.xbgr.xq62_u2.qnpn13g2[is]
print @r.xbgr.xq62_u2.rsub[i]
print @c.xbgr.xq62_u2.csub[i]
print @q.xbgr.xq62_u3.qnpn13g2[ic]
print @q.xbgr.xq62_u3.qnpn13g2[ib]
print @q.xbgr.xq62_u3.qnpn13g2[ie]
print @q.xbgr.xq62_u3.qnpn13g2[is]
print @r.xbgr.xq62_u3.rsub[i]
print @c.xbgr.xq62_u3.csub[i]
print @q.xbgr.xq62_u4.qnpn13g2[ic]
print @q.xbgr.xq62_u4.qnpn13g2[ib]
print @q.xbgr.xq62_u4.qnpn13g2[ie]
print @q.xbgr.xq62_u4.qnpn13g2[is]
print @r.xbgr.xq62_u4.rsub[i]
print @c.xbgr.xq62_u4.csub[i]
print @q.xbgr.xq62_u5.qnpn13g2[ic]
print @q.xbgr.xq62_u5.qnpn13g2[ib]
print @q.xbgr.xq62_u5.qnpn13g2[ie]
print @q.xbgr.xq62_u5.qnpn13g2[is]
print @r.xbgr.xq62_u5.rsub[i]
print @c.xbgr.xq62_u5.csub[i]
print @q.xbgr.xq62_u6.qnpn13g2[ic]
print @q.xbgr.xq62_u6.qnpn13g2[ib]
print @q.xbgr.xq62_u6.qnpn13g2[ie]
print @q.xbgr.xq62_u6.qnpn13g2[is]
print @r.xbgr.xq62_u6.rsub[i]
print @c.xbgr.xq62_u6.csub[i]
print @q.xbgr.xq62_u7.qnpn13g2[ic]
print @q.xbgr.xq62_u7.qnpn13g2[ib]
print @q.xbgr.xq62_u7.qnpn13g2[ie]
print @q.xbgr.xq62_u7.qnpn13g2[is]
print @r.xbgr.xq62_u7.rsub[i]
print @c.xbgr.xq62_u7.csub[i]
print @q.xbgr.xq62_u8.qnpn13g2[ic]
print @q.xbgr.xq62_u8.qnpn13g2[ib]
print @q.xbgr.xq62_u8.qnpn13g2[ie]
print @q.xbgr.xq62_u8.qnpn13g2[is]
print @r.xbgr.xq62_u8.rsub[i]
print @c.xbgr.xq62_u8.csub[i]
print @q.xbgr.xq62_u9.qnpn13g2[ic]
print @q.xbgr.xq62_u9.qnpn13g2[ib]
print @q.xbgr.xq62_u9.qnpn13g2[ie]
print @q.xbgr.xq62_u9.qnpn13g2[is]
print @r.xbgr.xq62_u9.rsub[i]
print @c.xbgr.xq62_u9.csub[i]
print @q.xbgr.xq62_u10.qnpn13g2[ic]
print @q.xbgr.xq62_u10.qnpn13g2[ib]
print @q.xbgr.xq62_u10.qnpn13g2[ie]
print @q.xbgr.xq62_u10.qnpn13g2[is]
print @r.xbgr.xq62_u10.rsub[i]
print @c.xbgr.xq62_u10.csub[i]
print @q.xbgr.xq62_u11.qnpn13g2[ic]
print @q.xbgr.xq62_u11.qnpn13g2[ib]
print @q.xbgr.xq62_u11.qnpn13g2[ie]
print @q.xbgr.xq62_u11.qnpn13g2[is]
print @r.xbgr.xq62_u11.rsub[i]
print @c.xbgr.xq62_u11.csub[i]
print @q.xbgr.xq62_u12.qnpn13g2[ic]
print @q.xbgr.xq62_u12.qnpn13g2[ib]
print @q.xbgr.xq62_u12.qnpn13g2[ie]
print @q.xbgr.xq62_u12.qnpn13g2[is]
print @r.xbgr.xq62_u12.rsub[i]
print @c.xbgr.xq62_u12.csub[i]
print @q.xbgr.xq62_u13.qnpn13g2[ic]
print @q.xbgr.xq62_u13.qnpn13g2[ib]
print @q.xbgr.xq62_u13.qnpn13g2[ie]
print @q.xbgr.xq62_u13.qnpn13g2[is]
print @r.xbgr.xq62_u13.rsub[i]
print @c.xbgr.xq62_u13.csub[i]
print @q.xbgr.xq62_u14.qnpn13g2[ic]
print @q.xbgr.xq62_u14.qnpn13g2[ib]
print @q.xbgr.xq62_u14.qnpn13g2[ie]
print @q.xbgr.xq62_u14.qnpn13g2[is]
print @r.xbgr.xq62_u14.rsub[i]
print @c.xbgr.xq62_u14.csub[i]
print @q.xbgr.xq62_u15.qnpn13g2[ic]
print @q.xbgr.xq62_u15.qnpn13g2[ib]
print @q.xbgr.xq62_u15.qnpn13g2[ie]
print @q.xbgr.xq62_u15.qnpn13g2[is]
print @r.xbgr.xq62_u15.rsub[i]
print @c.xbgr.xq62_u15.csub[i]
print @q.xbgr.xq62_u16.qnpn13g2[ic]
print @q.xbgr.xq62_u16.qnpn13g2[ib]
print @q.xbgr.xq62_u16.qnpn13g2[ie]
print @q.xbgr.xq62_u16.qnpn13g2[is]
print @r.xbgr.xq62_u16.rsub[i]
print @c.xbgr.xq62_u16.csub[i]
print @q.xbgr.xq62_u17.qnpn13g2[ic]
print @q.xbgr.xq62_u17.qnpn13g2[ib]
print @q.xbgr.xq62_u17.qnpn13g2[ie]
print @q.xbgr.xq62_u17.qnpn13g2[is]
print @r.xbgr.xq62_u17.rsub[i]
print @c.xbgr.xq62_u17.csub[i]
print @q.xbgr.xq62_u18.qnpn13g2[ic]
print @q.xbgr.xq62_u18.qnpn13g2[ib]
print @q.xbgr.xq62_u18.qnpn13g2[ie]
print @q.xbgr.xq62_u18.qnpn13g2[is]
print @r.xbgr.xq62_u18.rsub[i]
print @c.xbgr.xq62_u18.csub[i]
print @q.xbgr.xq62_u19.qnpn13g2[ic]
print @q.xbgr.xq62_u19.qnpn13g2[ib]
print @q.xbgr.xq62_u19.qnpn13g2[ie]
print @q.xbgr.xq62_u19.qnpn13g2[is]
print @r.xbgr.xq62_u19.rsub[i]
print @c.xbgr.xq62_u19.csub[i]
print @q.xbgr.xq62_u20.qnpn13g2[ic]
print @q.xbgr.xq62_u20.qnpn13g2[ib]
print @q.xbgr.xq62_u20.qnpn13g2[ie]
print @q.xbgr.xq62_u20.qnpn13g2[is]
print @r.xbgr.xq62_u20.rsub[i]
print @c.xbgr.xq62_u20.csub[i]
print @q.xbgr.xq62_u21.qnpn13g2[ic]
print @q.xbgr.xq62_u21.qnpn13g2[ib]
print @q.xbgr.xq62_u21.qnpn13g2[ie]
print @q.xbgr.xq62_u21.qnpn13g2[is]
print @r.xbgr.xq62_u21.rsub[i]
print @c.xbgr.xq62_u21.csub[i]
print @q.xbgr.xq62_u22.qnpn13g2[ic]
print @q.xbgr.xq62_u22.qnpn13g2[ib]
print @q.xbgr.xq62_u22.qnpn13g2[ie]
print @q.xbgr.xq62_u22.qnpn13g2[is]
print @r.xbgr.xq62_u22.rsub[i]
print @c.xbgr.xq62_u22.csub[i]
print @q.xbgr.xq62_u23.qnpn13g2[ic]
print @q.xbgr.xq62_u23.qnpn13g2[ib]
print @q.xbgr.xq62_u23.qnpn13g2[ie]
print @q.xbgr.xq62_u23.qnpn13g2[is]
print @r.xbgr.xq62_u23.rsub[i]
print @c.xbgr.xq62_u23.csub[i]
print @q.xbgr.xq62_u24.qnpn13g2[ic]
print @q.xbgr.xq62_u24.qnpn13g2[ib]
print @q.xbgr.xq62_u24.qnpn13g2[ie]
print @q.xbgr.xq62_u24.qnpn13g2[is]
print @r.xbgr.xq62_u24.rsub[i]
print @c.xbgr.xq62_u24.csub[i]
print @q.xbgr.xq67_u2.qnpn13g2[ic]
print @q.xbgr.xq67_u2.qnpn13g2[ib]
print @q.xbgr.xq67_u2.qnpn13g2[ie]
print @q.xbgr.xq67_u2.qnpn13g2[is]
print @r.xbgr.xq67_u2.rsub[i]
print @c.xbgr.xq67_u2.csub[i]
print @q.xbgr.xq67_u3.qnpn13g2[ic]
print @q.xbgr.xq67_u3.qnpn13g2[ib]
print @q.xbgr.xq67_u3.qnpn13g2[ie]
print @q.xbgr.xq67_u3.qnpn13g2[is]
print @r.xbgr.xq67_u3.rsub[i]
print @c.xbgr.xq67_u3.csub[i]
print @q.xbgr.xq67_u4.qnpn13g2[ic]
print @q.xbgr.xq67_u4.qnpn13g2[ib]
print @q.xbgr.xq67_u4.qnpn13g2[ie]
print @q.xbgr.xq67_u4.qnpn13g2[is]
print @r.xbgr.xq67_u4.rsub[i]
print @c.xbgr.xq67_u4.csub[i]
print @q.xbgr.xq67_u5.qnpn13g2[ic]
print @q.xbgr.xq67_u5.qnpn13g2[ib]
print @q.xbgr.xq67_u5.qnpn13g2[ie]
print @q.xbgr.xq67_u5.qnpn13g2[is]
print @r.xbgr.xq67_u5.rsub[i]
print @c.xbgr.xq67_u5.csub[i]
print @q.xbgr.xq67_u6.qnpn13g2[ic]
print @q.xbgr.xq67_u6.qnpn13g2[ib]
print @q.xbgr.xq67_u6.qnpn13g2[ie]
print @q.xbgr.xq67_u6.qnpn13g2[is]
print @r.xbgr.xq67_u6.rsub[i]
print @c.xbgr.xq67_u6.csub[i]
print @q.xbgr.xq67_u7.qnpn13g2[ic]
print @q.xbgr.xq67_u7.qnpn13g2[ib]
print @q.xbgr.xq67_u7.qnpn13g2[ie]
print @q.xbgr.xq67_u7.qnpn13g2[is]
print @r.xbgr.xq67_u7.rsub[i]
print @c.xbgr.xq67_u7.csub[i]
print @q.xbgr.xq67_u8.qnpn13g2[ic]
print @q.xbgr.xq67_u8.qnpn13g2[ib]
print @q.xbgr.xq67_u8.qnpn13g2[ie]
print @q.xbgr.xq67_u8.qnpn13g2[is]
print @r.xbgr.xq67_u8.rsub[i]
print @c.xbgr.xq67_u8.csub[i]
print @q.xbgr.xq67_u9.qnpn13g2[ic]
print @q.xbgr.xq67_u9.qnpn13g2[ib]
print @q.xbgr.xq67_u9.qnpn13g2[ie]
print @q.xbgr.xq67_u9.qnpn13g2[is]
print @r.xbgr.xq67_u9.rsub[i]
print @c.xbgr.xq67_u9.csub[i]
print @q.xbgr.xq67_u10.qnpn13g2[ic]
print @q.xbgr.xq67_u10.qnpn13g2[ib]
print @q.xbgr.xq67_u10.qnpn13g2[ie]
print @q.xbgr.xq67_u10.qnpn13g2[is]
print @r.xbgr.xq67_u10.rsub[i]
print @c.xbgr.xq67_u10.csub[i]
print @q.xbgr.xq67_u11.qnpn13g2[ic]
print @q.xbgr.xq67_u11.qnpn13g2[ib]
print @q.xbgr.xq67_u11.qnpn13g2[ie]
print @q.xbgr.xq67_u11.qnpn13g2[is]
print @r.xbgr.xq67_u11.rsub[i]
print @c.xbgr.xq67_u11.csub[i]
print @q.xbgr.xq67_u12.qnpn13g2[ic]
print @q.xbgr.xq67_u12.qnpn13g2[ib]
print @q.xbgr.xq67_u12.qnpn13g2[ie]
print @q.xbgr.xq67_u12.qnpn13g2[is]
print @r.xbgr.xq67_u12.rsub[i]
print @c.xbgr.xq67_u12.csub[i]
print @q.xbgr.xq67_u13.qnpn13g2[ic]
print @q.xbgr.xq67_u13.qnpn13g2[ib]
print @q.xbgr.xq67_u13.qnpn13g2[ie]
print @q.xbgr.xq67_u13.qnpn13g2[is]
print @r.xbgr.xq67_u13.rsub[i]
print @c.xbgr.xq67_u13.csub[i]
print @q.xbgr.xq67_u14.qnpn13g2[ic]
print @q.xbgr.xq67_u14.qnpn13g2[ib]
print @q.xbgr.xq67_u14.qnpn13g2[ie]
print @q.xbgr.xq67_u14.qnpn13g2[is]
print @r.xbgr.xq67_u14.rsub[i]
print @c.xbgr.xq67_u14.csub[i]
print @q.xbgr.xq67_u15.qnpn13g2[ic]
print @q.xbgr.xq67_u15.qnpn13g2[ib]
print @q.xbgr.xq67_u15.qnpn13g2[ie]
print @q.xbgr.xq67_u15.qnpn13g2[is]
print @r.xbgr.xq67_u15.rsub[i]
print @c.xbgr.xq67_u15.csub[i]
print @q.xbgr.xq67_u16.qnpn13g2[ic]
print @q.xbgr.xq67_u16.qnpn13g2[ib]
print @q.xbgr.xq67_u16.qnpn13g2[ie]
print @q.xbgr.xq67_u16.qnpn13g2[is]
print @r.xbgr.xq67_u16.rsub[i]
print @c.xbgr.xq67_u16.csub[i]
print @q.xbgr.xq67_u17.qnpn13g2[ic]
print @q.xbgr.xq67_u17.qnpn13g2[ib]
print @q.xbgr.xq67_u17.qnpn13g2[ie]
print @q.xbgr.xq67_u17.qnpn13g2[is]
print @r.xbgr.xq67_u17.rsub[i]
print @c.xbgr.xq67_u17.csub[i]
print @q.xbgr.xq67_u18.qnpn13g2[ic]
print @q.xbgr.xq67_u18.qnpn13g2[ib]
print @q.xbgr.xq67_u18.qnpn13g2[ie]
print @q.xbgr.xq67_u18.qnpn13g2[is]
print @r.xbgr.xq67_u18.rsub[i]
print @c.xbgr.xq67_u18.csub[i]
print @q.xbgr.xq67_u19.qnpn13g2[ic]
print @q.xbgr.xq67_u19.qnpn13g2[ib]
print @q.xbgr.xq67_u19.qnpn13g2[ie]
print @q.xbgr.xq67_u19.qnpn13g2[is]
print @r.xbgr.xq67_u19.rsub[i]
print @c.xbgr.xq67_u19.csub[i]
print @q.xbgr.xq67_u20.qnpn13g2[ic]
print @q.xbgr.xq67_u20.qnpn13g2[ib]
print @q.xbgr.xq67_u20.qnpn13g2[ie]
print @q.xbgr.xq67_u20.qnpn13g2[is]
print @r.xbgr.xq67_u20.rsub[i]
print @c.xbgr.xq67_u20.csub[i]
print @q.xbgr.xq67_u21.qnpn13g2[ic]
print @q.xbgr.xq67_u21.qnpn13g2[ib]
print @q.xbgr.xq67_u21.qnpn13g2[ie]
print @q.xbgr.xq67_u21.qnpn13g2[is]
print @r.xbgr.xq67_u21.rsub[i]
print @c.xbgr.xq67_u21.csub[i]
print @q.xbgr.xq67_u22.qnpn13g2[ic]
print @q.xbgr.xq67_u22.qnpn13g2[ib]
print @q.xbgr.xq67_u22.qnpn13g2[ie]
print @q.xbgr.xq67_u22.qnpn13g2[is]
print @r.xbgr.xq67_u22.rsub[i]
print @c.xbgr.xq67_u22.csub[i]
print @q.xbgr.xq67_u23.qnpn13g2[ic]
print @q.xbgr.xq67_u23.qnpn13g2[ib]
print @q.xbgr.xq67_u23.qnpn13g2[ie]
print @q.xbgr.xq67_u23.qnpn13g2[is]
print @r.xbgr.xq67_u23.rsub[i]
print @c.xbgr.xq67_u23.csub[i]
print @q.xbgr.xq67_u24.qnpn13g2[ic]
print @q.xbgr.xq67_u24.qnpn13g2[ib]
print @q.xbgr.xq67_u24.qnpn13g2[ie]
print @q.xbgr.xq67_u24.qnpn13g2[is]
print @r.xbgr.xq67_u24.rsub[i]
print @c.xbgr.xq67_u24.csub[i]
print @q.xbgr.xq68_u2.qnpn13g2[ic]
print @q.xbgr.xq68_u2.qnpn13g2[ib]
print @q.xbgr.xq68_u2.qnpn13g2[ie]
print @q.xbgr.xq68_u2.qnpn13g2[is]
print @r.xbgr.xq68_u2.rsub[i]
print @c.xbgr.xq68_u2.csub[i]
print @q.xbgr.xq68_u3.qnpn13g2[ic]
print @q.xbgr.xq68_u3.qnpn13g2[ib]
print @q.xbgr.xq68_u3.qnpn13g2[ie]
print @q.xbgr.xq68_u3.qnpn13g2[is]
print @r.xbgr.xq68_u3.rsub[i]
print @c.xbgr.xq68_u3.csub[i]
print @q.xbgr.xq68_u4.qnpn13g2[ic]
print @q.xbgr.xq68_u4.qnpn13g2[ib]
print @q.xbgr.xq68_u4.qnpn13g2[ie]
print @q.xbgr.xq68_u4.qnpn13g2[is]
print @r.xbgr.xq68_u4.rsub[i]
print @c.xbgr.xq68_u4.csub[i]
print @q.xbgr.xq68_u5.qnpn13g2[ic]
print @q.xbgr.xq68_u5.qnpn13g2[ib]
print @q.xbgr.xq68_u5.qnpn13g2[ie]
print @q.xbgr.xq68_u5.qnpn13g2[is]
print @r.xbgr.xq68_u5.rsub[i]
print @c.xbgr.xq68_u5.csub[i]
print @q.xbgr.xq68_u6.qnpn13g2[ic]
print @q.xbgr.xq68_u6.qnpn13g2[ib]
print @q.xbgr.xq68_u6.qnpn13g2[ie]
print @q.xbgr.xq68_u6.qnpn13g2[is]
print @r.xbgr.xq68_u6.rsub[i]
print @c.xbgr.xq68_u6.csub[i]
print @q.xbgr.xq68_u7.qnpn13g2[ic]
print @q.xbgr.xq68_u7.qnpn13g2[ib]
print @q.xbgr.xq68_u7.qnpn13g2[ie]
print @q.xbgr.xq68_u7.qnpn13g2[is]
print @r.xbgr.xq68_u7.rsub[i]
print @c.xbgr.xq68_u7.csub[i]
print @q.xbgr.xq68_u8.qnpn13g2[ic]
print @q.xbgr.xq68_u8.qnpn13g2[ib]
print @q.xbgr.xq68_u8.qnpn13g2[ie]
print @q.xbgr.xq68_u8.qnpn13g2[is]
print @r.xbgr.xq68_u8.rsub[i]
print @c.xbgr.xq68_u8.csub[i]
print @q.xbgr.xq68_u9.qnpn13g2[ic]
print @q.xbgr.xq68_u9.qnpn13g2[ib]
print @q.xbgr.xq68_u9.qnpn13g2[ie]
print @q.xbgr.xq68_u9.qnpn13g2[is]
print @r.xbgr.xq68_u9.rsub[i]
print @c.xbgr.xq68_u9.csub[i]
print @q.xbgr.xq68_u10.qnpn13g2[ic]
print @q.xbgr.xq68_u10.qnpn13g2[ib]
print @q.xbgr.xq68_u10.qnpn13g2[ie]
print @q.xbgr.xq68_u10.qnpn13g2[is]
print @r.xbgr.xq68_u10.rsub[i]
print @c.xbgr.xq68_u10.csub[i]
print @q.xbgr.xq68_u11.qnpn13g2[ic]
print @q.xbgr.xq68_u11.qnpn13g2[ib]
print @q.xbgr.xq68_u11.qnpn13g2[ie]
print @q.xbgr.xq68_u11.qnpn13g2[is]
print @r.xbgr.xq68_u11.rsub[i]
print @c.xbgr.xq68_u11.csub[i]
print @q.xbgr.xq68_u12.qnpn13g2[ic]
print @q.xbgr.xq68_u12.qnpn13g2[ib]
print @q.xbgr.xq68_u12.qnpn13g2[ie]
print @q.xbgr.xq68_u12.qnpn13g2[is]
print @r.xbgr.xq68_u12.rsub[i]
print @c.xbgr.xq68_u12.csub[i]
print @q.xbgr.xq68_u13.qnpn13g2[ic]
print @q.xbgr.xq68_u13.qnpn13g2[ib]
print @q.xbgr.xq68_u13.qnpn13g2[ie]
print @q.xbgr.xq68_u13.qnpn13g2[is]
print @r.xbgr.xq68_u13.rsub[i]
print @c.xbgr.xq68_u13.csub[i]
print @q.xbgr.xq68_u14.qnpn13g2[ic]
print @q.xbgr.xq68_u14.qnpn13g2[ib]
print @q.xbgr.xq68_u14.qnpn13g2[ie]
print @q.xbgr.xq68_u14.qnpn13g2[is]
print @r.xbgr.xq68_u14.rsub[i]
print @c.xbgr.xq68_u14.csub[i]
print @q.xbgr.xq68_u15.qnpn13g2[ic]
print @q.xbgr.xq68_u15.qnpn13g2[ib]
print @q.xbgr.xq68_u15.qnpn13g2[ie]
print @q.xbgr.xq68_u15.qnpn13g2[is]
print @r.xbgr.xq68_u15.rsub[i]
print @c.xbgr.xq68_u15.csub[i]
print @q.xbgr.xq68_u16.qnpn13g2[ic]
print @q.xbgr.xq68_u16.qnpn13g2[ib]
print @q.xbgr.xq68_u16.qnpn13g2[ie]
print @q.xbgr.xq68_u16.qnpn13g2[is]
print @r.xbgr.xq68_u16.rsub[i]
print @c.xbgr.xq68_u16.csub[i]
print @q.xbgr.xq68_u17.qnpn13g2[ic]
print @q.xbgr.xq68_u17.qnpn13g2[ib]
print @q.xbgr.xq68_u17.qnpn13g2[ie]
print @q.xbgr.xq68_u17.qnpn13g2[is]
print @r.xbgr.xq68_u17.rsub[i]
print @c.xbgr.xq68_u17.csub[i]
print @q.xbgr.xq68_u18.qnpn13g2[ic]
print @q.xbgr.xq68_u18.qnpn13g2[ib]
print @q.xbgr.xq68_u18.qnpn13g2[ie]
print @q.xbgr.xq68_u18.qnpn13g2[is]
print @r.xbgr.xq68_u18.rsub[i]
print @c.xbgr.xq68_u18.csub[i]
print @q.xbgr.xq68_u19.qnpn13g2[ic]
print @q.xbgr.xq68_u19.qnpn13g2[ib]
print @q.xbgr.xq68_u19.qnpn13g2[ie]
print @q.xbgr.xq68_u19.qnpn13g2[is]
print @r.xbgr.xq68_u19.rsub[i]
print @c.xbgr.xq68_u19.csub[i]
print @q.xbgr.xq68_u20.qnpn13g2[ic]
print @q.xbgr.xq68_u20.qnpn13g2[ib]
print @q.xbgr.xq68_u20.qnpn13g2[ie]
print @q.xbgr.xq68_u20.qnpn13g2[is]
print @r.xbgr.xq68_u20.rsub[i]
print @c.xbgr.xq68_u20.csub[i]
print @q.xbgr.xq68_u21.qnpn13g2[ic]
print @q.xbgr.xq68_u21.qnpn13g2[ib]
print @q.xbgr.xq68_u21.qnpn13g2[ie]
print @q.xbgr.xq68_u21.qnpn13g2[is]
print @r.xbgr.xq68_u21.rsub[i]
print @c.xbgr.xq68_u21.csub[i]
print @q.xbgr.xq68_u22.qnpn13g2[ic]
print @q.xbgr.xq68_u22.qnpn13g2[ib]
print @q.xbgr.xq68_u22.qnpn13g2[ie]
print @q.xbgr.xq68_u22.qnpn13g2[is]
print @r.xbgr.xq68_u22.rsub[i]
print @c.xbgr.xq68_u22.csub[i]
print @q.xbgr.xq68_u23.qnpn13g2[ic]
print @q.xbgr.xq68_u23.qnpn13g2[ib]
print @q.xbgr.xq68_u23.qnpn13g2[ie]
print @q.xbgr.xq68_u23.qnpn13g2[is]
print @r.xbgr.xq68_u23.rsub[i]
print @c.xbgr.xq68_u23.csub[i]
print @q.xbgr.xq68_u24.qnpn13g2[ic]
print @q.xbgr.xq68_u24.qnpn13g2[ib]
print @q.xbgr.xq68_u24.qnpn13g2[ie]
print @q.xbgr.xq68_u24.qnpn13g2[is]
print @r.xbgr.xq68_u24.rsub[i]
print @c.xbgr.xq68_u24.csub[i]
print @q.xbgr.xq69_u2.qnpn13g2[ic]
print @q.xbgr.xq69_u2.qnpn13g2[ib]
print @q.xbgr.xq69_u2.qnpn13g2[ie]
print @q.xbgr.xq69_u2.qnpn13g2[is]
print @r.xbgr.xq69_u2.rsub[i]
print @c.xbgr.xq69_u2.csub[i]
print @q.xbgr.xq69_u3.qnpn13g2[ic]
print @q.xbgr.xq69_u3.qnpn13g2[ib]
print @q.xbgr.xq69_u3.qnpn13g2[ie]
print @q.xbgr.xq69_u3.qnpn13g2[is]
print @r.xbgr.xq69_u3.rsub[i]
print @c.xbgr.xq69_u3.csub[i]
print @q.xbgr.xq69_u4.qnpn13g2[ic]
print @q.xbgr.xq69_u4.qnpn13g2[ib]
print @q.xbgr.xq69_u4.qnpn13g2[ie]
print @q.xbgr.xq69_u4.qnpn13g2[is]
print @r.xbgr.xq69_u4.rsub[i]
print @c.xbgr.xq69_u4.csub[i]
print @q.xbgr.xq69_u5.qnpn13g2[ic]
print @q.xbgr.xq69_u5.qnpn13g2[ib]
print @q.xbgr.xq69_u5.qnpn13g2[ie]
print @q.xbgr.xq69_u5.qnpn13g2[is]
print @r.xbgr.xq69_u5.rsub[i]
print @c.xbgr.xq69_u5.csub[i]
print @q.xbgr.xq69_u6.qnpn13g2[ic]
print @q.xbgr.xq69_u6.qnpn13g2[ib]
print @q.xbgr.xq69_u6.qnpn13g2[ie]
print @q.xbgr.xq69_u6.qnpn13g2[is]
print @r.xbgr.xq69_u6.rsub[i]
print @c.xbgr.xq69_u6.csub[i]
print @q.xbgr.xq69_u7.qnpn13g2[ic]
print @q.xbgr.xq69_u7.qnpn13g2[ib]
print @q.xbgr.xq69_u7.qnpn13g2[ie]
print @q.xbgr.xq69_u7.qnpn13g2[is]
print @r.xbgr.xq69_u7.rsub[i]
print @c.xbgr.xq69_u7.csub[i]
print @q.xbgr.xq69_u8.qnpn13g2[ic]
print @q.xbgr.xq69_u8.qnpn13g2[ib]
print @q.xbgr.xq69_u8.qnpn13g2[ie]
print @q.xbgr.xq69_u8.qnpn13g2[is]
print @r.xbgr.xq69_u8.rsub[i]
print @c.xbgr.xq69_u8.csub[i]
print @q.xbgr.xq69_u9.qnpn13g2[ic]
print @q.xbgr.xq69_u9.qnpn13g2[ib]
print @q.xbgr.xq69_u9.qnpn13g2[ie]
print @q.xbgr.xq69_u9.qnpn13g2[is]
print @r.xbgr.xq69_u9.rsub[i]
print @c.xbgr.xq69_u9.csub[i]
print @q.xbgr.xq69_u10.qnpn13g2[ic]
print @q.xbgr.xq69_u10.qnpn13g2[ib]
print @q.xbgr.xq69_u10.qnpn13g2[ie]
print @q.xbgr.xq69_u10.qnpn13g2[is]
print @r.xbgr.xq69_u10.rsub[i]
print @c.xbgr.xq69_u10.csub[i]
print @q.xbgr.xq69_u11.qnpn13g2[ic]
print @q.xbgr.xq69_u11.qnpn13g2[ib]
print @q.xbgr.xq69_u11.qnpn13g2[ie]
print @q.xbgr.xq69_u11.qnpn13g2[is]
print @r.xbgr.xq69_u11.rsub[i]
print @c.xbgr.xq69_u11.csub[i]
print @q.xbgr.xq69_u12.qnpn13g2[ic]
print @q.xbgr.xq69_u12.qnpn13g2[ib]
print @q.xbgr.xq69_u12.qnpn13g2[ie]
print @q.xbgr.xq69_u12.qnpn13g2[is]
print @r.xbgr.xq69_u12.rsub[i]
print @c.xbgr.xq69_u12.csub[i]
print @q.xbgr.xq69_u13.qnpn13g2[ic]
print @q.xbgr.xq69_u13.qnpn13g2[ib]
print @q.xbgr.xq69_u13.qnpn13g2[ie]
print @q.xbgr.xq69_u13.qnpn13g2[is]
print @r.xbgr.xq69_u13.rsub[i]
print @c.xbgr.xq69_u13.csub[i]
print @q.xbgr.xq69_u14.qnpn13g2[ic]
print @q.xbgr.xq69_u14.qnpn13g2[ib]
print @q.xbgr.xq69_u14.qnpn13g2[ie]
print @q.xbgr.xq69_u14.qnpn13g2[is]
print @r.xbgr.xq69_u14.rsub[i]
print @c.xbgr.xq69_u14.csub[i]
print @q.xbgr.xq69_u15.qnpn13g2[ic]
print @q.xbgr.xq69_u15.qnpn13g2[ib]
print @q.xbgr.xq69_u15.qnpn13g2[ie]
print @q.xbgr.xq69_u15.qnpn13g2[is]
print @r.xbgr.xq69_u15.rsub[i]
print @c.xbgr.xq69_u15.csub[i]
print @q.xbgr.xq69_u16.qnpn13g2[ic]
print @q.xbgr.xq69_u16.qnpn13g2[ib]
print @q.xbgr.xq69_u16.qnpn13g2[ie]
print @q.xbgr.xq69_u16.qnpn13g2[is]
print @r.xbgr.xq69_u16.rsub[i]
print @c.xbgr.xq69_u16.csub[i]
print @q.xbgr.xq69_u17.qnpn13g2[ic]
print @q.xbgr.xq69_u17.qnpn13g2[ib]
print @q.xbgr.xq69_u17.qnpn13g2[ie]
print @q.xbgr.xq69_u17.qnpn13g2[is]
print @r.xbgr.xq69_u17.rsub[i]
print @c.xbgr.xq69_u17.csub[i]
print @q.xbgr.xq69_u18.qnpn13g2[ic]
print @q.xbgr.xq69_u18.qnpn13g2[ib]
print @q.xbgr.xq69_u18.qnpn13g2[ie]
print @q.xbgr.xq69_u18.qnpn13g2[is]
print @r.xbgr.xq69_u18.rsub[i]
print @c.xbgr.xq69_u18.csub[i]
print @q.xbgr.xq69_u19.qnpn13g2[ic]
print @q.xbgr.xq69_u19.qnpn13g2[ib]
print @q.xbgr.xq69_u19.qnpn13g2[ie]
print @q.xbgr.xq69_u19.qnpn13g2[is]
print @r.xbgr.xq69_u19.rsub[i]
print @c.xbgr.xq69_u19.csub[i]
print @q.xbgr.xq69_u20.qnpn13g2[ic]
print @q.xbgr.xq69_u20.qnpn13g2[ib]
print @q.xbgr.xq69_u20.qnpn13g2[ie]
print @q.xbgr.xq69_u20.qnpn13g2[is]
print @r.xbgr.xq69_u20.rsub[i]
print @c.xbgr.xq69_u20.csub[i]
print @q.xbgr.xq69_u21.qnpn13g2[ic]
print @q.xbgr.xq69_u21.qnpn13g2[ib]
print @q.xbgr.xq69_u21.qnpn13g2[ie]
print @q.xbgr.xq69_u21.qnpn13g2[is]
print @r.xbgr.xq69_u21.rsub[i]
print @c.xbgr.xq69_u21.csub[i]
print @q.xbgr.xq69_u22.qnpn13g2[ic]
print @q.xbgr.xq69_u22.qnpn13g2[ib]
print @q.xbgr.xq69_u22.qnpn13g2[ie]
print @q.xbgr.xq69_u22.qnpn13g2[is]
print @r.xbgr.xq69_u22.rsub[i]
print @c.xbgr.xq69_u22.csub[i]
print @q.xbgr.xq69_u23.qnpn13g2[ic]
print @q.xbgr.xq69_u23.qnpn13g2[ib]
print @q.xbgr.xq69_u23.qnpn13g2[ie]
print @q.xbgr.xq69_u23.qnpn13g2[is]
print @r.xbgr.xq69_u23.rsub[i]
print @c.xbgr.xq69_u23.csub[i]
print @q.xbgr.xq69_u24.qnpn13g2[ic]
print @q.xbgr.xq69_u24.qnpn13g2[ib]
print @q.xbgr.xq69_u24.qnpn13g2[ie]
print @q.xbgr.xq69_u24.qnpn13g2[is]
print @r.xbgr.xq69_u24.rsub[i]
print @c.xbgr.xq69_u24.csub[i]
print @q.xbgr.xq70_u2.qnpn13g2[ic]
print @q.xbgr.xq70_u2.qnpn13g2[ib]
print @q.xbgr.xq70_u2.qnpn13g2[ie]
print @q.xbgr.xq70_u2.qnpn13g2[is]
print @r.xbgr.xq70_u2.rsub[i]
print @c.xbgr.xq70_u2.csub[i]
print @q.xbgr.xq70_u3.qnpn13g2[ic]
print @q.xbgr.xq70_u3.qnpn13g2[ib]
print @q.xbgr.xq70_u3.qnpn13g2[ie]
print @q.xbgr.xq70_u3.qnpn13g2[is]
print @r.xbgr.xq70_u3.rsub[i]
print @c.xbgr.xq70_u3.csub[i]
print @q.xbgr.xq70_u4.qnpn13g2[ic]
print @q.xbgr.xq70_u4.qnpn13g2[ib]
print @q.xbgr.xq70_u4.qnpn13g2[ie]
print @q.xbgr.xq70_u4.qnpn13g2[is]
print @r.xbgr.xq70_u4.rsub[i]
print @c.xbgr.xq70_u4.csub[i]
print @q.xbgr.xq70_u5.qnpn13g2[ic]
print @q.xbgr.xq70_u5.qnpn13g2[ib]
print @q.xbgr.xq70_u5.qnpn13g2[ie]
print @q.xbgr.xq70_u5.qnpn13g2[is]
print @r.xbgr.xq70_u5.rsub[i]
print @c.xbgr.xq70_u5.csub[i]
print @q.xbgr.xq70_u6.qnpn13g2[ic]
print @q.xbgr.xq70_u6.qnpn13g2[ib]
print @q.xbgr.xq70_u6.qnpn13g2[ie]
print @q.xbgr.xq70_u6.qnpn13g2[is]
print @r.xbgr.xq70_u6.rsub[i]
print @c.xbgr.xq70_u6.csub[i]
print @q.xbgr.xq70_u7.qnpn13g2[ic]
print @q.xbgr.xq70_u7.qnpn13g2[ib]
print @q.xbgr.xq70_u7.qnpn13g2[ie]
print @q.xbgr.xq70_u7.qnpn13g2[is]
print @r.xbgr.xq70_u7.rsub[i]
print @c.xbgr.xq70_u7.csub[i]
print @q.xbgr.xq70_u8.qnpn13g2[ic]
print @q.xbgr.xq70_u8.qnpn13g2[ib]
print @q.xbgr.xq70_u8.qnpn13g2[ie]
print @q.xbgr.xq70_u8.qnpn13g2[is]
print @r.xbgr.xq70_u8.rsub[i]
print @c.xbgr.xq70_u8.csub[i]
print @q.xbgr.xq70_u9.qnpn13g2[ic]
print @q.xbgr.xq70_u9.qnpn13g2[ib]
print @q.xbgr.xq70_u9.qnpn13g2[ie]
print @q.xbgr.xq70_u9.qnpn13g2[is]
print @r.xbgr.xq70_u9.rsub[i]
print @c.xbgr.xq70_u9.csub[i]
print @q.xbgr.xq70_u10.qnpn13g2[ic]
print @q.xbgr.xq70_u10.qnpn13g2[ib]
print @q.xbgr.xq70_u10.qnpn13g2[ie]
print @q.xbgr.xq70_u10.qnpn13g2[is]
print @r.xbgr.xq70_u10.rsub[i]
print @c.xbgr.xq70_u10.csub[i]
print @q.xbgr.xq70_u11.qnpn13g2[ic]
print @q.xbgr.xq70_u11.qnpn13g2[ib]
print @q.xbgr.xq70_u11.qnpn13g2[ie]
print @q.xbgr.xq70_u11.qnpn13g2[is]
print @r.xbgr.xq70_u11.rsub[i]
print @c.xbgr.xq70_u11.csub[i]
print @q.xbgr.xq70_u12.qnpn13g2[ic]
print @q.xbgr.xq70_u12.qnpn13g2[ib]
print @q.xbgr.xq70_u12.qnpn13g2[ie]
print @q.xbgr.xq70_u12.qnpn13g2[is]
print @r.xbgr.xq70_u12.rsub[i]
print @c.xbgr.xq70_u12.csub[i]
print @q.xbgr.xq70_u13.qnpn13g2[ic]
print @q.xbgr.xq70_u13.qnpn13g2[ib]
print @q.xbgr.xq70_u13.qnpn13g2[ie]
print @q.xbgr.xq70_u13.qnpn13g2[is]
print @r.xbgr.xq70_u13.rsub[i]
print @c.xbgr.xq70_u13.csub[i]
print @q.xbgr.xq70_u14.qnpn13g2[ic]
print @q.xbgr.xq70_u14.qnpn13g2[ib]
print @q.xbgr.xq70_u14.qnpn13g2[ie]
print @q.xbgr.xq70_u14.qnpn13g2[is]
print @r.xbgr.xq70_u14.rsub[i]
print @c.xbgr.xq70_u14.csub[i]
print @q.xbgr.xq70_u15.qnpn13g2[ic]
print @q.xbgr.xq70_u15.qnpn13g2[ib]
print @q.xbgr.xq70_u15.qnpn13g2[ie]
print @q.xbgr.xq70_u15.qnpn13g2[is]
print @r.xbgr.xq70_u15.rsub[i]
print @c.xbgr.xq70_u15.csub[i]
print @q.xbgr.xq70_u16.qnpn13g2[ic]
print @q.xbgr.xq70_u16.qnpn13g2[ib]
print @q.xbgr.xq70_u16.qnpn13g2[ie]
print @q.xbgr.xq70_u16.qnpn13g2[is]
print @r.xbgr.xq70_u16.rsub[i]
print @c.xbgr.xq70_u16.csub[i]
print @q.xbgr.xq70_u17.qnpn13g2[ic]
print @q.xbgr.xq70_u17.qnpn13g2[ib]
print @q.xbgr.xq70_u17.qnpn13g2[ie]
print @q.xbgr.xq70_u17.qnpn13g2[is]
print @r.xbgr.xq70_u17.rsub[i]
print @c.xbgr.xq70_u17.csub[i]
print @q.xbgr.xq70_u18.qnpn13g2[ic]
print @q.xbgr.xq70_u18.qnpn13g2[ib]
print @q.xbgr.xq70_u18.qnpn13g2[ie]
print @q.xbgr.xq70_u18.qnpn13g2[is]
print @r.xbgr.xq70_u18.rsub[i]
print @c.xbgr.xq70_u18.csub[i]
print @q.xbgr.xq70_u19.qnpn13g2[ic]
print @q.xbgr.xq70_u19.qnpn13g2[ib]
print @q.xbgr.xq70_u19.qnpn13g2[ie]
print @q.xbgr.xq70_u19.qnpn13g2[is]
print @r.xbgr.xq70_u19.rsub[i]
print @c.xbgr.xq70_u19.csub[i]
print @q.xbgr.xq70_u20.qnpn13g2[ic]
print @q.xbgr.xq70_u20.qnpn13g2[ib]
print @q.xbgr.xq70_u20.qnpn13g2[ie]
print @q.xbgr.xq70_u20.qnpn13g2[is]
print @r.xbgr.xq70_u20.rsub[i]
print @c.xbgr.xq70_u20.csub[i]
print @q.xbgr.xq70_u21.qnpn13g2[ic]
print @q.xbgr.xq70_u21.qnpn13g2[ib]
print @q.xbgr.xq70_u21.qnpn13g2[ie]
print @q.xbgr.xq70_u21.qnpn13g2[is]
print @r.xbgr.xq70_u21.rsub[i]
print @c.xbgr.xq70_u21.csub[i]
print @q.xbgr.xq70_u22.qnpn13g2[ic]
print @q.xbgr.xq70_u22.qnpn13g2[ib]
print @q.xbgr.xq70_u22.qnpn13g2[ie]
print @q.xbgr.xq70_u22.qnpn13g2[is]
print @r.xbgr.xq70_u22.rsub[i]
print @c.xbgr.xq70_u22.csub[i]
print @q.xbgr.xq70_u23.qnpn13g2[ic]
print @q.xbgr.xq70_u23.qnpn13g2[ib]
print @q.xbgr.xq70_u23.qnpn13g2[ie]
print @q.xbgr.xq70_u23.qnpn13g2[is]
print @r.xbgr.xq70_u23.rsub[i]
print @c.xbgr.xq70_u23.csub[i]
print @q.xbgr.xq70_u24.qnpn13g2[ic]
print @q.xbgr.xq70_u24.qnpn13g2[ib]
print @q.xbgr.xq70_u24.qnpn13g2[ie]
print @q.xbgr.xq70_u24.qnpn13g2[is]
print @r.xbgr.xq70_u24.rsub[i]
print @c.xbgr.xq70_u24.csub[i]
print @q.xbgr.xq71_u2.qnpn13g2[ic]
print @q.xbgr.xq71_u2.qnpn13g2[ib]
print @q.xbgr.xq71_u2.qnpn13g2[ie]
print @q.xbgr.xq71_u2.qnpn13g2[is]
print @r.xbgr.xq71_u2.rsub[i]
print @c.xbgr.xq71_u2.csub[i]
print @q.xbgr.xq71_u3.qnpn13g2[ic]
print @q.xbgr.xq71_u3.qnpn13g2[ib]
print @q.xbgr.xq71_u3.qnpn13g2[ie]
print @q.xbgr.xq71_u3.qnpn13g2[is]
print @r.xbgr.xq71_u3.rsub[i]
print @c.xbgr.xq71_u3.csub[i]
print @q.xbgr.xq71_u4.qnpn13g2[ic]
print @q.xbgr.xq71_u4.qnpn13g2[ib]
print @q.xbgr.xq71_u4.qnpn13g2[ie]
print @q.xbgr.xq71_u4.qnpn13g2[is]
print @r.xbgr.xq71_u4.rsub[i]
print @c.xbgr.xq71_u4.csub[i]
print @q.xbgr.xq71_u5.qnpn13g2[ic]
print @q.xbgr.xq71_u5.qnpn13g2[ib]
print @q.xbgr.xq71_u5.qnpn13g2[ie]
print @q.xbgr.xq71_u5.qnpn13g2[is]
print @r.xbgr.xq71_u5.rsub[i]
print @c.xbgr.xq71_u5.csub[i]
print @q.xbgr.xq71_u6.qnpn13g2[ic]
print @q.xbgr.xq71_u6.qnpn13g2[ib]
print @q.xbgr.xq71_u6.qnpn13g2[ie]
print @q.xbgr.xq71_u6.qnpn13g2[is]
print @r.xbgr.xq71_u6.rsub[i]
print @c.xbgr.xq71_u6.csub[i]
print @q.xbgr.xq71_u7.qnpn13g2[ic]
print @q.xbgr.xq71_u7.qnpn13g2[ib]
print @q.xbgr.xq71_u7.qnpn13g2[ie]
print @q.xbgr.xq71_u7.qnpn13g2[is]
print @r.xbgr.xq71_u7.rsub[i]
print @c.xbgr.xq71_u7.csub[i]
print @q.xbgr.xq71_u8.qnpn13g2[ic]
print @q.xbgr.xq71_u8.qnpn13g2[ib]
print @q.xbgr.xq71_u8.qnpn13g2[ie]
print @q.xbgr.xq71_u8.qnpn13g2[is]
print @r.xbgr.xq71_u8.rsub[i]
print @c.xbgr.xq71_u8.csub[i]
print @q.xbgr.xq71_u9.qnpn13g2[ic]
print @q.xbgr.xq71_u9.qnpn13g2[ib]
print @q.xbgr.xq71_u9.qnpn13g2[ie]
print @q.xbgr.xq71_u9.qnpn13g2[is]
print @r.xbgr.xq71_u9.rsub[i]
print @c.xbgr.xq71_u9.csub[i]
print @q.xbgr.xq71_u10.qnpn13g2[ic]
print @q.xbgr.xq71_u10.qnpn13g2[ib]
print @q.xbgr.xq71_u10.qnpn13g2[ie]
print @q.xbgr.xq71_u10.qnpn13g2[is]
print @r.xbgr.xq71_u10.rsub[i]
print @c.xbgr.xq71_u10.csub[i]
print @q.xbgr.xq71_u11.qnpn13g2[ic]
print @q.xbgr.xq71_u11.qnpn13g2[ib]
print @q.xbgr.xq71_u11.qnpn13g2[ie]
print @q.xbgr.xq71_u11.qnpn13g2[is]
print @r.xbgr.xq71_u11.rsub[i]
print @c.xbgr.xq71_u11.csub[i]
print @q.xbgr.xq71_u12.qnpn13g2[ic]
print @q.xbgr.xq71_u12.qnpn13g2[ib]
print @q.xbgr.xq71_u12.qnpn13g2[ie]
print @q.xbgr.xq71_u12.qnpn13g2[is]
print @r.xbgr.xq71_u12.rsub[i]
print @c.xbgr.xq71_u12.csub[i]
print @q.xbgr.xq71_u13.qnpn13g2[ic]
print @q.xbgr.xq71_u13.qnpn13g2[ib]
print @q.xbgr.xq71_u13.qnpn13g2[ie]
print @q.xbgr.xq71_u13.qnpn13g2[is]
print @r.xbgr.xq71_u13.rsub[i]
print @c.xbgr.xq71_u13.csub[i]
print @q.xbgr.xq71_u14.qnpn13g2[ic]
print @q.xbgr.xq71_u14.qnpn13g2[ib]
print @q.xbgr.xq71_u14.qnpn13g2[ie]
print @q.xbgr.xq71_u14.qnpn13g2[is]
print @r.xbgr.xq71_u14.rsub[i]
print @c.xbgr.xq71_u14.csub[i]
print @q.xbgr.xq71_u15.qnpn13g2[ic]
print @q.xbgr.xq71_u15.qnpn13g2[ib]
print @q.xbgr.xq71_u15.qnpn13g2[ie]
print @q.xbgr.xq71_u15.qnpn13g2[is]
print @r.xbgr.xq71_u15.rsub[i]
print @c.xbgr.xq71_u15.csub[i]
print @q.xbgr.xq71_u16.qnpn13g2[ic]
print @q.xbgr.xq71_u16.qnpn13g2[ib]
print @q.xbgr.xq71_u16.qnpn13g2[ie]
print @q.xbgr.xq71_u16.qnpn13g2[is]
print @r.xbgr.xq71_u16.rsub[i]
print @c.xbgr.xq71_u16.csub[i]
print @q.xbgr.xq71_u17.qnpn13g2[ic]
print @q.xbgr.xq71_u17.qnpn13g2[ib]
print @q.xbgr.xq71_u17.qnpn13g2[ie]
print @q.xbgr.xq71_u17.qnpn13g2[is]
print @r.xbgr.xq71_u17.rsub[i]
print @c.xbgr.xq71_u17.csub[i]
print @q.xbgr.xq71_u18.qnpn13g2[ic]
print @q.xbgr.xq71_u18.qnpn13g2[ib]
print @q.xbgr.xq71_u18.qnpn13g2[ie]
print @q.xbgr.xq71_u18.qnpn13g2[is]
print @r.xbgr.xq71_u18.rsub[i]
print @c.xbgr.xq71_u18.csub[i]
print @q.xbgr.xq71_u19.qnpn13g2[ic]
print @q.xbgr.xq71_u19.qnpn13g2[ib]
print @q.xbgr.xq71_u19.qnpn13g2[ie]
print @q.xbgr.xq71_u19.qnpn13g2[is]
print @r.xbgr.xq71_u19.rsub[i]
print @c.xbgr.xq71_u19.csub[i]
print @q.xbgr.xq71_u20.qnpn13g2[ic]
print @q.xbgr.xq71_u20.qnpn13g2[ib]
print @q.xbgr.xq71_u20.qnpn13g2[ie]
print @q.xbgr.xq71_u20.qnpn13g2[is]
print @r.xbgr.xq71_u20.rsub[i]
print @c.xbgr.xq71_u20.csub[i]
print @q.xbgr.xq71_u21.qnpn13g2[ic]
print @q.xbgr.xq71_u21.qnpn13g2[ib]
print @q.xbgr.xq71_u21.qnpn13g2[ie]
print @q.xbgr.xq71_u21.qnpn13g2[is]
print @r.xbgr.xq71_u21.rsub[i]
print @c.xbgr.xq71_u21.csub[i]
print @q.xbgr.xq71_u22.qnpn13g2[ic]
print @q.xbgr.xq71_u22.qnpn13g2[ib]
print @q.xbgr.xq71_u22.qnpn13g2[ie]
print @q.xbgr.xq71_u22.qnpn13g2[is]
print @r.xbgr.xq71_u22.rsub[i]
print @c.xbgr.xq71_u22.csub[i]
print @q.xbgr.xq71_u23.qnpn13g2[ic]
print @q.xbgr.xq71_u23.qnpn13g2[ib]
print @q.xbgr.xq71_u23.qnpn13g2[ie]
print @q.xbgr.xq71_u23.qnpn13g2[is]
print @r.xbgr.xq71_u23.rsub[i]
print @c.xbgr.xq71_u23.csub[i]
print @q.xbgr.xq71_u24.qnpn13g2[ic]
print @q.xbgr.xq71_u24.qnpn13g2[ib]
print @q.xbgr.xq71_u24.qnpn13g2[ie]
print @q.xbgr.xq71_u24.qnpn13g2[is]
print @r.xbgr.xq71_u24.rsub[i]
print @c.xbgr.xq71_u24.csub[i]
print @q.xbgr.xq72_u2.qnpn13g2[ic]
print @q.xbgr.xq72_u2.qnpn13g2[ib]
print @q.xbgr.xq72_u2.qnpn13g2[ie]
print @q.xbgr.xq72_u2.qnpn13g2[is]
print @r.xbgr.xq72_u2.rsub[i]
print @c.xbgr.xq72_u2.csub[i]
print @q.xbgr.xq72_u3.qnpn13g2[ic]
print @q.xbgr.xq72_u3.qnpn13g2[ib]
print @q.xbgr.xq72_u3.qnpn13g2[ie]
print @q.xbgr.xq72_u3.qnpn13g2[is]
print @r.xbgr.xq72_u3.rsub[i]
print @c.xbgr.xq72_u3.csub[i]
print @q.xbgr.xq72_u4.qnpn13g2[ic]
print @q.xbgr.xq72_u4.qnpn13g2[ib]
print @q.xbgr.xq72_u4.qnpn13g2[ie]
print @q.xbgr.xq72_u4.qnpn13g2[is]
print @r.xbgr.xq72_u4.rsub[i]
print @c.xbgr.xq72_u4.csub[i]
print @q.xbgr.xq72_u5.qnpn13g2[ic]
print @q.xbgr.xq72_u5.qnpn13g2[ib]
print @q.xbgr.xq72_u5.qnpn13g2[ie]
print @q.xbgr.xq72_u5.qnpn13g2[is]
print @r.xbgr.xq72_u5.rsub[i]
print @c.xbgr.xq72_u5.csub[i]
print @q.xbgr.xq72_u6.qnpn13g2[ic]
print @q.xbgr.xq72_u6.qnpn13g2[ib]
print @q.xbgr.xq72_u6.qnpn13g2[ie]
print @q.xbgr.xq72_u6.qnpn13g2[is]
print @r.xbgr.xq72_u6.rsub[i]
print @c.xbgr.xq72_u6.csub[i]
print @q.xbgr.xq72_u7.qnpn13g2[ic]
print @q.xbgr.xq72_u7.qnpn13g2[ib]
print @q.xbgr.xq72_u7.qnpn13g2[ie]
print @q.xbgr.xq72_u7.qnpn13g2[is]
print @r.xbgr.xq72_u7.rsub[i]
print @c.xbgr.xq72_u7.csub[i]
print @q.xbgr.xq72_u8.qnpn13g2[ic]
print @q.xbgr.xq72_u8.qnpn13g2[ib]
print @q.xbgr.xq72_u8.qnpn13g2[ie]
print @q.xbgr.xq72_u8.qnpn13g2[is]
print @r.xbgr.xq72_u8.rsub[i]
print @c.xbgr.xq72_u8.csub[i]
print @q.xbgr.xq72_u9.qnpn13g2[ic]
print @q.xbgr.xq72_u9.qnpn13g2[ib]
print @q.xbgr.xq72_u9.qnpn13g2[ie]
print @q.xbgr.xq72_u9.qnpn13g2[is]
print @r.xbgr.xq72_u9.rsub[i]
print @c.xbgr.xq72_u9.csub[i]
print @q.xbgr.xq72_u10.qnpn13g2[ic]
print @q.xbgr.xq72_u10.qnpn13g2[ib]
print @q.xbgr.xq72_u10.qnpn13g2[ie]
print @q.xbgr.xq72_u10.qnpn13g2[is]
print @r.xbgr.xq72_u10.rsub[i]
print @c.xbgr.xq72_u10.csub[i]
print @q.xbgr.xq72_u11.qnpn13g2[ic]
print @q.xbgr.xq72_u11.qnpn13g2[ib]
print @q.xbgr.xq72_u11.qnpn13g2[ie]
print @q.xbgr.xq72_u11.qnpn13g2[is]
print @r.xbgr.xq72_u11.rsub[i]
print @c.xbgr.xq72_u11.csub[i]
print @q.xbgr.xq72_u12.qnpn13g2[ic]
print @q.xbgr.xq72_u12.qnpn13g2[ib]
print @q.xbgr.xq72_u12.qnpn13g2[ie]
print @q.xbgr.xq72_u12.qnpn13g2[is]
print @r.xbgr.xq72_u12.rsub[i]
print @c.xbgr.xq72_u12.csub[i]
print @q.xbgr.xq72_u13.qnpn13g2[ic]
print @q.xbgr.xq72_u13.qnpn13g2[ib]
print @q.xbgr.xq72_u13.qnpn13g2[ie]
print @q.xbgr.xq72_u13.qnpn13g2[is]
print @r.xbgr.xq72_u13.rsub[i]
print @c.xbgr.xq72_u13.csub[i]
print @q.xbgr.xq72_u14.qnpn13g2[ic]
print @q.xbgr.xq72_u14.qnpn13g2[ib]
print @q.xbgr.xq72_u14.qnpn13g2[ie]
print @q.xbgr.xq72_u14.qnpn13g2[is]
print @r.xbgr.xq72_u14.rsub[i]
print @c.xbgr.xq72_u14.csub[i]
print @q.xbgr.xq72_u15.qnpn13g2[ic]
print @q.xbgr.xq72_u15.qnpn13g2[ib]
print @q.xbgr.xq72_u15.qnpn13g2[ie]
print @q.xbgr.xq72_u15.qnpn13g2[is]
print @r.xbgr.xq72_u15.rsub[i]
print @c.xbgr.xq72_u15.csub[i]
print @q.xbgr.xq72_u16.qnpn13g2[ic]
print @q.xbgr.xq72_u16.qnpn13g2[ib]
print @q.xbgr.xq72_u16.qnpn13g2[ie]
print @q.xbgr.xq72_u16.qnpn13g2[is]
print @r.xbgr.xq72_u16.rsub[i]
print @c.xbgr.xq72_u16.csub[i]
print @q.xbgr.xq72_u17.qnpn13g2[ic]
print @q.xbgr.xq72_u17.qnpn13g2[ib]
print @q.xbgr.xq72_u17.qnpn13g2[ie]
print @q.xbgr.xq72_u17.qnpn13g2[is]
print @r.xbgr.xq72_u17.rsub[i]
print @c.xbgr.xq72_u17.csub[i]
print @q.xbgr.xq72_u18.qnpn13g2[ic]
print @q.xbgr.xq72_u18.qnpn13g2[ib]
print @q.xbgr.xq72_u18.qnpn13g2[ie]
print @q.xbgr.xq72_u18.qnpn13g2[is]
print @r.xbgr.xq72_u18.rsub[i]
print @c.xbgr.xq72_u18.csub[i]
print @q.xbgr.xq72_u19.qnpn13g2[ic]
print @q.xbgr.xq72_u19.qnpn13g2[ib]
print @q.xbgr.xq72_u19.qnpn13g2[ie]
print @q.xbgr.xq72_u19.qnpn13g2[is]
print @r.xbgr.xq72_u19.rsub[i]
print @c.xbgr.xq72_u19.csub[i]
print @q.xbgr.xq72_u20.qnpn13g2[ic]
print @q.xbgr.xq72_u20.qnpn13g2[ib]
print @q.xbgr.xq72_u20.qnpn13g2[ie]
print @q.xbgr.xq72_u20.qnpn13g2[is]
print @r.xbgr.xq72_u20.rsub[i]
print @c.xbgr.xq72_u20.csub[i]
print @q.xbgr.xq72_u21.qnpn13g2[ic]
print @q.xbgr.xq72_u21.qnpn13g2[ib]
print @q.xbgr.xq72_u21.qnpn13g2[ie]
print @q.xbgr.xq72_u21.qnpn13g2[is]
print @r.xbgr.xq72_u21.rsub[i]
print @c.xbgr.xq72_u21.csub[i]
print @q.xbgr.xq72_u22.qnpn13g2[ic]
print @q.xbgr.xq72_u22.qnpn13g2[ib]
print @q.xbgr.xq72_u22.qnpn13g2[ie]
print @q.xbgr.xq72_u22.qnpn13g2[is]
print @r.xbgr.xq72_u22.rsub[i]
print @c.xbgr.xq72_u22.csub[i]
print @q.xbgr.xq72_u23.qnpn13g2[ic]
print @q.xbgr.xq72_u23.qnpn13g2[ib]
print @q.xbgr.xq72_u23.qnpn13g2[ie]
print @q.xbgr.xq72_u23.qnpn13g2[is]
print @r.xbgr.xq72_u23.rsub[i]
print @c.xbgr.xq72_u23.csub[i]
print @q.xbgr.xq72_u24.qnpn13g2[ic]
print @q.xbgr.xq72_u24.qnpn13g2[ib]
print @q.xbgr.xq72_u24.qnpn13g2[ie]
print @q.xbgr.xq72_u24.qnpn13g2[is]
print @r.xbgr.xq72_u24.rsub[i]
print @c.xbgr.xq72_u24.csub[i]
print @q.xbgr.xq73_u2.qnpn13g2[ic]
print @q.xbgr.xq73_u2.qnpn13g2[ib]
print @q.xbgr.xq73_u2.qnpn13g2[ie]
print @q.xbgr.xq73_u2.qnpn13g2[is]
print @r.xbgr.xq73_u2.rsub[i]
print @c.xbgr.xq73_u2.csub[i]
print @q.xbgr.xq73_u3.qnpn13g2[ic]
print @q.xbgr.xq73_u3.qnpn13g2[ib]
print @q.xbgr.xq73_u3.qnpn13g2[ie]
print @q.xbgr.xq73_u3.qnpn13g2[is]
print @r.xbgr.xq73_u3.rsub[i]
print @c.xbgr.xq73_u3.csub[i]
print @q.xbgr.xq73_u4.qnpn13g2[ic]
print @q.xbgr.xq73_u4.qnpn13g2[ib]
print @q.xbgr.xq73_u4.qnpn13g2[ie]
print @q.xbgr.xq73_u4.qnpn13g2[is]
print @r.xbgr.xq73_u4.rsub[i]
print @c.xbgr.xq73_u4.csub[i]
print @q.xbgr.xq73_u5.qnpn13g2[ic]
print @q.xbgr.xq73_u5.qnpn13g2[ib]
print @q.xbgr.xq73_u5.qnpn13g2[ie]
print @q.xbgr.xq73_u5.qnpn13g2[is]
print @r.xbgr.xq73_u5.rsub[i]
print @c.xbgr.xq73_u5.csub[i]
print @q.xbgr.xq73_u6.qnpn13g2[ic]
print @q.xbgr.xq73_u6.qnpn13g2[ib]
print @q.xbgr.xq73_u6.qnpn13g2[ie]
print @q.xbgr.xq73_u6.qnpn13g2[is]
print @r.xbgr.xq73_u6.rsub[i]
print @c.xbgr.xq73_u6.csub[i]
print @q.xbgr.xq73_u7.qnpn13g2[ic]
print @q.xbgr.xq73_u7.qnpn13g2[ib]
print @q.xbgr.xq73_u7.qnpn13g2[ie]
print @q.xbgr.xq73_u7.qnpn13g2[is]
print @r.xbgr.xq73_u7.rsub[i]
print @c.xbgr.xq73_u7.csub[i]
print @q.xbgr.xq73_u8.qnpn13g2[ic]
print @q.xbgr.xq73_u8.qnpn13g2[ib]
print @q.xbgr.xq73_u8.qnpn13g2[ie]
print @q.xbgr.xq73_u8.qnpn13g2[is]
print @r.xbgr.xq73_u8.rsub[i]
print @c.xbgr.xq73_u8.csub[i]
print @q.xbgr.xq73_u9.qnpn13g2[ic]
print @q.xbgr.xq73_u9.qnpn13g2[ib]
print @q.xbgr.xq73_u9.qnpn13g2[ie]
print @q.xbgr.xq73_u9.qnpn13g2[is]
print @r.xbgr.xq73_u9.rsub[i]
print @c.xbgr.xq73_u9.csub[i]
print @q.xbgr.xq73_u10.qnpn13g2[ic]
print @q.xbgr.xq73_u10.qnpn13g2[ib]
print @q.xbgr.xq73_u10.qnpn13g2[ie]
print @q.xbgr.xq73_u10.qnpn13g2[is]
print @r.xbgr.xq73_u10.rsub[i]
print @c.xbgr.xq73_u10.csub[i]
print @q.xbgr.xq73_u11.qnpn13g2[ic]
print @q.xbgr.xq73_u11.qnpn13g2[ib]
print @q.xbgr.xq73_u11.qnpn13g2[ie]
print @q.xbgr.xq73_u11.qnpn13g2[is]
print @r.xbgr.xq73_u11.rsub[i]
print @c.xbgr.xq73_u11.csub[i]
print @q.xbgr.xq73_u12.qnpn13g2[ic]
print @q.xbgr.xq73_u12.qnpn13g2[ib]
print @q.xbgr.xq73_u12.qnpn13g2[ie]
print @q.xbgr.xq73_u12.qnpn13g2[is]
print @r.xbgr.xq73_u12.rsub[i]
print @c.xbgr.xq73_u12.csub[i]
print @q.xbgr.xq73_u13.qnpn13g2[ic]
print @q.xbgr.xq73_u13.qnpn13g2[ib]
print @q.xbgr.xq73_u13.qnpn13g2[ie]
print @q.xbgr.xq73_u13.qnpn13g2[is]
print @r.xbgr.xq73_u13.rsub[i]
print @c.xbgr.xq73_u13.csub[i]
print @q.xbgr.xq73_u14.qnpn13g2[ic]
print @q.xbgr.xq73_u14.qnpn13g2[ib]
print @q.xbgr.xq73_u14.qnpn13g2[ie]
print @q.xbgr.xq73_u14.qnpn13g2[is]
print @r.xbgr.xq73_u14.rsub[i]
print @c.xbgr.xq73_u14.csub[i]
print @q.xbgr.xq73_u15.qnpn13g2[ic]
print @q.xbgr.xq73_u15.qnpn13g2[ib]
print @q.xbgr.xq73_u15.qnpn13g2[ie]
print @q.xbgr.xq73_u15.qnpn13g2[is]
print @r.xbgr.xq73_u15.rsub[i]
print @c.xbgr.xq73_u15.csub[i]
print @q.xbgr.xq73_u16.qnpn13g2[ic]
print @q.xbgr.xq73_u16.qnpn13g2[ib]
print @q.xbgr.xq73_u16.qnpn13g2[ie]
print @q.xbgr.xq73_u16.qnpn13g2[is]
print @r.xbgr.xq73_u16.rsub[i]
print @c.xbgr.xq73_u16.csub[i]
print @q.xbgr.xq73_u17.qnpn13g2[ic]
print @q.xbgr.xq73_u17.qnpn13g2[ib]
print @q.xbgr.xq73_u17.qnpn13g2[ie]
print @q.xbgr.xq73_u17.qnpn13g2[is]
print @r.xbgr.xq73_u17.rsub[i]
print @c.xbgr.xq73_u17.csub[i]
print @q.xbgr.xq73_u18.qnpn13g2[ic]
print @q.xbgr.xq73_u18.qnpn13g2[ib]
print @q.xbgr.xq73_u18.qnpn13g2[ie]
print @q.xbgr.xq73_u18.qnpn13g2[is]
print @r.xbgr.xq73_u18.rsub[i]
print @c.xbgr.xq73_u18.csub[i]
print @q.xbgr.xq73_u19.qnpn13g2[ic]
print @q.xbgr.xq73_u19.qnpn13g2[ib]
print @q.xbgr.xq73_u19.qnpn13g2[ie]
print @q.xbgr.xq73_u19.qnpn13g2[is]
print @r.xbgr.xq73_u19.rsub[i]
print @c.xbgr.xq73_u19.csub[i]
print @q.xbgr.xq73_u20.qnpn13g2[ic]
print @q.xbgr.xq73_u20.qnpn13g2[ib]
print @q.xbgr.xq73_u20.qnpn13g2[ie]
print @q.xbgr.xq73_u20.qnpn13g2[is]
print @r.xbgr.xq73_u20.rsub[i]
print @c.xbgr.xq73_u20.csub[i]
print @q.xbgr.xq73_u21.qnpn13g2[ic]
print @q.xbgr.xq73_u21.qnpn13g2[ib]
print @q.xbgr.xq73_u21.qnpn13g2[ie]
print @q.xbgr.xq73_u21.qnpn13g2[is]
print @r.xbgr.xq73_u21.rsub[i]
print @c.xbgr.xq73_u21.csub[i]
print @q.xbgr.xq73_u22.qnpn13g2[ic]
print @q.xbgr.xq73_u22.qnpn13g2[ib]
print @q.xbgr.xq73_u22.qnpn13g2[ie]
print @q.xbgr.xq73_u22.qnpn13g2[is]
print @r.xbgr.xq73_u22.rsub[i]
print @c.xbgr.xq73_u22.csub[i]
print @q.xbgr.xq73_u23.qnpn13g2[ic]
print @q.xbgr.xq73_u23.qnpn13g2[ib]
print @q.xbgr.xq73_u23.qnpn13g2[ie]
print @q.xbgr.xq73_u23.qnpn13g2[is]
print @r.xbgr.xq73_u23.rsub[i]
print @c.xbgr.xq73_u23.csub[i]
print @q.xbgr.xq73_u24.qnpn13g2[ic]
print @q.xbgr.xq73_u24.qnpn13g2[ib]
print @q.xbgr.xq73_u24.qnpn13g2[ie]
print @q.xbgr.xq73_u24.qnpn13g2[is]
print @r.xbgr.xq73_u24.rsub[i]
print @c.xbgr.xq73_u24.csub[i]
print @q.xbgr.xq74_u2.qnpn13g2[ic]
print @q.xbgr.xq74_u2.qnpn13g2[ib]
print @q.xbgr.xq74_u2.qnpn13g2[ie]
print @q.xbgr.xq74_u2.qnpn13g2[is]
print @r.xbgr.xq74_u2.rsub[i]
print @c.xbgr.xq74_u2.csub[i]
print @q.xbgr.xq74_u3.qnpn13g2[ic]
print @q.xbgr.xq74_u3.qnpn13g2[ib]
print @q.xbgr.xq74_u3.qnpn13g2[ie]
print @q.xbgr.xq74_u3.qnpn13g2[is]
print @r.xbgr.xq74_u3.rsub[i]
print @c.xbgr.xq74_u3.csub[i]
print @q.xbgr.xq74_u4.qnpn13g2[ic]
print @q.xbgr.xq74_u4.qnpn13g2[ib]
print @q.xbgr.xq74_u4.qnpn13g2[ie]
print @q.xbgr.xq74_u4.qnpn13g2[is]
print @r.xbgr.xq74_u4.rsub[i]
print @c.xbgr.xq74_u4.csub[i]
print @q.xbgr.xq74_u5.qnpn13g2[ic]
print @q.xbgr.xq74_u5.qnpn13g2[ib]
print @q.xbgr.xq74_u5.qnpn13g2[ie]
print @q.xbgr.xq74_u5.qnpn13g2[is]
print @r.xbgr.xq74_u5.rsub[i]
print @c.xbgr.xq74_u5.csub[i]
print @q.xbgr.xq74_u6.qnpn13g2[ic]
print @q.xbgr.xq74_u6.qnpn13g2[ib]
print @q.xbgr.xq74_u6.qnpn13g2[ie]
print @q.xbgr.xq74_u6.qnpn13g2[is]
print @r.xbgr.xq74_u6.rsub[i]
print @c.xbgr.xq74_u6.csub[i]
print @q.xbgr.xq74_u7.qnpn13g2[ic]
print @q.xbgr.xq74_u7.qnpn13g2[ib]
print @q.xbgr.xq74_u7.qnpn13g2[ie]
print @q.xbgr.xq74_u7.qnpn13g2[is]
print @r.xbgr.xq74_u7.rsub[i]
print @c.xbgr.xq74_u7.csub[i]
print @q.xbgr.xq74_u8.qnpn13g2[ic]
print @q.xbgr.xq74_u8.qnpn13g2[ib]
print @q.xbgr.xq74_u8.qnpn13g2[ie]
print @q.xbgr.xq74_u8.qnpn13g2[is]
print @r.xbgr.xq74_u8.rsub[i]
print @c.xbgr.xq74_u8.csub[i]
print @q.xbgr.xq74_u9.qnpn13g2[ic]
print @q.xbgr.xq74_u9.qnpn13g2[ib]
print @q.xbgr.xq74_u9.qnpn13g2[ie]
print @q.xbgr.xq74_u9.qnpn13g2[is]
print @r.xbgr.xq74_u9.rsub[i]
print @c.xbgr.xq74_u9.csub[i]
print @q.xbgr.xq74_u10.qnpn13g2[ic]
print @q.xbgr.xq74_u10.qnpn13g2[ib]
print @q.xbgr.xq74_u10.qnpn13g2[ie]
print @q.xbgr.xq74_u10.qnpn13g2[is]
print @r.xbgr.xq74_u10.rsub[i]
print @c.xbgr.xq74_u10.csub[i]
print @q.xbgr.xq74_u11.qnpn13g2[ic]
print @q.xbgr.xq74_u11.qnpn13g2[ib]
print @q.xbgr.xq74_u11.qnpn13g2[ie]
print @q.xbgr.xq74_u11.qnpn13g2[is]
print @r.xbgr.xq74_u11.rsub[i]
print @c.xbgr.xq74_u11.csub[i]
print @q.xbgr.xq74_u12.qnpn13g2[ic]
print @q.xbgr.xq74_u12.qnpn13g2[ib]
print @q.xbgr.xq74_u12.qnpn13g2[ie]
print @q.xbgr.xq74_u12.qnpn13g2[is]
print @r.xbgr.xq74_u12.rsub[i]
print @c.xbgr.xq74_u12.csub[i]
print @q.xbgr.xq74_u13.qnpn13g2[ic]
print @q.xbgr.xq74_u13.qnpn13g2[ib]
print @q.xbgr.xq74_u13.qnpn13g2[ie]
print @q.xbgr.xq74_u13.qnpn13g2[is]
print @r.xbgr.xq74_u13.rsub[i]
print @c.xbgr.xq74_u13.csub[i]
print @q.xbgr.xq74_u14.qnpn13g2[ic]
print @q.xbgr.xq74_u14.qnpn13g2[ib]
print @q.xbgr.xq74_u14.qnpn13g2[ie]
print @q.xbgr.xq74_u14.qnpn13g2[is]
print @r.xbgr.xq74_u14.rsub[i]
print @c.xbgr.xq74_u14.csub[i]
print @q.xbgr.xq74_u15.qnpn13g2[ic]
print @q.xbgr.xq74_u15.qnpn13g2[ib]
print @q.xbgr.xq74_u15.qnpn13g2[ie]
print @q.xbgr.xq74_u15.qnpn13g2[is]
print @r.xbgr.xq74_u15.rsub[i]
print @c.xbgr.xq74_u15.csub[i]
print @q.xbgr.xq74_u16.qnpn13g2[ic]
print @q.xbgr.xq74_u16.qnpn13g2[ib]
print @q.xbgr.xq74_u16.qnpn13g2[ie]
print @q.xbgr.xq74_u16.qnpn13g2[is]
print @r.xbgr.xq74_u16.rsub[i]
print @c.xbgr.xq74_u16.csub[i]
print @q.xbgr.xq74_u17.qnpn13g2[ic]
print @q.xbgr.xq74_u17.qnpn13g2[ib]
print @q.xbgr.xq74_u17.qnpn13g2[ie]
print @q.xbgr.xq74_u17.qnpn13g2[is]
print @r.xbgr.xq74_u17.rsub[i]
print @c.xbgr.xq74_u17.csub[i]
print @q.xbgr.xq74_u18.qnpn13g2[ic]
print @q.xbgr.xq74_u18.qnpn13g2[ib]
print @q.xbgr.xq74_u18.qnpn13g2[ie]
print @q.xbgr.xq74_u18.qnpn13g2[is]
print @r.xbgr.xq74_u18.rsub[i]
print @c.xbgr.xq74_u18.csub[i]
print @q.xbgr.xq74_u19.qnpn13g2[ic]
print @q.xbgr.xq74_u19.qnpn13g2[ib]
print @q.xbgr.xq74_u19.qnpn13g2[ie]
print @q.xbgr.xq74_u19.qnpn13g2[is]
print @r.xbgr.xq74_u19.rsub[i]
print @c.xbgr.xq74_u19.csub[i]
print @q.xbgr.xq74_u20.qnpn13g2[ic]
print @q.xbgr.xq74_u20.qnpn13g2[ib]
print @q.xbgr.xq74_u20.qnpn13g2[ie]
print @q.xbgr.xq74_u20.qnpn13g2[is]
print @r.xbgr.xq74_u20.rsub[i]
print @c.xbgr.xq74_u20.csub[i]
print @q.xbgr.xq74_u21.qnpn13g2[ic]
print @q.xbgr.xq74_u21.qnpn13g2[ib]
print @q.xbgr.xq74_u21.qnpn13g2[ie]
print @q.xbgr.xq74_u21.qnpn13g2[is]
print @r.xbgr.xq74_u21.rsub[i]
print @c.xbgr.xq74_u21.csub[i]
print @q.xbgr.xq74_u22.qnpn13g2[ic]
print @q.xbgr.xq74_u22.qnpn13g2[ib]
print @q.xbgr.xq74_u22.qnpn13g2[ie]
print @q.xbgr.xq74_u22.qnpn13g2[is]
print @r.xbgr.xq74_u22.rsub[i]
print @c.xbgr.xq74_u22.csub[i]
print @q.xbgr.xq74_u23.qnpn13g2[ic]
print @q.xbgr.xq74_u23.qnpn13g2[ib]
print @q.xbgr.xq74_u23.qnpn13g2[ie]
print @q.xbgr.xq74_u23.qnpn13g2[is]
print @r.xbgr.xq74_u23.rsub[i]
print @c.xbgr.xq74_u23.csub[i]
print @q.xbgr.xq74_u24.qnpn13g2[ic]
print @q.xbgr.xq74_u24.qnpn13g2[ib]
print @q.xbgr.xq74_u24.qnpn13g2[ie]
print @q.xbgr.xq74_u24.qnpn13g2[is]
print @r.xbgr.xq74_u24.rsub[i]
print @c.xbgr.xq74_u24.csub[i]
print @q.xbgr.xq75_u2.qnpn13g2[ic]
print @q.xbgr.xq75_u2.qnpn13g2[ib]
print @q.xbgr.xq75_u2.qnpn13g2[ie]
print @q.xbgr.xq75_u2.qnpn13g2[is]
print @r.xbgr.xq75_u2.rsub[i]
print @c.xbgr.xq75_u2.csub[i]
print @q.xbgr.xq75_u3.qnpn13g2[ic]
print @q.xbgr.xq75_u3.qnpn13g2[ib]
print @q.xbgr.xq75_u3.qnpn13g2[ie]
print @q.xbgr.xq75_u3.qnpn13g2[is]
print @r.xbgr.xq75_u3.rsub[i]
print @c.xbgr.xq75_u3.csub[i]
print @q.xbgr.xq75_u4.qnpn13g2[ic]
print @q.xbgr.xq75_u4.qnpn13g2[ib]
print @q.xbgr.xq75_u4.qnpn13g2[ie]
print @q.xbgr.xq75_u4.qnpn13g2[is]
print @r.xbgr.xq75_u4.rsub[i]
print @c.xbgr.xq75_u4.csub[i]
print @q.xbgr.xq75_u5.qnpn13g2[ic]
print @q.xbgr.xq75_u5.qnpn13g2[ib]
print @q.xbgr.xq75_u5.qnpn13g2[ie]
print @q.xbgr.xq75_u5.qnpn13g2[is]
print @r.xbgr.xq75_u5.rsub[i]
print @c.xbgr.xq75_u5.csub[i]
print @q.xbgr.xq75_u6.qnpn13g2[ic]
print @q.xbgr.xq75_u6.qnpn13g2[ib]
print @q.xbgr.xq75_u6.qnpn13g2[ie]
print @q.xbgr.xq75_u6.qnpn13g2[is]
print @r.xbgr.xq75_u6.rsub[i]
print @c.xbgr.xq75_u6.csub[i]
print @q.xbgr.xq75_u7.qnpn13g2[ic]
print @q.xbgr.xq75_u7.qnpn13g2[ib]
print @q.xbgr.xq75_u7.qnpn13g2[ie]
print @q.xbgr.xq75_u7.qnpn13g2[is]
print @r.xbgr.xq75_u7.rsub[i]
print @c.xbgr.xq75_u7.csub[i]
print @q.xbgr.xq75_u8.qnpn13g2[ic]
print @q.xbgr.xq75_u8.qnpn13g2[ib]
print @q.xbgr.xq75_u8.qnpn13g2[ie]
print @q.xbgr.xq75_u8.qnpn13g2[is]
print @r.xbgr.xq75_u8.rsub[i]
print @c.xbgr.xq75_u8.csub[i]
print @q.xbgr.xq75_u9.qnpn13g2[ic]
print @q.xbgr.xq75_u9.qnpn13g2[ib]
print @q.xbgr.xq75_u9.qnpn13g2[ie]
print @q.xbgr.xq75_u9.qnpn13g2[is]
print @r.xbgr.xq75_u9.rsub[i]
print @c.xbgr.xq75_u9.csub[i]
print @q.xbgr.xq75_u10.qnpn13g2[ic]
print @q.xbgr.xq75_u10.qnpn13g2[ib]
print @q.xbgr.xq75_u10.qnpn13g2[ie]
print @q.xbgr.xq75_u10.qnpn13g2[is]
print @r.xbgr.xq75_u10.rsub[i]
print @c.xbgr.xq75_u10.csub[i]
print @q.xbgr.xq75_u11.qnpn13g2[ic]
print @q.xbgr.xq75_u11.qnpn13g2[ib]
print @q.xbgr.xq75_u11.qnpn13g2[ie]
print @q.xbgr.xq75_u11.qnpn13g2[is]
print @r.xbgr.xq75_u11.rsub[i]
print @c.xbgr.xq75_u11.csub[i]
print @q.xbgr.xq75_u12.qnpn13g2[ic]
print @q.xbgr.xq75_u12.qnpn13g2[ib]
print @q.xbgr.xq75_u12.qnpn13g2[ie]
print @q.xbgr.xq75_u12.qnpn13g2[is]
print @r.xbgr.xq75_u12.rsub[i]
print @c.xbgr.xq75_u12.csub[i]
print @q.xbgr.xq75_u13.qnpn13g2[ic]
print @q.xbgr.xq75_u13.qnpn13g2[ib]
print @q.xbgr.xq75_u13.qnpn13g2[ie]
print @q.xbgr.xq75_u13.qnpn13g2[is]
print @r.xbgr.xq75_u13.rsub[i]
print @c.xbgr.xq75_u13.csub[i]
print @q.xbgr.xq75_u14.qnpn13g2[ic]
print @q.xbgr.xq75_u14.qnpn13g2[ib]
print @q.xbgr.xq75_u14.qnpn13g2[ie]
print @q.xbgr.xq75_u14.qnpn13g2[is]
print @r.xbgr.xq75_u14.rsub[i]
print @c.xbgr.xq75_u14.csub[i]
print @q.xbgr.xq75_u15.qnpn13g2[ic]
print @q.xbgr.xq75_u15.qnpn13g2[ib]
print @q.xbgr.xq75_u15.qnpn13g2[ie]
print @q.xbgr.xq75_u15.qnpn13g2[is]
print @r.xbgr.xq75_u15.rsub[i]
print @c.xbgr.xq75_u15.csub[i]
print @q.xbgr.xq75_u16.qnpn13g2[ic]
print @q.xbgr.xq75_u16.qnpn13g2[ib]
print @q.xbgr.xq75_u16.qnpn13g2[ie]
print @q.xbgr.xq75_u16.qnpn13g2[is]
print @r.xbgr.xq75_u16.rsub[i]
print @c.xbgr.xq75_u16.csub[i]
print @q.xbgr.xq75_u17.qnpn13g2[ic]
print @q.xbgr.xq75_u17.qnpn13g2[ib]
print @q.xbgr.xq75_u17.qnpn13g2[ie]
print @q.xbgr.xq75_u17.qnpn13g2[is]
print @r.xbgr.xq75_u17.rsub[i]
print @c.xbgr.xq75_u17.csub[i]
print @q.xbgr.xq75_u18.qnpn13g2[ic]
print @q.xbgr.xq75_u18.qnpn13g2[ib]
print @q.xbgr.xq75_u18.qnpn13g2[ie]
print @q.xbgr.xq75_u18.qnpn13g2[is]
print @r.xbgr.xq75_u18.rsub[i]
print @c.xbgr.xq75_u18.csub[i]
print @q.xbgr.xq75_u19.qnpn13g2[ic]
print @q.xbgr.xq75_u19.qnpn13g2[ib]
print @q.xbgr.xq75_u19.qnpn13g2[ie]
print @q.xbgr.xq75_u19.qnpn13g2[is]
print @r.xbgr.xq75_u19.rsub[i]
print @c.xbgr.xq75_u19.csub[i]
print @q.xbgr.xq75_u20.qnpn13g2[ic]
print @q.xbgr.xq75_u20.qnpn13g2[ib]
print @q.xbgr.xq75_u20.qnpn13g2[ie]
print @q.xbgr.xq75_u20.qnpn13g2[is]
print @r.xbgr.xq75_u20.rsub[i]
print @c.xbgr.xq75_u20.csub[i]
print @q.xbgr.xq75_u21.qnpn13g2[ic]
print @q.xbgr.xq75_u21.qnpn13g2[ib]
print @q.xbgr.xq75_u21.qnpn13g2[ie]
print @q.xbgr.xq75_u21.qnpn13g2[is]
print @r.xbgr.xq75_u21.rsub[i]
print @c.xbgr.xq75_u21.csub[i]
print @q.xbgr.xq75_u22.qnpn13g2[ic]
print @q.xbgr.xq75_u22.qnpn13g2[ib]
print @q.xbgr.xq75_u22.qnpn13g2[ie]
print @q.xbgr.xq75_u22.qnpn13g2[is]
print @r.xbgr.xq75_u22.rsub[i]
print @c.xbgr.xq75_u22.csub[i]
print @q.xbgr.xq75_u23.qnpn13g2[ic]
print @q.xbgr.xq75_u23.qnpn13g2[ib]
print @q.xbgr.xq75_u23.qnpn13g2[ie]
print @q.xbgr.xq75_u23.qnpn13g2[is]
print @r.xbgr.xq75_u23.rsub[i]
print @c.xbgr.xq75_u23.csub[i]
print @q.xbgr.xq75_u24.qnpn13g2[ic]
print @q.xbgr.xq75_u24.qnpn13g2[ib]
print @q.xbgr.xq75_u24.qnpn13g2[ie]
print @q.xbgr.xq75_u24.qnpn13g2[is]
print @r.xbgr.xq75_u24.rsub[i]
print @c.xbgr.xq75_u24.csub[i]
print @q.xbgr.xq76_u2.qnpn13g2[ic]
print @q.xbgr.xq76_u2.qnpn13g2[ib]
print @q.xbgr.xq76_u2.qnpn13g2[ie]
print @q.xbgr.xq76_u2.qnpn13g2[is]
print @r.xbgr.xq76_u2.rsub[i]
print @c.xbgr.xq76_u2.csub[i]
print @q.xbgr.xq76_u3.qnpn13g2[ic]
print @q.xbgr.xq76_u3.qnpn13g2[ib]
print @q.xbgr.xq76_u3.qnpn13g2[ie]
print @q.xbgr.xq76_u3.qnpn13g2[is]
print @r.xbgr.xq76_u3.rsub[i]
print @c.xbgr.xq76_u3.csub[i]
print @q.xbgr.xq76_u4.qnpn13g2[ic]
print @q.xbgr.xq76_u4.qnpn13g2[ib]
print @q.xbgr.xq76_u4.qnpn13g2[ie]
print @q.xbgr.xq76_u4.qnpn13g2[is]
print @r.xbgr.xq76_u4.rsub[i]
print @c.xbgr.xq76_u4.csub[i]
print @q.xbgr.xq76_u5.qnpn13g2[ic]
print @q.xbgr.xq76_u5.qnpn13g2[ib]
print @q.xbgr.xq76_u5.qnpn13g2[ie]
print @q.xbgr.xq76_u5.qnpn13g2[is]
print @r.xbgr.xq76_u5.rsub[i]
print @c.xbgr.xq76_u5.csub[i]
print @q.xbgr.xq76_u6.qnpn13g2[ic]
print @q.xbgr.xq76_u6.qnpn13g2[ib]
print @q.xbgr.xq76_u6.qnpn13g2[ie]
print @q.xbgr.xq76_u6.qnpn13g2[is]
print @r.xbgr.xq76_u6.rsub[i]
print @c.xbgr.xq76_u6.csub[i]
print @q.xbgr.xq76_u7.qnpn13g2[ic]
print @q.xbgr.xq76_u7.qnpn13g2[ib]
print @q.xbgr.xq76_u7.qnpn13g2[ie]
print @q.xbgr.xq76_u7.qnpn13g2[is]
print @r.xbgr.xq76_u7.rsub[i]
print @c.xbgr.xq76_u7.csub[i]
print @q.xbgr.xq76_u8.qnpn13g2[ic]
print @q.xbgr.xq76_u8.qnpn13g2[ib]
print @q.xbgr.xq76_u8.qnpn13g2[ie]
print @q.xbgr.xq76_u8.qnpn13g2[is]
print @r.xbgr.xq76_u8.rsub[i]
print @c.xbgr.xq76_u8.csub[i]
print @q.xbgr.xq76_u9.qnpn13g2[ic]
print @q.xbgr.xq76_u9.qnpn13g2[ib]
print @q.xbgr.xq76_u9.qnpn13g2[ie]
print @q.xbgr.xq76_u9.qnpn13g2[is]
print @r.xbgr.xq76_u9.rsub[i]
print @c.xbgr.xq76_u9.csub[i]
print @q.xbgr.xq76_u10.qnpn13g2[ic]
print @q.xbgr.xq76_u10.qnpn13g2[ib]
print @q.xbgr.xq76_u10.qnpn13g2[ie]
print @q.xbgr.xq76_u10.qnpn13g2[is]
print @r.xbgr.xq76_u10.rsub[i]
print @c.xbgr.xq76_u10.csub[i]
print @q.xbgr.xq76_u11.qnpn13g2[ic]
print @q.xbgr.xq76_u11.qnpn13g2[ib]
print @q.xbgr.xq76_u11.qnpn13g2[ie]
print @q.xbgr.xq76_u11.qnpn13g2[is]
print @r.xbgr.xq76_u11.rsub[i]
print @c.xbgr.xq76_u11.csub[i]
print @q.xbgr.xq76_u12.qnpn13g2[ic]
print @q.xbgr.xq76_u12.qnpn13g2[ib]
print @q.xbgr.xq76_u12.qnpn13g2[ie]
print @q.xbgr.xq76_u12.qnpn13g2[is]
print @r.xbgr.xq76_u12.rsub[i]
print @c.xbgr.xq76_u12.csub[i]
print @q.xbgr.xq76_u13.qnpn13g2[ic]
print @q.xbgr.xq76_u13.qnpn13g2[ib]
print @q.xbgr.xq76_u13.qnpn13g2[ie]
print @q.xbgr.xq76_u13.qnpn13g2[is]
print @r.xbgr.xq76_u13.rsub[i]
print @c.xbgr.xq76_u13.csub[i]
print @q.xbgr.xq76_u14.qnpn13g2[ic]
print @q.xbgr.xq76_u14.qnpn13g2[ib]
print @q.xbgr.xq76_u14.qnpn13g2[ie]
print @q.xbgr.xq76_u14.qnpn13g2[is]
print @r.xbgr.xq76_u14.rsub[i]
print @c.xbgr.xq76_u14.csub[i]
print @q.xbgr.xq76_u15.qnpn13g2[ic]
print @q.xbgr.xq76_u15.qnpn13g2[ib]
print @q.xbgr.xq76_u15.qnpn13g2[ie]
print @q.xbgr.xq76_u15.qnpn13g2[is]
print @r.xbgr.xq76_u15.rsub[i]
print @c.xbgr.xq76_u15.csub[i]
print @q.xbgr.xq76_u16.qnpn13g2[ic]
print @q.xbgr.xq76_u16.qnpn13g2[ib]
print @q.xbgr.xq76_u16.qnpn13g2[ie]
print @q.xbgr.xq76_u16.qnpn13g2[is]
print @r.xbgr.xq76_u16.rsub[i]
print @c.xbgr.xq76_u16.csub[i]
print @q.xbgr.xq76_u17.qnpn13g2[ic]
print @q.xbgr.xq76_u17.qnpn13g2[ib]
print @q.xbgr.xq76_u17.qnpn13g2[ie]
print @q.xbgr.xq76_u17.qnpn13g2[is]
print @r.xbgr.xq76_u17.rsub[i]
print @c.xbgr.xq76_u17.csub[i]
print @q.xbgr.xq76_u18.qnpn13g2[ic]
print @q.xbgr.xq76_u18.qnpn13g2[ib]
print @q.xbgr.xq76_u18.qnpn13g2[ie]
print @q.xbgr.xq76_u18.qnpn13g2[is]
print @r.xbgr.xq76_u18.rsub[i]
print @c.xbgr.xq76_u18.csub[i]
print @q.xbgr.xq76_u19.qnpn13g2[ic]
print @q.xbgr.xq76_u19.qnpn13g2[ib]
print @q.xbgr.xq76_u19.qnpn13g2[ie]
print @q.xbgr.xq76_u19.qnpn13g2[is]
print @r.xbgr.xq76_u19.rsub[i]
print @c.xbgr.xq76_u19.csub[i]
print @q.xbgr.xq76_u20.qnpn13g2[ic]
print @q.xbgr.xq76_u20.qnpn13g2[ib]
print @q.xbgr.xq76_u20.qnpn13g2[ie]
print @q.xbgr.xq76_u20.qnpn13g2[is]
print @r.xbgr.xq76_u20.rsub[i]
print @c.xbgr.xq76_u20.csub[i]
print @q.xbgr.xq76_u21.qnpn13g2[ic]
print @q.xbgr.xq76_u21.qnpn13g2[ib]
print @q.xbgr.xq76_u21.qnpn13g2[ie]
print @q.xbgr.xq76_u21.qnpn13g2[is]
print @r.xbgr.xq76_u21.rsub[i]
print @c.xbgr.xq76_u21.csub[i]
print @q.xbgr.xq76_u22.qnpn13g2[ic]
print @q.xbgr.xq76_u22.qnpn13g2[ib]
print @q.xbgr.xq76_u22.qnpn13g2[ie]
print @q.xbgr.xq76_u22.qnpn13g2[is]
print @r.xbgr.xq76_u22.rsub[i]
print @c.xbgr.xq76_u22.csub[i]
print @q.xbgr.xq76_u23.qnpn13g2[ic]
print @q.xbgr.xq76_u23.qnpn13g2[ib]
print @q.xbgr.xq76_u23.qnpn13g2[ie]
print @q.xbgr.xq76_u23.qnpn13g2[is]
print @r.xbgr.xq76_u23.rsub[i]
print @c.xbgr.xq76_u23.csub[i]
print @q.xbgr.xq76_u24.qnpn13g2[ic]
print @q.xbgr.xq76_u24.qnpn13g2[ib]
print @q.xbgr.xq76_u24.qnpn13g2[ie]
print @q.xbgr.xq76_u24.qnpn13g2[is]
print @r.xbgr.xq76_u24.rsub[i]
print @c.xbgr.xq76_u24.csub[i]
print @n.xbgr.xr77_u2.nr1[ibody]
print @n.xbgr.xr77_u3.nr1[ibody]
print @n.xbgr.xr77_u4.nr1[ibody]
print @n.xbgr.xr77_u5.nr1[ibody]
print @n.xbgr.xr77_u6.nr1[ibody]
print @n.xbgr.xr77_u7.nr1[ibody]
print @n.xbgr.xr77_u8.nr1[ibody]
print @n.xbgr.xr77_u9.nr1[ibody]
print @n.xbgr.xr77_u10.nr1[ibody]
print @n.xbgr.xr77_u11.nr1[ibody]
print @n.xbgr.xr77_u12.nr1[ibody]
print @n.xbgr.xr77_u13.nr1[ibody]
print @n.xbgr.xr77_u14.nr1[ibody]
print @n.xbgr.xr77_u15.nr1[ibody]
print @n.xbgr.xr77_u16.nr1[ibody]
print @n.xbgr.xr77_u17.nr1[ibody]
print @n.xbgr.xr77_u18.nr1[ibody]
print @n.xbgr.xr77_u19.nr1[ibody]
print @n.xbgr.xr77_u20.nr1[ibody]
print @n.xbgr.xr77_u21.nr1[ibody]
print @n.xbgr.xr77_u22.nr1[ibody]
print @n.xbgr.xr77_u23.nr1[ibody]
print @n.xbgr.xr77_u24.nr1[ibody]
print @n.xbgr.xr78_u2.nr1[ibody]
print @n.xbgr.xr78_u3.nr1[ibody]
print @n.xbgr.xr78_u4.nr1[ibody]
print @n.xbgr.xr78_u5.nr1[ibody]
print @n.xbgr.xr78_u6.nr1[ibody]
print @n.xbgr.xr78_u7.nr1[ibody]
print @n.xbgr.xr78_u8.nr1[ibody]
print @n.xbgr.xr78_u9.nr1[ibody]
print @n.xbgr.xr78_u10.nr1[ibody]
print @n.xbgr.xr78_u11.nr1[ibody]
print @n.xbgr.xr78_u12.nr1[ibody]
print @n.xbgr.xr78_u13.nr1[ibody]
print @n.xbgr.xr78_u14.nr1[ibody]
print @n.xbgr.xr78_u15.nr1[ibody]
print @n.xbgr.xr78_u16.nr1[ibody]
print @n.xbgr.xr78_u17.nr1[ibody]
print @n.xbgr.xr78_u18.nr1[ibody]
print @n.xbgr.xr78_u19.nr1[ibody]
print @n.xbgr.xr78_u20.nr1[ibody]
print @n.xbgr.xr78_u21.nr1[ibody]
print @n.xbgr.xr78_u22.nr1[ibody]
print @n.xbgr.xr78_u23.nr1[ibody]
print @n.xbgr.xr78_u24.nr1[ibody]
print @n.xbgr.xr79_u2.nr1[ibody]
print @n.xbgr.xr79_u3.nr1[ibody]
print @n.xbgr.xr79_u4.nr1[ibody]
print @n.xbgr.xr79_u5.nr1[ibody]
print @n.xbgr.xr79_u6.nr1[ibody]
print @n.xbgr.xr79_u7.nr1[ibody]
print @n.xbgr.xr79_u8.nr1[ibody]
print @n.xbgr.xr79_u9.nr1[ibody]
print @n.xbgr.xr79_u10.nr1[ibody]
print @n.xbgr.xr79_u11.nr1[ibody]
print @n.xbgr.xr79_u12.nr1[ibody]
print @n.xbgr.xr79_u13.nr1[ibody]
print @n.xbgr.xr79_u14.nr1[ibody]
print @n.xbgr.xr79_u15.nr1[ibody]
print @n.xbgr.xr79_u16.nr1[ibody]
print @n.xbgr.xr79_u17.nr1[ibody]
print @n.xbgr.xr79_u18.nr1[ibody]
print @n.xbgr.xr79_u19.nr1[ibody]
print @n.xbgr.xr79_u20.nr1[ibody]
print @n.xbgr.xr79_u21.nr1[ibody]
print @n.xbgr.xr79_u22.nr1[ibody]
print @n.xbgr.xr79_u23.nr1[ibody]
print @n.xbgr.xr79_u24.nr1[ibody]
print @n.xbgr.xr80_u2.nr1[ibody]
print @n.xbgr.xr80_u3.nr1[ibody]
print @n.xbgr.xr80_u4.nr1[ibody]
print @n.xbgr.xr80_u5.nr1[ibody]
print @n.xbgr.xr80_u6.nr1[ibody]
print @n.xbgr.xr80_u7.nr1[ibody]
print @n.xbgr.xr80_u8.nr1[ibody]
print @n.xbgr.xr80_u9.nr1[ibody]
print @n.xbgr.xr80_u10.nr1[ibody]
print @n.xbgr.xr80_u11.nr1[ibody]
print @n.xbgr.xr80_u12.nr1[ibody]
print @n.xbgr.xr80_u13.nr1[ibody]
print @n.xbgr.xr80_u14.nr1[ibody]
print @n.xbgr.xr80_u15.nr1[ibody]
print @n.xbgr.xr80_u16.nr1[ibody]
print @n.xbgr.xr80_u17.nr1[ibody]
print @n.xbgr.xr80_u18.nr1[ibody]
print @n.xbgr.xr80_u19.nr1[ibody]
print @n.xbgr.xr80_u20.nr1[ibody]
print @n.xbgr.xr80_u21.nr1[ibody]
print @n.xbgr.xr80_u22.nr1[ibody]
print @n.xbgr.xr80_u23.nr1[ibody]
print @n.xbgr.xr80_u24.nr1[ibody]
print @n.xbgr.xr81_u2.nr1[ibody]
print @n.xbgr.xr81_u3.nr1[ibody]
print @n.xbgr.xr81_u4.nr1[ibody]
print @n.xbgr.xr81_u5.nr1[ibody]
print @n.xbgr.xr81_u6.nr1[ibody]
print @n.xbgr.xr81_u7.nr1[ibody]
print @n.xbgr.xr81_u8.nr1[ibody]
print @n.xbgr.xr81_u9.nr1[ibody]
print @n.xbgr.xr81_u10.nr1[ibody]
print @n.xbgr.xr81_u11.nr1[ibody]
print @n.xbgr.xr81_u12.nr1[ibody]
print @n.xbgr.xr81_u13.nr1[ibody]
print @n.xbgr.xr81_u14.nr1[ibody]
print @n.xbgr.xr81_u15.nr1[ibody]
print @n.xbgr.xr81_u16.nr1[ibody]
print @n.xbgr.xr81_u17.nr1[ibody]
print @n.xbgr.xr81_u18.nr1[ibody]
print @n.xbgr.xr81_u19.nr1[ibody]
print @n.xbgr.xr81_u20.nr1[ibody]
print @n.xbgr.xr81_u21.nr1[ibody]
print @n.xbgr.xr81_u22.nr1[ibody]
print @n.xbgr.xr81_u23.nr1[ibody]
print @n.xbgr.xr81_u24.nr1[ibody]
print @n.xbgr.xr82_u2.nr1[ibody]
print @n.xbgr.xr82_u3.nr1[ibody]
print @n.xbgr.xr82_u4.nr1[ibody]
print @n.xbgr.xr82_u5.nr1[ibody]
print @n.xbgr.xr82_u6.nr1[ibody]
print @n.xbgr.xr82_u7.nr1[ibody]
print @n.xbgr.xr82_u8.nr1[ibody]
print @n.xbgr.xr82_u9.nr1[ibody]
print @n.xbgr.xr82_u10.nr1[ibody]
print @n.xbgr.xr82_u11.nr1[ibody]
print @n.xbgr.xr82_u12.nr1[ibody]
print @n.xbgr.xr82_u13.nr1[ibody]
print @n.xbgr.xr82_u14.nr1[ibody]
print @n.xbgr.xr82_u15.nr1[ibody]
print @n.xbgr.xr82_u16.nr1[ibody]
print @n.xbgr.xr82_u17.nr1[ibody]
print @n.xbgr.xr82_u18.nr1[ibody]
print @n.xbgr.xr82_u19.nr1[ibody]
print @n.xbgr.xr82_u20.nr1[ibody]
print @n.xbgr.xr82_u21.nr1[ibody]
print @n.xbgr.xr82_u22.nr1[ibody]
print @n.xbgr.xr82_u23.nr1[ibody]
print @n.xbgr.xr82_u24.nr1[ibody]
print @n.xbgr.xr83_u2.nr1[ibody]
print @n.xbgr.xr83_u3.nr1[ibody]
print @n.xbgr.xr83_u4.nr1[ibody]
print @n.xbgr.xr83_u5.nr1[ibody]
print @n.xbgr.xr83_u6.nr1[ibody]
print @n.xbgr.xr83_u7.nr1[ibody]
print @n.xbgr.xr83_u8.nr1[ibody]
print @n.xbgr.xr83_u9.nr1[ibody]
print @n.xbgr.xr83_u10.nr1[ibody]
print @n.xbgr.xr83_u11.nr1[ibody]
print @n.xbgr.xr83_u12.nr1[ibody]
print @n.xbgr.xr83_u13.nr1[ibody]
print @n.xbgr.xr83_u14.nr1[ibody]
print @n.xbgr.xr83_u15.nr1[ibody]
print @n.xbgr.xr83_u16.nr1[ibody]
print @n.xbgr.xr83_u17.nr1[ibody]
print @n.xbgr.xr83_u18.nr1[ibody]
print @n.xbgr.xr83_u19.nr1[ibody]
print @n.xbgr.xr83_u20.nr1[ibody]
print @n.xbgr.xr83_u21.nr1[ibody]
print @n.xbgr.xr83_u22.nr1[ibody]
print @n.xbgr.xr83_u23.nr1[ibody]
print @n.xbgr.xr83_u24.nr1[ibody]
print @n.xbgr.xr84_u2.nr1[ibody]
print @n.xbgr.xr84_u3.nr1[ibody]
print @n.xbgr.xr84_u4.nr1[ibody]
print @n.xbgr.xr84_u5.nr1[ibody]
print @n.xbgr.xr84_u6.nr1[ibody]
print @n.xbgr.xr84_u7.nr1[ibody]
print @n.xbgr.xr84_u8.nr1[ibody]
print @n.xbgr.xr84_u9.nr1[ibody]
print @n.xbgr.xr84_u10.nr1[ibody]
print @n.xbgr.xr84_u11.nr1[ibody]
print @n.xbgr.xr84_u12.nr1[ibody]
print @n.xbgr.xr84_u13.nr1[ibody]
print @n.xbgr.xr84_u14.nr1[ibody]
print @n.xbgr.xr84_u15.nr1[ibody]
print @n.xbgr.xr84_u16.nr1[ibody]
print @n.xbgr.xr84_u17.nr1[ibody]
print @n.xbgr.xr84_u18.nr1[ibody]
print @n.xbgr.xr84_u19.nr1[ibody]
print @n.xbgr.xr84_u20.nr1[ibody]
print @n.xbgr.xr84_u21.nr1[ibody]
print @n.xbgr.xr84_u22.nr1[ibody]
print @n.xbgr.xr84_u23.nr1[ibody]
print @n.xbgr.xr84_u24.nr1[ibody]
print @n.xbgr.xr85_u2.nr1[ibody]
print @n.xbgr.xr85_u3.nr1[ibody]
print @n.xbgr.xr85_u4.nr1[ibody]
print @n.xbgr.xr85_u5.nr1[ibody]
print @n.xbgr.xr85_u6.nr1[ibody]
print @n.xbgr.xr85_u7.nr1[ibody]
print @n.xbgr.xr85_u8.nr1[ibody]
print @n.xbgr.xr85_u9.nr1[ibody]
print @n.xbgr.xr85_u10.nr1[ibody]
print @n.xbgr.xr85_u11.nr1[ibody]
print @n.xbgr.xr85_u12.nr1[ibody]
print @n.xbgr.xr85_u13.nr1[ibody]
print @n.xbgr.xr85_u14.nr1[ibody]
print @n.xbgr.xr85_u15.nr1[ibody]
print @n.xbgr.xr85_u16.nr1[ibody]
print @n.xbgr.xr85_u17.nr1[ibody]
print @n.xbgr.xr85_u18.nr1[ibody]
print @n.xbgr.xr85_u19.nr1[ibody]
print @n.xbgr.xr85_u20.nr1[ibody]
print @n.xbgr.xr85_u21.nr1[ibody]
print @n.xbgr.xr85_u22.nr1[ibody]
print @n.xbgr.xr85_u23.nr1[ibody]
print @n.xbgr.xr85_u24.nr1[ibody]
print @n.xbgr.xr86_u2.nr1[ibody]
print @n.xbgr.xr86_u3.nr1[ibody]
print @n.xbgr.xr86_u4.nr1[ibody]
print @n.xbgr.xr86_u5.nr1[ibody]
print @n.xbgr.xr86_u6.nr1[ibody]
print @n.xbgr.xr86_u7.nr1[ibody]
print @n.xbgr.xr86_u8.nr1[ibody]
print @n.xbgr.xr86_u9.nr1[ibody]
print @n.xbgr.xr86_u10.nr1[ibody]
print @n.xbgr.xr86_u11.nr1[ibody]
print @n.xbgr.xr86_u12.nr1[ibody]
print @n.xbgr.xr86_u13.nr1[ibody]
print @n.xbgr.xr86_u14.nr1[ibody]
print @n.xbgr.xr86_u15.nr1[ibody]
print @n.xbgr.xr86_u16.nr1[ibody]
print @n.xbgr.xr86_u17.nr1[ibody]
print @n.xbgr.xr86_u18.nr1[ibody]
print @n.xbgr.xr86_u19.nr1[ibody]
print @n.xbgr.xr86_u20.nr1[ibody]
print @n.xbgr.xr86_u21.nr1[ibody]
print @n.xbgr.xr86_u22.nr1[ibody]
print @n.xbgr.xr86_u23.nr1[ibody]
print @n.xbgr.xr86_u24.nr1[ibody]
echo RAW_CURRENT_LEDGER_END
wrdata op_nodes.dat v(xbgr.b1b) v(xbgr.c2) v(xbgr.d1) v(xbgr.d2) v(xbgr.d3) v(xbgr.d4) v(xbgr.d5) v(xbgr.det) v(dvbe) v(iptat) v(xbgr.kick) v(xbgr.n1) v(xbgr.n_10) v(xbgr.n_11) v(xbgr.n_12) v(xbgr.n_13) v(xbgr.n_14) v(xbgr.n_15) v(xbgr.n_16) v(xbgr.n_17) v(xbgr.n_18) v(xbgr.n_19) v(xbgr.n_2) v(xbgr.n_21) v(xbgr.n_22) v(xbgr.n_23) v(xbgr.n_24) v(xbgr.n_25) v(xbgr.n_26) v(xbgr.n_27) v(xbgr.n_3) v(xbgr.n_30) v(xbgr.n_31) v(xbgr.n_33) v(xbgr.n_34) v(xbgr.n_36) v(xbgr.n_37) v(xbgr.n_4) v(xbgr.n_5) v(xbgr.n_6) v(xbgr.n_7) v(xbgr.n_8) v(xbgr.n_9) v(pbias) v(pcasc) v(r4) v(xbgr.r4n) v(xbgr.vb2) v(vbe) v(xbgr.vbe3) v(xbgr.vd1) v(xbgr.vd2) v(vdd) v(vref) v(vdd)-v(vdd) i(vdd) i(vload) i(vr4) i(vsub)
print @n.xbgr.xr1.nr1[nsmm_rsh]
print @n.xbgr.xr1.nr1[nsmm_w]
print @n.xbgr.xr1.nr1[nsmm_l]
print @n.xbgr.xr2.nr1[nsmm_rsh]
print @n.xbgr.xr2.nr1[nsmm_w]
print @n.xbgr.xr2.nr1[nsmm_l]
print @n.xbgr.xr3.nr1[nsmm_rsh]
print @n.xbgr.xr3.nr1[nsmm_w]
print @n.xbgr.xr3.nr1[nsmm_l]
print @n.xbgr.xr4.nr1[nsmm_rsh]
print @n.xbgr.xr4.nr1[nsmm_w]
print @n.xbgr.xr4.nr1[nsmm_l]
print @n.xbgr.xr5.nr1[nsmm_rsh]
print @n.xbgr.xr5.nr1[nsmm_w]
print @n.xbgr.xr5.nr1[nsmm_l]
print @n.xbgr.xr6.nr1[nsmm_rsh]
print @n.xbgr.xr6.nr1[nsmm_w]
print @n.xbgr.xr6.nr1[nsmm_l]
print @n.xbgr.xr7.nr1[nsmm_rsh]
print @n.xbgr.xr7.nr1[nsmm_w]
print @n.xbgr.xr7.nr1[nsmm_l]
print @n.xbgr.xr8.nr1[nsmm_rsh]
print @n.xbgr.xr8.nr1[nsmm_w]
print @n.xbgr.xr8.nr1[nsmm_l]
print @n.xbgr.xr9.nr1[nsmm_rsh]
print @n.xbgr.xr9.nr1[nsmm_w]
print @n.xbgr.xr9.nr1[nsmm_l]
print @n.xbgr.xr10.nr1[nsmm_rsh]
print @n.xbgr.xr10.nr1[nsmm_w]
print @n.xbgr.xr10.nr1[nsmm_l]
print @n.xbgr.xr11.nr1[nsmm_rsh]
print @n.xbgr.xr11.nr1[nsmm_w]
print @n.xbgr.xr11.nr1[nsmm_l]
print @n.xbgr.xr12.nr1[nsmm_rsh]
print @n.xbgr.xr12.nr1[nsmm_w]
print @n.xbgr.xr12.nr1[nsmm_l]
print @n.xbgr.xr13.nr1[nsmm_rsh]
print @n.xbgr.xr13.nr1[nsmm_w]
print @n.xbgr.xr13.nr1[nsmm_l]
print @n.xbgr.xr14.nr1[nsmm_rsh]
print @n.xbgr.xr14.nr1[nsmm_w]
print @n.xbgr.xr14.nr1[nsmm_l]
print @n.xbgr.xr15.nr1[nsmm_rsh]
print @n.xbgr.xr15.nr1[nsmm_w]
print @n.xbgr.xr15.nr1[nsmm_l]
print @n.xbgr.xr16.nr1[nsmm_rsh]
print @n.xbgr.xr16.nr1[nsmm_w]
print @n.xbgr.xr16.nr1[nsmm_l]
print @n.xbgr.xr17.nr1[nsmm_rsh]
print @n.xbgr.xr17.nr1[nsmm_w]
print @n.xbgr.xr17.nr1[nsmm_l]
print @n.xbgr.xr18.nr1[nsmm_rsh]
print @n.xbgr.xr18.nr1[nsmm_w]
print @n.xbgr.xr18.nr1[nsmm_l]
print @n.xbgr.xr19.nr1[nsmm_rsh]
print @n.xbgr.xr19.nr1[nsmm_w]
print @n.xbgr.xr19.nr1[nsmm_l]
print @n.xbgr.xr20.nr1[nsmm_rsh]
print @n.xbgr.xr20.nr1[nsmm_w]
print @n.xbgr.xr20.nr1[nsmm_l]
print @n.xbgr.xr21.nr1[nsmm_rsh]
print @n.xbgr.xr21.nr1[nsmm_w]
print @n.xbgr.xr21.nr1[nsmm_l]
print @n.xbgr.xr22.nr1[nsmm_rsh]
print @n.xbgr.xr22.nr1[nsmm_w]
print @n.xbgr.xr22.nr1[nsmm_l]
print @n.xbgr.xr23.nr1[nsmm_rsh]
print @n.xbgr.xr23.nr1[nsmm_w]
print @n.xbgr.xr23.nr1[nsmm_l]
print @n.xbgr.xr24.nr1[nsmm_rsh]
print @n.xbgr.xr24.nr1[nsmm_w]
print @n.xbgr.xr24.nr1[nsmm_l]
print @n.xbgr.xr25.nr1[nsmm_rsh]
print @n.xbgr.xr25.nr1[nsmm_w]
print @n.xbgr.xr25.nr1[nsmm_l]
print @n.xbgr.xr26.nr1[nsmm_rsh]
print @n.xbgr.xr26.nr1[nsmm_w]
print @n.xbgr.xr26.nr1[nsmm_l]
print @n.xbgr.xm27.nsg13_hv_pmos[w]
print @n.xbgr.xm27.nsg13_hv_pmos[l]
print @n.xbgr.xm27.nsg13_hv_pmos[delvto]
print @n.xbgr.xm27.nsg13_hv_pmos[factuo]
print @n.xbgr.xm28.nsg13_hv_pmos[w]
print @n.xbgr.xm28.nsg13_hv_pmos[l]
print @n.xbgr.xm28.nsg13_hv_pmos[delvto]
print @n.xbgr.xm28.nsg13_hv_pmos[factuo]
print @n.xbgr.xm29.nsg13_hv_nmos[w]
print @n.xbgr.xm29.nsg13_hv_nmos[l]
print @n.xbgr.xm29.nsg13_hv_nmos[delvto]
print @n.xbgr.xm29.nsg13_hv_nmos[factuo]
print @n.xbgr.xm30.nsg13_hv_nmos[w]
print @n.xbgr.xm30.nsg13_hv_nmos[l]
print @n.xbgr.xm30.nsg13_hv_nmos[delvto]
print @n.xbgr.xm30.nsg13_hv_nmos[factuo]
print @n.xbgr.xm31.nsg13_hv_nmos[w]
print @n.xbgr.xm31.nsg13_hv_nmos[l]
print @n.xbgr.xm31.nsg13_hv_nmos[delvto]
print @n.xbgr.xm31.nsg13_hv_nmos[factuo]
print @n.xbgr.xm32.nsg13_hv_nmos[w]
print @n.xbgr.xm32.nsg13_hv_nmos[l]
print @n.xbgr.xm32.nsg13_hv_nmos[delvto]
print @n.xbgr.xm32.nsg13_hv_nmos[factuo]
print @n.xbgr.xm33.nsg13_hv_nmos[w]
print @n.xbgr.xm33.nsg13_hv_nmos[l]
print @n.xbgr.xm33.nsg13_hv_nmos[delvto]
print @n.xbgr.xm33.nsg13_hv_nmos[factuo]
print @n.xbgr.xm34.nsg13_hv_nmos[w]
print @n.xbgr.xm34.nsg13_hv_nmos[l]
print @n.xbgr.xm34.nsg13_hv_nmos[delvto]
print @n.xbgr.xm34.nsg13_hv_nmos[factuo]
print @n.xbgr.xm35.nsg13_hv_nmos[w]
print @n.xbgr.xm35.nsg13_hv_nmos[l]
print @n.xbgr.xm35.nsg13_hv_nmos[delvto]
print @n.xbgr.xm35.nsg13_hv_nmos[factuo]
print @n.xbgr.xm36.nsg13_hv_nmos[w]
print @n.xbgr.xm36.nsg13_hv_nmos[l]
print @n.xbgr.xm36.nsg13_hv_nmos[delvto]
print @n.xbgr.xm36.nsg13_hv_nmos[factuo]
print @n.xbgr.xm37.nsg13_hv_nmos[w]
print @n.xbgr.xm37.nsg13_hv_nmos[l]
print @n.xbgr.xm37.nsg13_hv_nmos[delvto]
print @n.xbgr.xm37.nsg13_hv_nmos[factuo]
print @n.xbgr.xm38.nsg13_hv_pmos[w]
print @n.xbgr.xm38.nsg13_hv_pmos[l]
print @n.xbgr.xm38.nsg13_hv_pmos[delvto]
print @n.xbgr.xm38.nsg13_hv_pmos[factuo]
print @n.xbgr.xm39.nsg13_hv_pmos[w]
print @n.xbgr.xm39.nsg13_hv_pmos[l]
print @n.xbgr.xm39.nsg13_hv_pmos[delvto]
print @n.xbgr.xm39.nsg13_hv_pmos[factuo]
print @n.xbgr.xm40.nsg13_hv_pmos[w]
print @n.xbgr.xm40.nsg13_hv_pmos[l]
print @n.xbgr.xm40.nsg13_hv_pmos[delvto]
print @n.xbgr.xm40.nsg13_hv_pmos[factuo]
print @n.xbgr.xm41.nsg13_hv_pmos[w]
print @n.xbgr.xm41.nsg13_hv_pmos[l]
print @n.xbgr.xm41.nsg13_hv_pmos[delvto]
print @n.xbgr.xm41.nsg13_hv_pmos[factuo]
print @n.xbgr.xm42.nsg13_hv_pmos[w]
print @n.xbgr.xm42.nsg13_hv_pmos[l]
print @n.xbgr.xm42.nsg13_hv_pmos[delvto]
print @n.xbgr.xm42.nsg13_hv_pmos[factuo]
print @n.xbgr.xm43.nsg13_hv_pmos[w]
print @n.xbgr.xm43.nsg13_hv_pmos[l]
print @n.xbgr.xm43.nsg13_hv_pmos[delvto]
print @n.xbgr.xm43.nsg13_hv_pmos[factuo]
print @n.xbgr.xm44.nsg13_hv_pmos[w]
print @n.xbgr.xm44.nsg13_hv_pmos[l]
print @n.xbgr.xm44.nsg13_hv_pmos[delvto]
print @n.xbgr.xm44.nsg13_hv_pmos[factuo]
print @n.xbgr.xm45.nsg13_hv_pmos[w]
print @n.xbgr.xm45.nsg13_hv_pmos[l]
print @n.xbgr.xm45.nsg13_hv_pmos[delvto]
print @n.xbgr.xm45.nsg13_hv_pmos[factuo]
print @n.xbgr.xm46.nsg13_hv_pmos[w]
print @n.xbgr.xm46.nsg13_hv_pmos[l]
print @n.xbgr.xm46.nsg13_hv_pmos[delvto]
print @n.xbgr.xm46.nsg13_hv_pmos[factuo]
print @n.xbgr.xm47.nsg13_hv_pmos[w]
print @n.xbgr.xm47.nsg13_hv_pmos[l]
print @n.xbgr.xm47.nsg13_hv_pmos[delvto]
print @n.xbgr.xm47.nsg13_hv_pmos[factuo]
print @n.xbgr.xm48.nsg13_hv_pmos[w]
print @n.xbgr.xm48.nsg13_hv_pmos[l]
print @n.xbgr.xm48.nsg13_hv_pmos[delvto]
print @n.xbgr.xm48.nsg13_hv_pmos[factuo]
print @n.xbgr.xm49.nsg13_hv_pmos[w]
print @n.xbgr.xm49.nsg13_hv_pmos[l]
print @n.xbgr.xm49.nsg13_hv_pmos[delvto]
print @n.xbgr.xm49.nsg13_hv_pmos[factuo]
print @n.xbgr.xm50.nsg13_hv_pmos[w]
print @n.xbgr.xm50.nsg13_hv_pmos[l]
print @n.xbgr.xm50.nsg13_hv_pmos[delvto]
print @n.xbgr.xm50.nsg13_hv_pmos[factuo]
print @n.xbgr.xm51.nsg13_hv_pmos[w]
print @n.xbgr.xm51.nsg13_hv_pmos[l]
print @n.xbgr.xm51.nsg13_hv_pmos[delvto]
print @n.xbgr.xm51.nsg13_hv_pmos[factuo]
print @n.xbgr.xm52.nsg13_hv_pmos[w]
print @n.xbgr.xm52.nsg13_hv_pmos[l]
print @n.xbgr.xm52.nsg13_hv_pmos[delvto]
print @n.xbgr.xm52.nsg13_hv_pmos[factuo]
print @n.xbgr.xm53.nsg13_hv_pmos[w]
print @n.xbgr.xm53.nsg13_hv_pmos[l]
print @n.xbgr.xm53.nsg13_hv_pmos[delvto]
print @n.xbgr.xm53.nsg13_hv_pmos[factuo]
print @n.xbgr.xm54.nsg13_hv_pmos[w]
print @n.xbgr.xm54.nsg13_hv_pmos[l]
print @n.xbgr.xm54.nsg13_hv_pmos[delvto]
print @n.xbgr.xm54.nsg13_hv_pmos[factuo]
print @q.xbgr.xq55.qnpn13g2[area]
print @q.xbgr.xq56.qnpn13g2[area]
print @q.xbgr.xq57.qnpn13g2[area]
print @q.xbgr.xq58.qnpn13g2[area]
print @q.xbgr.xq59.qnpn13g2[area]
print @q.xbgr.xq60.qnpn13g2[area]
print @q.xbgr.xq61.qnpn13g2[area]
print @q.xbgr.xq62.qnpn13g2[area]
print @q.xbgr.xq63.qnpn13g2[area]
print @q.xbgr.xq64.qnpn13g2[area]
print @q.xbgr.xq65.qnpn13g2[area]
print @q.xbgr.xq66.qnpn13g2[area]
print @q.xbgr.xq67.qnpn13g2[area]
print @q.xbgr.xq68.qnpn13g2[area]
print @q.xbgr.xq69.qnpn13g2[area]
print @q.xbgr.xq70.qnpn13g2[area]
print @q.xbgr.xq71.qnpn13g2[area]
print @q.xbgr.xq72.qnpn13g2[area]
print @q.xbgr.xq73.qnpn13g2[area]
print @q.xbgr.xq74.qnpn13g2[area]
print @q.xbgr.xq75.qnpn13g2[area]
print @q.xbgr.xq76.qnpn13g2[area]
print @n.xbgr.xr77.nr1[nsmm_rsh]
print @n.xbgr.xr77.nr1[nsmm_w]
print @n.xbgr.xr77.nr1[nsmm_l]
print @n.xbgr.xr78.nr1[nsmm_rsh]
print @n.xbgr.xr78.nr1[nsmm_w]
print @n.xbgr.xr78.nr1[nsmm_l]
print @n.xbgr.xr79.nr1[nsmm_rsh]
print @n.xbgr.xr79.nr1[nsmm_w]
print @n.xbgr.xr79.nr1[nsmm_l]
print @n.xbgr.xr80.nr1[nsmm_rsh]
print @n.xbgr.xr80.nr1[nsmm_w]
print @n.xbgr.xr80.nr1[nsmm_l]
print @n.xbgr.xr81.nr1[nsmm_rsh]
print @n.xbgr.xr81.nr1[nsmm_w]
print @n.xbgr.xr81.nr1[nsmm_l]
print @n.xbgr.xr82.nr1[nsmm_rsh]
print @n.xbgr.xr82.nr1[nsmm_w]
print @n.xbgr.xr82.nr1[nsmm_l]
print @n.xbgr.xr83.nr1[nsmm_rsh]
print @n.xbgr.xr83.nr1[nsmm_w]
print @n.xbgr.xr83.nr1[nsmm_l]
print @n.xbgr.xr84.nr1[nsmm_rsh]
print @n.xbgr.xr84.nr1[nsmm_w]
print @n.xbgr.xr84.nr1[nsmm_l]
print @n.xbgr.xr85.nr1[nsmm_rsh]
print @n.xbgr.xr85.nr1[nsmm_w]
print @n.xbgr.xr85.nr1[nsmm_l]
print @n.xbgr.xr86.nr1[nsmm_rsh]
print @n.xbgr.xr86.nr1[nsmm_w]
print @n.xbgr.xr86.nr1[nsmm_l]
print @n.xbgr.xr16_u2.nr1[nsmm_rsh]
print @n.xbgr.xr16_u2.nr1[nsmm_w]
print @n.xbgr.xr16_u2.nr1[nsmm_l]
print @n.xbgr.xr16_u3.nr1[nsmm_rsh]
print @n.xbgr.xr16_u3.nr1[nsmm_w]
print @n.xbgr.xr16_u3.nr1[nsmm_l]
print @n.xbgr.xr16_u4.nr1[nsmm_rsh]
print @n.xbgr.xr16_u4.nr1[nsmm_w]
print @n.xbgr.xr16_u4.nr1[nsmm_l]
print @n.xbgr.xr16_u5.nr1[nsmm_rsh]
print @n.xbgr.xr16_u5.nr1[nsmm_w]
print @n.xbgr.xr16_u5.nr1[nsmm_l]
print @n.xbgr.xr16_u6.nr1[nsmm_rsh]
print @n.xbgr.xr16_u6.nr1[nsmm_w]
print @n.xbgr.xr16_u6.nr1[nsmm_l]
print @n.xbgr.xr16_u7.nr1[nsmm_rsh]
print @n.xbgr.xr16_u7.nr1[nsmm_w]
print @n.xbgr.xr16_u7.nr1[nsmm_l]
print @n.xbgr.xr16_u8.nr1[nsmm_rsh]
print @n.xbgr.xr16_u8.nr1[nsmm_w]
print @n.xbgr.xr16_u8.nr1[nsmm_l]
print @n.xbgr.xr16_u9.nr1[nsmm_rsh]
print @n.xbgr.xr16_u9.nr1[nsmm_w]
print @n.xbgr.xr16_u9.nr1[nsmm_l]
print @n.xbgr.xr16_u10.nr1[nsmm_rsh]
print @n.xbgr.xr16_u10.nr1[nsmm_w]
print @n.xbgr.xr16_u10.nr1[nsmm_l]
print @n.xbgr.xr16_u11.nr1[nsmm_rsh]
print @n.xbgr.xr16_u11.nr1[nsmm_w]
print @n.xbgr.xr16_u11.nr1[nsmm_l]
print @n.xbgr.xr16_u12.nr1[nsmm_rsh]
print @n.xbgr.xr16_u12.nr1[nsmm_w]
print @n.xbgr.xr16_u12.nr1[nsmm_l]
print @n.xbgr.xr16_u13.nr1[nsmm_rsh]
print @n.xbgr.xr16_u13.nr1[nsmm_w]
print @n.xbgr.xr16_u13.nr1[nsmm_l]
print @n.xbgr.xr16_u14.nr1[nsmm_rsh]
print @n.xbgr.xr16_u14.nr1[nsmm_w]
print @n.xbgr.xr16_u14.nr1[nsmm_l]
print @n.xbgr.xr16_u15.nr1[nsmm_rsh]
print @n.xbgr.xr16_u15.nr1[nsmm_w]
print @n.xbgr.xr16_u15.nr1[nsmm_l]
print @n.xbgr.xr16_u16.nr1[nsmm_rsh]
print @n.xbgr.xr16_u16.nr1[nsmm_w]
print @n.xbgr.xr16_u16.nr1[nsmm_l]
print @n.xbgr.xr16_u17.nr1[nsmm_rsh]
print @n.xbgr.xr16_u17.nr1[nsmm_w]
print @n.xbgr.xr16_u17.nr1[nsmm_l]
print @n.xbgr.xr16_u18.nr1[nsmm_rsh]
print @n.xbgr.xr16_u18.nr1[nsmm_w]
print @n.xbgr.xr16_u18.nr1[nsmm_l]
print @n.xbgr.xr16_u19.nr1[nsmm_rsh]
print @n.xbgr.xr16_u19.nr1[nsmm_w]
print @n.xbgr.xr16_u19.nr1[nsmm_l]
print @n.xbgr.xr16_u20.nr1[nsmm_rsh]
print @n.xbgr.xr16_u20.nr1[nsmm_w]
print @n.xbgr.xr16_u20.nr1[nsmm_l]
print @n.xbgr.xr16_u21.nr1[nsmm_rsh]
print @n.xbgr.xr16_u21.nr1[nsmm_w]
print @n.xbgr.xr16_u21.nr1[nsmm_l]
print @n.xbgr.xr16_u22.nr1[nsmm_rsh]
print @n.xbgr.xr16_u22.nr1[nsmm_w]
print @n.xbgr.xr16_u22.nr1[nsmm_l]
print @n.xbgr.xr16_u23.nr1[nsmm_rsh]
print @n.xbgr.xr16_u23.nr1[nsmm_w]
print @n.xbgr.xr16_u23.nr1[nsmm_l]
print @n.xbgr.xr16_u24.nr1[nsmm_rsh]
print @n.xbgr.xr16_u24.nr1[nsmm_w]
print @n.xbgr.xr16_u24.nr1[nsmm_l]
print @n.xbgr.xr17_u2.nr1[nsmm_rsh]
print @n.xbgr.xr17_u2.nr1[nsmm_w]
print @n.xbgr.xr17_u2.nr1[nsmm_l]
print @n.xbgr.xr17_u3.nr1[nsmm_rsh]
print @n.xbgr.xr17_u3.nr1[nsmm_w]
print @n.xbgr.xr17_u3.nr1[nsmm_l]
print @n.xbgr.xr17_u4.nr1[nsmm_rsh]
print @n.xbgr.xr17_u4.nr1[nsmm_w]
print @n.xbgr.xr17_u4.nr1[nsmm_l]
print @n.xbgr.xr18_u2.nr1[nsmm_rsh]
print @n.xbgr.xr18_u2.nr1[nsmm_w]
print @n.xbgr.xr18_u2.nr1[nsmm_l]
print @n.xbgr.xr18_u3.nr1[nsmm_rsh]
print @n.xbgr.xr18_u3.nr1[nsmm_w]
print @n.xbgr.xr18_u3.nr1[nsmm_l]
print @n.xbgr.xr18_u4.nr1[nsmm_rsh]
print @n.xbgr.xr18_u4.nr1[nsmm_w]
print @n.xbgr.xr18_u4.nr1[nsmm_l]
print @n.xbgr.xr19_u2.nr1[nsmm_rsh]
print @n.xbgr.xr19_u2.nr1[nsmm_w]
print @n.xbgr.xr19_u2.nr1[nsmm_l]
print @n.xbgr.xr19_u3.nr1[nsmm_rsh]
print @n.xbgr.xr19_u3.nr1[nsmm_w]
print @n.xbgr.xr19_u3.nr1[nsmm_l]
print @n.xbgr.xr19_u4.nr1[nsmm_rsh]
print @n.xbgr.xr19_u4.nr1[nsmm_w]
print @n.xbgr.xr19_u4.nr1[nsmm_l]
print @n.xbgr.xr20_u2.nr1[nsmm_rsh]
print @n.xbgr.xr20_u2.nr1[nsmm_w]
print @n.xbgr.xr20_u2.nr1[nsmm_l]
print @n.xbgr.xr20_u3.nr1[nsmm_rsh]
print @n.xbgr.xr20_u3.nr1[nsmm_w]
print @n.xbgr.xr20_u3.nr1[nsmm_l]
print @n.xbgr.xr20_u4.nr1[nsmm_rsh]
print @n.xbgr.xr20_u4.nr1[nsmm_w]
print @n.xbgr.xr20_u4.nr1[nsmm_l]
print @n.xbgr.xr21_u2.nr1[nsmm_rsh]
print @n.xbgr.xr21_u2.nr1[nsmm_w]
print @n.xbgr.xr21_u2.nr1[nsmm_l]
print @n.xbgr.xr21_u3.nr1[nsmm_rsh]
print @n.xbgr.xr21_u3.nr1[nsmm_w]
print @n.xbgr.xr21_u3.nr1[nsmm_l]
print @n.xbgr.xr21_u4.nr1[nsmm_rsh]
print @n.xbgr.xr21_u4.nr1[nsmm_w]
print @n.xbgr.xr21_u4.nr1[nsmm_l]
print @n.xbgr.xr22_u2.nr1[nsmm_rsh]
print @n.xbgr.xr22_u2.nr1[nsmm_w]
print @n.xbgr.xr22_u2.nr1[nsmm_l]
print @n.xbgr.xr22_u3.nr1[nsmm_rsh]
print @n.xbgr.xr22_u3.nr1[nsmm_w]
print @n.xbgr.xr22_u3.nr1[nsmm_l]
print @n.xbgr.xr22_u4.nr1[nsmm_rsh]
print @n.xbgr.xr22_u4.nr1[nsmm_w]
print @n.xbgr.xr22_u4.nr1[nsmm_l]
print @n.xbgr.xr23_u2.nr1[nsmm_rsh]
print @n.xbgr.xr23_u2.nr1[nsmm_w]
print @n.xbgr.xr23_u2.nr1[nsmm_l]
print @n.xbgr.xr23_u3.nr1[nsmm_rsh]
print @n.xbgr.xr23_u3.nr1[nsmm_w]
print @n.xbgr.xr23_u3.nr1[nsmm_l]
print @n.xbgr.xr23_u4.nr1[nsmm_rsh]
print @n.xbgr.xr23_u4.nr1[nsmm_w]
print @n.xbgr.xr23_u4.nr1[nsmm_l]
print @n.xbgr.xr23_u5.nr1[nsmm_rsh]
print @n.xbgr.xr23_u5.nr1[nsmm_w]
print @n.xbgr.xr23_u5.nr1[nsmm_l]
print @n.xbgr.xr23_u6.nr1[nsmm_rsh]
print @n.xbgr.xr23_u6.nr1[nsmm_w]
print @n.xbgr.xr23_u6.nr1[nsmm_l]
print @n.xbgr.xr23_u7.nr1[nsmm_rsh]
print @n.xbgr.xr23_u7.nr1[nsmm_w]
print @n.xbgr.xr23_u7.nr1[nsmm_l]
print @n.xbgr.xr23_u8.nr1[nsmm_rsh]
print @n.xbgr.xr23_u8.nr1[nsmm_w]
print @n.xbgr.xr23_u8.nr1[nsmm_l]
print @n.xbgr.xr23_u9.nr1[nsmm_rsh]
print @n.xbgr.xr23_u9.nr1[nsmm_w]
print @n.xbgr.xr23_u9.nr1[nsmm_l]
print @n.xbgr.xr23_u10.nr1[nsmm_rsh]
print @n.xbgr.xr23_u10.nr1[nsmm_w]
print @n.xbgr.xr23_u10.nr1[nsmm_l]
print @n.xbgr.xr23_u11.nr1[nsmm_rsh]
print @n.xbgr.xr23_u11.nr1[nsmm_w]
print @n.xbgr.xr23_u11.nr1[nsmm_l]
print @n.xbgr.xr23_u12.nr1[nsmm_rsh]
print @n.xbgr.xr23_u12.nr1[nsmm_w]
print @n.xbgr.xr23_u12.nr1[nsmm_l]
print @n.xbgr.xr23_u13.nr1[nsmm_rsh]
print @n.xbgr.xr23_u13.nr1[nsmm_w]
print @n.xbgr.xr23_u13.nr1[nsmm_l]
print @n.xbgr.xr23_u14.nr1[nsmm_rsh]
print @n.xbgr.xr23_u14.nr1[nsmm_w]
print @n.xbgr.xr23_u14.nr1[nsmm_l]
print @n.xbgr.xr23_u15.nr1[nsmm_rsh]
print @n.xbgr.xr23_u15.nr1[nsmm_w]
print @n.xbgr.xr23_u15.nr1[nsmm_l]
print @n.xbgr.xr23_u16.nr1[nsmm_rsh]
print @n.xbgr.xr23_u16.nr1[nsmm_w]
print @n.xbgr.xr23_u16.nr1[nsmm_l]
print @n.xbgr.xr23_u17.nr1[nsmm_rsh]
print @n.xbgr.xr23_u17.nr1[nsmm_w]
print @n.xbgr.xr23_u17.nr1[nsmm_l]
print @n.xbgr.xr23_u18.nr1[nsmm_rsh]
print @n.xbgr.xr23_u18.nr1[nsmm_w]
print @n.xbgr.xr23_u18.nr1[nsmm_l]
print @n.xbgr.xr23_u19.nr1[nsmm_rsh]
print @n.xbgr.xr23_u19.nr1[nsmm_w]
print @n.xbgr.xr23_u19.nr1[nsmm_l]
print @n.xbgr.xr23_u20.nr1[nsmm_rsh]
print @n.xbgr.xr23_u20.nr1[nsmm_w]
print @n.xbgr.xr23_u20.nr1[nsmm_l]
print @n.xbgr.xr23_u21.nr1[nsmm_rsh]
print @n.xbgr.xr23_u21.nr1[nsmm_w]
print @n.xbgr.xr23_u21.nr1[nsmm_l]
print @n.xbgr.xr23_u22.nr1[nsmm_rsh]
print @n.xbgr.xr23_u22.nr1[nsmm_w]
print @n.xbgr.xr23_u22.nr1[nsmm_l]
print @n.xbgr.xr23_u23.nr1[nsmm_rsh]
print @n.xbgr.xr23_u23.nr1[nsmm_w]
print @n.xbgr.xr23_u23.nr1[nsmm_l]
print @n.xbgr.xr23_u24.nr1[nsmm_rsh]
print @n.xbgr.xr23_u24.nr1[nsmm_w]
print @n.xbgr.xr23_u24.nr1[nsmm_l]
print @n.xbgr.xr24_u2.nr1[nsmm_rsh]
print @n.xbgr.xr24_u2.nr1[nsmm_w]
print @n.xbgr.xr24_u2.nr1[nsmm_l]
print @n.xbgr.xr24_u3.nr1[nsmm_rsh]
print @n.xbgr.xr24_u3.nr1[nsmm_w]
print @n.xbgr.xr24_u3.nr1[nsmm_l]
print @n.xbgr.xr24_u4.nr1[nsmm_rsh]
print @n.xbgr.xr24_u4.nr1[nsmm_w]
print @n.xbgr.xr24_u4.nr1[nsmm_l]
print @n.xbgr.xr24_u5.nr1[nsmm_rsh]
print @n.xbgr.xr24_u5.nr1[nsmm_w]
print @n.xbgr.xr24_u5.nr1[nsmm_l]
print @n.xbgr.xr24_u6.nr1[nsmm_rsh]
print @n.xbgr.xr24_u6.nr1[nsmm_w]
print @n.xbgr.xr24_u6.nr1[nsmm_l]
print @n.xbgr.xr24_u7.nr1[nsmm_rsh]
print @n.xbgr.xr24_u7.nr1[nsmm_w]
print @n.xbgr.xr24_u7.nr1[nsmm_l]
print @n.xbgr.xr24_u8.nr1[nsmm_rsh]
print @n.xbgr.xr24_u8.nr1[nsmm_w]
print @n.xbgr.xr24_u8.nr1[nsmm_l]
print @n.xbgr.xr24_u9.nr1[nsmm_rsh]
print @n.xbgr.xr24_u9.nr1[nsmm_w]
print @n.xbgr.xr24_u9.nr1[nsmm_l]
print @n.xbgr.xr24_u10.nr1[nsmm_rsh]
print @n.xbgr.xr24_u10.nr1[nsmm_w]
print @n.xbgr.xr24_u10.nr1[nsmm_l]
print @n.xbgr.xr24_u11.nr1[nsmm_rsh]
print @n.xbgr.xr24_u11.nr1[nsmm_w]
print @n.xbgr.xr24_u11.nr1[nsmm_l]
print @n.xbgr.xr24_u12.nr1[nsmm_rsh]
print @n.xbgr.xr24_u12.nr1[nsmm_w]
print @n.xbgr.xr24_u12.nr1[nsmm_l]
print @n.xbgr.xr24_u13.nr1[nsmm_rsh]
print @n.xbgr.xr24_u13.nr1[nsmm_w]
print @n.xbgr.xr24_u13.nr1[nsmm_l]
print @n.xbgr.xr24_u14.nr1[nsmm_rsh]
print @n.xbgr.xr24_u14.nr1[nsmm_w]
print @n.xbgr.xr24_u14.nr1[nsmm_l]
print @n.xbgr.xr24_u15.nr1[nsmm_rsh]
print @n.xbgr.xr24_u15.nr1[nsmm_w]
print @n.xbgr.xr24_u15.nr1[nsmm_l]
print @n.xbgr.xr24_u16.nr1[nsmm_rsh]
print @n.xbgr.xr24_u16.nr1[nsmm_w]
print @n.xbgr.xr24_u16.nr1[nsmm_l]
print @n.xbgr.xr24_u17.nr1[nsmm_rsh]
print @n.xbgr.xr24_u17.nr1[nsmm_w]
print @n.xbgr.xr24_u17.nr1[nsmm_l]
print @n.xbgr.xr24_u18.nr1[nsmm_rsh]
print @n.xbgr.xr24_u18.nr1[nsmm_w]
print @n.xbgr.xr24_u18.nr1[nsmm_l]
print @n.xbgr.xr24_u19.nr1[nsmm_rsh]
print @n.xbgr.xr24_u19.nr1[nsmm_w]
print @n.xbgr.xr24_u19.nr1[nsmm_l]
print @n.xbgr.xr24_u20.nr1[nsmm_rsh]
print @n.xbgr.xr24_u20.nr1[nsmm_w]
print @n.xbgr.xr24_u20.nr1[nsmm_l]
print @n.xbgr.xr24_u21.nr1[nsmm_rsh]
print @n.xbgr.xr24_u21.nr1[nsmm_w]
print @n.xbgr.xr24_u21.nr1[nsmm_l]
print @n.xbgr.xr24_u22.nr1[nsmm_rsh]
print @n.xbgr.xr24_u22.nr1[nsmm_w]
print @n.xbgr.xr24_u22.nr1[nsmm_l]
print @n.xbgr.xr24_u23.nr1[nsmm_rsh]
print @n.xbgr.xr24_u23.nr1[nsmm_w]
print @n.xbgr.xr24_u23.nr1[nsmm_l]
print @n.xbgr.xr24_u24.nr1[nsmm_rsh]
print @n.xbgr.xr24_u24.nr1[nsmm_w]
print @n.xbgr.xr24_u24.nr1[nsmm_l]
print @n.xbgr.xr25_u2.nr1[nsmm_rsh]
print @n.xbgr.xr25_u2.nr1[nsmm_w]
print @n.xbgr.xr25_u2.nr1[nsmm_l]
print @n.xbgr.xr25_u3.nr1[nsmm_rsh]
print @n.xbgr.xr25_u3.nr1[nsmm_w]
print @n.xbgr.xr25_u3.nr1[nsmm_l]
print @n.xbgr.xr25_u4.nr1[nsmm_rsh]
print @n.xbgr.xr25_u4.nr1[nsmm_w]
print @n.xbgr.xr25_u4.nr1[nsmm_l]
print @n.xbgr.xr25_u5.nr1[nsmm_rsh]
print @n.xbgr.xr25_u5.nr1[nsmm_w]
print @n.xbgr.xr25_u5.nr1[nsmm_l]
print @n.xbgr.xr25_u6.nr1[nsmm_rsh]
print @n.xbgr.xr25_u6.nr1[nsmm_w]
print @n.xbgr.xr25_u6.nr1[nsmm_l]
print @n.xbgr.xr25_u7.nr1[nsmm_rsh]
print @n.xbgr.xr25_u7.nr1[nsmm_w]
print @n.xbgr.xr25_u7.nr1[nsmm_l]
print @n.xbgr.xr25_u8.nr1[nsmm_rsh]
print @n.xbgr.xr25_u8.nr1[nsmm_w]
print @n.xbgr.xr25_u8.nr1[nsmm_l]
print @n.xbgr.xr25_u9.nr1[nsmm_rsh]
print @n.xbgr.xr25_u9.nr1[nsmm_w]
print @n.xbgr.xr25_u9.nr1[nsmm_l]
print @n.xbgr.xr25_u10.nr1[nsmm_rsh]
print @n.xbgr.xr25_u10.nr1[nsmm_w]
print @n.xbgr.xr25_u10.nr1[nsmm_l]
print @n.xbgr.xr25_u11.nr1[nsmm_rsh]
print @n.xbgr.xr25_u11.nr1[nsmm_w]
print @n.xbgr.xr25_u11.nr1[nsmm_l]
print @n.xbgr.xr25_u12.nr1[nsmm_rsh]
print @n.xbgr.xr25_u12.nr1[nsmm_w]
print @n.xbgr.xr25_u12.nr1[nsmm_l]
print @n.xbgr.xr25_u13.nr1[nsmm_rsh]
print @n.xbgr.xr25_u13.nr1[nsmm_w]
print @n.xbgr.xr25_u13.nr1[nsmm_l]
print @n.xbgr.xr25_u14.nr1[nsmm_rsh]
print @n.xbgr.xr25_u14.nr1[nsmm_w]
print @n.xbgr.xr25_u14.nr1[nsmm_l]
print @n.xbgr.xr25_u15.nr1[nsmm_rsh]
print @n.xbgr.xr25_u15.nr1[nsmm_w]
print @n.xbgr.xr25_u15.nr1[nsmm_l]
print @n.xbgr.xr25_u16.nr1[nsmm_rsh]
print @n.xbgr.xr25_u16.nr1[nsmm_w]
print @n.xbgr.xr25_u16.nr1[nsmm_l]
print @n.xbgr.xr25_u17.nr1[nsmm_rsh]
print @n.xbgr.xr25_u17.nr1[nsmm_w]
print @n.xbgr.xr25_u17.nr1[nsmm_l]
print @n.xbgr.xr25_u18.nr1[nsmm_rsh]
print @n.xbgr.xr25_u18.nr1[nsmm_w]
print @n.xbgr.xr25_u18.nr1[nsmm_l]
print @n.xbgr.xr25_u19.nr1[nsmm_rsh]
print @n.xbgr.xr25_u19.nr1[nsmm_w]
print @n.xbgr.xr25_u19.nr1[nsmm_l]
print @n.xbgr.xr25_u20.nr1[nsmm_rsh]
print @n.xbgr.xr25_u20.nr1[nsmm_w]
print @n.xbgr.xr25_u20.nr1[nsmm_l]
print @n.xbgr.xr25_u21.nr1[nsmm_rsh]
print @n.xbgr.xr25_u21.nr1[nsmm_w]
print @n.xbgr.xr25_u21.nr1[nsmm_l]
print @n.xbgr.xr25_u22.nr1[nsmm_rsh]
print @n.xbgr.xr25_u22.nr1[nsmm_w]
print @n.xbgr.xr25_u22.nr1[nsmm_l]
print @n.xbgr.xr25_u23.nr1[nsmm_rsh]
print @n.xbgr.xr25_u23.nr1[nsmm_w]
print @n.xbgr.xr25_u23.nr1[nsmm_l]
print @n.xbgr.xr25_u24.nr1[nsmm_rsh]
print @n.xbgr.xr25_u24.nr1[nsmm_w]
print @n.xbgr.xr25_u24.nr1[nsmm_l]
print @n.xbgr.xr26_u2.nr1[nsmm_rsh]
print @n.xbgr.xr26_u2.nr1[nsmm_w]
print @n.xbgr.xr26_u2.nr1[nsmm_l]
print @n.xbgr.xr26_u3.nr1[nsmm_rsh]
print @n.xbgr.xr26_u3.nr1[nsmm_w]
print @n.xbgr.xr26_u3.nr1[nsmm_l]
print @n.xbgr.xr26_u4.nr1[nsmm_rsh]
print @n.xbgr.xr26_u4.nr1[nsmm_w]
print @n.xbgr.xr26_u4.nr1[nsmm_l]
print @n.xbgr.xr26_u5.nr1[nsmm_rsh]
print @n.xbgr.xr26_u5.nr1[nsmm_w]
print @n.xbgr.xr26_u5.nr1[nsmm_l]
print @n.xbgr.xr26_u6.nr1[nsmm_rsh]
print @n.xbgr.xr26_u6.nr1[nsmm_w]
print @n.xbgr.xr26_u6.nr1[nsmm_l]
print @n.xbgr.xr26_u7.nr1[nsmm_rsh]
print @n.xbgr.xr26_u7.nr1[nsmm_w]
print @n.xbgr.xr26_u7.nr1[nsmm_l]
print @n.xbgr.xr26_u8.nr1[nsmm_rsh]
print @n.xbgr.xr26_u8.nr1[nsmm_w]
print @n.xbgr.xr26_u8.nr1[nsmm_l]
print @n.xbgr.xr26_u9.nr1[nsmm_rsh]
print @n.xbgr.xr26_u9.nr1[nsmm_w]
print @n.xbgr.xr26_u9.nr1[nsmm_l]
print @n.xbgr.xr26_u10.nr1[nsmm_rsh]
print @n.xbgr.xr26_u10.nr1[nsmm_w]
print @n.xbgr.xr26_u10.nr1[nsmm_l]
print @n.xbgr.xr26_u11.nr1[nsmm_rsh]
print @n.xbgr.xr26_u11.nr1[nsmm_w]
print @n.xbgr.xr26_u11.nr1[nsmm_l]
print @n.xbgr.xr26_u12.nr1[nsmm_rsh]
print @n.xbgr.xr26_u12.nr1[nsmm_w]
print @n.xbgr.xr26_u12.nr1[nsmm_l]
print @n.xbgr.xr26_u13.nr1[nsmm_rsh]
print @n.xbgr.xr26_u13.nr1[nsmm_w]
print @n.xbgr.xr26_u13.nr1[nsmm_l]
print @n.xbgr.xr26_u14.nr1[nsmm_rsh]
print @n.xbgr.xr26_u14.nr1[nsmm_w]
print @n.xbgr.xr26_u14.nr1[nsmm_l]
print @n.xbgr.xr26_u15.nr1[nsmm_rsh]
print @n.xbgr.xr26_u15.nr1[nsmm_w]
print @n.xbgr.xr26_u15.nr1[nsmm_l]
print @n.xbgr.xr26_u16.nr1[nsmm_rsh]
print @n.xbgr.xr26_u16.nr1[nsmm_w]
print @n.xbgr.xr26_u16.nr1[nsmm_l]
print @n.xbgr.xr26_u17.nr1[nsmm_rsh]
print @n.xbgr.xr26_u17.nr1[nsmm_w]
print @n.xbgr.xr26_u17.nr1[nsmm_l]
print @n.xbgr.xr26_u18.nr1[nsmm_rsh]
print @n.xbgr.xr26_u18.nr1[nsmm_w]
print @n.xbgr.xr26_u18.nr1[nsmm_l]
print @n.xbgr.xr26_u19.nr1[nsmm_rsh]
print @n.xbgr.xr26_u19.nr1[nsmm_w]
print @n.xbgr.xr26_u19.nr1[nsmm_l]
print @n.xbgr.xr26_u20.nr1[nsmm_rsh]
print @n.xbgr.xr26_u20.nr1[nsmm_w]
print @n.xbgr.xr26_u20.nr1[nsmm_l]
print @n.xbgr.xr26_u21.nr1[nsmm_rsh]
print @n.xbgr.xr26_u21.nr1[nsmm_w]
print @n.xbgr.xr26_u21.nr1[nsmm_l]
print @n.xbgr.xr26_u22.nr1[nsmm_rsh]
print @n.xbgr.xr26_u22.nr1[nsmm_w]
print @n.xbgr.xr26_u22.nr1[nsmm_l]
print @n.xbgr.xr26_u23.nr1[nsmm_rsh]
print @n.xbgr.xr26_u23.nr1[nsmm_w]
print @n.xbgr.xr26_u23.nr1[nsmm_l]
print @n.xbgr.xr26_u24.nr1[nsmm_rsh]
print @n.xbgr.xr26_u24.nr1[nsmm_w]
print @n.xbgr.xr26_u24.nr1[nsmm_l]
print @n.xbgr.xm34_u2.nsg13_hv_nmos[w]
print @n.xbgr.xm34_u2.nsg13_hv_nmos[l]
print @n.xbgr.xm34_u2.nsg13_hv_nmos[delvto]
print @n.xbgr.xm34_u2.nsg13_hv_nmos[factuo]
print @n.xbgr.xm34_u3.nsg13_hv_nmos[w]
print @n.xbgr.xm34_u3.nsg13_hv_nmos[l]
print @n.xbgr.xm34_u3.nsg13_hv_nmos[delvto]
print @n.xbgr.xm34_u3.nsg13_hv_nmos[factuo]
print @n.xbgr.xm34_u4.nsg13_hv_nmos[w]
print @n.xbgr.xm34_u4.nsg13_hv_nmos[l]
print @n.xbgr.xm34_u4.nsg13_hv_nmos[delvto]
print @n.xbgr.xm34_u4.nsg13_hv_nmos[factuo]
print @n.xbgr.xm34_u5.nsg13_hv_nmos[w]
print @n.xbgr.xm34_u5.nsg13_hv_nmos[l]
print @n.xbgr.xm34_u5.nsg13_hv_nmos[delvto]
print @n.xbgr.xm34_u5.nsg13_hv_nmos[factuo]
print @n.xbgr.xm34_u6.nsg13_hv_nmos[w]
print @n.xbgr.xm34_u6.nsg13_hv_nmos[l]
print @n.xbgr.xm34_u6.nsg13_hv_nmos[delvto]
print @n.xbgr.xm34_u6.nsg13_hv_nmos[factuo]
print @n.xbgr.xm34_u7.nsg13_hv_nmos[w]
print @n.xbgr.xm34_u7.nsg13_hv_nmos[l]
print @n.xbgr.xm34_u7.nsg13_hv_nmos[delvto]
print @n.xbgr.xm34_u7.nsg13_hv_nmos[factuo]
print @n.xbgr.xm34_u8.nsg13_hv_nmos[w]
print @n.xbgr.xm34_u8.nsg13_hv_nmos[l]
print @n.xbgr.xm34_u8.nsg13_hv_nmos[delvto]
print @n.xbgr.xm34_u8.nsg13_hv_nmos[factuo]
print @n.xbgr.xm34_u9.nsg13_hv_nmos[w]
print @n.xbgr.xm34_u9.nsg13_hv_nmos[l]
print @n.xbgr.xm34_u9.nsg13_hv_nmos[delvto]
print @n.xbgr.xm34_u9.nsg13_hv_nmos[factuo]
print @n.xbgr.xm34_u10.nsg13_hv_nmos[w]
print @n.xbgr.xm34_u10.nsg13_hv_nmos[l]
print @n.xbgr.xm34_u10.nsg13_hv_nmos[delvto]
print @n.xbgr.xm34_u10.nsg13_hv_nmos[factuo]
print @n.xbgr.xm34_u11.nsg13_hv_nmos[w]
print @n.xbgr.xm34_u11.nsg13_hv_nmos[l]
print @n.xbgr.xm34_u11.nsg13_hv_nmos[delvto]
print @n.xbgr.xm34_u11.nsg13_hv_nmos[factuo]
print @n.xbgr.xm34_u12.nsg13_hv_nmos[w]
print @n.xbgr.xm34_u12.nsg13_hv_nmos[l]
print @n.xbgr.xm34_u12.nsg13_hv_nmos[delvto]
print @n.xbgr.xm34_u12.nsg13_hv_nmos[factuo]
print @n.xbgr.xm34_u13.nsg13_hv_nmos[w]
print @n.xbgr.xm34_u13.nsg13_hv_nmos[l]
print @n.xbgr.xm34_u13.nsg13_hv_nmos[delvto]
print @n.xbgr.xm34_u13.nsg13_hv_nmos[factuo]
print @n.xbgr.xm34_u14.nsg13_hv_nmos[w]
print @n.xbgr.xm34_u14.nsg13_hv_nmos[l]
print @n.xbgr.xm34_u14.nsg13_hv_nmos[delvto]
print @n.xbgr.xm34_u14.nsg13_hv_nmos[factuo]
print @n.xbgr.xm34_u15.nsg13_hv_nmos[w]
print @n.xbgr.xm34_u15.nsg13_hv_nmos[l]
print @n.xbgr.xm34_u15.nsg13_hv_nmos[delvto]
print @n.xbgr.xm34_u15.nsg13_hv_nmos[factuo]
print @n.xbgr.xm34_u16.nsg13_hv_nmos[w]
print @n.xbgr.xm34_u16.nsg13_hv_nmos[l]
print @n.xbgr.xm34_u16.nsg13_hv_nmos[delvto]
print @n.xbgr.xm34_u16.nsg13_hv_nmos[factuo]
print @n.xbgr.xm34_u17.nsg13_hv_nmos[w]
print @n.xbgr.xm34_u17.nsg13_hv_nmos[l]
print @n.xbgr.xm34_u17.nsg13_hv_nmos[delvto]
print @n.xbgr.xm34_u17.nsg13_hv_nmos[factuo]
print @n.xbgr.xm34_u18.nsg13_hv_nmos[w]
print @n.xbgr.xm34_u18.nsg13_hv_nmos[l]
print @n.xbgr.xm34_u18.nsg13_hv_nmos[delvto]
print @n.xbgr.xm34_u18.nsg13_hv_nmos[factuo]
print @n.xbgr.xm34_u19.nsg13_hv_nmos[w]
print @n.xbgr.xm34_u19.nsg13_hv_nmos[l]
print @n.xbgr.xm34_u19.nsg13_hv_nmos[delvto]
print @n.xbgr.xm34_u19.nsg13_hv_nmos[factuo]
print @n.xbgr.xm34_u20.nsg13_hv_nmos[w]
print @n.xbgr.xm34_u20.nsg13_hv_nmos[l]
print @n.xbgr.xm34_u20.nsg13_hv_nmos[delvto]
print @n.xbgr.xm34_u20.nsg13_hv_nmos[factuo]
print @n.xbgr.xm34_u21.nsg13_hv_nmos[w]
print @n.xbgr.xm34_u21.nsg13_hv_nmos[l]
print @n.xbgr.xm34_u21.nsg13_hv_nmos[delvto]
print @n.xbgr.xm34_u21.nsg13_hv_nmos[factuo]
print @n.xbgr.xm34_u22.nsg13_hv_nmos[w]
print @n.xbgr.xm34_u22.nsg13_hv_nmos[l]
print @n.xbgr.xm34_u22.nsg13_hv_nmos[delvto]
print @n.xbgr.xm34_u22.nsg13_hv_nmos[factuo]
print @n.xbgr.xm34_u23.nsg13_hv_nmos[w]
print @n.xbgr.xm34_u23.nsg13_hv_nmos[l]
print @n.xbgr.xm34_u23.nsg13_hv_nmos[delvto]
print @n.xbgr.xm34_u23.nsg13_hv_nmos[factuo]
print @n.xbgr.xm34_u24.nsg13_hv_nmos[w]
print @n.xbgr.xm34_u24.nsg13_hv_nmos[l]
print @n.xbgr.xm34_u24.nsg13_hv_nmos[delvto]
print @n.xbgr.xm34_u24.nsg13_hv_nmos[factuo]
print @n.xbgr.xm35_u2.nsg13_hv_nmos[w]
print @n.xbgr.xm35_u2.nsg13_hv_nmos[l]
print @n.xbgr.xm35_u2.nsg13_hv_nmos[delvto]
print @n.xbgr.xm35_u2.nsg13_hv_nmos[factuo]
print @n.xbgr.xm35_u3.nsg13_hv_nmos[w]
print @n.xbgr.xm35_u3.nsg13_hv_nmos[l]
print @n.xbgr.xm35_u3.nsg13_hv_nmos[delvto]
print @n.xbgr.xm35_u3.nsg13_hv_nmos[factuo]
print @n.xbgr.xm35_u4.nsg13_hv_nmos[w]
print @n.xbgr.xm35_u4.nsg13_hv_nmos[l]
print @n.xbgr.xm35_u4.nsg13_hv_nmos[delvto]
print @n.xbgr.xm35_u4.nsg13_hv_nmos[factuo]
print @n.xbgr.xm35_u5.nsg13_hv_nmos[w]
print @n.xbgr.xm35_u5.nsg13_hv_nmos[l]
print @n.xbgr.xm35_u5.nsg13_hv_nmos[delvto]
print @n.xbgr.xm35_u5.nsg13_hv_nmos[factuo]
print @n.xbgr.xm35_u6.nsg13_hv_nmos[w]
print @n.xbgr.xm35_u6.nsg13_hv_nmos[l]
print @n.xbgr.xm35_u6.nsg13_hv_nmos[delvto]
print @n.xbgr.xm35_u6.nsg13_hv_nmos[factuo]
print @n.xbgr.xm35_u7.nsg13_hv_nmos[w]
print @n.xbgr.xm35_u7.nsg13_hv_nmos[l]
print @n.xbgr.xm35_u7.nsg13_hv_nmos[delvto]
print @n.xbgr.xm35_u7.nsg13_hv_nmos[factuo]
print @n.xbgr.xm35_u8.nsg13_hv_nmos[w]
print @n.xbgr.xm35_u8.nsg13_hv_nmos[l]
print @n.xbgr.xm35_u8.nsg13_hv_nmos[delvto]
print @n.xbgr.xm35_u8.nsg13_hv_nmos[factuo]
print @n.xbgr.xm35_u9.nsg13_hv_nmos[w]
print @n.xbgr.xm35_u9.nsg13_hv_nmos[l]
print @n.xbgr.xm35_u9.nsg13_hv_nmos[delvto]
print @n.xbgr.xm35_u9.nsg13_hv_nmos[factuo]
print @n.xbgr.xm35_u10.nsg13_hv_nmos[w]
print @n.xbgr.xm35_u10.nsg13_hv_nmos[l]
print @n.xbgr.xm35_u10.nsg13_hv_nmos[delvto]
print @n.xbgr.xm35_u10.nsg13_hv_nmos[factuo]
print @n.xbgr.xm35_u11.nsg13_hv_nmos[w]
print @n.xbgr.xm35_u11.nsg13_hv_nmos[l]
print @n.xbgr.xm35_u11.nsg13_hv_nmos[delvto]
print @n.xbgr.xm35_u11.nsg13_hv_nmos[factuo]
print @n.xbgr.xm35_u12.nsg13_hv_nmos[w]
print @n.xbgr.xm35_u12.nsg13_hv_nmos[l]
print @n.xbgr.xm35_u12.nsg13_hv_nmos[delvto]
print @n.xbgr.xm35_u12.nsg13_hv_nmos[factuo]
print @n.xbgr.xm35_u13.nsg13_hv_nmos[w]
print @n.xbgr.xm35_u13.nsg13_hv_nmos[l]
print @n.xbgr.xm35_u13.nsg13_hv_nmos[delvto]
print @n.xbgr.xm35_u13.nsg13_hv_nmos[factuo]
print @n.xbgr.xm35_u14.nsg13_hv_nmos[w]
print @n.xbgr.xm35_u14.nsg13_hv_nmos[l]
print @n.xbgr.xm35_u14.nsg13_hv_nmos[delvto]
print @n.xbgr.xm35_u14.nsg13_hv_nmos[factuo]
print @n.xbgr.xm35_u15.nsg13_hv_nmos[w]
print @n.xbgr.xm35_u15.nsg13_hv_nmos[l]
print @n.xbgr.xm35_u15.nsg13_hv_nmos[delvto]
print @n.xbgr.xm35_u15.nsg13_hv_nmos[factuo]
print @n.xbgr.xm35_u16.nsg13_hv_nmos[w]
print @n.xbgr.xm35_u16.nsg13_hv_nmos[l]
print @n.xbgr.xm35_u16.nsg13_hv_nmos[delvto]
print @n.xbgr.xm35_u16.nsg13_hv_nmos[factuo]
print @n.xbgr.xm35_u17.nsg13_hv_nmos[w]
print @n.xbgr.xm35_u17.nsg13_hv_nmos[l]
print @n.xbgr.xm35_u17.nsg13_hv_nmos[delvto]
print @n.xbgr.xm35_u17.nsg13_hv_nmos[factuo]
print @n.xbgr.xm35_u18.nsg13_hv_nmos[w]
print @n.xbgr.xm35_u18.nsg13_hv_nmos[l]
print @n.xbgr.xm35_u18.nsg13_hv_nmos[delvto]
print @n.xbgr.xm35_u18.nsg13_hv_nmos[factuo]
print @n.xbgr.xm35_u19.nsg13_hv_nmos[w]
print @n.xbgr.xm35_u19.nsg13_hv_nmos[l]
print @n.xbgr.xm35_u19.nsg13_hv_nmos[delvto]
print @n.xbgr.xm35_u19.nsg13_hv_nmos[factuo]
print @n.xbgr.xm35_u20.nsg13_hv_nmos[w]
print @n.xbgr.xm35_u20.nsg13_hv_nmos[l]
print @n.xbgr.xm35_u20.nsg13_hv_nmos[delvto]
print @n.xbgr.xm35_u20.nsg13_hv_nmos[factuo]
print @n.xbgr.xm35_u21.nsg13_hv_nmos[w]
print @n.xbgr.xm35_u21.nsg13_hv_nmos[l]
print @n.xbgr.xm35_u21.nsg13_hv_nmos[delvto]
print @n.xbgr.xm35_u21.nsg13_hv_nmos[factuo]
print @n.xbgr.xm35_u22.nsg13_hv_nmos[w]
print @n.xbgr.xm35_u22.nsg13_hv_nmos[l]
print @n.xbgr.xm35_u22.nsg13_hv_nmos[delvto]
print @n.xbgr.xm35_u22.nsg13_hv_nmos[factuo]
print @n.xbgr.xm35_u23.nsg13_hv_nmos[w]
print @n.xbgr.xm35_u23.nsg13_hv_nmos[l]
print @n.xbgr.xm35_u23.nsg13_hv_nmos[delvto]
print @n.xbgr.xm35_u23.nsg13_hv_nmos[factuo]
print @n.xbgr.xm35_u24.nsg13_hv_nmos[w]
print @n.xbgr.xm35_u24.nsg13_hv_nmos[l]
print @n.xbgr.xm35_u24.nsg13_hv_nmos[delvto]
print @n.xbgr.xm35_u24.nsg13_hv_nmos[factuo]
print @n.xbgr.xm36_u2.nsg13_hv_nmos[w]
print @n.xbgr.xm36_u2.nsg13_hv_nmos[l]
print @n.xbgr.xm36_u2.nsg13_hv_nmos[delvto]
print @n.xbgr.xm36_u2.nsg13_hv_nmos[factuo]
print @n.xbgr.xm36_u3.nsg13_hv_nmos[w]
print @n.xbgr.xm36_u3.nsg13_hv_nmos[l]
print @n.xbgr.xm36_u3.nsg13_hv_nmos[delvto]
print @n.xbgr.xm36_u3.nsg13_hv_nmos[factuo]
print @n.xbgr.xm36_u4.nsg13_hv_nmos[w]
print @n.xbgr.xm36_u4.nsg13_hv_nmos[l]
print @n.xbgr.xm36_u4.nsg13_hv_nmos[delvto]
print @n.xbgr.xm36_u4.nsg13_hv_nmos[factuo]
print @n.xbgr.xm36_u5.nsg13_hv_nmos[w]
print @n.xbgr.xm36_u5.nsg13_hv_nmos[l]
print @n.xbgr.xm36_u5.nsg13_hv_nmos[delvto]
print @n.xbgr.xm36_u5.nsg13_hv_nmos[factuo]
print @n.xbgr.xm36_u6.nsg13_hv_nmos[w]
print @n.xbgr.xm36_u6.nsg13_hv_nmos[l]
print @n.xbgr.xm36_u6.nsg13_hv_nmos[delvto]
print @n.xbgr.xm36_u6.nsg13_hv_nmos[factuo]
print @n.xbgr.xm36_u7.nsg13_hv_nmos[w]
print @n.xbgr.xm36_u7.nsg13_hv_nmos[l]
print @n.xbgr.xm36_u7.nsg13_hv_nmos[delvto]
print @n.xbgr.xm36_u7.nsg13_hv_nmos[factuo]
print @n.xbgr.xm36_u8.nsg13_hv_nmos[w]
print @n.xbgr.xm36_u8.nsg13_hv_nmos[l]
print @n.xbgr.xm36_u8.nsg13_hv_nmos[delvto]
print @n.xbgr.xm36_u8.nsg13_hv_nmos[factuo]
print @n.xbgr.xm36_u9.nsg13_hv_nmos[w]
print @n.xbgr.xm36_u9.nsg13_hv_nmos[l]
print @n.xbgr.xm36_u9.nsg13_hv_nmos[delvto]
print @n.xbgr.xm36_u9.nsg13_hv_nmos[factuo]
print @n.xbgr.xm36_u10.nsg13_hv_nmos[w]
print @n.xbgr.xm36_u10.nsg13_hv_nmos[l]
print @n.xbgr.xm36_u10.nsg13_hv_nmos[delvto]
print @n.xbgr.xm36_u10.nsg13_hv_nmos[factuo]
print @n.xbgr.xm36_u11.nsg13_hv_nmos[w]
print @n.xbgr.xm36_u11.nsg13_hv_nmos[l]
print @n.xbgr.xm36_u11.nsg13_hv_nmos[delvto]
print @n.xbgr.xm36_u11.nsg13_hv_nmos[factuo]
print @n.xbgr.xm36_u12.nsg13_hv_nmos[w]
print @n.xbgr.xm36_u12.nsg13_hv_nmos[l]
print @n.xbgr.xm36_u12.nsg13_hv_nmos[delvto]
print @n.xbgr.xm36_u12.nsg13_hv_nmos[factuo]
print @n.xbgr.xm36_u13.nsg13_hv_nmos[w]
print @n.xbgr.xm36_u13.nsg13_hv_nmos[l]
print @n.xbgr.xm36_u13.nsg13_hv_nmos[delvto]
print @n.xbgr.xm36_u13.nsg13_hv_nmos[factuo]
print @n.xbgr.xm36_u14.nsg13_hv_nmos[w]
print @n.xbgr.xm36_u14.nsg13_hv_nmos[l]
print @n.xbgr.xm36_u14.nsg13_hv_nmos[delvto]
print @n.xbgr.xm36_u14.nsg13_hv_nmos[factuo]
print @n.xbgr.xm36_u15.nsg13_hv_nmos[w]
print @n.xbgr.xm36_u15.nsg13_hv_nmos[l]
print @n.xbgr.xm36_u15.nsg13_hv_nmos[delvto]
print @n.xbgr.xm36_u15.nsg13_hv_nmos[factuo]
print @n.xbgr.xm36_u16.nsg13_hv_nmos[w]
print @n.xbgr.xm36_u16.nsg13_hv_nmos[l]
print @n.xbgr.xm36_u16.nsg13_hv_nmos[delvto]
print @n.xbgr.xm36_u16.nsg13_hv_nmos[factuo]
print @n.xbgr.xm36_u17.nsg13_hv_nmos[w]
print @n.xbgr.xm36_u17.nsg13_hv_nmos[l]
print @n.xbgr.xm36_u17.nsg13_hv_nmos[delvto]
print @n.xbgr.xm36_u17.nsg13_hv_nmos[factuo]
print @n.xbgr.xm36_u18.nsg13_hv_nmos[w]
print @n.xbgr.xm36_u18.nsg13_hv_nmos[l]
print @n.xbgr.xm36_u18.nsg13_hv_nmos[delvto]
print @n.xbgr.xm36_u18.nsg13_hv_nmos[factuo]
print @n.xbgr.xm36_u19.nsg13_hv_nmos[w]
print @n.xbgr.xm36_u19.nsg13_hv_nmos[l]
print @n.xbgr.xm36_u19.nsg13_hv_nmos[delvto]
print @n.xbgr.xm36_u19.nsg13_hv_nmos[factuo]
print @n.xbgr.xm36_u20.nsg13_hv_nmos[w]
print @n.xbgr.xm36_u20.nsg13_hv_nmos[l]
print @n.xbgr.xm36_u20.nsg13_hv_nmos[delvto]
print @n.xbgr.xm36_u20.nsg13_hv_nmos[factuo]
print @n.xbgr.xm36_u21.nsg13_hv_nmos[w]
print @n.xbgr.xm36_u21.nsg13_hv_nmos[l]
print @n.xbgr.xm36_u21.nsg13_hv_nmos[delvto]
print @n.xbgr.xm36_u21.nsg13_hv_nmos[factuo]
print @n.xbgr.xm36_u22.nsg13_hv_nmos[w]
print @n.xbgr.xm36_u22.nsg13_hv_nmos[l]
print @n.xbgr.xm36_u22.nsg13_hv_nmos[delvto]
print @n.xbgr.xm36_u22.nsg13_hv_nmos[factuo]
print @n.xbgr.xm36_u23.nsg13_hv_nmos[w]
print @n.xbgr.xm36_u23.nsg13_hv_nmos[l]
print @n.xbgr.xm36_u23.nsg13_hv_nmos[delvto]
print @n.xbgr.xm36_u23.nsg13_hv_nmos[factuo]
print @n.xbgr.xm36_u24.nsg13_hv_nmos[w]
print @n.xbgr.xm36_u24.nsg13_hv_nmos[l]
print @n.xbgr.xm36_u24.nsg13_hv_nmos[delvto]
print @n.xbgr.xm36_u24.nsg13_hv_nmos[factuo]
print @n.xbgr.xm37_u2.nsg13_hv_nmos[w]
print @n.xbgr.xm37_u2.nsg13_hv_nmos[l]
print @n.xbgr.xm37_u2.nsg13_hv_nmos[delvto]
print @n.xbgr.xm37_u2.nsg13_hv_nmos[factuo]
print @n.xbgr.xm37_u3.nsg13_hv_nmos[w]
print @n.xbgr.xm37_u3.nsg13_hv_nmos[l]
print @n.xbgr.xm37_u3.nsg13_hv_nmos[delvto]
print @n.xbgr.xm37_u3.nsg13_hv_nmos[factuo]
print @n.xbgr.xm37_u4.nsg13_hv_nmos[w]
print @n.xbgr.xm37_u4.nsg13_hv_nmos[l]
print @n.xbgr.xm37_u4.nsg13_hv_nmos[delvto]
print @n.xbgr.xm37_u4.nsg13_hv_nmos[factuo]
print @n.xbgr.xm37_u5.nsg13_hv_nmos[w]
print @n.xbgr.xm37_u5.nsg13_hv_nmos[l]
print @n.xbgr.xm37_u5.nsg13_hv_nmos[delvto]
print @n.xbgr.xm37_u5.nsg13_hv_nmos[factuo]
print @n.xbgr.xm37_u6.nsg13_hv_nmos[w]
print @n.xbgr.xm37_u6.nsg13_hv_nmos[l]
print @n.xbgr.xm37_u6.nsg13_hv_nmos[delvto]
print @n.xbgr.xm37_u6.nsg13_hv_nmos[factuo]
print @n.xbgr.xm37_u7.nsg13_hv_nmos[w]
print @n.xbgr.xm37_u7.nsg13_hv_nmos[l]
print @n.xbgr.xm37_u7.nsg13_hv_nmos[delvto]
print @n.xbgr.xm37_u7.nsg13_hv_nmos[factuo]
print @n.xbgr.xm37_u8.nsg13_hv_nmos[w]
print @n.xbgr.xm37_u8.nsg13_hv_nmos[l]
print @n.xbgr.xm37_u8.nsg13_hv_nmos[delvto]
print @n.xbgr.xm37_u8.nsg13_hv_nmos[factuo]
print @n.xbgr.xm37_u9.nsg13_hv_nmos[w]
print @n.xbgr.xm37_u9.nsg13_hv_nmos[l]
print @n.xbgr.xm37_u9.nsg13_hv_nmos[delvto]
print @n.xbgr.xm37_u9.nsg13_hv_nmos[factuo]
print @n.xbgr.xm37_u10.nsg13_hv_nmos[w]
print @n.xbgr.xm37_u10.nsg13_hv_nmos[l]
print @n.xbgr.xm37_u10.nsg13_hv_nmos[delvto]
print @n.xbgr.xm37_u10.nsg13_hv_nmos[factuo]
print @n.xbgr.xm37_u11.nsg13_hv_nmos[w]
print @n.xbgr.xm37_u11.nsg13_hv_nmos[l]
print @n.xbgr.xm37_u11.nsg13_hv_nmos[delvto]
print @n.xbgr.xm37_u11.nsg13_hv_nmos[factuo]
print @n.xbgr.xm37_u12.nsg13_hv_nmos[w]
print @n.xbgr.xm37_u12.nsg13_hv_nmos[l]
print @n.xbgr.xm37_u12.nsg13_hv_nmos[delvto]
print @n.xbgr.xm37_u12.nsg13_hv_nmos[factuo]
print @n.xbgr.xm37_u13.nsg13_hv_nmos[w]
print @n.xbgr.xm37_u13.nsg13_hv_nmos[l]
print @n.xbgr.xm37_u13.nsg13_hv_nmos[delvto]
print @n.xbgr.xm37_u13.nsg13_hv_nmos[factuo]
print @n.xbgr.xm37_u14.nsg13_hv_nmos[w]
print @n.xbgr.xm37_u14.nsg13_hv_nmos[l]
print @n.xbgr.xm37_u14.nsg13_hv_nmos[delvto]
print @n.xbgr.xm37_u14.nsg13_hv_nmos[factuo]
print @n.xbgr.xm37_u15.nsg13_hv_nmos[w]
print @n.xbgr.xm37_u15.nsg13_hv_nmos[l]
print @n.xbgr.xm37_u15.nsg13_hv_nmos[delvto]
print @n.xbgr.xm37_u15.nsg13_hv_nmos[factuo]
print @n.xbgr.xm37_u16.nsg13_hv_nmos[w]
print @n.xbgr.xm37_u16.nsg13_hv_nmos[l]
print @n.xbgr.xm37_u16.nsg13_hv_nmos[delvto]
print @n.xbgr.xm37_u16.nsg13_hv_nmos[factuo]
print @n.xbgr.xm37_u17.nsg13_hv_nmos[w]
print @n.xbgr.xm37_u17.nsg13_hv_nmos[l]
print @n.xbgr.xm37_u17.nsg13_hv_nmos[delvto]
print @n.xbgr.xm37_u17.nsg13_hv_nmos[factuo]
print @n.xbgr.xm37_u18.nsg13_hv_nmos[w]
print @n.xbgr.xm37_u18.nsg13_hv_nmos[l]
print @n.xbgr.xm37_u18.nsg13_hv_nmos[delvto]
print @n.xbgr.xm37_u18.nsg13_hv_nmos[factuo]
print @n.xbgr.xm37_u19.nsg13_hv_nmos[w]
print @n.xbgr.xm37_u19.nsg13_hv_nmos[l]
print @n.xbgr.xm37_u19.nsg13_hv_nmos[delvto]
print @n.xbgr.xm37_u19.nsg13_hv_nmos[factuo]
print @n.xbgr.xm37_u20.nsg13_hv_nmos[w]
print @n.xbgr.xm37_u20.nsg13_hv_nmos[l]
print @n.xbgr.xm37_u20.nsg13_hv_nmos[delvto]
print @n.xbgr.xm37_u20.nsg13_hv_nmos[factuo]
print @n.xbgr.xm37_u21.nsg13_hv_nmos[w]
print @n.xbgr.xm37_u21.nsg13_hv_nmos[l]
print @n.xbgr.xm37_u21.nsg13_hv_nmos[delvto]
print @n.xbgr.xm37_u21.nsg13_hv_nmos[factuo]
print @n.xbgr.xm37_u22.nsg13_hv_nmos[w]
print @n.xbgr.xm37_u22.nsg13_hv_nmos[l]
print @n.xbgr.xm37_u22.nsg13_hv_nmos[delvto]
print @n.xbgr.xm37_u22.nsg13_hv_nmos[factuo]
print @n.xbgr.xm37_u23.nsg13_hv_nmos[w]
print @n.xbgr.xm37_u23.nsg13_hv_nmos[l]
print @n.xbgr.xm37_u23.nsg13_hv_nmos[delvto]
print @n.xbgr.xm37_u23.nsg13_hv_nmos[factuo]
print @n.xbgr.xm37_u24.nsg13_hv_nmos[w]
print @n.xbgr.xm37_u24.nsg13_hv_nmos[l]
print @n.xbgr.xm37_u24.nsg13_hv_nmos[delvto]
print @n.xbgr.xm37_u24.nsg13_hv_nmos[factuo]
print @n.xbgr.xm38_u2.nsg13_hv_pmos[w]
print @n.xbgr.xm38_u2.nsg13_hv_pmos[l]
print @n.xbgr.xm38_u2.nsg13_hv_pmos[delvto]
print @n.xbgr.xm38_u2.nsg13_hv_pmos[factuo]
print @n.xbgr.xm38_u3.nsg13_hv_pmos[w]
print @n.xbgr.xm38_u3.nsg13_hv_pmos[l]
print @n.xbgr.xm38_u3.nsg13_hv_pmos[delvto]
print @n.xbgr.xm38_u3.nsg13_hv_pmos[factuo]
print @n.xbgr.xm38_u4.nsg13_hv_pmos[w]
print @n.xbgr.xm38_u4.nsg13_hv_pmos[l]
print @n.xbgr.xm38_u4.nsg13_hv_pmos[delvto]
print @n.xbgr.xm38_u4.nsg13_hv_pmos[factuo]
print @n.xbgr.xm38_u5.nsg13_hv_pmos[w]
print @n.xbgr.xm38_u5.nsg13_hv_pmos[l]
print @n.xbgr.xm38_u5.nsg13_hv_pmos[delvto]
print @n.xbgr.xm38_u5.nsg13_hv_pmos[factuo]
print @n.xbgr.xm38_u6.nsg13_hv_pmos[w]
print @n.xbgr.xm38_u6.nsg13_hv_pmos[l]
print @n.xbgr.xm38_u6.nsg13_hv_pmos[delvto]
print @n.xbgr.xm38_u6.nsg13_hv_pmos[factuo]
print @n.xbgr.xm38_u7.nsg13_hv_pmos[w]
print @n.xbgr.xm38_u7.nsg13_hv_pmos[l]
print @n.xbgr.xm38_u7.nsg13_hv_pmos[delvto]
print @n.xbgr.xm38_u7.nsg13_hv_pmos[factuo]
print @n.xbgr.xm38_u8.nsg13_hv_pmos[w]
print @n.xbgr.xm38_u8.nsg13_hv_pmos[l]
print @n.xbgr.xm38_u8.nsg13_hv_pmos[delvto]
print @n.xbgr.xm38_u8.nsg13_hv_pmos[factuo]
print @n.xbgr.xm38_u9.nsg13_hv_pmos[w]
print @n.xbgr.xm38_u9.nsg13_hv_pmos[l]
print @n.xbgr.xm38_u9.nsg13_hv_pmos[delvto]
print @n.xbgr.xm38_u9.nsg13_hv_pmos[factuo]
print @n.xbgr.xm38_u10.nsg13_hv_pmos[w]
print @n.xbgr.xm38_u10.nsg13_hv_pmos[l]
print @n.xbgr.xm38_u10.nsg13_hv_pmos[delvto]
print @n.xbgr.xm38_u10.nsg13_hv_pmos[factuo]
print @n.xbgr.xm38_u11.nsg13_hv_pmos[w]
print @n.xbgr.xm38_u11.nsg13_hv_pmos[l]
print @n.xbgr.xm38_u11.nsg13_hv_pmos[delvto]
print @n.xbgr.xm38_u11.nsg13_hv_pmos[factuo]
print @n.xbgr.xm38_u12.nsg13_hv_pmos[w]
print @n.xbgr.xm38_u12.nsg13_hv_pmos[l]
print @n.xbgr.xm38_u12.nsg13_hv_pmos[delvto]
print @n.xbgr.xm38_u12.nsg13_hv_pmos[factuo]
print @n.xbgr.xm38_u13.nsg13_hv_pmos[w]
print @n.xbgr.xm38_u13.nsg13_hv_pmos[l]
print @n.xbgr.xm38_u13.nsg13_hv_pmos[delvto]
print @n.xbgr.xm38_u13.nsg13_hv_pmos[factuo]
print @n.xbgr.xm38_u14.nsg13_hv_pmos[w]
print @n.xbgr.xm38_u14.nsg13_hv_pmos[l]
print @n.xbgr.xm38_u14.nsg13_hv_pmos[delvto]
print @n.xbgr.xm38_u14.nsg13_hv_pmos[factuo]
print @n.xbgr.xm38_u15.nsg13_hv_pmos[w]
print @n.xbgr.xm38_u15.nsg13_hv_pmos[l]
print @n.xbgr.xm38_u15.nsg13_hv_pmos[delvto]
print @n.xbgr.xm38_u15.nsg13_hv_pmos[factuo]
print @n.xbgr.xm38_u16.nsg13_hv_pmos[w]
print @n.xbgr.xm38_u16.nsg13_hv_pmos[l]
print @n.xbgr.xm38_u16.nsg13_hv_pmos[delvto]
print @n.xbgr.xm38_u16.nsg13_hv_pmos[factuo]
print @n.xbgr.xm38_u17.nsg13_hv_pmos[w]
print @n.xbgr.xm38_u17.nsg13_hv_pmos[l]
print @n.xbgr.xm38_u17.nsg13_hv_pmos[delvto]
print @n.xbgr.xm38_u17.nsg13_hv_pmos[factuo]
print @n.xbgr.xm38_u18.nsg13_hv_pmos[w]
print @n.xbgr.xm38_u18.nsg13_hv_pmos[l]
print @n.xbgr.xm38_u18.nsg13_hv_pmos[delvto]
print @n.xbgr.xm38_u18.nsg13_hv_pmos[factuo]
print @n.xbgr.xm38_u19.nsg13_hv_pmos[w]
print @n.xbgr.xm38_u19.nsg13_hv_pmos[l]
print @n.xbgr.xm38_u19.nsg13_hv_pmos[delvto]
print @n.xbgr.xm38_u19.nsg13_hv_pmos[factuo]
print @n.xbgr.xm38_u20.nsg13_hv_pmos[w]
print @n.xbgr.xm38_u20.nsg13_hv_pmos[l]
print @n.xbgr.xm38_u20.nsg13_hv_pmos[delvto]
print @n.xbgr.xm38_u20.nsg13_hv_pmos[factuo]
print @n.xbgr.xm38_u21.nsg13_hv_pmos[w]
print @n.xbgr.xm38_u21.nsg13_hv_pmos[l]
print @n.xbgr.xm38_u21.nsg13_hv_pmos[delvto]
print @n.xbgr.xm38_u21.nsg13_hv_pmos[factuo]
print @n.xbgr.xm38_u22.nsg13_hv_pmos[w]
print @n.xbgr.xm38_u22.nsg13_hv_pmos[l]
print @n.xbgr.xm38_u22.nsg13_hv_pmos[delvto]
print @n.xbgr.xm38_u22.nsg13_hv_pmos[factuo]
print @n.xbgr.xm38_u23.nsg13_hv_pmos[w]
print @n.xbgr.xm38_u23.nsg13_hv_pmos[l]
print @n.xbgr.xm38_u23.nsg13_hv_pmos[delvto]
print @n.xbgr.xm38_u23.nsg13_hv_pmos[factuo]
print @n.xbgr.xm38_u24.nsg13_hv_pmos[w]
print @n.xbgr.xm38_u24.nsg13_hv_pmos[l]
print @n.xbgr.xm38_u24.nsg13_hv_pmos[delvto]
print @n.xbgr.xm38_u24.nsg13_hv_pmos[factuo]
print @n.xbgr.xm39_u2.nsg13_hv_pmos[w]
print @n.xbgr.xm39_u2.nsg13_hv_pmos[l]
print @n.xbgr.xm39_u2.nsg13_hv_pmos[delvto]
print @n.xbgr.xm39_u2.nsg13_hv_pmos[factuo]
print @n.xbgr.xm39_u3.nsg13_hv_pmos[w]
print @n.xbgr.xm39_u3.nsg13_hv_pmos[l]
print @n.xbgr.xm39_u3.nsg13_hv_pmos[delvto]
print @n.xbgr.xm39_u3.nsg13_hv_pmos[factuo]
print @n.xbgr.xm39_u4.nsg13_hv_pmos[w]
print @n.xbgr.xm39_u4.nsg13_hv_pmos[l]
print @n.xbgr.xm39_u4.nsg13_hv_pmos[delvto]
print @n.xbgr.xm39_u4.nsg13_hv_pmos[factuo]
print @n.xbgr.xm39_u5.nsg13_hv_pmos[w]
print @n.xbgr.xm39_u5.nsg13_hv_pmos[l]
print @n.xbgr.xm39_u5.nsg13_hv_pmos[delvto]
print @n.xbgr.xm39_u5.nsg13_hv_pmos[factuo]
print @n.xbgr.xm39_u6.nsg13_hv_pmos[w]
print @n.xbgr.xm39_u6.nsg13_hv_pmos[l]
print @n.xbgr.xm39_u6.nsg13_hv_pmos[delvto]
print @n.xbgr.xm39_u6.nsg13_hv_pmos[factuo]
print @n.xbgr.xm39_u7.nsg13_hv_pmos[w]
print @n.xbgr.xm39_u7.nsg13_hv_pmos[l]
print @n.xbgr.xm39_u7.nsg13_hv_pmos[delvto]
print @n.xbgr.xm39_u7.nsg13_hv_pmos[factuo]
print @n.xbgr.xm39_u8.nsg13_hv_pmos[w]
print @n.xbgr.xm39_u8.nsg13_hv_pmos[l]
print @n.xbgr.xm39_u8.nsg13_hv_pmos[delvto]
print @n.xbgr.xm39_u8.nsg13_hv_pmos[factuo]
print @n.xbgr.xm39_u9.nsg13_hv_pmos[w]
print @n.xbgr.xm39_u9.nsg13_hv_pmos[l]
print @n.xbgr.xm39_u9.nsg13_hv_pmos[delvto]
print @n.xbgr.xm39_u9.nsg13_hv_pmos[factuo]
print @n.xbgr.xm39_u10.nsg13_hv_pmos[w]
print @n.xbgr.xm39_u10.nsg13_hv_pmos[l]
print @n.xbgr.xm39_u10.nsg13_hv_pmos[delvto]
print @n.xbgr.xm39_u10.nsg13_hv_pmos[factuo]
print @n.xbgr.xm39_u11.nsg13_hv_pmos[w]
print @n.xbgr.xm39_u11.nsg13_hv_pmos[l]
print @n.xbgr.xm39_u11.nsg13_hv_pmos[delvto]
print @n.xbgr.xm39_u11.nsg13_hv_pmos[factuo]
print @n.xbgr.xm39_u12.nsg13_hv_pmos[w]
print @n.xbgr.xm39_u12.nsg13_hv_pmos[l]
print @n.xbgr.xm39_u12.nsg13_hv_pmos[delvto]
print @n.xbgr.xm39_u12.nsg13_hv_pmos[factuo]
print @n.xbgr.xm39_u13.nsg13_hv_pmos[w]
print @n.xbgr.xm39_u13.nsg13_hv_pmos[l]
print @n.xbgr.xm39_u13.nsg13_hv_pmos[delvto]
print @n.xbgr.xm39_u13.nsg13_hv_pmos[factuo]
print @n.xbgr.xm39_u14.nsg13_hv_pmos[w]
print @n.xbgr.xm39_u14.nsg13_hv_pmos[l]
print @n.xbgr.xm39_u14.nsg13_hv_pmos[delvto]
print @n.xbgr.xm39_u14.nsg13_hv_pmos[factuo]
print @n.xbgr.xm39_u15.nsg13_hv_pmos[w]
print @n.xbgr.xm39_u15.nsg13_hv_pmos[l]
print @n.xbgr.xm39_u15.nsg13_hv_pmos[delvto]
print @n.xbgr.xm39_u15.nsg13_hv_pmos[factuo]
print @n.xbgr.xm39_u16.nsg13_hv_pmos[w]
print @n.xbgr.xm39_u16.nsg13_hv_pmos[l]
print @n.xbgr.xm39_u16.nsg13_hv_pmos[delvto]
print @n.xbgr.xm39_u16.nsg13_hv_pmos[factuo]
print @n.xbgr.xm39_u17.nsg13_hv_pmos[w]
print @n.xbgr.xm39_u17.nsg13_hv_pmos[l]
print @n.xbgr.xm39_u17.nsg13_hv_pmos[delvto]
print @n.xbgr.xm39_u17.nsg13_hv_pmos[factuo]
print @n.xbgr.xm39_u18.nsg13_hv_pmos[w]
print @n.xbgr.xm39_u18.nsg13_hv_pmos[l]
print @n.xbgr.xm39_u18.nsg13_hv_pmos[delvto]
print @n.xbgr.xm39_u18.nsg13_hv_pmos[factuo]
print @n.xbgr.xm39_u19.nsg13_hv_pmos[w]
print @n.xbgr.xm39_u19.nsg13_hv_pmos[l]
print @n.xbgr.xm39_u19.nsg13_hv_pmos[delvto]
print @n.xbgr.xm39_u19.nsg13_hv_pmos[factuo]
print @n.xbgr.xm39_u20.nsg13_hv_pmos[w]
print @n.xbgr.xm39_u20.nsg13_hv_pmos[l]
print @n.xbgr.xm39_u20.nsg13_hv_pmos[delvto]
print @n.xbgr.xm39_u20.nsg13_hv_pmos[factuo]
print @n.xbgr.xm39_u21.nsg13_hv_pmos[w]
print @n.xbgr.xm39_u21.nsg13_hv_pmos[l]
print @n.xbgr.xm39_u21.nsg13_hv_pmos[delvto]
print @n.xbgr.xm39_u21.nsg13_hv_pmos[factuo]
print @n.xbgr.xm39_u22.nsg13_hv_pmos[w]
print @n.xbgr.xm39_u22.nsg13_hv_pmos[l]
print @n.xbgr.xm39_u22.nsg13_hv_pmos[delvto]
print @n.xbgr.xm39_u22.nsg13_hv_pmos[factuo]
print @n.xbgr.xm39_u23.nsg13_hv_pmos[w]
print @n.xbgr.xm39_u23.nsg13_hv_pmos[l]
print @n.xbgr.xm39_u23.nsg13_hv_pmos[delvto]
print @n.xbgr.xm39_u23.nsg13_hv_pmos[factuo]
print @n.xbgr.xm39_u24.nsg13_hv_pmos[w]
print @n.xbgr.xm39_u24.nsg13_hv_pmos[l]
print @n.xbgr.xm39_u24.nsg13_hv_pmos[delvto]
print @n.xbgr.xm39_u24.nsg13_hv_pmos[factuo]
print @n.xbgr.xm41_u2.nsg13_hv_pmos[w]
print @n.xbgr.xm41_u2.nsg13_hv_pmos[l]
print @n.xbgr.xm41_u2.nsg13_hv_pmos[delvto]
print @n.xbgr.xm41_u2.nsg13_hv_pmos[factuo]
print @n.xbgr.xm41_u3.nsg13_hv_pmos[w]
print @n.xbgr.xm41_u3.nsg13_hv_pmos[l]
print @n.xbgr.xm41_u3.nsg13_hv_pmos[delvto]
print @n.xbgr.xm41_u3.nsg13_hv_pmos[factuo]
print @n.xbgr.xm41_u4.nsg13_hv_pmos[w]
print @n.xbgr.xm41_u4.nsg13_hv_pmos[l]
print @n.xbgr.xm41_u4.nsg13_hv_pmos[delvto]
print @n.xbgr.xm41_u4.nsg13_hv_pmos[factuo]
print @n.xbgr.xm41_u5.nsg13_hv_pmos[w]
print @n.xbgr.xm41_u5.nsg13_hv_pmos[l]
print @n.xbgr.xm41_u5.nsg13_hv_pmos[delvto]
print @n.xbgr.xm41_u5.nsg13_hv_pmos[factuo]
print @n.xbgr.xm41_u6.nsg13_hv_pmos[w]
print @n.xbgr.xm41_u6.nsg13_hv_pmos[l]
print @n.xbgr.xm41_u6.nsg13_hv_pmos[delvto]
print @n.xbgr.xm41_u6.nsg13_hv_pmos[factuo]
print @n.xbgr.xm41_u7.nsg13_hv_pmos[w]
print @n.xbgr.xm41_u7.nsg13_hv_pmos[l]
print @n.xbgr.xm41_u7.nsg13_hv_pmos[delvto]
print @n.xbgr.xm41_u7.nsg13_hv_pmos[factuo]
print @n.xbgr.xm41_u8.nsg13_hv_pmos[w]
print @n.xbgr.xm41_u8.nsg13_hv_pmos[l]
print @n.xbgr.xm41_u8.nsg13_hv_pmos[delvto]
print @n.xbgr.xm41_u8.nsg13_hv_pmos[factuo]
print @n.xbgr.xm41_u9.nsg13_hv_pmos[w]
print @n.xbgr.xm41_u9.nsg13_hv_pmos[l]
print @n.xbgr.xm41_u9.nsg13_hv_pmos[delvto]
print @n.xbgr.xm41_u9.nsg13_hv_pmos[factuo]
print @n.xbgr.xm41_u10.nsg13_hv_pmos[w]
print @n.xbgr.xm41_u10.nsg13_hv_pmos[l]
print @n.xbgr.xm41_u10.nsg13_hv_pmos[delvto]
print @n.xbgr.xm41_u10.nsg13_hv_pmos[factuo]
print @n.xbgr.xm41_u11.nsg13_hv_pmos[w]
print @n.xbgr.xm41_u11.nsg13_hv_pmos[l]
print @n.xbgr.xm41_u11.nsg13_hv_pmos[delvto]
print @n.xbgr.xm41_u11.nsg13_hv_pmos[factuo]
print @n.xbgr.xm41_u12.nsg13_hv_pmos[w]
print @n.xbgr.xm41_u12.nsg13_hv_pmos[l]
print @n.xbgr.xm41_u12.nsg13_hv_pmos[delvto]
print @n.xbgr.xm41_u12.nsg13_hv_pmos[factuo]
print @n.xbgr.xm41_u13.nsg13_hv_pmos[w]
print @n.xbgr.xm41_u13.nsg13_hv_pmos[l]
print @n.xbgr.xm41_u13.nsg13_hv_pmos[delvto]
print @n.xbgr.xm41_u13.nsg13_hv_pmos[factuo]
print @n.xbgr.xm41_u14.nsg13_hv_pmos[w]
print @n.xbgr.xm41_u14.nsg13_hv_pmos[l]
print @n.xbgr.xm41_u14.nsg13_hv_pmos[delvto]
print @n.xbgr.xm41_u14.nsg13_hv_pmos[factuo]
print @n.xbgr.xm41_u15.nsg13_hv_pmos[w]
print @n.xbgr.xm41_u15.nsg13_hv_pmos[l]
print @n.xbgr.xm41_u15.nsg13_hv_pmos[delvto]
print @n.xbgr.xm41_u15.nsg13_hv_pmos[factuo]
print @n.xbgr.xm41_u16.nsg13_hv_pmos[w]
print @n.xbgr.xm41_u16.nsg13_hv_pmos[l]
print @n.xbgr.xm41_u16.nsg13_hv_pmos[delvto]
print @n.xbgr.xm41_u16.nsg13_hv_pmos[factuo]
print @n.xbgr.xm41_u17.nsg13_hv_pmos[w]
print @n.xbgr.xm41_u17.nsg13_hv_pmos[l]
print @n.xbgr.xm41_u17.nsg13_hv_pmos[delvto]
print @n.xbgr.xm41_u17.nsg13_hv_pmos[factuo]
print @n.xbgr.xm41_u18.nsg13_hv_pmos[w]
print @n.xbgr.xm41_u18.nsg13_hv_pmos[l]
print @n.xbgr.xm41_u18.nsg13_hv_pmos[delvto]
print @n.xbgr.xm41_u18.nsg13_hv_pmos[factuo]
print @n.xbgr.xm41_u19.nsg13_hv_pmos[w]
print @n.xbgr.xm41_u19.nsg13_hv_pmos[l]
print @n.xbgr.xm41_u19.nsg13_hv_pmos[delvto]
print @n.xbgr.xm41_u19.nsg13_hv_pmos[factuo]
print @n.xbgr.xm41_u20.nsg13_hv_pmos[w]
print @n.xbgr.xm41_u20.nsg13_hv_pmos[l]
print @n.xbgr.xm41_u20.nsg13_hv_pmos[delvto]
print @n.xbgr.xm41_u20.nsg13_hv_pmos[factuo]
print @n.xbgr.xm41_u21.nsg13_hv_pmos[w]
print @n.xbgr.xm41_u21.nsg13_hv_pmos[l]
print @n.xbgr.xm41_u21.nsg13_hv_pmos[delvto]
print @n.xbgr.xm41_u21.nsg13_hv_pmos[factuo]
print @n.xbgr.xm41_u22.nsg13_hv_pmos[w]
print @n.xbgr.xm41_u22.nsg13_hv_pmos[l]
print @n.xbgr.xm41_u22.nsg13_hv_pmos[delvto]
print @n.xbgr.xm41_u22.nsg13_hv_pmos[factuo]
print @n.xbgr.xm41_u23.nsg13_hv_pmos[w]
print @n.xbgr.xm41_u23.nsg13_hv_pmos[l]
print @n.xbgr.xm41_u23.nsg13_hv_pmos[delvto]
print @n.xbgr.xm41_u23.nsg13_hv_pmos[factuo]
print @n.xbgr.xm41_u24.nsg13_hv_pmos[w]
print @n.xbgr.xm41_u24.nsg13_hv_pmos[l]
print @n.xbgr.xm41_u24.nsg13_hv_pmos[delvto]
print @n.xbgr.xm41_u24.nsg13_hv_pmos[factuo]
print @n.xbgr.xm43_u2.nsg13_hv_pmos[w]
print @n.xbgr.xm43_u2.nsg13_hv_pmos[l]
print @n.xbgr.xm43_u2.nsg13_hv_pmos[delvto]
print @n.xbgr.xm43_u2.nsg13_hv_pmos[factuo]
print @n.xbgr.xm43_u3.nsg13_hv_pmos[w]
print @n.xbgr.xm43_u3.nsg13_hv_pmos[l]
print @n.xbgr.xm43_u3.nsg13_hv_pmos[delvto]
print @n.xbgr.xm43_u3.nsg13_hv_pmos[factuo]
print @n.xbgr.xm43_u4.nsg13_hv_pmos[w]
print @n.xbgr.xm43_u4.nsg13_hv_pmos[l]
print @n.xbgr.xm43_u4.nsg13_hv_pmos[delvto]
print @n.xbgr.xm43_u4.nsg13_hv_pmos[factuo]
print @n.xbgr.xm44_u2.nsg13_hv_pmos[w]
print @n.xbgr.xm44_u2.nsg13_hv_pmos[l]
print @n.xbgr.xm44_u2.nsg13_hv_pmos[delvto]
print @n.xbgr.xm44_u2.nsg13_hv_pmos[factuo]
print @n.xbgr.xm44_u3.nsg13_hv_pmos[w]
print @n.xbgr.xm44_u3.nsg13_hv_pmos[l]
print @n.xbgr.xm44_u3.nsg13_hv_pmos[delvto]
print @n.xbgr.xm44_u3.nsg13_hv_pmos[factuo]
print @n.xbgr.xm44_u4.nsg13_hv_pmos[w]
print @n.xbgr.xm44_u4.nsg13_hv_pmos[l]
print @n.xbgr.xm44_u4.nsg13_hv_pmos[delvto]
print @n.xbgr.xm44_u4.nsg13_hv_pmos[factuo]
print @n.xbgr.xm45_u2.nsg13_hv_pmos[w]
print @n.xbgr.xm45_u2.nsg13_hv_pmos[l]
print @n.xbgr.xm45_u2.nsg13_hv_pmos[delvto]
print @n.xbgr.xm45_u2.nsg13_hv_pmos[factuo]
print @n.xbgr.xm45_u3.nsg13_hv_pmos[w]
print @n.xbgr.xm45_u3.nsg13_hv_pmos[l]
print @n.xbgr.xm45_u3.nsg13_hv_pmos[delvto]
print @n.xbgr.xm45_u3.nsg13_hv_pmos[factuo]
print @n.xbgr.xm45_u4.nsg13_hv_pmos[w]
print @n.xbgr.xm45_u4.nsg13_hv_pmos[l]
print @n.xbgr.xm45_u4.nsg13_hv_pmos[delvto]
print @n.xbgr.xm45_u4.nsg13_hv_pmos[factuo]
print @n.xbgr.xm45_u5.nsg13_hv_pmos[w]
print @n.xbgr.xm45_u5.nsg13_hv_pmos[l]
print @n.xbgr.xm45_u5.nsg13_hv_pmos[delvto]
print @n.xbgr.xm45_u5.nsg13_hv_pmos[factuo]
print @n.xbgr.xm45_u6.nsg13_hv_pmos[w]
print @n.xbgr.xm45_u6.nsg13_hv_pmos[l]
print @n.xbgr.xm45_u6.nsg13_hv_pmos[delvto]
print @n.xbgr.xm45_u6.nsg13_hv_pmos[factuo]
print @n.xbgr.xm45_u7.nsg13_hv_pmos[w]
print @n.xbgr.xm45_u7.nsg13_hv_pmos[l]
print @n.xbgr.xm45_u7.nsg13_hv_pmos[delvto]
print @n.xbgr.xm45_u7.nsg13_hv_pmos[factuo]
print @n.xbgr.xm45_u8.nsg13_hv_pmos[w]
print @n.xbgr.xm45_u8.nsg13_hv_pmos[l]
print @n.xbgr.xm45_u8.nsg13_hv_pmos[delvto]
print @n.xbgr.xm45_u8.nsg13_hv_pmos[factuo]
print @n.xbgr.xm45_u9.nsg13_hv_pmos[w]
print @n.xbgr.xm45_u9.nsg13_hv_pmos[l]
print @n.xbgr.xm45_u9.nsg13_hv_pmos[delvto]
print @n.xbgr.xm45_u9.nsg13_hv_pmos[factuo]
print @n.xbgr.xm45_u10.nsg13_hv_pmos[w]
print @n.xbgr.xm45_u10.nsg13_hv_pmos[l]
print @n.xbgr.xm45_u10.nsg13_hv_pmos[delvto]
print @n.xbgr.xm45_u10.nsg13_hv_pmos[factuo]
print @n.xbgr.xm45_u11.nsg13_hv_pmos[w]
print @n.xbgr.xm45_u11.nsg13_hv_pmos[l]
print @n.xbgr.xm45_u11.nsg13_hv_pmos[delvto]
print @n.xbgr.xm45_u11.nsg13_hv_pmos[factuo]
print @n.xbgr.xm45_u12.nsg13_hv_pmos[w]
print @n.xbgr.xm45_u12.nsg13_hv_pmos[l]
print @n.xbgr.xm45_u12.nsg13_hv_pmos[delvto]
print @n.xbgr.xm45_u12.nsg13_hv_pmos[factuo]
print @n.xbgr.xm45_u13.nsg13_hv_pmos[w]
print @n.xbgr.xm45_u13.nsg13_hv_pmos[l]
print @n.xbgr.xm45_u13.nsg13_hv_pmos[delvto]
print @n.xbgr.xm45_u13.nsg13_hv_pmos[factuo]
print @n.xbgr.xm45_u14.nsg13_hv_pmos[w]
print @n.xbgr.xm45_u14.nsg13_hv_pmos[l]
print @n.xbgr.xm45_u14.nsg13_hv_pmos[delvto]
print @n.xbgr.xm45_u14.nsg13_hv_pmos[factuo]
print @n.xbgr.xm45_u15.nsg13_hv_pmos[w]
print @n.xbgr.xm45_u15.nsg13_hv_pmos[l]
print @n.xbgr.xm45_u15.nsg13_hv_pmos[delvto]
print @n.xbgr.xm45_u15.nsg13_hv_pmos[factuo]
print @n.xbgr.xm45_u16.nsg13_hv_pmos[w]
print @n.xbgr.xm45_u16.nsg13_hv_pmos[l]
print @n.xbgr.xm45_u16.nsg13_hv_pmos[delvto]
print @n.xbgr.xm45_u16.nsg13_hv_pmos[factuo]
print @n.xbgr.xm45_u17.nsg13_hv_pmos[w]
print @n.xbgr.xm45_u17.nsg13_hv_pmos[l]
print @n.xbgr.xm45_u17.nsg13_hv_pmos[delvto]
print @n.xbgr.xm45_u17.nsg13_hv_pmos[factuo]
print @n.xbgr.xm45_u18.nsg13_hv_pmos[w]
print @n.xbgr.xm45_u18.nsg13_hv_pmos[l]
print @n.xbgr.xm45_u18.nsg13_hv_pmos[delvto]
print @n.xbgr.xm45_u18.nsg13_hv_pmos[factuo]
print @n.xbgr.xm45_u19.nsg13_hv_pmos[w]
print @n.xbgr.xm45_u19.nsg13_hv_pmos[l]
print @n.xbgr.xm45_u19.nsg13_hv_pmos[delvto]
print @n.xbgr.xm45_u19.nsg13_hv_pmos[factuo]
print @n.xbgr.xm45_u20.nsg13_hv_pmos[w]
print @n.xbgr.xm45_u20.nsg13_hv_pmos[l]
print @n.xbgr.xm45_u20.nsg13_hv_pmos[delvto]
print @n.xbgr.xm45_u20.nsg13_hv_pmos[factuo]
print @n.xbgr.xm45_u21.nsg13_hv_pmos[w]
print @n.xbgr.xm45_u21.nsg13_hv_pmos[l]
print @n.xbgr.xm45_u21.nsg13_hv_pmos[delvto]
print @n.xbgr.xm45_u21.nsg13_hv_pmos[factuo]
print @n.xbgr.xm45_u22.nsg13_hv_pmos[w]
print @n.xbgr.xm45_u22.nsg13_hv_pmos[l]
print @n.xbgr.xm45_u22.nsg13_hv_pmos[delvto]
print @n.xbgr.xm45_u22.nsg13_hv_pmos[factuo]
print @n.xbgr.xm45_u23.nsg13_hv_pmos[w]
print @n.xbgr.xm45_u23.nsg13_hv_pmos[l]
print @n.xbgr.xm45_u23.nsg13_hv_pmos[delvto]
print @n.xbgr.xm45_u23.nsg13_hv_pmos[factuo]
print @n.xbgr.xm45_u24.nsg13_hv_pmos[w]
print @n.xbgr.xm45_u24.nsg13_hv_pmos[l]
print @n.xbgr.xm45_u24.nsg13_hv_pmos[delvto]
print @n.xbgr.xm45_u24.nsg13_hv_pmos[factuo]
print @n.xbgr.xm47_u2.nsg13_hv_pmos[w]
print @n.xbgr.xm47_u2.nsg13_hv_pmos[l]
print @n.xbgr.xm47_u2.nsg13_hv_pmos[delvto]
print @n.xbgr.xm47_u2.nsg13_hv_pmos[factuo]
print @n.xbgr.xm47_u3.nsg13_hv_pmos[w]
print @n.xbgr.xm47_u3.nsg13_hv_pmos[l]
print @n.xbgr.xm47_u3.nsg13_hv_pmos[delvto]
print @n.xbgr.xm47_u3.nsg13_hv_pmos[factuo]
print @n.xbgr.xm47_u4.nsg13_hv_pmos[w]
print @n.xbgr.xm47_u4.nsg13_hv_pmos[l]
print @n.xbgr.xm47_u4.nsg13_hv_pmos[delvto]
print @n.xbgr.xm47_u4.nsg13_hv_pmos[factuo]
print @n.xbgr.xm47_u5.nsg13_hv_pmos[w]
print @n.xbgr.xm47_u5.nsg13_hv_pmos[l]
print @n.xbgr.xm47_u5.nsg13_hv_pmos[delvto]
print @n.xbgr.xm47_u5.nsg13_hv_pmos[factuo]
print @n.xbgr.xm47_u6.nsg13_hv_pmos[w]
print @n.xbgr.xm47_u6.nsg13_hv_pmos[l]
print @n.xbgr.xm47_u6.nsg13_hv_pmos[delvto]
print @n.xbgr.xm47_u6.nsg13_hv_pmos[factuo]
print @n.xbgr.xm47_u7.nsg13_hv_pmos[w]
print @n.xbgr.xm47_u7.nsg13_hv_pmos[l]
print @n.xbgr.xm47_u7.nsg13_hv_pmos[delvto]
print @n.xbgr.xm47_u7.nsg13_hv_pmos[factuo]
print @n.xbgr.xm47_u8.nsg13_hv_pmos[w]
print @n.xbgr.xm47_u8.nsg13_hv_pmos[l]
print @n.xbgr.xm47_u8.nsg13_hv_pmos[delvto]
print @n.xbgr.xm47_u8.nsg13_hv_pmos[factuo]
print @n.xbgr.xm47_u9.nsg13_hv_pmos[w]
print @n.xbgr.xm47_u9.nsg13_hv_pmos[l]
print @n.xbgr.xm47_u9.nsg13_hv_pmos[delvto]
print @n.xbgr.xm47_u9.nsg13_hv_pmos[factuo]
print @n.xbgr.xm47_u10.nsg13_hv_pmos[w]
print @n.xbgr.xm47_u10.nsg13_hv_pmos[l]
print @n.xbgr.xm47_u10.nsg13_hv_pmos[delvto]
print @n.xbgr.xm47_u10.nsg13_hv_pmos[factuo]
print @n.xbgr.xm47_u11.nsg13_hv_pmos[w]
print @n.xbgr.xm47_u11.nsg13_hv_pmos[l]
print @n.xbgr.xm47_u11.nsg13_hv_pmos[delvto]
print @n.xbgr.xm47_u11.nsg13_hv_pmos[factuo]
print @n.xbgr.xm47_u12.nsg13_hv_pmos[w]
print @n.xbgr.xm47_u12.nsg13_hv_pmos[l]
print @n.xbgr.xm47_u12.nsg13_hv_pmos[delvto]
print @n.xbgr.xm47_u12.nsg13_hv_pmos[factuo]
print @n.xbgr.xm47_u13.nsg13_hv_pmos[w]
print @n.xbgr.xm47_u13.nsg13_hv_pmos[l]
print @n.xbgr.xm47_u13.nsg13_hv_pmos[delvto]
print @n.xbgr.xm47_u13.nsg13_hv_pmos[factuo]
print @n.xbgr.xm47_u14.nsg13_hv_pmos[w]
print @n.xbgr.xm47_u14.nsg13_hv_pmos[l]
print @n.xbgr.xm47_u14.nsg13_hv_pmos[delvto]
print @n.xbgr.xm47_u14.nsg13_hv_pmos[factuo]
print @n.xbgr.xm47_u15.nsg13_hv_pmos[w]
print @n.xbgr.xm47_u15.nsg13_hv_pmos[l]
print @n.xbgr.xm47_u15.nsg13_hv_pmos[delvto]
print @n.xbgr.xm47_u15.nsg13_hv_pmos[factuo]
print @n.xbgr.xm47_u16.nsg13_hv_pmos[w]
print @n.xbgr.xm47_u16.nsg13_hv_pmos[l]
print @n.xbgr.xm47_u16.nsg13_hv_pmos[delvto]
print @n.xbgr.xm47_u16.nsg13_hv_pmos[factuo]
print @n.xbgr.xm47_u17.nsg13_hv_pmos[w]
print @n.xbgr.xm47_u17.nsg13_hv_pmos[l]
print @n.xbgr.xm47_u17.nsg13_hv_pmos[delvto]
print @n.xbgr.xm47_u17.nsg13_hv_pmos[factuo]
print @n.xbgr.xm47_u18.nsg13_hv_pmos[w]
print @n.xbgr.xm47_u18.nsg13_hv_pmos[l]
print @n.xbgr.xm47_u18.nsg13_hv_pmos[delvto]
print @n.xbgr.xm47_u18.nsg13_hv_pmos[factuo]
print @n.xbgr.xm47_u19.nsg13_hv_pmos[w]
print @n.xbgr.xm47_u19.nsg13_hv_pmos[l]
print @n.xbgr.xm47_u19.nsg13_hv_pmos[delvto]
print @n.xbgr.xm47_u19.nsg13_hv_pmos[factuo]
print @n.xbgr.xm47_u20.nsg13_hv_pmos[w]
print @n.xbgr.xm47_u20.nsg13_hv_pmos[l]
print @n.xbgr.xm47_u20.nsg13_hv_pmos[delvto]
print @n.xbgr.xm47_u20.nsg13_hv_pmos[factuo]
print @n.xbgr.xm47_u21.nsg13_hv_pmos[w]
print @n.xbgr.xm47_u21.nsg13_hv_pmos[l]
print @n.xbgr.xm47_u21.nsg13_hv_pmos[delvto]
print @n.xbgr.xm47_u21.nsg13_hv_pmos[factuo]
print @n.xbgr.xm47_u22.nsg13_hv_pmos[w]
print @n.xbgr.xm47_u22.nsg13_hv_pmos[l]
print @n.xbgr.xm47_u22.nsg13_hv_pmos[delvto]
print @n.xbgr.xm47_u22.nsg13_hv_pmos[factuo]
print @n.xbgr.xm47_u23.nsg13_hv_pmos[w]
print @n.xbgr.xm47_u23.nsg13_hv_pmos[l]
print @n.xbgr.xm47_u23.nsg13_hv_pmos[delvto]
print @n.xbgr.xm47_u23.nsg13_hv_pmos[factuo]
print @n.xbgr.xm47_u24.nsg13_hv_pmos[w]
print @n.xbgr.xm47_u24.nsg13_hv_pmos[l]
print @n.xbgr.xm47_u24.nsg13_hv_pmos[delvto]
print @n.xbgr.xm47_u24.nsg13_hv_pmos[factuo]
print @n.xbgr.xm48_u2.nsg13_hv_pmos[w]
print @n.xbgr.xm48_u2.nsg13_hv_pmos[l]
print @n.xbgr.xm48_u2.nsg13_hv_pmos[delvto]
print @n.xbgr.xm48_u2.nsg13_hv_pmos[factuo]
print @n.xbgr.xm48_u3.nsg13_hv_pmos[w]
print @n.xbgr.xm48_u3.nsg13_hv_pmos[l]
print @n.xbgr.xm48_u3.nsg13_hv_pmos[delvto]
print @n.xbgr.xm48_u3.nsg13_hv_pmos[factuo]
print @n.xbgr.xm48_u4.nsg13_hv_pmos[w]
print @n.xbgr.xm48_u4.nsg13_hv_pmos[l]
print @n.xbgr.xm48_u4.nsg13_hv_pmos[delvto]
print @n.xbgr.xm48_u4.nsg13_hv_pmos[factuo]
print @n.xbgr.xm48_u5.nsg13_hv_pmos[w]
print @n.xbgr.xm48_u5.nsg13_hv_pmos[l]
print @n.xbgr.xm48_u5.nsg13_hv_pmos[delvto]
print @n.xbgr.xm48_u5.nsg13_hv_pmos[factuo]
print @n.xbgr.xm48_u6.nsg13_hv_pmos[w]
print @n.xbgr.xm48_u6.nsg13_hv_pmos[l]
print @n.xbgr.xm48_u6.nsg13_hv_pmos[delvto]
print @n.xbgr.xm48_u6.nsg13_hv_pmos[factuo]
print @n.xbgr.xm48_u7.nsg13_hv_pmos[w]
print @n.xbgr.xm48_u7.nsg13_hv_pmos[l]
print @n.xbgr.xm48_u7.nsg13_hv_pmos[delvto]
print @n.xbgr.xm48_u7.nsg13_hv_pmos[factuo]
print @n.xbgr.xm48_u8.nsg13_hv_pmos[w]
print @n.xbgr.xm48_u8.nsg13_hv_pmos[l]
print @n.xbgr.xm48_u8.nsg13_hv_pmos[delvto]
print @n.xbgr.xm48_u8.nsg13_hv_pmos[factuo]
print @n.xbgr.xm48_u9.nsg13_hv_pmos[w]
print @n.xbgr.xm48_u9.nsg13_hv_pmos[l]
print @n.xbgr.xm48_u9.nsg13_hv_pmos[delvto]
print @n.xbgr.xm48_u9.nsg13_hv_pmos[factuo]
print @n.xbgr.xm48_u10.nsg13_hv_pmos[w]
print @n.xbgr.xm48_u10.nsg13_hv_pmos[l]
print @n.xbgr.xm48_u10.nsg13_hv_pmos[delvto]
print @n.xbgr.xm48_u10.nsg13_hv_pmos[factuo]
print @n.xbgr.xm48_u11.nsg13_hv_pmos[w]
print @n.xbgr.xm48_u11.nsg13_hv_pmos[l]
print @n.xbgr.xm48_u11.nsg13_hv_pmos[delvto]
print @n.xbgr.xm48_u11.nsg13_hv_pmos[factuo]
print @n.xbgr.xm48_u12.nsg13_hv_pmos[w]
print @n.xbgr.xm48_u12.nsg13_hv_pmos[l]
print @n.xbgr.xm48_u12.nsg13_hv_pmos[delvto]
print @n.xbgr.xm48_u12.nsg13_hv_pmos[factuo]
print @n.xbgr.xm48_u13.nsg13_hv_pmos[w]
print @n.xbgr.xm48_u13.nsg13_hv_pmos[l]
print @n.xbgr.xm48_u13.nsg13_hv_pmos[delvto]
print @n.xbgr.xm48_u13.nsg13_hv_pmos[factuo]
print @n.xbgr.xm48_u14.nsg13_hv_pmos[w]
print @n.xbgr.xm48_u14.nsg13_hv_pmos[l]
print @n.xbgr.xm48_u14.nsg13_hv_pmos[delvto]
print @n.xbgr.xm48_u14.nsg13_hv_pmos[factuo]
print @n.xbgr.xm48_u15.nsg13_hv_pmos[w]
print @n.xbgr.xm48_u15.nsg13_hv_pmos[l]
print @n.xbgr.xm48_u15.nsg13_hv_pmos[delvto]
print @n.xbgr.xm48_u15.nsg13_hv_pmos[factuo]
print @n.xbgr.xm48_u16.nsg13_hv_pmos[w]
print @n.xbgr.xm48_u16.nsg13_hv_pmos[l]
print @n.xbgr.xm48_u16.nsg13_hv_pmos[delvto]
print @n.xbgr.xm48_u16.nsg13_hv_pmos[factuo]
print @n.xbgr.xm48_u17.nsg13_hv_pmos[w]
print @n.xbgr.xm48_u17.nsg13_hv_pmos[l]
print @n.xbgr.xm48_u17.nsg13_hv_pmos[delvto]
print @n.xbgr.xm48_u17.nsg13_hv_pmos[factuo]
print @n.xbgr.xm48_u18.nsg13_hv_pmos[w]
print @n.xbgr.xm48_u18.nsg13_hv_pmos[l]
print @n.xbgr.xm48_u18.nsg13_hv_pmos[delvto]
print @n.xbgr.xm48_u18.nsg13_hv_pmos[factuo]
print @n.xbgr.xm48_u19.nsg13_hv_pmos[w]
print @n.xbgr.xm48_u19.nsg13_hv_pmos[l]
print @n.xbgr.xm48_u19.nsg13_hv_pmos[delvto]
print @n.xbgr.xm48_u19.nsg13_hv_pmos[factuo]
print @n.xbgr.xm48_u20.nsg13_hv_pmos[w]
print @n.xbgr.xm48_u20.nsg13_hv_pmos[l]
print @n.xbgr.xm48_u20.nsg13_hv_pmos[delvto]
print @n.xbgr.xm48_u20.nsg13_hv_pmos[factuo]
print @n.xbgr.xm48_u21.nsg13_hv_pmos[w]
print @n.xbgr.xm48_u21.nsg13_hv_pmos[l]
print @n.xbgr.xm48_u21.nsg13_hv_pmos[delvto]
print @n.xbgr.xm48_u21.nsg13_hv_pmos[factuo]
print @n.xbgr.xm48_u22.nsg13_hv_pmos[w]
print @n.xbgr.xm48_u22.nsg13_hv_pmos[l]
print @n.xbgr.xm48_u22.nsg13_hv_pmos[delvto]
print @n.xbgr.xm48_u22.nsg13_hv_pmos[factuo]
print @n.xbgr.xm48_u23.nsg13_hv_pmos[w]
print @n.xbgr.xm48_u23.nsg13_hv_pmos[l]
print @n.xbgr.xm48_u23.nsg13_hv_pmos[delvto]
print @n.xbgr.xm48_u23.nsg13_hv_pmos[factuo]
print @n.xbgr.xm48_u24.nsg13_hv_pmos[w]
print @n.xbgr.xm48_u24.nsg13_hv_pmos[l]
print @n.xbgr.xm48_u24.nsg13_hv_pmos[delvto]
print @n.xbgr.xm48_u24.nsg13_hv_pmos[factuo]
print @n.xbgr.xm50_u2.nsg13_hv_pmos[w]
print @n.xbgr.xm50_u2.nsg13_hv_pmos[l]
print @n.xbgr.xm50_u2.nsg13_hv_pmos[delvto]
print @n.xbgr.xm50_u2.nsg13_hv_pmos[factuo]
print @n.xbgr.xm50_u3.nsg13_hv_pmos[w]
print @n.xbgr.xm50_u3.nsg13_hv_pmos[l]
print @n.xbgr.xm50_u3.nsg13_hv_pmos[delvto]
print @n.xbgr.xm50_u3.nsg13_hv_pmos[factuo]
print @n.xbgr.xm50_u4.nsg13_hv_pmos[w]
print @n.xbgr.xm50_u4.nsg13_hv_pmos[l]
print @n.xbgr.xm50_u4.nsg13_hv_pmos[delvto]
print @n.xbgr.xm50_u4.nsg13_hv_pmos[factuo]
print @n.xbgr.xm50_u5.nsg13_hv_pmos[w]
print @n.xbgr.xm50_u5.nsg13_hv_pmos[l]
print @n.xbgr.xm50_u5.nsg13_hv_pmos[delvto]
print @n.xbgr.xm50_u5.nsg13_hv_pmos[factuo]
print @n.xbgr.xm50_u6.nsg13_hv_pmos[w]
print @n.xbgr.xm50_u6.nsg13_hv_pmos[l]
print @n.xbgr.xm50_u6.nsg13_hv_pmos[delvto]
print @n.xbgr.xm50_u6.nsg13_hv_pmos[factuo]
print @n.xbgr.xm50_u7.nsg13_hv_pmos[w]
print @n.xbgr.xm50_u7.nsg13_hv_pmos[l]
print @n.xbgr.xm50_u7.nsg13_hv_pmos[delvto]
print @n.xbgr.xm50_u7.nsg13_hv_pmos[factuo]
print @n.xbgr.xm50_u8.nsg13_hv_pmos[w]
print @n.xbgr.xm50_u8.nsg13_hv_pmos[l]
print @n.xbgr.xm50_u8.nsg13_hv_pmos[delvto]
print @n.xbgr.xm50_u8.nsg13_hv_pmos[factuo]
print @n.xbgr.xm50_u9.nsg13_hv_pmos[w]
print @n.xbgr.xm50_u9.nsg13_hv_pmos[l]
print @n.xbgr.xm50_u9.nsg13_hv_pmos[delvto]
print @n.xbgr.xm50_u9.nsg13_hv_pmos[factuo]
print @n.xbgr.xm50_u10.nsg13_hv_pmos[w]
print @n.xbgr.xm50_u10.nsg13_hv_pmos[l]
print @n.xbgr.xm50_u10.nsg13_hv_pmos[delvto]
print @n.xbgr.xm50_u10.nsg13_hv_pmos[factuo]
print @n.xbgr.xm50_u11.nsg13_hv_pmos[w]
print @n.xbgr.xm50_u11.nsg13_hv_pmos[l]
print @n.xbgr.xm50_u11.nsg13_hv_pmos[delvto]
print @n.xbgr.xm50_u11.nsg13_hv_pmos[factuo]
print @n.xbgr.xm50_u12.nsg13_hv_pmos[w]
print @n.xbgr.xm50_u12.nsg13_hv_pmos[l]
print @n.xbgr.xm50_u12.nsg13_hv_pmos[delvto]
print @n.xbgr.xm50_u12.nsg13_hv_pmos[factuo]
print @n.xbgr.xm50_u13.nsg13_hv_pmos[w]
print @n.xbgr.xm50_u13.nsg13_hv_pmos[l]
print @n.xbgr.xm50_u13.nsg13_hv_pmos[delvto]
print @n.xbgr.xm50_u13.nsg13_hv_pmos[factuo]
print @n.xbgr.xm50_u14.nsg13_hv_pmos[w]
print @n.xbgr.xm50_u14.nsg13_hv_pmos[l]
print @n.xbgr.xm50_u14.nsg13_hv_pmos[delvto]
print @n.xbgr.xm50_u14.nsg13_hv_pmos[factuo]
print @n.xbgr.xm50_u15.nsg13_hv_pmos[w]
print @n.xbgr.xm50_u15.nsg13_hv_pmos[l]
print @n.xbgr.xm50_u15.nsg13_hv_pmos[delvto]
print @n.xbgr.xm50_u15.nsg13_hv_pmos[factuo]
print @n.xbgr.xm50_u16.nsg13_hv_pmos[w]
print @n.xbgr.xm50_u16.nsg13_hv_pmos[l]
print @n.xbgr.xm50_u16.nsg13_hv_pmos[delvto]
print @n.xbgr.xm50_u16.nsg13_hv_pmos[factuo]
print @n.xbgr.xm50_u17.nsg13_hv_pmos[w]
print @n.xbgr.xm50_u17.nsg13_hv_pmos[l]
print @n.xbgr.xm50_u17.nsg13_hv_pmos[delvto]
print @n.xbgr.xm50_u17.nsg13_hv_pmos[factuo]
print @n.xbgr.xm50_u18.nsg13_hv_pmos[w]
print @n.xbgr.xm50_u18.nsg13_hv_pmos[l]
print @n.xbgr.xm50_u18.nsg13_hv_pmos[delvto]
print @n.xbgr.xm50_u18.nsg13_hv_pmos[factuo]
print @n.xbgr.xm50_u19.nsg13_hv_pmos[w]
print @n.xbgr.xm50_u19.nsg13_hv_pmos[l]
print @n.xbgr.xm50_u19.nsg13_hv_pmos[delvto]
print @n.xbgr.xm50_u19.nsg13_hv_pmos[factuo]
print @n.xbgr.xm50_u20.nsg13_hv_pmos[w]
print @n.xbgr.xm50_u20.nsg13_hv_pmos[l]
print @n.xbgr.xm50_u20.nsg13_hv_pmos[delvto]
print @n.xbgr.xm50_u20.nsg13_hv_pmos[factuo]
print @n.xbgr.xm50_u21.nsg13_hv_pmos[w]
print @n.xbgr.xm50_u21.nsg13_hv_pmos[l]
print @n.xbgr.xm50_u21.nsg13_hv_pmos[delvto]
print @n.xbgr.xm50_u21.nsg13_hv_pmos[factuo]
print @n.xbgr.xm50_u22.nsg13_hv_pmos[w]
print @n.xbgr.xm50_u22.nsg13_hv_pmos[l]
print @n.xbgr.xm50_u22.nsg13_hv_pmos[delvto]
print @n.xbgr.xm50_u22.nsg13_hv_pmos[factuo]
print @n.xbgr.xm50_u23.nsg13_hv_pmos[w]
print @n.xbgr.xm50_u23.nsg13_hv_pmos[l]
print @n.xbgr.xm50_u23.nsg13_hv_pmos[delvto]
print @n.xbgr.xm50_u23.nsg13_hv_pmos[factuo]
print @n.xbgr.xm50_u24.nsg13_hv_pmos[w]
print @n.xbgr.xm50_u24.nsg13_hv_pmos[l]
print @n.xbgr.xm50_u24.nsg13_hv_pmos[delvto]
print @n.xbgr.xm50_u24.nsg13_hv_pmos[factuo]
print @n.xbgr.xm51_u2.nsg13_hv_pmos[w]
print @n.xbgr.xm51_u2.nsg13_hv_pmos[l]
print @n.xbgr.xm51_u2.nsg13_hv_pmos[delvto]
print @n.xbgr.xm51_u2.nsg13_hv_pmos[factuo]
print @n.xbgr.xm51_u3.nsg13_hv_pmos[w]
print @n.xbgr.xm51_u3.nsg13_hv_pmos[l]
print @n.xbgr.xm51_u3.nsg13_hv_pmos[delvto]
print @n.xbgr.xm51_u3.nsg13_hv_pmos[factuo]
print @n.xbgr.xm51_u4.nsg13_hv_pmos[w]
print @n.xbgr.xm51_u4.nsg13_hv_pmos[l]
print @n.xbgr.xm51_u4.nsg13_hv_pmos[delvto]
print @n.xbgr.xm51_u4.nsg13_hv_pmos[factuo]
print @n.xbgr.xm52_u2.nsg13_hv_pmos[w]
print @n.xbgr.xm52_u2.nsg13_hv_pmos[l]
print @n.xbgr.xm52_u2.nsg13_hv_pmos[delvto]
print @n.xbgr.xm52_u2.nsg13_hv_pmos[factuo]
print @n.xbgr.xm52_u3.nsg13_hv_pmos[w]
print @n.xbgr.xm52_u3.nsg13_hv_pmos[l]
print @n.xbgr.xm52_u3.nsg13_hv_pmos[delvto]
print @n.xbgr.xm52_u3.nsg13_hv_pmos[factuo]
print @n.xbgr.xm52_u4.nsg13_hv_pmos[w]
print @n.xbgr.xm52_u4.nsg13_hv_pmos[l]
print @n.xbgr.xm52_u4.nsg13_hv_pmos[delvto]
print @n.xbgr.xm52_u4.nsg13_hv_pmos[factuo]
print @n.xbgr.xm52_u5.nsg13_hv_pmos[w]
print @n.xbgr.xm52_u5.nsg13_hv_pmos[l]
print @n.xbgr.xm52_u5.nsg13_hv_pmos[delvto]
print @n.xbgr.xm52_u5.nsg13_hv_pmos[factuo]
print @n.xbgr.xm52_u6.nsg13_hv_pmos[w]
print @n.xbgr.xm52_u6.nsg13_hv_pmos[l]
print @n.xbgr.xm52_u6.nsg13_hv_pmos[delvto]
print @n.xbgr.xm52_u6.nsg13_hv_pmos[factuo]
print @n.xbgr.xm52_u7.nsg13_hv_pmos[w]
print @n.xbgr.xm52_u7.nsg13_hv_pmos[l]
print @n.xbgr.xm52_u7.nsg13_hv_pmos[delvto]
print @n.xbgr.xm52_u7.nsg13_hv_pmos[factuo]
print @n.xbgr.xm52_u8.nsg13_hv_pmos[w]
print @n.xbgr.xm52_u8.nsg13_hv_pmos[l]
print @n.xbgr.xm52_u8.nsg13_hv_pmos[delvto]
print @n.xbgr.xm52_u8.nsg13_hv_pmos[factuo]
print @n.xbgr.xm52_u9.nsg13_hv_pmos[w]
print @n.xbgr.xm52_u9.nsg13_hv_pmos[l]
print @n.xbgr.xm52_u9.nsg13_hv_pmos[delvto]
print @n.xbgr.xm52_u9.nsg13_hv_pmos[factuo]
print @n.xbgr.xm52_u10.nsg13_hv_pmos[w]
print @n.xbgr.xm52_u10.nsg13_hv_pmos[l]
print @n.xbgr.xm52_u10.nsg13_hv_pmos[delvto]
print @n.xbgr.xm52_u10.nsg13_hv_pmos[factuo]
print @n.xbgr.xm52_u11.nsg13_hv_pmos[w]
print @n.xbgr.xm52_u11.nsg13_hv_pmos[l]
print @n.xbgr.xm52_u11.nsg13_hv_pmos[delvto]
print @n.xbgr.xm52_u11.nsg13_hv_pmos[factuo]
print @n.xbgr.xm52_u12.nsg13_hv_pmos[w]
print @n.xbgr.xm52_u12.nsg13_hv_pmos[l]
print @n.xbgr.xm52_u12.nsg13_hv_pmos[delvto]
print @n.xbgr.xm52_u12.nsg13_hv_pmos[factuo]
print @n.xbgr.xm52_u13.nsg13_hv_pmos[w]
print @n.xbgr.xm52_u13.nsg13_hv_pmos[l]
print @n.xbgr.xm52_u13.nsg13_hv_pmos[delvto]
print @n.xbgr.xm52_u13.nsg13_hv_pmos[factuo]
print @n.xbgr.xm52_u14.nsg13_hv_pmos[w]
print @n.xbgr.xm52_u14.nsg13_hv_pmos[l]
print @n.xbgr.xm52_u14.nsg13_hv_pmos[delvto]
print @n.xbgr.xm52_u14.nsg13_hv_pmos[factuo]
print @n.xbgr.xm52_u15.nsg13_hv_pmos[w]
print @n.xbgr.xm52_u15.nsg13_hv_pmos[l]
print @n.xbgr.xm52_u15.nsg13_hv_pmos[delvto]
print @n.xbgr.xm52_u15.nsg13_hv_pmos[factuo]
print @n.xbgr.xm52_u16.nsg13_hv_pmos[w]
print @n.xbgr.xm52_u16.nsg13_hv_pmos[l]
print @n.xbgr.xm52_u16.nsg13_hv_pmos[delvto]
print @n.xbgr.xm52_u16.nsg13_hv_pmos[factuo]
print @n.xbgr.xm52_u17.nsg13_hv_pmos[w]
print @n.xbgr.xm52_u17.nsg13_hv_pmos[l]
print @n.xbgr.xm52_u17.nsg13_hv_pmos[delvto]
print @n.xbgr.xm52_u17.nsg13_hv_pmos[factuo]
print @n.xbgr.xm52_u18.nsg13_hv_pmos[w]
print @n.xbgr.xm52_u18.nsg13_hv_pmos[l]
print @n.xbgr.xm52_u18.nsg13_hv_pmos[delvto]
print @n.xbgr.xm52_u18.nsg13_hv_pmos[factuo]
print @n.xbgr.xm52_u19.nsg13_hv_pmos[w]
print @n.xbgr.xm52_u19.nsg13_hv_pmos[l]
print @n.xbgr.xm52_u19.nsg13_hv_pmos[delvto]
print @n.xbgr.xm52_u19.nsg13_hv_pmos[factuo]
print @n.xbgr.xm52_u20.nsg13_hv_pmos[w]
print @n.xbgr.xm52_u20.nsg13_hv_pmos[l]
print @n.xbgr.xm52_u20.nsg13_hv_pmos[delvto]
print @n.xbgr.xm52_u20.nsg13_hv_pmos[factuo]
print @n.xbgr.xm52_u21.nsg13_hv_pmos[w]
print @n.xbgr.xm52_u21.nsg13_hv_pmos[l]
print @n.xbgr.xm52_u21.nsg13_hv_pmos[delvto]
print @n.xbgr.xm52_u21.nsg13_hv_pmos[factuo]
print @n.xbgr.xm52_u22.nsg13_hv_pmos[w]
print @n.xbgr.xm52_u22.nsg13_hv_pmos[l]
print @n.xbgr.xm52_u22.nsg13_hv_pmos[delvto]
print @n.xbgr.xm52_u22.nsg13_hv_pmos[factuo]
print @n.xbgr.xm52_u23.nsg13_hv_pmos[w]
print @n.xbgr.xm52_u23.nsg13_hv_pmos[l]
print @n.xbgr.xm52_u23.nsg13_hv_pmos[delvto]
print @n.xbgr.xm52_u23.nsg13_hv_pmos[factuo]
print @n.xbgr.xm52_u24.nsg13_hv_pmos[w]
print @n.xbgr.xm52_u24.nsg13_hv_pmos[l]
print @n.xbgr.xm52_u24.nsg13_hv_pmos[delvto]
print @n.xbgr.xm52_u24.nsg13_hv_pmos[factuo]
print @n.xbgr.xm54_u2.nsg13_hv_pmos[w]
print @n.xbgr.xm54_u2.nsg13_hv_pmos[l]
print @n.xbgr.xm54_u2.nsg13_hv_pmos[delvto]
print @n.xbgr.xm54_u2.nsg13_hv_pmos[factuo]
print @n.xbgr.xm54_u3.nsg13_hv_pmos[w]
print @n.xbgr.xm54_u3.nsg13_hv_pmos[l]
print @n.xbgr.xm54_u3.nsg13_hv_pmos[delvto]
print @n.xbgr.xm54_u3.nsg13_hv_pmos[factuo]
print @n.xbgr.xm54_u4.nsg13_hv_pmos[w]
print @n.xbgr.xm54_u4.nsg13_hv_pmos[l]
print @n.xbgr.xm54_u4.nsg13_hv_pmos[delvto]
print @n.xbgr.xm54_u4.nsg13_hv_pmos[factuo]
print @n.xbgr.xm54_u5.nsg13_hv_pmos[w]
print @n.xbgr.xm54_u5.nsg13_hv_pmos[l]
print @n.xbgr.xm54_u5.nsg13_hv_pmos[delvto]
print @n.xbgr.xm54_u5.nsg13_hv_pmos[factuo]
print @n.xbgr.xm54_u6.nsg13_hv_pmos[w]
print @n.xbgr.xm54_u6.nsg13_hv_pmos[l]
print @n.xbgr.xm54_u6.nsg13_hv_pmos[delvto]
print @n.xbgr.xm54_u6.nsg13_hv_pmos[factuo]
print @n.xbgr.xm54_u7.nsg13_hv_pmos[w]
print @n.xbgr.xm54_u7.nsg13_hv_pmos[l]
print @n.xbgr.xm54_u7.nsg13_hv_pmos[delvto]
print @n.xbgr.xm54_u7.nsg13_hv_pmos[factuo]
print @n.xbgr.xm54_u8.nsg13_hv_pmos[w]
print @n.xbgr.xm54_u8.nsg13_hv_pmos[l]
print @n.xbgr.xm54_u8.nsg13_hv_pmos[delvto]
print @n.xbgr.xm54_u8.nsg13_hv_pmos[factuo]
print @n.xbgr.xm54_u9.nsg13_hv_pmos[w]
print @n.xbgr.xm54_u9.nsg13_hv_pmos[l]
print @n.xbgr.xm54_u9.nsg13_hv_pmos[delvto]
print @n.xbgr.xm54_u9.nsg13_hv_pmos[factuo]
print @n.xbgr.xm54_u10.nsg13_hv_pmos[w]
print @n.xbgr.xm54_u10.nsg13_hv_pmos[l]
print @n.xbgr.xm54_u10.nsg13_hv_pmos[delvto]
print @n.xbgr.xm54_u10.nsg13_hv_pmos[factuo]
print @n.xbgr.xm54_u11.nsg13_hv_pmos[w]
print @n.xbgr.xm54_u11.nsg13_hv_pmos[l]
print @n.xbgr.xm54_u11.nsg13_hv_pmos[delvto]
print @n.xbgr.xm54_u11.nsg13_hv_pmos[factuo]
print @n.xbgr.xm54_u12.nsg13_hv_pmos[w]
print @n.xbgr.xm54_u12.nsg13_hv_pmos[l]
print @n.xbgr.xm54_u12.nsg13_hv_pmos[delvto]
print @n.xbgr.xm54_u12.nsg13_hv_pmos[factuo]
print @n.xbgr.xm54_u13.nsg13_hv_pmos[w]
print @n.xbgr.xm54_u13.nsg13_hv_pmos[l]
print @n.xbgr.xm54_u13.nsg13_hv_pmos[delvto]
print @n.xbgr.xm54_u13.nsg13_hv_pmos[factuo]
print @n.xbgr.xm54_u14.nsg13_hv_pmos[w]
print @n.xbgr.xm54_u14.nsg13_hv_pmos[l]
print @n.xbgr.xm54_u14.nsg13_hv_pmos[delvto]
print @n.xbgr.xm54_u14.nsg13_hv_pmos[factuo]
print @n.xbgr.xm54_u15.nsg13_hv_pmos[w]
print @n.xbgr.xm54_u15.nsg13_hv_pmos[l]
print @n.xbgr.xm54_u15.nsg13_hv_pmos[delvto]
print @n.xbgr.xm54_u15.nsg13_hv_pmos[factuo]
print @n.xbgr.xm54_u16.nsg13_hv_pmos[w]
print @n.xbgr.xm54_u16.nsg13_hv_pmos[l]
print @n.xbgr.xm54_u16.nsg13_hv_pmos[delvto]
print @n.xbgr.xm54_u16.nsg13_hv_pmos[factuo]
print @n.xbgr.xm54_u17.nsg13_hv_pmos[w]
print @n.xbgr.xm54_u17.nsg13_hv_pmos[l]
print @n.xbgr.xm54_u17.nsg13_hv_pmos[delvto]
print @n.xbgr.xm54_u17.nsg13_hv_pmos[factuo]
print @n.xbgr.xm54_u18.nsg13_hv_pmos[w]
print @n.xbgr.xm54_u18.nsg13_hv_pmos[l]
print @n.xbgr.xm54_u18.nsg13_hv_pmos[delvto]
print @n.xbgr.xm54_u18.nsg13_hv_pmos[factuo]
print @n.xbgr.xm54_u19.nsg13_hv_pmos[w]
print @n.xbgr.xm54_u19.nsg13_hv_pmos[l]
print @n.xbgr.xm54_u19.nsg13_hv_pmos[delvto]
print @n.xbgr.xm54_u19.nsg13_hv_pmos[factuo]
print @n.xbgr.xm54_u20.nsg13_hv_pmos[w]
print @n.xbgr.xm54_u20.nsg13_hv_pmos[l]
print @n.xbgr.xm54_u20.nsg13_hv_pmos[delvto]
print @n.xbgr.xm54_u20.nsg13_hv_pmos[factuo]
print @n.xbgr.xm54_u21.nsg13_hv_pmos[w]
print @n.xbgr.xm54_u21.nsg13_hv_pmos[l]
print @n.xbgr.xm54_u21.nsg13_hv_pmos[delvto]
print @n.xbgr.xm54_u21.nsg13_hv_pmos[factuo]
print @n.xbgr.xm54_u22.nsg13_hv_pmos[w]
print @n.xbgr.xm54_u22.nsg13_hv_pmos[l]
print @n.xbgr.xm54_u22.nsg13_hv_pmos[delvto]
print @n.xbgr.xm54_u22.nsg13_hv_pmos[factuo]
print @n.xbgr.xm54_u23.nsg13_hv_pmos[w]
print @n.xbgr.xm54_u23.nsg13_hv_pmos[l]
print @n.xbgr.xm54_u23.nsg13_hv_pmos[delvto]
print @n.xbgr.xm54_u23.nsg13_hv_pmos[factuo]
print @n.xbgr.xm54_u24.nsg13_hv_pmos[w]
print @n.xbgr.xm54_u24.nsg13_hv_pmos[l]
print @n.xbgr.xm54_u24.nsg13_hv_pmos[delvto]
print @n.xbgr.xm54_u24.nsg13_hv_pmos[factuo]
print @q.xbgr.xq56_u2.qnpn13g2[area]
print @q.xbgr.xq56_u3.qnpn13g2[area]
print @q.xbgr.xq56_u4.qnpn13g2[area]
print @q.xbgr.xq56_u5.qnpn13g2[area]
print @q.xbgr.xq56_u6.qnpn13g2[area]
print @q.xbgr.xq56_u7.qnpn13g2[area]
print @q.xbgr.xq56_u8.qnpn13g2[area]
print @q.xbgr.xq56_u9.qnpn13g2[area]
print @q.xbgr.xq56_u10.qnpn13g2[area]
print @q.xbgr.xq56_u11.qnpn13g2[area]
print @q.xbgr.xq56_u12.qnpn13g2[area]
print @q.xbgr.xq56_u13.qnpn13g2[area]
print @q.xbgr.xq56_u14.qnpn13g2[area]
print @q.xbgr.xq56_u15.qnpn13g2[area]
print @q.xbgr.xq56_u16.qnpn13g2[area]
print @q.xbgr.xq56_u17.qnpn13g2[area]
print @q.xbgr.xq56_u18.qnpn13g2[area]
print @q.xbgr.xq56_u19.qnpn13g2[area]
print @q.xbgr.xq56_u20.qnpn13g2[area]
print @q.xbgr.xq56_u21.qnpn13g2[area]
print @q.xbgr.xq56_u22.qnpn13g2[area]
print @q.xbgr.xq56_u23.qnpn13g2[area]
print @q.xbgr.xq56_u24.qnpn13g2[area]
print @q.xbgr.xq60_u2.qnpn13g2[area]
print @q.xbgr.xq60_u3.qnpn13g2[area]
print @q.xbgr.xq60_u4.qnpn13g2[area]
print @q.xbgr.xq62_u2.qnpn13g2[area]
print @q.xbgr.xq62_u3.qnpn13g2[area]
print @q.xbgr.xq62_u4.qnpn13g2[area]
print @q.xbgr.xq62_u5.qnpn13g2[area]
print @q.xbgr.xq62_u6.qnpn13g2[area]
print @q.xbgr.xq62_u7.qnpn13g2[area]
print @q.xbgr.xq62_u8.qnpn13g2[area]
print @q.xbgr.xq62_u9.qnpn13g2[area]
print @q.xbgr.xq62_u10.qnpn13g2[area]
print @q.xbgr.xq62_u11.qnpn13g2[area]
print @q.xbgr.xq62_u12.qnpn13g2[area]
print @q.xbgr.xq62_u13.qnpn13g2[area]
print @q.xbgr.xq62_u14.qnpn13g2[area]
print @q.xbgr.xq62_u15.qnpn13g2[area]
print @q.xbgr.xq62_u16.qnpn13g2[area]
print @q.xbgr.xq62_u17.qnpn13g2[area]
print @q.xbgr.xq62_u18.qnpn13g2[area]
print @q.xbgr.xq62_u19.qnpn13g2[area]
print @q.xbgr.xq62_u20.qnpn13g2[area]
print @q.xbgr.xq62_u21.qnpn13g2[area]
print @q.xbgr.xq62_u22.qnpn13g2[area]
print @q.xbgr.xq62_u23.qnpn13g2[area]
print @q.xbgr.xq62_u24.qnpn13g2[area]
print @q.xbgr.xq67_u2.qnpn13g2[area]
print @q.xbgr.xq67_u3.qnpn13g2[area]
print @q.xbgr.xq67_u4.qnpn13g2[area]
print @q.xbgr.xq67_u5.qnpn13g2[area]
print @q.xbgr.xq67_u6.qnpn13g2[area]
print @q.xbgr.xq67_u7.qnpn13g2[area]
print @q.xbgr.xq67_u8.qnpn13g2[area]
print @q.xbgr.xq67_u9.qnpn13g2[area]
print @q.xbgr.xq67_u10.qnpn13g2[area]
print @q.xbgr.xq67_u11.qnpn13g2[area]
print @q.xbgr.xq67_u12.qnpn13g2[area]
print @q.xbgr.xq67_u13.qnpn13g2[area]
print @q.xbgr.xq67_u14.qnpn13g2[area]
print @q.xbgr.xq67_u15.qnpn13g2[area]
print @q.xbgr.xq67_u16.qnpn13g2[area]
print @q.xbgr.xq67_u17.qnpn13g2[area]
print @q.xbgr.xq67_u18.qnpn13g2[area]
print @q.xbgr.xq67_u19.qnpn13g2[area]
print @q.xbgr.xq67_u20.qnpn13g2[area]
print @q.xbgr.xq67_u21.qnpn13g2[area]
print @q.xbgr.xq67_u22.qnpn13g2[area]
print @q.xbgr.xq67_u23.qnpn13g2[area]
print @q.xbgr.xq67_u24.qnpn13g2[area]
print @q.xbgr.xq68_u2.qnpn13g2[area]
print @q.xbgr.xq68_u3.qnpn13g2[area]
print @q.xbgr.xq68_u4.qnpn13g2[area]
print @q.xbgr.xq68_u5.qnpn13g2[area]
print @q.xbgr.xq68_u6.qnpn13g2[area]
print @q.xbgr.xq68_u7.qnpn13g2[area]
print @q.xbgr.xq68_u8.qnpn13g2[area]
print @q.xbgr.xq68_u9.qnpn13g2[area]
print @q.xbgr.xq68_u10.qnpn13g2[area]
print @q.xbgr.xq68_u11.qnpn13g2[area]
print @q.xbgr.xq68_u12.qnpn13g2[area]
print @q.xbgr.xq68_u13.qnpn13g2[area]
print @q.xbgr.xq68_u14.qnpn13g2[area]
print @q.xbgr.xq68_u15.qnpn13g2[area]
print @q.xbgr.xq68_u16.qnpn13g2[area]
print @q.xbgr.xq68_u17.qnpn13g2[area]
print @q.xbgr.xq68_u18.qnpn13g2[area]
print @q.xbgr.xq68_u19.qnpn13g2[area]
print @q.xbgr.xq68_u20.qnpn13g2[area]
print @q.xbgr.xq68_u21.qnpn13g2[area]
print @q.xbgr.xq68_u22.qnpn13g2[area]
print @q.xbgr.xq68_u23.qnpn13g2[area]
print @q.xbgr.xq68_u24.qnpn13g2[area]
print @q.xbgr.xq69_u2.qnpn13g2[area]
print @q.xbgr.xq69_u3.qnpn13g2[area]
print @q.xbgr.xq69_u4.qnpn13g2[area]
print @q.xbgr.xq69_u5.qnpn13g2[area]
print @q.xbgr.xq69_u6.qnpn13g2[area]
print @q.xbgr.xq69_u7.qnpn13g2[area]
print @q.xbgr.xq69_u8.qnpn13g2[area]
print @q.xbgr.xq69_u9.qnpn13g2[area]
print @q.xbgr.xq69_u10.qnpn13g2[area]
print @q.xbgr.xq69_u11.qnpn13g2[area]
print @q.xbgr.xq69_u12.qnpn13g2[area]
print @q.xbgr.xq69_u13.qnpn13g2[area]
print @q.xbgr.xq69_u14.qnpn13g2[area]
print @q.xbgr.xq69_u15.qnpn13g2[area]
print @q.xbgr.xq69_u16.qnpn13g2[area]
print @q.xbgr.xq69_u17.qnpn13g2[area]
print @q.xbgr.xq69_u18.qnpn13g2[area]
print @q.xbgr.xq69_u19.qnpn13g2[area]
print @q.xbgr.xq69_u20.qnpn13g2[area]
print @q.xbgr.xq69_u21.qnpn13g2[area]
print @q.xbgr.xq69_u22.qnpn13g2[area]
print @q.xbgr.xq69_u23.qnpn13g2[area]
print @q.xbgr.xq69_u24.qnpn13g2[area]
print @q.xbgr.xq70_u2.qnpn13g2[area]
print @q.xbgr.xq70_u3.qnpn13g2[area]
print @q.xbgr.xq70_u4.qnpn13g2[area]
print @q.xbgr.xq70_u5.qnpn13g2[area]
print @q.xbgr.xq70_u6.qnpn13g2[area]
print @q.xbgr.xq70_u7.qnpn13g2[area]
print @q.xbgr.xq70_u8.qnpn13g2[area]
print @q.xbgr.xq70_u9.qnpn13g2[area]
print @q.xbgr.xq70_u10.qnpn13g2[area]
print @q.xbgr.xq70_u11.qnpn13g2[area]
print @q.xbgr.xq70_u12.qnpn13g2[area]
print @q.xbgr.xq70_u13.qnpn13g2[area]
print @q.xbgr.xq70_u14.qnpn13g2[area]
print @q.xbgr.xq70_u15.qnpn13g2[area]
print @q.xbgr.xq70_u16.qnpn13g2[area]
print @q.xbgr.xq70_u17.qnpn13g2[area]
print @q.xbgr.xq70_u18.qnpn13g2[area]
print @q.xbgr.xq70_u19.qnpn13g2[area]
print @q.xbgr.xq70_u20.qnpn13g2[area]
print @q.xbgr.xq70_u21.qnpn13g2[area]
print @q.xbgr.xq70_u22.qnpn13g2[area]
print @q.xbgr.xq70_u23.qnpn13g2[area]
print @q.xbgr.xq70_u24.qnpn13g2[area]
print @q.xbgr.xq71_u2.qnpn13g2[area]
print @q.xbgr.xq71_u3.qnpn13g2[area]
print @q.xbgr.xq71_u4.qnpn13g2[area]
print @q.xbgr.xq71_u5.qnpn13g2[area]
print @q.xbgr.xq71_u6.qnpn13g2[area]
print @q.xbgr.xq71_u7.qnpn13g2[area]
print @q.xbgr.xq71_u8.qnpn13g2[area]
print @q.xbgr.xq71_u9.qnpn13g2[area]
print @q.xbgr.xq71_u10.qnpn13g2[area]
print @q.xbgr.xq71_u11.qnpn13g2[area]
print @q.xbgr.xq71_u12.qnpn13g2[area]
print @q.xbgr.xq71_u13.qnpn13g2[area]
print @q.xbgr.xq71_u14.qnpn13g2[area]
print @q.xbgr.xq71_u15.qnpn13g2[area]
print @q.xbgr.xq71_u16.qnpn13g2[area]
print @q.xbgr.xq71_u17.qnpn13g2[area]
print @q.xbgr.xq71_u18.qnpn13g2[area]
print @q.xbgr.xq71_u19.qnpn13g2[area]
print @q.xbgr.xq71_u20.qnpn13g2[area]
print @q.xbgr.xq71_u21.qnpn13g2[area]
print @q.xbgr.xq71_u22.qnpn13g2[area]
print @q.xbgr.xq71_u23.qnpn13g2[area]
print @q.xbgr.xq71_u24.qnpn13g2[area]
print @q.xbgr.xq72_u2.qnpn13g2[area]
print @q.xbgr.xq72_u3.qnpn13g2[area]
print @q.xbgr.xq72_u4.qnpn13g2[area]
print @q.xbgr.xq72_u5.qnpn13g2[area]
print @q.xbgr.xq72_u6.qnpn13g2[area]
print @q.xbgr.xq72_u7.qnpn13g2[area]
print @q.xbgr.xq72_u8.qnpn13g2[area]
print @q.xbgr.xq72_u9.qnpn13g2[area]
print @q.xbgr.xq72_u10.qnpn13g2[area]
print @q.xbgr.xq72_u11.qnpn13g2[area]
print @q.xbgr.xq72_u12.qnpn13g2[area]
print @q.xbgr.xq72_u13.qnpn13g2[area]
print @q.xbgr.xq72_u14.qnpn13g2[area]
print @q.xbgr.xq72_u15.qnpn13g2[area]
print @q.xbgr.xq72_u16.qnpn13g2[area]
print @q.xbgr.xq72_u17.qnpn13g2[area]
print @q.xbgr.xq72_u18.qnpn13g2[area]
print @q.xbgr.xq72_u19.qnpn13g2[area]
print @q.xbgr.xq72_u20.qnpn13g2[area]
print @q.xbgr.xq72_u21.qnpn13g2[area]
print @q.xbgr.xq72_u22.qnpn13g2[area]
print @q.xbgr.xq72_u23.qnpn13g2[area]
print @q.xbgr.xq72_u24.qnpn13g2[area]
print @q.xbgr.xq73_u2.qnpn13g2[area]
print @q.xbgr.xq73_u3.qnpn13g2[area]
print @q.xbgr.xq73_u4.qnpn13g2[area]
print @q.xbgr.xq73_u5.qnpn13g2[area]
print @q.xbgr.xq73_u6.qnpn13g2[area]
print @q.xbgr.xq73_u7.qnpn13g2[area]
print @q.xbgr.xq73_u8.qnpn13g2[area]
print @q.xbgr.xq73_u9.qnpn13g2[area]
print @q.xbgr.xq73_u10.qnpn13g2[area]
print @q.xbgr.xq73_u11.qnpn13g2[area]
print @q.xbgr.xq73_u12.qnpn13g2[area]
print @q.xbgr.xq73_u13.qnpn13g2[area]
print @q.xbgr.xq73_u14.qnpn13g2[area]
print @q.xbgr.xq73_u15.qnpn13g2[area]
print @q.xbgr.xq73_u16.qnpn13g2[area]
print @q.xbgr.xq73_u17.qnpn13g2[area]
print @q.xbgr.xq73_u18.qnpn13g2[area]
print @q.xbgr.xq73_u19.qnpn13g2[area]
print @q.xbgr.xq73_u20.qnpn13g2[area]
print @q.xbgr.xq73_u21.qnpn13g2[area]
print @q.xbgr.xq73_u22.qnpn13g2[area]
print @q.xbgr.xq73_u23.qnpn13g2[area]
print @q.xbgr.xq73_u24.qnpn13g2[area]
print @q.xbgr.xq74_u2.qnpn13g2[area]
print @q.xbgr.xq74_u3.qnpn13g2[area]
print @q.xbgr.xq74_u4.qnpn13g2[area]
print @q.xbgr.xq74_u5.qnpn13g2[area]
print @q.xbgr.xq74_u6.qnpn13g2[area]
print @q.xbgr.xq74_u7.qnpn13g2[area]
print @q.xbgr.xq74_u8.qnpn13g2[area]
print @q.xbgr.xq74_u9.qnpn13g2[area]
print @q.xbgr.xq74_u10.qnpn13g2[area]
print @q.xbgr.xq74_u11.qnpn13g2[area]
print @q.xbgr.xq74_u12.qnpn13g2[area]
print @q.xbgr.xq74_u13.qnpn13g2[area]
print @q.xbgr.xq74_u14.qnpn13g2[area]
print @q.xbgr.xq74_u15.qnpn13g2[area]
print @q.xbgr.xq74_u16.qnpn13g2[area]
print @q.xbgr.xq74_u17.qnpn13g2[area]
print @q.xbgr.xq74_u18.qnpn13g2[area]
print @q.xbgr.xq74_u19.qnpn13g2[area]
print @q.xbgr.xq74_u20.qnpn13g2[area]
print @q.xbgr.xq74_u21.qnpn13g2[area]
print @q.xbgr.xq74_u22.qnpn13g2[area]
print @q.xbgr.xq74_u23.qnpn13g2[area]
print @q.xbgr.xq74_u24.qnpn13g2[area]
print @q.xbgr.xq75_u2.qnpn13g2[area]
print @q.xbgr.xq75_u3.qnpn13g2[area]
print @q.xbgr.xq75_u4.qnpn13g2[area]
print @q.xbgr.xq75_u5.qnpn13g2[area]
print @q.xbgr.xq75_u6.qnpn13g2[area]
print @q.xbgr.xq75_u7.qnpn13g2[area]
print @q.xbgr.xq75_u8.qnpn13g2[area]
print @q.xbgr.xq75_u9.qnpn13g2[area]
print @q.xbgr.xq75_u10.qnpn13g2[area]
print @q.xbgr.xq75_u11.qnpn13g2[area]
print @q.xbgr.xq75_u12.qnpn13g2[area]
print @q.xbgr.xq75_u13.qnpn13g2[area]
print @q.xbgr.xq75_u14.qnpn13g2[area]
print @q.xbgr.xq75_u15.qnpn13g2[area]
print @q.xbgr.xq75_u16.qnpn13g2[area]
print @q.xbgr.xq75_u17.qnpn13g2[area]
print @q.xbgr.xq75_u18.qnpn13g2[area]
print @q.xbgr.xq75_u19.qnpn13g2[area]
print @q.xbgr.xq75_u20.qnpn13g2[area]
print @q.xbgr.xq75_u21.qnpn13g2[area]
print @q.xbgr.xq75_u22.qnpn13g2[area]
print @q.xbgr.xq75_u23.qnpn13g2[area]
print @q.xbgr.xq75_u24.qnpn13g2[area]
print @q.xbgr.xq76_u2.qnpn13g2[area]
print @q.xbgr.xq76_u3.qnpn13g2[area]
print @q.xbgr.xq76_u4.qnpn13g2[area]
print @q.xbgr.xq76_u5.qnpn13g2[area]
print @q.xbgr.xq76_u6.qnpn13g2[area]
print @q.xbgr.xq76_u7.qnpn13g2[area]
print @q.xbgr.xq76_u8.qnpn13g2[area]
print @q.xbgr.xq76_u9.qnpn13g2[area]
print @q.xbgr.xq76_u10.qnpn13g2[area]
print @q.xbgr.xq76_u11.qnpn13g2[area]
print @q.xbgr.xq76_u12.qnpn13g2[area]
print @q.xbgr.xq76_u13.qnpn13g2[area]
print @q.xbgr.xq76_u14.qnpn13g2[area]
print @q.xbgr.xq76_u15.qnpn13g2[area]
print @q.xbgr.xq76_u16.qnpn13g2[area]
print @q.xbgr.xq76_u17.qnpn13g2[area]
print @q.xbgr.xq76_u18.qnpn13g2[area]
print @q.xbgr.xq76_u19.qnpn13g2[area]
print @q.xbgr.xq76_u20.qnpn13g2[area]
print @q.xbgr.xq76_u21.qnpn13g2[area]
print @q.xbgr.xq76_u22.qnpn13g2[area]
print @q.xbgr.xq76_u23.qnpn13g2[area]
print @q.xbgr.xq76_u24.qnpn13g2[area]
print @n.xbgr.xr77_u2.nr1[nsmm_rsh]
print @n.xbgr.xr77_u2.nr1[nsmm_w]
print @n.xbgr.xr77_u2.nr1[nsmm_l]
print @n.xbgr.xr77_u3.nr1[nsmm_rsh]
print @n.xbgr.xr77_u3.nr1[nsmm_w]
print @n.xbgr.xr77_u3.nr1[nsmm_l]
print @n.xbgr.xr77_u4.nr1[nsmm_rsh]
print @n.xbgr.xr77_u4.nr1[nsmm_w]
print @n.xbgr.xr77_u4.nr1[nsmm_l]
print @n.xbgr.xr77_u5.nr1[nsmm_rsh]
print @n.xbgr.xr77_u5.nr1[nsmm_w]
print @n.xbgr.xr77_u5.nr1[nsmm_l]
print @n.xbgr.xr77_u6.nr1[nsmm_rsh]
print @n.xbgr.xr77_u6.nr1[nsmm_w]
print @n.xbgr.xr77_u6.nr1[nsmm_l]
print @n.xbgr.xr77_u7.nr1[nsmm_rsh]
print @n.xbgr.xr77_u7.nr1[nsmm_w]
print @n.xbgr.xr77_u7.nr1[nsmm_l]
print @n.xbgr.xr77_u8.nr1[nsmm_rsh]
print @n.xbgr.xr77_u8.nr1[nsmm_w]
print @n.xbgr.xr77_u8.nr1[nsmm_l]
print @n.xbgr.xr77_u9.nr1[nsmm_rsh]
print @n.xbgr.xr77_u9.nr1[nsmm_w]
print @n.xbgr.xr77_u9.nr1[nsmm_l]
print @n.xbgr.xr77_u10.nr1[nsmm_rsh]
print @n.xbgr.xr77_u10.nr1[nsmm_w]
print @n.xbgr.xr77_u10.nr1[nsmm_l]
print @n.xbgr.xr77_u11.nr1[nsmm_rsh]
print @n.xbgr.xr77_u11.nr1[nsmm_w]
print @n.xbgr.xr77_u11.nr1[nsmm_l]
print @n.xbgr.xr77_u12.nr1[nsmm_rsh]
print @n.xbgr.xr77_u12.nr1[nsmm_w]
print @n.xbgr.xr77_u12.nr1[nsmm_l]
print @n.xbgr.xr77_u13.nr1[nsmm_rsh]
print @n.xbgr.xr77_u13.nr1[nsmm_w]
print @n.xbgr.xr77_u13.nr1[nsmm_l]
print @n.xbgr.xr77_u14.nr1[nsmm_rsh]
print @n.xbgr.xr77_u14.nr1[nsmm_w]
print @n.xbgr.xr77_u14.nr1[nsmm_l]
print @n.xbgr.xr77_u15.nr1[nsmm_rsh]
print @n.xbgr.xr77_u15.nr1[nsmm_w]
print @n.xbgr.xr77_u15.nr1[nsmm_l]
print @n.xbgr.xr77_u16.nr1[nsmm_rsh]
print @n.xbgr.xr77_u16.nr1[nsmm_w]
print @n.xbgr.xr77_u16.nr1[nsmm_l]
print @n.xbgr.xr77_u17.nr1[nsmm_rsh]
print @n.xbgr.xr77_u17.nr1[nsmm_w]
print @n.xbgr.xr77_u17.nr1[nsmm_l]
print @n.xbgr.xr77_u18.nr1[nsmm_rsh]
print @n.xbgr.xr77_u18.nr1[nsmm_w]
print @n.xbgr.xr77_u18.nr1[nsmm_l]
print @n.xbgr.xr77_u19.nr1[nsmm_rsh]
print @n.xbgr.xr77_u19.nr1[nsmm_w]
print @n.xbgr.xr77_u19.nr1[nsmm_l]
print @n.xbgr.xr77_u20.nr1[nsmm_rsh]
print @n.xbgr.xr77_u20.nr1[nsmm_w]
print @n.xbgr.xr77_u20.nr1[nsmm_l]
print @n.xbgr.xr77_u21.nr1[nsmm_rsh]
print @n.xbgr.xr77_u21.nr1[nsmm_w]
print @n.xbgr.xr77_u21.nr1[nsmm_l]
print @n.xbgr.xr77_u22.nr1[nsmm_rsh]
print @n.xbgr.xr77_u22.nr1[nsmm_w]
print @n.xbgr.xr77_u22.nr1[nsmm_l]
print @n.xbgr.xr77_u23.nr1[nsmm_rsh]
print @n.xbgr.xr77_u23.nr1[nsmm_w]
print @n.xbgr.xr77_u23.nr1[nsmm_l]
print @n.xbgr.xr77_u24.nr1[nsmm_rsh]
print @n.xbgr.xr77_u24.nr1[nsmm_w]
print @n.xbgr.xr77_u24.nr1[nsmm_l]
print @n.xbgr.xr78_u2.nr1[nsmm_rsh]
print @n.xbgr.xr78_u2.nr1[nsmm_w]
print @n.xbgr.xr78_u2.nr1[nsmm_l]
print @n.xbgr.xr78_u3.nr1[nsmm_rsh]
print @n.xbgr.xr78_u3.nr1[nsmm_w]
print @n.xbgr.xr78_u3.nr1[nsmm_l]
print @n.xbgr.xr78_u4.nr1[nsmm_rsh]
print @n.xbgr.xr78_u4.nr1[nsmm_w]
print @n.xbgr.xr78_u4.nr1[nsmm_l]
print @n.xbgr.xr78_u5.nr1[nsmm_rsh]
print @n.xbgr.xr78_u5.nr1[nsmm_w]
print @n.xbgr.xr78_u5.nr1[nsmm_l]
print @n.xbgr.xr78_u6.nr1[nsmm_rsh]
print @n.xbgr.xr78_u6.nr1[nsmm_w]
print @n.xbgr.xr78_u6.nr1[nsmm_l]
print @n.xbgr.xr78_u7.nr1[nsmm_rsh]
print @n.xbgr.xr78_u7.nr1[nsmm_w]
print @n.xbgr.xr78_u7.nr1[nsmm_l]
print @n.xbgr.xr78_u8.nr1[nsmm_rsh]
print @n.xbgr.xr78_u8.nr1[nsmm_w]
print @n.xbgr.xr78_u8.nr1[nsmm_l]
print @n.xbgr.xr78_u9.nr1[nsmm_rsh]
print @n.xbgr.xr78_u9.nr1[nsmm_w]
print @n.xbgr.xr78_u9.nr1[nsmm_l]
print @n.xbgr.xr78_u10.nr1[nsmm_rsh]
print @n.xbgr.xr78_u10.nr1[nsmm_w]
print @n.xbgr.xr78_u10.nr1[nsmm_l]
print @n.xbgr.xr78_u11.nr1[nsmm_rsh]
print @n.xbgr.xr78_u11.nr1[nsmm_w]
print @n.xbgr.xr78_u11.nr1[nsmm_l]
print @n.xbgr.xr78_u12.nr1[nsmm_rsh]
print @n.xbgr.xr78_u12.nr1[nsmm_w]
print @n.xbgr.xr78_u12.nr1[nsmm_l]
print @n.xbgr.xr78_u13.nr1[nsmm_rsh]
print @n.xbgr.xr78_u13.nr1[nsmm_w]
print @n.xbgr.xr78_u13.nr1[nsmm_l]
print @n.xbgr.xr78_u14.nr1[nsmm_rsh]
print @n.xbgr.xr78_u14.nr1[nsmm_w]
print @n.xbgr.xr78_u14.nr1[nsmm_l]
print @n.xbgr.xr78_u15.nr1[nsmm_rsh]
print @n.xbgr.xr78_u15.nr1[nsmm_w]
print @n.xbgr.xr78_u15.nr1[nsmm_l]
print @n.xbgr.xr78_u16.nr1[nsmm_rsh]
print @n.xbgr.xr78_u16.nr1[nsmm_w]
print @n.xbgr.xr78_u16.nr1[nsmm_l]
print @n.xbgr.xr78_u17.nr1[nsmm_rsh]
print @n.xbgr.xr78_u17.nr1[nsmm_w]
print @n.xbgr.xr78_u17.nr1[nsmm_l]
print @n.xbgr.xr78_u18.nr1[nsmm_rsh]
print @n.xbgr.xr78_u18.nr1[nsmm_w]
print @n.xbgr.xr78_u18.nr1[nsmm_l]
print @n.xbgr.xr78_u19.nr1[nsmm_rsh]
print @n.xbgr.xr78_u19.nr1[nsmm_w]
print @n.xbgr.xr78_u19.nr1[nsmm_l]
print @n.xbgr.xr78_u20.nr1[nsmm_rsh]
print @n.xbgr.xr78_u20.nr1[nsmm_w]
print @n.xbgr.xr78_u20.nr1[nsmm_l]
print @n.xbgr.xr78_u21.nr1[nsmm_rsh]
print @n.xbgr.xr78_u21.nr1[nsmm_w]
print @n.xbgr.xr78_u21.nr1[nsmm_l]
print @n.xbgr.xr78_u22.nr1[nsmm_rsh]
print @n.xbgr.xr78_u22.nr1[nsmm_w]
print @n.xbgr.xr78_u22.nr1[nsmm_l]
print @n.xbgr.xr78_u23.nr1[nsmm_rsh]
print @n.xbgr.xr78_u23.nr1[nsmm_w]
print @n.xbgr.xr78_u23.nr1[nsmm_l]
print @n.xbgr.xr78_u24.nr1[nsmm_rsh]
print @n.xbgr.xr78_u24.nr1[nsmm_w]
print @n.xbgr.xr78_u24.nr1[nsmm_l]
print @n.xbgr.xr79_u2.nr1[nsmm_rsh]
print @n.xbgr.xr79_u2.nr1[nsmm_w]
print @n.xbgr.xr79_u2.nr1[nsmm_l]
print @n.xbgr.xr79_u3.nr1[nsmm_rsh]
print @n.xbgr.xr79_u3.nr1[nsmm_w]
print @n.xbgr.xr79_u3.nr1[nsmm_l]
print @n.xbgr.xr79_u4.nr1[nsmm_rsh]
print @n.xbgr.xr79_u4.nr1[nsmm_w]
print @n.xbgr.xr79_u4.nr1[nsmm_l]
print @n.xbgr.xr79_u5.nr1[nsmm_rsh]
print @n.xbgr.xr79_u5.nr1[nsmm_w]
print @n.xbgr.xr79_u5.nr1[nsmm_l]
print @n.xbgr.xr79_u6.nr1[nsmm_rsh]
print @n.xbgr.xr79_u6.nr1[nsmm_w]
print @n.xbgr.xr79_u6.nr1[nsmm_l]
print @n.xbgr.xr79_u7.nr1[nsmm_rsh]
print @n.xbgr.xr79_u7.nr1[nsmm_w]
print @n.xbgr.xr79_u7.nr1[nsmm_l]
print @n.xbgr.xr79_u8.nr1[nsmm_rsh]
print @n.xbgr.xr79_u8.nr1[nsmm_w]
print @n.xbgr.xr79_u8.nr1[nsmm_l]
print @n.xbgr.xr79_u9.nr1[nsmm_rsh]
print @n.xbgr.xr79_u9.nr1[nsmm_w]
print @n.xbgr.xr79_u9.nr1[nsmm_l]
print @n.xbgr.xr79_u10.nr1[nsmm_rsh]
print @n.xbgr.xr79_u10.nr1[nsmm_w]
print @n.xbgr.xr79_u10.nr1[nsmm_l]
print @n.xbgr.xr79_u11.nr1[nsmm_rsh]
print @n.xbgr.xr79_u11.nr1[nsmm_w]
print @n.xbgr.xr79_u11.nr1[nsmm_l]
print @n.xbgr.xr79_u12.nr1[nsmm_rsh]
print @n.xbgr.xr79_u12.nr1[nsmm_w]
print @n.xbgr.xr79_u12.nr1[nsmm_l]
print @n.xbgr.xr79_u13.nr1[nsmm_rsh]
print @n.xbgr.xr79_u13.nr1[nsmm_w]
print @n.xbgr.xr79_u13.nr1[nsmm_l]
print @n.xbgr.xr79_u14.nr1[nsmm_rsh]
print @n.xbgr.xr79_u14.nr1[nsmm_w]
print @n.xbgr.xr79_u14.nr1[nsmm_l]
print @n.xbgr.xr79_u15.nr1[nsmm_rsh]
print @n.xbgr.xr79_u15.nr1[nsmm_w]
print @n.xbgr.xr79_u15.nr1[nsmm_l]
print @n.xbgr.xr79_u16.nr1[nsmm_rsh]
print @n.xbgr.xr79_u16.nr1[nsmm_w]
print @n.xbgr.xr79_u16.nr1[nsmm_l]
print @n.xbgr.xr79_u17.nr1[nsmm_rsh]
print @n.xbgr.xr79_u17.nr1[nsmm_w]
print @n.xbgr.xr79_u17.nr1[nsmm_l]
print @n.xbgr.xr79_u18.nr1[nsmm_rsh]
print @n.xbgr.xr79_u18.nr1[nsmm_w]
print @n.xbgr.xr79_u18.nr1[nsmm_l]
print @n.xbgr.xr79_u19.nr1[nsmm_rsh]
print @n.xbgr.xr79_u19.nr1[nsmm_w]
print @n.xbgr.xr79_u19.nr1[nsmm_l]
print @n.xbgr.xr79_u20.nr1[nsmm_rsh]
print @n.xbgr.xr79_u20.nr1[nsmm_w]
print @n.xbgr.xr79_u20.nr1[nsmm_l]
print @n.xbgr.xr79_u21.nr1[nsmm_rsh]
print @n.xbgr.xr79_u21.nr1[nsmm_w]
print @n.xbgr.xr79_u21.nr1[nsmm_l]
print @n.xbgr.xr79_u22.nr1[nsmm_rsh]
print @n.xbgr.xr79_u22.nr1[nsmm_w]
print @n.xbgr.xr79_u22.nr1[nsmm_l]
print @n.xbgr.xr79_u23.nr1[nsmm_rsh]
print @n.xbgr.xr79_u23.nr1[nsmm_w]
print @n.xbgr.xr79_u23.nr1[nsmm_l]
print @n.xbgr.xr79_u24.nr1[nsmm_rsh]
print @n.xbgr.xr79_u24.nr1[nsmm_w]
print @n.xbgr.xr79_u24.nr1[nsmm_l]
print @n.xbgr.xr80_u2.nr1[nsmm_rsh]
print @n.xbgr.xr80_u2.nr1[nsmm_w]
print @n.xbgr.xr80_u2.nr1[nsmm_l]
print @n.xbgr.xr80_u3.nr1[nsmm_rsh]
print @n.xbgr.xr80_u3.nr1[nsmm_w]
print @n.xbgr.xr80_u3.nr1[nsmm_l]
print @n.xbgr.xr80_u4.nr1[nsmm_rsh]
print @n.xbgr.xr80_u4.nr1[nsmm_w]
print @n.xbgr.xr80_u4.nr1[nsmm_l]
print @n.xbgr.xr80_u5.nr1[nsmm_rsh]
print @n.xbgr.xr80_u5.nr1[nsmm_w]
print @n.xbgr.xr80_u5.nr1[nsmm_l]
print @n.xbgr.xr80_u6.nr1[nsmm_rsh]
print @n.xbgr.xr80_u6.nr1[nsmm_w]
print @n.xbgr.xr80_u6.nr1[nsmm_l]
print @n.xbgr.xr80_u7.nr1[nsmm_rsh]
print @n.xbgr.xr80_u7.nr1[nsmm_w]
print @n.xbgr.xr80_u7.nr1[nsmm_l]
print @n.xbgr.xr80_u8.nr1[nsmm_rsh]
print @n.xbgr.xr80_u8.nr1[nsmm_w]
print @n.xbgr.xr80_u8.nr1[nsmm_l]
print @n.xbgr.xr80_u9.nr1[nsmm_rsh]
print @n.xbgr.xr80_u9.nr1[nsmm_w]
print @n.xbgr.xr80_u9.nr1[nsmm_l]
print @n.xbgr.xr80_u10.nr1[nsmm_rsh]
print @n.xbgr.xr80_u10.nr1[nsmm_w]
print @n.xbgr.xr80_u10.nr1[nsmm_l]
print @n.xbgr.xr80_u11.nr1[nsmm_rsh]
print @n.xbgr.xr80_u11.nr1[nsmm_w]
print @n.xbgr.xr80_u11.nr1[nsmm_l]
print @n.xbgr.xr80_u12.nr1[nsmm_rsh]
print @n.xbgr.xr80_u12.nr1[nsmm_w]
print @n.xbgr.xr80_u12.nr1[nsmm_l]
print @n.xbgr.xr80_u13.nr1[nsmm_rsh]
print @n.xbgr.xr80_u13.nr1[nsmm_w]
print @n.xbgr.xr80_u13.nr1[nsmm_l]
print @n.xbgr.xr80_u14.nr1[nsmm_rsh]
print @n.xbgr.xr80_u14.nr1[nsmm_w]
print @n.xbgr.xr80_u14.nr1[nsmm_l]
print @n.xbgr.xr80_u15.nr1[nsmm_rsh]
print @n.xbgr.xr80_u15.nr1[nsmm_w]
print @n.xbgr.xr80_u15.nr1[nsmm_l]
print @n.xbgr.xr80_u16.nr1[nsmm_rsh]
print @n.xbgr.xr80_u16.nr1[nsmm_w]
print @n.xbgr.xr80_u16.nr1[nsmm_l]
print @n.xbgr.xr80_u17.nr1[nsmm_rsh]
print @n.xbgr.xr80_u17.nr1[nsmm_w]
print @n.xbgr.xr80_u17.nr1[nsmm_l]
print @n.xbgr.xr80_u18.nr1[nsmm_rsh]
print @n.xbgr.xr80_u18.nr1[nsmm_w]
print @n.xbgr.xr80_u18.nr1[nsmm_l]
print @n.xbgr.xr80_u19.nr1[nsmm_rsh]
print @n.xbgr.xr80_u19.nr1[nsmm_w]
print @n.xbgr.xr80_u19.nr1[nsmm_l]
print @n.xbgr.xr80_u20.nr1[nsmm_rsh]
print @n.xbgr.xr80_u20.nr1[nsmm_w]
print @n.xbgr.xr80_u20.nr1[nsmm_l]
print @n.xbgr.xr80_u21.nr1[nsmm_rsh]
print @n.xbgr.xr80_u21.nr1[nsmm_w]
print @n.xbgr.xr80_u21.nr1[nsmm_l]
print @n.xbgr.xr80_u22.nr1[nsmm_rsh]
print @n.xbgr.xr80_u22.nr1[nsmm_w]
print @n.xbgr.xr80_u22.nr1[nsmm_l]
print @n.xbgr.xr80_u23.nr1[nsmm_rsh]
print @n.xbgr.xr80_u23.nr1[nsmm_w]
print @n.xbgr.xr80_u23.nr1[nsmm_l]
print @n.xbgr.xr80_u24.nr1[nsmm_rsh]
print @n.xbgr.xr80_u24.nr1[nsmm_w]
print @n.xbgr.xr80_u24.nr1[nsmm_l]
print @n.xbgr.xr81_u2.nr1[nsmm_rsh]
print @n.xbgr.xr81_u2.nr1[nsmm_w]
print @n.xbgr.xr81_u2.nr1[nsmm_l]
print @n.xbgr.xr81_u3.nr1[nsmm_rsh]
print @n.xbgr.xr81_u3.nr1[nsmm_w]
print @n.xbgr.xr81_u3.nr1[nsmm_l]
print @n.xbgr.xr81_u4.nr1[nsmm_rsh]
print @n.xbgr.xr81_u4.nr1[nsmm_w]
print @n.xbgr.xr81_u4.nr1[nsmm_l]
print @n.xbgr.xr81_u5.nr1[nsmm_rsh]
print @n.xbgr.xr81_u5.nr1[nsmm_w]
print @n.xbgr.xr81_u5.nr1[nsmm_l]
print @n.xbgr.xr81_u6.nr1[nsmm_rsh]
print @n.xbgr.xr81_u6.nr1[nsmm_w]
print @n.xbgr.xr81_u6.nr1[nsmm_l]
print @n.xbgr.xr81_u7.nr1[nsmm_rsh]
print @n.xbgr.xr81_u7.nr1[nsmm_w]
print @n.xbgr.xr81_u7.nr1[nsmm_l]
print @n.xbgr.xr81_u8.nr1[nsmm_rsh]
print @n.xbgr.xr81_u8.nr1[nsmm_w]
print @n.xbgr.xr81_u8.nr1[nsmm_l]
print @n.xbgr.xr81_u9.nr1[nsmm_rsh]
print @n.xbgr.xr81_u9.nr1[nsmm_w]
print @n.xbgr.xr81_u9.nr1[nsmm_l]
print @n.xbgr.xr81_u10.nr1[nsmm_rsh]
print @n.xbgr.xr81_u10.nr1[nsmm_w]
print @n.xbgr.xr81_u10.nr1[nsmm_l]
print @n.xbgr.xr81_u11.nr1[nsmm_rsh]
print @n.xbgr.xr81_u11.nr1[nsmm_w]
print @n.xbgr.xr81_u11.nr1[nsmm_l]
print @n.xbgr.xr81_u12.nr1[nsmm_rsh]
print @n.xbgr.xr81_u12.nr1[nsmm_w]
print @n.xbgr.xr81_u12.nr1[nsmm_l]
print @n.xbgr.xr81_u13.nr1[nsmm_rsh]
print @n.xbgr.xr81_u13.nr1[nsmm_w]
print @n.xbgr.xr81_u13.nr1[nsmm_l]
print @n.xbgr.xr81_u14.nr1[nsmm_rsh]
print @n.xbgr.xr81_u14.nr1[nsmm_w]
print @n.xbgr.xr81_u14.nr1[nsmm_l]
print @n.xbgr.xr81_u15.nr1[nsmm_rsh]
print @n.xbgr.xr81_u15.nr1[nsmm_w]
print @n.xbgr.xr81_u15.nr1[nsmm_l]
print @n.xbgr.xr81_u16.nr1[nsmm_rsh]
print @n.xbgr.xr81_u16.nr1[nsmm_w]
print @n.xbgr.xr81_u16.nr1[nsmm_l]
print @n.xbgr.xr81_u17.nr1[nsmm_rsh]
print @n.xbgr.xr81_u17.nr1[nsmm_w]
print @n.xbgr.xr81_u17.nr1[nsmm_l]
print @n.xbgr.xr81_u18.nr1[nsmm_rsh]
print @n.xbgr.xr81_u18.nr1[nsmm_w]
print @n.xbgr.xr81_u18.nr1[nsmm_l]
print @n.xbgr.xr81_u19.nr1[nsmm_rsh]
print @n.xbgr.xr81_u19.nr1[nsmm_w]
print @n.xbgr.xr81_u19.nr1[nsmm_l]
print @n.xbgr.xr81_u20.nr1[nsmm_rsh]
print @n.xbgr.xr81_u20.nr1[nsmm_w]
print @n.xbgr.xr81_u20.nr1[nsmm_l]
print @n.xbgr.xr81_u21.nr1[nsmm_rsh]
print @n.xbgr.xr81_u21.nr1[nsmm_w]
print @n.xbgr.xr81_u21.nr1[nsmm_l]
print @n.xbgr.xr81_u22.nr1[nsmm_rsh]
print @n.xbgr.xr81_u22.nr1[nsmm_w]
print @n.xbgr.xr81_u22.nr1[nsmm_l]
print @n.xbgr.xr81_u23.nr1[nsmm_rsh]
print @n.xbgr.xr81_u23.nr1[nsmm_w]
print @n.xbgr.xr81_u23.nr1[nsmm_l]
print @n.xbgr.xr81_u24.nr1[nsmm_rsh]
print @n.xbgr.xr81_u24.nr1[nsmm_w]
print @n.xbgr.xr81_u24.nr1[nsmm_l]
print @n.xbgr.xr82_u2.nr1[nsmm_rsh]
print @n.xbgr.xr82_u2.nr1[nsmm_w]
print @n.xbgr.xr82_u2.nr1[nsmm_l]
print @n.xbgr.xr82_u3.nr1[nsmm_rsh]
print @n.xbgr.xr82_u3.nr1[nsmm_w]
print @n.xbgr.xr82_u3.nr1[nsmm_l]
print @n.xbgr.xr82_u4.nr1[nsmm_rsh]
print @n.xbgr.xr82_u4.nr1[nsmm_w]
print @n.xbgr.xr82_u4.nr1[nsmm_l]
print @n.xbgr.xr82_u5.nr1[nsmm_rsh]
print @n.xbgr.xr82_u5.nr1[nsmm_w]
print @n.xbgr.xr82_u5.nr1[nsmm_l]
print @n.xbgr.xr82_u6.nr1[nsmm_rsh]
print @n.xbgr.xr82_u6.nr1[nsmm_w]
print @n.xbgr.xr82_u6.nr1[nsmm_l]
print @n.xbgr.xr82_u7.nr1[nsmm_rsh]
print @n.xbgr.xr82_u7.nr1[nsmm_w]
print @n.xbgr.xr82_u7.nr1[nsmm_l]
print @n.xbgr.xr82_u8.nr1[nsmm_rsh]
print @n.xbgr.xr82_u8.nr1[nsmm_w]
print @n.xbgr.xr82_u8.nr1[nsmm_l]
print @n.xbgr.xr82_u9.nr1[nsmm_rsh]
print @n.xbgr.xr82_u9.nr1[nsmm_w]
print @n.xbgr.xr82_u9.nr1[nsmm_l]
print @n.xbgr.xr82_u10.nr1[nsmm_rsh]
print @n.xbgr.xr82_u10.nr1[nsmm_w]
print @n.xbgr.xr82_u10.nr1[nsmm_l]
print @n.xbgr.xr82_u11.nr1[nsmm_rsh]
print @n.xbgr.xr82_u11.nr1[nsmm_w]
print @n.xbgr.xr82_u11.nr1[nsmm_l]
print @n.xbgr.xr82_u12.nr1[nsmm_rsh]
print @n.xbgr.xr82_u12.nr1[nsmm_w]
print @n.xbgr.xr82_u12.nr1[nsmm_l]
print @n.xbgr.xr82_u13.nr1[nsmm_rsh]
print @n.xbgr.xr82_u13.nr1[nsmm_w]
print @n.xbgr.xr82_u13.nr1[nsmm_l]
print @n.xbgr.xr82_u14.nr1[nsmm_rsh]
print @n.xbgr.xr82_u14.nr1[nsmm_w]
print @n.xbgr.xr82_u14.nr1[nsmm_l]
print @n.xbgr.xr82_u15.nr1[nsmm_rsh]
print @n.xbgr.xr82_u15.nr1[nsmm_w]
print @n.xbgr.xr82_u15.nr1[nsmm_l]
print @n.xbgr.xr82_u16.nr1[nsmm_rsh]
print @n.xbgr.xr82_u16.nr1[nsmm_w]
print @n.xbgr.xr82_u16.nr1[nsmm_l]
print @n.xbgr.xr82_u17.nr1[nsmm_rsh]
print @n.xbgr.xr82_u17.nr1[nsmm_w]
print @n.xbgr.xr82_u17.nr1[nsmm_l]
print @n.xbgr.xr82_u18.nr1[nsmm_rsh]
print @n.xbgr.xr82_u18.nr1[nsmm_w]
print @n.xbgr.xr82_u18.nr1[nsmm_l]
print @n.xbgr.xr82_u19.nr1[nsmm_rsh]
print @n.xbgr.xr82_u19.nr1[nsmm_w]
print @n.xbgr.xr82_u19.nr1[nsmm_l]
print @n.xbgr.xr82_u20.nr1[nsmm_rsh]
print @n.xbgr.xr82_u20.nr1[nsmm_w]
print @n.xbgr.xr82_u20.nr1[nsmm_l]
print @n.xbgr.xr82_u21.nr1[nsmm_rsh]
print @n.xbgr.xr82_u21.nr1[nsmm_w]
print @n.xbgr.xr82_u21.nr1[nsmm_l]
print @n.xbgr.xr82_u22.nr1[nsmm_rsh]
print @n.xbgr.xr82_u22.nr1[nsmm_w]
print @n.xbgr.xr82_u22.nr1[nsmm_l]
print @n.xbgr.xr82_u23.nr1[nsmm_rsh]
print @n.xbgr.xr82_u23.nr1[nsmm_w]
print @n.xbgr.xr82_u23.nr1[nsmm_l]
print @n.xbgr.xr82_u24.nr1[nsmm_rsh]
print @n.xbgr.xr82_u24.nr1[nsmm_w]
print @n.xbgr.xr82_u24.nr1[nsmm_l]
print @n.xbgr.xr83_u2.nr1[nsmm_rsh]
print @n.xbgr.xr83_u2.nr1[nsmm_w]
print @n.xbgr.xr83_u2.nr1[nsmm_l]
print @n.xbgr.xr83_u3.nr1[nsmm_rsh]
print @n.xbgr.xr83_u3.nr1[nsmm_w]
print @n.xbgr.xr83_u3.nr1[nsmm_l]
print @n.xbgr.xr83_u4.nr1[nsmm_rsh]
print @n.xbgr.xr83_u4.nr1[nsmm_w]
print @n.xbgr.xr83_u4.nr1[nsmm_l]
print @n.xbgr.xr83_u5.nr1[nsmm_rsh]
print @n.xbgr.xr83_u5.nr1[nsmm_w]
print @n.xbgr.xr83_u5.nr1[nsmm_l]
print @n.xbgr.xr83_u6.nr1[nsmm_rsh]
print @n.xbgr.xr83_u6.nr1[nsmm_w]
print @n.xbgr.xr83_u6.nr1[nsmm_l]
print @n.xbgr.xr83_u7.nr1[nsmm_rsh]
print @n.xbgr.xr83_u7.nr1[nsmm_w]
print @n.xbgr.xr83_u7.nr1[nsmm_l]
print @n.xbgr.xr83_u8.nr1[nsmm_rsh]
print @n.xbgr.xr83_u8.nr1[nsmm_w]
print @n.xbgr.xr83_u8.nr1[nsmm_l]
print @n.xbgr.xr83_u9.nr1[nsmm_rsh]
print @n.xbgr.xr83_u9.nr1[nsmm_w]
print @n.xbgr.xr83_u9.nr1[nsmm_l]
print @n.xbgr.xr83_u10.nr1[nsmm_rsh]
print @n.xbgr.xr83_u10.nr1[nsmm_w]
print @n.xbgr.xr83_u10.nr1[nsmm_l]
print @n.xbgr.xr83_u11.nr1[nsmm_rsh]
print @n.xbgr.xr83_u11.nr1[nsmm_w]
print @n.xbgr.xr83_u11.nr1[nsmm_l]
print @n.xbgr.xr83_u12.nr1[nsmm_rsh]
print @n.xbgr.xr83_u12.nr1[nsmm_w]
print @n.xbgr.xr83_u12.nr1[nsmm_l]
print @n.xbgr.xr83_u13.nr1[nsmm_rsh]
print @n.xbgr.xr83_u13.nr1[nsmm_w]
print @n.xbgr.xr83_u13.nr1[nsmm_l]
print @n.xbgr.xr83_u14.nr1[nsmm_rsh]
print @n.xbgr.xr83_u14.nr1[nsmm_w]
print @n.xbgr.xr83_u14.nr1[nsmm_l]
print @n.xbgr.xr83_u15.nr1[nsmm_rsh]
print @n.xbgr.xr83_u15.nr1[nsmm_w]
print @n.xbgr.xr83_u15.nr1[nsmm_l]
print @n.xbgr.xr83_u16.nr1[nsmm_rsh]
print @n.xbgr.xr83_u16.nr1[nsmm_w]
print @n.xbgr.xr83_u16.nr1[nsmm_l]
print @n.xbgr.xr83_u17.nr1[nsmm_rsh]
print @n.xbgr.xr83_u17.nr1[nsmm_w]
print @n.xbgr.xr83_u17.nr1[nsmm_l]
print @n.xbgr.xr83_u18.nr1[nsmm_rsh]
print @n.xbgr.xr83_u18.nr1[nsmm_w]
print @n.xbgr.xr83_u18.nr1[nsmm_l]
print @n.xbgr.xr83_u19.nr1[nsmm_rsh]
print @n.xbgr.xr83_u19.nr1[nsmm_w]
print @n.xbgr.xr83_u19.nr1[nsmm_l]
print @n.xbgr.xr83_u20.nr1[nsmm_rsh]
print @n.xbgr.xr83_u20.nr1[nsmm_w]
print @n.xbgr.xr83_u20.nr1[nsmm_l]
print @n.xbgr.xr83_u21.nr1[nsmm_rsh]
print @n.xbgr.xr83_u21.nr1[nsmm_w]
print @n.xbgr.xr83_u21.nr1[nsmm_l]
print @n.xbgr.xr83_u22.nr1[nsmm_rsh]
print @n.xbgr.xr83_u22.nr1[nsmm_w]
print @n.xbgr.xr83_u22.nr1[nsmm_l]
print @n.xbgr.xr83_u23.nr1[nsmm_rsh]
print @n.xbgr.xr83_u23.nr1[nsmm_w]
print @n.xbgr.xr83_u23.nr1[nsmm_l]
print @n.xbgr.xr83_u24.nr1[nsmm_rsh]
print @n.xbgr.xr83_u24.nr1[nsmm_w]
print @n.xbgr.xr83_u24.nr1[nsmm_l]
print @n.xbgr.xr84_u2.nr1[nsmm_rsh]
print @n.xbgr.xr84_u2.nr1[nsmm_w]
print @n.xbgr.xr84_u2.nr1[nsmm_l]
print @n.xbgr.xr84_u3.nr1[nsmm_rsh]
print @n.xbgr.xr84_u3.nr1[nsmm_w]
print @n.xbgr.xr84_u3.nr1[nsmm_l]
print @n.xbgr.xr84_u4.nr1[nsmm_rsh]
print @n.xbgr.xr84_u4.nr1[nsmm_w]
print @n.xbgr.xr84_u4.nr1[nsmm_l]
print @n.xbgr.xr84_u5.nr1[nsmm_rsh]
print @n.xbgr.xr84_u5.nr1[nsmm_w]
print @n.xbgr.xr84_u5.nr1[nsmm_l]
print @n.xbgr.xr84_u6.nr1[nsmm_rsh]
print @n.xbgr.xr84_u6.nr1[nsmm_w]
print @n.xbgr.xr84_u6.nr1[nsmm_l]
print @n.xbgr.xr84_u7.nr1[nsmm_rsh]
print @n.xbgr.xr84_u7.nr1[nsmm_w]
print @n.xbgr.xr84_u7.nr1[nsmm_l]
print @n.xbgr.xr84_u8.nr1[nsmm_rsh]
print @n.xbgr.xr84_u8.nr1[nsmm_w]
print @n.xbgr.xr84_u8.nr1[nsmm_l]
print @n.xbgr.xr84_u9.nr1[nsmm_rsh]
print @n.xbgr.xr84_u9.nr1[nsmm_w]
print @n.xbgr.xr84_u9.nr1[nsmm_l]
print @n.xbgr.xr84_u10.nr1[nsmm_rsh]
print @n.xbgr.xr84_u10.nr1[nsmm_w]
print @n.xbgr.xr84_u10.nr1[nsmm_l]
print @n.xbgr.xr84_u11.nr1[nsmm_rsh]
print @n.xbgr.xr84_u11.nr1[nsmm_w]
print @n.xbgr.xr84_u11.nr1[nsmm_l]
print @n.xbgr.xr84_u12.nr1[nsmm_rsh]
print @n.xbgr.xr84_u12.nr1[nsmm_w]
print @n.xbgr.xr84_u12.nr1[nsmm_l]
print @n.xbgr.xr84_u13.nr1[nsmm_rsh]
print @n.xbgr.xr84_u13.nr1[nsmm_w]
print @n.xbgr.xr84_u13.nr1[nsmm_l]
print @n.xbgr.xr84_u14.nr1[nsmm_rsh]
print @n.xbgr.xr84_u14.nr1[nsmm_w]
print @n.xbgr.xr84_u14.nr1[nsmm_l]
print @n.xbgr.xr84_u15.nr1[nsmm_rsh]
print @n.xbgr.xr84_u15.nr1[nsmm_w]
print @n.xbgr.xr84_u15.nr1[nsmm_l]
print @n.xbgr.xr84_u16.nr1[nsmm_rsh]
print @n.xbgr.xr84_u16.nr1[nsmm_w]
print @n.xbgr.xr84_u16.nr1[nsmm_l]
print @n.xbgr.xr84_u17.nr1[nsmm_rsh]
print @n.xbgr.xr84_u17.nr1[nsmm_w]
print @n.xbgr.xr84_u17.nr1[nsmm_l]
print @n.xbgr.xr84_u18.nr1[nsmm_rsh]
print @n.xbgr.xr84_u18.nr1[nsmm_w]
print @n.xbgr.xr84_u18.nr1[nsmm_l]
print @n.xbgr.xr84_u19.nr1[nsmm_rsh]
print @n.xbgr.xr84_u19.nr1[nsmm_w]
print @n.xbgr.xr84_u19.nr1[nsmm_l]
print @n.xbgr.xr84_u20.nr1[nsmm_rsh]
print @n.xbgr.xr84_u20.nr1[nsmm_w]
print @n.xbgr.xr84_u20.nr1[nsmm_l]
print @n.xbgr.xr84_u21.nr1[nsmm_rsh]
print @n.xbgr.xr84_u21.nr1[nsmm_w]
print @n.xbgr.xr84_u21.nr1[nsmm_l]
print @n.xbgr.xr84_u22.nr1[nsmm_rsh]
print @n.xbgr.xr84_u22.nr1[nsmm_w]
print @n.xbgr.xr84_u22.nr1[nsmm_l]
print @n.xbgr.xr84_u23.nr1[nsmm_rsh]
print @n.xbgr.xr84_u23.nr1[nsmm_w]
print @n.xbgr.xr84_u23.nr1[nsmm_l]
print @n.xbgr.xr84_u24.nr1[nsmm_rsh]
print @n.xbgr.xr84_u24.nr1[nsmm_w]
print @n.xbgr.xr84_u24.nr1[nsmm_l]
print @n.xbgr.xr85_u2.nr1[nsmm_rsh]
print @n.xbgr.xr85_u2.nr1[nsmm_w]
print @n.xbgr.xr85_u2.nr1[nsmm_l]
print @n.xbgr.xr85_u3.nr1[nsmm_rsh]
print @n.xbgr.xr85_u3.nr1[nsmm_w]
print @n.xbgr.xr85_u3.nr1[nsmm_l]
print @n.xbgr.xr85_u4.nr1[nsmm_rsh]
print @n.xbgr.xr85_u4.nr1[nsmm_w]
print @n.xbgr.xr85_u4.nr1[nsmm_l]
print @n.xbgr.xr85_u5.nr1[nsmm_rsh]
print @n.xbgr.xr85_u5.nr1[nsmm_w]
print @n.xbgr.xr85_u5.nr1[nsmm_l]
print @n.xbgr.xr85_u6.nr1[nsmm_rsh]
print @n.xbgr.xr85_u6.nr1[nsmm_w]
print @n.xbgr.xr85_u6.nr1[nsmm_l]
print @n.xbgr.xr85_u7.nr1[nsmm_rsh]
print @n.xbgr.xr85_u7.nr1[nsmm_w]
print @n.xbgr.xr85_u7.nr1[nsmm_l]
print @n.xbgr.xr85_u8.nr1[nsmm_rsh]
print @n.xbgr.xr85_u8.nr1[nsmm_w]
print @n.xbgr.xr85_u8.nr1[nsmm_l]
print @n.xbgr.xr85_u9.nr1[nsmm_rsh]
print @n.xbgr.xr85_u9.nr1[nsmm_w]
print @n.xbgr.xr85_u9.nr1[nsmm_l]
print @n.xbgr.xr85_u10.nr1[nsmm_rsh]
print @n.xbgr.xr85_u10.nr1[nsmm_w]
print @n.xbgr.xr85_u10.nr1[nsmm_l]
print @n.xbgr.xr85_u11.nr1[nsmm_rsh]
print @n.xbgr.xr85_u11.nr1[nsmm_w]
print @n.xbgr.xr85_u11.nr1[nsmm_l]
print @n.xbgr.xr85_u12.nr1[nsmm_rsh]
print @n.xbgr.xr85_u12.nr1[nsmm_w]
print @n.xbgr.xr85_u12.nr1[nsmm_l]
print @n.xbgr.xr85_u13.nr1[nsmm_rsh]
print @n.xbgr.xr85_u13.nr1[nsmm_w]
print @n.xbgr.xr85_u13.nr1[nsmm_l]
print @n.xbgr.xr85_u14.nr1[nsmm_rsh]
print @n.xbgr.xr85_u14.nr1[nsmm_w]
print @n.xbgr.xr85_u14.nr1[nsmm_l]
print @n.xbgr.xr85_u15.nr1[nsmm_rsh]
print @n.xbgr.xr85_u15.nr1[nsmm_w]
print @n.xbgr.xr85_u15.nr1[nsmm_l]
print @n.xbgr.xr85_u16.nr1[nsmm_rsh]
print @n.xbgr.xr85_u16.nr1[nsmm_w]
print @n.xbgr.xr85_u16.nr1[nsmm_l]
print @n.xbgr.xr85_u17.nr1[nsmm_rsh]
print @n.xbgr.xr85_u17.nr1[nsmm_w]
print @n.xbgr.xr85_u17.nr1[nsmm_l]
print @n.xbgr.xr85_u18.nr1[nsmm_rsh]
print @n.xbgr.xr85_u18.nr1[nsmm_w]
print @n.xbgr.xr85_u18.nr1[nsmm_l]
print @n.xbgr.xr85_u19.nr1[nsmm_rsh]
print @n.xbgr.xr85_u19.nr1[nsmm_w]
print @n.xbgr.xr85_u19.nr1[nsmm_l]
print @n.xbgr.xr85_u20.nr1[nsmm_rsh]
print @n.xbgr.xr85_u20.nr1[nsmm_w]
print @n.xbgr.xr85_u20.nr1[nsmm_l]
print @n.xbgr.xr85_u21.nr1[nsmm_rsh]
print @n.xbgr.xr85_u21.nr1[nsmm_w]
print @n.xbgr.xr85_u21.nr1[nsmm_l]
print @n.xbgr.xr85_u22.nr1[nsmm_rsh]
print @n.xbgr.xr85_u22.nr1[nsmm_w]
print @n.xbgr.xr85_u22.nr1[nsmm_l]
print @n.xbgr.xr85_u23.nr1[nsmm_rsh]
print @n.xbgr.xr85_u23.nr1[nsmm_w]
print @n.xbgr.xr85_u23.nr1[nsmm_l]
print @n.xbgr.xr85_u24.nr1[nsmm_rsh]
print @n.xbgr.xr85_u24.nr1[nsmm_w]
print @n.xbgr.xr85_u24.nr1[nsmm_l]
print @n.xbgr.xr86_u2.nr1[nsmm_rsh]
print @n.xbgr.xr86_u2.nr1[nsmm_w]
print @n.xbgr.xr86_u2.nr1[nsmm_l]
print @n.xbgr.xr86_u3.nr1[nsmm_rsh]
print @n.xbgr.xr86_u3.nr1[nsmm_w]
print @n.xbgr.xr86_u3.nr1[nsmm_l]
print @n.xbgr.xr86_u4.nr1[nsmm_rsh]
print @n.xbgr.xr86_u4.nr1[nsmm_w]
print @n.xbgr.xr86_u4.nr1[nsmm_l]
print @n.xbgr.xr86_u5.nr1[nsmm_rsh]
print @n.xbgr.xr86_u5.nr1[nsmm_w]
print @n.xbgr.xr86_u5.nr1[nsmm_l]
print @n.xbgr.xr86_u6.nr1[nsmm_rsh]
print @n.xbgr.xr86_u6.nr1[nsmm_w]
print @n.xbgr.xr86_u6.nr1[nsmm_l]
print @n.xbgr.xr86_u7.nr1[nsmm_rsh]
print @n.xbgr.xr86_u7.nr1[nsmm_w]
print @n.xbgr.xr86_u7.nr1[nsmm_l]
print @n.xbgr.xr86_u8.nr1[nsmm_rsh]
print @n.xbgr.xr86_u8.nr1[nsmm_w]
print @n.xbgr.xr86_u8.nr1[nsmm_l]
print @n.xbgr.xr86_u9.nr1[nsmm_rsh]
print @n.xbgr.xr86_u9.nr1[nsmm_w]
print @n.xbgr.xr86_u9.nr1[nsmm_l]
print @n.xbgr.xr86_u10.nr1[nsmm_rsh]
print @n.xbgr.xr86_u10.nr1[nsmm_w]
print @n.xbgr.xr86_u10.nr1[nsmm_l]
print @n.xbgr.xr86_u11.nr1[nsmm_rsh]
print @n.xbgr.xr86_u11.nr1[nsmm_w]
print @n.xbgr.xr86_u11.nr1[nsmm_l]
print @n.xbgr.xr86_u12.nr1[nsmm_rsh]
print @n.xbgr.xr86_u12.nr1[nsmm_w]
print @n.xbgr.xr86_u12.nr1[nsmm_l]
print @n.xbgr.xr86_u13.nr1[nsmm_rsh]
print @n.xbgr.xr86_u13.nr1[nsmm_w]
print @n.xbgr.xr86_u13.nr1[nsmm_l]
print @n.xbgr.xr86_u14.nr1[nsmm_rsh]
print @n.xbgr.xr86_u14.nr1[nsmm_w]
print @n.xbgr.xr86_u14.nr1[nsmm_l]
print @n.xbgr.xr86_u15.nr1[nsmm_rsh]
print @n.xbgr.xr86_u15.nr1[nsmm_w]
print @n.xbgr.xr86_u15.nr1[nsmm_l]
print @n.xbgr.xr86_u16.nr1[nsmm_rsh]
print @n.xbgr.xr86_u16.nr1[nsmm_w]
print @n.xbgr.xr86_u16.nr1[nsmm_l]
print @n.xbgr.xr86_u17.nr1[nsmm_rsh]
print @n.xbgr.xr86_u17.nr1[nsmm_w]
print @n.xbgr.xr86_u17.nr1[nsmm_l]
print @n.xbgr.xr86_u18.nr1[nsmm_rsh]
print @n.xbgr.xr86_u18.nr1[nsmm_w]
print @n.xbgr.xr86_u18.nr1[nsmm_l]
print @n.xbgr.xr86_u19.nr1[nsmm_rsh]
print @n.xbgr.xr86_u19.nr1[nsmm_w]
print @n.xbgr.xr86_u19.nr1[nsmm_l]
print @n.xbgr.xr86_u20.nr1[nsmm_rsh]
print @n.xbgr.xr86_u20.nr1[nsmm_w]
print @n.xbgr.xr86_u20.nr1[nsmm_l]
print @n.xbgr.xr86_u21.nr1[nsmm_rsh]
print @n.xbgr.xr86_u21.nr1[nsmm_w]
print @n.xbgr.xr86_u21.nr1[nsmm_l]
print @n.xbgr.xr86_u22.nr1[nsmm_rsh]
print @n.xbgr.xr86_u22.nr1[nsmm_w]
print @n.xbgr.xr86_u22.nr1[nsmm_l]
print @n.xbgr.xr86_u23.nr1[nsmm_rsh]
print @n.xbgr.xr86_u23.nr1[nsmm_w]
print @n.xbgr.xr86_u23.nr1[nsmm_l]
print @n.xbgr.xr86_u24.nr1[nsmm_rsh]
print @n.xbgr.xr86_u24.nr1[nsmm_w]
print @n.xbgr.xr86_u24.nr1[nsmm_l]
set numdgt=17
echo METALLIC_POINT_VOLTAGES_BEGIN
print v(xbgr.mr_n57840336)
print v(xbgr.vd2)
print v(xbgr.mr_n57065488)
print v(xbgr.c2)
print v(xbgr.mr_n58131072)
print v(xbgr.mr_n58228064)
print v(xbgr.mr_n58346016)
print v(xbgr.mr_n58403072)
print v(xbgr.mr_n58581328)
print v(xbgr.mr_n58717888)
print v(xbgr.mr_n58784000)
print v(xbgr.mr_n59014912)
print v(xbgr.mr_n59179776)
print v(xbgr.mr_n59302384)
print v(xbgr.mr_n59333328)
print v(xbgr.mr_n59620640)
print v(xbgr.mr_n59712448)
print v(xbgr.mr_n59773232)
print v(xbgr.mr_n60011648)
print v(xbgr.mr_n60387968)
print v(xbgr.mr_n60560016)
print v(xbgr.mr_n60757984)
print v(xbgr.mr_n60924272)
print v(xbgr.mr_n61064128)
print v(xbgr.mr_n61269648)
print v(xbgr.mr_n61471616)
print v(xbgr.mr_n61682656)
print v(xbgr.mr_n58728832)
print v(xbgr.mr_n61768528)
print v(xbgr.mr_n62051568)
print v(xbgr.mr_n62244480)
print v(xbgr.mr_n62460944)
print v(xbgr.mr_n62642544)
print v(xbgr.mr_n62852128)
print v(xbgr.mr_n63151664)
print v(xbgr.mr_n63385216)
print v(xbgr.mr_n63718848)
print v(xbgr.mr_n57840784)
print v(xbgr.mr_n57904224)
print v(xbgr.b1b)
print v(xbgr.mr_n57990704)
print v(xbgr.mr_n58088144)
print v(xbgr.mr_n58183824)
print v(xbgr.mr_n58288976)
print v(xbgr.mr_n58406208)
print v(xbgr.mr_n58520240)
print v(xbgr.mr_n58859776)
print v(xbgr.mr_n58977312)
print v(xbgr.mr_n59108784)
print v(xbgr.mr_n59213248)
print v(xbgr.mr_n59384848)
print v(xbgr.mr_n59498608)
print v(xbgr.mr_n59651808)
print v(xbgr.mr_n59900928)
print v(xbgr.mr_n57875600)
print v(xbgr.mr_n57937024)
print v(xbgr.mr_n57049296)
print v(xbgr.mr_n58074912)
print v(xbgr.mr_n58160928)
print v(xbgr.mr_n58291536)
print v(xbgr.mr_n58348672)
print v(xbgr.mr_n58498000)
print v(xbgr.mr_n58601328)
print v(xbgr.mr_n58718224)
print v(xbgr.mr_n58905104)
print v(xbgr.mr_n59025008)
print v(xbgr.mr_n59186128)
print v(xbgr.mr_n59306880)
print v(xbgr.mr_n59416240)
print v(xbgr.mr_n59623536)
print v(xbgr.mr_n59730384)
print v(xbgr.mr_n59902896)
print v(xbgr.mr_n57109456)
print v(xbgr.mr_n57373872)
print v(xbgr.n_13)
print v(xbgr.n_24)
print v(xbgr.mr_n57107584)
print v(xbgr.mr_n57375856)
print v(xbgr.n_14)
print v(xbgr.mr_n57718272)
print v(xbgr.mr_n57824416)
print v(xbgr.mr_n57904416)
print v(xbgr.mr_n57754912)
print v(xbgr.mr_n58054512)
print v(xbgr.mr_n58133744)
print v(xbgr.mr_n58134528)
print v(xbgr.mr_n58289312)
print v(xbgr.vd1)
print v(xbgr.mr_n58581440)
print v(xbgr.mr_n58667504)
print v(xbgr.mr_n58782560)
print v(xbgr.mr_n58954704)
print v(xbgr.mr_n59146432)
print v(xbgr.mr_n59299760)
print v(xbgr.mr_n59418912)
print v(xbgr.mr_n59554448)
print v(xbgr.mr_n59729472)
print v(xbgr.mr_n59901600)
print v(xbgr.mr_n60244592)
print v(xbgr.mr_n60389232)
print v(xbgr.mr_n60564160)
print v(xbgr.mr_n60758176)
print v(xbgr.mr_n60925264)
print v(xbgr.mr_n61108784)
print v(xbgr.mr_n61317440)
print v(xbgr.mr_n61472720)
print v(xbgr.mr_n61687104)
print v(xbgr.mr_n58727008)
print v(xbgr.mr_n61774064)
print v(xbgr.mr_n62066400)
print v(xbgr.mr_n62244096)
print v(xbgr.mr_n62462064)
print v(xbgr.mr_n62657968)
print v(xbgr.mr_n62852656)
print v(xbgr.mr_n63152800)
print v(xbgr.mr_n63384640)
print v(xbgr.mr_n63721680)
print v(xbgr.mr_n57841360)
print v(xbgr.mr_n57905360)
print v(xbgr.mr_n57346912)
print v(xbgr.mr_n58014816)
print v(xbgr.mr_n58089536)
print v(xbgr.mr_n58182464)
print v(xbgr.mr_n58227872)
print v(xbgr.mr_n58462816)
print v(xbgr.mr_n58522240)
print v(xbgr.mr_n58861168)
print v(xbgr.mr_n58978704)
print v(xbgr.mr_n59110176)
print v(xbgr.mr_n59257664)
print v(xbgr.mr_n59386304)
print v(xbgr.mr_n59394000)
print v(xbgr.mr_n59650000)
print v(xbgr.mr_n59775872)
print v(xbgr.mr_n57110384)
print v(xbgr.mr_n57376448)
print v(xbgr.mr_n57603680)
print v(xbgr.n_26)
print v(xbgr.mr_n57109920)
print v(xbgr.mr_n57377040)
print v(xbgr.n_15)
print v(xbgr.mr_n57719712)
print v(xbgr.mr_n57866336)
print v(xbgr.mr_n57937744)
print v(xbgr.mr_n57631312)
print v(xbgr.mr_n58076352)
print v(xbgr.mr_n58176512)
print v(xbgr.mr_n58292448)
print v(xbgr.mr_n58289648)
print v(xbgr.mr_n58491824)
print v(xbgr.mr_n58602976)
print v(xbgr.mr_n58668128)
print v(xbgr.mr_n58907104)
print v(xbgr.mr_n59026944)
print v(xbgr.mr_n59201424)
print v(xbgr.mr_n59310176)
print v(xbgr.mr_n59508192)
print v(xbgr.mr_n59621312)
print v(xbgr.mr_n59711264)
print v(xbgr.mr_n59776416)
print v(xbgr.mr_n57111312)
print v(xbgr.mr_n57228688)
print v(xbgr.mr_n57604608)
print v(xbgr.n_27)
print v(xbgr.mr_n57110848)
print v(xbgr.mr_n57378224)
print v(xbgr.n_16)
print v(xbgr.mr_n57721152)
print v(xbgr.mr_n57112240)
print v(xbgr.mr_n57378816)
print v(xbgr.mr_n57605072)
print v(xbgr.n_21)
print v(xbgr.mr_n57840976)
print v(xbgr.mr_n57904032)
print v(xbgr.mr_n57326848)
print v(xbgr.mr_n58055024)
print v(xbgr.mr_n57995616)
print v(xbgr.mr_n58228768)
print v(xbgr.mr_n58345344)
print v(xbgr.mr_n58407360)
print v(xbgr.mr_n58602464)
print v(xbgr.mr_n58831168)
print v(xbgr.mr_n59017776)
print v(xbgr.mr_n59183184)
print v(xbgr.mr_n59310288)
print v(xbgr.mr_n59416496)
print v(xbgr.mr_n59621648)
print v(xbgr.mr_n59711856)
print v(xbgr.mr_n59903600)
print v(xbgr.mr_n57111776)
print v(xbgr.mr_n57379408)
print v(xbgr.mr_n56174800)
print v(xbgr.mr_n60367520)
print v(xbgr.mr_n60627888)
print v(xbgr.mr_n60750352)
print v(xbgr.mr_n60925376)
print v(xbgr.mr_n60898224)
print v(xbgr.mr_n61299568)
print v(xbgr.mr_n61454080)
print v(xbgr.mr_n61691760)
print v(xbgr.mr_n62051104)
print v(xbgr.mr_n62259904)
print v(xbgr.mr_n62467792)
print v(xbgr.mr_n62655072)
print v(xbgr.mr_n62962224)
print v(xbgr.mr_n63152912)
print v(xbgr.mr_n63364656)
print v(xbgr.mr_n63732896)
print v(xbgr.mr_n57847120)
print v(xbgr.mr_n57923680)
print v(xbgr.mr_n57944608)
print v(xbgr.mr_n58016208)
print v(xbgr.mr_n58090928)
print v(xbgr.mr_n58184704)
print v(xbgr.mr_n58329472)
print v(xbgr.mr_n58347408)
print v(xbgr.mr_n58536032)
print v(xbgr.mr_n58860704)
print v(xbgr.mr_n58980096)
print v(xbgr.mr_n59111568)
print v(xbgr.mr_n59259440)
print v(xbgr.mr_n59388080)
print v(xbgr.mr_n59505200)
print v(xbgr.mr_n59680192)
print v(xbgr.mr_n59775328)
print v(xbgr.mr_n57113168)
print v(xbgr.mr_n57380000)
print v(xbgr.n_8)
print v(xbgr.vbe3)
print v(xbgr.mr_n57878512)
print v(xbgr.mr_n57938144)
print v(xbgr.mr_n57692560)
print v(xbgr.mr_n58075616)
print v(xbgr.mr_n58177232)
print v(xbgr.mr_n58288640)
print v(xbgr.mr_n58352960)
print v(xbgr.mr_n58500144)
print v(xbgr.mr_n58603856)
print v(xbgr.mr_n58908912)
print v(xbgr.mr_n59015104)
print v(xbgr.mr_n59202224)
print v(xbgr.mr_n59324528)
print v(xbgr.mr_n59509792)
print v(xbgr.mr_n59620976)
print v(xbgr.mr_n59730976)
print v(xbgr.mr_n59901936)
print v(xbgr.mr_n57112704)
print v(xbgr.mr_n57381184)
print v(xbgr.mr_n57453936)
print v(xbgr.mr_n57766512)
print v(xbgr.mr_n57025920)
print v(xbgr.mr_n57382960)
print v(xbgr.mr_n57454176)
print v(xbgr.n_37)
print v(xbgr.mr_n57113632)
print v(xbgr.mr_n57377632)
print v(xbgr.mr_n57454416)
print v(xbgr.mr_n57660528)
print v(xbgr.n_6)
print v(xbgr.vb2)
print v(xbgr.n_2)
print v(xbgr.mr_n57767824)
print v(xbgr.mr_n57827616)
print v(xbgr.mr_n57924384)
print v(xbgr.mr_n57121888)
print v(xbgr.mr_n58077232)
print v(xbgr.mr_n58135696)
print v(xbgr.mr_n58255296)
print v(xbgr.mr_n58353744)
print v(xbgr.mr_n58343552)
print v(xbgr.mr_n58585008)
print v(xbgr.mr_n58830288)
print v(xbgr.mr_n59015616)
print v(xbgr.mr_n59172496)
print v(xbgr.mr_n59310992)
print v(xbgr.mr_n59484960)
print v(xbgr.mr_n59626384)
print v(xbgr.mr_n59708896)
print v(xbgr.mr_n59905776)
print v(xbgr.mr_n60244784)
print v(xbgr.mr_n60425472)
print v(xbgr.mr_n60640112)
print v(xbgr.mr_n60739648)
print v(xbgr.mr_n60866816)
print v(xbgr.mr_n61119920)
print v(xbgr.mr_n61305600)
print v(xbgr.mr_n61471808)
print v(xbgr.mr_n61696736)
print v(xbgr.mr_n62048208)
print v(xbgr.mr_n62241584)
print v(xbgr.mr_n62472528)
print v(xbgr.mr_n62660048)
print v(xbgr.mr_n62962336)
print v(xbgr.mr_n63170144)
print v(xbgr.mr_n63385024)
print v(xbgr.mr_n63720736)
print v(xbgr.mr_n57216688)
print v(xbgr.mr_n57251584)
print v(xbgr.mr_n57455136)
print v(xbgr.mr_n57768368)
print v(xbgr.mr_n57848032)
print v(xbgr.mr_n57924560)
print v(xbgr.mr_n57931904)
print v(xbgr.mr_n58017600)
print v(xbgr.mr_n58092320)
print v(xbgr.mr_n58200000)
print v(xbgr.mr_n58330624)
print v(xbgr.mr_n58460848)
print v(xbgr.mr_n58537424)
print v(xbgr.mr_n58860240)
print v(xbgr.mr_n58981808)
print v(xbgr.mr_n59113280)
print v(xbgr.mr_n59261216)
print v(xbgr.mr_n59389856)
print v(xbgr.mr_n59510304)
print v(xbgr.mr_n59681584)
print v(xbgr.mr_n59903712)
print v(xbgr.mr_n57217424)
print v(xbgr.mr_n57252176)
print v(xbgr.n_7)
print v(xbgr.n_36)
print v(xbgr.mr_n57879568)
print v(xbgr.mr_n57938544)
print v(xbgr.mr_n57039984)
print v(xbgr.mr_n58078192)
print v(xbgr.mr_n58178032)
print v(xbgr.mr_n58293248)
print v(xbgr.mr_n58339024)
print v(xbgr.mr_n58500704)
print v(xbgr.mr_n58604656)
print v(xbgr.mr_n58910640)
print v(xbgr.mr_n59028544)
print v(xbgr.mr_n59203024)
print v(xbgr.mr_n59325328)
print v(xbgr.mr_n59511136)
print v(xbgr.mr_n59559584)
print v(xbgr.mr_n59732784)
print v(xbgr.mr_n59905552)
print v(xbgr.mr_n57218160)
print v(xbgr.mr_n57252768)
print v(xbgr.mr_n57455936)
print v(xbgr.mr_n57769520)
print v(xbgr.mr_n57218896)
print v(xbgr.mr_n57253360)
print v(xbgr.mr_n57456336)
print v(xbgr.mr_n57770112)
print v(xbgr.mr_n57219632)
print v(xbgr.mr_n57253952)
print v(xbgr.mr_n57456736)
print v(xbgr.mr_n57770704)
print v(xbgr.mr_n57220368)
print v(xbgr.mr_n57254544)
print v(xbgr.mr_n57405424)
print v(xbgr.mr_n57771296)
print v(xbgr.mr_n57846064)
print v(xbgr.mr_n57925440)
print v(xbgr.mr_n57002256)
print v(xbgr.mr_n58078016)
print v(xbgr.mr_n58137024)
print v(xbgr.mr_n58256096)
print v(xbgr.mr_n58281856)
print v(xbgr.mr_n58286688)
print v(xbgr.mr_n58604480)
print v(xbgr.mr_n58778544)
print v(xbgr.mr_n58985952)
print v(xbgr.mr_n59202848)
print v(xbgr.mr_n59303088)
print v(xbgr.mr_n59486144)
print v(xbgr.mr_n59624432)
print v(xbgr.mr_n59713040)
print v(xbgr.mr_n59907728)
print v(xbgr.mr_n60010656)
print v(xbgr.mr_n60420368)
print v(xbgr.mr_n60642048)
print v(xbgr.mr_n60763968)
print v(xbgr.mr_n60927344)
print v(xbgr.mr_n61061600)
print v(xbgr.mr_n61272480)
print v(xbgr.mr_n61478528)
print v(xbgr.mr_n61701712)
print v(xbgr.mr_n62067568)
print v(xbgr.mr_n62217936)
print v(xbgr.mr_n62477040)
print v(xbgr.mr_n62665024)
print v(xbgr.mr_n62969760)
print v(xbgr.mr_n63154880)
print v(xbgr.mr_n63051168)
print v(xbgr.mr_n63733664)
print v(xbgr.mr_n57852112)
print v(xbgr.mr_n57925792)
print v(xbgr.mr_n57043456)
print v(xbgr.mr_n58018992)
print v(xbgr.mr_n58093712)
print v(xbgr.mr_n58202544)
print v(xbgr.mr_n58332016)
print v(xbgr.mr_n58487616)
print v(xbgr.mr_n58538816)
print v(xbgr.mr_n58861632)
print v(xbgr.mr_n58983584)
print v(xbgr.mr_n59115056)
print v(xbgr.mr_n59262992)
print v(xbgr.mr_n59391632)
print v(xbgr.mr_n59498256)
print v(xbgr.mr_n59683104)
print v(xbgr.mr_n59903488)
print v(xbgr.mr_n57220880)
print v(xbgr.mr_n57255136)
print v(xbgr.mr_n57457536)
print v(xbgr.mr_n57772480)
print v(xbgr.mr_n57221424)
print v(xbgr.mr_n57255728)
print v(xbgr.n_11)
print v(xbgr.mr_n57771888)
print v(xbgr.mr_n57881424)
print v(xbgr.mr_n57938944)
print v(xbgr.mr_n57687904)
print v(xbgr.mr_n58079392)
print v(xbgr.mr_n58178832)
print v(xbgr.mr_n58293648)
print v(xbgr.mr_n58351680)
print v(xbgr.mr_n58501520)
print v(xbgr.mr_n58605456)
print v(xbgr.mr_n58912784)
print v(xbgr.mr_n59031712)
print v(xbgr.mr_n59203824)
print v(xbgr.mr_n59326128)
print v(xbgr.mr_n59513280)
print v(xbgr.mr_n59624320)
print v(xbgr.mr_n59731088)
print v(xbgr.mr_n59907616)
print v(xbgr.mr_n57221920)
print v(xbgr.mr_n57256320)
print v(xbgr.mr_n57537424)
print v(xbgr.mr_n57767440)
print v(xbgr.mr_n57211552)
print v(xbgr.mr_n57256912)
print v(xbgr.mr_n57491200)
print v(xbgr.mr_n57721760)
print v(xbgr.mr_n57223248)
print v(xbgr.mr_n57257504)
print v(xbgr.mr_n57535648)
print v(xbgr.mr_n57774176)
print v(xbgr.mr_n57848784)
print v(xbgr.mr_n57926496)
print v(xbgr.mr_n57131920)
print v(xbgr.mr_n58052400)
print v(xbgr.mr_n58142512)
print v(xbgr.mr_n58256896)
print v(xbgr.mr_n58292848)
print v(xbgr.mr_n58490032)
print v(xbgr.mr_n58605280)
print v(xbgr.mr_n58907616)
print v(xbgr.mr_n59027872)
print v(xbgr.mr_n59187296)
print v(xbgr.mr_n59325952)
print v(xbgr.mr_n59487328)
print v(xbgr.mr_n59577040)
print v(xbgr.mr_n59729808)
print v(xbgr.mr_n59907840)
print v(xbgr.n_9)
print v(xbgr.mr_n57258096)
print v(xbgr.mr_n57444224)
print v(xbgr.mr_n57774848)
print v(xbgr.mr_n60258560)
print v(xbgr.mr_n60433504)
print v(xbgr.mr_n60644880)
print v(xbgr.mr_n60770832)
print v(xbgr.mr_n60932256)
print v(xbgr.mr_n61131056)
print v(xbgr.mr_n61329664)
print v(xbgr.mr_n61497792)
print v(xbgr.mr_n61706688)
print v(xbgr.mr_n62078128)
print v(xbgr.mr_n62259440)
print v(xbgr.mr_n62481936)
print v(xbgr.mr_n62670000)
print v(xbgr.mr_n62982128)
print v(xbgr.mr_n63167920)
print v(xbgr.mr_n63412544)
print v(xbgr.mr_n63621280)
print v(xbgr.mr_n57841168)
print v(xbgr.mr_n57926848)
print v(xbgr.mr_n57126752)
print v(xbgr.mr_n58020384)
print v(xbgr.mr_n58095104)
print v(xbgr.mr_n58205264)
print v(xbgr.mr_n58333408)
print v(xbgr.mr_n58489856)
print v(xbgr.mr_n58540208)
print v(xbgr.mr_n58905808)
print v(xbgr.mr_n58985360)
print v(xbgr.mr_n59116832)
print v(xbgr.mr_n59264768)
print v(xbgr.mr_n59393408)
print v(xbgr.mr_n59511872)
print v(xbgr.mr_n59684880)
print v(xbgr.mr_n59909680)
print v(xbgr.mr_n57224336)
print v(xbgr.mr_n57258688)
print v(xbgr.mr_n57539792)
print v(xbgr.mr_n57775440)
print v(xbgr.mr_n57882480)
print v(xbgr.mr_n57939344)
print v(xbgr.mr_n57947216)
print v(xbgr.mr_n58080512)
print v(xbgr.mr_n58179632)
print v(xbgr.mr_n58294048)
print v(xbgr.mr_n58355920)
print v(xbgr.mr_n58502400)
print v(xbgr.mr_n58606256)
print v(xbgr.mr_n58912128)
print v(xbgr.mr_n59033440)
print v(xbgr.mr_n59204624)
print v(xbgr.mr_n59326928)
print v(xbgr.mr_n59514880)
print v(xbgr.mr_n59630000)
print v(xbgr.mr_n59732896)
print v(xbgr.mr_n59905664)
print v(xbgr.mr_n57224880)
print v(xbgr.mr_n57259280)
print v(xbgr.mr_n57540384)
print v(xbgr.mr_n57776032)
print v(xbgr.mr_n57225424)
print v(xbgr.mr_n57259872)
print v(xbgr.mr_n57528784)
print v(xbgr.mr_n57776624)
print v(xbgr.mr_n57225968)
print v(xbgr.mr_n57260464)
print v(xbgr.mr_n57539200)
print v(xbgr.mr_n57777216)
print v(xbgr.mr_n57226512)
print v(xbgr.mr_n57261056)
print v(xbgr.mr_n57540672)
print v(xbgr.mr_n57777808)
print v(xbgr.mr_n57853776)
print v(xbgr.mr_n57927552)
print v(xbgr.mr_n57330192)
print v(xbgr.mr_n57326608)
print v(xbgr.mr_n58143840)
print v(xbgr.mr_n58257760)
print v(xbgr.mr_n58345680)
print v(xbgr.mr_n58488720)
print v(xbgr.mr_n58578944)
print v(xbgr.mr_n58911232)
print v(xbgr.mr_n59025648)
print v(xbgr.mr_n59204448)
print v(xbgr.mr_n59306416)
print v(xbgr.mr_n59488512)
print v(xbgr.mr_n59628304)
print v(xbgr.mr_n59736512)
print v(xbgr.mr_n59911968)
print v(xbgr.mr_n60262496)
print v(xbgr.mr_n60429360)
print v(xbgr.mr_n60645152)
print v(xbgr.mr_n60781504)
print v(xbgr.mr_n60946688)
print v(xbgr.mr_n61142768)
print v(xbgr.mr_n61321376)
print v(xbgr.mr_n61487776)
print v(xbgr.mr_n61719792)
print v(xbgr.mr_n62082976)
print v(xbgr.mr_n62281280)
print v(xbgr.mr_n62486832)
print v(xbgr.mr_n62245760)
print v(xbgr.mr_n62982240)
print v(xbgr.mr_n63164192)
print v(xbgr.mr_n63389232)
print v(xbgr.mr_n63628896)
print v(xbgr.mr_n57227056)
print v(xbgr.mr_n57261648)
print v(xbgr.mr_n57541216)
print v(xbgr.mr_n57778400)
print v(xbgr.mr_n57857104)
print v(xbgr.mr_n57927904)
print v(xbgr.mr_n57076752)
print v(xbgr.mr_n58021776)
print v(xbgr.mr_n58094640)
print v(xbgr.mr_n58214224)
print v(xbgr.mr_n58332944)
print v(xbgr.mr_n58491344)
print v(xbgr.mr_n58541600)
print v(xbgr.mr_n58909424)
print v(xbgr.mr_n58984768)
print v(xbgr.mr_n59116240)
print v(xbgr.mr_n59266544)
print v(xbgr.mr_n59392816)
print v(xbgr.mr_n59515952)
print v(xbgr.mr_n59686656)
print v(xbgr.mr_n59909792)
print v(xbgr.mr_n57227872)
print v(xbgr.mr_n57262240)
print v(xbgr.mr_n57542176)
print v(xbgr.mr_n57778992)
print v(xbgr.mr_n57884336)
print v(xbgr.mr_n57939744)
print v(xbgr.mr_n57950912)
print v(xbgr.mr_n58080256)
print v(xbgr.mr_n58180432)
print v(xbgr.mr_n58294448)
print v(xbgr.mr_n58363760)
print v(xbgr.mr_n58503376)
print v(xbgr.mr_n58607056)
print v(xbgr.mr_n58916832)
print v(xbgr.mr_n59035328)
print v(xbgr.mr_n59205424)
print v(xbgr.mr_n59327728)
print v(xbgr.mr_n59516624)
print v(xbgr.mr_n59560400)
print v(xbgr.mr_n59734592)
print v(xbgr.mr_n59909904)
print v(xbgr.mr_n57228144)
print v(xbgr.mr_n57262832)
print v(xbgr.n_3)
print v(xbgr.n_33)
print v(xbgr.mr_n57219520)
print v(xbgr.mr_n57263424)
print v(xbgr.mr_n57543520)
print v(xbgr.mr_n57780096)
print v(xbgr.mr_n57229232)
print v(xbgr.mr_n57264016)
print v(xbgr.mr_n57544112)
print v(xbgr.mr_n57780768)
print v(xbgr.mr_n57230624)
print v(xbgr.mr_n57264608)
print v(xbgr.mr_n57544704)
print v(xbgr.mr_n57781360)
print v(xbgr.mr_n57851360)
print v(xbgr.mr_n57928960)
print v(xbgr.mr_n57946688)
print v(xbgr.mr_n57995120)
print v(xbgr.mr_n58148656)
print v(xbgr.mr_n58258944)
print v(xbgr.mr_n58361376)
print v(xbgr.mr_n58490512)
print v(xbgr.mr_n58606880)
print v(xbgr.mr_n58775296)
print v(xbgr.mr_n58828208)
print v(xbgr.mr_n58952896)
print v(xbgr.mr_n59186480)
print v(xbgr.mr_n59323728)
print v(xbgr.mr_n59489696)
print v(xbgr.mr_n59626496)
print v(xbgr.mr_n59734704)
print v(xbgr.mr_n59914032)
print v(xbgr.mr_n60260240)
print v(xbgr.mr_n60455008)
print v(xbgr.mr_n60658448)
print v(xbgr.mr_n60765984)
print v(xbgr.mr_n60942032)
print v(xbgr.mr_n61142256)
print v(xbgr.mr_n61342992)
print v(xbgr.mr_n61507040)
print v(xbgr.mr_n61716800)
print v(xbgr.mr_n61887296)
print v(xbgr.mr_n62101584)
print v(xbgr.mr_n62266064)
print v(xbgr.mr_n62489280)
print v(xbgr.mr_n62563520)
print v(xbgr.mr_n62989664)
print v(xbgr.mr_n63167536)
print v(xbgr.mr_n63388000)
print v(xbgr.mr_n63560288)
print v(xbgr.mr_n57858016)
print v(xbgr.mr_n57903408)
print v(xbgr.mr_n57042848)
print v(xbgr.mr_n58022240)
print v(xbgr.mr_n58094176)
print v(xbgr.mr_n58207632)
print v(xbgr.mr_n58332480)
print v(xbgr.mr_n58492656)
print v(xbgr.mr_n58542992)
print v(xbgr.mr_n58775488)
print v(xbgr.mr_n58916256)
print v(xbgr.mr_n58984176)
print v(xbgr.mr_n59115648)
print v(xbgr.mr_n59268320)
print v(xbgr.mr_n59392224)
print v(xbgr.mr_n59514288)
print v(xbgr.mr_n59688432)
print v(xbgr.mr_n59901264)
print v(xbgr.mr_n57231088)
print v(xbgr.n_19)
print v(xbgr.mr_n57535056)
print v(xbgr.mr_n57781952)
print v(xbgr.mr_n57885792)
print v(xbgr.mr_n57940144)
print v(xbgr.mr_n57952720)
print v(xbgr.mr_n58079216)
print v(xbgr.mr_n58181232)
print v(xbgr.mr_n58270784)
print v(xbgr.mr_n58359344)
print v(xbgr.mr_n58503200)
print v(xbgr.mr_n58607856)
print v(xbgr.mr_n58786368)
print v(xbgr.mr_n58918976)
print v(xbgr.mr_n59037056)
print v(xbgr.mr_n59186592)
print v(xbgr.mr_n59328528)
print v(xbgr.mr_n59517744)
print v(xbgr.mr_n59628192)
print v(xbgr.mr_n59740016)
print v(xbgr.mr_n59911744)
print v(xbgr.mr_n57232016)
print v(xbgr.mr_n57265792)
print v(xbgr.mr_n57545888)
print v(xbgr.mr_n57782544)
print v(xbgr.mr_n57232944)
print v(xbgr.mr_n57266384)
print v(xbgr.mr_n57546480)
print v(xbgr.mr_n57783136)
print v(xbgr.mr_n57234336)
print v(xbgr.mr_n57266976)
print v(xbgr.mr_n57547072)
print v(xbgr.mr_n57783728)
print v(xbgr.mr_n57020016)
print v(xbgr.mr_n57267568)
print v(xbgr.mr_n57547664)
print v(xbgr.mr_n57784320)
print v(xbgr.mr_n57853024)
print v(xbgr.mr_n57936448)
print v(xbgr.mr_n57139872)
print v(xbgr.mr_n58010272)
print v(xbgr.mr_n58149984)
print v(xbgr.mr_n58260128)
print v(xbgr.mr_n58364400)
print v(xbgr.mr_n58491168)
print v(xbgr.mr_n58546896)
print v(xbgr.mr_n58776192)
print v(xbgr.mr_n58915360)
print v(xbgr.mr_n59029216)
print v(xbgr.mr_n59202048)
print v(xbgr.mr_n59324352)
print v(xbgr.mr_n59490288)
print v(xbgr.mr_n59631920)
print v(xbgr.mr_n59738208)
print v(xbgr.mr_n59913920)
print v(xbgr.mr_n57233408)
print v(xbgr.mr_n57268160)
print v(xbgr.mr_n57548256)
print v(xbgr.mr_n57784912)
print v(xbgr.mr_n60256944)
print v(xbgr.mr_n60459792)
print v(xbgr.mr_n60653712)
print v(xbgr.mr_n60797232)
print v(xbgr.mr_n60936912)
print v(xbgr.mr_n61130592)
print v(xbgr.mr_n61326960)
print v(xbgr.mr_n61497088)
print v(xbgr.mr_n61621616)
print v(xbgr.mr_n61890496)
print v(xbgr.mr_n62076336)
print v(xbgr.mr_n62292416)
print v(xbgr.mr_n62484384)
print v(xbgr.mr_n62680896)
print v(xbgr.mr_n63002032)
print v(xbgr.mr_n63183280)
print v(xbgr.mr_n63365920)
print v(xbgr.mr_n63601696)
print v(xbgr.mr_n57862096)
print v(xbgr.mr_n57903136)
print v(xbgr.mr_n57362112)
print v(xbgr.mr_n58021312)
print v(xbgr.mr_n58093248)
print v(xbgr.mr_n58130240)
print v(xbgr.mr_n58331552)
print v(xbgr.mr_n58493312)
print v(xbgr.mr_n58579456)
print v(xbgr.mr_n58746640)
print v(xbgr.mr_n58914192)
print v(xbgr.mr_n58982992)
print v(xbgr.mr_n59114464)
print v(xbgr.mr_n59270096)
print v(xbgr.mr_n59391040)
print v(xbgr.mr_n59518448)
print v(xbgr.mr_n59690208)
print v(xbgr.mr_n59913808)
print v(xbgr.mr_n57232480)
print v(xbgr.mr_n57268752)
print v(xbgr.mr_n57548848)
print v(xbgr.mr_n57785504)
print v(xbgr.mr_n57886848)
print v(xbgr.mr_n57940784)
print v(xbgr.mr_n57954528)
print v(xbgr.mr_n57045456)
print v(xbgr.mr_n58181632)
print v(xbgr.mr_n58295248)
print v(xbgr.mr_n58368736)
print v(xbgr.mr_n58505712)
print v(xbgr.mr_n58608656)
print v(xbgr.mr_n58789808)
print v(xbgr.mr_n58892928)
print v(xbgr.mr_n59038864)
print v(xbgr.mr_n59207024)
print v(xbgr.mr_n59329328)
print v(xbgr.mr_n59520912)
print v(xbgr.mr_n59635536)
print v(xbgr.mr_n59741824)
print v(xbgr.mr_n59915872)
print v(xbgr.mr_n57231552)
print v(xbgr.mr_n57269344)
print v(xbgr.mr_n57549440)
print v(xbgr.mr_n57786096)
print v(xbgr.mr_n57230160)
print v(xbgr.mr_n57269936)
print v(xbgr.n_4)
print v(xbgr.n_30)
print v(xbgr.mr_n57229696)
print v(xbgr.mr_n57056832)
print v(xbgr.mr_n57550624)
print v(xbgr.mr_n57787280)
print v(xbgr.mr_n57228960)
print v(xbgr.mr_n57220144)
print v(xbgr.mr_n57551216)
print v(xbgr.mr_n57787872)
print v(xbgr.mr_n57856352)
print v(xbgr.mr_n57935440)
print v(xbgr.mr_n57325632)
print v(xbgr.mr_n57999456)
print v(xbgr.mr_n58154800)
print v(xbgr.mr_n58261312)
print v(xbgr.mr_n58367120)
print v(xbgr.mr_n58487344)
print v(xbgr.mr_n58520128)
print v(xbgr.mr_n58748752)
print v(xbgr.mr_n58917424)
print v(xbgr.mr_n58945872)
print v(xbgr.mr_n59205248)
print v(xbgr.mr_n59329152)
print v(xbgr.mr_n59489104)
print v(xbgr.mr_n59633616)
print v(xbgr.mr_n59710080)
print v(xbgr.mr_n59918160)
print v(xbgr.mr_n56185520)
print v(xbgr.mr_n60465568)
print v(xbgr.mr_n60669584)
print v(xbgr.mr_n60809408)
print v(xbgr.mr_n60950880)
print v(xbgr.mr_n61153328)
print v(xbgr.mr_n61354128)
print v(xbgr.mr_n61462704)
print v(xbgr.mr_n61625040)
print v(xbgr.mr_n61922064)
print v(xbgr.mr_n62032528)
print v(xbgr.mr_n62278736)
print v(xbgr.mr_n62479488)
print v(xbgr.mr_n62687504)
print v(xbgr.mr_n63002144)
print v(xbgr.mr_n63178160)
print v(xbgr.mr_n63363392)
print v(xbgr.mr_n63567792)
print v(xbgr.mr_n57228416)
print v(xbgr.mr_n57084288)
print v(xbgr.mr_n57551808)
print v(xbgr.mr_n57788464)
print v(xbgr.mr_n57863008)
print v(xbgr.mr_n57902864)
print v(xbgr.mr_n57124320)
print v(xbgr.mr_n58020848)
print v(xbgr.mr_n58092784)
print v(xbgr.mr_n58172224)
print v(xbgr.mr_n58331088)
print v(xbgr.mr_n58492000)
print v(xbgr.mr_n58523296)
print v(xbgr.mr_n58620272)
print v(xbgr.mr_n58779568)
print v(xbgr.mr_n58982400)
print v(xbgr.mr_n59113872)
print v(xbgr.mr_n59271872)
print v(xbgr.mr_n59390448)
print v(xbgr.mr_n59520336)
print v(xbgr.mr_n59691984)
print v(xbgr.mr_n59915984)
print v(xbgr.mr_n57227600)
print v(xbgr.mr_n57095552)
print v(xbgr.mr_n57552400)
print v(xbgr.mr_n57789056)
print v(xbgr.mr_n57888704)
print v(xbgr.mr_n57941584)
print v(xbgr.mr_n57356400)
print v(xbgr.mr_n58080080)
print v(xbgr.mr_n58180832)
print v(xbgr.mr_n58295648)
print v(xbgr.mr_n58361648)
print v(xbgr.mr_n58502224)
print v(xbgr.mr_n58609216)
print v(xbgr.mr_n58791696)
print v(xbgr.mr_n58923024)
print v(xbgr.mr_n59040752)
print v(xbgr.mr_n59207824)
print v(xbgr.mr_n59330128)
print v(xbgr.mr_n59521792)
print v(xbgr.mr_n59631808)
print v(xbgr.mr_n59736400)
print v(xbgr.mr_n59916096)
print v(xbgr.mr_n57227328)
print v(xbgr.mr_n57212016)
print v(xbgr.mr_n57552992)
print v(xbgr.mr_n57721040)
print v(xbgr.mr_n57226784)
print v(xbgr.mr_n57221696)
print v(xbgr.mr_n57553584)
print v(xbgr.mr_n57790160)
print v(xbgr.mr_n57226240)
print v(xbgr.mr_n57089920)
print v(xbgr.mr_n57545296)
print v(xbgr.mr_n57773072)
print v(xbgr.mr_n57858768)
print v(xbgr.mr_n57941408)
print v(xbgr.mr_n57946800)
print v(xbgr.mr_n58011552)
print v(xbgr.mr_n58156128)
print v(xbgr.mr_n58262496)
print v(xbgr.mr_n58371488)
print v(xbgr.mr_n58486880)
print v(xbgr.mr_n58607680)
print v(xbgr.mr_n58747040)
print v(xbgr.mr_n58920800)
print v(xbgr.mr_n59032224)
print v(xbgr.mr_n59206048)
print v(xbgr.mr_n59323552)
print v(xbgr.mr_n59487920)
print v(xbgr.mr_n59633728)
print v(xbgr.mr_n59745440)
print v(xbgr.mr_n59911856)
print v(xbgr.mr_n57225696)
print v(xbgr.mr_n57060352)
print v(xbgr.mr_n57554768)
print v(xbgr.mr_n57791344)
print v(xbgr.mr_n60130992)
print v(xbgr.mr_n60458352)
print v(xbgr.mr_n60686464)
print v(xbgr.mr_n60788048)
print v(xbgr.mr_n60869344)
print v(xbgr.mr_n61147888)
print v(xbgr.mr_n61348688)
print v(xbgr.mr_n61506336)
print v(xbgr.mr_n58638528)
print v(xbgr.mr_n61625152)
print v(xbgr.mr_n61927296)
print v(xbgr.mr_n62088704)
print v(xbgr.mr_n62305872)
print v(xbgr.mr_n62494752)
print v(xbgr.mr_n62692480)
print v(xbgr.mr_n63024832)
print v(xbgr.mr_n63136576)
print v(xbgr.mr_n63387808)
print v(xbgr.mr_n62736832)
print v(xbgr.mr_n57867088)
print v(xbgr.mr_n57902592)
print v(xbgr.mr_n57011424)
print v(xbgr.mr_n58019920)
print v(xbgr.mr_n58091856)
print v(xbgr.mr_n58215072)
print v(xbgr.mr_n58330160)
print v(xbgr.mr_n58490688)
print v(xbgr.mr_n58710192)
print v(xbgr.mr_n58919488)
print v(xbgr.mr_n58981216)
print v(xbgr.mr_n59112688)
print v(xbgr.mr_n59267488)
print v(xbgr.mr_n59389264)
print v(xbgr.mr_n59521616)
print v(xbgr.mr_n59740128)
print v(xbgr.mr_n59922064)
print v(xbgr.mr_n57225152)
print v(xbgr.mr_n57079360)
print v(xbgr.mr_n57555360)
print v(xbgr.mr_n57792016)
print v(xbgr.mr_n57890080)
print v(xbgr.mr_n57942384)
print v(xbgr.mr_n57958144)
print v(xbgr.mr_n58077056)
print v(xbgr.mr_n58180032)
print v(xbgr.mr_n58296048)
print v(xbgr.mr_n58371264)
print v(xbgr.mr_n58507568)
print v(xbgr.mr_n58608480)
print v(xbgr.mr_n58793504)
print v(xbgr.mr_n58925168)
print v(xbgr.mr_n59042480)
print v(xbgr.mr_n59208624)
print v(xbgr.mr_n59330928)
print v(xbgr.mr_n59524176)
print v(xbgr.mr_n59637344)
print v(xbgr.mr_n59738320)
print v(xbgr.mr_n59917936)
print v(xbgr.mr_n57224608)
print v(xbgr.mr_n57009008)
print v(xbgr.mr_n57555952)
print v(xbgr.mr_n57792608)
print v(xbgr.mr_n57224064)
print v(xbgr.mr_n57072320)
print v(xbgr.mr_n57556544)
print v(xbgr.mr_n57793200)
print v(xbgr.mr_n57223520)
print v(xbgr.mr_n57075136)
print v(xbgr.n_5)
print v(xbgr.mr_n57793792)
print v(xbgr.mr_n57222704)
print v(xbgr.mr_n57006064)
print v(xbgr.mr_n57557728)
print v(xbgr.mr_n57794368)
print v(xbgr.mr_n57866032)
print v(xbgr.mr_n57936112)
print v(xbgr.mr_n57946576)
print v(xbgr.mr_n57997728)
print v(xbgr.mr_n58131520)
print v(xbgr.mr_n58263680)
print v(xbgr.mr_n58371376)
print v(xbgr.mr_n58486992)
print v(xbgr.mr_n58602640)
print v(xbgr.mr_n58775936)
print v(xbgr.mr_n58923616)
print v(xbgr.mr_n59034032)
print v(xbgr.mr_n59208448)
print v(xbgr.mr_n59325152)
print v(xbgr.mr_n59486736)
print v(xbgr.mr_n59630112)
print v(xbgr.mr_n59747360)
print v(xbgr.mr_n59920112)
print v(xbgr.mr_n56421984)
print v(xbgr.mr_n60369408)
print v(xbgr.mr_n60663616)
print v(xbgr.mr_n60808896)
print v(xbgr.mr_n60946224)
print v(xbgr.mr_n61136752)
print v(xbgr.mr_n61337552)
print v(xbgr.mr_n61515248)
print v(xbgr.mr_n58581632)
print v(xbgr.mr_n61613792)
print v(xbgr.mr_n61924304)
print v(xbgr.mr_n62060848)
print v(xbgr.mr_n62286976)
print v(xbgr.mr_n62469072)
print v(xbgr.mr_n62697568)
print v(xbgr.mr_n63021936)
print v(xbgr.mr_n63173504)
print v(xbgr.mr_n63242144)
print v(xbgr.mr_n63593376)
print v(xbgr.mr_n57222432)
print v(xbgr.mr_n57233872)
print v(xbgr.mr_n57558320)
print v(xbgr.mr_n57794960)
print v(xbgr.mr_n57866144)
print v(xbgr.mr_n57902320)
print v(xbgr.mr_n57087840)
print v(xbgr.mr_n58019456)
print v(xbgr.mr_n58091392)
print v(xbgr.mr_n58134864)
print v(xbgr.mr_n58329776)
print v(xbgr.mr_n58488896)
print v(xbgr.mr_n58281568)
print v(xbgr.mr_n58924512)
print v(xbgr.mr_n58980624)
print v(xbgr.mr_n59112096)
print v(xbgr.mr_n59274960)
print v(xbgr.mr_n59388672)
print v(xbgr.mr_n59517568)
print v(xbgr.mr_n59741936)
print v(xbgr.mr_n59922288)
print v(xbgr.mr_n57221152)
print v(xbgr.mr_n57081472)
print v(xbgr.mr_n57558912)
print v(xbgr.mr_n57795552)
print v(xbgr.mr_n57891616)
print v(xbgr.mr_n57943184)
print v(xbgr.mr_n57959952)
print v(xbgr.mr_n57999200)
print v(xbgr.mr_n58179232)
print v(xbgr.mr_n58296448)
print v(xbgr.mr_n58376448)
print v(xbgr.mr_n58508544)
print v(xbgr.mr_n58606080)
print v(xbgr.mr_n58795312)
print v(xbgr.mr_n58918320)
print v(xbgr.mr_n59027760)
print v(xbgr.mr_n59209424)
print v(xbgr.mr_n59331728)
print v(xbgr.mr_n59525136)
print v(xbgr.mr_n59635424)
print v(xbgr.mr_n59745552)
print v(xbgr.mr_n59920000)
print v(xbgr.mr_n57182320)
print v(xbgr.mr_n57389472)
print v(xbgr.mr_n57559504)
print v(xbgr.mr_n57796144)
print v(xbgr.mr_n57182784)
print v(xbgr.mr_n57390064)
print v(xbgr.mr_n57560096)
print v(xbgr.mr_n57790832)
print v(xbgr.mr_n57183248)
print v(xbgr.mr_n57390656)
print v(xbgr.mr_n57560688)
print v(xbgr.mr_n57779584)
print v(xbgr.mr_n57183712)
print v(xbgr.mr_n57391248)
print v(xbgr.mr_n57561280)
print v(xbgr.mr_n57797840)
print v(xbgr.mr_n57861040)
print v(xbgr.mr_n57927728)
print v(xbgr.mr_n57956096)
print v(xbgr.mr_n57979264)
print v(xbgr.mr_n58131776)
print v(xbgr.mr_n58264864)
print v(xbgr.mr_n58375696)
print v(xbgr.mr_n58486512)
print v(xbgr.mr_n58642624)
print v(xbgr.mr_n58789232)
print v(xbgr.mr_n58914608)
print v(xbgr.mr_n58897008)
print v(xbgr.mr_n59209248)
print v(xbgr.mr_n59327552)
print v(xbgr.mr_n59485552)
print v(xbgr.mr_n59639152)
print v(xbgr.mr_n59749168)
print v(xbgr.mr_n59926416)
print v(xbgr.mr_n60131792)
print v(xbgr.mr_n60408912)
print v(xbgr.mr_n60689168)
print v(xbgr.mr_n60816384)
print v(xbgr.mr_n60941568)
print v(xbgr.mr_n61133632)
print v(xbgr.mr_n61321840)
print v(xbgr.mr_n61528432)
print v(xbgr.mr_n58603680)
print v(xbgr.mr_n61619472)
print v(xbgr.mr_n61936992)
print v(xbgr.mr_n62065696)
print v(xbgr.mr_n62254928)
print v(xbgr.mr_n62463328)
print v(xbgr.mr_n62702432)
print v(xbgr.mr_n63006096)
print v(xbgr.mr_n63159536)
print v(xbgr.mr_n63388512)
print v(xbgr.mr_n63610496)
print v(xbgr.mr_n57861152)
print v(xbgr.mr_n57902048)
print v(xbgr.mr_n57353600)
print v(xbgr.mr_n58018528)
print v(xbgr.mr_n58090464)
print v(xbgr.mr_n58134752)
print v(xbgr.mr_n58329168)
print v(xbgr.mr_n58486768)
print v(xbgr.mr_n58602144)
print v(xbgr.mr_n58926576)
print v(xbgr.mr_n58979632)
print v(xbgr.mr_n59111104)
print v(xbgr.mr_n59275568)
print v(xbgr.mr_n59387488)
print v(xbgr.mr_n59526128)
print v(xbgr.mr_n59743744)
print v(xbgr.mr_n59924128)
print v(xbgr.mr_n57175952)
print v(xbgr.mr_n57391840)
print v(xbgr.mr_n57561872)
print v(xbgr.mr_n57798512)
print v(xbgr.mr_n57184640)
print v(xbgr.mr_n57392432)
print v(xbgr.mr_n57562464)
print v(xbgr.mr_n57799104)
print v(xbgr.mr_n57892672)
print v(xbgr.mr_n57943984)
print v(xbgr.mr_n57951424)
print v(xbgr.mr_n57993696)
print v(xbgr.mr_n58178432)
print v(xbgr.mr_n58296848)
print v(xbgr.mr_n58378848)
print v(xbgr.mr_n58509184)
print v(xbgr.mr_n58585760)
print v(xbgr.mr_n58794016)
print v(xbgr.mr_n58929296)
print v(xbgr.mr_n59046176)
print v(xbgr.mr_n59210224)
print v(xbgr.mr_n59332528)
print v(xbgr.mr_n59526800)
print v(xbgr.mr_n59637232)
print v(xbgr.mr_n59749056)
print v(xbgr.mr_n59920224)
print v(xbgr.mr_n57185104)
print v(xbgr.mr_n57393024)
print v(xbgr.mr_n57554176)
print v(xbgr.mr_n57799696)
print v(xbgr.mr_n57185568)
print v(xbgr.mr_n57384736)
print v(xbgr.mr_n57563648)
print v(xbgr.mr_n57800288)
print v(xbgr.mr_n57172240)
print v(xbgr.mr_n57385264)
print v(xbgr.mr_n57564240)
print v(xbgr.n_31)
print v(xbgr.mr_n57856048)
print v(xbgr.mr_n57935776)
print v(xbgr.mr_n57946464)
print v(xbgr.mr_n57992688)
print v(xbgr.mr_n57714688)
print v(xbgr.mr_n58266048)
print v(xbgr.mr_n58377344)
print v(xbgr.mr_n58460592)
print v(xbgr.mr_n58641328)
print v(xbgr.mr_n58778160)
print v(xbgr.mr_n58927744)
print v(xbgr.mr_n59037648)
print v(xbgr.mr_n59206848)
print v(xbgr.mr_n59332352)
print v(xbgr.mr_n59484368)
print v(xbgr.mr_n59642768)
print v(xbgr.mr_n59749280)
print v(xbgr.mr_n59924240)
print v(xbgr.mr_n57186496)
print v(xbgr.mr_n57394800)
print v(xbgr.mr_n57564832)
print v(xbgr.mr_n57801472)
print v(xbgr.mr_n60126464)
print v(xbgr.mr_n60390496)
print v(xbgr.mr_n60677776)
print v(xbgr.mr_n60791344)
print v(xbgr.mr_n60955536)
print v(xbgr.mr_n61114480)
print v(xbgr.mr_n61271536)
print v(xbgr.mr_n61504016)
print v(xbgr.mr_n58642368)
print v(xbgr.mr_n61621728)
print v(xbgr.mr_n61934096)
print v(xbgr.mr_n62063504)
print v(xbgr.mr_n62265600)
print v(xbgr.mr_n62447040)
print v(xbgr.mr_n62707520)
print v(xbgr.mr_n62991872)
print v(xbgr.mr_n63182816)
print v(xbgr.mr_n63387536)
print v(xbgr.mr_n63599600)
print v(xbgr.mr_n57856160)
print v(xbgr.mr_n57901856)
print v(xbgr.mr_n57358320)
print v(xbgr.mr_n58018064)
print v(xbgr.mr_n58090000)
print v(xbgr.mr_n58129888)
print v(xbgr.mr_n58328864)
print v(xbgr.mr_n58412944)
print v(xbgr.mr_n58253472)
print v(xbgr.mr_n58913296)
print v(xbgr.mr_n58979168)
print v(xbgr.mr_n59110640)
print v(xbgr.mr_n59275232)
print v(xbgr.mr_n59386896)
print v(xbgr.mr_n59525568)
print v(xbgr.mr_n59743632)
print v(xbgr.mr_n59922176)
print v(xbgr.mr_n57186960)
print v(xbgr.mr_n57395392)
print v(xbgr.mr_n57565424)
print v(xbgr.mr_n57802064)
print v(xbgr.mr_n57894128)
print v(xbgr.mr_n57944784)
print v(xbgr.mr_n57963568)
print v(xbgr.mr_n57998112)
print v(xbgr.mr_n58176832)
print v(xbgr.mr_n58297248)
print v(xbgr.mr_n58369456)
print v(xbgr.mr_n58510400)
print v(xbgr.mr_n58637904)
print v(xbgr.mr_n58798848)
print v(xbgr.mr_n58931360)
print v(xbgr.mr_n59047984)
print v(xbgr.mr_n59211024)
print v(xbgr.mr_n59326752)
print v(xbgr.mr_n59528384)
print v(xbgr.mr_n59640960)
print v(xbgr.mr_n59751120)
print v(xbgr.mr_n59926192)
print v(xbgr.mr_n57187424)
print v(xbgr.mr_n57395984)
print v(xbgr.mr_n57566016)
print v(xbgr.mr_n57802656)
print v(xbgr.mr_n57187888)
print v(xbgr.n_34)
print v(xbgr.mr_n57566608)
print v(xbgr.mr_n57797248)
print v(xbgr.mr_n57188352)
print v(xbgr.mr_n57397104)
print v(xbgr.mr_n57567200)
print v(xbgr.mr_n57803760)
print v(xbgr.mr_n57175024)
print v(xbgr.mr_n57397760)
print v(xbgr.mr_n57567792)
print v(xbgr.mr_n57804432)
print v(xbgr.mr_n57851056)
print v(xbgr.mr_n57940608)
print v(xbgr.mr_n57956848)
print v(xbgr.mr_n58076880)
print v(xbgr.mr_n58095568)
print v(xbgr.mr_n58267232)
print v(xbgr.mr_n58381872)
print v(xbgr.mr_n58460336)
print v(xbgr.mr_n58644720)
print v(xbgr.mr_n58787152)
print v(xbgr.mr_n58929808)
print v(xbgr.mr_n59044128)
print v(xbgr.mr_n59201248)
print v(xbgr.mr_n59331552)
print v(xbgr.mr_n59416752)
print v(xbgr.mr_n59640848)
print v(xbgr.mr_n59751344)
print v(xbgr.mr_n59924352)
print v(xbgr.mr_n60130192)
print v(xbgr.mr_n60423728)
print v(xbgr.mr_n60666640)
print v(xbgr.mr_n56175952)
print v(xbgr.mr_n60960192)
print v(xbgr.mr_n61103344)
print v(xbgr.mr_n61305792)
print v(xbgr.mr_n61531840)
print v(xbgr.mr_n58634080)
print v(xbgr.mr_n61619280)
print v(xbgr.mr_n61939184)
print v(xbgr.mr_n62063696)
print v(xbgr.mr_n62254464)
print v(xbgr.mr_n62413072)
print v(xbgr.mr_n62712496)
print v(xbgr.mr_n62964544)
print v(xbgr.mr_n63187472)
print v(xbgr.mr_n63392992)
print v(xbgr.mr_n63618080)
print v(xbgr.mr_n57189280)
print v(xbgr.mr_n57398352)
print v(xbgr.mr_n57568384)
print v(xbgr.mr_n57805024)
print v(xbgr.mr_n57851168)
print v(xbgr.mr_n57900464)
print v(xbgr.mr_n57127056)
print v(xbgr.mr_n58017136)
print v(xbgr.mr_n58089072)
print v(xbgr.mr_n58170976)
print v(xbgr.mr_n58272592)
print v(xbgr.mr_n58412640)
print v(xbgr.mr_n58712016)
print v(xbgr.mr_n58930704)
print v(xbgr.mr_n58978240)
print v(xbgr.mr_n59109712)
print v(xbgr.mr_n59274688)
print v(xbgr.mr_n59385776)
print v(xbgr.mr_n59529056)
print v(xbgr.mr_n59753296)
print v(xbgr.mr_n59928256)
print v(xbgr.mr_n57181392)
print v(xbgr.mr_n57398944)
print v(xbgr.mr_n57568976)
print v(xbgr.mr_n57805616)
print v(xbgr.mr_n57895584)
print v(xbgr.mr_n57945584)
print v(xbgr.mr_n57965376)
print v(xbgr.mr_n58053328)
print v(xbgr.mr_n58162256)
print v(xbgr.mr_n58297648)
print v(xbgr.mr_n58361264)
print v(xbgr.mr_n58511280)
print v(xbgr.mr_n58644832)
print v(xbgr.mr_n58800736)
print v(xbgr.mr_n58933424)
print v(xbgr.mr_n59049792)
print v(xbgr.mr_n59211824)
print v(xbgr.mr_n59334128)
print v(xbgr.mr_n59530144)
print v(xbgr.mr_n59646272)
print v(xbgr.mr_n59747248)
print v(xbgr.mr_n59918048)
print v(xbgr.mr_n57190208)
print v(xbgr.mr_n57399536)
print v(xbgr.mr_n57569568)
print v(xbgr.mr_n57806208)
print v(xbgr.mr_n57190672)
print v(xbgr.mr_n57393616)
print v(xbgr.mr_n57570160)
print v(xbgr.mr_n57806800)
print v(xbgr.mr_n57191136)
print v(xbgr.mr_n57400720)
print v(xbgr.mr_n57570752)
print v(xbgr.mr_n57807392)
print v(xbgr.mr_n57191600)
print v(xbgr.mr_n57394128)
print v(xbgr.n_10)
print v(xbgr.mr_n57807984)
print v(xbgr.mr_n57846176)
print v(xbgr.mr_n57336640)
print v(xbgr.mr_n57948320)
print v(xbgr.mr_n58053024)
print v(xbgr.mr_n58131264)
print v(xbgr.mr_n58268416)
print v(xbgr.mr_n58384144)
print v(xbgr.mr_n58404640)
print v(xbgr.mr_n58634384)
print v(xbgr.mr_n58775680)
print v(xbgr.mr_n58927072)
print v(xbgr.mr_n59015360)
print v(xbgr.mr_n59210848)
print v(xbgr.mr_n59328352)
print v(xbgr.mr_n59309824)
print v(xbgr.mr_n59642656)
print v(xbgr.mr_n59755248)
print v(xbgr.mr_n59935488)
print v(xbgr.mr_n56537408)
print v(xbgr.mr_n60421616)
print v(xbgr.mr_n60654224)
print v(xbgr.mr_n60770368)
print v(xbgr.mr_n60964848)
print v(xbgr.mr_n61093792)
print v(xbgr.mr_n61306304)
print v(xbgr.mr_n61536816)
print v(xbgr.mr_n58648304)
print v(xbgr.mr_n61618704)
print v(xbgr.mr_n61944160)
print v(xbgr.mr_n62065888)
print v(xbgr.mr_n62241200)
print v(xbgr.mr_n62454480)
print v(xbgr.mr_n62717360)
print v(xbgr.mr_n62851424)
print v(xbgr.mr_n63079040)
print v(xbgr.mr_n63268224)
print v(xbgr.mr_n63582704)
print v(xbgr.mr_n57846368)
print v(xbgr.mr_n57898320)
print v(xbgr.mr_n57943008)
print v(xbgr.mr_n58016672)
print v(xbgr.mr_n58088608)
print v(xbgr.mr_n57716192)
print v(xbgr.mr_n58294848)
print v(xbgr.mr_n58386480)
print v(xbgr.mr_n58692432)
print v(xbgr.mr_n58932768)
print v(xbgr.mr_n58977776)
print v(xbgr.mr_n59109248)
print v(xbgr.mr_n59255312)
print v(xbgr.mr_n59385312)
print v(xbgr.mr_n59523168)
print v(xbgr.mr_n59757312)
print v(xbgr.mr_n59926304)
print v(xbgr.mr_n57192064)
print v(xbgr.mr_n57401840)
print v(xbgr.mr_n57563056)
print v(xbgr.mr_n57808576)
print v(xbgr.mr_n57192528)
print v(xbgr.mr_n57383552)
print v(xbgr.mr_n57572528)
print v(xbgr.mr_n57809168)
print v(xbgr.mr_n57897360)
print v(xbgr.mr_n56606544)
print v(xbgr.mr_n57967184)
print v(xbgr.mr_n58078752)
print v(xbgr.mr_n58176112)
print v(xbgr.mr_n58298048)
print v(xbgr.mr_n58381376)
print v(xbgr.mr_n58512256)
print v(xbgr.mr_n58637712)
print v(xbgr.mr_n58802544)
print v(xbgr.mr_n58935488)
print v(xbgr.mr_n59051600)
print v(xbgr.mr_n59211648)
print v(xbgr.mr_n59334928)
print v(xbgr.mr_n59531488)
print v(xbgr.mr_n59644464)
print v(xbgr.mr_n59751232)
print v(xbgr.mr_n59928368)
print v(xbgr.mr_n57192992)
print v(xbgr.mr_n57403088)
print v(xbgr.mr_n57573120)
print v(xbgr.mr_n57809760)
print v(xbgr.mr_n57193456)
print v(xbgr.mr_n57403680)
print v(xbgr.mr_n57573712)
print v(xbgr.mr_n57810352)
print v(xbgr.mr_n57193920)
print v(xbgr.mr_n57404272)
print v(xbgr.mr_n57574304)
print v(xbgr.mr_n57761632)
print v(xbgr.mr_n57835216)
print v(xbgr.mr_n57120736)
print v(xbgr.mr_n57964080)
print v(xbgr.mr_n58027104)
print v(xbgr.mr_n58036368)
print v(xbgr.mr_n58269600)
print v(xbgr.mr_n58386592)
print v(xbgr.mr_n58460144)
print v(xbgr.mr_n58644944)
print v(xbgr.mr_n58790400)
print v(xbgr.mr_n58921552)
print v(xbgr.mr_n59041264)
print v(xbgr.mr_n59203648)
print v(xbgr.mr_n59333152)
print v(xbgr.mr_n59416048)
print v(xbgr.mr_n59639040)
print v(xbgr.mr_n59759600)
print v(xbgr.mr_n59938992)
print v(xbgr.mr_n57184176)
print v(xbgr.mr_n57404864)
print v(xbgr.mr_n57574896)
print v(xbgr.mr_n57051200)
print v(xbgr.mr_n56529952)
print v(xbgr.mr_n60412016)
print v(xbgr.mr_n60633792)
print v(xbgr.mr_n60765712)
print v(xbgr.mr_n60969504)
print v(xbgr.mr_n61059920)
print v(xbgr.mr_n61267760)
print v(xbgr.mr_n61541792)
print v(xbgr.mr_n58650160)
print v(xbgr.mr_n61618896)
print v(xbgr.mr_n61912576)
print v(xbgr.mr_n62028768)
print v(xbgr.mr_n62208448)
print v(xbgr.mr_n62471616)
print v(xbgr.mr_n62621504)
print v(xbgr.mr_n62853424)
print v(xbgr.mr_n63081888)
print v(xbgr.mr_n63362256)
print v(xbgr.mr_n63607488)
print v(xbgr.mr_n57842304)
print v(xbgr.mr_n57901392)
print v(xbgr.mr_n57044912)
print v(xbgr.mr_n58015744)
print v(xbgr.mr_n58081152)
print v(xbgr.mr_n58047664)
print v(xbgr.mr_n58215440)
print v(xbgr.mr_n58406896)
print v(xbgr.mr_n58751376)
print v(xbgr.mr_n58829248)
print v(xbgr.mr_n58950912)
print v(xbgr.mr_n59073776)
print v(xbgr.mr_n59272816)
print v(xbgr.mr_n59334752)
print v(xbgr.mr_n59526304)
print v(xbgr.mr_n59755472)
print v(xbgr.mr_n59931136)
print v(xbgr.mr_n57194848)
print v(xbgr.mr_n57221808)
print v(xbgr.mr_n57575488)
print v(xbgr.mr_n57483632)
print v(xbgr.mr_n57898496)
print v(xbgr.mr_n57010512)
print v(xbgr.mr_n57968992)
print v(xbgr.mr_n58075792)
print v(xbgr.mr_n58158160)
print v(xbgr.mr_n58298448)
print v(xbgr.mr_n58386368)
print v(xbgr.mr_n58512896)
print v(xbgr.mr_n58633504)
print v(xbgr.mr_n58804272)
print v(xbgr.mr_n58937296)
print v(xbgr.mr_n59053408)
print v(xbgr.mr_n59213424)
print v(xbgr.mr_n59335728)
print v(xbgr.mr_n59534272)
print v(xbgr.mr_n59646384)
print v(xbgr.mr_n59753184)
print v(xbgr.mr_n59935008)
print v(xbgr.mr_n57180464)
print v(xbgr.mr_n57369472)
print v(xbgr.mr_n57576080)
print v(xbgr.mr_n57529936)
print v(xbgr.mr_n57195776)
print v(xbgr.mr_n57403936)
print v(xbgr.mr_n57576672)
print v(xbgr.mr_n57789648)
print v(xbgr.mr_n57196240)
print v(xbgr.mr_n57360896)
print v(xbgr.mr_n57577264)
print v(xbgr.mr_n57765456)
print v(xbgr.mr_n57196704)
print v(xbgr.mr_n57363920)
print v(xbgr.mr_n57577856)
print v(xbgr.mr_n57764384)
print v(xbgr.mr_n57197168)
print v(xbgr.mr_n57366944)
print v(xbgr.mr_n57578432)
print v(xbgr.mr_n57668816)
print v(xbgr.mr_n57195312)
print v(xbgr.mr_n57103568)
print v(xbgr.mr_n57579024)
print v(xbgr.mr_n57717296)
print v(xbgr.mr_n57189744)
print v(xbgr.mr_n57368832)
print v(xbgr.mr_n57579616)
print v(xbgr.mr_n57760736)
print v(xbgr.mr_n57198560)
print v(xbgr.mr_n57114656)
print v(xbgr.mr_n57580208)
print v(xbgr.mr_n57761984)
print v(xbgr.mr_n58054016)
print v(xbgr.mr_n59533776)
print v(xbgr.mr_n59755360)
print v(xbgr.mr_n59935120)
print v(xbgr.mr_n57199024)
print v(xbgr.mr_n57400128)
print v(xbgr.mr_n57571936)
print v(xbgr.mr_n57761248)
print v(xbgr.d5)
print v(xbgr.d1)
print v(xbgr.mr_n58051840)
print v(xbgr.mr_n58386864)
print v(xbgr.mr_n57899120)
print v(xbgr.mr_n57955040)
print v(xbgr.mr_n58374032)
print v(xbgr.mr_n59533520)
print v(xbgr.n1)
print v(xbgr.mr_n59939472)
print v(xbgr.mr_n57199488)
print v(xbgr.mr_n57314192)
print v(xbgr.mr_n57581392)
print v(xbgr.mr_n57810912)
print v(xbgr.mr_n59333952)
print v(xbgr.mr_n59559328)
print v(xbgr.mr_n59774784)
print v(xbgr.mr_n57839520)
print v(xbgr.mr_n57931632)
print v(xbgr.kick)
print v(xbgr.mr_n58228256)
print v(xbgr.mr_n59532000)
print v(xbgr.mr_n59702992)
print v(xbgr.mr_n59931024)
print v(xbgr.mr_n57186032)
print v(xbgr.mr_n57314400)
print v(xbgr.mr_n57581984)
print v(xbgr.mr_n57812048)
print v(xbgr.mr_n57200416)
print v(xbgr.mr_n57401312)
print v(xbgr.mr_n57540560)
print v(xbgr.mr_n57812592)
print v(xbgr.mr_n57896944)
print v(xbgr.mr_n57969504)
print v(xbgr.mr_n58030816)
print v(xbgr.mr_n58379680)
print v(xbgr.mr_n59534944)
print v(xbgr.mr_n59761440)
print v(xbgr.mr_n59928480)
print v(xbgr.mr_n58509456)
print v(xbgr.mr_n58622752)
print v(xbgr.mr_n58727616)
print v(xbgr.mr_n58799440)
print v(xbgr.mr_n59044880)
print v(xbgr.mr_n59176368)
print v(xbgr.mr_n59295456)
print v(xbgr.mr_n58507392)
print v(xbgr.mr_n58625040)
print v(xbgr.mr_n58722992)
print v(xbgr.mr_n58792208)
print v(xbgr.mr_n59039456)
print v(xbgr.mr_n59183072)
print v(xbgr.mr_n59306768)
print v(xbgr.mr_n57200880)
print v(xbgr.mr_n57405536)
print v(xbgr.mr_n57583168)
print v(xbgr.mr_n57813056)
print v(xbgr.mr_n59528128)
print v(xbgr.mr_n59703344)
print v(xbgr.mr_n59943088)
print v(xbgr.mr_n58413328)
print v(xbgr.mr_n58544384)
print v(xbgr.mr_n58660800)
print v(xbgr.mr_n58748192)
print v(xbgr.mr_n58951328)
print v(xbgr.mr_n59076912)
print v(xbgr.mr_n59210048)
print v(xbgr.mr_n59348272)
print v(xbgr.mr_n59576576)
print v(xbgr.mr_n59778784)
print v(xbgr.mr_n57201344)
print v(xbgr.mr_n57406176)
print v(xbgr.mr_n57583760)
print v(xbgr.mr_n57813520)
print v(xbgr.mr_n59530656)
print v(xbgr.mr_n59703232)
print v(xbgr.mr_n59943456)
print v(xbgr.mr_n58053744)
print v(xbgr.mr_n58504320)
print v(xbgr.d2)
print v(xbgr.mr_n58727392)
print v(xbgr.mr_n58803056)
print v(xbgr.mr_n59043072)
print v(xbgr.mr_n59144656)
print v(xbgr.mr_n59271040)
print v(xbgr.mr_n57899344)
print v(xbgr.mr_n57969616)
print v(xbgr.mr_n58389088)
print v(xbgr.mr_n57201808)
print v(xbgr.mr_n57406880)
print v(xbgr.mr_n57584352)
print v(xbgr.mr_n57813984)
print v(xbgr.mr_n57899456)
print v(xbgr.mr_n57962272)
print v(xbgr.mr_n58389904)
print v(xbgr.mr_n59536336)
print v(xbgr.mr_n59757536)
print v(xbgr.mr_n59939104)
print v(xbgr.mr_n58052624)
print v(xbgr.mr_n57202272)
print v(xbgr.mr_n57407792)
print v(xbgr.mr_n57584944)
print v(xbgr.mr_n57815424)
print v(xbgr.mr_n57840064)
print v(xbgr.mr_n57931360)
print v(xbgr.mr_n58271856)
print v(xbgr.det)
print v(xbgr.mr_n59537136)
print v(xbgr.mr_n59703456)
print v(xbgr.mr_n59931504)
print v(xbgr.mr_n58030096)
print v(xbgr.mr_n57188816)
print v(xbgr.mr_n57408768)
print v(xbgr.mr_n57585536)
print v(xbgr.mr_n57814448)
print v(xbgr.mr_n59350048)
print v(xbgr.mr_n59576112)
print v(xbgr.mr_n59780640)
print v(xbgr.mr_n57899232)
print v(xbgr.mr_n57953232)
print v(xbgr.mr_n58389200)
print v(xbgr.mr_n59538080)
print v(xbgr.mr_n59703680)
print v(xbgr.mr_n59947664)
print v(xbgr.mr_n58513504)
print v(xbgr.mr_n58622864)
print v(xbgr.mr_n58727504)
print v(xbgr.mr_n58797632)
print v(xbgr.mr_n59053920)
print v(xbgr.mr_n59179664)
print v(xbgr.mr_n59298816)
print v(xbgr.mr_n58513616)
print v(xbgr.mr_n58622640)
print v(xbgr.mr_n58688384)
print v(xbgr.mr_n58804976)
print v(xbgr.mr_n59050304)
print v(xbgr.mr_n59183888)
print v(xbgr.mr_n59307584)
print v(xbgr.mr_n57203200)
print v(xbgr.mr_n57409360)
print v(xbgr.mr_n57586128)
print v(xbgr.mr_n57665264)
print v(xbgr.mr_n58436608)
print v(xbgr.mr_n58546304)
print v(xbgr.mr_n58668944)
print v(xbgr.mr_n58752192)
print v(xbgr.mr_n58955360)
print v(xbgr.mr_n59080944)
print v(xbgr.mr_n59213968)
print v(xbgr.mr_n59538496)
print v(xbgr.mr_n59763984)
print v(xbgr.mr_n59946160)
print v(xbgr.mr_n57197632)
print v(xbgr.mr_n57409952)
print v(xbgr.mr_n57586720)
print v(xbgr.mr_n57764272)
print v(xbgr.mr_n59535056)
print v(xbgr.mr_n59703568)
print v(xbgr.mr_n59942976)
print v(xbgr.mr_n57204128)
print v(xbgr.mr_n57410544)
print v(xbgr.mr_n57587312)
print v(xbgr.mr_n57821504)
print v(xbgr.mr_n58051648)
print v(xbgr.mr_n58511904)
print v(xbgr.mr_n58638848)
print v(xbgr.mr_n58725296)
print v(xbgr.mr_n58805088)
print v(xbgr.mr_n59054640)
print v(xbgr.mr_n59142288)
print v(xbgr.mr_n59268144)
print v(xbgr.mr_n57900080)
print v(xbgr.mr_n57970576)
print v(xbgr.mr_n58390592)
print v(xbgr.mr_n59351904)
print v(xbgr.mr_n59575648)
print v(xbgr.mr_n59782496)
print v(xbgr.mr_n57900192)
print v(xbgr.mr_n57970112)
print v(xbgr.mr_n58384032)
print v(xbgr.mr_n59538608)
print v(xbgr.mr_n59704224)
print v(xbgr.mr_n59946048)
print v(xbgr.mr_n57204592)
print v(xbgr.mr_n57411136)
print v(xbgr.mr_n57587904)
print v(xbgr.mr_n57821728)
print v(xbgr.mr_n58027440)
print v(xbgr.mr_n57839792)
print v(xbgr.mr_n57931088)
print v(xbgr.mr_n57990240)
print v(xbgr.mr_n58272128)
print v(xbgr.r4n)
print v(xbgr.mr_n57205056)
print v(xbgr.mr_n57411728)
print v(xbgr.mr_n57588496)
print v(xbgr.mr_n57821840)
print v(xbgr.mr_n59539168)
print v(xbgr.mr_n59765616)
print v(xbgr.mr_n59948560)
print v(xbgr.mr_n57896208)
print v(xbgr.mr_n57971312)
print v(xbgr.mr_n58389392)
print v(xbgr.mr_n58513392)
print v(xbgr.mr_n58663920)
print v(xbgr.mr_n58724272)
print v(xbgr.mr_n58801248)
print v(xbgr.mr_n59054144)
print v(xbgr.mr_n59179312)
print v(xbgr.mr_n59301920)
print v(xbgr.mr_n58514464)
print v(xbgr.mr_n58662288)
print v(xbgr.mr_n58731728)
print v(xbgr.mr_n58796880)
print v(xbgr.mr_n59035840)
print v(xbgr.mr_n59177072)
print v(xbgr.mr_n59302272)
print v(xbgr.mr_n57205520)
print v(xbgr.mr_n57412320)
print v(xbgr.mr_n57589088)
print v(xbgr.mr_n57821952)
print v(xbgr.mr_n59539424)
print v(xbgr.mr_n59706528)
print v(xbgr.mr_n59950128)
print v(xbgr.mr_n59353760)
print v(xbgr.mr_n59575184)
print v(xbgr.mr_n59784352)
print v(xbgr.mr_n58436144)
print v(xbgr.mr_n58545776)
print v(xbgr.mr_n58669760)
print v(xbgr.mr_n58753008)
print v(xbgr.mr_n58956176)
print v(xbgr.mr_n59081760)
print v(xbgr.mr_n59214384)
print v(xbgr.mr_n57205984)
print v(xbgr.mr_n57412896)
print v(xbgr.mr_n57589680)
print v(xbgr.mr_n57822064)
print v(xbgr.mr_n59541776)
print v(xbgr.mr_n59707120)
print v(xbgr.mr_n59952688)
print v(xbgr.mr_n57206448)
print v(xbgr.mr_n57413488)
print v(xbgr.mr_n57590272)
print v(xbgr.mr_n57822176)
print v(xbgr.mr_n58050752)
print v(xbgr.mr_n58514352)
print v(xbgr.mr_n58662720)
print v(xbgr.mr_n58726816)
print v(xbgr.mr_n58805424)
print v(xbgr.mr_n59055104)
print v(xbgr.mr_n59145248)
print v(xbgr.mr_n59269264)
print v(xbgr.mr_n59542640)
print v(xbgr.mr_n59767248)
print v(xbgr.mr_n59951120)
print v(xbgr.mr_n57900816)
print v(xbgr.mr_n57971424)
print v(xbgr.mr_n58390240)
print v(xbgr.mr_n57898144)
print v(xbgr.mr_n57971856)
print v(xbgr.mr_n58391216)
print v(xbgr.mr_n57206912)
print v(xbgr.mr_n57414080)
print v(xbgr.mr_n57590864)
print v(xbgr.mr_n57822480)
print v(xbgr.mr_n59542528)
print v(xbgr.mr_n59708304)
print v(xbgr.mr_n59948384)
print v(xbgr.mr_n58044832)
print v(xbgr.mr_n57839248)
print v(xbgr.mr_n57930816)
print v(xbgr.mr_n58271664)
print v(xbgr.mr_n57992336)
print v(xbgr.mr_n59355616)
print v(xbgr.mr_n59574720)
print v(xbgr.mr_n59786208)
print v(xbgr.mr_n57207376)
print v(xbgr.mr_n57414640)
print v(xbgr.mr_n57591456)
print v(xbgr.mr_n57822752)
print v(xbgr.mr_n58022704)
print v(xbgr.mr_n59544800)
print v(xbgr.mr_n59710672)
print v(xbgr.mr_n59953680)
print v(xbgr.mr_n57899728)
print v(xbgr.mr_n57970960)
print v(xbgr.mr_n58377232)
print v(xbgr.mr_n57207840)
print v(xbgr.mr_n57415216)
print v(xbgr.mr_n57592048)
print v(xbgr.mr_n57823024)
print v(xbgr.mr_n58512080)
print v(xbgr.mr_n58622416)
print v(xbgr.mr_n58721136)
print v(xbgr.mr_n58805312)
print v(xbgr.mr_n59054032)
print v(xbgr.mr_n59172960)
print v(xbgr.mr_n59285232)
print v(xbgr.mr_n58516272)
print v(xbgr.mr_n58665792)
print v(xbgr.mr_n58734064)
print v(xbgr.mr_n58805968)
print v(xbgr.mr_n59056208)
print v(xbgr.mr_n59180480)
print v(xbgr.mr_n59292048)
print v(xbgr.mr_n59545216)
print v(xbgr.mr_n59768880)
print v(xbgr.mr_n59950944)
print v(xbgr.mr_n57198096)
print v(xbgr.mr_n57415808)
print v(xbgr.mr_n57592640)
print v(xbgr.mr_n57821616)
print v(xbgr.mr_n58435680)
print v(xbgr.mr_n58545312)
print v(xbgr.mr_n58670576)
print v(xbgr.mr_n58753744)
print v(xbgr.mr_n58956992)
print v(xbgr.mr_n59082576)
print v(xbgr.mr_n59215200)
print v(xbgr.mr_n59540240)
print v(xbgr.mr_n59702400)
print v(xbgr.mr_n59955248)
print v(xbgr.mr_n57208768)
print v(xbgr.mr_n57416400)
print v(xbgr.mr_n57593232)
print v(xbgr.mr_n57823488)
print v(xbgr.mr_n59357472)
print v(xbgr.mr_n59574256)
print v(xbgr.mr_n59788096)
print v(xbgr.mr_n58514240)
print v(xbgr.mr_n58665520)
print v(xbgr.mr_n58719072)
print v(xbgr.mr_n58806240)
print v(xbgr.mr_n59057744)
print v(xbgr.mr_n59141104)
print v(xbgr.mr_n59269920)
print v(xbgr.mr_n59547088)
print v(xbgr.mr_n59709488)
print v(xbgr.mr_n59953504)
print v(xbgr.mr_n57893792)
print v(xbgr.mr_n57973872)
print v(xbgr.d3)
print v(xbgr.mr_n58391680)
print v(xbgr.mr_n57893184)
print v(xbgr.mr_n57974560)
print v(xbgr.mr_n58169056)
print v(xbgr.mr_n58392784)
print v(xbgr.mr_n57194384)
print v(xbgr.mr_n57416992)
print v(xbgr.mr_n57593824)
print v(xbgr.mr_n57823840)
print v(xbgr.mr_n57838976)
print v(xbgr.mr_n57930544)
print v(xbgr.mr_n58031776)
print v(xbgr.mr_n58270480)
print v(xbgr.mr_n59547616)
print v(xbgr.mr_n59770512)
print v(xbgr.mr_n59956240)
print v(xbgr.mr_n57209696)
print v(xbgr.mr_n57417584)
print v(xbgr.mr_n57594416)
print v(xbgr.mr_n57824112)
print v(xbgr.mr_n59545888)
print v(xbgr.mr_n59707712)
print v(xbgr.mr_n59957808)
print v(xbgr.mr_n57210160)
print v(xbgr.mr_n57418176)
print v(xbgr.mr_n57595008)
print v(xbgr.mr_n57824816)
print v(xbgr.mr_n57896096)
print v(xbgr.mr_n57958656)
print v(xbgr.mr_n58184096)
print v(xbgr.mr_n58394816)
print v(xbgr.mr_n58513888)
print v(xbgr.mr_n58642768)
print v(xbgr.mr_n58688272)
print v(xbgr.mr_n58795824)
print v(xbgr.mr_n58933936)
print v(xbgr.mr_n59052112)
print v(xbgr.mr_n59175904)
print v(xbgr.mr_n59298624)
print v(xbgr.mr_n58517568)
print v(xbgr.mr_n58623424)
print v(xbgr.mr_n58719296)
print v(xbgr.mr_n58805200)
print v(xbgr.mr_n58920384)
print v(xbgr.mr_n59054992)
print v(xbgr.mr_n59176256)
print v(xbgr.mr_n59297952)
print v(xbgr.mr_n59359328)
print v(xbgr.mr_n59573792)
print v(xbgr.mr_n59790464)
print v(xbgr.mr_n59548496)
print v(xbgr.mr_n59705616)
print v(xbgr.mr_n59960368)
print v(xbgr.mr_n57210624)
print v(xbgr.mr_n57418768)
print v(xbgr.mr_n57595600)
print v(xbgr.mr_n57825216)
print v(xbgr.mr_n58435216)
print v(xbgr.mr_n58544848)
print v(xbgr.mr_n58671392)
print v(xbgr.mr_n58753280)
print v(xbgr.mr_n58829600)
print v(xbgr.mr_n58957808)
print v(xbgr.mr_n59083392)
print v(xbgr.mr_n59216016)
print v(xbgr.mr_n57211088)
print v(xbgr.mr_n57419360)
print v(xbgr.mr_n57596192)
print v(xbgr.mr_n57825616)
print v(xbgr.mr_n59547504)
print v(xbgr.mr_n59769424)
print v(xbgr.mr_n59956064)
print v(xbgr.mr_n58518720)
print v(xbgr.mr_n58662144)
print v(xbgr.mr_n58732832)
print v(xbgr.mr_n58785408)
print v(xbgr.mr_n58938144)
print v(xbgr.mr_n59058784)
print v(xbgr.mr_n59144064)
print v(xbgr.mr_n59263936)
print v(xbgr.mr_n57894640)
print v(xbgr.mr_n57975440)
print v(xbgr.mr_n58213680)
print v(xbgr.mr_n58393248)
print v(xbgr.mr_n57896768)
print v(xbgr.mr_n57969728)
print v(xbgr.mr_n58112416)
print v(xbgr.mr_n58394352)
print v(xbgr.mr_n57209232)
print v(xbgr.mr_n57419952)
print v(xbgr.mr_n57596784)
print v(xbgr.mr_n57826016)
print v(xbgr.mr_n59543520)
print v(xbgr.mr_n59703952)
print v(xbgr.mr_n59963744)
print v(xbgr.mr_n59360256)
print v(xbgr.mr_n59573328)
print v(xbgr.mr_n59791648)
print v(xbgr.mr_n57203664)
print v(xbgr.mr_n57420544)
print v(xbgr.mr_n57597376)
print v(xbgr.mr_n57529680)
print v(xbgr.mr_n57838704)
print v(xbgr.mr_n57930272)
print v(xbgr.mr_n58006896)
print v(xbgr.mr_n58269296)
print v(xbgr.mr_n59551200)
print v(xbgr.mr_n59619264)
print v(xbgr.mr_n59962928)
print v(xbgr.mr_n57212480)
print v(xbgr.mr_n57421136)
print v(xbgr.mr_n57597968)
print v(xbgr.mr_n57827216)
print v(xbgr.mr_n57887360)
print v(xbgr.mr_n57975088)
print v(xbgr.mr_n58182272)
print v(xbgr.mr_n58396384)
print v(xbgr.mr_n59552048)
print v(xbgr.mr_n59771600)
print v(xbgr.mr_n59958624)
print v(xbgr.mr_n58518544)
print v(xbgr.mr_n57385840)
print v(xbgr.mr_n58719520)
print v(xbgr.mr_n58807648)
print v(xbgr.mr_n58938880)
print v(xbgr.mr_n59055840)
print v(xbgr.mr_n59162864)
print v(xbgr.mr_n58783552)
print v(xbgr.mr_n58519440)
print v(xbgr.mr_n58641824)
print v(xbgr.mr_n58718560)
print v(xbgr.mr_n58804864)
print v(xbgr.mr_n58937920)
print v(xbgr.mr_n59060784)
print v(xbgr.mr_n59169552)
print v(xbgr.mr_n59297728)
print v(xbgr.mr_n57212944)
print v(xbgr.mr_n57421728)
print v(xbgr.mr_n57580800)
print v(xbgr.mr_n57823296)
print v(xbgr.mr_n59552864)
print v(xbgr.mr_n59615968)
print v(xbgr.mr_n59966304)
print v(xbgr.mr_n58434752)
print v(xbgr.mr_n58543920)
print v(xbgr.mr_n58672464)
print v(xbgr.mr_n58752736)
print v(xbgr.mr_n58832064)
print v(xbgr.mr_n58958624)
print v(xbgr.mr_n59084208)
print v(xbgr.mr_n59216832)
print v(xbgr.mr_n59359792)
print v(xbgr.mr_n59572864)
print v(xbgr.mr_n59791056)
print v(xbgr.mr_n57213408)
print v(xbgr.mr_n57422320)
print v(xbgr.mr_n57599152)
print v(xbgr.mr_n57828016)
print v(xbgr.mr_n59548832)
print v(xbgr.mr_n59608800)
print v(xbgr.mr_n59965488)
print v(xbgr.mr_n58518064)
print v(xbgr.mr_n58648608)
print v(xbgr.mr_n58719184)
print v(xbgr.mr_n58810368)
print v(xbgr.mr_n58928640)
print v(xbgr.mr_n59062384)
print v(xbgr.mr_n59143472)
print v(xbgr.mr_n59266368)
print v(xbgr.mr_n57199952)
print v(xbgr.mr_n57422912)
print v(xbgr.mr_n57599744)
print v(xbgr.mr_n57828416)
print v(xbgr.mr_n57895072)
print v(xbgr.mr_n57977008)
print v(xbgr.mr_n58215264)
print v(xbgr.mr_n58395920)
print v(xbgr.mr_n57892496)
print v(xbgr.mr_n57977696)
print v(xbgr.mr_n58216144)
print v(xbgr.mr_n58397488)
print v(xbgr.mr_n59554336)
print v(xbgr.mr_n59774240)
print v(xbgr.mr_n59961184)
print v(xbgr.mr_n57214336)
print v(xbgr.mr_n57423504)
print v(xbgr.mr_n57582576)
print v(xbgr.mr_n57829216)
print v(xbgr.mr_n57838432)
print v(xbgr.mr_n57930000)
print v(xbgr.mr_n58010016)
print v(xbgr.mr_n58268112)
print v(xbgr.mr_n59549840)
print v(xbgr.mr_n59701808)
print v(xbgr.mr_n59963920)
print v(xbgr.mr_n57214800)
print v(xbgr.mr_n57424096)
print v(xbgr.mr_n57600928)
print v(xbgr.mr_n57829616)
print v(xbgr.mr_n59358864)
print v(xbgr.mr_n59572400)
print v(xbgr.mr_n59789872)
print v(xbgr.mr_n57891280)
print v(xbgr.mr_n57973456)
print v(xbgr.mr_n58182736)
print v(xbgr.mr_n58398016)
print v(xbgr.mr_n58517072)
print v(xbgr.mr_n58630304)
print v(xbgr.mr_n58719632)
print v(xbgr.mr_n58808080)
print v(xbgr.mr_n58938992)
print v(xbgr.mr_n59061952)
print v(xbgr.mr_n59169024)
print v(xbgr.mr_n59294928)
print v(xbgr.mr_n59555552)
print v(xbgr.mr_n59700624)
print v(xbgr.mr_n59958800)
print v(xbgr.mr_n58520736)
print v(xbgr.mr_n58629888)
print v(xbgr.mr_n58720448)
print v(xbgr.mr_n58809936)
print v(xbgr.mr_n58940016)
print v(xbgr.mr_n59063488)
print v(xbgr.mr_n59172848)
print v(xbgr.mr_n59297840)
print v(xbgr.mr_n57215264)
print v(xbgr.mr_n57424688)
print v(xbgr.mr_n57601520)
print v(xbgr.mr_n57830016)
print v(xbgr.mr_n58434288)
print v(xbgr.mr_n58543456)
print v(xbgr.mr_n58672928)
print v(xbgr.mr_n58752464)
print v(xbgr.mr_n58832880)
print v(xbgr.mr_n58959440)
print v(xbgr.mr_n59085024)
print v(xbgr.mr_n59217648)
print v(xbgr.mr_n57181856)
print v(xbgr.mr_n57425280)
print v(xbgr.mr_n57602112)
print v(xbgr.mr_n57830416)
print v(xbgr.mr_n59556368)
print v(xbgr.mr_n59771056)
print v(xbgr.mr_n59966480)
print v(xbgr.mr_n59557296)
print v(xbgr.mr_n59609600)
print v(xbgr.mr_n59971424)
print v(xbgr.mr_n57166672)
print v(xbgr.mr_n57425872)
print v(xbgr.mr_n57536240)
print v(xbgr.mr_n57830816)
print v(xbgr.mr_n58519072)
print v(xbgr.mr_n58611760)
print v(xbgr.mr_n58720096)
print v(xbgr.mr_n58809392)
print v(xbgr.mr_n58940912)
print v(xbgr.mr_n59061472)
print v(xbgr.mr_n59142880)
print v(xbgr.mr_n59265712)
print v(xbgr.mr_n57888208)
print v(xbgr.mr_n57978576)
print v(xbgr.mr_n58211200)
print v(xbgr.mr_n58395232)
print v(xbgr.mr_n57893616)
print v(xbgr.mr_n57976128)
print v(xbgr.mr_n58214656)
print v(xbgr.mr_n58399056)
print v(xbgr.mr_n59358400)
print v(xbgr.mr_n59571936)
print v(xbgr.mr_n59789280)
print v(xbgr.mr_n59558240)
print v(xbgr.mr_n59701216)
print v(xbgr.mr_n59970608)
print v(xbgr.mr_n57158336)
print v(xbgr.mr_n57426464)
print v(xbgr.mr_n57313744)
print v(xbgr.mr_n57831616)
print v(xbgr.mr_n57838160)
print v(xbgr.mr_n57929728)
print v(xbgr.mr_n57157664)
print v(xbgr.mr_n58266928)
print v(xbgr.mr_n57170384)
print v(xbgr.mr_n57427056)
print v(xbgr.mr_n57494752)
print v(xbgr.mr_n57832016)
print v(xbgr.mr_n59558656)
print v(xbgr.mr_n59772688)
print v(xbgr.mr_n59968864)
print v(xbgr.mr_n57890672)
print v(xbgr.mr_n57978224)
print v(xbgr.mr_n58183280)
print v(xbgr.mr_n58399584)
print v(xbgr.mr_n58521712)
print v(xbgr.mr_n58662544)
print v(xbgr.mr_n58720560)
print v(xbgr.mr_n58806592)
print v(xbgr.mr_n58941600)
print v(xbgr.mr_n59064368)
print v(xbgr.mr_n59164576)
print v(xbgr.mr_n59288640)
print v(xbgr.mr_n57180000)
print v(xbgr.mr_n57427648)
print v(xbgr.mr_n57367920)
print v(xbgr.mr_n57832416)
print v(xbgr.mr_n58522608)
print v(xbgr.mr_n58663728)
print v(xbgr.mr_n58736960)
print v(xbgr.mr_n58813472)
print v(xbgr.mr_n58940192)
print v(xbgr.mr_n59060096)
print v(xbgr.mr_n59173664)
print v(xbgr.mr_n58783776)
print v(xbgr.mr_n59552608)
print v(xbgr.mr_n59698256)
print v(xbgr.mr_n59968048)
print v(xbgr.mr_n59357936)
print v(xbgr.mr_n59571472)
print v(xbgr.mr_n59788688)
print v(xbgr.mr_n57179536)
print v(xbgr.mr_n57428240)
print v(xbgr.mr_n57533872)
print v(xbgr.mr_n57832816)
print v(xbgr.mr_n58433824)
print v(xbgr.mr_n58542528)
print v(xbgr.mr_n58672000)
print v(xbgr.mr_n58751920)
print v(xbgr.mr_n58833696)
print v(xbgr.mr_n58959168)
print v(xbgr.mr_n59084752)
print v(xbgr.mr_n59217376)
print v(xbgr.mr_n59558768)
print v(xbgr.mr_n59699440)
print v(xbgr.mr_n59971600)
print v(xbgr.mr_n57179072)
print v(xbgr.mr_n57428832)
print v(xbgr.mr_n57533280)
print v(xbgr.mr_n57676576)
print v(xbgr.mr_n58522944)
print v(xbgr.mr_n58611408)
print v(xbgr.mr_n58738304)
print v(xbgr.mr_n58815136)
print v(xbgr.mr_n58943360)
print v(xbgr.mr_n59067152)
print v(xbgr.mr_n59140512)
print v(xbgr.mr_n59264592)
print v(xbgr.mr_n57892320)
print v(xbgr.mr_n57980144)
print v(xbgr.mr_n58212896)
print v(xbgr.mr_n58392096)
print v(xbgr.mr_n59553808)
print v(xbgr.mr_n59772144)
print v(xbgr.mr_n59902352)
print v(xbgr.mr_n57891104)
print v(xbgr.mr_n57980832)
print v(xbgr.mr_n58212720)
print v(xbgr.mr_n58396800)
print v(xbgr.mr_n57178608)
print v(xbgr.mr_n57429424)
print v(xbgr.mr_n57531280)
print v(xbgr.mr_n57834016)
print v(xbgr.mr_n59555216)
print v(xbgr.mr_n59698848)
print v(xbgr.mr_n59902592)
print v(xbgr.mr_n57837888)
print v(xbgr.mr_n57929536)
print v(xbgr.mr_n57996896)
print v(xbgr.mr_n58265744)
print v(xbgr.mr_n57178144)
print v(xbgr.mr_n57430016)
print v(xbgr.mr_n57538608)
print v(xbgr.mr_n57672368)
print v(xbgr.mr_n59357008)
print v(xbgr.mr_n59571008)
print v(xbgr.mr_n59787600)
print v(xbgr.mr_n59557040)
print v(xbgr.mr_n59700032)
print v(xbgr.mr_n59969040)
print v(xbgr.mr_n57889824)
print v(xbgr.mr_n57973024)
print v(xbgr.mr_n58183008)
print v(xbgr.mr_n58401008)
print v(xbgr.mr_n57177744)
print v(xbgr.mr_n57430608)
print v(xbgr.mr_n57606464)
print v(xbgr.mr_n57671712)
print v(xbgr.mr_n58519776)
print v(xbgr.mr_n58657472)
print v(xbgr.mr_n58737936)
print v(xbgr.mr_n58806832)
print v(xbgr.mr_n58941712)
print v(xbgr.mr_n59068192)
print v(xbgr.mr_n59161568)
print v(xbgr.mr_n59276384)
print v(xbgr.mr_n58516960)
print v(xbgr.mr_n58617600)
print v(xbgr.mr_n58739152)
print v(xbgr.mr_n58810784)
print v(xbgr.mr_n58943184)
print v(xbgr.mr_n59062800)
print v(xbgr.mr_n59169440)
print v(xbgr.mr_n59295344)
print v(xbgr.mr_n59556480)
print v(xbgr.mr_n59766704)
print v(xbgr.mr_n59973168)
print v(xbgr.mr_n57177280)
print v(xbgr.mr_n57431200)
print v(xbgr.mr_n57534464)
print v(xbgr.mr_n57661120)
print v(xbgr.mr_n58433360)
print v(xbgr.mr_n58542064)
print v(xbgr.mr_n58671664)
print v(xbgr.mr_n58751648)
print v(xbgr.mr_n58834512)
print v(xbgr.mr_n58958896)
print v(xbgr.mr_n59084480)
print v(xbgr.mr_n59217104)
print v(xbgr.mr_n59554224)
print v(xbgr.mr_n59695888)
print v(xbgr.mr_n59885520)
print v(xbgr.mr_n57176816)
print v(xbgr.mr_n57431792)
print v(xbgr.mr_n57607696)
print v(xbgr.mr_n57670528)
print v(xbgr.mr_n59356544)
print v(xbgr.mr_n59570560)
print v(xbgr.mr_n59787136)
print v(xbgr.mr_n58515904)
print v(xbgr.mr_n58597024)
print v(xbgr.mr_n58737584)
print v(xbgr.mr_n58816176)
print v(xbgr.mr_n58942624)
print v(xbgr.mr_n59059664)
print v(xbgr.mr_n59078480)
print v(xbgr.mr_n59260384)
print v(xbgr.mr_n57889216)
print v(xbgr.mr_n57981712)
print v(xbgr.mr_n58203568)
print v(xbgr.mr_n58393664)
print v(xbgr.mr_n59551024)
print v(xbgr.mr_n59695296)
print v(xbgr.mr_n58774464)
print v(xbgr.mr_n57885280)
print v(xbgr.mr_n57982400)
print v(xbgr.mr_n58212176)
print v(xbgr.mr_n58400624)
print v(xbgr.mr_n57176416)
print v(xbgr.mr_n57432384)
print v(xbgr.mr_n57608496)
print v(xbgr.mr_n57665856)
print v(xbgr.mr_n57837616)
print v(xbgr.mr_n57928784)
print v(xbgr.mr_n58047184)
print v(xbgr.mr_n58264560)
print v(xbgr.mr_n57169920)
print v(xbgr.mr_n57432976)
print v(xbgr.mr_n57608896)
print v(xbgr.mr_n57656976)
print v(xbgr.mr_n59551936)
print v(xbgr.mr_n59961360)
print v(xbgr.mr_n57175488)
print v(xbgr.mr_n57433568)
print v(xbgr.mr_n57610096)
print v(xbgr.mr_n57656384)
print v(xbgr.mr_n59550592)
print v(xbgr.mr_n59886832)
print v(xbgr.mr_n57889648)
print v(xbgr.mr_n57979728)
print v(xbgr.mr_n58182160)
print v(xbgr.mr_n58402656)
print v(xbgr.mr_n58516608)
print v(xbgr.mr_n58656064)
print v(xbgr.mr_n58736656)
print v(xbgr.mr_n58812784)
print v(xbgr.mr_n58940544)
print v(xbgr.mr_n59065488)
print v(xbgr.mr_n59170256)
print v(xbgr.mr_n59291936)
print v(xbgr.mr_n58514896)
print v(xbgr.mr_n58611120)
print v(xbgr.mr_n58740704)
print v(xbgr.mr_n58818176)
print v(xbgr.mr_n58945376)
print v(xbgr.mr_n59070192)
print v(xbgr.mr_n59164464)
print v(xbgr.mr_n59296160)
print v(xbgr.mr_n59356080)
print v(xbgr.mr_n59786672)
print v(xbgr.mr_n57161104)
print v(xbgr.mr_n57434160)
print v(xbgr.mr_n57610496)
print v(xbgr.mr_n57668224)
print v(xbgr.mr_n59550016)
print v(xbgr.mr_n59844816)
print v(xbgr.mr_n58432896)
print v(xbgr.mr_n58541136)
print v(xbgr.mr_n58671120)
print v(xbgr.mr_n58751104)
print v(xbgr.mr_n58835056)
print v(xbgr.mr_n58958352)
print v(xbgr.mr_n59083936)
print v(xbgr.mr_n59216560)
print v(xbgr.mr_n57174560)
print v(xbgr.mr_n57434752)
print v(xbgr.mr_n57611696)
print v(xbgr.mr_n57667632)
print v(xbgr.mr_n59543856)
print v(xbgr.mr_n59865952)
print v(xbgr.mr_n58515552)
print v(xbgr.mr_n58661600)
print v(xbgr.mr_n58738720)
print v(xbgr.mr_n58817488)
print v(xbgr.mr_n58946528)
print v(xbgr.mr_n59067504)
print v(xbgr.mr_n59139328)
print v(xbgr.mr_n59262816)
print v(xbgr.mr_n57887472)
print v(xbgr.mr_n57983280)
print v(xbgr.mr_n58208656)
print v(xbgr.mr_n58398368)
print v(xbgr.mr_n57174096)
print v(xbgr.mr_n57435344)
print v(xbgr.mr_n57612496)
print v(xbgr.mr_n57667040)
print v(xbgr.mr_n57886672)
print v(xbgr.mr_n57983968)
print v(xbgr.mr_n58211680)
print v(xbgr.mr_n58402192)
print v(xbgr.mr_n59547728)
print v(xbgr.mr_n59890224)
print v(xbgr.mr_n59355152)
print v(xbgr.mr_n59785744)
print v(xbgr.mr_n57173632)
print v(xbgr.mr_n57435936)
print v(xbgr.mr_n57598560)
print v(xbgr.mr_n57666384)
print v(xbgr.mr_n57837344)
print v(xbgr.mr_n57926672)
print v(xbgr.mr_n57716064)
print v(xbgr.mr_n58263376)
print v(xbgr.mr_n59546144)
print v(xbgr.mr_n59893712)
print v(xbgr.mr_n57173168)
print v(xbgr.mr_n57436528)
print v(xbgr.mr_n57613696)
print v(xbgr.mr_n57658752)
print v(xbgr.mr_n57880192)
print v(xbgr.mr_n57982928)
print v(xbgr.mr_n58177632)
print v(xbgr.mr_n58401504)
print v(xbgr.mr_n58513168)
print v(xbgr.mr_n58616048)
print v(xbgr.mr_n58740400)
print v(xbgr.mr_n58815488)
print v(xbgr.mr_n58944880)
print v(xbgr.mr_n59069504)
print v(xbgr.mr_n59164112)
print v(xbgr.mr_n59291520)
print v(xbgr.mr_n59545328)
print v(xbgr.mr_n59849248)
print v(xbgr.mr_n58515376)
print v(xbgr.mr_n58658256)
print v(xbgr.mr_n58741680)
print v(xbgr.mr_n58820880)
print v(xbgr.mr_n58946352)
print v(xbgr.mr_n59071360)
print v(xbgr.mr_n59162592)
print v(xbgr.mr_n59276960)
print v(xbgr.mr_n57172704)
print v(xbgr.mr_n57373696)
print v(xbgr.mr_n57614496)
print v(xbgr.mr_n57650464)
print v(xbgr.mr_n59532224)
print v(xbgr.mr_n59890448)
print v(xbgr.mr_n58432432)
print v(xbgr.mr_n58540672)
print v(xbgr.mr_n58670848)
print v(xbgr.mr_n58750832)
print v(xbgr.mr_n58834784)
print v(xbgr.mr_n58958080)
print v(xbgr.mr_n59083664)
print v(xbgr.mr_n59216288)
print v(xbgr.mr_n57020288)
print v(xbgr.mr_n57437632)
print v(xbgr.mr_n57618096)
print v(xbgr.mr_n57652240)
print v(xbgr.mr_n59354688)
print v(xbgr.mr_n59785280)
print v(xbgr.mr_n59540848)
print v(xbgr.mr_n59895472)
print v(xbgr.mr_n57171776)
print v(xbgr.mr_n57438304)
print v(xbgr.mr_n57610896)
print v(xbgr.mr_n57664080)
print v(xbgr.mr_n58509888)
print v(xbgr.mr_n58651696)
print v(xbgr.mr_n58741328)
print v(xbgr.mr_n58817056)
print v(xbgr.mr_n58947312)
print v(xbgr.mr_n59070880)
print v(xbgr.mr_n59135776)
print v(xbgr.mr_n59262160)
print v(xbgr.mr_n57884848)
print v(xbgr.mr_n57984848)
print v(xbgr.mr_n58209632)
print v(xbgr.mr_n58399936)
print v(xbgr.mr_n57888032)
print v(xbgr.mr_n57985536)
print v(xbgr.mr_n58210352)
print v(xbgr.mr_n58403760)
print v(xbgr.mr_n59542752)
print v(xbgr.mr_n59769968)
print v(xbgr.mr_n59973712)
print v(xbgr.mr_n57171312)
print v(xbgr.mr_n57438896)
print v(xbgr.mr_n57616896)
print v(xbgr.mr_n57663488)
print v(xbgr.mr_n57837072)
print v(xbgr.mr_n57925616)
print v(xbgr.mr_n58004000)
print v(xbgr.mr_n58262192)
print v(xbgr.mr_n59541952)
print v(xbgr.mr_n59696480)
print v(xbgr.mr_n59973600)
print v(xbgr.mr_n57170848)
print v(xbgr.mr_n57439488)
print v(xbgr.mr_n57616096)
print v(xbgr.mr_n57662896)
print v(xbgr.mr_n59354224)
print v(xbgr.mr_n59570096)
print v(xbgr.mr_n59784816)
print v(xbgr.mr_n57883840)
print v(xbgr.mr_n57984496)
print v(xbgr.mr_n58181936)
print v(xbgr.mr_n58405792)
print v(xbgr.mr_n58510064)
print v(xbgr.mr_n58613792)
print v(xbgr.mr_n58743712)
print v(xbgr.mr_n58821760)
print v(xbgr.mr_n58948192)
print v(xbgr.mr_n59071792)
print v(xbgr.mr_n59162032)
print v(xbgr.mr_n59288528)
print v(xbgr.mr_n59540672)
print v(xbgr.mr_n59697664)
print v(xbgr.mr_n59872992)
print v(xbgr.mr_n58513280)
print v(xbgr.mr_n58615232)
print v(xbgr.mr_n58742048)
print v(xbgr.mr_n58816640)
print v(xbgr.mr_n58943712)
print v(xbgr.mr_n59074896)
print v(xbgr.mr_n59165280)
print v(xbgr.mr_n59292752)
print v(xbgr.mr_n57164352)
print v(xbgr.mr_n57440080)
print v(xbgr.mr_n57618496)
print v(xbgr.mr_n57662304)
print v(xbgr.mr_n58431968)
print v(xbgr.mr_n58539744)
print v(xbgr.mr_n58670304)
print v(xbgr.mr_n58750560)
print v(xbgr.mr_n58834240)
print v(xbgr.mr_n58957536)
print v(xbgr.mr_n59083120)
print v(xbgr.mr_n59215744)
print v(xbgr.mr_n57167600)
print v(xbgr.mr_n57440672)
print v(xbgr.mr_n57619696)
print v(xbgr.mr_n57661712)
print v(xbgr.mr_n59536800)
print v(xbgr.mr_n59765072)
print v(xbgr.mr_n59889440)
print v(xbgr.mr_n57169456)
print v(xbgr.mr_n57441264)
print v(xbgr.mr_n57620096)
print v(xbgr.mr_n57652768)
print v(xbgr.mr_n59536224)
print v(xbgr.mr_n59697072)
print v(xbgr.mr_n59974032)
print v(xbgr.mr_n58497424)
print v(xbgr.mr_n58616880)
print v(xbgr.mr_n58742464)
print v(xbgr.mr_n58820192)
print v(xbgr.mr_n58946880)
print v(xbgr.mr_n59074208)
print v(xbgr.mr_n59139920)
print v(xbgr.mr_n59257488)
print v(xbgr.mr_n57882304)
print v(xbgr.mr_n57986416)
print v(xbgr.mr_n58206048)
print v(xbgr.mr_n58404144)
print v(xbgr.mr_n57886496)
print v(xbgr.mr_n57987104)
print v(xbgr.mr_n58209136)
print v(xbgr.mr_n58405328)
print v(xbgr.mr_n59353296)
print v(xbgr.mr_n59569632)
print v(xbgr.mr_n59783888)
print v(xbgr.mr_n57168992)
print v(xbgr.mr_n57441856)
print v(xbgr.mr_n57621296)
print v(xbgr.mr_n57648096)
print v(xbgr.mr_n59535712)
print v(xbgr.mr_n59694704)
print v(xbgr.mr_n59976512)
print v(xbgr.mr_n57836800)
print v(xbgr.mr_n57899008)
print v(xbgr.mr_n58041168)
print v(xbgr.mr_n58261008)
print v(xbgr.mr_n57168528)
print v(xbgr.mr_n57442448)
print v(xbgr.mr_n57622160)
print v(xbgr.mr_n57659936)
print v(xbgr.mr_n59536448)
print v(xbgr.mr_n59768336)
print v(xbgr.mr_n59888496)
print v(xbgr.mr_n57879216)
print v(xbgr.mr_n57986064)
print v(xbgr.mr_n58139584)
print v(xbgr.mr_n58381600)
print v(xbgr.mr_n57168064)
print v(xbgr.mr_n57443040)
print v(xbgr.mr_n57622752)
print v(xbgr.mr_n57659280)
print v(xbgr.mr_n58508192)
print v(xbgr.mr_n58663072)
print v(xbgr.mr_n58744144)
print v(xbgr.mr_n58824048)
print v(xbgr.mr_n58950480)
print v(xbgr.mr_n59069072)
print v(xbgr.mr_n58779872)
print v(xbgr.mr_n59289344)
print v(xbgr.mr_n58511104)
print v(xbgr.mr_n58666752)
print v(xbgr.mr_n58745424)
print v(xbgr.mr_n58825584)
print v(xbgr.mr_n58952016)
print v(xbgr.mr_n59072208)
print v(xbgr.mr_n59163280)
print v(xbgr.mr_n59288112)
print v(xbgr.mr_n59535248)
print v(xbgr.mr_n59687600)
print v(xbgr.mr_n59980752)
print v(xbgr.mr_n59352832)
print v(xbgr.mr_n59569168)
print v(xbgr.mr_n59783424)
print v(xbgr.mr_n57114096)
print v(xbgr.mr_n57443632)
print v(xbgr.mr_n57620496)
print v(xbgr.mr_n57653424)
print v(xbgr.mr_n58431504)
print v(xbgr.mr_n58539280)
print v(xbgr.mr_n58670032)
print v(xbgr.mr_n58750288)
print v(xbgr.mr_n58833968)
print v(xbgr.mr_n58957264)
print v(xbgr.mr_n59082848)
print v(xbgr.mr_n59215472)
print v(xbgr.mr_n59535600)
print v(xbgr.mr_n59692928)
print v(xbgr.mr_n59979200)
print v(xbgr.mr_n57167136)
print v(xbgr.mr_n57368224)
print v(xbgr.mr_n57624528)
print v(xbgr.mr_n57658160)
print v(xbgr.mr_n58498912)
print v(xbgr.mr_n58625520)
print v(xbgr.mr_n58745008)
print v(xbgr.mr_n58818864)
print v(xbgr.mr_n58949936)
print v(xbgr.mr_n59075584)
print v(xbgr.mr_n59137552)
print v(xbgr.mr_n59255136)
print v(xbgr.mr_n57883104)
print v(xbgr.mr_n57987984)
print v(xbgr.mr_n58207088)
print v(xbgr.mr_n58381488)
print v(xbgr.mr_n57885456)
print v(xbgr.mr_n57976656)
print v(xbgr.mr_n58207808)
print v(xbgr.mr_n58384336)
print v(xbgr.mr_n59533344)
print v(xbgr.mr_n59767792)
print v(xbgr.mr_n59974656)
print v(xbgr.mr_n57019488)
print v(xbgr.mr_n57444736)
print v(xbgr.mr_n57626896)
print v(xbgr.mr_n57657568)
print v(xbgr.mr_n59532112)
print v(xbgr.mr_n59686480)
print v(xbgr.mr_n59983312)
print v(xbgr.mr_n57836528)
print v(xbgr.mr_n57924736)
print v(xbgr.mr_n58033040)
print v(xbgr.mr_n58259824)
print v(xbgr.mr_n57166208)
print v(xbgr.mr_n57445408)
print v(xbgr.mr_n57621696)
print v(xbgr.mr_n57648624)
print v(xbgr.mr_n59352368)
print v(xbgr.mr_n59568544)
print v(xbgr.mr_n59782960)
print v(xbgr.mr_n59531152)
print v(xbgr.mr_n59693760)
print v(xbgr.mr_n59982496)
print v(xbgr.mr_n57165744)
print v(xbgr.mr_n57446000)
print v(xbgr.mr_n57620896)
print v(xbgr.mr_n57628080)
print v(xbgr.mr_n57883664)
print v(xbgr.mr_n57987632)
print v(xbgr.mr_n58182048)
print v(xbgr.mr_n58353856)
print v(xbgr.mr_n58508368)
print v(xbgr.mr_n58614256)
print v(xbgr.mr_n58747456)
print v(xbgr.mr_n58826464)
print v(xbgr.mr_n58948624)
print v(xbgr.mr_n59076560)
print v(xbgr.mr_n59158624)
print v(xbgr.mr_n59281824)
print v(xbgr.mr_n58506336)
print v(xbgr.mr_n58621232)
print v(xbgr.mr_n58745792)
print v(xbgr.mr_n58822192)
print v(xbgr.mr_n58954016)
print v(xbgr.mr_n59079600)
print v(xbgr.mr_n59161920)
print v(xbgr.mr_n59285120)
print v(xbgr.mr_n57165280)
print v(xbgr.mr_n57446592)
print v(xbgr.mr_n57615696)
print v(xbgr.mr_n57655792)
print v(xbgr.mr_n59529552)
print v(xbgr.mr_n59764528)
print v(xbgr.mr_n59977008)
print v(xbgr.mr_n58431040)
print v(xbgr.mr_n58538352)
print v(xbgr.mr_n58669488)
print v(xbgr.mr_n58750016)
print v(xbgr.mr_n58833424)
print v(xbgr.mr_n58956720)
print v(xbgr.mr_n59082304)
print v(xbgr.mr_n59214928)
print v(xbgr.mr_n59527424)
print v(xbgr.mr_n59649888)
print v(xbgr.mr_n59980928)
print v(xbgr.mr_n57164816)
print v(xbgr.mr_n57447184)
print v(xbgr.mr_n57619296)
print v(xbgr.mr_n57655200)
print v(xbgr.mr_n59351440)
print v(xbgr.mr_n59568080)
print v(xbgr.mr_n59782032)
print v(xbgr.mr_n58503024)
print v(xbgr.mr_n58626880)
print v(xbgr.mr_n58742896)
print v(xbgr.mr_n58826896)
print v(xbgr.mr_n58952544)
print v(xbgr.mr_n59078064)
print v(xbgr.mr_n59138736)
print v(xbgr.mr_n59261040)
print v(xbgr.mr_n57882992)
print v(xbgr.mr_n57989552)
print v(xbgr.mr_n58205088)
print v(xbgr.mr_n58371760)
print v(xbgr.mr_n57877568)
print v(xbgr.mr_n57988672)
print v(xbgr.mr_n58206592)
print v(xbgr.mr_n58379568)
print v(xbgr.mr_n59520160)
print v(xbgr.mr_n59693584)
print v(xbgr.mr_n59974928)
print v(xbgr.mr_n57162032)
print v(xbgr.mr_n57447776)
print v(xbgr.mr_n57618896)
print v(xbgr.mr_n57654608)
print v(xbgr.mr_n57836256)
print v(xbgr.mr_n57923504)
print v(xbgr.mr_n57080448)
print v(xbgr.mr_n58258640)
print v(xbgr.mr_n57163888)
print v(xbgr.mr_n57448368)
print v(xbgr.mr_n57617696)
print v(xbgr.mr_n57653952)
print v(xbgr.mr_n59529728)
print v(xbgr.mr_n59766160)
print v(xbgr.mr_n59983488)
print v(xbgr.mr_n57163424)
print v(xbgr.mr_n57448960)
print v(xbgr.mr_n57617296)
print v(xbgr.mr_n57649280)
print v(xbgr.mr_n59522336)
print v(xbgr.mr_n59691152)
print v(xbgr.mr_n59988432)
print v(xbgr.mr_n57880752)
print v(xbgr.mr_n57989136)
print v(xbgr.mr_n58145888)
print v(xbgr.mr_n58373920)
print v(xbgr.mr_n58506688)
print v(xbgr.mr_n58655312)
print v(xbgr.mr_n58744448)
print v(xbgr.mr_n58827584)
print v(xbgr.mr_n58949312)
print v(xbgr.mr_n59072896)
print v(xbgr.mr_n59158160)
print v(xbgr.mr_n59284704)
print v(xbgr.mr_n58506512)
print v(xbgr.mr_n58627776)
print v(xbgr.mr_n58739968)
print v(xbgr.mr_n58824896)
print v(xbgr.mr_n58947776)
print v(xbgr.mr_n59076064)
print v(xbgr.mr_n59159712)
print v(xbgr.mr_n59273648)
print v(xbgr.mr_n59350976)
print v(xbgr.mr_n59494656)
print v(xbgr.mr_n59781568)
print v(xbgr.mr_n57162960)
print v(xbgr.mr_n57449552)
print v(xbgr.mr_n57616496)
print v(xbgr.mr_n57643456)
print v(xbgr.mr_n59527312)
print v(xbgr.mr_n59691808)
print v(xbgr.mr_n59987616)
print v(xbgr.mr_n58430576)
print v(xbgr.mr_n58537888)
print v(xbgr.mr_n58669216)
print v(xbgr.mr_n58749744)
print v(xbgr.mr_n58833152)
print v(xbgr.mr_n58956448)
print v(xbgr.mr_n59082032)
print v(xbgr.mr_n59214656)
print v(xbgr.mr_n57162496)
print v(xbgr.mr_n57450144)
print v(xbgr.mr_n57615296)
print v(xbgr.mr_n57623872)
print v(xbgr.mr_n59518560)
print v(xbgr.mr_n59757424)
print v(xbgr.mr_n59986048)
print v(xbgr.mr_n58505536)
print v(xbgr.mr_n58650352)
print v(xbgr.mr_n58743296)
print v(xbgr.mr_n58823504)
print v(xbgr.mr_n58944768)
print v(xbgr.mr_n59073360)
print v(xbgr.mr_n59138144)
print v(xbgr.mr_n59258608)
print v(xbgr.mr_n57019712)
print v(xbgr.mr_n57450736)
print v(xbgr.mr_n57614896)
print v(xbgr.mr_n57651648)
print v(xbgr.mr_n57882128)
print v(xbgr.mr_n57991120)
print v(xbgr.mr_n58185104)
print v(xbgr.mr_n58365776)
print v(xbgr.mr_n57879392)
print v(xbgr.mr_n57991808)
print v(xbgr.mr_n58204544)
print v(xbgr.mr_n58374224)
print v(xbgr.mr_n59523344)
print v(xbgr.mr_n59689376)
print v(xbgr.mr_n59977120)
print v(xbgr.mr_n57161568)
print v(xbgr.mr_n57451328)
print v(xbgr.mr_n57614096)
print v(xbgr.mr_n57650992)
print v(xbgr.mr_n59350512)
print v(xbgr.mr_n59494192)
print v(xbgr.mr_n59781104)
print v(xbgr.mr_n57836064)
print v(xbgr.mr_n57904608)
print v(xbgr.mr_n57762288)
print v(xbgr.mr_n58257456)
print v(xbgr.mr_n59524960)
print v(xbgr.mr_n59690032)
print v(xbgr.mr_n59988608)
print v(xbgr.mr_n57019600)
print v(xbgr.mr_n57451920)
print v(xbgr.mr_n57611296)
print v(xbgr.mr_n57627488)
print v(xbgr.mr_n57880928)
print v(xbgr.mr_n57981360)
print v(xbgr.mr_n58181824)
print v(xbgr.mr_n58366192)
print v(xbgr.mr_n58504672)
print v(xbgr.mr_n58628240)
print v(xbgr.mr_n58720912)
print v(xbgr.mr_n58828752)
print v(xbgr.mr_n58944416)
print v(xbgr.mr_n59068720)
print v(xbgr.mr_n59157120)
print v(xbgr.mr_n59281712)
print v(xbgr.mr_n58503888)
print v(xbgr.mr_n58632672)
print v(xbgr.mr_n58736224)
print v(xbgr.mr_n58826112)
print v(xbgr.mr_n58944080)
print v(xbgr.mr_n59066112)
print v(xbgr.mr_n59148208)
print v(xbgr.mr_n59285936)
print v(xbgr.mr_n59523600)
print v(xbgr.mr_n59762576)
print v(xbgr.mr_n59985872)
print v(xbgr.mr_n57160640)
print v(xbgr.mr_n57452512)
print v(xbgr.mr_n57612096)
print v(xbgr.mr_n57649808)
print v(xbgr.mr_n59513792)
print v(xbgr.mr_n59653616)
print v(xbgr.mr_n59993552)
print v(xbgr.mr_n58430112)
print v(xbgr.mr_n58536960)
print v(xbgr.mr_n58668672)
print v(xbgr.mr_n58749472)
print v(xbgr.mr_n58832608)
print v(xbgr.mr_n58955904)
print v(xbgr.mr_n59081488)
print v(xbgr.mr_n59214192)
print v(xbgr.mr_n57158528)
print v(xbgr.mr_n57453104)
print v(xbgr.mr_n57612896)
print v(xbgr.mr_n57645136)
print v(xbgr.mr_n59349584)
print v(xbgr.mr_n59493728)
print v(xbgr.mr_n59780176)
print v(xbgr.mr_n59522224)
print v(xbgr.mr_n59688256)
print v(xbgr.mr_n59985056)
print v(xbgr.mr_n57027312)
print v(xbgr.mr_n57388816)
print v(xbgr.mr_n57613296)
print v(xbgr.mr_n57626304)
print v(xbgr.mr_n58504496)
print v(xbgr.mr_n58627504)
print v(xbgr.mr_n58739616)
print v(xbgr.mr_n58824480)
print v(xbgr.mr_n58939536)
print v(xbgr.mr_n59064800)
print v(xbgr.mr_n59117424)
print v(xbgr.mr_n59259264)
print v(xbgr.mr_n57880080)
print v(xbgr.mr_n57969840)
print v(xbgr.mr_n58201024)
print v(xbgr.mr_n58367232)
print v(xbgr.mr_n57872080)
print v(xbgr.mr_n57970688)
print v(xbgr.mr_n58204048)
print v(xbgr.mr_n58369568)
print v(xbgr.mr_n57026848)
print v(xbgr.mr_n57094144)
print v(xbgr.mr_n57609696)
print v(xbgr.mr_n57625712)
print v(xbgr.mr_n59518672)
print v(xbgr.mr_n59763440)
print v(xbgr.mr_n59991168)
print v(xbgr.mr_n57835952)
print v(xbgr.mr_n57901744)
print v(xbgr.mr_n58008736)
print v(xbgr.mr_n58256592)
print v(xbgr.mr_n57026384)
print v(xbgr.mr_n57387696)
print v(xbgr.mr_n57609296)
print v(xbgr.mr_n57647504)
print v(xbgr.mr_n59511648)
print v(xbgr.mr_n59685824)
print v(xbgr.mr_n59992736)
print v(xbgr.mr_n59349120)
print v(xbgr.mr_n59493264)
print v(xbgr.mr_n59779712)
print v(xbgr.mr_n57878176)
print v(xbgr.mr_n57970224)
print v(xbgr.mr_n58152032)
print v(xbgr.mr_n58364512)
print v(xbgr.mr_n58501344)
print v(xbgr.mr_n58599776)
print v(xbgr.mr_n58735808)
print v(xbgr.mr_n58822880)
print v(xbgr.mr_n58942208)
print v(xbgr.mr_n59058096)
print v(xbgr.mr_n59155456)
print v(xbgr.mr_n59282528)
print v(xbgr.mr_n57019376)
print v(xbgr.mr_n57387104)
print v(xbgr.mr_n57608096)
print v(xbgr.mr_n57646912)
print v(xbgr.mr_n58501168)
print v(xbgr.mr_n58645056)
print v(xbgr.mr_n58721024)
print v(xbgr.mr_n58821408)
print v(xbgr.mr_n58938416)
print v(xbgr.mr_n59066656)
print v(xbgr.mr_n59158512)
print v(xbgr.mr_n59281296)
print v(xbgr.mr_n59508704)
print v(xbgr.mr_n59682928)
print v(xbgr.mr_n59995296)
print v(xbgr.mr_n57025456)
print v(xbgr.mr_n57386512)
print v(xbgr.mr_n57607056)
print v(xbgr.mr_n57646320)
print v(xbgr.mr_n58429648)
print v(xbgr.mr_n58536496)
print v(xbgr.mr_n58668400)
print v(xbgr.mr_n58749280)
print v(xbgr.mr_n58832336)
print v(xbgr.mr_n58955632)
print v(xbgr.mr_n59081216)
print v(xbgr.mr_n59214080)
print v(xbgr.mr_n59518336)
print v(xbgr.mr_n59762928)
print v(xbgr.mr_n59990992)
print v(xbgr.mr_n57024992)
print v(xbgr.mr_n57320720)
print v(xbgr.mr_n57604960)
print v(xbgr.mr_n57645664)
print v(xbgr.mr_n59516128)
print v(xbgr.mr_n59684048)
print v(xbgr.mr_n59993728)
print v(xbgr.mr_n58499264)
print v(xbgr.mr_n58613264)
print v(xbgr.mr_n58732448)
print v(xbgr.d4)
print v(xbgr.mr_n58941168)
print v(xbgr.mr_n59064016)
print v(xbgr.mr_n59080288)
print v(xbgr.mr_n59255648)
print v(xbgr.mr_n57861344)
print v(xbgr.mr_n57965888)
print v(xbgr.mr_n58202000)
print v(xbgr.mr_n58356304)
print v(xbgr.mr_n57876112)
print v(xbgr.mr_n57961600)
print v(xbgr.mr_n58202720)
print v(xbgr.mr_n58359456)
print v(xbgr.mr_n59348656)
print v(xbgr.mr_n59492800)
print v(xbgr.mr_n59779248)
print v(xbgr.mr_n57024528)
print v(xbgr.mr_n57373520)
print v(xbgr.mr_n57604496)
print v(xbgr.mr_n57625056)
print v(xbgr.mr_n59510800)
print v(xbgr.mr_n59684704)
print v(xbgr.mr_n59997856)
print v(xbgr.mr_n57821392)
print v(xbgr.mr_n57901056)
print v(xbgr.mr_n57999008)
print v(xbgr.mr_n58255792)
print v(xbgr.mr_n57024064)
print v(xbgr.mr_n57384144)
print v(xbgr.mr_n57606720)
print v(xbgr.mr_n57623344)
print v(xbgr.mr_n59517392)
print v(xbgr.mr_n59759376)
print v(xbgr.mr_n59990176)
print v(xbgr.mr_n57878000)
print v(xbgr.mr_n57967696)
print v(xbgr.mr_n58167072)
print v(xbgr.mr_n58361152)
print v(xbgr.mr_n57023600)
print v(xbgr.mr_n57321632)
print v(xbgr.mr_n57494160)
print v(xbgr.mr_n57796736)
print v(xbgr.mr_n58493968)
print v(xbgr.mr_n58610128)
print v(xbgr.mr_n58719744)
print v(xbgr.mr_n58814160)
print v(xbgr.mr_n58939104)
print v(xbgr.mr_n59055728)
print v(xbgr.mr_n59141696)
print v(xbgr.mr_n59276576)
print v(xbgr.mr_n58499968)
print v(xbgr.mr_n58610016)
print v(xbgr.mr_n58733728)
print v(xbgr.mr_n58819344)
print v(xbgr.mr_n58931872)
print v(xbgr.mr_n59056768)
print v(xbgr.mr_n59159328)
print v(xbgr.mr_n59276768)
print v(xbgr.mr_n59515392)
print v(xbgr.mr_n59682400)
print v(xbgr.mr_n59996288)
print v(xbgr.mr_n57023136)
print v(xbgr.mr_n57382368)
print v(xbgr.mr_n57437120)
print v(xbgr.mr_n57833216)
print v(xbgr.mr_n59347968)
print v(xbgr.mr_n59501072)
print v(xbgr.mr_n59778320)
print v(xbgr.mr_n58429184)
print v(xbgr.mr_n58535568)
print v(xbgr.mr_n58667936)
print v(xbgr.mr_n58749168)
print v(xbgr.mr_n58831792)
print v(xbgr.mr_n58955168)
print v(xbgr.mr_n59080752)
print v(xbgr.mr_n59213856)
print v(xbgr.mr_n59514464)
print v(xbgr.mr_n59648192)
print v(xbgr.mr_n59998848)
print v(xbgr.mr_n57022672)
print v(xbgr.mr_n57381776)
print v(xbgr.mr_n57492976)
print v(xbgr.mr_n57834816)
print v(xbgr.mr_n58494624)
print v(xbgr.mr_n58617920)
print v(xbgr.mr_n58719408)
print v(xbgr.mr_n58812352)
print v(xbgr.mr_n58938528)
print v(xbgr.mr_n59059248)
print v(xbgr.mr_n59135264)
print v(xbgr.mr_n59212448)
print v(xbgr.mr_n57876896)
print v(xbgr.mr_n58183552)
print v(xbgr.mr_n58358208)
print v(xbgr.mr_n57863760)
print v(xbgr.mr_n58201504)
print v(xbgr.mr_n58356032)
print v(xbgr.mr_n59512864)
print v(xbgr.mr_n59761552)
print v(xbgr.mr_n59996112)
print v(xbgr.mr_n57020560)
print v(xbgr.mr_n57380592)
print v(xbgr.mr_n57457136)
print v(xbgr.mr_n57834416)
print v(xbgr.mr_n57002720)
print v(xbgr.mr_n57334208)
print v(xbgr.mr_n59490880)
print v(xbgr.mr_n59681008)
print v(xbgr.mr_n60000416)
print v(xbgr.mr_n57826816)
print v(xbgr.mr_n57942208)
print v(xbgr.mr_n57998688)
print v(xbgr.mr_n58228512)
print v(xbgr.mr_n57218784)
print v(xbgr.n_23)
print v(xbgr.mr_n57491792)
print v(xbgr.mr_n57833616)
print v(xbgr.mr_n57121344)
print v(xbgr.mr_n59347664)
print v(xbgr.mr_n59502400)
print v(xbgr.mr_n59777936)
print v(xbgr.mr_n59511760)
print v(xbgr.mr_n59681472)
print v(xbgr.mr_n60001408)
print v(xbgr.n_12)
print v(xbgr.n_25)
print v(xbgr.mr_n57492384)
print v(xbgr.mr_n57831216)
print v(xbgr.mr_n57876544)
print v(xbgr.mr_n58175712)
print v(xbgr.mr_n58355808)
print v(xbgr.mr_n58497088)
print v(xbgr.mr_n58657008)
print v(xbgr.mr_n58732640)
print v(xbgr.mr_n58811472)
print v(xbgr.mr_n58925680)
print v(xbgr.mr_n59054256)
print v(xbgr.mr_n59145840)
print v(xbgr.mr_n59277712)
print v(xbgr.mr_n58493792)
print v(xbgr.mr_n58663536)
print v(xbgr.mr_n58734816)
print v(xbgr.mr_n58814640)
print v(xbgr.mr_n58938032)
print v(xbgr.mr_n59057248)
print v(xbgr.mr_n59157664)
print v(xbgr.mr_n59271696)
print v(xbgr.mr_n57202736)
print v(xbgr.mr_n57319728)
print v(xbgr.mr_n57490608)
print v(xbgr.mr_n57828816)
print v(xbgr.mr_n59509376)
print v(xbgr.mr_n59753408)
print v(xbgr.mr_n59998672)
print v(xbgr.mr_n58428720)
print v(xbgr.mr_n58535184)
print v(xbgr.mr_n58625856)
print v(xbgr.mr_n58746208)
print v(xbgr.mr_n58831600)
print v(xbgr.mr_n58955056)
print v(xbgr.mr_n59080640)
print v(xbgr.mr_n59182656)
print v(xbgr.n_17)
print v(xbgr.n_22)
print v(xbgr.mr_n57402496)
print v(xbgr.mr_n57826416)
print v(xbgr.mr_n59509200)
print v(xbgr.mr_n59679616)
print v(xbgr.mr_n60002976)
print v(xbgr.mr_n59347360)
print v(xbgr.mr_n59495824)
print v(xbgr.mr_n59777632)
print v(xbgr.mr_n58499088)
print v(xbgr.mr_n58617392)
print v(xbgr.mr_n58717552)
print v(xbgr.mr_n58811936)
print v(xbgr.mr_n58937808)
print v(xbgr.mr_n59055376)
print v(xbgr.mr_n59135440)
print v(xbgr.mr_n59207648)
print v(xbgr.mr_n57871136)
print v(xbgr.mr_n58199456)
print v(xbgr.mr_n58346352)
print v(xbgr.n_18)
print v(xbgr.mr_n57318064)
print v(xbgr.mr_n57489424)
print v(xbgr.mr_n57715280)
print v(xbgr.mr_n57876720)
print v(xbgr.mr_n58200176)
print v(xbgr.mr_n58349616)
print v(xbgr.mr_n59505536)
print v(xbgr.mr_n59680080)
print v(xbgr.mr_n60003968)
print v(xbgr.mr_n57041264)
print v(xbgr.mr_n57012944)
print v(xbgr.mr_n57215840)
print v(xbgr.mr_n57317344)
print v(xbgr.mr_n57396576)
print v(xbgr.mr_n57822288)
print v(xbgr.mr_n57835536)
print v(xbgr.mr_n57928608)
print v(xbgr.mr_n58031312)
print v(xbgr.mr_n58230736)
print v(xbgr.mr_n59508016)
print v(xbgr.mr_n59759488)
print v(xbgr.mr_n60001232)
print v(xbgr.mr_n57043632)
print v(xbgr.mr_n57208304)
print v(xbgr.mr_n57316624)
print v(xbgr.mr_n57488832)
print v(xbgr.mr_n57803248)
print v(xbgr.mr_n57868752)
print v(xbgr.mr_n58164304)
print v(xbgr.mr_n58350144)
print v(xbgr.mr_n59500400)
print v(xbgr.mr_n59651696)
print v(xbgr.mr_n60008912)
print v(xbgr.mr_n58492480)
print v(xbgr.mr_n58579120)
print v(xbgr.mr_n58721680)
print v(xbgr.mr_n58808768)
print v(xbgr.mr_n58934832)
print v(xbgr.mr_n59046688)
print v(xbgr.mr_n59147616)
print v(xbgr.mr_n59273472)
print v(xbgr.mr_n58494448)
print v(xbgr.mr_n58582384)
print v(xbgr.mr_n58718896)
print v(xbgr.mr_n58805856)
print v(xbgr.mr_n58936000)
print v(xbgr.mr_n59054528)
print v(xbgr.mr_n59147024)
print v(xbgr.mr_n59276032)
print v(xbgr.mr_n59329952)
print v(xbgr.mr_n59561008)
print v(xbgr.mr_n59773696)
print v(xbgr.mr_n57180928)
print v(xbgr.mr_n57315904)
print v(xbgr.mr_n57486928)
print v(xbgr.mr_n57811024)
print v(xbgr.mr_n59506640)
print v(xbgr.mr_n59653504)
print v(xbgr.mr_n60008096)
print v(xbgr.mr_n58428256)
print v(xbgr.mr_n58521888)
print v(xbgr.mr_n58667152)
print v(xbgr.mr_n58747888)
print v(xbgr.mr_n58830752)
print v(xbgr.mr_n58953328)
print v(xbgr.mr_n59078912)
print v(xbgr.mr_n59206224)
print v(xbgr.mr_n59504864)
print v(xbgr.mr_n59761664)
print v(xbgr.mr_n60006528)
print v(xbgr.mr_n57042480)
print v(xbgr.mr_n58493136)
print v(xbgr.mr_n58521232)
print v(xbgr.mr_n58727728)
print v(xbgr.mr_n58807232)
print v(xbgr.mr_n58922448)
print v(xbgr.mr_n59048496)
print v(xbgr.mr_n59077600)
print v(xbgr.mr_n59212624)
print v(xbgr.mr_n57871024)
print v(xbgr.mr_n58184368)
print v(xbgr.mr_n58349312)
print v(xbgr.mr_n57871328)
print v(xbgr.mr_n58197728)
print v(xbgr.mr_n58349424)
print v(xbgr.mr_n59498432)
print v(xbgr.mr_n59644576)
print v(xbgr.mr_n60003792)
print v(xbgr.mr_n57331408)
print v(xbgr.mr_n59335552)
print v(xbgr.mr_n59560832)
print v(xbgr.mr_n59776960)
print v(xbgr.mr_n57819776)
print v(xbgr.mr_n57329648)
print v(xbgr.mr_n57999856)
print v(xbgr.mr_n58210176)
print v(xbgr.mr_n57945408)
print v(xbgr.mr_n59330752)
print v(xbgr.mr_n59648080)
print v(xbgr.mr_n60006352)
print v(xbgr.mr_n57868000)
print v(xbgr.mr_n58168400)
print v(xbgr.mr_n58333872)
print v(dvbe)
print v(iptat)
print v(pbias)
print v(pcasc)
print v(r4)
print v(vbe)
print v(vdd)
print v(vref)
print v(vdd)-v(vdd)
echo METALLIC_POINT_VOLTAGES_END
echo METALLIC_ALL_NODE_VOLTAGES_BEGIN
print v(xbgr.b1b)
print v(xbgr.c2)
print v(xbgr.d1)
print v(xbgr.d2)
print v(xbgr.d3)
print v(xbgr.d4)
print v(xbgr.d5)
print v(xbgr.det)
print v(dvbe)
print v(iptat)
print v(xbgr.kick)
print v(xbgr.mr_n43947904)
print v(xbgr.mr_n44205824)
print v(xbgr.mr_n46339296)
print v(xbgr.mr_n46384944)
print v(xbgr.mr_n46437648)
print v(xbgr.mr_n46437760)
print v(xbgr.mr_n46447440)
print v(xbgr.mr_n47308384)
print v(xbgr.mr_n47308496)
print v(xbgr.mr_n47308816)
print v(xbgr.mr_n47308928)
print v(xbgr.mr_n47309344)
print v(xbgr.mr_n47309456)
print v(xbgr.mr_n47309776)
print v(xbgr.mr_n47309888)
print v(xbgr.mr_n47312752)
print v(xbgr.mr_n47312992)
print v(xbgr.mr_n47313104)
print v(xbgr.mr_n47313456)
print v(xbgr.mr_n47313776)
print v(xbgr.mr_n47313888)
print v(xbgr.mr_n47314320)
print v(xbgr.mr_n47314640)
print v(xbgr.mr_n47314752)
print v(xbgr.mr_n47315184)
print v(xbgr.mr_n47315504)
print v(xbgr.mr_n47315616)
print v(xbgr.mr_n47316048)
print v(xbgr.mr_n47316368)
print v(xbgr.mr_n47316480)
print v(xbgr.mr_n47316912)
print v(xbgr.mr_n47317232)
print v(xbgr.mr_n47317344)
print v(xbgr.mr_n47317776)
print v(xbgr.mr_n47318096)
print v(xbgr.mr_n47318208)
print v(xbgr.mr_n47318640)
print v(xbgr.mr_n47318960)
print v(xbgr.mr_n47319072)
print v(xbgr.mr_n47319504)
print v(xbgr.mr_n47319824)
print v(xbgr.mr_n47319936)
print v(xbgr.mr_n47320368)
print v(xbgr.mr_n47320688)
print v(xbgr.mr_n47320800)
print v(xbgr.mr_n47321232)
print v(xbgr.mr_n47321552)
print v(xbgr.mr_n47321664)
print v(xbgr.mr_n47322096)
print v(xbgr.mr_n47322416)
print v(xbgr.mr_n47322528)
print v(xbgr.mr_n47322960)
print v(xbgr.mr_n47323280)
print v(xbgr.mr_n47323392)
print v(xbgr.mr_n47323824)
print v(xbgr.mr_n47324144)
print v(xbgr.mr_n47324256)
print v(xbgr.mr_n47324688)
print v(xbgr.mr_n47325008)
print v(xbgr.mr_n47325120)
print v(xbgr.mr_n47325552)
print v(xbgr.mr_n47325872)
print v(xbgr.mr_n47325984)
print v(xbgr.mr_n47326416)
print v(xbgr.mr_n47326736)
print v(xbgr.mr_n47326848)
print v(xbgr.mr_n47327168)
print v(xbgr.mr_n47327280)
print v(xbgr.mr_n47327600)
print v(xbgr.mr_n47327712)
print v(xbgr.mr_n47328032)
print v(xbgr.mr_n47328144)
print v(xbgr.mr_n47328464)
print v(xbgr.mr_n47328576)
print v(xbgr.mr_n47328896)
print v(xbgr.mr_n47329008)
print v(xbgr.mr_n47329328)
print v(xbgr.mr_n47329440)
print v(xbgr.mr_n47329760)
print v(xbgr.mr_n47329872)
print v(xbgr.mr_n47330192)
print v(xbgr.mr_n47330304)
print v(xbgr.mr_n47330624)
print v(xbgr.mr_n47330736)
print v(xbgr.mr_n47331056)
print v(xbgr.mr_n47331168)
print v(xbgr.mr_n47331488)
print v(xbgr.mr_n47331600)
print v(xbgr.mr_n47331920)
print v(xbgr.mr_n47332032)
print v(xbgr.mr_n47332352)
print v(xbgr.mr_n47332464)
print v(xbgr.mr_n47332784)
print v(xbgr.mr_n47332896)
print v(xbgr.mr_n47333216)
print v(xbgr.mr_n47333328)
print v(xbgr.mr_n47333648)
print v(xbgr.mr_n47333760)
print v(xbgr.mr_n47334080)
print v(xbgr.mr_n47334192)
print v(xbgr.mr_n47334512)
print v(xbgr.mr_n47334624)
print v(xbgr.mr_n47334944)
print v(xbgr.mr_n47335056)
print v(xbgr.mr_n47335376)
print v(xbgr.mr_n47335488)
print v(xbgr.mr_n47335808)
print v(xbgr.mr_n47335920)
print v(xbgr.mr_n47336240)
print v(xbgr.mr_n47336352)
print v(xbgr.mr_n47336672)
print v(xbgr.mr_n47336784)
print v(xbgr.mr_n47337104)
print v(xbgr.mr_n47337216)
print v(xbgr.mr_n47337536)
print v(xbgr.mr_n47337648)
print v(xbgr.mr_n47337968)
print v(xbgr.mr_n47338080)
print v(xbgr.mr_n47338400)
print v(xbgr.mr_n47338512)
print v(xbgr.mr_n47338832)
print v(xbgr.mr_n47338944)
print v(xbgr.mr_n47339264)
print v(xbgr.mr_n47339376)
print v(xbgr.mr_n47339696)
print v(xbgr.mr_n47339808)
print v(xbgr.mr_n47340128)
print v(xbgr.mr_n47340240)
print v(xbgr.mr_n47340560)
print v(xbgr.mr_n47340672)
print v(xbgr.mr_n47340992)
print v(xbgr.mr_n47341104)
print v(xbgr.mr_n47341424)
print v(xbgr.mr_n47341536)
print v(xbgr.mr_n47341856)
print v(xbgr.mr_n47341968)
print v(xbgr.mr_n47342288)
print v(xbgr.mr_n47342400)
print v(xbgr.mr_n47342528)
print v(xbgr.mr_n47342640)
print v(xbgr.mr_n47342960)
print v(xbgr.mr_n47343072)
print v(xbgr.mr_n47343392)
print v(xbgr.mr_n47343504)
print v(xbgr.mr_n47343824)
print v(xbgr.mr_n47343936)
print v(xbgr.mr_n47344256)
print v(xbgr.mr_n47344368)
print v(xbgr.mr_n47344688)
print v(xbgr.mr_n47344800)
print v(xbgr.mr_n47345120)
print v(xbgr.mr_n47345232)
print v(xbgr.mr_n47345552)
print v(xbgr.mr_n47345664)
print v(xbgr.mr_n47345984)
print v(xbgr.mr_n47346096)
print v(xbgr.mr_n47346416)
print v(xbgr.mr_n47346528)
print v(xbgr.mr_n47346848)
print v(xbgr.mr_n47346960)
print v(xbgr.mr_n47347280)
print v(xbgr.mr_n47347392)
print v(xbgr.mr_n47347712)
print v(xbgr.mr_n47347824)
print v(xbgr.mr_n47348144)
print v(xbgr.mr_n47348256)
print v(xbgr.mr_n47348576)
print v(xbgr.mr_n47348688)
print v(xbgr.mr_n47349008)
print v(xbgr.mr_n47349120)
print v(xbgr.mr_n47349440)
print v(xbgr.mr_n47349552)
print v(xbgr.mr_n47349872)
print v(xbgr.mr_n47349984)
print v(xbgr.mr_n47350304)
print v(xbgr.mr_n47350416)
print v(xbgr.mr_n47350736)
print v(xbgr.mr_n47350848)
print v(xbgr.mr_n47351168)
print v(xbgr.mr_n47351280)
print v(xbgr.mr_n47351600)
print v(xbgr.mr_n47351712)
print v(xbgr.mr_n47352032)
print v(xbgr.mr_n47352144)
print v(xbgr.mr_n47352464)
print v(xbgr.mr_n47352576)
print v(xbgr.mr_n47352896)
print v(xbgr.mr_n47353008)
print v(xbgr.mr_n47353328)
print v(xbgr.mr_n47353440)
print v(xbgr.mr_n47353760)
print v(xbgr.mr_n47353872)
print v(xbgr.mr_n47354192)
print v(xbgr.mr_n47354304)
print v(xbgr.mr_n47354624)
print v(xbgr.mr_n47354736)
print v(xbgr.mr_n47355056)
print v(xbgr.mr_n47355168)
print v(xbgr.mr_n47355488)
print v(xbgr.mr_n47355600)
print v(xbgr.mr_n47355920)
print v(xbgr.mr_n47356032)
print v(xbgr.mr_n47356352)
print v(xbgr.mr_n47356464)
print v(xbgr.mr_n47356784)
print v(xbgr.mr_n47356896)
print v(xbgr.mr_n47357216)
print v(xbgr.mr_n47357328)
print v(xbgr.mr_n47357648)
print v(xbgr.mr_n47357760)
print v(xbgr.mr_n47358080)
print v(xbgr.mr_n47358192)
print v(xbgr.mr_n47358512)
print v(xbgr.mr_n47358624)
print v(xbgr.mr_n47358944)
print v(xbgr.mr_n47359056)
print v(xbgr.mr_n47359376)
print v(xbgr.mr_n47359488)
print v(xbgr.mr_n47359808)
print v(xbgr.mr_n47359920)
print v(xbgr.mr_n47360240)
print v(xbgr.mr_n47360352)
print v(xbgr.mr_n47360672)
print v(xbgr.mr_n47360784)
print v(xbgr.mr_n47361104)
print v(xbgr.mr_n47361216)
print v(xbgr.mr_n47361536)
print v(xbgr.mr_n47361648)
print v(xbgr.mr_n47361968)
print v(xbgr.mr_n47362080)
print v(xbgr.mr_n47362400)
print v(xbgr.mr_n47362512)
print v(xbgr.mr_n47362832)
print v(xbgr.mr_n47362944)
print v(xbgr.mr_n47363264)
print v(xbgr.mr_n47363376)
print v(xbgr.mr_n47363696)
print v(xbgr.mr_n47363808)
print v(xbgr.mr_n47364128)
print v(xbgr.mr_n47364240)
print v(xbgr.mr_n47364560)
print v(xbgr.mr_n47364672)
print v(xbgr.mr_n47364992)
print v(xbgr.mr_n47365104)
print v(xbgr.mr_n47365424)
print v(xbgr.mr_n47365536)
print v(xbgr.mr_n47365856)
print v(xbgr.mr_n47365968)
print v(xbgr.mr_n47366288)
print v(xbgr.mr_n47366400)
print v(xbgr.mr_n47366720)
print v(xbgr.mr_n47366832)
print v(xbgr.mr_n47367152)
print v(xbgr.mr_n47367264)
print v(xbgr.mr_n47367584)
print v(xbgr.mr_n47367696)
print v(xbgr.mr_n47368016)
print v(xbgr.mr_n47368128)
print v(xbgr.mr_n47368448)
print v(xbgr.mr_n47368560)
print v(xbgr.mr_n47368880)
print v(xbgr.mr_n47368992)
print v(xbgr.mr_n47369312)
print v(xbgr.mr_n47369424)
print v(xbgr.mr_n47369744)
print v(xbgr.mr_n47369856)
print v(xbgr.mr_n47370176)
print v(xbgr.mr_n47370288)
print v(xbgr.mr_n47370608)
print v(xbgr.mr_n47370720)
print v(xbgr.mr_n47371040)
print v(xbgr.mr_n47371152)
print v(xbgr.mr_n47371472)
print v(xbgr.mr_n47371584)
print v(xbgr.mr_n47371904)
print v(xbgr.mr_n47372016)
print v(xbgr.mr_n47372336)
print v(xbgr.mr_n47372448)
print v(xbgr.mr_n47372768)
print v(xbgr.mr_n47372880)
print v(xbgr.mr_n47373200)
print v(xbgr.mr_n47373312)
print v(xbgr.mr_n47373632)
print v(xbgr.mr_n47373744)
print v(xbgr.mr_n47374064)
print v(xbgr.mr_n47374176)
print v(xbgr.mr_n47374496)
print v(xbgr.mr_n47374608)
print v(xbgr.mr_n47374928)
print v(xbgr.mr_n47375040)
print v(xbgr.mr_n47375360)
print v(xbgr.mr_n47375472)
print v(xbgr.mr_n47375792)
print v(xbgr.mr_n47375904)
print v(xbgr.mr_n47376224)
print v(xbgr.mr_n47376336)
print v(xbgr.mr_n47376656)
print v(xbgr.mr_n47376768)
print v(xbgr.mr_n47377088)
print v(xbgr.mr_n47377200)
print v(xbgr.mr_n47377520)
print v(xbgr.mr_n47377632)
print v(xbgr.mr_n47377952)
print v(xbgr.mr_n47378064)
print v(xbgr.mr_n47378608)
print v(xbgr.mr_n47378720)
print v(xbgr.mr_n47379040)
print v(xbgr.mr_n47379152)
print v(xbgr.mr_n47379472)
print v(xbgr.mr_n47379584)
print v(xbgr.mr_n47379904)
print v(xbgr.mr_n47380016)
print v(xbgr.mr_n47380336)
print v(xbgr.mr_n47380448)
print v(xbgr.mr_n47380768)
print v(xbgr.mr_n47380880)
print v(xbgr.mr_n47381200)
print v(xbgr.mr_n47381312)
print v(xbgr.mr_n47381632)
print v(xbgr.mr_n47381744)
print v(xbgr.mr_n47382064)
print v(xbgr.mr_n47382176)
print v(xbgr.mr_n47382496)
print v(xbgr.mr_n47382608)
print v(xbgr.mr_n47382928)
print v(xbgr.mr_n47383040)
print v(xbgr.mr_n47383360)
print v(xbgr.mr_n47383472)
print v(xbgr.mr_n47383792)
print v(xbgr.mr_n47383904)
print v(xbgr.mr_n47384224)
print v(xbgr.mr_n47384336)
print v(xbgr.mr_n47384656)
print v(xbgr.mr_n47384768)
print v(xbgr.mr_n47385088)
print v(xbgr.mr_n47385200)
print v(xbgr.mr_n47385520)
print v(xbgr.mr_n47385632)
print v(xbgr.mr_n47385952)
print v(xbgr.mr_n47386064)
print v(xbgr.mr_n47386384)
print v(xbgr.mr_n47386496)
print v(xbgr.mr_n47386816)
print v(xbgr.mr_n47386928)
print v(xbgr.mr_n47387248)
print v(xbgr.mr_n47387360)
print v(xbgr.mr_n47387680)
print v(xbgr.mr_n47387792)
print v(xbgr.mr_n47388112)
print v(xbgr.mr_n47388224)
print v(xbgr.mr_n47388544)
print v(xbgr.mr_n47388656)
print v(xbgr.mr_n47388976)
print v(xbgr.mr_n47389088)
print v(xbgr.mr_n47389408)
print v(xbgr.mr_n47389520)
print v(xbgr.mr_n47389840)
print v(xbgr.mr_n47389952)
print v(xbgr.mr_n47390272)
print v(xbgr.mr_n47390384)
print v(xbgr.mr_n47390704)
print v(xbgr.mr_n47390816)
print v(xbgr.mr_n47391136)
print v(xbgr.mr_n47391248)
print v(xbgr.mr_n47391568)
print v(xbgr.mr_n47391680)
print v(xbgr.mr_n47392000)
print v(xbgr.mr_n47392112)
print v(xbgr.mr_n47392432)
print v(xbgr.mr_n47392544)
print v(xbgr.mr_n47392864)
print v(xbgr.mr_n47392976)
print v(xbgr.mr_n47393296)
print v(xbgr.mr_n47393408)
print v(xbgr.mr_n47393728)
print v(xbgr.mr_n47393840)
print v(xbgr.mr_n47394160)
print v(xbgr.mr_n47394272)
print v(xbgr.mr_n47394592)
print v(xbgr.mr_n47394704)
print v(xbgr.mr_n47395024)
print v(xbgr.mr_n47395136)
print v(xbgr.mr_n47395456)
print v(xbgr.mr_n47395568)
print v(xbgr.mr_n47395888)
print v(xbgr.mr_n47396000)
print v(xbgr.mr_n47396320)
print v(xbgr.mr_n47396432)
print v(xbgr.mr_n47396752)
print v(xbgr.mr_n47396864)
print v(xbgr.mr_n47397184)
print v(xbgr.mr_n47397296)
print v(xbgr.mr_n47397616)
print v(xbgr.mr_n47397728)
print v(xbgr.mr_n47398048)
print v(xbgr.mr_n47398160)
print v(xbgr.mr_n47398480)
print v(xbgr.mr_n47398592)
print v(xbgr.mr_n47398912)
print v(xbgr.mr_n47399024)
print v(xbgr.mr_n47399344)
print v(xbgr.mr_n47399456)
print v(xbgr.mr_n47399776)
print v(xbgr.mr_n47399888)
print v(xbgr.mr_n47400208)
print v(xbgr.mr_n47400320)
print v(xbgr.mr_n47400640)
print v(xbgr.mr_n47400752)
print v(xbgr.mr_n47401072)
print v(xbgr.mr_n47401184)
print v(xbgr.mr_n47401504)
print v(xbgr.mr_n47401616)
print v(xbgr.mr_n47401936)
print v(xbgr.mr_n47402048)
print v(xbgr.mr_n47402368)
print v(xbgr.mr_n47402480)
print v(xbgr.mr_n47402800)
print v(xbgr.mr_n47402912)
print v(xbgr.mr_n47403232)
print v(xbgr.mr_n47403344)
print v(xbgr.mr_n47403664)
print v(xbgr.mr_n47403776)
print v(xbgr.mr_n47404096)
print v(xbgr.mr_n47404208)
print v(xbgr.mr_n47404528)
print v(xbgr.mr_n47404640)
print v(xbgr.mr_n47404960)
print v(xbgr.mr_n47405072)
print v(xbgr.mr_n47405392)
print v(xbgr.mr_n47405504)
print v(xbgr.mr_n47405824)
print v(xbgr.mr_n47405936)
print v(xbgr.mr_n47406256)
print v(xbgr.mr_n47406368)
print v(xbgr.mr_n47406688)
print v(xbgr.mr_n47406800)
print v(xbgr.mr_n47407120)
print v(xbgr.mr_n47407232)
print v(xbgr.mr_n47407552)
print v(xbgr.mr_n47407664)
print v(xbgr.mr_n47407984)
print v(xbgr.mr_n47408096)
print v(xbgr.mr_n47408416)
print v(xbgr.mr_n47408528)
print v(xbgr.mr_n47408848)
print v(xbgr.mr_n47408960)
print v(xbgr.mr_n47409280)
print v(xbgr.mr_n47409392)
print v(xbgr.mr_n47409712)
print v(xbgr.mr_n47409824)
print v(xbgr.mr_n47410144)
print v(xbgr.mr_n47410256)
print v(xbgr.mr_n47410576)
print v(xbgr.mr_n47410688)
print v(xbgr.mr_n47411008)
print v(xbgr.mr_n47411120)
print v(xbgr.mr_n47411440)
print v(xbgr.mr_n47411552)
print v(xbgr.mr_n47411872)
print v(xbgr.mr_n47411984)
print v(xbgr.mr_n47412304)
print v(xbgr.mr_n47412416)
print v(xbgr.mr_n47412736)
print v(xbgr.mr_n47412848)
print v(xbgr.mr_n47413168)
print v(xbgr.mr_n47413280)
print v(xbgr.mr_n47413600)
print v(xbgr.mr_n47413712)
print v(xbgr.mr_n47414032)
print v(xbgr.mr_n47414144)
print v(xbgr.mr_n47414464)
print v(xbgr.mr_n47414576)
print v(xbgr.mr_n47414896)
print v(xbgr.mr_n47415008)
print v(xbgr.mr_n47415328)
print v(xbgr.mr_n47415440)
print v(xbgr.mr_n47415760)
print v(xbgr.mr_n47415872)
print v(xbgr.mr_n47416192)
print v(xbgr.mr_n47416304)
print v(xbgr.mr_n47416624)
print v(xbgr.mr_n47416736)
print v(xbgr.mr_n47417056)
print v(xbgr.mr_n47417168)
print v(xbgr.mr_n47417488)
print v(xbgr.mr_n47417600)
print v(xbgr.mr_n47417920)
print v(xbgr.mr_n47418032)
print v(xbgr.mr_n47418352)
print v(xbgr.mr_n47418464)
print v(xbgr.mr_n47418784)
print v(xbgr.mr_n47418896)
print v(xbgr.mr_n47419216)
print v(xbgr.mr_n47419328)
print v(xbgr.mr_n47419648)
print v(xbgr.mr_n47419760)
print v(xbgr.mr_n47420080)
print v(xbgr.mr_n47420192)
print v(xbgr.mr_n47420512)
print v(xbgr.mr_n47420624)
print v(xbgr.mr_n47420944)
print v(xbgr.mr_n47421056)
print v(xbgr.mr_n47421376)
print v(xbgr.mr_n47421488)
print v(xbgr.mr_n47421808)
print v(xbgr.mr_n47421920)
print v(xbgr.mr_n47422240)
print v(xbgr.mr_n47422352)
print v(xbgr.mr_n47422672)
print v(xbgr.mr_n47422784)
print v(xbgr.mr_n47423104)
print v(xbgr.mr_n47423216)
print v(xbgr.mr_n47423536)
print v(xbgr.mr_n47423648)
print v(xbgr.mr_n47423968)
print v(xbgr.mr_n47424080)
print v(xbgr.mr_n47424400)
print v(xbgr.mr_n47424512)
print v(xbgr.mr_n47424832)
print v(xbgr.mr_n47424944)
print v(xbgr.mr_n47425264)
print v(xbgr.mr_n47425376)
print v(xbgr.mr_n47425696)
print v(xbgr.mr_n47425808)
print v(xbgr.mr_n47426128)
print v(xbgr.mr_n47426240)
print v(xbgr.mr_n47426560)
print v(xbgr.mr_n47426672)
print v(xbgr.mr_n47426992)
print v(xbgr.mr_n47427104)
print v(xbgr.mr_n47427424)
print v(xbgr.mr_n47427536)
print v(xbgr.mr_n47427856)
print v(xbgr.mr_n47427968)
print v(xbgr.mr_n47428288)
print v(xbgr.mr_n47428400)
print v(xbgr.mr_n47428720)
print v(xbgr.mr_n47428832)
print v(xbgr.mr_n47429152)
print v(xbgr.mr_n47429264)
print v(xbgr.mr_n47429584)
print v(xbgr.mr_n47429696)
print v(xbgr.mr_n47430016)
print v(xbgr.mr_n47430128)
print v(xbgr.mr_n47430448)
print v(xbgr.mr_n47430560)
print v(xbgr.mr_n47430880)
print v(xbgr.mr_n47430992)
print v(xbgr.mr_n47431312)
print v(xbgr.mr_n47431424)
print v(xbgr.mr_n47431744)
print v(xbgr.mr_n47431856)
print v(xbgr.mr_n47432176)
print v(xbgr.mr_n47432288)
print v(xbgr.mr_n47432608)
print v(xbgr.mr_n47432720)
print v(xbgr.mr_n47433040)
print v(xbgr.mr_n47433152)
print v(xbgr.mr_n47433472)
print v(xbgr.mr_n47433584)
print v(xbgr.mr_n47433904)
print v(xbgr.mr_n47434016)
print v(xbgr.mr_n47434336)
print v(xbgr.mr_n47434448)
print v(xbgr.mr_n47434768)
print v(xbgr.mr_n47434880)
print v(xbgr.mr_n47435200)
print v(xbgr.mr_n47435312)
print v(xbgr.mr_n47435632)
print v(xbgr.mr_n47435744)
print v(xbgr.mr_n47436064)
print v(xbgr.mr_n47436176)
print v(xbgr.mr_n47436496)
print v(xbgr.mr_n47436608)
print v(xbgr.mr_n47436928)
print v(xbgr.mr_n47437040)
print v(xbgr.mr_n47437360)
print v(xbgr.mr_n47437472)
print v(xbgr.mr_n47437792)
print v(xbgr.mr_n47437904)
print v(xbgr.mr_n47438224)
print v(xbgr.mr_n47438336)
print v(xbgr.mr_n47438656)
print v(xbgr.mr_n47438768)
print v(xbgr.mr_n47439088)
print v(xbgr.mr_n47439200)
print v(xbgr.mr_n47439520)
print v(xbgr.mr_n47439632)
print v(xbgr.mr_n47439952)
print v(xbgr.mr_n47440064)
print v(xbgr.mr_n47440384)
print v(xbgr.mr_n47440496)
print v(xbgr.mr_n47440816)
print v(xbgr.mr_n47440928)
print v(xbgr.mr_n47441248)
print v(xbgr.mr_n47441360)
print v(xbgr.mr_n47441680)
print v(xbgr.mr_n47441792)
print v(xbgr.mr_n47442112)
print v(xbgr.mr_n47442224)
print v(xbgr.mr_n47442544)
print v(xbgr.mr_n47442656)
print v(xbgr.mr_n47442976)
print v(xbgr.mr_n47443088)
print v(xbgr.mr_n47443408)
print v(xbgr.mr_n47443520)
print v(xbgr.mr_n47443840)
print v(xbgr.mr_n47443952)
print v(xbgr.mr_n47444272)
print v(xbgr.mr_n47444384)
print v(xbgr.mr_n47444704)
print v(xbgr.mr_n47444816)
print v(xbgr.mr_n47445136)
print v(xbgr.mr_n47445248)
print v(xbgr.mr_n47445568)
print v(xbgr.mr_n47445680)
print v(xbgr.mr_n47446000)
print v(xbgr.mr_n47446112)
print v(xbgr.mr_n47446432)
print v(xbgr.mr_n47446544)
print v(xbgr.mr_n47446864)
print v(xbgr.mr_n47446976)
print v(xbgr.mr_n47447296)
print v(xbgr.mr_n47447408)
print v(xbgr.mr_n47447728)
print v(xbgr.mr_n47447840)
print v(xbgr.mr_n47448160)
print v(xbgr.mr_n47448272)
print v(xbgr.mr_n47448592)
print v(xbgr.mr_n47448704)
print v(xbgr.mr_n47449024)
print v(xbgr.mr_n47449136)
print v(xbgr.mr_n47449456)
print v(xbgr.mr_n47449568)
print v(xbgr.mr_n47449888)
print v(xbgr.mr_n47450000)
print v(xbgr.mr_n47450320)
print v(xbgr.mr_n47450432)
print v(xbgr.mr_n47450752)
print v(xbgr.mr_n47450864)
print v(xbgr.mr_n47451184)
print v(xbgr.mr_n47451296)
print v(xbgr.mr_n47451616)
print v(xbgr.mr_n47451728)
print v(xbgr.mr_n47452048)
print v(xbgr.mr_n47452160)
print v(xbgr.mr_n47452480)
print v(xbgr.mr_n47452592)
print v(xbgr.mr_n47452912)
print v(xbgr.mr_n47453024)
print v(xbgr.mr_n47453344)
print v(xbgr.mr_n47453456)
print v(xbgr.mr_n47453776)
print v(xbgr.mr_n47453888)
print v(xbgr.mr_n47454208)
print v(xbgr.mr_n47454320)
print v(xbgr.mr_n47454640)
print v(xbgr.mr_n47454752)
print v(xbgr.mr_n47455072)
print v(xbgr.mr_n47455184)
print v(xbgr.mr_n47455504)
print v(xbgr.mr_n47455616)
print v(xbgr.mr_n47455936)
print v(xbgr.mr_n47456048)
print v(xbgr.mr_n47456368)
print v(xbgr.mr_n47456480)
print v(xbgr.mr_n47456800)
print v(xbgr.mr_n47456912)
print v(xbgr.mr_n47457232)
print v(xbgr.mr_n47457344)
print v(xbgr.mr_n47457664)
print v(xbgr.mr_n47457776)
print v(xbgr.mr_n47458096)
print v(xbgr.mr_n47458208)
print v(xbgr.mr_n47458528)
print v(xbgr.mr_n47458640)
print v(xbgr.mr_n47458960)
print v(xbgr.mr_n47459072)
print v(xbgr.mr_n47459392)
print v(xbgr.mr_n47459504)
print v(xbgr.mr_n47459824)
print v(xbgr.mr_n47459936)
print v(xbgr.mr_n47460256)
print v(xbgr.mr_n47460368)
print v(xbgr.mr_n47460688)
print v(xbgr.mr_n47460800)
print v(xbgr.mr_n47461120)
print v(xbgr.mr_n47461232)
print v(xbgr.mr_n47461552)
print v(xbgr.mr_n47461664)
print v(xbgr.mr_n47461984)
print v(xbgr.mr_n47462096)
print v(xbgr.mr_n47462416)
print v(xbgr.mr_n47462528)
print v(xbgr.mr_n47462848)
print v(xbgr.mr_n47462960)
print v(xbgr.mr_n47463280)
print v(xbgr.mr_n47463392)
print v(xbgr.mr_n47463712)
print v(xbgr.mr_n47463824)
print v(xbgr.mr_n47464144)
print v(xbgr.mr_n47464256)
print v(xbgr.mr_n47464576)
print v(xbgr.mr_n47464688)
print v(xbgr.mr_n47465008)
print v(xbgr.mr_n47465120)
print v(xbgr.mr_n47465440)
print v(xbgr.mr_n47465552)
print v(xbgr.mr_n47465872)
print v(xbgr.mr_n47465984)
print v(xbgr.mr_n47466304)
print v(xbgr.mr_n47466416)
print v(xbgr.mr_n47466736)
print v(xbgr.mr_n47466848)
print v(xbgr.mr_n47467168)
print v(xbgr.mr_n47467280)
print v(xbgr.mr_n47467600)
print v(xbgr.mr_n47467712)
print v(xbgr.mr_n47468032)
print v(xbgr.mr_n47468144)
print v(xbgr.mr_n47468464)
print v(xbgr.mr_n47468576)
print v(xbgr.mr_n47468896)
print v(xbgr.mr_n47469008)
print v(xbgr.mr_n47469328)
print v(xbgr.mr_n47469440)
print v(xbgr.mr_n47469760)
print v(xbgr.mr_n47469872)
print v(xbgr.mr_n47470192)
print v(xbgr.mr_n47470304)
print v(xbgr.mr_n47470624)
print v(xbgr.mr_n47470736)
print v(xbgr.mr_n47471056)
print v(xbgr.mr_n47471168)
print v(xbgr.mr_n47471488)
print v(xbgr.mr_n47471600)
print v(xbgr.mr_n47471920)
print v(xbgr.mr_n47472032)
print v(xbgr.mr_n47472352)
print v(xbgr.mr_n47472464)
print v(xbgr.mr_n47472784)
print v(xbgr.mr_n47472896)
print v(xbgr.mr_n47473216)
print v(xbgr.mr_n47473328)
print v(xbgr.mr_n47473648)
print v(xbgr.mr_n47473760)
print v(xbgr.mr_n47474080)
print v(xbgr.mr_n47474192)
print v(xbgr.mr_n47474512)
print v(xbgr.mr_n47474624)
print v(xbgr.mr_n47474944)
print v(xbgr.mr_n47475056)
print v(xbgr.mr_n47475376)
print v(xbgr.mr_n47475488)
print v(xbgr.mr_n47475808)
print v(xbgr.mr_n47475920)
print v(xbgr.mr_n47476240)
print v(xbgr.mr_n47476352)
print v(xbgr.mr_n47476672)
print v(xbgr.mr_n47476784)
print v(xbgr.mr_n47477104)
print v(xbgr.mr_n47477216)
print v(xbgr.mr_n47477536)
print v(xbgr.mr_n47477648)
print v(xbgr.mr_n48480320)
print v(xbgr.mr_n48480432)
print v(xbgr.mr_n48480688)
print v(xbgr.mr_n48480800)
print v(xbgr.mr_n48481056)
print v(xbgr.mr_n48481168)
print v(xbgr.mr_n48481424)
print v(xbgr.mr_n48481536)
print v(xbgr.mr_n48481792)
print v(xbgr.mr_n48481904)
print v(xbgr.mr_n48482192)
print v(xbgr.mr_n48482304)
print v(xbgr.mr_n48482624)
print v(xbgr.mr_n48482736)
print v(xbgr.mr_n48483056)
print v(xbgr.mr_n48483168)
print v(xbgr.mr_n48483488)
print v(xbgr.mr_n48483600)
print v(xbgr.mr_n48483920)
print v(xbgr.mr_n48484032)
print v(xbgr.mr_n48484352)
print v(xbgr.mr_n48484464)
print v(xbgr.mr_n48484784)
print v(xbgr.mr_n48484896)
print v(xbgr.mr_n48485216)
print v(xbgr.mr_n48485328)
print v(xbgr.mr_n48485648)
print v(xbgr.mr_n48485760)
print v(xbgr.mr_n48486080)
print v(xbgr.mr_n48486192)
print v(xbgr.mr_n48486512)
print v(xbgr.mr_n48486624)
print v(xbgr.mr_n48486944)
print v(xbgr.mr_n48487056)
print v(xbgr.mr_n48487376)
print v(xbgr.mr_n48487488)
print v(xbgr.mr_n48487808)
print v(xbgr.mr_n48487920)
print v(xbgr.mr_n48488240)
print v(xbgr.mr_n48488352)
print v(xbgr.mr_n48488672)
print v(xbgr.mr_n48488784)
print v(xbgr.mr_n48489104)
print v(xbgr.mr_n48489216)
print v(xbgr.mr_n48489536)
print v(xbgr.mr_n48489648)
print v(xbgr.mr_n48489968)
print v(xbgr.mr_n48490080)
print v(xbgr.mr_n48490400)
print v(xbgr.mr_n48490512)
print v(xbgr.mr_n48490832)
print v(xbgr.mr_n48490944)
print v(xbgr.mr_n48491264)
print v(xbgr.mr_n48491376)
print v(xbgr.mr_n48491696)
print v(xbgr.mr_n48491808)
print v(xbgr.mr_n48492128)
print v(xbgr.mr_n48492240)
print v(xbgr.mr_n48492560)
print v(xbgr.mr_n48492672)
print v(xbgr.mr_n48492992)
print v(xbgr.mr_n48493104)
print v(xbgr.mr_n48493424)
print v(xbgr.mr_n48493536)
print v(xbgr.mr_n48493856)
print v(xbgr.mr_n48493968)
print v(xbgr.mr_n48494288)
print v(xbgr.mr_n48494400)
print v(xbgr.mr_n48494720)
print v(xbgr.mr_n48494832)
print v(xbgr.mr_n48495152)
print v(xbgr.mr_n48495264)
print v(xbgr.mr_n48495584)
print v(xbgr.mr_n48495696)
print v(xbgr.mr_n48496016)
print v(xbgr.mr_n48496128)
print v(xbgr.mr_n48496448)
print v(xbgr.mr_n48496560)
print v(xbgr.mr_n48496880)
print v(xbgr.mr_n48496992)
print v(xbgr.mr_n48497312)
print v(xbgr.mr_n48497424)
print v(xbgr.mr_n48497744)
print v(xbgr.mr_n48497856)
print v(xbgr.mr_n48498176)
print v(xbgr.mr_n48498288)
print v(xbgr.mr_n48498608)
print v(xbgr.mr_n48498720)
print v(xbgr.mr_n48499040)
print v(xbgr.mr_n48499152)
print v(xbgr.mr_n48499472)
print v(xbgr.mr_n48499584)
print v(xbgr.mr_n48499904)
print v(xbgr.mr_n48500016)
print v(xbgr.mr_n48500336)
print v(xbgr.mr_n48500448)
print v(xbgr.mr_n48500768)
print v(xbgr.mr_n48500880)
print v(xbgr.mr_n48501200)
print v(xbgr.mr_n48501312)
print v(xbgr.mr_n48501632)
print v(xbgr.mr_n48501744)
print v(xbgr.mr_n48502064)
print v(xbgr.mr_n48502176)
print v(xbgr.mr_n48502496)
print v(xbgr.mr_n48502608)
print v(xbgr.mr_n48502928)
print v(xbgr.mr_n48503040)
print v(xbgr.mr_n48503360)
print v(xbgr.mr_n48503472)
print v(xbgr.mr_n48503792)
print v(xbgr.mr_n48503904)
print v(xbgr.mr_n48504224)
print v(xbgr.mr_n48504336)
print v(xbgr.mr_n48504656)
print v(xbgr.mr_n48504768)
print v(xbgr.mr_n48505088)
print v(xbgr.mr_n48505200)
print v(xbgr.mr_n48505520)
print v(xbgr.mr_n48505632)
print v(xbgr.mr_n48505952)
print v(xbgr.mr_n48506064)
print v(xbgr.mr_n48506384)
print v(xbgr.mr_n48506496)
print v(xbgr.mr_n48506816)
print v(xbgr.mr_n48506928)
print v(xbgr.mr_n48507248)
print v(xbgr.mr_n48507360)
print v(xbgr.mr_n48507680)
print v(xbgr.mr_n48507792)
print v(xbgr.mr_n48508112)
print v(xbgr.mr_n48508224)
print v(xbgr.mr_n48508544)
print v(xbgr.mr_n48508656)
print v(xbgr.mr_n48508976)
print v(xbgr.mr_n48509088)
print v(xbgr.mr_n48509408)
print v(xbgr.mr_n48509520)
print v(xbgr.mr_n48509840)
print v(xbgr.mr_n48509952)
print v(xbgr.mr_n48510272)
print v(xbgr.mr_n48510384)
print v(xbgr.mr_n48510704)
print v(xbgr.mr_n48510816)
print v(xbgr.mr_n48511136)
print v(xbgr.mr_n48511248)
print v(xbgr.mr_n48511568)
print v(xbgr.mr_n48511680)
print v(xbgr.mr_n48512000)
print v(xbgr.mr_n48512112)
print v(xbgr.mr_n48512432)
print v(xbgr.mr_n48512544)
print v(xbgr.mr_n48512864)
print v(xbgr.mr_n48512976)
print v(xbgr.mr_n48513296)
print v(xbgr.mr_n48513408)
print v(xbgr.mr_n48513728)
print v(xbgr.mr_n48513840)
print v(xbgr.mr_n48514160)
print v(xbgr.mr_n48514272)
print v(xbgr.mr_n48514592)
print v(xbgr.mr_n48514704)
print v(xbgr.mr_n48515024)
print v(xbgr.mr_n48515136)
print v(xbgr.mr_n48515456)
print v(xbgr.mr_n48515568)
print v(xbgr.mr_n48515888)
print v(xbgr.mr_n48516000)
print v(xbgr.mr_n48516320)
print v(xbgr.mr_n48516432)
print v(xbgr.mr_n48516752)
print v(xbgr.mr_n48516864)
print v(xbgr.mr_n48517184)
print v(xbgr.mr_n48517296)
print v(xbgr.mr_n48517616)
print v(xbgr.mr_n48517728)
print v(xbgr.mr_n48518048)
print v(xbgr.mr_n48518160)
print v(xbgr.mr_n48518480)
print v(xbgr.mr_n48518592)
print v(xbgr.mr_n48518912)
print v(xbgr.mr_n48519024)
print v(xbgr.mr_n48519344)
print v(xbgr.mr_n48519456)
print v(xbgr.mr_n48519776)
print v(xbgr.mr_n48519888)
print v(xbgr.mr_n48520208)
print v(xbgr.mr_n48520320)
print v(xbgr.mr_n48520640)
print v(xbgr.mr_n48520752)
print v(xbgr.mr_n48521072)
print v(xbgr.mr_n48521184)
print v(xbgr.mr_n48521504)
print v(xbgr.mr_n48521616)
print v(xbgr.mr_n48521936)
print v(xbgr.mr_n48522048)
print v(xbgr.mr_n48522368)
print v(xbgr.mr_n48522480)
print v(xbgr.mr_n48522800)
print v(xbgr.mr_n48522912)
print v(xbgr.mr_n48523232)
print v(xbgr.mr_n48523344)
print v(xbgr.mr_n48523664)
print v(xbgr.mr_n48523776)
print v(xbgr.mr_n48524096)
print v(xbgr.mr_n48524208)
print v(xbgr.mr_n48524528)
print v(xbgr.mr_n48524640)
print v(xbgr.mr_n48524960)
print v(xbgr.mr_n48525072)
print v(xbgr.mr_n48525392)
print v(xbgr.mr_n48525504)
print v(xbgr.mr_n48525824)
print v(xbgr.mr_n48525936)
print v(xbgr.mr_n48526256)
print v(xbgr.mr_n48526368)
print v(xbgr.mr_n48526688)
print v(xbgr.mr_n48526800)
print v(xbgr.mr_n48527120)
print v(xbgr.mr_n48527232)
print v(xbgr.mr_n48527552)
print v(xbgr.mr_n48527664)
print v(xbgr.mr_n48527984)
print v(xbgr.mr_n48528096)
print v(xbgr.mr_n48528416)
print v(xbgr.mr_n48528528)
print v(xbgr.mr_n48528848)
print v(xbgr.mr_n48528960)
print v(xbgr.mr_n48529280)
print v(xbgr.mr_n48529392)
print v(xbgr.mr_n48529712)
print v(xbgr.mr_n48529824)
print v(xbgr.mr_n48530144)
print v(xbgr.mr_n48530256)
print v(xbgr.mr_n48530576)
print v(xbgr.mr_n48530688)
print v(xbgr.mr_n48531008)
print v(xbgr.mr_n48531120)
print v(xbgr.mr_n48531440)
print v(xbgr.mr_n48531552)
print v(xbgr.mr_n48531872)
print v(xbgr.mr_n48531984)
print v(xbgr.mr_n48532304)
print v(xbgr.mr_n48532416)
print v(xbgr.mr_n48532736)
print v(xbgr.mr_n48532848)
print v(xbgr.mr_n48533168)
print v(xbgr.mr_n48533280)
print v(xbgr.mr_n48533600)
print v(xbgr.mr_n48533712)
print v(xbgr.mr_n48534032)
print v(xbgr.mr_n48534144)
print v(xbgr.mr_n48534464)
print v(xbgr.mr_n48534576)
print v(xbgr.mr_n48534896)
print v(xbgr.mr_n48535008)
print v(xbgr.mr_n48535328)
print v(xbgr.mr_n48535440)
print v(xbgr.mr_n48535760)
print v(xbgr.mr_n48535872)
print v(xbgr.mr_n48536192)
print v(xbgr.mr_n48536304)
print v(xbgr.mr_n48536624)
print v(xbgr.mr_n48536736)
print v(xbgr.mr_n48537056)
print v(xbgr.mr_n48537168)
print v(xbgr.mr_n48537488)
print v(xbgr.mr_n48537600)
print v(xbgr.mr_n48537920)
print v(xbgr.mr_n48538032)
print v(xbgr.mr_n48538352)
print v(xbgr.mr_n48538464)
print v(xbgr.mr_n48538784)
print v(xbgr.mr_n48538896)
print v(xbgr.mr_n48539216)
print v(xbgr.mr_n48539328)
print v(xbgr.mr_n48539648)
print v(xbgr.mr_n48539760)
print v(xbgr.mr_n48540080)
print v(xbgr.mr_n48540192)
print v(xbgr.mr_n48540512)
print v(xbgr.mr_n48540624)
print v(xbgr.mr_n48540944)
print v(xbgr.mr_n48541056)
print v(xbgr.mr_n48541376)
print v(xbgr.mr_n48541488)
print v(xbgr.mr_n48541808)
print v(xbgr.mr_n48541920)
print v(xbgr.mr_n48542240)
print v(xbgr.mr_n48542352)
print v(xbgr.mr_n48542672)
print v(xbgr.mr_n48542784)
print v(xbgr.mr_n48543104)
print v(xbgr.mr_n48543216)
print v(xbgr.mr_n48543536)
print v(xbgr.mr_n48543648)
print v(xbgr.mr_n48543968)
print v(xbgr.mr_n48544080)
print v(xbgr.mr_n48544400)
print v(xbgr.mr_n48544512)
print v(xbgr.mr_n48544832)
print v(xbgr.mr_n48544944)
print v(xbgr.mr_n48545264)
print v(xbgr.mr_n48545376)
print v(xbgr.mr_n48545696)
print v(xbgr.mr_n48545808)
print v(xbgr.mr_n48546128)
print v(xbgr.mr_n48546240)
print v(xbgr.mr_n48546560)
print v(xbgr.mr_n48546672)
print v(xbgr.mr_n48546992)
print v(xbgr.mr_n48547104)
print v(xbgr.mr_n48547424)
print v(xbgr.mr_n48547536)
print v(xbgr.mr_n48547856)
print v(xbgr.mr_n48547968)
print v(xbgr.mr_n48548288)
print v(xbgr.mr_n48548400)
print v(xbgr.mr_n48548720)
print v(xbgr.mr_n48548832)
print v(xbgr.mr_n48549152)
print v(xbgr.mr_n48549264)
print v(xbgr.mr_n48549584)
print v(xbgr.mr_n48549696)
print v(xbgr.mr_n48550016)
print v(xbgr.mr_n48550128)
print v(xbgr.mr_n48550448)
print v(xbgr.mr_n48550560)
print v(xbgr.mr_n48550880)
print v(xbgr.mr_n48550992)
print v(xbgr.mr_n48551312)
print v(xbgr.mr_n48551424)
print v(xbgr.mr_n48551744)
print v(xbgr.mr_n48551856)
print v(xbgr.mr_n48552176)
print v(xbgr.mr_n48552288)
print v(xbgr.mr_n48552608)
print v(xbgr.mr_n48552720)
print v(xbgr.mr_n48553040)
print v(xbgr.mr_n48553152)
print v(xbgr.mr_n48553472)
print v(xbgr.mr_n48553584)
print v(xbgr.mr_n48553904)
print v(xbgr.mr_n48554016)
print v(xbgr.mr_n48554336)
print v(xbgr.mr_n48554448)
print v(xbgr.mr_n48554768)
print v(xbgr.mr_n48554880)
print v(xbgr.mr_n48555200)
print v(xbgr.mr_n48555312)
print v(xbgr.mr_n48555632)
print v(xbgr.mr_n48555744)
print v(xbgr.mr_n48556064)
print v(xbgr.mr_n48556176)
print v(xbgr.mr_n48556496)
print v(xbgr.mr_n48556608)
print v(xbgr.mr_n48556928)
print v(xbgr.mr_n48557040)
print v(xbgr.mr_n48557360)
print v(xbgr.mr_n48557472)
print v(xbgr.mr_n48557792)
print v(xbgr.mr_n48557904)
print v(xbgr.mr_n48558224)
print v(xbgr.mr_n48558336)
print v(xbgr.mr_n48558656)
print v(xbgr.mr_n48558768)
print v(xbgr.mr_n48559088)
print v(xbgr.mr_n48559200)
print v(xbgr.mr_n48559520)
print v(xbgr.mr_n48559632)
print v(xbgr.mr_n48559952)
print v(xbgr.mr_n48560064)
print v(xbgr.mr_n48560384)
print v(xbgr.mr_n48560496)
print v(xbgr.mr_n48560816)
print v(xbgr.mr_n48560928)
print v(xbgr.mr_n48561248)
print v(xbgr.mr_n48561360)
print v(xbgr.mr_n48561680)
print v(xbgr.mr_n48561792)
print v(xbgr.mr_n48562112)
print v(xbgr.mr_n48562224)
print v(xbgr.mr_n48562544)
print v(xbgr.mr_n48562656)
print v(xbgr.mr_n48562976)
print v(xbgr.mr_n48563088)
print v(xbgr.mr_n48563408)
print v(xbgr.mr_n48563520)
print v(xbgr.mr_n48563840)
print v(xbgr.mr_n48563952)
print v(xbgr.mr_n48564272)
print v(xbgr.mr_n48564384)
print v(xbgr.mr_n48564704)
print v(xbgr.mr_n48564816)
print v(xbgr.mr_n48565136)
print v(xbgr.mr_n48565248)
print v(xbgr.mr_n48565568)
print v(xbgr.mr_n48565680)
print v(xbgr.mr_n48566000)
print v(xbgr.mr_n48566112)
print v(xbgr.mr_n48566432)
print v(xbgr.mr_n48566544)
print v(xbgr.mr_n48566864)
print v(xbgr.mr_n48566976)
print v(xbgr.mr_n48567296)
print v(xbgr.mr_n48567408)
print v(xbgr.mr_n48567728)
print v(xbgr.mr_n48567840)
print v(xbgr.mr_n48568160)
print v(xbgr.mr_n48568272)
print v(xbgr.mr_n48568592)
print v(xbgr.mr_n48568704)
print v(xbgr.mr_n48569024)
print v(xbgr.mr_n48569136)
print v(xbgr.mr_n48569456)
print v(xbgr.mr_n48569568)
print v(xbgr.mr_n48569888)
print v(xbgr.mr_n48570000)
print v(xbgr.mr_n48570320)
print v(xbgr.mr_n48570432)
print v(xbgr.mr_n48570752)
print v(xbgr.mr_n48570864)
print v(xbgr.mr_n48571184)
print v(xbgr.mr_n48571296)
print v(xbgr.mr_n48571616)
print v(xbgr.mr_n48571728)
print v(xbgr.mr_n48572048)
print v(xbgr.mr_n48572160)
print v(xbgr.mr_n48572480)
print v(xbgr.mr_n48572592)
print v(xbgr.mr_n48572912)
print v(xbgr.mr_n48573024)
print v(xbgr.mr_n48573344)
print v(xbgr.mr_n48573456)
print v(xbgr.mr_n48573776)
print v(xbgr.mr_n48573888)
print v(xbgr.mr_n48574208)
print v(xbgr.mr_n48574320)
print v(xbgr.mr_n48574640)
print v(xbgr.mr_n48574752)
print v(xbgr.mr_n48575072)
print v(xbgr.mr_n48575184)
print v(xbgr.mr_n48575504)
print v(xbgr.mr_n48575616)
print v(xbgr.mr_n48575936)
print v(xbgr.mr_n48576048)
print v(xbgr.mr_n48576368)
print v(xbgr.mr_n48576480)
print v(xbgr.mr_n48576800)
print v(xbgr.mr_n48576912)
print v(xbgr.mr_n48577232)
print v(xbgr.mr_n48577344)
print v(xbgr.mr_n48577664)
print v(xbgr.mr_n48577776)
print v(xbgr.mr_n48578096)
print v(xbgr.mr_n48578208)
print v(xbgr.mr_n48578528)
print v(xbgr.mr_n48578640)
print v(xbgr.mr_n48578960)
print v(xbgr.mr_n48579072)
print v(xbgr.mr_n48579392)
print v(xbgr.mr_n48579504)
print v(xbgr.mr_n48579824)
print v(xbgr.mr_n48579936)
print v(xbgr.mr_n48580256)
print v(xbgr.mr_n48580368)
print v(xbgr.mr_n48580688)
print v(xbgr.mr_n48580800)
print v(xbgr.mr_n48581120)
print v(xbgr.mr_n48581232)
print v(xbgr.mr_n48581552)
print v(xbgr.mr_n48581664)
print v(xbgr.mr_n48581984)
print v(xbgr.mr_n48582096)
print v(xbgr.mr_n48582416)
print v(xbgr.mr_n48582528)
print v(xbgr.mr_n48582848)
print v(xbgr.mr_n48582960)
print v(xbgr.mr_n48583248)
print v(xbgr.mr_n48583360)
print v(xbgr.mr_n48583680)
print v(xbgr.mr_n48583792)
print v(xbgr.mr_n48584112)
print v(xbgr.mr_n48584224)
print v(xbgr.mr_n48584544)
print v(xbgr.mr_n48584656)
print v(xbgr.mr_n48584976)
print v(xbgr.mr_n48585088)
print v(xbgr.mr_n48585408)
print v(xbgr.mr_n48585520)
print v(xbgr.mr_n48585840)
print v(xbgr.mr_n48585952)
print v(xbgr.mr_n48586272)
print v(xbgr.mr_n48586384)
print v(xbgr.mr_n48586704)
print v(xbgr.mr_n48586816)
print v(xbgr.mr_n48587136)
print v(xbgr.mr_n48587248)
print v(xbgr.mr_n48587568)
print v(xbgr.mr_n48587680)
print v(xbgr.mr_n48588000)
print v(xbgr.mr_n48588112)
print v(xbgr.mr_n48588432)
print v(xbgr.mr_n48588544)
print v(xbgr.mr_n48588864)
print v(xbgr.mr_n48588976)
print v(xbgr.mr_n48589296)
print v(xbgr.mr_n48589408)
print v(xbgr.mr_n48589728)
print v(xbgr.mr_n48589840)
print v(xbgr.mr_n48590160)
print v(xbgr.mr_n48590272)
print v(xbgr.mr_n48590592)
print v(xbgr.mr_n48590704)
print v(xbgr.mr_n48591024)
print v(xbgr.mr_n48591136)
print v(xbgr.mr_n48591456)
print v(xbgr.mr_n48591568)
print v(xbgr.mr_n48591888)
print v(xbgr.mr_n48592000)
print v(xbgr.mr_n48592320)
print v(xbgr.mr_n48592432)
print v(xbgr.mr_n48592752)
print v(xbgr.mr_n48592864)
print v(xbgr.mr_n48593184)
print v(xbgr.mr_n48593296)
print v(xbgr.mr_n48593616)
print v(xbgr.mr_n48593728)
print v(xbgr.mr_n48594048)
print v(xbgr.mr_n48594160)
print v(xbgr.mr_n48594480)
print v(xbgr.mr_n48594592)
print v(xbgr.mr_n48594912)
print v(xbgr.mr_n48595024)
print v(xbgr.mr_n48595344)
print v(xbgr.mr_n48595456)
print v(xbgr.mr_n48595776)
print v(xbgr.mr_n48595888)
print v(xbgr.mr_n48596208)
print v(xbgr.mr_n48596320)
print v(xbgr.mr_n48596640)
print v(xbgr.mr_n48596752)
print v(xbgr.mr_n48597072)
print v(xbgr.mr_n48597184)
print v(xbgr.mr_n48597504)
print v(xbgr.mr_n48597616)
print v(xbgr.mr_n48597936)
print v(xbgr.mr_n48598048)
print v(xbgr.mr_n48598368)
print v(xbgr.mr_n48598480)
print v(xbgr.mr_n48598800)
print v(xbgr.mr_n48598912)
print v(xbgr.mr_n48599232)
print v(xbgr.mr_n48599344)
print v(xbgr.mr_n48599664)
print v(xbgr.mr_n48599776)
print v(xbgr.mr_n48600096)
print v(xbgr.mr_n48600208)
print v(xbgr.mr_n48600528)
print v(xbgr.mr_n48600640)
print v(xbgr.mr_n48600960)
print v(xbgr.mr_n48601072)
print v(xbgr.mr_n48601392)
print v(xbgr.mr_n48601504)
print v(xbgr.mr_n48601824)
print v(xbgr.mr_n48601936)
print v(xbgr.mr_n48602256)
print v(xbgr.mr_n48602368)
print v(xbgr.mr_n48602688)
print v(xbgr.mr_n48602800)
print v(xbgr.mr_n48603120)
print v(xbgr.mr_n48603232)
print v(xbgr.mr_n48603552)
print v(xbgr.mr_n48603664)
print v(xbgr.mr_n48603984)
print v(xbgr.mr_n48604096)
print v(xbgr.mr_n48604416)
print v(xbgr.mr_n48604528)
print v(xbgr.mr_n48604848)
print v(xbgr.mr_n48604960)
print v(xbgr.mr_n48605280)
print v(xbgr.mr_n48605392)
print v(xbgr.mr_n48605712)
print v(xbgr.mr_n48605824)
print v(xbgr.mr_n48606144)
print v(xbgr.mr_n48606256)
print v(xbgr.mr_n48606576)
print v(xbgr.mr_n48606688)
print v(xbgr.mr_n48607008)
print v(xbgr.mr_n48607120)
print v(xbgr.mr_n48607440)
print v(xbgr.mr_n48607552)
print v(xbgr.mr_n48607872)
print v(xbgr.mr_n48607984)
print v(xbgr.mr_n48608304)
print v(xbgr.mr_n48608416)
print v(xbgr.mr_n48608736)
print v(xbgr.mr_n48608848)
print v(xbgr.mr_n48609168)
print v(xbgr.mr_n48609280)
print v(xbgr.mr_n48609600)
print v(xbgr.mr_n48609712)
print v(xbgr.mr_n48610032)
print v(xbgr.mr_n48610144)
print v(xbgr.mr_n48610464)
print v(xbgr.mr_n48610576)
print v(xbgr.mr_n48610896)
print v(xbgr.mr_n48611008)
print v(xbgr.mr_n48611328)
print v(xbgr.mr_n48611440)
print v(xbgr.mr_n48611760)
print v(xbgr.mr_n48611872)
print v(xbgr.mr_n48612192)
print v(xbgr.mr_n48612304)
print v(xbgr.mr_n48612624)
print v(xbgr.mr_n48612736)
print v(xbgr.mr_n48613056)
print v(xbgr.mr_n48613168)
print v(xbgr.mr_n48613488)
print v(xbgr.mr_n48613600)
print v(xbgr.mr_n48613920)
print v(xbgr.mr_n48614032)
print v(xbgr.mr_n48614352)
print v(xbgr.mr_n48614464)
print v(xbgr.mr_n48614784)
print v(xbgr.mr_n48614896)
print v(xbgr.mr_n48615216)
print v(xbgr.mr_n48615328)
print v(xbgr.mr_n48615648)
print v(xbgr.mr_n48615760)
print v(xbgr.mr_n48616080)
print v(xbgr.mr_n48616192)
print v(xbgr.mr_n48616512)
print v(xbgr.mr_n48616624)
print v(xbgr.mr_n48616944)
print v(xbgr.mr_n48617056)
print v(xbgr.mr_n48617376)
print v(xbgr.mr_n48617488)
print v(xbgr.mr_n48617808)
print v(xbgr.mr_n48617920)
print v(xbgr.mr_n48618240)
print v(xbgr.mr_n48618352)
print v(xbgr.mr_n48618672)
print v(xbgr.mr_n48618784)
print v(xbgr.mr_n48619104)
print v(xbgr.mr_n48619216)
print v(xbgr.mr_n48619536)
print v(xbgr.mr_n48619648)
print v(xbgr.mr_n48619968)
print v(xbgr.mr_n48620080)
print v(xbgr.mr_n48620400)
print v(xbgr.mr_n48620512)
print v(xbgr.mr_n48620832)
print v(xbgr.mr_n48620944)
print v(xbgr.mr_n48621264)
print v(xbgr.mr_n48621376)
print v(xbgr.mr_n48621696)
print v(xbgr.mr_n48621808)
print v(xbgr.mr_n48622128)
print v(xbgr.mr_n48622240)
print v(xbgr.mr_n48622560)
print v(xbgr.mr_n48622672)
print v(xbgr.mr_n48622992)
print v(xbgr.mr_n48623104)
print v(xbgr.mr_n48623424)
print v(xbgr.mr_n48623536)
print v(xbgr.mr_n48623856)
print v(xbgr.mr_n48623968)
print v(xbgr.mr_n48624288)
print v(xbgr.mr_n48624400)
print v(xbgr.mr_n48624720)
print v(xbgr.mr_n48624832)
print v(xbgr.mr_n48625152)
print v(xbgr.mr_n48625264)
print v(xbgr.mr_n48625584)
print v(xbgr.mr_n48625696)
print v(xbgr.mr_n48626016)
print v(xbgr.mr_n48626128)
print v(xbgr.mr_n48626448)
print v(xbgr.mr_n48626560)
print v(xbgr.mr_n48626880)
print v(xbgr.mr_n48626992)
print v(xbgr.mr_n48627312)
print v(xbgr.mr_n48627424)
print v(xbgr.mr_n48627744)
print v(xbgr.mr_n48627856)
print v(xbgr.mr_n48628176)
print v(xbgr.mr_n48628288)
print v(xbgr.mr_n48628608)
print v(xbgr.mr_n48628720)
print v(xbgr.mr_n48629040)
print v(xbgr.mr_n48629152)
print v(xbgr.mr_n48629472)
print v(xbgr.mr_n48629584)
print v(xbgr.mr_n48629904)
print v(xbgr.mr_n48630016)
print v(xbgr.mr_n48630336)
print v(xbgr.mr_n48630448)
print v(xbgr.mr_n48630768)
print v(xbgr.mr_n48630880)
print v(xbgr.mr_n48631200)
print v(xbgr.mr_n48631312)
print v(xbgr.mr_n48631632)
print v(xbgr.mr_n48631744)
print v(xbgr.mr_n48632064)
print v(xbgr.mr_n48632176)
print v(xbgr.mr_n48632496)
print v(xbgr.mr_n48632608)
print v(xbgr.mr_n48632928)
print v(xbgr.mr_n48633040)
print v(xbgr.mr_n48633360)
print v(xbgr.mr_n48633472)
print v(xbgr.mr_n48633792)
print v(xbgr.mr_n48633904)
print v(xbgr.mr_n48634224)
print v(xbgr.mr_n48634336)
print v(xbgr.mr_n48634656)
print v(xbgr.mr_n48634768)
print v(xbgr.mr_n48635088)
print v(xbgr.mr_n48635200)
print v(xbgr.mr_n48635520)
print v(xbgr.mr_n48635632)
print v(xbgr.mr_n48635952)
print v(xbgr.mr_n48636064)
print v(xbgr.mr_n48636384)
print v(xbgr.mr_n48636496)
print v(xbgr.mr_n48636816)
print v(xbgr.mr_n48636928)
print v(xbgr.mr_n48637248)
print v(xbgr.mr_n48637360)
print v(xbgr.mr_n48637680)
print v(xbgr.mr_n48637792)
print v(xbgr.mr_n48638112)
print v(xbgr.mr_n48638224)
print v(xbgr.mr_n48638544)
print v(xbgr.mr_n48638656)
print v(xbgr.mr_n48638976)
print v(xbgr.mr_n48639088)
print v(xbgr.mr_n48639408)
print v(xbgr.mr_n48639520)
print v(xbgr.mr_n48639840)
print v(xbgr.mr_n48639952)
print v(xbgr.mr_n48640272)
print v(xbgr.mr_n48640384)
print v(xbgr.mr_n48640704)
print v(xbgr.mr_n48640816)
print v(xbgr.mr_n48641136)
print v(xbgr.mr_n48641248)
print v(xbgr.mr_n48641568)
print v(xbgr.mr_n48641680)
print v(xbgr.mr_n48642000)
print v(xbgr.mr_n48642112)
print v(xbgr.mr_n48642432)
print v(xbgr.mr_n48642544)
print v(xbgr.mr_n48642864)
print v(xbgr.mr_n48642976)
print v(xbgr.mr_n48643296)
print v(xbgr.mr_n48643408)
print v(xbgr.mr_n48643728)
print v(xbgr.mr_n48643840)
print v(xbgr.mr_n48644160)
print v(xbgr.mr_n48644272)
print v(xbgr.mr_n48644592)
print v(xbgr.mr_n48644704)
print v(xbgr.mr_n48645024)
print v(xbgr.mr_n48645136)
print v(xbgr.mr_n48645456)
print v(xbgr.mr_n48645568)
print v(xbgr.mr_n48645888)
print v(xbgr.mr_n48646000)
print v(xbgr.mr_n48646320)
print v(xbgr.mr_n48646432)
print v(xbgr.mr_n48646752)
print v(xbgr.mr_n48646864)
print v(xbgr.mr_n48647184)
print v(xbgr.mr_n48647296)
print v(xbgr.mr_n48647616)
print v(xbgr.mr_n48647728)
print v(xbgr.mr_n48648048)
print v(xbgr.mr_n48648160)
print v(xbgr.mr_n48648480)
print v(xbgr.mr_n48648592)
print v(xbgr.mr_n48648912)
print v(xbgr.mr_n48649024)
print v(xbgr.mr_n48649344)
print v(xbgr.mr_n48649456)
print v(xbgr.mr_n48649776)
print v(xbgr.mr_n48649888)
print v(xbgr.mr_n48650208)
print v(xbgr.mr_n48650320)
print v(xbgr.mr_n48650640)
print v(xbgr.mr_n48650752)
print v(xbgr.mr_n48651072)
print v(xbgr.mr_n48651184)
print v(xbgr.mr_n48651504)
print v(xbgr.mr_n48651616)
print v(xbgr.mr_n48651936)
print v(xbgr.mr_n48652048)
print v(xbgr.mr_n48652368)
print v(xbgr.mr_n48652480)
print v(xbgr.mr_n48652800)
print v(xbgr.mr_n48652912)
print v(xbgr.mr_n48653232)
print v(xbgr.mr_n48653344)
print v(xbgr.mr_n48653664)
print v(xbgr.mr_n48653776)
print v(xbgr.mr_n48654096)
print v(xbgr.mr_n48654208)
print v(xbgr.mr_n48654528)
print v(xbgr.mr_n48654640)
print v(xbgr.mr_n48654960)
print v(xbgr.mr_n48655072)
print v(xbgr.mr_n48655392)
print v(xbgr.mr_n48655504)
print v(xbgr.mr_n48655824)
print v(xbgr.mr_n48655936)
print v(xbgr.mr_n48656256)
print v(xbgr.mr_n48656368)
print v(xbgr.mr_n48656688)
print v(xbgr.mr_n48656800)
print v(xbgr.mr_n48657120)
print v(xbgr.mr_n48657232)
print v(xbgr.mr_n48657552)
print v(xbgr.mr_n48657664)
print v(xbgr.mr_n48657984)
print v(xbgr.mr_n48658096)
print v(xbgr.mr_n48658416)
print v(xbgr.mr_n48658528)
print v(xbgr.mr_n48658848)
print v(xbgr.mr_n48658960)
print v(xbgr.mr_n48659280)
print v(xbgr.mr_n48659392)
print v(xbgr.mr_n48659712)
print v(xbgr.mr_n48659824)
print v(xbgr.mr_n48660144)
print v(xbgr.mr_n48660256)
print v(xbgr.mr_n48660576)
print v(xbgr.mr_n48660688)
print v(xbgr.mr_n48661008)
print v(xbgr.mr_n48661120)
print v(xbgr.mr_n48661440)
print v(xbgr.mr_n48661552)
print v(xbgr.mr_n48661872)
print v(xbgr.mr_n48661984)
print v(xbgr.mr_n48662304)
print v(xbgr.mr_n48662416)
print v(xbgr.mr_n48662736)
print v(xbgr.mr_n48662848)
print v(xbgr.mr_n48663168)
print v(xbgr.mr_n48663280)
print v(xbgr.mr_n48663600)
print v(xbgr.mr_n48663712)
print v(xbgr.mr_n48664032)
print v(xbgr.mr_n48664144)
print v(xbgr.mr_n48664464)
print v(xbgr.mr_n48664576)
print v(xbgr.mr_n48664896)
print v(xbgr.mr_n48665008)
print v(xbgr.mr_n48665328)
print v(xbgr.mr_n48665440)
print v(xbgr.mr_n48665760)
print v(xbgr.mr_n48665872)
print v(xbgr.mr_n48666192)
print v(xbgr.mr_n48666304)
print v(xbgr.mr_n48666624)
print v(xbgr.mr_n48666736)
print v(xbgr.mr_n48667056)
print v(xbgr.mr_n48667168)
print v(xbgr.mr_n48667488)
print v(xbgr.mr_n48667600)
print v(xbgr.mr_n48667920)
print v(xbgr.mr_n48668032)
print v(xbgr.mr_n48668352)
print v(xbgr.mr_n48668464)
print v(xbgr.mr_n48668784)
print v(xbgr.mr_n48668896)
print v(xbgr.mr_n48669216)
print v(xbgr.mr_n48669328)
print v(xbgr.mr_n48669648)
print v(xbgr.mr_n48669760)
print v(xbgr.mr_n48670080)
print v(xbgr.mr_n48670192)
print v(xbgr.mr_n48670512)
print v(xbgr.mr_n48670624)
print v(xbgr.mr_n48670944)
print v(xbgr.mr_n48671056)
print v(xbgr.mr_n48671376)
print v(xbgr.mr_n48671488)
print v(xbgr.mr_n48671808)
print v(xbgr.mr_n48671920)
print v(xbgr.mr_n48672240)
print v(xbgr.mr_n48672352)
print v(xbgr.mr_n48672672)
print v(xbgr.mr_n48672784)
print v(xbgr.mr_n48673104)
print v(xbgr.mr_n48673216)
print v(xbgr.mr_n48673536)
print v(xbgr.mr_n48673648)
print v(xbgr.mr_n48673968)
print v(xbgr.mr_n48674080)
print v(xbgr.mr_n48674400)
print v(xbgr.mr_n48674512)
print v(xbgr.mr_n48674832)
print v(xbgr.mr_n48674944)
print v(xbgr.mr_n48675264)
print v(xbgr.mr_n48675376)
print v(xbgr.mr_n48675696)
print v(xbgr.mr_n48675808)
print v(xbgr.mr_n48676128)
print v(xbgr.mr_n48676240)
print v(xbgr.mr_n48676560)
print v(xbgr.mr_n48676672)
print v(xbgr.mr_n48676992)
print v(xbgr.mr_n48677104)
print v(xbgr.mr_n48677424)
print v(xbgr.mr_n48677536)
print v(xbgr.mr_n48677856)
print v(xbgr.mr_n48677968)
print v(xbgr.mr_n48678288)
print v(xbgr.mr_n48678400)
print v(xbgr.mr_n48678720)
print v(xbgr.mr_n48678832)
print v(xbgr.mr_n48679152)
print v(xbgr.mr_n48679264)
print v(xbgr.mr_n48679584)
print v(xbgr.mr_n48679696)
print v(xbgr.mr_n48680016)
print v(xbgr.mr_n48680128)
print v(xbgr.mr_n48680448)
print v(xbgr.mr_n48680560)
print v(xbgr.mr_n48680880)
print v(xbgr.mr_n48680992)
print v(xbgr.mr_n48681312)
print v(xbgr.mr_n48681424)
print v(xbgr.mr_n48681744)
print v(xbgr.mr_n48681856)
print v(xbgr.mr_n48682176)
print v(xbgr.mr_n48682288)
print v(xbgr.mr_n48682608)
print v(xbgr.mr_n48682720)
print v(xbgr.mr_n48683040)
print v(xbgr.mr_n48683152)
print v(xbgr.mr_n48683472)
print v(xbgr.mr_n48683584)
print v(xbgr.mr_n48683904)
print v(xbgr.mr_n48684016)
print v(xbgr.mr_n48684336)
print v(xbgr.mr_n48684448)
print v(xbgr.mr_n48684768)
print v(xbgr.mr_n48684880)
print v(xbgr.mr_n48685200)
print v(xbgr.mr_n48685312)
print v(xbgr.mr_n48685632)
print v(xbgr.mr_n48685744)
print v(xbgr.mr_n48686064)
print v(xbgr.mr_n48686176)
print v(xbgr.mr_n48686496)
print v(xbgr.mr_n48686608)
print v(xbgr.mr_n48686928)
print v(xbgr.mr_n48687040)
print v(xbgr.mr_n48687360)
print v(xbgr.mr_n48687472)
print v(xbgr.mr_n48687792)
print v(xbgr.mr_n48687904)
print v(xbgr.mr_n48688224)
print v(xbgr.mr_n48688336)
print v(xbgr.mr_n48688656)
print v(xbgr.mr_n48688768)
print v(xbgr.mr_n48689088)
print v(xbgr.mr_n48689200)
print v(xbgr.mr_n48689520)
print v(xbgr.mr_n48689632)
print v(xbgr.mr_n48689952)
print v(xbgr.mr_n48690064)
print v(xbgr.mr_n48690384)
print v(xbgr.mr_n48690496)
print v(xbgr.mr_n48690816)
print v(xbgr.mr_n48690928)
print v(xbgr.mr_n48691248)
print v(xbgr.mr_n48691360)
print v(xbgr.mr_n48691680)
print v(xbgr.mr_n48691792)
print v(xbgr.mr_n48692112)
print v(xbgr.mr_n48692224)
print v(xbgr.mr_n48692544)
print v(xbgr.mr_n48692656)
print v(xbgr.mr_n48692976)
print v(xbgr.mr_n48693088)
print v(xbgr.mr_n48693408)
print v(xbgr.mr_n48693520)
print v(xbgr.mr_n48693840)
print v(xbgr.mr_n48693952)
print v(xbgr.mr_n48694272)
print v(xbgr.mr_n48694384)
print v(xbgr.mr_n48694704)
print v(xbgr.mr_n48694816)
print v(xbgr.mr_n48695136)
print v(xbgr.mr_n48695248)
print v(xbgr.mr_n48695568)
print v(xbgr.mr_n48695680)
print v(xbgr.mr_n48696000)
print v(xbgr.mr_n48696112)
print v(xbgr.mr_n48696432)
print v(xbgr.mr_n48696544)
print v(xbgr.mr_n48696864)
print v(xbgr.mr_n48696976)
print v(xbgr.mr_n48697296)
print v(xbgr.mr_n48697408)
print v(xbgr.mr_n48697728)
print v(xbgr.mr_n48697840)
print v(xbgr.mr_n48698160)
print v(xbgr.mr_n48698272)
print v(xbgr.mr_n48698592)
print v(xbgr.mr_n48698704)
print v(xbgr.mr_n48699024)
print v(xbgr.mr_n48699136)
print v(xbgr.mr_n48699456)
print v(xbgr.mr_n48699568)
print v(xbgr.mr_n48699888)
print v(xbgr.mr_n48700000)
print v(xbgr.mr_n48700320)
print v(xbgr.mr_n48700432)
print v(xbgr.mr_n48700752)
print v(xbgr.mr_n48700864)
print v(xbgr.mr_n48701184)
print v(xbgr.mr_n48701296)
print v(xbgr.mr_n48701616)
print v(xbgr.mr_n48701728)
print v(xbgr.mr_n48702048)
print v(xbgr.mr_n48702160)
print v(xbgr.mr_n48702480)
print v(xbgr.mr_n48702592)
print v(xbgr.mr_n48702912)
print v(xbgr.mr_n48703024)
print v(xbgr.mr_n48703344)
print v(xbgr.mr_n48703456)
print v(xbgr.mr_n48703776)
print v(xbgr.mr_n48703888)
print v(xbgr.mr_n48704208)
print v(xbgr.mr_n48704320)
print v(xbgr.mr_n48704640)
print v(xbgr.mr_n48704752)
print v(xbgr.mr_n48705072)
print v(xbgr.mr_n48705184)
print v(xbgr.mr_n48705504)
print v(xbgr.mr_n48705616)
print v(xbgr.mr_n48705936)
print v(xbgr.mr_n48706048)
print v(xbgr.mr_n48706368)
print v(xbgr.mr_n48706480)
print v(xbgr.mr_n48706800)
print v(xbgr.mr_n48706912)
print v(xbgr.mr_n48707232)
print v(xbgr.mr_n48707344)
print v(xbgr.mr_n48707664)
print v(xbgr.mr_n48707776)
print v(xbgr.mr_n48708096)
print v(xbgr.mr_n48708208)
print v(xbgr.mr_n48708528)
print v(xbgr.mr_n48708640)
print v(xbgr.mr_n48708960)
print v(xbgr.mr_n48709072)
print v(xbgr.mr_n48709392)
print v(xbgr.mr_n48709504)
print v(xbgr.mr_n48709824)
print v(xbgr.mr_n48709936)
print v(xbgr.mr_n48710256)
print v(xbgr.mr_n48710368)
print v(xbgr.mr_n48710688)
print v(xbgr.mr_n48710800)
print v(xbgr.mr_n48711120)
print v(xbgr.mr_n48711232)
print v(xbgr.mr_n48711552)
print v(xbgr.mr_n48711664)
print v(xbgr.mr_n48711984)
print v(xbgr.mr_n48712096)
print v(xbgr.mr_n48712416)
print v(xbgr.mr_n48712528)
print v(xbgr.mr_n48712848)
print v(xbgr.mr_n48712960)
print v(xbgr.mr_n48713280)
print v(xbgr.mr_n48713392)
print v(xbgr.mr_n48713712)
print v(xbgr.mr_n48713824)
print v(xbgr.mr_n48714144)
print v(xbgr.mr_n48714256)
print v(xbgr.mr_n48714576)
print v(xbgr.mr_n48714688)
print v(xbgr.mr_n48715008)
print v(xbgr.mr_n48715120)
print v(xbgr.mr_n48715440)
print v(xbgr.mr_n48715552)
print v(xbgr.mr_n48715872)
print v(xbgr.mr_n48715984)
print v(xbgr.mr_n48716304)
print v(xbgr.mr_n48716416)
print v(xbgr.mr_n48716736)
print v(xbgr.mr_n48716848)
print v(xbgr.mr_n48717168)
print v(xbgr.mr_n48717280)
print v(xbgr.mr_n48717600)
print v(xbgr.mr_n48717712)
print v(xbgr.mr_n48718032)
print v(xbgr.mr_n48718144)
print v(xbgr.mr_n48718464)
print v(xbgr.mr_n48718576)
print v(xbgr.mr_n48718896)
print v(xbgr.mr_n48719008)
print v(xbgr.mr_n48719328)
print v(xbgr.mr_n48719440)
print v(xbgr.mr_n48719760)
print v(xbgr.mr_n48719872)
print v(xbgr.mr_n48720192)
print v(xbgr.mr_n48720304)
print v(xbgr.mr_n48720624)
print v(xbgr.mr_n48720736)
print v(xbgr.mr_n48721056)
print v(xbgr.mr_n48721168)
print v(xbgr.mr_n48721488)
print v(xbgr.mr_n48721600)
print v(xbgr.mr_n48721920)
print v(xbgr.mr_n48722032)
print v(xbgr.mr_n48722352)
print v(xbgr.mr_n48722464)
print v(xbgr.mr_n48722784)
print v(xbgr.mr_n48722896)
print v(xbgr.mr_n48723216)
print v(xbgr.mr_n48723328)
print v(xbgr.mr_n48723648)
print v(xbgr.mr_n48723760)
print v(xbgr.mr_n48724080)
print v(xbgr.mr_n48724192)
print v(xbgr.mr_n48724512)
print v(xbgr.mr_n48724624)
print v(xbgr.mr_n48724944)
print v(xbgr.mr_n48725056)
print v(xbgr.mr_n48725376)
print v(xbgr.mr_n48725488)
print v(xbgr.mr_n48725808)
print v(xbgr.mr_n48725920)
print v(xbgr.mr_n48726240)
print v(xbgr.mr_n48726352)
print v(xbgr.mr_n48726672)
print v(xbgr.mr_n48726784)
print v(xbgr.mr_n48727104)
print v(xbgr.mr_n48727216)
print v(xbgr.mr_n48727536)
print v(xbgr.mr_n48727648)
print v(xbgr.mr_n48727968)
print v(xbgr.mr_n48728080)
print v(xbgr.mr_n48728400)
print v(xbgr.mr_n48728512)
print v(xbgr.mr_n48728832)
print v(xbgr.mr_n48728944)
print v(xbgr.mr_n48729264)
print v(xbgr.mr_n48729376)
print v(xbgr.mr_n48729696)
print v(xbgr.mr_n48729808)
print v(xbgr.mr_n48730128)
print v(xbgr.mr_n48730240)
print v(xbgr.mr_n48730560)
print v(xbgr.mr_n48730672)
print v(xbgr.mr_n48730992)
print v(xbgr.mr_n48731104)
print v(xbgr.mr_n48731424)
print v(xbgr.mr_n48731536)
print v(xbgr.mr_n48731856)
print v(xbgr.mr_n48731968)
print v(xbgr.mr_n48732288)
print v(xbgr.mr_n48732400)
print v(xbgr.mr_n48732720)
print v(xbgr.mr_n48732832)
print v(xbgr.mr_n48733152)
print v(xbgr.mr_n48733264)
print v(xbgr.mr_n48733584)
print v(xbgr.mr_n48733696)
print v(xbgr.mr_n48734016)
print v(xbgr.mr_n48734128)
print v(xbgr.mr_n48734448)
print v(xbgr.mr_n48734560)
print v(xbgr.mr_n48734880)
print v(xbgr.mr_n48734992)
print v(xbgr.mr_n48735312)
print v(xbgr.mr_n48735424)
print v(xbgr.mr_n48735744)
print v(xbgr.mr_n48735856)
print v(xbgr.mr_n48736176)
print v(xbgr.mr_n48736288)
print v(xbgr.mr_n48736608)
print v(xbgr.mr_n48736720)
print v(xbgr.mr_n48737040)
print v(xbgr.mr_n48737152)
print v(xbgr.mr_n48737472)
print v(xbgr.mr_n48737584)
print v(xbgr.mr_n48737904)
print v(xbgr.mr_n48738016)
print v(xbgr.mr_n48738336)
print v(xbgr.mr_n48738448)
print v(xbgr.mr_n48738768)
print v(xbgr.mr_n48738880)
print v(xbgr.mr_n48739200)
print v(xbgr.mr_n48739312)
print v(xbgr.mr_n48739632)
print v(xbgr.mr_n48739744)
print v(xbgr.mr_n48740064)
print v(xbgr.mr_n48740176)
print v(xbgr.mr_n48740496)
print v(xbgr.mr_n48740608)
print v(xbgr.mr_n48740928)
print v(xbgr.mr_n48741040)
print v(xbgr.mr_n48741360)
print v(xbgr.mr_n48741472)
print v(xbgr.mr_n48741792)
print v(xbgr.mr_n48741904)
print v(xbgr.mr_n48742224)
print v(xbgr.mr_n48742336)
print v(xbgr.mr_n48742656)
print v(xbgr.mr_n48742768)
print v(xbgr.mr_n48743088)
print v(xbgr.mr_n48743200)
print v(xbgr.mr_n48743520)
print v(xbgr.mr_n48743632)
print v(xbgr.mr_n48743952)
print v(xbgr.mr_n48744064)
print v(xbgr.mr_n48744384)
print v(xbgr.mr_n48744496)
print v(xbgr.mr_n48744816)
print v(xbgr.mr_n48744928)
print v(xbgr.mr_n48745248)
print v(xbgr.mr_n48745360)
print v(xbgr.mr_n48745680)
print v(xbgr.mr_n48745792)
print v(xbgr.mr_n48746112)
print v(xbgr.mr_n48746224)
print v(xbgr.mr_n48746544)
print v(xbgr.mr_n48746656)
print v(xbgr.mr_n48746976)
print v(xbgr.mr_n48747088)
print v(xbgr.mr_n48747408)
print v(xbgr.mr_n48747520)
print v(xbgr.mr_n48747840)
print v(xbgr.mr_n48747952)
print v(xbgr.mr_n48748272)
print v(xbgr.mr_n48748384)
print v(xbgr.mr_n48748704)
print v(xbgr.mr_n48748816)
print v(xbgr.mr_n48749136)
print v(xbgr.mr_n48749248)
print v(xbgr.mr_n48749568)
print v(xbgr.mr_n48749680)
print v(xbgr.mr_n48750000)
print v(xbgr.mr_n48750112)
print v(xbgr.mr_n48750432)
print v(xbgr.mr_n48750544)
print v(xbgr.mr_n48750864)
print v(xbgr.mr_n48750976)
print v(xbgr.mr_n48751296)
print v(xbgr.mr_n48751408)
print v(xbgr.mr_n48751728)
print v(xbgr.mr_n48751840)
print v(xbgr.mr_n48752160)
print v(xbgr.mr_n48752272)
print v(xbgr.mr_n48752592)
print v(xbgr.mr_n48752704)
print v(xbgr.mr_n48753024)
print v(xbgr.mr_n48753136)
print v(xbgr.mr_n48753456)
print v(xbgr.mr_n48753568)
print v(xbgr.mr_n48753888)
print v(xbgr.mr_n48754000)
print v(xbgr.mr_n48754320)
print v(xbgr.mr_n48754432)
print v(xbgr.mr_n48754752)
print v(xbgr.mr_n48754864)
print v(xbgr.mr_n48755184)
print v(xbgr.mr_n48755296)
print v(xbgr.mr_n48755616)
print v(xbgr.mr_n48755728)
print v(xbgr.mr_n48756048)
print v(xbgr.mr_n48756160)
print v(xbgr.mr_n48756480)
print v(xbgr.mr_n48756592)
print v(xbgr.mr_n48756912)
print v(xbgr.mr_n48757024)
print v(xbgr.mr_n48757344)
print v(xbgr.mr_n48757456)
print v(xbgr.mr_n48757776)
print v(xbgr.mr_n48757888)
print v(xbgr.mr_n48758208)
print v(xbgr.mr_n48758320)
print v(xbgr.mr_n48758640)
print v(xbgr.mr_n48758752)
print v(xbgr.mr_n48759072)
print v(xbgr.mr_n48759184)
print v(xbgr.mr_n48759504)
print v(xbgr.mr_n48759616)
print v(xbgr.mr_n48759936)
print v(xbgr.mr_n48760048)
print v(xbgr.mr_n48760368)
print v(xbgr.mr_n48760480)
print v(xbgr.mr_n48760800)
print v(xbgr.mr_n48760912)
print v(xbgr.mr_n48761232)
print v(xbgr.mr_n48761344)
print v(xbgr.mr_n48761664)
print v(xbgr.mr_n48761776)
print v(xbgr.mr_n48762096)
print v(xbgr.mr_n48762208)
print v(xbgr.mr_n48762528)
print v(xbgr.mr_n48762640)
print v(xbgr.mr_n48762960)
print v(xbgr.mr_n48763072)
print v(xbgr.mr_n48763392)
print v(xbgr.mr_n48763504)
print v(xbgr.mr_n48763824)
print v(xbgr.mr_n48763936)
print v(xbgr.mr_n48764256)
print v(xbgr.mr_n48764368)
print v(xbgr.mr_n48764688)
print v(xbgr.mr_n48764800)
print v(xbgr.mr_n48765120)
print v(xbgr.mr_n48765232)
print v(xbgr.mr_n48765552)
print v(xbgr.mr_n48765664)
print v(xbgr.mr_n48765984)
print v(xbgr.mr_n48766096)
print v(xbgr.mr_n48766416)
print v(xbgr.mr_n48766528)
print v(xbgr.mr_n48766848)
print v(xbgr.mr_n48766960)
print v(xbgr.mr_n48767280)
print v(xbgr.mr_n48767392)
print v(xbgr.mr_n48767712)
print v(xbgr.mr_n48767824)
print v(xbgr.mr_n48768144)
print v(xbgr.mr_n48768256)
print v(xbgr.mr_n48768576)
print v(xbgr.mr_n48768688)
print v(xbgr.mr_n48769008)
print v(xbgr.mr_n48769120)
print v(xbgr.mr_n48769440)
print v(xbgr.mr_n48769552)
print v(xbgr.mr_n48769872)
print v(xbgr.mr_n48769984)
print v(xbgr.mr_n48770304)
print v(xbgr.mr_n48770416)
print v(xbgr.mr_n48770736)
print v(xbgr.mr_n48770848)
print v(xbgr.mr_n48771168)
print v(xbgr.mr_n48771280)
print v(xbgr.mr_n48771600)
print v(xbgr.mr_n48771712)
print v(xbgr.mr_n48772032)
print v(xbgr.mr_n48772144)
print v(xbgr.mr_n48772464)
print v(xbgr.mr_n48772576)
print v(xbgr.mr_n48772896)
print v(xbgr.mr_n48773008)
print v(xbgr.mr_n48773328)
print v(xbgr.mr_n48773440)
print v(xbgr.mr_n48773760)
print v(xbgr.mr_n48773872)
print v(xbgr.mr_n48774192)
print v(xbgr.mr_n48774304)
print v(xbgr.mr_n48774624)
print v(xbgr.mr_n48774736)
print v(xbgr.mr_n48775056)
print v(xbgr.mr_n48775168)
print v(xbgr.mr_n48775488)
print v(xbgr.mr_n48775600)
print v(xbgr.mr_n48775920)
print v(xbgr.mr_n48776032)
print v(xbgr.mr_n48776352)
print v(xbgr.mr_n48776464)
print v(xbgr.mr_n48776784)
print v(xbgr.mr_n48776896)
print v(xbgr.mr_n48777216)
print v(xbgr.mr_n48777328)
print v(xbgr.mr_n48777648)
print v(xbgr.mr_n48777760)
print v(xbgr.mr_n48778080)
print v(xbgr.mr_n48778192)
print v(xbgr.mr_n48778512)
print v(xbgr.mr_n48778624)
print v(xbgr.mr_n48778944)
print v(xbgr.mr_n48779056)
print v(xbgr.mr_n48779376)
print v(xbgr.mr_n48779488)
print v(xbgr.mr_n48779808)
print v(xbgr.mr_n48779920)
print v(xbgr.mr_n48780240)
print v(xbgr.mr_n48780352)
print v(xbgr.mr_n48780672)
print v(xbgr.mr_n48780784)
print v(xbgr.mr_n48781104)
print v(xbgr.mr_n48781216)
print v(xbgr.mr_n48781536)
print v(xbgr.mr_n48781648)
print v(xbgr.mr_n48781968)
print v(xbgr.mr_n48782080)
print v(xbgr.mr_n48782400)
print v(xbgr.mr_n48782512)
print v(xbgr.mr_n48782832)
print v(xbgr.mr_n48782944)
print v(xbgr.mr_n48783264)
print v(xbgr.mr_n48783376)
print v(xbgr.mr_n48783696)
print v(xbgr.mr_n48783808)
print v(xbgr.mr_n48784128)
print v(xbgr.mr_n48784240)
print v(xbgr.mr_n48784560)
print v(xbgr.mr_n48784672)
print v(xbgr.mr_n48784992)
print v(xbgr.mr_n48785104)
print v(xbgr.mr_n48785424)
print v(xbgr.mr_n48785536)
print v(xbgr.mr_n48785856)
print v(xbgr.mr_n48785968)
print v(xbgr.mr_n48786288)
print v(xbgr.mr_n48786400)
print v(xbgr.mr_n48786720)
print v(xbgr.mr_n48786832)
print v(xbgr.mr_n48787152)
print v(xbgr.mr_n48787264)
print v(xbgr.mr_n48787584)
print v(xbgr.mr_n48787696)
print v(xbgr.mr_n48788016)
print v(xbgr.mr_n48788128)
print v(xbgr.mr_n48788560)
print v(xbgr.mr_n48788880)
print v(xbgr.mr_n48788992)
print v(xbgr.mr_n48789424)
print v(xbgr.mr_n48789744)
print v(xbgr.mr_n48789856)
print v(xbgr.mr_n48790288)
print v(xbgr.mr_n48790608)
print v(xbgr.mr_n48791472)
print v(xbgr.mr_n48792336)
print v(xbgr.mr_n48793200)
print v(xbgr.mr_n48794064)
print v(xbgr.mr_n48794928)
print v(xbgr.mr_n48795792)
print v(xbgr.mr_n48795904)
print v(xbgr.mr_n48796224)
print v(xbgr.mr_n48796336)
print v(xbgr.mr_n48796656)
print v(xbgr.mr_n48796768)
print v(xbgr.mr_n48797088)
print v(xbgr.mr_n48797200)
print v(xbgr.mr_n48797520)
print v(xbgr.mr_n48798384)
print v(xbgr.mr_n48799248)
print v(xbgr.mr_n48800112)
print v(xbgr.mr_n48800224)
print v(xbgr.mr_n48800544)
print v(xbgr.mr_n48800656)
print v(xbgr.mr_n48800976)
print v(xbgr.mr_n48801088)
print v(xbgr.mr_n48801520)
print v(xbgr.mr_n48801952)
print v(xbgr.mr_n48802384)
print v(xbgr.mr_n48802704)
print v(xbgr.mr_n48802816)
print v(xbgr.mr_n48803136)
print v(xbgr.mr_n48803248)
print v(xbgr.mr_n48803568)
print v(xbgr.mr_n48803680)
print v(xbgr.mr_n48804000)
print v(xbgr.mr_n48804112)
print v(xbgr.mr_n48804432)
print v(xbgr.mr_n48804544)
print v(xbgr.mr_n48804864)
print v(xbgr.mr_n48804976)
print v(xbgr.mr_n48805296)
print v(xbgr.mr_n48805408)
print v(xbgr.mr_n48805728)
print v(xbgr.mr_n48805840)
print v(xbgr.mr_n48806160)
print v(xbgr.mr_n48806272)
print v(xbgr.mr_n48806592)
print v(xbgr.mr_n48806704)
print v(xbgr.mr_n48807024)
print v(xbgr.mr_n48807136)
print v(xbgr.mr_n48807456)
print v(xbgr.mr_n48807568)
print v(xbgr.mr_n48807888)
print v(xbgr.mr_n48808000)
print v(xbgr.mr_n48808320)
print v(xbgr.mr_n48808432)
print v(xbgr.mr_n48808752)
print v(xbgr.mr_n48808864)
print v(xbgr.mr_n48809184)
print v(xbgr.mr_n48809296)
print v(xbgr.mr_n48809616)
print v(xbgr.mr_n48809728)
print v(xbgr.mr_n48810048)
print v(xbgr.mr_n48810160)
print v(xbgr.mr_n48810480)
print v(xbgr.mr_n48810592)
print v(xbgr.mr_n48810912)
print v(xbgr.mr_n48811024)
print v(xbgr.mr_n48811344)
print v(xbgr.mr_n48811456)
print v(xbgr.mr_n48811776)
print v(xbgr.mr_n48811888)
print v(xbgr.mr_n48812208)
print v(xbgr.mr_n48812320)
print v(xbgr.mr_n48812640)
print v(xbgr.mr_n48812752)
print v(xbgr.mr_n48813072)
print v(xbgr.mr_n48813184)
print v(xbgr.mr_n48813504)
print v(xbgr.mr_n48813616)
print v(xbgr.mr_n48813936)
print v(xbgr.mr_n48814048)
print v(xbgr.mr_n48814368)
print v(xbgr.mr_n48814480)
print v(xbgr.mr_n48814800)
print v(xbgr.mr_n48814912)
print v(xbgr.mr_n48815232)
print v(xbgr.mr_n48815344)
print v(xbgr.mr_n48815664)
print v(xbgr.mr_n48815776)
print v(xbgr.mr_n48816208)
print v(xbgr.mr_n48816528)
print v(xbgr.mr_n48816640)
print v(xbgr.mr_n48817072)
print v(xbgr.mr_n48817392)
print v(xbgr.mr_n48818256)
print v(xbgr.mr_n48819120)
print v(xbgr.mr_n48819984)
print v(xbgr.mr_n48820848)
print v(xbgr.mr_n48820960)
print v(xbgr.mr_n48821280)
print v(xbgr.mr_n48821392)
print v(xbgr.mr_n48821712)
print v(xbgr.mr_n48821824)
print v(xbgr.mr_n48822144)
print v(xbgr.mr_n48822256)
print v(xbgr.mr_n48822576)
print v(xbgr.mr_n48823440)
print v(xbgr.mr_n48824304)
print v(xbgr.mr_n48824416)
print v(xbgr.mr_n48824736)
print v(xbgr.mr_n48824848)
print v(xbgr.mr_n48825168)
print v(xbgr.mr_n48825280)
print v(xbgr.mr_n48825600)
print v(xbgr.mr_n48825712)
print v(xbgr.mr_n48826032)
print v(xbgr.mr_n48826144)
print v(xbgr.mr_n48826576)
print v(xbgr.mr_n48826896)
print v(xbgr.mr_n48827008)
print v(xbgr.mr_n48827440)
print v(xbgr.mr_n48827760)
print v(xbgr.mr_n48828624)
print v(xbgr.mr_n48829488)
print v(xbgr.mr_n48830352)
print v(xbgr.mr_n48831216)
print v(xbgr.mr_n48831328)
print v(xbgr.mr_n48831648)
print v(xbgr.mr_n48831760)
print v(xbgr.mr_n48832080)
print v(xbgr.mr_n48832192)
print v(xbgr.mr_n48832512)
print v(xbgr.mr_n48832624)
print v(xbgr.mr_n48832944)
print v(xbgr.mr_n48833808)
print v(xbgr.mr_n48834672)
print v(xbgr.mr_n48834784)
print v(xbgr.mr_n48835216)
print v(xbgr.mr_n48835536)
print v(xbgr.mr_n48835648)
print v(xbgr.mr_n48835968)
print v(xbgr.mr_n48836080)
print v(xbgr.mr_n48836400)
print v(xbgr.mr_n48836512)
print v(xbgr.mr_n48836832)
print v(xbgr.mr_n48836944)
print v(xbgr.mr_n48837264)
print v(xbgr.mr_n48837376)
print v(xbgr.mr_n48837808)
print v(xbgr.mr_n48838128)
print v(xbgr.mr_n48838992)
print v(xbgr.mr_n48839104)
print v(xbgr.mr_n48839536)
print v(xbgr.mr_n48839856)
print v(xbgr.mr_n48839968)
print v(xbgr.mr_n48840400)
print v(xbgr.mr_n48840720)
print v(xbgr.mr_n48840832)
print v(xbgr.mr_n48841152)
print v(xbgr.mr_n48841264)
print v(xbgr.mr_n48841584)
print v(xbgr.mr_n48841696)
print v(xbgr.mr_n48842016)
print v(xbgr.mr_n48842128)
print v(xbgr.mr_n48842448)
print v(xbgr.mr_n48843312)
print v(xbgr.mr_n48844176)
print v(xbgr.mr_n48844288)
print v(xbgr.mr_n48844608)
print v(xbgr.mr_n48844720)
print v(xbgr.mr_n48845040)
print v(xbgr.mr_n48845152)
print v(xbgr.mr_n48845472)
print v(xbgr.mr_n48845584)
print v(xbgr.mr_n48845904)
print v(xbgr.mr_n48846768)
print v(xbgr.mr_n48847632)
print v(xbgr.mr_n48847744)
print v(xbgr.mr_n48848064)
print v(xbgr.mr_n48848176)
print v(xbgr.mr_n48848496)
print v(xbgr.mr_n48849360)
print v(xbgr.mr_n48849472)
print v(xbgr.mr_n48849792)
print v(xbgr.mr_n48849904)
print v(xbgr.mr_n48850224)
print v(xbgr.mr_n48850336)
print v(xbgr.mr_n48850656)
print v(xbgr.mr_n48850768)
print v(xbgr.mr_n48851088)
print v(xbgr.mr_n48851200)
print v(xbgr.mr_n48851520)
print v(xbgr.mr_n48851632)
print v(xbgr.mr_n48851952)
print v(xbgr.mr_n48852816)
print v(xbgr.mr_n48853616)
print v(xbgr.mr_n48853728)
print v(xbgr.mr_n48854048)
print v(xbgr.mr_n48854160)
print v(xbgr.mr_n48854480)
print v(xbgr.mr_n48854592)
print v(xbgr.mr_n48854912)
print v(xbgr.mr_n48855024)
print v(xbgr.mr_n48855344)
print v(xbgr.mr_n48855456)
print v(xbgr.mr_n48855776)
print v(xbgr.mr_n48855888)
print v(xbgr.mr_n48856208)
print v(xbgr.mr_n48856320)
print v(xbgr.mr_n48856640)
print v(xbgr.mr_n48856752)
print v(xbgr.mr_n48857072)
print v(xbgr.mr_n48857184)
print v(xbgr.mr_n48857504)
print v(xbgr.mr_n48857616)
print v(xbgr.mr_n48857936)
print v(xbgr.mr_n48858048)
print v(xbgr.mr_n48858368)
print v(xbgr.mr_n48858480)
print v(xbgr.mr_n48858800)
print v(xbgr.mr_n48858912)
print v(xbgr.mr_n48859232)
print v(xbgr.mr_n48859344)
print v(xbgr.mr_n48859664)
print v(xbgr.mr_n48859776)
print v(xbgr.mr_n48860096)
print v(xbgr.mr_n48860208)
print v(xbgr.mr_n48860528)
print v(xbgr.mr_n48860640)
print v(xbgr.mr_n48860960)
print v(xbgr.mr_n48861072)
print v(xbgr.mr_n48861392)
print v(xbgr.mr_n48861504)
print v(xbgr.mr_n48861824)
print v(xbgr.mr_n48861936)
print v(xbgr.mr_n48862256)
print v(xbgr.mr_n48862368)
print v(xbgr.mr_n48862688)
print v(xbgr.mr_n48862800)
print v(xbgr.mr_n48863120)
print v(xbgr.mr_n48863232)
print v(xbgr.mr_n48863552)
print v(xbgr.mr_n48863664)
print v(xbgr.mr_n48863984)
print v(xbgr.mr_n48864096)
print v(xbgr.mr_n48864416)
print v(xbgr.mr_n48864528)
print v(xbgr.mr_n48864848)
print v(xbgr.mr_n48864960)
print v(xbgr.mr_n48865280)
print v(xbgr.mr_n48865392)
print v(xbgr.mr_n48865712)
print v(xbgr.mr_n48865824)
print v(xbgr.mr_n48866144)
print v(xbgr.mr_n48866256)
print v(xbgr.mr_n48866576)
print v(xbgr.mr_n48866688)
print v(xbgr.mr_n48867008)
print v(xbgr.mr_n48867120)
print v(xbgr.mr_n48867440)
print v(xbgr.mr_n48867552)
print v(xbgr.mr_n48867872)
print v(xbgr.mr_n48867984)
print v(xbgr.mr_n48868304)
print v(xbgr.mr_n48868416)
print v(xbgr.mr_n48868736)
print v(xbgr.mr_n48868848)
print v(xbgr.mr_n48869168)
print v(xbgr.mr_n48869280)
print v(xbgr.mr_n48869600)
print v(xbgr.mr_n48869712)
print v(xbgr.mr_n48870032)
print v(xbgr.mr_n48870144)
print v(xbgr.mr_n48870464)
print v(xbgr.mr_n48870576)
print v(xbgr.mr_n48870896)
print v(xbgr.mr_n48871008)
print v(xbgr.mr_n48871328)
print v(xbgr.mr_n48871440)
print v(xbgr.mr_n48871760)
print v(xbgr.mr_n48871872)
print v(xbgr.mr_n48872192)
print v(xbgr.mr_n48872304)
print v(xbgr.mr_n48872624)
print v(xbgr.mr_n48872736)
print v(xbgr.mr_n48873056)
print v(xbgr.mr_n48873168)
print v(xbgr.mr_n48873488)
print v(xbgr.mr_n48873600)
print v(xbgr.mr_n48873920)
print v(xbgr.mr_n48874032)
print v(xbgr.mr_n48874352)
print v(xbgr.mr_n48874464)
print v(xbgr.mr_n48874784)
print v(xbgr.mr_n48874896)
print v(xbgr.mr_n48875216)
print v(xbgr.mr_n48875328)
print v(xbgr.mr_n48875648)
print v(xbgr.mr_n48875760)
print v(xbgr.mr_n48876080)
print v(xbgr.mr_n48876192)
print v(xbgr.mr_n48876512)
print v(xbgr.mr_n48876624)
print v(xbgr.mr_n48876944)
print v(xbgr.mr_n48877056)
print v(xbgr.mr_n48877376)
print v(xbgr.mr_n48877488)
print v(xbgr.mr_n48877808)
print v(xbgr.mr_n48877920)
print v(xbgr.mr_n48878240)
print v(xbgr.mr_n48878352)
print v(xbgr.mr_n48878672)
print v(xbgr.mr_n48878784)
print v(xbgr.mr_n48879104)
print v(xbgr.mr_n48879216)
print v(xbgr.mr_n48879536)
print v(xbgr.mr_n48879648)
print v(xbgr.mr_n48879968)
print v(xbgr.mr_n48880080)
print v(xbgr.mr_n48880400)
print v(xbgr.mr_n48880512)
print v(xbgr.mr_n48880832)
print v(xbgr.mr_n48880944)
print v(xbgr.mr_n48881264)
print v(xbgr.mr_n48881376)
print v(xbgr.mr_n48881696)
print v(xbgr.mr_n48881808)
print v(xbgr.mr_n48882128)
print v(xbgr.mr_n48882240)
print v(xbgr.mr_n48882560)
print v(xbgr.mr_n48882672)
print v(xbgr.mr_n48882992)
print v(xbgr.mr_n48883104)
print v(xbgr.mr_n48883424)
print v(xbgr.mr_n48883536)
print v(xbgr.mr_n48883856)
print v(xbgr.mr_n48883968)
print v(xbgr.mr_n48884288)
print v(xbgr.mr_n48884400)
print v(xbgr.mr_n48884720)
print v(xbgr.mr_n48884832)
print v(xbgr.mr_n48885152)
print v(xbgr.mr_n48885264)
print v(xbgr.mr_n48885584)
print v(xbgr.mr_n48885696)
print v(xbgr.mr_n48886016)
print v(xbgr.mr_n48886128)
print v(xbgr.mr_n48886448)
print v(xbgr.mr_n48886560)
print v(xbgr.mr_n48886880)
print v(xbgr.mr_n48886992)
print v(xbgr.mr_n48887312)
print v(xbgr.mr_n48887424)
print v(xbgr.mr_n48887744)
print v(xbgr.mr_n48887856)
print v(xbgr.mr_n48888176)
print v(xbgr.mr_n48888288)
print v(xbgr.mr_n48888608)
print v(xbgr.mr_n48888720)
print v(xbgr.mr_n48889040)
print v(xbgr.mr_n48889152)
print v(xbgr.mr_n48889472)
print v(xbgr.mr_n48889584)
print v(xbgr.mr_n48889904)
print v(xbgr.mr_n48890016)
print v(xbgr.mr_n48890336)
print v(xbgr.mr_n48890448)
print v(xbgr.mr_n48890768)
print v(xbgr.mr_n48890880)
print v(xbgr.mr_n48891200)
print v(xbgr.mr_n48891312)
print v(xbgr.mr_n48891632)
print v(xbgr.mr_n48891744)
print v(xbgr.mr_n48892064)
print v(xbgr.mr_n48892176)
print v(xbgr.mr_n48892496)
print v(xbgr.mr_n48892608)
print v(xbgr.mr_n48892928)
print v(xbgr.mr_n48893040)
print v(xbgr.mr_n48893360)
print v(xbgr.mr_n48893472)
print v(xbgr.mr_n48893792)
print v(xbgr.mr_n48893904)
print v(xbgr.mr_n48894224)
print v(xbgr.mr_n48894336)
print v(xbgr.mr_n48894656)
print v(xbgr.mr_n48894768)
print v(xbgr.mr_n48895088)
print v(xbgr.mr_n48895200)
print v(xbgr.mr_n48895520)
print v(xbgr.mr_n48895632)
print v(xbgr.mr_n48895952)
print v(xbgr.mr_n48896064)
print v(xbgr.mr_n48896384)
print v(xbgr.mr_n48896496)
print v(xbgr.mr_n48896816)
print v(xbgr.mr_n48896928)
print v(xbgr.mr_n48897248)
print v(xbgr.mr_n48897360)
print v(xbgr.mr_n48897680)
print v(xbgr.mr_n48897792)
print v(xbgr.mr_n48898112)
print v(xbgr.mr_n48898224)
print v(xbgr.mr_n48898544)
print v(xbgr.mr_n48898656)
print v(xbgr.mr_n48898976)
print v(xbgr.mr_n48899088)
print v(xbgr.mr_n48899408)
print v(xbgr.mr_n48899520)
print v(xbgr.mr_n48899840)
print v(xbgr.mr_n48899952)
print v(xbgr.mr_n48900272)
print v(xbgr.mr_n48900384)
print v(xbgr.mr_n48900704)
print v(xbgr.mr_n48900816)
print v(xbgr.mr_n48901136)
print v(xbgr.mr_n48901248)
print v(xbgr.mr_n48901568)
print v(xbgr.mr_n48901680)
print v(xbgr.mr_n48902000)
print v(xbgr.mr_n48902112)
print v(xbgr.mr_n48902432)
print v(xbgr.mr_n48902544)
print v(xbgr.mr_n48902864)
print v(xbgr.mr_n48902976)
print v(xbgr.mr_n48903296)
print v(xbgr.mr_n48903408)
print v(xbgr.mr_n48903728)
print v(xbgr.mr_n48903840)
print v(xbgr.mr_n48904160)
print v(xbgr.mr_n48904272)
print v(xbgr.mr_n48904592)
print v(xbgr.mr_n48904704)
print v(xbgr.mr_n48905024)
print v(xbgr.mr_n48905136)
print v(xbgr.mr_n48905456)
print v(xbgr.mr_n48905568)
print v(xbgr.mr_n48905888)
print v(xbgr.mr_n48906000)
print v(xbgr.mr_n48906320)
print v(xbgr.mr_n48906432)
print v(xbgr.mr_n48906752)
print v(xbgr.mr_n48906864)
print v(xbgr.mr_n48907184)
print v(xbgr.mr_n48907296)
print v(xbgr.mr_n48907616)
print v(xbgr.mr_n48907728)
print v(xbgr.mr_n48908048)
print v(xbgr.mr_n48908160)
print v(xbgr.mr_n48908480)
print v(xbgr.mr_n48908592)
print v(xbgr.mr_n48908912)
print v(xbgr.mr_n48909024)
print v(xbgr.mr_n48909344)
print v(xbgr.mr_n48909456)
print v(xbgr.mr_n48909776)
print v(xbgr.mr_n48909888)
print v(xbgr.mr_n48910208)
print v(xbgr.mr_n48910320)
print v(xbgr.mr_n48910640)
print v(xbgr.mr_n48910752)
print v(xbgr.mr_n48911072)
print v(xbgr.mr_n48911184)
print v(xbgr.mr_n48911504)
print v(xbgr.mr_n48911616)
print v(xbgr.mr_n48911936)
print v(xbgr.mr_n48912048)
print v(xbgr.mr_n48912368)
print v(xbgr.mr_n48912480)
print v(xbgr.mr_n48912800)
print v(xbgr.mr_n48912912)
print v(xbgr.mr_n48913232)
print v(xbgr.mr_n48913344)
print v(xbgr.mr_n48913664)
print v(xbgr.mr_n48913776)
print v(xbgr.mr_n48914096)
print v(xbgr.mr_n48914208)
print v(xbgr.mr_n48914528)
print v(xbgr.mr_n48914640)
print v(xbgr.mr_n48914960)
print v(xbgr.mr_n48915072)
print v(xbgr.mr_n48915392)
print v(xbgr.mr_n48915504)
print v(xbgr.mr_n48915824)
print v(xbgr.mr_n48915936)
print v(xbgr.mr_n48916256)
print v(xbgr.mr_n48916368)
print v(xbgr.mr_n48916688)
print v(xbgr.mr_n48916800)
print v(xbgr.mr_n48917120)
print v(xbgr.mr_n48917232)
print v(xbgr.mr_n48917552)
print v(xbgr.mr_n48917664)
print v(xbgr.mr_n48917984)
print v(xbgr.mr_n48918096)
print v(xbgr.mr_n48918416)
print v(xbgr.mr_n48918528)
print v(xbgr.mr_n48918848)
print v(xbgr.mr_n48918960)
print v(xbgr.mr_n48919280)
print v(xbgr.mr_n48919392)
print v(xbgr.mr_n48919712)
print v(xbgr.mr_n48919824)
print v(xbgr.mr_n48920144)
print v(xbgr.mr_n48920256)
print v(xbgr.mr_n48920576)
print v(xbgr.mr_n48920688)
print v(xbgr.mr_n48921008)
print v(xbgr.mr_n48921120)
print v(xbgr.mr_n48921440)
print v(xbgr.mr_n48921552)
print v(xbgr.mr_n48921872)
print v(xbgr.mr_n48921984)
print v(xbgr.mr_n48922304)
print v(xbgr.mr_n48922416)
print v(xbgr.mr_n48922736)
print v(xbgr.mr_n48922848)
print v(xbgr.mr_n48923168)
print v(xbgr.mr_n48923280)
print v(xbgr.mr_n48923600)
print v(xbgr.mr_n48923712)
print v(xbgr.mr_n48924032)
print v(xbgr.mr_n48924144)
print v(xbgr.mr_n48924464)
print v(xbgr.mr_n48924576)
print v(xbgr.mr_n48924896)
print v(xbgr.mr_n48925008)
print v(xbgr.mr_n48925328)
print v(xbgr.mr_n48925440)
print v(xbgr.mr_n48925760)
print v(xbgr.mr_n48925872)
print v(xbgr.mr_n48926192)
print v(xbgr.mr_n48926304)
print v(xbgr.mr_n48926624)
print v(xbgr.mr_n48926736)
print v(xbgr.mr_n48927056)
print v(xbgr.mr_n48927168)
print v(xbgr.mr_n48927488)
print v(xbgr.mr_n48927600)
print v(xbgr.mr_n48927920)
print v(xbgr.mr_n48928032)
print v(xbgr.mr_n48928352)
print v(xbgr.mr_n48928464)
print v(xbgr.mr_n48928784)
print v(xbgr.mr_n48928896)
print v(xbgr.mr_n48929216)
print v(xbgr.mr_n48929328)
print v(xbgr.mr_n48929648)
print v(xbgr.mr_n48929760)
print v(xbgr.mr_n48930080)
print v(xbgr.mr_n48930192)
print v(xbgr.mr_n48930512)
print v(xbgr.mr_n48930624)
print v(xbgr.mr_n48930944)
print v(xbgr.mr_n48931056)
print v(xbgr.mr_n48931376)
print v(xbgr.mr_n48931488)
print v(xbgr.mr_n48931808)
print v(xbgr.mr_n48931920)
print v(xbgr.mr_n48932240)
print v(xbgr.mr_n48932352)
print v(xbgr.mr_n48932672)
print v(xbgr.mr_n48932784)
print v(xbgr.mr_n48933104)
print v(xbgr.mr_n48933216)
print v(xbgr.mr_n48933536)
print v(xbgr.mr_n48933648)
print v(xbgr.mr_n48933968)
print v(xbgr.mr_n48934080)
print v(xbgr.mr_n48934400)
print v(xbgr.mr_n48934512)
print v(xbgr.mr_n48934832)
print v(xbgr.mr_n48934944)
print v(xbgr.mr_n48935264)
print v(xbgr.mr_n48935376)
print v(xbgr.mr_n48935696)
print v(xbgr.mr_n48935808)
print v(xbgr.mr_n48936128)
print v(xbgr.mr_n48936240)
print v(xbgr.mr_n48936560)
print v(xbgr.mr_n48936672)
print v(xbgr.mr_n48936992)
print v(xbgr.mr_n48937104)
print v(xbgr.mr_n48937424)
print v(xbgr.mr_n48937536)
print v(xbgr.mr_n48937856)
print v(xbgr.mr_n48937968)
print v(xbgr.mr_n48938288)
print v(xbgr.mr_n48938400)
print v(xbgr.mr_n48938720)
print v(xbgr.mr_n48938832)
print v(xbgr.mr_n48939152)
print v(xbgr.mr_n48939264)
print v(xbgr.mr_n48939584)
print v(xbgr.mr_n48939696)
print v(xbgr.mr_n48940016)
print v(xbgr.mr_n48940128)
print v(xbgr.mr_n48940448)
print v(xbgr.mr_n48940560)
print v(xbgr.mr_n48940880)
print v(xbgr.mr_n48940992)
print v(xbgr.mr_n48941312)
print v(xbgr.mr_n48941424)
print v(xbgr.mr_n48941744)
print v(xbgr.mr_n48941856)
print v(xbgr.mr_n48942176)
print v(xbgr.mr_n48942288)
print v(xbgr.mr_n48942608)
print v(xbgr.mr_n48942720)
print v(xbgr.mr_n48943040)
print v(xbgr.mr_n48943152)
print v(xbgr.mr_n48943472)
print v(xbgr.mr_n48943584)
print v(xbgr.mr_n48943904)
print v(xbgr.mr_n48944016)
print v(xbgr.mr_n48944336)
print v(xbgr.mr_n48944448)
print v(xbgr.mr_n48944768)
print v(xbgr.mr_n48944880)
print v(xbgr.mr_n48945200)
print v(xbgr.mr_n48945312)
print v(xbgr.mr_n48945632)
print v(xbgr.mr_n48945744)
print v(xbgr.mr_n48946064)
print v(xbgr.mr_n48946176)
print v(xbgr.mr_n48946496)
print v(xbgr.mr_n48946608)
print v(xbgr.mr_n48946928)
print v(xbgr.mr_n48947040)
print v(xbgr.mr_n48947360)
print v(xbgr.mr_n48947472)
print v(xbgr.mr_n48947792)
print v(xbgr.mr_n48947904)
print v(xbgr.mr_n48948224)
print v(xbgr.mr_n48948336)
print v(xbgr.mr_n48948656)
print v(xbgr.mr_n48948768)
print v(xbgr.mr_n48949088)
print v(xbgr.mr_n48949200)
print v(xbgr.mr_n48949520)
print v(xbgr.mr_n48949632)
print v(xbgr.mr_n48949952)
print v(xbgr.mr_n48950064)
print v(xbgr.mr_n48950384)
print v(xbgr.mr_n48950496)
print v(xbgr.mr_n48950816)
print v(xbgr.mr_n48950928)
print v(xbgr.mr_n48951248)
print v(xbgr.mr_n48951360)
print v(xbgr.mr_n48951680)
print v(xbgr.mr_n48951792)
print v(xbgr.mr_n48952112)
print v(xbgr.mr_n48952224)
print v(xbgr.mr_n48952544)
print v(xbgr.mr_n48952656)
print v(xbgr.mr_n48952976)
print v(xbgr.mr_n48953088)
print v(xbgr.mr_n48953408)
print v(xbgr.mr_n48953520)
print v(xbgr.mr_n48953840)
print v(xbgr.mr_n48953952)
print v(xbgr.mr_n48954272)
print v(xbgr.mr_n48954384)
print v(xbgr.mr_n48954704)
print v(xbgr.mr_n48954816)
print v(xbgr.mr_n48955136)
print v(xbgr.mr_n48955248)
print v(xbgr.mr_n48955568)
print v(xbgr.mr_n48955680)
print v(xbgr.mr_n48956000)
print v(xbgr.mr_n48956112)
print v(xbgr.mr_n48956432)
print v(xbgr.mr_n48956544)
print v(xbgr.mr_n48956864)
print v(xbgr.mr_n48956976)
print v(xbgr.mr_n48957296)
print v(xbgr.mr_n48957408)
print v(xbgr.mr_n48957728)
print v(xbgr.mr_n48957840)
print v(xbgr.mr_n48958160)
print v(xbgr.mr_n48958272)
print v(xbgr.mr_n48958592)
print v(xbgr.mr_n48958704)
print v(xbgr.mr_n48959024)
print v(xbgr.mr_n48959136)
print v(xbgr.mr_n48959456)
print v(xbgr.mr_n48959568)
print v(xbgr.mr_n48959888)
print v(xbgr.mr_n48960000)
print v(xbgr.mr_n48960320)
print v(xbgr.mr_n48960432)
print v(xbgr.mr_n48960752)
print v(xbgr.mr_n48960864)
print v(xbgr.mr_n48961184)
print v(xbgr.mr_n48961296)
print v(xbgr.mr_n48961616)
print v(xbgr.mr_n48961728)
print v(xbgr.mr_n48962048)
print v(xbgr.mr_n48962160)
print v(xbgr.mr_n48962480)
print v(xbgr.mr_n48962592)
print v(xbgr.mr_n48962912)
print v(xbgr.mr_n48963024)
print v(xbgr.mr_n48963344)
print v(xbgr.mr_n48963456)
print v(xbgr.mr_n48963776)
print v(xbgr.mr_n48963888)
print v(xbgr.mr_n48964208)
print v(xbgr.mr_n48964320)
print v(xbgr.mr_n48964640)
print v(xbgr.mr_n48964752)
print v(xbgr.mr_n48965072)
print v(xbgr.mr_n48965184)
print v(xbgr.mr_n48965504)
print v(xbgr.mr_n48965616)
print v(xbgr.mr_n48965936)
print v(xbgr.mr_n48966048)
print v(xbgr.mr_n48966368)
print v(xbgr.mr_n48966480)
print v(xbgr.mr_n48966800)
print v(xbgr.mr_n48966912)
print v(xbgr.mr_n48967232)
print v(xbgr.mr_n48967344)
print v(xbgr.mr_n48967664)
print v(xbgr.mr_n48967776)
print v(xbgr.mr_n48968096)
print v(xbgr.mr_n48968208)
print v(xbgr.mr_n48968528)
print v(xbgr.mr_n48968640)
print v(xbgr.mr_n48968960)
print v(xbgr.mr_n48969072)
print v(xbgr.mr_n48969392)
print v(xbgr.mr_n48969504)
print v(xbgr.mr_n48969824)
print v(xbgr.mr_n48969936)
print v(xbgr.mr_n48970256)
print v(xbgr.mr_n48970368)
print v(xbgr.mr_n48970688)
print v(xbgr.mr_n48970800)
print v(xbgr.mr_n48971120)
print v(xbgr.mr_n48971232)
print v(xbgr.mr_n48971552)
print v(xbgr.mr_n48971664)
print v(xbgr.mr_n48971984)
print v(xbgr.mr_n48972096)
print v(xbgr.mr_n48972416)
print v(xbgr.mr_n48972528)
print v(xbgr.mr_n48972848)
print v(xbgr.mr_n48972960)
print v(xbgr.mr_n48973280)
print v(xbgr.mr_n48973392)
print v(xbgr.mr_n48973712)
print v(xbgr.mr_n48973824)
print v(xbgr.mr_n48974144)
print v(xbgr.mr_n48974256)
print v(xbgr.mr_n48974576)
print v(xbgr.mr_n48974688)
print v(xbgr.mr_n48975008)
print v(xbgr.mr_n48975120)
print v(xbgr.mr_n48975440)
print v(xbgr.mr_n48975552)
print v(xbgr.mr_n48975872)
print v(xbgr.mr_n48975984)
print v(xbgr.mr_n48976304)
print v(xbgr.mr_n48976416)
print v(xbgr.mr_n48976736)
print v(xbgr.mr_n48976848)
print v(xbgr.mr_n48977168)
print v(xbgr.mr_n48977280)
print v(xbgr.mr_n48977600)
print v(xbgr.mr_n48977712)
print v(xbgr.mr_n48978032)
print v(xbgr.mr_n48978144)
print v(xbgr.mr_n48978464)
print v(xbgr.mr_n48978576)
print v(xbgr.mr_n48978896)
print v(xbgr.mr_n48979008)
print v(xbgr.mr_n48979328)
print v(xbgr.mr_n48979440)
print v(xbgr.mr_n48979760)
print v(xbgr.mr_n48979872)
print v(xbgr.mr_n48980192)
print v(xbgr.mr_n48980304)
print v(xbgr.mr_n48980624)
print v(xbgr.mr_n48980736)
print v(xbgr.mr_n48981056)
print v(xbgr.mr_n48981168)
print v(xbgr.mr_n48981488)
print v(xbgr.mr_n48981600)
print v(xbgr.mr_n48981920)
print v(xbgr.mr_n48982032)
print v(xbgr.mr_n48982352)
print v(xbgr.mr_n48982464)
print v(xbgr.mr_n48982784)
print v(xbgr.mr_n48982896)
print v(xbgr.mr_n48983216)
print v(xbgr.mr_n48983328)
print v(xbgr.mr_n48983648)
print v(xbgr.mr_n48983760)
print v(xbgr.mr_n48984080)
print v(xbgr.mr_n48984192)
print v(xbgr.mr_n48984512)
print v(xbgr.mr_n48984624)
print v(xbgr.mr_n48984944)
print v(xbgr.mr_n48985056)
print v(xbgr.mr_n48985376)
print v(xbgr.mr_n48985488)
print v(xbgr.mr_n48985808)
print v(xbgr.mr_n48985920)
print v(xbgr.mr_n48986240)
print v(xbgr.mr_n48986352)
print v(xbgr.mr_n48986672)
print v(xbgr.mr_n48986784)
print v(xbgr.mr_n48987104)
print v(xbgr.mr_n48987216)
print v(xbgr.mr_n48987536)
print v(xbgr.mr_n48987648)
print v(xbgr.mr_n48987968)
print v(xbgr.mr_n48988080)
print v(xbgr.mr_n48988400)
print v(xbgr.mr_n48988512)
print v(xbgr.mr_n48988832)
print v(xbgr.mr_n48988944)
print v(xbgr.mr_n48989264)
print v(xbgr.mr_n48989376)
print v(xbgr.mr_n48989696)
print v(xbgr.mr_n48989808)
print v(xbgr.mr_n48990128)
print v(xbgr.mr_n48990240)
print v(xbgr.mr_n48990560)
print v(xbgr.mr_n48990672)
print v(xbgr.mr_n48990992)
print v(xbgr.mr_n48991104)
print v(xbgr.mr_n48991424)
print v(xbgr.mr_n48991536)
print v(xbgr.mr_n48991856)
print v(xbgr.mr_n48991968)
print v(xbgr.mr_n48992288)
print v(xbgr.mr_n48992400)
print v(xbgr.mr_n48992720)
print v(xbgr.mr_n48992832)
print v(xbgr.mr_n48993152)
print v(xbgr.mr_n48993264)
print v(xbgr.mr_n48993584)
print v(xbgr.mr_n48993696)
print v(xbgr.mr_n48994016)
print v(xbgr.mr_n48994128)
print v(xbgr.mr_n48994448)
print v(xbgr.mr_n48994560)
print v(xbgr.mr_n48994880)
print v(xbgr.mr_n48994992)
print v(xbgr.mr_n48995312)
print v(xbgr.mr_n48995424)
print v(xbgr.mr_n48995744)
print v(xbgr.mr_n48995856)
print v(xbgr.mr_n48996176)
print v(xbgr.mr_n48996288)
print v(xbgr.mr_n48996608)
print v(xbgr.mr_n48996720)
print v(xbgr.mr_n48997040)
print v(xbgr.mr_n48997152)
print v(xbgr.mr_n48997472)
print v(xbgr.mr_n48997584)
print v(xbgr.mr_n48997904)
print v(xbgr.mr_n48998016)
print v(xbgr.mr_n48998336)
print v(xbgr.mr_n48998448)
print v(xbgr.mr_n48998768)
print v(xbgr.mr_n48998880)
print v(xbgr.mr_n48999200)
print v(xbgr.mr_n48999312)
print v(xbgr.mr_n48999632)
print v(xbgr.mr_n48999744)
print v(xbgr.mr_n49000064)
print v(xbgr.mr_n49000176)
print v(xbgr.mr_n49000496)
print v(xbgr.mr_n49000608)
print v(xbgr.mr_n49000928)
print v(xbgr.mr_n49001040)
print v(xbgr.mr_n49001360)
print v(xbgr.mr_n49001472)
print v(xbgr.mr_n49001792)
print v(xbgr.mr_n49001904)
print v(xbgr.mr_n49002224)
print v(xbgr.mr_n49002336)
print v(xbgr.mr_n49002656)
print v(xbgr.mr_n49002768)
print v(xbgr.mr_n49003088)
print v(xbgr.mr_n49003200)
print v(xbgr.mr_n49003520)
print v(xbgr.mr_n49003632)
print v(xbgr.mr_n49003952)
print v(xbgr.mr_n49004064)
print v(xbgr.mr_n49004384)
print v(xbgr.mr_n49004496)
print v(xbgr.mr_n49004816)
print v(xbgr.mr_n49004928)
print v(xbgr.mr_n49005248)
print v(xbgr.mr_n49005360)
print v(xbgr.mr_n49005680)
print v(xbgr.mr_n49005792)
print v(xbgr.mr_n49006112)
print v(xbgr.mr_n49006224)
print v(xbgr.mr_n49006544)
print v(xbgr.mr_n49006656)
print v(xbgr.mr_n49006976)
print v(xbgr.mr_n49007088)
print v(xbgr.mr_n49007408)
print v(xbgr.mr_n49007520)
print v(xbgr.mr_n49007840)
print v(xbgr.mr_n49007952)
print v(xbgr.mr_n49008272)
print v(xbgr.mr_n49008384)
print v(xbgr.mr_n49008704)
print v(xbgr.mr_n49008816)
print v(xbgr.mr_n49009136)
print v(xbgr.mr_n49009248)
print v(xbgr.mr_n49009568)
print v(xbgr.mr_n49009680)
print v(xbgr.mr_n49010000)
print v(xbgr.mr_n49010112)
print v(xbgr.mr_n49010432)
print v(xbgr.mr_n49010544)
print v(xbgr.mr_n49010864)
print v(xbgr.mr_n49010976)
print v(xbgr.mr_n49011296)
print v(xbgr.mr_n49011408)
print v(xbgr.mr_n49011728)
print v(xbgr.mr_n49011840)
print v(xbgr.mr_n49012160)
print v(xbgr.mr_n49012272)
print v(xbgr.mr_n49012592)
print v(xbgr.mr_n49012704)
print v(xbgr.mr_n49013024)
print v(xbgr.mr_n49013136)
print v(xbgr.mr_n49013456)
print v(xbgr.mr_n49013568)
print v(xbgr.mr_n49013888)
print v(xbgr.mr_n49014000)
print v(xbgr.mr_n49014320)
print v(xbgr.mr_n49014432)
print v(xbgr.mr_n49014752)
print v(xbgr.mr_n49015184)
print v(xbgr.mr_n49015296)
print v(xbgr.mr_n49015616)
print v(xbgr.mr_n49016048)
print v(xbgr.mr_n49016160)
print v(xbgr.mr_n49016480)
print v(xbgr.mr_n49016592)
print v(xbgr.mr_n49016912)
print v(xbgr.mr_n49017024)
print v(xbgr.mr_n49017344)
print v(xbgr.mr_n49017456)
print v(xbgr.mr_n49017776)
print v(xbgr.mr_n49017888)
print v(xbgr.mr_n49018208)
print v(xbgr.mr_n49018320)
print v(xbgr.mr_n49018640)
print v(xbgr.mr_n49018752)
print v(xbgr.mr_n49019072)
print v(xbgr.mr_n49019184)
print v(xbgr.mr_n49019504)
print v(xbgr.mr_n49019616)
print v(xbgr.mr_n49019936)
print v(xbgr.mr_n49020048)
print v(xbgr.mr_n49020368)
print v(xbgr.mr_n49020480)
print v(xbgr.mr_n49020800)
print v(xbgr.mr_n49020912)
print v(xbgr.mr_n49021232)
print v(xbgr.mr_n49021344)
print v(xbgr.mr_n49021664)
print v(xbgr.mr_n49021776)
print v(xbgr.mr_n49022096)
print v(xbgr.mr_n49022208)
print v(xbgr.mr_n49022528)
print v(xbgr.mr_n49022640)
print v(xbgr.mr_n49022960)
print v(xbgr.mr_n49023072)
print v(xbgr.mr_n49023392)
print v(xbgr.mr_n49023504)
print v(xbgr.mr_n49023824)
print v(xbgr.mr_n49023936)
print v(xbgr.mr_n49024256)
print v(xbgr.mr_n49024368)
print v(xbgr.mr_n49024688)
print v(xbgr.mr_n49024800)
print v(xbgr.mr_n49025120)
print v(xbgr.mr_n49025232)
print v(xbgr.mr_n49025552)
print v(xbgr.mr_n49025984)
print v(xbgr.mr_n49026096)
print v(xbgr.mr_n49026416)
print v(xbgr.mr_n49026848)
print v(xbgr.mr_n49026960)
print v(xbgr.mr_n49027280)
print v(xbgr.mr_n49027712)
print v(xbgr.mr_n49027824)
print v(xbgr.mr_n49028144)
print v(xbgr.mr_n49028576)
print v(xbgr.mr_n49028688)
print v(xbgr.mr_n49029008)
print v(xbgr.mr_n49029440)
print v(xbgr.mr_n49029552)
print v(xbgr.mr_n49029872)
print v(xbgr.mr_n49029984)
print v(xbgr.mr_n49030304)
print v(xbgr.mr_n49030416)
print v(xbgr.mr_n49030736)
print v(xbgr.mr_n49030848)
print v(xbgr.mr_n49031168)
print v(xbgr.mr_n49031280)
print v(xbgr.mr_n49031600)
print v(xbgr.mr_n49031712)
print v(xbgr.mr_n49032032)
print v(xbgr.mr_n49032144)
print v(xbgr.mr_n49032464)
print v(xbgr.mr_n49032576)
print v(xbgr.mr_n49032896)
print v(xbgr.mr_n49033008)
print v(xbgr.mr_n49033328)
print v(xbgr.mr_n49033440)
print v(xbgr.mr_n49033760)
print v(xbgr.mr_n49033872)
print v(xbgr.mr_n49034192)
print v(xbgr.mr_n49034304)
print v(xbgr.mr_n49034624)
print v(xbgr.mr_n49034736)
print v(xbgr.mr_n49035056)
print v(xbgr.mr_n49035168)
print v(xbgr.mr_n49035488)
print v(xbgr.mr_n49035600)
print v(xbgr.mr_n49035920)
print v(xbgr.mr_n49036032)
print v(xbgr.mr_n49036352)
print v(xbgr.mr_n49036464)
print v(xbgr.mr_n49036784)
print v(xbgr.mr_n49036896)
print v(xbgr.mr_n49037216)
print v(xbgr.mr_n49037328)
print v(xbgr.mr_n49037648)
print v(xbgr.mr_n49037760)
print v(xbgr.mr_n49038080)
print v(xbgr.mr_n49038192)
print v(xbgr.mr_n49038512)
print v(xbgr.mr_n49038624)
print v(xbgr.mr_n49038944)
print v(xbgr.mr_n49039056)
print v(xbgr.mr_n49039376)
print v(xbgr.mr_n49039488)
print v(xbgr.mr_n49039808)
print v(xbgr.mr_n49039920)
print v(xbgr.mr_n49040240)
print v(xbgr.mr_n49040352)
print v(xbgr.mr_n49040672)
print v(xbgr.mr_n49040784)
print v(xbgr.mr_n49041104)
print v(xbgr.mr_n49041216)
print v(xbgr.mr_n49041536)
print v(xbgr.mr_n49041648)
print v(xbgr.mr_n49041968)
print v(xbgr.mr_n49042080)
print v(xbgr.mr_n49042400)
print v(xbgr.mr_n49042512)
print v(xbgr.mr_n49042832)
print v(xbgr.mr_n49042944)
print v(xbgr.mr_n49043264)
print v(xbgr.mr_n49043376)
print v(xbgr.mr_n49043696)
print v(xbgr.mr_n49043808)
print v(xbgr.mr_n49044128)
print v(xbgr.mr_n49044240)
print v(xbgr.mr_n49044560)
print v(xbgr.mr_n49044672)
print v(xbgr.mr_n49044992)
print v(xbgr.mr_n49045104)
print v(xbgr.mr_n49045424)
print v(xbgr.mr_n49045536)
print v(xbgr.mr_n49045856)
print v(xbgr.mr_n49045968)
print v(xbgr.mr_n49046288)
print v(xbgr.mr_n49046400)
print v(xbgr.mr_n49046720)
print v(xbgr.mr_n49046832)
print v(xbgr.mr_n49047152)
print v(xbgr.mr_n49047264)
print v(xbgr.mr_n49047584)
print v(xbgr.mr_n49047696)
print v(xbgr.mr_n49048016)
print v(xbgr.mr_n49048128)
print v(xbgr.mr_n49048448)
print v(xbgr.mr_n49048560)
print v(xbgr.mr_n49048880)
print v(xbgr.mr_n49048992)
print v(xbgr.mr_n49049312)
print v(xbgr.mr_n49049744)
print v(xbgr.mr_n49049856)
print v(xbgr.mr_n49050176)
print v(xbgr.mr_n49050608)
print v(xbgr.mr_n49050720)
print v(xbgr.mr_n49051040)
print v(xbgr.mr_n49051472)
print v(xbgr.mr_n49051584)
print v(xbgr.mr_n49051904)
print v(xbgr.mr_n49052016)
print v(xbgr.mr_n49052336)
print v(xbgr.mr_n49052448)
print v(xbgr.mr_n49052768)
print v(xbgr.mr_n49052880)
print v(xbgr.mr_n49053200)
print v(xbgr.mr_n49053312)
print v(xbgr.mr_n49053632)
print v(xbgr.mr_n49053744)
print v(xbgr.mr_n49054064)
print v(xbgr.mr_n49054176)
print v(xbgr.mr_n49054496)
print v(xbgr.mr_n49054608)
print v(xbgr.mr_n49054928)
print v(xbgr.mr_n49055040)
print v(xbgr.mr_n49055360)
print v(xbgr.mr_n49055472)
print v(xbgr.mr_n49055792)
print v(xbgr.mr_n49055904)
print v(xbgr.mr_n49056224)
print v(xbgr.mr_n49056336)
print v(xbgr.mr_n49056656)
print v(xbgr.mr_n49056768)
print v(xbgr.mr_n49057088)
print v(xbgr.mr_n49057200)
print v(xbgr.mr_n49057520)
print v(xbgr.mr_n49057632)
print v(xbgr.mr_n49057952)
print v(xbgr.mr_n49058064)
print v(xbgr.mr_n49058384)
print v(xbgr.mr_n49058496)
print v(xbgr.mr_n49058816)
print v(xbgr.mr_n49058928)
print v(xbgr.mr_n49059248)
print v(xbgr.mr_n49059360)
print v(xbgr.mr_n49059680)
print v(xbgr.mr_n49059792)
print v(xbgr.mr_n49060112)
print v(xbgr.mr_n49060224)
print v(xbgr.mr_n49060544)
print v(xbgr.mr_n49060656)
print v(xbgr.mr_n49060976)
print v(xbgr.mr_n49061088)
print v(xbgr.mr_n49061408)
print v(xbgr.mr_n49061520)
print v(xbgr.mr_n49061840)
print v(xbgr.mr_n49061952)
print v(xbgr.mr_n49062272)
print v(xbgr.mr_n49062384)
print v(xbgr.mr_n49062704)
print v(xbgr.mr_n49062816)
print v(xbgr.mr_n49063136)
print v(xbgr.mr_n49063248)
print v(xbgr.mr_n49063568)
print v(xbgr.mr_n49063680)
print v(xbgr.mr_n49064000)
print v(xbgr.mr_n49064112)
print v(xbgr.mr_n49064432)
print v(xbgr.mr_n49064544)
print v(xbgr.mr_n49064864)
print v(xbgr.mr_n49064976)
print v(xbgr.mr_n49065296)
print v(xbgr.mr_n49065408)
print v(xbgr.mr_n49065728)
print v(xbgr.mr_n49065840)
print v(xbgr.mr_n49066160)
print v(xbgr.mr_n49066272)
print v(xbgr.mr_n49066592)
print v(xbgr.mr_n49066704)
print v(xbgr.mr_n49067024)
print v(xbgr.mr_n49067136)
print v(xbgr.mr_n49067456)
print v(xbgr.mr_n49067568)
print v(xbgr.mr_n49067888)
print v(xbgr.mr_n49068000)
print v(xbgr.mr_n49068320)
print v(xbgr.mr_n49068432)
print v(xbgr.mr_n49068752)
print v(xbgr.mr_n49068864)
print v(xbgr.mr_n49069184)
print v(xbgr.mr_n49069296)
print v(xbgr.mr_n49069616)
print v(xbgr.mr_n49069728)
print v(xbgr.mr_n49070048)
print v(xbgr.mr_n49070160)
print v(xbgr.mr_n49070480)
print v(xbgr.mr_n49070592)
print v(xbgr.mr_n49070912)
print v(xbgr.mr_n49071024)
print v(xbgr.mr_n49071344)
print v(xbgr.mr_n49071456)
print v(xbgr.mr_n49071776)
print v(xbgr.mr_n49071888)
print v(xbgr.mr_n49072208)
print v(xbgr.mr_n49072320)
print v(xbgr.mr_n49072640)
print v(xbgr.mr_n49072752)
print v(xbgr.mr_n49073072)
print v(xbgr.mr_n49073184)
print v(xbgr.mr_n49073504)
print v(xbgr.mr_n49073616)
print v(xbgr.mr_n49073936)
print v(xbgr.mr_n49074048)
print v(xbgr.mr_n49074368)
print v(xbgr.mr_n49074480)
print v(xbgr.mr_n49074800)
print v(xbgr.mr_n49074912)
print v(xbgr.mr_n49075232)
print v(xbgr.mr_n49075344)
print v(xbgr.mr_n49075664)
print v(xbgr.mr_n49075776)
print v(xbgr.mr_n49076096)
print v(xbgr.mr_n49076208)
print v(xbgr.mr_n49076528)
print v(xbgr.mr_n49076640)
print v(xbgr.mr_n49076960)
print v(xbgr.mr_n49077072)
print v(xbgr.mr_n49077392)
print v(xbgr.mr_n49077504)
print v(xbgr.mr_n49077824)
print v(xbgr.mr_n49077936)
print v(xbgr.mr_n49078256)
print v(xbgr.mr_n49078368)
print v(xbgr.mr_n49078688)
print v(xbgr.mr_n49078800)
print v(xbgr.mr_n49079120)
print v(xbgr.mr_n49079232)
print v(xbgr.mr_n49079552)
print v(xbgr.mr_n49079664)
print v(xbgr.mr_n49079984)
print v(xbgr.mr_n49080096)
print v(xbgr.mr_n49080416)
print v(xbgr.mr_n49080528)
print v(xbgr.mr_n49080848)
print v(xbgr.mr_n49080960)
print v(xbgr.mr_n49081280)
print v(xbgr.mr_n49081392)
print v(xbgr.mr_n49081712)
print v(xbgr.mr_n49081824)
print v(xbgr.mr_n49082144)
print v(xbgr.mr_n49082256)
print v(xbgr.mr_n49082576)
print v(xbgr.mr_n49082688)
print v(xbgr.mr_n49083008)
print v(xbgr.mr_n49083120)
print v(xbgr.mr_n49083440)
print v(xbgr.mr_n49083552)
print v(xbgr.mr_n49083872)
print v(xbgr.mr_n49083984)
print v(xbgr.mr_n49084304)
print v(xbgr.mr_n49084416)
print v(xbgr.mr_n49084736)
print v(xbgr.mr_n49084848)
print v(xbgr.mr_n49085168)
print v(xbgr.mr_n49085280)
print v(xbgr.mr_n49085600)
print v(xbgr.mr_n49085712)
print v(xbgr.mr_n49086032)
print v(xbgr.mr_n49086144)
print v(xbgr.mr_n49086464)
print v(xbgr.mr_n49086576)
print v(xbgr.mr_n49086896)
print v(xbgr.mr_n49087008)
print v(xbgr.mr_n49087328)
print v(xbgr.mr_n49087440)
print v(xbgr.mr_n49087760)
print v(xbgr.mr_n49087872)
print v(xbgr.mr_n49088192)
print v(xbgr.mr_n49088304)
print v(xbgr.mr_n49088624)
print v(xbgr.mr_n49088736)
print v(xbgr.mr_n49089056)
print v(xbgr.mr_n49089168)
print v(xbgr.mr_n49089488)
print v(xbgr.mr_n49089600)
print v(xbgr.mr_n49089920)
print v(xbgr.mr_n49090032)
print v(xbgr.mr_n49090352)
print v(xbgr.mr_n49090464)
print v(xbgr.mr_n49090784)
print v(xbgr.mr_n49090896)
print v(xbgr.mr_n49091216)
print v(xbgr.mr_n49091328)
print v(xbgr.mr_n49091648)
print v(xbgr.mr_n49091760)
print v(xbgr.mr_n49092080)
print v(xbgr.mr_n49092192)
print v(xbgr.mr_n49092512)
print v(xbgr.mr_n49092624)
print v(xbgr.mr_n49092944)
print v(xbgr.mr_n49093056)
print v(xbgr.mr_n49093376)
print v(xbgr.mr_n49093488)
print v(xbgr.mr_n49093808)
print v(xbgr.mr_n49093920)
print v(xbgr.mr_n49094240)
print v(xbgr.mr_n49094352)
print v(xbgr.mr_n49094672)
print v(xbgr.mr_n49094784)
print v(xbgr.mr_n49095104)
print v(xbgr.mr_n49095216)
print v(xbgr.mr_n49095536)
print v(xbgr.mr_n49095648)
print v(xbgr.mr_n49095968)
print v(xbgr.mr_n49096080)
print v(xbgr.mr_n49096400)
print v(xbgr.mr_n49096512)
print v(xbgr.mr_n49096832)
print v(xbgr.mr_n49096944)
print v(xbgr.mr_n49097264)
print v(xbgr.mr_n49097376)
print v(xbgr.mr_n49097696)
print v(xbgr.mr_n49097808)
print v(xbgr.mr_n49098128)
print v(xbgr.mr_n49098240)
print v(xbgr.mr_n49098560)
print v(xbgr.mr_n49098672)
print v(xbgr.mr_n49098992)
print v(xbgr.mr_n49099104)
print v(xbgr.mr_n49099424)
print v(xbgr.mr_n49099536)
print v(xbgr.mr_n49099856)
print v(xbgr.mr_n49099968)
print v(xbgr.mr_n49100288)
print v(xbgr.mr_n49100400)
print v(xbgr.mr_n49100720)
print v(xbgr.mr_n49100832)
print v(xbgr.mr_n49101152)
print v(xbgr.mr_n49101264)
print v(xbgr.mr_n49101584)
print v(xbgr.mr_n49101696)
print v(xbgr.mr_n49102016)
print v(xbgr.mr_n49102128)
print v(xbgr.mr_n49102448)
print v(xbgr.mr_n49102560)
print v(xbgr.mr_n49102880)
print v(xbgr.mr_n49102992)
print v(xbgr.mr_n49103312)
print v(xbgr.mr_n49103424)
print v(xbgr.mr_n49103744)
print v(xbgr.mr_n49103856)
print v(xbgr.mr_n49104176)
print v(xbgr.mr_n49104288)
print v(xbgr.mr_n49104608)
print v(xbgr.mr_n49104720)
print v(xbgr.mr_n49105040)
print v(xbgr.mr_n49105152)
print v(xbgr.mr_n49105472)
print v(xbgr.mr_n49105584)
print v(xbgr.mr_n49105904)
print v(xbgr.mr_n49106016)
print v(xbgr.mr_n49106336)
print v(xbgr.mr_n49106448)
print v(xbgr.mr_n49106768)
print v(xbgr.mr_n49106880)
print v(xbgr.mr_n49107200)
print v(xbgr.mr_n49107312)
print v(xbgr.mr_n49107632)
print v(xbgr.mr_n49107744)
print v(xbgr.mr_n49108064)
print v(xbgr.mr_n49108176)
print v(xbgr.mr_n49108496)
print v(xbgr.mr_n49108608)
print v(xbgr.mr_n49108928)
print v(xbgr.mr_n49109040)
print v(xbgr.mr_n49109360)
print v(xbgr.mr_n49109472)
print v(xbgr.mr_n49109792)
print v(xbgr.mr_n49109904)
print v(xbgr.mr_n49110224)
print v(xbgr.mr_n49110336)
print v(xbgr.mr_n49110656)
print v(xbgr.mr_n49110768)
print v(xbgr.mr_n49111088)
print v(xbgr.mr_n49111200)
print v(xbgr.mr_n49111520)
print v(xbgr.mr_n49111632)
print v(xbgr.mr_n49111952)
print v(xbgr.mr_n49112064)
print v(xbgr.mr_n49112384)
print v(xbgr.mr_n49112496)
print v(xbgr.mr_n49112816)
print v(xbgr.mr_n49112928)
print v(xbgr.mr_n49113248)
print v(xbgr.mr_n49113360)
print v(xbgr.mr_n49113680)
print v(xbgr.mr_n49113792)
print v(xbgr.mr_n49114112)
print v(xbgr.mr_n49114224)
print v(xbgr.mr_n49114544)
print v(xbgr.mr_n49114656)
print v(xbgr.mr_n49114976)
print v(xbgr.mr_n49115088)
print v(xbgr.mr_n49115408)
print v(xbgr.mr_n49115520)
print v(xbgr.mr_n49115840)
print v(xbgr.mr_n49115952)
print v(xbgr.mr_n49116272)
print v(xbgr.mr_n49116384)
print v(xbgr.mr_n49116704)
print v(xbgr.mr_n49116816)
print v(xbgr.mr_n49117136)
print v(xbgr.mr_n49117248)
print v(xbgr.mr_n49117568)
print v(xbgr.mr_n49117680)
print v(xbgr.mr_n49118000)
print v(xbgr.mr_n49118112)
print v(xbgr.mr_n49118432)
print v(xbgr.mr_n49118544)
print v(xbgr.mr_n49118864)
print v(xbgr.mr_n49118976)
print v(xbgr.mr_n49119296)
print v(xbgr.mr_n49119408)
print v(xbgr.mr_n49119728)
print v(xbgr.mr_n49119840)
print v(xbgr.mr_n49120160)
print v(xbgr.mr_n49120272)
print v(xbgr.mr_n49120592)
print v(xbgr.mr_n49120704)
print v(xbgr.mr_n49121024)
print v(xbgr.mr_n49121136)
print v(xbgr.mr_n49121456)
print v(xbgr.mr_n49121568)
print v(xbgr.mr_n49121888)
print v(xbgr.mr_n49122000)
print v(xbgr.mr_n49122320)
print v(xbgr.mr_n49122432)
print v(xbgr.mr_n49122752)
print v(xbgr.mr_n49122864)
print v(xbgr.mr_n49123184)
print v(xbgr.mr_n49123296)
print v(xbgr.mr_n49123616)
print v(xbgr.mr_n49123728)
print v(xbgr.mr_n49124048)
print v(xbgr.mr_n49124160)
print v(xbgr.mr_n49124480)
print v(xbgr.mr_n49124592)
print v(xbgr.mr_n49124912)
print v(xbgr.mr_n49125024)
print v(xbgr.mr_n49125344)
print v(xbgr.mr_n49125456)
print v(xbgr.mr_n49125776)
print v(xbgr.mr_n49125888)
print v(xbgr.mr_n49126208)
print v(xbgr.mr_n49126320)
print v(xbgr.mr_n49126640)
print v(xbgr.mr_n49126752)
print v(xbgr.mr_n49127072)
print v(xbgr.mr_n49127184)
print v(xbgr.mr_n49127504)
print v(xbgr.mr_n49127616)
print v(xbgr.mr_n49127936)
print v(xbgr.mr_n49128048)
print v(xbgr.mr_n49128368)
print v(xbgr.mr_n49128480)
print v(xbgr.mr_n49128800)
print v(xbgr.mr_n49128912)
print v(xbgr.mr_n49129232)
print v(xbgr.mr_n49129344)
print v(xbgr.mr_n49129664)
print v(xbgr.mr_n49129776)
print v(xbgr.mr_n49130096)
print v(xbgr.mr_n49130208)
print v(xbgr.mr_n49130528)
print v(xbgr.mr_n49130640)
print v(xbgr.mr_n49130960)
print v(xbgr.mr_n49131072)
print v(xbgr.mr_n49131392)
print v(xbgr.mr_n49131504)
print v(xbgr.mr_n49131824)
print v(xbgr.mr_n49131936)
print v(xbgr.mr_n49132256)
print v(xbgr.mr_n49132368)
print v(xbgr.mr_n49132688)
print v(xbgr.mr_n49132800)
print v(xbgr.mr_n49133120)
print v(xbgr.mr_n49133232)
print v(xbgr.mr_n49133552)
print v(xbgr.mr_n49133664)
print v(xbgr.mr_n49133984)
print v(xbgr.mr_n49134096)
print v(xbgr.mr_n49134416)
print v(xbgr.mr_n49134528)
print v(xbgr.mr_n49134848)
print v(xbgr.mr_n49134960)
print v(xbgr.mr_n49135280)
print v(xbgr.mr_n49135392)
print v(xbgr.mr_n49135712)
print v(xbgr.mr_n49135824)
print v(xbgr.mr_n49136144)
print v(xbgr.mr_n49136256)
print v(xbgr.mr_n49136576)
print v(xbgr.mr_n49136688)
print v(xbgr.mr_n49137008)
print v(xbgr.mr_n49137120)
print v(xbgr.mr_n49137440)
print v(xbgr.mr_n49137552)
print v(xbgr.mr_n49137872)
print v(xbgr.mr_n49137984)
print v(xbgr.mr_n49138304)
print v(xbgr.mr_n49138416)
print v(xbgr.mr_n49138736)
print v(xbgr.mr_n49138848)
print v(xbgr.mr_n49139168)
print v(xbgr.mr_n49139280)
print v(xbgr.mr_n49139600)
print v(xbgr.mr_n49139712)
print v(xbgr.mr_n49140032)
print v(xbgr.mr_n49140144)
print v(xbgr.mr_n49140464)
print v(xbgr.mr_n49140576)
print v(xbgr.mr_n49140896)
print v(xbgr.mr_n49141008)
print v(xbgr.mr_n49141328)
print v(xbgr.mr_n49141440)
print v(xbgr.mr_n49141760)
print v(xbgr.mr_n49141872)
print v(xbgr.mr_n49142192)
print v(xbgr.mr_n49142304)
print v(xbgr.mr_n49142624)
print v(xbgr.mr_n49142736)
print v(xbgr.mr_n49143056)
print v(xbgr.mr_n49143168)
print v(xbgr.mr_n49143488)
print v(xbgr.mr_n49143600)
print v(xbgr.mr_n49143920)
print v(xbgr.mr_n49144032)
print v(xbgr.mr_n49144352)
print v(xbgr.mr_n49144464)
print v(xbgr.mr_n49144784)
print v(xbgr.mr_n49144896)
print v(xbgr.mr_n49145216)
print v(xbgr.mr_n49145328)
print v(xbgr.mr_n49145648)
print v(xbgr.mr_n49145760)
print v(xbgr.mr_n49146080)
print v(xbgr.mr_n49146192)
print v(xbgr.mr_n49146512)
print v(xbgr.mr_n49146624)
print v(xbgr.mr_n49146944)
print v(xbgr.mr_n49147056)
print v(xbgr.mr_n49147376)
print v(xbgr.mr_n49147488)
print v(xbgr.mr_n49147808)
print v(xbgr.mr_n49147920)
print v(xbgr.mr_n49148240)
print v(xbgr.mr_n49148352)
print v(xbgr.mr_n49148672)
print v(xbgr.mr_n49148784)
print v(xbgr.mr_n49149104)
print v(xbgr.mr_n49149216)
print v(xbgr.mr_n49149536)
print v(xbgr.mr_n49149648)
print v(xbgr.mr_n49149968)
print v(xbgr.mr_n49150080)
print v(xbgr.mr_n49150400)
print v(xbgr.mr_n49150512)
print v(xbgr.mr_n49150832)
print v(xbgr.mr_n49150944)
print v(xbgr.mr_n49151264)
print v(xbgr.mr_n49151376)
print v(xbgr.mr_n49151696)
print v(xbgr.mr_n49151808)
print v(xbgr.mr_n49152128)
print v(xbgr.mr_n49152240)
print v(xbgr.mr_n49152560)
print v(xbgr.mr_n49152672)
print v(xbgr.mr_n49152992)
print v(xbgr.mr_n49153104)
print v(xbgr.mr_n49153424)
print v(xbgr.mr_n49153536)
print v(xbgr.mr_n49153856)
print v(xbgr.mr_n49153968)
print v(xbgr.mr_n49154288)
print v(xbgr.mr_n49154400)
print v(xbgr.mr_n49154720)
print v(xbgr.mr_n49154832)
print v(xbgr.mr_n49155152)
print v(xbgr.mr_n49155264)
print v(xbgr.mr_n49155584)
print v(xbgr.mr_n49155696)
print v(xbgr.mr_n49156016)
print v(xbgr.mr_n49156128)
print v(xbgr.mr_n49156448)
print v(xbgr.mr_n49156560)
print v(xbgr.mr_n49156880)
print v(xbgr.mr_n49156992)
print v(xbgr.mr_n49157312)
print v(xbgr.mr_n49157424)
print v(xbgr.mr_n49157744)
print v(xbgr.mr_n49157856)
print v(xbgr.mr_n49158176)
print v(xbgr.mr_n49158288)
print v(xbgr.mr_n49158608)
print v(xbgr.mr_n49158720)
print v(xbgr.mr_n49159040)
print v(xbgr.mr_n49159152)
print v(xbgr.mr_n49159472)
print v(xbgr.mr_n49159584)
print v(xbgr.mr_n49159904)
print v(xbgr.mr_n49160016)
print v(xbgr.mr_n49160336)
print v(xbgr.mr_n49160448)
print v(xbgr.mr_n49160768)
print v(xbgr.mr_n49160880)
print v(xbgr.mr_n49161200)
print v(xbgr.mr_n49161312)
print v(xbgr.mr_n49161632)
print v(xbgr.mr_n49161744)
print v(xbgr.mr_n49162064)
print v(xbgr.mr_n49162176)
print v(xbgr.mr_n49162496)
print v(xbgr.mr_n49162608)
print v(xbgr.mr_n49162928)
print v(xbgr.mr_n49163040)
print v(xbgr.mr_n49163360)
print v(xbgr.mr_n49163472)
print v(xbgr.mr_n49163792)
print v(xbgr.mr_n49163904)
print v(xbgr.mr_n49164224)
print v(xbgr.mr_n49164336)
print v(xbgr.mr_n49164656)
print v(xbgr.mr_n49164768)
print v(xbgr.mr_n49165088)
print v(xbgr.mr_n49165200)
print v(xbgr.mr_n49165520)
print v(xbgr.mr_n49165632)
print v(xbgr.mr_n49165952)
print v(xbgr.mr_n49166064)
print v(xbgr.mr_n49166384)
print v(xbgr.mr_n49166496)
print v(xbgr.mr_n49166816)
print v(xbgr.mr_n49166928)
print v(xbgr.mr_n49167248)
print v(xbgr.mr_n49167360)
print v(xbgr.mr_n49167680)
print v(xbgr.mr_n49167792)
print v(xbgr.mr_n49168112)
print v(xbgr.mr_n49168224)
print v(xbgr.mr_n49168544)
print v(xbgr.mr_n49168656)
print v(xbgr.mr_n49168976)
print v(xbgr.mr_n49169088)
print v(xbgr.mr_n49169408)
print v(xbgr.mr_n49169520)
print v(xbgr.mr_n49169840)
print v(xbgr.mr_n49169952)
print v(xbgr.mr_n49170272)
print v(xbgr.mr_n49170384)
print v(xbgr.mr_n49170704)
print v(xbgr.mr_n49170816)
print v(xbgr.mr_n49171136)
print v(xbgr.mr_n49171248)
print v(xbgr.mr_n49171568)
print v(xbgr.mr_n49171680)
print v(xbgr.mr_n49172000)
print v(xbgr.mr_n49172112)
print v(xbgr.mr_n49172432)
print v(xbgr.mr_n49172544)
print v(xbgr.mr_n49172864)
print v(xbgr.mr_n49172976)
print v(xbgr.mr_n49173296)
print v(xbgr.mr_n49173408)
print v(xbgr.mr_n49173728)
print v(xbgr.mr_n49173840)
print v(xbgr.mr_n49174160)
print v(xbgr.mr_n49174272)
print v(xbgr.mr_n49174592)
print v(xbgr.mr_n49174704)
print v(xbgr.mr_n49175024)
print v(xbgr.mr_n49175136)
print v(xbgr.mr_n49175456)
print v(xbgr.mr_n49175568)
print v(xbgr.mr_n49175888)
print v(xbgr.mr_n49176000)
print v(xbgr.mr_n49176320)
print v(xbgr.mr_n49176432)
print v(xbgr.mr_n49176752)
print v(xbgr.mr_n49176864)
print v(xbgr.mr_n49177184)
print v(xbgr.mr_n49177296)
print v(xbgr.mr_n49177616)
print v(xbgr.mr_n49177728)
print v(xbgr.mr_n49178048)
print v(xbgr.mr_n49178160)
print v(xbgr.mr_n49178480)
print v(xbgr.mr_n49178592)
print v(xbgr.mr_n49178912)
print v(xbgr.mr_n49179024)
print v(xbgr.mr_n49179344)
print v(xbgr.mr_n49179456)
print v(xbgr.mr_n49179776)
print v(xbgr.mr_n49179888)
print v(xbgr.mr_n49180208)
print v(xbgr.mr_n49180320)
print v(xbgr.mr_n49180640)
print v(xbgr.mr_n49180752)
print v(xbgr.mr_n49181072)
print v(xbgr.mr_n49181184)
print v(xbgr.mr_n49181504)
print v(xbgr.mr_n49181616)
print v(xbgr.mr_n49181936)
print v(xbgr.mr_n49182048)
print v(xbgr.mr_n49182368)
print v(xbgr.mr_n49182480)
print v(xbgr.mr_n49182800)
print v(xbgr.mr_n49182912)
print v(xbgr.mr_n49183232)
print v(xbgr.mr_n49183344)
print v(xbgr.mr_n49183664)
print v(xbgr.mr_n49183776)
print v(xbgr.mr_n49184096)
print v(xbgr.mr_n49184208)
print v(xbgr.mr_n49184528)
print v(xbgr.mr_n49184640)
print v(xbgr.mr_n49184960)
print v(xbgr.mr_n49185072)
print v(xbgr.mr_n49185392)
print v(xbgr.mr_n49185504)
print v(xbgr.mr_n49185824)
print v(xbgr.mr_n49185936)
print v(xbgr.mr_n49186256)
print v(xbgr.mr_n49186368)
print v(xbgr.mr_n49186688)
print v(xbgr.mr_n49186800)
print v(xbgr.mr_n49187120)
print v(xbgr.mr_n49187232)
print v(xbgr.mr_n49187552)
print v(xbgr.mr_n49187664)
print v(xbgr.mr_n49187984)
print v(xbgr.mr_n49188096)
print v(xbgr.mr_n49188416)
print v(xbgr.mr_n49188528)
print v(xbgr.mr_n49188848)
print v(xbgr.mr_n49188960)
print v(xbgr.mr_n49189280)
print v(xbgr.mr_n49189392)
print v(xbgr.mr_n49189712)
print v(xbgr.mr_n49189824)
print v(xbgr.mr_n49190144)
print v(xbgr.mr_n49190256)
print v(xbgr.mr_n49190576)
print v(xbgr.mr_n49190688)
print v(xbgr.mr_n49191008)
print v(xbgr.mr_n49191120)
print v(xbgr.mr_n49191440)
print v(xbgr.mr_n49191552)
print v(xbgr.mr_n49191872)
print v(xbgr.mr_n49191984)
print v(xbgr.mr_n49192304)
print v(xbgr.mr_n49192416)
print v(xbgr.mr_n49192736)
print v(xbgr.mr_n49192848)
print v(xbgr.mr_n49193168)
print v(xbgr.mr_n49193280)
print v(xbgr.mr_n49193600)
print v(xbgr.mr_n49193712)
print v(xbgr.mr_n49194032)
print v(xbgr.mr_n49194144)
print v(xbgr.mr_n49194464)
print v(xbgr.mr_n49194576)
print v(xbgr.mr_n49194896)
print v(xbgr.mr_n49195008)
print v(xbgr.mr_n49195328)
print v(xbgr.mr_n49195440)
print v(xbgr.mr_n49195760)
print v(xbgr.mr_n49195872)
print v(xbgr.mr_n49196192)
print v(xbgr.mr_n49196304)
print v(xbgr.mr_n49196624)
print v(xbgr.mr_n49196736)
print v(xbgr.mr_n49197056)
print v(xbgr.mr_n49197168)
print v(xbgr.mr_n49197488)
print v(xbgr.mr_n49197600)
print v(xbgr.mr_n49197920)
print v(xbgr.mr_n49198032)
print v(xbgr.mr_n49198352)
print v(xbgr.mr_n49198464)
print v(xbgr.mr_n49198784)
print v(xbgr.mr_n49198896)
print v(xbgr.mr_n49199216)
print v(xbgr.mr_n49199328)
print v(xbgr.mr_n49199648)
print v(xbgr.mr_n49199760)
print v(xbgr.mr_n49200080)
print v(xbgr.mr_n49200192)
print v(xbgr.mr_n49200512)
print v(xbgr.mr_n49200624)
print v(xbgr.mr_n49200944)
print v(xbgr.mr_n49201056)
print v(xbgr.mr_n49201376)
print v(xbgr.mr_n49201488)
print v(xbgr.mr_n49201808)
print v(xbgr.mr_n49201920)
print v(xbgr.mr_n49202240)
print v(xbgr.mr_n49202352)
print v(xbgr.mr_n49202672)
print v(xbgr.mr_n49202784)
print v(xbgr.mr_n49203104)
print v(xbgr.mr_n49203216)
print v(xbgr.mr_n49203536)
print v(xbgr.mr_n49203648)
print v(xbgr.mr_n49203968)
print v(xbgr.mr_n49204080)
print v(xbgr.mr_n49204400)
print v(xbgr.mr_n49204512)
print v(xbgr.mr_n49204832)
print v(xbgr.mr_n49204944)
print v(xbgr.mr_n49205264)
print v(xbgr.mr_n49205376)
print v(xbgr.mr_n49205696)
print v(xbgr.mr_n49205808)
print v(xbgr.mr_n49206128)
print v(xbgr.mr_n49206240)
print v(xbgr.mr_n49206560)
print v(xbgr.mr_n49206672)
print v(xbgr.mr_n49206992)
print v(xbgr.mr_n49207104)
print v(xbgr.mr_n49207424)
print v(xbgr.mr_n49207536)
print v(xbgr.mr_n49207856)
print v(xbgr.mr_n49207968)
print v(xbgr.mr_n49208288)
print v(xbgr.mr_n49208400)
print v(xbgr.mr_n49208720)
print v(xbgr.mr_n49208832)
print v(xbgr.mr_n49209152)
print v(xbgr.mr_n49209264)
print v(xbgr.mr_n49209584)
print v(xbgr.mr_n49209696)
print v(xbgr.mr_n49210016)
print v(xbgr.mr_n49210128)
print v(xbgr.mr_n49210448)
print v(xbgr.mr_n49210560)
print v(xbgr.mr_n49210880)
print v(xbgr.mr_n49210992)
print v(xbgr.mr_n49211312)
print v(xbgr.mr_n49211424)
print v(xbgr.mr_n49211744)
print v(xbgr.mr_n49211856)
print v(xbgr.mr_n49212176)
print v(xbgr.mr_n49212288)
print v(xbgr.mr_n49212608)
print v(xbgr.mr_n49212720)
print v(xbgr.mr_n49213040)
print v(xbgr.mr_n49213152)
print v(xbgr.mr_n49213472)
print v(xbgr.mr_n49213584)
print v(xbgr.mr_n49213904)
print v(xbgr.mr_n49214016)
print v(xbgr.mr_n49214336)
print v(xbgr.mr_n49214448)
print v(xbgr.mr_n49214768)
print v(xbgr.mr_n49214880)
print v(xbgr.mr_n49215200)
print v(xbgr.mr_n49215312)
print v(xbgr.mr_n49215632)
print v(xbgr.mr_n49215744)
print v(xbgr.mr_n49216064)
print v(xbgr.mr_n49216176)
print v(xbgr.mr_n49216496)
print v(xbgr.mr_n49216608)
print v(xbgr.mr_n49217040)
print v(xbgr.mr_n49217360)
print v(xbgr.mr_n49217472)
print v(xbgr.mr_n49217904)
print v(xbgr.mr_n49218224)
print v(xbgr.mr_n49218336)
print v(xbgr.mr_n49218768)
print v(xbgr.mr_n49219088)
print v(xbgr.mr_n49219952)
print v(xbgr.mr_n49220816)
print v(xbgr.mr_n49220928)
print v(xbgr.mr_n49221248)
print v(xbgr.mr_n49221360)
print v(xbgr.mr_n49221680)
print v(xbgr.mr_n49221792)
print v(xbgr.mr_n49222112)
print v(xbgr.mr_n49222224)
print v(xbgr.mr_n49222544)
print v(xbgr.mr_n49222656)
print v(xbgr.mr_n49222976)
print v(xbgr.mr_n49223088)
print v(xbgr.mr_n49223408)
print v(xbgr.mr_n49224272)
print v(xbgr.mr_n49225136)
print v(xbgr.mr_n49226000)
print v(xbgr.mr_n49226112)
print v(xbgr.mr_n49226432)
print v(xbgr.mr_n49226544)
print v(xbgr.mr_n49226864)
print v(xbgr.mr_n49226976)
print v(xbgr.mr_n49227296)
print v(xbgr.mr_n49227408)
print v(xbgr.mr_n49227728)
print v(xbgr.mr_n49228592)
print v(xbgr.mr_n49229456)
print v(xbgr.mr_n49229568)
print v(xbgr.mr_n49229888)
print v(xbgr.mr_n49230000)
print v(xbgr.mr_n49230320)
print v(xbgr.mr_n49230432)
print v(xbgr.mr_n49230752)
print v(xbgr.mr_n49230864)
print v(xbgr.mr_n49231184)
print v(xbgr.mr_n49231296)
print v(xbgr.mr_n49231616)
print v(xbgr.mr_n49231728)
print v(xbgr.mr_n49232048)
print v(xbgr.mr_n49232912)
print v(xbgr.mr_n49233024)
print v(xbgr.mr_n49233456)
print v(xbgr.mr_n49233776)
print v(xbgr.mr_n49233888)
print v(xbgr.mr_n49234320)
print v(xbgr.mr_n49234640)
print v(xbgr.mr_n49234752)
print v(xbgr.mr_n49235184)
print v(xbgr.mr_n49235504)
print v(xbgr.mr_n49236368)
print v(xbgr.mr_n49237232)
print v(xbgr.mr_n49238096)
print v(xbgr.mr_n49238960)
print v(xbgr.mr_n49239824)
print v(xbgr.mr_n49240688)
print v(xbgr.mr_n49240800)
print v(xbgr.mr_n49241120)
print v(xbgr.mr_n49241232)
print v(xbgr.mr_n49241552)
print v(xbgr.mr_n49241664)
print v(xbgr.mr_n49241984)
print v(xbgr.mr_n49242096)
print v(xbgr.mr_n49242416)
print v(xbgr.mr_n49243280)
print v(xbgr.mr_n49244144)
print v(xbgr.mr_n49245008)
print v(xbgr.mr_n49245872)
print v(xbgr.mr_n49245984)
print v(xbgr.mr_n49246416)
print v(xbgr.mr_n49246736)
print v(xbgr.mr_n49246848)
print v(xbgr.mr_n49247280)
print v(xbgr.mr_n49247600)
print v(xbgr.mr_n49247712)
print v(xbgr.mr_n49248144)
print v(xbgr.mr_n49248464)
print v(xbgr.mr_n49249328)
print v(xbgr.mr_n49250192)
print v(xbgr.mr_n49251056)
print v(xbgr.mr_n49251920)
print v(xbgr.mr_n49252784)
print v(xbgr.mr_n49253648)
print v(xbgr.mr_n49253760)
print v(xbgr.mr_n49254080)
print v(xbgr.mr_n49254192)
print v(xbgr.mr_n49254512)
print v(xbgr.mr_n49254624)
print v(xbgr.mr_n49254944)
print v(xbgr.mr_n49255056)
print v(xbgr.mr_n49255376)
print v(xbgr.mr_n49256240)
print v(xbgr.mr_n49257104)
print v(xbgr.mr_n49257968)
print v(xbgr.mr_n49258080)
print v(xbgr.mr_n49258400)
print v(xbgr.mr_n49258512)
print v(xbgr.mr_n49258832)
print v(xbgr.mr_n49258944)
print v(xbgr.mr_n49259376)
print v(xbgr.mr_n49259808)
print v(xbgr.mr_n49260240)
print v(xbgr.mr_n49260560)
print v(xbgr.mr_n49260672)
print v(xbgr.mr_n49260992)
print v(xbgr.mr_n49261104)
print v(xbgr.mr_n49261424)
print v(xbgr.mr_n49261536)
print v(xbgr.mr_n49261856)
print v(xbgr.mr_n49261968)
print v(xbgr.mr_n49262288)
print v(xbgr.mr_n49262400)
print v(xbgr.mr_n49262720)
print v(xbgr.mr_n49262832)
print v(xbgr.mr_n49263152)
print v(xbgr.mr_n49263264)
print v(xbgr.mr_n49263696)
print v(xbgr.mr_n49264016)
print v(xbgr.mr_n49264448)
print v(xbgr.mr_n49264560)
print v(xbgr.mr_n49264880)
print v(xbgr.mr_n49264992)
print v(xbgr.mr_n49265312)
print v(xbgr.mr_n49265424)
print v(xbgr.mr_n49265744)
print v(xbgr.mr_n49265856)
print v(xbgr.mr_n49266176)
print v(xbgr.mr_n49266288)
print v(xbgr.mr_n49266608)
print v(xbgr.mr_n49266720)
print v(xbgr.mr_n49267040)
print v(xbgr.mr_n49267152)
print v(xbgr.mr_n49267584)
print v(xbgr.mr_n49267904)
print v(xbgr.mr_n49268016)
print v(xbgr.mr_n49268448)
print v(xbgr.mr_n49268768)
print v(xbgr.mr_n49268880)
print v(xbgr.mr_n49269200)
print v(xbgr.mr_n49269312)
print v(xbgr.mr_n49269632)
print v(xbgr.mr_n49269744)
print v(xbgr.mr_n49270176)
print v(xbgr.mr_n49270608)
print v(xbgr.mr_n49270928)
print v(xbgr.mr_n49271040)
print v(xbgr.mr_n49271360)
print v(xbgr.mr_n49271472)
print v(xbgr.mr_n49271792)
print v(xbgr.mr_n49271904)
print v(xbgr.mr_n49272224)
print v(xbgr.mr_n49272336)
print v(xbgr.mr_n49272656)
print v(xbgr.mr_n49272768)
print v(xbgr.mr_n49273088)
print v(xbgr.mr_n49273200)
print v(xbgr.mr_n49273520)
print v(xbgr.mr_n49273632)
print v(xbgr.mr_n49273952)
print v(xbgr.mr_n49274064)
print v(xbgr.mr_n49274384)
print v(xbgr.mr_n49274496)
print v(xbgr.mr_n49274816)
print v(xbgr.mr_n49274928)
print v(xbgr.mr_n49275248)
print v(xbgr.mr_n49275360)
print v(xbgr.mr_n49275680)
print v(xbgr.mr_n49276544)
print v(xbgr.mr_n49277408)
print v(xbgr.mr_n49277520)
print v(xbgr.mr_n49277952)
print v(xbgr.mr_n49278272)
print v(xbgr.mr_n49278384)
print v(xbgr.mr_n49279136)
print v(xbgr.mr_n49279568)
print v(xbgr.mr_n49279680)
print v(xbgr.mr_n49280000)
print v(xbgr.mr_n49280112)
print v(xbgr.mr_n49280432)
print v(xbgr.mr_n49280544)
print v(xbgr.mr_n49280864)
print v(xbgr.mr_n49280976)
print v(xbgr.mr_n49281296)
print v(xbgr.mr_n49282160)
print v(xbgr.mr_n49282592)
print v(xbgr.mr_n49282704)
print v(xbgr.mr_n49283024)
print v(xbgr.mr_n49283136)
print v(xbgr.mr_n49283456)
print v(xbgr.mr_n49284320)
print v(xbgr.mr_n49285616)
print v(xbgr.mr_n49286480)
print v(xbgr.mr_n49287344)
print v(xbgr.mr_n49287456)
print v(xbgr.mr_n49288208)
print v(xbgr.mr_n49288320)
print v(xbgr.mr_n49288752)
print v(xbgr.mr_n49289184)
print v(xbgr.mr_n49289936)
print v(xbgr.mr_n49290800)
print v(xbgr.mr_n49291664)
print v(xbgr.mr_n49291776)
print v(xbgr.mr_n49292096)
print v(xbgr.mr_n49292208)
print v(xbgr.mr_n49292640)
print v(xbgr.mr_n49292960)
print v(xbgr.mr_n49293072)
print v(xbgr.mr_n49293504)
print v(xbgr.mr_n49293824)
print v(xbgr.mr_n49293936)
print v(xbgr.mr_n49294256)
print v(xbgr.mr_n49294368)
print v(xbgr.mr_n49294688)
print v(xbgr.mr_n49295552)
print v(xbgr.mr_n49295664)
print v(xbgr.mr_n49296096)
print v(xbgr.mr_n49296416)
print v(xbgr.mr_n49297392)
print v(xbgr.mr_n49297712)
print v(xbgr.mr_n49297824)
print v(xbgr.mr_n49298256)
print v(xbgr.mr_n49298576)
print v(xbgr.mr_n49299008)
print v(xbgr.mr_n49299120)
print v(xbgr.mr_n49299440)
print v(xbgr.mr_n49299552)
print v(xbgr.mr_n49299872)
print v(xbgr.mr_n49300304)
print v(xbgr.mr_n49300416)
print v(xbgr.mr_n49300736)
print v(xbgr.mr_n49300848)
print v(xbgr.mr_n49301168)
print v(xbgr.mr_n49301280)
print v(xbgr.mr_n49301600)
print v(xbgr.mr_n49301712)
print v(xbgr.mr_n49302032)
print v(xbgr.mr_n49302144)
print v(xbgr.mr_n49302576)
print v(xbgr.mr_n49302896)
print v(xbgr.mr_n49303008)
print v(xbgr.mr_n49303328)
print v(xbgr.mr_n49303440)
print v(xbgr.mr_n49303760)
print v(xbgr.mr_n49304304)
print v(xbgr.mr_n49305056)
print v(xbgr.mr_n49306352)
print v(xbgr.mr_n49306464)
print v(xbgr.mr_n49306784)
print v(xbgr.mr_n49306896)
print v(xbgr.mr_n49307216)
print v(xbgr.mr_n49308080)
print v(xbgr.mr_n49308944)
print v(xbgr.mr_n49309808)
print v(xbgr.mr_n49309920)
print v(xbgr.mr_n49310240)
print v(xbgr.mr_n49310352)
print v(xbgr.mr_n49310672)
print v(xbgr.mr_n49310784)
print v(xbgr.mr_n49311104)
print v(xbgr.mr_n49311216)
print v(xbgr.mr_n49311536)
print v(xbgr.mr_n49311648)
print v(xbgr.mr_n49311968)
print v(xbgr.mr_n49312832)
print v(xbgr.mr_n49313696)
print v(xbgr.mr_n49314560)
print v(xbgr.mr_n49314672)
print v(xbgr.mr_n49314992)
print v(xbgr.mr_n49315104)
print v(xbgr.mr_n49315424)
print v(xbgr.mr_n49315536)
print v(xbgr.mr_n49315856)
print v(xbgr.mr_n49315968)
print v(xbgr.mr_n49316400)
print v(xbgr.mr_n49316720)
print v(xbgr.mr_n49316832)
print v(xbgr.mr_n49317152)
print v(xbgr.mr_n49317264)
print v(xbgr.mr_n49317584)
print v(xbgr.mr_n49317696)
print v(xbgr.mr_n49318016)
print v(xbgr.mr_n49318128)
print v(xbgr.mr_n49318880)
print v(xbgr.mr_n49319424)
print v(xbgr.mr_n49319856)
print v(xbgr.mr_n49320288)
print v(xbgr.mr_n49320720)
print v(xbgr.mr_n49321040)
print v(xbgr.mr_n49321152)
print v(xbgr.mr_n49321904)
print v(xbgr.mr_n49322768)
print v(xbgr.mr_n49323632)
print v(xbgr.mr_n49324496)
print v(xbgr.mr_n49325360)
print v(xbgr.mr_n49326224)
print v(xbgr.mr_n49327088)
print v(xbgr.mr_n49327200)
print v(xbgr.mr_n49327520)
print v(xbgr.mr_n49327632)
print v(xbgr.mr_n49328064)
print v(xbgr.mr_n49328384)
print v(xbgr.mr_n49328496)
print v(xbgr.mr_n49328928)
print v(xbgr.mr_n49329248)
print v(xbgr.mr_n49329360)
print v(xbgr.mr_n49329680)
print v(xbgr.mr_n49329792)
print v(xbgr.mr_n49330112)
print v(xbgr.mr_n49330224)
print v(xbgr.mr_n49330544)
print v(xbgr.mr_n49330656)
print v(xbgr.mr_n49330976)
print v(xbgr.mr_n49331088)
print v(xbgr.mr_n49331408)
print v(xbgr.mr_n49331520)
print v(xbgr.mr_n49331840)
print v(xbgr.mr_n49332704)
print v(xbgr.mr_n49333136)
print v(xbgr.mr_n49334112)
print v(xbgr.mr_n49334544)
print v(xbgr.mr_n49334976)
print v(xbgr.mr_n49335408)
print v(xbgr.mr_n49335728)
print v(xbgr.mr_n49336592)
print v(xbgr.mr_n49337456)
print v(xbgr.mr_n49338320)
print v(xbgr.mr_n49339184)
print v(xbgr.mr_n49340048)
print v(xbgr.mr_n49340912)
print v(xbgr.mr_n49342208)
print v(xbgr.mr_n49342640)
print v(xbgr.mr_n49343936)
print v(xbgr.mr_n49344048)
print v(xbgr.mr_n49344368)
print v(xbgr.mr_n49344480)
print v(xbgr.mr_n49344800)
print v(xbgr.mr_n49344912)
print v(xbgr.mr_n49345344)
print v(xbgr.mr_n49345776)
print v(xbgr.mr_n49346096)
print v(xbgr.mr_n49346208)
print v(xbgr.mr_n49346528)
print v(xbgr.mr_n49346640)
print v(xbgr.mr_n49346960)
print v(xbgr.mr_n49347072)
print v(xbgr.mr_n49347392)
print v(xbgr.mr_n49347504)
print v(xbgr.mr_n49347936)
print v(xbgr.mr_n49348256)
print v(xbgr.mr_n49349120)
print v(xbgr.mr_n49349232)
print v(xbgr.mr_n49349552)
print v(xbgr.mr_n49349664)
print v(xbgr.mr_n49349984)
print v(xbgr.mr_n49350096)
print v(xbgr.mr_n49350416)
print v(xbgr.mr_n49350528)
print v(xbgr.mr_n49350848)
print v(xbgr.mr_n49351712)
print v(xbgr.mr_n49352144)
print v(xbgr.mr_n49353440)
print v(xbgr.mr_n49353552)
print v(xbgr.mr_n49353872)
print v(xbgr.mr_n49353984)
print v(xbgr.mr_n49354304)
print v(xbgr.mr_n49354416)
print v(xbgr.mr_n49354736)
print v(xbgr.mr_n49355600)
print v(xbgr.mr_n49355712)
print v(xbgr.mr_n49356144)
print v(xbgr.mr_n49356464)
print v(xbgr.mr_n49356576)
print v(xbgr.mr_n49356896)
print v(xbgr.mr_n49357008)
print v(xbgr.mr_n49357328)
print v(xbgr.mr_n49357440)
print v(xbgr.mr_n49357760)
print v(xbgr.mr_n49357872)
print v(xbgr.mr_n49358304)
print v(xbgr.mr_n49358624)
print v(xbgr.mr_n49359488)
print v(xbgr.mr_n49359600)
print v(xbgr.mr_n49359920)
print v(xbgr.mr_n49360784)
print v(xbgr.mr_n49360896)
print v(xbgr.mr_n49361216)
print v(xbgr.mr_n49361328)
print v(xbgr.mr_n49361648)
print v(xbgr.mr_n49362192)
print v(xbgr.mr_n49362624)
print v(xbgr.mr_n49362944)
print v(xbgr.mr_n49363376)
print v(xbgr.mr_n49363488)
print v(xbgr.mr_n49363808)
print v(xbgr.mr_n49363920)
print v(xbgr.mr_n49364240)
print v(xbgr.mr_n49364352)
print v(xbgr.mr_n49364672)
print v(xbgr.mr_n49364784)
print v(xbgr.mr_n49365104)
print v(xbgr.mr_n49365216)
print v(xbgr.mr_n49365968)
print v(xbgr.mr_n49366080)
print v(xbgr.mr_n49366400)
print v(xbgr.mr_n49366512)
print v(xbgr.mr_n49366832)
print v(xbgr.mr_n49368128)
print v(xbgr.mr_n49368240)
print v(xbgr.mr_n49368560)
print v(xbgr.mr_n49368672)
print v(xbgr.mr_n49368992)
print v(xbgr.mr_n49369968)
print v(xbgr.mr_n49370288)
print v(xbgr.mr_n49371152)
print v(xbgr.mr_n49371584)
print v(xbgr.mr_n49371696)
print v(xbgr.mr_n49372016)
print v(xbgr.mr_n49372128)
print v(xbgr.mr_n49372448)
print v(xbgr.mr_n49372560)
print v(xbgr.mr_n49372880)
print v(xbgr.mr_n49373744)
print v(xbgr.mr_n49375040)
print v(xbgr.mr_n49375904)
print v(xbgr.mr_n49376880)
print v(xbgr.mr_n49377200)
print v(xbgr.mr_n49377312)
print v(xbgr.mr_n49377744)
print v(xbgr.mr_n49378064)
print v(xbgr.mr_n49378176)
print v(xbgr.mr_n49378496)
print v(xbgr.mr_n49378608)
print v(xbgr.mr_n49378928)
print v(xbgr.mr_n49379040)
print v(xbgr.mr_n49379360)
print v(xbgr.mr_n49379472)
print v(xbgr.mr_n49379792)
print v(xbgr.mr_n49379904)
print v(xbgr.mr_n49380224)
print v(xbgr.mr_n49380336)
print v(xbgr.mr_n49380656)
print v(xbgr.mr_n49380768)
print v(xbgr.mr_n49381088)
print v(xbgr.mr_n49381200)
print v(xbgr.mr_n49381632)
print v(xbgr.mr_n49381952)
print v(xbgr.mr_n49382064)
print v(xbgr.mr_n49382496)
print v(xbgr.mr_n49382816)
print v(xbgr.mr_n49383680)
print v(xbgr.mr_n49384544)
print v(xbgr.mr_n49385408)
print v(xbgr.mr_n49385520)
print v(xbgr.mr_n49385840)
print v(xbgr.mr_n49385952)
print v(xbgr.mr_n49386272)
print v(xbgr.mr_n49386384)
print v(xbgr.mr_n49386704)
print v(xbgr.mr_n49386816)
print v(xbgr.mr_n49387248)
print v(xbgr.mr_n49387680)
print v(xbgr.mr_n49388112)
print v(xbgr.mr_n49388544)
print v(xbgr.mr_n49388864)
print v(xbgr.mr_n49388976)
print v(xbgr.mr_n49389296)
print v(xbgr.mr_n49389408)
print v(xbgr.mr_n49389728)
print v(xbgr.mr_n49389840)
print v(xbgr.mr_n49390160)
print v(xbgr.mr_n49390272)
print v(xbgr.mr_n49390592)
print v(xbgr.mr_n49390704)
print v(xbgr.mr_n49391024)
print v(xbgr.mr_n49391136)
print v(xbgr.mr_n49391456)
print v(xbgr.mr_n49391568)
print v(xbgr.mr_n49392000)
print v(xbgr.mr_n49392320)
print v(xbgr.mr_n49392432)
print v(xbgr.mr_n49392752)
print v(xbgr.mr_n49393616)
print v(xbgr.mr_n49394352)
print v(xbgr.mr_n49395216)
print v(xbgr.mr_n49396080)
print v(xbgr.mr_n49396944)
print v(xbgr.mr_n49397808)
print v(xbgr.mr_n49397920)
print v(xbgr.mr_n49398352)
print v(xbgr.mr_n49398672)
print v(xbgr.mr_n49398784)
print v(xbgr.mr_n49399216)
print v(xbgr.mr_n49399536)
print v(xbgr.mr_n49399648)
print v(xbgr.mr_n49399968)
print v(xbgr.mr_n49400080)
print v(xbgr.mr_n49400400)
print v(xbgr.mr_n49400512)
print v(xbgr.mr_n49400944)
print v(xbgr.mr_n49401264)
print v(xbgr.mr_n49402128)
print v(xbgr.mr_n49402240)
print v(xbgr.mr_n49402560)
print v(xbgr.mr_n49402672)
print v(xbgr.mr_n49402992)
print v(xbgr.mr_n49403104)
print v(xbgr.mr_n49403424)
print v(xbgr.mr_n49403536)
print v(xbgr.mr_n49403856)
print v(xbgr.mr_n49403968)
print v(xbgr.mr_n49404288)
print v(xbgr.mr_n49404400)
print v(xbgr.mr_n49404720)
print v(xbgr.mr_n49404832)
print v(xbgr.mr_n49405152)
print v(xbgr.mr_n49405584)
print v(xbgr.mr_n49405696)
print v(xbgr.mr_n49406016)
print v(xbgr.mr_n49406128)
print v(xbgr.mr_n49406448)
print v(xbgr.mr_n49406560)
print v(xbgr.mr_n49406880)
print v(xbgr.mr_n49406992)
print v(xbgr.mr_n49407312)
print v(xbgr.mr_n49408608)
print v(xbgr.mr_n49409472)
print v(xbgr.mr_n49410016)
print v(xbgr.mr_n49410448)
print v(xbgr.mr_n49410768)
print v(xbgr.mr_n49410880)
print v(xbgr.mr_n49411200)
print v(xbgr.mr_n49411312)
print v(xbgr.mr_n49411632)
print v(xbgr.mr_n49411744)
print v(xbgr.mr_n49412064)
print v(xbgr.mr_n49412176)
print v(xbgr.mr_n49412496)
print v(xbgr.mr_n49412608)
print v(xbgr.mr_n49412928)
print v(xbgr.mr_n49413040)
print v(xbgr.mr_n49413360)
print v(xbgr.mr_n49413472)
print v(xbgr.mr_n49413792)
print v(xbgr.mr_n49413904)
print v(xbgr.mr_n49414224)
print v(xbgr.mr_n49414336)
print v(xbgr.mr_n49414656)
print v(xbgr.mr_n49415520)
print v(xbgr.mr_n49416384)
print v(xbgr.mr_n49416496)
print v(xbgr.mr_n49416928)
print v(xbgr.mr_n49417680)
print v(xbgr.mr_n49418544)
print v(xbgr.mr_n49419408)
print v(xbgr.mr_n49420384)
print v(xbgr.mr_n49420816)
print v(xbgr.mr_n49421136)
print v(xbgr.mr_n49421248)
print v(xbgr.mr_n49421568)
print v(xbgr.mr_n49421680)
print v(xbgr.mr_n49422000)
print v(xbgr.mr_n49422864)
print v(xbgr.mr_n49423728)
print v(xbgr.mr_n49423840)
print v(xbgr.mr_n49424160)
print v(xbgr.mr_n49424272)
print v(xbgr.mr_n49424592)
print v(xbgr.mr_n49424704)
print v(xbgr.mr_n49425024)
print v(xbgr.mr_n49425136)
print v(xbgr.mr_n49425456)
print v(xbgr.mr_n49425568)
print v(xbgr.mr_n49425888)
print v(xbgr.mr_n49426000)
print v(xbgr.mr_n49426320)
print v(xbgr.mr_n49426432)
print v(xbgr.mr_n49426752)
print v(xbgr.mr_n49426864)
print v(xbgr.mr_n49427184)
print v(xbgr.mr_n49427296)
print v(xbgr.mr_n49427728)
print v(xbgr.mr_n49428048)
print v(xbgr.mr_n49428480)
print v(xbgr.mr_n49428592)
print v(xbgr.mr_n49429344)
print v(xbgr.mr_n49429456)
print v(xbgr.mr_n49429888)
print v(xbgr.mr_n49430640)
print v(xbgr.mr_n49430752)
print v(xbgr.mr_n49431072)
print v(xbgr.mr_n49431184)
print v(xbgr.mr_n49431616)
print v(xbgr.mr_n49432048)
print v(xbgr.mr_n49432480)
print v(xbgr.mr_n49432800)
print v(xbgr.mr_n49432912)
print v(xbgr.mr_n49433232)
print v(xbgr.mr_n49433344)
print v(xbgr.mr_n49433776)
print v(xbgr.mr_n49434096)
print v(xbgr.mr_n49434960)
print v(xbgr.mr_n49435072)
print v(xbgr.mr_n49435392)
print v(xbgr.mr_n49435504)
print v(xbgr.mr_n49435824)
print v(xbgr.mr_n49435936)
print v(xbgr.mr_n49436256)
print v(xbgr.mr_n49436368)
print v(xbgr.mr_n49436688)
print v(xbgr.mr_n49436800)
print v(xbgr.mr_n49437120)
print v(xbgr.mr_n49437232)
print v(xbgr.mr_n49437552)
print v(xbgr.mr_n49438416)
print v(xbgr.mr_n49439280)
print v(xbgr.mr_n49439392)
print v(xbgr.mr_n49439712)
print v(xbgr.mr_n49439824)
print v(xbgr.mr_n49440144)
print v(xbgr.mr_n49440256)
print v(xbgr.mr_n49440576)
print v(xbgr.mr_n49440688)
print v(xbgr.mr_n49441008)
print v(xbgr.mr_n49441872)
print v(xbgr.mr_n49442736)
print v(xbgr.mr_n49443600)
print v(xbgr.mr_n49444464)
print v(xbgr.mr_n49445872)
print v(xbgr.mr_n49446192)
print v(xbgr.mr_n49447056)
print v(xbgr.mr_n49447920)
print v(xbgr.mr_n49448032)
print v(xbgr.mr_n49448464)
print v(xbgr.mr_n49448784)
print v(xbgr.mr_n49448896)
print v(xbgr.mr_n49449328)
print v(xbgr.mr_n49449648)
print v(xbgr.mr_n49450512)
print v(xbgr.mr_n49451376)
print v(xbgr.mr_n49452240)
print v(xbgr.mr_n49453104)
print v(xbgr.mr_n49453216)
print v(xbgr.mr_n49453536)
print v(xbgr.mr_n49453648)
print v(xbgr.mr_n49453968)
print v(xbgr.mr_n49454080)
print v(xbgr.mr_n49454400)
print v(xbgr.mr_n49454512)
print v(xbgr.mr_n49454832)
print v(xbgr.mr_n49455696)
print v(xbgr.mr_n49456560)
print v(xbgr.mr_n49456672)
print v(xbgr.mr_n49456992)
print v(xbgr.mr_n49457104)
print v(xbgr.mr_n49457536)
print v(xbgr.mr_n49457968)
print v(xbgr.mr_n49458288)
print v(xbgr.mr_n49458400)
print v(xbgr.mr_n49458720)
print v(xbgr.mr_n49458832)
print v(xbgr.mr_n49459152)
print v(xbgr.mr_n49459264)
print v(xbgr.mr_n49459584)
print v(xbgr.mr_n49459696)
print v(xbgr.mr_n49460016)
print v(xbgr.mr_n49460128)
print v(xbgr.mr_n49460560)
print v(xbgr.mr_n49460880)
print v(xbgr.mr_n49460992)
print v(xbgr.mr_n49461424)
print v(xbgr.mr_n49461744)
print v(xbgr.mr_n49462608)
print v(xbgr.mr_n49463472)
print v(xbgr.mr_n49464336)
print v(xbgr.mr_n49465200)
print v(xbgr.mr_n49465312)
print v(xbgr.mr_n49465632)
print v(xbgr.mr_n49465744)
print v(xbgr.mr_n49466064)
print v(xbgr.mr_n49466176)
print v(xbgr.mr_n49466496)
print v(xbgr.mr_n49466608)
print v(xbgr.mr_n49466928)
print v(xbgr.mr_n49467792)
print v(xbgr.mr_n49468656)
print v(xbgr.mr_n49468768)
print v(xbgr.mr_n49469088)
print v(xbgr.mr_n49469200)
print v(xbgr.mr_n49469632)
print v(xbgr.mr_n49470064)
print v(xbgr.mr_n49470384)
print v(xbgr.mr_n49470496)
print v(xbgr.mr_n49470816)
print v(xbgr.mr_n49470928)
print v(xbgr.mr_n49471248)
print v(xbgr.mr_n49471360)
print v(xbgr.mr_n49471680)
print v(xbgr.mr_n49471792)
print v(xbgr.mr_n49472112)
print v(xbgr.mr_n49472224)
print v(xbgr.mr_n49472656)
print v(xbgr.mr_n49472976)
print v(xbgr.mr_n49473088)
print v(xbgr.mr_n49473520)
print v(xbgr.mr_n49473840)
print v(xbgr.mr_n49473952)
print v(xbgr.mr_n49474384)
print v(xbgr.mr_n49474704)
print v(xbgr.mr_n49474816)
print v(xbgr.mr_n49475248)
print v(xbgr.mr_n49475568)
print v(xbgr.mr_n49476432)
print v(xbgr.mr_n49477296)
print v(xbgr.mr_n49478160)
print v(xbgr.mr_n49479024)
print v(xbgr.mr_n49479888)
print v(xbgr.mr_n49480752)
print v(xbgr.mr_n49480864)
print v(xbgr.mr_n49481184)
print v(xbgr.mr_n49481296)
print v(xbgr.mr_n49481616)
print v(xbgr.mr_n49481728)
print v(xbgr.mr_n49482048)
print v(xbgr.mr_n49482160)
print v(xbgr.mr_n49482480)
print v(xbgr.mr_n49482592)
print v(xbgr.mr_n49482912)
print v(xbgr.mr_n49483024)
print v(xbgr.mr_n49483344)
print v(xbgr.mr_n49483456)
print v(xbgr.mr_n49483776)
print v(xbgr.mr_n49483888)
print v(xbgr.mr_n49484208)
print v(xbgr.mr_n49484320)
print v(xbgr.mr_n49484640)
print v(xbgr.mr_n49484752)
print v(xbgr.mr_n49485184)
print v(xbgr.mr_n49485616)
print v(xbgr.mr_n49485936)
print v(xbgr.mr_n49486800)
print v(xbgr.mr_n49487664)
print v(xbgr.mr_n49487776)
print v(xbgr.mr_n49488096)
print v(xbgr.mr_n49488208)
print v(xbgr.mr_n49488528)
print v(xbgr.mr_n49488640)
print v(xbgr.mr_n49488960)
print v(xbgr.mr_n49489072)
print v(xbgr.mr_n49489392)
print v(xbgr.mr_n49489504)
print v(xbgr.mr_n49489824)
print v(xbgr.mr_n49489936)
print v(xbgr.mr_n49490256)
print v(xbgr.mr_n49490368)
print v(xbgr.mr_n49490688)
print v(xbgr.mr_n49490800)
print v(xbgr.mr_n49491232)
print v(xbgr.mr_n49491664)
print v(xbgr.mr_n49491984)
print v(xbgr.mr_n49492096)
print v(xbgr.mr_n49492416)
print v(xbgr.mr_n49492528)
print v(xbgr.mr_n49492848)
print v(xbgr.mr_n49492960)
print v(xbgr.mr_n49493280)
print v(xbgr.mr_n49493392)
print v(xbgr.mr_n49493712)
print v(xbgr.mr_n49493824)
print v(xbgr.mr_n49494144)
print v(xbgr.mr_n49494256)
print v(xbgr.mr_n49494576)
print v(xbgr.mr_n49495440)
print v(xbgr.mr_n49496304)
print v(xbgr.mr_n49497168)
print v(xbgr.mr_n49498032)
print v(xbgr.mr_n49498144)
print v(xbgr.mr_n49498576)
print v(xbgr.mr_n49498896)
print v(xbgr.mr_n49499008)
print v(xbgr.mr_n49499328)
print v(xbgr.mr_n49499440)
print v(xbgr.mr_n49499760)
print v(xbgr.mr_n49499872)
print v(xbgr.mr_n49500192)
print v(xbgr.mr_n49500304)
print v(xbgr.mr_n49500624)
print v(xbgr.mr_n49500736)
print v(xbgr.mr_n49501056)
print v(xbgr.mr_n49501168)
print v(xbgr.mr_n49501488)
print v(xbgr.mr_n49501600)
print v(xbgr.mr_n49502032)
print v(xbgr.mr_n49502352)
print v(xbgr.mr_n49503216)
print v(xbgr.mr_n49503328)
print v(xbgr.mr_n49503648)
print v(xbgr.mr_n49503760)
print v(xbgr.mr_n49504080)
print v(xbgr.mr_n49504192)
print v(xbgr.mr_n49504512)
print v(xbgr.mr_n49504624)
print v(xbgr.mr_n49504944)
print v(xbgr.mr_n49505056)
print v(xbgr.mr_n49505488)
print v(xbgr.mr_n49505808)
print v(xbgr.mr_n49505920)
print v(xbgr.mr_n49506352)
print v(xbgr.mr_n49506672)
print v(xbgr.mr_n49507536)
print v(xbgr.mr_n49508400)
print v(xbgr.mr_n49509264)
print v(xbgr.mr_n49510128)
print v(xbgr.mr_n49510240)
print v(xbgr.mr_n49510560)
print v(xbgr.mr_n49510672)
print v(xbgr.mr_n49510992)
print v(xbgr.mr_n49511104)
print v(xbgr.mr_n49511424)
print v(xbgr.mr_n49511536)
print v(xbgr.mr_n49511856)
print v(xbgr.mr_n49511968)
print v(xbgr.mr_n49512288)
print v(xbgr.mr_n49512400)
print v(xbgr.mr_n49512720)
print v(xbgr.mr_n49513584)
print v(xbgr.mr_n49514448)
print v(xbgr.mr_n49514560)
print v(xbgr.mr_n49514880)
print v(xbgr.mr_n49514992)
print v(xbgr.mr_n49515424)
print v(xbgr.mr_n49515856)
print v(xbgr.mr_n49516176)
print v(xbgr.mr_n49516288)
print v(xbgr.mr_n49516608)
print v(xbgr.mr_n49516720)
print v(xbgr.mr_n49517040)
print v(xbgr.mr_n49517152)
print v(xbgr.mr_n49517472)
print v(xbgr.mr_n49517584)
print v(xbgr.mr_n49517904)
print v(xbgr.mr_n49518768)
print v(xbgr.mr_n49519632)
print v(xbgr.mr_n49520496)
print v(xbgr.mr_n49521360)
print v(xbgr.mr_n49522224)
print v(xbgr.mr_n49522336)
print v(xbgr.mr_n49522656)
print v(xbgr.mr_n49522768)
print v(xbgr.mr_n49523088)
print v(xbgr.mr_n49523200)
print v(xbgr.mr_n49523520)
print v(xbgr.mr_n49523632)
print v(xbgr.mr_n49523952)
print v(xbgr.mr_n49524064)
print v(xbgr.mr_n49524496)
print v(xbgr.mr_n49524816)
print v(xbgr.mr_n49524928)
print v(xbgr.mr_n49525360)
print v(xbgr.mr_n49525680)
print v(xbgr.mr_n49525792)
print v(xbgr.mr_n49526224)
print v(xbgr.mr_n49526544)
print v(xbgr.mr_n49526656)
print v(xbgr.mr_n49527088)
print v(xbgr.mr_n49527408)
print v(xbgr.mr_n49528272)
print v(xbgr.mr_n49528384)
print v(xbgr.mr_n49528704)
print v(xbgr.mr_n49528816)
print v(xbgr.mr_n49529136)
print v(xbgr.mr_n49529248)
print v(xbgr.mr_n49529568)
print v(xbgr.mr_n49529680)
print v(xbgr.mr_n49530000)
print v(xbgr.mr_n49530864)
print v(xbgr.mr_n49531728)
print v(xbgr.mr_n49532592)
print v(xbgr.mr_n49533456)
print v(xbgr.mr_n49534320)
print v(xbgr.mr_n49534432)
print v(xbgr.mr_n49534752)
print v(xbgr.mr_n49534864)
print v(xbgr.mr_n49535184)
print v(xbgr.mr_n49535296)
print v(xbgr.mr_n49535616)
print v(xbgr.mr_n49535728)
print v(xbgr.mr_n49536160)
print v(xbgr.mr_n49536592)
print v(xbgr.mr_n49536912)
print v(xbgr.mr_n49537024)
print v(xbgr.mr_n49537344)
print v(xbgr.mr_n49537456)
print v(xbgr.mr_n49537776)
print v(xbgr.mr_n49538640)
print v(xbgr.mr_n49538752)
print v(xbgr.mr_n49539072)
print v(xbgr.mr_n49539184)
print v(xbgr.mr_n49539504)
print v(xbgr.mr_n49540368)
print v(xbgr.mr_n49541232)
print v(xbgr.mr_n49541344)
print v(xbgr.mr_n49541664)
print v(xbgr.mr_n49541776)
print v(xbgr.mr_n49542096)
print v(xbgr.mr_n49542960)
print v(xbgr.mr_n49543824)
print v(xbgr.mr_n49544688)
print v(xbgr.mr_n49544800)
print v(xbgr.mr_n49545120)
print v(xbgr.mr_n49545232)
print v(xbgr.mr_n49545552)
print v(xbgr.mr_n49545664)
print v(xbgr.mr_n49545984)
print v(xbgr.mr_n49546096)
print v(xbgr.mr_n49546416)
print v(xbgr.mr_n49546528)
print v(xbgr.mr_n49546848)
print v(xbgr.mr_n49546960)
print v(xbgr.mr_n49547280)
print v(xbgr.mr_n49547392)
print v(xbgr.mr_n49547712)
print v(xbgr.mr_n49547824)
print v(xbgr.mr_n49548144)
print v(xbgr.mr_n49548256)
print v(xbgr.mr_n49548576)
print v(xbgr.mr_n49548688)
print v(xbgr.mr_n49549008)
print v(xbgr.mr_n49549120)
print v(xbgr.mr_n49549440)
print v(xbgr.mr_n49549552)
print v(xbgr.mr_n49549984)
print v(xbgr.mr_n49550304)
print v(xbgr.mr_n49550416)
print v(xbgr.mr_n49550848)
print v(xbgr.mr_n49551168)
print v(xbgr.mr_n49551280)
print v(xbgr.mr_n49551712)
print v(xbgr.mr_n49552032)
print v(xbgr.mr_n49552896)
print v(xbgr.mr_n49553760)
print v(xbgr.mr_n49554624)
print v(xbgr.mr_n49554736)
print v(xbgr.mr_n49555056)
print v(xbgr.mr_n49555168)
print v(xbgr.mr_n49555488)
print v(xbgr.mr_n49556352)
print v(xbgr.mr_n49557216)
print v(xbgr.mr_n49558080)
print v(xbgr.mr_n49558192)
print v(xbgr.mr_n49558512)
print v(xbgr.mr_n49558624)
print v(xbgr.mr_n49558944)
print v(xbgr.mr_n49559056)
print v(xbgr.mr_n49559376)
print v(xbgr.mr_n49559488)
print v(xbgr.mr_n49559808)
print v(xbgr.mr_n49559920)
print v(xbgr.mr_n49560240)
print v(xbgr.mr_n49560352)
print v(xbgr.mr_n49560672)
print v(xbgr.mr_n49560784)
print v(xbgr.mr_n49561104)
print v(xbgr.mr_n49561216)
print v(xbgr.mr_n49561536)
print v(xbgr.mr_n49561648)
print v(xbgr.mr_n49561968)
print v(xbgr.mr_n49562080)
print v(xbgr.mr_n49562400)
print v(xbgr.mr_n49562512)
print v(xbgr.mr_n49562832)
print v(xbgr.mr_n49562944)
print v(xbgr.mr_n49563264)
print v(xbgr.mr_n49563376)
print v(xbgr.mr_n49563808)
print v(xbgr.mr_n49564128)
print v(xbgr.mr_n49564992)
print v(xbgr.mr_n49565856)
print v(xbgr.mr_n49566720)
print v(xbgr.mr_n49566832)
print v(xbgr.mr_n49567264)
print v(xbgr.mr_n49567584)
print v(xbgr.mr_n49567696)
print v(xbgr.mr_n49568128)
print v(xbgr.mr_n49568448)
print v(xbgr.mr_n49568560)
print v(xbgr.mr_n49568880)
print v(xbgr.mr_n49568992)
print v(xbgr.mr_n49569312)
print v(xbgr.mr_n49569424)
print v(xbgr.mr_n49569856)
print v(xbgr.mr_n49570288)
print v(xbgr.mr_n49570720)
print v(xbgr.mr_n49571040)
print v(xbgr.mr_n49571904)
print v(xbgr.mr_n49572768)
print v(xbgr.mr_n49573632)
print v(xbgr.mr_n49574496)
print v(xbgr.mr_n49575360)
print v(xbgr.mr_n49576224)
print v(xbgr.mr_n49576336)
print v(xbgr.mr_n49576656)
print v(xbgr.mr_n49576768)
print v(xbgr.mr_n49577088)
print v(xbgr.mr_n49577200)
print v(xbgr.mr_n49577520)
print v(xbgr.mr_n49577632)
print v(xbgr.mr_n49577952)
print v(xbgr.mr_n49578064)
print v(xbgr.mr_n49578384)
print v(xbgr.mr_n49578496)
print v(xbgr.mr_n49578816)
print v(xbgr.mr_n49579680)
print v(xbgr.mr_n49580544)
print v(xbgr.mr_n49581520)
print v(xbgr.mr_n49581952)
print v(xbgr.mr_n49582384)
print v(xbgr.mr_n49582704)
print v(xbgr.mr_n49582816)
print v(xbgr.mr_n49583136)
print v(xbgr.mr_n49583248)
print v(xbgr.mr_n49583568)
print v(xbgr.mr_n49583680)
print v(xbgr.mr_n49584112)
print v(xbgr.mr_n49584432)
print v(xbgr.mr_n49584544)
print v(xbgr.mr_n49584864)
print v(xbgr.mr_n49584976)
print v(xbgr.mr_n49585408)
print v(xbgr.mr_n49585728)
print v(xbgr.mr_n49585840)
print v(xbgr.mr_n49586272)
print v(xbgr.mr_n49586592)
print v(xbgr.mr_n49586704)
print v(xbgr.mr_n49587136)
print v(xbgr.mr_n49587456)
print v(xbgr.mr_n49588320)
print v(xbgr.mr_n49589184)
print v(xbgr.mr_n49589296)
print v(xbgr.mr_n49589616)
print v(xbgr.mr_n49589728)
print v(xbgr.mr_n49590048)
print v(xbgr.mr_n49590160)
print v(xbgr.mr_n49590480)
print v(xbgr.mr_n49590592)
print v(xbgr.mr_n49591024)
print v(xbgr.mr_n49591344)
print v(xbgr.mr_n49592208)
print v(xbgr.mr_n49592320)
print v(xbgr.mr_n49592640)
print v(xbgr.mr_n49592752)
print v(xbgr.mr_n49593072)
print v(xbgr.mr_n49593184)
print v(xbgr.mr_n49593504)
print v(xbgr.mr_n49594368)
print v(xbgr.mr_n49594800)
print v(xbgr.mr_n49595664)
print v(xbgr.mr_n49595776)
print v(xbgr.mr_n49596096)
print v(xbgr.mr_n49596208)
print v(xbgr.mr_n49596528)
print v(xbgr.mr_n49596640)
print v(xbgr.mr_n49596960)
print v(xbgr.mr_n49597072)
print v(xbgr.mr_n49597392)
print v(xbgr.mr_n49597504)
print v(xbgr.mr_n49597936)
print v(xbgr.mr_n49598688)
print v(xbgr.mr_n49599552)
print v(xbgr.mr_n49599984)
print v(xbgr.mr_n49600096)
print v(xbgr.mr_n49600416)
print v(xbgr.mr_n49600848)
print v(xbgr.mr_n49601712)
print v(xbgr.mr_n49602576)
print v(xbgr.mr_n49603440)
print v(xbgr.mr_n49604304)
print v(xbgr.mr_n49605600)
print v(xbgr.mr_n49606464)
print v(xbgr.mr_n49607440)
print v(xbgr.mr_n49607760)
print v(xbgr.mr_n49607872)
print v(xbgr.mr_n49608304)
print v(xbgr.mr_n49608624)
print v(xbgr.mr_n49609488)
print v(xbgr.mr_n49609600)
print v(xbgr.mr_n49609920)
print v(xbgr.mr_n49610032)
print v(xbgr.mr_n49610464)
print v(xbgr.mr_n49610784)
print v(xbgr.mr_n49610896)
print v(xbgr.mr_n49611216)
print v(xbgr.mr_n49611328)
print v(xbgr.mr_n49611648)
print v(xbgr.mr_n49611760)
print v(xbgr.mr_n49612080)
print v(xbgr.mr_n49612192)
print v(xbgr.mr_n49612624)
print v(xbgr.mr_n49612944)
print v(xbgr.mr_n49613056)
print v(xbgr.mr_n49613376)
print v(xbgr.mr_n49613488)
print v(xbgr.mr_n49613808)
print v(xbgr.mr_n49614672)
print v(xbgr.mr_n49614784)
print v(xbgr.mr_n49615536)
print v(xbgr.mr_n49615648)
print v(xbgr.mr_n49615968)
print v(xbgr.mr_n49616080)
print v(xbgr.mr_n49616400)
print v(xbgr.mr_n49616512)
print v(xbgr.mr_n49616832)
print v(xbgr.mr_n49616944)
print v(xbgr.mr_n49617264)
print v(xbgr.mr_n49617376)
print v(xbgr.mr_n49617696)
print v(xbgr.mr_n49617808)
print v(xbgr.mr_n49618128)
print v(xbgr.mr_n49618240)
print v(xbgr.mr_n49618560)
print v(xbgr.mr_n49618672)
print v(xbgr.mr_n49618992)
print v(xbgr.mr_n49619104)
print v(xbgr.mr_n49619424)
print v(xbgr.mr_n49619536)
print v(xbgr.mr_n49619856)
print v(xbgr.mr_n49619968)
print v(xbgr.mr_n49620288)
print v(xbgr.mr_n49620400)
print v(xbgr.mr_n49620720)
print v(xbgr.mr_n49620832)
print v(xbgr.mr_n49621264)
print v(xbgr.mr_n49621584)
print v(xbgr.mr_n49621696)
print v(xbgr.mr_n49622128)
print v(xbgr.mr_n49622448)
print v(xbgr.mr_n49622560)
print v(xbgr.mr_n49622992)
print v(xbgr.mr_n49623312)
print v(xbgr.mr_n49624176)
print v(xbgr.mr_n49625040)
print v(xbgr.mr_n49625904)
print v(xbgr.mr_n49626768)
print v(xbgr.mr_n49627632)
print v(xbgr.mr_n49628496)
print v(xbgr.mr_n49628608)
print v(xbgr.mr_n49628928)
print v(xbgr.mr_n49629040)
print v(xbgr.mr_n49629360)
print v(xbgr.mr_n49629472)
print v(xbgr.mr_n49629792)
print v(xbgr.mr_n49629904)
print v(xbgr.mr_n49630224)
print v(xbgr.mr_n49631088)
print v(xbgr.mr_n49631952)
print v(xbgr.mr_n49632816)
print v(xbgr.mr_n49632928)
print v(xbgr.mr_n49633248)
print v(xbgr.mr_n49633360)
print v(xbgr.mr_n49633680)
print v(xbgr.mr_n49633792)
print v(xbgr.mr_n49634224)
print v(xbgr.mr_n49634656)
print v(xbgr.mr_n49635088)
print v(xbgr.mr_n49635408)
print v(xbgr.mr_n49635520)
print v(xbgr.mr_n49635840)
print v(xbgr.mr_n49635952)
print v(xbgr.mr_n49636272)
print v(xbgr.mr_n49636384)
print v(xbgr.mr_n49636704)
print v(xbgr.mr_n49636816)
print v(xbgr.mr_n49637136)
print v(xbgr.mr_n49637248)
print v(xbgr.mr_n49637568)
print v(xbgr.mr_n49637680)
print v(xbgr.mr_n49638000)
print v(xbgr.mr_n49638112)
print v(xbgr.mr_n49638544)
print v(xbgr.mr_n49638864)
print v(xbgr.mr_n49638976)
print v(xbgr.mr_n49639408)
print v(xbgr.mr_n49639728)
print v(xbgr.mr_n49639840)
print v(xbgr.mr_n49640272)
print v(xbgr.mr_n49640592)
print v(xbgr.mr_n49641456)
print v(xbgr.mr_n49642320)
print v(xbgr.mr_n49643184)
print v(xbgr.mr_n49644048)
print v(xbgr.mr_n49644912)
print v(xbgr.mr_n49645776)
print v(xbgr.mr_n49645888)
print v(xbgr.mr_n49646208)
print v(xbgr.mr_n49646320)
print v(xbgr.mr_n49646640)
print v(xbgr.mr_n49646752)
print v(xbgr.mr_n49647072)
print v(xbgr.mr_n49647184)
print v(xbgr.mr_n49647504)
print v(xbgr.mr_n49648368)
print v(xbgr.mr_n49649232)
print v(xbgr.mr_n49650096)
print v(xbgr.mr_n49650208)
print v(xbgr.mr_n49650528)
print v(xbgr.mr_n49650640)
print v(xbgr.mr_n49650960)
print v(xbgr.mr_n49651072)
print v(xbgr.mr_n49651504)
print v(xbgr.mr_n49651824)
print v(xbgr.mr_n49651936)
print v(xbgr.mr_n49652368)
print v(xbgr.mr_n49652688)
print v(xbgr.mr_n49652800)
print v(xbgr.mr_n49653232)
print v(xbgr.mr_n49653552)
print v(xbgr.mr_n49653664)
print v(xbgr.mr_n49653984)
print v(xbgr.mr_n49654096)
print v(xbgr.mr_n49654416)
print v(xbgr.mr_n49654528)
print v(xbgr.mr_n49654960)
print v(xbgr.mr_n49655280)
print v(xbgr.mr_n49656144)
print v(xbgr.mr_n49657008)
print v(xbgr.mr_n49657872)
print v(xbgr.mr_n49657984)
print v(xbgr.mr_n49658304)
print v(xbgr.mr_n49658416)
print v(xbgr.mr_n49658736)
print v(xbgr.mr_n49659600)
print v(xbgr.mr_n49660464)
print v(xbgr.mr_n49661328)
print v(xbgr.mr_n49662192)
print v(xbgr.mr_n49662304)
print v(xbgr.mr_n49662624)
print v(xbgr.mr_n49662736)
print v(xbgr.mr_n49663056)
print v(xbgr.mr_n49663920)
print v(xbgr.mr_n49664464)
print v(xbgr.mr_n49664784)
print v(xbgr.mr_n49664896)
print v(xbgr.mr_n49665216)
print v(xbgr.mr_n49665328)
print v(xbgr.mr_n49665648)
print v(xbgr.mr_n49665760)
print v(xbgr.mr_n49666080)
print v(xbgr.mr_n49666192)
print v(xbgr.mr_n49666624)
print v(xbgr.mr_n49667376)
print v(xbgr.mr_n49668240)
print v(xbgr.mr_n49669104)
print v(xbgr.mr_n49669968)
print v(xbgr.mr_n49670080)
print v(xbgr.mr_n49670400)
print v(xbgr.mr_n49670512)
print v(xbgr.mr_n49670832)
print v(xbgr.mr_n49670944)
print v(xbgr.mr_n49671264)
print v(xbgr.mr_n49671376)
print v(xbgr.mr_n49671696)
print v(xbgr.mr_n49671808)
print v(xbgr.mr_n49672128)
print v(xbgr.mr_n49672240)
print v(xbgr.mr_n49672560)
print v(xbgr.mr_n49672672)
print v(xbgr.mr_n49673104)
print v(xbgr.mr_n49673424)
print v(xbgr.mr_n49673536)
print v(xbgr.mr_n49673856)
print v(xbgr.mr_n49673968)
print v(xbgr.mr_n49674288)
print v(xbgr.mr_n49674400)
print v(xbgr.mr_n49674720)
print v(xbgr.mr_n49674832)
print v(xbgr.mr_n49675152)
print v(xbgr.mr_n49675264)
print v(xbgr.mr_n49675696)
print v(xbgr.mr_n49676016)
print v(xbgr.mr_n49676880)
print v(xbgr.mr_n49676992)
print v(xbgr.mr_n49677312)
print v(xbgr.mr_n49677424)
print v(xbgr.mr_n49677856)
print v(xbgr.mr_n49678288)
print v(xbgr.mr_n49678608)
print v(xbgr.mr_n49678720)
print v(xbgr.mr_n49679040)
print v(xbgr.mr_n49679152)
print v(xbgr.mr_n49679472)
print v(xbgr.mr_n49679584)
print v(xbgr.mr_n49679904)
print v(xbgr.mr_n49680016)
print v(xbgr.mr_n49680336)
print v(xbgr.mr_n49680448)
print v(xbgr.mr_n49680880)
print v(xbgr.mr_n49681200)
print v(xbgr.mr_n49681312)
print v(xbgr.mr_n49681744)
print v(xbgr.mr_n49682064)
print v(xbgr.mr_n49682928)
print v(xbgr.mr_n49683792)
print v(xbgr.mr_n49684656)
print v(xbgr.mr_n49685520)
print v(xbgr.mr_n49685632)
print v(xbgr.mr_n49685952)
print v(xbgr.mr_n49686064)
print v(xbgr.mr_n49686384)
print v(xbgr.mr_n49686496)
print v(xbgr.mr_n49686816)
print v(xbgr.mr_n49686928)
print v(xbgr.mr_n49687248)
print v(xbgr.mr_n49688112)
print v(xbgr.mr_n49688976)
print v(xbgr.mr_n49689088)
print v(xbgr.mr_n49689408)
print v(xbgr.mr_n49689520)
print v(xbgr.mr_n49689952)
print v(xbgr.mr_n49690384)
print v(xbgr.mr_n49690704)
print v(xbgr.mr_n49690816)
print v(xbgr.mr_n49691136)
print v(xbgr.mr_n49691248)
print v(xbgr.mr_n49691568)
print v(xbgr.mr_n49691680)
print v(xbgr.mr_n49692000)
print v(xbgr.mr_n49692112)
print v(xbgr.mr_n49692432)
print v(xbgr.mr_n49693296)
print v(xbgr.mr_n49694160)
print v(xbgr.mr_n49695024)
print v(xbgr.mr_n49695888)
print v(xbgr.mr_n49696752)
print v(xbgr.mr_n49696864)
print v(xbgr.mr_n49697296)
print v(xbgr.mr_n49697616)
print v(xbgr.mr_n49697728)
print v(xbgr.mr_n49698160)
print v(xbgr.mr_n49698480)
print v(xbgr.mr_n49698592)
print v(xbgr.mr_n49699024)
print v(xbgr.mr_n49699344)
print v(xbgr.mr_n49699456)
print v(xbgr.mr_n49699776)
print v(xbgr.mr_n49699888)
print v(xbgr.mr_n49700208)
print v(xbgr.mr_n49700320)
print v(xbgr.mr_n49700640)
print v(xbgr.mr_n49700752)
print v(xbgr.mr_n49701072)
print v(xbgr.mr_n49701184)
print v(xbgr.mr_n49701504)
print v(xbgr.mr_n49701616)
print v(xbgr.mr_n49701936)
print v(xbgr.mr_n49702048)
print v(xbgr.mr_n49702368)
print v(xbgr.mr_n49702480)
print v(xbgr.mr_n49702800)
print v(xbgr.mr_n49702912)
print v(xbgr.mr_n49703232)
print v(xbgr.mr_n49703344)
print v(xbgr.mr_n49703664)
print v(xbgr.mr_n49703776)
print v(xbgr.mr_n49704096)
print v(xbgr.mr_n49704208)
print v(xbgr.mr_n49704528)
print v(xbgr.mr_n49705392)
print v(xbgr.mr_n49706256)
print v(xbgr.mr_n49707120)
print v(xbgr.mr_n49707232)
print v(xbgr.mr_n49707664)
print v(xbgr.mr_n49707984)
print v(xbgr.mr_n49708096)
print v(xbgr.mr_n49708416)
print v(xbgr.mr_n49708528)
print v(xbgr.mr_n49708848)
print v(xbgr.mr_n49708960)
print v(xbgr.mr_n49709280)
print v(xbgr.mr_n49709392)
print v(xbgr.mr_n49709824)
print v(xbgr.mr_n49710256)
print v(xbgr.mr_n49710688)
print v(xbgr.mr_n49711120)
print v(xbgr.mr_n49711440)
print v(xbgr.mr_n49711552)
print v(xbgr.mr_n49711984)
print v(xbgr.mr_n49712304)
print v(xbgr.mr_n49713168)
print v(xbgr.mr_n49713280)
print v(xbgr.mr_n49713600)
print v(xbgr.mr_n49713712)
print v(xbgr.mr_n49714032)
print v(xbgr.mr_n49714144)
print v(xbgr.mr_n49714464)
print v(xbgr.mr_n49715440)
print v(xbgr.mr_n49715872)
print v(xbgr.mr_n49716304)
print v(xbgr.mr_n49716624)
print v(xbgr.mr_n49717488)
print v(xbgr.mr_n49717600)
print v(xbgr.mr_n49717920)
print v(xbgr.mr_n49718032)
print v(xbgr.mr_n49718352)
print v(xbgr.mr_n49718464)
print v(xbgr.mr_n49718784)
print v(xbgr.mr_n49718896)
print v(xbgr.mr_n49719216)
print v(xbgr.mr_n49719328)
print v(xbgr.mr_n49719648)
print v(xbgr.mr_n49719760)
print v(xbgr.mr_n49720080)
print v(xbgr.mr_n49720192)
print v(xbgr.mr_n49720512)
print v(xbgr.mr_n49720624)
print v(xbgr.mr_n49720944)
print v(xbgr.mr_n49721808)
print v(xbgr.mr_n49722672)
print v(xbgr.mr_n49723536)
print v(xbgr.mr_n49724400)
print v(xbgr.mr_n49725264)
print v(xbgr.mr_n49726128)
print v(xbgr.mr_n49726992)
print v(xbgr.mr_n49727856)
print v(xbgr.mr_n49728720)
print v(xbgr.mr_n49729584)
print v(xbgr.mr_n49730448)
print v(xbgr.mr_n49731312)
print v(xbgr.mr_n49731424)
print v(xbgr.mr_n49731744)
print v(xbgr.mr_n49731856)
print v(xbgr.mr_n49732176)
print v(xbgr.mr_n49732288)
print v(xbgr.mr_n49732608)
print v(xbgr.mr_n49732720)
print v(xbgr.mr_n49733040)
print v(xbgr.mr_n49733152)
print v(xbgr.mr_n49733584)
print v(xbgr.mr_n49733904)
print v(xbgr.mr_n49734016)
print v(xbgr.mr_n49734448)
print v(xbgr.mr_n49734768)
print v(xbgr.mr_n49735632)
print v(xbgr.mr_n49736496)
print v(xbgr.mr_n49737360)
print v(xbgr.mr_n49738224)
print v(xbgr.mr_n49738336)
print v(xbgr.mr_n49738656)
print v(xbgr.mr_n49738768)
print v(xbgr.mr_n49739088)
print v(xbgr.mr_n49739200)
print v(xbgr.mr_n49739520)
print v(xbgr.mr_n49739632)
print v(xbgr.mr_n49739952)
print v(xbgr.mr_n49740064)
print v(xbgr.mr_n49740384)
print v(xbgr.mr_n49740496)
print v(xbgr.mr_n49740816)
print v(xbgr.mr_n49740928)
print v(xbgr.mr_n49741248)
print v(xbgr.mr_n49742112)
print v(xbgr.mr_n49742976)
print v(xbgr.mr_n49743088)
print v(xbgr.mr_n49743408)
print v(xbgr.mr_n49743520)
print v(xbgr.mr_n49743952)
print v(xbgr.mr_n49744384)
print v(xbgr.mr_n49744704)
print v(xbgr.mr_n49744816)
print v(xbgr.mr_n49745136)
print v(xbgr.mr_n49745248)
print v(xbgr.mr_n49745568)
print v(xbgr.mr_n49745680)
print v(xbgr.mr_n49746000)
print v(xbgr.mr_n49746112)
print v(xbgr.mr_n49746432)
print v(xbgr.mr_n49746544)
print v(xbgr.mr_n49746976)
print v(xbgr.mr_n49747296)
print v(xbgr.mr_n49747408)
print v(xbgr.mr_n49747840)
print v(xbgr.mr_n49748160)
print v(xbgr.mr_n49748272)
print v(xbgr.mr_n49748592)
print v(xbgr.mr_n49749456)
print v(xbgr.mr_n49750320)
print v(xbgr.mr_n49751184)
print v(xbgr.mr_n49752048)
print v(xbgr.mr_n49752160)
print v(xbgr.mr_n49752480)
print v(xbgr.mr_n49752592)
print v(xbgr.mr_n49752912)
print v(xbgr.mr_n49753024)
print v(xbgr.mr_n49753344)
print v(xbgr.mr_n49753456)
print v(xbgr.mr_n49753776)
print v(xbgr.mr_n49753888)
print v(xbgr.mr_n49754208)
print v(xbgr.mr_n49754320)
print v(xbgr.mr_n49754640)
print v(xbgr.mr_n49755504)
print v(xbgr.mr_n49756368)
print v(xbgr.mr_n49756480)
print v(xbgr.mr_n49756912)
print v(xbgr.mr_n49757232)
print v(xbgr.mr_n49757344)
print v(xbgr.mr_n49757664)
print v(xbgr.mr_n49757776)
print v(xbgr.mr_n49758096)
print v(xbgr.mr_n49758208)
print v(xbgr.mr_n49758528)
print v(xbgr.mr_n49758640)
print v(xbgr.mr_n49758960)
print v(xbgr.mr_n49759072)
print v(xbgr.mr_n49759392)
print v(xbgr.mr_n49759504)
print v(xbgr.mr_n49759936)
print v(xbgr.mr_n49760368)
print v(xbgr.mr_n49760800)
print v(xbgr.mr_n49761232)
print v(xbgr.mr_n49761552)
print v(xbgr.mr_n49761984)
print v(xbgr.mr_n49762096)
print v(xbgr.mr_n49762416)
print v(xbgr.mr_n49762528)
print v(xbgr.mr_n49762848)
print v(xbgr.mr_n49762960)
print v(xbgr.mr_n49763280)
print v(xbgr.mr_n49763392)
print v(xbgr.mr_n49763712)
print v(xbgr.mr_n49763824)
print v(xbgr.mr_n49764144)
print v(xbgr.mr_n49764256)
print v(xbgr.mr_n49765008)
print v(xbgr.mr_n49765120)
print v(xbgr.mr_n49765552)
print v(xbgr.mr_n49765872)
print v(xbgr.mr_n49766304)
print v(xbgr.mr_n49766416)
print v(xbgr.mr_n49766848)
print v(xbgr.mr_n49767168)
print v(xbgr.mr_n49767280)
print v(xbgr.mr_n49767712)
print v(xbgr.mr_n49768032)
print v(xbgr.mr_n49768144)
print v(xbgr.mr_n49768576)
print v(xbgr.mr_n49769328)
print v(xbgr.mr_n49770192)
print v(xbgr.mr_n49771056)
print v(xbgr.mr_n49771920)
print v(xbgr.mr_n49772784)
print v(xbgr.mr_n49773648)
print v(xbgr.mr_n49773760)
print v(xbgr.mr_n49774080)
print v(xbgr.mr_n49774192)
print v(xbgr.mr_n49774512)
print v(xbgr.mr_n49774624)
print v(xbgr.mr_n49774944)
print v(xbgr.mr_n49775056)
print v(xbgr.mr_n49775376)
print v(xbgr.mr_n49776240)
print v(xbgr.mr_n49777104)
print v(xbgr.mr_n49777968)
print v(xbgr.mr_n49778080)
print v(xbgr.mr_n49778400)
print v(xbgr.mr_n49778512)
print v(xbgr.mr_n49778832)
print v(xbgr.mr_n49778944)
print v(xbgr.mr_n49779264)
print v(xbgr.mr_n49779376)
print v(xbgr.mr_n49779696)
print v(xbgr.mr_n49779808)
print v(xbgr.mr_n49780128)
print v(xbgr.mr_n49780240)
print v(xbgr.mr_n49780560)
print v(xbgr.mr_n49780672)
print v(xbgr.mr_n49780992)
print v(xbgr.mr_n49781104)
print v(xbgr.mr_n49781424)
print v(xbgr.mr_n49782288)
print v(xbgr.mr_n49782720)
print v(xbgr.mr_n49783584)
print v(xbgr.mr_n49784016)
print v(xbgr.mr_n49784880)
print v(xbgr.mr_n49785744)
print v(xbgr.mr_n49787040)
print v(xbgr.mr_n49788336)
print v(xbgr.mr_n49788448)
print v(xbgr.mr_n49788768)
print v(xbgr.mr_n49788880)
print v(xbgr.mr_n49789312)
print v(xbgr.mr_n49789632)
print v(xbgr.mr_n49789744)
print v(xbgr.mr_n49790176)
print v(xbgr.mr_n49790496)
print v(xbgr.mr_n49790608)
print v(xbgr.mr_n49790928)
print v(xbgr.mr_n49791040)
print v(xbgr.mr_n49791360)
print v(xbgr.mr_n49791472)
print v(xbgr.mr_n49791904)
print v(xbgr.mr_n49792224)
print v(xbgr.mr_n49792336)
print v(xbgr.mr_n49792768)
print v(xbgr.mr_n49793088)
print v(xbgr.mr_n49793200)
print v(xbgr.mr_n49793632)
print v(xbgr.mr_n49793952)
print v(xbgr.mr_n49794064)
print v(xbgr.mr_n49794384)
print v(xbgr.mr_n49794816)
print v(xbgr.mr_n49794928)
print v(xbgr.mr_n49795248)
print v(xbgr.mr_n49795360)
print v(xbgr.mr_n49795680)
print v(xbgr.mr_n49795792)
print v(xbgr.mr_n49796112)
print v(xbgr.mr_n49796224)
print v(xbgr.mr_n49796976)
print v(xbgr.mr_n49797840)
print v(xbgr.mr_n49798704)
print v(xbgr.mr_n49798816)
print v(xbgr.mr_n49799136)
print v(xbgr.mr_n49799248)
print v(xbgr.mr_n49799568)
print v(xbgr.mr_n49799680)
print v(xbgr.mr_n49800000)
print v(xbgr.mr_n49800112)
print v(xbgr.mr_n49800864)
print v(xbgr.mr_n49801296)
print v(xbgr.mr_n49802160)
print v(xbgr.mr_n49803456)
print v(xbgr.mr_n49803888)
print v(xbgr.mr_n49804752)
print v(xbgr.mr_n49804864)
print v(xbgr.mr_n49805184)
print v(xbgr.mr_n49805296)
print v(xbgr.mr_n49805616)
print v(xbgr.mr_n49806480)
print v(xbgr.mr_n49806912)
print v(xbgr.mr_n49807024)
print v(xbgr.mr_n49807344)
print v(xbgr.mr_n49808208)
print v(xbgr.mr_n49809072)
print v(xbgr.mr_n49809936)
print v(xbgr.mr_n49810800)
print v(xbgr.mr_n49810912)
print v(xbgr.mr_n49811232)
print v(xbgr.mr_n49811344)
print v(xbgr.mr_n49811664)
print v(xbgr.mr_n49811776)
print v(xbgr.mr_n49812096)
print v(xbgr.mr_n49812208)
print v(xbgr.mr_n49812960)
print v(xbgr.mr_n49813824)
print v(xbgr.mr_n49814688)
print v(xbgr.mr_n49814800)
print v(xbgr.mr_n49815232)
print v(xbgr.mr_n49815664)
print v(xbgr.mr_n49816096)
print v(xbgr.mr_n49816416)
print v(xbgr.mr_n49816528)
print v(xbgr.mr_n49816848)
print v(xbgr.mr_n49816960)
print v(xbgr.mr_n49817280)
print v(xbgr.mr_n49817392)
print v(xbgr.mr_n49817712)
print v(xbgr.mr_n49817824)
print v(xbgr.mr_n49818144)
print v(xbgr.mr_n49818256)
print v(xbgr.mr_n49818576)
print v(xbgr.mr_n49818688)
print v(xbgr.mr_n49819008)
print v(xbgr.mr_n49819120)
print v(xbgr.mr_n49819440)
print v(xbgr.mr_n49819552)
print v(xbgr.mr_n49820736)
print v(xbgr.mr_n49821280)
print v(xbgr.mr_n49821712)
print v(xbgr.mr_n49822144)
print v(xbgr.mr_n49822896)
print v(xbgr.mr_n49823008)
print v(xbgr.mr_n49823328)
print v(xbgr.mr_n49823440)
print v(xbgr.mr_n49823760)
print v(xbgr.mr_n49823872)
print v(xbgr.mr_n49824192)
print v(xbgr.mr_n49824304)
print v(xbgr.mr_n49824624)
print v(xbgr.mr_n49824736)
print v(xbgr.mr_n49825056)
print v(xbgr.mr_n49825168)
print v(xbgr.mr_n49825600)
print v(xbgr.mr_n49825920)
print v(xbgr.mr_n49826032)
print v(xbgr.mr_n49826352)
print v(xbgr.mr_n49826464)
print v(xbgr.mr_n49826896)
print v(xbgr.mr_n49827216)
print v(xbgr.mr_n49827328)
print v(xbgr.mr_n49827648)
print v(xbgr.mr_n49827760)
print v(xbgr.mr_n49828080)
print v(xbgr.mr_n49828192)
print v(xbgr.mr_n49828512)
print v(xbgr.mr_n49828624)
print v(xbgr.mr_n49828944)
print v(xbgr.mr_n49829056)
print v(xbgr.mr_n49829376)
print v(xbgr.mr_n49829488)
print v(xbgr.mr_n49829808)
print v(xbgr.mr_n49830672)
print v(xbgr.mr_n49831216)
print v(xbgr.mr_n49831536)
print v(xbgr.mr_n49831648)
print v(xbgr.mr_n49832080)
print v(xbgr.mr_n49832400)
print v(xbgr.mr_n49832512)
print v(xbgr.mr_n49833264)
print v(xbgr.mr_n49834128)
print v(xbgr.mr_n49834240)
print v(xbgr.mr_n49834560)
print v(xbgr.mr_n49834672)
print v(xbgr.mr_n49834992)
print v(xbgr.mr_n49835104)
print v(xbgr.mr_n49835424)
print v(xbgr.mr_n49835856)
print v(xbgr.mr_n49836720)
print v(xbgr.mr_n49838016)
print v(xbgr.mr_n49838992)
print v(xbgr.mr_n49839312)
print v(xbgr.mr_n49839424)
print v(xbgr.mr_n49839744)
print v(xbgr.mr_n49839856)
print v(xbgr.mr_n49840176)
print v(xbgr.mr_n49841040)
print v(xbgr.mr_n49841152)
print v(xbgr.mr_n49841472)
print v(xbgr.mr_n49841584)
print v(xbgr.mr_n49841904)
print v(xbgr.mr_n49842016)
print v(xbgr.mr_n49842336)
print v(xbgr.mr_n49842448)
print v(xbgr.mr_n49842768)
print v(xbgr.mr_n49842880)
print v(xbgr.mr_n49843200)
print v(xbgr.mr_n49843744)
print v(xbgr.mr_n49844064)
print v(xbgr.mr_n49845360)
print v(xbgr.mr_n49846224)
print v(xbgr.mr_n49846768)
print v(xbgr.mr_n49847200)
print v(xbgr.mr_n49847952)
print v(xbgr.mr_n49848064)
print v(xbgr.mr_n49848384)
print v(xbgr.mr_n49848496)
print v(xbgr.mr_n49848816)
print v(xbgr.mr_n49848928)
print v(xbgr.mr_n49849248)
print v(xbgr.mr_n49849360)
print v(xbgr.mr_n49849680)
print v(xbgr.mr_n49849792)
print v(xbgr.mr_n49850112)
print v(xbgr.mr_n49850224)
print v(xbgr.mr_n49850656)
print v(xbgr.mr_n49850976)
print v(xbgr.mr_n49851088)
print v(xbgr.mr_n49851408)
print v(xbgr.mr_n49851520)
print v(xbgr.mr_n49851840)
print v(xbgr.mr_n49851952)
print v(xbgr.mr_n49852272)
print v(xbgr.mr_n49852384)
print v(xbgr.mr_n49852704)
print v(xbgr.mr_n49852816)
print v(xbgr.mr_n49853136)
print v(xbgr.mr_n49853248)
print v(xbgr.mr_n49853568)
print v(xbgr.mr_n49853680)
print v(xbgr.mr_n49854000)
print v(xbgr.mr_n49854112)
print v(xbgr.mr_n49854544)
print v(xbgr.mr_n49854976)
print v(xbgr.mr_n49855408)
print v(xbgr.mr_n49855728)
print v(xbgr.mr_n49855840)
print v(xbgr.mr_n49856160)
print v(xbgr.mr_n49856272)
print v(xbgr.mr_n49856592)
print v(xbgr.mr_n49856704)
print v(xbgr.mr_n49857024)
print v(xbgr.mr_n49857136)
print v(xbgr.mr_n49857456)
print v(xbgr.mr_n49857568)
print v(xbgr.mr_n49858000)
print v(xbgr.mr_n49858320)
print v(xbgr.mr_n49859184)
print v(xbgr.mr_n49860048)
print v(xbgr.mr_n49860160)
print v(xbgr.mr_n49860480)
print v(xbgr.mr_n49860592)
print v(xbgr.mr_n49860912)
print v(xbgr.mr_n49861024)
print v(xbgr.mr_n49861344)
print v(xbgr.mr_n49861456)
print v(xbgr.mr_n49861776)
print v(xbgr.mr_n49862752)
print v(xbgr.mr_n49863072)
print v(xbgr.mr_n49863184)
print v(xbgr.mr_n49863504)
print v(xbgr.mr_n49863616)
print v(xbgr.mr_n49863936)
print v(xbgr.mr_n49864048)
print v(xbgr.mr_n49864368)
print v(xbgr.mr_n49864480)
print v(xbgr.mr_n49864800)
print v(xbgr.mr_n49864912)
print v(xbgr.mr_n49865232)
print v(xbgr.mr_n49866096)
print v(xbgr.mr_n49866960)
print v(xbgr.mr_n49867824)
print v(xbgr.mr_n49868688)
print v(xbgr.mr_n49868800)
print v(xbgr.mr_n49869120)
print v(xbgr.mr_n49869232)
print v(xbgr.mr_n49869552)
print v(xbgr.mr_n49870528)
print v(xbgr.mr_n49870960)
print v(xbgr.mr_n49871280)
print v(xbgr.mr_n49872144)
print v(xbgr.mr_n49873008)
print v(xbgr.mr_n49873872)
print v(xbgr.mr_n49874736)
print v(xbgr.mr_n49874848)
print v(xbgr.mr_n49875280)
print v(xbgr.mr_n49875600)
print v(xbgr.mr_n49875712)
print v(xbgr.mr_n49876032)
print v(xbgr.mr_n49876144)
print v(xbgr.mr_n49876464)
print v(xbgr.mr_n49876576)
print v(xbgr.mr_n49877008)
print v(xbgr.mr_n49877328)
print v(xbgr.mr_n49877440)
print v(xbgr.mr_n49877872)
print v(xbgr.mr_n49878192)
print v(xbgr.mr_n49878304)
print v(xbgr.mr_n49878624)
print v(xbgr.mr_n49878736)
print v(xbgr.mr_n49879056)
print v(xbgr.mr_n49879168)
print v(xbgr.mr_n49879488)
print v(xbgr.mr_n49879600)
print v(xbgr.mr_n49879920)
print v(xbgr.mr_n49880032)
print v(xbgr.mr_n49880352)
print v(xbgr.mr_n49880464)
print v(xbgr.mr_n49880896)
print v(xbgr.mr_n49881216)
print v(xbgr.mr_n49882080)
print v(xbgr.mr_n49882624)
print v(xbgr.mr_n49882944)
print v(xbgr.mr_n49883056)
print v(xbgr.mr_n49883376)
print v(xbgr.mr_n49883488)
print v(xbgr.mr_n49883808)
print v(xbgr.mr_n49883920)
print v(xbgr.mr_n49884240)
print v(xbgr.mr_n49884352)
print v(xbgr.mr_n49884672)
print v(xbgr.mr_n49884784)
print v(xbgr.mr_n49885104)
print v(xbgr.mr_n49885216)
print v(xbgr.mr_n49885648)
print v(xbgr.mr_n49885968)
print v(xbgr.mr_n49886832)
print v(xbgr.mr_n49887264)
print v(xbgr.mr_n49888128)
print v(xbgr.mr_n49888992)
print v(xbgr.mr_n49890400)
print v(xbgr.mr_n49891264)
print v(xbgr.mr_n49891696)
print v(xbgr.mr_n49892016)
print v(xbgr.mr_n49892880)
print v(xbgr.mr_n49892992)
print v(xbgr.mr_n49893312)
print v(xbgr.mr_n49893424)
print v(xbgr.mr_n49893744)
print v(xbgr.mr_n49893856)
print v(xbgr.mr_n49894176)
print v(xbgr.mr_n49894288)
print v(xbgr.mr_n49894608)
print v(xbgr.mr_n49894720)
print v(xbgr.mr_n49895040)
print v(xbgr.mr_n49895152)
print v(xbgr.mr_n49895472)
print v(xbgr.mr_n49895584)
print v(xbgr.mr_n49895904)
print v(xbgr.mr_n49896768)
print v(xbgr.mr_n49897744)
print v(xbgr.mr_n49898176)
print v(xbgr.mr_n49898608)
print v(xbgr.mr_n49898928)
print v(xbgr.mr_n49899040)
print v(xbgr.mr_n49899360)
print v(xbgr.mr_n49899472)
print v(xbgr.mr_n49899792)
print v(xbgr.mr_n49900656)
print v(xbgr.mr_n49901520)
print v(xbgr.mr_n49902384)
print v(xbgr.mr_n49902496)
print v(xbgr.mr_n49902816)
print v(xbgr.mr_n49902928)
print v(xbgr.mr_n49903248)
print v(xbgr.mr_n49904112)
print v(xbgr.mr_n49904976)
print v(xbgr.mr_n49905840)
print v(xbgr.mr_n49905952)
print v(xbgr.mr_n49906272)
print v(xbgr.mr_n49906384)
print v(xbgr.mr_n49906704)
print v(xbgr.mr_n49906816)
print v(xbgr.mr_n49907136)
print v(xbgr.mr_n49907248)
print v(xbgr.mr_n49907568)
print v(xbgr.mr_n49908432)
print v(xbgr.mr_n49909296)
print v(xbgr.mr_n49909408)
print v(xbgr.mr_n49909728)
print v(xbgr.mr_n49909840)
print v(xbgr.mr_n49910160)
print v(xbgr.mr_n49910272)
print v(xbgr.mr_n49910592)
print v(xbgr.mr_n49910704)
print v(xbgr.mr_n49911024)
print v(xbgr.mr_n49911136)
print v(xbgr.mr_n49911568)
print v(xbgr.mr_n49911888)
print v(xbgr.mr_n49912000)
print v(xbgr.mr_n49912320)
print v(xbgr.mr_n49912432)
print v(xbgr.mr_n49912752)
print v(xbgr.mr_n49912864)
print v(xbgr.mr_n49913184)
print v(xbgr.mr_n49913296)
print v(xbgr.mr_n49913616)
print v(xbgr.mr_n49914480)
print v(xbgr.mr_n49914592)
print v(xbgr.mr_n49915024)
print v(xbgr.mr_n49915344)
print v(xbgr.mr_n49915456)
print v(xbgr.mr_n49915776)
print v(xbgr.mr_n49915888)
print v(xbgr.mr_n49916208)
print v(xbgr.mr_n49916320)
print v(xbgr.mr_n49916640)
print v(xbgr.mr_n49916752)
print v(xbgr.mr_n49917072)
print v(xbgr.mr_n49917184)
print v(xbgr.mr_n49917504)
print v(xbgr.mr_n49917616)
print v(xbgr.mr_n49917936)
print v(xbgr.mr_n49918368)
print v(xbgr.mr_n49918480)
print v(xbgr.mr_n49918800)
print v(xbgr.mr_n49919344)
print v(xbgr.mr_n49919664)
print v(xbgr.mr_n49919776)
print v(xbgr.mr_n49920208)
print v(xbgr.mr_n49920640)
print v(xbgr.mr_n49921072)
print v(xbgr.mr_n49921504)
print v(xbgr.mr_n49921936)
print v(xbgr.mr_n49922256)
print v(xbgr.mr_n49922368)
print v(xbgr.mr_n49922800)
print v(xbgr.mr_n49923120)
print v(xbgr.mr_n49923232)
print v(xbgr.mr_n49923664)
print v(xbgr.mr_n49923984)
print v(xbgr.mr_n49924848)
print v(xbgr.mr_n49926144)
print v(xbgr.mr_n49926688)
print v(xbgr.mr_n49927008)
print v(xbgr.mr_n49927552)
print v(xbgr.mr_n49927872)
print v(xbgr.mr_n49927984)
print v(xbgr.mr_n49928736)
print v(xbgr.mr_n49929168)
print v(xbgr.mr_n49930032)
print v(xbgr.mr_n49930896)
print v(xbgr.mr_n49932192)
print v(xbgr.mr_n49933056)
print v(xbgr.mr_n49933488)
print v(xbgr.mr_n49933600)
print v(xbgr.mr_n49934352)
print v(xbgr.mr_n49934464)
print v(xbgr.mr_n49934784)
print v(xbgr.mr_n49934896)
print v(xbgr.mr_n49935216)
print v(xbgr.mr_n49935328)
print v(xbgr.mr_n49936080)
print v(xbgr.mr_n49937376)
print v(xbgr.mr_n49938240)
print v(xbgr.mr_n49939104)
print v(xbgr.mr_n49939536)
print v(xbgr.mr_n49939648)
print v(xbgr.mr_n49939968)
print v(xbgr.mr_n49940080)
print v(xbgr.mr_n49940400)
print v(xbgr.mr_n49940512)
print v(xbgr.mr_n49940832)
print v(xbgr.mr_n49940944)
print v(xbgr.mr_n49941696)
print v(xbgr.mr_n49941808)
print v(xbgr.mr_n49942128)
print v(xbgr.mr_n49942240)
print v(xbgr.mr_n49942560)
print v(xbgr.mr_n49942672)
print v(xbgr.mr_n49942992)
print v(xbgr.mr_n49943856)
print v(xbgr.mr_n49943968)
print v(xbgr.mr_n49944288)
print v(xbgr.mr_n49944400)
print v(xbgr.mr_n49944832)
print v(xbgr.mr_n49945152)
print v(xbgr.mr_n49945264)
print v(xbgr.mr_n49945584)
print v(xbgr.mr_n49945696)
print v(xbgr.mr_n49946016)
print v(xbgr.mr_n49946128)
print v(xbgr.mr_n49946560)
print v(xbgr.mr_n49946992)
print v(xbgr.mr_n49947312)
print v(xbgr.mr_n49947424)
print v(xbgr.mr_n49947744)
print v(xbgr.mr_n49947856)
print v(xbgr.mr_n49948176)
print v(xbgr.mr_n49948288)
print v(xbgr.mr_n49948720)
print v(xbgr.mr_n49949040)
print v(xbgr.mr_n49949152)
print v(xbgr.mr_n49949584)
print v(xbgr.mr_n49949904)
print v(xbgr.mr_n49950016)
print v(xbgr.mr_n49950336)
print v(xbgr.mr_n49950448)
print v(xbgr.mr_n49950768)
print v(xbgr.mr_n49950880)
print v(xbgr.mr_n49951200)
print v(xbgr.mr_n49951312)
print v(xbgr.mr_n49951632)
print v(xbgr.mr_n49952496)
print v(xbgr.mr_n49953360)
print v(xbgr.mr_n49953472)
print v(xbgr.mr_n49953792)
print v(xbgr.mr_n49954336)
print v(xbgr.mr_n49954656)
print v(xbgr.mr_n49955088)
print v(xbgr.mr_n49956384)
print v(xbgr.mr_n49957680)
print v(xbgr.mr_n49957792)
print v(xbgr.mr_n49958112)
print v(xbgr.mr_n49958224)
print v(xbgr.mr_n49958544)
print v(xbgr.mr_n49958656)
print v(xbgr.mr_n49958976)
print v(xbgr.mr_n49959088)
print v(xbgr.mr_n49959408)
print v(xbgr.mr_n49959520)
print v(xbgr.mr_n49959840)
print v(xbgr.mr_n49959952)
print v(xbgr.mr_n49960272)
print v(xbgr.mr_n49960384)
print v(xbgr.mr_n49960816)
print v(xbgr.mr_n49961136)
print v(xbgr.mr_n49962000)
print v(xbgr.mr_n49962112)
print v(xbgr.mr_n49962432)
print v(xbgr.mr_n49962544)
print v(xbgr.mr_n49962864)
print v(xbgr.mr_n49962976)
print v(xbgr.mr_n49963296)
print v(xbgr.mr_n49963408)
print v(xbgr.mr_n49963728)
print v(xbgr.mr_n49964592)
print v(xbgr.mr_n49965456)
print v(xbgr.mr_n49966320)
print v(xbgr.mr_n49967184)
print v(xbgr.mr_n49968048)
print v(xbgr.mr_n49968160)
print v(xbgr.mr_n49968480)
print v(xbgr.mr_n49968592)
print v(xbgr.mr_n49968912)
print v(xbgr.mr_n49969024)
print v(xbgr.mr_n49969344)
print v(xbgr.mr_n49969456)
print v(xbgr.mr_n49969776)
print v(xbgr.mr_n49969888)
print v(xbgr.mr_n49970208)
print v(xbgr.mr_n49970320)
print v(xbgr.mr_n49970640)
print v(xbgr.mr_n49970752)
print v(xbgr.mr_n49971072)
print v(xbgr.mr_n49971184)
print v(xbgr.mr_n49971504)
print v(xbgr.mr_n49971616)
print v(xbgr.mr_n49971936)
print v(xbgr.mr_n49972048)
print v(xbgr.mr_n49972480)
print v(xbgr.mr_n49972800)
print v(xbgr.mr_n49972912)
print v(xbgr.mr_n49973232)
print v(xbgr.mr_n49973344)
print v(xbgr.mr_n49973776)
print v(xbgr.mr_n49974096)
print v(xbgr.mr_n49974208)
print v(xbgr.mr_n49974640)
print v(xbgr.mr_n49974960)
print v(xbgr.mr_n49975072)
print v(xbgr.mr_n49975504)
print v(xbgr.mr_n49975936)
print v(xbgr.mr_n49976256)
print v(xbgr.mr_n49976368)
print v(xbgr.mr_n49976800)
print v(xbgr.mr_n49977120)
print v(xbgr.mr_n49977232)
print v(xbgr.mr_n49977552)
print v(xbgr.mr_n49977664)
print v(xbgr.mr_n49977984)
print v(xbgr.mr_n49978096)
print v(xbgr.mr_n49978416)
print v(xbgr.mr_n49978528)
print v(xbgr.mr_n49978848)
print v(xbgr.mr_n49978960)
print v(xbgr.mr_n49979280)
print v(xbgr.mr_n49979392)
print v(xbgr.mr_n49979712)
print v(xbgr.mr_n49979824)
print v(xbgr.mr_n49980144)
print v(xbgr.mr_n49980256)
print v(xbgr.mr_n49980576)
print v(xbgr.mr_n49981440)
print v(xbgr.mr_n49981552)
print v(xbgr.mr_n49981872)
print v(xbgr.mr_n49981984)
print v(xbgr.mr_n49982304)
print v(xbgr.mr_n49983168)
print v(xbgr.mr_n49984032)
print v(xbgr.mr_n49984896)
print v(xbgr.mr_n49985760)
print v(xbgr.mr_n49986624)
print v(xbgr.mr_n49986736)
print v(xbgr.mr_n49987056)
print v(xbgr.mr_n49987168)
print v(xbgr.mr_n49987488)
print v(xbgr.mr_n49987600)
print v(xbgr.mr_n49987920)
print v(xbgr.mr_n49988784)
print v(xbgr.mr_n49989648)
print v(xbgr.mr_n49990512)
print v(xbgr.mr_n49991376)
print v(xbgr.mr_n49992240)
print v(xbgr.mr_n49993104)
print v(xbgr.mr_n49993968)
print v(xbgr.mr_n49994080)
print v(xbgr.mr_n49994400)
print v(xbgr.mr_n49994512)
print v(xbgr.mr_n49994944)
print v(xbgr.mr_n49995264)
print v(xbgr.mr_n49996128)
print v(xbgr.mr_n49996672)
print v(xbgr.mr_n49997104)
print v(xbgr.mr_n49997536)
print v(xbgr.mr_n49998288)
print v(xbgr.mr_n49999152)
print v(xbgr.mr_n50000016)
print v(xbgr.mr_n50000128)
print v(xbgr.mr_n50000448)
print v(xbgr.mr_n50000560)
print v(xbgr.mr_n50000992)
print v(xbgr.mr_n50001424)
print v(xbgr.mr_n50001744)
print v(xbgr.mr_n50002608)
print v(xbgr.mr_n50002720)
print v(xbgr.mr_n50003152)
print v(xbgr.mr_n50003472)
print v(xbgr.mr_n50003584)
print v(xbgr.mr_n50004016)
print v(xbgr.mr_n50004336)
print v(xbgr.mr_n50005200)
print v(xbgr.mr_n50005312)
print v(xbgr.mr_n50005632)
print v(xbgr.mr_n50006496)
print v(xbgr.mr_n50007360)
print v(xbgr.mr_n50007472)
print v(xbgr.mr_n50007792)
print v(xbgr.mr_n50007904)
print v(xbgr.mr_n50008224)
print v(xbgr.mr_n50009088)
print v(xbgr.mr_n50009520)
print v(xbgr.mr_n50009632)
print v(xbgr.mr_n50010064)
print v(xbgr.mr_n50010384)
print v(xbgr.mr_n50010496)
print v(xbgr.mr_n50010928)
print v(xbgr.mr_n50011680)
print v(xbgr.mr_n50011792)
print v(xbgr.mr_n50012112)
print v(xbgr.mr_n50012224)
print v(xbgr.mr_n50012544)
print v(xbgr.mr_n50012656)
print v(xbgr.mr_n50012976)
print v(xbgr.mr_n50013408)
print v(xbgr.mr_n50013520)
print v(xbgr.mr_n50014272)
print v(xbgr.mr_n50014704)
print v(xbgr.mr_n50014816)
print v(xbgr.mr_n50015680)
print v(xbgr.mr_n50016000)
print v(xbgr.mr_n50016112)
print v(xbgr.mr_n50016432)
print v(xbgr.mr_n50017296)
print v(xbgr.mr_n50018160)
print v(xbgr.mr_n50019024)
print v(xbgr.mr_n50019888)
print v(xbgr.mr_n50020000)
print v(xbgr.mr_n50020320)
print v(xbgr.mr_n50020432)
print v(xbgr.mr_n50020752)
print v(xbgr.mr_n50020864)
print v(xbgr.mr_n50021184)
print v(xbgr.mr_n50021296)
print v(xbgr.mr_n50021616)
print v(xbgr.mr_n50021728)
print v(xbgr.mr_n50022048)
print v(xbgr.mr_n50022160)
print v(xbgr.mr_n50022480)
print v(xbgr.mr_n50022592)
print v(xbgr.mr_n50022912)
print v(xbgr.mr_n50023024)
print v(xbgr.mr_n50023344)
print v(xbgr.mr_n50023456)
print v(xbgr.mr_n50023776)
print v(xbgr.mr_n50023888)
print v(xbgr.mr_n50024320)
print v(xbgr.mr_n50024752)
print v(xbgr.mr_n50025184)
print v(xbgr.mr_n50025504)
print v(xbgr.mr_n50025616)
print v(xbgr.mr_n50025936)
print v(xbgr.mr_n50026800)
print v(xbgr.mr_n50026912)
print v(xbgr.mr_n50027232)
print v(xbgr.mr_n50027344)
print v(xbgr.mr_n50027664)
print v(xbgr.mr_n50027776)
print v(xbgr.mr_n50028208)
print v(xbgr.mr_n50028528)
print v(xbgr.mr_n50028640)
print v(xbgr.mr_n50028960)
print v(xbgr.mr_n50029072)
print v(xbgr.mr_n50029504)
print v(xbgr.mr_n50029824)
print v(xbgr.mr_n50030256)
print v(xbgr.mr_n50030368)
print v(xbgr.mr_n50030688)
print v(xbgr.mr_n50030800)
print v(xbgr.mr_n50031120)
print v(xbgr.mr_n50031232)
print v(xbgr.mr_n50031552)
print v(xbgr.mr_n50031664)
print v(xbgr.mr_n50032096)
print v(xbgr.mr_n50032416)
print v(xbgr.mr_n50032528)
print v(xbgr.mr_n50032848)
print v(xbgr.mr_n50032960)
print v(xbgr.mr_n50033280)
print v(xbgr.mr_n50033392)
print v(xbgr.mr_n50033712)
print v(xbgr.mr_n50033824)
print v(xbgr.mr_n50034144)
print v(xbgr.mr_n50034256)
print v(xbgr.mr_n50034576)
print v(xbgr.mr_n50034688)
print v(xbgr.mr_n50035008)
print v(xbgr.mr_n50035120)
print v(xbgr.mr_n50035872)
print v(xbgr.mr_n50036304)
print v(xbgr.mr_n50037168)
print v(xbgr.mr_n50037280)
print v(xbgr.mr_n50037600)
print v(xbgr.mr_n50038144)
print v(xbgr.mr_n50038576)
print v(xbgr.mr_n50039008)
print v(xbgr.mr_n50039328)
print v(xbgr.mr_n50039760)
print v(xbgr.mr_n50040624)
print v(xbgr.mr_n50042784)
print v(xbgr.mr_n50043648)
print v(xbgr.mr_n50043760)
print v(xbgr.mr_n50044080)
print v(xbgr.mr_n50044944)
print v(xbgr.mr_n50045808)
print v(xbgr.mr_n50045920)
print v(xbgr.mr_n50046240)
print v(xbgr.mr_n50046352)
print v(xbgr.mr_n50046672)
print v(xbgr.mr_n50046784)
print v(xbgr.mr_n50047104)
print v(xbgr.mr_n50047216)
print v(xbgr.mr_n50047536)
print v(xbgr.mr_n50048400)
print v(xbgr.mr_n50049264)
print v(xbgr.mr_n50049376)
print v(xbgr.mr_n50049696)
print v(xbgr.mr_n50049808)
print v(xbgr.mr_n50050128)
print v(xbgr.mr_n50050240)
print v(xbgr.mr_n50050560)
print v(xbgr.mr_n50050672)
print v(xbgr.mr_n50050992)
print v(xbgr.mr_n50051104)
print v(xbgr.mr_n50051424)
print v(xbgr.mr_n50051536)
print v(xbgr.mr_n50051856)
print v(xbgr.mr_n50051968)
print v(xbgr.mr_n50052400)
print v(xbgr.mr_n50052720)
print v(xbgr.mr_n50052832)
print v(xbgr.mr_n50053264)
print v(xbgr.mr_n50053584)
print v(xbgr.mr_n50054128)
print v(xbgr.mr_n50054992)
print v(xbgr.mr_n50055312)
print v(xbgr.mr_n50055424)
print v(xbgr.mr_n50056608)
print v(xbgr.mr_n50056720)
print v(xbgr.mr_n50057040)
print v(xbgr.mr_n50057152)
print v(xbgr.mr_n50057472)
print v(xbgr.mr_n50057584)
print v(xbgr.mr_n50057904)
print v(xbgr.mr_n50058016)
print v(xbgr.mr_n50058336)
print v(xbgr.mr_n50059200)
print v(xbgr.mr_n50060064)
print v(xbgr.mr_n50060176)
print v(xbgr.mr_n50060608)
print v(xbgr.mr_n50061040)
print v(xbgr.mr_n50061472)
print v(xbgr.mr_n50061792)
print v(xbgr.mr_n50061904)
print v(xbgr.mr_n50062224)
print v(xbgr.mr_n50062336)
print v(xbgr.mr_n50062656)
print v(xbgr.mr_n50062768)
print v(xbgr.mr_n50063088)
print v(xbgr.mr_n50063200)
print v(xbgr.mr_n50063520)
print v(xbgr.mr_n50063632)
print v(xbgr.mr_n50063952)
print v(xbgr.mr_n50064064)
print v(xbgr.mr_n50064384)
print v(xbgr.mr_n50065248)
print v(xbgr.mr_n50065360)
print v(xbgr.mr_n50065680)
print v(xbgr.mr_n50065792)
print v(xbgr.mr_n50066112)
print v(xbgr.mr_n50066224)
print v(xbgr.mr_n50066544)
print v(xbgr.mr_n50066656)
print v(xbgr.mr_n50066976)
print v(xbgr.mr_n50067520)
print v(xbgr.mr_n50068272)
print v(xbgr.mr_n50069136)
print v(xbgr.mr_n50070000)
print v(xbgr.mr_n50070864)
print v(xbgr.mr_n50071728)
print v(xbgr.mr_n50072592)
print v(xbgr.mr_n50072704)
print v(xbgr.mr_n50073024)
print v(xbgr.mr_n50073136)
print v(xbgr.mr_n50073456)
print v(xbgr.mr_n50073568)
print v(xbgr.mr_n50073888)
print v(xbgr.mr_n50074000)
print v(xbgr.mr_n50074320)
print v(xbgr.mr_n50074432)
print v(xbgr.mr_n50074752)
print v(xbgr.mr_n50074864)
print v(xbgr.mr_n50075184)
print v(xbgr.mr_n50076048)
print v(xbgr.mr_n50076912)
print v(xbgr.mr_n50077776)
print v(xbgr.mr_n50078640)
print v(xbgr.mr_n50079504)
print v(xbgr.mr_n50080368)
print v(xbgr.mr_n50081232)
print v(xbgr.mr_n50081344)
print v(xbgr.mr_n50081664)
print v(xbgr.mr_n50081776)
print v(xbgr.mr_n50082096)
print v(xbgr.mr_n50082208)
print v(xbgr.mr_n50082528)
print v(xbgr.mr_n50082640)
print v(xbgr.mr_n50082960)
print v(xbgr.mr_n50083072)
print v(xbgr.mr_n50083392)
print v(xbgr.mr_n50083504)
print v(xbgr.mr_n50083824)
print v(xbgr.mr_n50083936)
print v(xbgr.mr_n50084368)
print v(xbgr.mr_n50084688)
print v(xbgr.mr_n50084800)
print v(xbgr.mr_n50085232)
print v(xbgr.mr_n50085552)
print v(xbgr.mr_n50085664)
print v(xbgr.mr_n50086096)
print v(xbgr.mr_n50086416)
print v(xbgr.mr_n50087280)
print v(xbgr.mr_n50088144)
print v(xbgr.mr_n50089008)
print v(xbgr.mr_n50089872)
print v(xbgr.mr_n50090736)
print v(xbgr.mr_n50091600)
print v(xbgr.mr_n50091712)
print v(xbgr.mr_n50092032)
print v(xbgr.mr_n50092144)
print v(xbgr.mr_n50092464)
print v(xbgr.mr_n50092576)
print v(xbgr.mr_n50092896)
print v(xbgr.mr_n50093008)
print v(xbgr.mr_n50093328)
print v(xbgr.mr_n50094192)
print v(xbgr.mr_n50095056)
print v(xbgr.mr_n50095920)
print v(xbgr.mr_n50096032)
print v(xbgr.mr_n50096464)
print v(xbgr.mr_n50096784)
print v(xbgr.mr_n50096896)
print v(xbgr.mr_n50097216)
print v(xbgr.mr_n50097328)
print v(xbgr.mr_n50097648)
print v(xbgr.mr_n50097760)
print v(xbgr.mr_n50098080)
print v(xbgr.mr_n50098192)
print v(xbgr.mr_n50098512)
print v(xbgr.mr_n50098624)
print v(xbgr.mr_n50099056)
print v(xbgr.mr_n50099376)
print v(xbgr.mr_n50099488)
print v(xbgr.mr_n50099920)
print v(xbgr.mr_n50100240)
print v(xbgr.mr_n50100352)
print v(xbgr.mr_n50100672)
print v(xbgr.mr_n50100784)
print v(xbgr.mr_n50101216)
print v(xbgr.mr_n50101648)
print v(xbgr.mr_n50101968)
print v(xbgr.mr_n50102080)
print v(xbgr.mr_n50102512)
print v(xbgr.mr_n50102832)
print v(xbgr.mr_n50102944)
print v(xbgr.mr_n50103376)
print v(xbgr.mr_n50103696)
print v(xbgr.mr_n50104560)
print v(xbgr.mr_n50105424)
print v(xbgr.mr_n50106288)
print v(xbgr.mr_n50107152)
print v(xbgr.mr_n50107264)
print v(xbgr.mr_n50107584)
print v(xbgr.mr_n50107696)
print v(xbgr.mr_n50108016)
print v(xbgr.mr_n50108128)
print v(xbgr.mr_n50108448)
print v(xbgr.mr_n50108560)
print v(xbgr.mr_n50108880)
print v(xbgr.mr_n50109744)
print v(xbgr.mr_n50110608)
print v(xbgr.mr_n50111472)
print v(xbgr.mr_n50112336)
print v(xbgr.mr_n50113200)
print v(xbgr.mr_n50114064)
print v(xbgr.mr_n50114928)
print v(xbgr.mr_n50115792)
print v(xbgr.mr_n50115904)
print v(xbgr.mr_n50116224)
print v(xbgr.mr_n50116336)
print v(xbgr.mr_n50116656)
print v(xbgr.mr_n50116768)
print v(xbgr.mr_n50117088)
print v(xbgr.mr_n50117200)
print v(xbgr.mr_n50117520)
print v(xbgr.mr_n50117632)
print v(xbgr.mr_n50117952)
print v(xbgr.mr_n50118064)
print v(xbgr.mr_n50118384)
print v(xbgr.mr_n50118496)
print v(xbgr.mr_n50118816)
print v(xbgr.mr_n50118928)
print v(xbgr.mr_n50119248)
print v(xbgr.mr_n50119360)
print v(xbgr.mr_n50119680)
print v(xbgr.mr_n50119792)
print v(xbgr.mr_n50120224)
print v(xbgr.mr_n50120544)
print v(xbgr.mr_n50120656)
print v(xbgr.mr_n50120976)
print v(xbgr.mr_n50121088)
print v(xbgr.mr_n50121408)
print v(xbgr.mr_n50121520)
print v(xbgr.mr_n50121840)
print v(xbgr.mr_n50121952)
print v(xbgr.mr_n50122272)
print v(xbgr.mr_n50122384)
print v(xbgr.mr_n50122816)
print v(xbgr.mr_n50123136)
print v(xbgr.mr_n50123248)
print v(xbgr.mr_n50123680)
print v(xbgr.mr_n50124000)
print v(xbgr.mr_n50124112)
print v(xbgr.mr_n50124432)
print v(xbgr.mr_n50125296)
print v(xbgr.mr_n50126160)
print v(xbgr.mr_n50126704)
print v(xbgr.mr_n50127456)
print v(xbgr.mr_n50127888)
print v(xbgr.mr_n50128000)
print v(xbgr.mr_n50128752)
print v(xbgr.mr_n50128864)
print v(xbgr.mr_n50129296)
print v(xbgr.mr_n50129728)
print v(xbgr.mr_n50130048)
print v(xbgr.mr_n50130912)
print v(xbgr.mr_n50131344)
print v(xbgr.mr_n50132208)
print v(xbgr.mr_n50132320)
print v(xbgr.mr_n50133072)
print v(xbgr.mr_n50134368)
print v(xbgr.mr_n50135232)
print v(xbgr.mr_n50135344)
print v(xbgr.mr_n50135664)
print v(xbgr.mr_n50135776)
print v(xbgr.mr_n50136096)
print v(xbgr.mr_n50136208)
print v(xbgr.mr_n50136528)
print v(xbgr.mr_n50136640)
print v(xbgr.mr_n50136960)
print v(xbgr.mr_n50137824)
print v(xbgr.mr_n50138688)
print v(xbgr.mr_n50139552)
print v(xbgr.mr_n50139664)
print v(xbgr.mr_n50139984)
print v(xbgr.mr_n50140096)
print v(xbgr.mr_n50140416)
print v(xbgr.mr_n50141280)
print v(xbgr.mr_n50141392)
print v(xbgr.mr_n50141712)
print v(xbgr.mr_n50141824)
print v(xbgr.mr_n50142144)
print v(xbgr.mr_n50142256)
print v(xbgr.mr_n50142576)
print v(xbgr.mr_n50142688)
print v(xbgr.mr_n50143008)
print v(xbgr.mr_n50143872)
print v(xbgr.mr_n50144736)
print v(xbgr.mr_n50144848)
print v(xbgr.mr_n50145168)
print v(xbgr.mr_n50145280)
print v(xbgr.mr_n50145600)
print v(xbgr.mr_n50145712)
print v(xbgr.mr_n50146032)
print v(xbgr.mr_n50146144)
print v(xbgr.mr_n50146464)
print v(xbgr.mr_n50146576)
print v(xbgr.mr_n50146896)
print v(xbgr.mr_n50147008)
print v(xbgr.mr_n50147760)
print v(xbgr.mr_n50148624)
print v(xbgr.mr_n50149488)
print v(xbgr.mr_n50149600)
print v(xbgr.mr_n50149920)
print v(xbgr.mr_n50150032)
print v(xbgr.mr_n50150352)
print v(xbgr.mr_n50150464)
print v(xbgr.mr_n50150784)
print v(xbgr.mr_n50150896)
print v(xbgr.mr_n50151328)
print v(xbgr.mr_n50151648)
print v(xbgr.mr_n50151760)
print v(xbgr.mr_n50152512)
print v(xbgr.mr_n50153376)
print v(xbgr.mr_n50154240)
print v(xbgr.mr_n50155104)
print v(xbgr.mr_n50155216)
print v(xbgr.mr_n50155536)
print v(xbgr.mr_n50155648)
print v(xbgr.mr_n50155968)
print v(xbgr.mr_n50156080)
print v(xbgr.mr_n50156400)
print v(xbgr.mr_n50156512)
print v(xbgr.mr_n50156832)
print v(xbgr.mr_n50157696)
print v(xbgr.mr_n50158992)
print v(xbgr.mr_n50159104)
print v(xbgr.mr_n50159424)
print v(xbgr.mr_n50159536)
print v(xbgr.mr_n50159968)
print v(xbgr.mr_n50160288)
print v(xbgr.mr_n50160400)
print v(xbgr.mr_n50160832)
print v(xbgr.mr_n50161152)
print v(xbgr.mr_n50161584)
print v(xbgr.mr_n50162448)
print v(xbgr.mr_n50163312)
print v(xbgr.mr_n50163424)
print v(xbgr.mr_n50163744)
print v(xbgr.mr_n50163856)
print v(xbgr.mr_n50164288)
print v(xbgr.mr_n50164608)
print v(xbgr.mr_n50164720)
print v(xbgr.mr_n50165040)
print v(xbgr.mr_n50165152)
print v(xbgr.mr_n50165472)
print v(xbgr.mr_n50165584)
print v(xbgr.mr_n50165904)
print v(xbgr.mr_n50166016)
print v(xbgr.mr_n50166448)
print v(xbgr.mr_n50166880)
print v(xbgr.mr_n50167312)
print v(xbgr.mr_n50167744)
print v(xbgr.mr_n50168064)
print v(xbgr.mr_n50168176)
print v(xbgr.mr_n50168608)
print v(xbgr.mr_n50168928)
print v(xbgr.mr_n50169792)
print v(xbgr.mr_n50170656)
print v(xbgr.mr_n50171088)
print v(xbgr.mr_n50171952)
print v(xbgr.mr_n50172384)
print v(xbgr.mr_n50172496)
print v(xbgr.mr_n50173248)
print v(xbgr.mr_n50174112)
print v(xbgr.mr_n50174976)
print v(xbgr.mr_n50175088)
print v(xbgr.mr_n50175520)
print v(xbgr.mr_n50175840)
print v(xbgr.mr_n50176704)
print v(xbgr.mr_n50176816)
print v(xbgr.mr_n50177136)
print v(xbgr.mr_n50177248)
print v(xbgr.mr_n50177568)
print v(xbgr.mr_n50177680)
print v(xbgr.mr_n50178000)
print v(xbgr.mr_n50178112)
print v(xbgr.mr_n50178432)
print v(xbgr.mr_n50178544)
print v(xbgr.mr_n50178864)
print v(xbgr.mr_n50178976)
print v(xbgr.mr_n50179296)
print v(xbgr.mr_n50179408)
print v(xbgr.mr_n50179728)
print v(xbgr.mr_n50179840)
print v(xbgr.mr_n50180160)
print v(xbgr.mr_n50180272)
print v(xbgr.mr_n50180592)
print v(xbgr.mr_n50180704)
print v(xbgr.mr_n50181456)
print v(xbgr.mr_n50182752)
print v(xbgr.mr_n50183616)
print v(xbgr.mr_n50184912)
print v(xbgr.mr_n50185024)
print v(xbgr.mr_n50185344)
print v(xbgr.mr_n50185456)
print v(xbgr.mr_n50185776)
print v(xbgr.mr_n50185888)
print v(xbgr.mr_n50186208)
print v(xbgr.mr_n50186320)
print v(xbgr.mr_n50187072)
print v(xbgr.mr_n50187936)
print v(xbgr.mr_n50188800)
print v(xbgr.mr_n50189664)
print v(xbgr.mr_n50189776)
print v(xbgr.mr_n50190096)
print v(xbgr.mr_n50190208)
print v(xbgr.mr_n50190528)
print v(xbgr.mr_n50190640)
print v(xbgr.mr_n50190960)
print v(xbgr.mr_n50191072)
print v(xbgr.mr_n50191392)
print v(xbgr.mr_n50191504)
print v(xbgr.mr_n50191824)
print v(xbgr.mr_n50192368)
print v(xbgr.mr_n50193120)
print v(xbgr.mr_n50193984)
print v(xbgr.mr_n50194096)
print v(xbgr.mr_n50194416)
print v(xbgr.mr_n50194528)
print v(xbgr.mr_n50194960)
print v(xbgr.mr_n50195280)
print v(xbgr.mr_n50195392)
print v(xbgr.mr_n50195712)
print v(xbgr.mr_n50195824)
print v(xbgr.mr_n50196144)
print v(xbgr.mr_n50196256)
print v(xbgr.mr_n50196576)
print v(xbgr.mr_n50196688)
print v(xbgr.mr_n50197008)
print v(xbgr.mr_n50197440)
print v(xbgr.mr_n50197552)
print v(xbgr.mr_n50197872)
print v(xbgr.mr_n50197984)
print v(xbgr.mr_n50198736)
print v(xbgr.mr_n50198848)
print v(xbgr.mr_n50199168)
print v(xbgr.mr_n50199280)
print v(xbgr.mr_n50200032)
print v(xbgr.mr_n50200896)
print v(xbgr.mr_n50201008)
print v(xbgr.mr_n50201328)
print v(xbgr.mr_n50202192)
print v(xbgr.mr_n50202736)
print v(xbgr.mr_n50203056)
print v(xbgr.mr_n50203600)
print v(xbgr.mr_n50204032)
print v(xbgr.mr_n50204352)
print v(xbgr.mr_n50204464)
print v(xbgr.mr_n50205216)
print v(xbgr.mr_n50205328)
print v(xbgr.mr_n50205648)
print v(xbgr.mr_n50205760)
print v(xbgr.mr_n50206080)
print v(xbgr.mr_n50206944)
print v(xbgr.mr_n50207376)
print v(xbgr.mr_n50207488)
print v(xbgr.mr_n50207808)
print v(xbgr.mr_n50207920)
print v(xbgr.mr_n50208240)
print v(xbgr.mr_n50208352)
print v(xbgr.mr_n50208672)
print v(xbgr.mr_n50208784)
print v(xbgr.mr_n50209104)
print v(xbgr.mr_n50209216)
print v(xbgr.mr_n50210400)
print v(xbgr.mr_n50210512)
print v(xbgr.mr_n50210832)
print v(xbgr.mr_n50210944)
print v(xbgr.mr_n50211264)
print v(xbgr.mr_n50211376)
print v(xbgr.mr_n50211696)
print v(xbgr.mr_n50212128)
print v(xbgr.mr_n50344512)
print v(xbgr.mr_n50344624)
print v(xbgr.mr_n50344944)
print v(xbgr.mr_n50345056)
print v(xbgr.mr_n50345376)
print v(xbgr.mr_n50345488)
print v(xbgr.mr_n50345808)
print v(xbgr.mr_n50345920)
print v(xbgr.mr_n50346240)
print v(xbgr.mr_n50346352)
print v(xbgr.mr_n50346672)
print v(xbgr.mr_n50346784)
print v(xbgr.mr_n50347104)
print v(xbgr.mr_n50347216)
print v(xbgr.mr_n50347536)
print v(xbgr.mr_n50347648)
print v(xbgr.mr_n50347968)
print v(xbgr.mr_n50348080)
print v(xbgr.mr_n50348400)
print v(xbgr.mr_n50348512)
print v(xbgr.mr_n50348832)
print v(xbgr.mr_n50348944)
print v(xbgr.mr_n50349264)
print v(xbgr.mr_n50349376)
print v(xbgr.mr_n50349696)
print v(xbgr.mr_n50349808)
print v(xbgr.mr_n50350128)
print v(xbgr.mr_n50350240)
print v(xbgr.mr_n50350560)
print v(xbgr.mr_n50350672)
print v(xbgr.mr_n50350992)
print v(xbgr.mr_n50351104)
print v(xbgr.mr_n50351424)
print v(xbgr.mr_n50351536)
print v(xbgr.mr_n50351856)
print v(xbgr.mr_n50351968)
print v(xbgr.mr_n50352288)
print v(xbgr.mr_n50352400)
print v(xbgr.mr_n50352720)
print v(xbgr.mr_n50352832)
print v(xbgr.mr_n50353152)
print v(xbgr.mr_n50353264)
print v(xbgr.mr_n50353584)
print v(xbgr.mr_n50353696)
print v(xbgr.mr_n50354016)
print v(xbgr.mr_n50354128)
print v(xbgr.mr_n50354448)
print v(xbgr.mr_n50354560)
print v(xbgr.mr_n50354880)
print v(xbgr.mr_n50354992)
print v(xbgr.mr_n50355312)
print v(xbgr.mr_n50355424)
print v(xbgr.mr_n50355744)
print v(xbgr.mr_n50355856)
print v(xbgr.mr_n50356176)
print v(xbgr.mr_n50356288)
print v(xbgr.mr_n50356608)
print v(xbgr.mr_n50356720)
print v(xbgr.mr_n50357040)
print v(xbgr.mr_n50357152)
print v(xbgr.mr_n50357472)
print v(xbgr.mr_n50357584)
print v(xbgr.mr_n50357904)
print v(xbgr.mr_n50358016)
print v(xbgr.mr_n50358336)
print v(xbgr.mr_n50358448)
print v(xbgr.mr_n50358768)
print v(xbgr.mr_n50358880)
print v(xbgr.mr_n50359200)
print v(xbgr.mr_n50359312)
print v(xbgr.mr_n50359632)
print v(xbgr.mr_n50359744)
print v(xbgr.mr_n50360064)
print v(xbgr.mr_n50360176)
print v(xbgr.mr_n50360496)
print v(xbgr.mr_n50360608)
print v(xbgr.mr_n50360928)
print v(xbgr.mr_n50361040)
print v(xbgr.mr_n50361360)
print v(xbgr.mr_n50361472)
print v(xbgr.mr_n50361792)
print v(xbgr.mr_n50361904)
print v(xbgr.mr_n50362224)
print v(xbgr.mr_n50362336)
print v(xbgr.mr_n50362656)
print v(xbgr.mr_n50362768)
print v(xbgr.mr_n50363088)
print v(xbgr.mr_n50363200)
print v(xbgr.mr_n50363520)
print v(xbgr.mr_n50363632)
print v(xbgr.mr_n50363952)
print v(xbgr.mr_n50364064)
print v(xbgr.mr_n50364384)
print v(xbgr.mr_n50364496)
print v(xbgr.mr_n50364816)
print v(xbgr.mr_n50364928)
print v(xbgr.mr_n50365248)
print v(xbgr.mr_n50365360)
print v(xbgr.mr_n50365680)
print v(xbgr.mr_n50365792)
print v(xbgr.mr_n50366112)
print v(xbgr.mr_n50366224)
print v(xbgr.mr_n50366544)
print v(xbgr.mr_n50366656)
print v(xbgr.mr_n50366976)
print v(xbgr.mr_n50367088)
print v(xbgr.mr_n50367408)
print v(xbgr.mr_n50367520)
print v(xbgr.mr_n50367840)
print v(xbgr.mr_n50367952)
print v(xbgr.mr_n50368272)
print v(xbgr.mr_n50368384)
print v(xbgr.mr_n50368704)
print v(xbgr.mr_n50368816)
print v(xbgr.mr_n50369136)
print v(xbgr.mr_n50369248)
print v(xbgr.mr_n50369568)
print v(xbgr.mr_n50369680)
print v(xbgr.mr_n50370000)
print v(xbgr.mr_n50370112)
print v(xbgr.mr_n50370432)
print v(xbgr.mr_n50370544)
print v(xbgr.mr_n50370864)
print v(xbgr.mr_n50370976)
print v(xbgr.mr_n50371296)
print v(xbgr.mr_n50371408)
print v(xbgr.mr_n50371728)
print v(xbgr.mr_n50371840)
print v(xbgr.mr_n50372160)
print v(xbgr.mr_n50372272)
print v(xbgr.mr_n50372592)
print v(xbgr.mr_n50372704)
print v(xbgr.mr_n50373024)
print v(xbgr.mr_n50373136)
print v(xbgr.mr_n50373456)
print v(xbgr.mr_n50373568)
print v(xbgr.mr_n50373888)
print v(xbgr.mr_n50374000)
print v(xbgr.mr_n50374320)
print v(xbgr.mr_n50374432)
print v(xbgr.mr_n50374752)
print v(xbgr.mr_n50374864)
print v(xbgr.mr_n50375184)
print v(xbgr.mr_n50375296)
print v(xbgr.mr_n50375616)
print v(xbgr.mr_n50375728)
print v(xbgr.mr_n50376048)
print v(xbgr.mr_n50376160)
print v(xbgr.mr_n50376480)
print v(xbgr.mr_n50376592)
print v(xbgr.mr_n50376912)
print v(xbgr.mr_n50377024)
print v(xbgr.mr_n50377344)
print v(xbgr.mr_n50377456)
print v(xbgr.mr_n50377776)
print v(xbgr.mr_n50377888)
print v(xbgr.mr_n50378208)
print v(xbgr.mr_n50378320)
print v(xbgr.mr_n50378640)
print v(xbgr.mr_n50378752)
print v(xbgr.mr_n50379072)
print v(xbgr.mr_n50379184)
print v(xbgr.mr_n50379504)
print v(xbgr.mr_n50379616)
print v(xbgr.mr_n50379936)
print v(xbgr.mr_n50380048)
print v(xbgr.mr_n50380368)
print v(xbgr.mr_n50380480)
print v(xbgr.mr_n50380800)
print v(xbgr.mr_n50380912)
print v(xbgr.mr_n50381232)
print v(xbgr.mr_n50381344)
print v(xbgr.mr_n50381664)
print v(xbgr.mr_n50381776)
print v(xbgr.mr_n50382096)
print v(xbgr.mr_n50382208)
print v(xbgr.mr_n50382528)
print v(xbgr.mr_n50382640)
print v(xbgr.mr_n50382960)
print v(xbgr.mr_n50383072)
print v(xbgr.mr_n50383392)
print v(xbgr.mr_n50383504)
print v(xbgr.mr_n50383824)
print v(xbgr.mr_n50383936)
print v(xbgr.mr_n50384256)
print v(xbgr.mr_n50384368)
print v(xbgr.mr_n50384688)
print v(xbgr.mr_n50384800)
print v(xbgr.mr_n50385120)
print v(xbgr.mr_n50385232)
print v(xbgr.mr_n50385552)
print v(xbgr.mr_n50385664)
print v(xbgr.mr_n50385984)
print v(xbgr.mr_n50386096)
print v(xbgr.mr_n50386416)
print v(xbgr.mr_n50386528)
print v(xbgr.mr_n50386848)
print v(xbgr.mr_n50386960)
print v(xbgr.mr_n50387280)
print v(xbgr.mr_n50387392)
print v(xbgr.mr_n50387712)
print v(xbgr.mr_n50387824)
print v(xbgr.mr_n50388144)
print v(xbgr.mr_n50388256)
print v(xbgr.mr_n50388576)
print v(xbgr.mr_n50388688)
print v(xbgr.mr_n50389008)
print v(xbgr.mr_n50389120)
print v(xbgr.mr_n50389440)
print v(xbgr.mr_n50389552)
print v(xbgr.mr_n50389872)
print v(xbgr.mr_n50389984)
print v(xbgr.mr_n50390304)
print v(xbgr.mr_n50390416)
print v(xbgr.mr_n50390736)
print v(xbgr.mr_n50390848)
print v(xbgr.mr_n50391168)
print v(xbgr.mr_n50391280)
print v(xbgr.mr_n50391600)
print v(xbgr.mr_n50391712)
print v(xbgr.mr_n50392032)
print v(xbgr.mr_n50392144)
print v(xbgr.mr_n50392464)
print v(xbgr.mr_n50392576)
print v(xbgr.mr_n50392896)
print v(xbgr.mr_n50393008)
print v(xbgr.mr_n50393328)
print v(xbgr.mr_n50393440)
print v(xbgr.mr_n50393760)
print v(xbgr.mr_n50393872)
print v(xbgr.mr_n50394192)
print v(xbgr.mr_n50394304)
print v(xbgr.mr_n50394624)
print v(xbgr.mr_n50394736)
print v(xbgr.mr_n50395056)
print v(xbgr.mr_n50395168)
print v(xbgr.mr_n50395488)
print v(xbgr.mr_n50395600)
print v(xbgr.mr_n50395920)
print v(xbgr.mr_n50396032)
print v(xbgr.mr_n50396352)
print v(xbgr.mr_n50396464)
print v(xbgr.mr_n50396784)
print v(xbgr.mr_n50396896)
print v(xbgr.mr_n50397216)
print v(xbgr.mr_n50397328)
print v(xbgr.mr_n50397648)
print v(xbgr.mr_n50397760)
print v(xbgr.mr_n50398080)
print v(xbgr.mr_n50398192)
print v(xbgr.mr_n50398512)
print v(xbgr.mr_n50398624)
print v(xbgr.mr_n50398944)
print v(xbgr.mr_n50399056)
print v(xbgr.mr_n50399376)
print v(xbgr.mr_n50399488)
print v(xbgr.mr_n50399808)
print v(xbgr.mr_n50399920)
print v(xbgr.mr_n50400240)
print v(xbgr.mr_n50400352)
print v(xbgr.mr_n50400672)
print v(xbgr.mr_n50400784)
print v(xbgr.mr_n50401104)
print v(xbgr.mr_n50401216)
print v(xbgr.mr_n50401536)
print v(xbgr.mr_n50401648)
print v(xbgr.mr_n50401968)
print v(xbgr.mr_n50402080)
print v(xbgr.mr_n50402400)
print v(xbgr.mr_n50402512)
print v(xbgr.mr_n50402832)
print v(xbgr.mr_n50402944)
print v(xbgr.mr_n50403264)
print v(xbgr.mr_n50403376)
print v(xbgr.mr_n50403696)
print v(xbgr.mr_n50403808)
print v(xbgr.mr_n50404128)
print v(xbgr.mr_n50404240)
print v(xbgr.mr_n50404560)
print v(xbgr.mr_n50404672)
print v(xbgr.mr_n50404992)
print v(xbgr.mr_n50405104)
print v(xbgr.mr_n50405424)
print v(xbgr.mr_n50405536)
print v(xbgr.mr_n50405856)
print v(xbgr.mr_n50405968)
print v(xbgr.mr_n50406288)
print v(xbgr.mr_n50406400)
print v(xbgr.mr_n50406720)
print v(xbgr.mr_n50406832)
print v(xbgr.mr_n50407152)
print v(xbgr.mr_n50407264)
print v(xbgr.mr_n50407584)
print v(xbgr.mr_n50407696)
print v(xbgr.mr_n50408016)
print v(xbgr.mr_n50408128)
print v(xbgr.mr_n50408448)
print v(xbgr.mr_n50408560)
print v(xbgr.mr_n50408880)
print v(xbgr.mr_n50408992)
print v(xbgr.mr_n50409312)
print v(xbgr.mr_n50409424)
print v(xbgr.mr_n50409744)
print v(xbgr.mr_n50409856)
print v(xbgr.mr_n50410176)
print v(xbgr.mr_n50410288)
print v(xbgr.mr_n50410608)
print v(xbgr.mr_n50410720)
print v(xbgr.mr_n50411040)
print v(xbgr.mr_n50411152)
print v(xbgr.mr_n50411472)
print v(xbgr.mr_n50411584)
print v(xbgr.mr_n50411904)
print v(xbgr.mr_n50412016)
print v(xbgr.mr_n50412336)
print v(xbgr.mr_n50412448)
print v(xbgr.mr_n50412768)
print v(xbgr.mr_n50412880)
print v(xbgr.mr_n50413200)
print v(xbgr.mr_n50413312)
print v(xbgr.mr_n50413632)
print v(xbgr.mr_n50413744)
print v(xbgr.mr_n50414064)
print v(xbgr.mr_n50414176)
print v(xbgr.mr_n50414496)
print v(xbgr.mr_n50414608)
print v(xbgr.mr_n50414928)
print v(xbgr.mr_n50415040)
print v(xbgr.mr_n50415360)
print v(xbgr.mr_n50415472)
print v(xbgr.mr_n50415792)
print v(xbgr.mr_n50415904)
print v(xbgr.mr_n50416224)
print v(xbgr.mr_n50416336)
print v(xbgr.mr_n50416656)
print v(xbgr.mr_n50416768)
print v(xbgr.mr_n50417088)
print v(xbgr.mr_n50417200)
print v(xbgr.mr_n50417520)
print v(xbgr.mr_n50417632)
print v(xbgr.mr_n50417952)
print v(xbgr.mr_n50418064)
print v(xbgr.mr_n50418384)
print v(xbgr.mr_n50418496)
print v(xbgr.mr_n50418816)
print v(xbgr.mr_n50418928)
print v(xbgr.mr_n50419248)
print v(xbgr.mr_n50419360)
print v(xbgr.mr_n50419680)
print v(xbgr.mr_n50419792)
print v(xbgr.mr_n50420112)
print v(xbgr.mr_n50420224)
print v(xbgr.mr_n50420544)
print v(xbgr.mr_n50420656)
print v(xbgr.mr_n50420976)
print v(xbgr.mr_n50421088)
print v(xbgr.mr_n50421408)
print v(xbgr.mr_n50421520)
print v(xbgr.mr_n50421840)
print v(xbgr.mr_n50421952)
print v(xbgr.mr_n50422272)
print v(xbgr.mr_n50422384)
print v(xbgr.mr_n50422704)
print v(xbgr.mr_n50422816)
print v(xbgr.mr_n50423136)
print v(xbgr.mr_n50423248)
print v(xbgr.mr_n50423568)
print v(xbgr.mr_n50423680)
print v(xbgr.mr_n50424000)
print v(xbgr.mr_n50424112)
print v(xbgr.mr_n50424432)
print v(xbgr.mr_n50424544)
print v(xbgr.mr_n50424864)
print v(xbgr.mr_n50424976)
print v(xbgr.mr_n50425296)
print v(xbgr.mr_n50425408)
print v(xbgr.mr_n50425728)
print v(xbgr.mr_n50425840)
print v(xbgr.mr_n50426160)
print v(xbgr.mr_n50426272)
print v(xbgr.mr_n50426592)
print v(xbgr.mr_n50426704)
print v(xbgr.mr_n50427024)
print v(xbgr.mr_n50427136)
print v(xbgr.mr_n50427440)
print v(xbgr.mr_n50427552)
print v(xbgr.mr_n50427872)
print v(xbgr.mr_n50427984)
print v(xbgr.mr_n50428304)
print v(xbgr.mr_n50428416)
print v(xbgr.mr_n50428736)
print v(xbgr.mr_n50428848)
print v(xbgr.mr_n50429168)
print v(xbgr.mr_n50429280)
print v(xbgr.mr_n50429600)
print v(xbgr.mr_n50429712)
print v(xbgr.mr_n50430032)
print v(xbgr.mr_n50430144)
print v(xbgr.mr_n50430464)
print v(xbgr.mr_n50430576)
print v(xbgr.mr_n50430896)
print v(xbgr.mr_n50431008)
print v(xbgr.mr_n50431328)
print v(xbgr.mr_n50431440)
print v(xbgr.mr_n50431760)
print v(xbgr.mr_n50431872)
print v(xbgr.mr_n50432192)
print v(xbgr.mr_n50432304)
print v(xbgr.mr_n50432624)
print v(xbgr.mr_n50432736)
print v(xbgr.mr_n50433056)
print v(xbgr.mr_n50433168)
print v(xbgr.mr_n50433488)
print v(xbgr.mr_n50433600)
print v(xbgr.mr_n50433920)
print v(xbgr.mr_n50434032)
print v(xbgr.mr_n50434352)
print v(xbgr.mr_n50434464)
print v(xbgr.mr_n50434784)
print v(xbgr.mr_n50434896)
print v(xbgr.mr_n50435216)
print v(xbgr.mr_n50435328)
print v(xbgr.mr_n50435648)
print v(xbgr.mr_n50435760)
print v(xbgr.mr_n50436080)
print v(xbgr.mr_n50436192)
print v(xbgr.mr_n50436512)
print v(xbgr.mr_n50436624)
print v(xbgr.mr_n50436944)
print v(xbgr.mr_n50437056)
print v(xbgr.mr_n50437376)
print v(xbgr.mr_n50437488)
print v(xbgr.mr_n50437808)
print v(xbgr.mr_n50437920)
print v(xbgr.mr_n50438240)
print v(xbgr.mr_n50438352)
print v(xbgr.mr_n50438672)
print v(xbgr.mr_n50438784)
print v(xbgr.mr_n50439104)
print v(xbgr.mr_n50439216)
print v(xbgr.mr_n50439536)
print v(xbgr.mr_n50439648)
print v(xbgr.mr_n50439968)
print v(xbgr.mr_n50440080)
print v(xbgr.mr_n50440400)
print v(xbgr.mr_n50440512)
print v(xbgr.mr_n50440832)
print v(xbgr.mr_n50440944)
print v(xbgr.mr_n50441264)
print v(xbgr.mr_n50441376)
print v(xbgr.mr_n50441696)
print v(xbgr.mr_n50441808)
print v(xbgr.mr_n50442128)
print v(xbgr.mr_n50442240)
print v(xbgr.mr_n50442560)
print v(xbgr.mr_n50442672)
print v(xbgr.mr_n50442992)
print v(xbgr.mr_n50443104)
print v(xbgr.mr_n50443424)
print v(xbgr.mr_n50443536)
print v(xbgr.mr_n50443856)
print v(xbgr.mr_n50443968)
print v(xbgr.mr_n50444288)
print v(xbgr.mr_n50444400)
print v(xbgr.mr_n50444720)
print v(xbgr.mr_n50444832)
print v(xbgr.mr_n50445152)
print v(xbgr.mr_n50445264)
print v(xbgr.mr_n50445584)
print v(xbgr.mr_n50445696)
print v(xbgr.mr_n50446016)
print v(xbgr.mr_n50446128)
print v(xbgr.mr_n50446448)
print v(xbgr.mr_n50446560)
print v(xbgr.mr_n50446880)
print v(xbgr.mr_n50446992)
print v(xbgr.mr_n50447312)
print v(xbgr.mr_n50447424)
print v(xbgr.mr_n50447744)
print v(xbgr.mr_n50447856)
print v(xbgr.mr_n50448176)
print v(xbgr.mr_n50448288)
print v(xbgr.mr_n50448608)
print v(xbgr.mr_n50448720)
print v(xbgr.mr_n50449040)
print v(xbgr.mr_n50449152)
print v(xbgr.mr_n50449472)
print v(xbgr.mr_n50449584)
print v(xbgr.mr_n50449904)
print v(xbgr.mr_n50450016)
print v(xbgr.mr_n50450336)
print v(xbgr.mr_n50450448)
print v(xbgr.mr_n50450768)
print v(xbgr.mr_n50450880)
print v(xbgr.mr_n50451200)
print v(xbgr.mr_n50451312)
print v(xbgr.mr_n50451632)
print v(xbgr.mr_n50451744)
print v(xbgr.mr_n50452064)
print v(xbgr.mr_n50452176)
print v(xbgr.mr_n50452496)
print v(xbgr.mr_n50452608)
print v(xbgr.mr_n50452928)
print v(xbgr.mr_n50453040)
print v(xbgr.mr_n50453360)
print v(xbgr.mr_n50453472)
print v(xbgr.mr_n50453792)
print v(xbgr.mr_n50453904)
print v(xbgr.mr_n50454224)
print v(xbgr.mr_n50454336)
print v(xbgr.mr_n50454656)
print v(xbgr.mr_n50454768)
print v(xbgr.mr_n50455088)
print v(xbgr.mr_n50455200)
print v(xbgr.mr_n50455520)
print v(xbgr.mr_n50455632)
print v(xbgr.mr_n50455952)
print v(xbgr.mr_n50456064)
print v(xbgr.mr_n50456384)
print v(xbgr.mr_n50456496)
print v(xbgr.mr_n50456816)
print v(xbgr.mr_n50456928)
print v(xbgr.mr_n50457248)
print v(xbgr.mr_n50457360)
print v(xbgr.mr_n50457680)
print v(xbgr.mr_n50457792)
print v(xbgr.mr_n50458112)
print v(xbgr.mr_n50458224)
print v(xbgr.mr_n50458544)
print v(xbgr.mr_n50458656)
print v(xbgr.mr_n50458976)
print v(xbgr.mr_n50459088)
print v(xbgr.mr_n50459408)
print v(xbgr.mr_n50459520)
print v(xbgr.mr_n50459840)
print v(xbgr.mr_n50459952)
print v(xbgr.mr_n50460272)
print v(xbgr.mr_n50460384)
print v(xbgr.mr_n50460704)
print v(xbgr.mr_n50460816)
print v(xbgr.mr_n50461136)
print v(xbgr.mr_n50461248)
print v(xbgr.mr_n50461568)
print v(xbgr.mr_n50461680)
print v(xbgr.mr_n50462000)
print v(xbgr.mr_n50462112)
print v(xbgr.mr_n50462432)
print v(xbgr.mr_n50462544)
print v(xbgr.mr_n50462864)
print v(xbgr.mr_n50462976)
print v(xbgr.mr_n50463296)
print v(xbgr.mr_n50463408)
print v(xbgr.mr_n50463728)
print v(xbgr.mr_n50463840)
print v(xbgr.mr_n50464160)
print v(xbgr.mr_n50464272)
print v(xbgr.mr_n50464592)
print v(xbgr.mr_n50464704)
print v(xbgr.mr_n50465024)
print v(xbgr.mr_n50465136)
print v(xbgr.mr_n50465456)
print v(xbgr.mr_n50465568)
print v(xbgr.mr_n50465888)
print v(xbgr.mr_n50466000)
print v(xbgr.mr_n50466320)
print v(xbgr.mr_n50466432)
print v(xbgr.mr_n50466752)
print v(xbgr.mr_n50466864)
print v(xbgr.mr_n50467184)
print v(xbgr.mr_n50467296)
print v(xbgr.mr_n50467616)
print v(xbgr.mr_n50467728)
print v(xbgr.mr_n50468048)
print v(xbgr.mr_n50468160)
print v(xbgr.mr_n50468480)
print v(xbgr.mr_n50468592)
print v(xbgr.mr_n50468912)
print v(xbgr.mr_n50469024)
print v(xbgr.mr_n50469344)
print v(xbgr.mr_n50469456)
print v(xbgr.mr_n50469776)
print v(xbgr.mr_n50469888)
print v(xbgr.mr_n50470208)
print v(xbgr.mr_n50470320)
print v(xbgr.mr_n50470640)
print v(xbgr.mr_n50470752)
print v(xbgr.mr_n50471072)
print v(xbgr.mr_n50471184)
print v(xbgr.mr_n50471504)
print v(xbgr.mr_n50471616)
print v(xbgr.mr_n50471936)
print v(xbgr.mr_n50472048)
print v(xbgr.mr_n50472368)
print v(xbgr.mr_n50472480)
print v(xbgr.mr_n50472800)
print v(xbgr.mr_n50472912)
print v(xbgr.mr_n50473232)
print v(xbgr.mr_n50473344)
print v(xbgr.mr_n50473664)
print v(xbgr.mr_n50473776)
print v(xbgr.mr_n50474096)
print v(xbgr.mr_n50474208)
print v(xbgr.mr_n50474528)
print v(xbgr.mr_n50474640)
print v(xbgr.mr_n50474960)
print v(xbgr.mr_n50475072)
print v(xbgr.mr_n50475392)
print v(xbgr.mr_n50475600)
print v(xbgr.mr_n50475840)
print v(xbgr.mr_n50476704)
print v(xbgr.mr_n50476816)
print v(xbgr.mr_n50477136)
print v(xbgr.mr_n50477248)
print v(xbgr.mr_n50477568)
print v(xbgr.mr_n50477680)
print v(xbgr.mr_n50478000)
print v(xbgr.mr_n50478112)
print v(xbgr.mr_n50478432)
print v(xbgr.mr_n50478544)
print v(xbgr.mr_n50478864)
print v(xbgr.mr_n50478976)
print v(xbgr.mr_n50479296)
print v(xbgr.mr_n50480160)
print v(xbgr.mr_n50481024)
print v(xbgr.mr_n50481888)
print v(xbgr.mr_n50482000)
print v(xbgr.mr_n50482752)
print v(xbgr.mr_n50482864)
print v(xbgr.mr_n50483184)
print v(xbgr.mr_n50484048)
print v(xbgr.mr_n50484912)
print v(xbgr.mr_n50485776)
print v(xbgr.mr_n50486640)
print v(xbgr.mr_n50487184)
print v(xbgr.mr_n50487936)
print v(xbgr.mr_n50488480)
print v(xbgr.mr_n50488912)
print v(xbgr.mr_n50489664)
print v(xbgr.mr_n50489776)
print v(xbgr.mr_n50490096)
print v(xbgr.mr_n50490208)
print v(xbgr.mr_n50490528)
print v(xbgr.mr_n50491392)
print v(xbgr.mr_n50492256)
print v(xbgr.mr_n50493120)
print v(xbgr.mr_n50493232)
print v(xbgr.mr_n50493552)
print v(xbgr.mr_n50493664)
print v(xbgr.mr_n50494096)
print v(xbgr.mr_n50494416)
print v(xbgr.mr_n50494528)
print v(xbgr.mr_n50494848)
print v(xbgr.mr_n50495712)
print v(xbgr.mr_n50495824)
print v(xbgr.mr_n50496256)
print v(xbgr.mr_n50496576)
print v(xbgr.mr_n50496688)
print v(xbgr.mr_n50497008)
print v(xbgr.mr_n50497120)
print v(xbgr.mr_n50497440)
print v(xbgr.mr_n50497552)
print v(xbgr.mr_n50497872)
print v(xbgr.mr_n50497984)
print v(xbgr.mr_n50498304)
print v(xbgr.mr_n50499280)
print v(xbgr.mr_n50499600)
print v(xbgr.mr_n50499712)
print v(xbgr.mr_n50500032)
print v(xbgr.mr_n50500144)
print v(xbgr.mr_n50500464)
print v(xbgr.mr_n50500576)
print v(xbgr.mr_n50500896)
print v(xbgr.mr_n50501008)
print v(xbgr.mr_n50501328)
print v(xbgr.mr_n50501760)
print v(xbgr.mr_n50502736)
print v(xbgr.mr_n50503056)
print v(xbgr.mr_n50503920)
print v(xbgr.mr_n50504784)
print v(xbgr.mr_n50504896)
print v(xbgr.mr_n50505648)
print v(xbgr.mr_n50506512)
print v(xbgr.mr_n50506624)
print v(xbgr.mr_n50506944)
print v(xbgr.mr_n50507808)
print v(xbgr.mr_n50507920)
print v(xbgr.mr_n50508240)
print v(xbgr.mr_n50508352)
print v(xbgr.mr_n50508672)
print v(xbgr.mr_n50509536)
print v(xbgr.mr_n50509648)
print v(xbgr.mr_n50509968)
print v(xbgr.mr_n50510080)
print v(xbgr.mr_n50510400)
print v(xbgr.mr_n50510512)
print v(xbgr.mr_n50510832)
print v(xbgr.mr_n50510944)
print v(xbgr.mr_n50511264)
print v(xbgr.mr_n50512240)
print v(xbgr.mr_n50512672)
print v(xbgr.mr_n50512992)
print v(xbgr.mr_n50513856)
print v(xbgr.mr_n50514720)
print v(xbgr.mr_n50514832)
print v(xbgr.mr_n50515152)
print v(xbgr.mr_n50515264)
print v(xbgr.mr_n50515584)
print v(xbgr.mr_n50515696)
print v(xbgr.mr_n50516016)
print v(xbgr.mr_n50516128)
print v(xbgr.mr_n50516560)
print v(xbgr.mr_n50516992)
print v(xbgr.mr_n50517312)
print v(xbgr.mr_n50517424)
print v(xbgr.mr_n50517744)
print v(xbgr.mr_n50517856)
print v(xbgr.mr_n50518176)
print v(xbgr.mr_n50518288)
print v(xbgr.mr_n50518608)
print v(xbgr.mr_n50518720)
print v(xbgr.mr_n50519040)
print v(xbgr.mr_n50519904)
print v(xbgr.mr_n50520768)
print v(xbgr.mr_n50520880)
print v(xbgr.mr_n50521200)
print v(xbgr.mr_n50522064)
print v(xbgr.mr_n50522928)
print v(xbgr.mr_n50523040)
print v(xbgr.mr_n50523360)
print v(xbgr.mr_n50523472)
print v(xbgr.mr_n50523904)
print v(xbgr.mr_n50524224)
print v(xbgr.mr_n50524336)
print v(xbgr.mr_n50524768)
print v(xbgr.mr_n50525088)
print v(xbgr.mr_n50525520)
print v(xbgr.mr_n50525632)
print v(xbgr.mr_n50525952)
print v(xbgr.mr_n50526064)
print v(xbgr.mr_n50526384)
print v(xbgr.mr_n50526816)
print v(xbgr.mr_n50526928)
print v(xbgr.mr_n50527680)
print v(xbgr.mr_n50527792)
print v(xbgr.mr_n50528112)
print v(xbgr.mr_n50528224)
print v(xbgr.mr_n50528544)
print v(xbgr.mr_n50528976)
print v(xbgr.mr_n50529088)
print v(xbgr.mr_n50529408)
print v(xbgr.mr_n50529840)
print v(xbgr.mr_n50530704)
print v(xbgr.mr_n50532432)
print v(xbgr.mr_n50532544)
print v(xbgr.mr_n50532864)
print v(xbgr.mr_n50532976)
print v(xbgr.mr_n50533296)
print v(xbgr.mr_n50533408)
print v(xbgr.mr_n50533840)
print v(xbgr.mr_n50534272)
print v(xbgr.mr_n50534592)
print v(xbgr.mr_n50534704)
print v(xbgr.mr_n50535024)
print v(xbgr.mr_n50536432)
print v(xbgr.mr_n50536752)
print v(xbgr.mr_n50537728)
print v(xbgr.mr_n50538048)
print v(xbgr.mr_n50538160)
print v(xbgr.mr_n50538480)
print v(xbgr.mr_n50538592)
print v(xbgr.mr_n50539024)
print v(xbgr.mr_n50539344)
print v(xbgr.mr_n50539456)
print v(xbgr.mr_n50539888)
print v(xbgr.mr_n50540208)
print v(xbgr.mr_n50540320)
print v(xbgr.mr_n50540640)
print v(xbgr.mr_n50540752)
print v(xbgr.mr_n50541072)
print v(xbgr.mr_n50541936)
print v(xbgr.mr_n50542368)
print v(xbgr.mr_n50543232)
print v(xbgr.mr_n50543344)
print v(xbgr.mr_n50543664)
print v(xbgr.mr_n50543776)
print v(xbgr.mr_n50544096)
print v(xbgr.mr_n50544208)
print v(xbgr.mr_n50544960)
print v(xbgr.mr_n50545392)
print v(xbgr.mr_n50545504)
print v(xbgr.mr_n50545824)
print v(xbgr.mr_n50546256)
print v(xbgr.mr_n50546368)
print v(xbgr.mr_n50546688)
print v(xbgr.mr_n50546800)
print v(xbgr.mr_n50547120)
print v(xbgr.mr_n50547232)
print v(xbgr.mr_n50547552)
print v(xbgr.mr_n50547664)
print v(xbgr.mr_n50547984)
print v(xbgr.mr_n50548096)
print v(xbgr.mr_n50548416)
print v(xbgr.mr_n50549824)
print v(xbgr.mr_n50550144)
print v(xbgr.mr_n50550256)
print v(xbgr.mr_n50550688)
print v(xbgr.mr_n50551008)
print v(xbgr.mr_n50551120)
print v(xbgr.mr_n50551440)
print v(xbgr.mr_n50551872)
print v(xbgr.mr_n50552736)
print v(xbgr.mr_n50553600)
print v(xbgr.mr_n50554464)
print v(xbgr.mr_n50555328)
print v(xbgr.mr_n50556192)
print v(xbgr.mr_n50557488)
print v(xbgr.mr_n50557920)
print v(xbgr.mr_n50558032)
print v(xbgr.mr_n50558352)
print v(xbgr.mr_n50558784)
print v(xbgr.mr_n50558896)
print v(xbgr.mr_n50559216)
print v(xbgr.mr_n50560080)
print v(xbgr.mr_n50560192)
print v(xbgr.mr_n50560512)
print v(xbgr.mr_n50560624)
print v(xbgr.mr_n50560944)
print v(xbgr.mr_n50561808)
print v(xbgr.mr_n50561920)
print v(xbgr.mr_n50562784)
print v(xbgr.mr_n50563216)
print v(xbgr.mr_n50563648)
print v(xbgr.mr_n50564400)
print v(xbgr.mr_n50564512)
print v(xbgr.mr_n50564944)
print v(xbgr.mr_n50565696)
print v(xbgr.mr_n50566128)
print v(xbgr.mr_n50566240)
print v(xbgr.mr_n50566672)
print v(xbgr.mr_n50567424)
print v(xbgr.mr_n50567536)
print v(xbgr.mr_n50567856)
print v(xbgr.mr_n50567968)
print v(xbgr.mr_n50568288)
print v(xbgr.mr_n50568400)
print v(xbgr.mr_n50568720)
print v(xbgr.mr_n50568832)
print v(xbgr.mr_n50569152)
print v(xbgr.mr_n50569264)
print v(xbgr.mr_n50569584)
print v(xbgr.mr_n50569696)
print v(xbgr.mr_n50570016)
print v(xbgr.mr_n50570128)
print v(xbgr.mr_n50570448)
print v(xbgr.mr_n50570560)
print v(xbgr.mr_n50570880)
print v(xbgr.mr_n50570992)
print v(xbgr.mr_n50571312)
print v(xbgr.mr_n50571424)
print v(xbgr.mr_n50571744)
print v(xbgr.mr_n50571856)
print v(xbgr.mr_n50572176)
print v(xbgr.mr_n50572288)
print v(xbgr.mr_n50572608)
print v(xbgr.mr_n50572720)
print v(xbgr.mr_n50573040)
print v(xbgr.mr_n50573152)
print v(xbgr.mr_n50573584)
print v(xbgr.mr_n50573904)
print v(xbgr.mr_n50574016)
print v(xbgr.mr_n50574448)
print v(xbgr.mr_n50574768)
print v(xbgr.mr_n50574880)
print v(xbgr.mr_n50575632)
print v(xbgr.mr_n50576064)
print v(xbgr.mr_n50576928)
print v(xbgr.mr_n50577792)
print v(xbgr.mr_n50578656)
print v(xbgr.mr_n50578768)
print v(xbgr.mr_n50579088)
print v(xbgr.mr_n50579200)
print v(xbgr.mr_n50579520)
print v(xbgr.mr_n50579632)
print v(xbgr.mr_n50579952)
print v(xbgr.mr_n50580064)
print v(xbgr.mr_n50580816)
print v(xbgr.mr_n50581680)
print v(xbgr.mr_n50582544)
print v(xbgr.mr_n50583408)
print v(xbgr.mr_n50584704)
print v(xbgr.mr_n50584816)
print v(xbgr.mr_n50585136)
print v(xbgr.mr_n50585248)
print v(xbgr.mr_n50585568)
print v(xbgr.mr_n50585680)
print v(xbgr.mr_n50586112)
print v(xbgr.mr_n50586544)
print v(xbgr.mr_n50586976)
print v(xbgr.mr_n50587296)
print v(xbgr.mr_n50587408)
print v(xbgr.mr_n50587840)
print v(xbgr.mr_n50588160)
print v(xbgr.mr_n50588272)
print v(xbgr.mr_n50588592)
print v(xbgr.mr_n50588704)
print v(xbgr.mr_n50589024)
print v(xbgr.mr_n50589136)
print v(xbgr.mr_n50589456)
print v(xbgr.mr_n50589568)
print v(xbgr.mr_n50589888)
print v(xbgr.mr_n50590000)
print v(xbgr.mr_n50590432)
print v(xbgr.mr_n50590752)
print v(xbgr.mr_n50590864)
print v(xbgr.mr_n50591296)
print v(xbgr.mr_n50591616)
print v(xbgr.mr_n50592048)
print v(xbgr.mr_n50592160)
print v(xbgr.mr_n50592592)
print v(xbgr.mr_n50592912)
print v(xbgr.mr_n50593024)
print v(xbgr.mr_n50593456)
print v(xbgr.mr_n50593776)
print v(xbgr.mr_n50593888)
print v(xbgr.mr_n50594320)
print v(xbgr.mr_n50594640)
print v(xbgr.mr_n50594752)
print v(xbgr.mr_n50595072)
print v(xbgr.mr_n50595184)
print v(xbgr.mr_n50595504)
print v(xbgr.mr_n50596368)
print v(xbgr.mr_n50597232)
print v(xbgr.mr_n50598096)
print v(xbgr.mr_n50598960)
print v(xbgr.mr_n50599824)
print v(xbgr.mr_n50600688)
print v(xbgr.mr_n50600800)
print v(xbgr.mr_n50601552)
print v(xbgr.mr_n50602416)
print v(xbgr.mr_n50603280)
print v(xbgr.mr_n50604144)
print v(xbgr.mr_n50605008)
print v(xbgr.mr_n50605872)
print v(xbgr.mr_n50605984)
print v(xbgr.mr_n50606304)
print v(xbgr.mr_n50606416)
print v(xbgr.mr_n50606736)
print v(xbgr.mr_n50606848)
print v(xbgr.mr_n50607168)
print v(xbgr.mr_n50607280)
print v(xbgr.mr_n50607600)
print v(xbgr.mr_n50608464)
print v(xbgr.mr_n50609328)
print v(xbgr.mr_n50610192)
print v(xbgr.mr_n50610304)
print v(xbgr.mr_n50610624)
print v(xbgr.mr_n50610736)
print v(xbgr.mr_n50611056)
print v(xbgr.mr_n50611168)
print v(xbgr.mr_n50611488)
print v(xbgr.mr_n50612352)
print v(xbgr.mr_n50613216)
print v(xbgr.mr_n50614080)
print v(xbgr.mr_n50614192)
print v(xbgr.mr_n50614512)
print v(xbgr.mr_n50614624)
print v(xbgr.mr_n50614944)
print v(xbgr.mr_n50615056)
print v(xbgr.mr_n50615488)
print v(xbgr.mr_n50615920)
print v(xbgr.mr_n50616352)
print v(xbgr.mr_n50616672)
print v(xbgr.mr_n50616784)
print v(xbgr.mr_n50617104)
print v(xbgr.mr_n50617216)
print v(xbgr.mr_n50617536)
print v(xbgr.mr_n50617648)
print v(xbgr.mr_n50617968)
print v(xbgr.mr_n50618080)
print v(xbgr.mr_n50618400)
print v(xbgr.mr_n50618512)
print v(xbgr.mr_n50618832)
print v(xbgr.mr_n50618944)
print v(xbgr.mr_n50619264)
print v(xbgr.mr_n50619376)
print v(xbgr.mr_n50619696)
print v(xbgr.mr_n50619808)
print v(xbgr.mr_n50620128)
print v(xbgr.mr_n50620240)
print v(xbgr.mr_n50620672)
print v(xbgr.mr_n50620992)
print v(xbgr.mr_n50621104)
print v(xbgr.mr_n50621424)
print v(xbgr.mr_n50621856)
print v(xbgr.mr_n50621968)
print v(xbgr.mr_n50622288)
print v(xbgr.mr_n50622400)
print v(xbgr.mr_n50622720)
print v(xbgr.mr_n50622832)
print v(xbgr.mr_n50623152)
print v(xbgr.mr_n50623264)
print v(xbgr.mr_n50624016)
print v(xbgr.mr_n50624128)
print v(xbgr.mr_n50624880)
print v(xbgr.mr_n50625744)
print v(xbgr.mr_n50625856)
print v(xbgr.mr_n50626176)
print v(xbgr.mr_n50626288)
print v(xbgr.mr_n50626608)
print v(xbgr.mr_n50626720)
print v(xbgr.mr_n50627040)
print v(xbgr.mr_n50627152)
print v(xbgr.mr_n50627584)
print v(xbgr.mr_n50628016)
print v(xbgr.mr_n50628336)
print v(xbgr.mr_n50628448)
print v(xbgr.mr_n50628768)
print v(xbgr.mr_n50628880)
print v(xbgr.mr_n50629200)
print v(xbgr.mr_n50630064)
print v(xbgr.mr_n50631360)
print v(xbgr.mr_n50632224)
print v(xbgr.mr_n50632336)
print v(xbgr.mr_n50632656)
print v(xbgr.mr_n50632768)
print v(xbgr.mr_n50633088)
print v(xbgr.mr_n50633200)
print v(xbgr.mr_n50633520)
print v(xbgr.mr_n50633632)
print v(xbgr.mr_n50634064)
print v(xbgr.mr_n50634384)
print v(xbgr.mr_n50634496)
print v(xbgr.mr_n50634816)
print v(xbgr.mr_n50634928)
print v(xbgr.mr_n50635248)
print v(xbgr.mr_n50635360)
print v(xbgr.mr_n50635792)
print v(xbgr.mr_n50636112)
print v(xbgr.mr_n50636224)
print v(xbgr.mr_n50636544)
print v(xbgr.mr_n50636656)
print v(xbgr.mr_n50636976)
print v(xbgr.mr_n50637840)
print v(xbgr.mr_n50638704)
print v(xbgr.mr_n50639568)
print v(xbgr.mr_n50640432)
print v(xbgr.mr_n50640544)
print v(xbgr.mr_n50640864)
print v(xbgr.mr_n50640976)
print v(xbgr.mr_n50641408)
print v(xbgr.mr_n50641840)
print v(xbgr.mr_n50642160)
print v(xbgr.mr_n50642272)
print v(xbgr.mr_n50642592)
print v(xbgr.mr_n50643456)
print v(xbgr.mr_n50644320)
print v(xbgr.mr_n50644432)
print v(xbgr.mr_n50644752)
print v(xbgr.mr_n50644864)
print v(xbgr.mr_n50645184)
print v(xbgr.mr_n50645296)
print v(xbgr.mr_n50645616)
print v(xbgr.mr_n50645728)
print v(xbgr.mr_n50646048)
print v(xbgr.mr_n50646160)
print v(xbgr.mr_n50646592)
print v(xbgr.mr_n50646912)
print v(xbgr.mr_n50647024)
print v(xbgr.mr_n50647776)
print v(xbgr.mr_n50648640)
print v(xbgr.mr_n50648752)
print v(xbgr.mr_n50649072)
print v(xbgr.mr_n50649184)
print v(xbgr.mr_n50649616)
print v(xbgr.mr_n50649936)
print v(xbgr.mr_n50650048)
print v(xbgr.mr_n50650368)
print v(xbgr.mr_n50650480)
print v(xbgr.mr_n50650800)
print v(xbgr.mr_n50650912)
print v(xbgr.mr_n50651232)
print v(xbgr.mr_n50651344)
print v(xbgr.mr_n50651664)
print v(xbgr.mr_n50651776)
print v(xbgr.mr_n50652096)
print v(xbgr.mr_n50652960)
print v(xbgr.mr_n50653936)
print v(xbgr.mr_n50654256)
print v(xbgr.mr_n50655120)
print v(xbgr.mr_n50655984)
print v(xbgr.mr_n50656848)
print v(xbgr.mr_n50657280)
print v(xbgr.mr_n50657712)
print v(xbgr.mr_n50657824)
print v(xbgr.mr_n50658144)
print v(xbgr.mr_n50658256)
print v(xbgr.mr_n50658576)
print v(xbgr.mr_n50658688)
print v(xbgr.mr_n50659008)
print v(xbgr.mr_n50659120)
print v(xbgr.mr_n50659440)
print v(xbgr.mr_n50659552)
print v(xbgr.mr_n50659872)
print v(xbgr.mr_n50659984)
print v(xbgr.mr_n50660304)
print v(xbgr.mr_n50661168)
print v(xbgr.mr_n50662032)
print v(xbgr.mr_n50662144)
print v(xbgr.mr_n50662464)
print v(xbgr.mr_n50662576)
print v(xbgr.mr_n50662896)
print v(xbgr.mr_n50663008)
print v(xbgr.mr_n50663328)
print v(xbgr.mr_n50663440)
print v(xbgr.mr_n50665056)
print v(xbgr.mr_n50665920)
print v(xbgr.mr_n50666032)
print v(xbgr.mr_n50666352)
print v(xbgr.mr_n50666464)
print v(xbgr.mr_n50666784)
print v(xbgr.mr_n50667216)
print v(xbgr.mr_n50667328)
print v(xbgr.mr_n50667648)
print v(xbgr.mr_n50667760)
print v(xbgr.mr_n50668080)
print v(xbgr.mr_n50668192)
print v(xbgr.mr_n50668624)
print v(xbgr.mr_n50668944)
print v(xbgr.mr_n50669056)
print v(xbgr.mr_n50669488)
print v(xbgr.mr_n50670240)
print v(xbgr.mr_n50671104)
print v(xbgr.mr_n50672400)
print v(xbgr.mr_n50672512)
print v(xbgr.mr_n50672944)
print v(xbgr.mr_n50673264)
print v(xbgr.mr_n50674128)
print v(xbgr.mr_n50674992)
print v(xbgr.mr_n50675424)
print v(xbgr.mr_n50676720)
print v(xbgr.mr_n50677584)
print v(xbgr.mr_n50678016)
print v(xbgr.mr_n50678880)
print v(xbgr.mr_n50680176)
print v(xbgr.mr_n50680288)
print v(xbgr.mr_n50680608)
print v(xbgr.mr_n50680720)
print v(xbgr.mr_n50681040)
print v(xbgr.mr_n50681152)
print v(xbgr.mr_n50681472)
print v(xbgr.mr_n50681584)
print v(xbgr.mr_n50681904)
print v(xbgr.mr_n50682016)
print v(xbgr.mr_n50682336)
print v(xbgr.mr_n50682448)
print v(xbgr.mr_n50682768)
print v(xbgr.mr_n50682880)
print v(xbgr.mr_n50683632)
print v(xbgr.mr_n50683744)
print v(xbgr.mr_n50684176)
print v(xbgr.mr_n50684496)
print v(xbgr.mr_n50684608)
print v(xbgr.mr_n50684928)
print v(xbgr.mr_n50685040)
print v(xbgr.mr_n50685360)
print v(xbgr.mr_n50685472)
print v(xbgr.mr_n50685792)
print v(xbgr.mr_n50685904)
print v(xbgr.mr_n50686224)
print v(xbgr.mr_n50686336)
print v(xbgr.mr_n50686768)
print v(xbgr.mr_n50687088)
print v(xbgr.mr_n50687632)
print v(xbgr.mr_n50687952)
print v(xbgr.mr_n50688064)
print v(xbgr.mr_n50688496)
print v(xbgr.mr_n50688816)
print v(xbgr.mr_n50688928)
print v(xbgr.mr_n50689360)
print v(xbgr.mr_n50689680)
print v(xbgr.mr_n50689792)
print v(xbgr.mr_n50690112)
print v(xbgr.mr_n50690224)
print v(xbgr.mr_n50690544)
print v(xbgr.mr_n50690656)
print v(xbgr.mr_n50690976)
print v(xbgr.mr_n50691088)
print v(xbgr.mr_n50691408)
print v(xbgr.mr_n50691520)
print v(xbgr.mr_n50691840)
print v(xbgr.mr_n50691952)
print v(xbgr.mr_n50692272)
print v(xbgr.mr_n50692384)
print v(xbgr.mr_n50692704)
print v(xbgr.mr_n50692816)
print v(xbgr.mr_n50693136)
print v(xbgr.mr_n50694000)
print v(xbgr.mr_n50694112)
print v(xbgr.mr_n50694432)
print v(xbgr.mr_n50694544)
print v(xbgr.mr_n50694864)
print v(xbgr.mr_n50694976)
print v(xbgr.mr_n50695296)
print v(xbgr.mr_n50695408)
print v(xbgr.mr_n50695728)
print v(xbgr.mr_n50696592)
print v(xbgr.mr_n50697456)
print v(xbgr.mr_n50698320)
print v(xbgr.mr_n50698864)
print v(xbgr.mr_n50699296)
print v(xbgr.mr_n50699616)
print v(xbgr.mr_n50699728)
print v(xbgr.mr_n50700048)
print v(xbgr.mr_n50700160)
print v(xbgr.mr_n50700480)
print v(xbgr.mr_n50700592)
print v(xbgr.mr_n50700912)
print v(xbgr.mr_n50701024)
print v(xbgr.mr_n50701344)
print v(xbgr.mr_n50702640)
print v(xbgr.mr_n50703504)
print v(xbgr.mr_n50704480)
print v(xbgr.mr_n50704912)
print v(xbgr.mr_n50705232)
print v(xbgr.mr_n50705664)
print v(xbgr.mr_n50706528)
print v(xbgr.mr_n50707392)
print v(xbgr.mr_n50707504)
print v(xbgr.mr_n50707824)
print v(xbgr.mr_n50707936)
print v(xbgr.mr_n50708256)
print v(xbgr.mr_n50708368)
print v(xbgr.mr_n50708688)
print v(xbgr.mr_n50708800)
print v(xbgr.mr_n50709984)
print v(xbgr.mr_n50710096)
print v(xbgr.mr_n50710416)
print v(xbgr.mr_n50710528)
print v(xbgr.mr_n50710848)
print v(xbgr.mr_n50710960)
print v(xbgr.mr_n50711392)
print v(xbgr.mr_n50711712)
print v(xbgr.mr_n50712144)
print v(xbgr.mr_n50712256)
print v(xbgr.mr_n50712688)
print v(xbgr.mr_n50713008)
print v(xbgr.mr_n50713872)
print v(xbgr.mr_n50713984)
print v(xbgr.mr_n50714416)
print v(xbgr.mr_n50714736)
print v(xbgr.mr_n50714848)
print v(xbgr.mr_n50715600)
print v(xbgr.mr_n50716144)
print v(xbgr.mr_n50716464)
print v(xbgr.mr_n50716576)
print v(xbgr.mr_n50716896)
print v(xbgr.mr_n50717008)
print v(xbgr.mr_n50717328)
print v(xbgr.mr_n50717440)
print v(xbgr.mr_n50717760)
print v(xbgr.mr_n50718192)
print v(xbgr.mr_n50718304)
print v(xbgr.mr_n50718624)
print v(xbgr.mr_n50718736)
print v(xbgr.mr_n50719056)
print v(xbgr.mr_n50719168)
print v(xbgr.mr_n50719920)
print v(xbgr.mr_n50720032)
print v(xbgr.mr_n50720464)
print v(xbgr.mr_n50720784)
print v(xbgr.mr_n50720896)
print v(xbgr.mr_n50721216)
print v(xbgr.mr_n50721328)
print v(xbgr.mr_n50721648)
print v(xbgr.mr_n50721760)
print v(xbgr.mr_n50722080)
print v(xbgr.mr_n50722944)
print v(xbgr.mr_n50723376)
print v(xbgr.mr_n50723808)
print v(xbgr.mr_n50723920)
print v(xbgr.mr_n50724240)
print v(xbgr.mr_n50724352)
print v(xbgr.mr_n50725104)
print v(xbgr.mr_n50725216)
print v(xbgr.mr_n50725536)
print v(xbgr.mr_n50725648)
print v(xbgr.mr_n50726400)
print v(xbgr.mr_n50727264)
print v(xbgr.mr_n50727376)
print v(xbgr.mr_n50727696)
print v(xbgr.mr_n50728560)
print v(xbgr.mr_n50728672)
print v(xbgr.mr_n50728992)
print v(xbgr.mr_n50729104)
print v(xbgr.mr_n50729424)
print v(xbgr.mr_n50729536)
print v(xbgr.mr_n50729856)
print v(xbgr.mr_n50729968)
print v(xbgr.mr_n50730288)
print v(xbgr.mr_n50730400)
print v(xbgr.mr_n50730720)
print v(xbgr.mr_n50730832)
print v(xbgr.mr_n50731152)
print v(xbgr.mr_n50731264)
print v(xbgr.mr_n50731696)
print v(xbgr.mr_n50732128)
print v(xbgr.mr_n50732448)
print v(xbgr.mr_n50732880)
print v(xbgr.mr_n50732992)
print v(xbgr.mr_n50734176)
print v(xbgr.mr_n50735904)
print v(xbgr.mr_n50736016)
print v(xbgr.mr_n50736448)
print v(xbgr.mr_n50736768)
print v(xbgr.mr_n50736880)
print v(xbgr.mr_n50737200)
print v(xbgr.mr_n50737312)
print v(xbgr.mr_n50737744)
print v(xbgr.mr_n50738064)
print v(xbgr.mr_n50738176)
print v(xbgr.mr_n50738496)
print v(xbgr.mr_n50738928)
print v(xbgr.mr_n50739040)
print v(xbgr.mr_n50739792)
print v(xbgr.mr_n50739904)
print v(xbgr.mr_n50740224)
print v(xbgr.mr_n50740336)
print v(xbgr.mr_n50740656)
print v(xbgr.mr_n50740768)
print v(xbgr.mr_n50741088)
print v(xbgr.mr_n50741200)
print v(xbgr.mr_n50741520)
print v(xbgr.mr_n50741632)
print v(xbgr.mr_n50741952)
print v(xbgr.mr_n50742816)
print v(xbgr.mr_n50743680)
print v(xbgr.mr_n50744544)
print v(xbgr.mr_n50744656)
print v(xbgr.mr_n50744976)
print v(xbgr.mr_n50745408)
print v(xbgr.mr_n50745520)
print v(xbgr.mr_n50745840)
print v(xbgr.mr_n50745952)
print v(xbgr.mr_n50746272)
print v(xbgr.mr_n50746384)
print v(xbgr.mr_n50746704)
print v(xbgr.mr_n50747568)
print v(xbgr.mr_n50748544)
print v(xbgr.mr_n50748864)
print v(xbgr.mr_n50748976)
print v(xbgr.mr_n50749296)
print v(xbgr.mr_n50749408)
print v(xbgr.mr_n50749728)
print v(xbgr.mr_n50749840)
print v(xbgr.mr_n50750160)
print v(xbgr.mr_n50750272)
print v(xbgr.mr_n50750592)
print v(xbgr.mr_n50751136)
print v(xbgr.mr_n50751568)
print v(xbgr.mr_n50752000)
print v(xbgr.mr_n50753184)
print v(xbgr.mr_n50753296)
print v(xbgr.mr_n50753616)
print v(xbgr.mr_n50753728)
print v(xbgr.mr_n50754048)
print v(xbgr.mr_n50754912)
print v(xbgr.mr_n50755024)
print v(xbgr.mr_n50755344)
print v(xbgr.mr_n50755456)
print v(xbgr.mr_n50755776)
print v(xbgr.mr_n50756208)
print v(xbgr.mr_n50757072)
print v(xbgr.mr_n50758368)
print v(xbgr.mr_n50758480)
print v(xbgr.mr_n50758800)
print v(xbgr.mr_n50758912)
print v(xbgr.mr_n50759232)
print v(xbgr.mr_n50759664)
print v(xbgr.mr_n50760528)
print v(xbgr.mr_n50760960)
print v(xbgr.mr_n50761072)
print v(xbgr.mr_n50761392)
print v(xbgr.mr_n50761504)
print v(xbgr.mr_n50761824)
print v(xbgr.mr_n50761936)
print v(xbgr.mr_n50762256)
print v(xbgr.mr_n50762368)
print v(xbgr.mr_n50763120)
print v(xbgr.mr_n50763232)
print v(xbgr.mr_n50763984)
print v(xbgr.mr_n50764960)
print v(xbgr.mr_n50765280)
print v(xbgr.mr_n50765392)
print v(xbgr.mr_n50765712)
print v(xbgr.mr_n50765824)
print v(xbgr.mr_n50766144)
print v(xbgr.mr_n50766576)
print v(xbgr.mr_n50767440)
print v(xbgr.mr_n50767552)
print v(xbgr.mr_n50767872)
print v(xbgr.mr_n50767984)
print v(xbgr.mr_n50768304)
print v(xbgr.mr_n50768416)
print v(xbgr.mr_n50768736)
print v(xbgr.mr_n50768848)
print v(xbgr.mr_n50769168)
print v(xbgr.mr_n50769280)
print v(xbgr.mr_n50769712)
print v(xbgr.mr_n50770464)
print v(xbgr.mr_n50771440)
print v(xbgr.mr_n50771872)
print v(xbgr.mr_n50772192)
print v(xbgr.mr_n50772624)
print v(xbgr.mr_n50773600)
print v(xbgr.mr_n50774032)
print v(xbgr.mr_n50774352)
print v(xbgr.mr_n50774784)
print v(xbgr.mr_n50774896)
print v(xbgr.mr_n50775216)
print v(xbgr.mr_n50775328)
print v(xbgr.mr_n50775648)
print v(xbgr.mr_n50775760)
print v(xbgr.mr_n50776080)
print v(xbgr.mr_n50776192)
print v(xbgr.mr_n50776944)
print v(xbgr.mr_n50777808)
print v(xbgr.mr_n50779104)
print v(xbgr.mr_n50779216)
print v(xbgr.mr_n50779536)
print v(xbgr.mr_n50779648)
print v(xbgr.mr_n50779968)
print v(xbgr.mr_n50780080)
print v(xbgr.mr_n50780400)
print v(xbgr.mr_n50780512)
print v(xbgr.mr_n50780832)
print v(xbgr.mr_n50780944)
print v(xbgr.mr_n50781264)
print v(xbgr.mr_n50781696)
print v(xbgr.mr_n50781808)
print v(xbgr.mr_n50782128)
print v(xbgr.mr_n50782240)
print v(xbgr.mr_n50782560)
print v(xbgr.mr_n50782672)
print v(xbgr.mr_n50782992)
print v(xbgr.mr_n50783104)
print v(xbgr.mr_n50783424)
print v(xbgr.mr_n50783536)
print v(xbgr.mr_n50783856)
print v(xbgr.mr_n50783968)
print v(xbgr.mr_n50784288)
print v(xbgr.mr_n50784400)
print v(xbgr.mr_n50784720)
print v(xbgr.mr_n50784832)
print v(xbgr.mr_n50785152)
print v(xbgr.mr_n50785264)
print v(xbgr.mr_n50785696)
print v(xbgr.mr_n50786016)
print v(xbgr.mr_n50786128)
print v(xbgr.mr_n50786560)
print v(xbgr.mr_n50786992)
print v(xbgr.mr_n50787312)
print v(xbgr.mr_n50787424)
print v(xbgr.mr_n50787744)
print v(xbgr.mr_n50787856)
print v(xbgr.mr_n50788176)
print v(xbgr.mr_n50788288)
print v(xbgr.mr_n50788608)
print v(xbgr.mr_n50788720)
print v(xbgr.mr_n50789472)
print v(xbgr.mr_n50789584)
print v(xbgr.mr_n50790016)
print v(xbgr.mr_n50790336)
print v(xbgr.mr_n50790880)
print v(xbgr.mr_n50791200)
print v(xbgr.mr_n50792064)
print v(xbgr.mr_n50792176)
print v(xbgr.mr_n50792496)
print v(xbgr.mr_n50792928)
print v(xbgr.mr_n50793360)
print v(xbgr.mr_n50793792)
print v(xbgr.mr_n50793904)
print v(xbgr.mr_n50794656)
print v(xbgr.mr_n50794768)
print v(xbgr.mr_n50795088)
print v(xbgr.mr_n50795200)
print v(xbgr.mr_n50795520)
print v(xbgr.mr_n50795952)
print v(xbgr.mr_n50796064)
print v(xbgr.mr_n50796384)
print v(xbgr.mr_n50796496)
print v(xbgr.mr_n50796816)
print v(xbgr.mr_n50796928)
print v(xbgr.mr_n50797248)
print v(xbgr.mr_n50797680)
print v(xbgr.mr_n50798544)
print v(xbgr.mr_n50799408)
print v(xbgr.mr_n50800704)
print v(xbgr.mr_n50801568)
print v(xbgr.mr_n50802432)
print v(xbgr.mr_n50803296)
print v(xbgr.mr_n50803408)
print v(xbgr.mr_n50803728)
print v(xbgr.mr_n50804592)
print v(xbgr.mr_n50805456)
print v(xbgr.mr_n50806320)
print v(xbgr.mr_n50806432)
print v(xbgr.mr_n50806752)
print v(xbgr.mr_n50806864)
print v(xbgr.mr_n50807184)
print v(xbgr.mr_n50807296)
print v(xbgr.mr_n50807616)
print v(xbgr.mr_n50807728)
print v(xbgr.mr_n50808048)
print v(xbgr.mr_n50808160)
print v(xbgr.mr_n50808480)
print v(xbgr.mr_n50808592)
print v(xbgr.mr_n50810208)
print v(xbgr.mr_n50811184)
print v(xbgr.mr_n50811616)
print v(xbgr.mr_n50812048)
print v(xbgr.mr_n50812368)
print v(xbgr.mr_n50812480)
print v(xbgr.mr_n50812800)
print v(xbgr.mr_n50812912)
print v(xbgr.mr_n50813232)
print v(xbgr.mr_n50813344)
print v(xbgr.mr_n50813664)
print v(xbgr.mr_n50813776)
print v(xbgr.mr_n50814096)
print v(xbgr.mr_n50814208)
print v(xbgr.mr_n50814528)
print v(xbgr.mr_n50814640)
print v(xbgr.mr_n50814960)
print v(xbgr.mr_n50815072)
print v(xbgr.mr_n50815504)
print v(xbgr.mr_n50815824)
print v(xbgr.mr_n50815936)
print v(xbgr.mr_n50816368)
print v(xbgr.mr_n50816800)
print v(xbgr.mr_n50817984)
print v(xbgr.mr_n50818096)
print v(xbgr.mr_n50818416)
print v(xbgr.mr_n50818528)
print v(xbgr.mr_n50818848)
print v(xbgr.mr_n50818960)
print v(xbgr.mr_n50819280)
print v(xbgr.mr_n50819392)
print v(xbgr.mr_n50819712)
print v(xbgr.mr_n50819824)
print v(xbgr.mr_n50820144)
print v(xbgr.mr_n50820576)
print v(xbgr.mr_n50820688)
print v(xbgr.mr_n50821008)
print v(xbgr.mr_n50821120)
print v(xbgr.mr_n50821440)
print v(xbgr.mr_n50821552)
print v(xbgr.mr_n50821872)
print v(xbgr.mr_n50821984)
print v(xbgr.mr_n50822416)
print v(xbgr.mr_n50822736)
print v(xbgr.mr_n50823168)
print v(xbgr.mr_n50824032)
print v(xbgr.mr_n50824144)
print v(xbgr.mr_n50824464)
print v(xbgr.mr_n50824896)
print v(xbgr.mr_n50825328)
print v(xbgr.mr_n50825872)
print v(xbgr.mr_n50826192)
print v(xbgr.mr_n50827056)
print v(xbgr.mr_n50827168)
print v(xbgr.mr_n50827488)
print v(xbgr.mr_n50827600)
print v(xbgr.mr_n50828032)
print v(xbgr.mr_n50828784)
print v(xbgr.mr_n50829216)
print v(xbgr.mr_n50829648)
print v(xbgr.mr_n50830080)
print v(xbgr.mr_n50830192)
print v(xbgr.mr_n50831376)
print v(xbgr.mr_n50832240)
print v(xbgr.mr_n50833216)
print v(xbgr.mr_n50833536)
print v(xbgr.mr_n50833648)
print v(xbgr.mr_n50834080)
print v(xbgr.mr_n50834400)
print v(xbgr.mr_n50834512)
print v(xbgr.mr_n50834832)
print v(xbgr.mr_n50834944)
print v(xbgr.mr_n50835264)
print v(xbgr.mr_n50835376)
print v(xbgr.mr_n50835696)
print v(xbgr.mr_n50835808)
print v(xbgr.mr_n50836128)
print v(xbgr.mr_n50836240)
print v(xbgr.mr_n50836560)
print v(xbgr.mr_n50836672)
print v(xbgr.mr_n50837104)
print v(xbgr.mr_n50837536)
print v(xbgr.mr_n50837968)
print v(xbgr.mr_n50838720)
print v(xbgr.mr_n50839152)
print v(xbgr.mr_n50840016)
print v(xbgr.mr_n50840880)
print v(xbgr.mr_n50842608)
print v(xbgr.mr_n50843472)
print v(xbgr.mr_n50843584)
print v(xbgr.mr_n50844336)
print v(xbgr.mr_n50844448)
print v(xbgr.mr_n50844768)
print v(xbgr.mr_n50844880)
print v(xbgr.mr_n50845200)
print v(xbgr.mr_n50845312)
print v(xbgr.mr_n50847360)
print v(xbgr.mr_n50847472)
print v(xbgr.mr_n50847792)
print v(xbgr.mr_n50847904)
print v(xbgr.mr_n50848224)
print v(xbgr.mr_n50848336)
print v(xbgr.mr_n50848656)
print v(xbgr.mr_n50848768)
print v(xbgr.mr_n50849088)
print v(xbgr.mr_n50849200)
print v(xbgr.mr_n50849520)
print v(xbgr.mr_n50849632)
print v(xbgr.mr_n50849952)
print v(xbgr.mr_n50850064)
print v(xbgr.mr_n50850496)
print v(xbgr.mr_n50850816)
print v(xbgr.mr_n50850928)
print v(xbgr.mr_n50851360)
print v(xbgr.mr_n50851680)
print v(xbgr.mr_n50851792)
print v(xbgr.mr_n50852224)
print v(xbgr.mr_n50852544)
print v(xbgr.mr_n50852656)
print v(xbgr.mr_n50852976)
print v(xbgr.mr_n50853088)
print v(xbgr.mr_n50853408)
print v(xbgr.mr_n50853520)
print v(xbgr.mr_n50853840)
print v(xbgr.mr_n50853952)
print v(xbgr.mr_n50854272)
print v(xbgr.mr_n50854384)
print v(xbgr.mr_n50854704)
print v(xbgr.mr_n50854816)
print v(xbgr.mr_n50855136)
print v(xbgr.mr_n50855248)
print v(xbgr.mr_n50855568)
print v(xbgr.mr_n50855680)
print v(xbgr.mr_n50856000)
print v(xbgr.mr_n50856112)
print v(xbgr.mr_n50856432)
print v(xbgr.mr_n50856544)
print v(xbgr.mr_n50856864)
print v(xbgr.mr_n50856976)
print v(xbgr.mr_n50857296)
print v(xbgr.mr_n50857408)
print v(xbgr.mr_n50857728)
print v(xbgr.mr_n50857840)
print v(xbgr.mr_n50858160)
print v(xbgr.mr_n50858272)
print v(xbgr.mr_n50858592)
print v(xbgr.mr_n50858704)
print v(xbgr.mr_n50859024)
print v(xbgr.mr_n50859136)
print v(xbgr.mr_n50859456)
print v(xbgr.mr_n50859568)
print v(xbgr.mr_n50859888)
print v(xbgr.mr_n50860000)
print v(xbgr.mr_n50860432)
print v(xbgr.mr_n50860752)
print v(xbgr.mr_n50860864)
print v(xbgr.mr_n50861296)
print v(xbgr.mr_n50861616)
print v(xbgr.mr_n50861728)
print v(xbgr.mr_n50862160)
print v(xbgr.mr_n50862480)
print v(xbgr.mr_n50863344)
print v(xbgr.mr_n50864208)
print v(xbgr.mr_n50865072)
print v(xbgr.mr_n50865936)
print v(xbgr.mr_n50866800)
print v(xbgr.mr_n50867664)
print v(xbgr.mr_n50867776)
print v(xbgr.mr_n50868096)
print v(xbgr.mr_n50868208)
print v(xbgr.mr_n50868528)
print v(xbgr.mr_n50868640)
print v(xbgr.mr_n50868960)
print v(xbgr.mr_n50869072)
print v(xbgr.mr_n50869392)
print v(xbgr.mr_n50869504)
print v(xbgr.mr_n50869824)
print v(xbgr.mr_n50869936)
print v(xbgr.mr_n50870256)
print v(xbgr.mr_n50871120)
print v(xbgr.mr_n50871984)
print v(xbgr.mr_n50872848)
print v(xbgr.mr_n50872960)
print v(xbgr.mr_n50873280)
print v(xbgr.mr_n50873392)
print v(xbgr.mr_n50873712)
print v(xbgr.mr_n50873824)
print v(xbgr.mr_n50874256)
print v(xbgr.mr_n50874688)
print v(xbgr.mr_n50875120)
print v(xbgr.mr_n50875440)
print v(xbgr.mr_n50875552)
print v(xbgr.mr_n50875984)
print v(xbgr.mr_n50876304)
print v(xbgr.mr_n50876416)
print v(xbgr.mr_n50876736)
print v(xbgr.mr_n50876848)
print v(xbgr.mr_n50877168)
print v(xbgr.mr_n50877280)
print v(xbgr.mr_n50877600)
print v(xbgr.mr_n50877712)
print v(xbgr.mr_n50878032)
print v(xbgr.mr_n50878144)
print v(xbgr.mr_n50878464)
print v(xbgr.mr_n50878576)
print v(xbgr.mr_n50879008)
print v(xbgr.mr_n50879440)
print v(xbgr.mr_n50879760)
print v(xbgr.mr_n50879872)
print v(xbgr.mr_n50880304)
print v(xbgr.mr_n50880624)
print v(xbgr.mr_n50880736)
print v(xbgr.mr_n50881168)
print v(xbgr.mr_n50881488)
print v(xbgr.mr_n50881600)
print v(xbgr.mr_n50882032)
print v(xbgr.mr_n50882352)
print v(xbgr.mr_n50883216)
print v(xbgr.mr_n50884080)
print v(xbgr.mr_n50884944)
print v(xbgr.mr_n50885808)
print v(xbgr.mr_n50886672)
print v(xbgr.mr_n50886784)
print v(xbgr.mr_n50887104)
print v(xbgr.mr_n50887216)
print v(xbgr.mr_n50887536)
print v(xbgr.mr_n50887648)
print v(xbgr.mr_n50887968)
print v(xbgr.mr_n50888080)
print v(xbgr.mr_n50888400)
print v(xbgr.mr_n50889264)
print v(xbgr.mr_n50890128)
print v(xbgr.mr_n50890992)
print v(xbgr.mr_n50891104)
print v(xbgr.mr_n50891424)
print v(xbgr.mr_n50891536)
print v(xbgr.mr_n50891856)
print v(xbgr.mr_n50891968)
print v(xbgr.mr_n50892288)
print v(xbgr.mr_n50892400)
print v(xbgr.mr_n50892720)
print v(xbgr.mr_n50892832)
print v(xbgr.mr_n50893152)
print v(xbgr.mr_n50893264)
print v(xbgr.mr_n50893584)
print v(xbgr.mr_n50894448)
print v(xbgr.mr_n50895312)
print v(xbgr.mr_n50896176)
print v(xbgr.mr_n50897040)
print v(xbgr.mr_n50897904)
print v(xbgr.mr_n50898768)
print v(xbgr.mr_n50899632)
print v(xbgr.mr_n50900496)
print v(xbgr.mr_n50901360)
print v(xbgr.mr_n50901472)
print v(xbgr.mr_n50901792)
print v(xbgr.mr_n50901904)
print v(xbgr.mr_n50902224)
print v(xbgr.mr_n50902336)
print v(xbgr.mr_n50902656)
print v(xbgr.mr_n50902768)
print v(xbgr.mr_n50903088)
print v(xbgr.mr_n50903200)
print v(xbgr.mr_n50903520)
print v(xbgr.mr_n50903632)
print v(xbgr.mr_n50903952)
print v(xbgr.mr_n50904064)
print v(xbgr.mr_n50904384)
print v(xbgr.mr_n50904496)
print v(xbgr.mr_n50904816)
print v(xbgr.mr_n50904928)
print v(xbgr.mr_n50905248)
print v(xbgr.mr_n50905360)
print v(xbgr.mr_n50905680)
print v(xbgr.mr_n50906544)
print v(xbgr.mr_n50906656)
print v(xbgr.mr_n50906976)
print v(xbgr.mr_n50907088)
print v(xbgr.mr_n50907408)
print v(xbgr.mr_n50907520)
print v(xbgr.mr_n50907840)
print v(xbgr.mr_n50907952)
print v(xbgr.mr_n50908272)
print v(xbgr.mr_n50908384)
print v(xbgr.mr_n50908704)
print v(xbgr.mr_n50908816)
print v(xbgr.mr_n50909136)
print v(xbgr.mr_n50909248)
print v(xbgr.mr_n50909568)
print v(xbgr.mr_n50909680)
print v(xbgr.mr_n50910000)
print v(xbgr.mr_n50910112)
print v(xbgr.mr_n50910432)
print v(xbgr.mr_n50910544)
print v(xbgr.mr_n50910864)
print v(xbgr.mr_n50910976)
print v(xbgr.mr_n50911408)
print v(xbgr.mr_n50911728)
print v(xbgr.mr_n50911840)
print v(xbgr.mr_n50912272)
print v(xbgr.mr_n50912592)
print v(xbgr.mr_n50912704)
print v(xbgr.mr_n50913136)
print v(xbgr.mr_n50913456)
print v(xbgr.mr_n50913568)
print v(xbgr.mr_n50914000)
print v(xbgr.mr_n50914320)
print v(xbgr.mr_n50914432)
print v(xbgr.mr_n50914752)
print v(xbgr.mr_n50914864)
print v(xbgr.mr_n50915296)
print v(xbgr.mr_n50915728)
print v(xbgr.mr_n50916048)
print v(xbgr.mr_n50916160)
print v(xbgr.mr_n50916480)
print v(xbgr.mr_n50916592)
print v(xbgr.mr_n50916912)
print v(xbgr.mr_n50917024)
print v(xbgr.mr_n50917344)
print v(xbgr.mr_n50917456)
print v(xbgr.mr_n50917776)
print v(xbgr.mr_n50917888)
print v(xbgr.mr_n50918320)
print v(xbgr.mr_n50918640)
print v(xbgr.mr_n50918752)
print v(xbgr.mr_n50919184)
print v(xbgr.mr_n50919504)
print v(xbgr.mr_n50920368)
print v(xbgr.mr_n50921232)
print v(xbgr.mr_n50922096)
print v(xbgr.mr_n50922960)
print v(xbgr.mr_n50923072)
print v(xbgr.mr_n50923392)
print v(xbgr.mr_n50923504)
print v(xbgr.mr_n50923824)
print v(xbgr.mr_n50923936)
print v(xbgr.mr_n50924256)
print v(xbgr.mr_n50924368)
print v(xbgr.mr_n50924688)
print v(xbgr.mr_n50925552)
print v(xbgr.mr_n50926416)
print v(xbgr.mr_n50926528)
print v(xbgr.mr_n50926848)
print v(xbgr.mr_n50926960)
print v(xbgr.mr_n50927392)
print v(xbgr.mr_n50927824)
print v(xbgr.mr_n50928144)
print v(xbgr.mr_n50928256)
print v(xbgr.mr_n50928576)
print v(xbgr.mr_n50928688)
print v(xbgr.mr_n50929008)
print v(xbgr.mr_n50929120)
print v(xbgr.mr_n50929440)
print v(xbgr.mr_n50929552)
print v(xbgr.mr_n50929872)
print v(xbgr.mr_n50929984)
print v(xbgr.mr_n50930416)
print v(xbgr.mr_n50930736)
print v(xbgr.mr_n50930848)
print v(xbgr.mr_n50931280)
print v(xbgr.mr_n50931600)
print v(xbgr.mr_n50931712)
print v(xbgr.mr_n50932032)
print v(xbgr.mr_n50932144)
print v(xbgr.mr_n50932464)
print v(xbgr.mr_n50932576)
print v(xbgr.mr_n50932896)
print v(xbgr.mr_n50933008)
print v(xbgr.mr_n50933328)
print v(xbgr.mr_n50933440)
print v(xbgr.mr_n50933760)
print v(xbgr.mr_n50933872)
print v(xbgr.mr_n50934192)
print v(xbgr.mr_n50934304)
print v(xbgr.mr_n50934624)
print v(xbgr.mr_n50934736)
print v(xbgr.mr_n50935056)
print v(xbgr.mr_n50935168)
print v(xbgr.mr_n50935488)
print v(xbgr.mr_n50935600)
print v(xbgr.mr_n50935920)
print v(xbgr.mr_n50936784)
print v(xbgr.mr_n50937648)
print v(xbgr.mr_n50938512)
print v(xbgr.mr_n50939376)
print v(xbgr.mr_n50939488)
print v(xbgr.mr_n50939808)
print v(xbgr.mr_n50939920)
print v(xbgr.mr_n50940240)
print v(xbgr.mr_n50940352)
print v(xbgr.mr_n50940672)
print v(xbgr.mr_n50940784)
print v(xbgr.mr_n50941216)
print v(xbgr.mr_n50941648)
print v(xbgr.mr_n50942080)
print v(xbgr.mr_n50942512)
print v(xbgr.mr_n50942832)
print v(xbgr.mr_n50942944)
print v(xbgr.mr_n50943264)
print v(xbgr.mr_n50943376)
print v(xbgr.mr_n50943696)
print v(xbgr.mr_n50943808)
print v(xbgr.mr_n50944128)
print v(xbgr.mr_n50944240)
print v(xbgr.mr_n50944560)
print v(xbgr.mr_n50945424)
print v(xbgr.mr_n50946288)
print v(xbgr.mr_n50946400)
print v(xbgr.mr_n50946832)
print v(xbgr.mr_n50947152)
print v(xbgr.mr_n50948016)
print v(xbgr.mr_n50948128)
print v(xbgr.mr_n50948448)
print v(xbgr.mr_n50948560)
print v(xbgr.mr_n50948880)
print v(xbgr.mr_n50948992)
print v(xbgr.mr_n50949312)
print v(xbgr.mr_n50949424)
print v(xbgr.mr_n50949744)
print v(xbgr.mr_n50950608)
print v(xbgr.mr_n50950720)
print v(xbgr.mr_n50951152)
print v(xbgr.mr_n50951472)
print v(xbgr.mr_n50951584)
print v(xbgr.mr_n50951904)
print v(xbgr.mr_n50952016)
print v(xbgr.mr_n50952336)
print v(xbgr.mr_n50952448)
print v(xbgr.mr_n50952768)
print v(xbgr.mr_n50952880)
print v(xbgr.mr_n50953200)
print v(xbgr.mr_n50954064)
print v(xbgr.mr_n50954496)
print v(xbgr.mr_n50954608)
print v(xbgr.mr_n50954928)
print v(xbgr.mr_n50955040)
print v(xbgr.mr_n50955360)
print v(xbgr.mr_n50955792)
print v(xbgr.mr_n50956656)
print v(xbgr.mr_n50957520)
print v(xbgr.mr_n50957632)
print v(xbgr.mr_n50958384)
print v(xbgr.mr_n50958496)
print v(xbgr.mr_n50958816)
print v(xbgr.mr_n50958928)
print v(xbgr.mr_n50959248)
print v(xbgr.mr_n50960112)
print v(xbgr.mr_n50960976)
print v(xbgr.mr_n50961088)
print v(xbgr.mr_n50961408)
print v(xbgr.mr_n50961520)
print v(xbgr.mr_n50961840)
print v(xbgr.mr_n50962704)
print v(xbgr.mr_n50962816)
print v(xbgr.mr_n50963136)
print v(xbgr.mr_n50963248)
print v(xbgr.mr_n50963568)
print v(xbgr.mr_n50963680)
print v(xbgr.mr_n50964000)
print v(xbgr.mr_n50964112)
print v(xbgr.mr_n50964432)
print v(xbgr.mr_n50964544)
print v(xbgr.mr_n50965296)
print v(xbgr.mr_n50966160)
print v(xbgr.mr_n50967024)
print v(xbgr.mr_n50967136)
print v(xbgr.mr_n50967456)
print v(xbgr.mr_n50967568)
print v(xbgr.mr_n50967888)
print v(xbgr.mr_n50968000)
print v(xbgr.mr_n50968320)
print v(xbgr.mr_n50968432)
print v(xbgr.mr_n50968752)
print v(xbgr.mr_n50968864)
print v(xbgr.mr_n50969184)
print v(xbgr.mr_n50969296)
print v(xbgr.mr_n50969616)
print v(xbgr.mr_n50969728)
print v(xbgr.mr_n50970160)
print v(xbgr.mr_n50970480)
print v(xbgr.mr_n50970592)
print v(xbgr.mr_n50970912)
print v(xbgr.mr_n50971024)
print v(xbgr.mr_n50971344)
print v(xbgr.mr_n50972208)
print v(xbgr.mr_n50973072)
print v(xbgr.mr_n50973936)
print v(xbgr.mr_n50974800)
print v(xbgr.mr_n50975232)
print v(xbgr.mr_n50975344)
print v(xbgr.mr_n50975664)
print v(xbgr.mr_n50975776)
print v(xbgr.mr_n50976096)
print v(xbgr.mr_n50976208)
print v(xbgr.mr_n50976640)
print v(xbgr.mr_n50977392)
print v(xbgr.mr_n50977504)
print v(xbgr.mr_n50977824)
print v(xbgr.mr_n50977936)
print v(xbgr.mr_n50978256)
print v(xbgr.mr_n50979120)
print v(xbgr.mr_n50979984)
print v(xbgr.mr_n50980096)
print v(xbgr.mr_n50980416)
print v(xbgr.mr_n50980528)
print v(xbgr.mr_n50980848)
print v(xbgr.mr_n50981712)
print v(xbgr.mr_n50982576)
print v(xbgr.mr_n50983440)
print v(xbgr.mr_n50983552)
print v(xbgr.mr_n50983872)
print v(xbgr.mr_n50983984)
print v(xbgr.mr_n50984304)
print v(xbgr.mr_n50985168)
print v(xbgr.mr_n50986032)
print v(xbgr.mr_n50986144)
print v(xbgr.mr_n50986464)
print v(xbgr.mr_n50986576)
print v(xbgr.mr_n50986896)
print v(xbgr.mr_n50987008)
print v(xbgr.mr_n50987328)
print v(xbgr.mr_n50987440)
print v(xbgr.mr_n50987760)
print v(xbgr.mr_n50987872)
print v(xbgr.mr_n50988192)
print v(xbgr.mr_n50988304)
print v(xbgr.mr_n50988624)
print v(xbgr.mr_n50988736)
print v(xbgr.mr_n50989056)
print v(xbgr.mr_n50989168)
print v(xbgr.mr_n50989488)
print v(xbgr.mr_n50989600)
print v(xbgr.mr_n50989920)
print v(xbgr.mr_n50990032)
print v(xbgr.mr_n50990352)
print v(xbgr.mr_n50990464)
print v(xbgr.mr_n50990784)
print v(xbgr.mr_n50990896)
print v(xbgr.mr_n50991216)
print v(xbgr.mr_n50991328)
print v(xbgr.mr_n50991648)
print v(xbgr.mr_n50991760)
print v(xbgr.mr_n50992080)
print v(xbgr.mr_n50992192)
print v(xbgr.mr_n50992512)
print v(xbgr.mr_n50992624)
print v(xbgr.mr_n50992944)
print v(xbgr.mr_n50993056)
print v(xbgr.mr_n50993376)
print v(xbgr.mr_n50993488)
print v(xbgr.mr_n50993808)
print v(xbgr.mr_n50993920)
print v(xbgr.mr_n50994240)
print v(xbgr.mr_n50994352)
print v(xbgr.mr_n50994672)
print v(xbgr.mr_n50994784)
print v(xbgr.mr_n50995104)
print v(xbgr.mr_n50995216)
print v(xbgr.mr_n50995536)
print v(xbgr.mr_n50995648)
print v(xbgr.mr_n50995968)
print v(xbgr.mr_n50996080)
print v(xbgr.mr_n50996400)
print v(xbgr.mr_n50996512)
print v(xbgr.mr_n50996832)
print v(xbgr.mr_n50996944)
print v(xbgr.mr_n50997376)
print v(xbgr.mr_n50997808)
print v(xbgr.mr_n50998240)
print v(xbgr.mr_n50998672)
print v(xbgr.mr_n50999104)
print v(xbgr.mr_n50999536)
print v(xbgr.mr_n50999968)
print v(xbgr.mr_n51000400)
print v(xbgr.mr_n51000832)
print v(xbgr.mr_n51001264)
print v(xbgr.mr_n51001696)
print v(xbgr.mr_n51002128)
print v(xbgr.mr_n51002560)
print v(xbgr.mr_n51002992)
print v(xbgr.mr_n51003424)
print v(xbgr.mr_n51003856)
print v(xbgr.mr_n51004288)
print v(xbgr.mr_n51004720)
print v(xbgr.mr_n51005152)
print v(xbgr.mr_n51005584)
print v(xbgr.mr_n51006016)
print v(xbgr.mr_n51006448)
print v(xbgr.mr_n51006880)
print v(xbgr.mr_n51007312)
print v(xbgr.mr_n51007744)
print v(xbgr.mr_n51008176)
print v(xbgr.mr_n51008496)
print v(xbgr.mr_n51008608)
print v(xbgr.mr_n51008928)
print v(xbgr.mr_n51009040)
print v(xbgr.mr_n51009360)
print v(xbgr.mr_n51009472)
print v(xbgr.mr_n51009792)
print v(xbgr.mr_n51009904)
print v(xbgr.mr_n51010224)
print v(xbgr.mr_n51010336)
print v(xbgr.mr_n51010656)
print v(xbgr.mr_n51010768)
print v(xbgr.mr_n51011088)
print v(xbgr.mr_n51011200)
print v(xbgr.mr_n51011520)
print v(xbgr.mr_n51011632)
print v(xbgr.mr_n51011952)
print v(xbgr.mr_n51012064)
print v(xbgr.mr_n51012384)
print v(xbgr.mr_n51012496)
print v(xbgr.mr_n51012816)
print v(xbgr.mr_n51012928)
print v(xbgr.mr_n51013248)
print v(xbgr.mr_n51013360)
print v(xbgr.mr_n51013680)
print v(xbgr.mr_n51013792)
print v(xbgr.mr_n51014112)
print v(xbgr.mr_n51014224)
print v(xbgr.mr_n51014544)
print v(xbgr.mr_n51014656)
print v(xbgr.mr_n51014976)
print v(xbgr.mr_n51015088)
print v(xbgr.mr_n51015408)
print v(xbgr.mr_n51015520)
print v(xbgr.mr_n51015840)
print v(xbgr.mr_n51015952)
print v(xbgr.mr_n51016272)
print v(xbgr.mr_n51016384)
print v(xbgr.mr_n51016704)
print v(xbgr.mr_n51016816)
print v(xbgr.mr_n51017136)
print v(xbgr.mr_n51017248)
print v(xbgr.mr_n51017568)
print v(xbgr.mr_n51017680)
print v(xbgr.mr_n51018000)
print v(xbgr.mr_n51018112)
print v(xbgr.mr_n51018432)
print v(xbgr.mr_n51018544)
print v(xbgr.mr_n51018976)
print v(xbgr.mr_n51019408)
print v(xbgr.mr_n51019840)
print v(xbgr.mr_n51020272)
print v(xbgr.mr_n51020592)
print v(xbgr.mr_n51020704)
print v(xbgr.mr_n51021024)
print v(xbgr.mr_n51021136)
print v(xbgr.mr_n51021568)
print v(xbgr.mr_n51022000)
print v(xbgr.mr_n51022432)
print v(xbgr.mr_n51022864)
print v(xbgr.mr_n51023296)
print v(xbgr.mr_n51023728)
print v(xbgr.mr_n51024160)
print v(xbgr.mr_n51024592)
print v(xbgr.mr_n51025024)
print v(xbgr.mr_n51025456)
print v(xbgr.mr_n51025888)
print v(xbgr.mr_n51026320)
print v(xbgr.mr_n51026752)
print v(xbgr.mr_n51027184)
print v(xbgr.mr_n51027616)
print v(xbgr.mr_n51028048)
print v(xbgr.mr_n51028480)
print v(xbgr.mr_n51028912)
print v(xbgr.mr_n51029344)
print v(xbgr.mr_n51029776)
print v(xbgr.mr_n51030208)
print v(xbgr.mr_n51030640)
print v(xbgr.mr_n51030960)
print v(xbgr.mr_n51031072)
print v(xbgr.mr_n51031504)
print v(xbgr.mr_n51031824)
print v(xbgr.mr_n51031936)
print v(xbgr.mr_n51032368)
print v(xbgr.mr_n51032688)
print v(xbgr.mr_n51032800)
print v(xbgr.mr_n51033232)
print v(xbgr.mr_n51033552)
print v(xbgr.mr_n51033664)
print v(xbgr.mr_n51034096)
print v(xbgr.mr_n51034416)
print v(xbgr.mr_n51034528)
print v(xbgr.mr_n51034960)
print v(xbgr.mr_n51035280)
print v(xbgr.mr_n51035392)
print v(xbgr.mr_n51035712)
print v(xbgr.mr_n51035824)
print v(xbgr.mr_n51036144)
print v(xbgr.mr_n51036256)
print v(xbgr.mr_n51036688)
print v(xbgr.mr_n51037120)
print v(xbgr.mr_n51037552)
print v(xbgr.mr_n51037872)
print v(xbgr.mr_n51037984)
print v(xbgr.mr_n51038304)
print v(xbgr.mr_n51038416)
print v(xbgr.mr_n51038736)
print v(xbgr.mr_n51038848)
print v(xbgr.mr_n51039168)
print v(xbgr.mr_n51039280)
print v(xbgr.mr_n51039600)
print v(xbgr.mr_n51039712)
print v(xbgr.mr_n51040032)
print v(xbgr.mr_n51040144)
print v(xbgr.mr_n51040464)
print v(xbgr.mr_n51040576)
print v(xbgr.mr_n51041008)
print v(xbgr.mr_n51041328)
print v(xbgr.mr_n51041440)
print v(xbgr.mr_n51041872)
print v(xbgr.mr_n51042192)
print v(xbgr.mr_n51042304)
print v(xbgr.mr_n51042736)
print v(xbgr.mr_n51043056)
print v(xbgr.mr_n51043920)
print v(xbgr.mr_n51044784)
print v(xbgr.mr_n51045648)
print v(xbgr.mr_n51046512)
print v(xbgr.mr_n51047376)
print v(xbgr.mr_n51048240)
print v(xbgr.mr_n51048352)
print v(xbgr.mr_n51048672)
print v(xbgr.mr_n51048784)
print v(xbgr.mr_n51049104)
print v(xbgr.mr_n51049216)
print v(xbgr.mr_n51049536)
print v(xbgr.mr_n51049648)
print v(xbgr.mr_n51049968)
print v(xbgr.mr_n51050832)
print v(xbgr.mr_n51051696)
print v(xbgr.mr_n51052560)
print v(xbgr.mr_n51052672)
print v(xbgr.mr_n51052992)
print v(xbgr.mr_n51053104)
print v(xbgr.mr_n51053424)
print v(xbgr.mr_n51053536)
print v(xbgr.mr_n51053968)
print v(xbgr.mr_n51054400)
print v(xbgr.mr_n51054832)
print v(xbgr.mr_n51055152)
print v(xbgr.mr_n51055264)
print v(xbgr.mr_n51055584)
print v(xbgr.mr_n51055696)
print v(xbgr.mr_n51056016)
print v(xbgr.mr_n51056128)
print v(xbgr.mr_n51056448)
print v(xbgr.mr_n51056560)
print v(xbgr.mr_n51056880)
print v(xbgr.mr_n51056992)
print v(xbgr.mr_n51057312)
print v(xbgr.mr_n51057424)
print v(xbgr.mr_n51057744)
print v(xbgr.mr_n51057856)
print v(xbgr.mr_n51058176)
print v(xbgr.mr_n51058288)
print v(xbgr.mr_n51058608)
print v(xbgr.mr_n51058720)
print v(xbgr.mr_n51059152)
print v(xbgr.mr_n51059472)
print v(xbgr.mr_n51059584)
print v(xbgr.mr_n51060016)
print v(xbgr.mr_n51060336)
print v(xbgr.mr_n51060448)
print v(xbgr.mr_n51060768)
print v(xbgr.mr_n51060880)
print v(xbgr.mr_n51061200)
print v(xbgr.mr_n51062064)
print v(xbgr.mr_n51062928)
print v(xbgr.mr_n51063040)
print v(xbgr.mr_n51063360)
print v(xbgr.mr_n51063472)
print v(xbgr.mr_n51063792)
print v(xbgr.mr_n51064656)
print v(xbgr.mr_n51065200)
print v(xbgr.mr_n51065632)
print v(xbgr.mr_n51066384)
print v(xbgr.mr_n51067248)
print v(xbgr.mr_n51067360)
print v(xbgr.mr_n51067680)
print v(xbgr.mr_n51067792)
print v(xbgr.mr_n51068112)
print v(xbgr.mr_n51068224)
print v(xbgr.mr_n51068544)
print v(xbgr.mr_n51068656)
print v(xbgr.mr_n51068976)
print v(xbgr.mr_n51069088)
print v(xbgr.mr_n51069408)
print v(xbgr.mr_n51069520)
print v(xbgr.mr_n51069840)
print v(xbgr.mr_n51069952)
print v(xbgr.mr_n51070272)
print v(xbgr.mr_n51070384)
print v(xbgr.mr_n51070704)
print v(xbgr.mr_n51071568)
print v(xbgr.mr_n51071680)
print v(xbgr.mr_n51072000)
print v(xbgr.mr_n51072112)
print v(xbgr.mr_n51072432)
print v(xbgr.mr_n51073296)
print v(xbgr.mr_n51074160)
print v(xbgr.mr_n51074272)
print v(xbgr.mr_n51074592)
print v(xbgr.mr_n51074704)
print v(xbgr.mr_n51075024)
print v(xbgr.mr_n51075136)
print v(xbgr.mr_n51075568)
print v(xbgr.mr_n51075888)
print v(xbgr.mr_n51076320)
print v(xbgr.mr_n51077616)
print v(xbgr.mr_n51077728)
print v(xbgr.mr_n51078048)
print v(xbgr.mr_n51078160)
print v(xbgr.mr_n51078480)
print v(xbgr.mr_n51078592)
print v(xbgr.mr_n51078912)
print v(xbgr.mr_n51079024)
print v(xbgr.mr_n51079344)
print v(xbgr.mr_n51079456)
print v(xbgr.mr_n51079888)
print v(xbgr.mr_n51080208)
print v(xbgr.mr_n51080320)
print v(xbgr.mr_n51080640)
print v(xbgr.mr_n51080752)
print v(xbgr.mr_n51081072)
print v(xbgr.mr_n51081184)
print v(xbgr.mr_n51081504)
print v(xbgr.mr_n51081616)
print v(xbgr.mr_n51081936)
print v(xbgr.mr_n51082800)
print v(xbgr.mr_n51083664)
print v(xbgr.mr_n51084528)
print v(xbgr.mr_n51085392)
print v(xbgr.mr_n51085504)
print v(xbgr.mr_n51085824)
print v(xbgr.mr_n51085936)
print v(xbgr.mr_n51086256)
print v(xbgr.mr_n51086368)
print v(xbgr.mr_n51086688)
print v(xbgr.mr_n51086800)
print v(xbgr.mr_n51087120)
print v(xbgr.mr_n51087984)
print v(xbgr.mr_n51088848)
print v(xbgr.mr_n51089712)
print v(xbgr.mr_n51090576)
print v(xbgr.mr_n51091008)
print v(xbgr.mr_n51091120)
print v(xbgr.mr_n51091440)
print v(xbgr.mr_n51091552)
print v(xbgr.mr_n51091872)
print v(xbgr.mr_n51091984)
print v(xbgr.mr_n51092304)
print v(xbgr.mr_n51092416)
print v(xbgr.mr_n51092736)
print v(xbgr.mr_n51092848)
print v(xbgr.mr_n51093168)
print v(xbgr.mr_n51093280)
print v(xbgr.mr_n51093600)
print v(xbgr.mr_n51093712)
print v(xbgr.mr_n51094032)
print v(xbgr.mr_n51094144)
print v(xbgr.mr_n51094576)
print v(xbgr.mr_n51094896)
print v(xbgr.mr_n51095008)
print v(xbgr.mr_n51095440)
print v(xbgr.mr_n51095760)
print v(xbgr.mr_n51095872)
print v(xbgr.mr_n51096304)
print v(xbgr.mr_n51096624)
print v(xbgr.mr_n51096736)
print v(xbgr.mr_n51097056)
print v(xbgr.mr_n51097168)
print v(xbgr.mr_n51097488)
print v(xbgr.mr_n51098352)
print v(xbgr.mr_n51099216)
print v(xbgr.mr_n51100080)
print v(xbgr.mr_n51100944)
print v(xbgr.mr_n51101808)
print v(xbgr.mr_n51102672)
print v(xbgr.mr_n51103536)
print v(xbgr.mr_n51104400)
print v(xbgr.mr_n51105264)
print v(xbgr.mr_n51105376)
print v(xbgr.mr_n51105696)
print v(xbgr.mr_n51105808)
print v(xbgr.mr_n51106128)
print v(xbgr.mr_n51106992)
print v(xbgr.mr_n51107104)
print v(xbgr.mr_n51107424)
print v(xbgr.mr_n51107536)
print v(xbgr.mr_n51107856)
print v(xbgr.mr_n51107968)
print v(xbgr.mr_n51108288)
print v(xbgr.mr_n51108400)
print v(xbgr.mr_n51108720)
print v(xbgr.mr_n51108832)
print v(xbgr.mr_n51109152)
print v(xbgr.mr_n51109264)
print v(xbgr.mr_n51109584)
print v(xbgr.mr_n51109696)
print v(xbgr.mr_n51110016)
print v(xbgr.mr_n51110128)
print v(xbgr.mr_n51110448)
print v(xbgr.mr_n51111312)
print v(xbgr.mr_n51112176)
print v(xbgr.mr_n51113040)
print v(xbgr.mr_n51113152)
print v(xbgr.mr_n51113472)
print v(xbgr.mr_n51114768)
print v(xbgr.mr_n51115632)
print v(xbgr.mr_n51116496)
print v(xbgr.mr_n51117360)
print v(xbgr.mr_n51117472)
print v(xbgr.mr_n51117792)
print v(xbgr.mr_n51117904)
print v(xbgr.mr_n51118336)
print v(xbgr.mr_n51118656)
print v(xbgr.mr_n51118768)
print v(xbgr.mr_n51119200)
print v(xbgr.mr_n51119520)
print v(xbgr.mr_n51119632)
print v(xbgr.mr_n51120064)
print v(xbgr.mr_n51120384)
print v(xbgr.mr_n51120496)
print v(xbgr.mr_n51120928)
print v(xbgr.mr_n51121248)
print v(xbgr.mr_n51121360)
print v(xbgr.mr_n51121792)
print v(xbgr.mr_n51122112)
print v(xbgr.mr_n51122224)
print v(xbgr.mr_n51122544)
print v(xbgr.mr_n51122656)
print v(xbgr.mr_n51122976)
print v(xbgr.mr_n51123088)
print v(xbgr.mr_n51123520)
print v(xbgr.mr_n51123840)
print v(xbgr.mr_n51123952)
print v(xbgr.mr_n51124272)
print v(xbgr.mr_n51124384)
print v(xbgr.mr_n51124704)
print v(xbgr.mr_n51124816)
print v(xbgr.mr_n51125136)
print v(xbgr.mr_n51125248)
print v(xbgr.mr_n51125568)
print v(xbgr.mr_n51125680)
print v(xbgr.mr_n51126000)
print v(xbgr.mr_n51126112)
print v(xbgr.mr_n51126432)
print v(xbgr.mr_n51126544)
print v(xbgr.mr_n51126864)
print v(xbgr.mr_n51126976)
print v(xbgr.mr_n51127408)
print v(xbgr.mr_n51127728)
print v(xbgr.mr_n51128704)
print v(xbgr.mr_n51129136)
print v(xbgr.mr_n51129456)
print v(xbgr.mr_n51130320)
print v(xbgr.mr_n51130432)
print v(xbgr.mr_n51130752)
print v(xbgr.mr_n51130864)
print v(xbgr.mr_n51131184)
print v(xbgr.mr_n51131296)
print v(xbgr.mr_n51131616)
print v(xbgr.mr_n51131728)
print v(xbgr.mr_n51132048)
print v(xbgr.mr_n51132912)
print v(xbgr.mr_n51133344)
print v(xbgr.mr_n51134208)
print v(xbgr.mr_n51135072)
print v(xbgr.mr_n51135184)
print v(xbgr.mr_n51135504)
print v(xbgr.mr_n51135616)
print v(xbgr.mr_n51135936)
print v(xbgr.mr_n51136048)
print v(xbgr.mr_n51136368)
print v(xbgr.mr_n51136480)
print v(xbgr.mr_n51137232)
print v(xbgr.mr_n51137344)
print v(xbgr.mr_n51137664)
print v(xbgr.mr_n51137776)
print v(xbgr.mr_n51138096)
print v(xbgr.mr_n51138208)
print v(xbgr.mr_n51138528)
print v(xbgr.mr_n51138640)
print v(xbgr.mr_n51138960)
print v(xbgr.mr_n51139504)
print v(xbgr.mr_n51139824)
print v(xbgr.mr_n51139936)
print v(xbgr.mr_n51140368)
print v(xbgr.mr_n51140688)
print v(xbgr.mr_n51140800)
print v(xbgr.mr_n51141984)
print v(xbgr.mr_n51142416)
print v(xbgr.mr_n51142528)
print v(xbgr.mr_n51142848)
print v(xbgr.mr_n51142960)
print v(xbgr.mr_n51143280)
print v(xbgr.mr_n51143392)
print v(xbgr.mr_n51143712)
print v(xbgr.mr_n51143824)
print v(xbgr.mr_n51144144)
print v(xbgr.mr_n51144256)
print v(xbgr.mr_n51144576)
print v(xbgr.mr_n51144688)
print v(xbgr.mr_n51145440)
print v(xbgr.mr_n51146304)
print v(xbgr.mr_n51146416)
print v(xbgr.mr_n51146736)
print v(xbgr.mr_n51146848)
print v(xbgr.mr_n51147168)
print v(xbgr.mr_n51147280)
print v(xbgr.mr_n51147600)
print v(xbgr.mr_n51147712)
print v(xbgr.mr_n51148032)
print v(xbgr.mr_n51148144)
print v(xbgr.mr_n51148464)
print v(xbgr.mr_n51148576)
print v(xbgr.mr_n51148896)
print v(xbgr.mr_n51149008)
print v(xbgr.mr_n51149328)
print v(xbgr.mr_n51149440)
print v(xbgr.mr_n51149760)
print v(xbgr.mr_n51150624)
print v(xbgr.mr_n51151488)
print v(xbgr.mr_n51152352)
print v(xbgr.mr_n51152464)
print v(xbgr.mr_n51152896)
print v(xbgr.mr_n51153328)
print v(xbgr.mr_n51153648)
print v(xbgr.mr_n51154080)
print v(xbgr.mr_n51154192)
print v(xbgr.mr_n51154512)
print v(xbgr.mr_n51154624)
print v(xbgr.mr_n51155376)
print v(xbgr.mr_n51156784)
print v(xbgr.mr_n51157104)
print v(xbgr.mr_n51157216)
print v(xbgr.mr_n51157536)
print v(xbgr.mr_n51157648)
print v(xbgr.mr_n51157968)
print v(xbgr.mr_n51158080)
print v(xbgr.mr_n51158512)
print v(xbgr.mr_n51158832)
print v(xbgr.mr_n51158944)
print v(xbgr.mr_n51159376)
print v(xbgr.mr_n51159696)
print v(xbgr.mr_n51160128)
print v(xbgr.mr_n51160560)
print v(xbgr.mr_n51160672)
print v(xbgr.mr_n51160992)
print v(xbgr.mr_n51161104)
print v(xbgr.mr_n51161424)
print v(xbgr.mr_n51161536)
print v(xbgr.mr_n51162288)
print v(xbgr.mr_n51163152)
print v(xbgr.mr_n51163264)
print v(xbgr.mr_n51163696)
print v(xbgr.mr_n51164016)
print v(xbgr.mr_n51164880)
print v(xbgr.mr_n51165744)
print v(xbgr.mr_n51167040)
print v(xbgr.mr_n51167472)
print v(xbgr.mr_n51167584)
print v(xbgr.mr_n51167904)
print v(xbgr.mr_n51168016)
print v(xbgr.mr_n51168336)
print v(xbgr.mr_n51168448)
print v(xbgr.mr_n51168768)
print v(xbgr.mr_n51168880)
print v(xbgr.mr_n51169200)
print v(xbgr.mr_n51169312)
print v(xbgr.mr_n51169632)
print v(xbgr.mr_n51169744)
print v(xbgr.mr_n51170064)
print v(xbgr.mr_n51170176)
print v(xbgr.mr_n51170496)
print v(xbgr.mr_n51170608)
print v(xbgr.mr_n51171360)
print v(xbgr.mr_n51172224)
print v(xbgr.mr_n51173088)
print v(xbgr.mr_n51173200)
print v(xbgr.mr_n51173520)
print v(xbgr.mr_n51173632)
print v(xbgr.mr_n51173952)
print v(xbgr.mr_n51174064)
print v(xbgr.mr_n51174384)
print v(xbgr.mr_n51175248)
print v(xbgr.mr_n51176112)
print v(xbgr.mr_n51176976)
print v(xbgr.mr_n51177840)
print v(xbgr.mr_n51178704)
print v(xbgr.mr_n51179568)
print v(xbgr.mr_n51179680)
print v(xbgr.mr_n51180000)
print v(xbgr.mr_n51180864)
print v(xbgr.mr_n51180976)
print v(xbgr.mr_n51181296)
print v(xbgr.mr_n51181408)
print v(xbgr.mr_n51181728)
print v(xbgr.mr_n51182592)
print v(xbgr.mr_n51183024)
print v(xbgr.mr_n51183136)
print v(xbgr.mr_n51183888)
print v(xbgr.mr_n51184000)
print v(xbgr.mr_n51184320)
print v(xbgr.mr_n51184432)
print v(xbgr.mr_n51184752)
print v(xbgr.mr_n51184864)
print v(xbgr.mr_n51185184)
print v(xbgr.mr_n51185296)
print v(xbgr.mr_n51185616)
print v(xbgr.mr_n51185728)
print v(xbgr.mr_n51186048)
print v(xbgr.mr_n51186160)
print v(xbgr.mr_n51186480)
print v(xbgr.mr_n51186592)
print v(xbgr.mr_n51186912)
print v(xbgr.mr_n51187024)
print v(xbgr.mr_n51187344)
print v(xbgr.mr_n51187456)
print v(xbgr.mr_n51187776)
print v(xbgr.mr_n51188320)
print v(xbgr.mr_n51189072)
print v(xbgr.mr_n51189936)
print v(xbgr.mr_n51190800)
print v(xbgr.mr_n51190912)
print v(xbgr.mr_n51191344)
print v(xbgr.mr_n51191664)
print v(xbgr.mr_n51192528)
print v(xbgr.mr_n51193392)
print v(xbgr.mr_n51194256)
print v(xbgr.mr_n51195120)
print v(xbgr.mr_n51195984)
print v(xbgr.mr_n51196848)
print v(xbgr.mr_n51196960)
print v(xbgr.mr_n51197280)
print v(xbgr.mr_n51197392)
print v(xbgr.mr_n51197712)
print v(xbgr.mr_n51198576)
print v(xbgr.mr_n51199440)
print v(xbgr.mr_n51199552)
print v(xbgr.mr_n51199872)
print v(xbgr.mr_n51199984)
print v(xbgr.mr_n51200304)
print v(xbgr.mr_n51200416)
print v(xbgr.mr_n51200736)
print v(xbgr.mr_n51200848)
print v(xbgr.mr_n51201168)
print v(xbgr.mr_n51201280)
print v(xbgr.mr_n51201600)
print v(xbgr.mr_n51201712)
print v(xbgr.mr_n51202032)
print v(xbgr.mr_n51202144)
print v(xbgr.mr_n51202464)
print v(xbgr.mr_n51203328)
print v(xbgr.mr_n51203440)
print v(xbgr.mr_n51203760)
print v(xbgr.mr_n51203872)
print v(xbgr.mr_n51204192)
print v(xbgr.mr_n51204304)
print v(xbgr.mr_n51204624)
print v(xbgr.mr_n51204736)
print v(xbgr.mr_n51205056)
print v(xbgr.mr_n51205168)
print v(xbgr.mr_n51205488)
print v(xbgr.mr_n51205600)
print v(xbgr.mr_n51205920)
print v(xbgr.mr_n51206032)
print v(xbgr.mr_n51206352)
print v(xbgr.mr_n51206464)
print v(xbgr.mr_n51206896)
print v(xbgr.mr_n51207328)
print v(xbgr.mr_n51207760)
print v(xbgr.mr_n51208080)
print v(xbgr.mr_n51208192)
print v(xbgr.mr_n51208512)
print v(xbgr.mr_n51208624)
print v(xbgr.mr_n51208944)
print v(xbgr.mr_n51209056)
print v(xbgr.mr_n51209376)
print v(xbgr.mr_n51209488)
print v(xbgr.mr_n51209808)
print v(xbgr.mr_n51209920)
print v(xbgr.mr_n51210240)
print v(xbgr.mr_n51210352)
print v(xbgr.mr_n51210672)
print v(xbgr.mr_n51210784)
print v(xbgr.mr_n51211104)
print v(xbgr.mr_n51211216)
print v(xbgr.mr_n51211536)
print v(xbgr.mr_n51211648)
print v(xbgr.mr_n51211968)
print v(xbgr.mr_n51212080)
print v(xbgr.mr_n51212400)
print v(xbgr.mr_n51212512)
print v(xbgr.mr_n51212832)
print v(xbgr.mr_n51212944)
print v(xbgr.mr_n51213264)
print v(xbgr.mr_n51213376)
print v(xbgr.mr_n51213696)
print v(xbgr.mr_n51213808)
print v(xbgr.mr_n51214128)
print v(xbgr.mr_n51214240)
print v(xbgr.mr_n51214560)
print v(xbgr.mr_n51214672)
print v(xbgr.mr_n51215104)
print v(xbgr.mr_n51215424)
print v(xbgr.mr_n51215536)
print v(xbgr.mr_n51215968)
print v(xbgr.mr_n51216400)
print v(xbgr.mr_n51216720)
print v(xbgr.mr_n51216832)
print v(xbgr.mr_n51217152)
print v(xbgr.mr_n51217264)
print v(xbgr.mr_n51217584)
print v(xbgr.mr_n51217696)
print v(xbgr.mr_n51218016)
print v(xbgr.mr_n51218128)
print v(xbgr.mr_n51218560)
print v(xbgr.mr_n51218992)
print v(xbgr.mr_n51219424)
print v(xbgr.mr_n51219856)
print v(xbgr.mr_n51220288)
print v(xbgr.mr_n51220720)
print v(xbgr.mr_n51221152)
print v(xbgr.mr_n51221584)
print v(xbgr.mr_n51221904)
print v(xbgr.mr_n51222016)
print v(xbgr.mr_n51222336)
print v(xbgr.mr_n51222448)
print v(xbgr.mr_n51222768)
print v(xbgr.mr_n51222880)
print v(xbgr.mr_n51223200)
print v(xbgr.mr_n51223312)
print v(xbgr.mr_n51223632)
print v(xbgr.mr_n51223744)
print v(xbgr.mr_n51224064)
print v(xbgr.mr_n51224176)
print v(xbgr.mr_n51224496)
print v(xbgr.mr_n51224608)
print v(xbgr.mr_n51224928)
print v(xbgr.mr_n51225040)
print v(xbgr.mr_n51225360)
print v(xbgr.mr_n51225472)
print v(xbgr.mr_n51225792)
print v(xbgr.mr_n51225904)
print v(xbgr.mr_n51226224)
print v(xbgr.mr_n51226336)
print v(xbgr.mr_n51226656)
print v(xbgr.mr_n51226768)
print v(xbgr.mr_n51227088)
print v(xbgr.mr_n51227200)
print v(xbgr.mr_n51227520)
print v(xbgr.mr_n51227632)
print v(xbgr.mr_n51227952)
print v(xbgr.mr_n51228064)
print v(xbgr.mr_n51228384)
print v(xbgr.mr_n51228496)
print v(xbgr.mr_n51228816)
print v(xbgr.mr_n51228928)
print v(xbgr.mr_n51229248)
print v(xbgr.mr_n51229360)
print v(xbgr.mr_n51229680)
print v(xbgr.mr_n51229792)
print v(xbgr.mr_n51230112)
print v(xbgr.mr_n51230224)
print v(xbgr.mr_n51230544)
print v(xbgr.mr_n51230656)
print v(xbgr.mr_n51230976)
print v(xbgr.mr_n51231088)
print v(xbgr.mr_n51231408)
print v(xbgr.mr_n51231520)
print v(xbgr.mr_n51231840)
print v(xbgr.mr_n51231952)
print v(xbgr.mr_n51232384)
print v(xbgr.mr_n51232816)
print v(xbgr.mr_n51233136)
print v(xbgr.mr_n51233248)
print v(xbgr.mr_n51233568)
print v(xbgr.mr_n51233680)
print v(xbgr.mr_n51234112)
print v(xbgr.mr_n51234544)
print v(xbgr.mr_n51234976)
print v(xbgr.mr_n51235408)
print v(xbgr.mr_n51235840)
print v(xbgr.mr_n51236272)
print v(xbgr.mr_n51236704)
print v(xbgr.mr_n51237136)
print v(xbgr.mr_n51237568)
print v(xbgr.mr_n51238000)
print v(xbgr.mr_n51238432)
print v(xbgr.mr_n51238864)
print v(xbgr.mr_n51239296)
print v(xbgr.mr_n51239728)
print v(xbgr.mr_n51240160)
print v(xbgr.mr_n51240592)
print v(xbgr.mr_n51241024)
print v(xbgr.mr_n51241456)
print v(xbgr.mr_n51241888)
print v(xbgr.mr_n51242320)
print v(xbgr.mr_n51242752)
print v(xbgr.mr_n51243184)
print v(xbgr.mr_n51243616)
print v(xbgr.mr_n51244048)
print v(xbgr.mr_n51244368)
print v(xbgr.mr_n51244480)
print v(xbgr.mr_n51244800)
print v(xbgr.mr_n51244912)
print v(xbgr.mr_n51245232)
print v(xbgr.mr_n51245344)
print v(xbgr.mr_n51245664)
print v(xbgr.mr_n51245776)
print v(xbgr.mr_n51246096)
print v(xbgr.mr_n51246208)
print v(xbgr.mr_n51246528)
print v(xbgr.mr_n51246640)
print v(xbgr.mr_n51246960)
print v(xbgr.mr_n51247072)
print v(xbgr.mr_n51247392)
print v(xbgr.mr_n51247504)
print v(xbgr.mr_n51247824)
print v(xbgr.mr_n51247936)
print v(xbgr.mr_n51248256)
print v(xbgr.mr_n51248368)
print v(xbgr.mr_n51248688)
print v(xbgr.mr_n51248800)
print v(xbgr.mr_n51249120)
print v(xbgr.mr_n51249232)
print v(xbgr.mr_n51249552)
print v(xbgr.mr_n51249664)
print v(xbgr.mr_n51250096)
print v(xbgr.mr_n51250528)
print v(xbgr.mr_n51250960)
print v(xbgr.mr_n51251392)
print v(xbgr.mr_n51251824)
print v(xbgr.mr_n51252256)
print v(xbgr.mr_n51252688)
print v(xbgr.mr_n51253120)
print v(xbgr.mr_n51253552)
print v(xbgr.mr_n51253984)
print v(xbgr.mr_n51254416)
print v(xbgr.mr_n51254848)
print v(xbgr.mr_n51255280)
print v(xbgr.mr_n51255600)
print v(xbgr.mr_n51255712)
print v(xbgr.mr_n51256032)
print v(xbgr.mr_n51256144)
print v(xbgr.mr_n51256464)
print v(xbgr.mr_n51256576)
print v(xbgr.mr_n51256896)
print v(xbgr.mr_n51257008)
print v(xbgr.mr_n51257328)
print v(xbgr.mr_n51257440)
print v(xbgr.mr_n51257760)
print v(xbgr.mr_n51257872)
print v(xbgr.mr_n51258192)
print v(xbgr.mr_n51258304)
print v(xbgr.mr_n51258624)
print v(xbgr.mr_n51258736)
print v(xbgr.mr_n51259056)
print v(xbgr.mr_n51259168)
print v(xbgr.mr_n51259488)
print v(xbgr.mr_n51259600)
print v(xbgr.mr_n51259920)
print v(xbgr.mr_n51260032)
print v(xbgr.mr_n51260352)
print v(xbgr.mr_n51260464)
print v(xbgr.mr_n51260784)
print v(xbgr.mr_n51260896)
print v(xbgr.mr_n51261328)
print v(xbgr.mr_n51261760)
print v(xbgr.mr_n51262192)
print v(xbgr.mr_n51262624)
print v(xbgr.mr_n51263056)
print v(xbgr.mr_n51263488)
print v(xbgr.mr_n51263920)
print v(xbgr.mr_n51264352)
print v(xbgr.mr_n51264784)
print v(xbgr.mr_n51265216)
print v(xbgr.mr_n51265648)
print v(xbgr.mr_n51266080)
print v(xbgr.mr_n51266512)
print v(xbgr.mr_n51266832)
print v(xbgr.mr_n51266944)
print v(xbgr.mr_n51267264)
print v(xbgr.mr_n51267376)
print v(xbgr.mr_n51267696)
print v(xbgr.mr_n51267808)
print v(xbgr.mr_n51268128)
print v(xbgr.mr_n51268240)
print v(xbgr.mr_n51268560)
print v(xbgr.mr_n51268672)
print v(xbgr.mr_n51268992)
print v(xbgr.mr_n51269104)
print v(xbgr.mr_n51269424)
print v(xbgr.mr_n51269536)
print v(xbgr.mr_n51269856)
print v(xbgr.mr_n51269968)
print v(xbgr.mr_n51270288)
print v(xbgr.mr_n51270400)
print v(xbgr.mr_n51270720)
print v(xbgr.mr_n51270832)
print v(xbgr.mr_n51271152)
print v(xbgr.mr_n51271264)
print v(xbgr.mr_n51271584)
print v(xbgr.mr_n51271696)
print v(xbgr.mr_n51272016)
print v(xbgr.mr_n51272128)
print v(xbgr.mr_n51272560)
print v(xbgr.mr_n51272992)
print v(xbgr.mr_n51273424)
print v(xbgr.mr_n51273856)
print v(xbgr.mr_n51274288)
print v(xbgr.mr_n51274720)
print v(xbgr.mr_n51275152)
print v(xbgr.mr_n51275584)
print v(xbgr.mr_n51276016)
print v(xbgr.mr_n51276448)
print v(xbgr.mr_n51276880)
print v(xbgr.mr_n51277312)
print v(xbgr.mr_n51277744)
print v(xbgr.mr_n51278064)
print v(xbgr.mr_n51278176)
print v(xbgr.mr_n51278496)
print v(xbgr.mr_n51278608)
print v(xbgr.mr_n51278928)
print v(xbgr.mr_n51279040)
print v(xbgr.mr_n51279360)
print v(xbgr.mr_n51279472)
print v(xbgr.mr_n51279792)
print v(xbgr.mr_n51279904)
print v(xbgr.mr_n51280224)
print v(xbgr.mr_n51280336)
print v(xbgr.mr_n51280656)
print v(xbgr.mr_n51280768)
print v(xbgr.mr_n51281200)
print v(xbgr.mr_n51281632)
print v(xbgr.mr_n51282064)
print v(xbgr.mr_n51282496)
print v(xbgr.mr_n51282816)
print v(xbgr.mr_n51282928)
print v(xbgr.mr_n51283248)
print v(xbgr.mr_n51283360)
print v(xbgr.mr_n51283680)
print v(xbgr.mr_n51283792)
print v(xbgr.mr_n51284112)
print v(xbgr.mr_n51284224)
print v(xbgr.mr_n51284544)
print v(xbgr.mr_n51284656)
print v(xbgr.mr_n51284976)
print v(xbgr.mr_n51285088)
print v(xbgr.mr_n51285520)
print v(xbgr.mr_n51285952)
print v(xbgr.mr_n51286384)
print v(xbgr.mr_n51286816)
print v(xbgr.mr_n51287248)
print v(xbgr.mr_n51287680)
print v(xbgr.mr_n51288112)
print v(xbgr.mr_n51288544)
print v(xbgr.mr_n51288976)
print v(xbgr.mr_n51289296)
print v(xbgr.mr_n51289408)
print v(xbgr.mr_n51289728)
print v(xbgr.mr_n51289840)
print v(xbgr.mr_n51290160)
print v(xbgr.mr_n51290272)
print v(xbgr.mr_n51290592)
print v(xbgr.mr_n51290704)
print v(xbgr.mr_n51291024)
print v(xbgr.mr_n51291136)
print v(xbgr.mr_n51291456)
print v(xbgr.mr_n51291568)
print v(xbgr.mr_n51291888)
print v(xbgr.mr_n51292000)
print v(xbgr.mr_n51292320)
print v(xbgr.mr_n51292432)
print v(xbgr.mr_n51292752)
print v(xbgr.mr_n51292864)
print v(xbgr.mr_n51293184)
print v(xbgr.mr_n51293296)
print v(xbgr.mr_n51293616)
print v(xbgr.mr_n51293728)
print v(xbgr.mr_n51294048)
print v(xbgr.mr_n51294160)
print v(xbgr.mr_n51294480)
print v(xbgr.mr_n51294592)
print v(xbgr.mr_n51294912)
print v(xbgr.mr_n51295024)
print v(xbgr.mr_n51295456)
print v(xbgr.mr_n51295888)
print v(xbgr.mr_n51296320)
print v(xbgr.mr_n51296752)
print v(xbgr.mr_n51297072)
print v(xbgr.mr_n51297184)
print v(xbgr.mr_n51297504)
print v(xbgr.mr_n51297616)
print v(xbgr.mr_n51298048)
print v(xbgr.mr_n51298480)
print v(xbgr.mr_n51298912)
print v(xbgr.mr_n51299344)
print v(xbgr.mr_n51299776)
print v(xbgr.mr_n51300208)
print v(xbgr.mr_n51300640)
print v(xbgr.mr_n51301072)
print v(xbgr.mr_n51301392)
print v(xbgr.mr_n51301504)
print v(xbgr.mr_n51301824)
print v(xbgr.mr_n51301936)
print v(xbgr.mr_n51302256)
print v(xbgr.mr_n51302368)
print v(xbgr.mr_n51302688)
print v(xbgr.mr_n51302800)
print v(xbgr.mr_n51303120)
print v(xbgr.mr_n51303232)
print v(xbgr.mr_n51303552)
print v(xbgr.mr_n51303664)
print v(xbgr.mr_n51303984)
print v(xbgr.mr_n51304096)
print v(xbgr.mr_n51304416)
print v(xbgr.mr_n51304528)
print v(xbgr.mr_n51304848)
print v(xbgr.mr_n51304960)
print v(xbgr.mr_n51305280)
print v(xbgr.mr_n51305392)
print v(xbgr.mr_n51305712)
print v(xbgr.mr_n51305824)
print v(xbgr.mr_n51306144)
print v(xbgr.mr_n51306256)
print v(xbgr.mr_n51306688)
print v(xbgr.mr_n51307120)
print v(xbgr.mr_n51307552)
print v(xbgr.mr_n51307984)
print v(xbgr.mr_n51308416)
print v(xbgr.mr_n51308848)
print v(xbgr.mr_n51309168)
print v(xbgr.mr_n51309280)
print v(xbgr.mr_n51309600)
print v(xbgr.mr_n51309712)
print v(xbgr.mr_n51310032)
print v(xbgr.mr_n51310144)
print v(xbgr.mr_n51310464)
print v(xbgr.mr_n51310576)
print v(xbgr.mr_n51310896)
print v(xbgr.mr_n51311008)
print v(xbgr.mr_n51311328)
print v(xbgr.mr_n51311440)
print v(xbgr.mr_n51311760)
print v(xbgr.mr_n51311872)
print v(xbgr.mr_n51312192)
print v(xbgr.mr_n51312304)
print v(xbgr.mr_n51312624)
print v(xbgr.mr_n51312736)
print v(xbgr.mr_n51313056)
print v(xbgr.mr_n51313168)
print v(xbgr.mr_n51313488)
print v(xbgr.mr_n51313600)
print v(xbgr.mr_n51313920)
print v(xbgr.mr_n51314032)
print v(xbgr.mr_n51314352)
print v(xbgr.mr_n51314464)
print v(xbgr.mr_n51314784)
print v(xbgr.mr_n51314896)
print v(xbgr.mr_n51315216)
print v(xbgr.mr_n51315328)
print v(xbgr.mr_n51315648)
print v(xbgr.mr_n51315760)
print v(xbgr.mr_n51316080)
print v(xbgr.mr_n51316192)
print v(xbgr.mr_n51316512)
print v(xbgr.mr_n51316624)
print v(xbgr.mr_n51317056)
print v(xbgr.mr_n51317488)
print v(xbgr.mr_n51317808)
print v(xbgr.mr_n51317920)
print v(xbgr.mr_n51318240)
print v(xbgr.mr_n51318352)
print v(xbgr.mr_n51318672)
print v(xbgr.mr_n51318784)
print v(xbgr.mr_n51319104)
print v(xbgr.mr_n51319216)
print v(xbgr.mr_n51319648)
print v(xbgr.mr_n51320080)
print v(xbgr.mr_n51320512)
print v(xbgr.mr_n51320944)
print v(xbgr.mr_n51321376)
print v(xbgr.mr_n51321808)
print v(xbgr.mr_n51322240)
print v(xbgr.mr_n51322672)
print v(xbgr.mr_n51323104)
print v(xbgr.mr_n51323536)
print v(xbgr.mr_n51323968)
print v(xbgr.mr_n51324400)
print v(xbgr.mr_n51324832)
print v(xbgr.mr_n51325264)
print v(xbgr.mr_n51325696)
print v(xbgr.mr_n51326128)
print v(xbgr.mr_n51326448)
print v(xbgr.mr_n51326560)
print v(xbgr.mr_n51326880)
print v(xbgr.mr_n51326992)
print v(xbgr.mr_n51327312)
print v(xbgr.mr_n51327424)
print v(xbgr.mr_n51327744)
print v(xbgr.mr_n51327856)
print v(xbgr.mr_n51328176)
print v(xbgr.mr_n51328288)
print v(xbgr.mr_n51328608)
print v(xbgr.mr_n51328720)
print v(xbgr.mr_n51329040)
print v(xbgr.mr_n51329152)
print v(xbgr.mr_n51329472)
print v(xbgr.mr_n51329584)
print v(xbgr.mr_n51329904)
print v(xbgr.mr_n51330016)
print v(xbgr.mr_n51330336)
print v(xbgr.mr_n51330448)
print v(xbgr.mr_n51330880)
print v(xbgr.mr_n51331312)
print v(xbgr.mr_n51331744)
print v(xbgr.mr_n51332176)
print v(xbgr.mr_n51332608)
print v(xbgr.mr_n51333040)
print v(xbgr.mr_n51333472)
print v(xbgr.mr_n51333904)
print v(xbgr.mr_n51334224)
print v(xbgr.mr_n51334336)
print v(xbgr.mr_n51334656)
print v(xbgr.mr_n51334768)
print v(xbgr.mr_n51335088)
print v(xbgr.mr_n51335200)
print v(xbgr.mr_n51335520)
print v(xbgr.mr_n51335632)
print v(xbgr.mr_n51335952)
print v(xbgr.mr_n51336064)
print v(xbgr.mr_n51336384)
print v(xbgr.mr_n51336496)
print v(xbgr.mr_n51336816)
print v(xbgr.mr_n51336928)
print v(xbgr.mr_n51337248)
print v(xbgr.mr_n51337360)
print v(xbgr.mr_n51337680)
print v(xbgr.mr_n51337792)
print v(xbgr.mr_n51338112)
print v(xbgr.mr_n51338224)
print v(xbgr.mr_n51338544)
print v(xbgr.mr_n51338656)
print v(xbgr.mr_n51338976)
print v(xbgr.mr_n51339088)
print v(xbgr.mr_n51339408)
print v(xbgr.mr_n51339520)
print v(xbgr.mr_n51339840)
print v(xbgr.mr_n51339952)
print v(xbgr.mr_n51340384)
print v(xbgr.mr_n51340816)
print v(xbgr.mr_n51341248)
print v(xbgr.mr_n51341680)
print v(xbgr.mr_n51342112)
print v(xbgr.mr_n51342544)
print v(xbgr.mr_n51342976)
print v(xbgr.mr_n51343408)
print v(xbgr.mr_n51343840)
print v(xbgr.mr_n51344272)
print v(xbgr.mr_n51344704)
print v(xbgr.mr_n51345136)
print v(xbgr.mr_n51345568)
print v(xbgr.mr_n51346000)
print v(xbgr.mr_n51346320)
print v(xbgr.mr_n51346432)
print v(xbgr.mr_n51346752)
print v(xbgr.mr_n51346864)
print v(xbgr.mr_n51347184)
print v(xbgr.mr_n51347296)
print v(xbgr.mr_n51347616)
print v(xbgr.mr_n51347728)
print v(xbgr.mr_n51348048)
print v(xbgr.mr_n51348160)
print v(xbgr.mr_n51348480)
print v(xbgr.mr_n51348592)
print v(xbgr.mr_n51348912)
print v(xbgr.mr_n51349024)
print v(xbgr.mr_n51349344)
print v(xbgr.mr_n51349456)
print v(xbgr.mr_n51349776)
print v(xbgr.mr_n51349888)
print v(xbgr.mr_n51350208)
print v(xbgr.mr_n51350320)
print v(xbgr.mr_n51350640)
print v(xbgr.mr_n51350752)
print v(xbgr.mr_n51351072)
print v(xbgr.mr_n51351184)
print v(xbgr.mr_n51351504)
print v(xbgr.mr_n51351616)
print v(xbgr.mr_n51351936)
print v(xbgr.mr_n51352048)
print v(xbgr.mr_n51352368)
print v(xbgr.mr_n51352480)
print v(xbgr.mr_n51352800)
print v(xbgr.mr_n51352912)
print v(xbgr.mr_n51353232)
print v(xbgr.mr_n51353344)
print v(xbgr.mr_n51353664)
print v(xbgr.mr_n51353776)
print v(xbgr.mr_n51354096)
print v(xbgr.mr_n51354208)
print v(xbgr.mr_n51354528)
print v(xbgr.mr_n51354640)
print v(xbgr.mr_n51354960)
print v(xbgr.mr_n51355072)
print v(xbgr.mr_n51355392)
print v(xbgr.mr_n51355504)
print v(xbgr.mr_n51355824)
print v(xbgr.mr_n51355936)
print v(xbgr.mr_n51356256)
print v(xbgr.mr_n51356368)
print v(xbgr.mr_n51356800)
print v(xbgr.mr_n51357232)
print v(xbgr.mr_n51357664)
print v(xbgr.mr_n51358096)
print v(xbgr.mr_n51358528)
print v(xbgr.mr_n51358960)
print v(xbgr.mr_n51359392)
print v(xbgr.mr_n51359824)
print v(xbgr.mr_n51360256)
print v(xbgr.mr_n51360688)
print v(xbgr.mr_n51361120)
print v(xbgr.mr_n51361552)
print v(xbgr.mr_n51361984)
print v(xbgr.mr_n51362416)
print v(xbgr.mr_n51362848)
print v(xbgr.mr_n51363280)
print v(xbgr.mr_n51363600)
print v(xbgr.mr_n51363712)
print v(xbgr.mr_n51364032)
print v(xbgr.mr_n51364144)
print v(xbgr.mr_n51364576)
print v(xbgr.mr_n51365008)
print v(xbgr.mr_n51365440)
print v(xbgr.mr_n51365872)
print v(xbgr.mr_n51366304)
print v(xbgr.mr_n51366736)
print v(xbgr.mr_n51367168)
print v(xbgr.mr_n51367600)
print v(xbgr.mr_n51368032)
print v(xbgr.mr_n51368464)
print v(xbgr.mr_n51368784)
print v(xbgr.mr_n51368896)
print v(xbgr.mr_n51369216)
print v(xbgr.mr_n51369328)
print v(xbgr.mr_n51369648)
print v(xbgr.mr_n51369760)
print v(xbgr.mr_n51370080)
print v(xbgr.mr_n51370192)
print v(xbgr.mr_n51370512)
print v(xbgr.mr_n51370624)
print v(xbgr.mr_n51370944)
print v(xbgr.mr_n51371056)
print v(xbgr.mr_n51371376)
print v(xbgr.mr_n51371488)
print v(xbgr.mr_n51371808)
print v(xbgr.mr_n51371920)
print v(xbgr.mr_n51372240)
print v(xbgr.mr_n51372352)
print v(xbgr.mr_n51372672)
print v(xbgr.mr_n51372784)
print v(xbgr.mr_n51373104)
print v(xbgr.mr_n51373216)
print v(xbgr.mr_n51373536)
print v(xbgr.mr_n51373648)
print v(xbgr.mr_n51373968)
print v(xbgr.mr_n51374080)
print v(xbgr.mr_n51374512)
print v(xbgr.mr_n51374944)
print v(xbgr.mr_n51375376)
print v(xbgr.mr_n51375808)
print v(xbgr.mr_n51376240)
print v(xbgr.mr_n51376672)
print v(xbgr.mr_n51377104)
print v(xbgr.mr_n51377536)
print v(xbgr.mr_n51377968)
print v(xbgr.mr_n51378400)
print v(xbgr.mr_n51378832)
print v(xbgr.mr_n51379264)
print v(xbgr.mr_n51379696)
print v(xbgr.mr_n51380016)
print v(xbgr.mr_n51380128)
print v(xbgr.mr_n51380448)
print v(xbgr.mr_n51380560)
print v(xbgr.mr_n51380880)
print v(xbgr.mr_n51380992)
print v(xbgr.mr_n51381312)
print v(xbgr.mr_n51381424)
print v(xbgr.mr_n51381744)
print v(xbgr.mr_n51381856)
print v(xbgr.mr_n51382176)
print v(xbgr.mr_n51382288)
print v(xbgr.mr_n51382608)
print v(xbgr.mr_n51382720)
print v(xbgr.mr_n51383040)
print v(xbgr.mr_n51383152)
print v(xbgr.mr_n51383472)
print v(xbgr.mr_n51383584)
print v(xbgr.mr_n51383904)
print v(xbgr.mr_n51384016)
print v(xbgr.mr_n51384336)
print v(xbgr.mr_n51384448)
print v(xbgr.mr_n51384768)
print v(xbgr.mr_n51384880)
print v(xbgr.mr_n51385200)
print v(xbgr.mr_n51385312)
print v(xbgr.mr_n51385744)
print v(xbgr.mr_n51386176)
print v(xbgr.mr_n51386608)
print v(xbgr.mr_n51387040)
print v(xbgr.mr_n51387472)
print v(xbgr.mr_n51387904)
print v(xbgr.mr_n51388336)
print v(xbgr.mr_n51388768)
print v(xbgr.mr_n51389200)
print v(xbgr.mr_n51389632)
print v(xbgr.mr_n51390064)
print v(xbgr.mr_n51390496)
print v(xbgr.mr_n51390928)
print v(xbgr.mr_n51391248)
print v(xbgr.mr_n51391360)
print v(xbgr.mr_n51391680)
print v(xbgr.mr_n51391792)
print v(xbgr.mr_n51392112)
print v(xbgr.mr_n51392224)
print v(xbgr.mr_n51392544)
print v(xbgr.mr_n51392656)
print v(xbgr.mr_n51392976)
print v(xbgr.mr_n51393088)
print v(xbgr.mr_n51393408)
print v(xbgr.mr_n51393520)
print v(xbgr.mr_n51393840)
print v(xbgr.mr_n51393952)
print v(xbgr.mr_n51394272)
print v(xbgr.mr_n51394384)
print v(xbgr.mr_n51394704)
print v(xbgr.mr_n51394816)
print v(xbgr.mr_n51395136)
print v(xbgr.mr_n51395248)
print v(xbgr.mr_n51395568)
print v(xbgr.mr_n51395680)
print v(xbgr.mr_n51396000)
print v(xbgr.mr_n51396112)
print v(xbgr.mr_n51396432)
print v(xbgr.mr_n51396544)
print v(xbgr.mr_n51396976)
print v(xbgr.mr_n51397408)
print v(xbgr.mr_n51397840)
print v(xbgr.mr_n51398272)
print v(xbgr.mr_n51398704)
print v(xbgr.mr_n51399136)
print v(xbgr.mr_n51399568)
print v(xbgr.mr_n51400000)
print v(xbgr.mr_n51400432)
print v(xbgr.mr_n51400864)
print v(xbgr.mr_n51401296)
print v(xbgr.mr_n51401728)
print v(xbgr.mr_n51402160)
print v(xbgr.mr_n51402480)
print v(xbgr.mr_n51402592)
print v(xbgr.mr_n51402912)
print v(xbgr.mr_n51403024)
print v(xbgr.mr_n51403344)
print v(xbgr.mr_n51403456)
print v(xbgr.mr_n51403776)
print v(xbgr.mr_n51403888)
print v(xbgr.mr_n51404208)
print v(xbgr.mr_n51404320)
print v(xbgr.mr_n51404640)
print v(xbgr.mr_n51404752)
print v(xbgr.mr_n51405072)
print v(xbgr.mr_n51405184)
print v(xbgr.mr_n51405504)
print v(xbgr.mr_n51405616)
print v(xbgr.mr_n51405936)
print v(xbgr.mr_n51406048)
print v(xbgr.mr_n51406368)
print v(xbgr.mr_n51406480)
print v(xbgr.mr_n51406800)
print v(xbgr.mr_n51406912)
print v(xbgr.mr_n51407232)
print v(xbgr.mr_n51407344)
print v(xbgr.mr_n51407664)
print v(xbgr.mr_n51407776)
print v(xbgr.mr_n51408208)
print v(xbgr.mr_n51408640)
print v(xbgr.mr_n51409072)
print v(xbgr.mr_n51409504)
print v(xbgr.mr_n51409936)
print v(xbgr.mr_n51410368)
print v(xbgr.mr_n51410800)
print v(xbgr.mr_n51411232)
print v(xbgr.mr_n51411664)
print v(xbgr.mr_n51412096)
print v(xbgr.mr_n51412528)
print v(xbgr.mr_n51412960)
print v(xbgr.mr_n51413392)
print v(xbgr.mr_n51413712)
print v(xbgr.mr_n51413824)
print v(xbgr.mr_n51414144)
print v(xbgr.mr_n51414256)
print v(xbgr.mr_n51414576)
print v(xbgr.mr_n51414688)
print v(xbgr.mr_n51415008)
print v(xbgr.mr_n51415120)
print v(xbgr.mr_n51415440)
print v(xbgr.mr_n51415552)
print v(xbgr.mr_n51415984)
print v(xbgr.mr_n51416416)
print v(xbgr.mr_n51416848)
print v(xbgr.mr_n51417280)
print v(xbgr.mr_n51417712)
print v(xbgr.mr_n51418032)
print v(xbgr.mr_n51418144)
print v(xbgr.mr_n51418464)
print v(xbgr.mr_n51418576)
print v(xbgr.mr_n51418896)
print v(xbgr.mr_n51419008)
print v(xbgr.mr_n51419328)
print v(xbgr.mr_n51419440)
print v(xbgr.mr_n51419760)
print v(xbgr.mr_n51419872)
print v(xbgr.mr_n51420192)
print v(xbgr.mr_n51420304)
print v(xbgr.mr_n51420624)
print v(xbgr.mr_n51420736)
print v(xbgr.mr_n51421056)
print v(xbgr.mr_n51421168)
print v(xbgr.mr_n51421600)
print v(xbgr.mr_n51422032)
print v(xbgr.mr_n51422464)
print v(xbgr.mr_n51422896)
print v(xbgr.mr_n51423328)
print v(xbgr.mr_n51423760)
print v(xbgr.mr_n51424192)
print v(xbgr.mr_n51424624)
print v(xbgr.mr_n51424944)
print v(xbgr.mr_n51425056)
print v(xbgr.mr_n51425376)
print v(xbgr.mr_n51425488)
print v(xbgr.mr_n51425808)
print v(xbgr.mr_n51425920)
print v(xbgr.mr_n51426240)
print v(xbgr.mr_n51426352)
print v(xbgr.mr_n51426672)
print v(xbgr.mr_n51426784)
print v(xbgr.mr_n51427104)
print v(xbgr.mr_n51427216)
print v(xbgr.mr_n51427536)
print v(xbgr.mr_n51427648)
print v(xbgr.mr_n51427968)
print v(xbgr.mr_n51428080)
print v(xbgr.mr_n51428512)
print v(xbgr.mr_n51428944)
print v(xbgr.mr_n51429376)
print v(xbgr.mr_n51429808)
print v(xbgr.mr_n51430240)
print v(xbgr.mr_n51430560)
print v(xbgr.mr_n51430672)
print v(xbgr.mr_n51430992)
print v(xbgr.mr_n51431104)
print v(xbgr.mr_n51431424)
print v(xbgr.mr_n51431536)
print v(xbgr.mr_n51431856)
print v(xbgr.mr_n51431968)
print v(xbgr.mr_n51432288)
print v(xbgr.mr_n51432400)
print v(xbgr.mr_n51432832)
print v(xbgr.mr_n51433264)
print v(xbgr.mr_n51433696)
print v(xbgr.mr_n51434128)
print v(xbgr.mr_n51434560)
print v(xbgr.mr_n51434992)
print v(xbgr.mr_n51435424)
print v(xbgr.mr_n51435856)
print v(xbgr.mr_n51436176)
print v(xbgr.mr_n51436288)
print v(xbgr.mr_n51436608)
print v(xbgr.mr_n51436720)
print v(xbgr.mr_n51437040)
print v(xbgr.mr_n51437152)
print v(xbgr.mr_n51437472)
print v(xbgr.mr_n51437584)
print v(xbgr.mr_n51437904)
print v(xbgr.mr_n51438016)
print v(xbgr.mr_n51438336)
print v(xbgr.mr_n51438448)
print v(xbgr.mr_n51438768)
print v(xbgr.mr_n51438880)
print v(xbgr.mr_n51439312)
print v(xbgr.mr_n51439744)
print v(xbgr.mr_n51440176)
print v(xbgr.mr_n51440608)
print v(xbgr.mr_n51440928)
print v(xbgr.mr_n51441040)
print v(xbgr.mr_n51441472)
print v(xbgr.mr_n51441904)
print v(xbgr.mr_n51442224)
print v(xbgr.mr_n51442336)
print v(xbgr.mr_n51442656)
print v(xbgr.mr_n51442768)
print v(xbgr.mr_n51443088)
print v(xbgr.mr_n51443200)
print v(xbgr.mr_n51443520)
print v(xbgr.mr_n51443632)
print v(xbgr.mr_n51443952)
print v(xbgr.mr_n51444064)
print v(xbgr.mr_n51444496)
print v(xbgr.mr_n51444928)
print v(xbgr.mr_n51445360)
print v(xbgr.mr_n51445792)
print v(xbgr.mr_n51446224)
print v(xbgr.mr_n51446656)
print v(xbgr.mr_n51447088)
print v(xbgr.mr_n51447408)
print v(xbgr.mr_n51447520)
print v(xbgr.mr_n51447840)
print v(xbgr.mr_n51447952)
print v(xbgr.mr_n51448272)
print v(xbgr.mr_n51448384)
print v(xbgr.mr_n51448704)
print v(xbgr.mr_n51448816)
print v(xbgr.mr_n51449136)
print v(xbgr.mr_n51449248)
print v(xbgr.mr_n51449568)
print v(xbgr.mr_n51449680)
print v(xbgr.mr_n51450000)
print v(xbgr.mr_n51450112)
print v(xbgr.mr_n51450432)
print v(xbgr.mr_n51450544)
print v(xbgr.mr_n51450864)
print v(xbgr.mr_n51450976)
print v(xbgr.mr_n51451296)
print v(xbgr.mr_n51451408)
print v(xbgr.mr_n51451728)
print v(xbgr.mr_n51451840)
print v(xbgr.mr_n51452160)
print v(xbgr.mr_n51452272)
print v(xbgr.mr_n51452592)
print v(xbgr.mr_n51452704)
print v(xbgr.mr_n51453136)
print v(xbgr.mr_n51453568)
print v(xbgr.mr_n51454000)
print v(xbgr.mr_n51454432)
print v(xbgr.mr_n51454864)
print v(xbgr.mr_n51455296)
print v(xbgr.mr_n51455728)
print v(xbgr.mr_n51456160)
print v(xbgr.mr_n51456592)
print v(xbgr.mr_n51457024)
print v(xbgr.mr_n51457456)
print v(xbgr.mr_n51457888)
print v(xbgr.mr_n51458320)
print v(xbgr.mr_n51458640)
print v(xbgr.mr_n51458752)
print v(xbgr.mr_n51459072)
print v(xbgr.mr_n51459184)
print v(xbgr.mr_n51459504)
print v(xbgr.mr_n51459616)
print v(xbgr.mr_n51459936)
print v(xbgr.mr_n51460048)
print v(xbgr.mr_n51460368)
print v(xbgr.mr_n51460480)
print v(xbgr.mr_n51460800)
print v(xbgr.mr_n51460912)
print v(xbgr.mr_n51461232)
print v(xbgr.mr_n51461344)
print v(xbgr.mr_n51461664)
print v(xbgr.mr_n51461776)
print v(xbgr.mr_n51462096)
print v(xbgr.mr_n51462208)
print v(xbgr.mr_n51462528)
print v(xbgr.mr_n51462640)
print v(xbgr.mr_n51462960)
print v(xbgr.mr_n51463072)
print v(xbgr.mr_n51463392)
print v(xbgr.mr_n51463504)
print v(xbgr.mr_n51463824)
print v(xbgr.mr_n51463936)
print v(xbgr.mr_n51464256)
print v(xbgr.mr_n51464368)
print v(xbgr.mr_n51464688)
print v(xbgr.mr_n51464800)
print v(xbgr.mr_n51465120)
print v(xbgr.mr_n51465232)
print v(xbgr.mr_n51465664)
print v(xbgr.mr_n51466096)
print v(xbgr.mr_n51466528)
print v(xbgr.mr_n51466960)
print v(xbgr.mr_n51467392)
print v(xbgr.mr_n51467824)
print v(xbgr.mr_n51468144)
print v(xbgr.mr_n51468256)
print v(xbgr.mr_n51468576)
print v(xbgr.mr_n51468688)
print v(xbgr.mr_n51469008)
print v(xbgr.mr_n51469120)
print v(xbgr.mr_n51469440)
print v(xbgr.mr_n51469552)
print v(xbgr.mr_n51469872)
print v(xbgr.mr_n51469984)
print v(xbgr.mr_n51470304)
print v(xbgr.mr_n51470416)
print v(xbgr.mr_n51470736)
print v(xbgr.mr_n51470848)
print v(xbgr.mr_n51471168)
print v(xbgr.mr_n51471280)
print v(xbgr.mr_n51471600)
print v(xbgr.mr_n51471712)
print v(xbgr.mr_n51472032)
print v(xbgr.mr_n51472144)
print v(xbgr.mr_n51472576)
print v(xbgr.mr_n51473008)
print v(xbgr.mr_n51473440)
print v(xbgr.mr_n51473872)
print v(xbgr.mr_n51474304)
print v(xbgr.mr_n51474736)
print v(xbgr.mr_n51475168)
print v(xbgr.mr_n51475600)
print v(xbgr.mr_n51476032)
print v(xbgr.mr_n51476464)
print v(xbgr.mr_n51476896)
print v(xbgr.mr_n51477328)
print v(xbgr.mr_n51477760)
print v(xbgr.mr_n51478192)
print v(xbgr.mr_n51478624)
print v(xbgr.mr_n51479056)
print v(xbgr.mr_n51479488)
print v(xbgr.mr_n51479920)
print v(xbgr.mr_n51480352)
print v(xbgr.mr_n51480784)
print v(xbgr.mr_n51481104)
print v(xbgr.mr_n51481216)
print v(xbgr.mr_n51481536)
print v(xbgr.mr_n51481648)
print v(xbgr.mr_n51481968)
print v(xbgr.mr_n51482080)
print v(xbgr.mr_n51482400)
print v(xbgr.mr_n51482512)
print v(xbgr.mr_n51482832)
print v(xbgr.mr_n51482944)
print v(xbgr.mr_n51483264)
print v(xbgr.mr_n51483376)
print v(xbgr.mr_n51483696)
print v(xbgr.mr_n51483808)
print v(xbgr.mr_n51484128)
print v(xbgr.mr_n51484240)
print v(xbgr.mr_n51484560)
print v(xbgr.mr_n51484672)
print v(xbgr.mr_n51484992)
print v(xbgr.mr_n51485104)
print v(xbgr.mr_n51485424)
print v(xbgr.mr_n51485536)
print v(xbgr.mr_n51485856)
print v(xbgr.mr_n51485968)
print v(xbgr.mr_n51486288)
print v(xbgr.mr_n51486400)
print v(xbgr.mr_n51486720)
print v(xbgr.mr_n51486832)
print v(xbgr.mr_n51487264)
print v(xbgr.mr_n51487696)
print v(xbgr.mr_n51488128)
print v(xbgr.mr_n51488560)
print v(xbgr.mr_n51488880)
print v(xbgr.mr_n51488992)
print v(xbgr.mr_n51489312)
print v(xbgr.mr_n51489424)
print v(xbgr.mr_n51489744)
print v(xbgr.mr_n51489856)
print v(xbgr.mr_n51490176)
print v(xbgr.mr_n51490288)
print v(xbgr.mr_n51490608)
print v(xbgr.mr_n51490720)
print v(xbgr.mr_n51491040)
print v(xbgr.mr_n51491152)
print v(xbgr.mr_n51491584)
print v(xbgr.mr_n51492016)
print v(xbgr.mr_n51492448)
print v(xbgr.mr_n51492880)
print v(xbgr.mr_n51493312)
print v(xbgr.mr_n51493744)
print v(xbgr.mr_n51494176)
print v(xbgr.mr_n51494608)
print v(xbgr.mr_n51495040)
print v(xbgr.mr_n51495472)
print v(xbgr.mr_n51495792)
print v(xbgr.mr_n51495904)
print v(xbgr.mr_n51496224)
print v(xbgr.mr_n51496336)
print v(xbgr.mr_n51496768)
print v(xbgr.mr_n51497200)
print v(xbgr.mr_n51497520)
print v(xbgr.mr_n51497632)
print v(xbgr.mr_n51497952)
print v(xbgr.mr_n51498064)
print v(xbgr.mr_n51498384)
print v(xbgr.mr_n51498496)
print v(xbgr.mr_n51498816)
print v(xbgr.mr_n51498928)
print v(xbgr.mr_n51499360)
print v(xbgr.mr_n51499792)
print v(xbgr.mr_n51500224)
print v(xbgr.mr_n51500656)
print v(xbgr.mr_n51501088)
print v(xbgr.mr_n51501520)
print v(xbgr.mr_n51501952)
print v(xbgr.mr_n51502384)
print v(xbgr.mr_n51502816)
print v(xbgr.mr_n51503248)
print v(xbgr.mr_n51503568)
print v(xbgr.mr_n51503680)
print v(xbgr.mr_n51504000)
print v(xbgr.mr_n51504112)
print v(xbgr.mr_n51504432)
print v(xbgr.mr_n51504544)
print v(xbgr.mr_n51504864)
print v(xbgr.mr_n51504976)
print v(xbgr.mr_n51505296)
print v(xbgr.mr_n51505408)
print v(xbgr.mr_n51505728)
print v(xbgr.mr_n51505840)
print v(xbgr.mr_n51506160)
print v(xbgr.mr_n51506272)
print v(xbgr.mr_n51506592)
print v(xbgr.mr_n51506704)
print v(xbgr.mr_n51507024)
print v(xbgr.mr_n51507136)
print v(xbgr.mr_n51507456)
print v(xbgr.mr_n51507568)
print v(xbgr.mr_n51507888)
print v(xbgr.mr_n51508000)
print v(xbgr.mr_n51508320)
print v(xbgr.mr_n51508432)
print v(xbgr.mr_n51508752)
print v(xbgr.mr_n51508864)
print v(xbgr.mr_n51509184)
print v(xbgr.mr_n51509296)
print v(xbgr.mr_n51509616)
print v(xbgr.mr_n51509728)
print v(xbgr.mr_n51510048)
print v(xbgr.mr_n51510160)
print v(xbgr.mr_n51510480)
print v(xbgr.mr_n51510592)
print v(xbgr.mr_n51510912)
print v(xbgr.mr_n51511024)
print v(xbgr.mr_n51511344)
print v(xbgr.mr_n51511456)
print v(xbgr.mr_n51511776)
print v(xbgr.mr_n51511888)
print v(xbgr.mr_n51512208)
print v(xbgr.mr_n51512320)
print v(xbgr.mr_n51512640)
print v(xbgr.mr_n51513072)
print v(xbgr.mr_n51513184)
print v(xbgr.mr_n51513504)
print v(xbgr.mr_n51513936)
print v(xbgr.mr_n51514048)
print v(xbgr.mr_n51514368)
print v(xbgr.mr_n51514800)
print v(xbgr.mr_n51514912)
print v(xbgr.mr_n51515232)
print v(xbgr.mr_n51515664)
print v(xbgr.mr_n51515776)
print v(xbgr.mr_n51516096)
print v(xbgr.mr_n51516528)
print v(xbgr.mr_n51516640)
print v(xbgr.mr_n51516960)
print v(xbgr.mr_n51517072)
print v(xbgr.mr_n51517392)
print v(xbgr.mr_n51517504)
print v(xbgr.mr_n51517824)
print v(xbgr.mr_n51517936)
print v(xbgr.mr_n51518256)
print v(xbgr.mr_n51518368)
print v(xbgr.mr_n51518688)
print v(xbgr.mr_n51518800)
print v(xbgr.mr_n51519120)
print v(xbgr.mr_n51519232)
print v(xbgr.mr_n51519552)
print v(xbgr.mr_n51519664)
print v(xbgr.mr_n51519984)
print v(xbgr.mr_n51520096)
print v(xbgr.mr_n51520416)
print v(xbgr.mr_n51520528)
print v(xbgr.mr_n51520848)
print v(xbgr.mr_n51520960)
print v(xbgr.mr_n51521280)
print v(xbgr.mr_n51521392)
print v(xbgr.mr_n51521712)
print v(xbgr.mr_n51521824)
print v(xbgr.mr_n51522144)
print v(xbgr.mr_n51522256)
print v(xbgr.mr_n51522576)
print v(xbgr.mr_n51522688)
print v(xbgr.mr_n51523008)
print v(xbgr.mr_n51523120)
print v(xbgr.mr_n51523440)
print v(xbgr.mr_n51523552)
print v(xbgr.mr_n51523872)
print v(xbgr.mr_n51523984)
print v(xbgr.mr_n51524304)
print v(xbgr.mr_n51524416)
print v(xbgr.mr_n51524736)
print v(xbgr.mr_n51524848)
print v(xbgr.mr_n51525168)
print v(xbgr.mr_n51525280)
print v(xbgr.mr_n51525600)
print v(xbgr.mr_n51525712)
print v(xbgr.mr_n51526032)
print v(xbgr.mr_n51526144)
print v(xbgr.mr_n51526464)
print v(xbgr.mr_n51526576)
print v(xbgr.mr_n51526896)
print v(xbgr.mr_n51527008)
print v(xbgr.mr_n51527328)
print v(xbgr.mr_n51527440)
print v(xbgr.mr_n51527760)
print v(xbgr.mr_n51527872)
print v(xbgr.mr_n51528192)
print v(xbgr.mr_n51528304)
print v(xbgr.mr_n51528624)
print v(xbgr.mr_n51528736)
print v(xbgr.mr_n51529056)
print v(xbgr.mr_n51529168)
print v(xbgr.mr_n51529488)
print v(xbgr.mr_n51529600)
print v(xbgr.mr_n51529920)
print v(xbgr.mr_n51530032)
print v(xbgr.mr_n51530352)
print v(xbgr.mr_n51530464)
print v(xbgr.mr_n51530784)
print v(xbgr.mr_n51530896)
print v(xbgr.mr_n51531216)
print v(xbgr.mr_n51531328)
print v(xbgr.mr_n51531648)
print v(xbgr.mr_n51531760)
print v(xbgr.mr_n51532080)
print v(xbgr.mr_n51532192)
print v(xbgr.mr_n51532512)
print v(xbgr.mr_n51532624)
print v(xbgr.mr_n51532944)
print v(xbgr.mr_n51533056)
print v(xbgr.mr_n51533376)
print v(xbgr.mr_n51533488)
print v(xbgr.mr_n51533808)
print v(xbgr.mr_n51533920)
print v(xbgr.mr_n51534240)
print v(xbgr.mr_n51534352)
print v(xbgr.mr_n51534672)
print v(xbgr.mr_n51534784)
print v(xbgr.mr_n51535104)
print v(xbgr.mr_n51535216)
print v(xbgr.mr_n51535536)
print v(xbgr.mr_n51535648)
print v(xbgr.mr_n51535968)
print v(xbgr.mr_n51536080)
print v(xbgr.mr_n51536400)
print v(xbgr.mr_n51536512)
print v(xbgr.mr_n51536832)
print v(xbgr.mr_n51536944)
print v(xbgr.mr_n51537264)
print v(xbgr.mr_n51537376)
print v(xbgr.mr_n51537696)
print v(xbgr.mr_n51537808)
print v(xbgr.mr_n51538128)
print v(xbgr.mr_n51538240)
print v(xbgr.mr_n51538560)
print v(xbgr.mr_n51538672)
print v(xbgr.mr_n51538992)
print v(xbgr.mr_n51539104)
print v(xbgr.mr_n51539424)
print v(xbgr.mr_n51539536)
print v(xbgr.mr_n51539856)
print v(xbgr.mr_n51539968)
print v(xbgr.mr_n51540288)
print v(xbgr.mr_n51540400)
print v(xbgr.mr_n51540720)
print v(xbgr.mr_n51540832)
print v(xbgr.mr_n51541152)
print v(xbgr.mr_n51541264)
print v(xbgr.mr_n51541584)
print v(xbgr.mr_n51541696)
print v(xbgr.mr_n51542016)
print v(xbgr.mr_n51542128)
print v(xbgr.mr_n51542448)
print v(xbgr.mr_n51542560)
print v(xbgr.mr_n51542880)
print v(xbgr.mr_n51542992)
print v(xbgr.mr_n51543312)
print v(xbgr.mr_n51543424)
print v(xbgr.mr_n51543744)
print v(xbgr.mr_n51543856)
print v(xbgr.mr_n51544176)
print v(xbgr.mr_n51544288)
print v(xbgr.mr_n51544608)
print v(xbgr.mr_n51544720)
print v(xbgr.mr_n51545040)
print v(xbgr.mr_n51545152)
print v(xbgr.mr_n51545472)
print v(xbgr.mr_n51545584)
print v(xbgr.mr_n51545904)
print v(xbgr.mr_n51546016)
print v(xbgr.mr_n51546336)
print v(xbgr.mr_n51546448)
print v(xbgr.mr_n51546768)
print v(xbgr.mr_n51546880)
print v(xbgr.mr_n51547200)
print v(xbgr.mr_n51547312)
print v(xbgr.mr_n51547632)
print v(xbgr.mr_n51548064)
print v(xbgr.mr_n51548176)
print v(xbgr.mr_n51548496)
print v(xbgr.mr_n51548928)
print v(xbgr.mr_n51549040)
print v(xbgr.mr_n51549360)
print v(xbgr.mr_n51549792)
print v(xbgr.mr_n51549904)
print v(xbgr.mr_n51550224)
print v(xbgr.mr_n51550656)
print v(xbgr.mr_n51550768)
print v(xbgr.mr_n51551088)
print v(xbgr.mr_n51551200)
print v(xbgr.mr_n51551520)
print v(xbgr.mr_n51551632)
print v(xbgr.mr_n51551952)
print v(xbgr.mr_n51552064)
print v(xbgr.mr_n51552384)
print v(xbgr.mr_n51552816)
print v(xbgr.mr_n51552928)
print v(xbgr.mr_n51553248)
print v(xbgr.mr_n51553680)
print v(xbgr.mr_n51553792)
print v(xbgr.mr_n51554112)
print v(xbgr.mr_n51554544)
print v(xbgr.mr_n51554656)
print v(xbgr.mr_n51554976)
print v(xbgr.mr_n51555408)
print v(xbgr.mr_n51555520)
print v(xbgr.mr_n51555840)
print v(xbgr.mr_n51555952)
print v(xbgr.mr_n51556272)
print v(xbgr.mr_n51556384)
print v(xbgr.mr_n51556704)
print v(xbgr.mr_n51556816)
print v(xbgr.mr_n51557136)
print v(xbgr.mr_n51557248)
print v(xbgr.mr_n51557568)
print v(xbgr.mr_n51557680)
print v(xbgr.mr_n51558000)
print v(xbgr.mr_n51558112)
print v(xbgr.mr_n51558432)
print v(xbgr.mr_n51558544)
print v(xbgr.mr_n51558864)
print v(xbgr.mr_n51558976)
print v(xbgr.mr_n51559296)
print v(xbgr.mr_n51559408)
print v(xbgr.mr_n51559728)
print v(xbgr.mr_n51559840)
print v(xbgr.mr_n51560160)
print v(xbgr.mr_n51560272)
print v(xbgr.mr_n51560592)
print v(xbgr.mr_n51560704)
print v(xbgr.mr_n51561024)
print v(xbgr.mr_n51561136)
print v(xbgr.mr_n51561456)
print v(xbgr.mr_n51561568)
print v(xbgr.mr_n51561888)
print v(xbgr.mr_n51562000)
print v(xbgr.mr_n51562320)
print v(xbgr.mr_n51562432)
print v(xbgr.mr_n51562752)
print v(xbgr.mr_n51562864)
print v(xbgr.mr_n51563184)
print v(xbgr.mr_n51563296)
print v(xbgr.mr_n51563616)
print v(xbgr.mr_n51563728)
print v(xbgr.mr_n51564048)
print v(xbgr.mr_n51564160)
print v(xbgr.mr_n51564480)
print v(xbgr.mr_n51564592)
print v(xbgr.mr_n51564912)
print v(xbgr.mr_n51565024)
print v(xbgr.mr_n51565344)
print v(xbgr.mr_n51565456)
print v(xbgr.mr_n51565776)
print v(xbgr.mr_n51565888)
print v(xbgr.mr_n51566208)
print v(xbgr.mr_n51566320)
print v(xbgr.mr_n51566640)
print v(xbgr.mr_n51566752)
print v(xbgr.mr_n51567072)
print v(xbgr.mr_n51567184)
print v(xbgr.mr_n51567616)
print v(xbgr.mr_n51568048)
print v(xbgr.mr_n51568480)
print v(xbgr.mr_n51568912)
print v(xbgr.mr_n51569344)
print v(xbgr.mr_n51569776)
print v(xbgr.mr_n51570208)
print v(xbgr.mr_n51570640)
print v(xbgr.mr_n51571072)
print v(xbgr.mr_n51571504)
print v(xbgr.mr_n51571936)
print v(xbgr.mr_n51572368)
print v(xbgr.mr_n51572800)
print v(xbgr.mr_n51573232)
print v(xbgr.mr_n51573664)
print v(xbgr.mr_n51574096)
print v(xbgr.mr_n51574528)
print v(xbgr.mr_n51574960)
print v(xbgr.mr_n51575392)
print v(xbgr.mr_n51575824)
print v(xbgr.mr_n51576256)
print v(xbgr.mr_n51576688)
print v(xbgr.mr_n51577120)
print v(xbgr.mr_n51577552)
print v(xbgr.mr_n51577984)
print v(xbgr.mr_n51578416)
print v(xbgr.mr_n51578736)
print v(xbgr.mr_n51578848)
print v(xbgr.mr_n51579168)
print v(xbgr.mr_n51579280)
print v(xbgr.mr_n51579600)
print v(xbgr.mr_n51579712)
print v(xbgr.mr_n51580032)
print v(xbgr.mr_n51580144)
print v(xbgr.mr_n51580464)
print v(xbgr.mr_n51580576)
print v(xbgr.mr_n51580896)
print v(xbgr.mr_n51581008)
print v(xbgr.mr_n51581328)
print v(xbgr.mr_n51581440)
print v(xbgr.mr_n51581760)
print v(xbgr.mr_n51581872)
print v(xbgr.mr_n51582192)
print v(xbgr.mr_n51582304)
print v(xbgr.mr_n51582624)
print v(xbgr.mr_n51582736)
print v(xbgr.mr_n51583056)
print v(xbgr.mr_n51583168)
print v(xbgr.mr_n51583488)
print v(xbgr.mr_n51583600)
print v(xbgr.mr_n51583920)
print v(xbgr.mr_n51584032)
print v(xbgr.mr_n51584352)
print v(xbgr.mr_n51584464)
print v(xbgr.mr_n51584784)
print v(xbgr.mr_n51584896)
print v(xbgr.mr_n51585216)
print v(xbgr.mr_n51585328)
print v(xbgr.mr_n51585648)
print v(xbgr.mr_n51585760)
print v(xbgr.mr_n51586080)
print v(xbgr.mr_n51586192)
print v(xbgr.mr_n51586512)
print v(xbgr.mr_n51586624)
print v(xbgr.mr_n51586944)
print v(xbgr.mr_n51587056)
print v(xbgr.mr_n51587488)
print v(xbgr.mr_n51587920)
print v(xbgr.mr_n51588352)
print v(xbgr.mr_n51588784)
print v(xbgr.mr_n51589216)
print v(xbgr.mr_n51589648)
print v(xbgr.mr_n51590080)
print v(xbgr.mr_n51590512)
print v(xbgr.mr_n51590944)
print v(xbgr.mr_n51591376)
print v(xbgr.mr_n51591808)
print v(xbgr.mr_n51592240)
print v(xbgr.mr_n51592560)
print v(xbgr.mr_n51592672)
print v(xbgr.mr_n51592992)
print v(xbgr.mr_n51593104)
print v(xbgr.mr_n51593536)
print v(xbgr.mr_n51593968)
print v(xbgr.mr_n51594400)
print v(xbgr.mr_n51594832)
print v(xbgr.mr_n51595264)
print v(xbgr.mr_n51595696)
print v(xbgr.mr_n51596128)
print v(xbgr.mr_n51596560)
print v(xbgr.mr_n51596992)
print v(xbgr.mr_n51597424)
print v(xbgr.mr_n51597744)
print v(xbgr.mr_n51597856)
print v(xbgr.mr_n51598176)
print v(xbgr.mr_n51598288)
print v(xbgr.mr_n51598608)
print v(xbgr.mr_n51598720)
print v(xbgr.mr_n51599040)
print v(xbgr.mr_n51599152)
print v(xbgr.mr_n51599472)
print v(xbgr.mr_n51599584)
print v(xbgr.mr_n51599904)
print v(xbgr.mr_n51600016)
print v(xbgr.mr_n51600336)
print v(xbgr.mr_n51600448)
print v(xbgr.mr_n51600768)
print v(xbgr.mr_n51600880)
print v(xbgr.mr_n51601200)
print v(xbgr.mr_n51601312)
print v(xbgr.mr_n51601632)
print v(xbgr.mr_n51601744)
print v(xbgr.mr_n51602064)
print v(xbgr.mr_n51602176)
print v(xbgr.mr_n51602496)
print v(xbgr.mr_n51602608)
print v(xbgr.mr_n51602928)
print v(xbgr.mr_n51603040)
print v(xbgr.mr_n51603360)
print v(xbgr.mr_n51603472)
print v(xbgr.mr_n51603792)
print v(xbgr.mr_n51603904)
print v(xbgr.mr_n51604224)
print v(xbgr.mr_n51604336)
print v(xbgr.mr_n51604656)
print v(xbgr.mr_n51604768)
print v(xbgr.mr_n51605088)
print v(xbgr.mr_n51605200)
print v(xbgr.mr_n51605520)
print v(xbgr.mr_n51605632)
print v(xbgr.mr_n51605952)
print v(xbgr.mr_n51606064)
print v(xbgr.mr_n51606384)
print v(xbgr.mr_n51606496)
print v(xbgr.mr_n51606816)
print v(xbgr.mr_n51606928)
print v(xbgr.mr_n51607248)
print v(xbgr.mr_n51607360)
print v(xbgr.mr_n51607680)
print v(xbgr.mr_n51607792)
print v(xbgr.mr_n51608112)
print v(xbgr.mr_n51608224)
print v(xbgr.mr_n51608544)
print v(xbgr.mr_n51608656)
print v(xbgr.mr_n51608976)
print v(xbgr.mr_n51609408)
print v(xbgr.mr_n51609520)
print v(xbgr.mr_n51609840)
print v(xbgr.mr_n51610272)
print v(xbgr.mr_n51610384)
print v(xbgr.mr_n51610704)
print v(xbgr.mr_n51611136)
print v(xbgr.mr_n51611248)
print v(xbgr.mr_n51611568)
print v(xbgr.mr_n51612000)
print v(xbgr.mr_n51612112)
print v(xbgr.mr_n51612432)
print v(xbgr.mr_n51612864)
print v(xbgr.mr_n51612976)
print v(xbgr.mr_n51613296)
print v(xbgr.mr_n51613408)
print v(xbgr.mr_n51613728)
print v(xbgr.mr_n51613840)
print v(xbgr.mr_n51614160)
print v(xbgr.mr_n51614272)
print v(xbgr.mr_n51614592)
print v(xbgr.mr_n51614704)
print v(xbgr.mr_n51615024)
print v(xbgr.mr_n51615136)
print v(xbgr.mr_n51615456)
print v(xbgr.mr_n51615568)
print v(xbgr.mr_n51615888)
print v(xbgr.mr_n51616000)
print v(xbgr.mr_n51616320)
print v(xbgr.mr_n51616432)
print v(xbgr.mr_n51616752)
print v(xbgr.mr_n51616864)
print v(xbgr.mr_n51617184)
print v(xbgr.mr_n51617296)
print v(xbgr.mr_n51617616)
print v(xbgr.mr_n51617728)
print v(xbgr.mr_n51618048)
print v(xbgr.mr_n51618160)
print v(xbgr.mr_n51618480)
print v(xbgr.mr_n51618592)
print v(xbgr.mr_n51618912)
print v(xbgr.mr_n51619024)
print v(xbgr.mr_n51619344)
print v(xbgr.mr_n51619456)
print v(xbgr.mr_n51619776)
print v(xbgr.mr_n51619888)
print v(xbgr.mr_n51620208)
print v(xbgr.mr_n51620320)
print v(xbgr.mr_n51620640)
print v(xbgr.mr_n51620752)
print v(xbgr.mr_n51621072)
print v(xbgr.mr_n51621184)
print v(xbgr.mr_n51621504)
print v(xbgr.mr_n51621616)
print v(xbgr.mr_n51621936)
print v(xbgr.mr_n51622048)
print v(xbgr.mr_n51622368)
print v(xbgr.mr_n51622480)
print v(xbgr.mr_n51622800)
print v(xbgr.mr_n51622912)
print v(xbgr.mr_n51623232)
print v(xbgr.mr_n51623344)
print v(xbgr.mr_n51623664)
print v(xbgr.mr_n51623776)
print v(xbgr.mr_n51624096)
print v(xbgr.mr_n51624208)
print v(xbgr.mr_n51624528)
print v(xbgr.mr_n51624640)
print v(xbgr.mr_n51624960)
print v(xbgr.mr_n51625072)
print v(xbgr.mr_n51625392)
print v(xbgr.mr_n51625504)
print v(xbgr.mr_n51625824)
print v(xbgr.mr_n51625936)
print v(xbgr.mr_n51626256)
print v(xbgr.mr_n51626368)
print v(xbgr.mr_n51626688)
print v(xbgr.mr_n51626800)
print v(xbgr.mr_n51627120)
print v(xbgr.mr_n51627232)
print v(xbgr.mr_n51627552)
print v(xbgr.mr_n51627664)
print v(xbgr.mr_n51627984)
print v(xbgr.mr_n51628096)
print v(xbgr.mr_n51628416)
print v(xbgr.mr_n51628528)
print v(xbgr.mr_n51628848)
print v(xbgr.mr_n51628960)
print v(xbgr.mr_n51629280)
print v(xbgr.mr_n51629392)
print v(xbgr.mr_n51629712)
print v(xbgr.mr_n51629824)
print v(xbgr.mr_n51630144)
print v(xbgr.mr_n51630256)
print v(xbgr.mr_n51630576)
print v(xbgr.mr_n51630688)
print v(xbgr.mr_n51631008)
print v(xbgr.mr_n51631120)
print v(xbgr.mr_n51631440)
print v(xbgr.mr_n51631872)
print v(xbgr.mr_n51631984)
print v(xbgr.mr_n51632304)
print v(xbgr.mr_n51632416)
print v(xbgr.mr_n51632736)
print v(xbgr.mr_n51632848)
print v(xbgr.mr_n51633168)
print v(xbgr.mr_n51633600)
print v(xbgr.mr_n51633712)
print v(xbgr.mr_n51634032)
print v(xbgr.mr_n51634464)
print v(xbgr.mr_n51634576)
print v(xbgr.mr_n51634896)
print v(xbgr.mr_n51635008)
print v(xbgr.mr_n51635328)
print v(xbgr.mr_n51635440)
print v(xbgr.mr_n51635760)
print v(xbgr.mr_n51635872)
print v(xbgr.mr_n51636192)
print v(xbgr.mr_n51636304)
print v(xbgr.mr_n51636624)
print v(xbgr.mr_n51636736)
print v(xbgr.mr_n51637056)
print v(xbgr.mr_n51637168)
print v(xbgr.mr_n51637488)
print v(xbgr.mr_n51637600)
print v(xbgr.mr_n51637920)
print v(xbgr.mr_n51638032)
print v(xbgr.mr_n51638352)
print v(xbgr.mr_n51638464)
print v(xbgr.mr_n51638784)
print v(xbgr.mr_n51638896)
print v(xbgr.mr_n51639216)
print v(xbgr.mr_n51639328)
print v(xbgr.mr_n51639648)
print v(xbgr.mr_n51639760)
print v(xbgr.mr_n51640080)
print v(xbgr.mr_n51640512)
print v(xbgr.mr_n51640624)
print v(xbgr.mr_n51640944)
print v(xbgr.mr_n51641056)
print v(xbgr.mr_n51641376)
print v(xbgr.mr_n51641488)
print v(xbgr.mr_n51641808)
print v(xbgr.mr_n51641920)
print v(xbgr.mr_n51642240)
print v(xbgr.mr_n51642352)
print v(xbgr.mr_n51642672)
print v(xbgr.mr_n51642784)
print v(xbgr.mr_n51643104)
print v(xbgr.mr_n51643216)
print v(xbgr.mr_n51643536)
print v(xbgr.mr_n51643648)
print v(xbgr.mr_n51643968)
print v(xbgr.mr_n51644080)
print v(xbgr.mr_n51644400)
print v(xbgr.mr_n51644512)
print v(xbgr.mr_n51644832)
print v(xbgr.mr_n51644944)
print v(xbgr.mr_n51645264)
print v(xbgr.mr_n51645376)
print v(xbgr.mr_n51645696)
print v(xbgr.mr_n51645808)
print v(xbgr.mr_n51646128)
print v(xbgr.mr_n51646240)
print v(xbgr.mr_n51646560)
print v(xbgr.mr_n51646672)
print v(xbgr.mr_n51646992)
print v(xbgr.mr_n51647104)
print v(xbgr.mr_n51647424)
print v(xbgr.mr_n51647536)
print v(xbgr.mr_n51647856)
print v(xbgr.mr_n51647968)
print v(xbgr.mr_n51648288)
print v(xbgr.mr_n51648400)
print v(xbgr.mr_n51648720)
print v(xbgr.mr_n51648832)
print v(xbgr.mr_n51649152)
print v(xbgr.mr_n51649264)
print v(xbgr.mr_n51649584)
print v(xbgr.mr_n51649696)
print v(xbgr.mr_n51650016)
print v(xbgr.mr_n51650128)
print v(xbgr.mr_n51650448)
print v(xbgr.mr_n51650560)
print v(xbgr.mr_n51650880)
print v(xbgr.mr_n51650992)
print v(xbgr.mr_n51651312)
print v(xbgr.mr_n51651424)
print v(xbgr.mr_n51651744)
print v(xbgr.mr_n51651856)
print v(xbgr.mr_n51652176)
print v(xbgr.mr_n51652288)
print v(xbgr.mr_n51652608)
print v(xbgr.mr_n51652720)
print v(xbgr.mr_n51653040)
print v(xbgr.mr_n51653152)
print v(xbgr.mr_n51653472)
print v(xbgr.mr_n51653584)
print v(xbgr.mr_n51653904)
print v(xbgr.mr_n51654016)
print v(xbgr.mr_n51654336)
print v(xbgr.mr_n51654448)
print v(xbgr.mr_n51654768)
print v(xbgr.mr_n51654880)
print v(xbgr.mr_n51655200)
print v(xbgr.mr_n51655312)
print v(xbgr.mr_n51655632)
print v(xbgr.mr_n51655744)
print v(xbgr.mr_n51656064)
print v(xbgr.mr_n51656176)
print v(xbgr.mr_n51656496)
print v(xbgr.mr_n51656608)
print v(xbgr.mr_n51656928)
print v(xbgr.mr_n51657040)
print v(xbgr.mr_n51657360)
print v(xbgr.mr_n51657472)
print v(xbgr.mr_n51657792)
print v(xbgr.mr_n51657904)
print v(xbgr.mr_n51658224)
print v(xbgr.mr_n51658336)
print v(xbgr.mr_n51658656)
print v(xbgr.mr_n51658768)
print v(xbgr.mr_n51659088)
print v(xbgr.mr_n51659200)
print v(xbgr.mr_n51659520)
print v(xbgr.mr_n51659632)
print v(xbgr.mr_n51659952)
print v(xbgr.mr_n51660064)
print v(xbgr.mr_n51660384)
print v(xbgr.mr_n51660496)
print v(xbgr.mr_n51660816)
print v(xbgr.mr_n51660928)
print v(xbgr.mr_n51661248)
print v(xbgr.mr_n51661360)
print v(xbgr.mr_n51661680)
print v(xbgr.mr_n51661792)
print v(xbgr.mr_n51662224)
print v(xbgr.mr_n51662656)
print v(xbgr.mr_n51663088)
print v(xbgr.mr_n51663520)
print v(xbgr.mr_n51663952)
print v(xbgr.mr_n51664384)
print v(xbgr.mr_n51664816)
print v(xbgr.mr_n51665248)
print v(xbgr.mr_n51665568)
print v(xbgr.mr_n51665680)
print v(xbgr.mr_n51666000)
print v(xbgr.mr_n51666112)
print v(xbgr.mr_n51666432)
print v(xbgr.mr_n51666544)
print v(xbgr.mr_n51666864)
print v(xbgr.mr_n51666976)
print v(xbgr.mr_n51667296)
print v(xbgr.mr_n51667408)
print v(xbgr.mr_n51667728)
print v(xbgr.mr_n51667840)
print v(xbgr.mr_n51668160)
print v(xbgr.mr_n51668272)
print v(xbgr.mr_n51668592)
print v(xbgr.mr_n51668704)
print v(xbgr.mr_n51669136)
print v(xbgr.mr_n51669568)
print v(xbgr.mr_n51670000)
print v(xbgr.mr_n51670432)
print v(xbgr.mr_n51670864)
print v(xbgr.mr_n51671296)
print v(xbgr.mr_n51671616)
print v(xbgr.mr_n51671728)
print v(xbgr.mr_n51672160)
print v(xbgr.mr_n51672592)
print v(xbgr.mr_n51673024)
print v(xbgr.mr_n51673456)
print v(xbgr.mr_n51673888)
print v(xbgr.mr_n51674320)
print v(xbgr.mr_n51674752)
print v(xbgr.mr_n51675184)
print v(xbgr.mr_n51675616)
print v(xbgr.mr_n51676048)
print v(xbgr.mr_n51676480)
print v(xbgr.mr_n51676912)
print v(xbgr.mr_n51677232)
print v(xbgr.mr_n51677344)
print v(xbgr.mr_n51677664)
print v(xbgr.mr_n51677776)
print v(xbgr.mr_n51678096)
print v(xbgr.mr_n51678208)
print v(xbgr.mr_n51678528)
print v(xbgr.mr_n51678640)
print v(xbgr.mr_n51678960)
print v(xbgr.mr_n51679072)
print v(xbgr.mr_n51679392)
print v(xbgr.mr_n51679504)
print v(xbgr.mr_n51679824)
print v(xbgr.mr_n51679936)
print v(xbgr.mr_n51680256)
print v(xbgr.mr_n51680368)
print v(xbgr.mr_n51680688)
print v(xbgr.mr_n51680800)
print v(xbgr.mr_n51681120)
print v(xbgr.mr_n51681232)
print v(xbgr.mr_n51681552)
print v(xbgr.mr_n51681664)
print v(xbgr.mr_n51681984)
print v(xbgr.mr_n51682096)
print v(xbgr.mr_n51682416)
print v(xbgr.mr_n51682528)
print v(xbgr.mr_n51682848)
print v(xbgr.mr_n51682960)
print v(xbgr.mr_n51683280)
print v(xbgr.mr_n51683392)
print v(xbgr.mr_n51683712)
print v(xbgr.mr_n51683824)
print v(xbgr.mr_n51684144)
print v(xbgr.mr_n51684256)
print v(xbgr.mr_n51684576)
print v(xbgr.mr_n51684688)
print v(xbgr.mr_n51685008)
print v(xbgr.mr_n51685120)
print v(xbgr.mr_n51685440)
print v(xbgr.mr_n51685552)
print v(xbgr.mr_n51685872)
print v(xbgr.mr_n51685984)
print v(xbgr.mr_n51686416)
print v(xbgr.mr_n51686848)
print v(xbgr.mr_n51687280)
print v(xbgr.mr_n51687712)
print v(xbgr.mr_n51688144)
print v(xbgr.mr_n51688576)
print v(xbgr.mr_n51689008)
print v(xbgr.mr_n51689440)
print v(xbgr.mr_n51689872)
print v(xbgr.mr_n51690304)
print v(xbgr.mr_n51690736)
print v(xbgr.mr_n51691168)
print v(xbgr.mr_n51691600)
print v(xbgr.mr_n51692032)
print v(xbgr.mr_n51692464)
print v(xbgr.mr_n51692896)
print v(xbgr.mr_n51693328)
print v(xbgr.mr_n51693760)
print v(xbgr.mr_n51694192)
print v(xbgr.mr_n51694512)
print v(xbgr.mr_n51694624)
print v(xbgr.mr_n51694944)
print v(xbgr.mr_n51695056)
print v(xbgr.mr_n51695376)
print v(xbgr.mr_n51695488)
print v(xbgr.mr_n51695808)
print v(xbgr.mr_n51695920)
print v(xbgr.mr_n51696240)
print v(xbgr.mr_n51696352)
print v(xbgr.mr_n51696784)
print v(xbgr.mr_n51697216)
print v(xbgr.mr_n51697648)
print v(xbgr.mr_n51698080)
print v(xbgr.mr_n51698512)
print v(xbgr.mr_n51698944)
print v(xbgr.mr_n51699376)
print v(xbgr.mr_n51699696)
print v(xbgr.mr_n51699808)
print v(xbgr.mr_n51700128)
print v(xbgr.mr_n51700240)
print v(xbgr.mr_n51700560)
print v(xbgr.mr_n51700672)
print v(xbgr.mr_n51700992)
print v(xbgr.mr_n51701104)
print v(xbgr.mr_n51701424)
print v(xbgr.mr_n51701536)
print v(xbgr.mr_n51701856)
print v(xbgr.mr_n51701968)
print v(xbgr.mr_n51702288)
print v(xbgr.mr_n51702400)
print v(xbgr.mr_n51702720)
print v(xbgr.mr_n51702832)
print v(xbgr.mr_n51703152)
print v(xbgr.mr_n51703264)
print v(xbgr.mr_n51703584)
print v(xbgr.mr_n51703696)
print v(xbgr.mr_n51704016)
print v(xbgr.mr_n51704128)
print v(xbgr.mr_n51704448)
print v(xbgr.mr_n51704560)
print v(xbgr.mr_n51704880)
print v(xbgr.mr_n51704992)
print v(xbgr.mr_n51705424)
print v(xbgr.mr_n51705856)
print v(xbgr.mr_n51706288)
print v(xbgr.mr_n51706720)
print v(xbgr.mr_n51707152)
print v(xbgr.mr_n51707584)
print v(xbgr.mr_n51708016)
print v(xbgr.mr_n51708448)
print v(xbgr.mr_n51708880)
print v(xbgr.mr_n51709312)
print v(xbgr.mr_n51709744)
print v(xbgr.mr_n51710176)
print v(xbgr.mr_n51710608)
print v(xbgr.mr_n51710928)
print v(xbgr.mr_n51711040)
print v(xbgr.mr_n51711360)
print v(xbgr.mr_n51711472)
print v(xbgr.mr_n51711792)
print v(xbgr.mr_n51711904)
print v(xbgr.mr_n51712224)
print v(xbgr.mr_n51712336)
print v(xbgr.mr_n51712656)
print v(xbgr.mr_n51712768)
print v(xbgr.mr_n51713088)
print v(xbgr.mr_n51713200)
print v(xbgr.mr_n51713520)
print v(xbgr.mr_n51713632)
print v(xbgr.mr_n51713952)
print v(xbgr.mr_n51714064)
print v(xbgr.mr_n51714384)
print v(xbgr.mr_n51714496)
print v(xbgr.mr_n51714816)
print v(xbgr.mr_n51714928)
print v(xbgr.mr_n51715248)
print v(xbgr.mr_n51715360)
print v(xbgr.mr_n51715680)
print v(xbgr.mr_n51715792)
print v(xbgr.mr_n51716224)
print v(xbgr.mr_n51716656)
print v(xbgr.mr_n51717088)
print v(xbgr.mr_n51717520)
print v(xbgr.mr_n51717952)
print v(xbgr.mr_n51718384)
print v(xbgr.mr_n51718816)
print v(xbgr.mr_n51719248)
print v(xbgr.mr_n51719680)
print v(xbgr.mr_n51720112)
print v(xbgr.mr_n51720544)
print v(xbgr.mr_n51720976)
print v(xbgr.mr_n51721296)
print v(xbgr.mr_n51721408)
print v(xbgr.mr_n51721840)
print v(xbgr.mr_n51722160)
print v(xbgr.mr_n51722272)
print v(xbgr.mr_n51722592)
print v(xbgr.mr_n51722704)
print v(xbgr.mr_n51723024)
print v(xbgr.mr_n51723136)
print v(xbgr.mr_n51723456)
print v(xbgr.mr_n51723568)
print v(xbgr.mr_n51723888)
print v(xbgr.mr_n51724000)
print v(xbgr.mr_n51724432)
print v(xbgr.mr_n51724864)
print v(xbgr.mr_n51725184)
print v(xbgr.mr_n51725296)
print v(xbgr.mr_n51725616)
print v(xbgr.mr_n51725728)
print v(xbgr.mr_n51726048)
print v(xbgr.mr_n51726160)
print v(xbgr.mr_n51726480)
print v(xbgr.mr_n51726592)
print v(xbgr.mr_n51726912)
print v(xbgr.mr_n51727024)
print v(xbgr.mr_n51727344)
print v(xbgr.mr_n51727456)
print v(xbgr.mr_n51727776)
print v(xbgr.mr_n51727888)
print v(xbgr.mr_n51728208)
print v(xbgr.mr_n51728320)
print v(xbgr.mr_n51728752)
print v(xbgr.mr_n51729184)
print v(xbgr.mr_n51729616)
print v(xbgr.mr_n51730048)
print v(xbgr.mr_n51730480)
print v(xbgr.mr_n51730912)
print v(xbgr.mr_n51731344)
print v(xbgr.mr_n51731776)
print v(xbgr.mr_n51732208)
print v(xbgr.mr_n51732640)
print v(xbgr.mr_n51733072)
print v(xbgr.mr_n51733392)
print v(xbgr.mr_n51733504)
print v(xbgr.mr_n51733824)
print v(xbgr.mr_n51733936)
print v(xbgr.mr_n51734256)
print v(xbgr.mr_n51734368)
print v(xbgr.mr_n51734800)
print v(xbgr.mr_n51735232)
print v(xbgr.mr_n51735552)
print v(xbgr.mr_n51735664)
print v(xbgr.mr_n51735984)
print v(xbgr.mr_n51736096)
print v(xbgr.mr_n51736416)
print v(xbgr.mr_n51736528)
print v(xbgr.mr_n51736848)
print v(xbgr.mr_n51736960)
print v(xbgr.mr_n51737392)
print v(xbgr.mr_n51737712)
print v(xbgr.mr_n51737824)
print v(xbgr.mr_n51738144)
print v(xbgr.mr_n51738256)
print v(xbgr.mr_n51738576)
print v(xbgr.mr_n51738688)
print v(xbgr.mr_n51739008)
print v(xbgr.mr_n51739120)
print v(xbgr.mr_n51739440)
print v(xbgr.mr_n51739552)
print v(xbgr.mr_n51739872)
print v(xbgr.mr_n51739984)
print v(xbgr.mr_n51740416)
print v(xbgr.mr_n51740848)
print v(xbgr.mr_n51741280)
print v(xbgr.mr_n51741712)
print v(xbgr.mr_n51742144)
print v(xbgr.mr_n51742576)
print v(xbgr.mr_n51743008)
print v(xbgr.mr_n51743440)
print v(xbgr.mr_n51743872)
print v(xbgr.mr_n51744304)
print v(xbgr.mr_n51744624)
print v(xbgr.mr_n51744736)
print v(xbgr.mr_n51745056)
print v(xbgr.mr_n51745168)
print v(xbgr.mr_n51745488)
print v(xbgr.mr_n51745600)
print v(xbgr.mr_n51745920)
print v(xbgr.mr_n51746032)
print v(xbgr.mr_n51746352)
print v(xbgr.mr_n51746464)
print v(xbgr.mr_n51746784)
print v(xbgr.mr_n51746896)
print v(xbgr.mr_n51747216)
print v(xbgr.mr_n51747328)
print v(xbgr.mr_n51747648)
print v(xbgr.mr_n51747760)
print v(xbgr.mr_n51748080)
print v(xbgr.mr_n51748192)
print v(xbgr.mr_n51748512)
print v(xbgr.mr_n51748624)
print v(xbgr.mr_n51748944)
print v(xbgr.mr_n51749056)
print v(xbgr.mr_n51749376)
print v(xbgr.mr_n51749488)
print v(xbgr.mr_n51749808)
print v(xbgr.mr_n51749920)
print v(xbgr.mr_n51750352)
print v(xbgr.mr_n51750784)
print v(xbgr.mr_n51751216)
print v(xbgr.mr_n51751648)
print v(xbgr.mr_n51752080)
print v(xbgr.mr_n51752512)
print v(xbgr.mr_n51752944)
print v(xbgr.mr_n51753376)
print v(xbgr.mr_n51753808)
print v(xbgr.mr_n51754240)
print v(xbgr.mr_n51754672)
print v(xbgr.mr_n51755104)
print v(xbgr.mr_n51755536)
print v(xbgr.mr_n51755856)
print v(xbgr.mr_n51755968)
print v(xbgr.mr_n51756288)
print v(xbgr.mr_n51756400)
print v(xbgr.mr_n51756720)
print v(xbgr.mr_n51756832)
print v(xbgr.mr_n51757152)
print v(xbgr.mr_n51757264)
print v(xbgr.mr_n51757584)
print v(xbgr.mr_n51757696)
print v(xbgr.mr_n51758016)
print v(xbgr.mr_n51758128)
print v(xbgr.mr_n51758448)
print v(xbgr.mr_n51758560)
print v(xbgr.mr_n51758880)
print v(xbgr.mr_n51758992)
print v(xbgr.mr_n51759312)
print v(xbgr.mr_n51759424)
print v(xbgr.mr_n51759744)
print v(xbgr.mr_n51759856)
print v(xbgr.mr_n51760176)
print v(xbgr.mr_n51760288)
print v(xbgr.mr_n51760608)
print v(xbgr.mr_n51760720)
print v(xbgr.mr_n51761040)
print v(xbgr.mr_n51761152)
print v(xbgr.mr_n51761584)
print v(xbgr.mr_n51762016)
print v(xbgr.mr_n51762448)
print v(xbgr.mr_n51762880)
print v(xbgr.mr_n51763312)
print v(xbgr.mr_n51763744)
print v(xbgr.mr_n51764176)
print v(xbgr.mr_n51764608)
print v(xbgr.mr_n51765040)
print v(xbgr.mr_n51765472)
print v(xbgr.mr_n51765904)
print v(xbgr.mr_n51766336)
print v(xbgr.mr_n51766768)
print v(xbgr.mr_n51767088)
print v(xbgr.mr_n51767200)
print v(xbgr.mr_n51767520)
print v(xbgr.mr_n51767632)
print v(xbgr.mr_n51767952)
print v(xbgr.mr_n51768064)
print v(xbgr.mr_n51768384)
print v(xbgr.mr_n51768496)
print v(xbgr.mr_n51768816)
print v(xbgr.mr_n51768928)
print v(xbgr.mr_n51769248)
print v(xbgr.mr_n51769360)
print v(xbgr.mr_n51769680)
print v(xbgr.mr_n51769792)
print v(xbgr.mr_n51770112)
print v(xbgr.mr_n51770224)
print v(xbgr.mr_n51770544)
print v(xbgr.mr_n51770656)
print v(xbgr.mr_n51770976)
print v(xbgr.mr_n51771088)
print v(xbgr.mr_n51771408)
print v(xbgr.mr_n51771520)
print v(xbgr.mr_n51771840)
print v(xbgr.mr_n51771952)
print v(xbgr.mr_n51772272)
print v(xbgr.mr_n51772384)
print v(xbgr.mr_n51772816)
print v(xbgr.mr_n51773248)
print v(xbgr.mr_n51773680)
print v(xbgr.mr_n51774112)
print v(xbgr.mr_n51774544)
print v(xbgr.mr_n51774976)
print v(xbgr.mr_n51775408)
print v(xbgr.mr_n51775840)
print v(xbgr.mr_n51776272)
print v(xbgr.mr_n51776704)
print v(xbgr.mr_n51777136)
print v(xbgr.mr_n51777568)
print v(xbgr.mr_n51778000)
print v(xbgr.mr_n51778320)
print v(xbgr.mr_n51778432)
print v(xbgr.mr_n51778752)
print v(xbgr.mr_n51778864)
print v(xbgr.mr_n51779296)
print v(xbgr.mr_n51779616)
print v(xbgr.mr_n51779728)
print v(xbgr.mr_n51780048)
print v(xbgr.mr_n51780160)
print v(xbgr.mr_n51780480)
print v(xbgr.mr_n51780592)
print v(xbgr.mr_n51780912)
print v(xbgr.mr_n51781024)
print v(xbgr.mr_n51781456)
print v(xbgr.mr_n51781888)
print v(xbgr.mr_n51782320)
print v(xbgr.mr_n51782752)
print v(xbgr.mr_n51783072)
print v(xbgr.mr_n51783184)
print v(xbgr.mr_n51783504)
print v(xbgr.mr_n51783616)
print v(xbgr.mr_n51784048)
print v(xbgr.mr_n51784480)
print v(xbgr.mr_n51784800)
print v(xbgr.mr_n51784912)
print v(xbgr.mr_n51785232)
print v(xbgr.mr_n51785344)
print v(xbgr.mr_n51785664)
print v(xbgr.mr_n51785776)
print v(xbgr.mr_n51786096)
print v(xbgr.mr_n51786208)
print v(xbgr.mr_n51786528)
print v(xbgr.mr_n51786640)
print v(xbgr.mr_n51787072)
print v(xbgr.mr_n51787504)
print v(xbgr.mr_n51787936)
print v(xbgr.mr_n51788368)
print v(xbgr.mr_n51788800)
print v(xbgr.mr_n51789232)
print v(xbgr.mr_n51789552)
print v(xbgr.mr_n51789664)
print v(xbgr.mr_n51789984)
print v(xbgr.mr_n51790096)
print v(xbgr.mr_n51790416)
print v(xbgr.mr_n51790528)
print v(xbgr.mr_n51790848)
print v(xbgr.mr_n51790960)
print v(xbgr.mr_n51791280)
print v(xbgr.mr_n51791392)
print v(xbgr.mr_n51791712)
print v(xbgr.mr_n51791824)
print v(xbgr.mr_n51792144)
print v(xbgr.mr_n51792256)
print v(xbgr.mr_n51792576)
print v(xbgr.mr_n51792688)
print v(xbgr.mr_n51793008)
print v(xbgr.mr_n51793120)
print v(xbgr.mr_n51793440)
print v(xbgr.mr_n51793552)
print v(xbgr.mr_n51793872)
print v(xbgr.mr_n51793984)
print v(xbgr.mr_n51794304)
print v(xbgr.mr_n51794416)
print v(xbgr.mr_n51794848)
print v(xbgr.mr_n51795280)
print v(xbgr.mr_n51795712)
print v(xbgr.mr_n51796144)
print v(xbgr.mr_n51796576)
print v(xbgr.mr_n51797008)
print v(xbgr.mr_n51797440)
print v(xbgr.mr_n51797872)
print v(xbgr.mr_n51798192)
print v(xbgr.mr_n51798304)
print v(xbgr.mr_n51798624)
print v(xbgr.mr_n51798736)
print v(xbgr.mr_n51799056)
print v(xbgr.mr_n51799168)
print v(xbgr.mr_n51799488)
print v(xbgr.mr_n51799600)
print v(xbgr.mr_n51799920)
print v(xbgr.mr_n51800032)
print v(xbgr.mr_n51800352)
print v(xbgr.mr_n51800464)
print v(xbgr.mr_n51800784)
print v(xbgr.mr_n51800896)
print v(xbgr.mr_n51801216)
print v(xbgr.mr_n51801328)
print v(xbgr.mr_n51801760)
print v(xbgr.mr_n51802192)
print v(xbgr.mr_n51802512)
print v(xbgr.mr_n51802624)
print v(xbgr.mr_n51802944)
print v(xbgr.mr_n51803056)
print v(xbgr.mr_n51803376)
print v(xbgr.mr_n51803488)
print v(xbgr.mr_n51803808)
print v(xbgr.mr_n51803920)
print v(xbgr.mr_n51804240)
print v(xbgr.mr_n51804352)
print v(xbgr.mr_n51804672)
print v(xbgr.mr_n51804784)
print v(xbgr.mr_n51805216)
print v(xbgr.mr_n51805648)
print v(xbgr.mr_n51806080)
print v(xbgr.mr_n51806512)
print v(xbgr.mr_n51806944)
print v(xbgr.mr_n51807376)
print v(xbgr.mr_n51807808)
print v(xbgr.mr_n51808240)
print v(xbgr.mr_n51808672)
print v(xbgr.mr_n51809104)
print v(xbgr.mr_n51809536)
print v(xbgr.mr_n51809968)
print v(xbgr.mr_n51810400)
print v(xbgr.mr_n51810832)
print v(xbgr.mr_n51811264)
print v(xbgr.mr_n51811696)
print v(xbgr.mr_n51812016)
print v(xbgr.mr_n51812128)
print v(xbgr.mr_n51812448)
print v(xbgr.mr_n51812560)
print v(xbgr.mr_n51812880)
print v(xbgr.mr_n51812992)
print v(xbgr.mr_n51813312)
print v(xbgr.mr_n51813424)
print v(xbgr.mr_n51813744)
print v(xbgr.mr_n51813856)
print v(xbgr.mr_n51814176)
print v(xbgr.mr_n51814288)
print v(xbgr.mr_n51814608)
print v(xbgr.mr_n51814720)
print v(xbgr.mr_n51815040)
print v(xbgr.mr_n51815152)
print v(xbgr.mr_n51815472)
print v(xbgr.mr_n51815584)
print v(xbgr.mr_n51815904)
print v(xbgr.mr_n51816016)
print v(xbgr.mr_n51816336)
print v(xbgr.mr_n51816448)
print v(xbgr.mr_n51816768)
print v(xbgr.mr_n51816880)
print v(xbgr.mr_n51817200)
print v(xbgr.mr_n51817312)
print v(xbgr.mr_n51817632)
print v(xbgr.mr_n51817744)
print v(xbgr.mr_n51818064)
print v(xbgr.mr_n51818176)
print v(xbgr.mr_n51818496)
print v(xbgr.mr_n51818608)
print v(xbgr.mr_n51818928)
print v(xbgr.mr_n51819040)
print v(xbgr.mr_n51819360)
print v(xbgr.mr_n51819472)
print v(xbgr.mr_n51819792)
print v(xbgr.mr_n51819904)
print v(xbgr.mr_n51820224)
print v(xbgr.mr_n51820336)
print v(xbgr.mr_n51820768)
print v(xbgr.mr_n51821200)
print v(xbgr.mr_n51821632)
print v(xbgr.mr_n51822064)
print v(xbgr.mr_n51822496)
print v(xbgr.mr_n51822928)
print v(xbgr.mr_n51823248)
print v(xbgr.mr_n51823360)
print v(xbgr.mr_n51823680)
print v(xbgr.mr_n51823792)
print v(xbgr.mr_n51824112)
print v(xbgr.mr_n51824224)
print v(xbgr.mr_n51824544)
print v(xbgr.mr_n51824656)
print v(xbgr.mr_n51824976)
print v(xbgr.mr_n51825088)
print v(xbgr.mr_n51825408)
print v(xbgr.mr_n51825520)
print v(xbgr.mr_n51825952)
print v(xbgr.mr_n51826384)
print v(xbgr.mr_n51826816)
print v(xbgr.mr_n51827248)
print v(xbgr.mr_n51827680)
print v(xbgr.mr_n51828112)
print v(xbgr.mr_n51828544)
print v(xbgr.mr_n51828976)
print v(xbgr.mr_n51829408)
print v(xbgr.mr_n51829840)
print v(xbgr.mr_n51830272)
print v(xbgr.mr_n51830704)
print v(xbgr.mr_n51831136)
print v(xbgr.mr_n51831568)
print v(xbgr.mr_n51832000)
print v(xbgr.mr_n51832432)
print v(xbgr.mr_n51832864)
print v(xbgr.mr_n51833296)
print v(xbgr.mr_n51833728)
print v(xbgr.mr_n51834160)
print v(xbgr.mr_n51834480)
print v(xbgr.mr_n51834592)
print v(xbgr.mr_n51834912)
print v(xbgr.mr_n51835024)
print v(xbgr.mr_n51835344)
print v(xbgr.mr_n51835456)
print v(xbgr.mr_n51835776)
print v(xbgr.mr_n51835888)
print v(xbgr.mr_n51836208)
print v(xbgr.mr_n51836320)
print v(xbgr.mr_n51836640)
print v(xbgr.mr_n51836752)
print v(xbgr.mr_n51837072)
print v(xbgr.mr_n51837184)
print v(xbgr.mr_n51837504)
print v(xbgr.mr_n51837616)
print v(xbgr.mr_n51837936)
print v(xbgr.mr_n51838048)
print v(xbgr.mr_n51838368)
print v(xbgr.mr_n51838480)
print v(xbgr.mr_n51838800)
print v(xbgr.mr_n51838912)
print v(xbgr.mr_n51839232)
print v(xbgr.mr_n51839344)
print v(xbgr.mr_n51839664)
print v(xbgr.mr_n51839776)
print v(xbgr.mr_n51840096)
print v(xbgr.mr_n51840208)
print v(xbgr.mr_n51840528)
print v(xbgr.mr_n51840640)
print v(xbgr.mr_n51840960)
print v(xbgr.mr_n51841072)
print v(xbgr.mr_n51841392)
print v(xbgr.mr_n51841504)
print v(xbgr.mr_n51841824)
print v(xbgr.mr_n51841936)
print v(xbgr.mr_n51842256)
print v(xbgr.mr_n51842368)
print v(xbgr.mr_n51842688)
print v(xbgr.mr_n51842800)
print v(xbgr.mr_n51843120)
print v(xbgr.mr_n51843232)
print v(xbgr.mr_n51843552)
print v(xbgr.mr_n51843664)
print v(xbgr.mr_n51843984)
print v(xbgr.mr_n51844096)
print v(xbgr.mr_n51844416)
print v(xbgr.mr_n51844528)
print v(xbgr.mr_n51844848)
print v(xbgr.mr_n51844960)
print v(xbgr.mr_n51845280)
print v(xbgr.mr_n51845392)
print v(xbgr.mr_n51845712)
print v(xbgr.mr_n51845824)
print v(xbgr.mr_n51846144)
print v(xbgr.mr_n51846256)
print v(xbgr.mr_n51846576)
print v(xbgr.mr_n51846688)
print v(xbgr.mr_n51847008)
print v(xbgr.mr_n51847120)
print v(xbgr.mr_n51847440)
print v(xbgr.mr_n51847552)
print v(xbgr.mr_n51847872)
print v(xbgr.mr_n51847984)
print v(xbgr.mr_n51848416)
print v(xbgr.mr_n51848848)
print v(xbgr.mr_n51849168)
print v(xbgr.mr_n51849280)
print v(xbgr.mr_n51849600)
print v(xbgr.mr_n51849712)
print v(xbgr.mr_n51850032)
print v(xbgr.mr_n51850144)
print v(xbgr.mr_n51850464)
print v(xbgr.mr_n51850576)
print v(xbgr.mr_n51850896)
print v(xbgr.mr_n51851008)
print v(xbgr.mr_n51851328)
print v(xbgr.mr_n51851440)
print v(xbgr.mr_n51851760)
print v(xbgr.mr_n51851872)
print v(xbgr.mr_n51852192)
print v(xbgr.mr_n51852304)
print v(xbgr.mr_n51852624)
print v(xbgr.mr_n51852736)
print v(xbgr.mr_n51853056)
print v(xbgr.mr_n51853168)
print v(xbgr.mr_n51853600)
print v(xbgr.mr_n51854032)
print v(xbgr.mr_n51854464)
print v(xbgr.mr_n51854784)
print v(xbgr.mr_n51854896)
print v(xbgr.mr_n51855216)
print v(xbgr.mr_n51855328)
print v(xbgr.mr_n51855760)
print v(xbgr.mr_n51856192)
print v(xbgr.mr_n51856624)
print v(xbgr.mr_n51857056)
print v(xbgr.mr_n51857488)
print v(xbgr.mr_n51857920)
print v(xbgr.mr_n51858352)
print v(xbgr.mr_n51858784)
print v(xbgr.mr_n51859216)
print v(xbgr.mr_n51859648)
print v(xbgr.mr_n51860080)
print v(xbgr.mr_n51860400)
print v(xbgr.mr_n51860512)
print v(xbgr.mr_n51860832)
print v(xbgr.mr_n51860944)
print v(xbgr.mr_n51861264)
print v(xbgr.mr_n51861376)
print v(xbgr.mr_n51861696)
print v(xbgr.mr_n51861808)
print v(xbgr.mr_n51862128)
print v(xbgr.mr_n51862240)
print v(xbgr.mr_n51862560)
print v(xbgr.mr_n51862672)
print v(xbgr.mr_n51862992)
print v(xbgr.mr_n51863104)
print v(xbgr.mr_n51863424)
print v(xbgr.mr_n51863536)
print v(xbgr.mr_n51863968)
print v(xbgr.mr_n51864400)
print v(xbgr.mr_n51864832)
print v(xbgr.mr_n51865264)
print v(xbgr.mr_n51865696)
print v(xbgr.mr_n51866128)
print v(xbgr.mr_n51866560)
print v(xbgr.mr_n51866992)
print v(xbgr.mr_n51867424)
print v(xbgr.mr_n51867856)
print v(xbgr.mr_n51868288)
print v(xbgr.mr_n51868720)
print v(xbgr.mr_n51869152)
print v(xbgr.mr_n51869584)
print v(xbgr.mr_n51870016)
print v(xbgr.mr_n51870448)
print v(xbgr.mr_n51870880)
print v(xbgr.mr_n51871312)
print v(xbgr.mr_n51871744)
print v(xbgr.mr_n51872176)
print v(xbgr.mr_n51872496)
print v(xbgr.mr_n51872608)
print v(xbgr.mr_n51872928)
print v(xbgr.mr_n51873040)
print v(xbgr.mr_n51873360)
print v(xbgr.mr_n51873472)
print v(xbgr.mr_n51873792)
print v(xbgr.mr_n51873904)
print v(xbgr.mr_n51874224)
print v(xbgr.mr_n51874336)
print v(xbgr.mr_n51874656)
print v(xbgr.mr_n51874768)
print v(xbgr.mr_n51875088)
print v(xbgr.mr_n51875200)
print v(xbgr.mr_n51875520)
print v(xbgr.mr_n51875632)
print v(xbgr.mr_n51875952)
print v(xbgr.mr_n51876064)
print v(xbgr.mr_n51876384)
print v(xbgr.mr_n51876496)
print v(xbgr.mr_n51876816)
print v(xbgr.mr_n51876928)
print v(xbgr.mr_n51877248)
print v(xbgr.mr_n51877360)
print v(xbgr.mr_n51877680)
print v(xbgr.mr_n51877792)
print v(xbgr.mr_n51878224)
print v(xbgr.mr_n51878656)
print v(xbgr.mr_n51879088)
print v(xbgr.mr_n51879520)
print v(xbgr.mr_n51879952)
print v(xbgr.mr_n51880384)
print v(xbgr.mr_n51880816)
print v(xbgr.mr_n51881248)
print v(xbgr.mr_n51881680)
print v(xbgr.mr_n51882112)
print v(xbgr.mr_n51882544)
print v(xbgr.mr_n51882976)
print v(xbgr.mr_n51883408)
print v(xbgr.mr_n51883728)
print v(xbgr.mr_n51883840)
print v(xbgr.mr_n51884160)
print v(xbgr.mr_n51884272)
print v(xbgr.mr_n51884592)
print v(xbgr.mr_n51884704)
print v(xbgr.mr_n51885024)
print v(xbgr.mr_n51885136)
print v(xbgr.mr_n51885456)
print v(xbgr.mr_n51885568)
print v(xbgr.mr_n51885888)
print v(xbgr.mr_n51886000)
print v(xbgr.mr_n51886320)
print v(xbgr.mr_n51886432)
print v(xbgr.mr_n51886752)
print v(xbgr.mr_n51886864)
print v(xbgr.mr_n51887184)
print v(xbgr.mr_n51887296)
print v(xbgr.mr_n51887616)
print v(xbgr.mr_n51887728)
print v(xbgr.mr_n51888048)
print v(xbgr.mr_n51888160)
print v(xbgr.mr_n51888480)
print v(xbgr.mr_n51888592)
print v(xbgr.mr_n51889024)
print v(xbgr.mr_n51889344)
print v(xbgr.mr_n51889456)
print v(xbgr.mr_n51889888)
print v(xbgr.mr_n51890320)
print v(xbgr.mr_n51890752)
print v(xbgr.mr_n51891184)
print v(xbgr.mr_n51891616)
print v(xbgr.mr_n51892048)
print v(xbgr.mr_n51892480)
print v(xbgr.mr_n51892912)
print v(xbgr.mr_n51893344)
print v(xbgr.mr_n51893776)
print v(xbgr.mr_n51894208)
print v(xbgr.mr_n51894640)
print v(xbgr.mr_n51894960)
print v(xbgr.mr_n51895072)
print v(xbgr.mr_n51895392)
print v(xbgr.mr_n51895504)
print v(xbgr.mr_n51895824)
print v(xbgr.mr_n51895936)
print v(xbgr.mr_n51896256)
print v(xbgr.mr_n51896368)
print v(xbgr.mr_n51896688)
print v(xbgr.mr_n51896800)
print v(xbgr.mr_n51897120)
print v(xbgr.mr_n51897232)
print v(xbgr.mr_n51897552)
print v(xbgr.mr_n51897664)
print v(xbgr.mr_n51897984)
print v(xbgr.mr_n51898096)
print v(xbgr.mr_n51898416)
print v(xbgr.mr_n51898528)
print v(xbgr.mr_n51898848)
print v(xbgr.mr_n51898960)
print v(xbgr.mr_n51899280)
print v(xbgr.mr_n51899392)
print v(xbgr.mr_n51899824)
print v(xbgr.mr_n51900256)
print v(xbgr.mr_n51900688)
print v(xbgr.mr_n51901008)
print v(xbgr.mr_n51901120)
print v(xbgr.mr_n51901440)
print v(xbgr.mr_n51901552)
print v(xbgr.mr_n51901984)
print v(xbgr.mr_n51902416)
print v(xbgr.mr_n51902848)
print v(xbgr.mr_n51903280)
print v(xbgr.mr_n51903712)
print v(xbgr.mr_n51904144)
print v(xbgr.mr_n51904576)
print v(xbgr.mr_n51905008)
print v(xbgr.mr_n51905440)
print v(xbgr.mr_n51905872)
print v(xbgr.mr_n51906192)
print v(xbgr.mr_n51906304)
print v(xbgr.mr_n51906624)
print v(xbgr.mr_n51906736)
print v(xbgr.mr_n51907056)
print v(xbgr.mr_n51907168)
print v(xbgr.mr_n51907488)
print v(xbgr.mr_n51907600)
print v(xbgr.mr_n51907920)
print v(xbgr.mr_n51908032)
print v(xbgr.mr_n51908352)
print v(xbgr.mr_n51908464)
print v(xbgr.mr_n51908784)
print v(xbgr.mr_n51908896)
print v(xbgr.mr_n51909216)
print v(xbgr.mr_n51909328)
print v(xbgr.mr_n51909648)
print v(xbgr.mr_n51909760)
print v(xbgr.mr_n51910080)
print v(xbgr.mr_n51910192)
print v(xbgr.mr_n51910512)
print v(xbgr.mr_n51910624)
print v(xbgr.mr_n51910944)
print v(xbgr.mr_n51911056)
print v(xbgr.mr_n51911488)
print v(xbgr.mr_n51911920)
print v(xbgr.mr_n51912352)
print v(xbgr.mr_n51912784)
print v(xbgr.mr_n51913216)
print v(xbgr.mr_n51913648)
print v(xbgr.mr_n51914080)
print v(xbgr.mr_n51914400)
print v(xbgr.mr_n51914512)
print v(xbgr.mr_n51914944)
print v(xbgr.mr_n51915376)
print v(xbgr.mr_n51915808)
print v(xbgr.mr_n51916240)
print v(xbgr.mr_n51916672)
print v(xbgr.mr_n51917104)
print v(xbgr.mr_n51917424)
print v(xbgr.mr_n51917536)
print v(xbgr.mr_n51917856)
print v(xbgr.mr_n51917968)
print v(xbgr.mr_n51918288)
print v(xbgr.mr_n51918400)
print v(xbgr.mr_n51918720)
print v(xbgr.mr_n51918832)
print v(xbgr.mr_n51919152)
print v(xbgr.mr_n51919264)
print v(xbgr.mr_n51919584)
print v(xbgr.mr_n51919696)
print v(xbgr.mr_n51920016)
print v(xbgr.mr_n51920128)
print v(xbgr.mr_n51920448)
print v(xbgr.mr_n51920560)
print v(xbgr.mr_n51920880)
print v(xbgr.mr_n51920992)
print v(xbgr.mr_n51921312)
print v(xbgr.mr_n51921424)
print v(xbgr.mr_n51921744)
print v(xbgr.mr_n51921856)
print v(xbgr.mr_n51922176)
print v(xbgr.mr_n51922288)
print v(xbgr.mr_n51922608)
print v(xbgr.mr_n51922720)
print v(xbgr.mr_n51923040)
print v(xbgr.mr_n51923152)
print v(xbgr.mr_n51923472)
print v(xbgr.mr_n51923584)
print v(xbgr.mr_n51923904)
print v(xbgr.mr_n51924016)
print v(xbgr.mr_n51924336)
print v(xbgr.mr_n51924448)
print v(xbgr.mr_n51924768)
print v(xbgr.mr_n51924880)
print v(xbgr.mr_n51925200)
print v(xbgr.mr_n51925312)
print v(xbgr.mr_n51925632)
print v(xbgr.mr_n51925744)
print v(xbgr.mr_n51926064)
print v(xbgr.mr_n51926176)
print v(xbgr.mr_n51926496)
print v(xbgr.mr_n51926608)
print v(xbgr.mr_n51926928)
print v(xbgr.mr_n51927040)
print v(xbgr.mr_n51927360)
print v(xbgr.mr_n51927472)
print v(xbgr.mr_n51927904)
print v(xbgr.mr_n51928336)
print v(xbgr.mr_n51928768)
print v(xbgr.mr_n51929088)
print v(xbgr.mr_n51929200)
print v(xbgr.mr_n51929520)
print v(xbgr.mr_n51929632)
print v(xbgr.mr_n51930064)
print v(xbgr.mr_n51930496)
print v(xbgr.mr_n51930928)
print v(xbgr.mr_n51931360)
print v(xbgr.mr_n51931792)
print v(xbgr.mr_n51932224)
print v(xbgr.mr_n51932656)
print v(xbgr.mr_n51933088)
print v(xbgr.mr_n51933520)
print v(xbgr.mr_n51933952)
print v(xbgr.mr_n51934384)
print v(xbgr.mr_n51934816)
print v(xbgr.mr_n51935248)
print v(xbgr.mr_n51935680)
print v(xbgr.mr_n51936112)
print v(xbgr.mr_n51936544)
print v(xbgr.mr_n51936976)
print v(xbgr.mr_n51937408)
print v(xbgr.mr_n51937840)
print v(xbgr.mr_n51938272)
print v(xbgr.mr_n51938704)
print v(xbgr.mr_n51939136)
print v(xbgr.mr_n51939568)
print v(xbgr.mr_n51939888)
print v(xbgr.mr_n51940000)
print v(xbgr.mr_n51940320)
print v(xbgr.mr_n51940432)
print v(xbgr.mr_n51940752)
print v(xbgr.mr_n51940864)
print v(xbgr.mr_n51941184)
print v(xbgr.mr_n51941296)
print v(xbgr.mr_n51941616)
print v(xbgr.mr_n51941728)
print v(xbgr.mr_n51942048)
print v(xbgr.mr_n51942160)
print v(xbgr.mr_n51942480)
print v(xbgr.mr_n51942592)
print v(xbgr.mr_n51942912)
print v(xbgr.mr_n51943024)
print v(xbgr.mr_n51943344)
print v(xbgr.mr_n51943456)
print v(xbgr.mr_n51943776)
print v(xbgr.mr_n51943888)
print v(xbgr.mr_n51944208)
print v(xbgr.mr_n51944320)
print v(xbgr.mr_n51944640)
print v(xbgr.mr_n51944752)
print v(xbgr.mr_n51945072)
print v(xbgr.mr_n51945184)
print v(xbgr.mr_n51945504)
print v(xbgr.mr_n51945616)
print v(xbgr.mr_n51946048)
print v(xbgr.mr_n51946480)
print v(xbgr.mr_n51946800)
print v(xbgr.mr_n51946912)
print v(xbgr.mr_n51947232)
print v(xbgr.mr_n51947344)
print v(xbgr.mr_n51947664)
print v(xbgr.mr_n51947776)
print v(xbgr.mr_n51948096)
print v(xbgr.mr_n51948208)
print v(xbgr.mr_n51948640)
print v(xbgr.mr_n51949072)
print v(xbgr.mr_n51949392)
print v(xbgr.mr_n51949504)
print v(xbgr.mr_n51949824)
print v(xbgr.mr_n51949936)
print v(xbgr.mr_n51950256)
print v(xbgr.mr_n51950368)
print v(xbgr.mr_n51950688)
print v(xbgr.mr_n51950800)
print v(xbgr.mr_n51951120)
print v(xbgr.mr_n51951232)
print v(xbgr.mr_n51951552)
print v(xbgr.mr_n51951664)
print v(xbgr.mr_n51951984)
print v(xbgr.mr_n51952096)
print v(xbgr.mr_n51952416)
print v(xbgr.mr_n51952528)
print v(xbgr.mr_n51952960)
print v(xbgr.mr_n51953392)
print v(xbgr.mr_n51953824)
print v(xbgr.mr_n51954256)
print v(xbgr.mr_n51954688)
print v(xbgr.mr_n51955120)
print v(xbgr.mr_n51955552)
print v(xbgr.mr_n51955984)
print v(xbgr.mr_n51956416)
print v(xbgr.mr_n51956848)
print v(xbgr.mr_n51957168)
print v(xbgr.mr_n51957280)
print v(xbgr.mr_n51957600)
print v(xbgr.mr_n51957712)
print v(xbgr.mr_n51958032)
print v(xbgr.mr_n51958144)
print v(xbgr.mr_n51958464)
print v(xbgr.mr_n51958576)
print v(xbgr.mr_n51963664)
print v(xbgr.mr_n51963776)
print v(xbgr.mr_n51964112)
print v(xbgr.mr_n51964224)
print v(xbgr.mr_n51964544)
print v(xbgr.mr_n51964656)
print v(xbgr.mr_n51965024)
print v(xbgr.mr_n51965136)
print v(xbgr.mr_n51965456)
print v(xbgr.mr_n51965568)
print v(xbgr.mr_n51965888)
print v(xbgr.mr_n51966000)
print v(xbgr.mr_n51966240)
print v(xbgr.mr_n51966352)
print v(xbgr.mr_n51966672)
print v(xbgr.mr_n51966784)
print v(xbgr.mr_n51967104)
print v(xbgr.mr_n51967216)
print v(xbgr.mr_n51967536)
print v(xbgr.mr_n51967648)
print v(xbgr.mr_n51967968)
print v(xbgr.mr_n51968080)
print v(xbgr.mr_n51968400)
print v(xbgr.mr_n51968512)
print v(xbgr.mr_n51968832)
print v(xbgr.mr_n51968944)
print v(xbgr.mr_n51969264)
print v(xbgr.mr_n51969376)
print v(xbgr.mr_n51969696)
print v(xbgr.mr_n51969808)
print v(xbgr.mr_n51970128)
print v(xbgr.mr_n51970240)
print v(xbgr.mr_n51970560)
print v(xbgr.mr_n51970672)
print v(xbgr.mr_n51970992)
print v(xbgr.mr_n51971104)
print v(xbgr.mr_n51971424)
print v(xbgr.mr_n51971536)
print v(xbgr.mr_n51971856)
print v(xbgr.mr_n51971968)
print v(xbgr.mr_n51972288)
print v(xbgr.mr_n51972400)
print v(xbgr.mr_n51972720)
print v(xbgr.mr_n51972832)
print v(xbgr.mr_n51973152)
print v(xbgr.mr_n51973264)
print v(xbgr.mr_n51973584)
print v(xbgr.mr_n51973696)
print v(xbgr.mr_n51974016)
print v(xbgr.mr_n51974128)
print v(xbgr.mr_n51974448)
print v(xbgr.mr_n51974560)
print v(xbgr.mr_n51974880)
print v(xbgr.mr_n51974992)
print v(xbgr.mr_n51975312)
print v(xbgr.mr_n51975424)
print v(xbgr.mr_n51975744)
print v(xbgr.mr_n51975856)
print v(xbgr.mr_n51976176)
print v(xbgr.mr_n51976288)
print v(xbgr.mr_n51976608)
print v(xbgr.mr_n51976720)
print v(xbgr.mr_n51977040)
print v(xbgr.mr_n51977152)
print v(xbgr.mr_n51977472)
print v(xbgr.mr_n51977584)
print v(xbgr.mr_n51977904)
print v(xbgr.mr_n51978016)
print v(xbgr.mr_n51978336)
print v(xbgr.mr_n51978448)
print v(xbgr.mr_n51978768)
print v(xbgr.mr_n51978880)
print v(xbgr.mr_n51979200)
print v(xbgr.mr_n51979312)
print v(xbgr.mr_n51979632)
print v(xbgr.mr_n51979744)
print v(xbgr.mr_n51980064)
print v(xbgr.mr_n51980176)
print v(xbgr.mr_n51980496)
print v(xbgr.mr_n51980608)
print v(xbgr.mr_n51980928)
print v(xbgr.mr_n51981040)
print v(xbgr.mr_n51981360)
print v(xbgr.mr_n51981472)
print v(xbgr.mr_n51981792)
print v(xbgr.mr_n51981904)
print v(xbgr.mr_n51982224)
print v(xbgr.mr_n51982336)
print v(xbgr.mr_n51982656)
print v(xbgr.mr_n51982768)
print v(xbgr.mr_n51983088)
print v(xbgr.mr_n51983200)
print v(xbgr.mr_n51983520)
print v(xbgr.mr_n51983632)
print v(xbgr.mr_n51983952)
print v(xbgr.mr_n51984064)
print v(xbgr.mr_n51984384)
print v(xbgr.mr_n51984496)
print v(xbgr.mr_n51984816)
print v(xbgr.mr_n51984928)
print v(xbgr.mr_n51985248)
print v(xbgr.mr_n51985360)
print v(xbgr.mr_n51985680)
print v(xbgr.mr_n51985792)
print v(xbgr.mr_n51986112)
print v(xbgr.mr_n51986224)
print v(xbgr.mr_n51986544)
print v(xbgr.mr_n51986656)
print v(xbgr.mr_n51986976)
print v(xbgr.mr_n51987088)
print v(xbgr.mr_n51987408)
print v(xbgr.mr_n51987520)
print v(xbgr.mr_n51987840)
print v(xbgr.mr_n51987952)
print v(xbgr.mr_n51988272)
print v(xbgr.mr_n51988384)
print v(xbgr.mr_n51988704)
print v(xbgr.mr_n51988816)
print v(xbgr.mr_n51989136)
print v(xbgr.mr_n51989248)
print v(xbgr.mr_n51989568)
print v(xbgr.mr_n51989680)
print v(xbgr.mr_n51990000)
print v(xbgr.mr_n51990112)
print v(xbgr.mr_n51990432)
print v(xbgr.mr_n51990544)
print v(xbgr.mr_n51990864)
print v(xbgr.mr_n51990976)
print v(xbgr.mr_n51991296)
print v(xbgr.mr_n51991408)
print v(xbgr.mr_n51991728)
print v(xbgr.mr_n51991840)
print v(xbgr.mr_n51992160)
print v(xbgr.mr_n51992272)
print v(xbgr.mr_n51992592)
print v(xbgr.mr_n51992704)
print v(xbgr.mr_n51993024)
print v(xbgr.mr_n51993136)
print v(xbgr.mr_n51993456)
print v(xbgr.mr_n51993568)
print v(xbgr.mr_n51993792)
print v(xbgr.mr_n51993904)
print v(xbgr.mr_n51994160)
print v(xbgr.mr_n51994272)
print v(xbgr.mr_n51994528)
print v(xbgr.mr_n51994640)
print v(xbgr.mr_n51994896)
print v(xbgr.mr_n51995008)
print v(xbgr.mr_n51995264)
print v(xbgr.mr_n51995376)
print v(xbgr.mr_n51995632)
print v(xbgr.mr_n51995744)
print v(xbgr.mr_n51996000)
print v(xbgr.mr_n51996112)
print v(xbgr.mr_n51996368)
print v(xbgr.mr_n51996480)
print v(xbgr.mr_n51996736)
print v(xbgr.mr_n51996848)
print v(xbgr.mr_n51997104)
print v(xbgr.mr_n51997216)
print v(xbgr.mr_n51997504)
print v(xbgr.mr_n51997616)
print v(xbgr.mr_n51997936)
print v(xbgr.mr_n51998048)
print v(xbgr.mr_n51998368)
print v(xbgr.mr_n51998480)
print v(xbgr.mr_n51998800)
print v(xbgr.mr_n51998912)
print v(xbgr.mr_n51999232)
print v(xbgr.mr_n51999344)
print v(xbgr.mr_n51999664)
print v(xbgr.mr_n51999776)
print v(xbgr.mr_n52000096)
print v(xbgr.mr_n52000208)
print v(xbgr.mr_n52000528)
print v(xbgr.mr_n52000640)
print v(xbgr.mr_n52000960)
print v(xbgr.mr_n52001072)
print v(xbgr.mr_n52001392)
print v(xbgr.mr_n52001504)
print v(xbgr.mr_n52001824)
print v(xbgr.mr_n52001936)
print v(xbgr.mr_n52002256)
print v(xbgr.mr_n52002368)
print v(xbgr.mr_n52002688)
print v(xbgr.mr_n52002800)
print v(xbgr.mr_n52003120)
print v(xbgr.mr_n52003232)
print v(xbgr.mr_n52003552)
print v(xbgr.mr_n52003664)
print v(xbgr.mr_n52003984)
print v(xbgr.mr_n52004096)
print v(xbgr.mr_n52004416)
print v(xbgr.mr_n52004528)
print v(xbgr.mr_n52004848)
print v(xbgr.mr_n52004960)
print v(xbgr.mr_n52005280)
print v(xbgr.mr_n52005392)
print v(xbgr.mr_n52005712)
print v(xbgr.mr_n52005824)
print v(xbgr.mr_n52006144)
print v(xbgr.mr_n52006256)
print v(xbgr.mr_n52006576)
print v(xbgr.mr_n52006688)
print v(xbgr.mr_n52007008)
print v(xbgr.mr_n52007120)
print v(xbgr.mr_n52007440)
print v(xbgr.mr_n52007552)
print v(xbgr.mr_n52007872)
print v(xbgr.mr_n52007984)
print v(xbgr.mr_n52008304)
print v(xbgr.mr_n52008416)
print v(xbgr.mr_n52008736)
print v(xbgr.mr_n52008848)
print v(xbgr.mr_n52009168)
print v(xbgr.mr_n52009280)
print v(xbgr.mr_n52009600)
print v(xbgr.mr_n52009712)
print v(xbgr.mr_n52010032)
print v(xbgr.mr_n52010144)
print v(xbgr.mr_n52010464)
print v(xbgr.mr_n52010576)
print v(xbgr.mr_n52010896)
print v(xbgr.mr_n52011008)
print v(xbgr.mr_n52011328)
print v(xbgr.mr_n52011440)
print v(xbgr.mr_n52011760)
print v(xbgr.mr_n52011872)
print v(xbgr.mr_n52012192)
print v(xbgr.mr_n52012304)
print v(xbgr.mr_n52012624)
print v(xbgr.mr_n52012736)
print v(xbgr.mr_n52013056)
print v(xbgr.mr_n52013168)
print v(xbgr.mr_n52013488)
print v(xbgr.mr_n52013600)
print v(xbgr.mr_n52013920)
print v(xbgr.mr_n52014032)
print v(xbgr.mr_n52014352)
print v(xbgr.mr_n52014464)
print v(xbgr.mr_n52014784)
print v(xbgr.mr_n52014896)
print v(xbgr.mr_n52015216)
print v(xbgr.mr_n52015328)
print v(xbgr.mr_n52015648)
print v(xbgr.mr_n52015760)
print v(xbgr.mr_n52016080)
print v(xbgr.mr_n52016192)
print v(xbgr.mr_n52016512)
print v(xbgr.mr_n52016624)
print v(xbgr.mr_n52016944)
print v(xbgr.mr_n52017056)
print v(xbgr.mr_n52017376)
print v(xbgr.mr_n52017488)
print v(xbgr.mr_n52017808)
print v(xbgr.mr_n52017920)
print v(xbgr.mr_n52018240)
print v(xbgr.mr_n52018352)
print v(xbgr.mr_n52018672)
print v(xbgr.mr_n52018784)
print v(xbgr.mr_n52019104)
print v(xbgr.mr_n52019216)
print v(xbgr.mr_n52019536)
print v(xbgr.mr_n52019648)
print v(xbgr.mr_n52019968)
print v(xbgr.mr_n52020080)
print v(xbgr.mr_n52020400)
print v(xbgr.mr_n52020512)
print v(xbgr.mr_n52020832)
print v(xbgr.mr_n52020944)
print v(xbgr.mr_n52021264)
print v(xbgr.mr_n52021376)
print v(xbgr.mr_n52021696)
print v(xbgr.mr_n52021808)
print v(xbgr.mr_n52022128)
print v(xbgr.mr_n52022240)
print v(xbgr.mr_n52022560)
print v(xbgr.mr_n52022672)
print v(xbgr.mr_n52022992)
print v(xbgr.mr_n52023104)
print v(xbgr.mr_n52023424)
print v(xbgr.mr_n52023536)
print v(xbgr.mr_n52023856)
print v(xbgr.mr_n52023968)
print v(xbgr.mr_n52024288)
print v(xbgr.mr_n52024400)
print v(xbgr.mr_n52024720)
print v(xbgr.mr_n52024832)
print v(xbgr.mr_n52025040)
print v(xbgr.mr_n52025152)
print v(xbgr.mr_n52025472)
print v(xbgr.mr_n52025584)
print v(xbgr.mr_n52025904)
print v(xbgr.mr_n52026016)
print v(xbgr.mr_n52026336)
print v(xbgr.mr_n52026448)
print v(xbgr.mr_n52026768)
print v(xbgr.mr_n52026880)
print v(xbgr.mr_n52027200)
print v(xbgr.mr_n52027312)
print v(xbgr.mr_n52027632)
print v(xbgr.mr_n52027744)
print v(xbgr.mr_n52028064)
print v(xbgr.mr_n52028176)
print v(xbgr.mr_n52028496)
print v(xbgr.mr_n52028608)
print v(xbgr.mr_n52028928)
print v(xbgr.mr_n52029040)
print v(xbgr.mr_n52029360)
print v(xbgr.mr_n52029472)
print v(xbgr.mr_n52029792)
print v(xbgr.mr_n52029904)
print v(xbgr.mr_n52030224)
print v(xbgr.mr_n52030336)
print v(xbgr.mr_n52030656)
print v(xbgr.mr_n52030768)
print v(xbgr.mr_n52031088)
print v(xbgr.mr_n52031200)
print v(xbgr.mr_n52031520)
print v(xbgr.mr_n52031632)
print v(xbgr.mr_n52031952)
print v(xbgr.mr_n52032064)
print v(xbgr.mr_n52032384)
print v(xbgr.mr_n52032496)
print v(xbgr.mr_n52032816)
print v(xbgr.mr_n52032928)
print v(xbgr.mr_n52033248)
print v(xbgr.mr_n52033360)
print v(xbgr.mr_n52033680)
print v(xbgr.mr_n52033792)
print v(xbgr.mr_n52034112)
print v(xbgr.mr_n52034224)
print v(xbgr.mr_n52034544)
print v(xbgr.mr_n52034656)
print v(xbgr.mr_n52034976)
print v(xbgr.mr_n52035088)
print v(xbgr.mr_n52035408)
print v(xbgr.mr_n52035520)
print v(xbgr.mr_n52035840)
print v(xbgr.mr_n52035952)
print v(xbgr.mr_n52036272)
print v(xbgr.mr_n52036384)
print v(xbgr.mr_n52036704)
print v(xbgr.mr_n52036816)
print v(xbgr.mr_n52037136)
print v(xbgr.mr_n52037248)
print v(xbgr.mr_n52037568)
print v(xbgr.mr_n52037680)
print v(xbgr.mr_n52038000)
print v(xbgr.mr_n52038112)
print v(xbgr.mr_n52038432)
print v(xbgr.mr_n52038544)
print v(xbgr.mr_n52038864)
print v(xbgr.mr_n52038976)
print v(xbgr.mr_n52039296)
print v(xbgr.mr_n52039408)
print v(xbgr.mr_n52039728)
print v(xbgr.mr_n52039840)
print v(xbgr.mr_n52040160)
print v(xbgr.mr_n52040272)
print v(xbgr.mr_n52040592)
print v(xbgr.mr_n52040704)
print v(xbgr.mr_n52041024)
print v(xbgr.mr_n52041136)
print v(xbgr.mr_n52041456)
print v(xbgr.mr_n52041568)
print v(xbgr.mr_n52041888)
print v(xbgr.mr_n52042000)
print v(xbgr.mr_n52042320)
print v(xbgr.mr_n52042432)
print v(xbgr.mr_n52042752)
print v(xbgr.mr_n52042864)
print v(xbgr.mr_n52043184)
print v(xbgr.mr_n52043296)
print v(xbgr.mr_n52043616)
print v(xbgr.mr_n52043728)
print v(xbgr.mr_n52044048)
print v(xbgr.mr_n52044160)
print v(xbgr.mr_n52044480)
print v(xbgr.mr_n52044592)
print v(xbgr.mr_n52044912)
print v(xbgr.mr_n52045024)
print v(xbgr.mr_n52045344)
print v(xbgr.mr_n52045456)
print v(xbgr.mr_n52045776)
print v(xbgr.mr_n52045888)
print v(xbgr.mr_n52046208)
print v(xbgr.mr_n52046320)
print v(xbgr.mr_n52046640)
print v(xbgr.mr_n52046752)
print v(xbgr.mr_n52047072)
print v(xbgr.mr_n52047184)
print v(xbgr.mr_n52047504)
print v(xbgr.mr_n52047616)
print v(xbgr.mr_n52047936)
print v(xbgr.mr_n52048048)
print v(xbgr.mr_n52048368)
print v(xbgr.mr_n52048480)
print v(xbgr.mr_n52048800)
print v(xbgr.mr_n52048912)
print v(xbgr.mr_n52049232)
print v(xbgr.mr_n52049344)
print v(xbgr.mr_n52049664)
print v(xbgr.mr_n52049776)
print v(xbgr.mr_n52050096)
print v(xbgr.mr_n52050208)
print v(xbgr.mr_n52050528)
print v(xbgr.mr_n52050640)
print v(xbgr.mr_n52050960)
print v(xbgr.mr_n52051072)
print v(xbgr.mr_n52051392)
print v(xbgr.mr_n52051504)
print v(xbgr.mr_n52051824)
print v(xbgr.mr_n52051936)
print v(xbgr.mr_n52052256)
print v(xbgr.mr_n52052368)
print v(xbgr.mr_n52052688)
print v(xbgr.mr_n52052800)
print v(xbgr.mr_n52053120)
print v(xbgr.mr_n52053232)
print v(xbgr.mr_n52053552)
print v(xbgr.mr_n52053664)
print v(xbgr.mr_n52053984)
print v(xbgr.mr_n52054096)
print v(xbgr.mr_n52054416)
print v(xbgr.mr_n52054528)
print v(xbgr.mr_n52054848)
print v(xbgr.mr_n52054960)
print v(xbgr.mr_n52055280)
print v(xbgr.mr_n52055392)
print v(xbgr.mr_n52055712)
print v(xbgr.mr_n52055824)
print v(xbgr.mr_n52056144)
print v(xbgr.mr_n52056256)
print v(xbgr.mr_n52056576)
print v(xbgr.mr_n52056688)
print v(xbgr.mr_n52057008)
print v(xbgr.mr_n52057120)
print v(xbgr.mr_n52057440)
print v(xbgr.mr_n52057552)
print v(xbgr.mr_n52057872)
print v(xbgr.mr_n52057984)
print v(xbgr.mr_n52058304)
print v(xbgr.mr_n52058416)
print v(xbgr.mr_n52058736)
print v(xbgr.mr_n52058848)
print v(xbgr.mr_n52059168)
print v(xbgr.mr_n52059280)
print v(xbgr.mr_n52059600)
print v(xbgr.mr_n52059712)
print v(xbgr.mr_n52060032)
print v(xbgr.mr_n52060144)
print v(xbgr.mr_n52060464)
print v(xbgr.mr_n52060576)
print v(xbgr.mr_n52060896)
print v(xbgr.mr_n52061008)
print v(xbgr.mr_n52061328)
print v(xbgr.mr_n52061440)
print v(xbgr.mr_n52061760)
print v(xbgr.mr_n52061872)
print v(xbgr.mr_n52062192)
print v(xbgr.mr_n52062304)
print v(xbgr.mr_n52062624)
print v(xbgr.mr_n52062736)
print v(xbgr.mr_n52063056)
print v(xbgr.mr_n52063168)
print v(xbgr.mr_n52063488)
print v(xbgr.mr_n52063600)
print v(xbgr.mr_n52063920)
print v(xbgr.mr_n52064032)
print v(xbgr.mr_n52064352)
print v(xbgr.mr_n52064464)
print v(xbgr.mr_n52064784)
print v(xbgr.mr_n52064896)
print v(xbgr.mr_n52065216)
print v(xbgr.mr_n52065328)
print v(xbgr.mr_n52065648)
print v(xbgr.mr_n52065760)
print v(xbgr.mr_n52066080)
print v(xbgr.mr_n52066192)
print v(xbgr.mr_n52066512)
print v(xbgr.mr_n52066624)
print v(xbgr.mr_n52066944)
print v(xbgr.mr_n52067056)
print v(xbgr.mr_n52067376)
print v(xbgr.mr_n52067488)
print v(xbgr.mr_n52067808)
print v(xbgr.mr_n52067920)
print v(xbgr.mr_n52068240)
print v(xbgr.mr_n52068352)
print v(xbgr.mr_n52068672)
print v(xbgr.mr_n52068784)
print v(xbgr.mr_n52069104)
print v(xbgr.mr_n52069216)
print v(xbgr.mr_n52069536)
print v(xbgr.mr_n52069648)
print v(xbgr.mr_n52069968)
print v(xbgr.mr_n52070080)
print v(xbgr.mr_n52070400)
print v(xbgr.mr_n52070512)
print v(xbgr.mr_n52070832)
print v(xbgr.mr_n52070944)
print v(xbgr.mr_n52071264)
print v(xbgr.mr_n52071376)
print v(xbgr.mr_n52071696)
print v(xbgr.mr_n52071808)
print v(xbgr.mr_n52072128)
print v(xbgr.mr_n52072240)
print v(xbgr.mr_n52072560)
print v(xbgr.mr_n52072672)
print v(xbgr.mr_n52072992)
print v(xbgr.mr_n52073104)
print v(xbgr.mr_n52073424)
print v(xbgr.mr_n52073536)
print v(xbgr.mr_n52073856)
print v(xbgr.mr_n52073968)
print v(xbgr.mr_n52074288)
print v(xbgr.mr_n52074400)
print v(xbgr.mr_n52074720)
print v(xbgr.mr_n52074832)
print v(xbgr.mr_n52075152)
print v(xbgr.mr_n52075264)
print v(xbgr.mr_n52075584)
print v(xbgr.mr_n52075696)
print v(xbgr.mr_n52076016)
print v(xbgr.mr_n52076128)
print v(xbgr.mr_n52076448)
print v(xbgr.mr_n52076560)
print v(xbgr.mr_n52076880)
print v(xbgr.mr_n52076992)
print v(xbgr.mr_n52077312)
print v(xbgr.mr_n52077424)
print v(xbgr.mr_n52077744)
print v(xbgr.mr_n52077856)
print v(xbgr.mr_n52078176)
print v(xbgr.mr_n52078288)
print v(xbgr.mr_n52078608)
print v(xbgr.mr_n52078720)
print v(xbgr.mr_n52079040)
print v(xbgr.mr_n52079152)
print v(xbgr.mr_n52079472)
print v(xbgr.mr_n52079584)
print v(xbgr.mr_n52079904)
print v(xbgr.mr_n52080016)
print v(xbgr.mr_n52080336)
print v(xbgr.mr_n52080448)
print v(xbgr.mr_n52080768)
print v(xbgr.mr_n52080880)
print v(xbgr.mr_n52081200)
print v(xbgr.mr_n52081312)
print v(xbgr.mr_n52081632)
print v(xbgr.mr_n52081744)
print v(xbgr.mr_n52082064)
print v(xbgr.mr_n52082176)
print v(xbgr.mr_n52082496)
print v(xbgr.mr_n52082608)
print v(xbgr.mr_n52082928)
print v(xbgr.mr_n52083040)
print v(xbgr.mr_n52083360)
print v(xbgr.mr_n52083472)
print v(xbgr.mr_n52083792)
print v(xbgr.mr_n52083904)
print v(xbgr.mr_n52084224)
print v(xbgr.mr_n52084336)
print v(xbgr.mr_n52084656)
print v(xbgr.mr_n52084768)
print v(xbgr.mr_n52085088)
print v(xbgr.mr_n52085200)
print v(xbgr.mr_n52085520)
print v(xbgr.mr_n52085632)
print v(xbgr.mr_n52085952)
print v(xbgr.mr_n52086064)
print v(xbgr.mr_n52086592)
print v(xbgr.mr_n52086704)
print v(xbgr.mr_n52087024)
print v(xbgr.mr_n52087136)
print v(xbgr.mr_n52087456)
print v(xbgr.mr_n52087568)
print v(xbgr.mr_n52087888)
print v(xbgr.mr_n52088000)
print v(xbgr.mr_n52088320)
print v(xbgr.mr_n52088432)
print v(xbgr.mr_n52088752)
print v(xbgr.mr_n52088864)
print v(xbgr.mr_n52089184)
print v(xbgr.mr_n52089296)
print v(xbgr.mr_n52089616)
print v(xbgr.mr_n52089728)
print v(xbgr.mr_n52090048)
print v(xbgr.mr_n52090160)
print v(xbgr.mr_n52090480)
print v(xbgr.mr_n52090592)
print v(xbgr.mr_n52090912)
print v(xbgr.mr_n52091024)
print v(xbgr.mr_n52091344)
print v(xbgr.mr_n52091456)
print v(xbgr.mr_n52091776)
print v(xbgr.mr_n52091888)
print v(xbgr.mr_n52092208)
print v(xbgr.mr_n52092320)
print v(xbgr.mr_n52092640)
print v(xbgr.mr_n52092752)
print v(xbgr.mr_n52093072)
print v(xbgr.mr_n52093184)
print v(xbgr.mr_n52093504)
print v(xbgr.mr_n52093616)
print v(xbgr.mr_n52093936)
print v(xbgr.mr_n52094048)
print v(xbgr.mr_n52094368)
print v(xbgr.mr_n52094480)
print v(xbgr.mr_n52094800)
print v(xbgr.mr_n52094912)
print v(xbgr.mr_n52095232)
print v(xbgr.mr_n52095344)
print v(xbgr.mr_n52095664)
print v(xbgr.mr_n52095776)
print v(xbgr.mr_n52096096)
print v(xbgr.mr_n52096208)
print v(xbgr.mr_n52096528)
print v(xbgr.mr_n52096640)
print v(xbgr.mr_n52096960)
print v(xbgr.mr_n52097072)
print v(xbgr.mr_n52097392)
print v(xbgr.mr_n52097504)
print v(xbgr.mr_n52097824)
print v(xbgr.mr_n52097936)
print v(xbgr.mr_n52098256)
print v(xbgr.mr_n52098368)
print v(xbgr.mr_n52098688)
print v(xbgr.mr_n52098800)
print v(xbgr.mr_n52099120)
print v(xbgr.mr_n52099232)
print v(xbgr.mr_n52099552)
print v(xbgr.mr_n52099664)
print v(xbgr.mr_n52099984)
print v(xbgr.mr_n52100096)
print v(xbgr.mr_n52100416)
print v(xbgr.mr_n52100528)
print v(xbgr.mr_n52100848)
print v(xbgr.mr_n52100960)
print v(xbgr.mr_n52101280)
print v(xbgr.mr_n52101392)
print v(xbgr.mr_n52101712)
print v(xbgr.mr_n52101824)
print v(xbgr.mr_n52102144)
print v(xbgr.mr_n52102256)
print v(xbgr.mr_n52102576)
print v(xbgr.mr_n52102688)
print v(xbgr.mr_n52103008)
print v(xbgr.mr_n52103120)
print v(xbgr.mr_n52103440)
print v(xbgr.mr_n52103552)
print v(xbgr.mr_n52103872)
print v(xbgr.mr_n52103984)
print v(xbgr.mr_n52104304)
print v(xbgr.mr_n52104416)
print v(xbgr.mr_n52104736)
print v(xbgr.mr_n52104848)
print v(xbgr.mr_n52105168)
print v(xbgr.mr_n52105280)
print v(xbgr.mr_n52105600)
print v(xbgr.mr_n52105712)
print v(xbgr.mr_n52106032)
print v(xbgr.mr_n52106144)
print v(xbgr.mr_n52106464)
print v(xbgr.mr_n52106576)
print v(xbgr.mr_n52106896)
print v(xbgr.mr_n52107008)
print v(xbgr.mr_n52107328)
print v(xbgr.mr_n52107440)
print v(xbgr.mr_n52107760)
print v(xbgr.mr_n52107872)
print v(xbgr.mr_n52108192)
print v(xbgr.mr_n52108304)
print v(xbgr.mr_n52108624)
print v(xbgr.mr_n52108736)
print v(xbgr.mr_n52109056)
print v(xbgr.mr_n52109168)
print v(xbgr.mr_n52109488)
print v(xbgr.mr_n52109600)
print v(xbgr.mr_n52109920)
print v(xbgr.mr_n52110032)
print v(xbgr.mr_n52110352)
print v(xbgr.mr_n52110464)
print v(xbgr.mr_n52110784)
print v(xbgr.mr_n52110896)
print v(xbgr.mr_n52111216)
print v(xbgr.mr_n52111328)
print v(xbgr.mr_n52111648)
print v(xbgr.mr_n52111760)
print v(xbgr.mr_n52112080)
print v(xbgr.mr_n52112192)
print v(xbgr.mr_n52112512)
print v(xbgr.mr_n52112624)
print v(xbgr.mr_n52112944)
print v(xbgr.mr_n52113056)
print v(xbgr.mr_n52113376)
print v(xbgr.mr_n52113488)
print v(xbgr.mr_n52113808)
print v(xbgr.mr_n52113920)
print v(xbgr.mr_n52114240)
print v(xbgr.mr_n52114352)
print v(xbgr.mr_n52114672)
print v(xbgr.mr_n52114784)
print v(xbgr.mr_n52115104)
print v(xbgr.mr_n52115216)
print v(xbgr.mr_n52115536)
print v(xbgr.mr_n52115648)
print v(xbgr.mr_n52115968)
print v(xbgr.mr_n52116080)
print v(xbgr.mr_n52116400)
print v(xbgr.mr_n52116512)
print v(xbgr.mr_n52116832)
print v(xbgr.mr_n52116944)
print v(xbgr.mr_n52117264)
print v(xbgr.mr_n52117376)
print v(xbgr.mr_n52117696)
print v(xbgr.mr_n52117808)
print v(xbgr.mr_n52118128)
print v(xbgr.mr_n52118240)
print v(xbgr.mr_n52118560)
print v(xbgr.mr_n52118672)
print v(xbgr.mr_n52118992)
print v(xbgr.mr_n52119104)
print v(xbgr.mr_n52119424)
print v(xbgr.mr_n52119536)
print v(xbgr.mr_n52119856)
print v(xbgr.mr_n52119968)
print v(xbgr.mr_n52120288)
print v(xbgr.mr_n52120400)
print v(xbgr.mr_n52120720)
print v(xbgr.mr_n52120832)
print v(xbgr.mr_n52121152)
print v(xbgr.mr_n52121264)
print v(xbgr.mr_n52121584)
print v(xbgr.mr_n52121696)
print v(xbgr.mr_n52122016)
print v(xbgr.mr_n52122128)
print v(xbgr.mr_n52122448)
print v(xbgr.mr_n52122560)
print v(xbgr.mr_n52122880)
print v(xbgr.mr_n52122992)
print v(xbgr.mr_n52123312)
print v(xbgr.mr_n52123424)
print v(xbgr.mr_n52123744)
print v(xbgr.mr_n52123856)
print v(xbgr.mr_n52124176)
print v(xbgr.mr_n52124288)
print v(xbgr.mr_n52124608)
print v(xbgr.mr_n52124720)
print v(xbgr.mr_n52125040)
print v(xbgr.mr_n52125152)
print v(xbgr.mr_n52125472)
print v(xbgr.mr_n52125584)
print v(xbgr.mr_n52125904)
print v(xbgr.mr_n52126016)
print v(xbgr.mr_n52388496)
print v(xbgr.mr_n52388736)
print v(xbgr.mr_n52388848)
print v(xbgr.mr_n52389168)
print v(xbgr.mr_n52389280)
print v(xbgr.mr_n52389600)
print v(xbgr.mr_n52389712)
print v(xbgr.mr_n52390032)
print v(xbgr.mr_n52390144)
print v(xbgr.mr_n52390464)
print v(xbgr.mr_n52390576)
print v(xbgr.mr_n52390896)
print v(xbgr.mr_n52391008)
print v(xbgr.mr_n52391328)
print v(xbgr.mr_n52391440)
print v(xbgr.mr_n52391760)
print v(xbgr.mr_n52391872)
print v(xbgr.mr_n52392192)
print v(xbgr.mr_n52392304)
print v(xbgr.mr_n52392624)
print v(xbgr.mr_n52392736)
print v(xbgr.mr_n52393056)
print v(xbgr.mr_n52393168)
print v(xbgr.mr_n52393488)
print v(xbgr.mr_n52393600)
print v(xbgr.mr_n52393920)
print v(xbgr.mr_n52394032)
print v(xbgr.mr_n52394352)
print v(xbgr.mr_n52394464)
print v(xbgr.mr_n52394784)
print v(xbgr.mr_n52394896)
print v(xbgr.mr_n52395216)
print v(xbgr.mr_n52395328)
print v(xbgr.mr_n52395648)
print v(xbgr.mr_n52395760)
print v(xbgr.mr_n52396080)
print v(xbgr.mr_n52396192)
print v(xbgr.mr_n52396512)
print v(xbgr.mr_n52396624)
print v(xbgr.mr_n52396944)
print v(xbgr.mr_n52397056)
print v(xbgr.mr_n52397376)
print v(xbgr.mr_n52397488)
print v(xbgr.mr_n52397808)
print v(xbgr.mr_n52397920)
print v(xbgr.mr_n52398240)
print v(xbgr.mr_n52398352)
print v(xbgr.mr_n52398672)
print v(xbgr.mr_n52398784)
print v(xbgr.mr_n52399104)
print v(xbgr.mr_n52399216)
print v(xbgr.mr_n52399536)
print v(xbgr.mr_n52399648)
print v(xbgr.mr_n52399968)
print v(xbgr.mr_n52400080)
print v(xbgr.mr_n52400400)
print v(xbgr.mr_n52400512)
print v(xbgr.mr_n52400832)
print v(xbgr.mr_n52400944)
print v(xbgr.mr_n52401264)
print v(xbgr.mr_n52401376)
print v(xbgr.mr_n52401696)
print v(xbgr.mr_n52401808)
print v(xbgr.mr_n52402128)
print v(xbgr.mr_n52402240)
print v(xbgr.mr_n52402560)
print v(xbgr.mr_n52402672)
print v(xbgr.mr_n52402992)
print v(xbgr.mr_n52403104)
print v(xbgr.mr_n52403424)
print v(xbgr.mr_n52403536)
print v(xbgr.mr_n52403856)
print v(xbgr.mr_n52403968)
print v(xbgr.mr_n52404288)
print v(xbgr.mr_n52404400)
print v(xbgr.mr_n52404720)
print v(xbgr.mr_n52404832)
print v(xbgr.mr_n52405152)
print v(xbgr.mr_n52405264)
print v(xbgr.mr_n52405584)
print v(xbgr.mr_n52405696)
print v(xbgr.mr_n52406016)
print v(xbgr.mr_n52406128)
print v(xbgr.mr_n52406448)
print v(xbgr.mr_n52406560)
print v(xbgr.mr_n52406880)
print v(xbgr.mr_n52406992)
print v(xbgr.mr_n52407312)
print v(xbgr.mr_n52407424)
print v(xbgr.mr_n52407744)
print v(xbgr.mr_n52407856)
print v(xbgr.mr_n52408176)
print v(xbgr.mr_n52408288)
print v(xbgr.mr_n52408608)
print v(xbgr.mr_n52408720)
print v(xbgr.mr_n52409040)
print v(xbgr.mr_n52409152)
print v(xbgr.mr_n52409472)
print v(xbgr.mr_n52409584)
print v(xbgr.mr_n52409904)
print v(xbgr.mr_n52410016)
print v(xbgr.mr_n52410336)
print v(xbgr.mr_n52410448)
print v(xbgr.mr_n52410768)
print v(xbgr.mr_n52410880)
print v(xbgr.mr_n52411200)
print v(xbgr.mr_n52411312)
print v(xbgr.mr_n52411632)
print v(xbgr.mr_n52411744)
print v(xbgr.mr_n52412064)
print v(xbgr.mr_n52412176)
print v(xbgr.mr_n52412496)
print v(xbgr.mr_n52412608)
print v(xbgr.mr_n52412928)
print v(xbgr.mr_n52413040)
print v(xbgr.mr_n52413360)
print v(xbgr.mr_n52413472)
print v(xbgr.mr_n52413792)
print v(xbgr.mr_n52413904)
print v(xbgr.mr_n52414224)
print v(xbgr.mr_n52414336)
print v(xbgr.mr_n52414656)
print v(xbgr.mr_n52414768)
print v(xbgr.mr_n52415088)
print v(xbgr.mr_n52415200)
print v(xbgr.mr_n52415520)
print v(xbgr.mr_n52415632)
print v(xbgr.mr_n52415952)
print v(xbgr.mr_n52416064)
print v(xbgr.mr_n52416384)
print v(xbgr.mr_n52416496)
print v(xbgr.mr_n52416816)
print v(xbgr.mr_n52416928)
print v(xbgr.mr_n52417248)
print v(xbgr.mr_n52417360)
print v(xbgr.mr_n52417680)
print v(xbgr.mr_n52417792)
print v(xbgr.mr_n52418112)
print v(xbgr.mr_n52418224)
print v(xbgr.mr_n52418544)
print v(xbgr.mr_n52418656)
print v(xbgr.mr_n52418976)
print v(xbgr.mr_n52419088)
print v(xbgr.mr_n52419408)
print v(xbgr.mr_n52419520)
print v(xbgr.mr_n52419840)
print v(xbgr.mr_n52419952)
print v(xbgr.mr_n52420272)
print v(xbgr.mr_n52420384)
print v(xbgr.mr_n52420704)
print v(xbgr.mr_n52420816)
print v(xbgr.mr_n52421136)
print v(xbgr.mr_n52421248)
print v(xbgr.mr_n52421568)
print v(xbgr.mr_n52421680)
print v(xbgr.mr_n52422000)
print v(xbgr.mr_n52422112)
print v(xbgr.mr_n52422432)
print v(xbgr.mr_n52422544)
print v(xbgr.mr_n52422864)
print v(xbgr.mr_n52422976)
print v(xbgr.mr_n52423296)
print v(xbgr.mr_n52423408)
print v(xbgr.mr_n52423728)
print v(xbgr.mr_n52423840)
print v(xbgr.mr_n52424160)
print v(xbgr.mr_n52424272)
print v(xbgr.mr_n52424592)
print v(xbgr.mr_n52424704)
print v(xbgr.mr_n52425024)
print v(xbgr.mr_n52425136)
print v(xbgr.mr_n52425456)
print v(xbgr.mr_n52425568)
print v(xbgr.mr_n52425888)
print v(xbgr.mr_n52426000)
print v(xbgr.mr_n52426320)
print v(xbgr.mr_n52426432)
print v(xbgr.mr_n52426752)
print v(xbgr.mr_n52426864)
print v(xbgr.mr_n52427184)
print v(xbgr.mr_n52427296)
print v(xbgr.mr_n52427616)
print v(xbgr.mr_n52427728)
print v(xbgr.mr_n52428048)
print v(xbgr.mr_n52428160)
print v(xbgr.mr_n52428480)
print v(xbgr.mr_n52428592)
print v(xbgr.mr_n52428912)
print v(xbgr.mr_n52429024)
print v(xbgr.mr_n52429344)
print v(xbgr.mr_n52429456)
print v(xbgr.mr_n52429776)
print v(xbgr.mr_n52429888)
print v(xbgr.mr_n52430208)
print v(xbgr.mr_n52430320)
print v(xbgr.mr_n52430640)
print v(xbgr.mr_n52430752)
print v(xbgr.mr_n52431072)
print v(xbgr.mr_n52431184)
print v(xbgr.mr_n52431504)
print v(xbgr.mr_n52431616)
print v(xbgr.mr_n52431936)
print v(xbgr.mr_n52432048)
print v(xbgr.mr_n52432368)
print v(xbgr.mr_n52432480)
print v(xbgr.mr_n52432800)
print v(xbgr.mr_n52432912)
print v(xbgr.mr_n52433232)
print v(xbgr.mr_n52433344)
print v(xbgr.mr_n52433664)
print v(xbgr.mr_n52433776)
print v(xbgr.mr_n52434096)
print v(xbgr.mr_n52434208)
print v(xbgr.mr_n52434528)
print v(xbgr.mr_n52434640)
print v(xbgr.mr_n52434960)
print v(xbgr.mr_n52435072)
print v(xbgr.mr_n52435392)
print v(xbgr.mr_n52435504)
print v(xbgr.mr_n52435824)
print v(xbgr.mr_n52435936)
print v(xbgr.mr_n52436256)
print v(xbgr.mr_n52436368)
print v(xbgr.mr_n52436688)
print v(xbgr.mr_n52436800)
print v(xbgr.mr_n52437120)
print v(xbgr.mr_n52437232)
print v(xbgr.mr_n52437552)
print v(xbgr.mr_n52437664)
print v(xbgr.mr_n52437984)
print v(xbgr.mr_n52438096)
print v(xbgr.mr_n52438416)
print v(xbgr.mr_n52438528)
print v(xbgr.mr_n52438848)
print v(xbgr.mr_n52438960)
print v(xbgr.mr_n52439280)
print v(xbgr.mr_n52439392)
print v(xbgr.mr_n52439712)
print v(xbgr.mr_n52439824)
print v(xbgr.mr_n52440144)
print v(xbgr.mr_n52440256)
print v(xbgr.mr_n52440576)
print v(xbgr.mr_n52440688)
print v(xbgr.mr_n52441008)
print v(xbgr.mr_n52441120)
print v(xbgr.mr_n52441440)
print v(xbgr.mr_n52441552)
print v(xbgr.mr_n52441872)
print v(xbgr.mr_n52441984)
print v(xbgr.mr_n52442304)
print v(xbgr.mr_n52442416)
print v(xbgr.mr_n52442736)
print v(xbgr.mr_n52442848)
print v(xbgr.mr_n52443168)
print v(xbgr.mr_n52443280)
print v(xbgr.mr_n52443600)
print v(xbgr.mr_n52443712)
print v(xbgr.mr_n52444032)
print v(xbgr.mr_n52444144)
print v(xbgr.mr_n52444464)
print v(xbgr.mr_n52444576)
print v(xbgr.mr_n52444896)
print v(xbgr.mr_n52445008)
print v(xbgr.mr_n52445328)
print v(xbgr.mr_n52445440)
print v(xbgr.mr_n52445760)
print v(xbgr.mr_n52445872)
print v(xbgr.mr_n52446192)
print v(xbgr.mr_n52446304)
print v(xbgr.mr_n52446624)
print v(xbgr.mr_n52446736)
print v(xbgr.mr_n52447056)
print v(xbgr.mr_n52447168)
print v(xbgr.mr_n52447488)
print v(xbgr.mr_n52447600)
print v(xbgr.mr_n52447920)
print v(xbgr.mr_n52448032)
print v(xbgr.mr_n52448352)
print v(xbgr.mr_n52448464)
print v(xbgr.mr_n52448784)
print v(xbgr.mr_n52448896)
print v(xbgr.mr_n52449216)
print v(xbgr.mr_n52449328)
print v(xbgr.mr_n52449648)
print v(xbgr.mr_n52449760)
print v(xbgr.mr_n52450080)
print v(xbgr.mr_n52450192)
print v(xbgr.mr_n52450512)
print v(xbgr.mr_n52450624)
print v(xbgr.mr_n52450944)
print v(xbgr.mr_n52451056)
print v(xbgr.mr_n52451376)
print v(xbgr.mr_n52451488)
print v(xbgr.mr_n52451808)
print v(xbgr.mr_n52451920)
print v(xbgr.mr_n52452240)
print v(xbgr.mr_n52452352)
print v(xbgr.mr_n52452672)
print v(xbgr.mr_n52452784)
print v(xbgr.mr_n52453104)
print v(xbgr.mr_n52453216)
print v(xbgr.mr_n52453536)
print v(xbgr.mr_n52453648)
print v(xbgr.mr_n52453968)
print v(xbgr.mr_n52454080)
print v(xbgr.mr_n52454400)
print v(xbgr.mr_n52454512)
print v(xbgr.mr_n52454832)
print v(xbgr.mr_n52454944)
print v(xbgr.mr_n52455264)
print v(xbgr.mr_n52455376)
print v(xbgr.mr_n52455696)
print v(xbgr.mr_n52455808)
print v(xbgr.mr_n52456128)
print v(xbgr.mr_n52456240)
print v(xbgr.mr_n52456560)
print v(xbgr.mr_n52456672)
print v(xbgr.mr_n52456992)
print v(xbgr.mr_n52457104)
print v(xbgr.mr_n52457424)
print v(xbgr.mr_n52457536)
print v(xbgr.mr_n52457856)
print v(xbgr.mr_n52457968)
print v(xbgr.mr_n52458288)
print v(xbgr.mr_n52458400)
print v(xbgr.mr_n52458720)
print v(xbgr.mr_n52458832)
print v(xbgr.mr_n52459152)
print v(xbgr.mr_n52459264)
print v(xbgr.mr_n52459584)
print v(xbgr.mr_n52459696)
print v(xbgr.mr_n52460016)
print v(xbgr.mr_n52460128)
print v(xbgr.mr_n52460448)
print v(xbgr.mr_n52460560)
print v(xbgr.mr_n52460880)
print v(xbgr.mr_n52460992)
print v(xbgr.mr_n52461312)
print v(xbgr.mr_n52461424)
print v(xbgr.mr_n52461744)
print v(xbgr.mr_n52461856)
print v(xbgr.mr_n52462176)
print v(xbgr.mr_n52462288)
print v(xbgr.mr_n52462608)
print v(xbgr.mr_n52462720)
print v(xbgr.mr_n52463040)
print v(xbgr.mr_n52463152)
print v(xbgr.mr_n52463472)
print v(xbgr.mr_n52463584)
print v(xbgr.mr_n52463904)
print v(xbgr.mr_n52464016)
print v(xbgr.mr_n52464336)
print v(xbgr.mr_n52464448)
print v(xbgr.mr_n52464768)
print v(xbgr.mr_n52464880)
print v(xbgr.mr_n52465200)
print v(xbgr.mr_n52465312)
print v(xbgr.mr_n52465632)
print v(xbgr.mr_n52465744)
print v(xbgr.mr_n52466064)
print v(xbgr.mr_n52466176)
print v(xbgr.mr_n52466496)
print v(xbgr.mr_n52466608)
print v(xbgr.mr_n52466928)
print v(xbgr.mr_n52467040)
print v(xbgr.mr_n52467360)
print v(xbgr.mr_n52467472)
print v(xbgr.mr_n52467792)
print v(xbgr.mr_n52467904)
print v(xbgr.mr_n52468224)
print v(xbgr.mr_n52468336)
print v(xbgr.mr_n52468656)
print v(xbgr.mr_n52468768)
print v(xbgr.mr_n52469088)
print v(xbgr.mr_n52469200)
print v(xbgr.mr_n52469520)
print v(xbgr.mr_n52469632)
print v(xbgr.mr_n52469952)
print v(xbgr.mr_n52470064)
print v(xbgr.mr_n52470384)
print v(xbgr.mr_n52470496)
print v(xbgr.mr_n52470816)
print v(xbgr.mr_n52470928)
print v(xbgr.mr_n52471248)
print v(xbgr.mr_n52471360)
print v(xbgr.mr_n52471680)
print v(xbgr.mr_n52471792)
print v(xbgr.mr_n52472112)
print v(xbgr.mr_n52472224)
print v(xbgr.mr_n52472544)
print v(xbgr.mr_n52472656)
print v(xbgr.mr_n52472976)
print v(xbgr.mr_n52473088)
print v(xbgr.mr_n52473408)
print v(xbgr.mr_n52473520)
print v(xbgr.mr_n52473840)
print v(xbgr.mr_n52473952)
print v(xbgr.mr_n52474272)
print v(xbgr.mr_n52474384)
print v(xbgr.mr_n52474704)
print v(xbgr.mr_n52474816)
print v(xbgr.mr_n52475136)
print v(xbgr.mr_n52475248)
print v(xbgr.mr_n52475568)
print v(xbgr.mr_n52475680)
print v(xbgr.mr_n52476000)
print v(xbgr.mr_n52476112)
print v(xbgr.mr_n52476432)
print v(xbgr.mr_n52476544)
print v(xbgr.mr_n52476864)
print v(xbgr.mr_n52476976)
print v(xbgr.mr_n52477296)
print v(xbgr.mr_n52477408)
print v(xbgr.mr_n52477728)
print v(xbgr.mr_n52477840)
print v(xbgr.mr_n52478160)
print v(xbgr.mr_n52478272)
print v(xbgr.mr_n52478592)
print v(xbgr.mr_n52478704)
print v(xbgr.mr_n52479024)
print v(xbgr.mr_n52479136)
print v(xbgr.mr_n52479456)
print v(xbgr.mr_n52479568)
print v(xbgr.mr_n52479888)
print v(xbgr.mr_n52480000)
print v(xbgr.mr_n52480320)
print v(xbgr.mr_n52480432)
print v(xbgr.mr_n52480752)
print v(xbgr.mr_n52480864)
print v(xbgr.mr_n52481184)
print v(xbgr.mr_n52481296)
print v(xbgr.mr_n52481616)
print v(xbgr.mr_n52481728)
print v(xbgr.mr_n52482048)
print v(xbgr.mr_n52482160)
print v(xbgr.mr_n52482480)
print v(xbgr.mr_n52482592)
print v(xbgr.mr_n52482912)
print v(xbgr.mr_n52483024)
print v(xbgr.mr_n52483344)
print v(xbgr.mr_n52483456)
print v(xbgr.mr_n52483776)
print v(xbgr.mr_n52483888)
print v(xbgr.mr_n52484208)
print v(xbgr.mr_n52484320)
print v(xbgr.mr_n52484640)
print v(xbgr.mr_n52484752)
print v(xbgr.mr_n52485072)
print v(xbgr.mr_n52485184)
print v(xbgr.mr_n52485504)
print v(xbgr.mr_n52485616)
print v(xbgr.mr_n52485936)
print v(xbgr.mr_n52486048)
print v(xbgr.mr_n52486368)
print v(xbgr.mr_n52486480)
print v(xbgr.mr_n52486800)
print v(xbgr.mr_n52486912)
print v(xbgr.mr_n52487232)
print v(xbgr.mr_n52487344)
print v(xbgr.mr_n52487664)
print v(xbgr.mr_n52487776)
print v(xbgr.mr_n52488096)
print v(xbgr.mr_n52488208)
print v(xbgr.mr_n52488528)
print v(xbgr.mr_n52488640)
print v(xbgr.mr_n52488960)
print v(xbgr.mr_n52489072)
print v(xbgr.mr_n52489392)
print v(xbgr.mr_n52489504)
print v(xbgr.mr_n52489824)
print v(xbgr.mr_n52489936)
print v(xbgr.mr_n52490256)
print v(xbgr.mr_n52490368)
print v(xbgr.mr_n52490688)
print v(xbgr.mr_n52490800)
print v(xbgr.mr_n52491120)
print v(xbgr.mr_n52491232)
print v(xbgr.mr_n52491552)
print v(xbgr.mr_n52491664)
print v(xbgr.mr_n52491984)
print v(xbgr.mr_n52492096)
print v(xbgr.mr_n52492416)
print v(xbgr.mr_n52492528)
print v(xbgr.mr_n52492848)
print v(xbgr.mr_n52492960)
print v(xbgr.mr_n52493280)
print v(xbgr.mr_n52493392)
print v(xbgr.mr_n52493712)
print v(xbgr.mr_n52493824)
print v(xbgr.mr_n52494144)
print v(xbgr.mr_n52494256)
print v(xbgr.mr_n52494576)
print v(xbgr.mr_n52494688)
print v(xbgr.mr_n52495008)
print v(xbgr.mr_n52495120)
print v(xbgr.mr_n52495440)
print v(xbgr.mr_n52495552)
print v(xbgr.mr_n52495872)
print v(xbgr.mr_n52495984)
print v(xbgr.mr_n52496304)
print v(xbgr.mr_n52496416)
print v(xbgr.mr_n52496736)
print v(xbgr.mr_n52496848)
print v(xbgr.mr_n52497168)
print v(xbgr.mr_n52497280)
print v(xbgr.mr_n52497600)
print v(xbgr.mr_n52497712)
print v(xbgr.mr_n52498032)
print v(xbgr.mr_n52498144)
print v(xbgr.mr_n52498464)
print v(xbgr.mr_n52498576)
print v(xbgr.mr_n52498896)
print v(xbgr.mr_n52499008)
print v(xbgr.mr_n52499328)
print v(xbgr.mr_n52499440)
print v(xbgr.mr_n52499760)
print v(xbgr.mr_n52499872)
print v(xbgr.mr_n52500192)
print v(xbgr.mr_n52500304)
print v(xbgr.mr_n52500624)
print v(xbgr.mr_n52500736)
print v(xbgr.mr_n52501056)
print v(xbgr.mr_n52501168)
print v(xbgr.mr_n52501488)
print v(xbgr.mr_n52501600)
print v(xbgr.mr_n52501920)
print v(xbgr.mr_n52502032)
print v(xbgr.mr_n52502352)
print v(xbgr.mr_n52502464)
print v(xbgr.mr_n52502784)
print v(xbgr.mr_n52502896)
print v(xbgr.mr_n52503216)
print v(xbgr.mr_n52503328)
print v(xbgr.mr_n52503648)
print v(xbgr.mr_n52503760)
print v(xbgr.mr_n52504080)
print v(xbgr.mr_n52504192)
print v(xbgr.mr_n52504512)
print v(xbgr.mr_n52504624)
print v(xbgr.mr_n52504944)
print v(xbgr.mr_n52505056)
print v(xbgr.mr_n52505376)
print v(xbgr.mr_n52505488)
print v(xbgr.mr_n52505808)
print v(xbgr.mr_n52505920)
print v(xbgr.mr_n52506240)
print v(xbgr.mr_n52506352)
print v(xbgr.mr_n52506672)
print v(xbgr.mr_n52506784)
print v(xbgr.mr_n52507104)
print v(xbgr.mr_n52507216)
print v(xbgr.mr_n52507536)
print v(xbgr.mr_n52507648)
print v(xbgr.mr_n52507968)
print v(xbgr.mr_n52508080)
print v(xbgr.mr_n52508400)
print v(xbgr.mr_n52508512)
print v(xbgr.mr_n52508832)
print v(xbgr.mr_n52508944)
print v(xbgr.mr_n52509264)
print v(xbgr.mr_n52509376)
print v(xbgr.mr_n52509696)
print v(xbgr.mr_n52509808)
print v(xbgr.mr_n52510128)
print v(xbgr.mr_n52510240)
print v(xbgr.mr_n52510560)
print v(xbgr.mr_n52510672)
print v(xbgr.mr_n52510992)
print v(xbgr.mr_n52511104)
print v(xbgr.mr_n52511424)
print v(xbgr.mr_n52511536)
print v(xbgr.mr_n52511856)
print v(xbgr.mr_n52511968)
print v(xbgr.mr_n52512288)
print v(xbgr.mr_n52512400)
print v(xbgr.mr_n52512720)
print v(xbgr.mr_n52512832)
print v(xbgr.mr_n52513152)
print v(xbgr.mr_n52513264)
print v(xbgr.mr_n52513584)
print v(xbgr.mr_n52513696)
print v(xbgr.mr_n52514016)
print v(xbgr.mr_n52514128)
print v(xbgr.mr_n52514448)
print v(xbgr.mr_n52514560)
print v(xbgr.mr_n52514880)
print v(xbgr.mr_n52514992)
print v(xbgr.mr_n52515312)
print v(xbgr.mr_n52515424)
print v(xbgr.mr_n52515744)
print v(xbgr.mr_n52515856)
print v(xbgr.mr_n52516176)
print v(xbgr.mr_n52516288)
print v(xbgr.mr_n52516608)
print v(xbgr.mr_n52516720)
print v(xbgr.mr_n52517040)
print v(xbgr.mr_n52517152)
print v(xbgr.mr_n52517472)
print v(xbgr.mr_n52517584)
print v(xbgr.mr_n52517904)
print v(xbgr.mr_n52518016)
print v(xbgr.mr_n52518336)
print v(xbgr.mr_n52518448)
print v(xbgr.mr_n52518768)
print v(xbgr.mr_n52518880)
print v(xbgr.mr_n52519200)
print v(xbgr.mr_n52519312)
print v(xbgr.mr_n52519632)
print v(xbgr.mr_n52519744)
print v(xbgr.mr_n52520064)
print v(xbgr.mr_n52520176)
print v(xbgr.mr_n52520496)
print v(xbgr.mr_n52520608)
print v(xbgr.mr_n52520928)
print v(xbgr.mr_n52521040)
print v(xbgr.mr_n52521360)
print v(xbgr.mr_n52521472)
print v(xbgr.mr_n52521792)
print v(xbgr.mr_n52521904)
print v(xbgr.mr_n52522224)
print v(xbgr.mr_n52522336)
print v(xbgr.mr_n52522656)
print v(xbgr.mr_n52522768)
print v(xbgr.mr_n52523088)
print v(xbgr.mr_n52523200)
print v(xbgr.mr_n52523520)
print v(xbgr.mr_n52523632)
print v(xbgr.mr_n52523952)
print v(xbgr.mr_n52524064)
print v(xbgr.mr_n52524384)
print v(xbgr.mr_n52524496)
print v(xbgr.mr_n52524816)
print v(xbgr.mr_n52524928)
print v(xbgr.mr_n52525248)
print v(xbgr.mr_n52525360)
print v(xbgr.mr_n52525680)
print v(xbgr.mr_n52525792)
print v(xbgr.mr_n52526112)
print v(xbgr.mr_n52526224)
print v(xbgr.mr_n52526544)
print v(xbgr.mr_n52526656)
print v(xbgr.mr_n52526976)
print v(xbgr.mr_n52527088)
print v(xbgr.mr_n52527408)
print v(xbgr.mr_n52527520)
print v(xbgr.mr_n52527840)
print v(xbgr.mr_n52527952)
print v(xbgr.mr_n52528272)
print v(xbgr.mr_n52528384)
print v(xbgr.mr_n52528704)
print v(xbgr.mr_n52528816)
print v(xbgr.mr_n52529136)
print v(xbgr.mr_n52529248)
print v(xbgr.mr_n52529568)
print v(xbgr.mr_n52529680)
print v(xbgr.mr_n52530000)
print v(xbgr.mr_n52530112)
print v(xbgr.mr_n52530432)
print v(xbgr.mr_n52530544)
print v(xbgr.mr_n52530864)
print v(xbgr.mr_n52530976)
print v(xbgr.mr_n52531296)
print v(xbgr.mr_n52531408)
print v(xbgr.mr_n52531728)
print v(xbgr.mr_n52531840)
print v(xbgr.mr_n52532160)
print v(xbgr.mr_n52532272)
print v(xbgr.mr_n52532592)
print v(xbgr.mr_n52532704)
print v(xbgr.mr_n52533024)
print v(xbgr.mr_n52533136)
print v(xbgr.mr_n52533456)
print v(xbgr.mr_n52533568)
print v(xbgr.mr_n52533888)
print v(xbgr.mr_n52534000)
print v(xbgr.mr_n52534320)
print v(xbgr.mr_n52534432)
print v(xbgr.mr_n52534752)
print v(xbgr.mr_n52534864)
print v(xbgr.mr_n52535184)
print v(xbgr.mr_n52535296)
print v(xbgr.mr_n52535616)
print v(xbgr.mr_n52535728)
print v(xbgr.mr_n52536048)
print v(xbgr.mr_n52536160)
print v(xbgr.mr_n52536480)
print v(xbgr.mr_n52536592)
print v(xbgr.mr_n52536912)
print v(xbgr.mr_n52537024)
print v(xbgr.mr_n52537344)
print v(xbgr.mr_n52537456)
print v(xbgr.mr_n52537776)
print v(xbgr.mr_n52537888)
print v(xbgr.mr_n52538208)
print v(xbgr.mr_n52538320)
print v(xbgr.mr_n52538640)
print v(xbgr.mr_n52538752)
print v(xbgr.mr_n52539072)
print v(xbgr.mr_n52539184)
print v(xbgr.mr_n52539504)
print v(xbgr.mr_n52539616)
print v(xbgr.mr_n52539936)
print v(xbgr.mr_n52540048)
print v(xbgr.mr_n52540368)
print v(xbgr.mr_n52540480)
print v(xbgr.mr_n52540800)
print v(xbgr.mr_n52540912)
print v(xbgr.mr_n52541232)
print v(xbgr.mr_n52541344)
print v(xbgr.mr_n52541664)
print v(xbgr.mr_n52541776)
print v(xbgr.mr_n52542096)
print v(xbgr.mr_n52542208)
print v(xbgr.mr_n52542528)
print v(xbgr.mr_n52542640)
print v(xbgr.mr_n52542960)
print v(xbgr.mr_n52543072)
print v(xbgr.mr_n52543392)
print v(xbgr.mr_n52543504)
print v(xbgr.mr_n52543824)
print v(xbgr.mr_n52543936)
print v(xbgr.mr_n52544256)
print v(xbgr.mr_n52544368)
print v(xbgr.mr_n52544688)
print v(xbgr.mr_n52544800)
print v(xbgr.mr_n52545120)
print v(xbgr.mr_n52545232)
print v(xbgr.mr_n52545552)
print v(xbgr.mr_n52545664)
print v(xbgr.mr_n52545984)
print v(xbgr.mr_n52546096)
print v(xbgr.mr_n52546416)
print v(xbgr.mr_n52546528)
print v(xbgr.mr_n52546848)
print v(xbgr.mr_n52546960)
print v(xbgr.mr_n52547280)
print v(xbgr.mr_n52547392)
print v(xbgr.mr_n52547712)
print v(xbgr.mr_n52547824)
print v(xbgr.mr_n52548144)
print v(xbgr.mr_n52548256)
print v(xbgr.mr_n52548576)
print v(xbgr.mr_n52548688)
print v(xbgr.mr_n52549008)
print v(xbgr.mr_n52549120)
print v(xbgr.mr_n52549440)
print v(xbgr.mr_n52549552)
print v(xbgr.mr_n52549872)
print v(xbgr.mr_n52549984)
print v(xbgr.mr_n52550304)
print v(xbgr.mr_n52550416)
print v(xbgr.mr_n52550736)
print v(xbgr.mr_n52550848)
print v(xbgr.mr_n52551168)
print v(xbgr.mr_n52551280)
print v(xbgr.mr_n52551600)
print v(xbgr.mr_n52551712)
print v(xbgr.mr_n52552032)
print v(xbgr.mr_n52552144)
print v(xbgr.mr_n52552464)
print v(xbgr.mr_n52552576)
print v(xbgr.mr_n52552896)
print v(xbgr.mr_n52553008)
print v(xbgr.mr_n52553328)
print v(xbgr.mr_n52553440)
print v(xbgr.mr_n52553760)
print v(xbgr.mr_n52553872)
print v(xbgr.mr_n52554192)
print v(xbgr.mr_n52554304)
print v(xbgr.mr_n52554624)
print v(xbgr.mr_n52554736)
print v(xbgr.mr_n52555056)
print v(xbgr.mr_n52555168)
print v(xbgr.mr_n52555488)
print v(xbgr.mr_n52555600)
print v(xbgr.mr_n52555920)
print v(xbgr.mr_n52556032)
print v(xbgr.mr_n52556352)
print v(xbgr.mr_n52556464)
print v(xbgr.mr_n52556784)
print v(xbgr.mr_n52556896)
print v(xbgr.mr_n52557216)
print v(xbgr.mr_n52557328)
print v(xbgr.mr_n52557648)
print v(xbgr.mr_n52557760)
print v(xbgr.mr_n52558080)
print v(xbgr.mr_n52558192)
print v(xbgr.mr_n52558512)
print v(xbgr.mr_n52558624)
print v(xbgr.mr_n52558944)
print v(xbgr.mr_n52559056)
print v(xbgr.mr_n52559376)
print v(xbgr.mr_n52559488)
print v(xbgr.mr_n52559808)
print v(xbgr.mr_n52559920)
print v(xbgr.mr_n52560240)
print v(xbgr.mr_n52560352)
print v(xbgr.mr_n52560672)
print v(xbgr.mr_n52560784)
print v(xbgr.mr_n52561104)
print v(xbgr.mr_n52561216)
print v(xbgr.mr_n52561536)
print v(xbgr.mr_n52561648)
print v(xbgr.mr_n52561968)
print v(xbgr.mr_n52562080)
print v(xbgr.mr_n52562400)
print v(xbgr.mr_n52562512)
print v(xbgr.mr_n52562832)
print v(xbgr.mr_n52562944)
print v(xbgr.mr_n52563264)
print v(xbgr.mr_n52563376)
print v(xbgr.mr_n52563696)
print v(xbgr.mr_n52563808)
print v(xbgr.mr_n52564128)
print v(xbgr.mr_n52564240)
print v(xbgr.mr_n52564560)
print v(xbgr.mr_n52564672)
print v(xbgr.mr_n52564992)
print v(xbgr.mr_n52565104)
print v(xbgr.mr_n52565424)
print v(xbgr.mr_n52565536)
print v(xbgr.mr_n52565856)
print v(xbgr.mr_n52565968)
print v(xbgr.mr_n52566288)
print v(xbgr.mr_n52566400)
print v(xbgr.mr_n52566720)
print v(xbgr.mr_n52566832)
print v(xbgr.mr_n52567152)
print v(xbgr.mr_n52567264)
print v(xbgr.mr_n52567584)
print v(xbgr.mr_n52567696)
print v(xbgr.mr_n52568016)
print v(xbgr.mr_n52568128)
print v(xbgr.mr_n52568448)
print v(xbgr.mr_n52568560)
print v(xbgr.mr_n52568880)
print v(xbgr.mr_n52568992)
print v(xbgr.mr_n52569312)
print v(xbgr.mr_n52569424)
print v(xbgr.mr_n52569744)
print v(xbgr.mr_n52569856)
print v(xbgr.mr_n52570176)
print v(xbgr.mr_n52570288)
print v(xbgr.mr_n52570608)
print v(xbgr.mr_n52570720)
print v(xbgr.mr_n52571040)
print v(xbgr.mr_n52571152)
print v(xbgr.mr_n52571472)
print v(xbgr.mr_n52571584)
print v(xbgr.mr_n52571904)
print v(xbgr.mr_n52572016)
print v(xbgr.mr_n52572336)
print v(xbgr.mr_n52572448)
print v(xbgr.mr_n52572768)
print v(xbgr.mr_n52572880)
print v(xbgr.mr_n52573200)
print v(xbgr.mr_n52573312)
print v(xbgr.mr_n52573632)
print v(xbgr.mr_n52573744)
print v(xbgr.mr_n52574064)
print v(xbgr.mr_n52574176)
print v(xbgr.mr_n52574496)
print v(xbgr.mr_n52574608)
print v(xbgr.mr_n52574928)
print v(xbgr.mr_n52575040)
print v(xbgr.mr_n52575360)
print v(xbgr.mr_n52575472)
print v(xbgr.mr_n52575792)
print v(xbgr.mr_n52575904)
print v(xbgr.mr_n52576224)
print v(xbgr.mr_n52576336)
print v(xbgr.mr_n52576656)
print v(xbgr.mr_n52576768)
print v(xbgr.mr_n52577088)
print v(xbgr.mr_n52577200)
print v(xbgr.mr_n52577520)
print v(xbgr.mr_n52577632)
print v(xbgr.mr_n52577952)
print v(xbgr.mr_n52578064)
print v(xbgr.mr_n52578384)
print v(xbgr.mr_n52578496)
print v(xbgr.mr_n52578816)
print v(xbgr.mr_n52578928)
print v(xbgr.mr_n52579248)
print v(xbgr.mr_n52579360)
print v(xbgr.mr_n52579680)
print v(xbgr.mr_n52579792)
print v(xbgr.mr_n52580112)
print v(xbgr.mr_n52580224)
print v(xbgr.mr_n52580544)
print v(xbgr.mr_n52580656)
print v(xbgr.mr_n52580976)
print v(xbgr.mr_n52581088)
print v(xbgr.mr_n52581408)
print v(xbgr.mr_n52581520)
print v(xbgr.mr_n52581840)
print v(xbgr.mr_n52581952)
print v(xbgr.mr_n52582272)
print v(xbgr.mr_n52582384)
print v(xbgr.mr_n52582704)
print v(xbgr.mr_n52582816)
print v(xbgr.mr_n52583136)
print v(xbgr.mr_n52583248)
print v(xbgr.mr_n52583568)
print v(xbgr.mr_n52583680)
print v(xbgr.mr_n52584000)
print v(xbgr.mr_n52584112)
print v(xbgr.mr_n52584432)
print v(xbgr.mr_n52584544)
print v(xbgr.mr_n52584864)
print v(xbgr.mr_n52584976)
print v(xbgr.mr_n52585296)
print v(xbgr.mr_n52585408)
print v(xbgr.mr_n52585728)
print v(xbgr.mr_n52585840)
print v(xbgr.mr_n52586144)
print v(xbgr.mr_n52586256)
print v(xbgr.mr_n52586576)
print v(xbgr.mr_n52586688)
print v(xbgr.mr_n52587008)
print v(xbgr.mr_n52587120)
print v(xbgr.mr_n52587440)
print v(xbgr.mr_n52587552)
print v(xbgr.mr_n52587872)
print v(xbgr.mr_n52587984)
print v(xbgr.mr_n52588304)
print v(xbgr.mr_n52588416)
print v(xbgr.mr_n52588736)
print v(xbgr.mr_n52588848)
print v(xbgr.mr_n52589168)
print v(xbgr.mr_n52589280)
print v(xbgr.mr_n52589600)
print v(xbgr.mr_n52589712)
print v(xbgr.mr_n52590032)
print v(xbgr.mr_n52590144)
print v(xbgr.mr_n52590464)
print v(xbgr.mr_n52590576)
print v(xbgr.mr_n52590896)
print v(xbgr.mr_n52591008)
print v(xbgr.mr_n52591328)
print v(xbgr.mr_n52591440)
print v(xbgr.mr_n52591760)
print v(xbgr.mr_n52591872)
print v(xbgr.mr_n52592192)
print v(xbgr.mr_n52592304)
print v(xbgr.mr_n52592624)
print v(xbgr.mr_n52592736)
print v(xbgr.mr_n52593056)
print v(xbgr.mr_n52593168)
print v(xbgr.mr_n52593488)
print v(xbgr.mr_n52593600)
print v(xbgr.mr_n52593920)
print v(xbgr.mr_n52594032)
print v(xbgr.mr_n52594352)
print v(xbgr.mr_n52594464)
print v(xbgr.mr_n52594784)
print v(xbgr.mr_n52594896)
print v(xbgr.mr_n52595216)
print v(xbgr.mr_n52595328)
print v(xbgr.mr_n52595648)
print v(xbgr.mr_n52595760)
print v(xbgr.mr_n52596080)
print v(xbgr.mr_n52596192)
print v(xbgr.mr_n52596512)
print v(xbgr.mr_n52596624)
print v(xbgr.mr_n52596944)
print v(xbgr.mr_n52597056)
print v(xbgr.mr_n52597376)
print v(xbgr.mr_n52597488)
print v(xbgr.mr_n52597808)
print v(xbgr.mr_n52597920)
print v(xbgr.mr_n52598240)
print v(xbgr.mr_n52598352)
print v(xbgr.mr_n52598672)
print v(xbgr.mr_n52598784)
print v(xbgr.mr_n52599104)
print v(xbgr.mr_n52599216)
print v(xbgr.mr_n52599536)
print v(xbgr.mr_n52599648)
print v(xbgr.mr_n52599968)
print v(xbgr.mr_n52600080)
print v(xbgr.mr_n52600400)
print v(xbgr.mr_n52600512)
print v(xbgr.mr_n52600832)
print v(xbgr.mr_n52600944)
print v(xbgr.mr_n52601264)
print v(xbgr.mr_n52601376)
print v(xbgr.mr_n52601696)
print v(xbgr.mr_n52601808)
print v(xbgr.mr_n52602128)
print v(xbgr.mr_n52602240)
print v(xbgr.mr_n52602560)
print v(xbgr.mr_n52602672)
print v(xbgr.mr_n52602992)
print v(xbgr.mr_n52603104)
print v(xbgr.mr_n52603424)
print v(xbgr.mr_n52603536)
print v(xbgr.mr_n52603856)
print v(xbgr.mr_n52603968)
print v(xbgr.mr_n52604288)
print v(xbgr.mr_n52604400)
print v(xbgr.mr_n52604720)
print v(xbgr.mr_n52604832)
print v(xbgr.mr_n52605152)
print v(xbgr.mr_n52605264)
print v(xbgr.mr_n52605584)
print v(xbgr.mr_n52605696)
print v(xbgr.mr_n52606016)
print v(xbgr.mr_n52606128)
print v(xbgr.mr_n52606448)
print v(xbgr.mr_n52606560)
print v(xbgr.mr_n52606880)
print v(xbgr.mr_n52606992)
print v(xbgr.mr_n52607312)
print v(xbgr.mr_n52607424)
print v(xbgr.mr_n52607744)
print v(xbgr.mr_n52607856)
print v(xbgr.mr_n52608176)
print v(xbgr.mr_n52608288)
print v(xbgr.mr_n52608608)
print v(xbgr.mr_n52608720)
print v(xbgr.mr_n52609040)
print v(xbgr.mr_n52609152)
print v(xbgr.mr_n52609472)
print v(xbgr.mr_n52609584)
print v(xbgr.mr_n52609904)
print v(xbgr.mr_n52610016)
print v(xbgr.mr_n52610336)
print v(xbgr.mr_n52610448)
print v(xbgr.mr_n52610768)
print v(xbgr.mr_n52610880)
print v(xbgr.mr_n52611200)
print v(xbgr.mr_n52611312)
print v(xbgr.mr_n52611632)
print v(xbgr.mr_n52611744)
print v(xbgr.mr_n52612064)
print v(xbgr.mr_n52612176)
print v(xbgr.mr_n52612496)
print v(xbgr.mr_n52612608)
print v(xbgr.mr_n52612928)
print v(xbgr.mr_n52613040)
print v(xbgr.mr_n52613360)
print v(xbgr.mr_n52613472)
print v(xbgr.mr_n52613792)
print v(xbgr.mr_n52613904)
print v(xbgr.mr_n52614224)
print v(xbgr.mr_n52614336)
print v(xbgr.mr_n52614656)
print v(xbgr.mr_n52614768)
print v(xbgr.mr_n52615088)
print v(xbgr.mr_n52615200)
print v(xbgr.mr_n52615520)
print v(xbgr.mr_n52615632)
print v(xbgr.mr_n52615952)
print v(xbgr.mr_n52616064)
print v(xbgr.mr_n52616384)
print v(xbgr.mr_n52616496)
print v(xbgr.mr_n52616816)
print v(xbgr.mr_n52616928)
print v(xbgr.mr_n52617248)
print v(xbgr.mr_n52617360)
print v(xbgr.mr_n52617680)
print v(xbgr.mr_n52617792)
print v(xbgr.mr_n52618112)
print v(xbgr.mr_n52618224)
print v(xbgr.mr_n52618544)
print v(xbgr.mr_n52618656)
print v(xbgr.mr_n52618976)
print v(xbgr.mr_n52619088)
print v(xbgr.mr_n52619408)
print v(xbgr.mr_n52619520)
print v(xbgr.mr_n52619840)
print v(xbgr.mr_n52619952)
print v(xbgr.mr_n52620272)
print v(xbgr.mr_n52620384)
print v(xbgr.mr_n52620704)
print v(xbgr.mr_n52620816)
print v(xbgr.mr_n52621136)
print v(xbgr.mr_n52621248)
print v(xbgr.mr_n52621568)
print v(xbgr.mr_n52621680)
print v(xbgr.mr_n52622000)
print v(xbgr.mr_n52622112)
print v(xbgr.mr_n52622432)
print v(xbgr.mr_n52622544)
print v(xbgr.mr_n52622864)
print v(xbgr.mr_n52622976)
print v(xbgr.mr_n52623296)
print v(xbgr.mr_n52623408)
print v(xbgr.mr_n52623728)
print v(xbgr.mr_n52623840)
print v(xbgr.mr_n52624160)
print v(xbgr.mr_n52624272)
print v(xbgr.mr_n52624592)
print v(xbgr.mr_n52624704)
print v(xbgr.mr_n52625024)
print v(xbgr.mr_n52625136)
print v(xbgr.mr_n52625456)
print v(xbgr.mr_n52625568)
print v(xbgr.mr_n52625888)
print v(xbgr.mr_n52626000)
print v(xbgr.mr_n52626320)
print v(xbgr.mr_n52626432)
print v(xbgr.mr_n52626752)
print v(xbgr.mr_n52626864)
print v(xbgr.mr_n52627184)
print v(xbgr.mr_n52627296)
print v(xbgr.mr_n52627616)
print v(xbgr.mr_n52627728)
print v(xbgr.mr_n52628048)
print v(xbgr.mr_n52628160)
print v(xbgr.mr_n52628480)
print v(xbgr.mr_n52628592)
print v(xbgr.mr_n52628912)
print v(xbgr.mr_n52629024)
print v(xbgr.mr_n52629344)
print v(xbgr.mr_n52629456)
print v(xbgr.mr_n52629776)
print v(xbgr.mr_n52629888)
print v(xbgr.mr_n52630208)
print v(xbgr.mr_n52630320)
print v(xbgr.mr_n52630640)
print v(xbgr.mr_n52630752)
print v(xbgr.mr_n52631072)
print v(xbgr.mr_n52631184)
print v(xbgr.mr_n52631504)
print v(xbgr.mr_n52631616)
print v(xbgr.mr_n52631936)
print v(xbgr.mr_n52632048)
print v(xbgr.mr_n52632368)
print v(xbgr.mr_n52632480)
print v(xbgr.mr_n52632800)
print v(xbgr.mr_n52632912)
print v(xbgr.mr_n52633232)
print v(xbgr.mr_n52633344)
print v(xbgr.mr_n52633664)
print v(xbgr.mr_n52633776)
print v(xbgr.mr_n52634096)
print v(xbgr.mr_n52634208)
print v(xbgr.mr_n52634528)
print v(xbgr.mr_n52634640)
print v(xbgr.mr_n52634960)
print v(xbgr.mr_n52635072)
print v(xbgr.mr_n52635392)
print v(xbgr.mr_n52635504)
print v(xbgr.mr_n52635824)
print v(xbgr.mr_n52635936)
print v(xbgr.mr_n52636256)
print v(xbgr.mr_n52636368)
print v(xbgr.mr_n52636688)
print v(xbgr.mr_n52636800)
print v(xbgr.mr_n52637120)
print v(xbgr.mr_n52637232)
print v(xbgr.mr_n52637552)
print v(xbgr.mr_n52637664)
print v(xbgr.mr_n52637984)
print v(xbgr.mr_n52638096)
print v(xbgr.mr_n52638416)
print v(xbgr.mr_n52638528)
print v(xbgr.mr_n52638848)
print v(xbgr.mr_n52638960)
print v(xbgr.mr_n52639280)
print v(xbgr.mr_n52639392)
print v(xbgr.mr_n52639712)
print v(xbgr.mr_n52639824)
print v(xbgr.mr_n52640144)
print v(xbgr.mr_n52640256)
print v(xbgr.mr_n52640576)
print v(xbgr.mr_n52640688)
print v(xbgr.mr_n52641008)
print v(xbgr.mr_n52641120)
print v(xbgr.mr_n52641440)
print v(xbgr.mr_n52641552)
print v(xbgr.mr_n52641872)
print v(xbgr.mr_n52641984)
print v(xbgr.mr_n52642304)
print v(xbgr.mr_n52642416)
print v(xbgr.mr_n52642736)
print v(xbgr.mr_n52642848)
print v(xbgr.mr_n52643168)
print v(xbgr.mr_n52643280)
print v(xbgr.mr_n52643600)
print v(xbgr.mr_n52643712)
print v(xbgr.mr_n52644032)
print v(xbgr.mr_n52644144)
print v(xbgr.mr_n52644464)
print v(xbgr.mr_n52644576)
print v(xbgr.mr_n52644896)
print v(xbgr.mr_n52645008)
print v(xbgr.mr_n52645328)
print v(xbgr.mr_n52645440)
print v(xbgr.mr_n52645760)
print v(xbgr.mr_n52645872)
print v(xbgr.mr_n52646192)
print v(xbgr.mr_n52646304)
print v(xbgr.mr_n52646624)
print v(xbgr.mr_n52646736)
print v(xbgr.mr_n52647056)
print v(xbgr.mr_n52647168)
print v(xbgr.mr_n52647488)
print v(xbgr.mr_n52647600)
print v(xbgr.mr_n52647920)
print v(xbgr.mr_n52648032)
print v(xbgr.mr_n52648352)
print v(xbgr.mr_n52648464)
print v(xbgr.mr_n52648784)
print v(xbgr.mr_n52648896)
print v(xbgr.mr_n52649216)
print v(xbgr.mr_n52649328)
print v(xbgr.mr_n52649648)
print v(xbgr.mr_n52649760)
print v(xbgr.mr_n52650080)
print v(xbgr.mr_n52650192)
print v(xbgr.mr_n52650512)
print v(xbgr.mr_n52650624)
print v(xbgr.mr_n52650944)
print v(xbgr.mr_n52651056)
print v(xbgr.mr_n52651376)
print v(xbgr.mr_n52651488)
print v(xbgr.mr_n52651808)
print v(xbgr.mr_n52651920)
print v(xbgr.mr_n52652240)
print v(xbgr.mr_n52652352)
print v(xbgr.mr_n52652672)
print v(xbgr.mr_n52652784)
print v(xbgr.mr_n52653104)
print v(xbgr.mr_n52653216)
print v(xbgr.mr_n52653536)
print v(xbgr.mr_n52653648)
print v(xbgr.mr_n52653968)
print v(xbgr.mr_n52654080)
print v(xbgr.mr_n52654400)
print v(xbgr.mr_n52654512)
print v(xbgr.mr_n52654832)
print v(xbgr.mr_n52654944)
print v(xbgr.mr_n52655264)
print v(xbgr.mr_n52655376)
print v(xbgr.mr_n52655696)
print v(xbgr.mr_n52655808)
print v(xbgr.mr_n52656128)
print v(xbgr.mr_n52656240)
print v(xbgr.mr_n52656560)
print v(xbgr.mr_n52656672)
print v(xbgr.mr_n52656992)
print v(xbgr.mr_n52657104)
print v(xbgr.mr_n52657424)
print v(xbgr.mr_n52657536)
print v(xbgr.mr_n52657856)
print v(xbgr.mr_n52657968)
print v(xbgr.mr_n52658288)
print v(xbgr.mr_n52658400)
print v(xbgr.mr_n52658720)
print v(xbgr.mr_n52658832)
print v(xbgr.mr_n52659152)
print v(xbgr.mr_n52659264)
print v(xbgr.mr_n52659584)
print v(xbgr.mr_n52659696)
print v(xbgr.mr_n52660016)
print v(xbgr.mr_n52660128)
print v(xbgr.mr_n52660448)
print v(xbgr.mr_n52660560)
print v(xbgr.mr_n52660880)
print v(xbgr.mr_n52660992)
print v(xbgr.mr_n52661312)
print v(xbgr.mr_n52661424)
print v(xbgr.mr_n52661744)
print v(xbgr.mr_n52661856)
print v(xbgr.mr_n52662176)
print v(xbgr.mr_n52662288)
print v(xbgr.mr_n52662608)
print v(xbgr.mr_n52662720)
print v(xbgr.mr_n52663040)
print v(xbgr.mr_n52663152)
print v(xbgr.mr_n52663472)
print v(xbgr.mr_n52663584)
print v(xbgr.mr_n52663904)
print v(xbgr.mr_n52664016)
print v(xbgr.mr_n52664336)
print v(xbgr.mr_n52664448)
print v(xbgr.mr_n52664768)
print v(xbgr.mr_n52664880)
print v(xbgr.mr_n52665200)
print v(xbgr.mr_n52665312)
print v(xbgr.mr_n52665632)
print v(xbgr.mr_n52665744)
print v(xbgr.mr_n52666064)
print v(xbgr.mr_n52666176)
print v(xbgr.mr_n52666496)
print v(xbgr.mr_n52666608)
print v(xbgr.mr_n52666928)
print v(xbgr.mr_n52667040)
print v(xbgr.mr_n52667360)
print v(xbgr.mr_n52667472)
print v(xbgr.mr_n52667792)
print v(xbgr.mr_n52667904)
print v(xbgr.mr_n52668224)
print v(xbgr.mr_n52668336)
print v(xbgr.mr_n52668656)
print v(xbgr.mr_n52668768)
print v(xbgr.mr_n52669088)
print v(xbgr.mr_n52669200)
print v(xbgr.mr_n52669520)
print v(xbgr.mr_n52669632)
print v(xbgr.mr_n52669952)
print v(xbgr.mr_n52670064)
print v(xbgr.mr_n52670384)
print v(xbgr.mr_n52670496)
print v(xbgr.mr_n52670816)
print v(xbgr.mr_n52670928)
print v(xbgr.mr_n52671248)
print v(xbgr.mr_n52671360)
print v(xbgr.mr_n52671680)
print v(xbgr.mr_n52671792)
print v(xbgr.mr_n52672112)
print v(xbgr.mr_n52672224)
print v(xbgr.mr_n52672544)
print v(xbgr.mr_n52672656)
print v(xbgr.mr_n52672976)
print v(xbgr.mr_n52673088)
print v(xbgr.mr_n52673408)
print v(xbgr.mr_n52673520)
print v(xbgr.mr_n52673840)
print v(xbgr.mr_n52673952)
print v(xbgr.mr_n52674272)
print v(xbgr.mr_n52674384)
print v(xbgr.mr_n52674704)
print v(xbgr.mr_n52674816)
print v(xbgr.mr_n52675136)
print v(xbgr.mr_n52675248)
print v(xbgr.mr_n52675568)
print v(xbgr.mr_n52675680)
print v(xbgr.mr_n52676000)
print v(xbgr.mr_n52676112)
print v(xbgr.mr_n52676432)
print v(xbgr.mr_n52676544)
print v(xbgr.mr_n52676864)
print v(xbgr.mr_n52676976)
print v(xbgr.mr_n52677296)
print v(xbgr.mr_n52677408)
print v(xbgr.mr_n52677728)
print v(xbgr.mr_n52677840)
print v(xbgr.mr_n52678160)
print v(xbgr.mr_n52678272)
print v(xbgr.mr_n52678592)
print v(xbgr.mr_n52678704)
print v(xbgr.mr_n52679024)
print v(xbgr.mr_n52679136)
print v(xbgr.mr_n52679456)
print v(xbgr.mr_n52679568)
print v(xbgr.mr_n52679888)
print v(xbgr.mr_n52680000)
print v(xbgr.mr_n52680320)
print v(xbgr.mr_n52680432)
print v(xbgr.mr_n52680752)
print v(xbgr.mr_n52680864)
print v(xbgr.mr_n52681184)
print v(xbgr.mr_n52681296)
print v(xbgr.mr_n52681616)
print v(xbgr.mr_n52681728)
print v(xbgr.mr_n52682048)
print v(xbgr.mr_n52682160)
print v(xbgr.mr_n52682480)
print v(xbgr.mr_n52682592)
print v(xbgr.mr_n52682912)
print v(xbgr.mr_n52683024)
print v(xbgr.mr_n52683344)
print v(xbgr.mr_n52683456)
print v(xbgr.mr_n52683776)
print v(xbgr.mr_n52683888)
print v(xbgr.mr_n52684208)
print v(xbgr.mr_n52684320)
print v(xbgr.mr_n52684640)
print v(xbgr.mr_n52684752)
print v(xbgr.mr_n52685072)
print v(xbgr.mr_n52685184)
print v(xbgr.mr_n52685504)
print v(xbgr.mr_n52685616)
print v(xbgr.mr_n52685936)
print v(xbgr.mr_n52686048)
print v(xbgr.mr_n52686368)
print v(xbgr.mr_n52686480)
print v(xbgr.mr_n52686800)
print v(xbgr.mr_n52686912)
print v(xbgr.mr_n52687232)
print v(xbgr.mr_n52687344)
print v(xbgr.mr_n52687664)
print v(xbgr.mr_n52687776)
print v(xbgr.mr_n52688096)
print v(xbgr.mr_n52688208)
print v(xbgr.mr_n52688528)
print v(xbgr.mr_n52688640)
print v(xbgr.mr_n52688960)
print v(xbgr.mr_n52689072)
print v(xbgr.mr_n52689392)
print v(xbgr.mr_n52689504)
print v(xbgr.mr_n52689824)
print v(xbgr.mr_n52689936)
print v(xbgr.mr_n52690256)
print v(xbgr.mr_n52690368)
print v(xbgr.mr_n52690688)
print v(xbgr.mr_n52690800)
print v(xbgr.mr_n52691120)
print v(xbgr.mr_n52691232)
print v(xbgr.mr_n52691552)
print v(xbgr.mr_n52691664)
print v(xbgr.mr_n52691984)
print v(xbgr.mr_n52692096)
print v(xbgr.mr_n52692416)
print v(xbgr.mr_n52692528)
print v(xbgr.mr_n52692848)
print v(xbgr.mr_n52692960)
print v(xbgr.mr_n52693280)
print v(xbgr.mr_n52693392)
print v(xbgr.mr_n52693712)
print v(xbgr.mr_n52693824)
print v(xbgr.mr_n52694144)
print v(xbgr.mr_n52694256)
print v(xbgr.mr_n52694576)
print v(xbgr.mr_n52694688)
print v(xbgr.mr_n52695008)
print v(xbgr.mr_n52695120)
print v(xbgr.mr_n52695440)
print v(xbgr.mr_n52695552)
print v(xbgr.mr_n52695872)
print v(xbgr.mr_n52695984)
print v(xbgr.mr_n52696304)
print v(xbgr.mr_n52696416)
print v(xbgr.mr_n52696736)
print v(xbgr.mr_n52696848)
print v(xbgr.mr_n52697168)
print v(xbgr.mr_n52697280)
print v(xbgr.mr_n52697600)
print v(xbgr.mr_n52697712)
print v(xbgr.mr_n52698032)
print v(xbgr.mr_n52698144)
print v(xbgr.mr_n52698464)
print v(xbgr.mr_n52698576)
print v(xbgr.mr_n52698896)
print v(xbgr.mr_n52699008)
print v(xbgr.mr_n52699328)
print v(xbgr.mr_n52699440)
print v(xbgr.mr_n52699760)
print v(xbgr.mr_n52699872)
print v(xbgr.mr_n52700192)
print v(xbgr.mr_n52700304)
print v(xbgr.mr_n52700624)
print v(xbgr.mr_n52700736)
print v(xbgr.mr_n52701056)
print v(xbgr.mr_n52701168)
print v(xbgr.mr_n52701488)
print v(xbgr.mr_n52701600)
print v(xbgr.mr_n52701920)
print v(xbgr.mr_n52702032)
print v(xbgr.mr_n52702352)
print v(xbgr.mr_n52702464)
print v(xbgr.mr_n52702784)
print v(xbgr.mr_n52702896)
print v(xbgr.mr_n52703216)
print v(xbgr.mr_n52703328)
print v(xbgr.mr_n52703648)
print v(xbgr.mr_n52703760)
print v(xbgr.mr_n52704080)
print v(xbgr.mr_n52704192)
print v(xbgr.mr_n52704512)
print v(xbgr.mr_n52704624)
print v(xbgr.mr_n52704944)
print v(xbgr.mr_n52705056)
print v(xbgr.mr_n52705376)
print v(xbgr.mr_n52705488)
print v(xbgr.mr_n52705808)
print v(xbgr.mr_n52705920)
print v(xbgr.mr_n52706240)
print v(xbgr.mr_n52706352)
print v(xbgr.mr_n52706672)
print v(xbgr.mr_n52706784)
print v(xbgr.mr_n52707104)
print v(xbgr.mr_n52707216)
print v(xbgr.mr_n52707536)
print v(xbgr.mr_n52707648)
print v(xbgr.mr_n52707968)
print v(xbgr.mr_n52708080)
print v(xbgr.mr_n52708400)
print v(xbgr.mr_n52708512)
print v(xbgr.mr_n52708832)
print v(xbgr.mr_n52708944)
print v(xbgr.mr_n52709264)
print v(xbgr.mr_n52709376)
print v(xbgr.mr_n52709696)
print v(xbgr.mr_n52709808)
print v(xbgr.mr_n52710128)
print v(xbgr.mr_n52710240)
print v(xbgr.mr_n52710560)
print v(xbgr.mr_n52710672)
print v(xbgr.mr_n52710992)
print v(xbgr.mr_n52711104)
print v(xbgr.mr_n52711424)
print v(xbgr.mr_n52711536)
print v(xbgr.mr_n52711856)
print v(xbgr.mr_n52711968)
print v(xbgr.mr_n52712288)
print v(xbgr.mr_n52712400)
print v(xbgr.mr_n52712720)
print v(xbgr.mr_n52712832)
print v(xbgr.mr_n52713152)
print v(xbgr.mr_n52713264)
print v(xbgr.mr_n52713584)
print v(xbgr.mr_n52713696)
print v(xbgr.mr_n52714016)
print v(xbgr.mr_n52714128)
print v(xbgr.mr_n52714448)
print v(xbgr.mr_n52714560)
print v(xbgr.mr_n52714880)
print v(xbgr.mr_n52714992)
print v(xbgr.mr_n52715312)
print v(xbgr.mr_n52715424)
print v(xbgr.mr_n52715744)
print v(xbgr.mr_n52715856)
print v(xbgr.mr_n52716176)
print v(xbgr.mr_n52716288)
print v(xbgr.mr_n52716608)
print v(xbgr.mr_n52716720)
print v(xbgr.mr_n52717040)
print v(xbgr.mr_n52717152)
print v(xbgr.mr_n52717472)
print v(xbgr.mr_n52717584)
print v(xbgr.mr_n52717904)
print v(xbgr.mr_n52718016)
print v(xbgr.mr_n52718336)
print v(xbgr.mr_n52718448)
print v(xbgr.mr_n52718768)
print v(xbgr.mr_n52718880)
print v(xbgr.mr_n52719200)
print v(xbgr.mr_n52719312)
print v(xbgr.mr_n52719632)
print v(xbgr.mr_n52719744)
print v(xbgr.mr_n52720064)
print v(xbgr.mr_n52720176)
print v(xbgr.mr_n52720496)
print v(xbgr.mr_n52720608)
print v(xbgr.mr_n52720928)
print v(xbgr.mr_n52721040)
print v(xbgr.mr_n52721360)
print v(xbgr.mr_n52721472)
print v(xbgr.mr_n52721792)
print v(xbgr.mr_n52721904)
print v(xbgr.mr_n52722224)
print v(xbgr.mr_n52722336)
print v(xbgr.mr_n52722656)
print v(xbgr.mr_n52722768)
print v(xbgr.mr_n52723088)
print v(xbgr.mr_n52723200)
print v(xbgr.mr_n52723520)
print v(xbgr.mr_n52723632)
print v(xbgr.mr_n52723952)
print v(xbgr.mr_n52724064)
print v(xbgr.mr_n52724384)
print v(xbgr.mr_n52724496)
print v(xbgr.mr_n52724816)
print v(xbgr.mr_n52724928)
print v(xbgr.mr_n52725248)
print v(xbgr.mr_n52725360)
print v(xbgr.mr_n52725680)
print v(xbgr.mr_n52725792)
print v(xbgr.mr_n52726112)
print v(xbgr.mr_n52726224)
print v(xbgr.mr_n52726544)
print v(xbgr.mr_n52726656)
print v(xbgr.mr_n52726976)
print v(xbgr.mr_n52727088)
print v(xbgr.mr_n52727408)
print v(xbgr.mr_n52727520)
print v(xbgr.mr_n52727840)
print v(xbgr.mr_n52727952)
print v(xbgr.mr_n52728272)
print v(xbgr.mr_n52728384)
print v(xbgr.mr_n52728704)
print v(xbgr.mr_n52728816)
print v(xbgr.mr_n52729136)
print v(xbgr.mr_n52729248)
print v(xbgr.mr_n52729568)
print v(xbgr.mr_n52729680)
print v(xbgr.mr_n52730000)
print v(xbgr.mr_n52730112)
print v(xbgr.mr_n52730432)
print v(xbgr.mr_n52730544)
print v(xbgr.mr_n52730864)
print v(xbgr.mr_n52730976)
print v(xbgr.mr_n52731296)
print v(xbgr.mr_n52731408)
print v(xbgr.mr_n52731728)
print v(xbgr.mr_n52731840)
print v(xbgr.mr_n52732160)
print v(xbgr.mr_n52732272)
print v(xbgr.mr_n52732592)
print v(xbgr.mr_n52732704)
print v(xbgr.mr_n52733024)
print v(xbgr.mr_n52733136)
print v(xbgr.mr_n52733456)
print v(xbgr.mr_n52733568)
print v(xbgr.mr_n52733888)
print v(xbgr.mr_n52734000)
print v(xbgr.mr_n52734320)
print v(xbgr.mr_n52734432)
print v(xbgr.mr_n52734752)
print v(xbgr.mr_n52734864)
print v(xbgr.mr_n52735184)
print v(xbgr.mr_n52735296)
print v(xbgr.mr_n52735616)
print v(xbgr.mr_n52735728)
print v(xbgr.mr_n52736048)
print v(xbgr.mr_n52736160)
print v(xbgr.mr_n52736480)
print v(xbgr.mr_n52736592)
print v(xbgr.mr_n52736912)
print v(xbgr.mr_n52737024)
print v(xbgr.mr_n52737344)
print v(xbgr.mr_n52737456)
print v(xbgr.mr_n52737776)
print v(xbgr.mr_n52737888)
print v(xbgr.mr_n52738208)
print v(xbgr.mr_n52738320)
print v(xbgr.mr_n52738640)
print v(xbgr.mr_n52738752)
print v(xbgr.mr_n52739072)
print v(xbgr.mr_n52739184)
print v(xbgr.mr_n52739504)
print v(xbgr.mr_n52739616)
print v(xbgr.mr_n52739936)
print v(xbgr.mr_n52740048)
print v(xbgr.mr_n52740368)
print v(xbgr.mr_n52740480)
print v(xbgr.mr_n52740800)
print v(xbgr.mr_n52740912)
print v(xbgr.mr_n52741232)
print v(xbgr.mr_n52741344)
print v(xbgr.mr_n52741664)
print v(xbgr.mr_n52741776)
print v(xbgr.mr_n52742096)
print v(xbgr.mr_n52742208)
print v(xbgr.mr_n52742528)
print v(xbgr.mr_n52742640)
print v(xbgr.mr_n52742960)
print v(xbgr.mr_n52743072)
print v(xbgr.mr_n52743392)
print v(xbgr.mr_n52743504)
print v(xbgr.mr_n52743824)
print v(xbgr.mr_n52743936)
print v(xbgr.mr_n52744256)
print v(xbgr.mr_n52744368)
print v(xbgr.mr_n52744688)
print v(xbgr.mr_n52744800)
print v(xbgr.mr_n52745120)
print v(xbgr.mr_n52745232)
print v(xbgr.mr_n52745552)
print v(xbgr.mr_n52745664)
print v(xbgr.mr_n52745984)
print v(xbgr.mr_n52746096)
print v(xbgr.mr_n52746416)
print v(xbgr.mr_n52746528)
print v(xbgr.mr_n52746848)
print v(xbgr.mr_n52746960)
print v(xbgr.mr_n52747280)
print v(xbgr.mr_n52747392)
print v(xbgr.mr_n52747712)
print v(xbgr.mr_n52747824)
print v(xbgr.mr_n52748144)
print v(xbgr.mr_n52748256)
print v(xbgr.mr_n52748576)
print v(xbgr.mr_n52748688)
print v(xbgr.mr_n52749008)
print v(xbgr.mr_n52749120)
print v(xbgr.mr_n52749440)
print v(xbgr.mr_n52749552)
print v(xbgr.mr_n52749872)
print v(xbgr.mr_n52749984)
print v(xbgr.mr_n52750304)
print v(xbgr.mr_n52750416)
print v(xbgr.mr_n52750736)
print v(xbgr.mr_n52750848)
print v(xbgr.mr_n52751168)
print v(xbgr.mr_n52751280)
print v(xbgr.mr_n52751600)
print v(xbgr.mr_n52751712)
print v(xbgr.mr_n52752032)
print v(xbgr.mr_n52752144)
print v(xbgr.mr_n52752464)
print v(xbgr.mr_n52752576)
print v(xbgr.mr_n52752896)
print v(xbgr.mr_n52753008)
print v(xbgr.mr_n52753328)
print v(xbgr.mr_n52753440)
print v(xbgr.mr_n52753760)
print v(xbgr.mr_n52753872)
print v(xbgr.mr_n52754192)
print v(xbgr.mr_n52754304)
print v(xbgr.mr_n52754624)
print v(xbgr.mr_n52754736)
print v(xbgr.mr_n52755056)
print v(xbgr.mr_n52755168)
print v(xbgr.mr_n52755488)
print v(xbgr.mr_n52755600)
print v(xbgr.mr_n52755920)
print v(xbgr.mr_n52756032)
print v(xbgr.mr_n52756352)
print v(xbgr.mr_n52756464)
print v(xbgr.mr_n52756784)
print v(xbgr.mr_n52756896)
print v(xbgr.mr_n52757216)
print v(xbgr.mr_n52757328)
print v(xbgr.mr_n52757648)
print v(xbgr.mr_n52757760)
print v(xbgr.mr_n52758080)
print v(xbgr.mr_n52758192)
print v(xbgr.mr_n52758512)
print v(xbgr.mr_n52758624)
print v(xbgr.mr_n52758944)
print v(xbgr.mr_n52759056)
print v(xbgr.mr_n52759376)
print v(xbgr.mr_n52759488)
print v(xbgr.mr_n52759808)
print v(xbgr.mr_n52759920)
print v(xbgr.mr_n52760240)
print v(xbgr.mr_n52760352)
print v(xbgr.mr_n52760672)
print v(xbgr.mr_n52760784)
print v(xbgr.mr_n52761104)
print v(xbgr.mr_n52761216)
print v(xbgr.mr_n52761536)
print v(xbgr.mr_n52761648)
print v(xbgr.mr_n52761968)
print v(xbgr.mr_n52762080)
print v(xbgr.mr_n52762400)
print v(xbgr.mr_n52762512)
print v(xbgr.mr_n52762832)
print v(xbgr.mr_n52762944)
print v(xbgr.mr_n52763264)
print v(xbgr.mr_n52763376)
print v(xbgr.mr_n52763696)
print v(xbgr.mr_n52763808)
print v(xbgr.mr_n52764128)
print v(xbgr.mr_n52764240)
print v(xbgr.mr_n52764560)
print v(xbgr.mr_n52764672)
print v(xbgr.mr_n52764992)
print v(xbgr.mr_n52765104)
print v(xbgr.mr_n52765424)
print v(xbgr.mr_n52765536)
print v(xbgr.mr_n52765856)
print v(xbgr.mr_n52765968)
print v(xbgr.mr_n52766288)
print v(xbgr.mr_n52766400)
print v(xbgr.mr_n52766720)
print v(xbgr.mr_n52766832)
print v(xbgr.mr_n52767152)
print v(xbgr.mr_n52767264)
print v(xbgr.mr_n52767584)
print v(xbgr.mr_n52767696)
print v(xbgr.mr_n52768016)
print v(xbgr.mr_n52768128)
print v(xbgr.mr_n52768448)
print v(xbgr.mr_n52768560)
print v(xbgr.mr_n52768880)
print v(xbgr.mr_n52768992)
print v(xbgr.mr_n52769312)
print v(xbgr.mr_n52769424)
print v(xbgr.mr_n52769744)
print v(xbgr.mr_n52769856)
print v(xbgr.mr_n52770176)
print v(xbgr.mr_n52770288)
print v(xbgr.mr_n52770608)
print v(xbgr.mr_n52770720)
print v(xbgr.mr_n52771040)
print v(xbgr.mr_n52771152)
print v(xbgr.mr_n52771472)
print v(xbgr.mr_n52771584)
print v(xbgr.mr_n52771904)
print v(xbgr.mr_n52772016)
print v(xbgr.mr_n52772336)
print v(xbgr.mr_n52772448)
print v(xbgr.mr_n52772768)
print v(xbgr.mr_n52772880)
print v(xbgr.mr_n52773200)
print v(xbgr.mr_n52773312)
print v(xbgr.mr_n52773632)
print v(xbgr.mr_n52773744)
print v(xbgr.mr_n52774064)
print v(xbgr.mr_n52774176)
print v(xbgr.mr_n52774496)
print v(xbgr.mr_n52774608)
print v(xbgr.mr_n52774928)
print v(xbgr.mr_n52775040)
print v(xbgr.mr_n52775360)
print v(xbgr.mr_n52775472)
print v(xbgr.mr_n52775792)
print v(xbgr.mr_n52775904)
print v(xbgr.mr_n52776224)
print v(xbgr.mr_n52776336)
print v(xbgr.mr_n52776656)
print v(xbgr.mr_n52776768)
print v(xbgr.mr_n52777088)
print v(xbgr.mr_n52777200)
print v(xbgr.mr_n52777520)
print v(xbgr.mr_n52777632)
print v(xbgr.mr_n52777952)
print v(xbgr.mr_n52778064)
print v(xbgr.mr_n52778384)
print v(xbgr.mr_n52778496)
print v(xbgr.mr_n52778816)
print v(xbgr.mr_n52778928)
print v(xbgr.mr_n52779248)
print v(xbgr.mr_n52779360)
print v(xbgr.mr_n52779680)
print v(xbgr.mr_n52779792)
print v(xbgr.mr_n52780112)
print v(xbgr.mr_n52780224)
print v(xbgr.mr_n52780544)
print v(xbgr.mr_n52780656)
print v(xbgr.mr_n52780976)
print v(xbgr.mr_n52781088)
print v(xbgr.mr_n52781408)
print v(xbgr.mr_n52781520)
print v(xbgr.mr_n52781840)
print v(xbgr.mr_n52781952)
print v(xbgr.mr_n52782272)
print v(xbgr.mr_n52782384)
print v(xbgr.mr_n52782704)
print v(xbgr.mr_n52782816)
print v(xbgr.mr_n52783136)
print v(xbgr.mr_n52783248)
print v(xbgr.mr_n52783568)
print v(xbgr.mr_n52783680)
print v(xbgr.mr_n52784000)
print v(xbgr.mr_n52784112)
print v(xbgr.mr_n52784432)
print v(xbgr.mr_n52784544)
print v(xbgr.mr_n52784864)
print v(xbgr.mr_n52784976)
print v(xbgr.mr_n52785296)
print v(xbgr.mr_n52785408)
print v(xbgr.mr_n52785728)
print v(xbgr.mr_n52785840)
print v(xbgr.mr_n52786160)
print v(xbgr.mr_n52786272)
print v(xbgr.mr_n52786592)
print v(xbgr.mr_n52786704)
print v(xbgr.mr_n52787024)
print v(xbgr.mr_n52787136)
print v(xbgr.mr_n52787456)
print v(xbgr.mr_n52787568)
print v(xbgr.mr_n52787888)
print v(xbgr.mr_n52788000)
print v(xbgr.mr_n52788320)
print v(xbgr.mr_n52788432)
print v(xbgr.mr_n52788752)
print v(xbgr.mr_n52788864)
print v(xbgr.mr_n52789184)
print v(xbgr.mr_n52789296)
print v(xbgr.mr_n52789616)
print v(xbgr.mr_n52789728)
print v(xbgr.mr_n52790048)
print v(xbgr.mr_n52790160)
print v(xbgr.mr_n52790480)
print v(xbgr.mr_n52790592)
print v(xbgr.mr_n52790912)
print v(xbgr.mr_n52791024)
print v(xbgr.mr_n52791344)
print v(xbgr.mr_n52791456)
print v(xbgr.mr_n52791776)
print v(xbgr.mr_n52791888)
print v(xbgr.mr_n52792208)
print v(xbgr.mr_n52792320)
print v(xbgr.mr_n52792640)
print v(xbgr.mr_n52792752)
print v(xbgr.mr_n52793072)
print v(xbgr.mr_n52793184)
print v(xbgr.mr_n52793504)
print v(xbgr.mr_n52793616)
print v(xbgr.mr_n52793936)
print v(xbgr.mr_n52794048)
print v(xbgr.mr_n52794368)
print v(xbgr.mr_n52794480)
print v(xbgr.mr_n52794800)
print v(xbgr.mr_n52794912)
print v(xbgr.mr_n52795232)
print v(xbgr.mr_n52795344)
print v(xbgr.mr_n52795664)
print v(xbgr.mr_n52795776)
print v(xbgr.mr_n52796096)
print v(xbgr.mr_n52796208)
print v(xbgr.mr_n52796528)
print v(xbgr.mr_n52796640)
print v(xbgr.mr_n52796960)
print v(xbgr.mr_n52797072)
print v(xbgr.mr_n52797392)
print v(xbgr.mr_n52797504)
print v(xbgr.mr_n52797824)
print v(xbgr.mr_n52797936)
print v(xbgr.mr_n52798256)
print v(xbgr.mr_n52798368)
print v(xbgr.mr_n52798688)
print v(xbgr.mr_n52798800)
print v(xbgr.mr_n52799120)
print v(xbgr.mr_n52799232)
print v(xbgr.mr_n52799552)
print v(xbgr.mr_n52799664)
print v(xbgr.mr_n52799984)
print v(xbgr.mr_n52800096)
print v(xbgr.mr_n52800416)
print v(xbgr.mr_n52800528)
print v(xbgr.mr_n52800848)
print v(xbgr.mr_n52800960)
print v(xbgr.mr_n52801280)
print v(xbgr.mr_n52801392)
print v(xbgr.mr_n52801712)
print v(xbgr.mr_n52801824)
print v(xbgr.mr_n52802144)
print v(xbgr.mr_n52802256)
print v(xbgr.mr_n52802576)
print v(xbgr.mr_n52802688)
print v(xbgr.mr_n52803008)
print v(xbgr.mr_n52803120)
print v(xbgr.mr_n52803440)
print v(xbgr.mr_n52803552)
print v(xbgr.mr_n52803872)
print v(xbgr.mr_n52803984)
print v(xbgr.mr_n52804304)
print v(xbgr.mr_n52804416)
print v(xbgr.mr_n52804736)
print v(xbgr.mr_n52804848)
print v(xbgr.mr_n52805168)
print v(xbgr.mr_n52805280)
print v(xbgr.mr_n52805600)
print v(xbgr.mr_n52805712)
print v(xbgr.mr_n52806032)
print v(xbgr.mr_n52806144)
print v(xbgr.mr_n52806464)
print v(xbgr.mr_n52806576)
print v(xbgr.mr_n52806896)
print v(xbgr.mr_n52807008)
print v(xbgr.mr_n52807328)
print v(xbgr.mr_n52807440)
print v(xbgr.mr_n52807760)
print v(xbgr.mr_n52807872)
print v(xbgr.mr_n52808192)
print v(xbgr.mr_n52808304)
print v(xbgr.mr_n52808624)
print v(xbgr.mr_n52808736)
print v(xbgr.mr_n52809056)
print v(xbgr.mr_n52809168)
print v(xbgr.mr_n52809488)
print v(xbgr.mr_n52809600)
print v(xbgr.mr_n52809920)
print v(xbgr.mr_n52810032)
print v(xbgr.mr_n52810352)
print v(xbgr.mr_n52810464)
print v(xbgr.mr_n52810784)
print v(xbgr.mr_n52810896)
print v(xbgr.mr_n52811216)
print v(xbgr.mr_n52811328)
print v(xbgr.mr_n52811648)
print v(xbgr.mr_n52811760)
print v(xbgr.mr_n52812080)
print v(xbgr.mr_n52812192)
print v(xbgr.mr_n52812512)
print v(xbgr.mr_n52812624)
print v(xbgr.mr_n52812944)
print v(xbgr.mr_n52813056)
print v(xbgr.mr_n52813376)
print v(xbgr.mr_n52813488)
print v(xbgr.mr_n52813808)
print v(xbgr.mr_n52813920)
print v(xbgr.mr_n52814240)
print v(xbgr.mr_n52814352)
print v(xbgr.mr_n52814672)
print v(xbgr.mr_n52814784)
print v(xbgr.mr_n52815104)
print v(xbgr.mr_n52815216)
print v(xbgr.mr_n52815536)
print v(xbgr.mr_n52815648)
print v(xbgr.mr_n52815968)
print v(xbgr.mr_n52816080)
print v(xbgr.mr_n52816400)
print v(xbgr.mr_n52816512)
print v(xbgr.mr_n52816832)
print v(xbgr.mr_n52816944)
print v(xbgr.mr_n52817264)
print v(xbgr.mr_n52817376)
print v(xbgr.mr_n52817696)
print v(xbgr.mr_n52817808)
print v(xbgr.mr_n52818128)
print v(xbgr.mr_n52818240)
print v(xbgr.mr_n52818560)
print v(xbgr.mr_n52818672)
print v(xbgr.mr_n52818992)
print v(xbgr.mr_n52819104)
print v(xbgr.mr_n52819424)
print v(xbgr.mr_n52819536)
print v(xbgr.mr_n52819856)
print v(xbgr.mr_n52819968)
print v(xbgr.mr_n52820288)
print v(xbgr.mr_n52820400)
print v(xbgr.mr_n52820720)
print v(xbgr.mr_n52820832)
print v(xbgr.mr_n52821152)
print v(xbgr.mr_n52821264)
print v(xbgr.mr_n52821584)
print v(xbgr.mr_n52821696)
print v(xbgr.mr_n52822016)
print v(xbgr.mr_n52822128)
print v(xbgr.mr_n52822448)
print v(xbgr.mr_n52822560)
print v(xbgr.mr_n52822880)
print v(xbgr.mr_n52822992)
print v(xbgr.mr_n52823312)
print v(xbgr.mr_n52823424)
print v(xbgr.mr_n52823744)
print v(xbgr.mr_n52823856)
print v(xbgr.mr_n52824176)
print v(xbgr.mr_n52824288)
print v(xbgr.mr_n52824608)
print v(xbgr.mr_n52824720)
print v(xbgr.mr_n52825040)
print v(xbgr.mr_n52825152)
print v(xbgr.mr_n52825472)
print v(xbgr.mr_n52825584)
print v(xbgr.mr_n52825904)
print v(xbgr.mr_n52826016)
print v(xbgr.mr_n52826336)
print v(xbgr.mr_n52826448)
print v(xbgr.mr_n52826768)
print v(xbgr.mr_n52826880)
print v(xbgr.mr_n52827200)
print v(xbgr.mr_n52827312)
print v(xbgr.mr_n52827632)
print v(xbgr.mr_n52827744)
print v(xbgr.mr_n52828064)
print v(xbgr.mr_n52828176)
print v(xbgr.mr_n52828496)
print v(xbgr.mr_n52828608)
print v(xbgr.mr_n52828928)
print v(xbgr.mr_n52829040)
print v(xbgr.mr_n52829360)
print v(xbgr.mr_n52829472)
print v(xbgr.mr_n52829792)
print v(xbgr.mr_n52829904)
print v(xbgr.mr_n52830224)
print v(xbgr.mr_n52830336)
print v(xbgr.mr_n52830656)
print v(xbgr.mr_n52830768)
print v(xbgr.mr_n52831088)
print v(xbgr.mr_n52831200)
print v(xbgr.mr_n52831520)
print v(xbgr.mr_n52831632)
print v(xbgr.mr_n52831952)
print v(xbgr.mr_n52832064)
print v(xbgr.mr_n52832384)
print v(xbgr.mr_n52832496)
print v(xbgr.mr_n52832816)
print v(xbgr.mr_n52832928)
print v(xbgr.mr_n52833248)
print v(xbgr.mr_n52833360)
print v(xbgr.mr_n52833680)
print v(xbgr.mr_n52833792)
print v(xbgr.mr_n52834112)
print v(xbgr.mr_n52834224)
print v(xbgr.mr_n52834544)
print v(xbgr.mr_n52834656)
print v(xbgr.mr_n52834976)
print v(xbgr.mr_n52835088)
print v(xbgr.mr_n52835408)
print v(xbgr.mr_n52835520)
print v(xbgr.mr_n52835840)
print v(xbgr.mr_n52835952)
print v(xbgr.mr_n52836272)
print v(xbgr.mr_n52836384)
print v(xbgr.mr_n52836704)
print v(xbgr.mr_n52836816)
print v(xbgr.mr_n52837136)
print v(xbgr.mr_n52837248)
print v(xbgr.mr_n52837568)
print v(xbgr.mr_n52837680)
print v(xbgr.mr_n52838000)
print v(xbgr.mr_n52838112)
print v(xbgr.mr_n52838432)
print v(xbgr.mr_n52838544)
print v(xbgr.mr_n52838864)
print v(xbgr.mr_n52838976)
print v(xbgr.mr_n52839296)
print v(xbgr.mr_n52839408)
print v(xbgr.mr_n52839728)
print v(xbgr.mr_n52839840)
print v(xbgr.mr_n52840160)
print v(xbgr.mr_n52840272)
print v(xbgr.mr_n52840592)
print v(xbgr.mr_n52840704)
print v(xbgr.mr_n52841024)
print v(xbgr.mr_n52841136)
print v(xbgr.mr_n52841456)
print v(xbgr.mr_n52841568)
print v(xbgr.mr_n52841888)
print v(xbgr.mr_n52842000)
print v(xbgr.mr_n52842320)
print v(xbgr.mr_n52842432)
print v(xbgr.mr_n52842752)
print v(xbgr.mr_n52842864)
print v(xbgr.mr_n52843184)
print v(xbgr.mr_n52843296)
print v(xbgr.mr_n52843616)
print v(xbgr.mr_n52843728)
print v(xbgr.mr_n52844048)
print v(xbgr.mr_n52844160)
print v(xbgr.mr_n52844480)
print v(xbgr.mr_n52844592)
print v(xbgr.mr_n52844912)
print v(xbgr.mr_n52845024)
print v(xbgr.mr_n52845344)
print v(xbgr.mr_n52845456)
print v(xbgr.mr_n52845776)
print v(xbgr.mr_n52845888)
print v(xbgr.mr_n52846208)
print v(xbgr.mr_n52846320)
print v(xbgr.mr_n52846640)
print v(xbgr.mr_n52846752)
print v(xbgr.mr_n52847072)
print v(xbgr.mr_n52847184)
print v(xbgr.mr_n52847504)
print v(xbgr.mr_n52847616)
print v(xbgr.mr_n52847936)
print v(xbgr.mr_n52848048)
print v(xbgr.mr_n52848368)
print v(xbgr.mr_n52848480)
print v(xbgr.mr_n52848800)
print v(xbgr.mr_n52848912)
print v(xbgr.mr_n52849232)
print v(xbgr.mr_n52849344)
print v(xbgr.mr_n52849664)
print v(xbgr.mr_n52849776)
print v(xbgr.mr_n52850096)
print v(xbgr.mr_n52850208)
print v(xbgr.mr_n52850528)
print v(xbgr.mr_n52850640)
print v(xbgr.mr_n52850960)
print v(xbgr.mr_n52851072)
print v(xbgr.mr_n52851392)
print v(xbgr.mr_n52851504)
print v(xbgr.mr_n52851824)
print v(xbgr.mr_n52851936)
print v(xbgr.mr_n52852256)
print v(xbgr.mr_n52852368)
print v(xbgr.mr_n52852688)
print v(xbgr.mr_n52852800)
print v(xbgr.mr_n52853120)
print v(xbgr.mr_n52853232)
print v(xbgr.mr_n52853552)
print v(xbgr.mr_n52853664)
print v(xbgr.mr_n52853984)
print v(xbgr.mr_n52854096)
print v(xbgr.mr_n52854416)
print v(xbgr.mr_n52854528)
print v(xbgr.mr_n52854848)
print v(xbgr.mr_n52854960)
print v(xbgr.mr_n52855280)
print v(xbgr.mr_n52855392)
print v(xbgr.mr_n52855712)
print v(xbgr.mr_n52855824)
print v(xbgr.mr_n52856144)
print v(xbgr.mr_n52856256)
print v(xbgr.mr_n52856576)
print v(xbgr.mr_n52856688)
print v(xbgr.mr_n52857008)
print v(xbgr.mr_n52857120)
print v(xbgr.mr_n52857440)
print v(xbgr.mr_n52857552)
print v(xbgr.mr_n52857872)
print v(xbgr.mr_n52857984)
print v(xbgr.mr_n52858304)
print v(xbgr.mr_n52858416)
print v(xbgr.mr_n52858736)
print v(xbgr.mr_n52858848)
print v(xbgr.mr_n52859168)
print v(xbgr.mr_n52859280)
print v(xbgr.mr_n52859600)
print v(xbgr.mr_n52859712)
print v(xbgr.mr_n52860032)
print v(xbgr.mr_n52860144)
print v(xbgr.mr_n52860464)
print v(xbgr.mr_n52860576)
print v(xbgr.mr_n52860896)
print v(xbgr.mr_n52861008)
print v(xbgr.mr_n52861328)
print v(xbgr.mr_n52861440)
print v(xbgr.mr_n52861760)
print v(xbgr.mr_n52861872)
print v(xbgr.mr_n52862192)
print v(xbgr.mr_n52862304)
print v(xbgr.mr_n52862624)
print v(xbgr.mr_n52862736)
print v(xbgr.mr_n52863056)
print v(xbgr.mr_n52863168)
print v(xbgr.mr_n52863488)
print v(xbgr.mr_n52863600)
print v(xbgr.mr_n52863920)
print v(xbgr.mr_n52864032)
print v(xbgr.mr_n52864352)
print v(xbgr.mr_n52864464)
print v(xbgr.mr_n52864784)
print v(xbgr.mr_n52864896)
print v(xbgr.mr_n52865216)
print v(xbgr.mr_n52865328)
print v(xbgr.mr_n52865648)
print v(xbgr.mr_n52865760)
print v(xbgr.mr_n52866080)
print v(xbgr.mr_n52866192)
print v(xbgr.mr_n52866512)
print v(xbgr.mr_n52866624)
print v(xbgr.mr_n52866944)
print v(xbgr.mr_n52867056)
print v(xbgr.mr_n52867376)
print v(xbgr.mr_n52867488)
print v(xbgr.mr_n52867808)
print v(xbgr.mr_n52867920)
print v(xbgr.mr_n52868240)
print v(xbgr.mr_n52868352)
print v(xbgr.mr_n52868672)
print v(xbgr.mr_n52868784)
print v(xbgr.mr_n52869104)
print v(xbgr.mr_n52869216)
print v(xbgr.mr_n52869536)
print v(xbgr.mr_n52869648)
print v(xbgr.mr_n52869968)
print v(xbgr.mr_n52870080)
print v(xbgr.mr_n52870400)
print v(xbgr.mr_n52870512)
print v(xbgr.mr_n52870832)
print v(xbgr.mr_n52870944)
print v(xbgr.mr_n52871264)
print v(xbgr.mr_n52871376)
print v(xbgr.mr_n52871696)
print v(xbgr.mr_n52871808)
print v(xbgr.mr_n52872128)
print v(xbgr.mr_n52872240)
print v(xbgr.mr_n52872560)
print v(xbgr.mr_n52872672)
print v(xbgr.mr_n52872992)
print v(xbgr.mr_n52873104)
print v(xbgr.mr_n52873424)
print v(xbgr.mr_n52873536)
print v(xbgr.mr_n52873856)
print v(xbgr.mr_n52873968)
print v(xbgr.mr_n52874288)
print v(xbgr.mr_n52874400)
print v(xbgr.mr_n52874720)
print v(xbgr.mr_n52874832)
print v(xbgr.mr_n52875152)
print v(xbgr.mr_n52875264)
print v(xbgr.mr_n52875584)
print v(xbgr.mr_n52875696)
print v(xbgr.mr_n52876016)
print v(xbgr.mr_n52876128)
print v(xbgr.mr_n52876448)
print v(xbgr.mr_n52876560)
print v(xbgr.mr_n52876880)
print v(xbgr.mr_n52876992)
print v(xbgr.mr_n52877312)
print v(xbgr.mr_n52877424)
print v(xbgr.mr_n52877744)
print v(xbgr.mr_n52877856)
print v(xbgr.mr_n52878176)
print v(xbgr.mr_n52878288)
print v(xbgr.mr_n52878608)
print v(xbgr.mr_n52878720)
print v(xbgr.mr_n52879040)
print v(xbgr.mr_n52879152)
print v(xbgr.mr_n52879472)
print v(xbgr.mr_n52879584)
print v(xbgr.mr_n52879904)
print v(xbgr.mr_n52880016)
print v(xbgr.mr_n52880336)
print v(xbgr.mr_n52880448)
print v(xbgr.mr_n52880768)
print v(xbgr.mr_n52880880)
print v(xbgr.mr_n52881200)
print v(xbgr.mr_n52881312)
print v(xbgr.mr_n52881632)
print v(xbgr.mr_n52881744)
print v(xbgr.mr_n52882064)
print v(xbgr.mr_n52882176)
print v(xbgr.mr_n52882496)
print v(xbgr.mr_n52882608)
print v(xbgr.mr_n52882928)
print v(xbgr.mr_n52883040)
print v(xbgr.mr_n52883360)
print v(xbgr.mr_n52883472)
print v(xbgr.mr_n52883792)
print v(xbgr.mr_n52883904)
print v(xbgr.mr_n52884224)
print v(xbgr.mr_n52884336)
print v(xbgr.mr_n52884656)
print v(xbgr.mr_n52884768)
print v(xbgr.mr_n52885088)
print v(xbgr.mr_n52885200)
print v(xbgr.mr_n52885520)
print v(xbgr.mr_n52885632)
print v(xbgr.mr_n52885952)
print v(xbgr.mr_n52886064)
print v(xbgr.mr_n52886384)
print v(xbgr.mr_n52886496)
print v(xbgr.mr_n52886816)
print v(xbgr.mr_n52886928)
print v(xbgr.mr_n52887248)
print v(xbgr.mr_n52887360)
print v(xbgr.mr_n52887680)
print v(xbgr.mr_n52887792)
print v(xbgr.mr_n52888112)
print v(xbgr.mr_n52888224)
print v(xbgr.mr_n52888544)
print v(xbgr.mr_n52888656)
print v(xbgr.mr_n52888976)
print v(xbgr.mr_n52889088)
print v(xbgr.mr_n52889408)
print v(xbgr.mr_n52889520)
print v(xbgr.mr_n52889840)
print v(xbgr.mr_n52889952)
print v(xbgr.mr_n52890272)
print v(xbgr.mr_n52890384)
print v(xbgr.mr_n52890704)
print v(xbgr.mr_n52890816)
print v(xbgr.mr_n52891136)
print v(xbgr.mr_n52891248)
print v(xbgr.mr_n52891568)
print v(xbgr.mr_n52891680)
print v(xbgr.mr_n52892000)
print v(xbgr.mr_n52892112)
print v(xbgr.mr_n52892432)
print v(xbgr.mr_n52892544)
print v(xbgr.mr_n52892864)
print v(xbgr.mr_n52892976)
print v(xbgr.mr_n52893296)
print v(xbgr.mr_n52893408)
print v(xbgr.mr_n52893728)
print v(xbgr.mr_n52893840)
print v(xbgr.mr_n52894160)
print v(xbgr.mr_n52894272)
print v(xbgr.mr_n52894592)
print v(xbgr.mr_n52894704)
print v(xbgr.mr_n52895024)
print v(xbgr.mr_n52895136)
print v(xbgr.mr_n52895456)
print v(xbgr.mr_n52895568)
print v(xbgr.mr_n52895888)
print v(xbgr.mr_n52896000)
print v(xbgr.mr_n52896320)
print v(xbgr.mr_n52896432)
print v(xbgr.mr_n52896752)
print v(xbgr.mr_n52896864)
print v(xbgr.mr_n52897184)
print v(xbgr.mr_n52897296)
print v(xbgr.mr_n52897616)
print v(xbgr.mr_n52897728)
print v(xbgr.mr_n52898048)
print v(xbgr.mr_n52898160)
print v(xbgr.mr_n52898480)
print v(xbgr.mr_n52898592)
print v(xbgr.mr_n52898912)
print v(xbgr.mr_n52899024)
print v(xbgr.mr_n52899344)
print v(xbgr.mr_n52899456)
print v(xbgr.mr_n52899776)
print v(xbgr.mr_n52899888)
print v(xbgr.mr_n52900208)
print v(xbgr.mr_n52900320)
print v(xbgr.mr_n52900640)
print v(xbgr.mr_n52900752)
print v(xbgr.mr_n52901072)
print v(xbgr.mr_n52901184)
print v(xbgr.mr_n52901504)
print v(xbgr.mr_n52901616)
print v(xbgr.mr_n52901936)
print v(xbgr.mr_n52902048)
print v(xbgr.mr_n52902368)
print v(xbgr.mr_n52902480)
print v(xbgr.mr_n52902800)
print v(xbgr.mr_n52902912)
print v(xbgr.mr_n52903232)
print v(xbgr.mr_n52903344)
print v(xbgr.mr_n52903664)
print v(xbgr.mr_n52903776)
print v(xbgr.mr_n52904096)
print v(xbgr.mr_n52904208)
print v(xbgr.mr_n52904528)
print v(xbgr.mr_n52904640)
print v(xbgr.mr_n52904960)
print v(xbgr.mr_n52905072)
print v(xbgr.mr_n52905392)
print v(xbgr.mr_n52905504)
print v(xbgr.mr_n52905824)
print v(xbgr.mr_n52905936)
print v(xbgr.mr_n52906256)
print v(xbgr.mr_n52906368)
print v(xbgr.mr_n52906688)
print v(xbgr.mr_n52906800)
print v(xbgr.mr_n52907120)
print v(xbgr.mr_n52907232)
print v(xbgr.mr_n52907552)
print v(xbgr.mr_n52907664)
print v(xbgr.mr_n52907984)
print v(xbgr.mr_n52908096)
print v(xbgr.mr_n52908416)
print v(xbgr.mr_n52908528)
print v(xbgr.mr_n52908848)
print v(xbgr.mr_n52908960)
print v(xbgr.mr_n52909280)
print v(xbgr.mr_n52909392)
print v(xbgr.mr_n52909712)
print v(xbgr.mr_n52909824)
print v(xbgr.mr_n52910144)
print v(xbgr.mr_n52910256)
print v(xbgr.mr_n52910576)
print v(xbgr.mr_n52910688)
print v(xbgr.mr_n52911008)
print v(xbgr.mr_n52911120)
print v(xbgr.mr_n52911440)
print v(xbgr.mr_n52911552)
print v(xbgr.mr_n52911872)
print v(xbgr.mr_n52911984)
print v(xbgr.mr_n52912304)
print v(xbgr.mr_n52912416)
print v(xbgr.mr_n52912736)
print v(xbgr.mr_n52912848)
print v(xbgr.mr_n52913168)
print v(xbgr.mr_n52913280)
print v(xbgr.mr_n52913600)
print v(xbgr.mr_n52913712)
print v(xbgr.mr_n52914032)
print v(xbgr.mr_n52914144)
print v(xbgr.mr_n52914464)
print v(xbgr.mr_n52914576)
print v(xbgr.mr_n52914896)
print v(xbgr.mr_n52915008)
print v(xbgr.mr_n52915328)
print v(xbgr.mr_n52915440)
print v(xbgr.mr_n52915760)
print v(xbgr.mr_n52915872)
print v(xbgr.mr_n52916192)
print v(xbgr.mr_n52916304)
print v(xbgr.mr_n52916624)
print v(xbgr.mr_n52916736)
print v(xbgr.mr_n52917056)
print v(xbgr.mr_n52917168)
print v(xbgr.mr_n52917488)
print v(xbgr.mr_n52917600)
print v(xbgr.mr_n52917920)
print v(xbgr.mr_n52918032)
print v(xbgr.mr_n52918352)
print v(xbgr.mr_n52918464)
print v(xbgr.mr_n52918784)
print v(xbgr.mr_n52918896)
print v(xbgr.mr_n52919216)
print v(xbgr.mr_n52919328)
print v(xbgr.mr_n52919648)
print v(xbgr.mr_n52919760)
print v(xbgr.mr_n52920080)
print v(xbgr.mr_n52920192)
print v(xbgr.mr_n52920512)
print v(xbgr.mr_n52920624)
print v(xbgr.mr_n52920944)
print v(xbgr.mr_n52921056)
print v(xbgr.mr_n52921376)
print v(xbgr.mr_n52921488)
print v(xbgr.mr_n52921808)
print v(xbgr.mr_n52921920)
print v(xbgr.mr_n52922240)
print v(xbgr.mr_n52922352)
print v(xbgr.mr_n52922672)
print v(xbgr.mr_n52922784)
print v(xbgr.mr_n52923104)
print v(xbgr.mr_n52923216)
print v(xbgr.mr_n52923536)
print v(xbgr.mr_n52923648)
print v(xbgr.mr_n52923968)
print v(xbgr.mr_n52924080)
print v(xbgr.mr_n52924400)
print v(xbgr.mr_n52924512)
print v(xbgr.mr_n52924832)
print v(xbgr.mr_n52924944)
print v(xbgr.mr_n52925264)
print v(xbgr.mr_n52925376)
print v(xbgr.mr_n52925696)
print v(xbgr.mr_n52925808)
print v(xbgr.mr_n52926128)
print v(xbgr.mr_n52926240)
print v(xbgr.mr_n52926560)
print v(xbgr.mr_n52926672)
print v(xbgr.mr_n52926992)
print v(xbgr.mr_n52927104)
print v(xbgr.mr_n52927424)
print v(xbgr.mr_n52927536)
print v(xbgr.mr_n52927856)
print v(xbgr.mr_n52927968)
print v(xbgr.mr_n52928288)
print v(xbgr.mr_n52928400)
print v(xbgr.mr_n52928720)
print v(xbgr.mr_n52928832)
print v(xbgr.mr_n52929152)
print v(xbgr.mr_n52929264)
print v(xbgr.mr_n52929584)
print v(xbgr.mr_n52929696)
print v(xbgr.mr_n52930016)
print v(xbgr.mr_n52930128)
print v(xbgr.mr_n52930448)
print v(xbgr.mr_n52930560)
print v(xbgr.mr_n52930880)
print v(xbgr.mr_n52930992)
print v(xbgr.mr_n52931312)
print v(xbgr.mr_n52931424)
print v(xbgr.mr_n52931744)
print v(xbgr.mr_n52931856)
print v(xbgr.mr_n52932176)
print v(xbgr.mr_n52932288)
print v(xbgr.mr_n52932608)
print v(xbgr.mr_n52932720)
print v(xbgr.mr_n52933040)
print v(xbgr.mr_n52933152)
print v(xbgr.mr_n52933472)
print v(xbgr.mr_n52933584)
print v(xbgr.mr_n52933904)
print v(xbgr.mr_n52934016)
print v(xbgr.mr_n52934336)
print v(xbgr.mr_n52934448)
print v(xbgr.mr_n52934768)
print v(xbgr.mr_n52934880)
print v(xbgr.mr_n52935200)
print v(xbgr.mr_n52935312)
print v(xbgr.mr_n52935632)
print v(xbgr.mr_n52935744)
print v(xbgr.mr_n52936064)
print v(xbgr.mr_n52936176)
print v(xbgr.mr_n52936496)
print v(xbgr.mr_n52936608)
print v(xbgr.mr_n52936928)
print v(xbgr.mr_n52937040)
print v(xbgr.mr_n52937360)
print v(xbgr.mr_n52937472)
print v(xbgr.mr_n52937792)
print v(xbgr.mr_n52937904)
print v(xbgr.mr_n52938224)
print v(xbgr.mr_n52938336)
print v(xbgr.mr_n52938656)
print v(xbgr.mr_n52938768)
print v(xbgr.mr_n52939088)
print v(xbgr.mr_n52939200)
print v(xbgr.mr_n52939520)
print v(xbgr.mr_n52939632)
print v(xbgr.mr_n52939952)
print v(xbgr.mr_n52940064)
print v(xbgr.mr_n52940384)
print v(xbgr.mr_n52940496)
print v(xbgr.mr_n52940816)
print v(xbgr.mr_n52940928)
print v(xbgr.mr_n52941248)
print v(xbgr.mr_n52941360)
print v(xbgr.mr_n52941680)
print v(xbgr.mr_n52941792)
print v(xbgr.mr_n52942112)
print v(xbgr.mr_n52942224)
print v(xbgr.mr_n52942544)
print v(xbgr.mr_n52942656)
print v(xbgr.mr_n52942976)
print v(xbgr.mr_n52943088)
print v(xbgr.mr_n52943408)
print v(xbgr.mr_n52943520)
print v(xbgr.mr_n52943840)
print v(xbgr.mr_n52943952)
print v(xbgr.mr_n52944272)
print v(xbgr.mr_n52944384)
print v(xbgr.mr_n52944704)
print v(xbgr.mr_n52944816)
print v(xbgr.mr_n52945136)
print v(xbgr.mr_n52945248)
print v(xbgr.mr_n52945568)
print v(xbgr.mr_n52945680)
print v(xbgr.mr_n52946000)
print v(xbgr.mr_n52946112)
print v(xbgr.mr_n52946432)
print v(xbgr.mr_n52946544)
print v(xbgr.mr_n52946864)
print v(xbgr.mr_n52946976)
print v(xbgr.mr_n52947296)
print v(xbgr.mr_n52947408)
print v(xbgr.mr_n52947728)
print v(xbgr.mr_n52947840)
print v(xbgr.mr_n52948160)
print v(xbgr.mr_n52948272)
print v(xbgr.mr_n52948592)
print v(xbgr.mr_n52948704)
print v(xbgr.mr_n52949024)
print v(xbgr.mr_n52949136)
print v(xbgr.mr_n52949456)
print v(xbgr.mr_n52949568)
print v(xbgr.mr_n52949888)
print v(xbgr.mr_n52950000)
print v(xbgr.mr_n52950320)
print v(xbgr.mr_n52950432)
print v(xbgr.mr_n52950752)
print v(xbgr.mr_n52950864)
print v(xbgr.mr_n52951184)
print v(xbgr.mr_n52951296)
print v(xbgr.mr_n52951616)
print v(xbgr.mr_n52951728)
print v(xbgr.mr_n52952048)
print v(xbgr.mr_n52952160)
print v(xbgr.mr_n52952480)
print v(xbgr.mr_n52952592)
print v(xbgr.mr_n52952912)
print v(xbgr.mr_n52953024)
print v(xbgr.mr_n52953344)
print v(xbgr.mr_n52953456)
print v(xbgr.mr_n52953776)
print v(xbgr.mr_n52953888)
print v(xbgr.mr_n52954208)
print v(xbgr.mr_n52954320)
print v(xbgr.mr_n52954640)
print v(xbgr.mr_n52954752)
print v(xbgr.mr_n52955072)
print v(xbgr.mr_n52955184)
print v(xbgr.mr_n52955504)
print v(xbgr.mr_n52955616)
print v(xbgr.mr_n52955936)
print v(xbgr.mr_n52956048)
print v(xbgr.mr_n52956368)
print v(xbgr.mr_n52956480)
print v(xbgr.mr_n52956800)
print v(xbgr.mr_n52956912)
print v(xbgr.mr_n52957232)
print v(xbgr.mr_n52957344)
print v(xbgr.mr_n52957664)
print v(xbgr.mr_n52957776)
print v(xbgr.mr_n52958096)
print v(xbgr.mr_n52958208)
print v(xbgr.mr_n52958528)
print v(xbgr.mr_n52958640)
print v(xbgr.mr_n52958960)
print v(xbgr.mr_n52959072)
print v(xbgr.mr_n52959392)
print v(xbgr.mr_n52959504)
print v(xbgr.mr_n52959824)
print v(xbgr.mr_n52959936)
print v(xbgr.mr_n52960256)
print v(xbgr.mr_n52960368)
print v(xbgr.mr_n52960688)
print v(xbgr.mr_n52960800)
print v(xbgr.mr_n52961120)
print v(xbgr.mr_n52961232)
print v(xbgr.mr_n52961552)
print v(xbgr.mr_n52961664)
print v(xbgr.mr_n52961984)
print v(xbgr.mr_n52962096)
print v(xbgr.mr_n52962416)
print v(xbgr.mr_n52962528)
print v(xbgr.mr_n52962848)
print v(xbgr.mr_n52962960)
print v(xbgr.mr_n52963280)
print v(xbgr.mr_n52963392)
print v(xbgr.mr_n52963824)
print v(xbgr.mr_n52964144)
print v(xbgr.mr_n52964256)
print v(xbgr.mr_n52964576)
print v(xbgr.mr_n52964688)
print v(xbgr.mr_n52965008)
print v(xbgr.mr_n52965120)
print v(xbgr.mr_n52965440)
print v(xbgr.mr_n52965552)
print v(xbgr.mr_n52965872)
print v(xbgr.mr_n52965984)
print v(xbgr.mr_n52966304)
print v(xbgr.mr_n52966416)
print v(xbgr.mr_n52966736)
print v(xbgr.mr_n52966848)
print v(xbgr.mr_n52967168)
print v(xbgr.mr_n52967280)
print v(xbgr.mr_n52967600)
print v(xbgr.mr_n52967712)
print v(xbgr.mr_n52968032)
print v(xbgr.mr_n52968144)
print v(xbgr.mr_n52968464)
print v(xbgr.mr_n52968576)
print v(xbgr.mr_n52968896)
print v(xbgr.mr_n52969008)
print v(xbgr.mr_n52969328)
print v(xbgr.mr_n52969440)
print v(xbgr.mr_n52969872)
print v(xbgr.mr_n52970192)
print v(xbgr.mr_n52970304)
print v(xbgr.mr_n52970624)
print v(xbgr.mr_n52970736)
print v(xbgr.mr_n52971056)
print v(xbgr.mr_n52971168)
print v(xbgr.mr_n52971488)
print v(xbgr.mr_n52971600)
print v(xbgr.mr_n52971920)
print v(xbgr.mr_n52972032)
print v(xbgr.mr_n52972352)
print v(xbgr.mr_n52972464)
print v(xbgr.mr_n52972784)
print v(xbgr.mr_n52972896)
print v(xbgr.mr_n52973216)
print v(xbgr.mr_n52973328)
print v(xbgr.mr_n52973648)
print v(xbgr.mr_n52973760)
print v(xbgr.mr_n52974080)
print v(xbgr.mr_n52974192)
print v(xbgr.mr_n52974512)
print v(xbgr.mr_n52974624)
print v(xbgr.mr_n52974944)
print v(xbgr.mr_n52975056)
print v(xbgr.mr_n52975376)
print v(xbgr.mr_n52975488)
print v(xbgr.mr_n52975808)
print v(xbgr.mr_n52975920)
print v(xbgr.mr_n52976240)
print v(xbgr.mr_n52976352)
print v(xbgr.mr_n52976672)
print v(xbgr.mr_n52976784)
print v(xbgr.mr_n52977104)
print v(xbgr.mr_n52977216)
print v(xbgr.mr_n52977536)
print v(xbgr.mr_n52977648)
print v(xbgr.mr_n52977968)
print v(xbgr.mr_n52978080)
print v(xbgr.mr_n52978400)
print v(xbgr.mr_n52978512)
print v(xbgr.mr_n52978832)
print v(xbgr.mr_n52978944)
print v(xbgr.mr_n52979264)
print v(xbgr.mr_n52979376)
print v(xbgr.mr_n52979696)
print v(xbgr.mr_n52979808)
print v(xbgr.mr_n52980128)
print v(xbgr.mr_n52980240)
print v(xbgr.mr_n52980560)
print v(xbgr.mr_n52980672)
print v(xbgr.mr_n52980992)
print v(xbgr.mr_n52981104)
print v(xbgr.mr_n52981424)
print v(xbgr.mr_n52981536)
print v(xbgr.mr_n52981856)
print v(xbgr.mr_n52981968)
print v(xbgr.mr_n52982288)
print v(xbgr.mr_n52982400)
print v(xbgr.mr_n52982720)
print v(xbgr.mr_n52982832)
print v(xbgr.mr_n52983152)
print v(xbgr.mr_n52983264)
print v(xbgr.mr_n52983584)
print v(xbgr.mr_n52983696)
print v(xbgr.mr_n52984016)
print v(xbgr.mr_n52984128)
print v(xbgr.mr_n52984448)
print v(xbgr.mr_n52984560)
print v(xbgr.mr_n52984880)
print v(xbgr.mr_n52984992)
print v(xbgr.mr_n52985312)
print v(xbgr.mr_n52985424)
print v(xbgr.mr_n52985744)
print v(xbgr.mr_n52985856)
print v(xbgr.mr_n52986176)
print v(xbgr.mr_n52986288)
print v(xbgr.mr_n52986608)
print v(xbgr.mr_n52986720)
print v(xbgr.mr_n52987040)
print v(xbgr.mr_n52987152)
print v(xbgr.mr_n52987472)
print v(xbgr.mr_n52987584)
print v(xbgr.mr_n52987904)
print v(xbgr.mr_n52988016)
print v(xbgr.mr_n52988336)
print v(xbgr.mr_n52988448)
print v(xbgr.mr_n52988768)
print v(xbgr.mr_n52988880)
print v(xbgr.mr_n52989200)
print v(xbgr.mr_n52989312)
print v(xbgr.mr_n52989632)
print v(xbgr.mr_n52989744)
print v(xbgr.mr_n52990064)
print v(xbgr.mr_n52990176)
print v(xbgr.mr_n52990496)
print v(xbgr.mr_n52990608)
print v(xbgr.mr_n52990928)
print v(xbgr.mr_n52991040)
print v(xbgr.mr_n52991360)
print v(xbgr.mr_n52991472)
print v(xbgr.mr_n52991792)
print v(xbgr.mr_n52991904)
print v(xbgr.mr_n52992224)
print v(xbgr.mr_n52992336)
print v(xbgr.mr_n52992656)
print v(xbgr.mr_n52992768)
print v(xbgr.mr_n52993088)
print v(xbgr.mr_n52993200)
print v(xbgr.mr_n52993520)
print v(xbgr.mr_n52993632)
print v(xbgr.mr_n52993952)
print v(xbgr.mr_n52994064)
print v(xbgr.mr_n52994384)
print v(xbgr.mr_n52994496)
print v(xbgr.mr_n52994816)
print v(xbgr.mr_n52994928)
print v(xbgr.mr_n52995248)
print v(xbgr.mr_n52995360)
print v(xbgr.mr_n52995680)
print v(xbgr.mr_n52995792)
print v(xbgr.mr_n52996112)
print v(xbgr.mr_n52996224)
print v(xbgr.mr_n52996544)
print v(xbgr.mr_n52996656)
print v(xbgr.mr_n52996976)
print v(xbgr.mr_n52997088)
print v(xbgr.mr_n52997408)
print v(xbgr.mr_n52997520)
print v(xbgr.mr_n52997840)
print v(xbgr.mr_n52997952)
print v(xbgr.mr_n52998272)
print v(xbgr.mr_n52998384)
print v(xbgr.mr_n52998704)
print v(xbgr.mr_n52998816)
print v(xbgr.mr_n52999136)
print v(xbgr.mr_n52999248)
print v(xbgr.mr_n52999568)
print v(xbgr.mr_n52999680)
print v(xbgr.mr_n53000000)
print v(xbgr.mr_n53000112)
print v(xbgr.mr_n53000432)
print v(xbgr.mr_n53000544)
print v(xbgr.mr_n53000864)
print v(xbgr.mr_n53000976)
print v(xbgr.mr_n53001296)
print v(xbgr.mr_n53001408)
print v(xbgr.mr_n53001728)
print v(xbgr.mr_n53001840)
print v(xbgr.mr_n53002160)
print v(xbgr.mr_n53002272)
print v(xbgr.mr_n53002704)
print v(xbgr.mr_n53003024)
print v(xbgr.mr_n53003136)
print v(xbgr.mr_n53003456)
print v(xbgr.mr_n53003568)
print v(xbgr.mr_n53003888)
print v(xbgr.mr_n53004000)
print v(xbgr.mr_n53004432)
print v(xbgr.mr_n53004752)
print v(xbgr.mr_n53004864)
print v(xbgr.mr_n53005184)
print v(xbgr.mr_n53005296)
print v(xbgr.mr_n53005616)
print v(xbgr.mr_n53005728)
print v(xbgr.mr_n53006160)
print v(xbgr.mr_n53006480)
print v(xbgr.mr_n53006592)
print v(xbgr.mr_n53006912)
print v(xbgr.mr_n53007024)
print v(xbgr.mr_n53007344)
print v(xbgr.mr_n53007456)
print v(xbgr.mr_n53007776)
print v(xbgr.mr_n53007888)
print v(xbgr.mr_n53008208)
print v(xbgr.mr_n53008320)
print v(xbgr.mr_n53008640)
print v(xbgr.mr_n53008752)
print v(xbgr.mr_n53009072)
print v(xbgr.mr_n53009184)
print v(xbgr.mr_n53009504)
print v(xbgr.mr_n53009616)
print v(xbgr.mr_n53009936)
print v(xbgr.mr_n53010048)
print v(xbgr.mr_n53010368)
print v(xbgr.mr_n53010480)
print v(xbgr.mr_n53010800)
print v(xbgr.mr_n53010912)
print v(xbgr.mr_n53011232)
print v(xbgr.mr_n53011344)
print v(xbgr.mr_n53011664)
print v(xbgr.mr_n53011776)
print v(xbgr.mr_n53012096)
print v(xbgr.mr_n53012208)
print v(xbgr.mr_n53012528)
print v(xbgr.mr_n53012640)
print v(xbgr.mr_n53012960)
print v(xbgr.mr_n53013072)
print v(xbgr.mr_n53013392)
print v(xbgr.mr_n53013504)
print v(xbgr.mr_n53013824)
print v(xbgr.mr_n53013936)
print v(xbgr.mr_n53014256)
print v(xbgr.mr_n53014368)
print v(xbgr.mr_n53014688)
print v(xbgr.mr_n53014800)
print v(xbgr.mr_n53015120)
print v(xbgr.mr_n53015232)
print v(xbgr.mr_n53015552)
print v(xbgr.mr_n53015664)
print v(xbgr.mr_n53015984)
print v(xbgr.mr_n53016096)
print v(xbgr.mr_n53016416)
print v(xbgr.mr_n53016528)
print v(xbgr.mr_n53016848)
print v(xbgr.mr_n53016960)
print v(xbgr.mr_n53017280)
print v(xbgr.mr_n53017392)
print v(xbgr.mr_n53017712)
print v(xbgr.mr_n53017824)
print v(xbgr.mr_n53018144)
print v(xbgr.mr_n53018256)
print v(xbgr.mr_n53018576)
print v(xbgr.mr_n53018688)
print v(xbgr.mr_n53019008)
print v(xbgr.mr_n53019120)
print v(xbgr.mr_n53019440)
print v(xbgr.mr_n53019552)
print v(xbgr.mr_n53019872)
print v(xbgr.mr_n53019984)
print v(xbgr.mr_n53020304)
print v(xbgr.mr_n53020416)
print v(xbgr.mr_n53020736)
print v(xbgr.mr_n53020848)
print v(xbgr.mr_n53021168)
print v(xbgr.mr_n53021280)
print v(xbgr.mr_n53021600)
print v(xbgr.mr_n53021712)
print v(xbgr.mr_n53022032)
print v(xbgr.mr_n53022144)
print v(xbgr.mr_n53022464)
print v(xbgr.mr_n53022576)
print v(xbgr.mr_n53022896)
print v(xbgr.mr_n53023008)
print v(xbgr.mr_n53023328)
print v(xbgr.mr_n53023440)
print v(xbgr.mr_n53023760)
print v(xbgr.mr_n53023872)
print v(xbgr.mr_n53024192)
print v(xbgr.mr_n53024304)
print v(xbgr.mr_n53024624)
print v(xbgr.mr_n53024736)
print v(xbgr.mr_n53025056)
print v(xbgr.mr_n53025168)
print v(xbgr.mr_n53025488)
print v(xbgr.mr_n53025600)
print v(xbgr.mr_n53025920)
print v(xbgr.mr_n53026032)
print v(xbgr.mr_n53026464)
print v(xbgr.mr_n53026896)
print v(xbgr.mr_n53027328)
print v(xbgr.mr_n53027760)
print v(xbgr.mr_n53028192)
print v(xbgr.mr_n53028624)
print v(xbgr.mr_n53029056)
print v(xbgr.mr_n53029488)
print v(xbgr.mr_n53029920)
print v(xbgr.mr_n53030352)
print v(xbgr.mr_n53030784)
print v(xbgr.mr_n53031216)
print v(xbgr.mr_n53031648)
print v(xbgr.mr_n53032080)
print v(xbgr.mr_n53032512)
print v(xbgr.mr_n53032944)
print v(xbgr.mr_n53033376)
print v(xbgr.mr_n53033808)
print v(xbgr.mr_n53034240)
print v(xbgr.mr_n53034672)
print v(xbgr.mr_n53035104)
print v(xbgr.mr_n53035536)
print v(xbgr.mr_n53035968)
print v(xbgr.mr_n53036400)
print v(xbgr.mr_n53036832)
print v(xbgr.mr_n53037264)
print v(xbgr.mr_n53037696)
print v(xbgr.mr_n53038128)
print v(xbgr.mr_n53038560)
print v(xbgr.mr_n53038992)
print v(xbgr.mr_n53039424)
print v(xbgr.mr_n53039856)
print v(xbgr.mr_n53040288)
print v(xbgr.mr_n53040720)
print v(xbgr.mr_n53041152)
print v(xbgr.mr_n53041584)
print v(xbgr.mr_n53042016)
print v(xbgr.mr_n53042448)
print v(xbgr.mr_n53042880)
print v(xbgr.mr_n53043312)
print v(xbgr.mr_n53043744)
print v(xbgr.mr_n53044176)
print v(xbgr.mr_n53044608)
print v(xbgr.mr_n53045040)
print v(xbgr.mr_n53045472)
print v(xbgr.mr_n53045904)
print v(xbgr.mr_n53046336)
print v(xbgr.mr_n53046768)
print v(xbgr.mr_n53047200)
print v(xbgr.mr_n53047632)
print v(xbgr.mr_n53048064)
print v(xbgr.mr_n53048496)
print v(xbgr.mr_n53048928)
print v(xbgr.mr_n53049360)
print v(xbgr.mr_n53049792)
print v(xbgr.mr_n53050224)
print v(xbgr.mr_n53050656)
print v(xbgr.mr_n53051088)
print v(xbgr.mr_n53051520)
print v(xbgr.mr_n53051952)
print v(xbgr.mr_n53052384)
print v(xbgr.mr_n53052816)
print v(xbgr.mr_n53053248)
print v(xbgr.mr_n53053680)
print v(xbgr.mr_n53054112)
print v(xbgr.mr_n53054544)
print v(xbgr.mr_n53054976)
print v(xbgr.mr_n53055408)
print v(xbgr.mr_n53055840)
print v(xbgr.mr_n53056272)
print v(xbgr.mr_n53056704)
print v(xbgr.mr_n53057136)
print v(xbgr.mr_n53057568)
print v(xbgr.mr_n53058000)
print v(xbgr.mr_n53058432)
print v(xbgr.mr_n53058864)
print v(xbgr.mr_n53059296)
print v(xbgr.mr_n53059728)
print v(xbgr.mr_n53060160)
print v(xbgr.mr_n53060592)
print v(xbgr.mr_n53060912)
print v(xbgr.mr_n53061024)
print v(xbgr.mr_n53061456)
print v(xbgr.mr_n53061776)
print v(xbgr.mr_n53061888)
print v(xbgr.mr_n53062208)
print v(xbgr.mr_n53062320)
print v(xbgr.mr_n53062640)
print v(xbgr.mr_n53062752)
print v(xbgr.mr_n53063072)
print v(xbgr.mr_n53063184)
print v(xbgr.mr_n53063504)
print v(xbgr.mr_n53063616)
print v(xbgr.mr_n53063936)
print v(xbgr.mr_n53064048)
print v(xbgr.mr_n53064368)
print v(xbgr.mr_n53064480)
print v(xbgr.mr_n53064800)
print v(xbgr.mr_n53064912)
print v(xbgr.mr_n53065232)
print v(xbgr.mr_n53065344)
print v(xbgr.mr_n53065664)
print v(xbgr.mr_n53065776)
print v(xbgr.mr_n53066208)
print v(xbgr.mr_n53066640)
print v(xbgr.mr_n53067072)
print v(xbgr.mr_n53067504)
print v(xbgr.mr_n53067936)
print v(xbgr.mr_n53068368)
print v(xbgr.mr_n53068800)
print v(xbgr.mr_n53069232)
print v(xbgr.mr_n53069664)
print v(xbgr.mr_n53070096)
print v(xbgr.mr_n53070528)
print v(xbgr.mr_n53070960)
print v(xbgr.mr_n53071392)
print v(xbgr.mr_n53071824)
print v(xbgr.mr_n53072256)
print v(xbgr.mr_n53072688)
print v(xbgr.mr_n53073120)
print v(xbgr.mr_n53073552)
print v(xbgr.mr_n53073984)
print v(xbgr.mr_n53074416)
print v(xbgr.mr_n53074848)
print v(xbgr.mr_n53075280)
print v(xbgr.mr_n53075712)
print v(xbgr.mr_n53076144)
print v(xbgr.mr_n53076576)
print v(xbgr.mr_n53077008)
print v(xbgr.mr_n53077440)
print v(xbgr.mr_n53077712)
print v(xbgr.mr_n53077824)
print v(xbgr.mr_n53078144)
print v(xbgr.mr_n53078256)
print v(xbgr.mr_n53078576)
print v(xbgr.mr_n53078688)
print v(xbgr.mr_n53079008)
print v(xbgr.mr_n53079120)
print v(xbgr.mr_n53079440)
print v(xbgr.mr_n53079552)
print v(xbgr.mr_n53079872)
print v(xbgr.mr_n53079984)
print v(xbgr.mr_n53080304)
print v(xbgr.mr_n53080416)
print v(xbgr.mr_n53080736)
print v(xbgr.mr_n53080848)
print v(xbgr.mr_n53081168)
print v(xbgr.mr_n53081280)
print v(xbgr.mr_n53081600)
print v(xbgr.mr_n53081712)
print v(xbgr.mr_n53082032)
print v(xbgr.mr_n53082144)
print v(xbgr.mr_n53082464)
print v(xbgr.mr_n53082576)
print v(xbgr.mr_n53082896)
print v(xbgr.mr_n53083008)
print v(xbgr.mr_n53083328)
print v(xbgr.mr_n53083440)
print v(xbgr.mr_n53083760)
print v(xbgr.mr_n53083872)
print v(xbgr.mr_n53084192)
print v(xbgr.mr_n53084304)
print v(xbgr.mr_n53084624)
print v(xbgr.mr_n53084736)
print v(xbgr.mr_n53085056)
print v(xbgr.mr_n53085168)
print v(xbgr.mr_n53085488)
print v(xbgr.mr_n53085600)
print v(xbgr.mr_n53085920)
print v(xbgr.mr_n53086032)
print v(xbgr.mr_n53086352)
print v(xbgr.mr_n53086464)
print v(xbgr.mr_n53086784)
print v(xbgr.mr_n53086896)
print v(xbgr.mr_n53087216)
print v(xbgr.mr_n53087328)
print v(xbgr.mr_n53087648)
print v(xbgr.mr_n53087760)
print v(xbgr.mr_n53088080)
print v(xbgr.mr_n53088192)
print v(xbgr.mr_n53088512)
print v(xbgr.mr_n53088624)
print v(xbgr.mr_n53088944)
print v(xbgr.mr_n53089056)
print v(xbgr.mr_n53089376)
print v(xbgr.mr_n53089488)
print v(xbgr.mr_n53089808)
print v(xbgr.mr_n53089920)
print v(xbgr.mr_n53090240)
print v(xbgr.mr_n53090352)
print v(xbgr.mr_n53090672)
print v(xbgr.mr_n53090784)
print v(xbgr.mr_n53091104)
print v(xbgr.mr_n53091216)
print v(xbgr.mr_n53091536)
print v(xbgr.mr_n53091648)
print v(xbgr.mr_n53091968)
print v(xbgr.mr_n53092080)
print v(xbgr.mr_n53092400)
print v(xbgr.mr_n53092512)
print v(xbgr.mr_n53092832)
print v(xbgr.mr_n53092944)
print v(xbgr.mr_n53093264)
print v(xbgr.mr_n53093376)
print v(xbgr.mr_n53093696)
print v(xbgr.mr_n53093808)
print v(xbgr.mr_n53094128)
print v(xbgr.mr_n53094240)
print v(xbgr.mr_n53094560)
print v(xbgr.mr_n53094672)
print v(xbgr.mr_n53094992)
print v(xbgr.mr_n53095104)
print v(xbgr.mr_n53095424)
print v(xbgr.mr_n53095536)
print v(xbgr.mr_n53095856)
print v(xbgr.mr_n53095968)
print v(xbgr.mr_n53096288)
print v(xbgr.mr_n53096400)
print v(xbgr.mr_n53096720)
print v(xbgr.mr_n53096832)
print v(xbgr.mr_n53097152)
print v(xbgr.mr_n53097264)
print v(xbgr.mr_n53097584)
print v(xbgr.mr_n53097696)
print v(xbgr.mr_n53098016)
print v(xbgr.mr_n53098128)
print v(xbgr.mr_n53098448)
print v(xbgr.mr_n53098560)
print v(xbgr.mr_n53098880)
print v(xbgr.mr_n53098992)
print v(xbgr.mr_n53099312)
print v(xbgr.mr_n53099424)
print v(xbgr.mr_n53099744)
print v(xbgr.mr_n53099856)
print v(xbgr.mr_n53100176)
print v(xbgr.mr_n53100288)
print v(xbgr.mr_n53100608)
print v(xbgr.mr_n53100720)
print v(xbgr.mr_n53101040)
print v(xbgr.mr_n53101152)
print v(xbgr.mr_n53101472)
print v(xbgr.mr_n53101584)
print v(xbgr.mr_n53101904)
print v(xbgr.mr_n53102016)
print v(xbgr.mr_n53102336)
print v(xbgr.mr_n53102448)
print v(xbgr.mr_n53102768)
print v(xbgr.mr_n53102880)
print v(xbgr.mr_n53103200)
print v(xbgr.mr_n53103312)
print v(xbgr.mr_n53103632)
print v(xbgr.mr_n53103744)
print v(xbgr.mr_n53104064)
print v(xbgr.mr_n53104176)
print v(xbgr.mr_n53104496)
print v(xbgr.mr_n53104608)
print v(xbgr.mr_n53104928)
print v(xbgr.mr_n53105040)
print v(xbgr.mr_n53105360)
print v(xbgr.mr_n53105472)
print v(xbgr.mr_n53105792)
print v(xbgr.mr_n53105904)
print v(xbgr.mr_n53106224)
print v(xbgr.mr_n53106336)
print v(xbgr.mr_n53106656)
print v(xbgr.mr_n53106768)
print v(xbgr.mr_n53107088)
print v(xbgr.mr_n53107200)
print v(xbgr.mr_n53107520)
print v(xbgr.mr_n53107632)
print v(xbgr.mr_n53107952)
print v(xbgr.mr_n53108064)
print v(xbgr.mr_n53108384)
print v(xbgr.mr_n53108496)
print v(xbgr.mr_n53108816)
print v(xbgr.mr_n53108928)
print v(xbgr.mr_n53109248)
print v(xbgr.mr_n53109360)
print v(xbgr.mr_n53109680)
print v(xbgr.mr_n53109792)
print v(xbgr.mr_n53110112)
print v(xbgr.mr_n53110224)
print v(xbgr.mr_n53110544)
print v(xbgr.mr_n53110656)
print v(xbgr.mr_n53110976)
print v(xbgr.mr_n53111088)
print v(xbgr.mr_n53111408)
print v(xbgr.mr_n53111520)
print v(xbgr.mr_n53111840)
print v(xbgr.mr_n53111952)
print v(xbgr.mr_n53112272)
print v(xbgr.mr_n53112384)
print v(xbgr.mr_n53112704)
print v(xbgr.mr_n53112816)
print v(xbgr.mr_n53113136)
print v(xbgr.mr_n53113248)
print v(xbgr.mr_n53113568)
print v(xbgr.mr_n53113680)
print v(xbgr.mr_n53114000)
print v(xbgr.mr_n53114112)
print v(xbgr.mr_n53114432)
print v(xbgr.mr_n53114544)
print v(xbgr.mr_n53114864)
print v(xbgr.mr_n53114976)
print v(xbgr.mr_n53115296)
print v(xbgr.mr_n53115408)
print v(xbgr.mr_n53115728)
print v(xbgr.mr_n53115840)
print v(xbgr.mr_n53116160)
print v(xbgr.mr_n53116272)
print v(xbgr.mr_n53116592)
print v(xbgr.mr_n53116704)
print v(xbgr.mr_n53117024)
print v(xbgr.mr_n53117136)
print v(xbgr.mr_n53117456)
print v(xbgr.mr_n53117568)
print v(xbgr.mr_n53117888)
print v(xbgr.mr_n53118000)
print v(xbgr.mr_n53118320)
print v(xbgr.mr_n53118432)
print v(xbgr.mr_n53118752)
print v(xbgr.mr_n53118864)
print v(xbgr.mr_n53119184)
print v(xbgr.mr_n53119296)
print v(xbgr.mr_n53119616)
print v(xbgr.mr_n53119728)
print v(xbgr.mr_n53120048)
print v(xbgr.mr_n53120160)
print v(xbgr.mr_n53120480)
print v(xbgr.mr_n53120592)
print v(xbgr.mr_n53120912)
print v(xbgr.mr_n53121024)
print v(xbgr.mr_n53121344)
print v(xbgr.mr_n53121456)
print v(xbgr.mr_n53121776)
print v(xbgr.mr_n53121888)
print v(xbgr.mr_n53122208)
print v(xbgr.mr_n53122320)
print v(xbgr.mr_n53122640)
print v(xbgr.mr_n53122752)
print v(xbgr.mr_n53123072)
print v(xbgr.mr_n53123184)
print v(xbgr.mr_n53123504)
print v(xbgr.mr_n53123616)
print v(xbgr.mr_n53123936)
print v(xbgr.mr_n53124048)
print v(xbgr.mr_n53124368)
print v(xbgr.mr_n53124480)
print v(xbgr.mr_n53124800)
print v(xbgr.mr_n53124912)
print v(xbgr.mr_n53125232)
print v(xbgr.mr_n53125344)
print v(xbgr.mr_n53125664)
print v(xbgr.mr_n53125776)
print v(xbgr.mr_n53126096)
print v(xbgr.mr_n53126208)
print v(xbgr.mr_n53126528)
print v(xbgr.mr_n53126640)
print v(xbgr.mr_n53126960)
print v(xbgr.mr_n53127072)
print v(xbgr.mr_n53127392)
print v(xbgr.mr_n53127504)
print v(xbgr.mr_n53127824)
print v(xbgr.mr_n53127936)
print v(xbgr.mr_n53128256)
print v(xbgr.mr_n53128368)
print v(xbgr.mr_n53128688)
print v(xbgr.mr_n53128800)
print v(xbgr.mr_n53129120)
print v(xbgr.mr_n53129232)
print v(xbgr.mr_n53129552)
print v(xbgr.mr_n53129664)
print v(xbgr.mr_n53129984)
print v(xbgr.mr_n53130096)
print v(xbgr.mr_n53130416)
print v(xbgr.mr_n53130528)
print v(xbgr.mr_n53130848)
print v(xbgr.mr_n53130960)
print v(xbgr.mr_n53131280)
print v(xbgr.mr_n53131392)
print v(xbgr.mr_n53131712)
print v(xbgr.mr_n53131824)
print v(xbgr.mr_n53132144)
print v(xbgr.mr_n53132256)
print v(xbgr.mr_n53132576)
print v(xbgr.mr_n53132688)
print v(xbgr.mr_n53133008)
print v(xbgr.mr_n53133120)
print v(xbgr.mr_n53133440)
print v(xbgr.mr_n53133552)
print v(xbgr.mr_n53133872)
print v(xbgr.mr_n53133984)
print v(xbgr.mr_n53134304)
print v(xbgr.mr_n53134416)
print v(xbgr.mr_n53134736)
print v(xbgr.mr_n53134848)
print v(xbgr.mr_n53135168)
print v(xbgr.mr_n53135280)
print v(xbgr.mr_n53135600)
print v(xbgr.mr_n53135712)
print v(xbgr.mr_n53136032)
print v(xbgr.mr_n53136144)
print v(xbgr.mr_n53136464)
print v(xbgr.mr_n53136576)
print v(xbgr.mr_n53136896)
print v(xbgr.mr_n53137008)
print v(xbgr.mr_n53137328)
print v(xbgr.mr_n53137440)
print v(xbgr.mr_n53137760)
print v(xbgr.mr_n53137872)
print v(xbgr.mr_n53138192)
print v(xbgr.mr_n53138304)
print v(xbgr.mr_n53138624)
print v(xbgr.mr_n53138736)
print v(xbgr.mr_n53139056)
print v(xbgr.mr_n53139168)
print v(xbgr.mr_n53139488)
print v(xbgr.mr_n53139600)
print v(xbgr.mr_n53139920)
print v(xbgr.mr_n53140032)
print v(xbgr.mr_n53140352)
print v(xbgr.mr_n53140464)
print v(xbgr.mr_n53140784)
print v(xbgr.mr_n53140896)
print v(xbgr.mr_n53141216)
print v(xbgr.mr_n53141328)
print v(xbgr.mr_n53141648)
print v(xbgr.mr_n53141760)
print v(xbgr.mr_n53142080)
print v(xbgr.mr_n53142192)
print v(xbgr.mr_n53142512)
print v(xbgr.mr_n53142624)
print v(xbgr.mr_n53142944)
print v(xbgr.mr_n53143056)
print v(xbgr.mr_n53143376)
print v(xbgr.mr_n53143488)
print v(xbgr.mr_n53143808)
print v(xbgr.mr_n53143920)
print v(xbgr.mr_n53144240)
print v(xbgr.mr_n53144352)
print v(xbgr.mr_n53144672)
print v(xbgr.mr_n53144784)
print v(xbgr.mr_n53145104)
print v(xbgr.mr_n53145216)
print v(xbgr.mr_n53145536)
print v(xbgr.mr_n53145648)
print v(xbgr.mr_n53145968)
print v(xbgr.mr_n53146080)
print v(xbgr.mr_n53146400)
print v(xbgr.mr_n53146512)
print v(xbgr.mr_n53146832)
print v(xbgr.mr_n53146944)
print v(xbgr.mr_n53147264)
print v(xbgr.mr_n53147376)
print v(xbgr.mr_n53147696)
print v(xbgr.mr_n53147808)
print v(xbgr.mr_n53148128)
print v(xbgr.mr_n53148240)
print v(xbgr.mr_n53148560)
print v(xbgr.mr_n53148672)
print v(xbgr.mr_n53148992)
print v(xbgr.mr_n53149104)
print v(xbgr.mr_n53149424)
print v(xbgr.mr_n53149536)
print v(xbgr.mr_n53149856)
print v(xbgr.mr_n53149968)
print v(xbgr.mr_n53150288)
print v(xbgr.mr_n53150400)
print v(xbgr.mr_n53150720)
print v(xbgr.mr_n53150832)
print v(xbgr.mr_n53151152)
print v(xbgr.mr_n53151264)
print v(xbgr.mr_n53151584)
print v(xbgr.mr_n53151696)
print v(xbgr.mr_n53152016)
print v(xbgr.mr_n53152128)
print v(xbgr.mr_n53152448)
print v(xbgr.mr_n53152560)
print v(xbgr.mr_n53152880)
print v(xbgr.mr_n53152992)
print v(xbgr.mr_n53153312)
print v(xbgr.mr_n53153424)
print v(xbgr.mr_n53153744)
print v(xbgr.mr_n53153856)
print v(xbgr.mr_n53154176)
print v(xbgr.mr_n53154288)
print v(xbgr.mr_n53154608)
print v(xbgr.mr_n53154720)
print v(xbgr.mr_n53155040)
print v(xbgr.mr_n53155152)
print v(xbgr.mr_n53155472)
print v(xbgr.mr_n53155584)
print v(xbgr.mr_n53155904)
print v(xbgr.mr_n53156016)
print v(xbgr.mr_n53156336)
print v(xbgr.mr_n53156448)
print v(xbgr.mr_n53156768)
print v(xbgr.mr_n53156880)
print v(xbgr.mr_n53157200)
print v(xbgr.mr_n53157312)
print v(xbgr.mr_n53157632)
print v(xbgr.mr_n53157744)
print v(xbgr.mr_n53158064)
print v(xbgr.mr_n53158176)
print v(xbgr.mr_n53158496)
print v(xbgr.mr_n53158608)
print v(xbgr.mr_n53158928)
print v(xbgr.mr_n53159040)
print v(xbgr.mr_n53159360)
print v(xbgr.mr_n53159472)
print v(xbgr.mr_n53159792)
print v(xbgr.mr_n53159904)
print v(xbgr.mr_n53160224)
print v(xbgr.mr_n53160336)
print v(xbgr.mr_n53160656)
print v(xbgr.mr_n53160768)
print v(xbgr.mr_n53161088)
print v(xbgr.mr_n53161200)
print v(xbgr.mr_n53161520)
print v(xbgr.mr_n53161632)
print v(xbgr.mr_n53161952)
print v(xbgr.mr_n53162064)
print v(xbgr.mr_n53162496)
print v(xbgr.mr_n53162816)
print v(xbgr.mr_n53162928)
print v(xbgr.mr_n53163248)
print v(xbgr.mr_n53163360)
print v(xbgr.mr_n53163680)
print v(xbgr.mr_n53163792)
print v(xbgr.mr_n53164224)
print v(xbgr.mr_n53164544)
print v(xbgr.mr_n53164656)
print v(xbgr.mr_n53164976)
print v(xbgr.mr_n53165088)
print v(xbgr.mr_n53165408)
print v(xbgr.mr_n53165520)
print v(xbgr.mr_n53165952)
print v(xbgr.mr_n53166272)
print v(xbgr.mr_n53166384)
print v(xbgr.mr_n53166704)
print v(xbgr.mr_n53166816)
print v(xbgr.mr_n53167136)
print v(xbgr.mr_n53167248)
print v(xbgr.mr_n53167680)
print v(xbgr.mr_n53168000)
print v(xbgr.mr_n53168112)
print v(xbgr.mr_n53168432)
print v(xbgr.mr_n53168544)
print v(xbgr.mr_n53168864)
print v(xbgr.mr_n53168976)
print v(xbgr.mr_n53169408)
print v(xbgr.mr_n53169728)
print v(xbgr.mr_n53169840)
print v(xbgr.mr_n53170160)
print v(xbgr.mr_n53170272)
print v(xbgr.mr_n53170592)
print v(xbgr.mr_n53170704)
print v(xbgr.mr_n53171136)
print v(xbgr.mr_n53171456)
print v(xbgr.mr_n53171568)
print v(xbgr.mr_n53171888)
print v(xbgr.mr_n53172000)
print v(xbgr.mr_n53172320)
print v(xbgr.mr_n53172432)
print v(xbgr.mr_n53172864)
print v(xbgr.mr_n53173184)
print v(xbgr.mr_n53173296)
print v(xbgr.mr_n53173616)
print v(xbgr.mr_n53173728)
print v(xbgr.mr_n53174048)
print v(xbgr.mr_n53174160)
print v(xbgr.mr_n53174592)
print v(xbgr.mr_n53174912)
print v(xbgr.mr_n53175024)
print v(xbgr.mr_n53175344)
print v(xbgr.mr_n53175456)
print v(xbgr.mr_n53175776)
print v(xbgr.mr_n53175888)
print v(xbgr.mr_n53176208)
print v(xbgr.mr_n53176320)
print v(xbgr.mr_n53176640)
print v(xbgr.mr_n53176752)
print v(xbgr.mr_n53177072)
print v(xbgr.mr_n53177184)
print v(xbgr.mr_n53177504)
print v(xbgr.mr_n53177616)
print v(xbgr.mr_n53177936)
print v(xbgr.mr_n53178048)
print v(xbgr.mr_n53178368)
print v(xbgr.mr_n53178480)
print v(xbgr.mr_n53178800)
print v(xbgr.mr_n53178912)
print v(xbgr.mr_n53179232)
print v(xbgr.mr_n53179344)
print v(xbgr.mr_n53179664)
print v(xbgr.mr_n53179776)
print v(xbgr.mr_n53180096)
print v(xbgr.mr_n53180208)
print v(xbgr.mr_n53180528)
print v(xbgr.mr_n53180640)
print v(xbgr.mr_n53180960)
print v(xbgr.mr_n53181072)
print v(xbgr.mr_n53181392)
print v(xbgr.mr_n53181504)
print v(xbgr.mr_n53181824)
print v(xbgr.mr_n53181936)
print v(xbgr.mr_n53182256)
print v(xbgr.mr_n53182368)
print v(xbgr.mr_n53182688)
print v(xbgr.mr_n53182800)
print v(xbgr.mr_n53183120)
print v(xbgr.mr_n53183232)
print v(xbgr.mr_n53183552)
print v(xbgr.mr_n53183664)
print v(xbgr.mr_n53183984)
print v(xbgr.mr_n53184096)
print v(xbgr.mr_n53184416)
print v(xbgr.mr_n53184528)
print v(xbgr.mr_n53184848)
print v(xbgr.mr_n53184960)
print v(xbgr.mr_n53185280)
print v(xbgr.mr_n53185392)
print v(xbgr.mr_n53185712)
print v(xbgr.mr_n53185824)
print v(xbgr.mr_n53186144)
print v(xbgr.mr_n53186256)
print v(xbgr.mr_n53186576)
print v(xbgr.mr_n53186688)
print v(xbgr.mr_n53187008)
print v(xbgr.mr_n53187120)
print v(xbgr.mr_n53187440)
print v(xbgr.mr_n53187552)
print v(xbgr.mr_n53187872)
print v(xbgr.mr_n53187984)
print v(xbgr.mr_n53188304)
print v(xbgr.mr_n53188416)
print v(xbgr.mr_n53188736)
print v(xbgr.mr_n53188848)
print v(xbgr.mr_n53189168)
print v(xbgr.mr_n53189280)
print v(xbgr.mr_n53189600)
print v(xbgr.mr_n53189712)
print v(xbgr.mr_n53190032)
print v(xbgr.mr_n53190144)
print v(xbgr.mr_n53190464)
print v(xbgr.mr_n53190576)
print v(xbgr.mr_n53190896)
print v(xbgr.mr_n53191008)
print v(xbgr.mr_n53191328)
print v(xbgr.mr_n53191440)
print v(xbgr.mr_n53191760)
print v(xbgr.mr_n53191872)
print v(xbgr.mr_n53192192)
print v(xbgr.mr_n53192304)
print v(xbgr.mr_n53192624)
print v(xbgr.mr_n53192736)
print v(xbgr.mr_n53193056)
print v(xbgr.mr_n53193168)
print v(xbgr.mr_n53193488)
print v(xbgr.mr_n53193600)
print v(xbgr.mr_n53193920)
print v(xbgr.mr_n53194032)
print v(xbgr.mr_n53194352)
print v(xbgr.mr_n53194464)
print v(xbgr.mr_n53194784)
print v(xbgr.mr_n53194896)
print v(xbgr.mr_n53195216)
print v(xbgr.mr_n53195328)
print v(xbgr.mr_n53195648)
print v(xbgr.mr_n53195760)
print v(xbgr.mr_n53196080)
print v(xbgr.mr_n53196192)
print v(xbgr.mr_n53196512)
print v(xbgr.mr_n53196624)
print v(xbgr.mr_n53196944)
print v(xbgr.mr_n53197056)
print v(xbgr.mr_n53197376)
print v(xbgr.mr_n53197488)
print v(xbgr.mr_n53197808)
print v(xbgr.mr_n53197920)
print v(xbgr.mr_n53198240)
print v(xbgr.mr_n53198352)
print v(xbgr.mr_n53198672)
print v(xbgr.mr_n53198784)
print v(xbgr.mr_n53199104)
print v(xbgr.mr_n53199216)
print v(xbgr.mr_n53199536)
print v(xbgr.mr_n53199648)
print v(xbgr.mr_n53199968)
print v(xbgr.mr_n53200080)
print v(xbgr.mr_n53200400)
print v(xbgr.mr_n53200512)
print v(xbgr.mr_n53200832)
print v(xbgr.mr_n53200944)
print v(xbgr.mr_n53201264)
print v(xbgr.mr_n53201376)
print v(xbgr.mr_n53201696)
print v(xbgr.mr_n53201808)
print v(xbgr.mr_n53202128)
print v(xbgr.mr_n53202240)
print v(xbgr.mr_n53202560)
print v(xbgr.mr_n53202672)
print v(xbgr.mr_n53202992)
print v(xbgr.mr_n53203104)
print v(xbgr.mr_n53203424)
print v(xbgr.mr_n53203536)
print v(xbgr.mr_n53203856)
print v(xbgr.mr_n53203968)
print v(xbgr.mr_n53204288)
print v(xbgr.mr_n53204400)
print v(xbgr.mr_n53204832)
print v(xbgr.mr_n53205152)
print v(xbgr.mr_n53205264)
print v(xbgr.mr_n53205584)
print v(xbgr.mr_n53205696)
print v(xbgr.mr_n53206016)
print v(xbgr.mr_n53206128)
print v(xbgr.mr_n53206560)
print v(xbgr.mr_n53206880)
print v(xbgr.mr_n53206992)
print v(xbgr.mr_n53207312)
print v(xbgr.mr_n53207424)
print v(xbgr.mr_n53207744)
print v(xbgr.mr_n53207856)
print v(xbgr.mr_n53208288)
print v(xbgr.mr_n53208608)
print v(xbgr.mr_n53208720)
print v(xbgr.mr_n53209040)
print v(xbgr.mr_n53209152)
print v(xbgr.mr_n53209472)
print v(xbgr.mr_n53209584)
print v(xbgr.mr_n53209904)
print v(xbgr.mr_n53210016)
print v(xbgr.mr_n53210336)
print v(xbgr.mr_n53210448)
print v(xbgr.mr_n53210768)
print v(xbgr.mr_n53210880)
print v(xbgr.mr_n53211200)
print v(xbgr.mr_n53211312)
print v(xbgr.mr_n53211632)
print v(xbgr.mr_n53211744)
print v(xbgr.mr_n53212064)
print v(xbgr.mr_n53212176)
print v(xbgr.mr_n53212608)
print v(xbgr.mr_n53212928)
print v(xbgr.mr_n53213040)
print v(xbgr.mr_n53213472)
print v(xbgr.mr_n53213792)
print v(xbgr.mr_n53213904)
print v(xbgr.mr_n53214336)
print v(xbgr.mr_n53214656)
print v(xbgr.mr_n53214768)
print v(xbgr.mr_n53215088)
print v(xbgr.mr_n53215200)
print v(xbgr.mr_n53215520)
print v(xbgr.mr_n53215632)
print v(xbgr.mr_n53216064)
print v(xbgr.mr_n53216384)
print v(xbgr.mr_n53216496)
print v(xbgr.mr_n53216816)
print v(xbgr.mr_n53216928)
print v(xbgr.mr_n53217248)
print v(xbgr.mr_n53217360)
print v(xbgr.mr_n53217680)
print v(xbgr.mr_n53217792)
print v(xbgr.mr_n53218112)
print v(xbgr.mr_n53218224)
print v(xbgr.mr_n53218656)
print v(xbgr.mr_n53218976)
print v(xbgr.mr_n53219088)
print v(xbgr.mr_n53219408)
print v(xbgr.mr_n53219520)
print v(xbgr.mr_n53219840)
print v(xbgr.mr_n53219952)
print v(xbgr.mr_n53220272)
print v(xbgr.mr_n53220384)
print v(xbgr.mr_n53220704)
print v(xbgr.mr_n53220816)
print v(xbgr.mr_n53221136)
print v(xbgr.mr_n53221248)
print v(xbgr.mr_n53221568)
print v(xbgr.mr_n53221680)
print v(xbgr.mr_n53222000)
print v(xbgr.mr_n53222112)
print v(xbgr.mr_n53222432)
print v(xbgr.mr_n53222544)
print v(xbgr.mr_n53222864)
print v(xbgr.mr_n53222976)
print v(xbgr.mr_n53223296)
print v(xbgr.mr_n53223408)
print v(xbgr.mr_n53223728)
print v(xbgr.mr_n53223840)
print v(xbgr.mr_n53224160)
print v(xbgr.mr_n53224272)
print v(xbgr.mr_n53224592)
print v(xbgr.mr_n53224704)
print v(xbgr.mr_n53225024)
print v(xbgr.mr_n53225136)
print v(xbgr.mr_n53225456)
print v(xbgr.mr_n53225568)
print v(xbgr.mr_n53225888)
print v(xbgr.mr_n53226000)
print v(xbgr.mr_n53226320)
print v(xbgr.mr_n53226432)
print v(xbgr.mr_n53226752)
print v(xbgr.mr_n53226864)
print v(xbgr.mr_n53227184)
print v(xbgr.mr_n53227296)
print v(xbgr.mr_n53227616)
print v(xbgr.mr_n53227728)
print v(xbgr.mr_n53228048)
print v(xbgr.mr_n53228160)
print v(xbgr.mr_n53228480)
print v(xbgr.mr_n53228592)
print v(xbgr.mr_n53228912)
print v(xbgr.mr_n53229024)
print v(xbgr.mr_n53229344)
print v(xbgr.mr_n53229456)
print v(xbgr.mr_n53229776)
print v(xbgr.mr_n53229888)
print v(xbgr.mr_n53230208)
print v(xbgr.mr_n53230320)
print v(xbgr.mr_n53230640)
print v(xbgr.mr_n53230752)
print v(xbgr.mr_n53231072)
print v(xbgr.mr_n53231184)
print v(xbgr.mr_n53231504)
print v(xbgr.mr_n53231616)
print v(xbgr.mr_n53231936)
print v(xbgr.mr_n53232048)
print v(xbgr.mr_n53232368)
print v(xbgr.mr_n53232480)
print v(xbgr.mr_n53232800)
print v(xbgr.mr_n53232912)
print v(xbgr.mr_n53233232)
print v(xbgr.mr_n53233344)
print v(xbgr.mr_n53233664)
print v(xbgr.mr_n53233776)
print v(xbgr.mr_n53234096)
print v(xbgr.mr_n53234208)
print v(xbgr.mr_n53234528)
print v(xbgr.mr_n53234640)
print v(xbgr.mr_n53234960)
print v(xbgr.mr_n53235072)
print v(xbgr.mr_n53235392)
print v(xbgr.mr_n53235504)
print v(xbgr.mr_n53235824)
print v(xbgr.mr_n53235936)
print v(xbgr.mr_n53236256)
print v(xbgr.mr_n53236368)
print v(xbgr.mr_n53236688)
print v(xbgr.mr_n53236800)
print v(xbgr.mr_n53237120)
print v(xbgr.mr_n53237232)
print v(xbgr.mr_n53237552)
print v(xbgr.mr_n53237664)
print v(xbgr.mr_n53237984)
print v(xbgr.mr_n53238096)
print v(xbgr.mr_n53238416)
print v(xbgr.mr_n53238528)
print v(xbgr.mr_n53238848)
print v(xbgr.mr_n53238960)
print v(xbgr.mr_n53239280)
print v(xbgr.mr_n53239392)
print v(xbgr.mr_n53239712)
print v(xbgr.mr_n53239824)
print v(xbgr.mr_n53240144)
print v(xbgr.mr_n53240256)
print v(xbgr.mr_n53240576)
print v(xbgr.mr_n53240688)
print v(xbgr.mr_n53241008)
print v(xbgr.mr_n53241120)
print v(xbgr.mr_n53241440)
print v(xbgr.mr_n53241552)
print v(xbgr.mr_n53241872)
print v(xbgr.mr_n53241984)
print v(xbgr.mr_n53242304)
print v(xbgr.mr_n53242416)
print v(xbgr.mr_n53242736)
print v(xbgr.mr_n53242848)
print v(xbgr.mr_n53243168)
print v(xbgr.mr_n53243280)
print v(xbgr.mr_n53243600)
print v(xbgr.mr_n53243712)
print v(xbgr.mr_n53244032)
print v(xbgr.mr_n53244144)
print v(xbgr.mr_n53244464)
print v(xbgr.mr_n53244576)
print v(xbgr.mr_n53244896)
print v(xbgr.mr_n53245008)
print v(xbgr.mr_n53245328)
print v(xbgr.mr_n53245440)
print v(xbgr.mr_n53245760)
print v(xbgr.mr_n53245872)
print v(xbgr.mr_n53246192)
print v(xbgr.mr_n53246304)
print v(xbgr.mr_n53246624)
print v(xbgr.mr_n53246736)
print v(xbgr.mr_n53247056)
print v(xbgr.mr_n53247168)
print v(xbgr.mr_n53247488)
print v(xbgr.mr_n53247600)
print v(xbgr.mr_n53247920)
print v(xbgr.mr_n53248032)
print v(xbgr.mr_n53248352)
print v(xbgr.mr_n53248464)
print v(xbgr.mr_n53248784)
print v(xbgr.mr_n53248896)
print v(xbgr.mr_n53249216)
print v(xbgr.mr_n53249328)
print v(xbgr.mr_n53249648)
print v(xbgr.mr_n53249760)
print v(xbgr.mr_n53250080)
print v(xbgr.mr_n53250192)
print v(xbgr.mr_n53250512)
print v(xbgr.mr_n53250624)
print v(xbgr.mr_n53250944)
print v(xbgr.mr_n53251056)
print v(xbgr.mr_n53251376)
print v(xbgr.mr_n53251488)
print v(xbgr.mr_n53251808)
print v(xbgr.mr_n53251920)
print v(xbgr.mr_n53252240)
print v(xbgr.mr_n53252352)
print v(xbgr.mr_n53252672)
print v(xbgr.mr_n53252784)
print v(xbgr.mr_n53253104)
print v(xbgr.mr_n53253216)
print v(xbgr.mr_n53253536)
print v(xbgr.mr_n53253648)
print v(xbgr.mr_n53253968)
print v(xbgr.mr_n53254080)
print v(xbgr.mr_n53254400)
print v(xbgr.mr_n53254512)
print v(xbgr.mr_n53254832)
print v(xbgr.mr_n53254944)
print v(xbgr.mr_n53255264)
print v(xbgr.mr_n53255376)
print v(xbgr.mr_n53255696)
print v(xbgr.mr_n53255808)
print v(xbgr.mr_n53256128)
print v(xbgr.mr_n53256240)
print v(xbgr.mr_n53256560)
print v(xbgr.mr_n53256672)
print v(xbgr.mr_n53256992)
print v(xbgr.mr_n53257104)
print v(xbgr.mr_n53257424)
print v(xbgr.mr_n53257536)
print v(xbgr.mr_n53257856)
print v(xbgr.mr_n53257968)
print v(xbgr.mr_n53258288)
print v(xbgr.mr_n53258400)
print v(xbgr.mr_n53258720)
print v(xbgr.mr_n53258832)
print v(xbgr.mr_n53259152)
print v(xbgr.mr_n53259264)
print v(xbgr.mr_n53259584)
print v(xbgr.mr_n53259696)
print v(xbgr.mr_n53260016)
print v(xbgr.mr_n53260128)
print v(xbgr.mr_n53260448)
print v(xbgr.mr_n53260560)
print v(xbgr.mr_n53260880)
print v(xbgr.mr_n53260992)
print v(xbgr.mr_n53261312)
print v(xbgr.mr_n53261424)
print v(xbgr.mr_n53261744)
print v(xbgr.mr_n53261856)
print v(xbgr.mr_n53262176)
print v(xbgr.mr_n53262288)
print v(xbgr.mr_n53262608)
print v(xbgr.mr_n53262720)
print v(xbgr.mr_n53263040)
print v(xbgr.mr_n53263152)
print v(xbgr.mr_n53263472)
print v(xbgr.mr_n53263584)
print v(xbgr.mr_n53263904)
print v(xbgr.mr_n53264016)
print v(xbgr.mr_n53264336)
print v(xbgr.mr_n53264448)
print v(xbgr.mr_n53264768)
print v(xbgr.mr_n53264880)
print v(xbgr.mr_n53265200)
print v(xbgr.mr_n53265312)
print v(xbgr.mr_n53265632)
print v(xbgr.mr_n53265744)
print v(xbgr.mr_n53266064)
print v(xbgr.mr_n53266176)
print v(xbgr.mr_n53266496)
print v(xbgr.mr_n53266608)
print v(xbgr.mr_n53266928)
print v(xbgr.mr_n53267040)
print v(xbgr.mr_n53267360)
print v(xbgr.mr_n53267472)
print v(xbgr.mr_n53267792)
print v(xbgr.mr_n53267904)
print v(xbgr.mr_n53268224)
print v(xbgr.mr_n53268336)
print v(xbgr.mr_n53268656)
print v(xbgr.mr_n53268768)
print v(xbgr.mr_n53269088)
print v(xbgr.mr_n53269200)
print v(xbgr.mr_n53269520)
print v(xbgr.mr_n53269632)
print v(xbgr.mr_n53269952)
print v(xbgr.mr_n53270064)
print v(xbgr.mr_n53270384)
print v(xbgr.mr_n53270496)
print v(xbgr.mr_n53270816)
print v(xbgr.mr_n53270928)
print v(xbgr.mr_n53271248)
print v(xbgr.mr_n53271360)
print v(xbgr.mr_n53271680)
print v(xbgr.mr_n53271792)
print v(xbgr.mr_n53272112)
print v(xbgr.mr_n53272224)
print v(xbgr.mr_n53272544)
print v(xbgr.mr_n53272656)
print v(xbgr.mr_n53272976)
print v(xbgr.mr_n53273088)
print v(xbgr.mr_n53273408)
print v(xbgr.mr_n53273520)
print v(xbgr.mr_n53273840)
print v(xbgr.mr_n53273952)
print v(xbgr.mr_n53274272)
print v(xbgr.mr_n53274384)
print v(xbgr.mr_n53274704)
print v(xbgr.mr_n53274816)
print v(xbgr.mr_n53275136)
print v(xbgr.mr_n53275248)
print v(xbgr.mr_n53275568)
print v(xbgr.mr_n53275680)
print v(xbgr.mr_n53276000)
print v(xbgr.mr_n53276112)
print v(xbgr.mr_n53276432)
print v(xbgr.mr_n53276544)
print v(xbgr.mr_n53276864)
print v(xbgr.mr_n53276976)
print v(xbgr.mr_n53277296)
print v(xbgr.mr_n53277408)
print v(xbgr.mr_n53277728)
print v(xbgr.mr_n53277840)
print v(xbgr.mr_n53278160)
print v(xbgr.mr_n53278272)
print v(xbgr.mr_n53278592)
print v(xbgr.mr_n53278704)
print v(xbgr.mr_n53279024)
print v(xbgr.mr_n53279136)
print v(xbgr.mr_n53279456)
print v(xbgr.mr_n53279568)
print v(xbgr.mr_n53279888)
print v(xbgr.mr_n53280000)
print v(xbgr.mr_n53280320)
print v(xbgr.mr_n53280432)
print v(xbgr.mr_n53280752)
print v(xbgr.mr_n53280864)
print v(xbgr.mr_n53281184)
print v(xbgr.mr_n53281296)
print v(xbgr.mr_n53281616)
print v(xbgr.mr_n53281728)
print v(xbgr.mr_n53282048)
print v(xbgr.mr_n53282160)
print v(xbgr.mr_n53282480)
print v(xbgr.mr_n53282592)
print v(xbgr.mr_n53282912)
print v(xbgr.mr_n53283024)
print v(xbgr.mr_n53283344)
print v(xbgr.mr_n53283456)
print v(xbgr.mr_n53283776)
print v(xbgr.mr_n53283888)
print v(xbgr.mr_n53284208)
print v(xbgr.mr_n53284320)
print v(xbgr.mr_n53284640)
print v(xbgr.mr_n53284752)
print v(xbgr.mr_n53285072)
print v(xbgr.mr_n53285184)
print v(xbgr.mr_n53285504)
print v(xbgr.mr_n53285616)
print v(xbgr.mr_n53285936)
print v(xbgr.mr_n53286048)
print v(xbgr.mr_n53286368)
print v(xbgr.mr_n53286480)
print v(xbgr.mr_n53286800)
print v(xbgr.mr_n53286912)
print v(xbgr.mr_n53287232)
print v(xbgr.mr_n53287344)
print v(xbgr.mr_n53287664)
print v(xbgr.mr_n53287776)
print v(xbgr.mr_n53288096)
print v(xbgr.mr_n53288208)
print v(xbgr.mr_n53288528)
print v(xbgr.mr_n53288640)
print v(xbgr.mr_n53288960)
print v(xbgr.mr_n53289072)
print v(xbgr.mr_n53289392)
print v(xbgr.mr_n53289504)
print v(xbgr.mr_n53289824)
print v(xbgr.mr_n53289936)
print v(xbgr.mr_n53290256)
print v(xbgr.mr_n53290368)
print v(xbgr.mr_n53290688)
print v(xbgr.mr_n53290800)
print v(xbgr.mr_n53291120)
print v(xbgr.mr_n53291232)
print v(xbgr.mr_n53291552)
print v(xbgr.mr_n53291664)
print v(xbgr.mr_n53291984)
print v(xbgr.mr_n53292096)
print v(xbgr.mr_n53292416)
print v(xbgr.mr_n53292528)
print v(xbgr.mr_n53292848)
print v(xbgr.mr_n53292960)
print v(xbgr.mr_n53293280)
print v(xbgr.mr_n53293392)
print v(xbgr.mr_n53293824)
print v(xbgr.mr_n53294144)
print v(xbgr.mr_n53294256)
print v(xbgr.mr_n53294688)
print v(xbgr.mr_n53295008)
print v(xbgr.mr_n53295120)
print v(xbgr.mr_n53295552)
print v(xbgr.mr_n53295872)
print v(xbgr.mr_n53296736)
print v(xbgr.mr_n53296848)
print v(xbgr.mr_n53297280)
print v(xbgr.mr_n53297600)
print v(xbgr.mr_n53297712)
print v(xbgr.mr_n53298032)
print v(xbgr.mr_n53298144)
print v(xbgr.mr_n53298464)
print v(xbgr.mr_n53298576)
print v(xbgr.mr_n53298896)
print v(xbgr.mr_n53299008)
print v(xbgr.mr_n53299328)
print v(xbgr.mr_n53299440)
print v(xbgr.mr_n53299760)
print v(xbgr.mr_n53299872)
print v(xbgr.mr_n53300192)
print v(xbgr.mr_n53300304)
print v(xbgr.mr_n53300624)
print v(xbgr.mr_n53300736)
print v(xbgr.mr_n53301056)
print v(xbgr.mr_n53301920)
print v(xbgr.mr_n53302784)
print v(xbgr.mr_n53302896)
print v(xbgr.mr_n53303216)
print v(xbgr.mr_n53303328)
print v(xbgr.mr_n53303648)
print v(xbgr.mr_n53304512)
print v(xbgr.mr_n53304624)
print v(xbgr.mr_n53304944)
print v(xbgr.mr_n53305056)
print v(xbgr.mr_n53305376)
print v(xbgr.mr_n53305488)
print v(xbgr.mr_n53305808)
print v(xbgr.mr_n53305920)
print v(xbgr.mr_n53306240)
print v(xbgr.mr_n53306352)
print v(xbgr.mr_n53306672)
print v(xbgr.mr_n53306784)
print v(xbgr.mr_n53307104)
print v(xbgr.mr_n53307216)
print v(xbgr.mr_n53307536)
print v(xbgr.mr_n53307648)
print v(xbgr.mr_n53307968)
print v(xbgr.mr_n53308080)
print v(xbgr.mr_n53308400)
print v(xbgr.mr_n53308512)
print v(xbgr.mr_n53308832)
print v(xbgr.mr_n53308944)
print v(xbgr.mr_n53309264)
print v(xbgr.mr_n53309376)
print v(xbgr.mr_n53309696)
print v(xbgr.mr_n53309808)
print v(xbgr.mr_n53310128)
print v(xbgr.mr_n53310240)
print v(xbgr.mr_n53310560)
print v(xbgr.mr_n53310672)
print v(xbgr.mr_n53310992)
print v(xbgr.mr_n53311104)
print v(xbgr.mr_n53311424)
print v(xbgr.mr_n53311536)
print v(xbgr.mr_n53311856)
print v(xbgr.mr_n53311968)
print v(xbgr.mr_n53312288)
print v(xbgr.mr_n53312400)
print v(xbgr.mr_n53312720)
print v(xbgr.mr_n53312832)
print v(xbgr.mr_n53313152)
print v(xbgr.mr_n53313264)
print v(xbgr.mr_n53313584)
print v(xbgr.mr_n53313696)
print v(xbgr.mr_n53314016)
print v(xbgr.mr_n53314128)
print v(xbgr.mr_n53314448)
print v(xbgr.mr_n53314560)
print v(xbgr.mr_n53314880)
print v(xbgr.mr_n53314992)
print v(xbgr.mr_n53315424)
print v(xbgr.mr_n53315744)
print v(xbgr.mr_n53315856)
print v(xbgr.mr_n53316176)
print v(xbgr.mr_n53316288)
print v(xbgr.mr_n53316608)
print v(xbgr.mr_n53316720)
print v(xbgr.mr_n53317040)
print v(xbgr.mr_n53317152)
print v(xbgr.mr_n53317472)
print v(xbgr.mr_n53317584)
print v(xbgr.mr_n53317904)
print v(xbgr.mr_n53318016)
print v(xbgr.mr_n53318336)
print v(xbgr.mr_n53318448)
print v(xbgr.mr_n53318768)
print v(xbgr.mr_n53318880)
print v(xbgr.mr_n53319200)
print v(xbgr.mr_n53319312)
print v(xbgr.mr_n53319632)
print v(xbgr.mr_n53319744)
print v(xbgr.mr_n53320064)
print v(xbgr.mr_n53320176)
print v(xbgr.mr_n53320496)
print v(xbgr.mr_n53320608)
print v(xbgr.mr_n53320928)
print v(xbgr.mr_n53321040)
print v(xbgr.mr_n53321360)
print v(xbgr.mr_n53321472)
print v(xbgr.mr_n53321792)
print v(xbgr.mr_n53322656)
print v(xbgr.mr_n53322768)
print v(xbgr.mr_n53323088)
print v(xbgr.mr_n53323200)
print v(xbgr.mr_n53323520)
print v(xbgr.mr_n53323632)
print v(xbgr.mr_n53323952)
print v(xbgr.mr_n53324064)
print v(xbgr.mr_n53324384)
print v(xbgr.mr_n53324496)
print v(xbgr.mr_n53324816)
print v(xbgr.mr_n53324928)
print v(xbgr.mr_n53325248)
print v(xbgr.mr_n53325360)
print v(xbgr.mr_n53325680)
print v(xbgr.mr_n53325792)
print v(xbgr.mr_n53326112)
print v(xbgr.mr_n53326224)
print v(xbgr.mr_n53326544)
print v(xbgr.mr_n53326656)
print v(xbgr.mr_n53326976)
print v(xbgr.mr_n53327088)
print v(xbgr.mr_n53327408)
print v(xbgr.mr_n53327520)
print v(xbgr.mr_n53327840)
print v(xbgr.mr_n53327952)
print v(xbgr.mr_n53328272)
print v(xbgr.mr_n53328384)
print v(xbgr.mr_n53328704)
print v(xbgr.mr_n53328816)
print v(xbgr.mr_n53329136)
print v(xbgr.mr_n53329248)
print v(xbgr.mr_n53329568)
print v(xbgr.mr_n53329680)
print v(xbgr.mr_n53330000)
print v(xbgr.mr_n53330112)
print v(xbgr.mr_n53330432)
print v(xbgr.mr_n53330544)
print v(xbgr.mr_n53330864)
print v(xbgr.mr_n53330976)
print v(xbgr.mr_n53331296)
print v(xbgr.mr_n53331408)
print v(xbgr.mr_n53331728)
print v(xbgr.mr_n53331840)
print v(xbgr.mr_n53332160)
print v(xbgr.mr_n53332272)
print v(xbgr.mr_n53332592)
print v(xbgr.mr_n53332704)
print v(xbgr.mr_n53333024)
print v(xbgr.mr_n53333136)
print v(xbgr.mr_n53333456)
print v(xbgr.mr_n53333568)
print v(xbgr.mr_n53333888)
print v(xbgr.mr_n53334000)
print v(xbgr.mr_n53334320)
print v(xbgr.mr_n53334432)
print v(xbgr.mr_n53334752)
print v(xbgr.mr_n53334864)
print v(xbgr.mr_n53335184)
print v(xbgr.mr_n53335296)
print v(xbgr.mr_n53335616)
print v(xbgr.mr_n53335728)
print v(xbgr.mr_n53336048)
print v(xbgr.mr_n53336160)
print v(xbgr.mr_n53336480)
print v(xbgr.mr_n53336592)
print v(xbgr.mr_n53336912)
print v(xbgr.mr_n53337024)
print v(xbgr.mr_n53337344)
print v(xbgr.mr_n53337456)
print v(xbgr.mr_n53337776)
print v(xbgr.mr_n53337888)
print v(xbgr.mr_n53338208)
print v(xbgr.mr_n53338320)
print v(xbgr.mr_n53338640)
print v(xbgr.mr_n53338752)
print v(xbgr.mr_n53339072)
print v(xbgr.mr_n53339184)
print v(xbgr.mr_n53339504)
print v(xbgr.mr_n53339616)
print v(xbgr.mr_n53339936)
print v(xbgr.mr_n53340048)
print v(xbgr.mr_n53340368)
print v(xbgr.mr_n53340480)
print v(xbgr.mr_n53340800)
print v(xbgr.mr_n53340912)
print v(xbgr.mr_n53341232)
print v(xbgr.mr_n53341344)
print v(xbgr.mr_n53341664)
print v(xbgr.mr_n53341776)
print v(xbgr.mr_n53342096)
print v(xbgr.mr_n53342208)
print v(xbgr.mr_n53342528)
print v(xbgr.mr_n53342640)
print v(xbgr.mr_n53342960)
print v(xbgr.mr_n53343072)
print v(xbgr.mr_n53343392)
print v(xbgr.mr_n53343504)
print v(xbgr.mr_n53343824)
print v(xbgr.mr_n53343936)
print v(xbgr.mr_n53344256)
print v(xbgr.mr_n53344368)
print v(xbgr.mr_n53344688)
print v(xbgr.mr_n53344800)
print v(xbgr.mr_n53345120)
print v(xbgr.mr_n53345232)
print v(xbgr.mr_n53345552)
print v(xbgr.mr_n53345664)
print v(xbgr.mr_n53345984)
print v(xbgr.mr_n53346096)
print v(xbgr.mr_n53346416)
print v(xbgr.mr_n53346528)
print v(xbgr.mr_n53346848)
print v(xbgr.mr_n53346960)
print v(xbgr.mr_n53347280)
print v(xbgr.mr_n53347392)
print v(xbgr.mr_n53347712)
print v(xbgr.mr_n53347824)
print v(xbgr.mr_n53348144)
print v(xbgr.mr_n53348256)
print v(xbgr.mr_n53348576)
print v(xbgr.mr_n53348688)
print v(xbgr.mr_n53349008)
print v(xbgr.mr_n53349120)
print v(xbgr.mr_n53349440)
print v(xbgr.mr_n53349552)
print v(xbgr.mr_n53349872)
print v(xbgr.mr_n53349984)
print v(xbgr.mr_n53350304)
print v(xbgr.mr_n53350416)
print v(xbgr.mr_n53350736)
print v(xbgr.mr_n53350848)
print v(xbgr.mr_n53351168)
print v(xbgr.mr_n53351280)
print v(xbgr.mr_n53351600)
print v(xbgr.mr_n53351712)
print v(xbgr.mr_n53352032)
print v(xbgr.mr_n53352144)
print v(xbgr.mr_n53352464)
print v(xbgr.mr_n53352576)
print v(xbgr.mr_n53352896)
print v(xbgr.mr_n53353008)
print v(xbgr.mr_n53353328)
print v(xbgr.mr_n53353440)
print v(xbgr.mr_n53353760)
print v(xbgr.mr_n53353872)
print v(xbgr.mr_n53354192)
print v(xbgr.mr_n53354304)
print v(xbgr.mr_n53354624)
print v(xbgr.mr_n53354736)
print v(xbgr.mr_n53355056)
print v(xbgr.mr_n53355168)
print v(xbgr.mr_n53355488)
print v(xbgr.mr_n53355600)
print v(xbgr.mr_n53355920)
print v(xbgr.mr_n53356032)
print v(xbgr.mr_n53356352)
print v(xbgr.mr_n53356464)
print v(xbgr.mr_n53356784)
print v(xbgr.mr_n53356896)
print v(xbgr.mr_n53357216)
print v(xbgr.mr_n53357328)
print v(xbgr.mr_n53357648)
print v(xbgr.mr_n53357760)
print v(xbgr.mr_n53358080)
print v(xbgr.mr_n53358192)
print v(xbgr.mr_n53358512)
print v(xbgr.mr_n53358624)
print v(xbgr.mr_n53358944)
print v(xbgr.mr_n53359056)
print v(xbgr.mr_n53359376)
print v(xbgr.mr_n53359488)
print v(xbgr.mr_n53359808)
print v(xbgr.mr_n53359920)
print v(xbgr.mr_n53360240)
print v(xbgr.mr_n53360352)
print v(xbgr.mr_n53360672)
print v(xbgr.mr_n53360784)
print v(xbgr.mr_n53361104)
print v(xbgr.mr_n53361216)
print v(xbgr.mr_n53361536)
print v(xbgr.mr_n53361648)
print v(xbgr.mr_n53361968)
print v(xbgr.mr_n53362080)
print v(xbgr.mr_n53362400)
print v(xbgr.mr_n53362512)
print v(xbgr.mr_n53362832)
print v(xbgr.mr_n53362944)
print v(xbgr.mr_n53363264)
print v(xbgr.mr_n53363376)
print v(xbgr.mr_n53363696)
print v(xbgr.mr_n53363808)
print v(xbgr.mr_n53364128)
print v(xbgr.mr_n53364240)
print v(xbgr.mr_n53364560)
print v(xbgr.mr_n53364672)
print v(xbgr.mr_n53364992)
print v(xbgr.mr_n53365104)
print v(xbgr.mr_n53365424)
print v(xbgr.mr_n53365536)
print v(xbgr.mr_n53365856)
print v(xbgr.mr_n53365968)
print v(xbgr.mr_n53366288)
print v(xbgr.mr_n53366400)
print v(xbgr.mr_n53366720)
print v(xbgr.mr_n53366832)
print v(xbgr.mr_n53367152)
print v(xbgr.mr_n53367264)
print v(xbgr.mr_n53367584)
print v(xbgr.mr_n53367696)
print v(xbgr.mr_n53368016)
print v(xbgr.mr_n53368128)
print v(xbgr.mr_n53368448)
print v(xbgr.mr_n53368560)
print v(xbgr.mr_n53368880)
print v(xbgr.mr_n53368992)
print v(xbgr.mr_n53369312)
print v(xbgr.mr_n53369424)
print v(xbgr.mr_n53369744)
print v(xbgr.mr_n53369856)
print v(xbgr.mr_n53370176)
print v(xbgr.mr_n53370288)
print v(xbgr.mr_n53370608)
print v(xbgr.mr_n53370720)
print v(xbgr.mr_n53371040)
print v(xbgr.mr_n53371152)
print v(xbgr.mr_n53371472)
print v(xbgr.mr_n53371584)
print v(xbgr.mr_n53371904)
print v(xbgr.mr_n53372016)
print v(xbgr.mr_n53372336)
print v(xbgr.mr_n53372448)
print v(xbgr.mr_n53372768)
print v(xbgr.mr_n53372880)
print v(xbgr.mr_n53373200)
print v(xbgr.mr_n53373312)
print v(xbgr.mr_n53373632)
print v(xbgr.mr_n53373744)
print v(xbgr.mr_n53374064)
print v(xbgr.mr_n53374176)
print v(xbgr.mr_n53374496)
print v(xbgr.mr_n53374608)
print v(xbgr.mr_n53374928)
print v(xbgr.mr_n53375040)
print v(xbgr.mr_n53375360)
print v(xbgr.mr_n53375472)
print v(xbgr.mr_n53375792)
print v(xbgr.mr_n53375904)
print v(xbgr.mr_n53376224)
print v(xbgr.mr_n53376336)
print v(xbgr.mr_n53376656)
print v(xbgr.mr_n53376768)
print v(xbgr.mr_n53377088)
print v(xbgr.mr_n53377200)
print v(xbgr.mr_n53377520)
print v(xbgr.mr_n53377632)
print v(xbgr.mr_n53377952)
print v(xbgr.mr_n53378064)
print v(xbgr.mr_n53378384)
print v(xbgr.mr_n53378496)
print v(xbgr.mr_n53378816)
print v(xbgr.mr_n53378928)
print v(xbgr.mr_n53379248)
print v(xbgr.mr_n53379360)
print v(xbgr.mr_n53379680)
print v(xbgr.mr_n53379792)
print v(xbgr.mr_n53380112)
print v(xbgr.mr_n53380224)
print v(xbgr.mr_n53380544)
print v(xbgr.mr_n53380656)
print v(xbgr.mr_n53380976)
print v(xbgr.mr_n53381088)
print v(xbgr.mr_n53381408)
print v(xbgr.mr_n53381520)
print v(xbgr.mr_n53381840)
print v(xbgr.mr_n53381952)
print v(xbgr.mr_n53382272)
print v(xbgr.mr_n53382384)
print v(xbgr.mr_n53382704)
print v(xbgr.mr_n53382816)
print v(xbgr.mr_n53383136)
print v(xbgr.mr_n53383248)
print v(xbgr.mr_n53383568)
print v(xbgr.mr_n53383680)
print v(xbgr.mr_n53384000)
print v(xbgr.mr_n53384112)
print v(xbgr.mr_n53384432)
print v(xbgr.mr_n53384544)
print v(xbgr.mr_n53384864)
print v(xbgr.mr_n53384976)
print v(xbgr.mr_n53385296)
print v(xbgr.mr_n53385408)
print v(xbgr.mr_n53385728)
print v(xbgr.mr_n53385840)
print v(xbgr.mr_n53386160)
print v(xbgr.mr_n53386272)
print v(xbgr.mr_n53386592)
print v(xbgr.mr_n53386704)
print v(xbgr.mr_n53387024)
print v(xbgr.mr_n53387136)
print v(xbgr.mr_n53387456)
print v(xbgr.mr_n53387568)
print v(xbgr.mr_n53387888)
print v(xbgr.mr_n53388000)
print v(xbgr.mr_n53388320)
print v(xbgr.mr_n53388432)
print v(xbgr.mr_n53388752)
print v(xbgr.mr_n53388864)
print v(xbgr.mr_n53389184)
print v(xbgr.mr_n53389296)
print v(xbgr.mr_n53389616)
print v(xbgr.mr_n53389728)
print v(xbgr.mr_n53390048)
print v(xbgr.mr_n53390160)
print v(xbgr.mr_n53390480)
print v(xbgr.mr_n53390592)
print v(xbgr.mr_n53390912)
print v(xbgr.mr_n53391024)
print v(xbgr.mr_n53391344)
print v(xbgr.mr_n53391456)
print v(xbgr.mr_n53391776)
print v(xbgr.mr_n53391888)
print v(xbgr.mr_n53392208)
print v(xbgr.mr_n53392320)
print v(xbgr.mr_n53392640)
print v(xbgr.mr_n53392752)
print v(xbgr.mr_n53393072)
print v(xbgr.mr_n53393184)
print v(xbgr.mr_n53393504)
print v(xbgr.mr_n53393616)
print v(xbgr.mr_n53393936)
print v(xbgr.mr_n53394048)
print v(xbgr.mr_n53394368)
print v(xbgr.mr_n53394480)
print v(xbgr.mr_n53394800)
print v(xbgr.mr_n53394912)
print v(xbgr.mr_n53395232)
print v(xbgr.mr_n53395344)
print v(xbgr.mr_n53395664)
print v(xbgr.mr_n53395776)
print v(xbgr.mr_n53396096)
print v(xbgr.mr_n53396208)
print v(xbgr.mr_n53396528)
print v(xbgr.mr_n53396640)
print v(xbgr.mr_n53396960)
print v(xbgr.mr_n53397072)
print v(xbgr.mr_n53397392)
print v(xbgr.mr_n53397504)
print v(xbgr.mr_n53397824)
print v(xbgr.mr_n53397936)
print v(xbgr.mr_n53398256)
print v(xbgr.mr_n53398368)
print v(xbgr.mr_n53398688)
print v(xbgr.mr_n53398800)
print v(xbgr.mr_n53399120)
print v(xbgr.mr_n53399232)
print v(xbgr.mr_n53399552)
print v(xbgr.mr_n53399664)
print v(xbgr.mr_n53399984)
print v(xbgr.mr_n53400096)
print v(xbgr.mr_n53400416)
print v(xbgr.mr_n53400528)
print v(xbgr.mr_n53400848)
print v(xbgr.mr_n53400960)
print v(xbgr.mr_n53401280)
print v(xbgr.mr_n53401392)
print v(xbgr.mr_n53401712)
print v(xbgr.mr_n53401824)
print v(xbgr.mr_n53402144)
print v(xbgr.mr_n53402256)
print v(xbgr.mr_n53402576)
print v(xbgr.mr_n53402688)
print v(xbgr.mr_n53403008)
print v(xbgr.mr_n53403120)
print v(xbgr.mr_n53403440)
print v(xbgr.mr_n53403552)
print v(xbgr.mr_n53403872)
print v(xbgr.mr_n53403984)
print v(xbgr.mr_n53404304)
print v(xbgr.mr_n53404416)
print v(xbgr.mr_n53404736)
print v(xbgr.mr_n53404848)
print v(xbgr.mr_n53405168)
print v(xbgr.mr_n53405280)
print v(xbgr.mr_n53405600)
print v(xbgr.mr_n53405712)
print v(xbgr.mr_n53406032)
print v(xbgr.mr_n53406144)
print v(xbgr.mr_n53406464)
print v(xbgr.mr_n53406576)
print v(xbgr.mr_n53406896)
print v(xbgr.mr_n53407008)
print v(xbgr.mr_n53407328)
print v(xbgr.mr_n53407440)
print v(xbgr.mr_n53407760)
print v(xbgr.mr_n53407872)
print v(xbgr.mr_n53408192)
print v(xbgr.mr_n53408304)
print v(xbgr.mr_n53408624)
print v(xbgr.mr_n53408736)
print v(xbgr.mr_n53409056)
print v(xbgr.mr_n53409168)
print v(xbgr.mr_n53409488)
print v(xbgr.mr_n53409600)
print v(xbgr.mr_n53409920)
print v(xbgr.mr_n53410032)
print v(xbgr.mr_n53410352)
print v(xbgr.mr_n53410464)
print v(xbgr.mr_n53410784)
print v(xbgr.mr_n53410896)
print v(xbgr.mr_n53411216)
print v(xbgr.mr_n53411328)
print v(xbgr.mr_n53411648)
print v(xbgr.mr_n53411760)
print v(xbgr.mr_n53412080)
print v(xbgr.mr_n53412192)
print v(xbgr.mr_n53412512)
print v(xbgr.mr_n53412624)
print v(xbgr.mr_n53412944)
print v(xbgr.mr_n53413056)
print v(xbgr.mr_n53413376)
print v(xbgr.mr_n53413488)
print v(xbgr.mr_n53413808)
print v(xbgr.mr_n53413920)
print v(xbgr.mr_n53414240)
print v(xbgr.mr_n53414352)
print v(xbgr.mr_n53414672)
print v(xbgr.mr_n53414784)
print v(xbgr.mr_n53415104)
print v(xbgr.mr_n53415216)
print v(xbgr.mr_n53415536)
print v(xbgr.mr_n53415648)
print v(xbgr.mr_n53415968)
print v(xbgr.mr_n53416080)
print v(xbgr.mr_n53416400)
print v(xbgr.mr_n53416512)
print v(xbgr.mr_n53416832)
print v(xbgr.mr_n53416944)
print v(xbgr.mr_n53417264)
print v(xbgr.mr_n53417376)
print v(xbgr.mr_n53417696)
print v(xbgr.mr_n53417808)
print v(xbgr.mr_n53418128)
print v(xbgr.mr_n53418240)
print v(xbgr.mr_n53418560)
print v(xbgr.mr_n53418672)
print v(xbgr.mr_n53418992)
print v(xbgr.mr_n53419104)
print v(xbgr.mr_n53419424)
print v(xbgr.mr_n53419536)
print v(xbgr.mr_n53419856)
print v(xbgr.mr_n53419968)
print v(xbgr.mr_n53420288)
print v(xbgr.mr_n53420400)
print v(xbgr.mr_n53420720)
print v(xbgr.mr_n53420832)
print v(xbgr.mr_n53421152)
print v(xbgr.mr_n53421264)
print v(xbgr.mr_n53421584)
print v(xbgr.mr_n53421696)
print v(xbgr.mr_n53422016)
print v(xbgr.mr_n53422128)
print v(xbgr.mr_n53422448)
print v(xbgr.mr_n53422560)
print v(xbgr.mr_n53422880)
print v(xbgr.mr_n53422992)
print v(xbgr.mr_n53423312)
print v(xbgr.mr_n53423424)
print v(xbgr.mr_n53423744)
print v(xbgr.mr_n53423856)
print v(xbgr.mr_n53424176)
print v(xbgr.mr_n53424288)
print v(xbgr.mr_n53424608)
print v(xbgr.mr_n53424720)
print v(xbgr.mr_n53425040)
print v(xbgr.mr_n53425152)
print v(xbgr.mr_n53425472)
print v(xbgr.mr_n53425584)
print v(xbgr.mr_n53425904)
print v(xbgr.mr_n53426016)
print v(xbgr.mr_n53426336)
print v(xbgr.mr_n53426448)
print v(xbgr.mr_n53426768)
print v(xbgr.mr_n53426880)
print v(xbgr.mr_n53427200)
print v(xbgr.mr_n53427312)
print v(xbgr.mr_n53427632)
print v(xbgr.mr_n53427744)
print v(xbgr.mr_n53428064)
print v(xbgr.mr_n53428176)
print v(xbgr.mr_n53428496)
print v(xbgr.mr_n53428608)
print v(xbgr.mr_n53428928)
print v(xbgr.mr_n53429040)
print v(xbgr.mr_n53429360)
print v(xbgr.mr_n53429472)
print v(xbgr.mr_n53429792)
print v(xbgr.mr_n53429904)
print v(xbgr.mr_n53430224)
print v(xbgr.mr_n53430336)
print v(xbgr.mr_n53430656)
print v(xbgr.mr_n53430768)
print v(xbgr.mr_n53431088)
print v(xbgr.mr_n53431200)
print v(xbgr.mr_n53431520)
print v(xbgr.mr_n53431632)
print v(xbgr.mr_n53431952)
print v(xbgr.mr_n53432064)
print v(xbgr.mr_n53432384)
print v(xbgr.mr_n53432496)
print v(xbgr.mr_n53432816)
print v(xbgr.mr_n53432928)
print v(xbgr.mr_n53433248)
print v(xbgr.mr_n53433360)
print v(xbgr.mr_n53433680)
print v(xbgr.mr_n53433792)
print v(xbgr.mr_n53434112)
print v(xbgr.mr_n53434224)
print v(xbgr.mr_n53434544)
print v(xbgr.mr_n53434656)
print v(xbgr.mr_n53434976)
print v(xbgr.mr_n53435088)
print v(xbgr.mr_n53435408)
print v(xbgr.mr_n53435520)
print v(xbgr.mr_n53435840)
print v(xbgr.mr_n53435952)
print v(xbgr.mr_n53436272)
print v(xbgr.mr_n53436384)
print v(xbgr.mr_n53436704)
print v(xbgr.mr_n53436816)
print v(xbgr.mr_n53437136)
print v(xbgr.mr_n53437248)
print v(xbgr.mr_n53437568)
print v(xbgr.mr_n53437680)
print v(xbgr.mr_n53438000)
print v(xbgr.mr_n53438112)
print v(xbgr.mr_n53438432)
print v(xbgr.mr_n53438544)
print v(xbgr.mr_n53438864)
print v(xbgr.mr_n53438976)
print v(xbgr.mr_n53439296)
print v(xbgr.mr_n53439408)
print v(xbgr.mr_n53439728)
print v(xbgr.mr_n53439840)
print v(xbgr.mr_n53440160)
print v(xbgr.mr_n53440272)
print v(xbgr.mr_n53440592)
print v(xbgr.mr_n53440704)
print v(xbgr.mr_n53441024)
print v(xbgr.mr_n53441136)
print v(xbgr.mr_n53441456)
print v(xbgr.mr_n53441568)
print v(xbgr.mr_n53441888)
print v(xbgr.mr_n53442000)
print v(xbgr.mr_n53442320)
print v(xbgr.mr_n53442432)
print v(xbgr.mr_n53442752)
print v(xbgr.mr_n53442864)
print v(xbgr.mr_n53443184)
print v(xbgr.mr_n53443296)
print v(xbgr.mr_n53443616)
print v(xbgr.mr_n53443728)
print v(xbgr.mr_n53444048)
print v(xbgr.mr_n53444160)
print v(xbgr.mr_n53444480)
print v(xbgr.mr_n53444592)
print v(xbgr.mr_n53444912)
print v(xbgr.mr_n53445024)
print v(xbgr.mr_n53445344)
print v(xbgr.mr_n53445456)
print v(xbgr.mr_n53445776)
print v(xbgr.mr_n53445888)
print v(xbgr.mr_n53446208)
print v(xbgr.mr_n53446320)
print v(xbgr.mr_n53446640)
print v(xbgr.mr_n53446752)
print v(xbgr.mr_n53447072)
print v(xbgr.mr_n53447184)
print v(xbgr.mr_n53447504)
print v(xbgr.mr_n53447616)
print v(xbgr.mr_n53447936)
print v(xbgr.mr_n53448048)
print v(xbgr.mr_n53448368)
print v(xbgr.mr_n53448480)
print v(xbgr.mr_n53448800)
print v(xbgr.mr_n53448912)
print v(xbgr.mr_n53449232)
print v(xbgr.mr_n53449344)
print v(xbgr.mr_n53449664)
print v(xbgr.mr_n53449776)
print v(xbgr.mr_n53450096)
print v(xbgr.mr_n53450208)
print v(xbgr.mr_n53450528)
print v(xbgr.mr_n53450640)
print v(xbgr.mr_n53450960)
print v(xbgr.mr_n53451072)
print v(xbgr.mr_n53451392)
print v(xbgr.mr_n53451504)
print v(xbgr.mr_n53451824)
print v(xbgr.mr_n53451936)
print v(xbgr.mr_n53452256)
print v(xbgr.mr_n53452368)
print v(xbgr.mr_n53452688)
print v(xbgr.mr_n53452800)
print v(xbgr.mr_n53453120)
print v(xbgr.mr_n53453232)
print v(xbgr.mr_n53453552)
print v(xbgr.mr_n53453664)
print v(xbgr.mr_n53453984)
print v(xbgr.mr_n53454096)
print v(xbgr.mr_n53454416)
print v(xbgr.mr_n53454528)
print v(xbgr.mr_n53454848)
print v(xbgr.mr_n53454960)
print v(xbgr.mr_n53455280)
print v(xbgr.mr_n53455392)
print v(xbgr.mr_n53455712)
print v(xbgr.mr_n53455824)
print v(xbgr.mr_n53456144)
print v(xbgr.mr_n53456256)
print v(xbgr.mr_n53456576)
print v(xbgr.mr_n53456688)
print v(xbgr.mr_n53457008)
print v(xbgr.mr_n53457120)
print v(xbgr.mr_n53457440)
print v(xbgr.mr_n53457552)
print v(xbgr.mr_n53457872)
print v(xbgr.mr_n53457984)
print v(xbgr.mr_n53458304)
print v(xbgr.mr_n53458416)
print v(xbgr.mr_n53458736)
print v(xbgr.mr_n53458848)
print v(xbgr.mr_n53459168)
print v(xbgr.mr_n53459280)
print v(xbgr.mr_n53459600)
print v(xbgr.mr_n53459712)
print v(xbgr.mr_n53460032)
print v(xbgr.mr_n53460144)
print v(xbgr.mr_n53460464)
print v(xbgr.mr_n53460576)
print v(xbgr.mr_n53460896)
print v(xbgr.mr_n53461008)
print v(xbgr.mr_n53461328)
print v(xbgr.mr_n53461440)
print v(xbgr.mr_n53461760)
print v(xbgr.mr_n53461872)
print v(xbgr.mr_n53462192)
print v(xbgr.mr_n53462304)
print v(xbgr.mr_n53462624)
print v(xbgr.mr_n53462736)
print v(xbgr.mr_n53463056)
print v(xbgr.mr_n53463168)
print v(xbgr.mr_n53463488)
print v(xbgr.mr_n53463600)
print v(xbgr.mr_n53463920)
print v(xbgr.mr_n53464032)
print v(xbgr.mr_n53464352)
print v(xbgr.mr_n53464464)
print v(xbgr.mr_n53464784)
print v(xbgr.mr_n53464896)
print v(xbgr.mr_n53465216)
print v(xbgr.mr_n53465328)
print v(xbgr.mr_n53465648)
print v(xbgr.mr_n53465760)
print v(xbgr.mr_n53466080)
print v(xbgr.mr_n53466192)
print v(xbgr.mr_n53466512)
print v(xbgr.mr_n53466624)
print v(xbgr.mr_n53466944)
print v(xbgr.mr_n53467056)
print v(xbgr.mr_n53467376)
print v(xbgr.mr_n53467488)
print v(xbgr.mr_n53467808)
print v(xbgr.mr_n53467920)
print v(xbgr.mr_n53468240)
print v(xbgr.mr_n53468352)
print v(xbgr.mr_n53468672)
print v(xbgr.mr_n53468784)
print v(xbgr.mr_n53469104)
print v(xbgr.mr_n53469216)
print v(xbgr.mr_n53469536)
print v(xbgr.mr_n53469648)
print v(xbgr.mr_n53469968)
print v(xbgr.mr_n53470080)
print v(xbgr.mr_n53470400)
print v(xbgr.mr_n53470512)
print v(xbgr.mr_n53470832)
print v(xbgr.mr_n53470944)
print v(xbgr.mr_n53471264)
print v(xbgr.mr_n53471376)
print v(xbgr.mr_n53471696)
print v(xbgr.mr_n53471808)
print v(xbgr.mr_n53472128)
print v(xbgr.mr_n53472240)
print v(xbgr.mr_n53472560)
print v(xbgr.mr_n53472672)
print v(xbgr.mr_n53472992)
print v(xbgr.mr_n53473104)
print v(xbgr.mr_n53473424)
print v(xbgr.mr_n53473536)
print v(xbgr.mr_n53473856)
print v(xbgr.mr_n53473968)
print v(xbgr.mr_n53474288)
print v(xbgr.mr_n53474400)
print v(xbgr.mr_n53474720)
print v(xbgr.mr_n53474832)
print v(xbgr.mr_n53475152)
print v(xbgr.mr_n53475264)
print v(xbgr.mr_n53475584)
print v(xbgr.mr_n53475696)
print v(xbgr.mr_n53476016)
print v(xbgr.mr_n53476128)
print v(xbgr.mr_n53476448)
print v(xbgr.mr_n53476560)
print v(xbgr.mr_n53476880)
print v(xbgr.mr_n53476992)
print v(xbgr.mr_n53477312)
print v(xbgr.mr_n53477424)
print v(xbgr.mr_n53477744)
print v(xbgr.mr_n53477856)
print v(xbgr.mr_n53478176)
print v(xbgr.mr_n53478288)
print v(xbgr.mr_n53478608)
print v(xbgr.mr_n53478720)
print v(xbgr.mr_n53479040)
print v(xbgr.mr_n53479152)
print v(xbgr.mr_n53479472)
print v(xbgr.mr_n53479584)
print v(xbgr.mr_n53479904)
print v(xbgr.mr_n53480016)
print v(xbgr.mr_n53480336)
print v(xbgr.mr_n53480448)
print v(xbgr.mr_n53480768)
print v(xbgr.mr_n53480880)
print v(xbgr.mr_n53481200)
print v(xbgr.mr_n53481312)
print v(xbgr.mr_n53481632)
print v(xbgr.mr_n53481744)
print v(xbgr.mr_n53482064)
print v(xbgr.mr_n53482176)
print v(xbgr.mr_n53482496)
print v(xbgr.mr_n53482608)
print v(xbgr.mr_n53482928)
print v(xbgr.mr_n53483040)
print v(xbgr.mr_n53483360)
print v(xbgr.mr_n53483472)
print v(xbgr.mr_n53483792)
print v(xbgr.mr_n53483904)
print v(xbgr.mr_n53484224)
print v(xbgr.mr_n53484336)
print v(xbgr.mr_n53484656)
print v(xbgr.mr_n53484768)
print v(xbgr.mr_n53485088)
print v(xbgr.mr_n53485200)
print v(xbgr.mr_n53485520)
print v(xbgr.mr_n53485632)
print v(xbgr.mr_n53485952)
print v(xbgr.mr_n53486064)
print v(xbgr.mr_n53486384)
print v(xbgr.mr_n53486496)
print v(xbgr.mr_n53486816)
print v(xbgr.mr_n53486928)
print v(xbgr.mr_n53487248)
print v(xbgr.mr_n53487360)
print v(xbgr.mr_n53487680)
print v(xbgr.mr_n53487792)
print v(xbgr.mr_n53488112)
print v(xbgr.mr_n53488224)
print v(xbgr.mr_n53488544)
print v(xbgr.mr_n53488656)
print v(xbgr.mr_n53488976)
print v(xbgr.mr_n53489088)
print v(xbgr.mr_n53489408)
print v(xbgr.mr_n53489520)
print v(xbgr.mr_n53489840)
print v(xbgr.mr_n53489952)
print v(xbgr.mr_n53490272)
print v(xbgr.mr_n53490384)
print v(xbgr.mr_n53490704)
print v(xbgr.mr_n53490816)
print v(xbgr.mr_n53491136)
print v(xbgr.mr_n53491248)
print v(xbgr.mr_n53491568)
print v(xbgr.mr_n53491680)
print v(xbgr.mr_n53492000)
print v(xbgr.mr_n53492112)
print v(xbgr.mr_n53492432)
print v(xbgr.mr_n53492544)
print v(xbgr.mr_n53492864)
print v(xbgr.mr_n53492976)
print v(xbgr.mr_n53493296)
print v(xbgr.mr_n53493408)
print v(xbgr.mr_n53493728)
print v(xbgr.mr_n53493840)
print v(xbgr.mr_n53494272)
print v(xbgr.mr_n53494592)
print v(xbgr.mr_n53494704)
print v(xbgr.mr_n53495024)
print v(xbgr.mr_n53495136)
print v(xbgr.mr_n53495456)
print v(xbgr.mr_n53495568)
print v(xbgr.mr_n53495888)
print v(xbgr.mr_n53496000)
print v(xbgr.mr_n53496320)
print v(xbgr.mr_n53497184)
print v(xbgr.mr_n53497296)
print v(xbgr.mr_n53497616)
print v(xbgr.mr_n53497728)
print v(xbgr.mr_n53498048)
print v(xbgr.mr_n53498160)
print v(xbgr.mr_n53498480)
print v(xbgr.mr_n53498592)
print v(xbgr.mr_n53498912)
print v(xbgr.mr_n53499024)
print v(xbgr.mr_n53499344)
print v(xbgr.mr_n53499456)
print v(xbgr.mr_n53499776)
print v(xbgr.mr_n53499888)
print v(xbgr.mr_n53500208)
print v(xbgr.mr_n53500320)
print v(xbgr.mr_n53500640)
print v(xbgr.mr_n53500752)
print v(xbgr.mr_n53501072)
print v(xbgr.mr_n53501184)
print v(xbgr.mr_n53501504)
print v(xbgr.mr_n53501616)
print v(xbgr.mr_n53502048)
print v(xbgr.mr_n53502368)
print v(xbgr.mr_n53502480)
print v(xbgr.mr_n53502800)
print v(xbgr.mr_n53502912)
print v(xbgr.mr_n53503232)
print v(xbgr.mr_n53503344)
print v(xbgr.mr_n53503664)
print v(xbgr.mr_n53503776)
print v(xbgr.mr_n53504096)
print v(xbgr.mr_n53504208)
print v(xbgr.mr_n53504528)
print v(xbgr.mr_n53504640)
print v(xbgr.mr_n53504960)
print v(xbgr.mr_n53505072)
print v(xbgr.mr_n53505392)
print v(xbgr.mr_n53505504)
print v(xbgr.mr_n53505824)
print v(xbgr.mr_n53505936)
print v(xbgr.mr_n53506256)
print v(xbgr.mr_n53506368)
print v(xbgr.mr_n53506688)
print v(xbgr.mr_n53506800)
print v(xbgr.mr_n53507120)
print v(xbgr.mr_n53507232)
print v(xbgr.mr_n53507552)
print v(xbgr.mr_n53507664)
print v(xbgr.mr_n53507984)
print v(xbgr.mr_n53508096)
print v(xbgr.mr_n53508416)
print v(xbgr.mr_n53508528)
print v(xbgr.mr_n53508848)
print v(xbgr.mr_n53508960)
print v(xbgr.mr_n53509280)
print v(xbgr.mr_n53509392)
print v(xbgr.mr_n53509712)
print v(xbgr.mr_n53509824)
print v(xbgr.mr_n53510144)
print v(xbgr.mr_n53510256)
print v(xbgr.mr_n53510576)
print v(xbgr.mr_n53510688)
print v(xbgr.mr_n53511008)
print v(xbgr.mr_n53511120)
print v(xbgr.mr_n53511440)
print v(xbgr.mr_n53511552)
print v(xbgr.mr_n53511872)
print v(xbgr.mr_n53511984)
print v(xbgr.mr_n53512304)
print v(xbgr.mr_n53512416)
print v(xbgr.mr_n53512736)
print v(xbgr.mr_n53512848)
print v(xbgr.mr_n53513168)
print v(xbgr.mr_n53513280)
print v(xbgr.mr_n53513600)
print v(xbgr.mr_n53513712)
print v(xbgr.mr_n53514032)
print v(xbgr.mr_n53514144)
print v(xbgr.mr_n53514464)
print v(xbgr.mr_n53514576)
print v(xbgr.mr_n53514896)
print v(xbgr.mr_n53515008)
print v(xbgr.mr_n53515328)
print v(xbgr.mr_n53515440)
print v(xbgr.mr_n53515760)
print v(xbgr.mr_n53515872)
print v(xbgr.mr_n53516192)
print v(xbgr.mr_n53516304)
print v(xbgr.mr_n53516624)
print v(xbgr.mr_n53516736)
print v(xbgr.mr_n53517056)
print v(xbgr.mr_n53517168)
print v(xbgr.mr_n53517488)
print v(xbgr.mr_n53517600)
print v(xbgr.mr_n53517920)
print v(xbgr.mr_n53518032)
print v(xbgr.mr_n53518352)
print v(xbgr.mr_n53518464)
print v(xbgr.mr_n53518784)
print v(xbgr.mr_n53519648)
print v(xbgr.mr_n53519760)
print v(xbgr.mr_n53520080)
print v(xbgr.mr_n53520192)
print v(xbgr.mr_n53520512)
print v(xbgr.mr_n53520624)
print v(xbgr.mr_n53520944)
print v(xbgr.mr_n53521056)
print v(xbgr.mr_n53521376)
print v(xbgr.mr_n53521488)
print v(xbgr.mr_n53521808)
print v(xbgr.mr_n53521920)
print v(xbgr.mr_n53522240)
print v(xbgr.mr_n53522352)
print v(xbgr.mr_n53522672)
print v(xbgr.mr_n53522784)
print v(xbgr.mr_n53523104)
print v(xbgr.mr_n53523216)
print v(xbgr.mr_n53523536)
print v(xbgr.mr_n53523648)
print v(xbgr.mr_n53523968)
print v(xbgr.mr_n53524080)
print v(xbgr.mr_n53524400)
print v(xbgr.mr_n53524512)
print v(xbgr.mr_n53524832)
print v(xbgr.mr_n53524944)
print v(xbgr.mr_n53525264)
print v(xbgr.mr_n53525376)
print v(xbgr.mr_n53525696)
print v(xbgr.mr_n53525808)
print v(xbgr.mr_n53526128)
print v(xbgr.mr_n53526240)
print v(xbgr.mr_n53526560)
print v(xbgr.mr_n53526672)
print v(xbgr.mr_n53526992)
print v(xbgr.mr_n53527104)
print v(xbgr.mr_n53527424)
print v(xbgr.mr_n53527536)
print v(xbgr.mr_n53527856)
print v(xbgr.mr_n53527968)
print v(xbgr.mr_n53528288)
print v(xbgr.mr_n53528400)
print v(xbgr.mr_n53528720)
print v(xbgr.mr_n53528832)
print v(xbgr.mr_n53529152)
print v(xbgr.mr_n53529264)
print v(xbgr.mr_n53529584)
print v(xbgr.mr_n53529696)
print v(xbgr.mr_n53530016)
print v(xbgr.mr_n53530128)
print v(xbgr.mr_n53530448)
print v(xbgr.mr_n53530560)
print v(xbgr.mr_n53530880)
print v(xbgr.mr_n53530992)
print v(xbgr.mr_n53531312)
print v(xbgr.mr_n53531424)
print v(xbgr.mr_n53531744)
print v(xbgr.mr_n53531856)
print v(xbgr.mr_n53532176)
print v(xbgr.mr_n53532288)
print v(xbgr.mr_n53532608)
print v(xbgr.mr_n53532720)
print v(xbgr.mr_n53533040)
print v(xbgr.mr_n53533152)
print v(xbgr.mr_n53533472)
print v(xbgr.mr_n53533584)
print v(xbgr.mr_n53533904)
print v(xbgr.mr_n53534016)
print v(xbgr.mr_n53534336)
print v(xbgr.mr_n53534448)
print v(xbgr.mr_n53534768)
print v(xbgr.mr_n53534880)
print v(xbgr.mr_n53535200)
print v(xbgr.mr_n53535312)
print v(xbgr.mr_n53535632)
print v(xbgr.mr_n53535744)
print v(xbgr.mr_n53536064)
print v(xbgr.mr_n53536176)
print v(xbgr.mr_n53536496)
print v(xbgr.mr_n53536608)
print v(xbgr.mr_n53536928)
print v(xbgr.mr_n53537040)
print v(xbgr.mr_n53537360)
print v(xbgr.mr_n53537472)
print v(xbgr.mr_n53537792)
print v(xbgr.mr_n53537904)
print v(xbgr.mr_n53538224)
print v(xbgr.mr_n53538336)
print v(xbgr.mr_n53538656)
print v(xbgr.mr_n53538768)
print v(xbgr.mr_n53539088)
print v(xbgr.mr_n53539200)
print v(xbgr.mr_n53539520)
print v(xbgr.mr_n53539632)
print v(xbgr.mr_n53539952)
print v(xbgr.mr_n53540064)
print v(xbgr.mr_n53540384)
print v(xbgr.mr_n53540496)
print v(xbgr.mr_n53540816)
print v(xbgr.mr_n53540928)
print v(xbgr.mr_n53541248)
print v(xbgr.mr_n53541360)
print v(xbgr.mr_n53541680)
print v(xbgr.mr_n53541792)
print v(xbgr.mr_n53542112)
print v(xbgr.mr_n53542224)
print v(xbgr.mr_n53542544)
print v(xbgr.mr_n53542656)
print v(xbgr.mr_n53542976)
print v(xbgr.mr_n53543088)
print v(xbgr.mr_n53543408)
print v(xbgr.mr_n53543520)
print v(xbgr.mr_n53543840)
print v(xbgr.mr_n53543952)
print v(xbgr.mr_n53544272)
print v(xbgr.mr_n53544384)
print v(xbgr.mr_n53544704)
print v(xbgr.mr_n53544816)
print v(xbgr.mr_n53545136)
print v(xbgr.mr_n53545248)
print v(xbgr.mr_n53545568)
print v(xbgr.mr_n53545680)
print v(xbgr.mr_n53546000)
print v(xbgr.mr_n53546112)
print v(xbgr.mr_n53546432)
print v(xbgr.mr_n53546544)
print v(xbgr.mr_n53546864)
print v(xbgr.mr_n53546976)
print v(xbgr.mr_n53547296)
print v(xbgr.mr_n53547408)
print v(xbgr.mr_n53547728)
print v(xbgr.mr_n53547840)
print v(xbgr.mr_n53548160)
print v(xbgr.mr_n53548272)
print v(xbgr.mr_n53548592)
print v(xbgr.mr_n53548704)
print v(xbgr.mr_n53549024)
print v(xbgr.mr_n53549136)
print v(xbgr.mr_n53549456)
print v(xbgr.mr_n53549568)
print v(xbgr.mr_n53549888)
print v(xbgr.mr_n53550000)
print v(xbgr.mr_n53550320)
print v(xbgr.mr_n53550432)
print v(xbgr.mr_n53550752)
print v(xbgr.mr_n53550864)
print v(xbgr.mr_n53551184)
print v(xbgr.mr_n53551296)
print v(xbgr.mr_n53551616)
print v(xbgr.mr_n53551728)
print v(xbgr.mr_n53552048)
print v(xbgr.mr_n53552160)
print v(xbgr.mr_n53552480)
print v(xbgr.mr_n53552592)
print v(xbgr.mr_n53552912)
print v(xbgr.mr_n53553024)
print v(xbgr.mr_n53553344)
print v(xbgr.mr_n53553456)
print v(xbgr.mr_n53553776)
print v(xbgr.mr_n53553888)
print v(xbgr.mr_n53554208)
print v(xbgr.mr_n53554320)
print v(xbgr.mr_n53554640)
print v(xbgr.mr_n53554752)
print v(xbgr.mr_n53555072)
print v(xbgr.mr_n53555184)
print v(xbgr.mr_n53555504)
print v(xbgr.mr_n53555616)
print v(xbgr.mr_n53555936)
print v(xbgr.mr_n53556048)
print v(xbgr.mr_n53556368)
print v(xbgr.mr_n53556480)
print v(xbgr.mr_n53556800)
print v(xbgr.mr_n53556912)
print v(xbgr.mr_n53557232)
print v(xbgr.mr_n53557344)
print v(xbgr.mr_n53557664)
print v(xbgr.mr_n53557776)
print v(xbgr.mr_n53558096)
print v(xbgr.mr_n53558208)
print v(xbgr.mr_n53558528)
print v(xbgr.mr_n53558640)
print v(xbgr.mr_n53558960)
print v(xbgr.mr_n53559072)
print v(xbgr.mr_n53559392)
print v(xbgr.mr_n53559504)
print v(xbgr.mr_n53559824)
print v(xbgr.mr_n53559936)
print v(xbgr.mr_n53560256)
print v(xbgr.mr_n53560368)
print v(xbgr.mr_n53560688)
print v(xbgr.mr_n53560800)
print v(xbgr.mr_n53561120)
print v(xbgr.mr_n53561232)
print v(xbgr.mr_n53561552)
print v(xbgr.mr_n53561664)
print v(xbgr.mr_n53561984)
print v(xbgr.mr_n53562096)
print v(xbgr.mr_n53562416)
print v(xbgr.mr_n53562528)
print v(xbgr.mr_n53562848)
print v(xbgr.mr_n53562960)
print v(xbgr.mr_n53563280)
print v(xbgr.mr_n53563392)
print v(xbgr.mr_n53563712)
print v(xbgr.mr_n53563824)
print v(xbgr.mr_n53564144)
print v(xbgr.mr_n53564256)
print v(xbgr.mr_n53564576)
print v(xbgr.mr_n53564688)
print v(xbgr.mr_n53565008)
print v(xbgr.mr_n53565120)
print v(xbgr.mr_n53565440)
print v(xbgr.mr_n53565552)
print v(xbgr.mr_n53565872)
print v(xbgr.mr_n53565984)
print v(xbgr.mr_n53566304)
print v(xbgr.mr_n53566416)
print v(xbgr.mr_n53566736)
print v(xbgr.mr_n53566848)
print v(xbgr.mr_n53567168)
print v(xbgr.mr_n53567280)
print v(xbgr.mr_n53567600)
print v(xbgr.mr_n53567712)
print v(xbgr.mr_n53568032)
print v(xbgr.mr_n53568144)
print v(xbgr.mr_n53568464)
print v(xbgr.mr_n53568576)
print v(xbgr.mr_n53568896)
print v(xbgr.mr_n53569008)
print v(xbgr.mr_n53569328)
print v(xbgr.mr_n53569440)
print v(xbgr.mr_n53569760)
print v(xbgr.mr_n53569872)
print v(xbgr.mr_n53570192)
print v(xbgr.mr_n53570304)
print v(xbgr.mr_n53570624)
print v(xbgr.mr_n53570736)
print v(xbgr.mr_n53571056)
print v(xbgr.mr_n53571168)
print v(xbgr.mr_n53571488)
print v(xbgr.mr_n53571600)
print v(xbgr.mr_n53571920)
print v(xbgr.mr_n53572032)
print v(xbgr.mr_n53572352)
print v(xbgr.mr_n53572464)
print v(xbgr.mr_n53572784)
print v(xbgr.mr_n53572896)
print v(xbgr.mr_n53573216)
print v(xbgr.mr_n53573328)
print v(xbgr.mr_n53573648)
print v(xbgr.mr_n53573760)
print v(xbgr.mr_n53574080)
print v(xbgr.mr_n53574192)
print v(xbgr.mr_n53574512)
print v(xbgr.mr_n53574624)
print v(xbgr.mr_n53574944)
print v(xbgr.mr_n53575056)
print v(xbgr.mr_n53575376)
print v(xbgr.mr_n53575488)
print v(xbgr.mr_n53575808)
print v(xbgr.mr_n53575920)
print v(xbgr.mr_n53576240)
print v(xbgr.mr_n53576352)
print v(xbgr.mr_n53576672)
print v(xbgr.mr_n53576784)
print v(xbgr.mr_n53577104)
print v(xbgr.mr_n53577216)
print v(xbgr.mr_n53577536)
print v(xbgr.mr_n53577648)
print v(xbgr.mr_n53577968)
print v(xbgr.mr_n53578080)
print v(xbgr.mr_n53578400)
print v(xbgr.mr_n53578512)
print v(xbgr.mr_n53578832)
print v(xbgr.mr_n53578944)
print v(xbgr.mr_n53579264)
print v(xbgr.mr_n53579376)
print v(xbgr.mr_n53579696)
print v(xbgr.mr_n53579808)
print v(xbgr.mr_n53580128)
print v(xbgr.mr_n53580240)
print v(xbgr.mr_n53580560)
print v(xbgr.mr_n53580672)
print v(xbgr.mr_n53580992)
print v(xbgr.mr_n53581104)
print v(xbgr.mr_n53581424)
print v(xbgr.mr_n53581536)
print v(xbgr.mr_n53581856)
print v(xbgr.mr_n53581968)
print v(xbgr.mr_n53582288)
print v(xbgr.mr_n53582400)
print v(xbgr.mr_n53582720)
print v(xbgr.mr_n53582832)
print v(xbgr.mr_n53583152)
print v(xbgr.mr_n53583264)
print v(xbgr.mr_n53583584)
print v(xbgr.mr_n53583696)
print v(xbgr.mr_n53584016)
print v(xbgr.mr_n53584128)
print v(xbgr.mr_n53584448)
print v(xbgr.mr_n53584560)
print v(xbgr.mr_n53584880)
print v(xbgr.mr_n53584992)
print v(xbgr.mr_n53585312)
print v(xbgr.mr_n53585424)
print v(xbgr.mr_n53585744)
print v(xbgr.mr_n53585856)
print v(xbgr.mr_n53586176)
print v(xbgr.mr_n53586288)
print v(xbgr.mr_n53586608)
print v(xbgr.mr_n53586720)
print v(xbgr.mr_n53587040)
print v(xbgr.mr_n53587152)
print v(xbgr.mr_n53587472)
print v(xbgr.mr_n53587584)
print v(xbgr.mr_n53587904)
print v(xbgr.mr_n53588016)
print v(xbgr.mr_n53588336)
print v(xbgr.mr_n53588448)
print v(xbgr.mr_n53588768)
print v(xbgr.mr_n53588880)
print v(xbgr.mr_n53589200)
print v(xbgr.mr_n53589312)
print v(xbgr.mr_n53589632)
print v(xbgr.mr_n53589744)
print v(xbgr.mr_n53590064)
print v(xbgr.mr_n53590176)
print v(xbgr.mr_n53590496)
print v(xbgr.mr_n53590608)
print v(xbgr.mr_n53590928)
print v(xbgr.mr_n53591040)
print v(xbgr.mr_n53591360)
print v(xbgr.mr_n53591472)
print v(xbgr.mr_n53591792)
print v(xbgr.mr_n53591904)
print v(xbgr.mr_n53592224)
print v(xbgr.mr_n53592336)
print v(xbgr.mr_n53592656)
print v(xbgr.mr_n53592768)
print v(xbgr.mr_n53593088)
print v(xbgr.mr_n53593200)
print v(xbgr.mr_n53593520)
print v(xbgr.mr_n53593632)
print v(xbgr.mr_n53593952)
print v(xbgr.mr_n53594064)
print v(xbgr.mr_n53594384)
print v(xbgr.mr_n53594496)
print v(xbgr.mr_n53594816)
print v(xbgr.mr_n53594928)
print v(xbgr.mr_n53595248)
print v(xbgr.mr_n53595360)
print v(xbgr.mr_n53595680)
print v(xbgr.mr_n53595792)
print v(xbgr.mr_n53596112)
print v(xbgr.mr_n53596224)
print v(xbgr.mr_n53596544)
print v(xbgr.mr_n53596656)
print v(xbgr.mr_n53596976)
print v(xbgr.mr_n53597088)
print v(xbgr.mr_n53597408)
print v(xbgr.mr_n53597520)
print v(xbgr.mr_n53597840)
print v(xbgr.mr_n53597952)
print v(xbgr.mr_n53598272)
print v(xbgr.mr_n53598384)
print v(xbgr.mr_n53598704)
print v(xbgr.mr_n53598816)
print v(xbgr.mr_n53599136)
print v(xbgr.mr_n53599248)
print v(xbgr.mr_n53599568)
print v(xbgr.mr_n53599680)
print v(xbgr.mr_n53600000)
print v(xbgr.mr_n53600112)
print v(xbgr.mr_n53600432)
print v(xbgr.mr_n53600544)
print v(xbgr.mr_n53600864)
print v(xbgr.mr_n53600976)
print v(xbgr.mr_n53601296)
print v(xbgr.mr_n53601408)
print v(xbgr.mr_n53601728)
print v(xbgr.mr_n53601840)
print v(xbgr.mr_n53602160)
print v(xbgr.mr_n53602272)
print v(xbgr.mr_n53602592)
print v(xbgr.mr_n53602704)
print v(xbgr.mr_n53603024)
print v(xbgr.mr_n53603136)
print v(xbgr.mr_n53603456)
print v(xbgr.mr_n53603568)
print v(xbgr.mr_n53603888)
print v(xbgr.mr_n53604000)
print v(xbgr.mr_n53604320)
print v(xbgr.mr_n53604432)
print v(xbgr.mr_n53604752)
print v(xbgr.mr_n53604864)
print v(xbgr.mr_n53605184)
print v(xbgr.mr_n53605296)
print v(xbgr.mr_n53605616)
print v(xbgr.mr_n53605728)
print v(xbgr.mr_n53606048)
print v(xbgr.mr_n53606160)
print v(xbgr.mr_n53606480)
print v(xbgr.mr_n53606592)
print v(xbgr.mr_n53606912)
print v(xbgr.mr_n53607024)
print v(xbgr.mr_n53607344)
print v(xbgr.mr_n53607456)
print v(xbgr.mr_n53607776)
print v(xbgr.mr_n53607888)
print v(xbgr.mr_n53608208)
print v(xbgr.mr_n53608320)
print v(xbgr.mr_n53608640)
print v(xbgr.mr_n53608752)
print v(xbgr.mr_n53609072)
print v(xbgr.mr_n53609184)
print v(xbgr.mr_n53609504)
print v(xbgr.mr_n53609616)
print v(xbgr.mr_n53609936)
print v(xbgr.mr_n53610048)
print v(xbgr.mr_n53610368)
print v(xbgr.mr_n53610480)
print v(xbgr.mr_n53610800)
print v(xbgr.mr_n53610912)
print v(xbgr.mr_n53611232)
print v(xbgr.mr_n53611344)
print v(xbgr.mr_n53611664)
print v(xbgr.mr_n53611776)
print v(xbgr.mr_n53612096)
print v(xbgr.mr_n53612208)
print v(xbgr.mr_n53612528)
print v(xbgr.mr_n53612640)
print v(xbgr.mr_n53612960)
print v(xbgr.mr_n53613072)
print v(xbgr.mr_n53613392)
print v(xbgr.mr_n53613504)
print v(xbgr.mr_n53613824)
print v(xbgr.mr_n53613936)
print v(xbgr.mr_n53614256)
print v(xbgr.mr_n53614368)
print v(xbgr.mr_n53614688)
print v(xbgr.mr_n53614800)
print v(xbgr.mr_n53615120)
print v(xbgr.mr_n53615232)
print v(xbgr.mr_n53615552)
print v(xbgr.mr_n53615664)
print v(xbgr.mr_n53615984)
print v(xbgr.mr_n53616096)
print v(xbgr.mr_n53616416)
print v(xbgr.mr_n53616528)
print v(xbgr.mr_n53616848)
print v(xbgr.mr_n53616960)
print v(xbgr.mr_n53617280)
print v(xbgr.mr_n53617392)
print v(xbgr.mr_n53617712)
print v(xbgr.mr_n53617824)
print v(xbgr.mr_n53618144)
print v(xbgr.mr_n53618256)
print v(xbgr.mr_n53618576)
print v(xbgr.mr_n53618688)
print v(xbgr.mr_n53619008)
print v(xbgr.mr_n53619120)
print v(xbgr.mr_n53619440)
print v(xbgr.mr_n53619552)
print v(xbgr.mr_n53619872)
print v(xbgr.mr_n53619984)
print v(xbgr.mr_n53620304)
print v(xbgr.mr_n53620416)
print v(xbgr.mr_n53620736)
print v(xbgr.mr_n53620848)
print v(xbgr.mr_n53621168)
print v(xbgr.mr_n53621280)
print v(xbgr.mr_n53621600)
print v(xbgr.mr_n53621712)
print v(xbgr.mr_n53622032)
print v(xbgr.mr_n53622144)
print v(xbgr.mr_n53622464)
print v(xbgr.mr_n53622576)
print v(xbgr.mr_n53622896)
print v(xbgr.mr_n53623008)
print v(xbgr.mr_n53623328)
print v(xbgr.mr_n53623440)
print v(xbgr.mr_n53623760)
print v(xbgr.mr_n53623872)
print v(xbgr.mr_n53624192)
print v(xbgr.mr_n53624304)
print v(xbgr.mr_n53624624)
print v(xbgr.mr_n53624736)
print v(xbgr.mr_n53625056)
print v(xbgr.mr_n53625168)
print v(xbgr.mr_n53625488)
print v(xbgr.mr_n53625600)
print v(xbgr.mr_n53625920)
print v(xbgr.mr_n53626032)
print v(xbgr.mr_n53626352)
print v(xbgr.mr_n53626464)
print v(xbgr.mr_n53626784)
print v(xbgr.mr_n53626896)
print v(xbgr.mr_n53627216)
print v(xbgr.mr_n53627328)
print v(xbgr.mr_n53627648)
print v(xbgr.mr_n53627760)
print v(xbgr.mr_n53628080)
print v(xbgr.mr_n53628192)
print v(xbgr.mr_n53628512)
print v(xbgr.mr_n53628624)
print v(xbgr.mr_n53628944)
print v(xbgr.mr_n53629056)
print v(xbgr.mr_n53629376)
print v(xbgr.mr_n53629488)
print v(xbgr.mr_n53629808)
print v(xbgr.mr_n53629920)
print v(xbgr.mr_n53630240)
print v(xbgr.mr_n53630352)
print v(xbgr.mr_n53630672)
print v(xbgr.mr_n53630784)
print v(xbgr.mr_n53631104)
print v(xbgr.mr_n53631216)
print v(xbgr.mr_n53631536)
print v(xbgr.mr_n53631648)
print v(xbgr.mr_n53631968)
print v(xbgr.mr_n53632080)
print v(xbgr.mr_n53632400)
print v(xbgr.mr_n53632512)
print v(xbgr.mr_n53632832)
print v(xbgr.mr_n53632944)
print v(xbgr.mr_n53633264)
print v(xbgr.mr_n53633376)
print v(xbgr.mr_n53633696)
print v(xbgr.mr_n53633808)
print v(xbgr.mr_n53634128)
print v(xbgr.mr_n53634240)
print v(xbgr.mr_n53634560)
print v(xbgr.mr_n53634672)
print v(xbgr.mr_n53634992)
print v(xbgr.mr_n53635104)
print v(xbgr.mr_n53635424)
print v(xbgr.mr_n53635536)
print v(xbgr.mr_n53635856)
print v(xbgr.mr_n53635968)
print v(xbgr.mr_n53636288)
print v(xbgr.mr_n53636400)
print v(xbgr.mr_n53636720)
print v(xbgr.mr_n53636832)
print v(xbgr.mr_n53637152)
print v(xbgr.mr_n53637264)
print v(xbgr.mr_n53637584)
print v(xbgr.mr_n53637696)
print v(xbgr.mr_n53638016)
print v(xbgr.mr_n53638128)
print v(xbgr.mr_n53638448)
print v(xbgr.mr_n53638560)
print v(xbgr.mr_n53638880)
print v(xbgr.mr_n53638992)
print v(xbgr.mr_n53639312)
print v(xbgr.mr_n53639424)
print v(xbgr.mr_n53639744)
print v(xbgr.mr_n53639856)
print v(xbgr.mr_n53640176)
print v(xbgr.mr_n53640288)
print v(xbgr.mr_n53640608)
print v(xbgr.mr_n53640720)
print v(xbgr.mr_n53641040)
print v(xbgr.mr_n53641152)
print v(xbgr.mr_n53641472)
print v(xbgr.mr_n53641584)
print v(xbgr.mr_n53641904)
print v(xbgr.mr_n53642016)
print v(xbgr.mr_n53642336)
print v(xbgr.mr_n53642448)
print v(xbgr.mr_n53642768)
print v(xbgr.mr_n53642880)
print v(xbgr.mr_n53643200)
print v(xbgr.mr_n53643312)
print v(xbgr.mr_n53643632)
print v(xbgr.mr_n53643744)
print v(xbgr.mr_n53644064)
print v(xbgr.mr_n53644176)
print v(xbgr.mr_n53644496)
print v(xbgr.mr_n53644608)
print v(xbgr.mr_n53644928)
print v(xbgr.mr_n53645040)
print v(xbgr.mr_n53645360)
print v(xbgr.mr_n53645472)
print v(xbgr.mr_n53645792)
print v(xbgr.mr_n53645904)
print v(xbgr.mr_n53646336)
print v(xbgr.mr_n53646656)
print v(xbgr.mr_n53646768)
print v(xbgr.mr_n53647088)
print v(xbgr.mr_n53647200)
print v(xbgr.mr_n53647520)
print v(xbgr.mr_n53647632)
print v(xbgr.mr_n53648064)
print v(xbgr.mr_n53648384)
print v(xbgr.mr_n53648496)
print v(xbgr.mr_n53648816)
print v(xbgr.mr_n53648928)
print v(xbgr.mr_n53649248)
print v(xbgr.mr_n53649360)
print v(xbgr.mr_n53649680)
print v(xbgr.mr_n53649792)
print v(xbgr.mr_n53650112)
print v(xbgr.mr_n53650224)
print v(xbgr.mr_n53650544)
print v(xbgr.mr_n53650656)
print v(xbgr.mr_n53650976)
print v(xbgr.mr_n53651088)
print v(xbgr.mr_n53651408)
print v(xbgr.mr_n53651520)
print v(xbgr.mr_n53651840)
print v(xbgr.mr_n53651952)
print v(xbgr.mr_n53652272)
print v(xbgr.mr_n53652384)
print v(xbgr.mr_n53652704)
print v(xbgr.mr_n53652816)
print v(xbgr.mr_n53653136)
print v(xbgr.mr_n53653248)
print v(xbgr.mr_n53653568)
print v(xbgr.mr_n53653680)
print v(xbgr.mr_n53654000)
print v(xbgr.mr_n53654112)
print v(xbgr.mr_n53654432)
print v(xbgr.mr_n53654544)
print v(xbgr.mr_n53654976)
print v(xbgr.mr_n53655296)
print v(xbgr.mr_n53655408)
print v(xbgr.mr_n53655728)
print v(xbgr.mr_n53655840)
print v(xbgr.mr_n53656160)
print v(xbgr.mr_n53656272)
print v(xbgr.mr_n53656592)
print v(xbgr.mr_n53656704)
print v(xbgr.mr_n53657024)
print v(xbgr.mr_n53657136)
print v(xbgr.mr_n53657456)
print v(xbgr.mr_n53657568)
print v(xbgr.mr_n53657888)
print v(xbgr.mr_n53658000)
print v(xbgr.mr_n53658432)
print v(xbgr.mr_n53658752)
print v(xbgr.mr_n53658864)
print v(xbgr.mr_n53659184)
print v(xbgr.mr_n53659296)
print v(xbgr.mr_n53659616)
print v(xbgr.mr_n53659728)
print v(xbgr.mr_n53660048)
print v(xbgr.mr_n53660160)
print v(xbgr.mr_n53660480)
print v(xbgr.mr_n53660592)
print v(xbgr.mr_n53660912)
print v(xbgr.mr_n53661024)
print v(xbgr.mr_n53661344)
print v(xbgr.mr_n53661456)
print v(xbgr.mr_n53661776)
print v(xbgr.mr_n53661888)
print v(xbgr.mr_n53662208)
print v(xbgr.mr_n53662320)
print v(xbgr.mr_n53662640)
print v(xbgr.mr_n53662752)
print v(xbgr.mr_n53663072)
print v(xbgr.mr_n53663184)
print v(xbgr.mr_n53663504)
print v(xbgr.mr_n53663616)
print v(xbgr.mr_n53663936)
print v(xbgr.mr_n53664048)
print v(xbgr.mr_n53664480)
print v(xbgr.mr_n53664800)
print v(xbgr.mr_n53664912)
print v(xbgr.mr_n53665232)
print v(xbgr.mr_n53665344)
print v(xbgr.mr_n53665664)
print v(xbgr.mr_n53665776)
print v(xbgr.mr_n53666208)
print v(xbgr.mr_n53666528)
print v(xbgr.mr_n53666640)
print v(xbgr.mr_n53666960)
print v(xbgr.mr_n53667072)
print v(xbgr.mr_n53667392)
print v(xbgr.mr_n53667504)
print v(xbgr.mr_n53667824)
print v(xbgr.mr_n53667936)
print v(xbgr.mr_n53668256)
print v(xbgr.mr_n53668368)
print v(xbgr.mr_n53668800)
print v(xbgr.mr_n53669120)
print v(xbgr.mr_n53669232)
print v(xbgr.mr_n53669552)
print v(xbgr.mr_n53669664)
print v(xbgr.mr_n53669984)
print v(xbgr.mr_n53670096)
print v(xbgr.mr_n53670416)
print v(xbgr.mr_n53670528)
print v(xbgr.mr_n53670848)
print v(xbgr.mr_n53670960)
print v(xbgr.mr_n53671280)
print v(xbgr.mr_n53671392)
print v(xbgr.mr_n53671712)
print v(xbgr.mr_n53671824)
print v(xbgr.mr_n53672144)
print v(xbgr.mr_n53672256)
print v(xbgr.mr_n53672576)
print v(xbgr.mr_n53672688)
print v(xbgr.mr_n53673008)
print v(xbgr.mr_n53673120)
print v(xbgr.mr_n53673440)
print v(xbgr.mr_n53673552)
print v(xbgr.mr_n53673872)
print v(xbgr.mr_n53673984)
print v(xbgr.mr_n53674304)
print v(xbgr.mr_n53674416)
print v(xbgr.mr_n53674848)
print v(xbgr.mr_n53675168)
print v(xbgr.mr_n53675280)
print v(xbgr.mr_n53675600)
print v(xbgr.mr_n53675712)
print v(xbgr.mr_n53676032)
print v(xbgr.mr_n53676144)
print v(xbgr.mr_n53676576)
print v(xbgr.mr_n53676896)
print v(xbgr.mr_n53677008)
print v(xbgr.mr_n53677440)
print v(xbgr.mr_n53677760)
print v(xbgr.mr_n53677872)
print v(xbgr.mr_n53678192)
print v(xbgr.mr_n53678304)
print v(xbgr.mr_n53678624)
print v(xbgr.mr_n53678736)
print v(xbgr.mr_n53679168)
print v(xbgr.mr_n53679488)
print v(xbgr.mr_n53679600)
print v(xbgr.mr_n53679920)
print v(xbgr.mr_n53680032)
print v(xbgr.mr_n53680352)
print v(xbgr.mr_n53680464)
print v(xbgr.mr_n53680784)
print v(xbgr.mr_n53680896)
print v(xbgr.mr_n53681216)
print v(xbgr.mr_n53681328)
print v(xbgr.mr_n53681648)
print v(xbgr.mr_n53681760)
print v(xbgr.mr_n53682080)
print v(xbgr.mr_n53682192)
print v(xbgr.mr_n53682512)
print v(xbgr.mr_n53682624)
print v(xbgr.mr_n53682944)
print v(xbgr.mr_n53683056)
print v(xbgr.mr_n53683488)
print v(xbgr.mr_n53683808)
print v(xbgr.mr_n53683920)
print v(xbgr.mr_n53684240)
print v(xbgr.mr_n53684352)
print v(xbgr.mr_n53684672)
print v(xbgr.mr_n53684784)
print v(xbgr.mr_n53685104)
print v(xbgr.mr_n53685216)
print v(xbgr.mr_n53685536)
print v(xbgr.mr_n53685648)
print v(xbgr.mr_n53685968)
print v(xbgr.mr_n53686080)
print v(xbgr.mr_n53686400)
print v(xbgr.mr_n53686512)
print v(xbgr.mr_n53686832)
print v(xbgr.mr_n53686944)
print v(xbgr.mr_n53687264)
print v(xbgr.mr_n53687376)
print v(xbgr.mr_n53687696)
print v(xbgr.mr_n53687808)
print v(xbgr.mr_n53688128)
print v(xbgr.mr_n53688240)
print v(xbgr.mr_n53688560)
print v(xbgr.mr_n53688672)
print v(xbgr.mr_n53688992)
print v(xbgr.mr_n53689104)
print v(xbgr.mr_n53689424)
print v(xbgr.mr_n53689536)
print v(xbgr.mr_n53689856)
print v(xbgr.mr_n53689968)
print v(xbgr.mr_n53690288)
print v(xbgr.mr_n53690400)
print v(xbgr.mr_n53690720)
print v(xbgr.mr_n53690832)
print v(xbgr.mr_n53691152)
print v(xbgr.mr_n53691264)
print v(xbgr.mr_n53691584)
print v(xbgr.mr_n53691696)
print v(xbgr.mr_n53692016)
print v(xbgr.mr_n53692128)
print v(xbgr.mr_n53692448)
print v(xbgr.mr_n53692560)
print v(xbgr.mr_n53692880)
print v(xbgr.mr_n53692992)
print v(xbgr.mr_n53693312)
print v(xbgr.mr_n53693424)
print v(xbgr.mr_n53693744)
print v(xbgr.mr_n53693856)
print v(xbgr.mr_n53694176)
print v(xbgr.mr_n53694288)
print v(xbgr.mr_n53694608)
print v(xbgr.mr_n53694720)
print v(xbgr.mr_n53695040)
print v(xbgr.mr_n53695152)
print v(xbgr.mr_n53695472)
print v(xbgr.mr_n53695584)
print v(xbgr.mr_n53695904)
print v(xbgr.mr_n53696016)
print v(xbgr.mr_n53696336)
print v(xbgr.mr_n53696448)
print v(xbgr.mr_n53696768)
print v(xbgr.mr_n53696880)
print v(xbgr.mr_n53697200)
print v(xbgr.mr_n53697312)
print v(xbgr.mr_n53697632)
print v(xbgr.mr_n53697744)
print v(xbgr.mr_n53698064)
print v(xbgr.mr_n53698176)
print v(xbgr.mr_n53698496)
print v(xbgr.mr_n53698608)
print v(xbgr.mr_n53698928)
print v(xbgr.mr_n53699040)
print v(xbgr.mr_n53699360)
print v(xbgr.mr_n53699472)
print v(xbgr.mr_n53699792)
print v(xbgr.mr_n53699904)
print v(xbgr.mr_n53700224)
print v(xbgr.mr_n53700336)
print v(xbgr.mr_n53700656)
print v(xbgr.mr_n53700768)
print v(xbgr.mr_n53701088)
print v(xbgr.mr_n53701200)
print v(xbgr.mr_n53701520)
print v(xbgr.mr_n53701632)
print v(xbgr.mr_n53701952)
print v(xbgr.mr_n53702064)
print v(xbgr.mr_n53702384)
print v(xbgr.mr_n53702496)
print v(xbgr.mr_n53702816)
print v(xbgr.mr_n53702928)
print v(xbgr.mr_n53703248)
print v(xbgr.mr_n53703360)
print v(xbgr.mr_n53703680)
print v(xbgr.mr_n53703792)
print v(xbgr.mr_n53704112)
print v(xbgr.mr_n53704224)
print v(xbgr.mr_n53704544)
print v(xbgr.mr_n53704656)
print v(xbgr.mr_n53704976)
print v(xbgr.mr_n53705088)
print v(xbgr.mr_n53705408)
print v(xbgr.mr_n53705520)
print v(xbgr.mr_n53705840)
print v(xbgr.mr_n53705952)
print v(xbgr.mr_n53706272)
print v(xbgr.mr_n53706384)
print v(xbgr.mr_n53706704)
print v(xbgr.mr_n53706816)
print v(xbgr.mr_n53707136)
print v(xbgr.mr_n53707248)
print v(xbgr.mr_n53707568)
print v(xbgr.mr_n53707680)
print v(xbgr.mr_n53708000)
print v(xbgr.mr_n53708112)
print v(xbgr.mr_n53708432)
print v(xbgr.mr_n53708544)
print v(xbgr.mr_n53708864)
print v(xbgr.mr_n53708976)
print v(xbgr.mr_n53709296)
print v(xbgr.mr_n53709408)
print v(xbgr.mr_n53709728)
print v(xbgr.mr_n53709840)
print v(xbgr.mr_n53710160)
print v(xbgr.mr_n53710272)
print v(xbgr.mr_n53710592)
print v(xbgr.mr_n53710704)
print v(xbgr.mr_n53711024)
print v(xbgr.mr_n53711136)
print v(xbgr.mr_n53711456)
print v(xbgr.mr_n53711568)
print v(xbgr.mr_n53711888)
print v(xbgr.mr_n53712000)
print v(xbgr.mr_n53712320)
print v(xbgr.mr_n53712432)
print v(xbgr.mr_n53712752)
print v(xbgr.mr_n53712864)
print v(xbgr.mr_n53713184)
print v(xbgr.mr_n53713296)
print v(xbgr.mr_n53713616)
print v(xbgr.mr_n53713728)
print v(xbgr.mr_n53714048)
print v(xbgr.mr_n53714160)
print v(xbgr.mr_n53714480)
print v(xbgr.mr_n53714592)
print v(xbgr.mr_n53714912)
print v(xbgr.mr_n53715024)
print v(xbgr.mr_n53715344)
print v(xbgr.mr_n53715456)
print v(xbgr.mr_n53715776)
print v(xbgr.mr_n53715888)
print v(xbgr.mr_n53716208)
print v(xbgr.mr_n53716320)
print v(xbgr.mr_n53716640)
print v(xbgr.mr_n53716752)
print v(xbgr.mr_n53717072)
print v(xbgr.mr_n53717184)
print v(xbgr.mr_n53717504)
print v(xbgr.mr_n53717616)
print v(xbgr.mr_n53717936)
print v(xbgr.mr_n53718048)
print v(xbgr.mr_n53718368)
print v(xbgr.mr_n53718480)
print v(xbgr.mr_n53718800)
print v(xbgr.mr_n53718912)
print v(xbgr.mr_n53719232)
print v(xbgr.mr_n53719344)
print v(xbgr.mr_n53719664)
print v(xbgr.mr_n53719776)
print v(xbgr.mr_n53720096)
print v(xbgr.mr_n53720208)
print v(xbgr.mr_n53720528)
print v(xbgr.mr_n53720640)
print v(xbgr.mr_n53720960)
print v(xbgr.mr_n53721072)
print v(xbgr.mr_n53721392)
print v(xbgr.mr_n53721504)
print v(xbgr.mr_n53721824)
print v(xbgr.mr_n53721936)
print v(xbgr.mr_n53722256)
print v(xbgr.mr_n53722368)
print v(xbgr.mr_n53722688)
print v(xbgr.mr_n53722800)
print v(xbgr.mr_n53723120)
print v(xbgr.mr_n53723232)
print v(xbgr.mr_n53723552)
print v(xbgr.mr_n53723664)
print v(xbgr.mr_n53723984)
print v(xbgr.mr_n53724096)
print v(xbgr.mr_n53724416)
print v(xbgr.mr_n53724528)
print v(xbgr.mr_n53724848)
print v(xbgr.mr_n53724960)
print v(xbgr.mr_n53725280)
print v(xbgr.mr_n53725392)
print v(xbgr.mr_n53725712)
print v(xbgr.mr_n53725824)
print v(xbgr.mr_n53726144)
print v(xbgr.mr_n53726256)
print v(xbgr.mr_n53726576)
print v(xbgr.mr_n53726688)
print v(xbgr.mr_n53727008)
print v(xbgr.mr_n53727120)
print v(xbgr.mr_n53727440)
print v(xbgr.mr_n53727552)
print v(xbgr.mr_n53727872)
print v(xbgr.mr_n53727984)
print v(xbgr.mr_n53728304)
print v(xbgr.mr_n53728416)
print v(xbgr.mr_n53728736)
print v(xbgr.mr_n53728848)
print v(xbgr.mr_n53729168)
print v(xbgr.mr_n53729280)
print v(xbgr.mr_n53729600)
print v(xbgr.mr_n53729712)
print v(xbgr.mr_n53730032)
print v(xbgr.mr_n53730144)
print v(xbgr.mr_n53730464)
print v(xbgr.mr_n53730576)
print v(xbgr.mr_n53730896)
print v(xbgr.mr_n53731008)
print v(xbgr.mr_n53731328)
print v(xbgr.mr_n53731440)
print v(xbgr.mr_n53731760)
print v(xbgr.mr_n53731872)
print v(xbgr.mr_n53732192)
print v(xbgr.mr_n53732304)
print v(xbgr.mr_n53732624)
print v(xbgr.mr_n53732736)
print v(xbgr.mr_n53733056)
print v(xbgr.mr_n53733168)
print v(xbgr.mr_n53733488)
print v(xbgr.mr_n53733600)
print v(xbgr.mr_n53733920)
print v(xbgr.mr_n53734032)
print v(xbgr.mr_n53734352)
print v(xbgr.mr_n53734464)
print v(xbgr.mr_n53734784)
print v(xbgr.mr_n53734896)
print v(xbgr.mr_n53735216)
print v(xbgr.mr_n53735328)
print v(xbgr.mr_n53735648)
print v(xbgr.mr_n53735760)
print v(xbgr.mr_n53736080)
print v(xbgr.mr_n53736192)
print v(xbgr.mr_n53736512)
print v(xbgr.mr_n53736624)
print v(xbgr.mr_n53736944)
print v(xbgr.mr_n53737056)
print v(xbgr.mr_n53737376)
print v(xbgr.mr_n53737488)
print v(xbgr.mr_n53737808)
print v(xbgr.mr_n53737920)
print v(xbgr.mr_n53738240)
print v(xbgr.mr_n53738352)
print v(xbgr.mr_n53738672)
print v(xbgr.mr_n53738784)
print v(xbgr.mr_n53739104)
print v(xbgr.mr_n53739216)
print v(xbgr.mr_n53739536)
print v(xbgr.mr_n53739648)
print v(xbgr.mr_n53739968)
print v(xbgr.mr_n53740080)
print v(xbgr.mr_n53740400)
print v(xbgr.mr_n53740512)
print v(xbgr.mr_n53740832)
print v(xbgr.mr_n53740944)
print v(xbgr.mr_n53741264)
print v(xbgr.mr_n53741376)
print v(xbgr.mr_n53741696)
print v(xbgr.mr_n53741808)
print v(xbgr.mr_n53742128)
print v(xbgr.mr_n53742240)
print v(xbgr.mr_n53742560)
print v(xbgr.mr_n53742672)
print v(xbgr.mr_n53742992)
print v(xbgr.mr_n53743104)
print v(xbgr.mr_n53743424)
print v(xbgr.mr_n53743536)
print v(xbgr.mr_n53743856)
print v(xbgr.mr_n53743968)
print v(xbgr.mr_n53744288)
print v(xbgr.mr_n53744400)
print v(xbgr.mr_n53744720)
print v(xbgr.mr_n53744832)
print v(xbgr.mr_n53745152)
print v(xbgr.mr_n53745264)
print v(xbgr.mr_n53745584)
print v(xbgr.mr_n53745696)
print v(xbgr.mr_n53746016)
print v(xbgr.mr_n53746128)
print v(xbgr.mr_n53746448)
print v(xbgr.mr_n53746560)
print v(xbgr.mr_n53746880)
print v(xbgr.mr_n53746992)
print v(xbgr.mr_n53747312)
print v(xbgr.mr_n53747424)
print v(xbgr.mr_n53747744)
print v(xbgr.mr_n53747856)
print v(xbgr.mr_n53748176)
print v(xbgr.mr_n53748288)
print v(xbgr.mr_n53748608)
print v(xbgr.mr_n53748720)
print v(xbgr.mr_n53749040)
print v(xbgr.mr_n53749152)
print v(xbgr.mr_n53749472)
print v(xbgr.mr_n53749584)
print v(xbgr.mr_n53749904)
print v(xbgr.mr_n53750016)
print v(xbgr.mr_n53750336)
print v(xbgr.mr_n53750448)
print v(xbgr.mr_n53750768)
print v(xbgr.mr_n53750880)
print v(xbgr.mr_n53751200)
print v(xbgr.mr_n53751312)
print v(xbgr.mr_n53751632)
print v(xbgr.mr_n53751744)
print v(xbgr.mr_n53752064)
print v(xbgr.mr_n53752176)
print v(xbgr.mr_n53752496)
print v(xbgr.mr_n53752608)
print v(xbgr.mr_n53752928)
print v(xbgr.mr_n53753040)
print v(xbgr.mr_n53753360)
print v(xbgr.mr_n53753472)
print v(xbgr.mr_n53753792)
print v(xbgr.mr_n53753904)
print v(xbgr.mr_n53754224)
print v(xbgr.mr_n53754336)
print v(xbgr.mr_n53754656)
print v(xbgr.mr_n53754768)
print v(xbgr.mr_n53755088)
print v(xbgr.mr_n53755200)
print v(xbgr.mr_n53755520)
print v(xbgr.mr_n53755632)
print v(xbgr.mr_n53755952)
print v(xbgr.mr_n53756064)
print v(xbgr.mr_n53756384)
print v(xbgr.mr_n53756496)
print v(xbgr.mr_n53756816)
print v(xbgr.mr_n53756928)
print v(xbgr.mr_n53757248)
print v(xbgr.mr_n53757360)
print v(xbgr.mr_n53757680)
print v(xbgr.mr_n53757792)
print v(xbgr.mr_n53758112)
print v(xbgr.mr_n53758224)
print v(xbgr.mr_n53758544)
print v(xbgr.mr_n53758656)
print v(xbgr.mr_n53758976)
print v(xbgr.mr_n53759088)
print v(xbgr.mr_n53759408)
print v(xbgr.mr_n53759520)
print v(xbgr.mr_n53759840)
print v(xbgr.mr_n53759952)
print v(xbgr.mr_n53760272)
print v(xbgr.mr_n53760384)
print v(xbgr.mr_n53760704)
print v(xbgr.mr_n53760816)
print v(xbgr.mr_n53761136)
print v(xbgr.mr_n53761248)
print v(xbgr.mr_n53761568)
print v(xbgr.mr_n53761680)
print v(xbgr.mr_n53762000)
print v(xbgr.mr_n53762112)
print v(xbgr.mr_n53762432)
print v(xbgr.mr_n53762544)
print v(xbgr.mr_n53762864)
print v(xbgr.mr_n53762976)
print v(xbgr.mr_n53763296)
print v(xbgr.mr_n53763408)
print v(xbgr.mr_n53763728)
print v(xbgr.mr_n53763840)
print v(xbgr.mr_n53764160)
print v(xbgr.mr_n53764272)
print v(xbgr.mr_n53764592)
print v(xbgr.mr_n53764704)
print v(xbgr.mr_n53765024)
print v(xbgr.mr_n53765136)
print v(xbgr.mr_n53765456)
print v(xbgr.mr_n53765568)
print v(xbgr.mr_n53765888)
print v(xbgr.mr_n53766000)
print v(xbgr.mr_n53766320)
print v(xbgr.mr_n53766432)
print v(xbgr.mr_n53766752)
print v(xbgr.mr_n53766864)
print v(xbgr.mr_n53767184)
print v(xbgr.mr_n53767296)
print v(xbgr.mr_n53767616)
print v(xbgr.mr_n53767728)
print v(xbgr.mr_n53768048)
print v(xbgr.mr_n53768160)
print v(xbgr.mr_n53768480)
print v(xbgr.mr_n53768592)
print v(xbgr.mr_n53768912)
print v(xbgr.mr_n53769024)
print v(xbgr.mr_n53769344)
print v(xbgr.mr_n53769456)
print v(xbgr.mr_n53769776)
print v(xbgr.mr_n53769888)
print v(xbgr.mr_n53770208)
print v(xbgr.mr_n53770320)
print v(xbgr.mr_n53770640)
print v(xbgr.mr_n53770752)
print v(xbgr.mr_n53771072)
print v(xbgr.mr_n53771184)
print v(xbgr.mr_n53771504)
print v(xbgr.mr_n53771616)
print v(xbgr.mr_n53771936)
print v(xbgr.mr_n53772048)
print v(xbgr.mr_n53772368)
print v(xbgr.mr_n53772480)
print v(xbgr.mr_n53772800)
print v(xbgr.mr_n53772912)
print v(xbgr.mr_n53773232)
print v(xbgr.mr_n53773344)
print v(xbgr.mr_n53773664)
print v(xbgr.mr_n53773776)
print v(xbgr.mr_n53774096)
print v(xbgr.mr_n53774208)
print v(xbgr.mr_n53774528)
print v(xbgr.mr_n53774640)
print v(xbgr.mr_n53774960)
print v(xbgr.mr_n53775072)
print v(xbgr.mr_n53775392)
print v(xbgr.mr_n53775504)
print v(xbgr.mr_n53775824)
print v(xbgr.mr_n53775936)
print v(xbgr.mr_n53776256)
print v(xbgr.mr_n53776368)
print v(xbgr.mr_n53776688)
print v(xbgr.mr_n53776800)
print v(xbgr.mr_n53777120)
print v(xbgr.mr_n53777232)
print v(xbgr.mr_n53777552)
print v(xbgr.mr_n53777664)
print v(xbgr.mr_n53777984)
print v(xbgr.mr_n53778096)
print v(xbgr.mr_n53778416)
print v(xbgr.mr_n53778528)
print v(xbgr.mr_n53778848)
print v(xbgr.mr_n53778960)
print v(xbgr.mr_n53779280)
print v(xbgr.mr_n53779392)
print v(xbgr.mr_n53779712)
print v(xbgr.mr_n53779824)
print v(xbgr.mr_n53780144)
print v(xbgr.mr_n53780256)
print v(xbgr.mr_n53780576)
print v(xbgr.mr_n53780688)
print v(xbgr.mr_n53781008)
print v(xbgr.mr_n53781120)
print v(xbgr.mr_n53781440)
print v(xbgr.mr_n53781552)
print v(xbgr.mr_n53781872)
print v(xbgr.mr_n53781984)
print v(xbgr.mr_n53782304)
print v(xbgr.mr_n53782416)
print v(xbgr.mr_n53782736)
print v(xbgr.mr_n53782848)
print v(xbgr.mr_n53783168)
print v(xbgr.mr_n53783280)
print v(xbgr.mr_n53783600)
print v(xbgr.mr_n53783712)
print v(xbgr.mr_n53784032)
print v(xbgr.mr_n53784144)
print v(xbgr.mr_n53784464)
print v(xbgr.mr_n53784576)
print v(xbgr.mr_n53784896)
print v(xbgr.mr_n53785008)
print v(xbgr.mr_n53785328)
print v(xbgr.mr_n53785440)
print v(xbgr.mr_n53785760)
print v(xbgr.mr_n53785872)
print v(xbgr.mr_n53786192)
print v(xbgr.mr_n53786304)
print v(xbgr.mr_n53786624)
print v(xbgr.mr_n53786736)
print v(xbgr.mr_n53787056)
print v(xbgr.mr_n53787168)
print v(xbgr.mr_n53787488)
print v(xbgr.mr_n53787600)
print v(xbgr.mr_n53788032)
print v(xbgr.mr_n53788352)
print v(xbgr.mr_n53788464)
print v(xbgr.mr_n53788784)
print v(xbgr.mr_n53788896)
print v(xbgr.mr_n53789216)
print v(xbgr.mr_n53789328)
print v(xbgr.mr_n53789648)
print v(xbgr.mr_n53789760)
print v(xbgr.mr_n53790080)
print v(xbgr.mr_n53790192)
print v(xbgr.mr_n53790624)
print v(xbgr.mr_n53790944)
print v(xbgr.mr_n53791056)
print v(xbgr.mr_n53791376)
print v(xbgr.mr_n53791488)
print v(xbgr.mr_n53791808)
print v(xbgr.mr_n53791920)
print v(xbgr.mr_n53792240)
print v(xbgr.mr_n53792352)
print v(xbgr.mr_n53792672)
print v(xbgr.mr_n53792784)
print v(xbgr.mr_n53793216)
print v(xbgr.mr_n53793536)
print v(xbgr.mr_n53793648)
print v(xbgr.mr_n53793968)
print v(xbgr.mr_n53794080)
print v(xbgr.mr_n53794400)
print v(xbgr.mr_n53794512)
print v(xbgr.mr_n53794832)
print v(xbgr.mr_n53794944)
print v(xbgr.mr_n53795264)
print v(xbgr.mr_n53795376)
print v(xbgr.mr_n53795696)
print v(xbgr.mr_n53795808)
print v(xbgr.mr_n53796128)
print v(xbgr.mr_n53796240)
print v(xbgr.mr_n53796672)
print v(xbgr.mr_n53796992)
print v(xbgr.mr_n53797104)
print v(xbgr.mr_n53797536)
print v(xbgr.mr_n53797856)
print v(xbgr.mr_n53797968)
print v(xbgr.mr_n53798288)
print v(xbgr.mr_n53798400)
print v(xbgr.mr_n53798720)
print v(xbgr.mr_n53798832)
print v(xbgr.mr_n53799152)
print v(xbgr.mr_n53799264)
print v(xbgr.mr_n53799584)
print v(xbgr.mr_n53799696)
print v(xbgr.mr_n53800128)
print v(xbgr.mr_n53800448)
print v(xbgr.mr_n53800560)
print v(xbgr.mr_n53800992)
print v(xbgr.mr_n53801312)
print v(xbgr.mr_n53801424)
print v(xbgr.mr_n53801744)
print v(xbgr.mr_n53801856)
print v(xbgr.mr_n53802176)
print v(xbgr.mr_n53802288)
print v(xbgr.mr_n53802608)
print v(xbgr.mr_n53802720)
print v(xbgr.mr_n53803040)
print v(xbgr.mr_n53803152)
print v(xbgr.mr_n53803472)
print v(xbgr.mr_n53803584)
print v(xbgr.mr_n53803904)
print v(xbgr.mr_n53804016)
print v(xbgr.mr_n53804336)
print v(xbgr.mr_n53804448)
print v(xbgr.mr_n53804768)
print v(xbgr.mr_n53804880)
print v(xbgr.mr_n53805200)
print v(xbgr.mr_n53805312)
print v(xbgr.mr_n53805632)
print v(xbgr.mr_n53805744)
print v(xbgr.mr_n53806064)
print v(xbgr.mr_n53806176)
print v(xbgr.mr_n53806496)
print v(xbgr.mr_n53806608)
print v(xbgr.mr_n53806928)
print v(xbgr.mr_n53807040)
print v(xbgr.mr_n53807360)
print v(xbgr.mr_n53807472)
print v(xbgr.mr_n53807792)
print v(xbgr.mr_n53807904)
print v(xbgr.mr_n53808224)
print v(xbgr.mr_n53808336)
print v(xbgr.mr_n53808656)
print v(xbgr.mr_n53808768)
print v(xbgr.mr_n53809088)
print v(xbgr.mr_n53809200)
print v(xbgr.mr_n53809520)
print v(xbgr.mr_n53809632)
print v(xbgr.mr_n53809952)
print v(xbgr.mr_n53810064)
print v(xbgr.mr_n53810384)
print v(xbgr.mr_n53810496)
print v(xbgr.mr_n53810816)
print v(xbgr.mr_n53810928)
print v(xbgr.mr_n53811248)
print v(xbgr.mr_n53811360)
print v(xbgr.mr_n53811680)
print v(xbgr.mr_n53811792)
print v(xbgr.mr_n53812112)
print v(xbgr.mr_n53812224)
print v(xbgr.mr_n53812544)
print v(xbgr.mr_n53812656)
print v(xbgr.mr_n53812976)
print v(xbgr.mr_n53813088)
print v(xbgr.mr_n53813408)
print v(xbgr.mr_n53813520)
print v(xbgr.mr_n53813840)
print v(xbgr.mr_n53813952)
print v(xbgr.mr_n53814272)
print v(xbgr.mr_n53814384)
print v(xbgr.mr_n53814704)
print v(xbgr.mr_n53814816)
print v(xbgr.mr_n53815136)
print v(xbgr.mr_n53815248)
print v(xbgr.mr_n53815568)
print v(xbgr.mr_n53815680)
print v(xbgr.mr_n53816000)
print v(xbgr.mr_n53816112)
print v(xbgr.mr_n53816432)
print v(xbgr.mr_n53816544)
print v(xbgr.mr_n53816864)
print v(xbgr.mr_n53816976)
print v(xbgr.mr_n53817296)
print v(xbgr.mr_n53817408)
print v(xbgr.mr_n53817728)
print v(xbgr.mr_n53817840)
print v(xbgr.mr_n53818160)
print v(xbgr.mr_n53818272)
print v(xbgr.mr_n53818592)
print v(xbgr.mr_n53818704)
print v(xbgr.mr_n53819024)
print v(xbgr.mr_n53819136)
print v(xbgr.mr_n53819456)
print v(xbgr.mr_n53819568)
print v(xbgr.mr_n53819888)
print v(xbgr.mr_n53820000)
print v(xbgr.mr_n53820320)
print v(xbgr.mr_n53820432)
print v(xbgr.mr_n53820752)
print v(xbgr.mr_n53820864)
print v(xbgr.mr_n53821184)
print v(xbgr.mr_n53821296)
print v(xbgr.mr_n53821616)
print v(xbgr.mr_n53821728)
print v(xbgr.mr_n53822048)
print v(xbgr.mr_n53822160)
print v(xbgr.mr_n53822480)
print v(xbgr.mr_n53822592)
print v(xbgr.mr_n53822912)
print v(xbgr.mr_n53823024)
print v(xbgr.mr_n53823344)
print v(xbgr.mr_n53823456)
print v(xbgr.mr_n53823776)
print v(xbgr.mr_n53823888)
print v(xbgr.mr_n53824208)
print v(xbgr.mr_n53824320)
print v(xbgr.mr_n53824640)
print v(xbgr.mr_n53824752)
print v(xbgr.mr_n53825072)
print v(xbgr.mr_n53825184)
print v(xbgr.mr_n53825504)
print v(xbgr.mr_n53825616)
print v(xbgr.mr_n53825936)
print v(xbgr.mr_n53826048)
print v(xbgr.mr_n53826368)
print v(xbgr.mr_n53826480)
print v(xbgr.mr_n53826800)
print v(xbgr.mr_n53826912)
print v(xbgr.mr_n53827232)
print v(xbgr.mr_n53827344)
print v(xbgr.mr_n53827664)
print v(xbgr.mr_n53827776)
print v(xbgr.mr_n53828096)
print v(xbgr.mr_n53828208)
print v(xbgr.mr_n53828528)
print v(xbgr.mr_n53828640)
print v(xbgr.mr_n53828960)
print v(xbgr.mr_n53829072)
print v(xbgr.mr_n53829392)
print v(xbgr.mr_n53829504)
print v(xbgr.mr_n53829824)
print v(xbgr.mr_n53829936)
print v(xbgr.mr_n53830256)
print v(xbgr.mr_n53830368)
print v(xbgr.mr_n53830688)
print v(xbgr.mr_n53830800)
print v(xbgr.mr_n53831120)
print v(xbgr.mr_n53831232)
print v(xbgr.mr_n53831552)
print v(xbgr.mr_n53831664)
print v(xbgr.mr_n53831984)
print v(xbgr.mr_n53832096)
print v(xbgr.mr_n53832416)
print v(xbgr.mr_n53832528)
print v(xbgr.mr_n53832848)
print v(xbgr.mr_n53832960)
print v(xbgr.mr_n53833280)
print v(xbgr.mr_n53833392)
print v(xbgr.mr_n53833712)
print v(xbgr.mr_n53833824)
print v(xbgr.mr_n53834144)
print v(xbgr.mr_n53834256)
print v(xbgr.mr_n53834688)
print v(xbgr.mr_n53835008)
print v(xbgr.mr_n53835120)
print v(xbgr.mr_n53835440)
print v(xbgr.mr_n53835552)
print v(xbgr.mr_n53835872)
print v(xbgr.mr_n53835984)
print v(xbgr.mr_n53836416)
print v(xbgr.mr_n53836736)
print v(xbgr.mr_n53836848)
print v(xbgr.mr_n53837280)
print v(xbgr.mr_n53837600)
print v(xbgr.mr_n53837712)
print v(xbgr.mr_n53838032)
print v(xbgr.mr_n53838144)
print v(xbgr.mr_n53838464)
print v(xbgr.mr_n53838576)
print v(xbgr.mr_n53838896)
print v(xbgr.mr_n53839008)
print v(xbgr.mr_n53839328)
print v(xbgr.mr_n53839440)
print v(xbgr.mr_n53839760)
print v(xbgr.mr_n53839872)
print v(xbgr.mr_n53840192)
print v(xbgr.mr_n53840304)
print v(xbgr.mr_n53840624)
print v(xbgr.mr_n53840736)
print v(xbgr.mr_n53841056)
print v(xbgr.mr_n53841168)
print v(xbgr.mr_n53841488)
print v(xbgr.mr_n53841600)
print v(xbgr.mr_n53841920)
print v(xbgr.mr_n53842032)
print v(xbgr.mr_n53842352)
print v(xbgr.mr_n53842464)
print v(xbgr.mr_n53842784)
print v(xbgr.mr_n53842896)
print v(xbgr.mr_n53843216)
print v(xbgr.mr_n53843328)
print v(xbgr.mr_n53843648)
print v(xbgr.mr_n53843760)
print v(xbgr.mr_n53844080)
print v(xbgr.mr_n53844192)
print v(xbgr.mr_n53844512)
print v(xbgr.mr_n53844624)
print v(xbgr.mr_n53844944)
print v(xbgr.mr_n53845056)
print v(xbgr.mr_n53845376)
print v(xbgr.mr_n53845488)
print v(xbgr.mr_n53845808)
print v(xbgr.mr_n53845920)
print v(xbgr.mr_n53846240)
print v(xbgr.mr_n53846352)
print v(xbgr.mr_n53846672)
print v(xbgr.mr_n53846784)
print v(xbgr.mr_n53847104)
print v(xbgr.mr_n53847216)
print v(xbgr.mr_n53847536)
print v(xbgr.mr_n53847648)
print v(xbgr.mr_n53847968)
print v(xbgr.mr_n53848080)
print v(xbgr.mr_n53848400)
print v(xbgr.mr_n53848512)
print v(xbgr.mr_n53848832)
print v(xbgr.mr_n53848944)
print v(xbgr.mr_n53849376)
print v(xbgr.mr_n53849696)
print v(xbgr.mr_n53849808)
print v(xbgr.mr_n53850128)
print v(xbgr.mr_n53850240)
print v(xbgr.mr_n53850560)
print v(xbgr.mr_n53850672)
print v(xbgr.mr_n53850992)
print v(xbgr.mr_n53851104)
print v(xbgr.mr_n53851424)
print v(xbgr.mr_n53851536)
print v(xbgr.mr_n53851856)
print v(xbgr.mr_n53851968)
print v(xbgr.mr_n53852288)
print v(xbgr.mr_n53852400)
print v(xbgr.mr_n53852720)
print v(xbgr.mr_n53852832)
print v(xbgr.mr_n53853152)
print v(xbgr.mr_n53853264)
print v(xbgr.mr_n53853696)
print v(xbgr.mr_n53854016)
print v(xbgr.mr_n53854128)
print v(xbgr.mr_n53854448)
print v(xbgr.mr_n53854560)
print v(xbgr.mr_n53854880)
print v(xbgr.mr_n53854992)
print v(xbgr.mr_n53855424)
print v(xbgr.mr_n53855744)
print v(xbgr.mr_n53855856)
print v(xbgr.mr_n53856176)
print v(xbgr.mr_n53856288)
print v(xbgr.mr_n53856608)
print v(xbgr.mr_n53856720)
print v(xbgr.mr_n53857040)
print v(xbgr.mr_n53857152)
print v(xbgr.mr_n53857472)
print v(xbgr.mr_n53857584)
print v(xbgr.mr_n53858016)
print v(xbgr.mr_n53858336)
print v(xbgr.mr_n53858448)
print v(xbgr.mr_n53858768)
print v(xbgr.mr_n53858880)
print v(xbgr.mr_n53859200)
print v(xbgr.mr_n53859312)
print v(xbgr.mr_n53859632)
print v(xbgr.mr_n53859744)
print v(xbgr.mr_n53860064)
print v(xbgr.mr_n53860176)
print v(xbgr.mr_n53860496)
print v(xbgr.mr_n53860608)
print v(xbgr.mr_n53860928)
print v(xbgr.mr_n53861040)
print v(xbgr.mr_n53861360)
print v(xbgr.mr_n53861472)
print v(xbgr.mr_n53861792)
print v(xbgr.mr_n53861904)
print v(xbgr.mr_n53862224)
print v(xbgr.mr_n53862336)
print v(xbgr.mr_n53862656)
print v(xbgr.mr_n53862768)
print v(xbgr.mr_n53863088)
print v(xbgr.mr_n53863200)
print v(xbgr.mr_n53863520)
print v(xbgr.mr_n53863632)
print v(xbgr.mr_n53863952)
print v(xbgr.mr_n53864064)
print v(xbgr.mr_n53864384)
print v(xbgr.mr_n53864496)
print v(xbgr.mr_n53864816)
print v(xbgr.mr_n53864928)
print v(xbgr.mr_n53865248)
print v(xbgr.mr_n53865360)
print v(xbgr.mr_n53865680)
print v(xbgr.mr_n53865792)
print v(xbgr.mr_n53866112)
print v(xbgr.mr_n53866224)
print v(xbgr.mr_n53866544)
print v(xbgr.mr_n53866656)
print v(xbgr.mr_n53866976)
print v(xbgr.mr_n53867088)
print v(xbgr.mr_n53867408)
print v(xbgr.mr_n53867520)
print v(xbgr.mr_n53867840)
print v(xbgr.mr_n53867952)
print v(xbgr.mr_n53868272)
print v(xbgr.mr_n53868384)
print v(xbgr.mr_n53868704)
print v(xbgr.mr_n53868816)
print v(xbgr.mr_n53869136)
print v(xbgr.mr_n53869248)
print v(xbgr.mr_n53869568)
print v(xbgr.mr_n53869680)
print v(xbgr.mr_n53870000)
print v(xbgr.mr_n53870112)
print v(xbgr.mr_n53870432)
print v(xbgr.mr_n53870544)
print v(xbgr.mr_n53870864)
print v(xbgr.mr_n53870976)
print v(xbgr.mr_n53871296)
print v(xbgr.mr_n53871408)
print v(xbgr.mr_n53871728)
print v(xbgr.mr_n53871840)
print v(xbgr.mr_n53872160)
print v(xbgr.mr_n53872272)
print v(xbgr.mr_n53872592)
print v(xbgr.mr_n53872704)
print v(xbgr.mr_n53873024)
print v(xbgr.mr_n53873136)
print v(xbgr.mr_n53873456)
print v(xbgr.mr_n53873568)
print v(xbgr.mr_n53873888)
print v(xbgr.mr_n53874000)
print v(xbgr.mr_n53874320)
print v(xbgr.mr_n53874432)
print v(xbgr.mr_n53874752)
print v(xbgr.mr_n53874864)
print v(xbgr.mr_n53875184)
print v(xbgr.mr_n53875296)
print v(xbgr.mr_n53875616)
print v(xbgr.mr_n53875728)
print v(xbgr.mr_n53876048)
print v(xbgr.mr_n53876160)
print v(xbgr.mr_n53876480)
print v(xbgr.mr_n53876592)
print v(xbgr.mr_n53876912)
print v(xbgr.mr_n53877024)
print v(xbgr.mr_n53877344)
print v(xbgr.mr_n53877456)
print v(xbgr.mr_n53877776)
print v(xbgr.mr_n53877888)
print v(xbgr.mr_n53878208)
print v(xbgr.mr_n53878320)
print v(xbgr.mr_n53878640)
print v(xbgr.mr_n53878752)
print v(xbgr.mr_n53879072)
print v(xbgr.mr_n53879184)
print v(xbgr.mr_n53879504)
print v(xbgr.mr_n53879616)
print v(xbgr.mr_n53879936)
print v(xbgr.mr_n53880048)
print v(xbgr.mr_n53880368)
print v(xbgr.mr_n53880480)
print v(xbgr.mr_n53880800)
print v(xbgr.mr_n53880912)
print v(xbgr.mr_n53881232)
print v(xbgr.mr_n53881344)
print v(xbgr.mr_n53881664)
print v(xbgr.mr_n53881776)
print v(xbgr.mr_n53882096)
print v(xbgr.mr_n53882208)
print v(xbgr.mr_n53882528)
print v(xbgr.mr_n53882640)
print v(xbgr.mr_n53882960)
print v(xbgr.mr_n53883072)
print v(xbgr.mr_n53883392)
print v(xbgr.mr_n53883504)
print v(xbgr.mr_n53883824)
print v(xbgr.mr_n53883936)
print v(xbgr.mr_n53884256)
print v(xbgr.mr_n53884368)
print v(xbgr.mr_n53884688)
print v(xbgr.mr_n53884800)
print v(xbgr.mr_n53885120)
print v(xbgr.mr_n53885232)
print v(xbgr.mr_n53885552)
print v(xbgr.mr_n53885664)
print v(xbgr.mr_n53885984)
print v(xbgr.mr_n53886096)
print v(xbgr.mr_n53886416)
print v(xbgr.mr_n53886528)
print v(xbgr.mr_n53886848)
print v(xbgr.mr_n53886960)
print v(xbgr.mr_n53887280)
print v(xbgr.mr_n53887392)
print v(xbgr.mr_n53887712)
print v(xbgr.mr_n53887824)
print v(xbgr.mr_n53888256)
print v(xbgr.mr_n53888576)
print v(xbgr.mr_n53888688)
print v(xbgr.mr_n53889008)
print v(xbgr.mr_n53889120)
print v(xbgr.mr_n53889440)
print v(xbgr.mr_n53889552)
print v(xbgr.mr_n53889984)
print v(xbgr.mr_n53890304)
print v(xbgr.mr_n53890416)
print v(xbgr.mr_n53890848)
print v(xbgr.mr_n53891168)
print v(xbgr.mr_n53891280)
print v(xbgr.mr_n53891600)
print v(xbgr.mr_n53891712)
print v(xbgr.mr_n53892032)
print v(xbgr.mr_n53892144)
print v(xbgr.mr_n53892464)
print v(xbgr.mr_n53892576)
print v(xbgr.mr_n53892896)
print v(xbgr.mr_n53893008)
print v(xbgr.mr_n53893328)
print v(xbgr.mr_n53893440)
print v(xbgr.mr_n53893760)
print v(xbgr.mr_n53893872)
print v(xbgr.mr_n53894192)
print v(xbgr.mr_n53894304)
print v(xbgr.mr_n53894624)
print v(xbgr.mr_n53894736)
print v(xbgr.mr_n53895056)
print v(xbgr.mr_n53895168)
print v(xbgr.mr_n53895488)
print v(xbgr.mr_n53895600)
print v(xbgr.mr_n53895920)
print v(xbgr.mr_n53896032)
print v(xbgr.mr_n53896352)
print v(xbgr.mr_n53896464)
print v(xbgr.mr_n53896784)
print v(xbgr.mr_n53896896)
print v(xbgr.mr_n53897216)
print v(xbgr.mr_n53897328)
print v(xbgr.mr_n53897648)
print v(xbgr.mr_n53897760)
print v(xbgr.mr_n53898080)
print v(xbgr.mr_n53898192)
print v(xbgr.mr_n53898512)
print v(xbgr.mr_n53898624)
print v(xbgr.mr_n53898944)
print v(xbgr.mr_n53899056)
print v(xbgr.mr_n53899376)
print v(xbgr.mr_n53899488)
print v(xbgr.mr_n53899808)
print v(xbgr.mr_n53899920)
print v(xbgr.mr_n53900240)
print v(xbgr.mr_n53900352)
print v(xbgr.mr_n53900672)
print v(xbgr.mr_n53900784)
print v(xbgr.mr_n53901104)
print v(xbgr.mr_n53901216)
print v(xbgr.mr_n53901536)
print v(xbgr.mr_n53901648)
print v(xbgr.mr_n53901968)
print v(xbgr.mr_n53902080)
print v(xbgr.mr_n53902400)
print v(xbgr.mr_n53902512)
print v(xbgr.mr_n53902832)
print v(xbgr.mr_n53902944)
print v(xbgr.mr_n53903264)
print v(xbgr.mr_n53903376)
print v(xbgr.mr_n53903696)
print v(xbgr.mr_n53903808)
print v(xbgr.mr_n53904128)
print v(xbgr.mr_n53904240)
print v(xbgr.mr_n53904560)
print v(xbgr.mr_n53904672)
print v(xbgr.mr_n53904992)
print v(xbgr.mr_n53905104)
print v(xbgr.mr_n53905424)
print v(xbgr.mr_n53905536)
print v(xbgr.mr_n53905856)
print v(xbgr.mr_n53905968)
print v(xbgr.mr_n53906288)
print v(xbgr.mr_n53906400)
print v(xbgr.mr_n53906720)
print v(xbgr.mr_n53906832)
print v(xbgr.mr_n53907152)
print v(xbgr.mr_n53907264)
print v(xbgr.mr_n53907584)
print v(xbgr.mr_n53907696)
print v(xbgr.mr_n53908016)
print v(xbgr.mr_n53908128)
print v(xbgr.mr_n53908448)
print v(xbgr.mr_n53908560)
print v(xbgr.mr_n53908880)
print v(xbgr.mr_n53908992)
print v(xbgr.mr_n53909312)
print v(xbgr.mr_n53909424)
print v(xbgr.mr_n53909744)
print v(xbgr.mr_n53909856)
print v(xbgr.mr_n53910176)
print v(xbgr.mr_n53910288)
print v(xbgr.mr_n53910608)
print v(xbgr.mr_n53910720)
print v(xbgr.mr_n53911040)
print v(xbgr.mr_n53911152)
print v(xbgr.mr_n53911472)
print v(xbgr.mr_n53911584)
print v(xbgr.mr_n53911904)
print v(xbgr.mr_n53912016)
print v(xbgr.mr_n53912336)
print v(xbgr.mr_n53912448)
print v(xbgr.mr_n53912768)
print v(xbgr.mr_n53912880)
print v(xbgr.mr_n53913200)
print v(xbgr.mr_n53913312)
print v(xbgr.mr_n53913632)
print v(xbgr.mr_n53913744)
print v(xbgr.mr_n53914064)
print v(xbgr.mr_n53914176)
print v(xbgr.mr_n53914496)
print v(xbgr.mr_n53914608)
print v(xbgr.mr_n53914928)
print v(xbgr.mr_n53915040)
print v(xbgr.mr_n53915360)
print v(xbgr.mr_n53915472)
print v(xbgr.mr_n53915792)
print v(xbgr.mr_n53915904)
print v(xbgr.mr_n53916224)
print v(xbgr.mr_n53916336)
print v(xbgr.mr_n53916656)
print v(xbgr.mr_n53916768)
print v(xbgr.mr_n53917088)
print v(xbgr.mr_n53917200)
print v(xbgr.mr_n53917520)
print v(xbgr.mr_n53917632)
print v(xbgr.mr_n53917952)
print v(xbgr.mr_n53918064)
print v(xbgr.mr_n53918384)
print v(xbgr.mr_n53918496)
print v(xbgr.mr_n53918816)
print v(xbgr.mr_n53918928)
print v(xbgr.mr_n53919248)
print v(xbgr.mr_n53919360)
print v(xbgr.mr_n53919680)
print v(xbgr.mr_n53919792)
print v(xbgr.mr_n53920112)
print v(xbgr.mr_n53920224)
print v(xbgr.mr_n53920544)
print v(xbgr.mr_n53920656)
print v(xbgr.mr_n53920976)
print v(xbgr.mr_n53921088)
print v(xbgr.mr_n53921408)
print v(xbgr.mr_n53921520)
print v(xbgr.mr_n53921840)
print v(xbgr.mr_n53921952)
print v(xbgr.mr_n53922272)
print v(xbgr.mr_n53922384)
print v(xbgr.mr_n53922704)
print v(xbgr.mr_n53922816)
print v(xbgr.mr_n53923136)
print v(xbgr.mr_n53923248)
print v(xbgr.mr_n53923568)
print v(xbgr.mr_n53923680)
print v(xbgr.mr_n53924000)
print v(xbgr.mr_n53924112)
print v(xbgr.mr_n53924432)
print v(xbgr.mr_n53924544)
print v(xbgr.mr_n53924864)
print v(xbgr.mr_n53924976)
print v(xbgr.mr_n53925296)
print v(xbgr.mr_n53925408)
print v(xbgr.mr_n53925728)
print v(xbgr.mr_n53925840)
print v(xbgr.mr_n53926160)
print v(xbgr.mr_n53926272)
print v(xbgr.mr_n53926592)
print v(xbgr.mr_n53926704)
print v(xbgr.mr_n53927024)
print v(xbgr.mr_n53927136)
print v(xbgr.mr_n53927456)
print v(xbgr.mr_n53927568)
print v(xbgr.mr_n53927888)
print v(xbgr.mr_n53928000)
print v(xbgr.mr_n53928320)
print v(xbgr.mr_n53928432)
print v(xbgr.mr_n53928752)
print v(xbgr.mr_n53928864)
print v(xbgr.mr_n53929184)
print v(xbgr.mr_n53929296)
print v(xbgr.mr_n53929616)
print v(xbgr.mr_n53929728)
print v(xbgr.mr_n53930048)
print v(xbgr.mr_n53930160)
print v(xbgr.mr_n53930480)
print v(xbgr.mr_n53930592)
print v(xbgr.mr_n53930912)
print v(xbgr.mr_n53931024)
print v(xbgr.mr_n53931344)
print v(xbgr.mr_n53931456)
print v(xbgr.mr_n53931776)
print v(xbgr.mr_n53931888)
print v(xbgr.mr_n53932208)
print v(xbgr.mr_n53932320)
print v(xbgr.mr_n53932640)
print v(xbgr.mr_n53932752)
print v(xbgr.mr_n53933072)
print v(xbgr.mr_n53933184)
print v(xbgr.mr_n53933504)
print v(xbgr.mr_n53933616)
print v(xbgr.mr_n53933936)
print v(xbgr.mr_n53934048)
print v(xbgr.mr_n53934368)
print v(xbgr.mr_n53934480)
print v(xbgr.mr_n53934800)
print v(xbgr.mr_n53934912)
print v(xbgr.mr_n53935232)
print v(xbgr.mr_n53935344)
print v(xbgr.mr_n53935664)
print v(xbgr.mr_n53935776)
print v(xbgr.mr_n53936096)
print v(xbgr.mr_n53936208)
print v(xbgr.mr_n53936528)
print v(xbgr.mr_n53936640)
print v(xbgr.mr_n53936960)
print v(xbgr.mr_n53937072)
print v(xbgr.mr_n53937392)
print v(xbgr.mr_n53937504)
print v(xbgr.mr_n53937824)
print v(xbgr.mr_n53937936)
print v(xbgr.mr_n53938256)
print v(xbgr.mr_n53938368)
print v(xbgr.mr_n53938688)
print v(xbgr.mr_n53938800)
print v(xbgr.mr_n53939120)
print v(xbgr.mr_n53939232)
print v(xbgr.mr_n53939552)
print v(xbgr.mr_n53939664)
print v(xbgr.mr_n53939984)
print v(xbgr.mr_n53940096)
print v(xbgr.mr_n53940416)
print v(xbgr.mr_n53940528)
print v(xbgr.mr_n53940848)
print v(xbgr.mr_n53940960)
print v(xbgr.mr_n53941280)
print v(xbgr.mr_n53941392)
print v(xbgr.mr_n53941712)
print v(xbgr.mr_n53941824)
print v(xbgr.mr_n53942144)
print v(xbgr.mr_n53942256)
print v(xbgr.mr_n53942576)
print v(xbgr.mr_n53942688)
print v(xbgr.mr_n53943008)
print v(xbgr.mr_n53943120)
print v(xbgr.mr_n53943440)
print v(xbgr.mr_n53943552)
print v(xbgr.mr_n53943872)
print v(xbgr.mr_n53943984)
print v(xbgr.mr_n53944304)
print v(xbgr.mr_n53944416)
print v(xbgr.mr_n53944736)
print v(xbgr.mr_n53944848)
print v(xbgr.mr_n53945168)
print v(xbgr.mr_n53945280)
print v(xbgr.mr_n53945600)
print v(xbgr.mr_n53945712)
print v(xbgr.mr_n53946032)
print v(xbgr.mr_n53946144)
print v(xbgr.mr_n53946464)
print v(xbgr.mr_n53946576)
print v(xbgr.mr_n53946896)
print v(xbgr.mr_n53947008)
print v(xbgr.mr_n53947328)
print v(xbgr.mr_n53947440)
print v(xbgr.mr_n53947760)
print v(xbgr.mr_n53947872)
print v(xbgr.mr_n53948192)
print v(xbgr.mr_n53948304)
print v(xbgr.mr_n53948624)
print v(xbgr.mr_n53948736)
print v(xbgr.mr_n53949056)
print v(xbgr.mr_n53949168)
print v(xbgr.mr_n53949488)
print v(xbgr.mr_n53949600)
print v(xbgr.mr_n53949920)
print v(xbgr.mr_n53950032)
print v(xbgr.mr_n53950352)
print v(xbgr.mr_n53950464)
print v(xbgr.mr_n53950784)
print v(xbgr.mr_n53950896)
print v(xbgr.mr_n53951216)
print v(xbgr.mr_n53951328)
print v(xbgr.mr_n53951648)
print v(xbgr.mr_n53951760)
print v(xbgr.mr_n53952080)
print v(xbgr.mr_n53952192)
print v(xbgr.mr_n53952512)
print v(xbgr.mr_n53952624)
print v(xbgr.mr_n53952944)
print v(xbgr.mr_n53953056)
print v(xbgr.mr_n53953376)
print v(xbgr.mr_n53953488)
print v(xbgr.mr_n53953808)
print v(xbgr.mr_n53953920)
print v(xbgr.mr_n53954240)
print v(xbgr.mr_n53954352)
print v(xbgr.mr_n53954672)
print v(xbgr.mr_n53954784)
print v(xbgr.mr_n53955104)
print v(xbgr.mr_n53955216)
print v(xbgr.mr_n53955536)
print v(xbgr.mr_n53955648)
print v(xbgr.mr_n53955968)
print v(xbgr.mr_n53956080)
print v(xbgr.mr_n53956400)
print v(xbgr.mr_n53956512)
print v(xbgr.mr_n53956832)
print v(xbgr.mr_n53956944)
print v(xbgr.mr_n53957264)
print v(xbgr.mr_n53957376)
print v(xbgr.mr_n53957696)
print v(xbgr.mr_n53957808)
print v(xbgr.mr_n53958128)
print v(xbgr.mr_n53958240)
print v(xbgr.mr_n53958560)
print v(xbgr.mr_n53958672)
print v(xbgr.mr_n53958992)
print v(xbgr.mr_n53959104)
print v(xbgr.mr_n53959424)
print v(xbgr.mr_n53959536)
print v(xbgr.mr_n53959856)
print v(xbgr.mr_n53959968)
print v(xbgr.mr_n53960288)
print v(xbgr.mr_n53960400)
print v(xbgr.mr_n53960720)
print v(xbgr.mr_n53960832)
print v(xbgr.mr_n53961152)
print v(xbgr.mr_n53961264)
print v(xbgr.mr_n53961584)
print v(xbgr.mr_n53961696)
print v(xbgr.mr_n53962016)
print v(xbgr.mr_n53962128)
print v(xbgr.mr_n53962448)
print v(xbgr.mr_n53962560)
print v(xbgr.mr_n53962880)
print v(xbgr.mr_n53962992)
print v(xbgr.mr_n53963312)
print v(xbgr.mr_n53963424)
print v(xbgr.mr_n53963744)
print v(xbgr.mr_n53963856)
print v(xbgr.mr_n53964176)
print v(xbgr.mr_n53964288)
print v(xbgr.mr_n53964608)
print v(xbgr.mr_n53964720)
print v(xbgr.mr_n53965040)
print v(xbgr.mr_n53965152)
print v(xbgr.mr_n53965472)
print v(xbgr.mr_n53965584)
print v(xbgr.mr_n53965904)
print v(xbgr.mr_n53966016)
print v(xbgr.mr_n53966336)
print v(xbgr.mr_n53966448)
print v(xbgr.mr_n53966768)
print v(xbgr.mr_n53966880)
print v(xbgr.mr_n53967200)
print v(xbgr.mr_n53967312)
print v(xbgr.mr_n53967632)
print v(xbgr.mr_n53967744)
print v(xbgr.mr_n53968064)
print v(xbgr.mr_n53968176)
print v(xbgr.mr_n53968496)
print v(xbgr.mr_n53968608)
print v(xbgr.mr_n53968928)
print v(xbgr.mr_n53969040)
print v(xbgr.mr_n53969360)
print v(xbgr.mr_n53969472)
print v(xbgr.mr_n53969792)
print v(xbgr.mr_n53969904)
print v(xbgr.mr_n53970224)
print v(xbgr.mr_n53970336)
print v(xbgr.mr_n53970656)
print v(xbgr.mr_n53970768)
print v(xbgr.mr_n53971088)
print v(xbgr.mr_n53971200)
print v(xbgr.mr_n53971520)
print v(xbgr.mr_n53971632)
print v(xbgr.mr_n53971952)
print v(xbgr.mr_n53972064)
print v(xbgr.mr_n53972384)
print v(xbgr.mr_n53972496)
print v(xbgr.mr_n53972816)
print v(xbgr.mr_n53972928)
print v(xbgr.mr_n53973248)
print v(xbgr.mr_n53973360)
print v(xbgr.mr_n53973680)
print v(xbgr.mr_n53973792)
print v(xbgr.mr_n53974112)
print v(xbgr.mr_n53974224)
print v(xbgr.mr_n53974544)
print v(xbgr.mr_n53974656)
print v(xbgr.mr_n53974976)
print v(xbgr.mr_n53975088)
print v(xbgr.mr_n53975408)
print v(xbgr.mr_n53975520)
print v(xbgr.mr_n53975840)
print v(xbgr.mr_n53975952)
print v(xbgr.mr_n53976272)
print v(xbgr.mr_n53976384)
print v(xbgr.mr_n53976704)
print v(xbgr.mr_n53976816)
print v(xbgr.mr_n53977136)
print v(xbgr.mr_n53977248)
print v(xbgr.mr_n53977568)
print v(xbgr.mr_n53977680)
print v(xbgr.mr_n53978000)
print v(xbgr.mr_n53978112)
print v(xbgr.mr_n53978432)
print v(xbgr.mr_n53978544)
print v(xbgr.mr_n53978864)
print v(xbgr.mr_n53978976)
print v(xbgr.mr_n53979296)
print v(xbgr.mr_n53979408)
print v(xbgr.mr_n53979728)
print v(xbgr.mr_n53979840)
print v(xbgr.mr_n53980160)
print v(xbgr.mr_n53980272)
print v(xbgr.mr_n53980592)
print v(xbgr.mr_n53980704)
print v(xbgr.mr_n53981024)
print v(xbgr.mr_n53981136)
print v(xbgr.mr_n54047008)
print v(xbgr.mr_n54047120)
print v(xbgr.mr_n54047440)
print v(xbgr.mr_n54047552)
print v(xbgr.mr_n54047872)
print v(xbgr.mr_n54047984)
print v(xbgr.mr_n54048416)
print v(xbgr.mr_n54048736)
print v(xbgr.mr_n54048848)
print v(xbgr.mr_n54049168)
print v(xbgr.mr_n54049280)
print v(xbgr.mr_n54049712)
print v(xbgr.mr_n54050144)
print v(xbgr.mr_n54050464)
print v(xbgr.mr_n54050576)
print v(xbgr.mr_n54050896)
print v(xbgr.mr_n54051008)
print v(xbgr.mr_n54051328)
print v(xbgr.mr_n54051440)
print v(xbgr.mr_n54051760)
print v(xbgr.mr_n54051872)
print v(xbgr.mr_n54052192)
print v(xbgr.mr_n54052304)
print v(xbgr.mr_n54052624)
print v(xbgr.mr_n54052736)
print v(xbgr.mr_n54053056)
print v(xbgr.mr_n54053168)
print v(xbgr.mr_n54053488)
print v(xbgr.mr_n54053600)
print v(xbgr.mr_n54053920)
print v(xbgr.mr_n54054032)
print v(xbgr.mr_n54054352)
print v(xbgr.mr_n54054464)
print v(xbgr.mr_n54054784)
print v(xbgr.mr_n54054896)
print v(xbgr.mr_n54055216)
print v(xbgr.mr_n54055328)
print v(xbgr.mr_n54055760)
print v(xbgr.mr_n54056080)
print v(xbgr.mr_n54056192)
print v(xbgr.mr_n54056512)
print v(xbgr.mr_n54056624)
print v(xbgr.mr_n54056944)
print v(xbgr.mr_n54057056)
print v(xbgr.mr_n54057376)
print v(xbgr.mr_n54057488)
print v(xbgr.mr_n54057808)
print v(xbgr.mr_n54057920)
print v(xbgr.mr_n54058240)
print v(xbgr.mr_n54058352)
print v(xbgr.mr_n54058672)
print v(xbgr.mr_n54058784)
print v(xbgr.mr_n54059104)
print v(xbgr.mr_n54059216)
print v(xbgr.mr_n54059536)
print v(xbgr.mr_n54059648)
print v(xbgr.mr_n54059968)
print v(xbgr.mr_n54060080)
print v(xbgr.mr_n54060512)
print v(xbgr.mr_n54060944)
print v(xbgr.mr_n54061264)
print v(xbgr.mr_n54061376)
print v(xbgr.mr_n54061696)
print v(xbgr.mr_n54061808)
print v(xbgr.mr_n54062128)
print v(xbgr.mr_n54062240)
print v(xbgr.mr_n54062560)
print v(xbgr.mr_n54062672)
print v(xbgr.mr_n54062992)
print v(xbgr.mr_n54063104)
print v(xbgr.mr_n54063424)
print v(xbgr.mr_n54063536)
print v(xbgr.mr_n54063856)
print v(xbgr.mr_n54063968)
print v(xbgr.mr_n54064288)
print v(xbgr.mr_n54064400)
print v(xbgr.mr_n54064720)
print v(xbgr.mr_n54064832)
print v(xbgr.mr_n54065152)
print v(xbgr.mr_n54065264)
print v(xbgr.mr_n54065584)
print v(xbgr.mr_n54065696)
print v(xbgr.mr_n54066016)
print v(xbgr.mr_n54066128)
print v(xbgr.mr_n54066448)
print v(xbgr.mr_n54066560)
print v(xbgr.mr_n54066880)
print v(xbgr.mr_n54066992)
print v(xbgr.mr_n54067312)
print v(xbgr.mr_n54067424)
print v(xbgr.mr_n54067744)
print v(xbgr.mr_n54067856)
print v(xbgr.mr_n54068176)
print v(xbgr.mr_n54068288)
print v(xbgr.mr_n54068608)
print v(xbgr.mr_n54068720)
print v(xbgr.mr_n54069040)
print v(xbgr.mr_n54069152)
print v(xbgr.mr_n54069472)
print v(xbgr.mr_n54069584)
print v(xbgr.mr_n54069904)
print v(xbgr.mr_n54070016)
print v(xbgr.mr_n54070336)
print v(xbgr.mr_n54070448)
print v(xbgr.mr_n54070768)
print v(xbgr.mr_n54070880)
print v(xbgr.mr_n54071200)
print v(xbgr.mr_n54071312)
print v(xbgr.mr_n54071632)
print v(xbgr.mr_n54071744)
print v(xbgr.mr_n54072064)
print v(xbgr.mr_n54072176)
print v(xbgr.mr_n54072496)
print v(xbgr.mr_n54072608)
print v(xbgr.mr_n54072928)
print v(xbgr.mr_n54073040)
print v(xbgr.mr_n54073360)
print v(xbgr.mr_n54073472)
print v(xbgr.mr_n54073792)
print v(xbgr.mr_n54073904)
print v(xbgr.mr_n54074224)
print v(xbgr.mr_n54074336)
print v(xbgr.mr_n54074656)
print v(xbgr.mr_n54074768)
print v(xbgr.mr_n54075088)
print v(xbgr.mr_n54075200)
print v(xbgr.mr_n54075520)
print v(xbgr.mr_n54075632)
print v(xbgr.mr_n54075952)
print v(xbgr.mr_n54076064)
print v(xbgr.mr_n54076384)
print v(xbgr.mr_n54076496)
print v(xbgr.mr_n54076816)
print v(xbgr.mr_n54076928)
print v(xbgr.mr_n54077248)
print v(xbgr.mr_n54077360)
print v(xbgr.mr_n54077680)
print v(xbgr.mr_n54077792)
print v(xbgr.mr_n54078112)
print v(xbgr.mr_n54078224)
print v(xbgr.mr_n54078544)
print v(xbgr.mr_n54078656)
print v(xbgr.mr_n54078976)
print v(xbgr.mr_n54079088)
print v(xbgr.mr_n54079408)
print v(xbgr.mr_n54079520)
print v(xbgr.mr_n54079840)
print v(xbgr.mr_n54079952)
print v(xbgr.mr_n54080272)
print v(xbgr.mr_n54080384)
print v(xbgr.mr_n54080704)
print v(xbgr.mr_n54080816)
print v(xbgr.mr_n54081136)
print v(xbgr.mr_n54081248)
print v(xbgr.mr_n54081568)
print v(xbgr.mr_n54081680)
print v(xbgr.mr_n54082000)
print v(xbgr.mr_n54082112)
print v(xbgr.mr_n54082432)
print v(xbgr.mr_n54082544)
print v(xbgr.mr_n54082864)
print v(xbgr.mr_n54082976)
print v(xbgr.mr_n54083296)
print v(xbgr.mr_n54083408)
print v(xbgr.mr_n54083728)
print v(xbgr.mr_n54083840)
print v(xbgr.mr_n54084160)
print v(xbgr.mr_n54084272)
print v(xbgr.mr_n54084592)
print v(xbgr.mr_n54084704)
print v(xbgr.mr_n54085024)
print v(xbgr.mr_n54085136)
print v(xbgr.mr_n54085456)
print v(xbgr.mr_n54085568)
print v(xbgr.mr_n54085888)
print v(xbgr.mr_n54086000)
print v(xbgr.mr_n54086320)
print v(xbgr.mr_n54086432)
print v(xbgr.mr_n54086752)
print v(xbgr.mr_n54086864)
print v(xbgr.mr_n54087184)
print v(xbgr.mr_n54087296)
print v(xbgr.mr_n54087616)
print v(xbgr.mr_n54087728)
print v(xbgr.mr_n54088048)
print v(xbgr.mr_n54088160)
print v(xbgr.mr_n54088480)
print v(xbgr.mr_n54088592)
print v(xbgr.mr_n54088912)
print v(xbgr.mr_n54089024)
print v(xbgr.mr_n54089344)
print v(xbgr.mr_n54089456)
print v(xbgr.mr_n54089776)
print v(xbgr.mr_n54089888)
print v(xbgr.mr_n54090208)
print v(xbgr.mr_n54090320)
print v(xbgr.mr_n54090640)
print v(xbgr.mr_n54090752)
print v(xbgr.mr_n54091072)
print v(xbgr.mr_n54091184)
print v(xbgr.mr_n54091504)
print v(xbgr.mr_n54091616)
print v(xbgr.mr_n54091936)
print v(xbgr.mr_n54092048)
print v(xbgr.mr_n54092368)
print v(xbgr.mr_n54092480)
print v(xbgr.mr_n54092800)
print v(xbgr.mr_n54092912)
print v(xbgr.mr_n54093232)
print v(xbgr.mr_n54093344)
print v(xbgr.mr_n54093664)
print v(xbgr.mr_n54093776)
print v(xbgr.mr_n54094096)
print v(xbgr.mr_n54094208)
print v(xbgr.mr_n54094528)
print v(xbgr.mr_n54094640)
print v(xbgr.mr_n54094960)
print v(xbgr.mr_n54095072)
print v(xbgr.mr_n54095392)
print v(xbgr.mr_n54095504)
print v(xbgr.mr_n54095824)
print v(xbgr.mr_n54095936)
print v(xbgr.mr_n54096256)
print v(xbgr.mr_n54096368)
print v(xbgr.mr_n54096688)
print v(xbgr.mr_n54096800)
print v(xbgr.mr_n54097120)
print v(xbgr.mr_n54097232)
print v(xbgr.mr_n54097552)
print v(xbgr.mr_n54097664)
print v(xbgr.mr_n54097984)
print v(xbgr.mr_n54098096)
print v(xbgr.mr_n54098416)
print v(xbgr.mr_n54098528)
print v(xbgr.mr_n54098848)
print v(xbgr.mr_n54098960)
print v(xbgr.mr_n54099280)
print v(xbgr.mr_n54099392)
print v(xbgr.mr_n54099712)
print v(xbgr.mr_n54099824)
print v(xbgr.mr_n54100144)
print v(xbgr.mr_n54100256)
print v(xbgr.mr_n54100576)
print v(xbgr.mr_n54100688)
print v(xbgr.mr_n54101008)
print v(xbgr.mr_n54101120)
print v(xbgr.mr_n54101440)
print v(xbgr.mr_n54101552)
print v(xbgr.mr_n54101872)
print v(xbgr.mr_n54101984)
print v(xbgr.mr_n54102304)
print v(xbgr.mr_n54102416)
print v(xbgr.mr_n54102736)
print v(xbgr.mr_n54102848)
print v(xbgr.mr_n54103168)
print v(xbgr.mr_n54103280)
print v(xbgr.mr_n54103600)
print v(xbgr.mr_n54103712)
print v(xbgr.mr_n54104032)
print v(xbgr.mr_n54104144)
print v(xbgr.mr_n54104464)
print v(xbgr.mr_n54104576)
print v(xbgr.mr_n54104896)
print v(xbgr.mr_n54105008)
print v(xbgr.mr_n54105328)
print v(xbgr.mr_n54105440)
print v(xbgr.mr_n54105760)
print v(xbgr.mr_n54105872)
print v(xbgr.mr_n54106192)
print v(xbgr.mr_n54106304)
print v(xbgr.mr_n54106624)
print v(xbgr.mr_n54106736)
print v(xbgr.mr_n54107056)
print v(xbgr.mr_n54107168)
print v(xbgr.mr_n54107488)
print v(xbgr.mr_n54107600)
print v(xbgr.mr_n54107920)
print v(xbgr.mr_n54108032)
print v(xbgr.mr_n54108352)
print v(xbgr.mr_n54108464)
print v(xbgr.mr_n54108784)
print v(xbgr.mr_n54108896)
print v(xbgr.mr_n54109216)
print v(xbgr.mr_n54109328)
print v(xbgr.mr_n54109648)
print v(xbgr.mr_n54109760)
print v(xbgr.mr_n54110080)
print v(xbgr.mr_n54110192)
print v(xbgr.mr_n54110512)
print v(xbgr.mr_n54110624)
print v(xbgr.mr_n54110944)
print v(xbgr.mr_n54111056)
print v(xbgr.mr_n54111376)
print v(xbgr.mr_n54111488)
print v(xbgr.mr_n54111808)
print v(xbgr.mr_n54111920)
print v(xbgr.mr_n54112240)
print v(xbgr.mr_n54112352)
print v(xbgr.mr_n54112672)
print v(xbgr.mr_n54112784)
print v(xbgr.mr_n54113104)
print v(xbgr.mr_n54113216)
print v(xbgr.mr_n54113536)
print v(xbgr.mr_n54113648)
print v(xbgr.mr_n54113968)
print v(xbgr.mr_n54114080)
print v(xbgr.mr_n54114400)
print v(xbgr.mr_n54114512)
print v(xbgr.mr_n54114832)
print v(xbgr.mr_n54114944)
print v(xbgr.mr_n54115264)
print v(xbgr.mr_n54115376)
print v(xbgr.mr_n54115696)
print v(xbgr.mr_n54115808)
print v(xbgr.mr_n54116128)
print v(xbgr.mr_n54116240)
print v(xbgr.mr_n54116560)
print v(xbgr.mr_n54116672)
print v(xbgr.mr_n54116992)
print v(xbgr.mr_n54117104)
print v(xbgr.mr_n54117424)
print v(xbgr.mr_n54117536)
print v(xbgr.mr_n54117856)
print v(xbgr.mr_n54117968)
print v(xbgr.mr_n54118288)
print v(xbgr.mr_n54118400)
print v(xbgr.mr_n54118720)
print v(xbgr.mr_n54118832)
print v(xbgr.mr_n54119152)
print v(xbgr.mr_n54119264)
print v(xbgr.mr_n54119584)
print v(xbgr.mr_n54119696)
print v(xbgr.mr_n54120016)
print v(xbgr.mr_n54120128)
print v(xbgr.mr_n54120448)
print v(xbgr.mr_n54120560)
print v(xbgr.mr_n54120880)
print v(xbgr.mr_n54120992)
print v(xbgr.mr_n54121312)
print v(xbgr.mr_n54121424)
print v(xbgr.mr_n54121744)
print v(xbgr.mr_n54121856)
print v(xbgr.mr_n54122176)
print v(xbgr.mr_n54122288)
print v(xbgr.mr_n54122608)
print v(xbgr.mr_n54122720)
print v(xbgr.mr_n54123040)
print v(xbgr.mr_n54123152)
print v(xbgr.mr_n54123472)
print v(xbgr.mr_n54123584)
print v(xbgr.mr_n54123904)
print v(xbgr.mr_n54124016)
print v(xbgr.mr_n54124336)
print v(xbgr.mr_n54124448)
print v(xbgr.mr_n54124768)
print v(xbgr.mr_n54124880)
print v(xbgr.mr_n54125200)
print v(xbgr.mr_n54125312)
print v(xbgr.mr_n54125632)
print v(xbgr.mr_n54125744)
print v(xbgr.mr_n54126064)
print v(xbgr.mr_n54126176)
print v(xbgr.mr_n54126496)
print v(xbgr.mr_n54126608)
print v(xbgr.mr_n54126928)
print v(xbgr.mr_n54127040)
print v(xbgr.mr_n54127360)
print v(xbgr.mr_n54127472)
print v(xbgr.mr_n54127792)
print v(xbgr.mr_n54127904)
print v(xbgr.mr_n54128224)
print v(xbgr.mr_n54128336)
print v(xbgr.mr_n54128656)
print v(xbgr.mr_n54128768)
print v(xbgr.mr_n54129200)
print v(xbgr.mr_n54129520)
print v(xbgr.mr_n54129632)
print v(xbgr.mr_n54129952)
print v(xbgr.mr_n54130064)
print v(xbgr.mr_n54130384)
print v(xbgr.mr_n54130496)
print v(xbgr.mr_n54130816)
print v(xbgr.mr_n54130928)
print v(xbgr.mr_n54131248)
print v(xbgr.mr_n54132112)
print v(xbgr.mr_n54132224)
print v(xbgr.mr_n54132544)
print v(xbgr.mr_n54132656)
print v(xbgr.mr_n54132976)
print v(xbgr.mr_n54133088)
print v(xbgr.mr_n54133408)
print v(xbgr.mr_n54133520)
print v(xbgr.mr_n54133840)
print v(xbgr.mr_n54133952)
print v(xbgr.mr_n54134384)
print v(xbgr.mr_n54134704)
print v(xbgr.mr_n54134816)
print v(xbgr.mr_n54135136)
print v(xbgr.mr_n54135248)
print v(xbgr.mr_n54135568)
print v(xbgr.mr_n54135680)
print v(xbgr.mr_n54136000)
print v(xbgr.mr_n54136112)
print v(xbgr.mr_n54136432)
print v(xbgr.mr_n54136544)
print v(xbgr.mr_n54136976)
print v(xbgr.mr_n54137296)
print v(xbgr.mr_n54138160)
print v(xbgr.mr_n54138272)
print v(xbgr.mr_n54138704)
print v(xbgr.mr_n54139024)
print v(xbgr.mr_n54139888)
print v(xbgr.mr_n54140000)
print v(xbgr.mr_n54140432)
print v(xbgr.mr_n54140752)
print v(xbgr.mr_n54140864)
print v(xbgr.mr_n54141184)
print v(xbgr.mr_n54141296)
print v(xbgr.mr_n54141616)
print v(xbgr.mr_n54141728)
print v(xbgr.mr_n54142048)
print v(xbgr.mr_n54142160)
print v(xbgr.mr_n54142480)
print v(xbgr.mr_n54142592)
print v(xbgr.mr_n54142912)
print v(xbgr.mr_n54143024)
print v(xbgr.mr_n54143344)
print v(xbgr.mr_n54144208)
print v(xbgr.mr_n54144320)
print v(xbgr.mr_n54144640)
print v(xbgr.mr_n54144752)
print v(xbgr.mr_n54145072)
print v(xbgr.mr_n54145936)
print v(xbgr.mr_n54146048)
print v(xbgr.mr_n54146368)
print v(xbgr.mr_n54146480)
print v(xbgr.mr_n54146800)
print v(xbgr.mr_n54146912)
print v(xbgr.mr_n54147232)
print v(xbgr.mr_n54147344)
print v(xbgr.mr_n54147664)
print v(xbgr.mr_n54147776)
print v(xbgr.mr_n54148096)
print v(xbgr.mr_n54148208)
print v(xbgr.mr_n54148528)
print v(xbgr.mr_n54148640)
print v(xbgr.mr_n54148960)
print v(xbgr.mr_n54149072)
print v(xbgr.mr_n54149392)
print v(xbgr.mr_n54149504)
print v(xbgr.mr_n54149824)
print v(xbgr.mr_n54149936)
print v(xbgr.mr_n54150256)
print v(xbgr.mr_n54150368)
print v(xbgr.mr_n54150688)
print v(xbgr.mr_n54150800)
print v(xbgr.mr_n54151120)
print v(xbgr.mr_n54151232)
print v(xbgr.mr_n54151552)
print v(xbgr.mr_n54151664)
print v(xbgr.mr_n54151984)
print v(xbgr.mr_n54152096)
print v(xbgr.mr_n54152416)
print v(xbgr.mr_n54152528)
print v(xbgr.mr_n54152848)
print v(xbgr.mr_n54152960)
print v(xbgr.mr_n54153280)
print v(xbgr.mr_n54153392)
print v(xbgr.mr_n54153712)
print v(xbgr.mr_n54153824)
print v(xbgr.mr_n54154144)
print v(xbgr.mr_n54154256)
print v(xbgr.mr_n54154576)
print v(xbgr.mr_n54154688)
print v(xbgr.mr_n54155008)
print v(xbgr.mr_n54155120)
print v(xbgr.mr_n54155440)
print v(xbgr.mr_n54155552)
print v(xbgr.mr_n54155872)
print v(xbgr.mr_n54155984)
print v(xbgr.mr_n54156304)
print v(xbgr.mr_n54156416)
print v(xbgr.mr_n54156736)
print v(xbgr.mr_n54156848)
print v(xbgr.mr_n54157280)
print v(xbgr.mr_n54157712)
print v(xbgr.mr_n54158144)
print v(xbgr.mr_n54158576)
print v(xbgr.mr_n54159008)
print v(xbgr.mr_n54159440)
print v(xbgr.mr_n54159872)
print v(xbgr.mr_n54160304)
print v(xbgr.mr_n54160736)
print v(xbgr.mr_n54161168)
print v(xbgr.mr_n54161600)
print v(xbgr.mr_n54162032)
print v(xbgr.mr_n54162464)
print v(xbgr.mr_n54162896)
print v(xbgr.mr_n54163328)
print v(xbgr.mr_n54163760)
print v(xbgr.mr_n54164192)
print v(xbgr.mr_n54164624)
print v(xbgr.mr_n54165056)
print v(xbgr.mr_n54165488)
print v(xbgr.mr_n54165920)
print v(xbgr.mr_n54166352)
print v(xbgr.mr_n54166672)
print v(xbgr.mr_n54166784)
print v(xbgr.mr_n54167216)
print v(xbgr.mr_n54167648)
print v(xbgr.mr_n54168080)
print v(xbgr.mr_n54168512)
print v(xbgr.mr_n54168944)
print v(xbgr.mr_n54169376)
print v(xbgr.mr_n54169808)
print v(xbgr.mr_n54170240)
print v(xbgr.mr_n54170672)
print v(xbgr.mr_n54171104)
print v(xbgr.mr_n54171536)
print v(xbgr.mr_n54171968)
print v(xbgr.mr_n54172400)
print v(xbgr.mr_n54172832)
print v(xbgr.mr_n54173264)
print v(xbgr.mr_n54173696)
print v(xbgr.mr_n54174128)
print v(xbgr.mr_n54174560)
print v(xbgr.mr_n54174992)
print v(xbgr.mr_n54175424)
print v(xbgr.mr_n54175856)
print v(xbgr.mr_n54176288)
print v(xbgr.mr_n54176720)
print v(xbgr.mr_n54177152)
print v(xbgr.mr_n54177584)
print v(xbgr.mr_n54178016)
print v(xbgr.mr_n54178448)
print v(xbgr.mr_n54178880)
print v(xbgr.mr_n54179312)
print v(xbgr.mr_n54179744)
print v(xbgr.mr_n54180176)
print v(xbgr.mr_n54180608)
print v(xbgr.mr_n54181040)
print v(xbgr.mr_n54181472)
print v(xbgr.mr_n54181904)
print v(xbgr.mr_n54182336)
print v(xbgr.mr_n54182768)
print v(xbgr.mr_n54183200)
print v(xbgr.mr_n54183632)
print v(xbgr.mr_n54184064)
print v(xbgr.mr_n54184496)
print v(xbgr.mr_n54184928)
print v(xbgr.mr_n54185360)
print v(xbgr.mr_n54185792)
print v(xbgr.mr_n54186224)
print v(xbgr.mr_n54186656)
print v(xbgr.mr_n54187088)
print v(xbgr.mr_n54187520)
print v(xbgr.mr_n54187952)
print v(xbgr.mr_n54188384)
print v(xbgr.mr_n54188816)
print v(xbgr.mr_n54189248)
print v(xbgr.mr_n54189680)
print v(xbgr.mr_n54190112)
print v(xbgr.mr_n54190544)
print v(xbgr.mr_n54190976)
print v(xbgr.mr_n54191408)
print v(xbgr.mr_n54191840)
print v(xbgr.mr_n54192272)
print v(xbgr.mr_n54192704)
print v(xbgr.mr_n54193136)
print v(xbgr.mr_n54193568)
print v(xbgr.mr_n54194000)
print v(xbgr.mr_n54194320)
print v(xbgr.mr_n54194432)
print v(xbgr.mr_n54194752)
print v(xbgr.mr_n54194864)
print v(xbgr.mr_n54195184)
print v(xbgr.mr_n54195296)
print v(xbgr.mr_n54195616)
print v(xbgr.mr_n54195728)
print v(xbgr.mr_n54196048)
print v(xbgr.mr_n54196160)
print v(xbgr.mr_n54196480)
print v(xbgr.mr_n54196592)
print v(xbgr.mr_n54196912)
print v(xbgr.mr_n54197024)
print v(xbgr.mr_n54197344)
print v(xbgr.mr_n54197456)
print v(xbgr.mr_n54197776)
print v(xbgr.mr_n54197888)
print v(xbgr.mr_n54198208)
print v(xbgr.mr_n54198320)
print v(xbgr.mr_n54198640)
print v(xbgr.mr_n54198752)
print v(xbgr.mr_n54199072)
print v(xbgr.mr_n54199184)
print v(xbgr.mr_n54199504)
print v(xbgr.mr_n54199936)
print v(xbgr.mr_n54200048)
print v(xbgr.mr_n54200368)
print v(xbgr.mr_n54200480)
print v(xbgr.mr_n54200800)
print v(xbgr.mr_n54200912)
print v(xbgr.mr_n54201232)
print v(xbgr.mr_n54201344)
print v(xbgr.mr_n54201664)
print v(xbgr.mr_n54201776)
print v(xbgr.mr_n54202096)
print v(xbgr.mr_n54202208)
print v(xbgr.mr_n54202528)
print v(xbgr.mr_n54202640)
print v(xbgr.mr_n54202960)
print v(xbgr.mr_n54203072)
print v(xbgr.mr_n54203392)
print v(xbgr.mr_n54203504)
print v(xbgr.mr_n54203824)
print v(xbgr.mr_n54203936)
print v(xbgr.mr_n54204256)
print v(xbgr.mr_n54204368)
print v(xbgr.mr_n54204800)
print v(xbgr.mr_n54205232)
print v(xbgr.mr_n54205664)
print v(xbgr.mr_n54206096)
print v(xbgr.mr_n54206528)
print v(xbgr.mr_n54206960)
print v(xbgr.mr_n54207392)
print v(xbgr.mr_n54207824)
print v(xbgr.mr_n54208256)
print v(xbgr.mr_n54208688)
print v(xbgr.mr_n54209120)
print v(xbgr.mr_n54209552)
print v(xbgr.mr_n54209984)
print v(xbgr.mr_n54210416)
print v(xbgr.mr_n54210848)
print v(xbgr.mr_n54211280)
print v(xbgr.mr_n54211712)
print v(xbgr.mr_n54212144)
print v(xbgr.mr_n54212576)
print v(xbgr.mr_n54213008)
print v(xbgr.mr_n54213440)
print v(xbgr.mr_n54213872)
print v(xbgr.mr_n54214304)
print v(xbgr.mr_n54214736)
print v(xbgr.mr_n54215168)
print v(xbgr.mr_n54215600)
print v(xbgr.mr_n54216032)
print v(xbgr.mr_n54216464)
print v(xbgr.mr_n54216896)
print v(xbgr.mr_n54217328)
print v(xbgr.mr_n54217760)
print v(xbgr.mr_n54218192)
print v(xbgr.mr_n54218624)
print v(xbgr.mr_n54219056)
print v(xbgr.mr_n54219488)
print v(xbgr.mr_n54219920)
print v(xbgr.mr_n54220352)
print v(xbgr.mr_n54220784)
print v(xbgr.mr_n54221216)
print v(xbgr.mr_n54221648)
print v(xbgr.mr_n54222080)
print v(xbgr.mr_n54222512)
print v(xbgr.mr_n54222944)
print v(xbgr.mr_n54223376)
print v(xbgr.mr_n54223808)
print v(xbgr.mr_n54224240)
print v(xbgr.mr_n54224672)
print v(xbgr.mr_n54225104)
print v(xbgr.mr_n54225536)
print v(xbgr.mr_n54225968)
print v(xbgr.mr_n54226400)
print v(xbgr.mr_n54226832)
print v(xbgr.mr_n54227264)
print v(xbgr.mr_n54227696)
print v(xbgr.mr_n54228128)
print v(xbgr.mr_n54228560)
print v(xbgr.mr_n54228992)
print v(xbgr.mr_n54229424)
print v(xbgr.mr_n54229856)
print v(xbgr.mr_n54230288)
print v(xbgr.mr_n54230720)
print v(xbgr.mr_n54231152)
print v(xbgr.mr_n54231584)
print v(xbgr.mr_n54232016)
print v(xbgr.mr_n54232448)
print v(xbgr.mr_n54232880)
print v(xbgr.mr_n54233312)
print v(xbgr.mr_n54233744)
print v(xbgr.mr_n54234176)
print v(xbgr.mr_n54234608)
print v(xbgr.mr_n54235040)
print v(xbgr.mr_n54235472)
print v(xbgr.mr_n54235904)
print v(xbgr.mr_n54236336)
print v(xbgr.mr_n54236768)
print v(xbgr.mr_n54237200)
print v(xbgr.mr_n54237632)
print v(xbgr.mr_n54238064)
print v(xbgr.mr_n54238496)
print v(xbgr.mr_n54238928)
print v(xbgr.mr_n54239360)
print v(xbgr.mr_n54239792)
print v(xbgr.mr_n54240224)
print v(xbgr.mr_n54240656)
print v(xbgr.mr_n54241088)
print v(xbgr.mr_n54241520)
print v(xbgr.mr_n54241840)
print v(xbgr.mr_n54241952)
print v(xbgr.mr_n54242272)
print v(xbgr.mr_n54242384)
print v(xbgr.mr_n54242704)
print v(xbgr.mr_n54242816)
print v(xbgr.mr_n54243136)
print v(xbgr.mr_n54243248)
print v(xbgr.mr_n54243568)
print v(xbgr.mr_n54243680)
print v(xbgr.mr_n54244000)
print v(xbgr.mr_n54244112)
print v(xbgr.mr_n54244432)
print v(xbgr.mr_n54244544)
print v(xbgr.mr_n54244864)
print v(xbgr.mr_n54244976)
print v(xbgr.mr_n54245296)
print v(xbgr.mr_n54245408)
print v(xbgr.mr_n54245728)
print v(xbgr.mr_n54245840)
print v(xbgr.mr_n54246160)
print v(xbgr.mr_n54246272)
print v(xbgr.mr_n54246592)
print v(xbgr.mr_n54246704)
print v(xbgr.mr_n54247024)
print v(xbgr.mr_n54247136)
print v(xbgr.mr_n54247456)
print v(xbgr.mr_n54247568)
print v(xbgr.mr_n54247888)
print v(xbgr.mr_n54248000)
print v(xbgr.mr_n54248320)
print v(xbgr.mr_n54248432)
print v(xbgr.mr_n54248752)
print v(xbgr.mr_n54248864)
print v(xbgr.mr_n54249184)
print v(xbgr.mr_n54249296)
print v(xbgr.mr_n54249616)
print v(xbgr.mr_n54250160)
print v(xbgr.mr_n54250480)
print v(xbgr.mr_n54250912)
print v(xbgr.mr_n54251024)
print v(xbgr.mr_n54251344)
print v(xbgr.mr_n54251456)
print v(xbgr.mr_n54251888)
print v(xbgr.mr_n54252208)
print v(xbgr.mr_n54253072)
print v(xbgr.mr_n54253184)
print v(xbgr.mr_n54253616)
print v(xbgr.mr_n54253936)
print v(xbgr.mr_n54254800)
print v(xbgr.mr_n54254912)
print v(xbgr.mr_n54255344)
print v(xbgr.mr_n54255664)
print v(xbgr.mr_n54255776)
print v(xbgr.mr_n54256208)
print v(xbgr.mr_n54256640)
print v(xbgr.mr_n54256960)
print v(xbgr.mr_n54257824)
print v(xbgr.mr_n54258800)
print v(xbgr.mr_n54259120)
print v(xbgr.mr_n54259232)
print v(xbgr.mr_n54259664)
print v(xbgr.mr_n54259984)
print v(xbgr.mr_n54260096)
print v(xbgr.mr_n54260528)
print v(xbgr.mr_n54260848)
print v(xbgr.mr_n54260960)
print v(xbgr.mr_n54261280)
print v(xbgr.mr_n54261392)
print v(xbgr.mr_n54261712)
print v(xbgr.mr_n54261824)
print v(xbgr.mr_n54262144)
print v(xbgr.mr_n54262256)
print v(xbgr.mr_n54262576)
print v(xbgr.mr_n54262688)
print v(xbgr.mr_n54263008)
print v(xbgr.mr_n54263120)
print v(xbgr.mr_n54263440)
print v(xbgr.mr_n54263552)
print v(xbgr.mr_n54263872)
print v(xbgr.mr_n54263984)
print v(xbgr.mr_n54264304)
print v(xbgr.mr_n54264416)
print v(xbgr.mr_n54264736)
print v(xbgr.mr_n54264848)
print v(xbgr.mr_n54265168)
print v(xbgr.mr_n54265280)
print v(xbgr.mr_n54265600)
print v(xbgr.mr_n54265712)
print v(xbgr.mr_n54266032)
print v(xbgr.mr_n54266896)
print v(xbgr.mr_n54267760)
print v(xbgr.mr_n54268192)
print v(xbgr.mr_n54268624)
print v(xbgr.mr_n54269056)
print v(xbgr.mr_n54269488)
print v(xbgr.mr_n54269920)
print v(xbgr.mr_n54270352)
print v(xbgr.mr_n54270784)
print v(xbgr.mr_n54271216)
print v(xbgr.mr_n54271648)
print v(xbgr.mr_n54272080)
print v(xbgr.mr_n54272512)
print v(xbgr.mr_n54272944)
print v(xbgr.mr_n54273056)
print v(xbgr.mr_n54273376)
print v(xbgr.mr_n54273488)
print v(xbgr.mr_n54273808)
print v(xbgr.mr_n54273920)
print v(xbgr.mr_n54274240)
print v(xbgr.mr_n54274352)
print v(xbgr.mr_n54274672)
print v(xbgr.mr_n54274784)
print v(xbgr.mr_n54275104)
print v(xbgr.mr_n54275216)
print v(xbgr.mr_n54275536)
print v(xbgr.mr_n54275648)
print v(xbgr.mr_n54275968)
print v(xbgr.mr_n54276080)
print v(xbgr.mr_n54276400)
print v(xbgr.mr_n54276512)
print v(xbgr.mr_n54276832)
print v(xbgr.mr_n54276944)
print v(xbgr.mr_n54277264)
print v(xbgr.mr_n54277376)
print v(xbgr.mr_n54277696)
print v(xbgr.mr_n54277808)
print v(xbgr.mr_n54278128)
print v(xbgr.mr_n54278560)
print v(xbgr.mr_n54278672)
print v(xbgr.mr_n54278992)
print v(xbgr.mr_n54279104)
print v(xbgr.mr_n54279424)
print v(xbgr.mr_n54279536)
print v(xbgr.mr_n54279856)
print v(xbgr.mr_n54279968)
print v(xbgr.mr_n54280288)
print v(xbgr.mr_n54280400)
print v(xbgr.mr_n54280720)
print v(xbgr.mr_n54280832)
print v(xbgr.mr_n54281152)
print v(xbgr.mr_n54281264)
print v(xbgr.mr_n54281584)
print v(xbgr.mr_n54281696)
print v(xbgr.mr_n54282016)
print v(xbgr.mr_n54282128)
print v(xbgr.mr_n54282448)
print v(xbgr.mr_n54282560)
print v(xbgr.mr_n54282880)
print v(xbgr.mr_n54282992)
print v(xbgr.mr_n54283312)
print v(xbgr.mr_n54283424)
print v(xbgr.mr_n54283744)
print v(xbgr.mr_n54283856)
print v(xbgr.mr_n54284176)
print v(xbgr.mr_n54284288)
print v(xbgr.mr_n54284608)
print v(xbgr.mr_n54284720)
print v(xbgr.mr_n54285040)
print v(xbgr.mr_n54285152)
print v(xbgr.mr_n54285472)
print v(xbgr.mr_n54285584)
print v(xbgr.mr_n54285904)
print v(xbgr.mr_n54286016)
print v(xbgr.mr_n54286336)
print v(xbgr.mr_n54286448)
print v(xbgr.mr_n54286768)
print v(xbgr.mr_n54286880)
print v(xbgr.mr_n54287200)
print v(xbgr.mr_n54287312)
print v(xbgr.mr_n54287632)
print v(xbgr.mr_n54287744)
print v(xbgr.mr_n54288064)
print v(xbgr.mr_n54288176)
print v(xbgr.mr_n54288496)
print v(xbgr.mr_n54288608)
print v(xbgr.mr_n54288928)
print v(xbgr.mr_n54289040)
print v(xbgr.mr_n54289360)
print v(xbgr.mr_n54289472)
print v(xbgr.mr_n54289792)
print v(xbgr.mr_n54289904)
print v(xbgr.mr_n54290224)
print v(xbgr.mr_n54290336)
print v(xbgr.mr_n54290656)
print v(xbgr.mr_n54290768)
print v(xbgr.mr_n54291088)
print v(xbgr.mr_n54291200)
print v(xbgr.mr_n54291520)
print v(xbgr.mr_n54291632)
print v(xbgr.mr_n54291952)
print v(xbgr.mr_n54292064)
print v(xbgr.mr_n54292384)
print v(xbgr.mr_n54292496)
print v(xbgr.mr_n54292816)
print v(xbgr.mr_n54292928)
print v(xbgr.mr_n54293248)
print v(xbgr.mr_n54293360)
print v(xbgr.mr_n54293680)
print v(xbgr.mr_n54293792)
print v(xbgr.mr_n54294112)
print v(xbgr.mr_n54294224)
print v(xbgr.mr_n54294544)
print v(xbgr.mr_n54294656)
print v(xbgr.mr_n54294976)
print v(xbgr.mr_n54295088)
print v(xbgr.mr_n54295408)
print v(xbgr.mr_n54295520)
print v(xbgr.mr_n54295840)
print v(xbgr.mr_n54295952)
print v(xbgr.mr_n54296272)
print v(xbgr.mr_n54296384)
print v(xbgr.mr_n54296704)
print v(xbgr.mr_n54296816)
print v(xbgr.mr_n54297136)
print v(xbgr.mr_n54297248)
print v(xbgr.mr_n54297568)
print v(xbgr.mr_n54297680)
print v(xbgr.mr_n54298000)
print v(xbgr.mr_n54298112)
print v(xbgr.mr_n54298432)
print v(xbgr.mr_n54298544)
print v(xbgr.mr_n54298864)
print v(xbgr.mr_n54298976)
print v(xbgr.mr_n54299296)
print v(xbgr.mr_n54299408)
print v(xbgr.mr_n54299728)
print v(xbgr.mr_n54299840)
print v(xbgr.mr_n54300160)
print v(xbgr.mr_n54300272)
print v(xbgr.mr_n54300592)
print v(xbgr.mr_n54300704)
print v(xbgr.mr_n54301024)
print v(xbgr.mr_n54301136)
print v(xbgr.mr_n54301456)
print v(xbgr.mr_n54301568)
print v(xbgr.mr_n54301888)
print v(xbgr.mr_n54302000)
print v(xbgr.mr_n54302320)
print v(xbgr.mr_n54302432)
print v(xbgr.mr_n54302752)
print v(xbgr.mr_n54302864)
print v(xbgr.mr_n54303184)
print v(xbgr.mr_n54303296)
print v(xbgr.mr_n54303616)
print v(xbgr.mr_n54303728)
print v(xbgr.mr_n54304048)
print v(xbgr.mr_n54304160)
print v(xbgr.mr_n54304480)
print v(xbgr.mr_n54304592)
print v(xbgr.mr_n54304912)
print v(xbgr.mr_n54305024)
print v(xbgr.mr_n54305344)
print v(xbgr.mr_n54305456)
print v(xbgr.mr_n54305776)
print v(xbgr.mr_n54305888)
print v(xbgr.mr_n54306208)
print v(xbgr.mr_n54306320)
print v(xbgr.mr_n54306640)
print v(xbgr.mr_n54306752)
print v(xbgr.mr_n54307072)
print v(xbgr.mr_n54307184)
print v(xbgr.mr_n54307504)
print v(xbgr.mr_n54307616)
print v(xbgr.mr_n54307936)
print v(xbgr.mr_n54308048)
print v(xbgr.mr_n54308368)
print v(xbgr.mr_n54308480)
print v(xbgr.mr_n54308800)
print v(xbgr.mr_n54308912)
print v(xbgr.mr_n54309232)
print v(xbgr.mr_n54309344)
print v(xbgr.mr_n54309664)
print v(xbgr.mr_n54309776)
print v(xbgr.mr_n54310096)
print v(xbgr.mr_n54310528)
print v(xbgr.mr_n54310640)
print v(xbgr.mr_n54310960)
print v(xbgr.mr_n54311072)
print v(xbgr.mr_n54311392)
print v(xbgr.mr_n54311504)
print v(xbgr.mr_n54311824)
print v(xbgr.mr_n54311936)
print v(xbgr.mr_n54312256)
print v(xbgr.mr_n54312368)
print v(xbgr.mr_n54312688)
print v(xbgr.mr_n54312800)
print v(xbgr.mr_n54313120)
print v(xbgr.mr_n54313232)
print v(xbgr.mr_n54313552)
print v(xbgr.mr_n54313664)
print v(xbgr.mr_n54313984)
print v(xbgr.mr_n54314096)
print v(xbgr.mr_n54314416)
print v(xbgr.mr_n54314528)
print v(xbgr.mr_n54314848)
print v(xbgr.mr_n54314960)
print v(xbgr.mr_n54315280)
print v(xbgr.mr_n54315392)
print v(xbgr.mr_n54315712)
print v(xbgr.mr_n54315824)
print v(xbgr.mr_n54316144)
print v(xbgr.mr_n54316256)
print v(xbgr.mr_n54316576)
print v(xbgr.mr_n54316688)
print v(xbgr.mr_n54317008)
print v(xbgr.mr_n54317120)
print v(xbgr.mr_n54317440)
print v(xbgr.mr_n54317552)
print v(xbgr.mr_n54317872)
print v(xbgr.mr_n54317984)
print v(xbgr.mr_n54318304)
print v(xbgr.mr_n54318848)
print v(xbgr.mr_n54319168)
print v(xbgr.mr_n54319280)
print v(xbgr.mr_n54319600)
print v(xbgr.mr_n54319712)
print v(xbgr.mr_n54320144)
print v(xbgr.mr_n54320576)
print v(xbgr.mr_n54321008)
print v(xbgr.mr_n54321440)
print v(xbgr.mr_n54321872)
print v(xbgr.mr_n54322304)
print v(xbgr.mr_n54322736)
print v(xbgr.mr_n54323168)
print v(xbgr.mr_n54323600)
print v(xbgr.mr_n54324032)
print v(xbgr.mr_n54324464)
print v(xbgr.mr_n54324896)
print v(xbgr.mr_n54325328)
print v(xbgr.mr_n54325760)
print v(xbgr.mr_n54326192)
print v(xbgr.mr_n54326624)
print v(xbgr.mr_n54327056)
print v(xbgr.mr_n54327488)
print v(xbgr.mr_n54327920)
print v(xbgr.mr_n54328352)
print v(xbgr.mr_n54328784)
print v(xbgr.mr_n54329216)
print v(xbgr.mr_n54329648)
print v(xbgr.mr_n54330080)
print v(xbgr.mr_n54330512)
print v(xbgr.mr_n54330944)
print v(xbgr.mr_n54331376)
print v(xbgr.mr_n54331808)
print v(xbgr.mr_n54332240)
print v(xbgr.mr_n54332672)
print v(xbgr.mr_n54333104)
print v(xbgr.mr_n54333536)
print v(xbgr.mr_n54333968)
print v(xbgr.mr_n54334400)
print v(xbgr.mr_n54334832)
print v(xbgr.mr_n54335264)
print v(xbgr.mr_n54335696)
print v(xbgr.mr_n54336128)
print v(xbgr.mr_n54336560)
print v(xbgr.mr_n54336992)
print v(xbgr.mr_n54337424)
print v(xbgr.mr_n54337856)
print v(xbgr.mr_n54338288)
print v(xbgr.mr_n54338720)
print v(xbgr.mr_n54339152)
print v(xbgr.mr_n54339584)
print v(xbgr.mr_n54340016)
print v(xbgr.mr_n54340448)
print v(xbgr.mr_n54340880)
print v(xbgr.mr_n54341312)
print v(xbgr.mr_n54341744)
print v(xbgr.mr_n54342176)
print v(xbgr.mr_n54342608)
print v(xbgr.mr_n54343040)
print v(xbgr.mr_n54343472)
print v(xbgr.mr_n54343904)
print v(xbgr.mr_n54344336)
print v(xbgr.mr_n54344768)
print v(xbgr.mr_n54345200)
print v(xbgr.mr_n54345632)
print v(xbgr.mr_n54346064)
print v(xbgr.mr_n54346496)
print v(xbgr.mr_n54346928)
print v(xbgr.mr_n54347360)
print v(xbgr.mr_n54347792)
print v(xbgr.mr_n54348224)
print v(xbgr.mr_n54348656)
print v(xbgr.mr_n54349088)
print v(xbgr.mr_n54349520)
print v(xbgr.mr_n54349952)
print v(xbgr.mr_n54350384)
print v(xbgr.mr_n54350816)
print v(xbgr.mr_n54351248)
print v(xbgr.mr_n54351680)
print v(xbgr.mr_n54352112)
print v(xbgr.mr_n54352544)
print v(xbgr.mr_n54352976)
print v(xbgr.mr_n54353408)
print v(xbgr.mr_n54353840)
print v(xbgr.mr_n54354272)
print v(xbgr.mr_n54354704)
print v(xbgr.mr_n54355136)
print v(xbgr.mr_n54355568)
print v(xbgr.mr_n54356000)
print v(xbgr.mr_n54356432)
print v(xbgr.mr_n54356864)
print v(xbgr.mr_n54357296)
print v(xbgr.mr_n54357728)
print v(xbgr.mr_n54358160)
print v(xbgr.mr_n54358592)
print v(xbgr.mr_n54359024)
print v(xbgr.mr_n54359456)
print v(xbgr.mr_n54359888)
print v(xbgr.mr_n54360320)
print v(xbgr.mr_n54360752)
print v(xbgr.mr_n54361184)
print v(xbgr.mr_n54361616)
print v(xbgr.mr_n54362048)
print v(xbgr.mr_n54362480)
print v(xbgr.mr_n54362912)
print v(xbgr.mr_n54363344)
print v(xbgr.mr_n54363776)
print v(xbgr.mr_n54364208)
print v(xbgr.mr_n54364640)
print v(xbgr.mr_n54365072)
print v(xbgr.mr_n54365392)
print v(xbgr.mr_n54365504)
print v(xbgr.mr_n54365824)
print v(xbgr.mr_n54365936)
print v(xbgr.mr_n54366256)
print v(xbgr.mr_n54366368)
print v(xbgr.mr_n54366688)
print v(xbgr.mr_n54366800)
print v(xbgr.mr_n54367120)
print v(xbgr.mr_n54367232)
print v(xbgr.mr_n54367552)
print v(xbgr.mr_n54367664)
print v(xbgr.mr_n54367984)
print v(xbgr.mr_n54368096)
print v(xbgr.mr_n54368416)
print v(xbgr.mr_n54368528)
print v(xbgr.mr_n54368848)
print v(xbgr.mr_n54368960)
print v(xbgr.mr_n54369280)
print v(xbgr.mr_n54369392)
print v(xbgr.mr_n54369712)
print v(xbgr.mr_n54369824)
print v(xbgr.mr_n54370144)
print v(xbgr.mr_n54370256)
print v(xbgr.mr_n54370576)
print v(xbgr.mr_n54370688)
print v(xbgr.mr_n54371008)
print v(xbgr.mr_n54371120)
print v(xbgr.mr_n54371440)
print v(xbgr.mr_n54371552)
print v(xbgr.mr_n54371872)
print v(xbgr.mr_n54371984)
print v(xbgr.mr_n54372304)
print v(xbgr.mr_n54372416)
print v(xbgr.mr_n54372736)
print v(xbgr.mr_n54372848)
print v(xbgr.mr_n54373168)
print v(xbgr.mr_n54373280)
print v(xbgr.mr_n54373600)
print v(xbgr.mr_n54373712)
print v(xbgr.mr_n54374032)
print v(xbgr.mr_n54374144)
print v(xbgr.mr_n54374464)
print v(xbgr.mr_n54374576)
print v(xbgr.mr_n54374896)
print v(xbgr.mr_n54375008)
print v(xbgr.mr_n54375328)
print v(xbgr.mr_n54375440)
print v(xbgr.mr_n54375760)
print v(xbgr.mr_n54375872)
print v(xbgr.mr_n54376192)
print v(xbgr.mr_n54376304)
print v(xbgr.mr_n54376624)
print v(xbgr.mr_n54376736)
print v(xbgr.mr_n54377056)
print v(xbgr.mr_n54377168)
print v(xbgr.mr_n54377488)
print v(xbgr.mr_n54377600)
print v(xbgr.mr_n54377920)
print v(xbgr.mr_n54378032)
print v(xbgr.mr_n54378352)
print v(xbgr.mr_n54378464)
print v(xbgr.mr_n54378784)
print v(xbgr.mr_n54378896)
print v(xbgr.mr_n54379216)
print v(xbgr.mr_n54379328)
print v(xbgr.mr_n54379648)
print v(xbgr.mr_n54379760)
print v(xbgr.mr_n54380080)
print v(xbgr.mr_n54380192)
print v(xbgr.mr_n54380512)
print v(xbgr.mr_n54380624)
print v(xbgr.mr_n54380944)
print v(xbgr.mr_n54381056)
print v(xbgr.mr_n54381376)
print v(xbgr.mr_n54381488)
print v(xbgr.mr_n54381808)
print v(xbgr.mr_n54381920)
print v(xbgr.mr_n54382240)
print v(xbgr.mr_n54382352)
print v(xbgr.mr_n54382672)
print v(xbgr.mr_n54382784)
print v(xbgr.mr_n54383104)
print v(xbgr.mr_n54383216)
print v(xbgr.mr_n54383536)
print v(xbgr.mr_n54383968)
print v(xbgr.mr_n54384080)
print v(xbgr.mr_n54384400)
print v(xbgr.mr_n54384512)
print v(xbgr.mr_n54384832)
print v(xbgr.mr_n54384944)
print v(xbgr.mr_n54385264)
print v(xbgr.mr_n54385376)
print v(xbgr.mr_n54385696)
print v(xbgr.mr_n54385808)
print v(xbgr.mr_n54386128)
print v(xbgr.mr_n54386240)
print v(xbgr.mr_n54386560)
print v(xbgr.mr_n54386672)
print v(xbgr.mr_n54386992)
print v(xbgr.mr_n54387104)
print v(xbgr.mr_n54387424)
print v(xbgr.mr_n54387536)
print v(xbgr.mr_n54387856)
print v(xbgr.mr_n54387968)
print v(xbgr.mr_n54388288)
print v(xbgr.mr_n54388400)
print v(xbgr.mr_n54388720)
print v(xbgr.mr_n54388832)
print v(xbgr.mr_n54389152)
print v(xbgr.mr_n54389264)
print v(xbgr.mr_n54389584)
print v(xbgr.mr_n54389696)
print v(xbgr.mr_n54390016)
print v(xbgr.mr_n54390128)
print v(xbgr.mr_n54390448)
print v(xbgr.mr_n54390560)
print v(xbgr.mr_n54390880)
print v(xbgr.mr_n54390992)
print v(xbgr.mr_n54391312)
print v(xbgr.mr_n54391424)
print v(xbgr.mr_n54391744)
print v(xbgr.mr_n54391856)
print v(xbgr.mr_n54392176)
print v(xbgr.mr_n54392288)
print v(xbgr.mr_n54392608)
print v(xbgr.mr_n54392720)
print v(xbgr.mr_n54393040)
print v(xbgr.mr_n54393152)
print v(xbgr.mr_n54393472)
print v(xbgr.mr_n54393584)
print v(xbgr.mr_n54393904)
print v(xbgr.mr_n54394016)
print v(xbgr.mr_n54394336)
print v(xbgr.mr_n54394448)
print v(xbgr.mr_n54394768)
print v(xbgr.mr_n54394880)
print v(xbgr.mr_n54395200)
print v(xbgr.mr_n54395312)
print v(xbgr.mr_n54395632)
print v(xbgr.mr_n54395744)
print v(xbgr.mr_n54396064)
print v(xbgr.mr_n54396176)
print v(xbgr.mr_n54396496)
print v(xbgr.mr_n54396608)
print v(xbgr.mr_n54396928)
print v(xbgr.mr_n54397040)
print v(xbgr.mr_n54397360)
print v(xbgr.mr_n54397472)
print v(xbgr.mr_n54397792)
print v(xbgr.mr_n54397904)
print v(xbgr.mr_n54398224)
print v(xbgr.mr_n54398336)
print v(xbgr.mr_n54398656)
print v(xbgr.mr_n54398768)
print v(xbgr.mr_n54399088)
print v(xbgr.mr_n54399200)
print v(xbgr.mr_n54399520)
print v(xbgr.mr_n54399632)
print v(xbgr.mr_n54399952)
print v(xbgr.mr_n54400064)
print v(xbgr.mr_n54400384)
print v(xbgr.mr_n54400496)
print v(xbgr.mr_n54400816)
print v(xbgr.mr_n54400928)
print v(xbgr.mr_n54401248)
print v(xbgr.mr_n54401360)
print v(xbgr.mr_n54401680)
print v(xbgr.mr_n54401792)
print v(xbgr.mr_n54402112)
print v(xbgr.mr_n54402224)
print v(xbgr.mr_n54402544)
print v(xbgr.mr_n54402656)
print v(xbgr.mr_n54402976)
print v(xbgr.mr_n54403088)
print v(xbgr.mr_n54403408)
print v(xbgr.mr_n54403520)
print v(xbgr.mr_n54403840)
print v(xbgr.mr_n54403952)
print v(xbgr.mr_n54404272)
print v(xbgr.mr_n54404384)
print v(xbgr.mr_n54404704)
print v(xbgr.mr_n54404816)
print v(xbgr.mr_n54405136)
print v(xbgr.mr_n54405248)
print v(xbgr.mr_n54405568)
print v(xbgr.mr_n54405680)
print v(xbgr.mr_n54406000)
print v(xbgr.mr_n54406112)
print v(xbgr.mr_n54406432)
print v(xbgr.mr_n54406544)
print v(xbgr.mr_n54406864)
print v(xbgr.mr_n54406976)
print v(xbgr.mr_n54407296)
print v(xbgr.mr_n54407408)
print v(xbgr.mr_n54407728)
print v(xbgr.mr_n54407840)
print v(xbgr.mr_n54408160)
print v(xbgr.mr_n54408272)
print v(xbgr.mr_n54408592)
print v(xbgr.mr_n54408704)
print v(xbgr.mr_n54409024)
print v(xbgr.mr_n54409136)
print v(xbgr.mr_n54409456)
print v(xbgr.mr_n54409568)
print v(xbgr.mr_n54409888)
print v(xbgr.mr_n54410000)
print v(xbgr.mr_n54410320)
print v(xbgr.mr_n54410432)
print v(xbgr.mr_n54410752)
print v(xbgr.mr_n54410864)
print v(xbgr.mr_n54411184)
print v(xbgr.mr_n54411296)
print v(xbgr.mr_n54411616)
print v(xbgr.mr_n54411728)
print v(xbgr.mr_n54412048)
print v(xbgr.mr_n54412160)
print v(xbgr.mr_n54412480)
print v(xbgr.mr_n54412592)
print v(xbgr.mr_n54412912)
print v(xbgr.mr_n54413024)
print v(xbgr.mr_n54413344)
print v(xbgr.mr_n54413456)
print v(xbgr.mr_n54413776)
print v(xbgr.mr_n54413888)
print v(xbgr.mr_n54414208)
print v(xbgr.mr_n54414320)
print v(xbgr.mr_n54414640)
print v(xbgr.mr_n54414752)
print v(xbgr.mr_n54415072)
print v(xbgr.mr_n54415184)
print v(xbgr.mr_n54415504)
print v(xbgr.mr_n54415616)
print v(xbgr.mr_n54415936)
print v(xbgr.mr_n54416048)
print v(xbgr.mr_n54416368)
print v(xbgr.mr_n54416480)
print v(xbgr.mr_n54416800)
print v(xbgr.mr_n54416912)
print v(xbgr.mr_n54417232)
print v(xbgr.mr_n54417344)
print v(xbgr.mr_n54417664)
print v(xbgr.mr_n54417776)
print v(xbgr.mr_n54418096)
print v(xbgr.mr_n54418208)
print v(xbgr.mr_n54418528)
print v(xbgr.mr_n54418640)
print v(xbgr.mr_n54418960)
print v(xbgr.mr_n54419072)
print v(xbgr.mr_n54419392)
print v(xbgr.mr_n54419504)
print v(xbgr.mr_n54419824)
print v(xbgr.mr_n54419936)
print v(xbgr.mr_n54420256)
print v(xbgr.mr_n54420368)
print v(xbgr.mr_n54420688)
print v(xbgr.mr_n54420800)
print v(xbgr.mr_n54421120)
print v(xbgr.mr_n54421232)
print v(xbgr.mr_n54421552)
print v(xbgr.mr_n54421664)
print v(xbgr.mr_n54421984)
print v(xbgr.mr_n54422096)
print v(xbgr.mr_n54422416)
print v(xbgr.mr_n54422528)
print v(xbgr.mr_n54422848)
print v(xbgr.mr_n54422960)
print v(xbgr.mr_n54423280)
print v(xbgr.mr_n54423392)
print v(xbgr.mr_n54423712)
print v(xbgr.mr_n54423824)
print v(xbgr.mr_n54424144)
print v(xbgr.mr_n54424256)
print v(xbgr.mr_n54424576)
print v(xbgr.mr_n54424688)
print v(xbgr.mr_n54425008)
print v(xbgr.mr_n54425120)
print v(xbgr.mr_n54425440)
print v(xbgr.mr_n54425552)
print v(xbgr.mr_n54425872)
print v(xbgr.mr_n54425984)
print v(xbgr.mr_n54426304)
print v(xbgr.mr_n54426416)
print v(xbgr.mr_n54426736)
print v(xbgr.mr_n54426848)
print v(xbgr.mr_n54427168)
print v(xbgr.mr_n54427280)
print v(xbgr.mr_n54427600)
print v(xbgr.mr_n54427712)
print v(xbgr.mr_n54428032)
print v(xbgr.mr_n54428144)
print v(xbgr.mr_n54428464)
print v(xbgr.mr_n54428576)
print v(xbgr.mr_n54428896)
print v(xbgr.mr_n54429008)
print v(xbgr.mr_n54429328)
print v(xbgr.mr_n54429440)
print v(xbgr.mr_n54429760)
print v(xbgr.mr_n54429872)
print v(xbgr.mr_n54430192)
print v(xbgr.mr_n54430304)
print v(xbgr.mr_n54430624)
print v(xbgr.mr_n54430736)
print v(xbgr.mr_n54431056)
print v(xbgr.mr_n54431168)
print v(xbgr.mr_n54431488)
print v(xbgr.mr_n54431600)
print v(xbgr.mr_n54431920)
print v(xbgr.mr_n54432032)
print v(xbgr.mr_n54432352)
print v(xbgr.mr_n54432464)
print v(xbgr.mr_n54432784)
print v(xbgr.mr_n54432896)
print v(xbgr.mr_n54433216)
print v(xbgr.mr_n54433328)
print v(xbgr.mr_n54433648)
print v(xbgr.mr_n54434080)
print v(xbgr.mr_n54434192)
print v(xbgr.mr_n54434512)
print v(xbgr.mr_n54434624)
print v(xbgr.mr_n54434944)
print v(xbgr.mr_n54435056)
print v(xbgr.mr_n54435376)
print v(xbgr.mr_n54435488)
print v(xbgr.mr_n54435808)
print v(xbgr.mr_n54435920)
print v(xbgr.mr_n54436240)
print v(xbgr.mr_n54436352)
print v(xbgr.mr_n54436672)
print v(xbgr.mr_n54436784)
print v(xbgr.mr_n54437104)
print v(xbgr.mr_n54437216)
print v(xbgr.mr_n54437536)
print v(xbgr.mr_n54437648)
print v(xbgr.mr_n54437968)
print v(xbgr.mr_n54438080)
print v(xbgr.mr_n54438400)
print v(xbgr.mr_n54438512)
print v(xbgr.mr_n54438832)
print v(xbgr.mr_n54438944)
print v(xbgr.mr_n54439264)
print v(xbgr.mr_n54439376)
print v(xbgr.mr_n54439696)
print v(xbgr.mr_n54439808)
print v(xbgr.mr_n54440128)
print v(xbgr.mr_n54440240)
print v(xbgr.mr_n54440560)
print v(xbgr.mr_n54440672)
print v(xbgr.mr_n54440992)
print v(xbgr.mr_n54441104)
print v(xbgr.mr_n54441424)
print v(xbgr.mr_n54441536)
print v(xbgr.mr_n54441856)
print v(xbgr.mr_n54441968)
print v(xbgr.mr_n54442288)
print v(xbgr.mr_n54442400)
print v(xbgr.mr_n54442720)
print v(xbgr.mr_n54442832)
print v(xbgr.mr_n54443152)
print v(xbgr.mr_n54443264)
print v(xbgr.mr_n54443584)
print v(xbgr.mr_n54443696)
print v(xbgr.mr_n54444016)
print v(xbgr.mr_n54444128)
print v(xbgr.mr_n54444448)
print v(xbgr.mr_n54444560)
print v(xbgr.mr_n54444880)
print v(xbgr.mr_n54444992)
print v(xbgr.mr_n54445312)
print v(xbgr.mr_n54445424)
print v(xbgr.mr_n54445744)
print v(xbgr.mr_n54445856)
print v(xbgr.mr_n54446176)
print v(xbgr.mr_n54446288)
print v(xbgr.mr_n54446608)
print v(xbgr.mr_n54446720)
print v(xbgr.mr_n54447040)
print v(xbgr.mr_n54447152)
print v(xbgr.mr_n54447472)
print v(xbgr.mr_n54447584)
print v(xbgr.mr_n54447904)
print v(xbgr.mr_n54448016)
print v(xbgr.mr_n54448336)
print v(xbgr.mr_n54448448)
print v(xbgr.mr_n54448768)
print v(xbgr.mr_n54448880)
print v(xbgr.mr_n54449200)
print v(xbgr.mr_n54449312)
print v(xbgr.mr_n54449632)
print v(xbgr.mr_n54449744)
print v(xbgr.mr_n54450064)
print v(xbgr.mr_n54450176)
print v(xbgr.mr_n54450496)
print v(xbgr.mr_n54450608)
print v(xbgr.mr_n54450928)
print v(xbgr.mr_n54451040)
print v(xbgr.mr_n54451360)
print v(xbgr.mr_n54451472)
print v(xbgr.mr_n54451792)
print v(xbgr.mr_n54451904)
print v(xbgr.mr_n54452224)
print v(xbgr.mr_n54452336)
print v(xbgr.mr_n54452656)
print v(xbgr.mr_n54452768)
print v(xbgr.mr_n54453088)
print v(xbgr.mr_n54453200)
print v(xbgr.mr_n54453520)
print v(xbgr.mr_n54453632)
print v(xbgr.mr_n54453952)
print v(xbgr.mr_n54454064)
print v(xbgr.mr_n54454384)
print v(xbgr.mr_n54454816)
print v(xbgr.mr_n54454928)
print v(xbgr.mr_n54455248)
print v(xbgr.mr_n54455360)
print v(xbgr.mr_n54455680)
print v(xbgr.mr_n54455792)
print v(xbgr.mr_n54456112)
print v(xbgr.mr_n54456224)
print v(xbgr.mr_n54456544)
print v(xbgr.mr_n54456656)
print v(xbgr.mr_n54456976)
print v(xbgr.mr_n54457088)
print v(xbgr.mr_n54457520)
print v(xbgr.mr_n54457952)
print v(xbgr.mr_n54458272)
print v(xbgr.mr_n54458384)
print v(xbgr.mr_n54458704)
print v(xbgr.mr_n54458816)
print v(xbgr.mr_n54459136)
print v(xbgr.mr_n54459248)
print v(xbgr.mr_n54459568)
print v(xbgr.mr_n54459680)
print v(xbgr.mr_n54460000)
print v(xbgr.mr_n54460112)
print v(xbgr.mr_n54460432)
print v(xbgr.mr_n54460544)
print v(xbgr.mr_n54460864)
print v(xbgr.mr_n54460976)
print v(xbgr.mr_n54461296)
print v(xbgr.mr_n54461408)
print v(xbgr.mr_n54461728)
print v(xbgr.mr_n54461840)
print v(xbgr.mr_n54462160)
print v(xbgr.mr_n54462272)
print v(xbgr.mr_n54462592)
print v(xbgr.mr_n54462704)
print v(xbgr.mr_n54463024)
print v(xbgr.mr_n54463136)
print v(xbgr.mr_n54463456)
print v(xbgr.mr_n54463568)
print v(xbgr.mr_n54463888)
print v(xbgr.mr_n54464000)
print v(xbgr.mr_n54464320)
print v(xbgr.mr_n54464432)
print v(xbgr.mr_n54464752)
print v(xbgr.mr_n54464864)
print v(xbgr.mr_n54465184)
print v(xbgr.mr_n54465296)
print v(xbgr.mr_n54465616)
print v(xbgr.mr_n54465728)
print v(xbgr.mr_n54466048)
print v(xbgr.mr_n54466160)
print v(xbgr.mr_n54466480)
print v(xbgr.mr_n54466592)
print v(xbgr.mr_n54466912)
print v(xbgr.mr_n54467024)
print v(xbgr.mr_n54467344)
print v(xbgr.mr_n54467456)
print v(xbgr.mr_n54467776)
print v(xbgr.mr_n54467888)
print v(xbgr.mr_n54468208)
print v(xbgr.mr_n54468320)
print v(xbgr.mr_n54468640)
print v(xbgr.mr_n54468752)
print v(xbgr.mr_n54469072)
print v(xbgr.mr_n54469184)
print v(xbgr.mr_n54469504)
print v(xbgr.mr_n54469616)
print v(xbgr.mr_n54469936)
print v(xbgr.mr_n54470048)
print v(xbgr.mr_n54470368)
print v(xbgr.mr_n54470480)
print v(xbgr.mr_n54470800)
print v(xbgr.mr_n54470912)
print v(xbgr.mr_n54471232)
print v(xbgr.mr_n54471344)
print v(xbgr.mr_n54471664)
print v(xbgr.mr_n54471776)
print v(xbgr.mr_n54472096)
print v(xbgr.mr_n54472208)
print v(xbgr.mr_n54472528)
print v(xbgr.mr_n54472640)
print v(xbgr.mr_n54472960)
print v(xbgr.mr_n54473072)
print v(xbgr.mr_n54473392)
print v(xbgr.mr_n54473504)
print v(xbgr.mr_n54473824)
print v(xbgr.mr_n54473936)
print v(xbgr.mr_n54474256)
print v(xbgr.mr_n54474368)
print v(xbgr.mr_n54474688)
print v(xbgr.mr_n54474800)
print v(xbgr.mr_n54475120)
print v(xbgr.mr_n54475232)
print v(xbgr.mr_n54475552)
print v(xbgr.mr_n54475664)
print v(xbgr.mr_n54475984)
print v(xbgr.mr_n54476096)
print v(xbgr.mr_n54476416)
print v(xbgr.mr_n54476528)
print v(xbgr.mr_n54476848)
print v(xbgr.mr_n54476960)
print v(xbgr.mr_n54477280)
print v(xbgr.mr_n54477392)
print v(xbgr.mr_n54477712)
print v(xbgr.mr_n54477824)
print v(xbgr.mr_n54478144)
print v(xbgr.mr_n54478256)
print v(xbgr.mr_n54478576)
print v(xbgr.mr_n54478688)
print v(xbgr.mr_n54479008)
print v(xbgr.mr_n54479120)
print v(xbgr.mr_n54479440)
print v(xbgr.mr_n54479552)
print v(xbgr.mr_n54479872)
print v(xbgr.mr_n54479984)
print v(xbgr.mr_n54480304)
print v(xbgr.mr_n54480416)
print v(xbgr.mr_n54480736)
print v(xbgr.mr_n54480848)
print v(xbgr.mr_n54481168)
print v(xbgr.mr_n54481280)
print v(xbgr.mr_n54481600)
print v(xbgr.mr_n54481712)
print v(xbgr.mr_n54482032)
print v(xbgr.mr_n54482144)
print v(xbgr.mr_n54482464)
print v(xbgr.mr_n54482576)
print v(xbgr.mr_n54482896)
print v(xbgr.mr_n54483008)
print v(xbgr.mr_n54483328)
print v(xbgr.mr_n54483440)
print v(xbgr.mr_n54483760)
print v(xbgr.mr_n54483872)
print v(xbgr.mr_n54484192)
print v(xbgr.mr_n54484304)
print v(xbgr.mr_n54484624)
print v(xbgr.mr_n54484736)
print v(xbgr.mr_n54485056)
print v(xbgr.mr_n54485168)
print v(xbgr.mr_n54485488)
print v(xbgr.mr_n54485600)
print v(xbgr.mr_n54485920)
print v(xbgr.mr_n54486032)
print v(xbgr.mr_n54486352)
print v(xbgr.mr_n54486464)
print v(xbgr.mr_n54486784)
print v(xbgr.mr_n54486896)
print v(xbgr.mr_n54487216)
print v(xbgr.mr_n54487328)
print v(xbgr.mr_n54487648)
print v(xbgr.mr_n54487760)
print v(xbgr.mr_n54488080)
print v(xbgr.mr_n54488192)
print v(xbgr.mr_n54488512)
print v(xbgr.mr_n54488624)
print v(xbgr.mr_n54488944)
print v(xbgr.mr_n54489056)
print v(xbgr.mr_n54489376)
print v(xbgr.mr_n54489488)
print v(xbgr.mr_n54489808)
print v(xbgr.mr_n54489920)
print v(xbgr.mr_n54490240)
print v(xbgr.mr_n54490352)
print v(xbgr.mr_n54490672)
print v(xbgr.mr_n54490784)
print v(xbgr.mr_n54491104)
print v(xbgr.mr_n54491216)
print v(xbgr.mr_n54491536)
print v(xbgr.mr_n54491648)
print v(xbgr.mr_n54491968)
print v(xbgr.mr_n54492080)
print v(xbgr.mr_n54492400)
print v(xbgr.mr_n54492512)
print v(xbgr.mr_n54492832)
print v(xbgr.mr_n54492944)
print v(xbgr.mr_n54493264)
print v(xbgr.mr_n54493376)
print v(xbgr.mr_n54493696)
print v(xbgr.mr_n54493808)
print v(xbgr.mr_n54494128)
print v(xbgr.mr_n54494240)
print v(xbgr.mr_n54494560)
print v(xbgr.mr_n54494672)
print v(xbgr.mr_n54494992)
print v(xbgr.mr_n54495104)
print v(xbgr.mr_n54495424)
print v(xbgr.mr_n54495536)
print v(xbgr.mr_n54495856)
print v(xbgr.mr_n54495968)
print v(xbgr.mr_n54496288)
print v(xbgr.mr_n54496400)
print v(xbgr.mr_n54496720)
print v(xbgr.mr_n54496832)
print v(xbgr.mr_n54497152)
print v(xbgr.mr_n54497264)
print v(xbgr.mr_n54497584)
print v(xbgr.mr_n54497696)
print v(xbgr.mr_n54498016)
print v(xbgr.mr_n54498128)
print v(xbgr.mr_n54498448)
print v(xbgr.mr_n54498560)
print v(xbgr.mr_n54498880)
print v(xbgr.mr_n54498992)
print v(xbgr.mr_n54499312)
print v(xbgr.mr_n54499424)
print v(xbgr.mr_n54499744)
print v(xbgr.mr_n54499856)
print v(xbgr.mr_n54500176)
print v(xbgr.mr_n54500288)
print v(xbgr.mr_n54500608)
print v(xbgr.mr_n54500720)
print v(xbgr.mr_n54501040)
print v(xbgr.mr_n54501152)
print v(xbgr.mr_n54501472)
print v(xbgr.mr_n54501584)
print v(xbgr.mr_n54501904)
print v(xbgr.mr_n54502016)
print v(xbgr.mr_n54502336)
print v(xbgr.mr_n54502448)
print v(xbgr.mr_n54502768)
print v(xbgr.mr_n54502880)
print v(xbgr.mr_n54503200)
print v(xbgr.mr_n54503312)
print v(xbgr.mr_n54503632)
print v(xbgr.mr_n54503744)
print v(xbgr.mr_n54504064)
print v(xbgr.mr_n54504176)
print v(xbgr.mr_n54504496)
print v(xbgr.mr_n54504608)
print v(xbgr.mr_n54504928)
print v(xbgr.mr_n54505040)
print v(xbgr.mr_n54505360)
print v(xbgr.mr_n54505472)
print v(xbgr.mr_n54505792)
print v(xbgr.mr_n54505904)
print v(xbgr.mr_n54506224)
print v(xbgr.mr_n54506336)
print v(xbgr.mr_n54506656)
print v(xbgr.mr_n54506768)
print v(xbgr.mr_n54507088)
print v(xbgr.mr_n54507200)
print v(xbgr.mr_n54507520)
print v(xbgr.mr_n54507632)
print v(xbgr.mr_n54507952)
print v(xbgr.mr_n54508064)
print v(xbgr.mr_n54508384)
print v(xbgr.mr_n54508496)
print v(xbgr.mr_n54508816)
print v(xbgr.mr_n54508928)
print v(xbgr.mr_n54509248)
print v(xbgr.mr_n54509360)
print v(xbgr.mr_n54509680)
print v(xbgr.mr_n54509792)
print v(xbgr.mr_n54510112)
print v(xbgr.mr_n54510224)
print v(xbgr.mr_n54510544)
print v(xbgr.mr_n54510656)
print v(xbgr.mr_n54510976)
print v(xbgr.mr_n54511088)
print v(xbgr.mr_n54511408)
print v(xbgr.mr_n54511520)
print v(xbgr.mr_n54511840)
print v(xbgr.mr_n54511952)
print v(xbgr.mr_n54512272)
print v(xbgr.mr_n54512384)
print v(xbgr.mr_n54512704)
print v(xbgr.mr_n54512816)
print v(xbgr.mr_n54513136)
print v(xbgr.mr_n54513248)
print v(xbgr.mr_n54513568)
print v(xbgr.mr_n54513680)
print v(xbgr.mr_n54514112)
print v(xbgr.mr_n54514544)
print v(xbgr.mr_n54514976)
print v(xbgr.mr_n54515408)
print v(xbgr.mr_n54515840)
print v(xbgr.mr_n54516272)
print v(xbgr.mr_n54516704)
print v(xbgr.mr_n54517136)
print v(xbgr.mr_n54517568)
print v(xbgr.mr_n54518000)
print v(xbgr.mr_n54518432)
print v(xbgr.mr_n54518864)
print v(xbgr.mr_n54519296)
print v(xbgr.mr_n54519728)
print v(xbgr.mr_n54520160)
print v(xbgr.mr_n54520592)
print v(xbgr.mr_n54521024)
print v(xbgr.mr_n54521456)
print v(xbgr.mr_n54521888)
print v(xbgr.mr_n54522320)
print v(xbgr.mr_n54522752)
print v(xbgr.mr_n54523184)
print v(xbgr.mr_n54523616)
print v(xbgr.mr_n54524048)
print v(xbgr.mr_n54524480)
print v(xbgr.mr_n54524912)
print v(xbgr.mr_n54525344)
print v(xbgr.mr_n54525776)
print v(xbgr.mr_n54526208)
print v(xbgr.mr_n54526640)
print v(xbgr.mr_n54527072)
print v(xbgr.mr_n54527504)
print v(xbgr.mr_n54527936)
print v(xbgr.mr_n54528368)
print v(xbgr.mr_n54528800)
print v(xbgr.mr_n54529232)
print v(xbgr.mr_n54529664)
print v(xbgr.mr_n54530096)
print v(xbgr.mr_n54530528)
print v(xbgr.mr_n54530960)
print v(xbgr.mr_n54531392)
print v(xbgr.mr_n54531824)
print v(xbgr.mr_n54532256)
print v(xbgr.mr_n54532688)
print v(xbgr.mr_n54533120)
print v(xbgr.mr_n54533552)
print v(xbgr.mr_n54533984)
print v(xbgr.mr_n54534416)
print v(xbgr.mr_n54534848)
print v(xbgr.mr_n54535280)
print v(xbgr.mr_n54535712)
print v(xbgr.mr_n54536144)
print v(xbgr.mr_n54536576)
print v(xbgr.mr_n54537008)
print v(xbgr.mr_n54537440)
print v(xbgr.mr_n54537872)
print v(xbgr.mr_n54538304)
print v(xbgr.mr_n54538736)
print v(xbgr.mr_n54539168)
print v(xbgr.mr_n54539600)
print v(xbgr.mr_n54540032)
print v(xbgr.mr_n54540464)
print v(xbgr.mr_n54540896)
print v(xbgr.mr_n54541328)
print v(xbgr.mr_n54541760)
print v(xbgr.mr_n54542192)
print v(xbgr.mr_n54542624)
print v(xbgr.mr_n54543056)
print v(xbgr.mr_n54543488)
print v(xbgr.mr_n54543920)
print v(xbgr.mr_n54544352)
print v(xbgr.mr_n54544784)
print v(xbgr.mr_n54545216)
print v(xbgr.mr_n54545648)
print v(xbgr.mr_n54546080)
print v(xbgr.mr_n54546512)
print v(xbgr.mr_n54546944)
print v(xbgr.mr_n54547376)
print v(xbgr.mr_n54547808)
print v(xbgr.mr_n54548240)
print v(xbgr.mr_n54548672)
print v(xbgr.mr_n54549104)
print v(xbgr.mr_n54549536)
print v(xbgr.mr_n54549968)
print v(xbgr.mr_n54550400)
print v(xbgr.mr_n54550832)
print v(xbgr.mr_n54551264)
print v(xbgr.mr_n54551696)
print v(xbgr.mr_n54552128)
print v(xbgr.mr_n54552560)
print v(xbgr.mr_n54552992)
print v(xbgr.mr_n54553424)
print v(xbgr.mr_n54553856)
print v(xbgr.mr_n54554288)
print v(xbgr.mr_n54554720)
print v(xbgr.mr_n54555152)
print v(xbgr.mr_n54555584)
print v(xbgr.mr_n54556016)
print v(xbgr.mr_n54556336)
print v(xbgr.mr_n54556448)
print v(xbgr.mr_n54556768)
print v(xbgr.mr_n54556880)
print v(xbgr.mr_n54557200)
print v(xbgr.mr_n54557312)
print v(xbgr.mr_n54557632)
print v(xbgr.mr_n54557744)
print v(xbgr.mr_n54558064)
print v(xbgr.mr_n54558176)
print v(xbgr.mr_n54558496)
print v(xbgr.mr_n54558608)
print v(xbgr.mr_n54558928)
print v(xbgr.mr_n54559040)
print v(xbgr.mr_n54559360)
print v(xbgr.mr_n54559472)
print v(xbgr.mr_n54559792)
print v(xbgr.mr_n54559904)
print v(xbgr.mr_n54560224)
print v(xbgr.mr_n54560336)
print v(xbgr.mr_n54560656)
print v(xbgr.mr_n54560768)
print v(xbgr.mr_n54561088)
print v(xbgr.mr_n54561200)
print v(xbgr.mr_n54561520)
print v(xbgr.mr_n54561632)
print v(xbgr.mr_n54561952)
print v(xbgr.mr_n54562064)
print v(xbgr.mr_n54562384)
print v(xbgr.mr_n54562496)
print v(xbgr.mr_n54562816)
print v(xbgr.mr_n54562928)
print v(xbgr.mr_n54563248)
print v(xbgr.mr_n54563360)
print v(xbgr.mr_n54563680)
print v(xbgr.mr_n54563792)
print v(xbgr.mr_n54564112)
print v(xbgr.mr_n54564224)
print v(xbgr.mr_n54564544)
print v(xbgr.mr_n54564656)
print v(xbgr.mr_n54564976)
print v(xbgr.mr_n54565088)
print v(xbgr.mr_n54565408)
print v(xbgr.mr_n54565520)
print v(xbgr.mr_n54565840)
print v(xbgr.mr_n54565952)
print v(xbgr.mr_n54566272)
print v(xbgr.mr_n54566384)
print v(xbgr.mr_n54566704)
print v(xbgr.mr_n54566816)
print v(xbgr.mr_n54567136)
print v(xbgr.mr_n54567248)
print v(xbgr.mr_n54567568)
print v(xbgr.mr_n54567680)
print v(xbgr.mr_n54568000)
print v(xbgr.mr_n54568112)
print v(xbgr.mr_n54568432)
print v(xbgr.mr_n54568544)
print v(xbgr.mr_n54568864)
print v(xbgr.mr_n54568976)
print v(xbgr.mr_n54569296)
print v(xbgr.mr_n54569408)
print v(xbgr.mr_n54569728)
print v(xbgr.mr_n54569840)
print v(xbgr.mr_n54570160)
print v(xbgr.mr_n54570272)
print v(xbgr.mr_n54570592)
print v(xbgr.mr_n54570704)
print v(xbgr.mr_n54571024)
print v(xbgr.mr_n54571136)
print v(xbgr.mr_n54571456)
print v(xbgr.mr_n54571568)
print v(xbgr.mr_n54571888)
print v(xbgr.mr_n54572000)
print v(xbgr.mr_n54572320)
print v(xbgr.mr_n54572432)
print v(xbgr.mr_n54572752)
print v(xbgr.mr_n54572864)
print v(xbgr.mr_n54573184)
print v(xbgr.mr_n54573296)
print v(xbgr.mr_n54573616)
print v(xbgr.mr_n54573728)
print v(xbgr.mr_n54574048)
print v(xbgr.mr_n54574160)
print v(xbgr.mr_n54574480)
print v(xbgr.mr_n54574592)
print v(xbgr.mr_n54574912)
print v(xbgr.mr_n54575024)
print v(xbgr.mr_n54575344)
print v(xbgr.mr_n54575456)
print v(xbgr.mr_n54575776)
print v(xbgr.mr_n54575888)
print v(xbgr.mr_n54576208)
print v(xbgr.mr_n54576320)
print v(xbgr.mr_n54576640)
print v(xbgr.mr_n54576752)
print v(xbgr.mr_n54577072)
print v(xbgr.mr_n54577184)
print v(xbgr.mr_n54577504)
print v(xbgr.mr_n54577616)
print v(xbgr.mr_n54577936)
print v(xbgr.mr_n54578048)
print v(xbgr.mr_n54578368)
print v(xbgr.mr_n54578480)
print v(xbgr.mr_n54578800)
print v(xbgr.mr_n54578912)
print v(xbgr.mr_n54579232)
print v(xbgr.mr_n54579344)
print v(xbgr.mr_n54579664)
print v(xbgr.mr_n54579776)
print v(xbgr.mr_n54580096)
print v(xbgr.mr_n54580208)
print v(xbgr.mr_n54580528)
print v(xbgr.mr_n54580640)
print v(xbgr.mr_n54580960)
print v(xbgr.mr_n54581072)
print v(xbgr.mr_n54581392)
print v(xbgr.mr_n54581504)
print v(xbgr.mr_n54581824)
print v(xbgr.mr_n54581936)
print v(xbgr.mr_n54582256)
print v(xbgr.mr_n54582368)
print v(xbgr.mr_n54582688)
print v(xbgr.mr_n54582800)
print v(xbgr.mr_n54583120)
print v(xbgr.mr_n54583232)
print v(xbgr.mr_n54583552)
print v(xbgr.mr_n54583664)
print v(xbgr.mr_n54583984)
print v(xbgr.mr_n54584096)
print v(xbgr.mr_n54584416)
print v(xbgr.mr_n54584528)
print v(xbgr.mr_n54584848)
print v(xbgr.mr_n54584960)
print v(xbgr.mr_n54585280)
print v(xbgr.mr_n54585392)
print v(xbgr.mr_n54585712)
print v(xbgr.mr_n54585824)
print v(xbgr.mr_n54586144)
print v(xbgr.mr_n54586256)
print v(xbgr.mr_n54586576)
print v(xbgr.mr_n54586688)
print v(xbgr.mr_n54587008)
print v(xbgr.mr_n54587120)
print v(xbgr.mr_n54587440)
print v(xbgr.mr_n54587552)
print v(xbgr.mr_n54587872)
print v(xbgr.mr_n54587984)
print v(xbgr.mr_n54588304)
print v(xbgr.mr_n54588416)
print v(xbgr.mr_n54588736)
print v(xbgr.mr_n54588848)
print v(xbgr.mr_n54589168)
print v(xbgr.mr_n54589280)
print v(xbgr.mr_n54589600)
print v(xbgr.mr_n54589712)
print v(xbgr.mr_n54590032)
print v(xbgr.mr_n54590144)
print v(xbgr.mr_n54590464)
print v(xbgr.mr_n54590576)
print v(xbgr.mr_n54590896)
print v(xbgr.mr_n54591008)
print v(xbgr.mr_n54591328)
print v(xbgr.mr_n54591440)
print v(xbgr.mr_n54591760)
print v(xbgr.mr_n54591872)
print v(xbgr.mr_n54592192)
print v(xbgr.mr_n54592304)
print v(xbgr.mr_n54592624)
print v(xbgr.mr_n54592736)
print v(xbgr.mr_n54593056)
print v(xbgr.mr_n54593168)
print v(xbgr.mr_n54593488)
print v(xbgr.mr_n54593600)
print v(xbgr.mr_n54593920)
print v(xbgr.mr_n54594032)
print v(xbgr.mr_n54594352)
print v(xbgr.mr_n54594464)
print v(xbgr.mr_n54594784)
print v(xbgr.mr_n54594896)
print v(xbgr.mr_n54595216)
print v(xbgr.mr_n54595328)
print v(xbgr.mr_n54595648)
print v(xbgr.mr_n54595760)
print v(xbgr.mr_n54596080)
print v(xbgr.mr_n54596192)
print v(xbgr.mr_n54596512)
print v(xbgr.mr_n54596624)
print v(xbgr.mr_n54596944)
print v(xbgr.mr_n54597056)
print v(xbgr.mr_n54597376)
print v(xbgr.mr_n54597488)
print v(xbgr.mr_n54597808)
print v(xbgr.mr_n54597920)
print v(xbgr.mr_n54598240)
print v(xbgr.mr_n54598352)
print v(xbgr.mr_n54598672)
print v(xbgr.mr_n54598784)
print v(xbgr.mr_n54599104)
print v(xbgr.mr_n54599216)
print v(xbgr.mr_n54599536)
print v(xbgr.mr_n54599648)
print v(xbgr.mr_n54599968)
print v(xbgr.mr_n54600080)
print v(xbgr.mr_n54600400)
print v(xbgr.mr_n54600512)
print v(xbgr.mr_n54600832)
print v(xbgr.mr_n54600944)
print v(xbgr.mr_n54601264)
print v(xbgr.mr_n54601376)
print v(xbgr.mr_n54601696)
print v(xbgr.mr_n54601808)
print v(xbgr.mr_n54602128)
print v(xbgr.mr_n54602240)
print v(xbgr.mr_n54602560)
print v(xbgr.mr_n54602672)
print v(xbgr.mr_n54602992)
print v(xbgr.mr_n54603104)
print v(xbgr.mr_n54603424)
print v(xbgr.mr_n54603536)
print v(xbgr.mr_n54603856)
print v(xbgr.mr_n54603968)
print v(xbgr.mr_n54604288)
print v(xbgr.mr_n54604400)
print v(xbgr.mr_n54604720)
print v(xbgr.mr_n54604832)
print v(xbgr.mr_n54605152)
print v(xbgr.mr_n54605264)
print v(xbgr.mr_n54605584)
print v(xbgr.mr_n54605696)
print v(xbgr.mr_n54606016)
print v(xbgr.mr_n54606128)
print v(xbgr.mr_n54606448)
print v(xbgr.mr_n54606560)
print v(xbgr.mr_n54606880)
print v(xbgr.mr_n54606992)
print v(xbgr.mr_n54607312)
print v(xbgr.mr_n54607424)
print v(xbgr.mr_n54607744)
print v(xbgr.mr_n54607856)
print v(xbgr.mr_n54608176)
print v(xbgr.mr_n54608288)
print v(xbgr.mr_n54608608)
print v(xbgr.mr_n54608720)
print v(xbgr.mr_n54609040)
print v(xbgr.mr_n54609152)
print v(xbgr.mr_n54609472)
print v(xbgr.mr_n54609584)
print v(xbgr.mr_n54609904)
print v(xbgr.mr_n54610016)
print v(xbgr.mr_n54610336)
print v(xbgr.mr_n54610448)
print v(xbgr.mr_n54610768)
print v(xbgr.mr_n54610880)
print v(xbgr.mr_n54611200)
print v(xbgr.mr_n54611312)
print v(xbgr.mr_n54611632)
print v(xbgr.mr_n54611744)
print v(xbgr.mr_n54612064)
print v(xbgr.mr_n54612176)
print v(xbgr.mr_n54612496)
print v(xbgr.mr_n54612608)
print v(xbgr.mr_n54612928)
print v(xbgr.mr_n54613040)
print v(xbgr.mr_n54613360)
print v(xbgr.mr_n54613472)
print v(xbgr.mr_n54613792)
print v(xbgr.mr_n54613904)
print v(xbgr.mr_n54614224)
print v(xbgr.mr_n54614336)
print v(xbgr.mr_n54614656)
print v(xbgr.mr_n54614768)
print v(xbgr.mr_n54615088)
print v(xbgr.mr_n54615200)
print v(xbgr.mr_n54615520)
print v(xbgr.mr_n54615632)
print v(xbgr.mr_n54615952)
print v(xbgr.mr_n54616064)
print v(xbgr.mr_n54616384)
print v(xbgr.mr_n54616496)
print v(xbgr.mr_n54616816)
print v(xbgr.mr_n54616928)
print v(xbgr.mr_n54617248)
print v(xbgr.mr_n54617360)
print v(xbgr.mr_n54617680)
print v(xbgr.mr_n54617792)
print v(xbgr.mr_n54618112)
print v(xbgr.mr_n54618224)
print v(xbgr.mr_n54618544)
print v(xbgr.mr_n54618656)
print v(xbgr.mr_n54618976)
print v(xbgr.mr_n54619088)
print v(xbgr.mr_n54619520)
print v(xbgr.mr_n54619952)
print v(xbgr.mr_n54620384)
print v(xbgr.mr_n54620816)
print v(xbgr.mr_n54621248)
print v(xbgr.mr_n54621680)
print v(xbgr.mr_n54622112)
print v(xbgr.mr_n54622544)
print v(xbgr.mr_n54622976)
print v(xbgr.mr_n54623408)
print v(xbgr.mr_n54623840)
print v(xbgr.mr_n54624272)
print v(xbgr.mr_n54624704)
print v(xbgr.mr_n54625136)
print v(xbgr.mr_n54625568)
print v(xbgr.mr_n54626000)
print v(xbgr.mr_n54626432)
print v(xbgr.mr_n54626864)
print v(xbgr.mr_n54627296)
print v(xbgr.mr_n54627728)
print v(xbgr.mr_n54628160)
print v(xbgr.mr_n54628592)
print v(xbgr.mr_n54629024)
print v(xbgr.mr_n54629456)
print v(xbgr.mr_n54629888)
print v(xbgr.mr_n54630320)
print v(xbgr.mr_n54630752)
print v(xbgr.mr_n54631184)
print v(xbgr.mr_n54631616)
print v(xbgr.mr_n54632048)
print v(xbgr.mr_n54632480)
print v(xbgr.mr_n54632912)
print v(xbgr.mr_n54633344)
print v(xbgr.mr_n54633776)
print v(xbgr.mr_n54634208)
print v(xbgr.mr_n54634640)
print v(xbgr.mr_n54635072)
print v(xbgr.mr_n54635504)
print v(xbgr.mr_n54635936)
print v(xbgr.mr_n54636368)
print v(xbgr.mr_n54636800)
print v(xbgr.mr_n54637232)
print v(xbgr.mr_n54637664)
print v(xbgr.mr_n54638096)
print v(xbgr.mr_n54638528)
print v(xbgr.mr_n54638960)
print v(xbgr.mr_n54639392)
print v(xbgr.mr_n54639824)
print v(xbgr.mr_n54640256)
print v(xbgr.mr_n54640688)
print v(xbgr.mr_n54641120)
print v(xbgr.mr_n54641552)
print v(xbgr.mr_n54641984)
print v(xbgr.mr_n54642416)
print v(xbgr.mr_n54642848)
print v(xbgr.mr_n54643280)
print v(xbgr.mr_n54643712)
print v(xbgr.mr_n54644144)
print v(xbgr.mr_n54644576)
print v(xbgr.mr_n54645008)
print v(xbgr.mr_n54645440)
print v(xbgr.mr_n54645872)
print v(xbgr.mr_n54646304)
print v(xbgr.mr_n54646736)
print v(xbgr.mr_n54647168)
print v(xbgr.mr_n54647600)
print v(xbgr.mr_n54648032)
print v(xbgr.mr_n54648464)
print v(xbgr.mr_n54648896)
print v(xbgr.mr_n54649328)
print v(xbgr.mr_n54649760)
print v(xbgr.mr_n54650192)
print v(xbgr.mr_n54650624)
print v(xbgr.mr_n54651056)
print v(xbgr.mr_n54651488)
print v(xbgr.mr_n54651920)
print v(xbgr.mr_n54652352)
print v(xbgr.mr_n54652784)
print v(xbgr.mr_n54653216)
print v(xbgr.mr_n54653648)
print v(xbgr.mr_n54654080)
print v(xbgr.mr_n54654512)
print v(xbgr.mr_n54654944)
print v(xbgr.mr_n54655376)
print v(xbgr.mr_n54655808)
print v(xbgr.mr_n54656240)
print v(xbgr.mr_n54656672)
print v(xbgr.mr_n54657104)
print v(xbgr.mr_n54657536)
print v(xbgr.mr_n54657968)
print v(xbgr.mr_n54658400)
print v(xbgr.mr_n54658832)
print v(xbgr.mr_n54659264)
print v(xbgr.mr_n54659696)
print v(xbgr.mr_n54660128)
print v(xbgr.mr_n54660560)
print v(xbgr.mr_n54660992)
print v(xbgr.mr_n54661424)
print v(xbgr.mr_n54661856)
print v(xbgr.mr_n54662288)
print v(xbgr.mr_n54662720)
print v(xbgr.mr_n54663152)
print v(xbgr.mr_n54663584)
print v(xbgr.mr_n54664016)
print v(xbgr.mr_n54664448)
print v(xbgr.mr_n54664880)
print v(xbgr.mr_n54665312)
print v(xbgr.mr_n54665744)
print v(xbgr.mr_n54666176)
print v(xbgr.mr_n54666608)
print v(xbgr.mr_n54667040)
print v(xbgr.mr_n54667472)
print v(xbgr.mr_n54667904)
print v(xbgr.mr_n54668336)
print v(xbgr.mr_n54668768)
print v(xbgr.mr_n54669200)
print v(xbgr.mr_n54669632)
print v(xbgr.mr_n54670064)
print v(xbgr.mr_n54670496)
print v(xbgr.mr_n54670928)
print v(xbgr.mr_n54671360)
print v(xbgr.mr_n54671792)
print v(xbgr.mr_n54672224)
print v(xbgr.mr_n54672656)
print v(xbgr.mr_n54673088)
print v(xbgr.mr_n54673520)
print v(xbgr.mr_n54673952)
print v(xbgr.mr_n54674384)
print v(xbgr.mr_n54674816)
print v(xbgr.mr_n54675248)
print v(xbgr.mr_n54675680)
print v(xbgr.mr_n54676112)
print v(xbgr.mr_n54676544)
print v(xbgr.mr_n54676976)
print v(xbgr.mr_n54677408)
print v(xbgr.mr_n54677840)
print v(xbgr.mr_n54678272)
print v(xbgr.mr_n54678704)
print v(xbgr.mr_n54679136)
print v(xbgr.mr_n54679568)
print v(xbgr.mr_n54680000)
print v(xbgr.mr_n54680432)
print v(xbgr.mr_n54680864)
print v(xbgr.mr_n54681296)
print v(xbgr.mr_n54681728)
print v(xbgr.mr_n54682160)
print v(xbgr.mr_n54682592)
print v(xbgr.mr_n54683024)
print v(xbgr.mr_n54683456)
print v(xbgr.mr_n54683888)
print v(xbgr.mr_n54684320)
print v(xbgr.mr_n54684752)
print v(xbgr.mr_n54685184)
print v(xbgr.mr_n54685616)
print v(xbgr.mr_n54686048)
print v(xbgr.mr_n54686480)
print v(xbgr.mr_n54686912)
print v(xbgr.mr_n54687344)
print v(xbgr.mr_n54687776)
print v(xbgr.mr_n54688208)
print v(xbgr.mr_n54688640)
print v(xbgr.mr_n54689072)
print v(xbgr.mr_n54689504)
print v(xbgr.mr_n54689936)
print v(xbgr.mr_n54690368)
print v(xbgr.mr_n54690800)
print v(xbgr.mr_n54691232)
print v(xbgr.mr_n54691664)
print v(xbgr.mr_n54692096)
print v(xbgr.mr_n54692528)
print v(xbgr.mr_n54692960)
print v(xbgr.mr_n54693392)
print v(xbgr.mr_n54693824)
print v(xbgr.mr_n54694256)
print v(xbgr.mr_n54694688)
print v(xbgr.mr_n54695120)
print v(xbgr.mr_n54695552)
print v(xbgr.mr_n54695984)
print v(xbgr.mr_n54696416)
print v(xbgr.mr_n54696848)
print v(xbgr.mr_n54697280)
print v(xbgr.mr_n54697712)
print v(xbgr.mr_n54698144)
print v(xbgr.mr_n54698576)
print v(xbgr.mr_n54699008)
print v(xbgr.mr_n54699440)
print v(xbgr.mr_n54699872)
print v(xbgr.mr_n54700304)
print v(xbgr.mr_n54700736)
print v(xbgr.mr_n54701168)
print v(xbgr.mr_n54701600)
print v(xbgr.mr_n54702032)
print v(xbgr.mr_n54702464)
print v(xbgr.mr_n54702896)
print v(xbgr.mr_n54703328)
print v(xbgr.mr_n54703760)
print v(xbgr.mr_n54704192)
print v(xbgr.mr_n54704624)
print v(xbgr.mr_n54705056)
print v(xbgr.mr_n54705488)
print v(xbgr.mr_n54705920)
print v(xbgr.mr_n54706352)
print v(xbgr.mr_n54706784)
print v(xbgr.mr_n54707216)
print v(xbgr.mr_n54707648)
print v(xbgr.mr_n54708080)
print v(xbgr.mr_n54708512)
print v(xbgr.mr_n54708944)
print v(xbgr.mr_n54709376)
print v(xbgr.mr_n54709808)
print v(xbgr.mr_n54710240)
print v(xbgr.mr_n54710672)
print v(xbgr.mr_n54711104)
print v(xbgr.mr_n54711536)
print v(xbgr.mr_n54711856)
print v(xbgr.mr_n54711968)
print v(xbgr.mr_n54712288)
print v(xbgr.mr_n54712400)
print v(xbgr.mr_n54712720)
print v(xbgr.mr_n54712832)
print v(xbgr.mr_n54713152)
print v(xbgr.mr_n54713264)
print v(xbgr.mr_n54713584)
print v(xbgr.mr_n54713696)
print v(xbgr.mr_n54714016)
print v(xbgr.mr_n54714128)
print v(xbgr.mr_n54714448)
print v(xbgr.mr_n54714560)
print v(xbgr.mr_n54714880)
print v(xbgr.mr_n54714992)
print v(xbgr.mr_n54715312)
print v(xbgr.mr_n54715424)
print v(xbgr.mr_n54715744)
print v(xbgr.mr_n54715856)
print v(xbgr.mr_n54716176)
print v(xbgr.mr_n54716288)
print v(xbgr.mr_n54716608)
print v(xbgr.mr_n54716720)
print v(xbgr.mr_n54717040)
print v(xbgr.mr_n54717152)
print v(xbgr.mr_n54717472)
print v(xbgr.mr_n54717584)
print v(xbgr.mr_n54717904)
print v(xbgr.mr_n54718016)
print v(xbgr.mr_n54718336)
print v(xbgr.mr_n54718448)
print v(xbgr.mr_n54718768)
print v(xbgr.mr_n54718880)
print v(xbgr.mr_n54719200)
print v(xbgr.mr_n54719312)
print v(xbgr.mr_n54719632)
print v(xbgr.mr_n54719744)
print v(xbgr.mr_n54720064)
print v(xbgr.mr_n54720176)
print v(xbgr.mr_n54720496)
print v(xbgr.mr_n54720608)
print v(xbgr.mr_n54720928)
print v(xbgr.mr_n54721040)
print v(xbgr.mr_n54721360)
print v(xbgr.mr_n54721472)
print v(xbgr.mr_n54721792)
print v(xbgr.mr_n54721904)
print v(xbgr.mr_n54722224)
print v(xbgr.mr_n54722336)
print v(xbgr.mr_n54722656)
print v(xbgr.mr_n54722768)
print v(xbgr.mr_n54723088)
print v(xbgr.mr_n54723200)
print v(xbgr.mr_n54723520)
print v(xbgr.mr_n54723632)
print v(xbgr.mr_n54723952)
print v(xbgr.mr_n54724064)
print v(xbgr.mr_n54724384)
print v(xbgr.mr_n54724496)
print v(xbgr.mr_n54724816)
print v(xbgr.mr_n54724928)
print v(xbgr.mr_n54725248)
print v(xbgr.mr_n54725360)
print v(xbgr.mr_n54725680)
print v(xbgr.mr_n54725792)
print v(xbgr.mr_n54726112)
print v(xbgr.mr_n54726224)
print v(xbgr.mr_n54726544)
print v(xbgr.mr_n54726656)
print v(xbgr.mr_n54726976)
print v(xbgr.mr_n54727088)
print v(xbgr.mr_n54727408)
print v(xbgr.mr_n54727520)
print v(xbgr.mr_n54727840)
print v(xbgr.mr_n54727952)
print v(xbgr.mr_n54728272)
print v(xbgr.mr_n54728384)
print v(xbgr.mr_n54728704)
print v(xbgr.mr_n54728816)
print v(xbgr.mr_n54729136)
print v(xbgr.mr_n54729248)
print v(xbgr.mr_n54729568)
print v(xbgr.mr_n54729680)
print v(xbgr.mr_n54730000)
print v(xbgr.mr_n54730112)
print v(xbgr.mr_n54730432)
print v(xbgr.mr_n54730544)
print v(xbgr.mr_n54730864)
print v(xbgr.mr_n54730976)
print v(xbgr.mr_n54731296)
print v(xbgr.mr_n54731408)
print v(xbgr.mr_n54731728)
print v(xbgr.mr_n54731840)
print v(xbgr.mr_n54732160)
print v(xbgr.mr_n54732272)
print v(xbgr.mr_n54732592)
print v(xbgr.mr_n54732704)
print v(xbgr.mr_n54733024)
print v(xbgr.mr_n54733136)
print v(xbgr.mr_n54733456)
print v(xbgr.mr_n54733568)
print v(xbgr.mr_n54733888)
print v(xbgr.mr_n54734000)
print v(xbgr.mr_n54734320)
print v(xbgr.mr_n54734432)
print v(xbgr.mr_n54734752)
print v(xbgr.mr_n54734864)
print v(xbgr.mr_n54735184)
print v(xbgr.mr_n54735296)
print v(xbgr.mr_n54735616)
print v(xbgr.mr_n54735728)
print v(xbgr.mr_n54736048)
print v(xbgr.mr_n54736160)
print v(xbgr.mr_n54736480)
print v(xbgr.mr_n54736592)
print v(xbgr.mr_n54736912)
print v(xbgr.mr_n54737024)
print v(xbgr.mr_n54737344)
print v(xbgr.mr_n54737456)
print v(xbgr.mr_n54737776)
print v(xbgr.mr_n54737888)
print v(xbgr.mr_n54738208)
print v(xbgr.mr_n54738320)
print v(xbgr.mr_n54738640)
print v(xbgr.mr_n54738752)
print v(xbgr.mr_n54739072)
print v(xbgr.mr_n54739184)
print v(xbgr.mr_n54739504)
print v(xbgr.mr_n54739616)
print v(xbgr.mr_n54739936)
print v(xbgr.mr_n54740048)
print v(xbgr.mr_n54740368)
print v(xbgr.mr_n54740480)
print v(xbgr.mr_n54740800)
print v(xbgr.mr_n54740912)
print v(xbgr.mr_n54741232)
print v(xbgr.mr_n54741344)
print v(xbgr.mr_n54741664)
print v(xbgr.mr_n54741776)
print v(xbgr.mr_n54742096)
print v(xbgr.mr_n54742208)
print v(xbgr.mr_n54742528)
print v(xbgr.mr_n54742640)
print v(xbgr.mr_n54742960)
print v(xbgr.mr_n54743072)
print v(xbgr.mr_n54743392)
print v(xbgr.mr_n54743504)
print v(xbgr.mr_n54743824)
print v(xbgr.mr_n54743936)
print v(xbgr.mr_n54744256)
print v(xbgr.mr_n54744368)
print v(xbgr.mr_n54744688)
print v(xbgr.mr_n54744800)
print v(xbgr.mr_n54745120)
print v(xbgr.mr_n54745232)
print v(xbgr.mr_n54745552)
print v(xbgr.mr_n54745664)
print v(xbgr.mr_n54745984)
print v(xbgr.mr_n54746096)
print v(xbgr.mr_n54746416)
print v(xbgr.mr_n54746528)
print v(xbgr.mr_n54746848)
print v(xbgr.mr_n54746960)
print v(xbgr.mr_n54747280)
print v(xbgr.mr_n54747392)
print v(xbgr.mr_n54747712)
print v(xbgr.mr_n54747824)
print v(xbgr.mr_n54748144)
print v(xbgr.mr_n54748256)
print v(xbgr.mr_n54748576)
print v(xbgr.mr_n54748688)
print v(xbgr.mr_n54749008)
print v(xbgr.mr_n54749120)
print v(xbgr.mr_n54749440)
print v(xbgr.mr_n54749552)
print v(xbgr.mr_n54749872)
print v(xbgr.mr_n54749984)
print v(xbgr.mr_n54750304)
print v(xbgr.mr_n54750416)
print v(xbgr.mr_n54750736)
print v(xbgr.mr_n54750848)
print v(xbgr.mr_n54751168)
print v(xbgr.mr_n54751280)
print v(xbgr.mr_n54751600)
print v(xbgr.mr_n54751712)
print v(xbgr.mr_n54752032)
print v(xbgr.mr_n54752144)
print v(xbgr.mr_n54752464)
print v(xbgr.mr_n54752576)
print v(xbgr.mr_n54752896)
print v(xbgr.mr_n54753008)
print v(xbgr.mr_n54753328)
print v(xbgr.mr_n54753440)
print v(xbgr.mr_n54753760)
print v(xbgr.mr_n54753872)
print v(xbgr.mr_n54754192)
print v(xbgr.mr_n54754304)
print v(xbgr.mr_n54754624)
print v(xbgr.mr_n54754736)
print v(xbgr.mr_n54755056)
print v(xbgr.mr_n54755168)
print v(xbgr.mr_n54755488)
print v(xbgr.mr_n54755600)
print v(xbgr.mr_n54755920)
print v(xbgr.mr_n54756032)
print v(xbgr.mr_n54756352)
print v(xbgr.mr_n54756464)
print v(xbgr.mr_n54756784)
print v(xbgr.mr_n54756896)
print v(xbgr.mr_n54757216)
print v(xbgr.mr_n54757328)
print v(xbgr.mr_n54757648)
print v(xbgr.mr_n54757760)
print v(xbgr.mr_n54758080)
print v(xbgr.mr_n54758192)
print v(xbgr.mr_n54758512)
print v(xbgr.mr_n54758624)
print v(xbgr.mr_n54758944)
print v(xbgr.mr_n54759056)
print v(xbgr.mr_n54759376)
print v(xbgr.mr_n54759488)
print v(xbgr.mr_n54759808)
print v(xbgr.mr_n54759920)
print v(xbgr.mr_n54760240)
print v(xbgr.mr_n54760352)
print v(xbgr.mr_n54760672)
print v(xbgr.mr_n54760784)
print v(xbgr.mr_n54761104)
print v(xbgr.mr_n54761216)
print v(xbgr.mr_n54761536)
print v(xbgr.mr_n54761648)
print v(xbgr.mr_n54761968)
print v(xbgr.mr_n54762080)
print v(xbgr.mr_n54762400)
print v(xbgr.mr_n54762512)
print v(xbgr.mr_n54762832)
print v(xbgr.mr_n54762944)
print v(xbgr.mr_n54763264)
print v(xbgr.mr_n54763376)
print v(xbgr.mr_n54763696)
print v(xbgr.mr_n54763808)
print v(xbgr.mr_n54764128)
print v(xbgr.mr_n54764240)
print v(xbgr.mr_n54764560)
print v(xbgr.mr_n54764672)
print v(xbgr.mr_n54764992)
print v(xbgr.mr_n54765104)
print v(xbgr.mr_n54765424)
print v(xbgr.mr_n54765536)
print v(xbgr.mr_n54765856)
print v(xbgr.mr_n54765968)
print v(xbgr.mr_n54766288)
print v(xbgr.mr_n54766400)
print v(xbgr.mr_n54766720)
print v(xbgr.mr_n54766832)
print v(xbgr.mr_n54767152)
print v(xbgr.mr_n54767264)
print v(xbgr.mr_n54767584)
print v(xbgr.mr_n54767696)
print v(xbgr.mr_n54768016)
print v(xbgr.mr_n54768128)
print v(xbgr.mr_n54768448)
print v(xbgr.mr_n54768560)
print v(xbgr.mr_n54768880)
print v(xbgr.mr_n54768992)
print v(xbgr.mr_n54769312)
print v(xbgr.mr_n54769424)
print v(xbgr.mr_n54769744)
print v(xbgr.mr_n54769856)
print v(xbgr.mr_n54770176)
print v(xbgr.mr_n54770288)
print v(xbgr.mr_n54770608)
print v(xbgr.mr_n54770720)
print v(xbgr.mr_n54771040)
print v(xbgr.mr_n54771152)
print v(xbgr.mr_n54771472)
print v(xbgr.mr_n54771584)
print v(xbgr.mr_n54771904)
print v(xbgr.mr_n54772016)
print v(xbgr.mr_n54772336)
print v(xbgr.mr_n54772448)
print v(xbgr.mr_n54772768)
print v(xbgr.mr_n54772880)
print v(xbgr.mr_n54773200)
print v(xbgr.mr_n54773312)
print v(xbgr.mr_n54773632)
print v(xbgr.mr_n54773744)
print v(xbgr.mr_n54774064)
print v(xbgr.mr_n54774176)
print v(xbgr.mr_n54774496)
print v(xbgr.mr_n54774608)
print v(xbgr.mr_n54774928)
print v(xbgr.mr_n54775040)
print v(xbgr.mr_n54775360)
print v(xbgr.mr_n54775472)
print v(xbgr.mr_n54775792)
print v(xbgr.mr_n54775904)
print v(xbgr.mr_n54776224)
print v(xbgr.mr_n54776336)
print v(xbgr.mr_n54776656)
print v(xbgr.mr_n54776768)
print v(xbgr.mr_n54777088)
print v(xbgr.mr_n54777200)
print v(xbgr.mr_n54777520)
print v(xbgr.mr_n54777632)
print v(xbgr.mr_n54777952)
print v(xbgr.mr_n54778064)
print v(xbgr.mr_n54778384)
print v(xbgr.mr_n54778496)
print v(xbgr.mr_n54778816)
print v(xbgr.mr_n54778928)
print v(xbgr.mr_n54779248)
print v(xbgr.mr_n54779360)
print v(xbgr.mr_n54779680)
print v(xbgr.mr_n54779792)
print v(xbgr.mr_n54780112)
print v(xbgr.mr_n54780224)
print v(xbgr.mr_n54780544)
print v(xbgr.mr_n54780656)
print v(xbgr.mr_n54780976)
print v(xbgr.mr_n54781088)
print v(xbgr.mr_n54781408)
print v(xbgr.mr_n54781520)
print v(xbgr.mr_n54781840)
print v(xbgr.mr_n54781952)
print v(xbgr.mr_n54782272)
print v(xbgr.mr_n54782384)
print v(xbgr.mr_n54782704)
print v(xbgr.mr_n54782816)
print v(xbgr.mr_n54783136)
print v(xbgr.mr_n54783248)
print v(xbgr.mr_n54783568)
print v(xbgr.mr_n54783680)
print v(xbgr.mr_n54784000)
print v(xbgr.mr_n54784112)
print v(xbgr.mr_n54784432)
print v(xbgr.mr_n54784544)
print v(xbgr.mr_n54784864)
print v(xbgr.mr_n54784976)
print v(xbgr.mr_n54785296)
print v(xbgr.mr_n54785408)
print v(xbgr.mr_n54785728)
print v(xbgr.mr_n54785840)
print v(xbgr.mr_n54786160)
print v(xbgr.mr_n54786272)
print v(xbgr.mr_n54786592)
print v(xbgr.mr_n54786704)
print v(xbgr.mr_n54787024)
print v(xbgr.mr_n54787136)
print v(xbgr.mr_n54787456)
print v(xbgr.mr_n54787568)
print v(xbgr.mr_n54787888)
print v(xbgr.mr_n54788000)
print v(xbgr.mr_n54788320)
print v(xbgr.mr_n54788432)
print v(xbgr.mr_n54788752)
print v(xbgr.mr_n54788864)
print v(xbgr.mr_n54789184)
print v(xbgr.mr_n54789296)
print v(xbgr.mr_n54789616)
print v(xbgr.mr_n54789728)
print v(xbgr.mr_n54790048)
print v(xbgr.mr_n54790160)
print v(xbgr.mr_n54790480)
print v(xbgr.mr_n54790592)
print v(xbgr.mr_n54790912)
print v(xbgr.mr_n54791024)
print v(xbgr.mr_n54791344)
print v(xbgr.mr_n54791456)
print v(xbgr.mr_n54791776)
print v(xbgr.mr_n54791888)
print v(xbgr.mr_n54792208)
print v(xbgr.mr_n54792320)
print v(xbgr.mr_n54792640)
print v(xbgr.mr_n54792752)
print v(xbgr.mr_n54793072)
print v(xbgr.mr_n54793184)
print v(xbgr.mr_n54793504)
print v(xbgr.mr_n54793616)
print v(xbgr.mr_n54793936)
print v(xbgr.mr_n54794048)
print v(xbgr.mr_n54794368)
print v(xbgr.mr_n54794480)
print v(xbgr.mr_n54794800)
print v(xbgr.mr_n54794912)
print v(xbgr.mr_n54795232)
print v(xbgr.mr_n54795344)
print v(xbgr.mr_n54795664)
print v(xbgr.mr_n54795776)
print v(xbgr.mr_n54796096)
print v(xbgr.mr_n54796208)
print v(xbgr.mr_n54796528)
print v(xbgr.mr_n54796640)
print v(xbgr.mr_n54796960)
print v(xbgr.mr_n54797072)
print v(xbgr.mr_n54797392)
print v(xbgr.mr_n54797504)
print v(xbgr.mr_n54797824)
print v(xbgr.mr_n54797936)
print v(xbgr.mr_n54798256)
print v(xbgr.mr_n54798368)
print v(xbgr.mr_n54798688)
print v(xbgr.mr_n54798800)
print v(xbgr.mr_n54799120)
print v(xbgr.mr_n54799232)
print v(xbgr.mr_n54799552)
print v(xbgr.mr_n54799664)
print v(xbgr.mr_n54799984)
print v(xbgr.mr_n54800096)
print v(xbgr.mr_n54800416)
print v(xbgr.mr_n54800528)
print v(xbgr.mr_n54800848)
print v(xbgr.mr_n54800960)
print v(xbgr.mr_n54801280)
print v(xbgr.mr_n54801392)
print v(xbgr.mr_n54801712)
print v(xbgr.mr_n54801824)
print v(xbgr.mr_n54802144)
print v(xbgr.mr_n54802256)
print v(xbgr.mr_n54802576)
print v(xbgr.mr_n54802688)
print v(xbgr.mr_n54803008)
print v(xbgr.mr_n54803120)
print v(xbgr.mr_n54803440)
print v(xbgr.mr_n54803552)
print v(xbgr.mr_n54803872)
print v(xbgr.mr_n54803984)
print v(xbgr.mr_n54804304)
print v(xbgr.mr_n54804416)
print v(xbgr.mr_n54804736)
print v(xbgr.mr_n54804848)
print v(xbgr.mr_n54805168)
print v(xbgr.mr_n54805280)
print v(xbgr.mr_n54805600)
print v(xbgr.mr_n54805712)
print v(xbgr.mr_n54806576)
print v(xbgr.mr_n54807008)
print v(xbgr.mr_n54807440)
print v(xbgr.mr_n54807872)
print v(xbgr.mr_n54808304)
print v(xbgr.mr_n54808736)
print v(xbgr.mr_n54809168)
print v(xbgr.mr_n54809600)
print v(xbgr.mr_n54810032)
print v(xbgr.mr_n54810464)
print v(xbgr.mr_n54810896)
print v(xbgr.mr_n54811328)
print v(xbgr.mr_n54811760)
print v(xbgr.mr_n54812192)
print v(xbgr.mr_n54812624)
print v(xbgr.mr_n54813056)
print v(xbgr.mr_n54813488)
print v(xbgr.mr_n54813920)
print v(xbgr.mr_n54814352)
print v(xbgr.mr_n54814784)
print v(xbgr.mr_n54815216)
print v(xbgr.mr_n54815648)
print v(xbgr.mr_n54816080)
print v(xbgr.mr_n54816512)
print v(xbgr.mr_n54818672)
print v(xbgr.mr_n54819104)
print v(xbgr.mr_n54819536)
print v(xbgr.mr_n54819968)
print v(xbgr.mr_n54820400)
print v(xbgr.mr_n54820832)
print v(xbgr.mr_n54821264)
print v(xbgr.mr_n54821696)
print v(xbgr.mr_n54822128)
print v(xbgr.mr_n54822560)
print v(xbgr.mr_n54822992)
print v(xbgr.mr_n54823424)
print v(xbgr.mr_n54823856)
print v(xbgr.mr_n54824288)
print v(xbgr.mr_n54824720)
print v(xbgr.mr_n54825152)
print v(xbgr.mr_n54825584)
print v(xbgr.mr_n54826016)
print v(xbgr.mr_n54826448)
print v(xbgr.mr_n54826880)
print v(xbgr.mr_n54827312)
print v(xbgr.mr_n54827744)
print v(xbgr.mr_n54828176)
print v(xbgr.mr_n54828608)
print v(xbgr.mr_n54832496)
print v(xbgr.mr_n54832928)
print v(xbgr.mr_n54833360)
print v(xbgr.mr_n54833792)
print v(xbgr.mr_n54834224)
print v(xbgr.mr_n54834656)
print v(xbgr.mr_n54835088)
print v(xbgr.mr_n54835520)
print v(xbgr.mr_n54835952)
print v(xbgr.mr_n54836384)
print v(xbgr.mr_n54836816)
print v(xbgr.mr_n54837248)
print v(xbgr.mr_n54837680)
print v(xbgr.mr_n54838112)
print v(xbgr.mr_n54838544)
print v(xbgr.mr_n54839840)
print v(xbgr.mr_n54840272)
print v(xbgr.mr_n54840704)
print v(xbgr.mr_n54841136)
print v(xbgr.mr_n54841568)
print v(xbgr.mr_n54842000)
print v(xbgr.mr_n54842432)
print v(xbgr.mr_n54842864)
print v(xbgr.mr_n54843296)
print v(xbgr.mr_n54843728)
print v(xbgr.mr_n54845024)
print v(xbgr.mr_n54845456)
print v(xbgr.mr_n54845888)
print v(xbgr.mr_n54846320)
print v(xbgr.mr_n54846752)
print v(xbgr.mr_n54847184)
print v(xbgr.mr_n54847616)
print v(xbgr.mr_n54848048)
print v(xbgr.mr_n54848368)
print v(xbgr.mr_n54848480)
print v(xbgr.mr_n54848800)
print v(xbgr.mr_n54848912)
print v(xbgr.mr_n54849232)
print v(xbgr.mr_n54849344)
print v(xbgr.mr_n54849664)
print v(xbgr.mr_n54849776)
print v(xbgr.mr_n54850096)
print v(xbgr.mr_n54850208)
print v(xbgr.mr_n54850528)
print v(xbgr.mr_n54850640)
print v(xbgr.mr_n54850960)
print v(xbgr.mr_n54851072)
print v(xbgr.mr_n54851392)
print v(xbgr.mr_n54851504)
print v(xbgr.mr_n54851824)
print v(xbgr.mr_n54851936)
print v(xbgr.mr_n54852256)
print v(xbgr.mr_n54852368)
print v(xbgr.mr_n54852688)
print v(xbgr.mr_n54852800)
print v(xbgr.mr_n54853120)
print v(xbgr.mr_n54853232)
print v(xbgr.mr_n54853552)
print v(xbgr.mr_n54853664)
print v(xbgr.mr_n54853984)
print v(xbgr.mr_n54854096)
print v(xbgr.mr_n54854416)
print v(xbgr.mr_n54854528)
print v(xbgr.mr_n54854848)
print v(xbgr.mr_n54854960)
print v(xbgr.mr_n54855280)
print v(xbgr.mr_n54855392)
print v(xbgr.mr_n54855712)
print v(xbgr.mr_n54855824)
print v(xbgr.mr_n54856144)
print v(xbgr.mr_n54856256)
print v(xbgr.mr_n54856576)
print v(xbgr.mr_n54856688)
print v(xbgr.mr_n54857008)
print v(xbgr.mr_n54857120)
print v(xbgr.mr_n54857440)
print v(xbgr.mr_n54857552)
print v(xbgr.mr_n54857872)
print v(xbgr.mr_n54857984)
print v(xbgr.mr_n54858304)
print v(xbgr.mr_n54858416)
print v(xbgr.mr_n54858736)
print v(xbgr.mr_n54858848)
print v(xbgr.mr_n54859168)
print v(xbgr.mr_n54859280)
print v(xbgr.mr_n54859600)
print v(xbgr.mr_n54859712)
print v(xbgr.mr_n54860032)
print v(xbgr.mr_n54860144)
print v(xbgr.mr_n54860464)
print v(xbgr.mr_n54860576)
print v(xbgr.mr_n54860896)
print v(xbgr.mr_n54861008)
print v(xbgr.mr_n54861328)
print v(xbgr.mr_n54861440)
print v(xbgr.mr_n54861760)
print v(xbgr.mr_n54861872)
print v(xbgr.mr_n54862192)
print v(xbgr.mr_n54862304)
print v(xbgr.mr_n54862624)
print v(xbgr.mr_n54862736)
print v(xbgr.mr_n54863056)
print v(xbgr.mr_n54863168)
print v(xbgr.mr_n54863488)
print v(xbgr.mr_n54863600)
print v(xbgr.mr_n54863920)
print v(xbgr.mr_n54864032)
print v(xbgr.mr_n54864352)
print v(xbgr.mr_n54864464)
print v(xbgr.mr_n54864784)
print v(xbgr.mr_n54864896)
print v(xbgr.mr_n54865216)
print v(xbgr.mr_n54865328)
print v(xbgr.mr_n54865648)
print v(xbgr.mr_n54865760)
print v(xbgr.mr_n54866080)
print v(xbgr.mr_n54866192)
print v(xbgr.mr_n54866512)
print v(xbgr.mr_n54866624)
print v(xbgr.mr_n54866944)
print v(xbgr.mr_n54867056)
print v(xbgr.mr_n54867376)
print v(xbgr.mr_n54867488)
print v(xbgr.mr_n54867808)
print v(xbgr.mr_n54867920)
print v(xbgr.mr_n54868240)
print v(xbgr.mr_n54868352)
print v(xbgr.mr_n54868672)
print v(xbgr.mr_n54868784)
print v(xbgr.mr_n54869104)
print v(xbgr.mr_n54869216)
print v(xbgr.mr_n54869536)
print v(xbgr.mr_n54869648)
print v(xbgr.mr_n54869968)
print v(xbgr.mr_n54870080)
print v(xbgr.mr_n54870400)
print v(xbgr.mr_n54870512)
print v(xbgr.mr_n54870832)
print v(xbgr.mr_n54870944)
print v(xbgr.mr_n54871264)
print v(xbgr.mr_n54871376)
print v(xbgr.mr_n54871696)
print v(xbgr.mr_n54871808)
print v(xbgr.mr_n54872128)
print v(xbgr.mr_n54872240)
print v(xbgr.mr_n54872560)
print v(xbgr.mr_n54872672)
print v(xbgr.mr_n54872992)
print v(xbgr.mr_n54873104)
print v(xbgr.mr_n54873424)
print v(xbgr.mr_n54873536)
print v(xbgr.mr_n54873856)
print v(xbgr.mr_n54873968)
print v(xbgr.mr_n54874288)
print v(xbgr.mr_n54874400)
print v(xbgr.mr_n54874720)
print v(xbgr.mr_n54874832)
print v(xbgr.mr_n54875152)
print v(xbgr.mr_n54875264)
print v(xbgr.mr_n54875584)
print v(xbgr.mr_n54875696)
print v(xbgr.mr_n54876016)
print v(xbgr.mr_n54876128)
print v(xbgr.mr_n54876448)
print v(xbgr.mr_n54876560)
print v(xbgr.mr_n54876880)
print v(xbgr.mr_n54876992)
print v(xbgr.mr_n54877312)
print v(xbgr.mr_n54877424)
print v(xbgr.mr_n54877744)
print v(xbgr.mr_n54877856)
print v(xbgr.mr_n54878176)
print v(xbgr.mr_n54878288)
print v(xbgr.mr_n54878608)
print v(xbgr.mr_n54878720)
print v(xbgr.mr_n54879040)
print v(xbgr.mr_n54879152)
print v(xbgr.mr_n54879472)
print v(xbgr.mr_n54879584)
print v(xbgr.mr_n54879904)
print v(xbgr.mr_n54880016)
print v(xbgr.mr_n54880336)
print v(xbgr.mr_n54880448)
print v(xbgr.mr_n54880768)
print v(xbgr.mr_n54880880)
print v(xbgr.mr_n54881200)
print v(xbgr.mr_n54881312)
print v(xbgr.mr_n54881632)
print v(xbgr.mr_n54881744)
print v(xbgr.mr_n54882064)
print v(xbgr.mr_n54882176)
print v(xbgr.mr_n54882496)
print v(xbgr.mr_n54882608)
print v(xbgr.mr_n54882928)
print v(xbgr.mr_n54883040)
print v(xbgr.mr_n54883360)
print v(xbgr.mr_n54883472)
print v(xbgr.mr_n54883792)
print v(xbgr.mr_n54883904)
print v(xbgr.mr_n54884224)
print v(xbgr.mr_n54884336)
print v(xbgr.mr_n54884656)
print v(xbgr.mr_n54884768)
print v(xbgr.mr_n54885088)
print v(xbgr.mr_n54885200)
print v(xbgr.mr_n54885520)
print v(xbgr.mr_n54885632)
print v(xbgr.mr_n54885952)
print v(xbgr.mr_n54886064)
print v(xbgr.mr_n54886384)
print v(xbgr.mr_n54886496)
print v(xbgr.mr_n54886816)
print v(xbgr.mr_n54886928)
print v(xbgr.mr_n54887248)
print v(xbgr.mr_n54887360)
print v(xbgr.mr_n54887680)
print v(xbgr.mr_n54887792)
print v(xbgr.mr_n54888112)
print v(xbgr.mr_n54888224)
print v(xbgr.mr_n54888544)
print v(xbgr.mr_n54888656)
print v(xbgr.mr_n54888976)
print v(xbgr.mr_n54889088)
print v(xbgr.mr_n54889408)
print v(xbgr.mr_n54889520)
print v(xbgr.mr_n54889840)
print v(xbgr.mr_n54889952)
print v(xbgr.mr_n54890272)
print v(xbgr.mr_n54890384)
print v(xbgr.mr_n54890704)
print v(xbgr.mr_n54890816)
print v(xbgr.mr_n54891136)
print v(xbgr.mr_n54891248)
print v(xbgr.mr_n54891568)
print v(xbgr.mr_n54891680)
print v(xbgr.mr_n54892000)
print v(xbgr.mr_n54892112)
print v(xbgr.mr_n54892432)
print v(xbgr.mr_n54892544)
print v(xbgr.mr_n54892864)
print v(xbgr.mr_n54892976)
print v(xbgr.mr_n54893296)
print v(xbgr.mr_n54893408)
print v(xbgr.mr_n54893728)
print v(xbgr.mr_n54893840)
print v(xbgr.mr_n54894160)
print v(xbgr.mr_n54894272)
print v(xbgr.mr_n54894592)
print v(xbgr.mr_n54894704)
print v(xbgr.mr_n54895024)
print v(xbgr.mr_n54895456)
print v(xbgr.mr_n54895568)
print v(xbgr.mr_n54895888)
print v(xbgr.mr_n54896000)
print v(xbgr.mr_n54896320)
print v(xbgr.mr_n54896432)
print v(xbgr.mr_n54896752)
print v(xbgr.mr_n54896864)
print v(xbgr.mr_n54897184)
print v(xbgr.mr_n54897296)
print v(xbgr.mr_n54897616)
print v(xbgr.mr_n54897728)
print v(xbgr.mr_n54898048)
print v(xbgr.mr_n54898160)
print v(xbgr.mr_n54898480)
print v(xbgr.mr_n54898592)
print v(xbgr.mr_n54898912)
print v(xbgr.mr_n54899024)
print v(xbgr.mr_n54899344)
print v(xbgr.mr_n54899456)
print v(xbgr.mr_n54899776)
print v(xbgr.mr_n54899888)
print v(xbgr.mr_n54900208)
print v(xbgr.mr_n54900320)
print v(xbgr.mr_n54900640)
print v(xbgr.mr_n54900752)
print v(xbgr.mr_n54901072)
print v(xbgr.mr_n54901184)
print v(xbgr.mr_n54901504)
print v(xbgr.mr_n54901616)
print v(xbgr.mr_n54901936)
print v(xbgr.mr_n54902048)
print v(xbgr.mr_n54902368)
print v(xbgr.mr_n54902480)
print v(xbgr.mr_n54902800)
print v(xbgr.mr_n54902912)
print v(xbgr.mr_n54903232)
print v(xbgr.mr_n54903344)
print v(xbgr.mr_n54903664)
print v(xbgr.mr_n54903776)
print v(xbgr.mr_n54904096)
print v(xbgr.mr_n54904208)
print v(xbgr.mr_n54904528)
print v(xbgr.mr_n54904640)
print v(xbgr.mr_n54904960)
print v(xbgr.mr_n54905072)
print v(xbgr.mr_n54905392)
print v(xbgr.mr_n54905504)
print v(xbgr.mr_n54905824)
print v(xbgr.mr_n54905936)
print v(xbgr.mr_n54906256)
print v(xbgr.mr_n54906368)
print v(xbgr.mr_n54906688)
print v(xbgr.mr_n54906800)
print v(xbgr.mr_n54907120)
print v(xbgr.mr_n54907232)
print v(xbgr.mr_n54907552)
print v(xbgr.mr_n54907664)
print v(xbgr.mr_n54907984)
print v(xbgr.mr_n54908096)
print v(xbgr.mr_n54908416)
print v(xbgr.mr_n54908528)
print v(xbgr.mr_n54908848)
print v(xbgr.mr_n54908960)
print v(xbgr.mr_n54909280)
print v(xbgr.mr_n54909392)
print v(xbgr.mr_n54909712)
print v(xbgr.mr_n54909824)
print v(xbgr.mr_n54910144)
print v(xbgr.mr_n54910256)
print v(xbgr.mr_n54910576)
print v(xbgr.mr_n54911008)
print v(xbgr.mr_n54911120)
print v(xbgr.mr_n54911440)
print v(xbgr.mr_n54911552)
print v(xbgr.mr_n54911872)
print v(xbgr.mr_n54911984)
print v(xbgr.mr_n54912304)
print v(xbgr.mr_n54912736)
print v(xbgr.mr_n54912848)
print v(xbgr.mr_n54913168)
print v(xbgr.mr_n54913280)
print v(xbgr.mr_n54913600)
print v(xbgr.mr_n54913712)
print v(xbgr.mr_n54914032)
print v(xbgr.mr_n54914464)
print v(xbgr.mr_n54914576)
print v(xbgr.mr_n54914896)
print v(xbgr.mr_n54915008)
print v(xbgr.mr_n54915328)
print v(xbgr.mr_n54915440)
print v(xbgr.mr_n54915760)
print v(xbgr.mr_n54915872)
print v(xbgr.mr_n54916192)
print v(xbgr.mr_n54916304)
print v(xbgr.mr_n54916624)
print v(xbgr.mr_n54916736)
print v(xbgr.mr_n54917056)
print v(xbgr.mr_n54917168)
print v(xbgr.mr_n54917488)
print v(xbgr.mr_n54917600)
print v(xbgr.mr_n54917920)
print v(xbgr.mr_n54918032)
print v(xbgr.mr_n54918352)
print v(xbgr.mr_n54918464)
print v(xbgr.mr_n54918784)
print v(xbgr.mr_n54918896)
print v(xbgr.mr_n54919216)
print v(xbgr.mr_n54919328)
print v(xbgr.mr_n54919648)
print v(xbgr.mr_n54919760)
print v(xbgr.mr_n54920080)
print v(xbgr.mr_n54920192)
print v(xbgr.mr_n54920512)
print v(xbgr.mr_n54920624)
print v(xbgr.mr_n54920944)
print v(xbgr.mr_n54921056)
print v(xbgr.mr_n54921376)
print v(xbgr.mr_n54921808)
print v(xbgr.mr_n54921920)
print v(xbgr.mr_n54922240)
print v(xbgr.mr_n54922352)
print v(xbgr.mr_n54922672)
print v(xbgr.mr_n54922784)
print v(xbgr.mr_n54923104)
print v(xbgr.mr_n54923216)
print v(xbgr.mr_n54923536)
print v(xbgr.mr_n54923648)
print v(xbgr.mr_n54923968)
print v(xbgr.mr_n54924080)
print v(xbgr.mr_n54924400)
print v(xbgr.mr_n54924512)
print v(xbgr.mr_n54924832)
print v(xbgr.mr_n54924944)
print v(xbgr.mr_n54925264)
print v(xbgr.mr_n54925376)
print v(xbgr.mr_n54925696)
print v(xbgr.mr_n54925808)
print v(xbgr.mr_n54926128)
print v(xbgr.mr_n54926560)
print v(xbgr.mr_n54926672)
print v(xbgr.mr_n54926992)
print v(xbgr.mr_n54927424)
print v(xbgr.mr_n54927536)
print v(xbgr.mr_n54927856)
print v(xbgr.mr_n54927968)
print v(xbgr.mr_n54928288)
print v(xbgr.mr_n54928400)
print v(xbgr.mr_n54928720)
print v(xbgr.mr_n54928832)
print v(xbgr.mr_n54929152)
print v(xbgr.mr_n54929264)
print v(xbgr.mr_n54929584)
print v(xbgr.mr_n54930016)
print v(xbgr.mr_n54930128)
print v(xbgr.mr_n54930448)
print v(xbgr.mr_n54930560)
print v(xbgr.mr_n54930880)
print v(xbgr.mr_n54930992)
print v(xbgr.mr_n54935248)
print v(xbgr.mr_n54935360)
print v(xbgr.mr_n54935696)
print v(xbgr.mr_n54935808)
print v(xbgr.mr_n54936128)
print v(xbgr.mr_n54936240)
print v(xbgr.mr_n54936608)
print v(xbgr.mr_n54936720)
print v(xbgr.mr_n54937040)
print v(xbgr.mr_n54937152)
print v(xbgr.mr_n54937472)
print v(xbgr.mr_n54937824)
print v(xbgr.mr_n54937936)
print v(xbgr.mr_n54938256)
print v(xbgr.mr_n54938688)
print v(xbgr.mr_n54938800)
print v(xbgr.mr_n54939120)
print v(xbgr.mr_n54939232)
print v(xbgr.mr_n54939552)
print v(xbgr.mr_n54939664)
print v(xbgr.mr_n54939984)
print v(xbgr.mr_n54940096)
print v(xbgr.mr_n54940416)
print v(xbgr.mr_n54940528)
print v(xbgr.mr_n54940848)
print v(xbgr.mr_n54941280)
print v(xbgr.mr_n54941392)
print v(xbgr.mr_n54941712)
print v(xbgr.mr_n54942144)
print v(xbgr.mr_n54942256)
print v(xbgr.mr_n54942576)
print v(xbgr.mr_n54942688)
print v(xbgr.mr_n54943008)
print v(xbgr.mr_n54943120)
print v(xbgr.mr_n54943440)
print v(xbgr.mr_n54943552)
print v(xbgr.mr_n54943872)
print v(xbgr.mr_n54943984)
print v(xbgr.mr_n54944304)
print v(xbgr.mr_n54944416)
print v(xbgr.mr_n54944736)
print v(xbgr.mr_n54944848)
print v(xbgr.mr_n54945168)
print v(xbgr.mr_n54945600)
print v(xbgr.mr_n54945712)
print v(xbgr.mr_n54946032)
print v(xbgr.mr_n54946144)
print v(xbgr.mr_n54946464)
print v(xbgr.mr_n54946576)
print v(xbgr.mr_n54946896)
print v(xbgr.mr_n54947008)
print v(xbgr.mr_n54947328)
print v(xbgr.mr_n54947440)
print v(xbgr.mr_n54947760)
print v(xbgr.mr_n54947872)
print v(xbgr.mr_n54948192)
print v(xbgr.mr_n54948304)
print v(xbgr.mr_n54948624)
print v(xbgr.mr_n54949056)
print v(xbgr.mr_n54949168)
print v(xbgr.mr_n54949488)
print v(xbgr.mr_n54949920)
print v(xbgr.mr_n54950032)
print v(xbgr.mr_n54950352)
print v(xbgr.mr_n54950464)
print v(xbgr.mr_n54950784)
print v(xbgr.mr_n54950896)
print v(xbgr.mr_n54951216)
print v(xbgr.mr_n54951328)
print v(xbgr.mr_n54951648)
print v(xbgr.mr_n54951760)
print v(xbgr.mr_n54952080)
print v(xbgr.mr_n54952192)
print v(xbgr.mr_n54952512)
print v(xbgr.mr_n54952624)
print v(xbgr.mr_n54952944)
print v(xbgr.mr_n54953376)
print v(xbgr.mr_n54953488)
print v(xbgr.mr_n54953808)
print v(xbgr.mr_n54953920)
print v(xbgr.mr_n54954240)
print v(xbgr.mr_n54954352)
print v(xbgr.mr_n54954672)
print v(xbgr.mr_n54955104)
print v(xbgr.mr_n54955216)
print v(xbgr.mr_n54955536)
print v(xbgr.mr_n54955648)
print v(xbgr.mr_n54955968)
print v(xbgr.mr_n54956080)
print v(xbgr.mr_n54956400)
print v(xbgr.mr_n54956512)
print v(xbgr.mr_n54956832)
print v(xbgr.mr_n54956944)
print v(xbgr.mr_n54957264)
print v(xbgr.mr_n54957376)
print v(xbgr.mr_n54957696)
print v(xbgr.mr_n54957808)
print v(xbgr.mr_n54958128)
print v(xbgr.mr_n54958560)
print v(xbgr.mr_n54958672)
print v(xbgr.mr_n54958992)
print v(xbgr.mr_n54959104)
print v(xbgr.mr_n54959424)
print v(xbgr.mr_n54959536)
print v(xbgr.mr_n54959856)
print v(xbgr.mr_n54960288)
print v(xbgr.mr_n54960400)
print v(xbgr.mr_n54960720)
print v(xbgr.mr_n54960832)
print v(xbgr.mr_n54961152)
print v(xbgr.mr_n54961264)
print v(xbgr.mr_n54961584)
print v(xbgr.mr_n54961696)
print v(xbgr.mr_n54962016)
print v(xbgr.mr_n54962128)
print v(xbgr.mr_n54962448)
print v(xbgr.mr_n54962560)
print v(xbgr.mr_n54962880)
print v(xbgr.mr_n54962992)
print v(xbgr.mr_n54963312)
print v(xbgr.mr_n54963424)
print v(xbgr.mr_n54963744)
print v(xbgr.mr_n54963856)
print v(xbgr.mr_n54964176)
print v(xbgr.mr_n54964608)
print v(xbgr.mr_n54964720)
print v(xbgr.mr_n54965040)
print v(xbgr.mr_n54965152)
print v(xbgr.mr_n54965376)
print v(xbgr.mr_n54965744)
print v(xbgr.mr_n54965856)
print v(xbgr.mr_n54966112)
print v(xbgr.mr_n54966224)
print v(xbgr.mr_n54966480)
print v(xbgr.mr_n54966592)
print v(xbgr.mr_n54966848)
print v(xbgr.mr_n54966960)
print v(xbgr.mr_n54967216)
print v(xbgr.mr_n54967328)
print v(xbgr.mr_n54967584)
print v(xbgr.mr_n54967952)
print v(xbgr.mr_n54968064)
print v(xbgr.mr_n54968320)
print v(xbgr.mr_n54968688)
print v(xbgr.mr_n54968800)
print v(xbgr.mr_n54969056)
print v(xbgr.mr_n54969424)
print v(xbgr.mr_n54969536)
print v(xbgr.mr_n54969792)
print v(xbgr.mr_n54969904)
print v(xbgr.mr_n54970160)
print v(xbgr.mr_n54970272)
print v(xbgr.mr_n54970528)
print v(xbgr.mr_n54970896)
print v(xbgr.mr_n54971008)
print v(xbgr.mr_n54971264)
print v(xbgr.mr_n54971632)
print v(xbgr.mr_n54971744)
print v(xbgr.mr_n54972000)
print v(xbgr.mr_n54972368)
print v(xbgr.mr_n54972480)
print v(xbgr.mr_n54972736)
print v(xbgr.mr_n54972848)
print v(xbgr.mr_n54973104)
print v(xbgr.mr_n54973216)
print v(xbgr.mr_n54973472)
print v(xbgr.mr_n54973584)
print v(xbgr.mr_n54973840)
print v(xbgr.mr_n54973952)
print v(xbgr.mr_n54974208)
print v(xbgr.mr_n54974576)
print v(xbgr.mr_n54974688)
print v(xbgr.mr_n54974944)
print v(xbgr.mr_n54975056)
print v(xbgr.mr_n54975312)
print v(xbgr.mr_n54975424)
print v(xbgr.mr_n54975680)
print v(xbgr.mr_n54975792)
print v(xbgr.mr_n54976048)
print v(xbgr.mr_n54976160)
print v(xbgr.mr_n54976416)
print v(xbgr.mr_n54976784)
print v(xbgr.mr_n54976896)
print v(xbgr.mr_n54977152)
print v(xbgr.mr_n54977520)
print v(xbgr.mr_n54977632)
print v(xbgr.mr_n54977888)
print v(xbgr.mr_n54978000)
print v(xbgr.mr_n54978256)
print v(xbgr.mr_n54978368)
print v(xbgr.mr_n54978624)
print v(xbgr.mr_n54978992)
print v(xbgr.mr_n54979104)
print v(xbgr.mr_n54979392)
print v(xbgr.mr_n54979824)
print v(xbgr.mr_n54979936)
print v(xbgr.mr_n54980256)
print v(xbgr.mr_n54980368)
print v(xbgr.mr_n54980688)
print v(xbgr.mr_n54980800)
print v(xbgr.mr_n54981120)
print v(xbgr.mr_n54981232)
print v(xbgr.mr_n54981552)
print v(xbgr.mr_n54981664)
print v(xbgr.mr_n54981984)
print v(xbgr.mr_n54982096)
print v(xbgr.mr_n54982416)
print v(xbgr.mr_n54982528)
print v(xbgr.mr_n54982848)
print v(xbgr.mr_n54983280)
print v(xbgr.mr_n54983392)
print v(xbgr.mr_n54983712)
print v(xbgr.mr_n54983824)
print v(xbgr.mr_n54984144)
print v(xbgr.mr_n54984256)
print v(xbgr.mr_n54984576)
print v(xbgr.mr_n54984688)
print v(xbgr.mr_n54985008)
print v(xbgr.mr_n54985120)
print v(xbgr.mr_n54985440)
print v(xbgr.mr_n54985872)
print v(xbgr.mr_n54985984)
print v(xbgr.mr_n54986304)
print v(xbgr.mr_n54986736)
print v(xbgr.mr_n54986848)
print v(xbgr.mr_n54987168)
print v(xbgr.mr_n54987280)
print v(xbgr.mr_n54987600)
print v(xbgr.mr_n54987712)
print v(xbgr.mr_n54988032)
print v(xbgr.mr_n54988144)
print v(xbgr.mr_n54988464)
print v(xbgr.mr_n54988576)
print v(xbgr.mr_n54988896)
print v(xbgr.mr_n54989008)
print v(xbgr.mr_n54989328)
print v(xbgr.mr_n54989440)
print v(xbgr.mr_n54989760)
print v(xbgr.mr_n54989872)
print v(xbgr.mr_n54990192)
print v(xbgr.mr_n54990736)
print v(xbgr.mr_n54991168)
print v(xbgr.mr_n54991600)
print v(xbgr.mr_n54992032)
print v(xbgr.mr_n54992464)
print v(xbgr.mr_n54992896)
print v(xbgr.mr_n54993328)
print v(xbgr.mr_n54993760)
print v(xbgr.mr_n54994192)
print v(xbgr.mr_n54994624)
print v(xbgr.mr_n54994944)
print v(xbgr.mr_n54995376)
print v(xbgr.mr_n54995808)
print v(xbgr.mr_n54996240)
print v(xbgr.mr_n54996672)
print v(xbgr.mr_n54997104)
print v(xbgr.mr_n54997536)
print v(xbgr.mr_n54997968)
print v(xbgr.mr_n54998400)
print v(xbgr.mr_n54998832)
print v(xbgr.mr_n54999264)
print v(xbgr.mr_n54999696)
print v(xbgr.mr_n55000128)
print v(xbgr.mr_n55000560)
print v(xbgr.mr_n55000992)
print v(xbgr.mr_n55001424)
print v(xbgr.mr_n55001856)
print v(xbgr.mr_n55002288)
print v(xbgr.mr_n55002720)
print v(xbgr.mr_n55003152)
print v(xbgr.mr_n55003584)
print v(xbgr.mr_n55004016)
print v(xbgr.mr_n55004448)
print v(xbgr.mr_n55004880)
print v(xbgr.mr_n55005312)
print v(xbgr.mr_n55005744)
print v(xbgr.mr_n55006176)
print v(xbgr.mr_n55006608)
print v(xbgr.mr_n55007040)
print v(xbgr.mr_n55007472)
print v(xbgr.mr_n55007904)
print v(xbgr.mr_n55008336)
print v(xbgr.mr_n55008768)
print v(xbgr.mr_n55009200)
print v(xbgr.mr_n55009632)
print v(xbgr.mr_n55010064)
print v(xbgr.mr_n55010496)
print v(xbgr.mr_n55010928)
print v(xbgr.mr_n55011360)
print v(xbgr.mr_n55011792)
print v(xbgr.mr_n55012224)
print v(xbgr.mr_n55012656)
print v(xbgr.mr_n55013088)
print v(xbgr.mr_n55013520)
print v(xbgr.mr_n55013952)
print v(xbgr.mr_n55014384)
print v(xbgr.mr_n55014816)
print v(xbgr.mr_n55015248)
print v(xbgr.mr_n55016544)
print v(xbgr.mr_n55016976)
print v(xbgr.mr_n55017408)
print v(xbgr.mr_n55017840)
print v(xbgr.mr_n55018272)
print v(xbgr.mr_n55018704)
print v(xbgr.mr_n55019136)
print v(xbgr.mr_n55019568)
print v(xbgr.mr_n55020000)
print v(xbgr.mr_n55020432)
print v(xbgr.mr_n55020864)
print v(xbgr.mr_n55021296)
print v(xbgr.mr_n55023456)
print v(xbgr.mr_n55023888)
print v(xbgr.mr_n55024320)
print v(xbgr.mr_n55024752)
print v(xbgr.mr_n55025184)
print v(xbgr.mr_n55025616)
print v(xbgr.mr_n55026048)
print v(xbgr.mr_n55026480)
print v(xbgr.mr_n55026912)
print v(xbgr.mr_n55027344)
print v(xbgr.mr_n55028640)
print v(xbgr.mr_n55029072)
print v(xbgr.mr_n55029504)
print v(xbgr.mr_n55029936)
print v(xbgr.mr_n55030368)
print v(xbgr.mr_n55030800)
print v(xbgr.mr_n55031232)
print v(xbgr.mr_n55031664)
print v(xbgr.mr_n55032096)
print v(xbgr.mr_n55032528)
print v(xbgr.mr_n55032960)
print v(xbgr.mr_n55033392)
print v(xbgr.mr_n55034688)
print v(xbgr.mr_n55035120)
print v(xbgr.mr_n55036416)
print v(xbgr.mr_n55036848)
print v(xbgr.mr_n55037280)
print v(xbgr.mr_n55037712)
print v(xbgr.mr_n55038144)
print v(xbgr.mr_n55038576)
print v(xbgr.mr_n55039008)
print v(xbgr.mr_n55039440)
print v(xbgr.mr_n55040736)
print v(xbgr.mr_n55041168)
print v(xbgr.mr_n55041488)
print v(xbgr.mr_n55041600)
print v(xbgr.mr_n55041920)
print v(xbgr.mr_n55042032)
print v(xbgr.mr_n55042352)
print v(xbgr.mr_n55042464)
print v(xbgr.mr_n55042784)
print v(xbgr.mr_n55042896)
print v(xbgr.mr_n55043216)
print v(xbgr.mr_n55043328)
print v(xbgr.mr_n55043648)
print v(xbgr.mr_n55043760)
print v(xbgr.mr_n55044080)
print v(xbgr.mr_n55044192)
print v(xbgr.mr_n55044512)
print v(xbgr.mr_n55044624)
print v(xbgr.mr_n55045056)
print v(xbgr.mr_n55045488)
print v(xbgr.mr_n55045920)
print v(xbgr.mr_n55046352)
print v(xbgr.mr_n55046784)
print v(xbgr.mr_n55047216)
print v(xbgr.mr_n55047648)
print v(xbgr.mr_n55048080)
print v(xbgr.mr_n55048512)
print v(xbgr.mr_n55048944)
print v(xbgr.mr_n55049376)
print v(xbgr.mr_n55049808)
print v(xbgr.mr_n55050240)
print v(xbgr.mr_n55050672)
print v(xbgr.mr_n55051104)
print v(xbgr.mr_n55051536)
print v(xbgr.mr_n55051968)
print v(xbgr.mr_n55052400)
print v(xbgr.mr_n55052832)
print v(xbgr.mr_n55053264)
print v(xbgr.mr_n55053696)
print v(xbgr.mr_n55054128)
print v(xbgr.mr_n55054560)
print v(xbgr.mr_n55054992)
print v(xbgr.mr_n55055424)
print v(xbgr.mr_n55055856)
print v(xbgr.mr_n55056496)
print v(xbgr.mr_n55056928)
print v(xbgr.mr_n55057360)
print v(xbgr.mr_n55057792)
print v(xbgr.mr_n55058224)
print v(xbgr.mr_n55058656)
print v(xbgr.mr_n55059088)
print v(xbgr.mr_n55059520)
print v(xbgr.mr_n55059952)
print v(xbgr.mr_n55060384)
print v(xbgr.mr_n55060816)
print v(xbgr.mr_n55061248)
print v(xbgr.mr_n55061680)
print v(xbgr.mr_n55062112)
print v(xbgr.mr_n55062544)
print v(xbgr.mr_n55062976)
print v(xbgr.mr_n55063408)
print v(xbgr.mr_n55063840)
print v(xbgr.mr_n55064272)
print v(xbgr.mr_n55064704)
print v(xbgr.mr_n55065136)
print v(xbgr.mr_n55065568)
print v(xbgr.mr_n55066000)
print v(xbgr.mr_n55066432)
print v(xbgr.mr_n55066864)
print v(xbgr.mr_n55067296)
print v(xbgr.mr_n55067728)
print v(xbgr.mr_n55068160)
print v(xbgr.mr_n55068592)
print v(xbgr.mr_n55069024)
print v(xbgr.mr_n55069456)
print v(xbgr.mr_n55069888)
print v(xbgr.mr_n55070320)
print v(xbgr.mr_n55070752)
print v(xbgr.mr_n55071184)
print v(xbgr.mr_n55071616)
print v(xbgr.mr_n55072048)
print v(xbgr.mr_n55072480)
print v(xbgr.mr_n55072912)
print v(xbgr.mr_n55073344)
print v(xbgr.mr_n55073776)
print v(xbgr.mr_n55074208)
print v(xbgr.mr_n55074640)
print v(xbgr.mr_n55075072)
print v(xbgr.mr_n55075504)
print v(xbgr.mr_n55075936)
print v(xbgr.mr_n55076368)
print v(xbgr.mr_n55076800)
print v(xbgr.mr_n55077232)
print v(xbgr.mr_n55077664)
print v(xbgr.mr_n55078096)
print v(xbgr.mr_n55078528)
print v(xbgr.mr_n55078960)
print v(xbgr.mr_n55079392)
print v(xbgr.mr_n55079824)
print v(xbgr.mr_n55080256)
print v(xbgr.mr_n55080688)
print v(xbgr.mr_n55081120)
print v(xbgr.mr_n55081552)
print v(xbgr.mr_n55081984)
print v(xbgr.mr_n55082416)
print v(xbgr.mr_n55082848)
print v(xbgr.mr_n55083280)
print v(xbgr.mr_n55083712)
print v(xbgr.mr_n55084144)
print v(xbgr.mr_n55084576)
print v(xbgr.mr_n55085008)
print v(xbgr.mr_n55085440)
print v(xbgr.mr_n55085872)
print v(xbgr.mr_n55086304)
print v(xbgr.mr_n55086736)
print v(xbgr.mr_n55087168)
print v(xbgr.mr_n55087600)
print v(xbgr.mr_n55088032)
print v(xbgr.mr_n55088464)
print v(xbgr.mr_n55088896)
print v(xbgr.mr_n55089328)
print v(xbgr.mr_n55089760)
print v(xbgr.mr_n55090192)
print v(xbgr.mr_n55090624)
print v(xbgr.mr_n55091056)
print v(xbgr.mr_n55091488)
print v(xbgr.mr_n55091920)
print v(xbgr.mr_n55092352)
print v(xbgr.mr_n55092784)
print v(xbgr.mr_n55093104)
print v(xbgr.mr_n55093216)
print v(xbgr.mr_n55093536)
print v(xbgr.mr_n55093648)
print v(xbgr.mr_n55093968)
print v(xbgr.mr_n55094080)
print v(xbgr.mr_n55094400)
print v(xbgr.mr_n55094512)
print v(xbgr.mr_n55094944)
print v(xbgr.mr_n55095376)
print v(xbgr.mr_n55095808)
print v(xbgr.mr_n55096240)
print v(xbgr.mr_n55096672)
print v(xbgr.mr_n55097104)
print v(xbgr.mr_n55097536)
print v(xbgr.mr_n55097968)
print v(xbgr.mr_n55098400)
print v(xbgr.mr_n55098832)
print v(xbgr.mr_n55099264)
print v(xbgr.mr_n55099696)
print v(xbgr.mr_n55100128)
print v(xbgr.mr_n55100560)
print v(xbgr.mr_n55100992)
print v(xbgr.mr_n55101424)
print v(xbgr.mr_n55101856)
print v(xbgr.mr_n55102288)
print v(xbgr.mr_n55102720)
print v(xbgr.mr_n55103152)
print v(xbgr.mr_n55103584)
print v(xbgr.mr_n55104016)
print v(xbgr.mr_n55104448)
print v(xbgr.mr_n55104880)
print v(xbgr.mr_n55105312)
print v(xbgr.mr_n55105744)
print v(xbgr.mr_n55106176)
print v(xbgr.mr_n55106608)
print v(xbgr.mr_n55107040)
print v(xbgr.mr_n55107472)
print v(xbgr.mr_n55107904)
print v(xbgr.mr_n55108336)
print v(xbgr.mr_n55108768)
print v(xbgr.mr_n55109200)
print v(xbgr.mr_n55109632)
print v(xbgr.mr_n55110064)
print v(xbgr.mr_n55110496)
print v(xbgr.mr_n55110928)
print v(xbgr.mr_n55111360)
print v(xbgr.mr_n55111792)
print v(xbgr.mr_n55112224)
print v(xbgr.mr_n55112656)
print v(xbgr.mr_n55113088)
print v(xbgr.mr_n55113520)
print v(xbgr.mr_n55113952)
print v(xbgr.mr_n55114384)
print v(xbgr.mr_n55114816)
print v(xbgr.mr_n55115248)
print v(xbgr.mr_n55115680)
print v(xbgr.mr_n55116112)
print v(xbgr.mr_n55116544)
print v(xbgr.mr_n55116976)
print v(xbgr.mr_n55117408)
print v(xbgr.mr_n55117840)
print v(xbgr.mr_n55118272)
print v(xbgr.mr_n55118704)
print v(xbgr.mr_n55119136)
print v(xbgr.mr_n55119568)
print v(xbgr.mr_n55120000)
print v(xbgr.mr_n55120432)
print v(xbgr.mr_n55120864)
print v(xbgr.mr_n55121296)
print v(xbgr.mr_n55121728)
print v(xbgr.mr_n55122160)
print v(xbgr.mr_n55123456)
print v(xbgr.mr_n55123888)
print v(xbgr.mr_n55125184)
print v(xbgr.mr_n55125616)
print v(xbgr.mr_n55126912)
print v(xbgr.mr_n55127344)
print v(xbgr.mr_n55127776)
print v(xbgr.mr_n55128208)
print v(xbgr.mr_n55128640)
print v(xbgr.mr_n55129072)
print v(xbgr.mr_n55129504)
print v(xbgr.mr_n55129936)
print v(xbgr.mr_n55130368)
print v(xbgr.mr_n55130800)
print v(xbgr.mr_n55131232)
print v(xbgr.mr_n55131664)
print v(xbgr.mr_n55132096)
print v(xbgr.mr_n55132528)
print v(xbgr.mr_n55132960)
print v(xbgr.mr_n55133392)
print v(xbgr.mr_n55134688)
print v(xbgr.mr_n55135120)
print v(xbgr.mr_n55135552)
print v(xbgr.mr_n55135984)
print v(xbgr.mr_n55136416)
print v(xbgr.mr_n55136848)
print v(xbgr.mr_n55138144)
print v(xbgr.mr_n55138576)
print v(xbgr.mr_n55139008)
print v(xbgr.mr_n55139440)
print v(xbgr.mr_n55139872)
print v(xbgr.mr_n55140304)
print v(xbgr.mr_n55140736)
print v(xbgr.mr_n55141168)
print v(xbgr.mr_n55141600)
print v(xbgr.mr_n55142032)
print v(xbgr.mr_n55142464)
print v(xbgr.mr_n55142896)
print v(xbgr.mr_n55143328)
print v(xbgr.mr_n55143760)
print v(xbgr.mr_n55144192)
print v(xbgr.mr_n55144624)
print v(xbgr.mr_n55145056)
print v(xbgr.mr_n55145488)
print v(xbgr.mr_n55145920)
print v(xbgr.mr_n55146352)
print v(xbgr.mr_n55146784)
print v(xbgr.mr_n55147216)
print v(xbgr.mr_n55147648)
print v(xbgr.mr_n55148080)
print v(xbgr.mr_n55148512)
print v(xbgr.mr_n55148944)
print v(xbgr.mr_n55149376)
print v(xbgr.mr_n55149808)
print v(xbgr.mr_n55150240)
print v(xbgr.mr_n55150672)
print v(xbgr.mr_n55151104)
print v(xbgr.mr_n55151536)
print v(xbgr.mr_n55151968)
print v(xbgr.mr_n55152400)
print v(xbgr.mr_n55152832)
print v(xbgr.mr_n55153264)
print v(xbgr.mr_n55153696)
print v(xbgr.mr_n55154128)
print v(xbgr.mr_n55154560)
print v(xbgr.mr_n55154992)
print v(xbgr.mr_n55155424)
print v(xbgr.mr_n55155856)
print v(xbgr.mr_n55156288)
print v(xbgr.mr_n55156720)
print v(xbgr.mr_n55157152)
print v(xbgr.mr_n55157584)
print v(xbgr.mr_n55158016)
print v(xbgr.mr_n55158448)
print v(xbgr.mr_n55158880)
print v(xbgr.mr_n55159312)
print v(xbgr.mr_n55159744)
print v(xbgr.mr_n55160176)
print v(xbgr.mr_n55160608)
print v(xbgr.mr_n55161040)
print v(xbgr.mr_n55161472)
print v(xbgr.mr_n55161904)
print v(xbgr.mr_n55162336)
print v(xbgr.mr_n55162656)
print v(xbgr.mr_n55162768)
print v(xbgr.mr_n55163088)
print v(xbgr.mr_n55163200)
print v(xbgr.mr_n55163520)
print v(xbgr.mr_n55163632)
print v(xbgr.mr_n55163952)
print v(xbgr.mr_n55164064)
print v(xbgr.mr_n55164384)
print v(xbgr.mr_n55164496)
print v(xbgr.mr_n55164816)
print v(xbgr.mr_n55164928)
print v(xbgr.mr_n55165248)
print v(xbgr.mr_n55165360)
print v(xbgr.mr_n55165680)
print v(xbgr.mr_n55165792)
print v(xbgr.mr_n55166112)
print v(xbgr.mr_n55166224)
print v(xbgr.mr_n55166544)
print v(xbgr.mr_n55166656)
print v(xbgr.mr_n55166976)
print v(xbgr.mr_n55167088)
print v(xbgr.mr_n55167408)
print v(xbgr.mr_n55167520)
print v(xbgr.mr_n55167840)
print v(xbgr.mr_n55167952)
print v(xbgr.mr_n55168272)
print v(xbgr.mr_n55168384)
print v(xbgr.mr_n55168704)
print v(xbgr.mr_n55168816)
print v(xbgr.mr_n55169136)
print v(xbgr.mr_n55169248)
print v(xbgr.mr_n55169568)
print v(xbgr.mr_n55169680)
print v(xbgr.mr_n55170000)
print v(xbgr.mr_n55170112)
print v(xbgr.mr_n55170432)
print v(xbgr.mr_n55170544)
print v(xbgr.mr_n55170864)
print v(xbgr.mr_n55170976)
print v(xbgr.mr_n55171296)
print v(xbgr.mr_n55171408)
print v(xbgr.mr_n55171728)
print v(xbgr.mr_n55171840)
print v(xbgr.mr_n55172160)
print v(xbgr.mr_n55172272)
print v(xbgr.mr_n55172592)
print v(xbgr.mr_n55172704)
print v(xbgr.mr_n55173024)
print v(xbgr.mr_n55173136)
print v(xbgr.mr_n55173456)
print v(xbgr.mr_n55173568)
print v(xbgr.mr_n55173888)
print v(xbgr.mr_n55174000)
print v(xbgr.mr_n55174320)
print v(xbgr.mr_n55174432)
print v(xbgr.mr_n55174752)
print v(xbgr.mr_n55174864)
print v(xbgr.mr_n55175184)
print v(xbgr.mr_n55175296)
print v(xbgr.mr_n55175616)
print v(xbgr.mr_n55175728)
print v(xbgr.mr_n55176048)
print v(xbgr.mr_n55176160)
print v(xbgr.mr_n55176480)
print v(xbgr.mr_n55176592)
print v(xbgr.mr_n55176912)
print v(xbgr.mr_n55177024)
print v(xbgr.mr_n55177344)
print v(xbgr.mr_n55177456)
print v(xbgr.mr_n55177776)
print v(xbgr.mr_n55177888)
print v(xbgr.mr_n55178208)
print v(xbgr.mr_n55178320)
print v(xbgr.mr_n55178640)
print v(xbgr.mr_n55178752)
print v(xbgr.mr_n55179168)
print v(xbgr.mr_n55179600)
print v(xbgr.mr_n55180032)
print v(xbgr.mr_n55180464)
print v(xbgr.mr_n55180896)
print v(xbgr.mr_n55181328)
print v(xbgr.mr_n55181760)
print v(xbgr.mr_n55182192)
print v(xbgr.mr_n55182624)
print v(xbgr.mr_n55183056)
print v(xbgr.mr_n55183488)
print v(xbgr.mr_n55183920)
print v(xbgr.mr_n55184240)
print v(xbgr.mr_n55184352)
print v(xbgr.mr_n55184672)
print v(xbgr.mr_n55184784)
print v(xbgr.mr_n55185216)
print v(xbgr.mr_n55185648)
print v(xbgr.mr_n55186080)
print v(xbgr.mr_n55186512)
print v(xbgr.mr_n55186944)
print v(xbgr.mr_n55187376)
print v(xbgr.mr_n55187808)
print v(xbgr.mr_n55188240)
print v(xbgr.mr_n55188672)
print v(xbgr.mr_n55189104)
print v(xbgr.mr_n55189536)
print v(xbgr.mr_n55189968)
print v(xbgr.mr_n55190400)
print v(xbgr.mr_n55190832)
print v(xbgr.mr_n55191264)
print v(xbgr.mr_n55191696)
print v(xbgr.mr_n55192128)
print v(xbgr.mr_n55192560)
print v(xbgr.mr_n55192992)
print v(xbgr.mr_n55193424)
print v(xbgr.mr_n55193856)
print v(xbgr.mr_n55194288)
print v(xbgr.mr_n55194720)
print v(xbgr.mr_n55195152)
print v(xbgr.mr_n55195584)
print v(xbgr.mr_n55196016)
print v(xbgr.mr_n55196448)
print v(xbgr.mr_n55196880)
print v(xbgr.mr_n55197312)
print v(xbgr.mr_n55197744)
print v(xbgr.mr_n55198176)
print v(xbgr.mr_n55198608)
print v(xbgr.mr_n55199040)
print v(xbgr.mr_n55199472)
print v(xbgr.mr_n55199904)
print v(xbgr.mr_n55200336)
print v(xbgr.mr_n55200768)
print v(xbgr.mr_n55201200)
print v(xbgr.mr_n55201632)
print v(xbgr.mr_n55202064)
print v(xbgr.mr_n55202384)
print v(xbgr.mr_n55202496)
print v(xbgr.mr_n55202816)
print v(xbgr.mr_n55202928)
print v(xbgr.mr_n55203360)
print v(xbgr.mr_n55203680)
print v(xbgr.mr_n55203792)
print v(xbgr.mr_n55204224)
print v(xbgr.mr_n55204656)
print v(xbgr.mr_n55205088)
print v(xbgr.mr_n55205520)
print v(xbgr.mr_n55205952)
print v(xbgr.mr_n55206384)
print v(xbgr.mr_n55206816)
print v(xbgr.mr_n55207248)
print v(xbgr.mr_n55207680)
print v(xbgr.mr_n55208112)
print v(xbgr.mr_n55208544)
print v(xbgr.mr_n55208976)
print v(xbgr.mr_n55209408)
print v(xbgr.mr_n55209840)
print v(xbgr.mr_n55210272)
print v(xbgr.mr_n55210704)
print v(xbgr.mr_n55211136)
print v(xbgr.mr_n55211568)
print v(xbgr.mr_n55212000)
print v(xbgr.mr_n55212432)
print v(xbgr.mr_n55212864)
print v(xbgr.mr_n55213296)
print v(xbgr.mr_n55213728)
print v(xbgr.mr_n55214160)
print v(xbgr.mr_n55214592)
print v(xbgr.mr_n55215024)
print v(xbgr.mr_n55215456)
print v(xbgr.mr_n55215888)
print v(xbgr.mr_n55216320)
print v(xbgr.mr_n55216752)
print v(xbgr.mr_n55217184)
print v(xbgr.mr_n55217616)
print v(xbgr.mr_n55218048)
print v(xbgr.mr_n55218480)
print v(xbgr.mr_n55218912)
print v(xbgr.mr_n55219344)
print v(xbgr.mr_n55219776)
print v(xbgr.mr_n55220208)
print v(xbgr.mr_n55220640)
print v(xbgr.mr_n55221072)
print v(xbgr.mr_n55221504)
print v(xbgr.mr_n55221936)
print v(xbgr.mr_n55222368)
print v(xbgr.mr_n55222800)
print v(xbgr.mr_n55223232)
print v(xbgr.mr_n55223664)
print v(xbgr.mr_n55224096)
print v(xbgr.mr_n55224416)
print v(xbgr.mr_n55224528)
print v(xbgr.mr_n55224960)
print v(xbgr.mr_n55225392)
print v(xbgr.mr_n55225712)
print v(xbgr.mr_n55225824)
print v(xbgr.mr_n55226144)
print v(xbgr.mr_n55226256)
print v(xbgr.mr_n55226576)
print v(xbgr.mr_n55226688)
print v(xbgr.mr_n55227008)
print v(xbgr.mr_n55227120)
print v(xbgr.mr_n55227440)
print v(xbgr.mr_n55227552)
print v(xbgr.mr_n55227872)
print v(xbgr.mr_n55227984)
print v(xbgr.mr_n55228416)
print v(xbgr.mr_n55228736)
print v(xbgr.mr_n55228848)
print v(xbgr.mr_n55229168)
print v(xbgr.mr_n55229280)
print v(xbgr.mr_n55229600)
print v(xbgr.mr_n55229712)
print v(xbgr.mr_n55230032)
print v(xbgr.mr_n55230144)
print v(xbgr.mr_n55230464)
print v(xbgr.mr_n55230576)
print v(xbgr.mr_n55230896)
print v(xbgr.mr_n55231008)
print v(xbgr.mr_n55231440)
print v(xbgr.mr_n55231760)
print v(xbgr.mr_n55231872)
print v(xbgr.mr_n55232192)
print v(xbgr.mr_n55232304)
print v(xbgr.mr_n55232624)
print v(xbgr.mr_n55232736)
print v(xbgr.mr_n55233056)
print v(xbgr.mr_n55233168)
print v(xbgr.mr_n55233488)
print v(xbgr.mr_n55233600)
print v(xbgr.mr_n55233920)
print v(xbgr.mr_n55234032)
print v(xbgr.mr_n55234464)
print v(xbgr.mr_n55234784)
print v(xbgr.mr_n55234896)
print v(xbgr.mr_n55235216)
print v(xbgr.mr_n55235328)
print v(xbgr.mr_n55235648)
print v(xbgr.mr_n55235760)
print v(xbgr.mr_n55236192)
print v(xbgr.mr_n55236512)
print v(xbgr.mr_n55236624)
print v(xbgr.mr_n55237056)
print v(xbgr.mr_n55237488)
print v(xbgr.mr_n55237920)
print v(xbgr.mr_n55238352)
print v(xbgr.mr_n55239648)
print v(xbgr.mr_n55240080)
print v(xbgr.mr_n55241376)
print v(xbgr.mr_n55241808)
print v(xbgr.mr_n55242128)
print v(xbgr.mr_n55242240)
print v(xbgr.mr_n55242560)
print v(xbgr.mr_n55242672)
print v(xbgr.mr_n55242992)
print v(xbgr.mr_n55243104)
print v(xbgr.mr_n55243424)
print v(xbgr.mr_n55243968)
print v(xbgr.mr_n55244720)
print v(xbgr.mr_n55244832)
print v(xbgr.mr_n55245152)
print v(xbgr.mr_n55247424)
print v(xbgr.mr_n55248288)
print v(xbgr.mr_n55249152)
print v(xbgr.mr_n55249584)
print v(xbgr.mr_n55250016)
print v(xbgr.mr_n55250448)
print v(xbgr.mr_n55252496)
print v(xbgr.mr_n55252608)
print v(xbgr.mr_n55253040)
print v(xbgr.mr_n55253360)
print v(xbgr.mr_n55253472)
print v(xbgr.mr_n55253792)
print v(xbgr.mr_n55253904)
print v(xbgr.mr_n55254336)
print v(xbgr.mr_n55254656)
print v(xbgr.mr_n55254768)
print v(xbgr.mr_n55255088)
print v(xbgr.mr_n55255200)
print v(xbgr.mr_n55255520)
print v(xbgr.mr_n55255632)
print v(xbgr.mr_n55256064)
print v(xbgr.mr_n55256384)
print v(xbgr.mr_n55256496)
print v(xbgr.mr_n55256816)
print v(xbgr.mr_n55256928)
print v(xbgr.mr_n55257248)
print v(xbgr.mr_n55257360)
print v(xbgr.mr_n55257792)
print v(xbgr.mr_n55258112)
print v(xbgr.mr_n55258224)
print v(xbgr.mr_n55258544)
print v(xbgr.mr_n55258656)
print v(xbgr.mr_n55258976)
print v(xbgr.mr_n55259088)
print v(xbgr.mr_n55259408)
print v(xbgr.mr_n55259520)
print v(xbgr.mr_n55259840)
print v(xbgr.mr_n55259952)
print v(xbgr.mr_n55260384)
print v(xbgr.mr_n55260704)
print v(xbgr.mr_n55260816)
print v(xbgr.mr_n55261136)
print v(xbgr.mr_n55261248)
print v(xbgr.mr_n55261568)
print v(xbgr.mr_n55261680)
print v(xbgr.mr_n55262000)
print v(xbgr.mr_n55262112)
print v(xbgr.mr_n55262544)
print v(xbgr.mr_n55262864)
print v(xbgr.mr_n55262976)
print v(xbgr.mr_n55263296)
print v(xbgr.mr_n55263408)
print v(xbgr.mr_n55263840)
print v(xbgr.mr_n55264160)
print v(xbgr.mr_n55264272)
print v(xbgr.mr_n55264592)
print v(xbgr.mr_n55264704)
print v(xbgr.mr_n55265024)
print v(xbgr.mr_n55265136)
print v(xbgr.mr_n55265568)
print v(xbgr.mr_n55265888)
print v(xbgr.mr_n55266000)
print v(xbgr.mr_n55266320)
print v(xbgr.mr_n55266432)
print v(xbgr.mr_n55266752)
print v(xbgr.mr_n55266864)
print v(xbgr.mr_n55267296)
print v(xbgr.mr_n55267616)
print v(xbgr.mr_n55267728)
print v(xbgr.mr_n55268048)
print v(xbgr.mr_n55268160)
print v(xbgr.mr_n55268480)
print v(xbgr.mr_n55268592)
print v(xbgr.mr_n55268912)
print v(xbgr.mr_n55269024)
print v(xbgr.mr_n55269344)
print v(xbgr.mr_n55269456)
print v(xbgr.mr_n55269776)
print v(xbgr.mr_n55269888)
print v(xbgr.mr_n55270208)
print v(xbgr.mr_n55270320)
print v(xbgr.mr_n55270640)
print v(xbgr.mr_n55270752)
print v(xbgr.mr_n55271072)
print v(xbgr.mr_n55271184)
print v(xbgr.mr_n55271504)
print v(xbgr.mr_n55271616)
print v(xbgr.mr_n55271936)
print v(xbgr.mr_n55272048)
print v(xbgr.mr_n55272368)
print v(xbgr.mr_n55272480)
print v(xbgr.mr_n55272800)
print v(xbgr.mr_n55272912)
print v(xbgr.mr_n55273344)
print v(xbgr.mr_n55273664)
print v(xbgr.mr_n55273776)
print v(xbgr.mr_n55274096)
print v(xbgr.mr_n55274208)
print v(xbgr.mr_n55274528)
print v(xbgr.mr_n55274640)
print v(xbgr.mr_n55274960)
print v(xbgr.mr_n55275072)
print v(xbgr.mr_n55275392)
print v(xbgr.mr_n55275504)
print v(xbgr.mr_n55275824)
print v(xbgr.mr_n55275936)
print v(xbgr.mr_n55276256)
print v(xbgr.mr_n55276368)
print v(xbgr.mr_n55276688)
print v(xbgr.mr_n55276800)
print v(xbgr.mr_n55277120)
print v(xbgr.mr_n55277232)
print v(xbgr.mr_n55277552)
print v(xbgr.mr_n55277664)
print v(xbgr.mr_n55278096)
print v(xbgr.mr_n55278416)
print v(xbgr.mr_n55278528)
print v(xbgr.mr_n55278848)
print v(xbgr.mr_n55278960)
print v(xbgr.mr_n55279280)
print v(xbgr.mr_n55279392)
print v(xbgr.mr_n55279712)
print v(xbgr.mr_n55279824)
print v(xbgr.mr_n55280144)
print v(xbgr.mr_n55280256)
print v(xbgr.mr_n55280576)
print v(xbgr.mr_n55280688)
print v(xbgr.mr_n55281008)
print v(xbgr.mr_n55281120)
print v(xbgr.mr_n55281440)
print v(xbgr.mr_n55281552)
print v(xbgr.mr_n55281872)
print v(xbgr.mr_n55281984)
print v(xbgr.mr_n55282304)
print v(xbgr.mr_n55282416)
print v(xbgr.mr_n55282736)
print v(xbgr.mr_n55282848)
print v(xbgr.mr_n55283168)
print v(xbgr.mr_n55283280)
print v(xbgr.mr_n55283600)
print v(xbgr.mr_n55283712)
print v(xbgr.mr_n55284032)
print v(xbgr.mr_n55284144)
print v(xbgr.mr_n55284464)
print v(xbgr.mr_n55284576)
print v(xbgr.mr_n55284896)
print v(xbgr.mr_n55285008)
print v(xbgr.mr_n55285440)
print v(xbgr.mr_n55285760)
print v(xbgr.mr_n55285872)
print v(xbgr.mr_n55286192)
print v(xbgr.mr_n55286304)
print v(xbgr.mr_n55286624)
print v(xbgr.mr_n55286736)
print v(xbgr.mr_n55287056)
print v(xbgr.mr_n55287168)
print v(xbgr.mr_n55287488)
print v(xbgr.mr_n55287600)
print v(xbgr.mr_n55287920)
print v(xbgr.mr_n55288032)
print v(xbgr.mr_n55288352)
print v(xbgr.mr_n55288464)
print v(xbgr.mr_n55288784)
print v(xbgr.mr_n55288896)
print v(xbgr.mr_n55289216)
print v(xbgr.mr_n55289328)
print v(xbgr.mr_n55289648)
print v(xbgr.mr_n55289760)
print v(xbgr.mr_n55290080)
print v(xbgr.mr_n55290192)
print v(xbgr.mr_n55290512)
print v(xbgr.mr_n55290624)
print v(xbgr.mr_n55291056)
print v(xbgr.mr_n55291376)
print v(xbgr.mr_n55291488)
print v(xbgr.mr_n55291808)
print v(xbgr.mr_n55291920)
print v(xbgr.mr_n55292240)
print v(xbgr.mr_n55292352)
print v(xbgr.mr_n55292672)
print v(xbgr.mr_n55292784)
print v(xbgr.mr_n55293104)
print v(xbgr.mr_n55293216)
print v(xbgr.mr_n55293536)
print v(xbgr.mr_n55293648)
print v(xbgr.mr_n55293968)
print v(xbgr.mr_n55294080)
print v(xbgr.mr_n55294400)
print v(xbgr.mr_n55294512)
print v(xbgr.mr_n55294832)
print v(xbgr.mr_n55294944)
print v(xbgr.mr_n55295264)
print v(xbgr.mr_n55295376)
print v(xbgr.mr_n55295696)
print v(xbgr.mr_n55295808)
print v(xbgr.mr_n55296128)
print v(xbgr.mr_n55296240)
print v(xbgr.mr_n55296560)
print v(xbgr.mr_n55296672)
print v(xbgr.mr_n55296992)
print v(xbgr.mr_n55297104)
print v(xbgr.mr_n55297424)
print v(xbgr.mr_n55297536)
print v(xbgr.mr_n55297856)
print v(xbgr.mr_n55297968)
print v(xbgr.mr_n55298288)
print v(xbgr.mr_n55298400)
print v(xbgr.mr_n55298720)
print v(xbgr.mr_n55298832)
print v(xbgr.mr_n55299152)
print v(xbgr.mr_n55299264)
print v(xbgr.mr_n55299584)
print v(xbgr.mr_n55299696)
print v(xbgr.mr_n55300128)
print v(xbgr.mr_n55300448)
print v(xbgr.mr_n55300560)
print v(xbgr.mr_n55300880)
print v(xbgr.mr_n55300992)
print v(xbgr.mr_n55301312)
print v(xbgr.mr_n55301424)
print v(xbgr.mr_n55301744)
print v(xbgr.mr_n55301856)
print v(xbgr.mr_n55302176)
print v(xbgr.mr_n55302288)
print v(xbgr.mr_n55302608)
print v(xbgr.mr_n55302720)
print v(xbgr.mr_n55303040)
print v(xbgr.mr_n55303152)
print v(xbgr.mr_n55303472)
print v(xbgr.mr_n55303584)
print v(xbgr.mr_n55303904)
print v(xbgr.mr_n55304016)
print v(xbgr.mr_n55304336)
print v(xbgr.mr_n55304448)
print v(xbgr.mr_n55304768)
print v(xbgr.mr_n55304880)
print v(xbgr.mr_n55305200)
print v(xbgr.mr_n55305312)
print v(xbgr.mr_n55305632)
print v(xbgr.mr_n55305744)
print v(xbgr.mr_n55306064)
print v(xbgr.mr_n55306176)
print v(xbgr.mr_n55306496)
print v(xbgr.mr_n55306608)
print v(xbgr.mr_n55306928)
print v(xbgr.mr_n55307040)
print v(xbgr.mr_n55307360)
print v(xbgr.mr_n55307472)
print v(xbgr.mr_n55307792)
print v(xbgr.mr_n55307904)
print v(xbgr.mr_n55308224)
print v(xbgr.mr_n55308336)
print v(xbgr.mr_n55308656)
print v(xbgr.mr_n55308768)
print v(xbgr.mr_n55309088)
print v(xbgr.mr_n55309200)
print v(xbgr.mr_n55309520)
print v(xbgr.mr_n55309632)
print v(xbgr.mr_n55310064)
print v(xbgr.mr_n55310384)
print v(xbgr.mr_n55310496)
print v(xbgr.mr_n55310816)
print v(xbgr.mr_n55310928)
print v(xbgr.mr_n55311248)
print v(xbgr.mr_n55311360)
print v(xbgr.mr_n55311680)
print v(xbgr.mr_n55311792)
print v(xbgr.mr_n55312112)
print v(xbgr.mr_n55312224)
print v(xbgr.mr_n55312544)
print v(xbgr.mr_n55312656)
print v(xbgr.mr_n55312976)
print v(xbgr.mr_n55313088)
print v(xbgr.mr_n55313408)
print v(xbgr.mr_n55313520)
print v(xbgr.mr_n55313840)
print v(xbgr.mr_n55313952)
print v(xbgr.mr_n55314272)
print v(xbgr.mr_n55314384)
print v(xbgr.mr_n55314704)
print v(xbgr.mr_n55314816)
print v(xbgr.mr_n55315136)
print v(xbgr.mr_n55315248)
print v(xbgr.mr_n55315680)
print v(xbgr.mr_n55316112)
print v(xbgr.mr_n55316544)
print v(xbgr.mr_n55316976)
print v(xbgr.mr_n55317408)
print v(xbgr.mr_n55317840)
print v(xbgr.mr_n55318272)
print v(xbgr.mr_n55318704)
print v(xbgr.mr_n55319136)
print v(xbgr.mr_n55319568)
print v(xbgr.mr_n55320000)
print v(xbgr.mr_n55320432)
print v(xbgr.mr_n55320864)
print v(xbgr.mr_n55321296)
print v(xbgr.mr_n55321728)
print v(xbgr.mr_n55322160)
print v(xbgr.mr_n55322592)
print v(xbgr.mr_n55323024)
print v(xbgr.mr_n55323456)
print v(xbgr.mr_n55323888)
print v(xbgr.mr_n55324320)
print v(xbgr.mr_n55324752)
print v(xbgr.mr_n55325184)
print v(xbgr.mr_n55325616)
print v(xbgr.mr_n55326048)
print v(xbgr.mr_n55326480)
print v(xbgr.mr_n55326912)
print v(xbgr.mr_n55327344)
print v(xbgr.mr_n55327776)
print v(xbgr.mr_n55328208)
print v(xbgr.mr_n55328640)
print v(xbgr.mr_n55329072)
print v(xbgr.mr_n55329504)
print v(xbgr.mr_n55329936)
print v(xbgr.mr_n55330368)
print v(xbgr.mr_n55330800)
print v(xbgr.mr_n55331232)
print v(xbgr.mr_n55331664)
print v(xbgr.mr_n55332096)
print v(xbgr.mr_n55332528)
print v(xbgr.mr_n55332960)
print v(xbgr.mr_n55333392)
print v(xbgr.mr_n55333824)
print v(xbgr.mr_n55334256)
print v(xbgr.mr_n55334688)
print v(xbgr.mr_n55335120)
print v(xbgr.mr_n55335552)
print v(xbgr.mr_n55335984)
print v(xbgr.mr_n55336416)
print v(xbgr.mr_n55336848)
print v(xbgr.mr_n55337280)
print v(xbgr.mr_n55337712)
print v(xbgr.mr_n55338144)
print v(xbgr.mr_n55338576)
print v(xbgr.mr_n55339008)
print v(xbgr.mr_n55339440)
print v(xbgr.mr_n55339872)
print v(xbgr.mr_n55340304)
print v(xbgr.mr_n55340736)
print v(xbgr.mr_n55341168)
print v(xbgr.mr_n55341600)
print v(xbgr.mr_n55342032)
print v(xbgr.mr_n55342464)
print v(xbgr.mr_n55342896)
print v(xbgr.mr_n55343328)
print v(xbgr.mr_n55343760)
print v(xbgr.mr_n55344192)
print v(xbgr.mr_n55344624)
print v(xbgr.mr_n55345056)
print v(xbgr.mr_n55345488)
print v(xbgr.mr_n55345920)
print v(xbgr.mr_n55346352)
print v(xbgr.mr_n55346784)
print v(xbgr.mr_n55347216)
print v(xbgr.mr_n55347648)
print v(xbgr.mr_n55348080)
print v(xbgr.mr_n55348512)
print v(xbgr.mr_n55348944)
print v(xbgr.mr_n55349376)
print v(xbgr.mr_n55349808)
print v(xbgr.mr_n55350240)
print v(xbgr.mr_n55350672)
print v(xbgr.mr_n55351104)
print v(xbgr.mr_n55351536)
print v(xbgr.mr_n55351968)
print v(xbgr.mr_n55352400)
print v(xbgr.mr_n55352832)
print v(xbgr.mr_n55353264)
print v(xbgr.mr_n55353696)
print v(xbgr.mr_n55354128)
print v(xbgr.mr_n55354560)
print v(xbgr.mr_n55354992)
print v(xbgr.mr_n55355424)
print v(xbgr.mr_n55355856)
print v(xbgr.mr_n55356288)
print v(xbgr.mr_n55356720)
print v(xbgr.mr_n55357152)
print v(xbgr.mr_n55357584)
print v(xbgr.mr_n55358016)
print v(xbgr.mr_n55358448)
print v(xbgr.mr_n55358880)
print v(xbgr.mr_n55359312)
print v(xbgr.mr_n55359744)
print v(xbgr.mr_n55360176)
print v(xbgr.mr_n55360608)
print v(xbgr.mr_n55361040)
print v(xbgr.mr_n55361472)
print v(xbgr.mr_n55361904)
print v(xbgr.mr_n55362336)
print v(xbgr.mr_n55362768)
print v(xbgr.mr_n55363088)
print v(xbgr.mr_n55363200)
print v(xbgr.mr_n55363520)
print v(xbgr.mr_n55363632)
print v(xbgr.mr_n55363952)
print v(xbgr.mr_n55364064)
print v(xbgr.mr_n55364384)
print v(xbgr.mr_n55364496)
print v(xbgr.mr_n55364816)
print v(xbgr.mr_n55364928)
print v(xbgr.mr_n55365248)
print v(xbgr.mr_n55365360)
print v(xbgr.mr_n55365680)
print v(xbgr.mr_n55365792)
print v(xbgr.mr_n55366112)
print v(xbgr.mr_n55366224)
print v(xbgr.mr_n55366544)
print v(xbgr.mr_n55366656)
print v(xbgr.mr_n55366976)
print v(xbgr.mr_n55367088)
print v(xbgr.mr_n55367408)
print v(xbgr.mr_n55367520)
print v(xbgr.mr_n55367840)
print v(xbgr.mr_n55367952)
print v(xbgr.mr_n55368272)
print v(xbgr.mr_n55368384)
print v(xbgr.mr_n55368704)
print v(xbgr.mr_n55368816)
print v(xbgr.mr_n55369136)
print v(xbgr.mr_n55369248)
print v(xbgr.mr_n55369568)
print v(xbgr.mr_n55369680)
print v(xbgr.mr_n55370000)
print v(xbgr.mr_n55370112)
print v(xbgr.mr_n55370432)
print v(xbgr.mr_n55370544)
print v(xbgr.mr_n55370864)
print v(xbgr.mr_n55370976)
print v(xbgr.mr_n55371296)
print v(xbgr.mr_n55371408)
print v(xbgr.mr_n55371728)
print v(xbgr.mr_n55371840)
print v(xbgr.mr_n55372160)
print v(xbgr.mr_n55372272)
print v(xbgr.mr_n55372592)
print v(xbgr.mr_n55372704)
print v(xbgr.mr_n55373024)
print v(xbgr.mr_n55373136)
print v(xbgr.mr_n55373456)
print v(xbgr.mr_n55373568)
print v(xbgr.mr_n55373888)
print v(xbgr.mr_n55374000)
print v(xbgr.mr_n55374320)
print v(xbgr.mr_n55374432)
print v(xbgr.mr_n55374752)
print v(xbgr.mr_n55374864)
print v(xbgr.mr_n55375184)
print v(xbgr.mr_n55375296)
print v(xbgr.mr_n55375616)
print v(xbgr.mr_n55375728)
print v(xbgr.mr_n55376048)
print v(xbgr.mr_n55376160)
print v(xbgr.mr_n55376480)
print v(xbgr.mr_n55376592)
print v(xbgr.mr_n55376912)
print v(xbgr.mr_n55377024)
print v(xbgr.mr_n55377344)
print v(xbgr.mr_n55377456)
print v(xbgr.mr_n55377776)
print v(xbgr.mr_n55377888)
print v(xbgr.mr_n55378208)
print v(xbgr.mr_n55378320)
print v(xbgr.mr_n55378640)
print v(xbgr.mr_n55378752)
print v(xbgr.mr_n55379072)
print v(xbgr.mr_n55379184)
print v(xbgr.mr_n55379504)
print v(xbgr.mr_n55379616)
print v(xbgr.mr_n55379936)
print v(xbgr.mr_n55380048)
print v(xbgr.mr_n55380368)
print v(xbgr.mr_n55380480)
print v(xbgr.mr_n55380800)
print v(xbgr.mr_n55380912)
print v(xbgr.mr_n55381232)
print v(xbgr.mr_n55381344)
print v(xbgr.mr_n55381664)
print v(xbgr.mr_n55381776)
print v(xbgr.mr_n55382096)
print v(xbgr.mr_n55382208)
print v(xbgr.mr_n55382528)
print v(xbgr.mr_n55382640)
print v(xbgr.mr_n55382960)
print v(xbgr.mr_n55383072)
print v(xbgr.mr_n55383392)
print v(xbgr.mr_n55383504)
print v(xbgr.mr_n55383824)
print v(xbgr.mr_n55383936)
print v(xbgr.mr_n55384256)
print v(xbgr.mr_n55384368)
print v(xbgr.mr_n55384800)
print v(xbgr.mr_n55385120)
print v(xbgr.mr_n55385232)
print v(xbgr.mr_n55385552)
print v(xbgr.mr_n55385664)
print v(xbgr.mr_n55385984)
print v(xbgr.mr_n55386096)
print v(xbgr.mr_n55386416)
print v(xbgr.mr_n55386528)
print v(xbgr.mr_n55386848)
print v(xbgr.mr_n55386960)
print v(xbgr.mr_n55387280)
print v(xbgr.mr_n55387392)
print v(xbgr.mr_n55387712)
print v(xbgr.mr_n55387824)
print v(xbgr.mr_n55388144)
print v(xbgr.mr_n55388256)
print v(xbgr.mr_n55388576)
print v(xbgr.mr_n55388688)
print v(xbgr.mr_n55389008)
print v(xbgr.mr_n55389120)
print v(xbgr.mr_n55389440)
print v(xbgr.mr_n55389552)
print v(xbgr.mr_n55389872)
print v(xbgr.mr_n55389984)
print v(xbgr.mr_n55390304)
print v(xbgr.mr_n55390416)
print v(xbgr.mr_n55390736)
print v(xbgr.mr_n55390848)
print v(xbgr.mr_n55391168)
print v(xbgr.mr_n55391280)
print v(xbgr.mr_n55391600)
print v(xbgr.mr_n55391712)
print v(xbgr.mr_n55392160)
print v(xbgr.mr_n55392272)
print v(xbgr.mr_n55392592)
print v(xbgr.mr_n55392704)
print v(xbgr.mr_n55393024)
print v(xbgr.mr_n55393136)
print v(xbgr.mr_n55393456)
print v(xbgr.mr_n55393568)
print v(xbgr.mr_n55393888)
print v(xbgr.mr_n55394000)
print v(xbgr.mr_n55394320)
print v(xbgr.mr_n55394432)
print v(xbgr.mr_n55394752)
print v(xbgr.mr_n55394864)
print v(xbgr.mr_n55395184)
print v(xbgr.mr_n55395296)
print v(xbgr.mr_n55395616)
print v(xbgr.mr_n55395728)
print v(xbgr.mr_n55396048)
print v(xbgr.mr_n55396160)
print v(xbgr.mr_n55396480)
print v(xbgr.mr_n55396592)
print v(xbgr.mr_n55396912)
print v(xbgr.mr_n55397024)
print v(xbgr.mr_n55397344)
print v(xbgr.mr_n55397456)
print v(xbgr.mr_n55397776)
print v(xbgr.mr_n55397888)
print v(xbgr.mr_n55398208)
print v(xbgr.mr_n55398320)
print v(xbgr.mr_n55398640)
print v(xbgr.mr_n55398752)
print v(xbgr.mr_n55399184)
print v(xbgr.mr_n55399616)
print v(xbgr.mr_n55399936)
print v(xbgr.mr_n55400048)
print v(xbgr.mr_n55400368)
print v(xbgr.mr_n55400480)
print v(xbgr.mr_n55400800)
print v(xbgr.mr_n55400912)
print v(xbgr.mr_n55401232)
print v(xbgr.mr_n55401344)
print v(xbgr.mr_n55401664)
print v(xbgr.mr_n55401776)
print v(xbgr.mr_n55402096)
print v(xbgr.mr_n55402208)
print v(xbgr.mr_n55402640)
print v(xbgr.mr_n55402960)
print v(xbgr.mr_n55403072)
print v(xbgr.mr_n55403392)
print v(xbgr.mr_n55403504)
print v(xbgr.mr_n55403824)
print v(xbgr.mr_n55403936)
print v(xbgr.mr_n55404256)
print v(xbgr.mr_n55404368)
print v(xbgr.mr_n55404688)
print v(xbgr.mr_n55404800)
print v(xbgr.mr_n55405120)
print v(xbgr.mr_n55405232)
print v(xbgr.mr_n55405552)
print v(xbgr.mr_n55405664)
print v(xbgr.mr_n55405984)
print v(xbgr.mr_n55406096)
print v(xbgr.mr_n55406416)
print v(xbgr.mr_n55406528)
print v(xbgr.mr_n55406848)
print v(xbgr.mr_n55406960)
print v(xbgr.mr_n55407280)
print v(xbgr.mr_n55407392)
print v(xbgr.mr_n55407712)
print v(xbgr.mr_n55407824)
print v(xbgr.mr_n55408256)
print v(xbgr.mr_n55408688)
print v(xbgr.mr_n55409120)
print v(xbgr.mr_n55409552)
print v(xbgr.mr_n55410048)
print v(xbgr.mr_n55410160)
print v(xbgr.mr_n55410496)
print v(xbgr.mr_n55410608)
print v(xbgr.mr_n55410928)
print v(xbgr.mr_n55411040)
print v(xbgr.mr_n55411408)
print v(xbgr.mr_n55411520)
print v(xbgr.mr_n55411840)
print v(xbgr.mr_n55411952)
print v(xbgr.mr_n55412272)
print v(xbgr.mr_n55412384)
print v(xbgr.mr_n55412624)
print v(xbgr.mr_n55412736)
print v(xbgr.mr_n55413056)
print v(xbgr.mr_n55413168)
print v(xbgr.mr_n55413488)
print v(xbgr.mr_n55413600)
print v(xbgr.mr_n55413920)
print v(xbgr.mr_n55414032)
print v(xbgr.mr_n55414352)
print v(xbgr.mr_n55414464)
print v(xbgr.mr_n55414784)
print v(xbgr.mr_n55414896)
print v(xbgr.mr_n55415216)
print v(xbgr.mr_n55415328)
print v(xbgr.mr_n55415648)
print v(xbgr.mr_n55415760)
print v(xbgr.mr_n55416080)
print v(xbgr.mr_n55416192)
print v(xbgr.mr_n55416512)
print v(xbgr.mr_n55416624)
print v(xbgr.mr_n55416944)
print v(xbgr.mr_n55417056)
print v(xbgr.mr_n55417376)
print v(xbgr.mr_n55417488)
print v(xbgr.mr_n55417808)
print v(xbgr.mr_n55417920)
print v(xbgr.mr_n55418240)
print v(xbgr.mr_n55418352)
print v(xbgr.mr_n55418672)
print v(xbgr.mr_n55418784)
print v(xbgr.mr_n55419104)
print v(xbgr.mr_n55419216)
print v(xbgr.mr_n55419536)
print v(xbgr.mr_n55419648)
print v(xbgr.mr_n55419968)
print v(xbgr.mr_n55420080)
print v(xbgr.mr_n55420400)
print v(xbgr.mr_n55420512)
print v(xbgr.mr_n55420832)
print v(xbgr.mr_n55420944)
print v(xbgr.mr_n55421264)
print v(xbgr.mr_n55421376)
print v(xbgr.mr_n55421696)
print v(xbgr.mr_n55421808)
print v(xbgr.mr_n55422128)
print v(xbgr.mr_n55422240)
print v(xbgr.mr_n55422560)
print v(xbgr.mr_n55422672)
print v(xbgr.mr_n55422992)
print v(xbgr.mr_n55423104)
print v(xbgr.mr_n55423536)
print v(xbgr.mr_n55423856)
print v(xbgr.mr_n55424848)
print v(xbgr.mr_n55424960)
print v(xbgr.mr_n55425280)
print v(xbgr.mr_n55425392)
print v(xbgr.mr_n55425712)
print v(xbgr.mr_n55425824)
print v(xbgr.mr_n55426256)
print v(xbgr.mr_n55426576)
print v(xbgr.mr_n55426688)
print v(xbgr.mr_n55427008)
print v(xbgr.mr_n55427120)
print v(xbgr.mr_n55427440)
print v(xbgr.mr_n55427552)
print v(xbgr.mr_n55427872)
print v(xbgr.mr_n55427984)
print v(xbgr.mr_n55428304)
print v(xbgr.mr_n55428416)
print v(xbgr.mr_n55428848)
print v(xbgr.mr_n55429280)
print v(xbgr.mr_n55429712)
print v(xbgr.mr_n55430144)
print v(xbgr.mr_n55430464)
print v(xbgr.mr_n55430576)
print v(xbgr.mr_n55430896)
print v(xbgr.mr_n55431008)
print v(xbgr.mr_n55431328)
print v(xbgr.mr_n55431440)
print v(xbgr.mr_n55431872)
print v(xbgr.mr_n55432304)
print v(xbgr.mr_n55432624)
print v(xbgr.mr_n55432736)
print v(xbgr.mr_n55433056)
print v(xbgr.mr_n55433168)
print v(xbgr.mr_n55433488)
print v(xbgr.mr_n55433600)
print v(xbgr.mr_n55433920)
print v(xbgr.mr_n55434032)
print v(xbgr.mr_n55434464)
print v(xbgr.mr_n55434896)
print v(xbgr.mr_n55435328)
print v(xbgr.mr_n55435760)
print v(xbgr.mr_n55436192)
print v(xbgr.mr_n55436512)
print v(xbgr.mr_n55436624)
print v(xbgr.mr_n55436944)
print v(xbgr.mr_n55437056)
print v(xbgr.mr_n55437376)
print v(xbgr.mr_n55437488)
print v(xbgr.mr_n55437808)
print v(xbgr.mr_n55437920)
print v(xbgr.mr_n55438240)
print v(xbgr.mr_n55438352)
print v(xbgr.mr_n55438672)
print v(xbgr.mr_n55438784)
print v(xbgr.mr_n55439104)
print v(xbgr.mr_n55439216)
print v(xbgr.mr_n55439536)
print v(xbgr.mr_n55439648)
print v(xbgr.mr_n55439968)
print v(xbgr.mr_n55440080)
print v(xbgr.mr_n55440400)
print v(xbgr.mr_n55440512)
print v(xbgr.mr_n55440832)
print v(xbgr.mr_n55440944)
print v(xbgr.mr_n55441264)
print v(xbgr.mr_n55441376)
print v(xbgr.mr_n55441808)
print v(xbgr.mr_n55442128)
print v(xbgr.mr_n55442240)
print v(xbgr.mr_n55442560)
print v(xbgr.mr_n55442672)
print v(xbgr.mr_n55442992)
print v(xbgr.mr_n55443104)
print v(xbgr.mr_n55443424)
print v(xbgr.mr_n55443536)
print v(xbgr.mr_n55443856)
print v(xbgr.mr_n55443968)
print v(xbgr.mr_n55444400)
print v(xbgr.mr_n55444832)
print v(xbgr.mr_n55445264)
print v(xbgr.mr_n55445696)
print v(xbgr.mr_n55446016)
print v(xbgr.mr_n55446128)
print v(xbgr.mr_n55446448)
print v(xbgr.mr_n55446560)
print v(xbgr.mr_n55446880)
print v(xbgr.mr_n55446992)
print v(xbgr.mr_n55447312)
print v(xbgr.mr_n55447424)
print v(xbgr.mr_n55447744)
print v(xbgr.mr_n55447856)
print v(xbgr.mr_n55448176)
print v(xbgr.mr_n55448288)
print v(xbgr.mr_n55448608)
print v(xbgr.mr_n55448720)
print v(xbgr.mr_n55449040)
print v(xbgr.mr_n55449152)
print v(xbgr.mr_n55449472)
print v(xbgr.mr_n55449584)
print v(xbgr.mr_n55449904)
print v(xbgr.mr_n55450016)
print v(xbgr.mr_n55450336)
print v(xbgr.mr_n55450448)
print v(xbgr.mr_n55450768)
print v(xbgr.mr_n55450880)
print v(xbgr.mr_n55451200)
print v(xbgr.mr_n55451312)
print v(xbgr.mr_n55451632)
print v(xbgr.mr_n55451744)
print v(xbgr.mr_n55452064)
print v(xbgr.mr_n55452176)
print v(xbgr.mr_n55452496)
print v(xbgr.mr_n55452608)
print v(xbgr.mr_n55452928)
print v(xbgr.mr_n55453040)
print v(xbgr.mr_n55453360)
print v(xbgr.mr_n55453472)
print v(xbgr.mr_n55453792)
print v(xbgr.mr_n55453904)
print v(xbgr.mr_n55454224)
print v(xbgr.mr_n55454336)
print v(xbgr.mr_n55454656)
print v(xbgr.mr_n55454768)
print v(xbgr.mr_n55455088)
print v(xbgr.mr_n55455200)
print v(xbgr.mr_n55455520)
print v(xbgr.mr_n55455632)
print v(xbgr.mr_n55455952)
print v(xbgr.mr_n55456064)
print v(xbgr.mr_n55456384)
print v(xbgr.mr_n55456496)
print v(xbgr.mr_n55456816)
print v(xbgr.mr_n55456928)
print v(xbgr.mr_n55457248)
print v(xbgr.mr_n55457360)
print v(xbgr.mr_n55457680)
print v(xbgr.mr_n55457792)
print v(xbgr.mr_n55458112)
print v(xbgr.mr_n55458224)
print v(xbgr.mr_n55458544)
print v(xbgr.mr_n55458656)
print v(xbgr.mr_n55458976)
print v(xbgr.mr_n55459088)
print v(xbgr.mr_n55459408)
print v(xbgr.mr_n55459520)
print v(xbgr.mr_n55459840)
print v(xbgr.mr_n55459952)
print v(xbgr.mr_n55460272)
print v(xbgr.mr_n55460384)
print v(xbgr.mr_n55460704)
print v(xbgr.mr_n55460816)
print v(xbgr.mr_n55461136)
print v(xbgr.mr_n55461248)
print v(xbgr.mr_n55461568)
print v(xbgr.mr_n55461680)
print v(xbgr.mr_n55462000)
print v(xbgr.mr_n55462112)
print v(xbgr.mr_n55462432)
print v(xbgr.mr_n55462544)
print v(xbgr.mr_n55462864)
print v(xbgr.mr_n55462976)
print v(xbgr.mr_n55463296)
print v(xbgr.mr_n55463408)
print v(xbgr.mr_n55463728)
print v(xbgr.mr_n55463840)
print v(xbgr.mr_n55464160)
print v(xbgr.mr_n55464272)
print v(xbgr.mr_n55464592)
print v(xbgr.mr_n55464704)
print v(xbgr.mr_n55465136)
print v(xbgr.mr_n55465568)
print v(xbgr.mr_n55465888)
print v(xbgr.mr_n55466000)
print v(xbgr.mr_n55466320)
print v(xbgr.mr_n55466432)
print v(xbgr.mr_n55466752)
print v(xbgr.mr_n55466864)
print v(xbgr.mr_n55467184)
print v(xbgr.mr_n55467296)
print v(xbgr.mr_n55467728)
print v(xbgr.mr_n55468160)
print v(xbgr.mr_n55468480)
print v(xbgr.mr_n55468592)
print v(xbgr.mr_n55468912)
print v(xbgr.mr_n55469024)
print v(xbgr.mr_n55469344)
print v(xbgr.mr_n55469456)
print v(xbgr.mr_n55469776)
print v(xbgr.mr_n55469888)
print v(xbgr.mr_n55470320)
print v(xbgr.mr_n55470752)
print v(xbgr.mr_n55471184)
print v(xbgr.mr_n55471616)
print v(xbgr.mr_n55472048)
print v(xbgr.mr_n55472480)
print v(xbgr.mr_n55472912)
print v(xbgr.mr_n55473344)
print v(xbgr.mr_n55473776)
print v(xbgr.mr_n55474208)
print v(xbgr.mr_n55474640)
print v(xbgr.mr_n55475072)
print v(xbgr.mr_n55475392)
print v(xbgr.mr_n55475824)
print v(xbgr.mr_n55476256)
print v(xbgr.mr_n55476688)
print v(xbgr.mr_n55477120)
print v(xbgr.mr_n55477552)
print v(xbgr.mr_n55477984)
print v(xbgr.mr_n55478416)
print v(xbgr.mr_n55478848)
print v(xbgr.mr_n55478960)
print v(xbgr.mr_n55479280)
print v(xbgr.mr_n55479392)
print v(xbgr.mr_n55479712)
print v(xbgr.mr_n55479824)
print v(xbgr.mr_n55480144)
print v(xbgr.mr_n55480256)
print v(xbgr.mr_n55480576)
print v(xbgr.mr_n55480688)
print v(xbgr.mr_n55481008)
print v(xbgr.mr_n55481120)
print v(xbgr.mr_n55481440)
print v(xbgr.mr_n55481552)
print v(xbgr.mr_n55481872)
print v(xbgr.mr_n55481984)
print v(xbgr.mr_n55482304)
print v(xbgr.mr_n55482736)
print v(xbgr.mr_n55483168)
print v(xbgr.mr_n55483600)
print v(xbgr.mr_n55484032)
print v(xbgr.mr_n55484464)
print v(xbgr.mr_n55484896)
print v(xbgr.mr_n55485328)
print v(xbgr.mr_n55485760)
print v(xbgr.mr_n55486192)
print v(xbgr.mr_n55486736)
print v(xbgr.mr_n55487168)
print v(xbgr.mr_n55487600)
print v(xbgr.mr_n55488032)
print v(xbgr.mr_n55488464)
print v(xbgr.mr_n55488896)
print v(xbgr.mr_n55489328)
print v(xbgr.mr_n55489760)
print v(xbgr.mr_n55490192)
print v(xbgr.mr_n55490624)
print v(xbgr.mr_n55491056)
print v(xbgr.mr_n55491488)
print v(xbgr.mr_n55491920)
print v(xbgr.mr_n55492352)
print v(xbgr.mr_n55492784)
print v(xbgr.mr_n55493216)
print v(xbgr.mr_n55493648)
print v(xbgr.mr_n55494080)
print v(xbgr.mr_n55494512)
print v(xbgr.mr_n55494944)
print v(xbgr.mr_n55495376)
print v(xbgr.mr_n55495808)
print v(xbgr.mr_n55496240)
print v(xbgr.mr_n55496672)
print v(xbgr.mr_n55497104)
print v(xbgr.mr_n55497536)
print v(xbgr.mr_n55497968)
print v(xbgr.mr_n55498400)
print v(xbgr.mr_n55498832)
print v(xbgr.mr_n55499264)
print v(xbgr.mr_n55499696)
print v(xbgr.mr_n55500128)
print v(xbgr.mr_n55500560)
print v(xbgr.mr_n55500992)
print v(xbgr.mr_n55501424)
print v(xbgr.mr_n55501856)
print v(xbgr.mr_n55502288)
print v(xbgr.mr_n55502720)
print v(xbgr.mr_n55503152)
print v(xbgr.mr_n55503584)
print v(xbgr.mr_n55504016)
print v(xbgr.mr_n55504448)
print v(xbgr.mr_n55504880)
print v(xbgr.mr_n55505312)
print v(xbgr.mr_n55505744)
print v(xbgr.mr_n55506176)
print v(xbgr.mr_n55506608)
print v(xbgr.mr_n55507040)
print v(xbgr.mr_n55507472)
print v(xbgr.mr_n55507904)
print v(xbgr.mr_n55508336)
print v(xbgr.mr_n55508768)
print v(xbgr.mr_n55509200)
print v(xbgr.mr_n55509632)
print v(xbgr.mr_n55510064)
print v(xbgr.mr_n55510496)
print v(xbgr.mr_n55510928)
print v(xbgr.mr_n55511360)
print v(xbgr.mr_n55511792)
print v(xbgr.mr_n55512224)
print v(xbgr.mr_n55512656)
print v(xbgr.mr_n55513088)
print v(xbgr.mr_n55513520)
print v(xbgr.mr_n55513952)
print v(xbgr.mr_n55514272)
print v(xbgr.mr_n55514704)
print v(xbgr.mr_n55515136)
print v(xbgr.mr_n55515568)
print v(xbgr.mr_n55516000)
print v(xbgr.mr_n55516432)
print v(xbgr.mr_n55516976)
print v(xbgr.mr_n55517408)
print v(xbgr.mr_n55517840)
print v(xbgr.mr_n55518272)
print v(xbgr.mr_n55518704)
print v(xbgr.mr_n55519136)
print v(xbgr.mr_n55519568)
print v(xbgr.mr_n55520000)
print v(xbgr.mr_n55520432)
print v(xbgr.mr_n55520864)
print v(xbgr.mr_n55521296)
print v(xbgr.mr_n55521728)
print v(xbgr.mr_n55522160)
print v(xbgr.mr_n55522592)
print v(xbgr.mr_n55523024)
print v(xbgr.mr_n55523456)
print v(xbgr.mr_n55523888)
print v(xbgr.mr_n55524320)
print v(xbgr.mr_n55524752)
print v(xbgr.mr_n55525184)
print v(xbgr.mr_n55525616)
print v(xbgr.mr_n55526048)
print v(xbgr.mr_n55526480)
print v(xbgr.mr_n55526912)
print v(xbgr.mr_n55527344)
print v(xbgr.mr_n55527776)
print v(xbgr.mr_n55528096)
print v(xbgr.mr_n55528208)
print v(xbgr.mr_n55528528)
print v(xbgr.mr_n55528640)
print v(xbgr.mr_n55528960)
print v(xbgr.mr_n55529072)
print v(xbgr.mr_n55529392)
print v(xbgr.mr_n55529504)
print v(xbgr.mr_n55529824)
print v(xbgr.mr_n55529936)
print v(xbgr.mr_n55530256)
print v(xbgr.mr_n55530368)
print v(xbgr.mr_n55530688)
print v(xbgr.mr_n55530800)
print v(xbgr.mr_n55531120)
print v(xbgr.mr_n55531232)
print v(xbgr.mr_n55531552)
print v(xbgr.mr_n55531664)
print v(xbgr.mr_n55531984)
print v(xbgr.mr_n55532096)
print v(xbgr.mr_n55532416)
print v(xbgr.mr_n55532528)
print v(xbgr.mr_n55532848)
print v(xbgr.mr_n55532960)
print v(xbgr.mr_n55533280)
print v(xbgr.mr_n55533392)
print v(xbgr.mr_n55533712)
print v(xbgr.mr_n55533824)
print v(xbgr.mr_n55534144)
print v(xbgr.mr_n55534256)
print v(xbgr.mr_n55534576)
print v(xbgr.mr_n55535008)
print v(xbgr.mr_n55535120)
print v(xbgr.mr_n55535440)
print v(xbgr.mr_n55535872)
print v(xbgr.mr_n55535984)
print v(xbgr.mr_n55536304)
print v(xbgr.mr_n55536416)
print v(xbgr.mr_n55536736)
print v(xbgr.mr_n55536848)
print v(xbgr.mr_n55537168)
print v(xbgr.mr_n55537280)
print v(xbgr.mr_n55537600)
print v(xbgr.mr_n55537712)
print v(xbgr.mr_n55538032)
print v(xbgr.mr_n55538144)
print v(xbgr.mr_n55538464)
print v(xbgr.mr_n55538576)
print v(xbgr.mr_n55538896)
print v(xbgr.mr_n55539328)
print v(xbgr.mr_n55539440)
print v(xbgr.mr_n55539760)
print v(xbgr.mr_n55539872)
print v(xbgr.mr_n55540192)
print v(xbgr.mr_n55540304)
print v(xbgr.mr_n55540624)
print v(xbgr.mr_n55540736)
print v(xbgr.mr_n55541056)
print v(xbgr.mr_n55541168)
print v(xbgr.mr_n55541488)
print v(xbgr.mr_n55541600)
print v(xbgr.mr_n55541920)
print v(xbgr.mr_n55542032)
print v(xbgr.mr_n55542352)
print v(xbgr.mr_n55542464)
print v(xbgr.mr_n55542784)
print v(xbgr.mr_n55542896)
print v(xbgr.mr_n55543216)
print v(xbgr.mr_n55543328)
print v(xbgr.mr_n55543648)
print v(xbgr.mr_n55543760)
print v(xbgr.mr_n55544080)
print v(xbgr.mr_n55544512)
print v(xbgr.mr_n55544624)
print v(xbgr.mr_n55544944)
print v(xbgr.mr_n55545056)
print v(xbgr.mr_n55545376)
print v(xbgr.mr_n55545488)
print v(xbgr.mr_n55545808)
print v(xbgr.mr_n55545920)
print v(xbgr.mr_n55546240)
print v(xbgr.mr_n55546352)
print v(xbgr.mr_n55546672)
print v(xbgr.mr_n55546784)
print v(xbgr.mr_n55547104)
print v(xbgr.mr_n55547216)
print v(xbgr.mr_n55547536)
print v(xbgr.mr_n55547648)
print v(xbgr.mr_n55547968)
print v(xbgr.mr_n55548080)
print v(xbgr.mr_n55548400)
print v(xbgr.mr_n55548512)
print v(xbgr.mr_n55548832)
print v(xbgr.mr_n55548944)
print v(xbgr.mr_n55549264)
print v(xbgr.mr_n55549376)
print v(xbgr.mr_n55549696)
print v(xbgr.mr_n55549808)
print v(xbgr.mr_n55550128)
print v(xbgr.mr_n55550560)
print v(xbgr.mr_n55550672)
print v(xbgr.mr_n55550992)
print v(xbgr.mr_n55551104)
print v(xbgr.mr_n55551424)
print v(xbgr.mr_n55551536)
print v(xbgr.mr_n55551856)
print v(xbgr.mr_n55551968)
print v(xbgr.mr_n55552288)
print v(xbgr.mr_n55552400)
print v(xbgr.mr_n55552720)
print v(xbgr.mr_n55552832)
print v(xbgr.mr_n55553152)
print v(xbgr.mr_n55553264)
print v(xbgr.mr_n55553584)
print v(xbgr.mr_n55554016)
print v(xbgr.mr_n55554128)
print v(xbgr.mr_n55554448)
print v(xbgr.mr_n55554880)
print v(xbgr.mr_n55554992)
print v(xbgr.mr_n55555312)
print v(xbgr.mr_n55555424)
print v(xbgr.mr_n55555744)
print v(xbgr.mr_n55555856)
print v(xbgr.mr_n55556176)
print v(xbgr.mr_n55556288)
print v(xbgr.mr_n55556608)
print v(xbgr.mr_n55556720)
print v(xbgr.mr_n55557040)
print v(xbgr.mr_n55557152)
print v(xbgr.mr_n55557472)
print v(xbgr.mr_n55557584)
print v(xbgr.mr_n55557904)
print v(xbgr.mr_n55558016)
print v(xbgr.mr_n55558336)
print v(xbgr.mr_n55558448)
print v(xbgr.mr_n55558768)
print v(xbgr.mr_n55558880)
print v(xbgr.mr_n55559200)
print v(xbgr.mr_n55559312)
print v(xbgr.mr_n55559632)
print v(xbgr.mr_n55559744)
print v(xbgr.mr_n55560176)
print v(xbgr.mr_n55560608)
print v(xbgr.mr_n55561040)
print v(xbgr.mr_n55561472)
print v(xbgr.mr_n55561904)
print v(xbgr.mr_n55562336)
print v(xbgr.mr_n55562768)
print v(xbgr.mr_n55563200)
print v(xbgr.mr_n55563632)
print v(xbgr.mr_n55564064)
print v(xbgr.mr_n55564496)
print v(xbgr.mr_n55564928)
print v(xbgr.mr_n55565360)
print v(xbgr.mr_n55565792)
print v(xbgr.mr_n55566224)
print v(xbgr.mr_n55566656)
print v(xbgr.mr_n55567088)
print v(xbgr.mr_n55567520)
print v(xbgr.mr_n55567952)
print v(xbgr.mr_n55568384)
print v(xbgr.mr_n55568816)
print v(xbgr.mr_n55569248)
print v(xbgr.mr_n55569680)
print v(xbgr.mr_n55570112)
print v(xbgr.mr_n55570544)
print v(xbgr.mr_n55570976)
print v(xbgr.mr_n55571408)
print v(xbgr.mr_n55571840)
print v(xbgr.mr_n55572272)
print v(xbgr.mr_n55572704)
print v(xbgr.mr_n55573136)
print v(xbgr.mr_n55573568)
print v(xbgr.mr_n55574000)
print v(xbgr.mr_n55574432)
print v(xbgr.mr_n55574864)
print v(xbgr.mr_n55575296)
print v(xbgr.mr_n55575728)
print v(xbgr.mr_n55576160)
print v(xbgr.mr_n55576592)
print v(xbgr.mr_n55577024)
print v(xbgr.mr_n55577456)
print v(xbgr.mr_n55577888)
print v(xbgr.mr_n55578320)
print v(xbgr.mr_n55578752)
print v(xbgr.mr_n55579184)
print v(xbgr.mr_n55579616)
print v(xbgr.mr_n55580048)
print v(xbgr.mr_n55580480)
print v(xbgr.mr_n55580912)
print v(xbgr.mr_n55581344)
print v(xbgr.mr_n55581776)
print v(xbgr.mr_n55582208)
print v(xbgr.mr_n55582640)
print v(xbgr.mr_n55583072)
print v(xbgr.mr_n55583504)
print v(xbgr.mr_n55583936)
print v(xbgr.mr_n55584368)
print v(xbgr.mr_n55584800)
print v(xbgr.mr_n55585232)
print v(xbgr.mr_n55585664)
print v(xbgr.mr_n55586096)
print v(xbgr.mr_n55586528)
print v(xbgr.mr_n55586960)
print v(xbgr.mr_n55587392)
print v(xbgr.mr_n55587824)
print v(xbgr.mr_n55588256)
print v(xbgr.mr_n55588688)
print v(xbgr.mr_n55589120)
print v(xbgr.mr_n55589552)
print v(xbgr.mr_n55589984)
print v(xbgr.mr_n55590416)
print v(xbgr.mr_n55590848)
print v(xbgr.mr_n55591280)
print v(xbgr.mr_n55591712)
print v(xbgr.mr_n55592144)
print v(xbgr.mr_n55592576)
print v(xbgr.mr_n55593008)
print v(xbgr.mr_n55593440)
print v(xbgr.mr_n55593760)
print v(xbgr.mr_n55593872)
print v(xbgr.mr_n55594192)
print v(xbgr.mr_n55594304)
print v(xbgr.mr_n55594736)
print v(xbgr.mr_n55595168)
print v(xbgr.mr_n55595488)
print v(xbgr.mr_n55595600)
print v(xbgr.mr_n55595920)
print v(xbgr.mr_n55596464)
print v(xbgr.mr_n55596896)
print v(xbgr.mr_n55597216)
print v(xbgr.mr_n55597328)
print v(xbgr.mr_n55597648)
print v(xbgr.mr_n55597760)
print v(xbgr.mr_n55598080)
print v(xbgr.mr_n55598192)
print v(xbgr.mr_n55598512)
print v(xbgr.mr_n55598624)
print v(xbgr.mr_n55598944)
print v(xbgr.mr_n55599056)
print v(xbgr.mr_n55599376)
print v(xbgr.mr_n55599488)
print v(xbgr.mr_n55599808)
print v(xbgr.mr_n55599920)
print v(xbgr.mr_n55600240)
print v(xbgr.mr_n55600352)
print v(xbgr.mr_n55600672)
print v(xbgr.mr_n55600784)
print v(xbgr.mr_n55601104)
print v(xbgr.mr_n55601216)
print v(xbgr.mr_n55601536)
print v(xbgr.mr_n55601648)
print v(xbgr.mr_n55601968)
print v(xbgr.mr_n55602080)
print v(xbgr.mr_n55602512)
print v(xbgr.mr_n55602944)
print v(xbgr.mr_n55603264)
print v(xbgr.mr_n55603376)
print v(xbgr.mr_n55603696)
print v(xbgr.mr_n55603808)
print v(xbgr.mr_n55604240)
print v(xbgr.mr_n55604672)
print v(xbgr.mr_n55605104)
print v(xbgr.mr_n55605536)
print v(xbgr.mr_n55605968)
print v(xbgr.mr_n55606400)
print v(xbgr.mr_n55606832)
print v(xbgr.mr_n55607264)
print v(xbgr.mr_n55607696)
print v(xbgr.mr_n55608128)
print v(xbgr.mr_n55608560)
print v(xbgr.mr_n55608992)
print v(xbgr.mr_n55609424)
print v(xbgr.mr_n55609856)
print v(xbgr.mr_n55610288)
print v(xbgr.mr_n55610720)
print v(xbgr.mr_n55611152)
print v(xbgr.mr_n55611584)
print v(xbgr.mr_n55612016)
print v(xbgr.mr_n55612448)
print v(xbgr.mr_n55612880)
print v(xbgr.mr_n55613312)
print v(xbgr.mr_n55613744)
print v(xbgr.mr_n55614176)
print v(xbgr.mr_n55614608)
print v(xbgr.mr_n55615040)
print v(xbgr.mr_n55615472)
print v(xbgr.mr_n55615904)
print v(xbgr.mr_n55616336)
print v(xbgr.mr_n55616768)
print v(xbgr.mr_n55617200)
print v(xbgr.mr_n55617632)
print v(xbgr.mr_n55618064)
print v(xbgr.mr_n55618496)
print v(xbgr.mr_n55618928)
print v(xbgr.mr_n55619360)
print v(xbgr.mr_n55619792)
print v(xbgr.mr_n55620224)
print v(xbgr.mr_n55620656)
print v(xbgr.mr_n55621088)
print v(xbgr.mr_n55621520)
print v(xbgr.mr_n55621952)
print v(xbgr.mr_n55622384)
print v(xbgr.mr_n55622816)
print v(xbgr.mr_n55623248)
print v(xbgr.mr_n55623680)
print v(xbgr.mr_n55624112)
print v(xbgr.mr_n55624544)
print v(xbgr.mr_n55624976)
print v(xbgr.mr_n55625408)
print v(xbgr.mr_n55625840)
print v(xbgr.mr_n55626272)
print v(xbgr.mr_n55626704)
print v(xbgr.mr_n55627136)
print v(xbgr.mr_n55627568)
print v(xbgr.mr_n55628000)
print v(xbgr.mr_n55628432)
print v(xbgr.mr_n55628864)
print v(xbgr.mr_n55629296)
print v(xbgr.mr_n55629728)
print v(xbgr.mr_n55630160)
print v(xbgr.mr_n55630592)
print v(xbgr.mr_n55631024)
print v(xbgr.mr_n55631456)
print v(xbgr.mr_n55631888)
print v(xbgr.mr_n55632320)
print v(xbgr.mr_n55632752)
print v(xbgr.mr_n55633184)
print v(xbgr.mr_n55633616)
print v(xbgr.mr_n55634048)
print v(xbgr.mr_n55634480)
print v(xbgr.mr_n55634912)
print v(xbgr.mr_n55635344)
print v(xbgr.mr_n55635776)
print v(xbgr.mr_n55636208)
print v(xbgr.mr_n55636640)
print v(xbgr.mr_n55637072)
print v(xbgr.mr_n55637504)
print v(xbgr.mr_n55637936)
print v(xbgr.mr_n55638368)
print v(xbgr.mr_n55638800)
print v(xbgr.mr_n55639232)
print v(xbgr.mr_n55639664)
print v(xbgr.mr_n55640096)
print v(xbgr.mr_n55640528)
print v(xbgr.mr_n55640960)
print v(xbgr.mr_n55641392)
print v(xbgr.mr_n55641824)
print v(xbgr.mr_n55642256)
print v(xbgr.mr_n55642688)
print v(xbgr.mr_n55643120)
print v(xbgr.mr_n55643552)
print v(xbgr.mr_n55643984)
print v(xbgr.mr_n55644416)
print v(xbgr.mr_n55644848)
print v(xbgr.mr_n55645280)
print v(xbgr.mr_n55645712)
print v(xbgr.mr_n55646144)
print v(xbgr.mr_n55646576)
print v(xbgr.mr_n55647008)
print v(xbgr.mr_n55647440)
print v(xbgr.mr_n55647872)
print v(xbgr.mr_n55648304)
print v(xbgr.mr_n55648736)
print v(xbgr.mr_n55649168)
print v(xbgr.mr_n55649600)
print v(xbgr.mr_n55650032)
print v(xbgr.mr_n55650464)
print v(xbgr.mr_n55650896)
print v(xbgr.mr_n55651328)
print v(xbgr.mr_n55651760)
print v(xbgr.mr_n55652192)
print v(xbgr.mr_n55652624)
print v(xbgr.mr_n55653056)
print v(xbgr.mr_n55653488)
print v(xbgr.mr_n55653920)
print v(xbgr.mr_n55654352)
print v(xbgr.mr_n55654784)
print v(xbgr.mr_n55655216)
print v(xbgr.mr_n55655648)
print v(xbgr.mr_n55656080)
print v(xbgr.mr_n55656512)
print v(xbgr.mr_n55656944)
print v(xbgr.mr_n55657376)
print v(xbgr.mr_n55657808)
print v(xbgr.mr_n55658240)
print v(xbgr.mr_n55658672)
print v(xbgr.mr_n55659104)
print v(xbgr.mr_n55659536)
print v(xbgr.mr_n55659968)
print v(xbgr.mr_n55660400)
print v(xbgr.mr_n55660832)
print v(xbgr.mr_n55661264)
print v(xbgr.mr_n55661696)
print v(xbgr.mr_n55662128)
print v(xbgr.mr_n55662560)
print v(xbgr.mr_n55662880)
print v(xbgr.mr_n55662992)
print v(xbgr.mr_n55663312)
print v(xbgr.mr_n55663424)
print v(xbgr.mr_n55663744)
print v(xbgr.mr_n55663856)
print v(xbgr.mr_n55664176)
print v(xbgr.mr_n55664288)
print v(xbgr.mr_n55664608)
print v(xbgr.mr_n55664720)
print v(xbgr.mr_n55665040)
print v(xbgr.mr_n55665152)
print v(xbgr.mr_n55665472)
print v(xbgr.mr_n55665584)
print v(xbgr.mr_n55665904)
print v(xbgr.mr_n55666016)
print v(xbgr.mr_n55666336)
print v(xbgr.mr_n55666448)
print v(xbgr.mr_n55666768)
print v(xbgr.mr_n55666880)
print v(xbgr.mr_n55667200)
print v(xbgr.mr_n55667312)
print v(xbgr.mr_n55667632)
print v(xbgr.mr_n55667744)
print v(xbgr.mr_n55668064)
print v(xbgr.mr_n55668176)
print v(xbgr.mr_n55668496)
print v(xbgr.mr_n55668608)
print v(xbgr.mr_n55668928)
print v(xbgr.mr_n55669040)
print v(xbgr.mr_n55669360)
print v(xbgr.mr_n55669472)
print v(xbgr.mr_n55669792)
print v(xbgr.mr_n55669904)
print v(xbgr.mr_n55670224)
print v(xbgr.mr_n55670336)
print v(xbgr.mr_n55670656)
print v(xbgr.mr_n55670768)
print v(xbgr.mr_n55671088)
print v(xbgr.mr_n55671200)
print v(xbgr.mr_n55671520)
print v(xbgr.mr_n55671632)
print v(xbgr.mr_n55671952)
print v(xbgr.mr_n55672064)
print v(xbgr.mr_n55672384)
print v(xbgr.mr_n55672496)
print v(xbgr.mr_n55672816)
print v(xbgr.mr_n55672928)
print v(xbgr.mr_n55673248)
print v(xbgr.mr_n55673360)
print v(xbgr.mr_n55673680)
print v(xbgr.mr_n55673792)
print v(xbgr.mr_n55674112)
print v(xbgr.mr_n55674224)
print v(xbgr.mr_n55674544)
print v(xbgr.mr_n55674656)
print v(xbgr.mr_n55674976)
print v(xbgr.mr_n55675088)
print v(xbgr.mr_n55675408)
print v(xbgr.mr_n55675520)
print v(xbgr.mr_n55675952)
print v(xbgr.mr_n55676384)
print v(xbgr.mr_n55676816)
print v(xbgr.mr_n55677248)
print v(xbgr.mr_n55677568)
print v(xbgr.mr_n55677680)
print v(xbgr.mr_n55678000)
print v(xbgr.mr_n55678112)
print v(xbgr.mr_n55678432)
print v(xbgr.mr_n55678544)
print v(xbgr.mr_n55678864)
print v(xbgr.mr_n55678976)
print v(xbgr.mr_n55679296)
print v(xbgr.mr_n55679408)
print v(xbgr.mr_n55679728)
print v(xbgr.mr_n55679840)
print v(xbgr.mr_n55680272)
print v(xbgr.mr_n55680704)
print v(xbgr.mr_n55681136)
print v(xbgr.mr_n55681456)
print v(xbgr.mr_n55681568)
print v(xbgr.mr_n55681888)
print v(xbgr.mr_n55682000)
print v(xbgr.mr_n55682320)
print v(xbgr.mr_n55682432)
print v(xbgr.mr_n55682752)
print v(xbgr.mr_n55682864)
print v(xbgr.mr_n55683184)
print v(xbgr.mr_n55683296)
print v(xbgr.mr_n55683616)
print v(xbgr.mr_n55683728)
print v(xbgr.mr_n55684048)
print v(xbgr.mr_n55684160)
print v(xbgr.mr_n55684480)
print v(xbgr.mr_n55684592)
print v(xbgr.mr_n55684912)
print v(xbgr.mr_n55685024)
print v(xbgr.mr_n55685344)
print v(xbgr.mr_n55685456)
print v(xbgr.mr_n55685888)
print v(xbgr.mr_n55686320)
print v(xbgr.mr_n55686752)
print v(xbgr.mr_n55687184)
print v(xbgr.mr_n55687616)
print v(xbgr.mr_n55688048)
print v(xbgr.mr_n55688480)
print v(xbgr.mr_n55688912)
print v(xbgr.mr_n55689344)
print v(xbgr.mr_n55689776)
print v(xbgr.mr_n55690208)
print v(xbgr.mr_n55690640)
print v(xbgr.mr_n55691072)
print v(xbgr.mr_n55691392)
print v(xbgr.mr_n55691504)
print v(xbgr.mr_n55691824)
print v(xbgr.mr_n55691936)
print v(xbgr.mr_n55692256)
print v(xbgr.mr_n55692368)
print v(xbgr.mr_n55692688)
print v(xbgr.mr_n55692800)
print v(xbgr.mr_n55693120)
print v(xbgr.mr_n55693232)
print v(xbgr.mr_n55693664)
print v(xbgr.mr_n55694096)
print v(xbgr.mr_n55694528)
print v(xbgr.mr_n55694960)
print v(xbgr.mr_n55695392)
print v(xbgr.mr_n55695824)
print v(xbgr.mr_n55696144)
print v(xbgr.mr_n55696256)
print v(xbgr.mr_n55696576)
print v(xbgr.mr_n55696688)
print v(xbgr.mr_n55697120)
print v(xbgr.mr_n55697552)
print v(xbgr.mr_n55697872)
print v(xbgr.mr_n55697984)
print v(xbgr.mr_n55698304)
print v(xbgr.mr_n55698416)
print v(xbgr.mr_n55698736)
print v(xbgr.mr_n55698848)
print v(xbgr.mr_n55699168)
print v(xbgr.mr_n55699280)
print v(xbgr.mr_n55699600)
print v(xbgr.mr_n55699712)
print v(xbgr.mr_n55700032)
print v(xbgr.mr_n55700144)
print v(xbgr.mr_n55700464)
print v(xbgr.mr_n55700576)
print v(xbgr.mr_n55700896)
print v(xbgr.mr_n55701008)
print v(xbgr.mr_n55701328)
print v(xbgr.mr_n55701440)
print v(xbgr.mr_n55701760)
print v(xbgr.mr_n55701872)
print v(xbgr.mr_n55702192)
print v(xbgr.mr_n55702304)
print v(xbgr.mr_n55702624)
print v(xbgr.mr_n55702736)
print v(xbgr.mr_n55703056)
print v(xbgr.mr_n55703168)
print v(xbgr.mr_n55703488)
print v(xbgr.mr_n55703600)
print v(xbgr.mr_n55704032)
print v(xbgr.mr_n55704464)
print v(xbgr.mr_n55704784)
print v(xbgr.mr_n55704896)
print v(xbgr.mr_n55705216)
print v(xbgr.mr_n55705328)
print v(xbgr.mr_n55705648)
print v(xbgr.mr_n55705760)
print v(xbgr.mr_n55706080)
print v(xbgr.mr_n55706192)
print v(xbgr.mr_n55706512)
print v(xbgr.mr_n55706624)
print v(xbgr.mr_n55706944)
print v(xbgr.mr_n55707056)
print v(xbgr.mr_n55707488)
print v(xbgr.mr_n55707920)
print v(xbgr.mr_n55708240)
print v(xbgr.mr_n55708352)
print v(xbgr.mr_n55708672)
print v(xbgr.mr_n55708784)
print v(xbgr.mr_n55709104)
print v(xbgr.mr_n55709216)
print v(xbgr.mr_n55709536)
print v(xbgr.mr_n55709648)
print v(xbgr.mr_n55709968)
print v(xbgr.mr_n55710080)
print v(xbgr.mr_n55710400)
print v(xbgr.mr_n55710512)
print v(xbgr.mr_n55710832)
print v(xbgr.mr_n55710944)
print v(xbgr.mr_n55711264)
print v(xbgr.mr_n55711376)
print v(xbgr.mr_n55711696)
print v(xbgr.mr_n55711808)
print v(xbgr.mr_n55712128)
print v(xbgr.mr_n55712240)
print v(xbgr.mr_n55712560)
print v(xbgr.mr_n55712672)
print v(xbgr.mr_n55712992)
print v(xbgr.mr_n55713104)
print v(xbgr.mr_n55713424)
print v(xbgr.mr_n55713536)
print v(xbgr.mr_n55713856)
print v(xbgr.mr_n55713968)
print v(xbgr.mr_n55714288)
print v(xbgr.mr_n55714400)
print v(xbgr.mr_n55714720)
print v(xbgr.mr_n55714832)
print v(xbgr.mr_n55715152)
print v(xbgr.mr_n55715264)
print v(xbgr.mr_n55715584)
print v(xbgr.mr_n55715696)
print v(xbgr.mr_n55716016)
print v(xbgr.mr_n55716128)
print v(xbgr.mr_n55716448)
print v(xbgr.mr_n55716560)
print v(xbgr.mr_n55716880)
print v(xbgr.mr_n55716992)
print v(xbgr.mr_n55717312)
print v(xbgr.mr_n55717424)
print v(xbgr.mr_n55717744)
print v(xbgr.mr_n55717856)
print v(xbgr.mr_n55718176)
print v(xbgr.mr_n55718288)
print v(xbgr.mr_n55718608)
print v(xbgr.mr_n55718720)
print v(xbgr.mr_n55719040)
print v(xbgr.mr_n55719152)
print v(xbgr.mr_n55719472)
print v(xbgr.mr_n55719584)
print v(xbgr.mr_n55719904)
print v(xbgr.mr_n55720016)
print v(xbgr.mr_n55720336)
print v(xbgr.mr_n55720448)
print v(xbgr.mr_n55720768)
print v(xbgr.mr_n55720880)
print v(xbgr.mr_n55721200)
print v(xbgr.mr_n55721312)
print v(xbgr.mr_n55721632)
print v(xbgr.mr_n55721744)
print v(xbgr.mr_n55722064)
print v(xbgr.mr_n55722176)
print v(xbgr.mr_n55722496)
print v(xbgr.mr_n55722608)
print v(xbgr.mr_n55722928)
print v(xbgr.mr_n55723040)
print v(xbgr.mr_n55723360)
print v(xbgr.mr_n55723472)
print v(xbgr.mr_n55723792)
print v(xbgr.mr_n55723904)
print v(xbgr.mr_n55724224)
print v(xbgr.mr_n55724336)
print v(xbgr.mr_n55724656)
print v(xbgr.mr_n55724768)
print v(xbgr.mr_n55725088)
print v(xbgr.mr_n55725200)
print v(xbgr.mr_n55725520)
print v(xbgr.mr_n55725632)
print v(xbgr.mr_n55725952)
print v(xbgr.mr_n55726064)
print v(xbgr.mr_n55726384)
print v(xbgr.mr_n55726496)
print v(xbgr.mr_n55726816)
print v(xbgr.mr_n55726928)
print v(xbgr.mr_n55727248)
print v(xbgr.mr_n55727360)
print v(xbgr.mr_n55727680)
print v(xbgr.mr_n55727792)
print v(xbgr.mr_n55728112)
print v(xbgr.mr_n55728224)
print v(xbgr.mr_n55728544)
print v(xbgr.mr_n55728656)
print v(xbgr.mr_n55728976)
print v(xbgr.mr_n55729088)
print v(xbgr.mr_n55729408)
print v(xbgr.mr_n55729520)
print v(xbgr.mr_n55729840)
print v(xbgr.mr_n55729952)
print v(xbgr.mr_n55730272)
print v(xbgr.mr_n55730384)
print v(xbgr.mr_n55730704)
print v(xbgr.mr_n55730816)
print v(xbgr.mr_n55731136)
print v(xbgr.mr_n55731248)
print v(xbgr.mr_n55731568)
print v(xbgr.mr_n55731680)
print v(xbgr.mr_n55732000)
print v(xbgr.mr_n55732112)
print v(xbgr.mr_n55732432)
print v(xbgr.mr_n55732544)
print v(xbgr.mr_n55732864)
print v(xbgr.mr_n55732976)
print v(xbgr.mr_n55733296)
print v(xbgr.mr_n55733408)
print v(xbgr.mr_n55733728)
print v(xbgr.mr_n55733840)
print v(xbgr.mr_n55734160)
print v(xbgr.mr_n55734272)
print v(xbgr.mr_n55734592)
print v(xbgr.mr_n55734704)
print v(xbgr.mr_n55735024)
print v(xbgr.mr_n55735136)
print v(xbgr.mr_n55735456)
print v(xbgr.mr_n55735568)
print v(xbgr.mr_n55735888)
print v(xbgr.mr_n55736000)
print v(xbgr.mr_n55736320)
print v(xbgr.mr_n55736432)
print v(xbgr.mr_n55736752)
print v(xbgr.mr_n55736864)
print v(xbgr.mr_n55737184)
print v(xbgr.mr_n55737296)
print v(xbgr.mr_n55737616)
print v(xbgr.mr_n55737728)
print v(xbgr.mr_n55738048)
print v(xbgr.mr_n55738160)
print v(xbgr.mr_n55738480)
print v(xbgr.mr_n55738592)
print v(xbgr.mr_n55738912)
print v(xbgr.mr_n55739024)
print v(xbgr.mr_n55739344)
print v(xbgr.mr_n55739456)
print v(xbgr.mr_n55739776)
print v(xbgr.mr_n55739888)
print v(xbgr.mr_n55740208)
print v(xbgr.mr_n55740320)
print v(xbgr.mr_n55740640)
print v(xbgr.mr_n55740752)
print v(xbgr.mr_n55741072)
print v(xbgr.mr_n55741184)
print v(xbgr.mr_n55741504)
print v(xbgr.mr_n55741616)
print v(xbgr.mr_n55741936)
print v(xbgr.mr_n55742048)
print v(xbgr.mr_n55742368)
print v(xbgr.mr_n55742480)
print v(xbgr.mr_n55742800)
print v(xbgr.mr_n55742912)
print v(xbgr.mr_n55743232)
print v(xbgr.mr_n55743344)
print v(xbgr.mr_n55743664)
print v(xbgr.mr_n55743776)
print v(xbgr.mr_n55744096)
print v(xbgr.mr_n55744208)
print v(xbgr.mr_n55744528)
print v(xbgr.mr_n55744640)
print v(xbgr.mr_n55744960)
print v(xbgr.mr_n55745072)
print v(xbgr.mr_n55745392)
print v(xbgr.mr_n55745504)
print v(xbgr.mr_n55745824)
print v(xbgr.mr_n55745936)
print v(xbgr.mr_n55746256)
print v(xbgr.mr_n55746368)
print v(xbgr.mr_n55746688)
print v(xbgr.mr_n55746800)
print v(xbgr.mr_n55747120)
print v(xbgr.mr_n55747232)
print v(xbgr.mr_n55747552)
print v(xbgr.mr_n55747664)
print v(xbgr.mr_n55747984)
print v(xbgr.mr_n55748096)
print v(xbgr.mr_n55748416)
print v(xbgr.mr_n55748528)
print v(xbgr.mr_n55748848)
print v(xbgr.mr_n55748960)
print v(xbgr.mr_n55749280)
print v(xbgr.mr_n55749392)
print v(xbgr.mr_n55749712)
print v(xbgr.mr_n55749824)
print v(xbgr.mr_n55750144)
print v(xbgr.mr_n55750256)
print v(xbgr.mr_n55750576)
print v(xbgr.mr_n55750688)
print v(xbgr.mr_n55751008)
print v(xbgr.mr_n55751120)
print v(xbgr.mr_n55751440)
print v(xbgr.mr_n55751552)
print v(xbgr.mr_n55751872)
print v(xbgr.mr_n55751984)
print v(xbgr.mr_n55752304)
print v(xbgr.mr_n55752416)
print v(xbgr.mr_n55752736)
print v(xbgr.mr_n55752848)
print v(xbgr.mr_n55753168)
print v(xbgr.mr_n55753280)
print v(xbgr.mr_n55753600)
print v(xbgr.mr_n55753712)
print v(xbgr.mr_n55754032)
print v(xbgr.mr_n55754144)
print v(xbgr.mr_n55754464)
print v(xbgr.mr_n55754576)
print v(xbgr.mr_n55754896)
print v(xbgr.mr_n55755008)
print v(xbgr.mr_n55755328)
print v(xbgr.mr_n55755440)
print v(xbgr.mr_n55755760)
print v(xbgr.mr_n55755872)
print v(xbgr.mr_n55756192)
print v(xbgr.mr_n55756304)
print v(xbgr.mr_n55756624)
print v(xbgr.mr_n55756736)
print v(xbgr.mr_n55757056)
print v(xbgr.mr_n55757168)
print v(xbgr.mr_n55757488)
print v(xbgr.mr_n55757600)
print v(xbgr.mr_n55757920)
print v(xbgr.mr_n55758032)
print v(xbgr.mr_n55758352)
print v(xbgr.mr_n55758464)
print v(xbgr.mr_n55758896)
print v(xbgr.mr_n55759328)
print v(xbgr.mr_n55759760)
print v(xbgr.mr_n55760192)
print v(xbgr.mr_n55760624)
print v(xbgr.mr_n55761056)
print v(xbgr.mr_n55761488)
print v(xbgr.mr_n55761920)
print v(xbgr.mr_n55762352)
print v(xbgr.mr_n55762784)
print v(xbgr.mr_n55763216)
print v(xbgr.mr_n55763648)
print v(xbgr.mr_n55764080)
print v(xbgr.mr_n55764512)
print v(xbgr.mr_n55764944)
print v(xbgr.mr_n55765376)
print v(xbgr.mr_n55765808)
print v(xbgr.mr_n55766240)
print v(xbgr.mr_n55766672)
print v(xbgr.mr_n55767104)
print v(xbgr.mr_n55767536)
print v(xbgr.mr_n55767968)
print v(xbgr.mr_n55768400)
print v(xbgr.mr_n55768832)
print v(xbgr.mr_n55769264)
print v(xbgr.mr_n55769696)
print v(xbgr.mr_n55770128)
print v(xbgr.mr_n55770560)
print v(xbgr.mr_n55770992)
print v(xbgr.mr_n55771424)
print v(xbgr.mr_n55771856)
print v(xbgr.mr_n55772288)
print v(xbgr.mr_n55772720)
print v(xbgr.mr_n55773152)
print v(xbgr.mr_n55773472)
print v(xbgr.mr_n55773584)
print v(xbgr.mr_n55773904)
print v(xbgr.mr_n55774016)
print v(xbgr.mr_n55774448)
print v(xbgr.mr_n55774768)
print v(xbgr.mr_n55774880)
print v(xbgr.mr_n55775200)
print v(xbgr.mr_n55775312)
print v(xbgr.mr_n55775632)
print v(xbgr.mr_n55775744)
print v(xbgr.mr_n55776064)
print v(xbgr.mr_n55776176)
print v(xbgr.mr_n55776496)
print v(xbgr.mr_n55776608)
print v(xbgr.mr_n55776928)
print v(xbgr.mr_n55777040)
print v(xbgr.mr_n55777360)
print v(xbgr.mr_n55777472)
print v(xbgr.mr_n55777792)
print v(xbgr.mr_n55777904)
print v(xbgr.mr_n55778336)
print v(xbgr.mr_n55778768)
print v(xbgr.mr_n55779200)
print v(xbgr.mr_n55779632)
print v(xbgr.mr_n55780064)
print v(xbgr.mr_n55780496)
print v(xbgr.mr_n55780928)
print v(xbgr.mr_n55781360)
print v(xbgr.mr_n55781792)
print v(xbgr.mr_n55782112)
print v(xbgr.mr_n55782224)
print v(xbgr.mr_n55782544)
print v(xbgr.mr_n55782656)
print v(xbgr.mr_n55782976)
print v(xbgr.mr_n55783088)
print v(xbgr.mr_n55783408)
print v(xbgr.mr_n55783520)
print v(xbgr.mr_n55783952)
print v(xbgr.mr_n55784384)
print v(xbgr.mr_n55784816)
print v(xbgr.mr_n55785248)
print v(xbgr.mr_n55785680)
print v(xbgr.mr_n55786112)
print v(xbgr.mr_n55786544)
print v(xbgr.mr_n55786976)
print v(xbgr.mr_n55787408)
print v(xbgr.mr_n55787840)
print v(xbgr.mr_n55788272)
print v(xbgr.mr_n55788704)
print v(xbgr.mr_n55789136)
print v(xbgr.mr_n55789568)
print v(xbgr.mr_n55790000)
print v(xbgr.mr_n55790432)
print v(xbgr.mr_n55790864)
print v(xbgr.mr_n55791296)
print v(xbgr.mr_n55791728)
print v(xbgr.mr_n55792160)
print v(xbgr.mr_n55792592)
print v(xbgr.mr_n55793024)
print v(xbgr.mr_n55793456)
print v(xbgr.mr_n55793888)
print v(xbgr.mr_n55794320)
print v(xbgr.mr_n55794752)
print v(xbgr.mr_n55795184)
print v(xbgr.mr_n55795616)
print v(xbgr.mr_n55796048)
print v(xbgr.mr_n55796368)
print v(xbgr.mr_n55796480)
print v(xbgr.mr_n55796800)
print v(xbgr.mr_n55796912)
print v(xbgr.mr_n55797232)
print v(xbgr.mr_n55797344)
print v(xbgr.mr_n55797664)
print v(xbgr.mr_n55797776)
print v(xbgr.mr_n55798096)
print v(xbgr.mr_n55798208)
print v(xbgr.mr_n55798528)
print v(xbgr.mr_n55798640)
print v(xbgr.mr_n56061120)
print v(xbgr.mr_n56061904)
print v(xbgr.mr_n56062768)
print v(xbgr.mr_n56062880)
print v(xbgr.mr_n56063200)
print v(xbgr.mr_n56063632)
print v(xbgr.mr_n56064064)
print v(xbgr.mr_n56064496)
print v(xbgr.mr_n56064608)
print v(xbgr.mr_n56064928)
print v(xbgr.mr_n56065360)
print v(xbgr.mr_n56065792)
print v(xbgr.mr_n56066224)
print v(xbgr.mr_n56066336)
print v(xbgr.mr_n56066656)
print v(xbgr.mr_n56066768)
print v(xbgr.mr_n56067088)
print v(xbgr.mr_n56067200)
print v(xbgr.mr_n56067632)
print v(xbgr.mr_n56068064)
print v(xbgr.mr_n56068496)
print v(xbgr.mr_n56068816)
print v(xbgr.mr_n56069680)
print v(xbgr.mr_n56069792)
print v(xbgr.mr_n56070112)
print v(xbgr.mr_n56070224)
print v(xbgr.mr_n56070544)
print v(xbgr.mr_n56071520)
print v(xbgr.mr_n56071952)
print v(xbgr.mr_n56072272)
print v(xbgr.mr_n56073136)
print v(xbgr.mr_n56073248)
print v(xbgr.mr_n56073568)
print v(xbgr.mr_n56073680)
print v(xbgr.mr_n56074000)
print v(xbgr.mr_n56074112)
print v(xbgr.mr_n56076608)
print v(xbgr.mr_n56077040)
print v(xbgr.mr_n56077360)
print v(xbgr.mr_n56078336)
print v(xbgr.mr_n56078656)
print v(xbgr.mr_n56079632)
print v(xbgr.mr_n56079952)
print v(xbgr.mr_n56080928)
print v(xbgr.mr_n56081248)
print v(xbgr.mr_n56081360)
print v(xbgr.mr_n56081792)
print v(xbgr.mr_n56082224)
print v(xbgr.mr_n56082544)
print v(xbgr.mr_n56083520)
print v(xbgr.mr_n56083840)
print v(xbgr.mr_n56084816)
print v(xbgr.mr_n56085136)
print v(xbgr.mr_n56086112)
print v(xbgr.mr_n56086544)
print v(xbgr.mr_n56086976)
print v(xbgr.mr_n56087408)
print v(xbgr.mr_n56087840)
print v(xbgr.mr_n56088272)
print v(xbgr.mr_n56088704)
print v(xbgr.mr_n56089136)
print v(xbgr.mr_n56089568)
print v(xbgr.mr_n56090000)
print v(xbgr.mr_n56090432)
print v(xbgr.mr_n56090864)
print v(xbgr.mr_n56091296)
print v(xbgr.mr_n56091728)
print v(xbgr.mr_n56092160)
print v(xbgr.mr_n56092592)
print v(xbgr.mr_n56093024)
print v(xbgr.mr_n56093456)
print v(xbgr.mr_n56093888)
print v(xbgr.mr_n56094320)
print v(xbgr.mr_n56094752)
print v(xbgr.mr_n56095184)
print v(xbgr.mr_n56095616)
print v(xbgr.mr_n56096048)
print v(xbgr.mr_n56096480)
print v(xbgr.mr_n56157552)
print v(xbgr.mr_n56158208)
print v(xbgr.mr_n56160896)
print v(xbgr.mr_n56161632)
print v(xbgr.mr_n56161840)
print v(xbgr.mr_n56163248)
print v(xbgr.mr_n56164528)
print v(xbgr.mr_n56165872)
print v(xbgr.mr_n56169968)
print v(xbgr.mr_n56172496)
print v(xbgr.mr_n56172608)
print v(xbgr.mr_n56174224)
print v(xbgr.mr_n56174800)
print v(xbgr.mr_n56175952)
print v(xbgr.mr_n56176432)
print v(xbgr.mr_n56177168)
print v(xbgr.mr_n56177408)
print v(xbgr.mr_n56178624)
print v(xbgr.mr_n56180528)
print v(xbgr.mr_n56180864)
print v(xbgr.mr_n56184560)
print v(xbgr.mr_n56184944)
print v(xbgr.mr_n56185520)
print v(xbgr.mr_n56186592)
print v(xbgr.mr_n56186800)
print v(xbgr.mr_n56187040)
print v(xbgr.mr_n56187312)
print v(xbgr.mr_n56187488)
print v(xbgr.mr_n56187696)
print v(xbgr.mr_n56188144)
print v(xbgr.mr_n56188384)
print v(xbgr.mr_n56189040)
print v(xbgr.mr_n56190448)
print v(xbgr.mr_n56190832)
print v(xbgr.mr_n56192624)
print v(xbgr.mr_n56193520)
print v(xbgr.mr_n56193760)
print v(xbgr.mr_n56194480)
print v(xbgr.mr_n56195552)
print v(xbgr.mr_n56197104)
print v(xbgr.mr_n56291008)
print v(xbgr.mr_n56309728)
print v(xbgr.mr_n56314032)
print v(xbgr.mr_n56320032)
print v(xbgr.mr_n56320480)
print v(xbgr.mr_n56342560)
print v(xbgr.mr_n56412720)
print v(xbgr.mr_n56414512)
print v(xbgr.mr_n56416368)
print v(xbgr.mr_n56417056)
print v(xbgr.mr_n56417712)
print v(xbgr.mr_n56421216)
print v(xbgr.mr_n56421536)
print v(xbgr.mr_n56421984)
print v(xbgr.mr_n56423984)
print v(xbgr.mr_n56425392)
print v(xbgr.mr_n56428464)
print v(xbgr.mr_n56428800)
print v(xbgr.mr_n56431600)
print v(xbgr.mr_n56431968)
print v(xbgr.mr_n56432384)
print v(xbgr.mr_n56435248)
print v(xbgr.mr_n56440176)
print v(xbgr.mr_n56440560)
print v(xbgr.mr_n56441968)
print v(xbgr.mr_n56442800)
print v(xbgr.mr_n56443248)
print v(xbgr.mr_n56457040)
print v(xbgr.mr_n56457648)
print v(xbgr.mr_n56458960)
print v(xbgr.mr_n56464064)
print v(xbgr.mr_n56464608)
print v(xbgr.mr_n56469056)
print v(xbgr.mr_n56469792)
print v(xbgr.mr_n56470272)
print v(xbgr.mr_n56471408)
print v(xbgr.mr_n56506080)
print v(xbgr.mr_n56509792)
print v(xbgr.mr_n56510688)
print v(xbgr.mr_n56512032)
print v(xbgr.mr_n56512400)
print v(xbgr.mr_n56516176)
print v(xbgr.mr_n56516944)
print v(xbgr.mr_n56517152)
print v(xbgr.mr_n56518016)
print v(xbgr.mr_n56518192)
print v(xbgr.mr_n56518400)
print v(xbgr.mr_n56518736)
print v(xbgr.mr_n56520192)
print v(xbgr.mr_n56521024)
print v(xbgr.mr_n56527632)
print v(xbgr.mr_n56527936)
print v(xbgr.mr_n56528368)
print v(xbgr.mr_n56529760)
print v(xbgr.mr_n56529952)
print v(xbgr.mr_n56534768)
print v(xbgr.mr_n56535296)
print v(xbgr.mr_n56536128)
print v(xbgr.mr_n56536912)
print v(xbgr.mr_n56537408)
print v(xbgr.mr_n56537520)
print v(xbgr.mr_n56537632)
print v(xbgr.mr_n56542624)
print v(xbgr.mr_n56543568)
print v(xbgr.mr_n56543808)
print v(xbgr.mr_n56602960)
print v(xbgr.mr_n56604832)
print v(xbgr.mr_n56605072)
print v(xbgr.mr_n56605536)
print v(xbgr.mr_n56605984)
print v(xbgr.mr_n56606544)
print v(xbgr.mr_n56606912)
print v(xbgr.mr_n56794288)
print v(xbgr.mr_n56819088)
print v(xbgr.mr_n56870352)
print v(xbgr.mr_n56928032)
print v(xbgr.mr_n56929312)
print v(xbgr.mr_n56936000)
print v(xbgr.mr_n56941360)
print v(xbgr.mr_n56943520)
print v(xbgr.mr_n56972592)
print v(xbgr.mr_n56985520)
print v(xbgr.mr_n56987456)
print v(xbgr.mr_n56992336)
print v(xbgr.mr_n57002256)
print v(xbgr.mr_n57002720)
print v(xbgr.mr_n57006064)
print v(xbgr.mr_n57009008)
print v(xbgr.mr_n57010512)
print v(xbgr.mr_n57011120)
print v(xbgr.mr_n57011424)
print v(xbgr.mr_n57012944)
print v(xbgr.mr_n57013552)
print v(xbgr.mr_n57019376)
print v(xbgr.mr_n57019488)
print v(xbgr.mr_n57019600)
print v(xbgr.mr_n57019712)
print v(xbgr.mr_n57020016)
print v(xbgr.mr_n57020288)
print v(xbgr.mr_n57020560)
print v(xbgr.mr_n57022672)
print v(xbgr.mr_n57023136)
print v(xbgr.mr_n57023600)
print v(xbgr.mr_n57024064)
print v(xbgr.mr_n57024528)
print v(xbgr.mr_n57024992)
print v(xbgr.mr_n57025456)
print v(xbgr.mr_n57025920)
print v(xbgr.mr_n57026384)
print v(xbgr.mr_n57026848)
print v(xbgr.mr_n57027312)
print v(xbgr.mr_n57028368)
print v(xbgr.mr_n57031712)
print v(xbgr.mr_n57036160)
print v(xbgr.mr_n57036832)
print v(xbgr.mr_n57037376)
print v(xbgr.mr_n57038224)
print v(xbgr.mr_n57039872)
print v(xbgr.mr_n57039984)
print v(xbgr.mr_n57041264)
print v(xbgr.mr_n57041872)
print v(xbgr.mr_n57042480)
print v(xbgr.mr_n57042672)
print v(xbgr.mr_n57042848)
print v(xbgr.mr_n57043456)
print v(xbgr.mr_n57043632)
print v(xbgr.mr_n57044064)
print v(xbgr.mr_n57044736)
print v(xbgr.mr_n57044912)
print v(xbgr.mr_n57045456)
print v(xbgr.mr_n57046128)
print v(xbgr.mr_n57046560)
print v(xbgr.mr_n57047952)
print v(xbgr.mr_n57049296)
print v(xbgr.mr_n57051200)
print v(xbgr.mr_n57052176)
print v(xbgr.mr_n57055424)
print v(xbgr.mr_n57056832)
print v(xbgr.mr_n57060352)
print v(xbgr.mr_n57062160)
print v(xbgr.mr_n57064144)
print v(xbgr.mr_n57065488)
print v(xbgr.mr_n57067568)
print v(xbgr.mr_n57068752)
print v(xbgr.mr_n57071184)
print v(xbgr.mr_n57072320)
print v(xbgr.mr_n57073024)
print v(xbgr.mr_n57075136)
print v(xbgr.mr_n57075536)
print v(xbgr.mr_n57076752)
print v(xbgr.mr_n57079360)
print v(xbgr.mr_n57079568)
print v(xbgr.mr_n57080336)
print v(xbgr.mr_n57080448)
print v(xbgr.mr_n57081472)
print v(xbgr.mr_n57084288)
print v(xbgr.mr_n57085232)
print v(xbgr.mr_n57086608)
print v(xbgr.mr_n57087840)
print v(xbgr.mr_n57089920)
print v(xbgr.mr_n57092304)
print v(xbgr.mr_n57094144)
print v(xbgr.mr_n57095552)
print v(xbgr.mr_n57098640)
print v(xbgr.mr_n57103568)
print v(xbgr.mr_n57104624)
print v(xbgr.mr_n57107584)
print v(xbgr.mr_n57107984)
print v(xbgr.mr_n57109456)
print v(xbgr.mr_n57109920)
print v(xbgr.mr_n57110384)
print v(xbgr.mr_n57110848)
print v(xbgr.mr_n57111312)
print v(xbgr.mr_n57111776)
print v(xbgr.mr_n57112240)
print v(xbgr.mr_n57112704)
print v(xbgr.mr_n57113168)
print v(xbgr.mr_n57113632)
print v(xbgr.mr_n57114096)
print v(xbgr.mr_n57114656)
print v(xbgr.mr_n57116112)
print v(xbgr.mr_n57120736)
print v(xbgr.mr_n57121344)
print v(xbgr.mr_n57121536)
print v(xbgr.mr_n57121888)
print v(xbgr.mr_n57122496)
print v(xbgr.mr_n57124320)
print v(xbgr.mr_n57125168)
print v(xbgr.mr_n57126752)
print v(xbgr.mr_n57127056)
print v(xbgr.mr_n57131376)
print v(xbgr.mr_n57131920)
print v(xbgr.mr_n57136896)
print v(xbgr.mr_n57137136)
print v(xbgr.mr_n57138592)
print v(xbgr.mr_n57139872)
print v(xbgr.mr_n57141152)
print v(xbgr.mr_n57141760)
print v(xbgr.mr_n57142176)
print v(xbgr.mr_n57143360)
print v(xbgr.mr_n57145104)
print v(xbgr.mr_n57145632)
print v(xbgr.mr_n57146304)
print v(xbgr.mr_n57147136)
print v(xbgr.mr_n57148320)
print v(xbgr.mr_n57149008)
print v(xbgr.mr_n57149696)
print v(xbgr.mr_n57150336)
print v(xbgr.mr_n57151680)
print v(xbgr.mr_n57157664)
print v(xbgr.mr_n57158336)
print v(xbgr.mr_n57158528)
print v(xbgr.mr_n57160640)
print v(xbgr.mr_n57161104)
print v(xbgr.mr_n57161568)
print v(xbgr.mr_n57162032)
print v(xbgr.mr_n57162496)
print v(xbgr.mr_n57162960)
print v(xbgr.mr_n57163424)
print v(xbgr.mr_n57163888)
print v(xbgr.mr_n57164352)
print v(xbgr.mr_n57164816)
print v(xbgr.mr_n57165280)
print v(xbgr.mr_n57165744)
print v(xbgr.mr_n57166208)
print v(xbgr.mr_n57166672)
print v(xbgr.mr_n57167136)
print v(xbgr.mr_n57167600)
print v(xbgr.mr_n57168064)
print v(xbgr.mr_n57168528)
print v(xbgr.mr_n57168992)
print v(xbgr.mr_n57169344)
print v(xbgr.mr_n57169456)
print v(xbgr.mr_n57169728)
print v(xbgr.mr_n57169920)
print v(xbgr.mr_n57170384)
print v(xbgr.mr_n57170848)
print v(xbgr.mr_n57171312)
print v(xbgr.mr_n57171776)
print v(xbgr.mr_n57172128)
print v(xbgr.mr_n57172240)
print v(xbgr.mr_n57172704)
print v(xbgr.mr_n57173168)
print v(xbgr.mr_n57173632)
print v(xbgr.mr_n57174096)
print v(xbgr.mr_n57174560)
print v(xbgr.mr_n57175024)
print v(xbgr.mr_n57175488)
print v(xbgr.mr_n57175952)
print v(xbgr.mr_n57176416)
print v(xbgr.mr_n57176816)
print v(xbgr.mr_n57177280)
print v(xbgr.mr_n57177744)
print v(xbgr.mr_n57178144)
print v(xbgr.mr_n57178608)
print v(xbgr.mr_n57179072)
print v(xbgr.mr_n57179536)
print v(xbgr.mr_n57180000)
print v(xbgr.mr_n57180464)
print v(xbgr.mr_n57180928)
print v(xbgr.mr_n57181392)
print v(xbgr.mr_n57181856)
print v(xbgr.mr_n57182320)
print v(xbgr.mr_n57182784)
print v(xbgr.mr_n57183248)
print v(xbgr.mr_n57183712)
print v(xbgr.mr_n57184176)
print v(xbgr.mr_n57184640)
print v(xbgr.mr_n57185104)
print v(xbgr.mr_n57185568)
print v(xbgr.mr_n57186032)
print v(xbgr.mr_n57186496)
print v(xbgr.mr_n57186960)
print v(xbgr.mr_n57187424)
print v(xbgr.mr_n57187888)
print v(xbgr.mr_n57188352)
print v(xbgr.mr_n57188816)
print v(xbgr.mr_n57189280)
print v(xbgr.mr_n57189744)
print v(xbgr.mr_n57190208)
print v(xbgr.mr_n57190672)
print v(xbgr.mr_n57191136)
print v(xbgr.mr_n57191600)
print v(xbgr.mr_n57192064)
print v(xbgr.mr_n57192528)
print v(xbgr.mr_n57192992)
print v(xbgr.mr_n57193456)
print v(xbgr.mr_n57193920)
print v(xbgr.mr_n57194384)
print v(xbgr.mr_n57194656)
print v(xbgr.mr_n57194848)
print v(xbgr.mr_n57195312)
print v(xbgr.mr_n57195776)
print v(xbgr.mr_n57196240)
print v(xbgr.mr_n57196704)
print v(xbgr.mr_n57197056)
print v(xbgr.mr_n57197168)
print v(xbgr.mr_n57197632)
print v(xbgr.mr_n57198096)
print v(xbgr.mr_n57198560)
print v(xbgr.mr_n57199024)
print v(xbgr.mr_n57199488)
print v(xbgr.mr_n57199952)
print v(xbgr.mr_n57200416)
print v(xbgr.mr_n57200880)
print v(xbgr.mr_n57201344)
print v(xbgr.mr_n57201616)
print v(xbgr.mr_n57201808)
print v(xbgr.mr_n57202272)
print v(xbgr.mr_n57202736)
print v(xbgr.mr_n57203200)
print v(xbgr.mr_n57203664)
print v(xbgr.mr_n57204128)
print v(xbgr.mr_n57204592)
print v(xbgr.mr_n57205056)
print v(xbgr.mr_n57205520)
print v(xbgr.mr_n57205984)
print v(xbgr.mr_n57206448)
print v(xbgr.mr_n57206912)
print v(xbgr.mr_n57207376)
print v(xbgr.mr_n57207840)
print v(xbgr.mr_n57208304)
print v(xbgr.mr_n57208768)
print v(xbgr.mr_n57209232)
print v(xbgr.mr_n57209696)
print v(xbgr.mr_n57210160)
print v(xbgr.mr_n57210624)
print v(xbgr.mr_n57211088)
print v(xbgr.mr_n57211552)
print v(xbgr.mr_n57212016)
print v(xbgr.mr_n57212480)
print v(xbgr.mr_n57212944)
print v(xbgr.mr_n57213408)
print v(xbgr.mr_n57213872)
print v(xbgr.mr_n57214336)
print v(xbgr.mr_n57214800)
print v(xbgr.mr_n57215264)
print v(xbgr.mr_n57215728)
print v(xbgr.mr_n57215840)
print v(xbgr.mr_n57216464)
print v(xbgr.mr_n57216688)
print v(xbgr.mr_n57217200)
print v(xbgr.mr_n57217424)
print v(xbgr.mr_n57217936)
print v(xbgr.mr_n57218160)
print v(xbgr.mr_n57218672)
print v(xbgr.mr_n57218784)
print v(xbgr.mr_n57218896)
print v(xbgr.mr_n57219408)
print v(xbgr.mr_n57219520)
print v(xbgr.mr_n57219632)
print v(xbgr.mr_n57220144)
print v(xbgr.mr_n57220256)
print v(xbgr.mr_n57220368)
print v(xbgr.mr_n57220880)
print v(xbgr.mr_n57221152)
print v(xbgr.mr_n57221424)
print v(xbgr.mr_n57221696)
print v(xbgr.mr_n57221808)
print v(xbgr.mr_n57221920)
print v(xbgr.mr_n57222432)
print v(xbgr.mr_n57222704)
print v(xbgr.mr_n57222976)
print v(xbgr.mr_n57223248)
print v(xbgr.mr_n57223520)
print v(xbgr.mr_n57224064)
print v(xbgr.mr_n57224336)
print v(xbgr.mr_n57224608)
print v(xbgr.mr_n57224880)
print v(xbgr.mr_n57225152)
print v(xbgr.mr_n57225424)
print v(xbgr.mr_n57225696)
print v(xbgr.mr_n57225968)
print v(xbgr.mr_n57226240)
print v(xbgr.mr_n57226512)
print v(xbgr.mr_n57226784)
print v(xbgr.mr_n57227056)
print v(xbgr.mr_n57227328)
print v(xbgr.mr_n57227600)
print v(xbgr.mr_n57227872)
print v(xbgr.mr_n57228144)
print v(xbgr.mr_n57228416)
print v(xbgr.mr_n57228688)
print v(xbgr.mr_n57228960)
print v(xbgr.mr_n57229232)
print v(xbgr.mr_n57229696)
print v(xbgr.mr_n57230160)
print v(xbgr.mr_n57230624)
print v(xbgr.mr_n57231088)
print v(xbgr.mr_n57231552)
print v(xbgr.mr_n57232016)
print v(xbgr.mr_n57232480)
print v(xbgr.mr_n57232944)
print v(xbgr.mr_n57233408)
print v(xbgr.mr_n57233872)
print v(xbgr.mr_n57234336)
print v(xbgr.mr_n57235952)
print v(xbgr.mr_n57246592)
print v(xbgr.mr_n57246832)
print v(xbgr.mr_n57247168)
print v(xbgr.mr_n57247808)
print v(xbgr.mr_n57250464)
print v(xbgr.mr_n57250928)
print v(xbgr.mr_n57251584)
print v(xbgr.mr_n57252176)
print v(xbgr.mr_n57252768)
print v(xbgr.mr_n57253360)
print v(xbgr.mr_n57253952)
print v(xbgr.mr_n57254544)
print v(xbgr.mr_n57255136)
print v(xbgr.mr_n57255728)
print v(xbgr.mr_n57256320)
print v(xbgr.mr_n57256912)
print v(xbgr.mr_n57257504)
print v(xbgr.mr_n57258096)
print v(xbgr.mr_n57258688)
print v(xbgr.mr_n57259280)
print v(xbgr.mr_n57259872)
print v(xbgr.mr_n57260464)
print v(xbgr.mr_n57261056)
print v(xbgr.mr_n57261648)
print v(xbgr.mr_n57262240)
print v(xbgr.mr_n57262832)
print v(xbgr.mr_n57263424)
print v(xbgr.mr_n57264016)
print v(xbgr.mr_n57264608)
print v(xbgr.mr_n57265792)
print v(xbgr.mr_n57266384)
print v(xbgr.mr_n57266976)
print v(xbgr.mr_n57267568)
print v(xbgr.mr_n57268160)
print v(xbgr.mr_n57268752)
print v(xbgr.mr_n57269344)
print v(xbgr.mr_n57269936)
print v(xbgr.mr_n57274400)
print v(xbgr.mr_n57281552)
print v(xbgr.mr_n57295136)
print v(xbgr.mr_n57296208)
print v(xbgr.mr_n57297024)
print v(xbgr.mr_n57297616)
print v(xbgr.mr_n57301408)
print v(xbgr.mr_n57303984)
print v(xbgr.mr_n57307216)
print v(xbgr.mr_n57308992)
print v(xbgr.mr_n57313744)
print v(xbgr.mr_n57314192)
print v(xbgr.mr_n57314400)
print v(xbgr.mr_n57315904)
print v(xbgr.mr_n57316512)
print v(xbgr.mr_n57316624)
print v(xbgr.mr_n57317232)
print v(xbgr.mr_n57317344)
print v(xbgr.mr_n57317952)
print v(xbgr.mr_n57318064)
print v(xbgr.mr_n57318672)
print v(xbgr.mr_n57319616)
print v(xbgr.mr_n57319728)
print v(xbgr.mr_n57320720)
print v(xbgr.mr_n57321632)
print v(xbgr.mr_n57322768)
print v(xbgr.mr_n57324560)
print v(xbgr.mr_n57325392)
print v(xbgr.mr_n57325632)
print v(xbgr.mr_n57326608)
print v(xbgr.mr_n57326848)
print v(xbgr.mr_n57329344)
print v(xbgr.mr_n57329648)
print v(xbgr.mr_n57330192)
print v(xbgr.mr_n57331104)
print v(xbgr.mr_n57331408)
print v(xbgr.mr_n57334208)
print v(xbgr.mr_n57334816)
print v(xbgr.mr_n57336272)
print v(xbgr.mr_n57336640)
print v(xbgr.mr_n57337552)
print v(xbgr.mr_n57338464)
print v(xbgr.mr_n57340032)
print v(xbgr.mr_n57343328)
print v(xbgr.mr_n57345648)
print v(xbgr.mr_n57346912)
print v(xbgr.mr_n57350624)
print v(xbgr.mr_n57352688)
print v(xbgr.mr_n57353056)
print v(xbgr.mr_n57353600)
print v(xbgr.mr_n57353968)
print v(xbgr.mr_n57354576)
print v(xbgr.mr_n57354880)
print v(xbgr.mr_n57356400)
print v(xbgr.mr_n57356640)
print v(xbgr.mr_n57357072)
print v(xbgr.mr_n57357248)
print v(xbgr.mr_n57358320)
print v(xbgr.mr_n57360896)
print v(xbgr.mr_n57362112)
print v(xbgr.mr_n57363920)
print v(xbgr.mr_n57366944)
print v(xbgr.mr_n57367152)
print v(xbgr.mr_n57367920)
print v(xbgr.mr_n57368224)
print v(xbgr.mr_n57368832)
print v(xbgr.mr_n57369472)
print v(xbgr.mr_n57373520)
print v(xbgr.mr_n57373696)
print v(xbgr.mr_n57373872)
print v(xbgr.mr_n57375856)
print v(xbgr.mr_n57376272)
print v(xbgr.mr_n57376448)
print v(xbgr.mr_n57377040)
print v(xbgr.mr_n57377632)
print v(xbgr.mr_n57378224)
print v(xbgr.mr_n57378816)
print v(xbgr.mr_n57379408)
print v(xbgr.mr_n57380000)
print v(xbgr.mr_n57380592)
print v(xbgr.mr_n57381184)
print v(xbgr.mr_n57381520)
print v(xbgr.mr_n57381776)
print v(xbgr.mr_n57382368)
print v(xbgr.mr_n57382704)
print v(xbgr.mr_n57382960)
print v(xbgr.mr_n57383552)
print v(xbgr.mr_n57384144)
print v(xbgr.mr_n57384736)
print v(xbgr.mr_n57385264)
print v(xbgr.mr_n57385840)
print v(xbgr.mr_n57386512)
print v(xbgr.mr_n57387104)
print v(xbgr.mr_n57387696)
print v(xbgr.mr_n57388816)
print v(xbgr.mr_n57389472)
print v(xbgr.mr_n57390064)
print v(xbgr.mr_n57390656)
print v(xbgr.mr_n57391248)
print v(xbgr.mr_n57391840)
print v(xbgr.mr_n57392432)
print v(xbgr.mr_n57392768)
print v(xbgr.mr_n57393024)
print v(xbgr.mr_n57393616)
print v(xbgr.mr_n57394128)
print v(xbgr.mr_n57394800)
print v(xbgr.mr_n57395392)
print v(xbgr.mr_n57395984)
print v(xbgr.mr_n57396576)
print v(xbgr.mr_n57397104)
print v(xbgr.mr_n57397760)
print v(xbgr.mr_n57398352)
print v(xbgr.mr_n57398944)
print v(xbgr.mr_n57399536)
print v(xbgr.mr_n57400128)
print v(xbgr.mr_n57400720)
print v(xbgr.mr_n57401312)
print v(xbgr.mr_n57401840)
print v(xbgr.mr_n57402496)
print v(xbgr.mr_n57403088)
print v(xbgr.mr_n57403680)
print v(xbgr.mr_n57403936)
print v(xbgr.mr_n57404272)
print v(xbgr.mr_n57404864)
print v(xbgr.mr_n57405424)
print v(xbgr.mr_n57405536)
print v(xbgr.mr_n57406176)
print v(xbgr.mr_n57406880)
print v(xbgr.mr_n57407792)
print v(xbgr.mr_n57408768)
print v(xbgr.mr_n57409360)
print v(xbgr.mr_n57409952)
print v(xbgr.mr_n57410544)
print v(xbgr.mr_n57411136)
print v(xbgr.mr_n57411728)
print v(xbgr.mr_n57412320)
print v(xbgr.mr_n57412896)
print v(xbgr.mr_n57413488)
print v(xbgr.mr_n57414080)
print v(xbgr.mr_n57414640)
print v(xbgr.mr_n57414960)
print v(xbgr.mr_n57415216)
print v(xbgr.mr_n57415808)
print v(xbgr.mr_n57416400)
print v(xbgr.mr_n57416992)
print v(xbgr.mr_n57417584)
print v(xbgr.mr_n57418176)
print v(xbgr.mr_n57418768)
print v(xbgr.mr_n57419360)
print v(xbgr.mr_n57419952)
print v(xbgr.mr_n57420544)
print v(xbgr.mr_n57421136)
print v(xbgr.mr_n57421728)
print v(xbgr.mr_n57422320)
print v(xbgr.mr_n57422912)
print v(xbgr.mr_n57423504)
print v(xbgr.mr_n57424096)
print v(xbgr.mr_n57424688)
print v(xbgr.mr_n57425280)
print v(xbgr.mr_n57425872)
print v(xbgr.mr_n57426464)
print v(xbgr.mr_n57427056)
print v(xbgr.mr_n57427648)
print v(xbgr.mr_n57428240)
print v(xbgr.mr_n57428832)
print v(xbgr.mr_n57429424)
print v(xbgr.mr_n57430016)
print v(xbgr.mr_n57430608)
print v(xbgr.mr_n57431200)
print v(xbgr.mr_n57431792)
print v(xbgr.mr_n57432384)
print v(xbgr.mr_n57432976)
print v(xbgr.mr_n57433568)
print v(xbgr.mr_n57434160)
print v(xbgr.mr_n57434752)
print v(xbgr.mr_n57435344)
print v(xbgr.mr_n57435936)
print v(xbgr.mr_n57436528)
print v(xbgr.mr_n57437120)
print v(xbgr.mr_n57437632)
print v(xbgr.mr_n57438304)
print v(xbgr.mr_n57438640)
print v(xbgr.mr_n57438896)
print v(xbgr.mr_n57439488)
print v(xbgr.mr_n57440080)
print v(xbgr.mr_n57440672)
print v(xbgr.mr_n57441264)
print v(xbgr.mr_n57441856)
print v(xbgr.mr_n57442448)
print v(xbgr.mr_n57443040)
print v(xbgr.mr_n57443632)
print v(xbgr.mr_n57444224)
print v(xbgr.mr_n57444736)
print v(xbgr.mr_n57445408)
print v(xbgr.mr_n57446000)
print v(xbgr.mr_n57446592)
print v(xbgr.mr_n57447184)
print v(xbgr.mr_n57447776)
print v(xbgr.mr_n57448368)
print v(xbgr.mr_n57448960)
print v(xbgr.mr_n57449552)
print v(xbgr.mr_n57450144)
print v(xbgr.mr_n57450736)
print v(xbgr.mr_n57451328)
print v(xbgr.mr_n57451920)
print v(xbgr.mr_n57452512)
print v(xbgr.mr_n57453104)
print v(xbgr.mr_n57453936)
print v(xbgr.mr_n57454176)
print v(xbgr.mr_n57454416)
print v(xbgr.mr_n57455136)
print v(xbgr.mr_n57455936)
print v(xbgr.mr_n57456336)
print v(xbgr.mr_n57456736)
print v(xbgr.mr_n57457136)
print v(xbgr.mr_n57457536)
print v(xbgr.mr_n57469008)
print v(xbgr.mr_n57469904)
print v(xbgr.mr_n57470496)
print v(xbgr.mr_n57477904)
print v(xbgr.mr_n57481296)
print v(xbgr.mr_n57482944)
print v(xbgr.mr_n57483632)
print v(xbgr.mr_n57486928)
print v(xbgr.mr_n57487184)
print v(xbgr.mr_n57488832)
print v(xbgr.mr_n57489424)
print v(xbgr.mr_n57490608)
print v(xbgr.mr_n57491200)
print v(xbgr.mr_n57491792)
print v(xbgr.mr_n57492384)
print v(xbgr.mr_n57492976)
print v(xbgr.mr_n57493568)
print v(xbgr.mr_n57494160)
print v(xbgr.mr_n57494752)
print v(xbgr.mr_n57501488)
print v(xbgr.mr_n57503488)
print v(xbgr.mr_n57505264)
print v(xbgr.mr_n57507440)
print v(xbgr.mr_n57525680)
print v(xbgr.mr_n57528784)
print v(xbgr.mr_n57528928)
print v(xbgr.mr_n57529680)
print v(xbgr.mr_n57529936)
print v(xbgr.mr_n57531280)
print v(xbgr.mr_n57533280)
print v(xbgr.mr_n57533872)
print v(xbgr.mr_n57534464)
print v(xbgr.mr_n57535056)
print v(xbgr.mr_n57535648)
print v(xbgr.mr_n57536240)
print v(xbgr.mr_n57537424)
print v(xbgr.mr_n57538016)
print v(xbgr.mr_n57538608)
print v(xbgr.mr_n57539200)
print v(xbgr.mr_n57539792)
print v(xbgr.mr_n57540384)
print v(xbgr.mr_n57540560)
print v(xbgr.mr_n57540672)
print v(xbgr.mr_n57541216)
print v(xbgr.mr_n57542176)
print v(xbgr.mr_n57543520)
print v(xbgr.mr_n57544112)
print v(xbgr.mr_n57544704)
print v(xbgr.mr_n57545296)
print v(xbgr.mr_n57545888)
print v(xbgr.mr_n57546480)
print v(xbgr.mr_n57547072)
print v(xbgr.mr_n57547664)
print v(xbgr.mr_n57548256)
print v(xbgr.mr_n57548848)
print v(xbgr.mr_n57549440)
print v(xbgr.mr_n57550624)
print v(xbgr.mr_n57551216)
print v(xbgr.mr_n57551808)
print v(xbgr.mr_n57552400)
print v(xbgr.mr_n57552992)
print v(xbgr.mr_n57553584)
print v(xbgr.mr_n57554176)
print v(xbgr.mr_n57554512)
print v(xbgr.mr_n57554768)
print v(xbgr.mr_n57555360)
print v(xbgr.mr_n57555952)
print v(xbgr.mr_n57556544)
print v(xbgr.mr_n57557728)
print v(xbgr.mr_n57558320)
print v(xbgr.mr_n57558736)
print v(xbgr.mr_n57558912)
print v(xbgr.mr_n57559504)
print v(xbgr.mr_n57560096)
print v(xbgr.mr_n57560688)
print v(xbgr.mr_n57561280)
print v(xbgr.mr_n57561872)
print v(xbgr.mr_n57562464)
print v(xbgr.mr_n57563056)
print v(xbgr.mr_n57563472)
print v(xbgr.mr_n57563648)
print v(xbgr.mr_n57564240)
print v(xbgr.mr_n57564832)
print v(xbgr.mr_n57565424)
print v(xbgr.mr_n57566016)
print v(xbgr.mr_n57566608)
print v(xbgr.mr_n57567200)
print v(xbgr.mr_n57567792)
print v(xbgr.mr_n57568384)
print v(xbgr.mr_n57568976)
print v(xbgr.mr_n57569568)
print v(xbgr.mr_n57570160)
print v(xbgr.mr_n57570752)
print v(xbgr.mr_n57571936)
print v(xbgr.mr_n57572528)
print v(xbgr.mr_n57573120)
print v(xbgr.mr_n57573712)
print v(xbgr.mr_n57574128)
print v(xbgr.mr_n57574304)
print v(xbgr.mr_n57574896)
print v(xbgr.mr_n57575488)
print v(xbgr.mr_n57576080)
print v(xbgr.mr_n57576672)
print v(xbgr.mr_n57577264)
print v(xbgr.mr_n57577856)
print v(xbgr.mr_n57578432)
print v(xbgr.mr_n57579024)
print v(xbgr.mr_n57579616)
print v(xbgr.mr_n57580208)
print v(xbgr.mr_n57580800)
print v(xbgr.mr_n57581392)
print v(xbgr.mr_n57581984)
print v(xbgr.mr_n57582576)
print v(xbgr.mr_n57583168)
print v(xbgr.mr_n57583760)
print v(xbgr.mr_n57584352)
print v(xbgr.mr_n57584944)
print v(xbgr.mr_n57585536)
print v(xbgr.mr_n57586128)
print v(xbgr.mr_n57586720)
print v(xbgr.mr_n57587312)
print v(xbgr.mr_n57587904)
print v(xbgr.mr_n57588496)
print v(xbgr.mr_n57589088)
print v(xbgr.mr_n57589680)
print v(xbgr.mr_n57590272)
print v(xbgr.mr_n57590864)
print v(xbgr.mr_n57591456)
print v(xbgr.mr_n57592048)
print v(xbgr.mr_n57592640)
print v(xbgr.mr_n57593232)
print v(xbgr.mr_n57593824)
print v(xbgr.mr_n57594416)
print v(xbgr.mr_n57595008)
print v(xbgr.mr_n57595600)
print v(xbgr.mr_n57596192)
print v(xbgr.mr_n57596784)
print v(xbgr.mr_n57597376)
print v(xbgr.mr_n57597968)
print v(xbgr.mr_n57598560)
print v(xbgr.mr_n57599152)
print v(xbgr.mr_n57599744)
print v(xbgr.mr_n57600336)
print v(xbgr.mr_n57600928)
print v(xbgr.mr_n57601520)
print v(xbgr.mr_n57602112)
print v(xbgr.mr_n57602640)
print v(xbgr.mr_n57603104)
print v(xbgr.mr_n57603568)
print v(xbgr.mr_n57603680)
print v(xbgr.mr_n57604032)
print v(xbgr.mr_n57604496)
print v(xbgr.mr_n57604608)
print v(xbgr.mr_n57604960)
print v(xbgr.mr_n57605072)
print v(xbgr.mr_n57606464)
print v(xbgr.mr_n57606720)
print v(xbgr.mr_n57607056)
print v(xbgr.mr_n57607696)
print v(xbgr.mr_n57608096)
print v(xbgr.mr_n57608496)
print v(xbgr.mr_n57608896)
print v(xbgr.mr_n57609296)
print v(xbgr.mr_n57609696)
print v(xbgr.mr_n57610096)
print v(xbgr.mr_n57610496)
print v(xbgr.mr_n57610896)
print v(xbgr.mr_n57611296)
print v(xbgr.mr_n57611696)
print v(xbgr.mr_n57612096)
print v(xbgr.mr_n57612496)
print v(xbgr.mr_n57612896)
print v(xbgr.mr_n57613296)
print v(xbgr.mr_n57613696)
print v(xbgr.mr_n57614096)
print v(xbgr.mr_n57614496)
print v(xbgr.mr_n57614896)
print v(xbgr.mr_n57615296)
print v(xbgr.mr_n57615696)
print v(xbgr.mr_n57616096)
print v(xbgr.mr_n57616496)
print v(xbgr.mr_n57616896)
print v(xbgr.mr_n57617296)
print v(xbgr.mr_n57617696)
print v(xbgr.mr_n57618096)
print v(xbgr.mr_n57618496)
print v(xbgr.mr_n57618896)
print v(xbgr.mr_n57619296)
print v(xbgr.mr_n57619696)
print v(xbgr.mr_n57620096)
print v(xbgr.mr_n57620496)
print v(xbgr.mr_n57620896)
print v(xbgr.mr_n57621296)
print v(xbgr.mr_n57621696)
print v(xbgr.mr_n57622160)
print v(xbgr.mr_n57622752)
print v(xbgr.mr_n57623344)
print v(xbgr.mr_n57623872)
print v(xbgr.mr_n57624528)
print v(xbgr.mr_n57625056)
print v(xbgr.mr_n57625712)
print v(xbgr.mr_n57626304)
print v(xbgr.mr_n57626896)
print v(xbgr.mr_n57627488)
print v(xbgr.mr_n57628080)
print v(xbgr.mr_n57631312)
print v(xbgr.mr_n57632400)
print v(xbgr.mr_n57633536)
print v(xbgr.mr_n57635264)
print v(xbgr.mr_n57638416)
print v(xbgr.mr_n57643456)
print v(xbgr.mr_n57645136)
print v(xbgr.mr_n57645664)
print v(xbgr.mr_n57646320)
print v(xbgr.mr_n57646912)
print v(xbgr.mr_n57647504)
print v(xbgr.mr_n57648096)
print v(xbgr.mr_n57648624)
print v(xbgr.mr_n57649280)
print v(xbgr.mr_n57649808)
print v(xbgr.mr_n57650208)
print v(xbgr.mr_n57650464)
print v(xbgr.mr_n57650992)
print v(xbgr.mr_n57651648)
print v(xbgr.mr_n57652240)
print v(xbgr.mr_n57652768)
print v(xbgr.mr_n57653424)
print v(xbgr.mr_n57653952)
print v(xbgr.mr_n57654608)
print v(xbgr.mr_n57655024)
print v(xbgr.mr_n57655200)
print v(xbgr.mr_n57655792)
print v(xbgr.mr_n57656384)
print v(xbgr.mr_n57656976)
print v(xbgr.mr_n57657568)
print v(xbgr.mr_n57658160)
print v(xbgr.mr_n57658752)
print v(xbgr.mr_n57659280)
print v(xbgr.mr_n57659936)
print v(xbgr.mr_n57660528)
print v(xbgr.mr_n57661120)
print v(xbgr.mr_n57661712)
print v(xbgr.mr_n57662304)
print v(xbgr.mr_n57662896)
print v(xbgr.mr_n57663488)
print v(xbgr.mr_n57664080)
print v(xbgr.mr_n57664416)
print v(xbgr.mr_n57664672)
print v(xbgr.mr_n57665264)
print v(xbgr.mr_n57665856)
print v(xbgr.mr_n57666384)
print v(xbgr.mr_n57667040)
print v(xbgr.mr_n57667376)
print v(xbgr.mr_n57667632)
print v(xbgr.mr_n57668224)
print v(xbgr.mr_n57668816)
print v(xbgr.mr_n57669344)
print v(xbgr.mr_n57670000)
print v(xbgr.mr_n57670528)
print v(xbgr.mr_n57671184)
print v(xbgr.mr_n57671712)
print v(xbgr.mr_n57672368)
print v(xbgr.mr_n57673552)
print v(xbgr.mr_n57674576)
print v(xbgr.mr_n57676576)
print v(xbgr.mr_n57683216)
print v(xbgr.mr_n57684912)
print v(xbgr.mr_n57686528)
print v(xbgr.mr_n57687904)
print v(xbgr.mr_n57692560)
print v(xbgr.mr_n57693696)
print v(xbgr.mr_n57697072)
print v(xbgr.mr_n57702944)
print v(xbgr.mr_n57714688)
print v(xbgr.mr_n57715280)
print v(xbgr.mr_n57716064)
print v(xbgr.mr_n57716192)
print v(xbgr.mr_n57716592)
print v(xbgr.mr_n57716832)
print v(xbgr.mr_n57717296)
print v(xbgr.mr_n57718160)
print v(xbgr.mr_n57718272)
print v(xbgr.mr_n57718880)
print v(xbgr.mr_n57719600)
print v(xbgr.mr_n57719712)
print v(xbgr.mr_n57720320)
print v(xbgr.mr_n57721040)
print v(xbgr.mr_n57721152)
print v(xbgr.mr_n57721760)
print v(xbgr.mr_n57725184)
print v(xbgr.mr_n57730816)
print v(xbgr.mr_n57731984)
print v(xbgr.mr_n57741184)
print v(xbgr.mr_n57742480)
print v(xbgr.mr_n57742736)
print v(xbgr.mr_n57744528)
print v(xbgr.mr_n57750080)
print v(xbgr.mr_n57751216)
print v(xbgr.mr_n57752896)
print v(xbgr.mr_n57754912)
print v(xbgr.mr_n57757152)
print v(xbgr.mr_n57757328)
print v(xbgr.mr_n57760736)
print v(xbgr.mr_n57761248)
print v(xbgr.mr_n57761632)
print v(xbgr.mr_n57761984)
print v(xbgr.mr_n57762288)
print v(xbgr.mr_n57763152)
print v(xbgr.mr_n57763776)
print v(xbgr.mr_n57764160)
print v(xbgr.mr_n57764272)
print v(xbgr.mr_n57764384)
print v(xbgr.mr_n57765456)
print v(xbgr.mr_n57766512)
print v(xbgr.mr_n57767440)
print v(xbgr.mr_n57767824)
print v(xbgr.mr_n57768368)
print v(xbgr.mr_n57769520)
print v(xbgr.mr_n57770112)
print v(xbgr.mr_n57770704)
print v(xbgr.mr_n57771040)
print v(xbgr.mr_n57771296)
print v(xbgr.mr_n57771632)
print v(xbgr.mr_n57771888)
print v(xbgr.mr_n57772480)
print v(xbgr.mr_n57773072)
print v(xbgr.mr_n57774176)
print v(xbgr.mr_n57774848)
print v(xbgr.mr_n57775440)
print v(xbgr.mr_n57776032)
print v(xbgr.mr_n57776624)
print v(xbgr.mr_n57777216)
print v(xbgr.mr_n57777808)
print v(xbgr.mr_n57778400)
print v(xbgr.mr_n57778992)
print v(xbgr.mr_n57779584)
print v(xbgr.mr_n57780096)
print v(xbgr.mr_n57780768)
print v(xbgr.mr_n57781360)
print v(xbgr.mr_n57781952)
print v(xbgr.mr_n57782544)
print v(xbgr.mr_n57783136)
print v(xbgr.mr_n57783728)
print v(xbgr.mr_n57784320)
print v(xbgr.mr_n57784912)
print v(xbgr.mr_n57785504)
print v(xbgr.mr_n57786096)
print v(xbgr.mr_n57787280)
print v(xbgr.mr_n57787872)
print v(xbgr.mr_n57788464)
print v(xbgr.mr_n57789056)
print v(xbgr.mr_n57789648)
print v(xbgr.mr_n57790160)
print v(xbgr.mr_n57790832)
print v(xbgr.mr_n57791344)
print v(xbgr.mr_n57792016)
print v(xbgr.mr_n57792608)
print v(xbgr.mr_n57793200)
print v(xbgr.mr_n57793792)
print v(xbgr.mr_n57794368)
print v(xbgr.mr_n57794960)
print v(xbgr.mr_n57795552)
print v(xbgr.mr_n57796144)
print v(xbgr.mr_n57796736)
print v(xbgr.mr_n57797248)
print v(xbgr.mr_n57797840)
print v(xbgr.mr_n57798512)
print v(xbgr.mr_n57799104)
print v(xbgr.mr_n57799696)
print v(xbgr.mr_n57800288)
print v(xbgr.mr_n57801472)
print v(xbgr.mr_n57802064)
print v(xbgr.mr_n57802656)
print v(xbgr.mr_n57803248)
print v(xbgr.mr_n57803760)
print v(xbgr.mr_n57804432)
print v(xbgr.mr_n57805024)
print v(xbgr.mr_n57805616)
print v(xbgr.mr_n57806208)
print v(xbgr.mr_n57806800)
print v(xbgr.mr_n57807392)
print v(xbgr.mr_n57807984)
print v(xbgr.mr_n57808576)
print v(xbgr.mr_n57809168)
print v(xbgr.mr_n57809760)
print v(xbgr.mr_n57810352)
print v(xbgr.mr_n57810768)
print v(xbgr.mr_n57810912)
print v(xbgr.mr_n57811024)
print v(xbgr.mr_n57812048)
print v(xbgr.mr_n57812592)
print v(xbgr.mr_n57813056)
print v(xbgr.mr_n57813520)
print v(xbgr.mr_n57813984)
print v(xbgr.mr_n57814448)
print v(xbgr.mr_n57815424)
print v(xbgr.mr_n57819776)
print v(xbgr.mr_n57821392)
print v(xbgr.mr_n57821504)
print v(xbgr.mr_n57821616)
print v(xbgr.mr_n57821728)
print v(xbgr.mr_n57821840)
print v(xbgr.mr_n57821952)
print v(xbgr.mr_n57822064)
print v(xbgr.mr_n57822176)
print v(xbgr.mr_n57822288)
print v(xbgr.mr_n57822480)
print v(xbgr.mr_n57822752)
print v(xbgr.mr_n57823024)
print v(xbgr.mr_n57823296)
print v(xbgr.mr_n57823488)
print v(xbgr.mr_n57823840)
print v(xbgr.mr_n57824112)
print v(xbgr.mr_n57824416)
print v(xbgr.mr_n57824816)
print v(xbgr.mr_n57825216)
print v(xbgr.mr_n57825616)
print v(xbgr.mr_n57826016)
print v(xbgr.mr_n57826416)
print v(xbgr.mr_n57826816)
print v(xbgr.mr_n57827216)
print v(xbgr.mr_n57827616)
print v(xbgr.mr_n57828016)
print v(xbgr.mr_n57828416)
print v(xbgr.mr_n57828816)
print v(xbgr.mr_n57829216)
print v(xbgr.mr_n57829616)
print v(xbgr.mr_n57830016)
print v(xbgr.mr_n57830416)
print v(xbgr.mr_n57830816)
print v(xbgr.mr_n57831216)
print v(xbgr.mr_n57831616)
print v(xbgr.mr_n57832016)
print v(xbgr.mr_n57832416)
print v(xbgr.mr_n57832816)
print v(xbgr.mr_n57833216)
print v(xbgr.mr_n57833616)
print v(xbgr.mr_n57834016)
print v(xbgr.mr_n57834416)
print v(xbgr.mr_n57834816)
print v(xbgr.mr_n57835216)
print v(xbgr.mr_n57835536)
print v(xbgr.mr_n57835952)
print v(xbgr.mr_n57836064)
print v(xbgr.mr_n57836256)
print v(xbgr.mr_n57836528)
print v(xbgr.mr_n57836800)
print v(xbgr.mr_n57837072)
print v(xbgr.mr_n57837344)
print v(xbgr.mr_n57837616)
print v(xbgr.mr_n57837888)
print v(xbgr.mr_n57838160)
print v(xbgr.mr_n57838432)
print v(xbgr.mr_n57838704)
print v(xbgr.mr_n57838976)
print v(xbgr.mr_n57839248)
print v(xbgr.mr_n57839520)
print v(xbgr.mr_n57839792)
print v(xbgr.mr_n57840064)
print v(xbgr.mr_n57840336)
print v(xbgr.mr_n57840784)
print v(xbgr.mr_n57840976)
print v(xbgr.mr_n57841168)
print v(xbgr.mr_n57841360)
print v(xbgr.mr_n57842304)
print v(xbgr.mr_n57846064)
print v(xbgr.mr_n57846176)
print v(xbgr.mr_n57846368)
print v(xbgr.mr_n57847120)
print v(xbgr.mr_n57848032)
print v(xbgr.mr_n57848784)
print v(xbgr.mr_n57851056)
print v(xbgr.mr_n57851168)
print v(xbgr.mr_n57851360)
print v(xbgr.mr_n57852112)
print v(xbgr.mr_n57853024)
print v(xbgr.mr_n57853776)
print v(xbgr.mr_n57856048)
print v(xbgr.mr_n57856160)
print v(xbgr.mr_n57856352)
print v(xbgr.mr_n57857104)
print v(xbgr.mr_n57858016)
print v(xbgr.mr_n57858768)
print v(xbgr.mr_n57861040)
print v(xbgr.mr_n57861152)
print v(xbgr.mr_n57861344)
print v(xbgr.mr_n57862096)
print v(xbgr.mr_n57863008)
print v(xbgr.mr_n57863760)
print v(xbgr.mr_n57866032)
print v(xbgr.mr_n57866144)
print v(xbgr.mr_n57866336)
print v(xbgr.mr_n57867088)
print v(xbgr.mr_n57868000)
print v(xbgr.mr_n57868752)
print v(xbgr.mr_n57871024)
print v(xbgr.mr_n57871136)
print v(xbgr.mr_n57871328)
print v(xbgr.mr_n57872080)
print v(xbgr.mr_n57875600)
print v(xbgr.mr_n57876112)
print v(xbgr.mr_n57876544)
print v(xbgr.mr_n57876720)
print v(xbgr.mr_n57876896)
print v(xbgr.mr_n57877568)
print v(xbgr.mr_n57878000)
print v(xbgr.mr_n57878176)
print v(xbgr.mr_n57878512)
print v(xbgr.mr_n57879216)
print v(xbgr.mr_n57879392)
print v(xbgr.mr_n57879568)
print v(xbgr.mr_n57880080)
print v(xbgr.mr_n57880192)
print v(xbgr.mr_n57880752)
print v(xbgr.mr_n57880928)
print v(xbgr.mr_n57881424)
print v(xbgr.mr_n57882128)
print v(xbgr.mr_n57882304)
print v(xbgr.mr_n57882480)
print v(xbgr.mr_n57882992)
print v(xbgr.mr_n57883104)
print v(xbgr.mr_n57883664)
print v(xbgr.mr_n57883840)
print v(xbgr.mr_n57884336)
print v(xbgr.mr_n57884848)
print v(xbgr.mr_n57885280)
print v(xbgr.mr_n57885456)
print v(xbgr.mr_n57885792)
print v(xbgr.mr_n57886496)
print v(xbgr.mr_n57886672)
print v(xbgr.mr_n57886848)
print v(xbgr.mr_n57887360)
print v(xbgr.mr_n57887472)
print v(xbgr.mr_n57888032)
print v(xbgr.mr_n57888208)
print v(xbgr.mr_n57888704)
print v(xbgr.mr_n57889216)
print v(xbgr.mr_n57889648)
print v(xbgr.mr_n57889824)
print v(xbgr.mr_n57890080)
print v(xbgr.mr_n57890672)
print v(xbgr.mr_n57891104)
print v(xbgr.mr_n57891280)
print v(xbgr.mr_n57891616)
print v(xbgr.mr_n57892320)
print v(xbgr.mr_n57892496)
print v(xbgr.mr_n57892672)
print v(xbgr.mr_n57893184)
print v(xbgr.mr_n57893616)
print v(xbgr.mr_n57893792)
print v(xbgr.mr_n57894128)
print v(xbgr.mr_n57894640)
print v(xbgr.mr_n57895072)
print v(xbgr.mr_n57895584)
print v(xbgr.mr_n57896096)
print v(xbgr.mr_n57896208)
print v(xbgr.mr_n57896768)
print v(xbgr.mr_n57896944)
print v(xbgr.mr_n57897360)
print v(xbgr.mr_n57898144)
print v(xbgr.mr_n57898320)
print v(xbgr.mr_n57898496)
print v(xbgr.mr_n57899008)
print v(xbgr.mr_n57899120)
print v(xbgr.mr_n57899232)
print v(xbgr.mr_n57899344)
print v(xbgr.mr_n57899456)
print v(xbgr.mr_n57899728)
print v(xbgr.mr_n57900080)
print v(xbgr.mr_n57900192)
print v(xbgr.mr_n57900464)
print v(xbgr.mr_n57900816)
print v(xbgr.mr_n57901056)
print v(xbgr.mr_n57901392)
print v(xbgr.mr_n57901744)
print v(xbgr.mr_n57901856)
print v(xbgr.mr_n57902048)
print v(xbgr.mr_n57902320)
print v(xbgr.mr_n57902592)
print v(xbgr.mr_n57902864)
print v(xbgr.mr_n57903136)
print v(xbgr.mr_n57903408)
print v(xbgr.mr_n57904032)
print v(xbgr.mr_n57904224)
print v(xbgr.mr_n57904416)
print v(xbgr.mr_n57904608)
print v(xbgr.mr_n57905360)
print v(xbgr.mr_n57923504)
print v(xbgr.mr_n57923680)
print v(xbgr.mr_n57924384)
print v(xbgr.mr_n57924560)
print v(xbgr.mr_n57924736)
print v(xbgr.mr_n57925440)
print v(xbgr.mr_n57925616)
print v(xbgr.mr_n57925792)
print v(xbgr.mr_n57926496)
print v(xbgr.mr_n57926672)
print v(xbgr.mr_n57926848)
print v(xbgr.mr_n57927552)
print v(xbgr.mr_n57927728)
print v(xbgr.mr_n57927904)
print v(xbgr.mr_n57928608)
print v(xbgr.mr_n57928784)
print v(xbgr.mr_n57928960)
print v(xbgr.mr_n57929536)
print v(xbgr.mr_n57929728)
print v(xbgr.mr_n57930000)
print v(xbgr.mr_n57930272)
print v(xbgr.mr_n57930544)
print v(xbgr.mr_n57930816)
print v(xbgr.mr_n57931088)
print v(xbgr.mr_n57931360)
print v(xbgr.mr_n57931632)
print v(xbgr.mr_n57931904)
print v(xbgr.mr_n57935440)
print v(xbgr.mr_n57935776)
print v(xbgr.mr_n57936112)
print v(xbgr.mr_n57936448)
print v(xbgr.mr_n57937024)
print v(xbgr.mr_n57937744)
print v(xbgr.mr_n57938144)
print v(xbgr.mr_n57938544)
print v(xbgr.mr_n57938944)
print v(xbgr.mr_n57939344)
print v(xbgr.mr_n57939744)
print v(xbgr.mr_n57940144)
print v(xbgr.mr_n57940608)
print v(xbgr.mr_n57940784)
print v(xbgr.mr_n57941408)
print v(xbgr.mr_n57941584)
print v(xbgr.mr_n57942208)
print v(xbgr.mr_n57942384)
print v(xbgr.mr_n57943008)
print v(xbgr.mr_n57943184)
print v(xbgr.mr_n57943984)
print v(xbgr.mr_n57944608)
print v(xbgr.mr_n57944784)
print v(xbgr.mr_n57945408)
print v(xbgr.mr_n57945584)
print v(xbgr.mr_n57946464)
print v(xbgr.mr_n57946576)
print v(xbgr.mr_n57946688)
print v(xbgr.mr_n57946800)
print v(xbgr.mr_n57947216)
print v(xbgr.mr_n57948320)
print v(xbgr.mr_n57950912)
print v(xbgr.mr_n57951424)
print v(xbgr.mr_n57952720)
print v(xbgr.mr_n57953232)
print v(xbgr.mr_n57954528)
print v(xbgr.mr_n57955040)
print v(xbgr.mr_n57956096)
print v(xbgr.mr_n57956848)
print v(xbgr.mr_n57958144)
print v(xbgr.mr_n57958656)
print v(xbgr.mr_n57959952)
print v(xbgr.mr_n57961600)
print v(xbgr.mr_n57962272)
print v(xbgr.mr_n57963568)
print v(xbgr.mr_n57964080)
print v(xbgr.mr_n57965376)
print v(xbgr.mr_n57965888)
print v(xbgr.mr_n57967184)
print v(xbgr.mr_n57967696)
print v(xbgr.mr_n57968992)
print v(xbgr.mr_n57969504)
print v(xbgr.mr_n57969616)
print v(xbgr.mr_n57969728)
print v(xbgr.mr_n57969840)
print v(xbgr.mr_n57970112)
print v(xbgr.mr_n57970224)
print v(xbgr.mr_n57970576)
print v(xbgr.mr_n57970688)
print v(xbgr.mr_n57970960)
print v(xbgr.mr_n57971312)
print v(xbgr.mr_n57971424)
print v(xbgr.mr_n57971856)
print v(xbgr.mr_n57972544)
print v(xbgr.mr_n57973024)
print v(xbgr.mr_n57973456)
print v(xbgr.mr_n57973872)
print v(xbgr.mr_n57974560)
print v(xbgr.mr_n57975088)
print v(xbgr.mr_n57975440)
print v(xbgr.mr_n57976128)
print v(xbgr.mr_n57976656)
print v(xbgr.mr_n57977008)
print v(xbgr.mr_n57977248)
print v(xbgr.mr_n57977696)
print v(xbgr.mr_n57978224)
print v(xbgr.mr_n57978576)
print v(xbgr.mr_n57979264)
print v(xbgr.mr_n57979728)
print v(xbgr.mr_n57980144)
print v(xbgr.mr_n57980832)
print v(xbgr.mr_n57981360)
print v(xbgr.mr_n57981712)
print v(xbgr.mr_n57982400)
print v(xbgr.mr_n57982928)
print v(xbgr.mr_n57983280)
print v(xbgr.mr_n57983968)
print v(xbgr.mr_n57984496)
print v(xbgr.mr_n57984848)
print v(xbgr.mr_n57985536)
print v(xbgr.mr_n57986064)
print v(xbgr.mr_n57986416)
print v(xbgr.mr_n57987104)
print v(xbgr.mr_n57987632)
print v(xbgr.mr_n57987984)
print v(xbgr.mr_n57988672)
print v(xbgr.mr_n57989136)
print v(xbgr.mr_n57989552)
print v(xbgr.mr_n57990240)
print v(xbgr.mr_n57990704)
print v(xbgr.mr_n57991120)
print v(xbgr.mr_n57991808)
print v(xbgr.mr_n57992336)
print v(xbgr.mr_n57992688)
print v(xbgr.mr_n57993696)
print v(xbgr.mr_n57995120)
print v(xbgr.mr_n57995616)
print v(xbgr.mr_n57996064)
print v(xbgr.mr_n57996896)
print v(xbgr.mr_n57997728)
print v(xbgr.mr_n57998112)
print v(xbgr.mr_n57998688)
print v(xbgr.mr_n57999008)
print v(xbgr.mr_n57999200)
print v(xbgr.mr_n57999456)
print v(xbgr.mr_n57999856)
print v(xbgr.mr_n58000544)
print v(xbgr.mr_n58000880)
print v(xbgr.mr_n58004000)
print v(xbgr.mr_n58006432)
print v(xbgr.mr_n58006896)
print v(xbgr.mr_n58008736)
print v(xbgr.mr_n58010016)
print v(xbgr.mr_n58010272)
print v(xbgr.mr_n58011552)
print v(xbgr.mr_n58014816)
print v(xbgr.mr_n58015744)
print v(xbgr.mr_n58016208)
print v(xbgr.mr_n58016672)
print v(xbgr.mr_n58017136)
print v(xbgr.mr_n58017600)
print v(xbgr.mr_n58018064)
print v(xbgr.mr_n58018528)
print v(xbgr.mr_n58018992)
print v(xbgr.mr_n58019456)
print v(xbgr.mr_n58019920)
print v(xbgr.mr_n58020384)
print v(xbgr.mr_n58020848)
print v(xbgr.mr_n58021312)
print v(xbgr.mr_n58021776)
print v(xbgr.mr_n58022240)
print v(xbgr.mr_n58022704)
print v(xbgr.mr_n58026560)
print v(xbgr.mr_n58027104)
print v(xbgr.mr_n58027440)
print v(xbgr.mr_n58027776)
print v(xbgr.mr_n58030096)
print v(xbgr.mr_n58030816)
print v(xbgr.mr_n58031312)
print v(xbgr.mr_n58031776)
print v(xbgr.mr_n58033040)
print v(xbgr.mr_n58036368)
print v(xbgr.mr_n58041168)
print v(xbgr.mr_n58043232)
print v(xbgr.mr_n58044192)
print v(xbgr.mr_n58044832)
print v(xbgr.mr_n58047184)
print v(xbgr.mr_n58047664)
print v(xbgr.mr_n58050752)
print v(xbgr.mr_n58051648)
print v(xbgr.mr_n58051840)
print v(xbgr.mr_n58052400)
print v(xbgr.mr_n58052624)
print v(xbgr.mr_n58053024)
print v(xbgr.mr_n58053328)
print v(xbgr.mr_n58053744)
print v(xbgr.mr_n58054016)
print v(xbgr.mr_n58054512)
print v(xbgr.mr_n58055024)
print v(xbgr.mr_n58074912)
print v(xbgr.mr_n58075616)
print v(xbgr.mr_n58075792)
print v(xbgr.mr_n58076352)
print v(xbgr.mr_n58076880)
print v(xbgr.mr_n58077056)
print v(xbgr.mr_n58077232)
print v(xbgr.mr_n58078016)
print v(xbgr.mr_n58078192)
print v(xbgr.mr_n58078752)
print v(xbgr.mr_n58079216)
print v(xbgr.mr_n58079392)
print v(xbgr.mr_n58080080)
print v(xbgr.mr_n58080256)
print v(xbgr.mr_n58080512)
print v(xbgr.mr_n58081152)
print v(xbgr.mr_n58088144)
print v(xbgr.mr_n58088608)
print v(xbgr.mr_n58089072)
print v(xbgr.mr_n58089536)
print v(xbgr.mr_n58090000)
print v(xbgr.mr_n58090464)
print v(xbgr.mr_n58090928)
print v(xbgr.mr_n58091392)
print v(xbgr.mr_n58091856)
print v(xbgr.mr_n58092320)
print v(xbgr.mr_n58092784)
print v(xbgr.mr_n58093248)
print v(xbgr.mr_n58093712)
print v(xbgr.mr_n58094176)
print v(xbgr.mr_n58094640)
print v(xbgr.mr_n58095104)
print v(xbgr.mr_n58095568)
print v(xbgr.mr_n58099152)
print v(xbgr.mr_n58103424)
print v(xbgr.mr_n58105344)
print v(xbgr.mr_n58108496)
print v(xbgr.mr_n58112416)
print v(xbgr.mr_n58117712)
print v(xbgr.mr_n58129888)
print v(xbgr.mr_n58130240)
print v(xbgr.mr_n58131072)
print v(xbgr.mr_n58131264)
print v(xbgr.mr_n58131520)
print v(xbgr.mr_n58131776)
print v(xbgr.mr_n58133744)
print v(xbgr.mr_n58134528)
print v(xbgr.mr_n58134752)
print v(xbgr.mr_n58134864)
print v(xbgr.mr_n58135696)
print v(xbgr.mr_n58137024)
print v(xbgr.mr_n58139584)
print v(xbgr.mr_n58142512)
print v(xbgr.mr_n58143840)
print v(xbgr.mr_n58145888)
print v(xbgr.mr_n58148656)
print v(xbgr.mr_n58149984)
print v(xbgr.mr_n58152032)
print v(xbgr.mr_n58154800)
print v(xbgr.mr_n58156128)
print v(xbgr.mr_n58158160)
print v(xbgr.mr_n58160928)
print v(xbgr.mr_n58162256)
print v(xbgr.mr_n58164304)
print v(xbgr.mr_n58167072)
print v(xbgr.mr_n58168400)
print v(xbgr.mr_n58169056)
print v(xbgr.mr_n58170976)
print v(xbgr.mr_n58172224)
print v(xbgr.mr_n58175712)
print v(xbgr.mr_n58176112)
print v(xbgr.mr_n58176512)
print v(xbgr.mr_n58176832)
print v(xbgr.mr_n58177232)
print v(xbgr.mr_n58177632)
print v(xbgr.mr_n58178032)
print v(xbgr.mr_n58178432)
print v(xbgr.mr_n58178832)
print v(xbgr.mr_n58179232)
print v(xbgr.mr_n58179632)
print v(xbgr.mr_n58180032)
print v(xbgr.mr_n58180432)
print v(xbgr.mr_n58180832)
print v(xbgr.mr_n58181232)
print v(xbgr.mr_n58181632)
print v(xbgr.mr_n58181824)
print v(xbgr.mr_n58181936)
print v(xbgr.mr_n58182048)
print v(xbgr.mr_n58182160)
print v(xbgr.mr_n58182272)
print v(xbgr.mr_n58182464)
print v(xbgr.mr_n58182736)
print v(xbgr.mr_n58183008)
print v(xbgr.mr_n58183280)
print v(xbgr.mr_n58183552)
print v(xbgr.mr_n58183824)
print v(xbgr.mr_n58184096)
print v(xbgr.mr_n58184368)
print v(xbgr.mr_n58184704)
print v(xbgr.mr_n58185104)
print v(xbgr.mr_n58188400)
print v(xbgr.mr_n58190064)
print v(xbgr.mr_n58194016)
print v(xbgr.mr_n58197728)
print v(xbgr.mr_n58199456)
print v(xbgr.mr_n58200000)
print v(xbgr.mr_n58200176)
print v(xbgr.mr_n58201024)
print v(xbgr.mr_n58201504)
print v(xbgr.mr_n58201744)
print v(xbgr.mr_n58202000)
print v(xbgr.mr_n58202544)
print v(xbgr.mr_n58202720)
print v(xbgr.mr_n58203568)
print v(xbgr.mr_n58204048)
print v(xbgr.mr_n58204544)
print v(xbgr.mr_n58205088)
print v(xbgr.mr_n58205264)
print v(xbgr.mr_n58206048)
print v(xbgr.mr_n58206592)
print v(xbgr.mr_n58207088)
print v(xbgr.mr_n58207632)
print v(xbgr.mr_n58207808)
print v(xbgr.mr_n58208656)
print v(xbgr.mr_n58209136)
print v(xbgr.mr_n58209632)
print v(xbgr.mr_n58210176)
print v(xbgr.mr_n58210352)
print v(xbgr.mr_n58211200)
print v(xbgr.mr_n58211680)
print v(xbgr.mr_n58212176)
print v(xbgr.mr_n58212720)
print v(xbgr.mr_n58212896)
print v(xbgr.mr_n58213680)
print v(xbgr.mr_n58214224)
print v(xbgr.mr_n58214656)
print v(xbgr.mr_n58215072)
print v(xbgr.mr_n58215264)
print v(xbgr.mr_n58215440)
print v(xbgr.mr_n58216144)
print v(xbgr.mr_n58227872)
print v(xbgr.mr_n58228064)
print v(xbgr.mr_n58228256)
print v(xbgr.mr_n58228512)
print v(xbgr.mr_n58228768)
print v(xbgr.mr_n58230736)
print v(xbgr.mr_n58253472)
print v(xbgr.mr_n58255296)
print v(xbgr.mr_n58255792)
print v(xbgr.mr_n58256096)
print v(xbgr.mr_n58256592)
print v(xbgr.mr_n58256896)
print v(xbgr.mr_n58257456)
print v(xbgr.mr_n58257760)
print v(xbgr.mr_n58258640)
print v(xbgr.mr_n58258944)
print v(xbgr.mr_n58259824)
print v(xbgr.mr_n58260128)
print v(xbgr.mr_n58261008)
print v(xbgr.mr_n58261312)
print v(xbgr.mr_n58262192)
print v(xbgr.mr_n58262496)
print v(xbgr.mr_n58263376)
print v(xbgr.mr_n58263680)
print v(xbgr.mr_n58264560)
print v(xbgr.mr_n58264864)
print v(xbgr.mr_n58265744)
print v(xbgr.mr_n58266048)
print v(xbgr.mr_n58266928)
print v(xbgr.mr_n58267232)
print v(xbgr.mr_n58268112)
print v(xbgr.mr_n58268416)
print v(xbgr.mr_n58269296)
print v(xbgr.mr_n58269600)
print v(xbgr.mr_n58270480)
print v(xbgr.mr_n58270784)
print v(xbgr.mr_n58271664)
print v(xbgr.mr_n58271856)
print v(xbgr.mr_n58272128)
print v(xbgr.mr_n58272592)
print v(xbgr.mr_n58278784)
print v(xbgr.mr_n58281568)
print v(xbgr.mr_n58281856)
print v(xbgr.mr_n58286688)
print v(xbgr.mr_n58288640)
print v(xbgr.mr_n58288976)
print v(xbgr.mr_n58289312)
print v(xbgr.mr_n58289648)
print v(xbgr.mr_n58291536)
print v(xbgr.mr_n58292448)
print v(xbgr.mr_n58292848)
print v(xbgr.mr_n58293248)
print v(xbgr.mr_n58293648)
print v(xbgr.mr_n58294048)
print v(xbgr.mr_n58294448)
print v(xbgr.mr_n58294848)
print v(xbgr.mr_n58295248)
print v(xbgr.mr_n58295648)
print v(xbgr.mr_n58296048)
print v(xbgr.mr_n58296448)
print v(xbgr.mr_n58296848)
print v(xbgr.mr_n58297248)
print v(xbgr.mr_n58297648)
print v(xbgr.mr_n58298048)
print v(xbgr.mr_n58298448)
print v(xbgr.mr_n58299104)
print v(xbgr.mr_n58303792)
print v(xbgr.mr_n58309600)
print v(xbgr.mr_n58315744)
print v(xbgr.mr_n58326256)
print v(xbgr.mr_n58328864)
print v(xbgr.mr_n58329168)
print v(xbgr.mr_n58329472)
print v(xbgr.mr_n58329776)
print v(xbgr.mr_n58330160)
print v(xbgr.mr_n58330624)
print v(xbgr.mr_n58331088)
print v(xbgr.mr_n58331552)
print v(xbgr.mr_n58332016)
print v(xbgr.mr_n58332480)
print v(xbgr.mr_n58332944)
print v(xbgr.mr_n58333408)
print v(xbgr.mr_n58333872)
print v(xbgr.mr_n58334240)
print v(xbgr.mr_n58337952)
print v(xbgr.mr_n58339024)
print v(xbgr.mr_n58343552)
print v(xbgr.mr_n58345344)
print v(xbgr.mr_n58345680)
print v(xbgr.mr_n58346016)
print v(xbgr.mr_n58346352)
print v(xbgr.mr_n58347408)
print v(xbgr.mr_n58348672)
print v(xbgr.mr_n58349312)
print v(xbgr.mr_n58349424)
print v(xbgr.mr_n58349616)
print v(xbgr.mr_n58350144)
print v(xbgr.mr_n58351680)
print v(xbgr.mr_n58352960)
print v(xbgr.mr_n58353744)
print v(xbgr.mr_n58353856)
print v(xbgr.mr_n58355808)
print v(xbgr.mr_n58355920)
print v(xbgr.mr_n58356032)
print v(xbgr.mr_n58356304)
print v(xbgr.mr_n58358208)
print v(xbgr.mr_n58359344)
print v(xbgr.mr_n58359456)
print v(xbgr.mr_n58361152)
print v(xbgr.mr_n58361264)
print v(xbgr.mr_n58361376)
print v(xbgr.mr_n58361648)
print v(xbgr.mr_n58363760)
print v(xbgr.mr_n58364400)
print v(xbgr.mr_n58364512)
print v(xbgr.mr_n58365776)
print v(xbgr.mr_n58366192)
print v(xbgr.mr_n58367120)
print v(xbgr.mr_n58367232)
print v(xbgr.mr_n58368736)
print v(xbgr.mr_n58369456)
print v(xbgr.mr_n58369568)
print v(xbgr.mr_n58371264)
print v(xbgr.mr_n58371376)
print v(xbgr.mr_n58371488)
print v(xbgr.mr_n58371760)
print v(xbgr.mr_n58373920)
print v(xbgr.mr_n58374032)
print v(xbgr.mr_n58374224)
print v(xbgr.mr_n58375696)
print v(xbgr.mr_n58376448)
print v(xbgr.mr_n58377232)
print v(xbgr.mr_n58377344)
print v(xbgr.mr_n58378848)
print v(xbgr.mr_n58379568)
print v(xbgr.mr_n58379680)
print v(xbgr.mr_n58381376)
print v(xbgr.mr_n58381488)
print v(xbgr.mr_n58381600)
print v(xbgr.mr_n58381872)
print v(xbgr.mr_n58384032)
print v(xbgr.mr_n58384144)
print v(xbgr.mr_n58384336)
print v(xbgr.mr_n58386368)
print v(xbgr.mr_n58386480)
print v(xbgr.mr_n58386592)
print v(xbgr.mr_n58386864)
print v(xbgr.mr_n58389088)
print v(xbgr.mr_n58389200)
print v(xbgr.mr_n58389392)
print v(xbgr.mr_n58389904)
print v(xbgr.mr_n58390240)
print v(xbgr.mr_n58390592)
print v(xbgr.mr_n58391216)
print v(xbgr.mr_n58391680)
print v(xbgr.mr_n58392096)
print v(xbgr.mr_n58392784)
print v(xbgr.mr_n58393248)
print v(xbgr.mr_n58393664)
print v(xbgr.mr_n58394352)
print v(xbgr.mr_n58394816)
print v(xbgr.mr_n58395232)
print v(xbgr.mr_n58395920)
print v(xbgr.mr_n58396384)
print v(xbgr.mr_n58396800)
print v(xbgr.mr_n58397488)
print v(xbgr.mr_n58398016)
print v(xbgr.mr_n58398368)
print v(xbgr.mr_n58399056)
print v(xbgr.mr_n58399584)
print v(xbgr.mr_n58399936)
print v(xbgr.mr_n58400624)
print v(xbgr.mr_n58401008)
print v(xbgr.mr_n58401504)
print v(xbgr.mr_n58402192)
print v(xbgr.mr_n58402656)
print v(xbgr.mr_n58403072)
print v(xbgr.mr_n58403760)
print v(xbgr.mr_n58404144)
print v(xbgr.mr_n58404640)
print v(xbgr.mr_n58405328)
print v(xbgr.mr_n58405792)
print v(xbgr.mr_n58406208)
print v(xbgr.mr_n58406896)
print v(xbgr.mr_n58407360)
print v(xbgr.mr_n58408160)
print v(xbgr.mr_n58410080)
print v(xbgr.mr_n58412640)
print v(xbgr.mr_n58412944)
print v(xbgr.mr_n58413328)
print v(xbgr.mr_n58414016)
print v(xbgr.mr_n58428256)
print v(xbgr.mr_n58428720)
print v(xbgr.mr_n58429184)
print v(xbgr.mr_n58429648)
print v(xbgr.mr_n58430112)
print v(xbgr.mr_n58430576)
print v(xbgr.mr_n58431040)
print v(xbgr.mr_n58431504)
print v(xbgr.mr_n58431968)
print v(xbgr.mr_n58432432)
print v(xbgr.mr_n58432896)
print v(xbgr.mr_n58433360)
print v(xbgr.mr_n58433824)
print v(xbgr.mr_n58434288)
print v(xbgr.mr_n58434752)
print v(xbgr.mr_n58435216)
print v(xbgr.mr_n58435680)
print v(xbgr.mr_n58436144)
print v(xbgr.mr_n58436608)
print v(xbgr.mr_n58445072)
print v(xbgr.mr_n58445584)
print v(xbgr.mr_n58460144)
print v(xbgr.mr_n58460336)
print v(xbgr.mr_n58460592)
print v(xbgr.mr_n58460848)
print v(xbgr.mr_n58462816)
print v(xbgr.mr_n58486512)
print v(xbgr.mr_n58486768)
print v(xbgr.mr_n58486880)
print v(xbgr.mr_n58486992)
print v(xbgr.mr_n58487344)
print v(xbgr.mr_n58487616)
print v(xbgr.mr_n58488720)
print v(xbgr.mr_n58488896)
print v(xbgr.mr_n58489856)
print v(xbgr.mr_n58490032)
print v(xbgr.mr_n58490512)
print v(xbgr.mr_n58490688)
print v(xbgr.mr_n58491168)
print v(xbgr.mr_n58491344)
print v(xbgr.mr_n58491824)
print v(xbgr.mr_n58492000)
print v(xbgr.mr_n58492480)
print v(xbgr.mr_n58492656)
print v(xbgr.mr_n58493136)
print v(xbgr.mr_n58493312)
print v(xbgr.mr_n58493792)
print v(xbgr.mr_n58493968)
print v(xbgr.mr_n58494448)
print v(xbgr.mr_n58494624)
print v(xbgr.mr_n58497088)
print v(xbgr.mr_n58497424)
print v(xbgr.mr_n58498000)
print v(xbgr.mr_n58498912)
print v(xbgr.mr_n58499088)
print v(xbgr.mr_n58499264)
print v(xbgr.mr_n58499968)
print v(xbgr.mr_n58500144)
print v(xbgr.mr_n58500704)
print v(xbgr.mr_n58501168)
print v(xbgr.mr_n58501344)
print v(xbgr.mr_n58501520)
print v(xbgr.mr_n58502224)
print v(xbgr.mr_n58502400)
print v(xbgr.mr_n58503024)
print v(xbgr.mr_n58503200)
print v(xbgr.mr_n58503376)
print v(xbgr.mr_n58503888)
print v(xbgr.mr_n58504320)
print v(xbgr.mr_n58504496)
print v(xbgr.mr_n58504672)
print v(xbgr.mr_n58505536)
print v(xbgr.mr_n58505712)
print v(xbgr.mr_n58506336)
print v(xbgr.mr_n58506512)
print v(xbgr.mr_n58506688)
print v(xbgr.mr_n58507392)
print v(xbgr.mr_n58507568)
print v(xbgr.mr_n58508192)
print v(xbgr.mr_n58508368)
print v(xbgr.mr_n58508544)
print v(xbgr.mr_n58509184)
print v(xbgr.mr_n58509456)
print v(xbgr.mr_n58509888)
print v(xbgr.mr_n58510064)
print v(xbgr.mr_n58510400)
print v(xbgr.mr_n58511104)
print v(xbgr.mr_n58511280)
print v(xbgr.mr_n58511904)
print v(xbgr.mr_n58512080)
print v(xbgr.mr_n58512256)
print v(xbgr.mr_n58512896)
print v(xbgr.mr_n58513168)
print v(xbgr.mr_n58513280)
print v(xbgr.mr_n58513392)
print v(xbgr.mr_n58513504)
print v(xbgr.mr_n58513616)
print v(xbgr.mr_n58513888)
print v(xbgr.mr_n58514240)
print v(xbgr.mr_n58514352)
print v(xbgr.mr_n58514464)
print v(xbgr.mr_n58514896)
print v(xbgr.mr_n58515376)
print v(xbgr.mr_n58515552)
print v(xbgr.mr_n58515904)
print v(xbgr.mr_n58516272)
print v(xbgr.mr_n58516608)
print v(xbgr.mr_n58516960)
print v(xbgr.mr_n58517072)
print v(xbgr.mr_n58517568)
print v(xbgr.mr_n58518064)
print v(xbgr.mr_n58518544)
print v(xbgr.mr_n58518720)
print v(xbgr.mr_n58519072)
print v(xbgr.mr_n58519440)
print v(xbgr.mr_n58519776)
print v(xbgr.mr_n58520128)
print v(xbgr.mr_n58520240)
print v(xbgr.mr_n58520736)
print v(xbgr.mr_n58521232)
print v(xbgr.mr_n58521712)
print v(xbgr.mr_n58521888)
print v(xbgr.mr_n58522240)
print v(xbgr.mr_n58522608)
print v(xbgr.mr_n58522944)
print v(xbgr.mr_n58523296)
print v(xbgr.mr_n58523680)
print v(xbgr.mr_n58527952)
print v(xbgr.mr_n58535184)
print v(xbgr.mr_n58535568)
print v(xbgr.mr_n58536032)
print v(xbgr.mr_n58536496)
print v(xbgr.mr_n58536960)
print v(xbgr.mr_n58537424)
print v(xbgr.mr_n58537888)
print v(xbgr.mr_n58538352)
print v(xbgr.mr_n58538816)
print v(xbgr.mr_n58539280)
print v(xbgr.mr_n58539744)
print v(xbgr.mr_n58540208)
print v(xbgr.mr_n58540672)
print v(xbgr.mr_n58541136)
print v(xbgr.mr_n58541600)
print v(xbgr.mr_n58542064)
print v(xbgr.mr_n58542528)
print v(xbgr.mr_n58542992)
print v(xbgr.mr_n58543456)
print v(xbgr.mr_n58543920)
print v(xbgr.mr_n58544384)
print v(xbgr.mr_n58544848)
print v(xbgr.mr_n58545312)
print v(xbgr.mr_n58545776)
print v(xbgr.mr_n58546304)
print v(xbgr.mr_n58546896)
print v(xbgr.mr_n58549264)
print v(xbgr.mr_n58575360)
print v(xbgr.mr_n58578944)
print v(xbgr.mr_n58579120)
print v(xbgr.mr_n58579456)
print v(xbgr.mr_n58580416)
print v(xbgr.mr_n58581328)
print v(xbgr.mr_n58581440)
print v(xbgr.mr_n58581632)
print v(xbgr.mr_n58582384)
print v(xbgr.mr_n58584672)
print v(xbgr.mr_n58585008)
print v(xbgr.mr_n58585760)
print v(xbgr.mr_n58597024)
print v(xbgr.mr_n58599776)
print v(xbgr.mr_n58601328)
print v(xbgr.mr_n58602032)
print v(xbgr.mr_n58602144)
print v(xbgr.mr_n58602464)
print v(xbgr.mr_n58602640)
print v(xbgr.mr_n58602976)
print v(xbgr.mr_n58603680)
print v(xbgr.mr_n58603856)
print v(xbgr.mr_n58604480)
print v(xbgr.mr_n58604656)
print v(xbgr.mr_n58605280)
print v(xbgr.mr_n58605456)
print v(xbgr.mr_n58606080)
print v(xbgr.mr_n58606256)
print v(xbgr.mr_n58606880)
print v(xbgr.mr_n58607056)
print v(xbgr.mr_n58607680)
print v(xbgr.mr_n58607856)
print v(xbgr.mr_n58608480)
print v(xbgr.mr_n58608656)
print v(xbgr.mr_n58609216)
print v(xbgr.mr_n58610016)
print v(xbgr.mr_n58610128)
print v(xbgr.mr_n58611120)
print v(xbgr.mr_n58611408)
print v(xbgr.mr_n58611760)
print v(xbgr.mr_n58612496)
print v(xbgr.mr_n58613264)
print v(xbgr.mr_n58613456)
print v(xbgr.mr_n58613792)
print v(xbgr.mr_n58614256)
print v(xbgr.mr_n58615232)
print v(xbgr.mr_n58616048)
print v(xbgr.mr_n58616880)
print v(xbgr.mr_n58617392)
print v(xbgr.mr_n58617600)
print v(xbgr.mr_n58617920)
print v(xbgr.mr_n58618624)
print v(xbgr.mr_n58620272)
print v(xbgr.mr_n58620688)
print v(xbgr.mr_n58621232)
print v(xbgr.mr_n58622416)
print v(xbgr.mr_n58622640)
print v(xbgr.mr_n58622752)
print v(xbgr.mr_n58622864)
print v(xbgr.mr_n58623424)
print v(xbgr.mr_n58625040)
print v(xbgr.mr_n58625152)
print v(xbgr.mr_n58625264)
print v(xbgr.mr_n58625520)
print v(xbgr.mr_n58625856)
print v(xbgr.mr_n58626880)
print v(xbgr.mr_n58627504)
print v(xbgr.mr_n58627776)
print v(xbgr.mr_n58628240)
print v(xbgr.mr_n58629888)
print v(xbgr.mr_n58630304)
print v(xbgr.mr_n58630752)
print v(xbgr.mr_n58630928)
print v(xbgr.mr_n58632272)
print v(xbgr.mr_n58632672)
print v(xbgr.mr_n58633504)
print v(xbgr.mr_n58633888)
print v(xbgr.mr_n58634080)
print v(xbgr.mr_n58634272)
print v(xbgr.mr_n58634384)
print v(xbgr.mr_n58636192)
print v(xbgr.mr_n58637712)
print v(xbgr.mr_n58637904)
print v(xbgr.mr_n58638096)
print v(xbgr.mr_n58638528)
print v(xbgr.mr_n58638848)
print v(xbgr.mr_n58639936)
print v(xbgr.mr_n58640432)
print v(xbgr.mr_n58641328)
print v(xbgr.mr_n58641824)
print v(xbgr.mr_n58641968)
print v(xbgr.mr_n58642368)
print v(xbgr.mr_n58642624)
print v(xbgr.mr_n58642768)
print v(xbgr.mr_n58643088)
print v(xbgr.mr_n58644224)
print v(xbgr.mr_n58644720)
print v(xbgr.mr_n58644832)
print v(xbgr.mr_n58644944)
print v(xbgr.mr_n58645056)
print v(xbgr.mr_n58648192)
print v(xbgr.mr_n58648304)
print v(xbgr.mr_n58648496)
print v(xbgr.mr_n58648608)
print v(xbgr.mr_n58649680)
print v(xbgr.mr_n58650160)
print v(xbgr.mr_n58650352)
print v(xbgr.mr_n58650624)
print v(xbgr.mr_n58650992)
print v(xbgr.mr_n58651104)
print v(xbgr.mr_n58651696)
print v(xbgr.mr_n58653584)
print v(xbgr.mr_n58653888)
print v(xbgr.mr_n58655312)
print v(xbgr.mr_n58655664)
print v(xbgr.mr_n58656064)
print v(xbgr.mr_n58657008)
print v(xbgr.mr_n58657472)
print v(xbgr.mr_n58657824)
print v(xbgr.mr_n58658256)
print v(xbgr.mr_n58658928)
print v(xbgr.mr_n58659920)
print v(xbgr.mr_n58660800)
print v(xbgr.mr_n58661264)
print v(xbgr.mr_n58661600)
print v(xbgr.mr_n58662144)
print v(xbgr.mr_n58662288)
print v(xbgr.mr_n58662544)
print v(xbgr.mr_n58662720)
print v(xbgr.mr_n58663072)
print v(xbgr.mr_n58663536)
print v(xbgr.mr_n58663728)
print v(xbgr.mr_n58663920)
print v(xbgr.mr_n58665520)
print v(xbgr.mr_n58665792)
print v(xbgr.mr_n58666752)
print v(xbgr.mr_n58667152)
print v(xbgr.mr_n58667504)
print v(xbgr.mr_n58667936)
print v(xbgr.mr_n58668128)
print v(xbgr.mr_n58668400)
print v(xbgr.mr_n58668672)
print v(xbgr.mr_n58668944)
print v(xbgr.mr_n58669216)
print v(xbgr.mr_n58669488)
print v(xbgr.mr_n58669760)
print v(xbgr.mr_n58670032)
print v(xbgr.mr_n58670304)
print v(xbgr.mr_n58670576)
print v(xbgr.mr_n58670848)
print v(xbgr.mr_n58671120)
print v(xbgr.mr_n58671392)
print v(xbgr.mr_n58671664)
print v(xbgr.mr_n58672000)
print v(xbgr.mr_n58672464)
print v(xbgr.mr_n58672928)
print v(xbgr.mr_n58680976)
print v(xbgr.mr_n58686672)
print v(xbgr.mr_n58687056)
print v(xbgr.mr_n58688272)
print v(xbgr.mr_n58688384)
print v(xbgr.mr_n58692432)
print v(xbgr.mr_n58701520)
print v(xbgr.mr_n58710192)
print v(xbgr.mr_n58712016)
print v(xbgr.mr_n58717552)
print v(xbgr.mr_n58717888)
print v(xbgr.mr_n58718224)
print v(xbgr.mr_n58718560)
print v(xbgr.mr_n58718896)
print v(xbgr.mr_n58719072)
print v(xbgr.mr_n58719184)
print v(xbgr.mr_n58719296)
print v(xbgr.mr_n58719408)
print v(xbgr.mr_n58719520)
print v(xbgr.mr_n58719632)
print v(xbgr.mr_n58719744)
print v(xbgr.mr_n58720096)
print v(xbgr.mr_n58720448)
print v(xbgr.mr_n58720560)
print v(xbgr.mr_n58720912)
print v(xbgr.mr_n58721024)
print v(xbgr.mr_n58721136)
print v(xbgr.mr_n58721248)
print v(xbgr.mr_n58721680)
print v(xbgr.mr_n58722160)
print v(xbgr.mr_n58722992)
print v(xbgr.mr_n58724272)
print v(xbgr.mr_n58725296)
print v(xbgr.mr_n58726816)
print v(xbgr.mr_n58727008)
print v(xbgr.mr_n58727200)
print v(xbgr.mr_n58727392)
print v(xbgr.mr_n58727504)
print v(xbgr.mr_n58727616)
print v(xbgr.mr_n58727728)
print v(xbgr.mr_n58728288)
print v(xbgr.mr_n58728832)
print v(xbgr.mr_n58731728)
print v(xbgr.mr_n58732448)
print v(xbgr.mr_n58732640)
print v(xbgr.mr_n58732832)
print v(xbgr.mr_n58733728)
print v(xbgr.mr_n58734064)
print v(xbgr.mr_n58734336)
print v(xbgr.mr_n58734816)
print v(xbgr.mr_n58735808)
print v(xbgr.mr_n58736224)
print v(xbgr.mr_n58736656)
print v(xbgr.mr_n58736960)
print v(xbgr.mr_n58737584)
print v(xbgr.mr_n58737936)
print v(xbgr.mr_n58738304)
print v(xbgr.mr_n58738720)
print v(xbgr.mr_n58739152)
print v(xbgr.mr_n58739616)
print v(xbgr.mr_n58739968)
print v(xbgr.mr_n58740400)
print v(xbgr.mr_n58740704)
print v(xbgr.mr_n58741328)
print v(xbgr.mr_n58741680)
print v(xbgr.mr_n58742048)
print v(xbgr.mr_n58742464)
print v(xbgr.mr_n58742896)
print v(xbgr.mr_n58743296)
print v(xbgr.mr_n58743712)
print v(xbgr.mr_n58744144)
print v(xbgr.mr_n58744336)
print v(xbgr.mr_n58744448)
print v(xbgr.mr_n58745008)
print v(xbgr.mr_n58745424)
print v(xbgr.mr_n58745792)
print v(xbgr.mr_n58746208)
print v(xbgr.mr_n58746640)
print v(xbgr.mr_n58747040)
print v(xbgr.mr_n58747456)
print v(xbgr.mr_n58747888)
print v(xbgr.mr_n58748192)
print v(xbgr.mr_n58748752)
print v(xbgr.mr_n58749168)
print v(xbgr.mr_n58749280)
print v(xbgr.mr_n58749472)
print v(xbgr.mr_n58749744)
print v(xbgr.mr_n58750016)
print v(xbgr.mr_n58750288)
print v(xbgr.mr_n58750560)
print v(xbgr.mr_n58750832)
print v(xbgr.mr_n58751104)
print v(xbgr.mr_n58751376)
print v(xbgr.mr_n58751648)
print v(xbgr.mr_n58751920)
print v(xbgr.mr_n58752192)
print v(xbgr.mr_n58752464)
print v(xbgr.mr_n58752736)
print v(xbgr.mr_n58753008)
print v(xbgr.mr_n58753280)
print v(xbgr.mr_n58753744)
print v(xbgr.mr_n58755840)
print v(xbgr.mr_n58764432)
print v(xbgr.mr_n58764736)
print v(xbgr.mr_n58774464)
print v(xbgr.mr_n58775296)
print v(xbgr.mr_n58775488)
print v(xbgr.mr_n58775680)
print v(xbgr.mr_n58775936)
print v(xbgr.mr_n58776192)
print v(xbgr.mr_n58778160)
print v(xbgr.mr_n58778544)
print v(xbgr.mr_n58779568)
print v(xbgr.mr_n58779872)
print v(xbgr.mr_n58782560)
print v(xbgr.mr_n58783552)
print v(xbgr.mr_n58783776)
print v(xbgr.mr_n58784000)
print v(xbgr.mr_n58785408)
print v(xbgr.mr_n58786368)
print v(xbgr.mr_n58787152)
print v(xbgr.mr_n58789232)
print v(xbgr.mr_n58789808)
print v(xbgr.mr_n58790400)
print v(xbgr.mr_n58791696)
print v(xbgr.mr_n58792208)
print v(xbgr.mr_n58793504)
print v(xbgr.mr_n58794016)
print v(xbgr.mr_n58795312)
print v(xbgr.mr_n58795824)
print v(xbgr.mr_n58796880)
print v(xbgr.mr_n58797632)
print v(xbgr.mr_n58798848)
print v(xbgr.mr_n58799440)
print v(xbgr.mr_n58800736)
print v(xbgr.mr_n58801248)
print v(xbgr.mr_n58802544)
print v(xbgr.mr_n58803056)
print v(xbgr.mr_n58804272)
print v(xbgr.mr_n58804864)
print v(xbgr.mr_n58804976)
print v(xbgr.mr_n58805088)
print v(xbgr.mr_n58805200)
print v(xbgr.mr_n58805312)
print v(xbgr.mr_n58805424)
print v(xbgr.mr_n58805856)
print v(xbgr.mr_n58805968)
print v(xbgr.mr_n58806240)
print v(xbgr.mr_n58806592)
print v(xbgr.mr_n58806832)
print v(xbgr.mr_n58807232)
print v(xbgr.mr_n58807648)
print v(xbgr.mr_n58808080)
print v(xbgr.mr_n58808768)
print v(xbgr.mr_n58809392)
print v(xbgr.mr_n58809936)
print v(xbgr.mr_n58810368)
print v(xbgr.mr_n58810784)
print v(xbgr.mr_n58811472)
print v(xbgr.mr_n58811936)
print v(xbgr.mr_n58812352)
print v(xbgr.mr_n58812784)
print v(xbgr.mr_n58813472)
print v(xbgr.mr_n58814160)
print v(xbgr.mr_n58814640)
print v(xbgr.mr_n58815024)
print v(xbgr.mr_n58815136)
print v(xbgr.mr_n58815488)
print v(xbgr.mr_n58815664)
print v(xbgr.mr_n58816176)
print v(xbgr.mr_n58816640)
print v(xbgr.mr_n58817056)
print v(xbgr.mr_n58817488)
print v(xbgr.mr_n58818176)
print v(xbgr.mr_n58818864)
print v(xbgr.mr_n58819344)
print v(xbgr.mr_n58820192)
print v(xbgr.mr_n58820880)
print v(xbgr.mr_n58821408)
print v(xbgr.mr_n58821760)
print v(xbgr.mr_n58822192)
print v(xbgr.mr_n58822880)
print v(xbgr.mr_n58823504)
print v(xbgr.mr_n58824048)
print v(xbgr.mr_n58824480)
print v(xbgr.mr_n58824896)
print v(xbgr.mr_n58825584)
print v(xbgr.mr_n58826112)
print v(xbgr.mr_n58826464)
print v(xbgr.mr_n58826896)
print v(xbgr.mr_n58827584)
print v(xbgr.mr_n58828208)
print v(xbgr.mr_n58828752)
print v(xbgr.mr_n58829248)
print v(xbgr.mr_n58829600)
print v(xbgr.mr_n58830288)
print v(xbgr.mr_n58830752)
print v(xbgr.mr_n58831168)
print v(xbgr.mr_n58831600)
print v(xbgr.mr_n58831792)
print v(xbgr.mr_n58832064)
print v(xbgr.mr_n58832336)
print v(xbgr.mr_n58832608)
print v(xbgr.mr_n58832880)
print v(xbgr.mr_n58833152)
print v(xbgr.mr_n58833424)
print v(xbgr.mr_n58833696)
print v(xbgr.mr_n58833968)
print v(xbgr.mr_n58834240)
print v(xbgr.mr_n58834512)
print v(xbgr.mr_n58834784)
print v(xbgr.mr_n58835056)
print v(xbgr.mr_n58838752)
print v(xbgr.mr_n58840560)
print v(xbgr.mr_n58845168)
print v(xbgr.mr_n58859776)
print v(xbgr.mr_n58860240)
print v(xbgr.mr_n58860704)
print v(xbgr.mr_n58861168)
print v(xbgr.mr_n58861632)
print v(xbgr.mr_n58861808)
print v(xbgr.mr_n58869808)
print v(xbgr.mr_n58871536)
print v(xbgr.mr_n58892928)
print v(xbgr.mr_n58897008)
print v(xbgr.mr_n58905104)
print v(xbgr.mr_n58905808)
print v(xbgr.mr_n58907104)
print v(xbgr.mr_n58907616)
print v(xbgr.mr_n58908912)
print v(xbgr.mr_n58909424)
print v(xbgr.mr_n58910640)
print v(xbgr.mr_n58911232)
print v(xbgr.mr_n58912128)
print v(xbgr.mr_n58912784)
print v(xbgr.mr_n58913296)
print v(xbgr.mr_n58914192)
print v(xbgr.mr_n58914608)
print v(xbgr.mr_n58915360)
print v(xbgr.mr_n58916256)
print v(xbgr.mr_n58916832)
print v(xbgr.mr_n58917424)
print v(xbgr.mr_n58918320)
print v(xbgr.mr_n58918976)
print v(xbgr.mr_n58919488)
print v(xbgr.mr_n58920384)
print v(xbgr.mr_n58920800)
print v(xbgr.mr_n58921552)
print v(xbgr.mr_n58922448)
print v(xbgr.mr_n58923024)
print v(xbgr.mr_n58923616)
print v(xbgr.mr_n58924512)
print v(xbgr.mr_n58925168)
print v(xbgr.mr_n58925680)
print v(xbgr.mr_n58926576)
print v(xbgr.mr_n58927072)
print v(xbgr.mr_n58927744)
print v(xbgr.mr_n58928640)
print v(xbgr.mr_n58929296)
print v(xbgr.mr_n58929808)
print v(xbgr.mr_n58930704)
print v(xbgr.mr_n58931360)
print v(xbgr.mr_n58931872)
print v(xbgr.mr_n58932768)
print v(xbgr.mr_n58933424)
print v(xbgr.mr_n58933936)
print v(xbgr.mr_n58934832)
print v(xbgr.mr_n58935488)
print v(xbgr.mr_n58936000)
print v(xbgr.mr_n58937296)
print v(xbgr.mr_n58937808)
print v(xbgr.mr_n58937920)
print v(xbgr.mr_n58938032)
print v(xbgr.mr_n58938144)
print v(xbgr.mr_n58938416)
print v(xbgr.mr_n58938528)
print v(xbgr.mr_n58938880)
print v(xbgr.mr_n58938992)
print v(xbgr.mr_n58939104)
print v(xbgr.mr_n58939536)
print v(xbgr.mr_n58940016)
print v(xbgr.mr_n58940192)
print v(xbgr.mr_n58940544)
print v(xbgr.mr_n58940912)
print v(xbgr.mr_n58941168)
print v(xbgr.mr_n58941600)
print v(xbgr.mr_n58941712)
print v(xbgr.mr_n58942208)
print v(xbgr.mr_n58942624)
print v(xbgr.mr_n58943184)
print v(xbgr.mr_n58943360)
print v(xbgr.mr_n58943712)
print v(xbgr.mr_n58944080)
print v(xbgr.mr_n58944416)
print v(xbgr.mr_n58944768)
print v(xbgr.mr_n58944880)
print v(xbgr.mr_n58945376)
print v(xbgr.mr_n58945872)
print v(xbgr.mr_n58946352)
print v(xbgr.mr_n58946528)
print v(xbgr.mr_n58946880)
print v(xbgr.mr_n58947312)
print v(xbgr.mr_n58947776)
print v(xbgr.mr_n58948192)
print v(xbgr.mr_n58948624)
print v(xbgr.mr_n58949312)
print v(xbgr.mr_n58949936)
print v(xbgr.mr_n58950480)
print v(xbgr.mr_n58950912)
print v(xbgr.mr_n58951328)
print v(xbgr.mr_n58952016)
print v(xbgr.mr_n58952544)
print v(xbgr.mr_n58952896)
print v(xbgr.mr_n58953328)
print v(xbgr.mr_n58954016)
print v(xbgr.mr_n58954704)
print v(xbgr.mr_n58955056)
print v(xbgr.mr_n58955168)
print v(xbgr.mr_n58955360)
print v(xbgr.mr_n58955632)
print v(xbgr.mr_n58955904)
print v(xbgr.mr_n58956176)
print v(xbgr.mr_n58956448)
print v(xbgr.mr_n58956720)
print v(xbgr.mr_n58956992)
print v(xbgr.mr_n58957264)
print v(xbgr.mr_n58957536)
print v(xbgr.mr_n58957808)
print v(xbgr.mr_n58958080)
print v(xbgr.mr_n58958352)
print v(xbgr.mr_n58958624)
print v(xbgr.mr_n58958896)
print v(xbgr.mr_n58959168)
print v(xbgr.mr_n58959440)
print v(xbgr.mr_n58968784)
print v(xbgr.mr_n58970000)
print v(xbgr.mr_n58974656)
print v(xbgr.mr_n58977312)
print v(xbgr.mr_n58977776)
print v(xbgr.mr_n58978240)
print v(xbgr.mr_n58978704)
print v(xbgr.mr_n58979168)
print v(xbgr.mr_n58979632)
print v(xbgr.mr_n58980096)
print v(xbgr.mr_n58980624)
print v(xbgr.mr_n58981216)
print v(xbgr.mr_n58981808)
print v(xbgr.mr_n58982400)
print v(xbgr.mr_n58982992)
print v(xbgr.mr_n58983584)
print v(xbgr.mr_n58984176)
print v(xbgr.mr_n58984768)
print v(xbgr.mr_n58985360)
print v(xbgr.mr_n58985952)
print v(xbgr.mr_n58993616)
print v(xbgr.mr_n59011536)
print v(xbgr.mr_n59011792)
print v(xbgr.mr_n59014912)
print v(xbgr.mr_n59015104)
print v(xbgr.mr_n59015360)
print v(xbgr.mr_n59015616)
print v(xbgr.mr_n59017776)
print v(xbgr.mr_n59025008)
print v(xbgr.mr_n59025648)
print v(xbgr.mr_n59026944)
print v(xbgr.mr_n59027760)
print v(xbgr.mr_n59027872)
print v(xbgr.mr_n59028544)
print v(xbgr.mr_n59029216)
print v(xbgr.mr_n59031712)
print v(xbgr.mr_n59032224)
print v(xbgr.mr_n59033440)
print v(xbgr.mr_n59034032)
print v(xbgr.mr_n59035328)
print v(xbgr.mr_n59035840)
print v(xbgr.mr_n59037056)
print v(xbgr.mr_n59037648)
print v(xbgr.mr_n59038864)
print v(xbgr.mr_n59039456)
print v(xbgr.mr_n59040752)
print v(xbgr.mr_n59041264)
print v(xbgr.mr_n59042480)
print v(xbgr.mr_n59043072)
print v(xbgr.mr_n59044128)
print v(xbgr.mr_n59044880)
print v(xbgr.mr_n59046176)
print v(xbgr.mr_n59046688)
print v(xbgr.mr_n59047984)
print v(xbgr.mr_n59048496)
print v(xbgr.mr_n59049792)
print v(xbgr.mr_n59050304)
print v(xbgr.mr_n59051600)
print v(xbgr.mr_n59052112)
print v(xbgr.mr_n59053408)
print v(xbgr.mr_n59053920)
print v(xbgr.mr_n59054032)
print v(xbgr.mr_n59054144)
print v(xbgr.mr_n59054256)
print v(xbgr.mr_n59054528)
print v(xbgr.mr_n59054640)
print v(xbgr.mr_n59054992)
print v(xbgr.mr_n59055104)
print v(xbgr.mr_n59055376)
print v(xbgr.mr_n59055728)
print v(xbgr.mr_n59055840)
print v(xbgr.mr_n59056208)
print v(xbgr.mr_n59056768)
print v(xbgr.mr_n59057248)
print v(xbgr.mr_n59057744)
print v(xbgr.mr_n59058096)
print v(xbgr.mr_n59058784)
print v(xbgr.mr_n59059248)
print v(xbgr.mr_n59059664)
print v(xbgr.mr_n59060096)
print v(xbgr.mr_n59060784)
print v(xbgr.mr_n59061472)
print v(xbgr.mr_n59061952)
print v(xbgr.mr_n59062384)
print v(xbgr.mr_n59062800)
print v(xbgr.mr_n59063488)
print v(xbgr.mr_n59064016)
print v(xbgr.mr_n59064368)
print v(xbgr.mr_n59064800)
print v(xbgr.mr_n59065488)
print v(xbgr.mr_n59066112)
print v(xbgr.mr_n59066656)
print v(xbgr.mr_n59067152)
print v(xbgr.mr_n59067504)
print v(xbgr.mr_n59068192)
print v(xbgr.mr_n59068720)
print v(xbgr.mr_n59069072)
print v(xbgr.mr_n59069504)
print v(xbgr.mr_n59070192)
print v(xbgr.mr_n59070880)
print v(xbgr.mr_n59071360)
print v(xbgr.mr_n59071792)
print v(xbgr.mr_n59072208)
print v(xbgr.mr_n59072896)
print v(xbgr.mr_n59073360)
print v(xbgr.mr_n59073776)
print v(xbgr.mr_n59074208)
print v(xbgr.mr_n59074896)
print v(xbgr.mr_n59075584)
print v(xbgr.mr_n59076064)
print v(xbgr.mr_n59076560)
print v(xbgr.mr_n59076912)
print v(xbgr.mr_n59077600)
print v(xbgr.mr_n59078064)
print v(xbgr.mr_n59078480)
print v(xbgr.mr_n59078912)
print v(xbgr.mr_n59079600)
print v(xbgr.mr_n59080288)
print v(xbgr.mr_n59080640)
print v(xbgr.mr_n59080752)
print v(xbgr.mr_n59080944)
print v(xbgr.mr_n59081216)
print v(xbgr.mr_n59081488)
print v(xbgr.mr_n59081760)
print v(xbgr.mr_n59082032)
print v(xbgr.mr_n59082304)
print v(xbgr.mr_n59082576)
print v(xbgr.mr_n59082848)
print v(xbgr.mr_n59083120)
print v(xbgr.mr_n59083392)
print v(xbgr.mr_n59083664)
print v(xbgr.mr_n59083936)
print v(xbgr.mr_n59084208)
print v(xbgr.mr_n59084480)
print v(xbgr.mr_n59084752)
print v(xbgr.mr_n59085024)
print v(xbgr.mr_n59091664)
print v(xbgr.mr_n59096448)
print v(xbgr.mr_n59100688)
print v(xbgr.mr_n59101200)
print v(xbgr.mr_n59108784)
print v(xbgr.mr_n59109248)
print v(xbgr.mr_n59109712)
print v(xbgr.mr_n59110176)
print v(xbgr.mr_n59110640)
print v(xbgr.mr_n59111104)
print v(xbgr.mr_n59111568)
print v(xbgr.mr_n59112096)
print v(xbgr.mr_n59112688)
print v(xbgr.mr_n59113280)
print v(xbgr.mr_n59113872)
print v(xbgr.mr_n59114464)
print v(xbgr.mr_n59115056)
print v(xbgr.mr_n59115648)
print v(xbgr.mr_n59116240)
print v(xbgr.mr_n59116832)
print v(xbgr.mr_n59117424)
print v(xbgr.mr_n59117616)
print v(xbgr.mr_n59124832)
print v(xbgr.mr_n59126080)
print v(xbgr.mr_n59127648)
print v(xbgr.mr_n59131424)
print v(xbgr.mr_n59135264)
print v(xbgr.mr_n59135440)
print v(xbgr.mr_n59135776)
print v(xbgr.mr_n59137552)
print v(xbgr.mr_n59138144)
print v(xbgr.mr_n59138736)
print v(xbgr.mr_n59139328)
print v(xbgr.mr_n59139920)
print v(xbgr.mr_n59140512)
print v(xbgr.mr_n59141104)
print v(xbgr.mr_n59141696)
print v(xbgr.mr_n59142288)
print v(xbgr.mr_n59142880)
print v(xbgr.mr_n59142992)
print v(xbgr.mr_n59143472)
print v(xbgr.mr_n59143584)
print v(xbgr.mr_n59144064)
print v(xbgr.mr_n59144656)
print v(xbgr.mr_n59145248)
print v(xbgr.mr_n59145840)
print v(xbgr.mr_n59146432)
print v(xbgr.mr_n59147024)
print v(xbgr.mr_n59147616)
print v(xbgr.mr_n59148208)
print v(xbgr.mr_n59155456)
print v(xbgr.mr_n59157120)
print v(xbgr.mr_n59157664)
print v(xbgr.mr_n59158160)
print v(xbgr.mr_n59158512)
print v(xbgr.mr_n59158624)
print v(xbgr.mr_n59159328)
print v(xbgr.mr_n59159712)
print v(xbgr.mr_n59161568)
print v(xbgr.mr_n59161920)
print v(xbgr.mr_n59162032)
print v(xbgr.mr_n59162592)
print v(xbgr.mr_n59162864)
print v(xbgr.mr_n59163280)
print v(xbgr.mr_n59164112)
print v(xbgr.mr_n59164464)
print v(xbgr.mr_n59164576)
print v(xbgr.mr_n59165280)
print v(xbgr.mr_n59169024)
print v(xbgr.mr_n59169440)
print v(xbgr.mr_n59169552)
print v(xbgr.mr_n59170256)
print v(xbgr.mr_n59172496)
print v(xbgr.mr_n59172848)
print v(xbgr.mr_n59172960)
print v(xbgr.mr_n59173664)
print v(xbgr.mr_n59175904)
print v(xbgr.mr_n59176256)
print v(xbgr.mr_n59176368)
print v(xbgr.mr_n59177072)
print v(xbgr.mr_n59179312)
print v(xbgr.mr_n59179664)
print v(xbgr.mr_n59179776)
print v(xbgr.mr_n59180480)
print v(xbgr.mr_n59182656)
print v(xbgr.mr_n59183072)
print v(xbgr.mr_n59183184)
print v(xbgr.mr_n59183888)
print v(xbgr.mr_n59186128)
print v(xbgr.mr_n59186480)
print v(xbgr.mr_n59186592)
print v(xbgr.mr_n59187296)
print v(xbgr.mr_n59201248)
print v(xbgr.mr_n59201424)
print v(xbgr.mr_n59202048)
print v(xbgr.mr_n59202224)
print v(xbgr.mr_n59202848)
print v(xbgr.mr_n59203024)
print v(xbgr.mr_n59203648)
print v(xbgr.mr_n59203824)
print v(xbgr.mr_n59204448)
print v(xbgr.mr_n59204624)
print v(xbgr.mr_n59205248)
print v(xbgr.mr_n59205424)
print v(xbgr.mr_n59206048)
print v(xbgr.mr_n59206224)
print v(xbgr.mr_n59206848)
print v(xbgr.mr_n59207024)
print v(xbgr.mr_n59207648)
print v(xbgr.mr_n59207824)
print v(xbgr.mr_n59208448)
print v(xbgr.mr_n59208624)
print v(xbgr.mr_n59209248)
print v(xbgr.mr_n59209424)
print v(xbgr.mr_n59210048)
print v(xbgr.mr_n59210224)
print v(xbgr.mr_n59210848)
print v(xbgr.mr_n59211024)
print v(xbgr.mr_n59211648)
print v(xbgr.mr_n59211824)
print v(xbgr.mr_n59212448)
print v(xbgr.mr_n59212624)
print v(xbgr.mr_n59213248)
print v(xbgr.mr_n59213424)
print v(xbgr.mr_n59213856)
print v(xbgr.mr_n59213968)
print v(xbgr.mr_n59214080)
print v(xbgr.mr_n59214192)
print v(xbgr.mr_n59214384)
print v(xbgr.mr_n59214656)
print v(xbgr.mr_n59214928)
print v(xbgr.mr_n59215200)
print v(xbgr.mr_n59215472)
print v(xbgr.mr_n59215744)
print v(xbgr.mr_n59216016)
print v(xbgr.mr_n59216288)
print v(xbgr.mr_n59216560)
print v(xbgr.mr_n59216832)
print v(xbgr.mr_n59217104)
print v(xbgr.mr_n59217376)
print v(xbgr.mr_n59217648)
print v(xbgr.mr_n59217760)
print v(xbgr.mr_n59218480)
print v(xbgr.mr_n59218816)
print v(xbgr.mr_n59220768)
print v(xbgr.mr_n59222112)
print v(xbgr.mr_n59227360)
print v(xbgr.mr_n59228016)
print v(xbgr.mr_n59237104)
print v(xbgr.mr_n59242592)
print v(xbgr.mr_n59242736)
print v(xbgr.mr_n59243040)
print v(xbgr.mr_n59245296)
print v(xbgr.mr_n59247584)
print v(xbgr.mr_n59251936)
print v(xbgr.mr_n59255136)
print v(xbgr.mr_n59255312)
print v(xbgr.mr_n59255648)
print v(xbgr.mr_n59257488)
print v(xbgr.mr_n59257664)
print v(xbgr.mr_n59258608)
print v(xbgr.mr_n59259264)
print v(xbgr.mr_n59259440)
print v(xbgr.mr_n59260384)
print v(xbgr.mr_n59261040)
print v(xbgr.mr_n59261216)
print v(xbgr.mr_n59262160)
print v(xbgr.mr_n59262816)
print v(xbgr.mr_n59262992)
print v(xbgr.mr_n59263936)
print v(xbgr.mr_n59264592)
print v(xbgr.mr_n59264768)
print v(xbgr.mr_n59265712)
print v(xbgr.mr_n59266368)
print v(xbgr.mr_n59266544)
print v(xbgr.mr_n59267488)
print v(xbgr.mr_n59268144)
print v(xbgr.mr_n59268320)
print v(xbgr.mr_n59269264)
print v(xbgr.mr_n59269920)
print v(xbgr.mr_n59270096)
print v(xbgr.mr_n59271040)
print v(xbgr.mr_n59271696)
print v(xbgr.mr_n59271872)
print v(xbgr.mr_n59272816)
print v(xbgr.mr_n59273472)
print v(xbgr.mr_n59273648)
print v(xbgr.mr_n59274688)
print v(xbgr.mr_n59274960)
print v(xbgr.mr_n59275232)
print v(xbgr.mr_n59275568)
print v(xbgr.mr_n59276032)
print v(xbgr.mr_n59276384)
print v(xbgr.mr_n59276576)
print v(xbgr.mr_n59276768)
print v(xbgr.mr_n59276960)
print v(xbgr.mr_n59277712)
print v(xbgr.mr_n59281296)
print v(xbgr.mr_n59281712)
print v(xbgr.mr_n59281824)
print v(xbgr.mr_n59282528)
print v(xbgr.mr_n59284704)
print v(xbgr.mr_n59285120)
print v(xbgr.mr_n59285232)
print v(xbgr.mr_n59285936)
print v(xbgr.mr_n59288112)
print v(xbgr.mr_n59288528)
print v(xbgr.mr_n59288640)
print v(xbgr.mr_n59289344)
print v(xbgr.mr_n59291520)
print v(xbgr.mr_n59291936)
print v(xbgr.mr_n59292048)
print v(xbgr.mr_n59292752)
print v(xbgr.mr_n59294928)
print v(xbgr.mr_n59295344)
print v(xbgr.mr_n59295456)
print v(xbgr.mr_n59296160)
print v(xbgr.mr_n59297728)
print v(xbgr.mr_n59297840)
print v(xbgr.mr_n59297952)
print v(xbgr.mr_n59298624)
print v(xbgr.mr_n59298816)
print v(xbgr.mr_n59299760)
print v(xbgr.mr_n59301920)
print v(xbgr.mr_n59302272)
print v(xbgr.mr_n59302384)
print v(xbgr.mr_n59303088)
print v(xbgr.mr_n59305152)
print v(xbgr.mr_n59306416)
print v(xbgr.mr_n59306768)
print v(xbgr.mr_n59306880)
print v(xbgr.mr_n59307584)
print v(xbgr.mr_n59309824)
print v(xbgr.mr_n59310176)
print v(xbgr.mr_n59310288)
print v(xbgr.mr_n59310992)
print v(xbgr.mr_n59323552)
print v(xbgr.mr_n59323728)
print v(xbgr.mr_n59324352)
print v(xbgr.mr_n59324528)
print v(xbgr.mr_n59325152)
print v(xbgr.mr_n59325328)
print v(xbgr.mr_n59325952)
print v(xbgr.mr_n59326128)
print v(xbgr.mr_n59326752)
print v(xbgr.mr_n59326928)
print v(xbgr.mr_n59327552)
print v(xbgr.mr_n59327728)
print v(xbgr.mr_n59328352)
print v(xbgr.mr_n59328528)
print v(xbgr.mr_n59329152)
print v(xbgr.mr_n59329328)
print v(xbgr.mr_n59329952)
print v(xbgr.mr_n59330128)
print v(xbgr.mr_n59330752)
print v(xbgr.mr_n59330928)
print v(xbgr.mr_n59331552)
print v(xbgr.mr_n59331728)
print v(xbgr.mr_n59332352)
print v(xbgr.mr_n59332528)
print v(xbgr.mr_n59333152)
print v(xbgr.mr_n59333328)
print v(xbgr.mr_n59333952)
print v(xbgr.mr_n59334128)
print v(xbgr.mr_n59334752)
print v(xbgr.mr_n59334928)
print v(xbgr.mr_n59335552)
print v(xbgr.mr_n59335728)
print v(xbgr.mr_n59347360)
print v(xbgr.mr_n59347664)
print v(xbgr.mr_n59347968)
print v(xbgr.mr_n59348272)
print v(xbgr.mr_n59348656)
print v(xbgr.mr_n59349120)
print v(xbgr.mr_n59349584)
print v(xbgr.mr_n59350048)
print v(xbgr.mr_n59350512)
print v(xbgr.mr_n59350976)
print v(xbgr.mr_n59351440)
print v(xbgr.mr_n59351904)
print v(xbgr.mr_n59352368)
print v(xbgr.mr_n59352832)
print v(xbgr.mr_n59353296)
print v(xbgr.mr_n59353760)
print v(xbgr.mr_n59354224)
print v(xbgr.mr_n59354688)
print v(xbgr.mr_n59355152)
print v(xbgr.mr_n59355616)
print v(xbgr.mr_n59356080)
print v(xbgr.mr_n59356544)
print v(xbgr.mr_n59357008)
print v(xbgr.mr_n59357472)
print v(xbgr.mr_n59357936)
print v(xbgr.mr_n59358400)
print v(xbgr.mr_n59358864)
print v(xbgr.mr_n59359328)
print v(xbgr.mr_n59359792)
print v(xbgr.mr_n59360256)
print v(xbgr.mr_n59361520)
print v(xbgr.mr_n59365872)
print v(xbgr.mr_n59373040)
print v(xbgr.mr_n59375792)
print v(xbgr.mr_n59384848)
print v(xbgr.mr_n59385312)
print v(xbgr.mr_n59385776)
print v(xbgr.mr_n59386304)
print v(xbgr.mr_n59386896)
print v(xbgr.mr_n59387488)
print v(xbgr.mr_n59388080)
print v(xbgr.mr_n59388672)
print v(xbgr.mr_n59389264)
print v(xbgr.mr_n59389856)
print v(xbgr.mr_n59390448)
print v(xbgr.mr_n59391040)
print v(xbgr.mr_n59391632)
print v(xbgr.mr_n59392224)
print v(xbgr.mr_n59392816)
print v(xbgr.mr_n59393408)
print v(xbgr.mr_n59394000)
print v(xbgr.mr_n59395904)
print v(xbgr.mr_n59399168)
print v(xbgr.mr_n59400256)
print v(xbgr.mr_n59408784)
print v(xbgr.mr_n59411904)
print v(xbgr.mr_n59414656)
print v(xbgr.mr_n59416048)
print v(xbgr.mr_n59416240)
print v(xbgr.mr_n59416496)
print v(xbgr.mr_n59416752)
print v(xbgr.mr_n59418912)
print v(xbgr.mr_n59437616)
print v(xbgr.mr_n59439424)
print v(xbgr.mr_n59441264)
print v(xbgr.mr_n59446384)
print v(xbgr.mr_n59456192)
print v(xbgr.mr_n59459888)
print v(xbgr.mr_n59463824)
print v(xbgr.mr_n59471792)
print v(xbgr.mr_n59478848)
print v(xbgr.mr_n59484368)
print v(xbgr.mr_n59484960)
print v(xbgr.mr_n59485552)
print v(xbgr.mr_n59486144)
print v(xbgr.mr_n59486736)
print v(xbgr.mr_n59487328)
print v(xbgr.mr_n59487920)
print v(xbgr.mr_n59488512)
print v(xbgr.mr_n59489104)
print v(xbgr.mr_n59489696)
print v(xbgr.mr_n59490288)
print v(xbgr.mr_n59490880)
print v(xbgr.mr_n59491936)
print v(xbgr.mr_n59492800)
print v(xbgr.mr_n59493264)
print v(xbgr.mr_n59493728)
print v(xbgr.mr_n59494192)
print v(xbgr.mr_n59494656)
print v(xbgr.mr_n59495824)
print v(xbgr.mr_n59498256)
print v(xbgr.mr_n59498432)
print v(xbgr.mr_n59498608)
print v(xbgr.mr_n59499632)
print v(xbgr.mr_n59500400)
print v(xbgr.mr_n59501072)
print v(xbgr.mr_n59502400)
print v(xbgr.mr_n59504864)
print v(xbgr.mr_n59505200)
print v(xbgr.mr_n59505536)
print v(xbgr.mr_n59506640)
print v(xbgr.mr_n59508016)
print v(xbgr.mr_n59508192)
print v(xbgr.mr_n59508704)
print v(xbgr.mr_n59509200)
print v(xbgr.mr_n59509376)
print v(xbgr.mr_n59509792)
print v(xbgr.mr_n59510304)
print v(xbgr.mr_n59510800)
print v(xbgr.mr_n59511136)
print v(xbgr.mr_n59511648)
print v(xbgr.mr_n59511760)
print v(xbgr.mr_n59511872)
print v(xbgr.mr_n59512864)
print v(xbgr.mr_n59513280)
print v(xbgr.mr_n59513792)
print v(xbgr.mr_n59514288)
print v(xbgr.mr_n59514464)
print v(xbgr.mr_n59514880)
print v(xbgr.mr_n59515392)
print v(xbgr.mr_n59515952)
print v(xbgr.mr_n59516128)
print v(xbgr.mr_n59516624)
print v(xbgr.mr_n59517392)
print v(xbgr.mr_n59517568)
print v(xbgr.mr_n59517744)
print v(xbgr.mr_n59518336)
print v(xbgr.mr_n59518448)
print v(xbgr.mr_n59518560)
print v(xbgr.mr_n59518672)
print v(xbgr.mr_n59520160)
print v(xbgr.mr_n59520336)
print v(xbgr.mr_n59520912)
print v(xbgr.mr_n59521616)
print v(xbgr.mr_n59521792)
print v(xbgr.mr_n59522224)
print v(xbgr.mr_n59522336)
print v(xbgr.mr_n59523168)
print v(xbgr.mr_n59523344)
print v(xbgr.mr_n59523600)
print v(xbgr.mr_n59524176)
print v(xbgr.mr_n59524960)
print v(xbgr.mr_n59525136)
print v(xbgr.mr_n59525568)
print v(xbgr.mr_n59526128)
print v(xbgr.mr_n59526304)
print v(xbgr.mr_n59526800)
print v(xbgr.mr_n59527312)
print v(xbgr.mr_n59527424)
print v(xbgr.mr_n59528128)
print v(xbgr.mr_n59528384)
print v(xbgr.mr_n59529056)
print v(xbgr.mr_n59529552)
print v(xbgr.mr_n59529728)
print v(xbgr.mr_n59530144)
print v(xbgr.mr_n59530656)
print v(xbgr.mr_n59531152)
print v(xbgr.mr_n59531488)
print v(xbgr.mr_n59532000)
print v(xbgr.mr_n59532112)
print v(xbgr.mr_n59532224)
print v(xbgr.mr_n59533344)
print v(xbgr.mr_n59533520)
print v(xbgr.mr_n59533776)
print v(xbgr.mr_n59534272)
print v(xbgr.mr_n59534944)
print v(xbgr.mr_n59535056)
print v(xbgr.mr_n59535248)
print v(xbgr.mr_n59535600)
print v(xbgr.mr_n59535712)
print v(xbgr.mr_n59536224)
print v(xbgr.mr_n59536336)
print v(xbgr.mr_n59536448)
print v(xbgr.mr_n59536800)
print v(xbgr.mr_n59537136)
print v(xbgr.mr_n59538080)
print v(xbgr.mr_n59538496)
print v(xbgr.mr_n59538608)
print v(xbgr.mr_n59539168)
print v(xbgr.mr_n59539424)
print v(xbgr.mr_n59540240)
print v(xbgr.mr_n59540672)
print v(xbgr.mr_n59540848)
print v(xbgr.mr_n59541776)
print v(xbgr.mr_n59541952)
print v(xbgr.mr_n59542528)
print v(xbgr.mr_n59542640)
print v(xbgr.mr_n59542752)
print v(xbgr.mr_n59543520)
print v(xbgr.mr_n59543856)
print v(xbgr.mr_n59544800)
print v(xbgr.mr_n59545216)
print v(xbgr.mr_n59545328)
print v(xbgr.mr_n59545888)
print v(xbgr.mr_n59546144)
print v(xbgr.mr_n59547088)
print v(xbgr.mr_n59547504)
print v(xbgr.mr_n59547616)
print v(xbgr.mr_n59547728)
print v(xbgr.mr_n59548496)
print v(xbgr.mr_n59548832)
print v(xbgr.mr_n59549840)
print v(xbgr.mr_n59550016)
print v(xbgr.mr_n59550592)
print v(xbgr.mr_n59551024)
print v(xbgr.mr_n59551200)
print v(xbgr.mr_n59551936)
print v(xbgr.mr_n59552048)
print v(xbgr.mr_n59552608)
print v(xbgr.mr_n59552864)
print v(xbgr.mr_n59553808)
print v(xbgr.mr_n59554224)
print v(xbgr.mr_n59554336)
print v(xbgr.mr_n59554448)
print v(xbgr.mr_n59555216)
print v(xbgr.mr_n59555552)
print v(xbgr.mr_n59556368)
print v(xbgr.mr_n59556480)
print v(xbgr.mr_n59557040)
print v(xbgr.mr_n59557296)
print v(xbgr.mr_n59558240)
print v(xbgr.mr_n59558656)
print v(xbgr.mr_n59558768)
print v(xbgr.mr_n59559328)
print v(xbgr.mr_n59559584)
print v(xbgr.mr_n59560400)
print v(xbgr.mr_n59560832)
print v(xbgr.mr_n59561008)
print v(xbgr.mr_n59568080)
print v(xbgr.mr_n59568544)
print v(xbgr.mr_n59569168)
print v(xbgr.mr_n59569632)
print v(xbgr.mr_n59570096)
print v(xbgr.mr_n59570560)
print v(xbgr.mr_n59571008)
print v(xbgr.mr_n59571472)
print v(xbgr.mr_n59571936)
print v(xbgr.mr_n59572400)
print v(xbgr.mr_n59572864)
print v(xbgr.mr_n59573328)
print v(xbgr.mr_n59573792)
print v(xbgr.mr_n59574256)
print v(xbgr.mr_n59574720)
print v(xbgr.mr_n59575184)
print v(xbgr.mr_n59575648)
print v(xbgr.mr_n59576112)
print v(xbgr.mr_n59576576)
print v(xbgr.mr_n59577040)
print v(xbgr.mr_n59585088)
print v(xbgr.mr_n59585744)
print v(xbgr.mr_n59586512)
print v(xbgr.mr_n59607904)
print v(xbgr.mr_n59608800)
print v(xbgr.mr_n59609600)
print v(xbgr.mr_n59610336)
print v(xbgr.mr_n59614720)
print v(xbgr.mr_n59615968)
print v(xbgr.mr_n59619264)
print v(xbgr.mr_n59620640)
print v(xbgr.mr_n59620976)
print v(xbgr.mr_n59621312)
print v(xbgr.mr_n59621648)
print v(xbgr.mr_n59623536)
print v(xbgr.mr_n59624320)
print v(xbgr.mr_n59624432)
print v(xbgr.mr_n59626384)
print v(xbgr.mr_n59626496)
print v(xbgr.mr_n59628192)
print v(xbgr.mr_n59628304)
print v(xbgr.mr_n59630000)
print v(xbgr.mr_n59630112)
print v(xbgr.mr_n59631808)
print v(xbgr.mr_n59631920)
print v(xbgr.mr_n59633616)
print v(xbgr.mr_n59633728)
print v(xbgr.mr_n59635424)
print v(xbgr.mr_n59635536)
print v(xbgr.mr_n59637232)
print v(xbgr.mr_n59637344)
print v(xbgr.mr_n59639040)
print v(xbgr.mr_n59639152)
print v(xbgr.mr_n59640848)
print v(xbgr.mr_n59640960)
print v(xbgr.mr_n59642656)
print v(xbgr.mr_n59642768)
print v(xbgr.mr_n59644464)
print v(xbgr.mr_n59644576)
print v(xbgr.mr_n59646272)
print v(xbgr.mr_n59646384)
print v(xbgr.mr_n59648080)
print v(xbgr.mr_n59648192)
print v(xbgr.mr_n59649888)
print v(xbgr.mr_n59650000)
print v(xbgr.mr_n59651696)
print v(xbgr.mr_n59651808)
print v(xbgr.mr_n59653504)
print v(xbgr.mr_n59653616)
print v(xbgr.mr_n59662880)
print v(xbgr.mr_n59667616)
print v(xbgr.mr_n59669552)
print v(xbgr.mr_n59671472)
print v(xbgr.mr_n59674656)
print v(xbgr.mr_n59679616)
print v(xbgr.mr_n59680080)
print v(xbgr.mr_n59680192)
print v(xbgr.mr_n59681008)
print v(xbgr.mr_n59681472)
print v(xbgr.mr_n59681584)
print v(xbgr.mr_n59682400)
print v(xbgr.mr_n59682928)
print v(xbgr.mr_n59683104)
print v(xbgr.mr_n59684048)
print v(xbgr.mr_n59684704)
print v(xbgr.mr_n59684880)
print v(xbgr.mr_n59685824)
print v(xbgr.mr_n59686480)
print v(xbgr.mr_n59686656)
print v(xbgr.mr_n59687600)
print v(xbgr.mr_n59688256)
print v(xbgr.mr_n59688432)
print v(xbgr.mr_n59689376)
print v(xbgr.mr_n59690032)
print v(xbgr.mr_n59690208)
print v(xbgr.mr_n59691152)
print v(xbgr.mr_n59691808)
print v(xbgr.mr_n59691984)
print v(xbgr.mr_n59692928)
print v(xbgr.mr_n59693584)
print v(xbgr.mr_n59693760)
print v(xbgr.mr_n59694704)
print v(xbgr.mr_n59695296)
print v(xbgr.mr_n59695888)
print v(xbgr.mr_n59696480)
print v(xbgr.mr_n59697072)
print v(xbgr.mr_n59697664)
print v(xbgr.mr_n59698256)
print v(xbgr.mr_n59698848)
print v(xbgr.mr_n59699440)
print v(xbgr.mr_n59700032)
print v(xbgr.mr_n59700624)
print v(xbgr.mr_n59701216)
print v(xbgr.mr_n59701808)
print v(xbgr.mr_n59702400)
print v(xbgr.mr_n59702992)
print v(xbgr.mr_n59703232)
print v(xbgr.mr_n59703344)
print v(xbgr.mr_n59703456)
print v(xbgr.mr_n59703568)
print v(xbgr.mr_n59703680)
print v(xbgr.mr_n59703952)
print v(xbgr.mr_n59704224)
print v(xbgr.mr_n59705616)
print v(xbgr.mr_n59706528)
print v(xbgr.mr_n59707120)
print v(xbgr.mr_n59707712)
print v(xbgr.mr_n59708304)
print v(xbgr.mr_n59708896)
print v(xbgr.mr_n59709488)
print v(xbgr.mr_n59710080)
print v(xbgr.mr_n59710672)
print v(xbgr.mr_n59711264)
print v(xbgr.mr_n59711856)
print v(xbgr.mr_n59712448)
print v(xbgr.mr_n59713040)
print v(xbgr.mr_n59714096)
print v(xbgr.mr_n59715376)
print v(xbgr.mr_n59723360)
print v(xbgr.mr_n59729472)
print v(xbgr.mr_n59729808)
print v(xbgr.mr_n59730384)
print v(xbgr.mr_n59730976)
print v(xbgr.mr_n59731088)
print v(xbgr.mr_n59732784)
print v(xbgr.mr_n59732896)
print v(xbgr.mr_n59734592)
print v(xbgr.mr_n59734704)
print v(xbgr.mr_n59736400)
print v(xbgr.mr_n59736512)
print v(xbgr.mr_n59738208)
print v(xbgr.mr_n59738320)
print v(xbgr.mr_n59740016)
print v(xbgr.mr_n59740128)
print v(xbgr.mr_n59741824)
print v(xbgr.mr_n59741936)
print v(xbgr.mr_n59743632)
print v(xbgr.mr_n59743744)
print v(xbgr.mr_n59745440)
print v(xbgr.mr_n59745552)
print v(xbgr.mr_n59747248)
print v(xbgr.mr_n59747360)
print v(xbgr.mr_n59749056)
print v(xbgr.mr_n59749168)
print v(xbgr.mr_n59749280)
print v(xbgr.mr_n59751120)
print v(xbgr.mr_n59751232)
print v(xbgr.mr_n59751344)
print v(xbgr.mr_n59753184)
print v(xbgr.mr_n59753296)
print v(xbgr.mr_n59753408)
print v(xbgr.mr_n59755248)
print v(xbgr.mr_n59755360)
print v(xbgr.mr_n59755472)
print v(xbgr.mr_n59757312)
print v(xbgr.mr_n59757424)
print v(xbgr.mr_n59757536)
print v(xbgr.mr_n59759376)
print v(xbgr.mr_n59759488)
print v(xbgr.mr_n59759600)
print v(xbgr.mr_n59761440)
print v(xbgr.mr_n59761552)
print v(xbgr.mr_n59761664)
print v(xbgr.mr_n59762576)
print v(xbgr.mr_n59762928)
print v(xbgr.mr_n59763440)
print v(xbgr.mr_n59763984)
print v(xbgr.mr_n59764528)
print v(xbgr.mr_n59765072)
print v(xbgr.mr_n59765616)
print v(xbgr.mr_n59766160)
print v(xbgr.mr_n59766704)
print v(xbgr.mr_n59767248)
print v(xbgr.mr_n59767792)
print v(xbgr.mr_n59768336)
print v(xbgr.mr_n59768880)
print v(xbgr.mr_n59769424)
print v(xbgr.mr_n59769968)
print v(xbgr.mr_n59770512)
print v(xbgr.mr_n59771056)
print v(xbgr.mr_n59771600)
print v(xbgr.mr_n59772144)
print v(xbgr.mr_n59772688)
print v(xbgr.mr_n59773232)
print v(xbgr.mr_n59773696)
print v(xbgr.mr_n59774240)
print v(xbgr.mr_n59774784)
print v(xbgr.mr_n59775328)
print v(xbgr.mr_n59775872)
print v(xbgr.mr_n59776416)
print v(xbgr.mr_n59776960)
print v(xbgr.mr_n59777632)
print v(xbgr.mr_n59777936)
print v(xbgr.mr_n59778320)
print v(xbgr.mr_n59778784)
print v(xbgr.mr_n59779248)
print v(xbgr.mr_n59779712)
print v(xbgr.mr_n59780176)
print v(xbgr.mr_n59780640)
print v(xbgr.mr_n59781104)
print v(xbgr.mr_n59781568)
print v(xbgr.mr_n59782032)
print v(xbgr.mr_n59782496)
print v(xbgr.mr_n59782960)
print v(xbgr.mr_n59783424)
print v(xbgr.mr_n59783888)
print v(xbgr.mr_n59784352)
print v(xbgr.mr_n59784816)
print v(xbgr.mr_n59785280)
print v(xbgr.mr_n59785744)
print v(xbgr.mr_n59786208)
print v(xbgr.mr_n59786672)
print v(xbgr.mr_n59787136)
print v(xbgr.mr_n59787600)
print v(xbgr.mr_n59788096)
print v(xbgr.mr_n59788688)
print v(xbgr.mr_n59789280)
print v(xbgr.mr_n59789872)
print v(xbgr.mr_n59790464)
print v(xbgr.mr_n59791056)
print v(xbgr.mr_n59791648)
print v(xbgr.mr_n59793376)
print v(xbgr.mr_n59793808)
print v(xbgr.mr_n59794704)
print v(xbgr.mr_n59794944)
print v(xbgr.mr_n59795392)
print v(xbgr.mr_n59795664)
print v(xbgr.mr_n59796256)
print v(xbgr.mr_n59797456)
print v(xbgr.mr_n59798416)
print v(xbgr.mr_n59800752)
print v(xbgr.mr_n59801568)
print v(xbgr.mr_n59808272)
print v(xbgr.mr_n59828480)
print v(xbgr.mr_n59828752)
print v(xbgr.mr_n59829056)
print v(xbgr.mr_n59829648)
print v(xbgr.mr_n59830000)
print v(xbgr.mr_n59831264)
print v(xbgr.mr_n59831440)
print v(xbgr.mr_n59832416)
print v(xbgr.mr_n59840464)
print v(xbgr.mr_n59844816)
print v(xbgr.mr_n59845776)
print v(xbgr.mr_n59848208)
print v(xbgr.mr_n59849248)
print v(xbgr.mr_n59852992)
print v(xbgr.mr_n59865952)
print v(xbgr.mr_n59866912)
print v(xbgr.mr_n59867264)
print v(xbgr.mr_n59869264)
print v(xbgr.mr_n59871792)
print v(xbgr.mr_n59872992)
print v(xbgr.mr_n59874576)
print v(xbgr.mr_n59877616)
print v(xbgr.mr_n59885520)
print v(xbgr.mr_n59885968)
print v(xbgr.mr_n59886832)
print v(xbgr.mr_n59887536)
print v(xbgr.mr_n59888496)
print v(xbgr.mr_n59889440)
print v(xbgr.mr_n59890224)
print v(xbgr.mr_n59890448)
print v(xbgr.mr_n59893712)
print v(xbgr.mr_n59895472)
print v(xbgr.mr_n59898528)
print v(xbgr.mr_n59900928)
print v(xbgr.mr_n59901264)
print v(xbgr.mr_n59901600)
print v(xbgr.mr_n59901936)
print v(xbgr.mr_n59902352)
print v(xbgr.mr_n59902592)
print v(xbgr.mr_n59902896)
print v(xbgr.mr_n59903488)
print v(xbgr.mr_n59903600)
print v(xbgr.mr_n59903712)
print v(xbgr.mr_n59905552)
print v(xbgr.mr_n59905664)
print v(xbgr.mr_n59905776)
print v(xbgr.mr_n59907616)
print v(xbgr.mr_n59907728)
print v(xbgr.mr_n59907840)
print v(xbgr.mr_n59909680)
print v(xbgr.mr_n59909792)
print v(xbgr.mr_n59909904)
print v(xbgr.mr_n59911744)
print v(xbgr.mr_n59911856)
print v(xbgr.mr_n59911968)
print v(xbgr.mr_n59913808)
print v(xbgr.mr_n59913920)
print v(xbgr.mr_n59914032)
print v(xbgr.mr_n59915872)
print v(xbgr.mr_n59915984)
print v(xbgr.mr_n59916096)
print v(xbgr.mr_n59917936)
print v(xbgr.mr_n59918048)
print v(xbgr.mr_n59918160)
print v(xbgr.mr_n59920000)
print v(xbgr.mr_n59920112)
print v(xbgr.mr_n59920224)
print v(xbgr.mr_n59922064)
print v(xbgr.mr_n59922176)
print v(xbgr.mr_n59922288)
print v(xbgr.mr_n59924128)
print v(xbgr.mr_n59924240)
print v(xbgr.mr_n59924352)
print v(xbgr.mr_n59926192)
print v(xbgr.mr_n59926304)
print v(xbgr.mr_n59926416)
print v(xbgr.mr_n59928256)
print v(xbgr.mr_n59928368)
print v(xbgr.mr_n59928480)
print v(xbgr.mr_n59931024)
print v(xbgr.mr_n59931136)
print v(xbgr.mr_n59931504)
print v(xbgr.mr_n59935008)
print v(xbgr.mr_n59935120)
print v(xbgr.mr_n59935488)
print v(xbgr.mr_n59938992)
print v(xbgr.mr_n59939104)
print v(xbgr.mr_n59939472)
print v(xbgr.mr_n59942976)
print v(xbgr.mr_n59943088)
print v(xbgr.mr_n59943456)
print v(xbgr.mr_n59946048)
print v(xbgr.mr_n59946160)
print v(xbgr.mr_n59947664)
print v(xbgr.mr_n59948384)
print v(xbgr.mr_n59948560)
print v(xbgr.mr_n59950128)
print v(xbgr.mr_n59950944)
print v(xbgr.mr_n59951120)
print v(xbgr.mr_n59952688)
print v(xbgr.mr_n59953504)
print v(xbgr.mr_n59953680)
print v(xbgr.mr_n59955248)
print v(xbgr.mr_n59956064)
print v(xbgr.mr_n59956240)
print v(xbgr.mr_n59957808)
print v(xbgr.mr_n59958624)
print v(xbgr.mr_n59958800)
print v(xbgr.mr_n59960368)
print v(xbgr.mr_n59961184)
print v(xbgr.mr_n59961360)
print v(xbgr.mr_n59962928)
print v(xbgr.mr_n59963744)
print v(xbgr.mr_n59963920)
print v(xbgr.mr_n59965488)
print v(xbgr.mr_n59966304)
print v(xbgr.mr_n59966480)
print v(xbgr.mr_n59966784)
print v(xbgr.mr_n59967104)
print v(xbgr.mr_n59968048)
print v(xbgr.mr_n59968864)
print v(xbgr.mr_n59969040)
print v(xbgr.mr_n59970608)
print v(xbgr.mr_n59971424)
print v(xbgr.mr_n59971600)
print v(xbgr.mr_n59973168)
print v(xbgr.mr_n59973600)
print v(xbgr.mr_n59973712)
print v(xbgr.mr_n59974032)
print v(xbgr.mr_n59974656)
print v(xbgr.mr_n59974928)
print v(xbgr.mr_n59976512)
print v(xbgr.mr_n59977008)
print v(xbgr.mr_n59977120)
print v(xbgr.mr_n59979200)
print v(xbgr.mr_n59980752)
print v(xbgr.mr_n59980928)
print v(xbgr.mr_n59982496)
print v(xbgr.mr_n59983312)
print v(xbgr.mr_n59983488)
print v(xbgr.mr_n59985056)
print v(xbgr.mr_n59985872)
print v(xbgr.mr_n59986048)
print v(xbgr.mr_n59987616)
print v(xbgr.mr_n59988432)
print v(xbgr.mr_n59988608)
print v(xbgr.mr_n59990176)
print v(xbgr.mr_n59990992)
print v(xbgr.mr_n59991168)
print v(xbgr.mr_n59992736)
print v(xbgr.mr_n59993552)
print v(xbgr.mr_n59993728)
print v(xbgr.mr_n59994096)
print v(xbgr.mr_n59995296)
print v(xbgr.mr_n59996112)
print v(xbgr.mr_n59996288)
print v(xbgr.mr_n59996592)
print v(xbgr.mr_n59997856)
print v(xbgr.mr_n59998672)
print v(xbgr.mr_n59998848)
print v(xbgr.mr_n60000416)
print v(xbgr.mr_n60001232)
print v(xbgr.mr_n60001408)
print v(xbgr.mr_n60002176)
print v(xbgr.mr_n60002976)
print v(xbgr.mr_n60003792)
print v(xbgr.mr_n60003968)
print v(xbgr.mr_n60005536)
print v(xbgr.mr_n60006352)
print v(xbgr.mr_n60006528)
print v(xbgr.mr_n60008096)
print v(xbgr.mr_n60008672)
print v(xbgr.mr_n60008912)
print v(xbgr.mr_n60009088)
print v(xbgr.mr_n60010656)
print v(xbgr.mr_n60011472)
print v(xbgr.mr_n60011648)
print v(xbgr.mr_n60013216)
print v(xbgr.mr_n60088016)
print v(xbgr.mr_n60109584)
print v(xbgr.mr_n60110352)
print v(xbgr.mr_n60111440)
print v(xbgr.mr_n60113616)
print v(xbgr.mr_n60126464)
print v(xbgr.mr_n60126640)
print v(xbgr.mr_n60126992)
print v(xbgr.mr_n60127264)
print v(xbgr.mr_n60127440)
print v(xbgr.mr_n60127616)
print v(xbgr.mr_n60128064)
print v(xbgr.mr_n60128688)
print v(xbgr.mr_n60129216)
print v(xbgr.mr_n60130192)
print v(xbgr.mr_n60130992)
print v(xbgr.mr_n60131792)
print v(xbgr.mr_n60132592)
print v(xbgr.mr_n60135104)
print v(xbgr.mr_n60229568)
print v(xbgr.mr_n60231728)
print v(xbgr.mr_n60231840)
print v(xbgr.mr_n60232672)
print v(xbgr.mr_n60232784)
print v(xbgr.mr_n60233616)
print v(xbgr.mr_n60233728)
print v(xbgr.mr_n60234560)
print v(xbgr.mr_n60234672)
print v(xbgr.mr_n60235504)
print v(xbgr.mr_n60235616)
print v(xbgr.mr_n60236448)
print v(xbgr.mr_n60236560)
print v(xbgr.mr_n60237392)
print v(xbgr.mr_n60237504)
print v(xbgr.mr_n60238336)
print v(xbgr.mr_n60238448)
print v(xbgr.mr_n60239280)
print v(xbgr.mr_n60239392)
print v(xbgr.mr_n60240224)
print v(xbgr.mr_n60240336)
print v(xbgr.mr_n60241168)
print v(xbgr.mr_n60241280)
print v(xbgr.mr_n60242112)
print v(xbgr.mr_n60242224)
print v(xbgr.mr_n60243056)
print v(xbgr.mr_n60243168)
print v(xbgr.mr_n60244320)
print v(xbgr.mr_n60244592)
print v(xbgr.mr_n60244784)
print v(xbgr.mr_n60256944)
print v(xbgr.mr_n60258560)
print v(xbgr.mr_n60260240)
print v(xbgr.mr_n60262496)
print v(xbgr.mr_n60264752)
print v(xbgr.mr_n60267008)
print v(xbgr.mr_n60269264)
print v(xbgr.mr_n60271520)
print v(xbgr.mr_n60273776)
print v(xbgr.mr_n60276032)
print v(xbgr.mr_n60278864)
print v(xbgr.mr_n60285248)
print v(xbgr.mr_n60286272)
print v(xbgr.mr_n60289968)
print v(xbgr.mr_n60291200)
print v(xbgr.mr_n60292528)
print v(xbgr.mr_n60292992)
print v(xbgr.mr_n60301344)
print v(xbgr.mr_n60302464)
print v(xbgr.mr_n60302576)
print v(xbgr.mr_n60303200)
print v(xbgr.mr_n60304736)
print v(xbgr.mr_n60305600)
print v(xbgr.mr_n60306560)
print v(xbgr.mr_n60306672)
print v(xbgr.mr_n60307616)
print v(xbgr.mr_n60308736)
print v(xbgr.mr_n60308848)
print v(xbgr.mr_n60309472)
print v(xbgr.mr_n60311008)
print v(xbgr.mr_n60311872)
print v(xbgr.mr_n60312832)
print v(xbgr.mr_n60312944)
print v(xbgr.mr_n60313888)
print v(xbgr.mr_n60315008)
print v(xbgr.mr_n60315120)
print v(xbgr.mr_n60315744)
print v(xbgr.mr_n60317280)
print v(xbgr.mr_n60318144)
print v(xbgr.mr_n60319104)
print v(xbgr.mr_n60319216)
print v(xbgr.mr_n60320160)
print v(xbgr.mr_n60321312)
print v(xbgr.mr_n60321424)
print v(xbgr.mr_n60322048)
print v(xbgr.mr_n60323584)
print v(xbgr.mr_n60324448)
print v(xbgr.mr_n60325408)
print v(xbgr.mr_n60325520)
print v(xbgr.mr_n60326464)
print v(xbgr.mr_n60327616)
print v(xbgr.mr_n60327728)
print v(xbgr.mr_n60328352)
print v(xbgr.mr_n60329888)
print v(xbgr.mr_n60330752)
print v(xbgr.mr_n60331712)
print v(xbgr.mr_n60331824)
print v(xbgr.mr_n60332768)
print v(xbgr.mr_n60333920)
print v(xbgr.mr_n60334032)
print v(xbgr.mr_n60334656)
print v(xbgr.mr_n60336832)
print v(xbgr.mr_n60337168)
print v(xbgr.mr_n60339024)
print v(xbgr.mr_n60339648)
print v(xbgr.mr_n60340336)
print v(xbgr.mr_n60341088)
print v(xbgr.mr_n60342032)
print v(xbgr.mr_n60342976)
print v(xbgr.mr_n60343920)
print v(xbgr.mr_n60344864)
print v(xbgr.mr_n60345808)
print v(xbgr.mr_n60346752)
print v(xbgr.mr_n60347696)
print v(xbgr.mr_n60348640)
print v(xbgr.mr_n60349584)
print v(xbgr.mr_n60350528)
print v(xbgr.mr_n60351472)
print v(xbgr.mr_n60352416)
print v(xbgr.mr_n60353360)
print v(xbgr.mr_n60354304)
print v(xbgr.mr_n60355248)
print v(xbgr.mr_n60356192)
print v(xbgr.mr_n60357136)
print v(xbgr.mr_n60358080)
print v(xbgr.mr_n60359024)
print v(xbgr.mr_n60359968)
print v(xbgr.mr_n60360912)
print v(xbgr.mr_n60361856)
print v(xbgr.mr_n60362800)
print v(xbgr.mr_n60363744)
print v(xbgr.mr_n60364688)
print v(xbgr.mr_n60365632)
print v(xbgr.mr_n60366576)
print v(xbgr.mr_n60367520)
print v(xbgr.mr_n60368464)
print v(xbgr.mr_n60369408)
print v(xbgr.mr_n60370352)
print v(xbgr.mr_n60371296)
print v(xbgr.mr_n60371408)
print v(xbgr.mr_n60373344)
print v(xbgr.mr_n60373840)
print v(xbgr.mr_n60376560)
print v(xbgr.mr_n60378416)
print v(xbgr.mr_n60378528)
print v(xbgr.mr_n60379120)
print v(xbgr.mr_n60379232)
print v(xbgr.mr_n60380720)
print v(xbgr.mr_n60380832)
print v(xbgr.mr_n60381664)
print v(xbgr.mr_n60381776)
print v(xbgr.mr_n60383312)
print v(xbgr.mr_n60383424)
print v(xbgr.mr_n60385376)
print v(xbgr.mr_n60385488)
print v(xbgr.mr_n60386704)
print v(xbgr.mr_n60386816)
print v(xbgr.mr_n60387968)
print v(xbgr.mr_n60388080)
print v(xbgr.mr_n60389232)
print v(xbgr.mr_n60389344)
print v(xbgr.mr_n60390496)
print v(xbgr.mr_n60390608)
print v(xbgr.mr_n60391760)
print v(xbgr.mr_n60391872)
print v(xbgr.mr_n60393328)
print v(xbgr.mr_n60393904)
print v(xbgr.mr_n60395968)
print v(xbgr.mr_n60397568)
print v(xbgr.mr_n60408656)
print v(xbgr.mr_n60408912)
print v(xbgr.mr_n60409168)
print v(xbgr.mr_n60409424)
print v(xbgr.mr_n60409760)
print v(xbgr.mr_n60412016)
print v(xbgr.mr_n60412128)
print v(xbgr.mr_n60416304)
print v(xbgr.mr_n60417488)
print v(xbgr.mr_n60420368)
print v(xbgr.mr_n60421616)
print v(xbgr.mr_n60421728)
print v(xbgr.mr_n60423728)
print v(xbgr.mr_n60425472)
print v(xbgr.mr_n60425744)
print v(xbgr.mr_n60425936)
print v(xbgr.mr_n60429168)
print v(xbgr.mr_n60429360)
print v(xbgr.mr_n60433504)
print v(xbgr.mr_n60433776)
print v(xbgr.mr_n60433968)
print v(xbgr.mr_n60435648)
print v(xbgr.mr_n60437200)
print v(xbgr.mr_n60437392)
print v(xbgr.mr_n60441536)
print v(xbgr.mr_n60441808)
print v(xbgr.mr_n60442000)
print v(xbgr.mr_n60445232)
print v(xbgr.mr_n60445424)
print v(xbgr.mr_n60449568)
print v(xbgr.mr_n60449840)
print v(xbgr.mr_n60450032)
print v(xbgr.mr_n60453760)
print v(xbgr.mr_n60455008)
print v(xbgr.mr_n60455120)
print v(xbgr.mr_n60456464)
print v(xbgr.mr_n60458160)
print v(xbgr.mr_n60458352)
print v(xbgr.mr_n60458544)
print v(xbgr.mr_n60459792)
print v(xbgr.mr_n60459904)
print v(xbgr.mr_n60461520)
print v(xbgr.mr_n60464320)
print v(xbgr.mr_n60465568)
print v(xbgr.mr_n60465680)
print v(xbgr.mr_n60469024)
print v(xbgr.mr_n60470688)
print v(xbgr.mr_n60477616)
print v(xbgr.mr_n60478448)
print v(xbgr.mr_n60478560)
print v(xbgr.mr_n60479392)
print v(xbgr.mr_n60479504)
print v(xbgr.mr_n60480336)
print v(xbgr.mr_n60480448)
print v(xbgr.mr_n60481536)
print v(xbgr.mr_n60481648)
print v(xbgr.mr_n60482800)
print v(xbgr.mr_n60482912)
print v(xbgr.mr_n60484064)
print v(xbgr.mr_n60484176)
print v(xbgr.mr_n60485328)
print v(xbgr.mr_n60485440)
print v(xbgr.mr_n60486592)
print v(xbgr.mr_n60486704)
print v(xbgr.mr_n60487792)
print v(xbgr.mr_n60487904)
print v(xbgr.mr_n60489120)
print v(xbgr.mr_n60489232)
print v(xbgr.mr_n60490384)
print v(xbgr.mr_n60490496)
print v(xbgr.mr_n60491648)
print v(xbgr.mr_n60491760)
print v(xbgr.mr_n60492912)
print v(xbgr.mr_n60493024)
print v(xbgr.mr_n60494176)
print v(xbgr.mr_n60494288)
print v(xbgr.mr_n60495440)
print v(xbgr.mr_n60495552)
print v(xbgr.mr_n60502960)
print v(xbgr.mr_n60503648)
print v(xbgr.mr_n60504336)
print v(xbgr.mr_n60505056)
print v(xbgr.mr_n60506672)
print v(xbgr.mr_n60507952)
print v(xbgr.mr_n60508064)
print v(xbgr.mr_n60509008)
print v(xbgr.mr_n60510160)
print v(xbgr.mr_n60510272)
print v(xbgr.mr_n60510896)
print v(xbgr.mr_n60512432)
print v(xbgr.mr_n60512976)
print v(xbgr.mr_n60514256)
print v(xbgr.mr_n60514368)
print v(xbgr.mr_n60515456)
print v(xbgr.mr_n60516368)
print v(xbgr.mr_n60518480)
print v(xbgr.mr_n60519024)
print v(xbgr.mr_n60520368)
print v(xbgr.mr_n60520912)
print v(xbgr.mr_n60522256)
print v(xbgr.mr_n60522800)
print v(xbgr.mr_n60523456)
print v(xbgr.mr_n60524144)
print v(xbgr.mr_n60524688)
print v(xbgr.mr_n60526032)
print v(xbgr.mr_n60526576)
print v(xbgr.mr_n60527920)
print v(xbgr.mr_n60528464)
print v(xbgr.mr_n60529808)
print v(xbgr.mr_n60530352)
print v(xbgr.mr_n60531696)
print v(xbgr.mr_n60532560)
print v(xbgr.mr_n60533520)
print v(xbgr.mr_n60533632)
print v(xbgr.mr_n60534576)
print v(xbgr.mr_n60535728)
print v(xbgr.mr_n60535840)
print v(xbgr.mr_n60536784)
print v(xbgr.mr_n60537936)
print v(xbgr.mr_n60538048)
print v(xbgr.mr_n60553872)
print v(xbgr.mr_n60554560)
print v(xbgr.mr_n60555248)
print v(xbgr.mr_n60555968)
print v(xbgr.mr_n60556912)
print v(xbgr.mr_n60557104)
print v(xbgr.mr_n60557296)
print v(xbgr.mr_n60557488)
print v(xbgr.mr_n60557680)
print v(xbgr.mr_n60557872)
print v(xbgr.mr_n60560016)
print v(xbgr.mr_n60560128)
print v(xbgr.mr_n60562144)
print v(xbgr.mr_n60564160)
print v(xbgr.mr_n60564272)
print v(xbgr.mr_n60569920)
print v(xbgr.mr_n60570864)
print v(xbgr.mr_n60571040)
print v(xbgr.mr_n60585888)
print v(xbgr.mr_n60586832)
print v(xbgr.mr_n60587776)
print v(xbgr.mr_n60588720)
print v(xbgr.mr_n60589664)
print v(xbgr.mr_n60590608)
print v(xbgr.mr_n60591552)
print v(xbgr.mr_n60592496)
print v(xbgr.mr_n60598048)
print v(xbgr.mr_n60598240)
print v(xbgr.mr_n60599072)
print v(xbgr.mr_n60599584)
print v(xbgr.mr_n60601200)
print v(xbgr.mr_n60601392)
print v(xbgr.mr_n60602224)
print v(xbgr.mr_n60602736)
print v(xbgr.mr_n60604496)
print v(xbgr.mr_n60604688)
print v(xbgr.mr_n60605376)
print v(xbgr.mr_n60605888)
print v(xbgr.mr_n60607504)
print v(xbgr.mr_n60607696)
print v(xbgr.mr_n60608528)
print v(xbgr.mr_n60609040)
print v(xbgr.mr_n60610592)
print v(xbgr.mr_n60611120)
print v(xbgr.mr_n60611680)
print v(xbgr.mr_n60612192)
print v(xbgr.mr_n60613952)
print v(xbgr.mr_n60614144)
print v(xbgr.mr_n60614832)
print v(xbgr.mr_n60615344)
print v(xbgr.mr_n60616960)
print v(xbgr.mr_n60617152)
print v(xbgr.mr_n60617984)
print v(xbgr.mr_n60618496)
print v(xbgr.mr_n60620256)
print v(xbgr.mr_n60620448)
print v(xbgr.mr_n60621136)
print v(xbgr.mr_n60621840)
print v(xbgr.mr_n60622400)
print v(xbgr.mr_n60622976)
print v(xbgr.mr_n60623664)
print v(xbgr.mr_n60624240)
print v(xbgr.mr_n60624928)
print v(xbgr.mr_n60625504)
print v(xbgr.mr_n60626192)
print v(xbgr.mr_n60626624)
print v(xbgr.mr_n60627456)
print v(xbgr.mr_n60627888)
print v(xbgr.mr_n60628720)
print v(xbgr.mr_n60629296)
print v(xbgr.mr_n60629984)
print v(xbgr.mr_n60632416)
print v(xbgr.mr_n60633104)
print v(xbgr.mr_n60633792)
print v(xbgr.mr_n60636240)
print v(xbgr.mr_n60636768)
print v(xbgr.mr_n60637328)
print v(xbgr.mr_n60637520)
print v(xbgr.mr_n60638096)
print v(xbgr.mr_n60638208)
print v(xbgr.mr_n60640112)
print v(xbgr.mr_n60640800)
print v(xbgr.mr_n60641072)
print v(xbgr.mr_n60641184)
print v(xbgr.mr_n60641824)
print v(xbgr.mr_n60641936)
print v(xbgr.mr_n60642048)
print v(xbgr.mr_n60642240)
print v(xbgr.mr_n60642432)
print v(xbgr.mr_n60642624)
print v(xbgr.mr_n60644880)
print v(xbgr.mr_n60645152)
print v(xbgr.mr_n60645344)
print v(xbgr.mr_n60645856)
print v(xbgr.mr_n60647344)
print v(xbgr.mr_n60647856)
print v(xbgr.mr_n60648816)
print v(xbgr.mr_n60649440)
print v(xbgr.mr_n60649552)
print v(xbgr.mr_n60649744)
print v(xbgr.mr_n60650256)
print v(xbgr.mr_n60651472)
print v(xbgr.mr_n60651840)
print v(xbgr.mr_n60653520)
print v(xbgr.mr_n60653712)
print v(xbgr.mr_n60654224)
print v(xbgr.mr_n60658176)
print v(xbgr.mr_n60658448)
print v(xbgr.mr_n60658640)
print v(xbgr.mr_n60659152)
print v(xbgr.mr_n60660768)
print v(xbgr.mr_n60660960)
print v(xbgr.mr_n60663152)
print v(xbgr.mr_n60663424)
print v(xbgr.mr_n60663616)
print v(xbgr.mr_n60664128)
print v(xbgr.mr_n60666128)
print v(xbgr.mr_n60666640)
print v(xbgr.mr_n60669312)
print v(xbgr.mr_n60669584)
print v(xbgr.mr_n60669776)
print v(xbgr.mr_n60670288)
print v(xbgr.mr_n60671904)
print v(xbgr.mr_n60672096)
print v(xbgr.mr_n60674288)
print v(xbgr.mr_n60674560)
print v(xbgr.mr_n60674752)
print v(xbgr.mr_n60675264)
print v(xbgr.mr_n60677264)
print v(xbgr.mr_n60677776)
print v(xbgr.mr_n60680448)
print v(xbgr.mr_n60680720)
print v(xbgr.mr_n60680912)
print v(xbgr.mr_n60681424)
print v(xbgr.mr_n60683120)
print v(xbgr.mr_n60683312)
print v(xbgr.mr_n60683504)
print v(xbgr.mr_n60685760)
print v(xbgr.mr_n60685952)
print v(xbgr.mr_n60686464)
print v(xbgr.mr_n60687280)
print v(xbgr.mr_n60689168)
print v(xbgr.mr_n60691584)
print v(xbgr.mr_n60691856)
print v(xbgr.mr_n60692048)
print v(xbgr.mr_n60692560)
print v(xbgr.mr_n60696272)
print v(xbgr.mr_n60697424)
print v(xbgr.mr_n60697536)
print v(xbgr.mr_n60698688)
print v(xbgr.mr_n60698800)
print v(xbgr.mr_n60699952)
print v(xbgr.mr_n60700064)
print v(xbgr.mr_n60701216)
print v(xbgr.mr_n60701328)
print v(xbgr.mr_n60702480)
print v(xbgr.mr_n60702592)
print v(xbgr.mr_n60703744)
print v(xbgr.mr_n60703856)
print v(xbgr.mr_n60705008)
print v(xbgr.mr_n60705120)
print v(xbgr.mr_n60706272)
print v(xbgr.mr_n60706384)
print v(xbgr.mr_n60707536)
print v(xbgr.mr_n60707648)
print v(xbgr.mr_n60708800)
print v(xbgr.mr_n60708912)
print v(xbgr.mr_n60710064)
print v(xbgr.mr_n60710176)
print v(xbgr.mr_n60711328)
print v(xbgr.mr_n60711440)
print v(xbgr.mr_n60712592)
print v(xbgr.mr_n60712704)
print v(xbgr.mr_n60713856)
print v(xbgr.mr_n60713968)
print v(xbgr.mr_n60715120)
print v(xbgr.mr_n60715232)
print v(xbgr.mr_n60718944)
print v(xbgr.mr_n60721488)
print v(xbgr.mr_n60722992)
print v(xbgr.mr_n60723328)
print v(xbgr.mr_n60729248)
print v(xbgr.mr_n60730608)
print v(xbgr.mr_n60739648)
print v(xbgr.mr_n60740656)
print v(xbgr.mr_n60742640)
print v(xbgr.mr_n60748912)
print v(xbgr.mr_n60749600)
print v(xbgr.mr_n60750352)
print v(xbgr.mr_n60751296)
print v(xbgr.mr_n60753904)
print v(xbgr.mr_n60757984)
print v(xbgr.mr_n60758176)
print v(xbgr.mr_n60758864)
print v(xbgr.mr_n60758976)
print v(xbgr.mr_n60759088)
print v(xbgr.mr_n60759200)
print v(xbgr.mr_n60759312)
print v(xbgr.mr_n60761056)
print v(xbgr.mr_n60761248)
print v(xbgr.mr_n60761440)
print v(xbgr.mr_n60762032)
print v(xbgr.mr_n60763968)
print v(xbgr.mr_n60765712)
print v(xbgr.mr_n60765984)
print v(xbgr.mr_n60766176)
print v(xbgr.mr_n60766688)
print v(xbgr.mr_n60768208)
print v(xbgr.mr_n60768624)
print v(xbgr.mr_n60770368)
print v(xbgr.mr_n60770640)
print v(xbgr.mr_n60770832)
print v(xbgr.mr_n60771344)
print v(xbgr.mr_n60772576)
print v(xbgr.mr_n60773088)
print v(xbgr.mr_n60776800)
print v(xbgr.mr_n60776992)
print v(xbgr.mr_n60777504)
print v(xbgr.mr_n60781504)
print v(xbgr.mr_n60781776)
print v(xbgr.mr_n60781968)
print v(xbgr.mr_n60782480)
print v(xbgr.mr_n60783712)
print v(xbgr.mr_n60784224)
print v(xbgr.mr_n60784896)
print v(xbgr.mr_n60788048)
print v(xbgr.mr_n60788880)
print v(xbgr.mr_n60788992)
print v(xbgr.mr_n60789104)
print v(xbgr.mr_n60789216)
print v(xbgr.mr_n60789328)
print v(xbgr.mr_n60791072)
print v(xbgr.mr_n60791344)
print v(xbgr.mr_n60791536)
print v(xbgr.mr_n60792048)
print v(xbgr.mr_n60793280)
print v(xbgr.mr_n60793792)
print v(xbgr.mr_n60797232)
print v(xbgr.mr_n60797504)
print v(xbgr.mr_n60797696)
print v(xbgr.mr_n60798208)
print v(xbgr.mr_n60800352)
print v(xbgr.mr_n60800464)
print v(xbgr.mr_n60802208)
print v(xbgr.mr_n60802480)
print v(xbgr.mr_n60802672)
print v(xbgr.mr_n60803184)
print v(xbgr.mr_n60803296)
print v(xbgr.mr_n60804416)
print v(xbgr.mr_n60804928)
print v(xbgr.mr_n60806896)
print v(xbgr.mr_n60808704)
print v(xbgr.mr_n60808896)
print v(xbgr.mr_n60809408)
print v(xbgr.mr_n60811488)
print v(xbgr.mr_n60811600)
print v(xbgr.mr_n60813344)
print v(xbgr.mr_n60813616)
print v(xbgr.mr_n60813808)
print v(xbgr.mr_n60814320)
print v(xbgr.mr_n60814432)
print v(xbgr.mr_n60814816)
print v(xbgr.mr_n60816384)
print v(xbgr.mr_n60819504)
print v(xbgr.mr_n60819776)
print v(xbgr.mr_n60819968)
print v(xbgr.mr_n60820480)
print v(xbgr.mr_n60822544)
print v(xbgr.mr_n60822656)
print v(xbgr.mr_n60823168)
print v(xbgr.mr_n60823280)
print v(xbgr.mr_n60823792)
print v(xbgr.mr_n60823904)
print v(xbgr.mr_n60824672)
print v(xbgr.mr_n60824784)
print v(xbgr.mr_n60825616)
print v(xbgr.mr_n60825728)
print v(xbgr.mr_n60826560)
print v(xbgr.mr_n60826672)
print v(xbgr.mr_n60827504)
print v(xbgr.mr_n60827616)
print v(xbgr.mr_n60828448)
print v(xbgr.mr_n60828560)
print v(xbgr.mr_n60829456)
print v(xbgr.mr_n60829568)
print v(xbgr.mr_n60830720)
print v(xbgr.mr_n60830832)
print v(xbgr.mr_n60831984)
print v(xbgr.mr_n60832096)
print v(xbgr.mr_n60833248)
print v(xbgr.mr_n60833360)
print v(xbgr.mr_n60834512)
print v(xbgr.mr_n60834624)
print v(xbgr.mr_n60835776)
print v(xbgr.mr_n60835888)
print v(xbgr.mr_n60837040)
print v(xbgr.mr_n60837152)
print v(xbgr.mr_n60839120)
print v(xbgr.mr_n60843168)
print v(xbgr.mr_n60843616)
print v(xbgr.mr_n60847328)
print v(xbgr.mr_n60849120)
print v(xbgr.mr_n60849232)
print v(xbgr.mr_n60850384)
print v(xbgr.mr_n60850496)
print v(xbgr.mr_n60851648)
print v(xbgr.mr_n60851760)
print v(xbgr.mr_n60852912)
print v(xbgr.mr_n60853024)
print v(xbgr.mr_n60854176)
print v(xbgr.mr_n60854288)
print v(xbgr.mr_n60855440)
print v(xbgr.mr_n60855552)
print v(xbgr.mr_n60856704)
print v(xbgr.mr_n60856816)
print v(xbgr.mr_n60857968)
print v(xbgr.mr_n60858080)
print v(xbgr.mr_n60859232)
print v(xbgr.mr_n60859344)
print v(xbgr.mr_n60860496)
print v(xbgr.mr_n60860608)
print v(xbgr.mr_n60861760)
print v(xbgr.mr_n60861872)
print v(xbgr.mr_n60863024)
print v(xbgr.mr_n60863136)
print v(xbgr.mr_n60864288)
print v(xbgr.mr_n60864400)
print v(xbgr.mr_n60865552)
print v(xbgr.mr_n60865664)
print v(xbgr.mr_n60866816)
print v(xbgr.mr_n60866928)
print v(xbgr.mr_n60868080)
print v(xbgr.mr_n60868192)
print v(xbgr.mr_n60869344)
print v(xbgr.mr_n60869456)
print v(xbgr.mr_n60876688)
print v(xbgr.mr_n60878592)
print v(xbgr.mr_n60881792)
print v(xbgr.mr_n60883280)
print v(xbgr.mr_n60886832)
print v(xbgr.mr_n60888304)
print v(xbgr.mr_n60890128)
print v(xbgr.mr_n60890480)
print v(xbgr.mr_n60893472)
print v(xbgr.mr_n60894000)
print v(xbgr.mr_n60894704)
print v(xbgr.mr_n60894880)
print v(xbgr.mr_n60895056)
print v(xbgr.mr_n60895584)
print v(xbgr.mr_n60895760)
print v(xbgr.mr_n60898224)
print v(xbgr.mr_n60898928)
print v(xbgr.mr_n60899872)
print v(xbgr.mr_n60900336)
print v(xbgr.mr_n60901104)
print v(xbgr.mr_n60901392)
print v(xbgr.mr_n60902688)
print v(xbgr.mr_n60903088)
print v(xbgr.mr_n60903440)
print v(xbgr.mr_n60904032)
print v(xbgr.mr_n60904272)
print v(xbgr.mr_n60905968)
print v(xbgr.mr_n60906736)
print v(xbgr.mr_n60907552)
print v(xbgr.mr_n60907728)
print v(xbgr.mr_n60908144)
print v(xbgr.mr_n60909488)
print v(xbgr.mr_n60909904)
print v(xbgr.mr_n60910432)
print v(xbgr.mr_n60910544)
print v(xbgr.mr_n60910896)
print v(xbgr.mr_n60911488)
print v(xbgr.mr_n60912192)
print v(xbgr.mr_n60912672)
print v(xbgr.mr_n60912784)
print v(xbgr.mr_n60913024)
print v(xbgr.mr_n60913776)
print v(xbgr.mr_n60917008)
print v(xbgr.mr_n60917696)
print v(xbgr.mr_n60918384)
print v(xbgr.mr_n60924272)
print v(xbgr.mr_n60924464)
print v(xbgr.mr_n60925152)
print v(xbgr.mr_n60925264)
print v(xbgr.mr_n60925376)
print v(xbgr.mr_n60925488)
print v(xbgr.mr_n60925600)
print v(xbgr.mr_n60927344)
print v(xbgr.mr_n60927616)
print v(xbgr.mr_n60927808)
print v(xbgr.mr_n60928320)
print v(xbgr.mr_n60930512)
print v(xbgr.mr_n60932256)
print v(xbgr.mr_n60932528)
print v(xbgr.mr_n60932720)
print v(xbgr.mr_n60933232)
print v(xbgr.mr_n60935168)
print v(xbgr.mr_n60936912)
print v(xbgr.mr_n60937184)
print v(xbgr.mr_n60937376)
print v(xbgr.mr_n60937888)
print v(xbgr.mr_n60939824)
print v(xbgr.mr_n60941568)
print v(xbgr.mr_n60941840)
print v(xbgr.mr_n60942032)
print v(xbgr.mr_n60942544)
print v(xbgr.mr_n60944480)
print v(xbgr.mr_n60946224)
print v(xbgr.mr_n60946496)
print v(xbgr.mr_n60946688)
print v(xbgr.mr_n60947200)
print v(xbgr.mr_n60949136)
print v(xbgr.mr_n60950880)
print v(xbgr.mr_n60951072)
print v(xbgr.mr_n60951264)
print v(xbgr.mr_n60951856)
print v(xbgr.mr_n60953792)
print v(xbgr.mr_n60953984)
print v(xbgr.mr_n60955536)
print v(xbgr.mr_n60955808)
print v(xbgr.mr_n60956000)
print v(xbgr.mr_n60956512)
print v(xbgr.mr_n60958448)
print v(xbgr.mr_n60960192)
print v(xbgr.mr_n60960464)
print v(xbgr.mr_n60960656)
print v(xbgr.mr_n60961168)
print v(xbgr.mr_n60963104)
print v(xbgr.mr_n60964848)
print v(xbgr.mr_n60965120)
print v(xbgr.mr_n60965312)
print v(xbgr.mr_n60965824)
print v(xbgr.mr_n60967760)
print v(xbgr.mr_n60969504)
print v(xbgr.mr_n60969776)
print v(xbgr.mr_n60969968)
print v(xbgr.mr_n60970480)
print v(xbgr.mr_n60972416)
print v(xbgr.mr_n60974160)
print v(xbgr.mr_n60974432)
print v(xbgr.mr_n60974624)
print v(xbgr.mr_n60975136)
print v(xbgr.mr_n60977072)
print v(xbgr.mr_n60978816)
print v(xbgr.mr_n60979088)
print v(xbgr.mr_n60979280)
print v(xbgr.mr_n60979792)
print v(xbgr.mr_n60981728)
print v(xbgr.mr_n60983472)
print v(xbgr.mr_n60983744)
print v(xbgr.mr_n60983936)
print v(xbgr.mr_n60984448)
print v(xbgr.mr_n60986384)
print v(xbgr.mr_n60988128)
print v(xbgr.mr_n60988400)
print v(xbgr.mr_n60988592)
print v(xbgr.mr_n60989104)
print v(xbgr.mr_n60991040)
print v(xbgr.mr_n60991376)
print v(xbgr.mr_n60992784)
print v(xbgr.mr_n60993056)
print v(xbgr.mr_n60993248)
print v(xbgr.mr_n60993760)
print v(xbgr.mr_n60995696)
print v(xbgr.mr_n60997440)
print v(xbgr.mr_n60997712)
print v(xbgr.mr_n60997904)
print v(xbgr.mr_n60998416)
print v(xbgr.mr_n61000352)
print v(xbgr.mr_n61002096)
print v(xbgr.mr_n61002368)
print v(xbgr.mr_n61002560)
print v(xbgr.mr_n61003072)
print v(xbgr.mr_n61005904)
print v(xbgr.mr_n61006688)
print v(xbgr.mr_n61008336)
print v(xbgr.mr_n61008672)
print v(xbgr.mr_n61010880)
print v(xbgr.mr_n61012544)
print v(xbgr.mr_n61012976)
print v(xbgr.mr_n61013408)
print v(xbgr.mr_n61014832)
print v(xbgr.mr_n61015408)
print v(xbgr.mr_n61015520)
print v(xbgr.mr_n61016464)
print v(xbgr.mr_n61017296)
print v(xbgr.mr_n61017408)
print v(xbgr.mr_n61018352)
print v(xbgr.mr_n61019504)
print v(xbgr.mr_n61019616)
print v(xbgr.mr_n61020560)
print v(xbgr.mr_n61021712)
print v(xbgr.mr_n61021824)
print v(xbgr.mr_n61022768)
print v(xbgr.mr_n61023088)
print v(xbgr.mr_n61023920)
print v(xbgr.mr_n61024032)
print v(xbgr.mr_n61024976)
print v(xbgr.mr_n61026128)
print v(xbgr.mr_n61026240)
print v(xbgr.mr_n61027184)
print v(xbgr.mr_n61028336)
print v(xbgr.mr_n61028448)
print v(xbgr.mr_n61029392)
print v(xbgr.mr_n61030544)
print v(xbgr.mr_n61030656)
print v(xbgr.mr_n61031600)
print v(xbgr.mr_n61031776)
print v(xbgr.mr_n61032752)
print v(xbgr.mr_n61032864)
print v(xbgr.mr_n61033808)
print v(xbgr.mr_n61034960)
print v(xbgr.mr_n61035072)
print v(xbgr.mr_n61036016)
print v(xbgr.mr_n61037168)
print v(xbgr.mr_n61037280)
print v(xbgr.mr_n61038224)
print v(xbgr.mr_n61039376)
print v(xbgr.mr_n61039488)
print v(xbgr.mr_n61040432)
print v(xbgr.mr_n61041584)
print v(xbgr.mr_n61041696)
print v(xbgr.mr_n61042640)
print v(xbgr.mr_n61042896)
print v(xbgr.mr_n61043792)
print v(xbgr.mr_n61043904)
print v(xbgr.mr_n61044848)
print v(xbgr.mr_n61046000)
print v(xbgr.mr_n61046112)
print v(xbgr.mr_n61047264)
print v(xbgr.mr_n61047376)
print v(xbgr.mr_n61048528)
print v(xbgr.mr_n61048640)
print v(xbgr.mr_n61051712)
print v(xbgr.mr_n61053632)
print v(xbgr.mr_n61053744)
print v(xbgr.mr_n61056768)
print v(xbgr.mr_n61057600)
print v(xbgr.mr_n61057712)
print v(xbgr.mr_n61059920)
print v(xbgr.mr_n61060032)
print v(xbgr.mr_n61061600)
print v(xbgr.mr_n61061712)
print v(xbgr.mr_n61062800)
print v(xbgr.mr_n61062912)
print v(xbgr.mr_n61064128)
print v(xbgr.mr_n61064240)
print v(xbgr.mr_n61066352)
print v(xbgr.mr_n61071920)
print v(xbgr.mr_n61073392)
print v(xbgr.mr_n61075600)
print v(xbgr.mr_n61077088)
print v(xbgr.mr_n61084016)
print v(xbgr.mr_n61087520)
print v(xbgr.mr_n61087904)
print v(xbgr.mr_n61093792)
print v(xbgr.mr_n61093984)
print v(xbgr.mr_n61094176)
print v(xbgr.mr_n61094368)
print v(xbgr.mr_n61096688)
print v(xbgr.mr_n61096960)
print v(xbgr.mr_n61097152)
print v(xbgr.mr_n61097664)
print v(xbgr.mr_n61103344)
print v(xbgr.mr_n61103616)
print v(xbgr.mr_n61103808)
print v(xbgr.mr_n61104320)
print v(xbgr.mr_n61106464)
print v(xbgr.mr_n61106576)
print v(xbgr.mr_n61106768)
print v(xbgr.mr_n61108320)
print v(xbgr.mr_n61108592)
print v(xbgr.mr_n61108784)
print v(xbgr.mr_n61109296)
print v(xbgr.mr_n61110448)
print v(xbgr.mr_n61111040)
print v(xbgr.mr_n61114480)
print v(xbgr.mr_n61114752)
print v(xbgr.mr_n61114944)
print v(xbgr.mr_n61115456)
print v(xbgr.mr_n61117600)
print v(xbgr.mr_n61117712)
print v(xbgr.mr_n61119456)
print v(xbgr.mr_n61119728)
print v(xbgr.mr_n61119920)
print v(xbgr.mr_n61120432)
print v(xbgr.mr_n61121664)
print v(xbgr.mr_n61122176)
print v(xbgr.mr_n61125616)
print v(xbgr.mr_n61125888)
print v(xbgr.mr_n61126080)
print v(xbgr.mr_n61126592)
print v(xbgr.mr_n61128736)
print v(xbgr.mr_n61128848)
print v(xbgr.mr_n61130592)
print v(xbgr.mr_n61130864)
print v(xbgr.mr_n61131056)
print v(xbgr.mr_n61131568)
print v(xbgr.mr_n61131680)
print v(xbgr.mr_n61133632)
print v(xbgr.mr_n61136752)
print v(xbgr.mr_n61137024)
print v(xbgr.mr_n61137216)
print v(xbgr.mr_n61137728)
print v(xbgr.mr_n61139872)
print v(xbgr.mr_n61140064)
print v(xbgr.mr_n61140256)
print v(xbgr.mr_n61142064)
print v(xbgr.mr_n61142256)
print v(xbgr.mr_n61142768)
print v(xbgr.mr_n61143936)
print v(xbgr.mr_n61144448)
print v(xbgr.mr_n61147888)
print v(xbgr.mr_n61148160)
print v(xbgr.mr_n61148352)
print v(xbgr.mr_n61148864)
print v(xbgr.mr_n61151008)
print v(xbgr.mr_n61151120)
print v(xbgr.mr_n61152864)
print v(xbgr.mr_n61153136)
print v(xbgr.mr_n61153328)
print v(xbgr.mr_n61153840)
print v(xbgr.mr_n61155072)
print v(xbgr.mr_n61155584)
print v(xbgr.mr_n61159024)
print v(xbgr.mr_n61159296)
print v(xbgr.mr_n61159488)
print v(xbgr.mr_n61160000)
print v(xbgr.mr_n61165200)
print v(xbgr.mr_n61165312)
print v(xbgr.mr_n61166080)
print v(xbgr.mr_n61166192)
print v(xbgr.mr_n61167088)
print v(xbgr.mr_n61167200)
print v(xbgr.mr_n61168288)
print v(xbgr.mr_n61168400)
print v(xbgr.mr_n61169552)
print v(xbgr.mr_n61169664)
print v(xbgr.mr_n61170816)
print v(xbgr.mr_n61170928)
print v(xbgr.mr_n61172080)
print v(xbgr.mr_n61172192)
print v(xbgr.mr_n61173344)
print v(xbgr.mr_n61173456)
print v(xbgr.mr_n61174608)
print v(xbgr.mr_n61174720)
print v(xbgr.mr_n61175872)
print v(xbgr.mr_n61175984)
print v(xbgr.mr_n61177136)
print v(xbgr.mr_n61177248)
print v(xbgr.mr_n61178400)
print v(xbgr.mr_n61178512)
print v(xbgr.mr_n61179664)
print v(xbgr.mr_n61179776)
print v(xbgr.mr_n61180864)
print v(xbgr.mr_n61180976)
print v(xbgr.mr_n61182192)
print v(xbgr.mr_n61182304)
print v(xbgr.mr_n61186352)
print v(xbgr.mr_n61189984)
print v(xbgr.mr_n61191136)
print v(xbgr.mr_n61192384)
print v(xbgr.mr_n61193072)
print v(xbgr.mr_n61193760)
print v(xbgr.mr_n61194704)
print v(xbgr.mr_n61196352)
print v(xbgr.mr_n61197296)
print v(xbgr.mr_n61198240)
print v(xbgr.mr_n61199184)
print v(xbgr.mr_n61200128)
print v(xbgr.mr_n61201072)
print v(xbgr.mr_n61202016)
print v(xbgr.mr_n61204432)
print v(xbgr.mr_n61204768)
print v(xbgr.mr_n61206976)
print v(xbgr.mr_n61208544)
print v(xbgr.mr_n61210112)
print v(xbgr.mr_n61211680)
print v(xbgr.mr_n61213184)
print v(xbgr.mr_n61214752)
print v(xbgr.mr_n61216384)
print v(xbgr.mr_n61217952)
print v(xbgr.mr_n61222432)
print v(xbgr.mr_n61223120)
print v(xbgr.mr_n61223808)
print v(xbgr.mr_n61224560)
print v(xbgr.mr_n61226176)
print v(xbgr.mr_n61227456)
print v(xbgr.mr_n61227568)
print v(xbgr.mr_n61228512)
print v(xbgr.mr_n61229664)
print v(xbgr.mr_n61229776)
print v(xbgr.mr_n61230720)
print v(xbgr.mr_n61231872)
print v(xbgr.mr_n61231984)
print v(xbgr.mr_n61232928)
print v(xbgr.mr_n61233248)
print v(xbgr.mr_n61234080)
print v(xbgr.mr_n61234192)
print v(xbgr.mr_n61235136)
print v(xbgr.mr_n61236288)
print v(xbgr.mr_n61236400)
print v(xbgr.mr_n61237344)
print v(xbgr.mr_n61238496)
print v(xbgr.mr_n61238608)
print v(xbgr.mr_n61239552)
print v(xbgr.mr_n61240704)
print v(xbgr.mr_n61240816)
print v(xbgr.mr_n61241760)
print v(xbgr.mr_n61242848)
print v(xbgr.mr_n61242960)
print v(xbgr.mr_n61243904)
print v(xbgr.mr_n61244144)
print v(xbgr.mr_n61245120)
print v(xbgr.mr_n61245232)
print v(xbgr.mr_n61246176)
print v(xbgr.mr_n61247328)
print v(xbgr.mr_n61247440)
print v(xbgr.mr_n61248384)
print v(xbgr.mr_n61249536)
print v(xbgr.mr_n61249648)
print v(xbgr.mr_n61250592)
print v(xbgr.mr_n61251680)
print v(xbgr.mr_n61251792)
print v(xbgr.mr_n61252736)
print v(xbgr.mr_n61253952)
print v(xbgr.mr_n61254064)
print v(xbgr.mr_n61255008)
print v(xbgr.mr_n61256160)
print v(xbgr.mr_n61256272)
print v(xbgr.mr_n61257216)
print v(xbgr.mr_n61258368)
print v(xbgr.mr_n61258480)
print v(xbgr.mr_n61259424)
print v(xbgr.mr_n61260576)
print v(xbgr.mr_n61260688)
print v(xbgr.mr_n61261632)
print v(xbgr.mr_n61261872)
print v(xbgr.mr_n61262784)
print v(xbgr.mr_n61262896)
print v(xbgr.mr_n61263776)
print v(xbgr.mr_n61264464)
print v(xbgr.mr_n61265152)
print v(xbgr.mr_n61265872)
print v(xbgr.mr_n61266816)
print v(xbgr.mr_n61267760)
print v(xbgr.mr_n61268704)
print v(xbgr.mr_n61269648)
print v(xbgr.mr_n61270592)
print v(xbgr.mr_n61271536)
print v(xbgr.mr_n61272480)
print v(xbgr.mr_n61275088)
print v(xbgr.mr_n61279504)
print v(xbgr.mr_n61279968)
print v(xbgr.mr_n61291536)
print v(xbgr.mr_n61295600)
print v(xbgr.mr_n61296160)
print v(xbgr.mr_n61296672)
print v(xbgr.mr_n61296864)
print v(xbgr.mr_n61297056)
print v(xbgr.mr_n61297248)
print v(xbgr.mr_n61299568)
print v(xbgr.mr_n61299840)
print v(xbgr.mr_n61300032)
print v(xbgr.mr_n61300544)
print v(xbgr.mr_n61301040)
print v(xbgr.mr_n61303792)
print v(xbgr.mr_n61305600)
print v(xbgr.mr_n61305792)
print v(xbgr.mr_n61306304)
print v(xbgr.mr_n61308384)
print v(xbgr.mr_n61308496)
print v(xbgr.mr_n61310240)
print v(xbgr.mr_n61310512)
print v(xbgr.mr_n61310704)
print v(xbgr.mr_n61311216)
print v(xbgr.mr_n61312448)
print v(xbgr.mr_n61312960)
print v(xbgr.mr_n61314928)
print v(xbgr.mr_n61315328)
print v(xbgr.mr_n61316736)
print v(xbgr.mr_n61316928)
print v(xbgr.mr_n61317440)
print v(xbgr.mr_n61319520)
print v(xbgr.mr_n61321376)
print v(xbgr.mr_n61321648)
print v(xbgr.mr_n61321840)
print v(xbgr.mr_n61322352)
print v(xbgr.mr_n61323584)
print v(xbgr.mr_n61324096)
print v(xbgr.mr_n61325904)
print v(xbgr.mr_n61326960)
print v(xbgr.mr_n61327152)
print v(xbgr.mr_n61327344)
print v(xbgr.mr_n61327536)
print v(xbgr.mr_n61329280)
print v(xbgr.mr_n61329472)
print v(xbgr.mr_n61329664)
print v(xbgr.mr_n61330416)
print v(xbgr.mr_n61333088)
print v(xbgr.mr_n61333600)
print v(xbgr.mr_n61337552)
print v(xbgr.mr_n61337824)
print v(xbgr.mr_n61338016)
print v(xbgr.mr_n61338528)
print v(xbgr.mr_n61340672)
print v(xbgr.mr_n61340784)
print v(xbgr.mr_n61342528)
print v(xbgr.mr_n61342800)
print v(xbgr.mr_n61342992)
print v(xbgr.mr_n61343504)
print v(xbgr.mr_n61344736)
print v(xbgr.mr_n61345248)
print v(xbgr.mr_n61348688)
print v(xbgr.mr_n61348960)
print v(xbgr.mr_n61349152)
print v(xbgr.mr_n61349664)
print v(xbgr.mr_n61351808)
print v(xbgr.mr_n61351920)
print v(xbgr.mr_n61353664)
print v(xbgr.mr_n61353936)
print v(xbgr.mr_n61354128)
print v(xbgr.mr_n61354640)
print v(xbgr.mr_n61355872)
print v(xbgr.mr_n61356384)
print v(xbgr.mr_n61359824)
print v(xbgr.mr_n61360096)
print v(xbgr.mr_n61360288)
print v(xbgr.mr_n61360800)
print v(xbgr.mr_n61362192)
print v(xbgr.mr_n61365744)
print v(xbgr.mr_n61365856)
print v(xbgr.mr_n61366688)
print v(xbgr.mr_n61366800)
print v(xbgr.mr_n61367632)
print v(xbgr.mr_n61367744)
print v(xbgr.mr_n61368832)
print v(xbgr.mr_n61368944)
print v(xbgr.mr_n61370096)
print v(xbgr.mr_n61370208)
print v(xbgr.mr_n61371360)
print v(xbgr.mr_n61371472)
print v(xbgr.mr_n61372624)
print v(xbgr.mr_n61372736)
print v(xbgr.mr_n61373888)
print v(xbgr.mr_n61374000)
print v(xbgr.mr_n61375152)
print v(xbgr.mr_n61375264)
print v(xbgr.mr_n61376416)
print v(xbgr.mr_n61376528)
print v(xbgr.mr_n61377680)
print v(xbgr.mr_n61377792)
print v(xbgr.mr_n61378944)
print v(xbgr.mr_n61379056)
print v(xbgr.mr_n61380208)
print v(xbgr.mr_n61380320)
print v(xbgr.mr_n61381472)
print v(xbgr.mr_n61381584)
print v(xbgr.mr_n61382736)
print v(xbgr.mr_n61382848)
print v(xbgr.mr_n61384384)
print v(xbgr.mr_n61384496)
print v(xbgr.mr_n61385648)
print v(xbgr.mr_n61385760)
print v(xbgr.mr_n61386912)
print v(xbgr.mr_n61387024)
print v(xbgr.mr_n61388176)
print v(xbgr.mr_n61388288)
print v(xbgr.mr_n61389440)
print v(xbgr.mr_n61389552)
print v(xbgr.mr_n61390704)
print v(xbgr.mr_n61390816)
print v(xbgr.mr_n61391968)
print v(xbgr.mr_n61392080)
print v(xbgr.mr_n61393232)
print v(xbgr.mr_n61393344)
print v(xbgr.mr_n61394496)
print v(xbgr.mr_n61394608)
print v(xbgr.mr_n61395760)
print v(xbgr.mr_n61395872)
print v(xbgr.mr_n61397024)
print v(xbgr.mr_n61397136)
print v(xbgr.mr_n61398288)
print v(xbgr.mr_n61398400)
print v(xbgr.mr_n61399552)
print v(xbgr.mr_n61399664)
print v(xbgr.mr_n61400816)
print v(xbgr.mr_n61400928)
print v(xbgr.mr_n61402080)
print v(xbgr.mr_n61402192)
print v(xbgr.mr_n61403344)
print v(xbgr.mr_n61403456)
print v(xbgr.mr_n61404608)
print v(xbgr.mr_n61404720)
print v(xbgr.mr_n61405664)
print v(xbgr.mr_n61406464)
print v(xbgr.mr_n61411056)
print v(xbgr.mr_n61413040)
print v(xbgr.mr_n61413808)
print v(xbgr.mr_n61415024)
print v(xbgr.mr_n61417376)
print v(xbgr.mr_n61417824)
print v(xbgr.mr_n61420208)
print v(xbgr.mr_n61421920)
print v(xbgr.mr_n61422560)
print v(xbgr.mr_n61424944)
print v(xbgr.mr_n61427568)
print v(xbgr.mr_n61430832)
print v(xbgr.mr_n61441600)
print v(xbgr.mr_n61442288)
print v(xbgr.mr_n61442976)
print v(xbgr.mr_n61443696)
print v(xbgr.mr_n61444640)
print v(xbgr.mr_n61445584)
print v(xbgr.mr_n61446528)
print v(xbgr.mr_n61447472)
print v(xbgr.mr_n61448416)
print v(xbgr.mr_n61449360)
print v(xbgr.mr_n61450304)
print v(xbgr.mr_n61451248)
print v(xbgr.mr_n61452192)
print v(xbgr.mr_n61453136)
print v(xbgr.mr_n61454080)
print v(xbgr.mr_n61455024)
print v(xbgr.mr_n61455968)
print v(xbgr.mr_n61456912)
print v(xbgr.mr_n61457856)
print v(xbgr.mr_n61458432)
print v(xbgr.mr_n61460416)
print v(xbgr.mr_n61460528)
print v(xbgr.mr_n61462704)
print v(xbgr.mr_n61471616)
print v(xbgr.mr_n61471808)
print v(xbgr.mr_n61472496)
print v(xbgr.mr_n61472608)
print v(xbgr.mr_n61472720)
print v(xbgr.mr_n61472832)
print v(xbgr.mr_n61472944)
print v(xbgr.mr_n61474688)
print v(xbgr.mr_n61474960)
print v(xbgr.mr_n61475152)
print v(xbgr.mr_n61475664)
print v(xbgr.mr_n61476128)
print v(xbgr.mr_n61478256)
print v(xbgr.mr_n61478528)
print v(xbgr.mr_n61478720)
print v(xbgr.mr_n61479232)
print v(xbgr.mr_n61482720)
print v(xbgr.mr_n61482912)
print v(xbgr.mr_n61483104)
print v(xbgr.mr_n61483696)
print v(xbgr.mr_n61485248)
print v(xbgr.mr_n61485520)
print v(xbgr.mr_n61487504)
print v(xbgr.mr_n61487776)
print v(xbgr.mr_n61487968)
print v(xbgr.mr_n61488480)
print v(xbgr.mr_n61491968)
print v(xbgr.mr_n61492240)
print v(xbgr.mr_n61492432)
print v(xbgr.mr_n61492944)
print v(xbgr.mr_n61494576)
print v(xbgr.mr_n61494768)
print v(xbgr.mr_n61497088)
print v(xbgr.mr_n61497280)
print v(xbgr.mr_n61497792)
print v(xbgr.mr_n61501216)
print v(xbgr.mr_n61501488)
print v(xbgr.mr_n61501680)
print v(xbgr.mr_n61502192)
print v(xbgr.mr_n61503824)
print v(xbgr.mr_n61504016)
print v(xbgr.mr_n61506336)
print v(xbgr.mr_n61506528)
print v(xbgr.mr_n61507040)
print v(xbgr.mr_n61510464)
print v(xbgr.mr_n61510736)
print v(xbgr.mr_n61510928)
print v(xbgr.mr_n61511440)
print v(xbgr.mr_n61512992)
print v(xbgr.mr_n61515248)
print v(xbgr.mr_n61515520)
print v(xbgr.mr_n61515712)
print v(xbgr.mr_n61516224)
print v(xbgr.mr_n61519712)
print v(xbgr.mr_n61519984)
print v(xbgr.mr_n61520176)
print v(xbgr.mr_n61520688)
print v(xbgr.mr_n61523552)
print v(xbgr.mr_n61523824)
print v(xbgr.mr_n61524016)
print v(xbgr.mr_n61524528)
print v(xbgr.mr_n61525664)
print v(xbgr.mr_n61526000)
print v(xbgr.mr_n61527728)
print v(xbgr.mr_n61527920)
print v(xbgr.mr_n61528432)
print v(xbgr.mr_n61531728)
print v(xbgr.mr_n61531840)
print v(xbgr.mr_n61533584)
print v(xbgr.mr_n61533856)
print v(xbgr.mr_n61534048)
print v(xbgr.mr_n61534560)
print v(xbgr.mr_n61536704)
print v(xbgr.mr_n61536816)
print v(xbgr.mr_n61538560)
print v(xbgr.mr_n61538832)
print v(xbgr.mr_n61539024)
print v(xbgr.mr_n61539536)
print v(xbgr.mr_n61541680)
print v(xbgr.mr_n61541792)
print v(xbgr.mr_n61543536)
print v(xbgr.mr_n61543808)
print v(xbgr.mr_n61544000)
print v(xbgr.mr_n61544512)
print v(xbgr.mr_n61546656)
print v(xbgr.mr_n61546768)
print v(xbgr.mr_n61548512)
print v(xbgr.mr_n61548784)
print v(xbgr.mr_n61548976)
print v(xbgr.mr_n61549488)
print v(xbgr.mr_n61554656)
print v(xbgr.mr_n61556848)
print v(xbgr.mr_n61558416)
print v(xbgr.mr_n61559360)
print v(xbgr.mr_n61561552)
print v(xbgr.mr_n61563120)
print v(xbgr.mr_n61564064)
print v(xbgr.mr_n61566256)
print v(xbgr.mr_n61567872)
print v(xbgr.mr_n61568448)
print v(xbgr.mr_n61568560)
print v(xbgr.mr_n61569392)
print v(xbgr.mr_n61569504)
print v(xbgr.mr_n61570336)
print v(xbgr.mr_n61570448)
print v(xbgr.mr_n61571280)
print v(xbgr.mr_n61571392)
print v(xbgr.mr_n61572224)
print v(xbgr.mr_n61572336)
print v(xbgr.mr_n61573168)
print v(xbgr.mr_n61573280)
print v(xbgr.mr_n61574112)
print v(xbgr.mr_n61574224)
print v(xbgr.mr_n61575056)
print v(xbgr.mr_n61575168)
print v(xbgr.mr_n61576000)
print v(xbgr.mr_n61576112)
print v(xbgr.mr_n61577072)
print v(xbgr.mr_n61577184)
print v(xbgr.mr_n61580384)
print v(xbgr.mr_n61581344)
print v(xbgr.mr_n61590176)
print v(xbgr.mr_n61592864)
print v(xbgr.mr_n61594208)
print v(xbgr.mr_n61600160)
print v(xbgr.mr_n61601424)
print v(xbgr.mr_n61602112)
print v(xbgr.mr_n61602800)
print v(xbgr.mr_n61603840)
print v(xbgr.mr_n61605296)
print v(xbgr.mr_n61606240)
print v(xbgr.mr_n61607184)
print v(xbgr.mr_n61608128)
print v(xbgr.mr_n61609072)
print v(xbgr.mr_n61610016)
print v(xbgr.mr_n61610960)
print v(xbgr.mr_n61611904)
print v(xbgr.mr_n61612848)
print v(xbgr.mr_n61613792)
print v(xbgr.mr_n61614736)
print v(xbgr.mr_n61615680)
print v(xbgr.mr_n61616624)
print v(xbgr.mr_n61617568)
print v(xbgr.mr_n61618512)
print v(xbgr.mr_n61618704)
print v(xbgr.mr_n61618896)
print v(xbgr.mr_n61619088)
print v(xbgr.mr_n61619280)
print v(xbgr.mr_n61619472)
print v(xbgr.mr_n61621616)
print v(xbgr.mr_n61621728)
print v(xbgr.mr_n61625040)
print v(xbgr.mr_n61625152)
print v(xbgr.mr_n61630032)
print v(xbgr.mr_n61631872)
print v(xbgr.mr_n61633712)
print v(xbgr.mr_n61635552)
print v(xbgr.mr_n61640784)
print v(xbgr.mr_n61642512)
print v(xbgr.mr_n61644176)
print v(xbgr.mr_n61652720)
print v(xbgr.mr_n61654288)
print v(xbgr.mr_n61655856)
print v(xbgr.mr_n61657424)
print v(xbgr.mr_n61658992)
print v(xbgr.mr_n61660560)
print v(xbgr.mr_n61662128)
print v(xbgr.mr_n61663696)
print v(xbgr.mr_n61665264)
print v(xbgr.mr_n61666832)
print v(xbgr.mr_n61668400)
print v(xbgr.mr_n61669968)
print v(xbgr.mr_n61671536)
print v(xbgr.mr_n61673104)
print v(xbgr.mr_n61674672)
print v(xbgr.mr_n61676240)
print v(xbgr.mr_n61679488)
print v(xbgr.mr_n61679824)
print v(xbgr.mr_n61679936)
print v(xbgr.mr_n61680768)
print v(xbgr.mr_n61680880)
print v(xbgr.mr_n61681712)
print v(xbgr.mr_n61681824)
print v(xbgr.mr_n61682656)
print v(xbgr.mr_n61682768)
print v(xbgr.mr_n61686256)
print v(xbgr.mr_n61686768)
print v(xbgr.mr_n61686880)
print v(xbgr.mr_n61686992)
print v(xbgr.mr_n61687104)
print v(xbgr.mr_n61687216)
print v(xbgr.mr_n61688640)
print v(xbgr.mr_n61688912)
print v(xbgr.mr_n61689104)
print v(xbgr.mr_n61689616)
print v(xbgr.mr_n61691760)
print v(xbgr.mr_n61691872)
print v(xbgr.mr_n61693616)
print v(xbgr.mr_n61693888)
print v(xbgr.mr_n61694080)
print v(xbgr.mr_n61694592)
print v(xbgr.mr_n61696736)
print v(xbgr.mr_n61696848)
print v(xbgr.mr_n61698592)
print v(xbgr.mr_n61698864)
print v(xbgr.mr_n61699056)
print v(xbgr.mr_n61699568)
print v(xbgr.mr_n61701712)
print v(xbgr.mr_n61701824)
print v(xbgr.mr_n61703568)
print v(xbgr.mr_n61703840)
print v(xbgr.mr_n61704032)
print v(xbgr.mr_n61704544)
print v(xbgr.mr_n61706688)
print v(xbgr.mr_n61706800)
print v(xbgr.mr_n61708544)
print v(xbgr.mr_n61708816)
print v(xbgr.mr_n61709008)
print v(xbgr.mr_n61709520)
print v(xbgr.mr_n61711664)
print v(xbgr.mr_n61711776)
print v(xbgr.mr_n61713520)
print v(xbgr.mr_n61713792)
print v(xbgr.mr_n61713984)
print v(xbgr.mr_n61714496)
print v(xbgr.mr_n61716800)
print v(xbgr.mr_n61716992)
print v(xbgr.mr_n61717184)
print v(xbgr.mr_n61717376)
print v(xbgr.mr_n61717568)
print v(xbgr.mr_n61719792)
print v(xbgr.mr_n61721616)
print v(xbgr.mr_n61721728)
print v(xbgr.mr_n61723472)
print v(xbgr.mr_n61723744)
print v(xbgr.mr_n61723936)
print v(xbgr.mr_n61724448)
print v(xbgr.mr_n61726256)
print v(xbgr.mr_n61726368)
print v(xbgr.mr_n61727520)
print v(xbgr.mr_n61727632)
print v(xbgr.mr_n61728784)
print v(xbgr.mr_n61728896)
print v(xbgr.mr_n61730224)
print v(xbgr.mr_n61730864)
print v(xbgr.mr_n61731936)
print v(xbgr.mr_n61732624)
print v(xbgr.mr_n61733312)
print v(xbgr.mr_n61734000)
print v(xbgr.mr_n61734688)
print v(xbgr.mr_n61735376)
print v(xbgr.mr_n61736064)
print v(xbgr.mr_n61736752)
print v(xbgr.mr_n61737440)
print v(xbgr.mr_n61739408)
print v(xbgr.mr_n61740544)
print v(xbgr.mr_n61741488)
print v(xbgr.mr_n61742432)
print v(xbgr.mr_n61743376)
print v(xbgr.mr_n61744320)
print v(xbgr.mr_n61745264)
print v(xbgr.mr_n61746208)
print v(xbgr.mr_n61747152)
print v(xbgr.mr_n61747792)
print v(xbgr.mr_n61749056)
print v(xbgr.mr_n61753104)
print v(xbgr.mr_n61753808)
print v(xbgr.mr_n61760400)
print v(xbgr.mr_n61761280)
print v(xbgr.mr_n61761984)
print v(xbgr.mr_n61764096)
print v(xbgr.mr_n61765664)
print v(xbgr.mr_n61766704)
print v(xbgr.mr_n61766816)
print v(xbgr.mr_n61766928)
print v(xbgr.mr_n61768528)
print v(xbgr.mr_n61768640)
print v(xbgr.mr_n61772848)
print v(xbgr.mr_n61774064)
print v(xbgr.mr_n61774176)
print v(xbgr.mr_n61777920)
print v(xbgr.mr_n61779392)
print v(xbgr.mr_n61780960)
print v(xbgr.mr_n61782528)
print v(xbgr.mr_n61784096)
print v(xbgr.mr_n61790176)
print v(xbgr.mr_n61790448)
print v(xbgr.mr_n61791008)
print v(xbgr.mr_n61792336)
print v(xbgr.mr_n61793008)
print v(xbgr.mr_n61793200)
print v(xbgr.mr_n61794240)
print v(xbgr.mr_n61794352)
print v(xbgr.mr_n61796592)
print v(xbgr.mr_n61798144)
print v(xbgr.mr_n61799264)
print v(xbgr.mr_n61799952)
print v(xbgr.mr_n61802848)
print v(xbgr.mr_n61804416)
print v(xbgr.mr_n61805360)
print v(xbgr.mr_n61807680)
print v(xbgr.mr_n61812512)
print v(xbgr.mr_n61814128)
print v(xbgr.mr_n61814240)
print v(xbgr.mr_n61815392)
print v(xbgr.mr_n61815504)
print v(xbgr.mr_n61816656)
print v(xbgr.mr_n61816768)
print v(xbgr.mr_n61817920)
print v(xbgr.mr_n61818032)
print v(xbgr.mr_n61819184)
print v(xbgr.mr_n61819296)
print v(xbgr.mr_n61820448)
print v(xbgr.mr_n61820560)
print v(xbgr.mr_n61821712)
print v(xbgr.mr_n61821824)
print v(xbgr.mr_n61822912)
print v(xbgr.mr_n61823024)
print v(xbgr.mr_n61824240)
print v(xbgr.mr_n61824352)
print v(xbgr.mr_n61825504)
print v(xbgr.mr_n61825616)
print v(xbgr.mr_n61830224)
print v(xbgr.mr_n61830608)
print v(xbgr.mr_n61831488)
print v(xbgr.mr_n61832976)
print v(xbgr.mr_n61836672)
print v(xbgr.mr_n61843360)
print v(xbgr.mr_n61844336)
print v(xbgr.mr_n61845120)
print v(xbgr.mr_n61845232)
print v(xbgr.mr_n61845424)
print v(xbgr.mr_n61845616)
print v(xbgr.mr_n61845808)
print v(xbgr.mr_n61848224)
print v(xbgr.mr_n61854064)
print v(xbgr.mr_n61855008)
print v(xbgr.mr_n61855952)
print v(xbgr.mr_n61856896)
print v(xbgr.mr_n61857840)
print v(xbgr.mr_n61858784)
print v(xbgr.mr_n61859728)
print v(xbgr.mr_n61860672)
print v(xbgr.mr_n61861616)
print v(xbgr.mr_n61862560)
print v(xbgr.mr_n61863504)
print v(xbgr.mr_n61864448)
print v(xbgr.mr_n61865392)
print v(xbgr.mr_n61866000)
print v(xbgr.mr_n61866608)
print v(xbgr.mr_n61867088)
print v(xbgr.mr_n61867696)
print v(xbgr.mr_n61868384)
print v(xbgr.mr_n61870992)
print v(xbgr.mr_n61871936)
print v(xbgr.mr_n61872880)
print v(xbgr.mr_n61873824)
print v(xbgr.mr_n61874768)
print v(xbgr.mr_n61875712)
print v(xbgr.mr_n61876656)
print v(xbgr.mr_n61877600)
print v(xbgr.mr_n61878544)
print v(xbgr.mr_n61878976)
print v(xbgr.mr_n61881616)
print v(xbgr.mr_n61882304)
print v(xbgr.mr_n61883248)
print v(xbgr.mr_n61884192)
print v(xbgr.mr_n61884384)
print v(xbgr.mr_n61884576)
print v(xbgr.mr_n61884768)
print v(xbgr.mr_n61884960)
print v(xbgr.mr_n61885152)
print v(xbgr.mr_n61887296)
print v(xbgr.mr_n61887408)
print v(xbgr.mr_n61890496)
print v(xbgr.mr_n61890608)
print v(xbgr.mr_n61896256)
print v(xbgr.mr_n61897200)
print v(xbgr.mr_n61898144)
print v(xbgr.mr_n61899088)
print v(xbgr.mr_n61900032)
print v(xbgr.mr_n61900976)
print v(xbgr.mr_n61901920)
print v(xbgr.mr_n61902864)
print v(xbgr.mr_n61903808)
print v(xbgr.mr_n61904752)
print v(xbgr.mr_n61905632)
print v(xbgr.mr_n61907136)
print v(xbgr.mr_n61907712)
print v(xbgr.mr_n61907824)
print v(xbgr.mr_n61907936)
print v(xbgr.mr_n61908848)
print v(xbgr.mr_n61909040)
print v(xbgr.mr_n61909232)
print v(xbgr.mr_n61909424)
print v(xbgr.mr_n61909616)
print v(xbgr.mr_n61909808)
print v(xbgr.mr_n61912064)
print v(xbgr.mr_n61912576)
print v(xbgr.mr_n61918144)
print v(xbgr.mr_n61918832)
print v(xbgr.mr_n61918944)
print v(xbgr.mr_n61919056)
print v(xbgr.mr_n61919168)
print v(xbgr.mr_n61919360)
print v(xbgr.mr_n61919552)
print v(xbgr.mr_n61921360)
print v(xbgr.mr_n61921552)
print v(xbgr.mr_n61922064)
print v(xbgr.mr_n61924304)
print v(xbgr.mr_n61924496)
print v(xbgr.mr_n61924688)
print v(xbgr.mr_n61924880)
print v(xbgr.mr_n61925072)
print v(xbgr.mr_n61925472)
print v(xbgr.mr_n61927296)
print v(xbgr.mr_n61929120)
print v(xbgr.mr_n61929232)
print v(xbgr.mr_n61930976)
print v(xbgr.mr_n61931248)
print v(xbgr.mr_n61931440)
print v(xbgr.mr_n61931952)
print v(xbgr.mr_n61934096)
print v(xbgr.mr_n61934288)
print v(xbgr.mr_n61934480)
print v(xbgr.mr_n61936288)
print v(xbgr.mr_n61936480)
print v(xbgr.mr_n61936992)
print v(xbgr.mr_n61939072)
print v(xbgr.mr_n61939184)
print v(xbgr.mr_n61940928)
print v(xbgr.mr_n61941200)
print v(xbgr.mr_n61941392)
print v(xbgr.mr_n61941904)
print v(xbgr.mr_n61944160)
print v(xbgr.mr_n61946176)
print v(xbgr.mr_n61946368)
print v(xbgr.mr_n61946880)
print v(xbgr.mr_n61949024)
print v(xbgr.mr_n61949136)
print v(xbgr.mr_n61949424)
print v(xbgr.mr_n61950880)
print v(xbgr.mr_n61951152)
print v(xbgr.mr_n61951344)
print v(xbgr.mr_n61951856)
print v(xbgr.mr_n61951968)
print v(xbgr.mr_n61953584)
print v(xbgr.mr_n61957664)
print v(xbgr.mr_n61959488)
print v(xbgr.mr_n61961248)
print v(xbgr.mr_n61961904)
print v(xbgr.mr_n61962576)
print v(xbgr.mr_n61962768)
print v(xbgr.mr_n61963808)
print v(xbgr.mr_n61963920)
print v(xbgr.mr_n61970320)
print v(xbgr.mr_n61971008)
print v(xbgr.mr_n61971696)
print v(xbgr.mr_n61972384)
print v(xbgr.mr_n61973072)
print v(xbgr.mr_n61973760)
print v(xbgr.mr_n61974448)
print v(xbgr.mr_n61975136)
print v(xbgr.mr_n61975824)
print v(xbgr.mr_n61976512)
print v(xbgr.mr_n61977200)
print v(xbgr.mr_n61977888)
print v(xbgr.mr_n61978208)
print v(xbgr.mr_n61983760)
print v(xbgr.mr_n61985168)
print v(xbgr.mr_n61986384)
print v(xbgr.mr_n61989008)
print v(xbgr.mr_n61990864)
print v(xbgr.mr_n61990976)
print v(xbgr.mr_n61993120)
print v(xbgr.mr_n61993232)
print v(xbgr.mr_n61994384)
print v(xbgr.mr_n61994496)
print v(xbgr.mr_n61995648)
print v(xbgr.mr_n61995760)
print v(xbgr.mr_n61996912)
print v(xbgr.mr_n61997024)
print v(xbgr.mr_n61998176)
print v(xbgr.mr_n61998288)
print v(xbgr.mr_n61999440)
print v(xbgr.mr_n61999552)
print v(xbgr.mr_n62000704)
print v(xbgr.mr_n62000816)
print v(xbgr.mr_n62001088)
print v(xbgr.mr_n62001200)
print v(xbgr.mr_n62001392)
print v(xbgr.mr_n62002064)
print v(xbgr.mr_n62002176)
print v(xbgr.mr_n62003408)
print v(xbgr.mr_n62003520)
print v(xbgr.mr_n62004352)
print v(xbgr.mr_n62004464)
print v(xbgr.mr_n62007248)
print v(xbgr.mr_n62007360)
print v(xbgr.mr_n62008512)
print v(xbgr.mr_n62008624)
print v(xbgr.mr_n62009776)
print v(xbgr.mr_n62009888)
print v(xbgr.mr_n62011312)
print v(xbgr.mr_n62013632)
print v(xbgr.mr_n62014752)
print v(xbgr.mr_n62016224)
print v(xbgr.mr_n62017792)
print v(xbgr.mr_n62019360)
print v(xbgr.mr_n62020928)
print v(xbgr.mr_n62022496)
print v(xbgr.mr_n62024064)
print v(xbgr.mr_n62025632)
print v(xbgr.mr_n62027200)
print v(xbgr.mr_n62028768)
print v(xbgr.mr_n62030336)
print v(xbgr.mr_n62031568)
print v(xbgr.mr_n62032528)
print v(xbgr.mr_n62034096)
print v(xbgr.mr_n62035664)
print v(xbgr.mr_n62038976)
print v(xbgr.mr_n62042688)
print v(xbgr.mr_n62042944)
print v(xbgr.mr_n62044944)
print v(xbgr.mr_n62047136)
print v(xbgr.mr_n62048208)
print v(xbgr.mr_n62048400)
print v(xbgr.mr_n62048592)
print v(xbgr.mr_n62048784)
print v(xbgr.mr_n62049488)
print v(xbgr.mr_n62051104)
print v(xbgr.mr_n62051376)
print v(xbgr.mr_n62051568)
print v(xbgr.mr_n62052080)
print v(xbgr.mr_n62056672)
print v(xbgr.mr_n62056944)
print v(xbgr.mr_n62057136)
print v(xbgr.mr_n62057648)
print v(xbgr.mr_n62060384)
print v(xbgr.mr_n62060656)
print v(xbgr.mr_n62060848)
print v(xbgr.mr_n62061360)
print v(xbgr.mr_n62063504)
print v(xbgr.mr_n62063696)
print v(xbgr.mr_n62063888)
print v(xbgr.mr_n62065696)
print v(xbgr.mr_n62065888)
print v(xbgr.mr_n62066400)
print v(xbgr.mr_n62067568)
print v(xbgr.mr_n62068080)
print v(xbgr.mr_n62075872)
print v(xbgr.mr_n62076144)
print v(xbgr.mr_n62076336)
print v(xbgr.mr_n62076848)
print v(xbgr.mr_n62078128)
print v(xbgr.mr_n62078720)
print v(xbgr.mr_n62080400)
print v(xbgr.mr_n62080912)
print v(xbgr.mr_n62082976)
print v(xbgr.mr_n62083488)
print v(xbgr.mr_n62085472)
print v(xbgr.mr_n62086064)
print v(xbgr.mr_n62088192)
print v(xbgr.mr_n62088704)
print v(xbgr.mr_n62090704)
print v(xbgr.mr_n62091216)
print v(xbgr.mr_n62093280)
print v(xbgr.mr_n62093792)
print v(xbgr.mr_n62095856)
print v(xbgr.mr_n62096368)
print v(xbgr.mr_n62098432)
print v(xbgr.mr_n62098944)
print v(xbgr.mr_n62101072)
print v(xbgr.mr_n62101584)
print v(xbgr.mr_n62103584)
print v(xbgr.mr_n62104096)
print v(xbgr.mr_n62112432)
print v(xbgr.mr_n62112544)
print v(xbgr.mr_n62113696)
print v(xbgr.mr_n62113808)
print v(xbgr.mr_n62114960)
print v(xbgr.mr_n62115072)
print v(xbgr.mr_n62116224)
print v(xbgr.mr_n62116336)
print v(xbgr.mr_n62117488)
print v(xbgr.mr_n62117600)
print v(xbgr.mr_n62118752)
print v(xbgr.mr_n62118864)
print v(xbgr.mr_n62120016)
print v(xbgr.mr_n62120128)
print v(xbgr.mr_n62121280)
print v(xbgr.mr_n62121392)
print v(xbgr.mr_n62122544)
print v(xbgr.mr_n62122656)
print v(xbgr.mr_n62123744)
print v(xbgr.mr_n62123856)
print v(xbgr.mr_n62125072)
print v(xbgr.mr_n62125184)
print v(xbgr.mr_n62126336)
print v(xbgr.mr_n62126448)
print v(xbgr.mr_n62127600)
print v(xbgr.mr_n62127712)
print v(xbgr.mr_n62128864)
print v(xbgr.mr_n62128976)
print v(xbgr.mr_n62130320)
print v(xbgr.mr_n62130960)
print v(xbgr.mr_n62138784)
print v(xbgr.mr_n62140608)
print v(xbgr.mr_n62140960)
print v(xbgr.mr_n62142464)
print v(xbgr.mr_n62142928)
print v(xbgr.mr_n62144384)
print v(xbgr.mr_n62145072)
print v(xbgr.mr_n62145824)
print v(xbgr.mr_n62147632)
print v(xbgr.mr_n62148576)
print v(xbgr.mr_n62149520)
print v(xbgr.mr_n62150464)
print v(xbgr.mr_n62151408)
print v(xbgr.mr_n62152352)
print v(xbgr.mr_n62153296)
print v(xbgr.mr_n62154240)
print v(xbgr.mr_n62155184)
print v(xbgr.mr_n62156128)
print v(xbgr.mr_n62157072)
print v(xbgr.mr_n62158016)
print v(xbgr.mr_n62158960)
print v(xbgr.mr_n62159904)
print v(xbgr.mr_n62160848)
print v(xbgr.mr_n62161792)
print v(xbgr.mr_n62168112)
print v(xbgr.mr_n62169680)
print v(xbgr.mr_n62173024)
print v(xbgr.mr_n62174256)
print v(xbgr.mr_n62174368)
print v(xbgr.mr_n62175312)
print v(xbgr.mr_n62176464)
print v(xbgr.mr_n62176576)
print v(xbgr.mr_n62178352)
print v(xbgr.mr_n62178464)
print v(xbgr.mr_n62179408)
print v(xbgr.mr_n62180560)
print v(xbgr.mr_n62180672)
print v(xbgr.mr_n62182448)
print v(xbgr.mr_n62182560)
print v(xbgr.mr_n62183504)
print v(xbgr.mr_n62184656)
print v(xbgr.mr_n62184768)
print v(xbgr.mr_n62186016)
print v(xbgr.mr_n62186544)
print v(xbgr.mr_n62186656)
print v(xbgr.mr_n62187600)
print v(xbgr.mr_n62188752)
print v(xbgr.mr_n62188864)
print v(xbgr.mr_n62190640)
print v(xbgr.mr_n62190752)
print v(xbgr.mr_n62191696)
print v(xbgr.mr_n62192848)
print v(xbgr.mr_n62192960)
print v(xbgr.mr_n62194736)
print v(xbgr.mr_n62194848)
print v(xbgr.mr_n62195792)
print v(xbgr.mr_n62196944)
print v(xbgr.mr_n62197056)
print v(xbgr.mr_n62198224)
print v(xbgr.mr_n62198832)
print v(xbgr.mr_n62198944)
print v(xbgr.mr_n62199888)
print v(xbgr.mr_n62201040)
print v(xbgr.mr_n62201152)
print v(xbgr.mr_n62202400)
print v(xbgr.mr_n62202928)
print v(xbgr.mr_n62203040)
print v(xbgr.mr_n62203984)
print v(xbgr.mr_n62205136)
print v(xbgr.mr_n62205248)
print v(xbgr.mr_n62207024)
print v(xbgr.mr_n62207136)
print v(xbgr.mr_n62208448)
print v(xbgr.mr_n62209568)
print v(xbgr.mr_n62210784)
print v(xbgr.mr_n62211664)
print v(xbgr.mr_n62213232)
print v(xbgr.mr_n62214800)
print v(xbgr.mr_n62216368)
print v(xbgr.mr_n62217936)
print v(xbgr.mr_n62219504)
print v(xbgr.mr_n62221072)
print v(xbgr.mr_n62235008)
print v(xbgr.mr_n62236672)
print v(xbgr.mr_n62239936)
print v(xbgr.mr_n62241200)
print v(xbgr.mr_n62241392)
print v(xbgr.mr_n62241584)
print v(xbgr.mr_n62241776)
print v(xbgr.mr_n62244096)
print v(xbgr.mr_n62244288)
print v(xbgr.mr_n62244480)
print v(xbgr.mr_n62245072)
print v(xbgr.mr_n62245760)
print v(xbgr.mr_n62247040)
print v(xbgr.mr_n62247360)
print v(xbgr.mr_n62248192)
print v(xbgr.mr_n62250752)
print v(xbgr.mr_n62251024)
print v(xbgr.mr_n62251216)
print v(xbgr.mr_n62251728)
print v(xbgr.mr_n62254464)
print v(xbgr.mr_n62254736)
print v(xbgr.mr_n62254928)
print v(xbgr.mr_n62255440)
print v(xbgr.mr_n62257584)
print v(xbgr.mr_n62257696)
print v(xbgr.mr_n62259440)
print v(xbgr.mr_n62259712)
print v(xbgr.mr_n62259904)
print v(xbgr.mr_n62260416)
print v(xbgr.mr_n62261648)
print v(xbgr.mr_n62262160)
print v(xbgr.mr_n62262720)
print v(xbgr.mr_n62265600)
print v(xbgr.mr_n62265872)
print v(xbgr.mr_n62266064)
print v(xbgr.mr_n62266576)
print v(xbgr.mr_n62269168)
print v(xbgr.mr_n62270576)
print v(xbgr.mr_n62270848)
print v(xbgr.mr_n62271040)
print v(xbgr.mr_n62271712)
print v(xbgr.mr_n62272048)
print v(xbgr.mr_n62277936)
print v(xbgr.mr_n62278624)
print v(xbgr.mr_n62278736)
print v(xbgr.mr_n62278848)
print v(xbgr.mr_n62278960)
print v(xbgr.mr_n62279072)
print v(xbgr.mr_n62280816)
print v(xbgr.mr_n62281088)
print v(xbgr.mr_n62281280)
print v(xbgr.mr_n62281792)
print v(xbgr.mr_n62282160)
print v(xbgr.mr_n62283024)
print v(xbgr.mr_n62283536)
print v(xbgr.mr_n62286976)
print v(xbgr.mr_n62287248)
print v(xbgr.mr_n62287440)
print v(xbgr.mr_n62287952)
print v(xbgr.mr_n62290096)
print v(xbgr.mr_n62290208)
print v(xbgr.mr_n62291952)
print v(xbgr.mr_n62292224)
print v(xbgr.mr_n62292416)
print v(xbgr.mr_n62292928)
print v(xbgr.mr_n62294160)
print v(xbgr.mr_n62294672)
print v(xbgr.mr_n62298112)
print v(xbgr.mr_n62298384)
print v(xbgr.mr_n62298576)
print v(xbgr.mr_n62299088)
print v(xbgr.mr_n62301232)
print v(xbgr.mr_n62301344)
print v(xbgr.mr_n62303088)
print v(xbgr.mr_n62303360)
print v(xbgr.mr_n62303552)
print v(xbgr.mr_n62304064)
print v(xbgr.mr_n62305360)
print v(xbgr.mr_n62305872)
print v(xbgr.mr_n62312864)
print v(xbgr.mr_n62312976)
print v(xbgr.mr_n62313808)
print v(xbgr.mr_n62313920)
print v(xbgr.mr_n62314752)
print v(xbgr.mr_n62314864)
print v(xbgr.mr_n62315952)
print v(xbgr.mr_n62316064)
print v(xbgr.mr_n62317216)
print v(xbgr.mr_n62317328)
print v(xbgr.mr_n62318480)
print v(xbgr.mr_n62318592)
print v(xbgr.mr_n62319744)
print v(xbgr.mr_n62319856)
print v(xbgr.mr_n62321008)
print v(xbgr.mr_n62321120)
print v(xbgr.mr_n62322272)
print v(xbgr.mr_n62322384)
print v(xbgr.mr_n62323536)
print v(xbgr.mr_n62323648)
print v(xbgr.mr_n62324800)
print v(xbgr.mr_n62324912)
print v(xbgr.mr_n62326064)
print v(xbgr.mr_n62326176)
print v(xbgr.mr_n62327328)
print v(xbgr.mr_n62327440)
print v(xbgr.mr_n62328592)
print v(xbgr.mr_n62328704)
print v(xbgr.mr_n62329856)
print v(xbgr.mr_n62329968)
print v(xbgr.mr_n62330416)
print v(xbgr.mr_n62330848)
print v(xbgr.mr_n62333936)
print v(xbgr.mr_n62336480)
print v(xbgr.mr_n62337168)
print v(xbgr.mr_n62337856)
print v(xbgr.mr_n62338576)
print v(xbgr.mr_n62339520)
print v(xbgr.mr_n62340464)
print v(xbgr.mr_n62341408)
print v(xbgr.mr_n62342352)
print v(xbgr.mr_n62343296)
print v(xbgr.mr_n62344240)
print v(xbgr.mr_n62345184)
print v(xbgr.mr_n62346128)
print v(xbgr.mr_n62347072)
print v(xbgr.mr_n62348016)
print v(xbgr.mr_n62348960)
print v(xbgr.mr_n62349904)
print v(xbgr.mr_n62350848)
print v(xbgr.mr_n62351792)
print v(xbgr.mr_n62352736)
print v(xbgr.mr_n62354256)
print v(xbgr.mr_n62355152)
print v(xbgr.mr_n62359760)
print v(xbgr.mr_n62368272)
print v(xbgr.mr_n62369840)
print v(xbgr.mr_n62372320)
print v(xbgr.mr_n62373456)
print v(xbgr.mr_n62373568)
print v(xbgr.mr_n62374512)
print v(xbgr.mr_n62375664)
print v(xbgr.mr_n62375776)
print v(xbgr.mr_n62377552)
print v(xbgr.mr_n62377664)
print v(xbgr.mr_n62378608)
print v(xbgr.mr_n62379760)
print v(xbgr.mr_n62379872)
print v(xbgr.mr_n62381040)
print v(xbgr.mr_n62381648)
print v(xbgr.mr_n62381760)
print v(xbgr.mr_n62382704)
print v(xbgr.mr_n62383856)
print v(xbgr.mr_n62383968)
print v(xbgr.mr_n62385744)
print v(xbgr.mr_n62385856)
print v(xbgr.mr_n62386800)
print v(xbgr.mr_n62387952)
print v(xbgr.mr_n62388064)
print v(xbgr.mr_n62389840)
print v(xbgr.mr_n62389952)
print v(xbgr.mr_n62390896)
print v(xbgr.mr_n62392048)
print v(xbgr.mr_n62392160)
print v(xbgr.mr_n62393328)
print v(xbgr.mr_n62393936)
print v(xbgr.mr_n62394048)
print v(xbgr.mr_n62394992)
print v(xbgr.mr_n62396144)
print v(xbgr.mr_n62396256)
print v(xbgr.mr_n62398032)
print v(xbgr.mr_n62398144)
print v(xbgr.mr_n62399088)
print v(xbgr.mr_n62400240)
print v(xbgr.mr_n62400352)
print v(xbgr.mr_n62401600)
print v(xbgr.mr_n62402128)
print v(xbgr.mr_n62402240)
print v(xbgr.mr_n62403184)
print v(xbgr.mr_n62404336)
print v(xbgr.mr_n62404448)
print v(xbgr.mr_n62405616)
print v(xbgr.mr_n62406224)
print v(xbgr.mr_n62406336)
print v(xbgr.mr_n62406736)
print v(xbgr.mr_n62407136)
print v(xbgr.mr_n62408656)
print v(xbgr.mr_n62411504)
print v(xbgr.mr_n62413072)
print v(xbgr.mr_n62414640)
print v(xbgr.mr_n62418032)
print v(xbgr.mr_n62426720)
print v(xbgr.mr_n62426912)
print v(xbgr.mr_n62433664)
print v(xbgr.mr_n62435552)
print v(xbgr.mr_n62439968)
print v(xbgr.mr_n62442912)
print v(xbgr.mr_n62443104)
print v(xbgr.mr_n62443936)
print v(xbgr.mr_n62444512)
print v(xbgr.mr_n62445200)
print v(xbgr.mr_n62445632)
print v(xbgr.mr_n62446464)
print v(xbgr.mr_n62447040)
print v(xbgr.mr_n62447728)
print v(xbgr.mr_n62448304)
print v(xbgr.mr_n62448992)
print v(xbgr.mr_n62449696)
print v(xbgr.mr_n62450256)
print v(xbgr.mr_n62450688)
print v(xbgr.mr_n62451520)
print v(xbgr.mr_n62451952)
print v(xbgr.mr_n62452784)
print v(xbgr.mr_n62453360)
print v(xbgr.mr_n62454048)
print v(xbgr.mr_n62454480)
print v(xbgr.mr_n62455312)
print v(xbgr.mr_n62455888)
print v(xbgr.mr_n62456576)
print v(xbgr.mr_n62457280)
print v(xbgr.mr_n62457840)
print v(xbgr.mr_n62458272)
print v(xbgr.mr_n62459104)
print v(xbgr.mr_n62459680)
print v(xbgr.mr_n62460368)
print v(xbgr.mr_n62460944)
print v(xbgr.mr_n62461632)
print v(xbgr.mr_n62462064)
print v(xbgr.mr_n62462896)
print v(xbgr.mr_n62463328)
print v(xbgr.mr_n62464160)
print v(xbgr.mr_n62467792)
print v(xbgr.mr_n62467984)
print v(xbgr.mr_n62468176)
print v(xbgr.mr_n62468368)
print v(xbgr.mr_n62468560)
print v(xbgr.mr_n62468816)
print v(xbgr.mr_n62469072)
print v(xbgr.mr_n62469328)
print v(xbgr.mr_n62471616)
print v(xbgr.mr_n62472528)
print v(xbgr.mr_n62473040)
print v(xbgr.mr_n62474592)
print v(xbgr.mr_n62475104)
print v(xbgr.mr_n62477040)
print v(xbgr.mr_n62477552)
print v(xbgr.mr_n62479488)
print v(xbgr.mr_n62480000)
print v(xbgr.mr_n62481936)
print v(xbgr.mr_n62482448)
print v(xbgr.mr_n62484384)
print v(xbgr.mr_n62484896)
print v(xbgr.mr_n62486832)
print v(xbgr.mr_n62487344)
print v(xbgr.mr_n62489280)
print v(xbgr.mr_n62489792)
print v(xbgr.mr_n62491728)
print v(xbgr.mr_n62492240)
print v(xbgr.mr_n62494240)
print v(xbgr.mr_n62494752)
print v(xbgr.mr_n62496624)
print v(xbgr.mr_n62497136)
print v(xbgr.mr_n62499072)
print v(xbgr.mr_n62499584)
print v(xbgr.mr_n62501440)
print v(xbgr.mr_n62502032)
print v(xbgr.mr_n62503968)
print v(xbgr.mr_n62504480)
print v(xbgr.mr_n62506416)
print v(xbgr.mr_n62506928)
print v(xbgr.mr_n62508864)
print v(xbgr.mr_n62509376)
print v(xbgr.mr_n62517232)
print v(xbgr.mr_n62518448)
print v(xbgr.mr_n62518560)
print v(xbgr.mr_n62519648)
print v(xbgr.mr_n62519760)
print v(xbgr.mr_n62520976)
print v(xbgr.mr_n62521088)
print v(xbgr.mr_n62522240)
print v(xbgr.mr_n62522352)
print v(xbgr.mr_n62523504)
print v(xbgr.mr_n62523616)
print v(xbgr.mr_n62524768)
print v(xbgr.mr_n62524880)
print v(xbgr.mr_n62526032)
print v(xbgr.mr_n62526144)
print v(xbgr.mr_n62527296)
print v(xbgr.mr_n62527408)
print v(xbgr.mr_n62528560)
print v(xbgr.mr_n62528672)
print v(xbgr.mr_n62529824)
print v(xbgr.mr_n62529936)
print v(xbgr.mr_n62531088)
print v(xbgr.mr_n62531200)
print v(xbgr.mr_n62532288)
print v(xbgr.mr_n62532400)
print v(xbgr.mr_n62533616)
print v(xbgr.mr_n62533728)
print v(xbgr.mr_n62534816)
print v(xbgr.mr_n62534928)
print v(xbgr.mr_n62536144)
print v(xbgr.mr_n62536256)
print v(xbgr.mr_n62537136)
print v(xbgr.mr_n62537824)
print v(xbgr.mr_n62538512)
print v(xbgr.mr_n62539232)
print v(xbgr.mr_n62540176)
print v(xbgr.mr_n62541120)
print v(xbgr.mr_n62541776)
print v(xbgr.mr_n62541888)
print v(xbgr.mr_n62542000)
print v(xbgr.mr_n62542192)
print v(xbgr.mr_n62542800)
print v(xbgr.mr_n62544320)
print v(xbgr.mr_n62544784)
print v(xbgr.mr_n62553696)
print v(xbgr.mr_n62562272)
print v(xbgr.mr_n62563520)
print v(xbgr.mr_n62563872)
print v(xbgr.mr_n62565248)
print v(xbgr.mr_n62567360)
print v(xbgr.mr_n62570464)
print v(xbgr.mr_n62572352)
print v(xbgr.mr_n62573456)
print v(xbgr.mr_n62574688)
print v(xbgr.mr_n62574800)
print v(xbgr.mr_n62575744)
print v(xbgr.mr_n62576896)
print v(xbgr.mr_n62577008)
print v(xbgr.mr_n62578784)
print v(xbgr.mr_n62578896)
print v(xbgr.mr_n62579840)
print v(xbgr.mr_n62580992)
print v(xbgr.mr_n62581104)
print v(xbgr.mr_n62582272)
print v(xbgr.mr_n62582880)
print v(xbgr.mr_n62582992)
print v(xbgr.mr_n62583936)
print v(xbgr.mr_n62585088)
print v(xbgr.mr_n62585200)
print v(xbgr.mr_n62586448)
print v(xbgr.mr_n62586976)
print v(xbgr.mr_n62587088)
print v(xbgr.mr_n62588032)
print v(xbgr.mr_n62589120)
print v(xbgr.mr_n62589232)
print v(xbgr.mr_n62591072)
print v(xbgr.mr_n62591184)
print v(xbgr.mr_n62592128)
print v(xbgr.mr_n62593280)
print v(xbgr.mr_n62593392)
print v(xbgr.mr_n62595168)
print v(xbgr.mr_n62595280)
print v(xbgr.mr_n62596224)
print v(xbgr.mr_n62597376)
print v(xbgr.mr_n62597488)
print v(xbgr.mr_n62598736)
print v(xbgr.mr_n62599264)
print v(xbgr.mr_n62599376)
print v(xbgr.mr_n62600320)
print v(xbgr.mr_n62601472)
print v(xbgr.mr_n62601584)
print v(xbgr.mr_n62603360)
print v(xbgr.mr_n62603472)
print v(xbgr.mr_n62604416)
print v(xbgr.mr_n62605568)
print v(xbgr.mr_n62605680)
print v(xbgr.mr_n62606928)
print v(xbgr.mr_n62607456)
print v(xbgr.mr_n62607568)
print v(xbgr.mr_n62608880)
print v(xbgr.mr_n62610000)
print v(xbgr.mr_n62612096)
print v(xbgr.mr_n62613664)
print v(xbgr.mr_n62615232)
print v(xbgr.mr_n62616800)
print v(xbgr.mr_n62618368)
print v(xbgr.mr_n62619936)
print v(xbgr.mr_n62621504)
print v(xbgr.mr_n62625152)
print v(xbgr.mr_n62625968)
print v(xbgr.mr_n62629520)
print v(xbgr.mr_n62631360)
print v(xbgr.mr_n62639248)
print v(xbgr.mr_n62641104)
print v(xbgr.mr_n62641216)
print v(xbgr.mr_n62642160)
print v(xbgr.mr_n62642352)
print v(xbgr.mr_n62642544)
print v(xbgr.mr_n62642736)
print v(xbgr.mr_n62644992)
print v(xbgr.mr_n62645264)
print v(xbgr.mr_n62645456)
print v(xbgr.mr_n62645968)
print v(xbgr.mr_n62650096)
print v(xbgr.mr_n62650208)
print v(xbgr.mr_n62651952)
print v(xbgr.mr_n62652224)
print v(xbgr.mr_n62652416)
print v(xbgr.mr_n62652928)
print v(xbgr.mr_n62655072)
print v(xbgr.mr_n62655264)
print v(xbgr.mr_n62655456)
print v(xbgr.mr_n62657264)
print v(xbgr.mr_n62657456)
print v(xbgr.mr_n62657968)
print v(xbgr.mr_n62660048)
print v(xbgr.mr_n62660160)
print v(xbgr.mr_n62661904)
print v(xbgr.mr_n62662176)
print v(xbgr.mr_n62662368)
print v(xbgr.mr_n62662880)
print v(xbgr.mr_n62665024)
print v(xbgr.mr_n62665136)
print v(xbgr.mr_n62666880)
print v(xbgr.mr_n62667152)
print v(xbgr.mr_n62667344)
print v(xbgr.mr_n62667856)
print v(xbgr.mr_n62670000)
print v(xbgr.mr_n62670112)
print v(xbgr.mr_n62671856)
print v(xbgr.mr_n62672128)
print v(xbgr.mr_n62672320)
print v(xbgr.mr_n62672832)
print v(xbgr.mr_n62674976)
print v(xbgr.mr_n62675088)
print v(xbgr.mr_n62676832)
print v(xbgr.mr_n62677216)
print v(xbgr.mr_n62678544)
print v(xbgr.mr_n62680672)
print v(xbgr.mr_n62680784)
print v(xbgr.mr_n62680896)
print v(xbgr.mr_n62681008)
print v(xbgr.mr_n62682752)
print v(xbgr.mr_n62683024)
print v(xbgr.mr_n62683216)
print v(xbgr.mr_n62683728)
print v(xbgr.mr_n62687504)
print v(xbgr.mr_n62687616)
print v(xbgr.mr_n62689360)
print v(xbgr.mr_n62689632)
print v(xbgr.mr_n62689824)
print v(xbgr.mr_n62690336)
print v(xbgr.mr_n62692480)
print v(xbgr.mr_n62692592)
print v(xbgr.mr_n62694336)
print v(xbgr.mr_n62694608)
print v(xbgr.mr_n62694800)
print v(xbgr.mr_n62695312)
print v(xbgr.mr_n62697456)
print v(xbgr.mr_n62697568)
print v(xbgr.mr_n62699312)
print v(xbgr.mr_n62699504)
print v(xbgr.mr_n62699696)
print v(xbgr.mr_n62700288)
print v(xbgr.mr_n62702432)
print v(xbgr.mr_n62702544)
print v(xbgr.mr_n62704288)
print v(xbgr.mr_n62704560)
print v(xbgr.mr_n62704752)
print v(xbgr.mr_n62705264)
print v(xbgr.mr_n62707408)
print v(xbgr.mr_n62707520)
print v(xbgr.mr_n62709264)
print v(xbgr.mr_n62709536)
print v(xbgr.mr_n62709728)
print v(xbgr.mr_n62710240)
print v(xbgr.mr_n62712384)
print v(xbgr.mr_n62712496)
print v(xbgr.mr_n62714240)
print v(xbgr.mr_n62714512)
print v(xbgr.mr_n62714704)
print v(xbgr.mr_n62715216)
print v(xbgr.mr_n62717360)
print v(xbgr.mr_n62717472)
print v(xbgr.mr_n62719216)
print v(xbgr.mr_n62719488)
print v(xbgr.mr_n62719680)
print v(xbgr.mr_n62720192)
print v(xbgr.mr_n62722336)
print v(xbgr.mr_n62722448)
print v(xbgr.mr_n62724192)
print v(xbgr.mr_n62724464)
print v(xbgr.mr_n62724656)
print v(xbgr.mr_n62725168)
print v(xbgr.mr_n62735008)
print v(xbgr.mr_n62736832)
print v(xbgr.mr_n62737168)
print v(xbgr.mr_n62748448)
print v(xbgr.mr_n62756960)
print v(xbgr.mr_n62757216)
print v(xbgr.mr_n62758688)
print v(xbgr.mr_n62763232)
print v(xbgr.mr_n62763344)
print v(xbgr.mr_n62764496)
print v(xbgr.mr_n62764608)
print v(xbgr.mr_n62765760)
print v(xbgr.mr_n62765872)
print v(xbgr.mr_n62767024)
print v(xbgr.mr_n62767136)
print v(xbgr.mr_n62768288)
print v(xbgr.mr_n62768400)
print v(xbgr.mr_n62769552)
print v(xbgr.mr_n62769664)
print v(xbgr.mr_n62770752)
print v(xbgr.mr_n62770864)
print v(xbgr.mr_n62772080)
print v(xbgr.mr_n62772192)
print v(xbgr.mr_n62773344)
print v(xbgr.mr_n62773456)
print v(xbgr.mr_n62774608)
print v(xbgr.mr_n62774720)
print v(xbgr.mr_n62775872)
print v(xbgr.mr_n62775984)
print v(xbgr.mr_n62777136)
print v(xbgr.mr_n62777248)
print v(xbgr.mr_n62778400)
print v(xbgr.mr_n62778512)
print v(xbgr.mr_n62779664)
print v(xbgr.mr_n62779776)
print v(xbgr.mr_n62780928)
print v(xbgr.mr_n62781040)
print v(xbgr.mr_n62781568)
print v(xbgr.mr_n62782640)
print v(xbgr.mr_n62786208)
print v(xbgr.mr_n62786992)
print v(xbgr.mr_n62787808)
print v(xbgr.mr_n62788640)
print v(xbgr.mr_n62791200)
print v(xbgr.mr_n62791888)
print v(xbgr.mr_n62792576)
print v(xbgr.mr_n62793296)
print v(xbgr.mr_n62794240)
print v(xbgr.mr_n62795184)
print v(xbgr.mr_n62796128)
print v(xbgr.mr_n62797072)
print v(xbgr.mr_n62798016)
print v(xbgr.mr_n62798960)
print v(xbgr.mr_n62799904)
print v(xbgr.mr_n62800848)
print v(xbgr.mr_n62801792)
print v(xbgr.mr_n62802736)
print v(xbgr.mr_n62803680)
print v(xbgr.mr_n62804624)
print v(xbgr.mr_n62805568)
print v(xbgr.mr_n62806512)
print v(xbgr.mr_n62807456)
print v(xbgr.mr_n62808400)
print v(xbgr.mr_n62809344)
print v(xbgr.mr_n62810288)
print v(xbgr.mr_n62811232)
print v(xbgr.mr_n62812336)
print v(xbgr.mr_n62815856)
print v(xbgr.mr_n62823536)
print v(xbgr.mr_n62824416)
print v(xbgr.mr_n62824720)
print v(xbgr.mr_n62824832)
print v(xbgr.mr_n62825232)
print v(xbgr.mr_n62828576)
print v(xbgr.mr_n62829408)
print v(xbgr.mr_n62830656)
print v(xbgr.mr_n62831248)
print v(xbgr.mr_n62831888)
print v(xbgr.mr_n62833536)
print v(xbgr.mr_n62834064)
print v(xbgr.mr_n62835232)
print v(xbgr.mr_n62835936)
print v(xbgr.mr_n62836176)
print v(xbgr.mr_n62836528)
print v(xbgr.mr_n62838928)
print v(xbgr.mr_n62839104)
print v(xbgr.mr_n62840048)
print v(xbgr.mr_n62841280)
print v(xbgr.mr_n62841808)
print v(xbgr.mr_n62842976)
print v(xbgr.mr_n62845088)
print v(xbgr.mr_n62845440)
print v(xbgr.mr_n62846208)
print v(xbgr.mr_n62846384)
print v(xbgr.mr_n62846672)
print v(xbgr.mr_n62846848)
print v(xbgr.mr_n62847616)
print v(xbgr.mr_n62847904)
print v(xbgr.mr_n62848256)
print v(xbgr.mr_n62849376)
print v(xbgr.mr_n62850608)
print v(xbgr.mr_n62851312)
print v(xbgr.mr_n62851424)
print v(xbgr.mr_n62851776)
print v(xbgr.mr_n62851952)
print v(xbgr.mr_n62852128)
print v(xbgr.mr_n62852304)
print v(xbgr.mr_n62852480)
print v(xbgr.mr_n62852656)
print v(xbgr.mr_n62852832)
print v(xbgr.mr_n62853424)
print v(xbgr.mr_n62854608)
print v(xbgr.mr_n62855648)
print v(xbgr.mr_n62856320)
print v(xbgr.mr_n62857376)
print v(xbgr.mr_n62857872)
print v(xbgr.mr_n62858880)
print v(xbgr.mr_n62859232)
print v(xbgr.mr_n62859840)
print v(xbgr.mr_n62860784)
print v(xbgr.mr_n62861728)
print v(xbgr.mr_n62862672)
print v(xbgr.mr_n62863616)
print v(xbgr.mr_n62864560)
print v(xbgr.mr_n62865504)
print v(xbgr.mr_n62866448)
print v(xbgr.mr_n62867392)
print v(xbgr.mr_n62868336)
print v(xbgr.mr_n62869280)
print v(xbgr.mr_n62870224)
print v(xbgr.mr_n62871168)
print v(xbgr.mr_n62872112)
print v(xbgr.mr_n62873056)
print v(xbgr.mr_n62874000)
print v(xbgr.mr_n62874944)
print v(xbgr.mr_n62875888)
print v(xbgr.mr_n62876832)
print v(xbgr.mr_n62877776)
print v(xbgr.mr_n62878720)
print v(xbgr.mr_n62879664)
print v(xbgr.mr_n62880608)
print v(xbgr.mr_n62881552)
print v(xbgr.mr_n62882496)
print v(xbgr.mr_n62883440)
print v(xbgr.mr_n62884384)
print v(xbgr.mr_n62885328)
print v(xbgr.mr_n62886272)
print v(xbgr.mr_n62887216)
print v(xbgr.mr_n62888160)
print v(xbgr.mr_n62889104)
print v(xbgr.mr_n62890048)
print v(xbgr.mr_n62890992)
print v(xbgr.mr_n62891936)
print v(xbgr.mr_n62892880)
print v(xbgr.mr_n62893824)
print v(xbgr.mr_n62894768)
print v(xbgr.mr_n62895712)
print v(xbgr.mr_n62896656)
print v(xbgr.mr_n62897600)
print v(xbgr.mr_n62898544)
print v(xbgr.mr_n62899488)
print v(xbgr.mr_n62900432)
print v(xbgr.mr_n62901376)
print v(xbgr.mr_n62902320)
print v(xbgr.mr_n62903264)
print v(xbgr.mr_n62904208)
print v(xbgr.mr_n62905152)
print v(xbgr.mr_n62906096)
print v(xbgr.mr_n62907040)
print v(xbgr.mr_n62907984)
print v(xbgr.mr_n62908928)
print v(xbgr.mr_n62909872)
print v(xbgr.mr_n62910816)
print v(xbgr.mr_n62911760)
print v(xbgr.mr_n62912704)
print v(xbgr.mr_n62913648)
print v(xbgr.mr_n62914592)
print v(xbgr.mr_n62915536)
print v(xbgr.mr_n62916480)
print v(xbgr.mr_n62917424)
print v(xbgr.mr_n62918368)
print v(xbgr.mr_n62919312)
print v(xbgr.mr_n62920256)
print v(xbgr.mr_n62921200)
print v(xbgr.mr_n62922144)
print v(xbgr.mr_n62923088)
print v(xbgr.mr_n62924032)
print v(xbgr.mr_n62924976)
print v(xbgr.mr_n62925920)
print v(xbgr.mr_n62926864)
print v(xbgr.mr_n62927808)
print v(xbgr.mr_n62928752)
print v(xbgr.mr_n62929696)
print v(xbgr.mr_n62930640)
print v(xbgr.mr_n62931584)
print v(xbgr.mr_n62932528)
print v(xbgr.mr_n62933472)
print v(xbgr.mr_n62934416)
print v(xbgr.mr_n62935360)
print v(xbgr.mr_n62936304)
print v(xbgr.mr_n62937248)
print v(xbgr.mr_n62938192)
print v(xbgr.mr_n62939136)
print v(xbgr.mr_n62940080)
print v(xbgr.mr_n62941024)
print v(xbgr.mr_n62941968)
print v(xbgr.mr_n62942912)
print v(xbgr.mr_n62943856)
print v(xbgr.mr_n62944800)
print v(xbgr.mr_n62945744)
print v(xbgr.mr_n62946688)
print v(xbgr.mr_n62949232)
print v(xbgr.mr_n62949424)
print v(xbgr.mr_n62950256)
print v(xbgr.mr_n62952608)
print v(xbgr.mr_n62955984)
print v(xbgr.mr_n62956096)
print v(xbgr.mr_n62957840)
print v(xbgr.mr_n62958032)
print v(xbgr.mr_n62958224)
print v(xbgr.mr_n62958816)
print v(xbgr.mr_n62962000)
print v(xbgr.mr_n62962112)
print v(xbgr.mr_n62962224)
print v(xbgr.mr_n62962336)
print v(xbgr.mr_n62962528)
print v(xbgr.mr_n62964080)
print v(xbgr.mr_n62964352)
print v(xbgr.mr_n62964544)
print v(xbgr.mr_n62965056)
print v(xbgr.mr_n62966288)
print v(xbgr.mr_n62966800)
print v(xbgr.mr_n62969648)
print v(xbgr.mr_n62969760)
print v(xbgr.mr_n62971504)
print v(xbgr.mr_n62971776)
print v(xbgr.mr_n62971968)
print v(xbgr.mr_n62972480)
print v(xbgr.mr_n62975664)
print v(xbgr.mr_n62975776)
print v(xbgr.mr_n62975888)
print v(xbgr.mr_n62976000)
print v(xbgr.mr_n62977744)
print v(xbgr.mr_n62978016)
print v(xbgr.mr_n62978208)
print v(xbgr.mr_n62978720)
print v(xbgr.mr_n62981904)
print v(xbgr.mr_n62982016)
print v(xbgr.mr_n62982128)
print v(xbgr.mr_n62982240)
print v(xbgr.mr_n62983984)
print v(xbgr.mr_n62984176)
print v(xbgr.mr_n62984368)
print v(xbgr.mr_n62984960)
print v(xbgr.mr_n62986192)
print v(xbgr.mr_n62986704)
print v(xbgr.mr_n62989552)
print v(xbgr.mr_n62989664)
print v(xbgr.mr_n62991408)
print v(xbgr.mr_n62991680)
print v(xbgr.mr_n62991872)
print v(xbgr.mr_n62992384)
print v(xbgr.mr_n62995568)
print v(xbgr.mr_n62995680)
print v(xbgr.mr_n62995792)
print v(xbgr.mr_n62995904)
print v(xbgr.mr_n62996240)
print v(xbgr.mr_n62997648)
print v(xbgr.mr_n62997920)
print v(xbgr.mr_n62998112)
print v(xbgr.mr_n62998624)
print v(xbgr.mr_n63000640)
print v(xbgr.mr_n63001808)
print v(xbgr.mr_n63001920)
print v(xbgr.mr_n63002032)
print v(xbgr.mr_n63002144)
print v(xbgr.mr_n63003888)
print v(xbgr.mr_n63004160)
print v(xbgr.mr_n63004352)
print v(xbgr.mr_n63004864)
print v(xbgr.mr_n63006096)
print v(xbgr.mr_n63006608)
print v(xbgr.mr_n63009456)
print v(xbgr.mr_n63009568)
print v(xbgr.mr_n63011312)
print v(xbgr.mr_n63011584)
print v(xbgr.mr_n63011776)
print v(xbgr.mr_n63012288)
print v(xbgr.mr_n63015472)
print v(xbgr.mr_n63015584)
print v(xbgr.mr_n63015696)
print v(xbgr.mr_n63015808)
print v(xbgr.mr_n63017552)
print v(xbgr.mr_n63017824)
print v(xbgr.mr_n63018016)
print v(xbgr.mr_n63018528)
print v(xbgr.mr_n63021712)
print v(xbgr.mr_n63021824)
print v(xbgr.mr_n63021936)
print v(xbgr.mr_n63022128)
print v(xbgr.mr_n63022320)
print v(xbgr.mr_n63024128)
print v(xbgr.mr_n63024320)
print v(xbgr.mr_n63024832)
print v(xbgr.mr_n63026000)
print v(xbgr.mr_n63026512)
print v(xbgr.mr_n63029360)
print v(xbgr.mr_n63029472)
print v(xbgr.mr_n63031216)
print v(xbgr.mr_n63031488)
print v(xbgr.mr_n63031680)
print v(xbgr.mr_n63032192)
print v(xbgr.mr_n63034256)
print v(xbgr.mr_n63034368)
print v(xbgr.mr_n63034880)
print v(xbgr.mr_n63034992)
print v(xbgr.mr_n63035504)
print v(xbgr.mr_n63035616)
print v(xbgr.mr_n63036384)
print v(xbgr.mr_n63036496)
print v(xbgr.mr_n63037328)
print v(xbgr.mr_n63037440)
print v(xbgr.mr_n63038528)
print v(xbgr.mr_n63038640)
print v(xbgr.mr_n63039792)
print v(xbgr.mr_n63039904)
print v(xbgr.mr_n63041056)
print v(xbgr.mr_n63041168)
print v(xbgr.mr_n63042320)
print v(xbgr.mr_n63042432)
print v(xbgr.mr_n63043584)
print v(xbgr.mr_n63043696)
print v(xbgr.mr_n63044848)
print v(xbgr.mr_n63044960)
print v(xbgr.mr_n63046112)
print v(xbgr.mr_n63046224)
print v(xbgr.mr_n63047376)
print v(xbgr.mr_n63047488)
print v(xbgr.mr_n63048640)
print v(xbgr.mr_n63048752)
print v(xbgr.mr_n63049904)
print v(xbgr.mr_n63050016)
print v(xbgr.mr_n63051168)
print v(xbgr.mr_n63051280)
print v(xbgr.mr_n63059520)
print v(xbgr.mr_n63065808)
print v(xbgr.mr_n63068416)
print v(xbgr.mr_n63077824)
print v(xbgr.mr_n63079040)
print v(xbgr.mr_n63079296)
print v(xbgr.mr_n63081888)
print v(xbgr.mr_n63082000)
print v(xbgr.mr_n63084240)
print v(xbgr.mr_n63084416)
print v(xbgr.mr_n63087040)
print v(xbgr.mr_n63089968)
print v(xbgr.mr_n63090144)
print v(xbgr.mr_n63093376)
print v(xbgr.mr_n63095440)
print v(xbgr.mr_n63098240)
print v(xbgr.mr_n63099072)
print v(xbgr.mr_n63099216)
print v(xbgr.mr_n63100304)
print v(xbgr.mr_n63100672)
print v(xbgr.mr_n63104832)
print v(xbgr.mr_n63105552)
print v(xbgr.mr_n63106544)
print v(xbgr.mr_n63106800)
print v(xbgr.mr_n63111088)
print v(xbgr.mr_n63112032)
print v(xbgr.mr_n63112976)
print v(xbgr.mr_n63113920)
print v(xbgr.mr_n63114864)
print v(xbgr.mr_n63115808)
print v(xbgr.mr_n63116752)
print v(xbgr.mr_n63117696)
print v(xbgr.mr_n63118640)
print v(xbgr.mr_n63119584)
print v(xbgr.mr_n63120528)
print v(xbgr.mr_n63121472)
print v(xbgr.mr_n63122416)
print v(xbgr.mr_n63123360)
print v(xbgr.mr_n63124304)
print v(xbgr.mr_n63125248)
print v(xbgr.mr_n63126192)
print v(xbgr.mr_n63127136)
print v(xbgr.mr_n63128080)
print v(xbgr.mr_n63129024)
print v(xbgr.mr_n63129968)
print v(xbgr.mr_n63130912)
print v(xbgr.mr_n63131856)
print v(xbgr.mr_n63132800)
print v(xbgr.mr_n63133744)
print v(xbgr.mr_n63134688)
print v(xbgr.mr_n63135632)
print v(xbgr.mr_n63136576)
print v(xbgr.mr_n63137520)
print v(xbgr.mr_n63143456)
print v(xbgr.mr_n63144400)
print v(xbgr.mr_n63145344)
print v(xbgr.mr_n63151216)
print v(xbgr.mr_n63151664)
print v(xbgr.mr_n63151856)
print v(xbgr.mr_n63152688)
print v(xbgr.mr_n63152800)
print v(xbgr.mr_n63152912)
print v(xbgr.mr_n63153024)
print v(xbgr.mr_n63153136)
print v(xbgr.mr_n63154880)
print v(xbgr.mr_n63155152)
print v(xbgr.mr_n63155344)
print v(xbgr.mr_n63155856)
print v(xbgr.mr_n63157792)
print v(xbgr.mr_n63159536)
print v(xbgr.mr_n63159808)
print v(xbgr.mr_n63160000)
print v(xbgr.mr_n63160512)
print v(xbgr.mr_n63162448)
print v(xbgr.mr_n63164192)
print v(xbgr.mr_n63164464)
print v(xbgr.mr_n63164656)
print v(xbgr.mr_n63165168)
print v(xbgr.mr_n63167344)
print v(xbgr.mr_n63167536)
print v(xbgr.mr_n63167728)
print v(xbgr.mr_n63167920)
print v(xbgr.mr_n63170144)
print v(xbgr.mr_n63171760)
print v(xbgr.mr_n63173504)
print v(xbgr.mr_n63173776)
print v(xbgr.mr_n63173968)
print v(xbgr.mr_n63174480)
print v(xbgr.mr_n63176416)
print v(xbgr.mr_n63178160)
print v(xbgr.mr_n63178432)
print v(xbgr.mr_n63178624)
print v(xbgr.mr_n63179136)
print v(xbgr.mr_n63181072)
print v(xbgr.mr_n63182816)
print v(xbgr.mr_n63183088)
print v(xbgr.mr_n63183280)
print v(xbgr.mr_n63183792)
print v(xbgr.mr_n63185728)
print v(xbgr.mr_n63187472)
print v(xbgr.mr_n63187744)
print v(xbgr.mr_n63187936)
print v(xbgr.mr_n63188448)
print v(xbgr.mr_n63190384)
print v(xbgr.mr_n63190576)
print v(xbgr.mr_n63192128)
print v(xbgr.mr_n63192400)
print v(xbgr.mr_n63192592)
print v(xbgr.mr_n63193104)
print v(xbgr.mr_n63195040)
print v(xbgr.mr_n63196784)
print v(xbgr.mr_n63197056)
print v(xbgr.mr_n63197248)
print v(xbgr.mr_n63197760)
print v(xbgr.mr_n63199696)
print v(xbgr.mr_n63201440)
print v(xbgr.mr_n63201712)
print v(xbgr.mr_n63201904)
print v(xbgr.mr_n63202416)
print v(xbgr.mr_n63204352)
print v(xbgr.mr_n63206096)
print v(xbgr.mr_n63206368)
print v(xbgr.mr_n63206560)
print v(xbgr.mr_n63207072)
print v(xbgr.mr_n63208592)
print v(xbgr.mr_n63209008)
print v(xbgr.mr_n63210752)
print v(xbgr.mr_n63211024)
print v(xbgr.mr_n63211216)
print v(xbgr.mr_n63211728)
print v(xbgr.mr_n63213664)
print v(xbgr.mr_n63215680)
print v(xbgr.mr_n63215872)
print v(xbgr.mr_n63216384)
print v(xbgr.mr_n63218336)
print v(xbgr.mr_n63218528)
print v(xbgr.mr_n63219856)
print v(xbgr.mr_n63220784)
print v(xbgr.mr_n63222336)
print v(xbgr.mr_n63223824)
print v(xbgr.mr_n63224176)
print v(xbgr.mr_n63224368)
print v(xbgr.mr_n63228160)
print v(xbgr.mr_n63229088)
print v(xbgr.mr_n63229632)
print v(xbgr.mr_n63230816)
print v(xbgr.mr_n63232336)
print v(xbgr.mr_n63233920)
print v(xbgr.mr_n63235488)
print v(xbgr.mr_n63236112)
print v(xbgr.mr_n63236576)
print v(xbgr.mr_n63237936)
print v(xbgr.mr_n63238560)
print v(xbgr.mr_n63239184)
print v(xbgr.mr_n63241632)
print v(xbgr.mr_n63242144)
print v(xbgr.mr_n63242672)
print v(xbgr.mr_n63243392)
print v(xbgr.mr_n63245824)
print v(xbgr.mr_n63246656)
print v(xbgr.mr_n63247248)
print v(xbgr.mr_n63250576)
print v(xbgr.mr_n63250912)
print v(xbgr.mr_n63252672)
print v(xbgr.mr_n63253648)
print v(xbgr.mr_n63254544)
print v(xbgr.mr_n63255680)
print v(xbgr.mr_n63257584)
print v(xbgr.mr_n63257696)
print v(xbgr.mr_n63258896)
print v(xbgr.mr_n63259376)
print v(xbgr.mr_n63259488)
print v(xbgr.mr_n63260592)
print v(xbgr.mr_n63261184)
print v(xbgr.mr_n63262832)
print v(xbgr.mr_n63264112)
print v(xbgr.mr_n63267408)
print v(xbgr.mr_n63268224)
print v(xbgr.mr_n63268880)
print v(xbgr.mr_n63269904)
print v(xbgr.mr_n63270208)
print v(xbgr.mr_n63271152)
print v(xbgr.mr_n63271776)
print v(xbgr.mr_n63277168)
print v(xbgr.mr_n63278320)
print v(xbgr.mr_n63282160)
print v(xbgr.mr_n63284096)
print v(xbgr.mr_n63284528)
print v(xbgr.mr_n63285040)
print v(xbgr.mr_n63285152)
print v(xbgr.mr_n63285584)
print v(xbgr.mr_n63286096)
print v(xbgr.mr_n63286208)
print v(xbgr.mr_n63286640)
print v(xbgr.mr_n63287152)
print v(xbgr.mr_n63287264)
print v(xbgr.mr_n63287744)
print v(xbgr.mr_n63288128)
print v(xbgr.mr_n63289776)
print v(xbgr.mr_n63290192)
print v(xbgr.mr_n63290800)
print v(xbgr.mr_n63291296)
print v(xbgr.mr_n63295072)
print v(xbgr.mr_n63295264)
print v(xbgr.mr_n63296048)
print v(xbgr.mr_n63296800)
print v(xbgr.mr_n63297792)
print v(xbgr.mr_n63297968)
print v(xbgr.mr_n63299024)
print v(xbgr.mr_n63299472)
print v(xbgr.mr_n63299696)
print v(xbgr.mr_n63301360)
print v(xbgr.mr_n63301824)
print v(xbgr.mr_n63302016)
print v(xbgr.mr_n63305872)
print v(xbgr.mr_n63306560)
print v(xbgr.mr_n63311744)
print v(xbgr.mr_n63313376)
print v(xbgr.mr_n63313568)
print v(xbgr.mr_n63313936)
print v(xbgr.mr_n63314128)
print v(xbgr.mr_n63314528)
print v(xbgr.mr_n63314768)
print v(xbgr.mr_n63317440)
print v(xbgr.mr_n63320784)
print v(xbgr.mr_n63321120)
print v(xbgr.mr_n63321520)
print v(xbgr.mr_n63321984)
print v(xbgr.mr_n63322448)
print v(xbgr.mr_n63322848)
print v(xbgr.mr_n63323312)
print v(xbgr.mr_n63323984)
print v(xbgr.mr_n63324448)
print v(xbgr.mr_n63324640)
print v(xbgr.mr_n63326288)
print v(xbgr.mr_n63327440)
print v(xbgr.mr_n63327712)
print v(xbgr.mr_n63328112)
print v(xbgr.mr_n63328512)
print v(xbgr.mr_n63328912)
print v(xbgr.mr_n63329312)
print v(xbgr.mr_n63330720)
print v(xbgr.mr_n63334016)
print v(xbgr.mr_n63336416)
print v(xbgr.mr_n63337184)
print v(xbgr.mr_n63337296)
print v(xbgr.mr_n63338176)
print v(xbgr.mr_n63338864)
print v(xbgr.mr_n63339552)
print v(xbgr.mr_n63340240)
print v(xbgr.mr_n63340928)
print v(xbgr.mr_n63341616)
print v(xbgr.mr_n63342304)
print v(xbgr.mr_n63342992)
print v(xbgr.mr_n63343680)
print v(xbgr.mr_n63344368)
print v(xbgr.mr_n63345056)
print v(xbgr.mr_n63345744)
print v(xbgr.mr_n63346432)
print v(xbgr.mr_n63347120)
print v(xbgr.mr_n63347808)
print v(xbgr.mr_n63348496)
print v(xbgr.mr_n63349184)
print v(xbgr.mr_n63349872)
print v(xbgr.mr_n63350560)
print v(xbgr.mr_n63351248)
print v(xbgr.mr_n63351936)
print v(xbgr.mr_n63352624)
print v(xbgr.mr_n63354496)
print v(xbgr.mr_n63354608)
print v(xbgr.mr_n63355120)
print v(xbgr.mr_n63355232)
print v(xbgr.mr_n63355744)
print v(xbgr.mr_n63355856)
print v(xbgr.mr_n63356368)
print v(xbgr.mr_n63356480)
print v(xbgr.mr_n63356992)
print v(xbgr.mr_n63357104)
print v(xbgr.mr_n63357616)
print v(xbgr.mr_n63357728)
print v(xbgr.mr_n63358240)
print v(xbgr.mr_n63358352)
print v(xbgr.mr_n63359056)
print v(xbgr.mr_n63359168)
print v(xbgr.mr_n63361312)
print v(xbgr.mr_n63361424)
print v(xbgr.mr_n63362256)
print v(xbgr.mr_n63362368)
print v(xbgr.mr_n63363392)
print v(xbgr.mr_n63363504)
print v(xbgr.mr_n63364656)
print v(xbgr.mr_n63364768)
print v(xbgr.mr_n63365920)
print v(xbgr.mr_n63366032)
print v(xbgr.mr_n63366528)
print v(xbgr.mr_n63378560)
print v(xbgr.mr_n63381120)
print v(xbgr.mr_n63384640)
print v(xbgr.mr_n63384832)
print v(xbgr.mr_n63385024)
print v(xbgr.mr_n63385216)
print v(xbgr.mr_n63387536)
print v(xbgr.mr_n63387808)
print v(xbgr.mr_n63388000)
print v(xbgr.mr_n63388512)
print v(xbgr.mr_n63388624)
print v(xbgr.mr_n63388736)
print v(xbgr.mr_n63388848)
print v(xbgr.mr_n63389040)
print v(xbgr.mr_n63389232)
print v(xbgr.mr_n63389424)
print v(xbgr.mr_n63392992)
print v(xbgr.mr_n63412544)
print v(xbgr.mr_n63414160)
print v(xbgr.mr_n63415840)
print v(xbgr.mr_n63418096)
print v(xbgr.mr_n63420352)
print v(xbgr.mr_n63422608)
print v(xbgr.mr_n63424864)
print v(xbgr.mr_n63435488)
print v(xbgr.mr_n63437664)
print v(xbgr.mr_n63446160)
print v(xbgr.mr_n63446736)
print v(xbgr.mr_n63447424)
print v(xbgr.mr_n63448000)
print v(xbgr.mr_n63448688)
print v(xbgr.mr_n63449120)
print v(xbgr.mr_n63449952)
print v(xbgr.mr_n63450656)
print v(xbgr.mr_n63451216)
print v(xbgr.mr_n63451648)
print v(xbgr.mr_n63452480)
print v(xbgr.mr_n63453056)
print v(xbgr.mr_n63453744)
print v(xbgr.mr_n63454320)
print v(xbgr.mr_n63455008)
print v(xbgr.mr_n63460128)
print v(xbgr.mr_n63462032)
print v(xbgr.mr_n63462432)
print v(xbgr.mr_n63469328)
print v(xbgr.mr_n63470160)
print v(xbgr.mr_n63478752)
print v(xbgr.mr_n63480224)
print v(xbgr.mr_n63483968)
print v(xbgr.mr_n63485392)
print v(xbgr.mr_n63486704)
print v(xbgr.mr_n63488400)
print v(xbgr.mr_n63488944)
print v(xbgr.mr_n63490816)
print v(xbgr.mr_n63490928)
print v(xbgr.mr_n63491040)
print v(xbgr.mr_n63491152)
print v(xbgr.mr_n63491264)
print v(xbgr.mr_n63491376)
print v(xbgr.mr_n63491488)
print v(xbgr.mr_n63491600)
print v(xbgr.mr_n63491712)
print v(xbgr.mr_n63491824)
print v(xbgr.mr_n63492256)
print v(xbgr.mr_n63492368)
print v(xbgr.mr_n63492560)
print v(xbgr.mr_n63493568)
print v(xbgr.mr_n63493760)
print v(xbgr.mr_n63495424)
print v(xbgr.mr_n63495968)
print v(xbgr.mr_n63496304)
print v(xbgr.mr_n63496704)
print v(xbgr.mr_n63497040)
print v(xbgr.mr_n63497232)
print v(xbgr.mr_n63498272)
print v(xbgr.mr_n63500288)
print v(xbgr.mr_n63500656)
print v(xbgr.mr_n63501168)
print v(xbgr.mr_n63501280)
print v(xbgr.mr_n63501792)
print v(xbgr.mr_n63501904)
print v(xbgr.mr_n63502416)
print v(xbgr.mr_n63502528)
print v(xbgr.mr_n63503040)
print v(xbgr.mr_n63503152)
print v(xbgr.mr_n63503664)
print v(xbgr.mr_n63503776)
print v(xbgr.mr_n63504288)
print v(xbgr.mr_n63504400)
print v(xbgr.mr_n63504912)
print v(xbgr.mr_n63505024)
print v(xbgr.mr_n63505536)
print v(xbgr.mr_n63505648)
print v(xbgr.mr_n63509408)
print v(xbgr.mr_n63517664)
print v(xbgr.mr_n63519072)
print v(xbgr.mr_n63519760)
print v(xbgr.mr_n63520448)
print v(xbgr.mr_n63521136)
print v(xbgr.mr_n63521824)
print v(xbgr.mr_n63522512)
print v(xbgr.mr_n63523200)
print v(xbgr.mr_n63523888)
print v(xbgr.mr_n63524576)
print v(xbgr.mr_n63525264)
print v(xbgr.mr_n63525952)
print v(xbgr.mr_n63527024)
print v(xbgr.mr_n63528800)
print v(xbgr.mr_n63529744)
print v(xbgr.mr_n63530688)
print v(xbgr.mr_n63531632)
print v(xbgr.mr_n63532576)
print v(xbgr.mr_n63532912)
print v(xbgr.mr_n63533520)
print v(xbgr.mr_n63542240)
print v(xbgr.mr_n63542624)
print v(xbgr.mr_n63543392)
print v(xbgr.mr_n63543776)
print v(xbgr.mr_n63544624)
print v(xbgr.mr_n63545696)
print v(xbgr.mr_n63546080)
print v(xbgr.mr_n63546464)
print v(xbgr.mr_n63548384)
print v(xbgr.mr_n63548768)
print v(xbgr.mr_n63549152)
print v(xbgr.mr_n63549536)
print v(xbgr.mr_n63550688)
print v(xbgr.mr_n63551744)
print v(xbgr.mr_n63553376)
print v(xbgr.mr_n63553568)
print v(xbgr.mr_n63554336)
print v(xbgr.mr_n63558560)
print v(xbgr.mr_n63558672)
print v(xbgr.mr_n63559840)
print v(xbgr.mr_n63560288)
print v(xbgr.mr_n63562224)
print v(xbgr.mr_n63564016)
print v(xbgr.mr_n63565664)
print v(xbgr.mr_n63567232)
print v(xbgr.mr_n63567792)
print v(xbgr.mr_n63568064)
print v(xbgr.mr_n63573840)
print v(xbgr.mr_n63575200)
print v(xbgr.mr_n63576992)
print v(xbgr.mr_n63578640)
print v(xbgr.mr_n63580000)
print v(xbgr.mr_n63580464)
print v(xbgr.mr_n63581392)
print v(xbgr.mr_n63582048)
print v(xbgr.mr_n63582272)
print v(xbgr.mr_n63582704)
print v(xbgr.mr_n63583664)
print v(xbgr.mr_n63585936)
print v(xbgr.mr_n63586256)
print v(xbgr.mr_n63589616)
print v(xbgr.mr_n63590128)
print v(xbgr.mr_n63590240)
print v(xbgr.mr_n63590672)
print v(xbgr.mr_n63591184)
print v(xbgr.mr_n63591296)
print v(xbgr.mr_n63591728)
print v(xbgr.mr_n63592240)
print v(xbgr.mr_n63592352)
print v(xbgr.mr_n63592784)
print v(xbgr.mr_n63593376)
print v(xbgr.mr_n63593856)
print v(xbgr.mr_n63595360)
print v(xbgr.mr_n63595920)
print v(xbgr.mr_n63596032)
print v(xbgr.mr_n63596672)
print v(xbgr.mr_n63597568)
print v(xbgr.mr_n63599600)
print v(xbgr.mr_n63601184)
print v(xbgr.mr_n63601472)
print v(xbgr.mr_n63601696)
print v(xbgr.mr_n63602752)
print v(xbgr.mr_n63603648)
print v(xbgr.mr_n63603936)
print v(xbgr.mr_n63604272)
print v(xbgr.mr_n63604480)
print v(xbgr.mr_n63605888)
print v(xbgr.mr_n63607280)
print v(xbgr.mr_n63607488)
print v(xbgr.mr_n63607968)
print v(xbgr.mr_n63610496)
print v(xbgr.mr_n63610704)
print v(xbgr.mr_n63612368)
print v(xbgr.mr_n63612960)
print v(xbgr.mr_n63614736)
print v(xbgr.mr_n63618080)
print v(xbgr.mr_n63621280)
print v(xbgr.mr_n63622608)
print v(xbgr.mr_n63623760)
print v(xbgr.mr_n63628896)
print v(xbgr.mr_n63631360)
print v(xbgr.mr_n63632352)
print v(xbgr.mr_n63632576)
print v(xbgr.mr_n63632864)
print v(xbgr.mr_n63633792)
print v(xbgr.mr_n63634368)
print v(xbgr.mr_n63637728)
print v(xbgr.mr_n63640048)
print v(xbgr.mr_n63643408)
print v(xbgr.mr_n63643808)
print v(xbgr.mr_n63644000)
print v(xbgr.mr_n63644944)
print v(xbgr.mr_n63645280)
print v(xbgr.mr_n63645632)
print v(xbgr.mr_n63646272)
print v(xbgr.mr_n63646512)
print v(xbgr.mr_n63646624)
print v(xbgr.mr_n63647152)
print v(xbgr.mr_n63647344)
print v(xbgr.mr_n63648288)
print v(xbgr.mr_n63648624)
print v(xbgr.mr_n63648816)
print v(xbgr.mr_n63649216)
print v(xbgr.mr_n63649408)
print v(xbgr.mr_n63649872)
print v(xbgr.mr_n63650336)
print v(xbgr.mr_n63651424)
print v(xbgr.mr_n63651616)
print v(xbgr.mr_n63652016)
print v(xbgr.mr_n63652688)
print v(xbgr.mr_n63652880)
print v(xbgr.mr_n63654096)
print v(xbgr.mr_n63654912)
print v(xbgr.mr_n63655248)
print v(xbgr.mr_n63655440)
print v(xbgr.mr_n63656864)
print v(xbgr.mr_n63658048)
print v(xbgr.mr_n63663408)
print v(xbgr.mr_n63663600)
print v(xbgr.mr_n63664544)
print v(xbgr.mr_n63664944)
print v(xbgr.mr_n63665168)
print v(xbgr.mr_n63666496)
print v(xbgr.mr_n63670624)
print v(xbgr.mr_n63674656)
print v(xbgr.mr_n63674768)
print v(xbgr.mr_n63675200)
print v(xbgr.mr_n63675712)
print v(xbgr.mr_n63675824)
print v(xbgr.mr_n63676256)
print v(xbgr.mr_n63676768)
print v(xbgr.mr_n63676880)
print v(xbgr.mr_n63677312)
print v(xbgr.mr_n63677824)
print v(xbgr.mr_n63677936)
print v(xbgr.mr_n63678368)
print v(xbgr.mr_n63678880)
print v(xbgr.mr_n63678992)
print v(xbgr.mr_n63679424)
print v(xbgr.mr_n63679936)
print v(xbgr.mr_n63680048)
print v(xbgr.mr_n63680480)
print v(xbgr.mr_n63680992)
print v(xbgr.mr_n63681104)
print v(xbgr.mr_n63681536)
print v(xbgr.mr_n63682048)
print v(xbgr.mr_n63682160)
print v(xbgr.mr_n63682592)
print v(xbgr.mr_n63683104)
print v(xbgr.mr_n63683216)
print v(xbgr.mr_n63683648)
print v(xbgr.mr_n63684480)
print v(xbgr.mr_n63684592)
print v(xbgr.mr_n63685472)
print v(xbgr.mr_n63686160)
print v(xbgr.mr_n63686848)
print v(xbgr.mr_n63687536)
print v(xbgr.mr_n63688224)
print v(xbgr.mr_n63688912)
print v(xbgr.mr_n63689600)
print v(xbgr.mr_n63690288)
print v(xbgr.mr_n63690976)
print v(xbgr.mr_n63691664)
print v(xbgr.mr_n63692352)
print v(xbgr.mr_n63693040)
print v(xbgr.mr_n63693728)
print v(xbgr.mr_n63694416)
print v(xbgr.mr_n63695104)
print v(xbgr.mr_n63695792)
print v(xbgr.mr_n63696480)
print v(xbgr.mr_n63697168)
print v(xbgr.mr_n63697856)
print v(xbgr.mr_n63698544)
print v(xbgr.mr_n63699840)
print v(xbgr.mr_n63700912)
print v(xbgr.mr_n63701856)
print v(xbgr.mr_n63702800)
print v(xbgr.mr_n63703744)
print v(xbgr.mr_n63704688)
print v(xbgr.mr_n63705632)
print v(xbgr.mr_n63706576)
print v(xbgr.mr_n63707520)
print v(xbgr.mr_n63708464)
print v(xbgr.mr_n63709408)
print v(xbgr.mr_n63710352)
print v(xbgr.mr_n63711296)
print v(xbgr.mr_n63712240)
print v(xbgr.mr_n63713184)
print v(xbgr.mr_n63714128)
print v(xbgr.mr_n63715072)
print v(xbgr.mr_n63716016)
print v(xbgr.mr_n63716960)
print v(xbgr.mr_n63717904)
print v(xbgr.mr_n63718848)
print v(xbgr.mr_n63719792)
print v(xbgr.mr_n63720736)
print v(xbgr.mr_n63721680)
print v(xbgr.mr_n63722624)
print v(xbgr.mr_n63723568)
print v(xbgr.mr_n63728368)
print v(xbgr.mr_n63728624)
print v(xbgr.mr_n63728880)
print v(xbgr.mr_n63729136)
print v(xbgr.mr_n63729392)
print v(xbgr.mr_n63729648)
print v(xbgr.mr_n63729968)
print v(xbgr.mr_n63732448)
print v(xbgr.mr_n63732896)
print v(xbgr.mr_n63733088)
print v(xbgr.mr_n63733280)
print v(xbgr.mr_n63733472)
print v(xbgr.mr_n63733664)
print v(xbgr.mr_n63733856)
print v(xbgr.mr_n63734112)
print v(xbgr.mr_n63739120)
print v(xbgr.mr_n63745984)
print v(xbgr.mr_n63750192)
print v(xbgr.mr_n63756144)
print v(xbgr.mr_n63756336)
print v(xbgr.mr_n63775408)
print v(xbgr.mr_n63775552)
print v(xbgr.mr_n63776624)
print v(xbgr.mr_n63780304)
print v(xbgr.mr_n63780496)
print v(xbgr.mr_n63782016)
print v(xbgr.mr_n63782416)
print v(xbgr.mr_n63784848)
print v(xbgr.mr_n64060464)
print v(xbgr.mr_n64075632)
print v(xbgr.mr_n64179824)
print v(xbgr.mr_n64180320)
print v(xbgr.mr_n64180496)
print v(xbgr.mr_n64181328)
print v(xbgr.mr_n64206112)
print v(xbgr.mr_n64208192)
print v(xbgr.mr_n64208384)
print v(xbgr.mr_n64225600)
print v(xbgr.mr_n64226240)
print v(xbgr.mr_n64289936)
print v(xbgr.mr_n64295696)
print v(xbgr.mr_n64295888)
print v(xbgr.mr_n64328624)
print v(xbgr.mr_n64341120)
print v(xbgr.mr_n64343760)
print v(xbgr.mr_n64343952)
print v(xbgr.mr_n64344144)
print v(xbgr.mr_n64344336)
print v(xbgr.mr_n64344528)
print v(xbgr.mr_n64396352)
print v(xbgr.mr_n64397776)
print v(xbgr.mr_n64400608)
print v(xbgr.mr_n64459056)
print v(xbgr.mr_n64459248)
print v(xbgr.mr_n64460048)
print v(xbgr.mr_n64463616)
print v(xbgr.mr_n64477744)
print v(xbgr.mr_n64488464)
print v(xbgr.mr_n64504448)
print v(xbgr.mr_n64557024)
print v(xbgr.mr_n64557216)
print v(xbgr.mr_n64557568)
print v(xbgr.mr_n64557760)
print v(xbgr.mr_n64558112)
print v(xbgr.mr_n64587360)
print v(xbgr.mr_n64591904)
print v(xbgr.mr_n64592192)
print v(xbgr.mr_n64593408)
print v(xbgr.mr_n64593520)
print v(xbgr.mr_n64594048)
print v(xbgr.mr_n64602448)
print v(xbgr.mr_n64619232)
print v(xbgr.mr_n64621424)
print v(xbgr.mr_n64647392)
print v(xbgr.mr_n64648864)
print v(xbgr.mr_n64653712)
print v(xbgr.mr_n64662656)
print v(xbgr.mr_n64663024)
print v(xbgr.mr_n64663424)
print v(xbgr.mr_n64663744)
print v(xbgr.mr_n64664064)
print v(xbgr.mr_n64664336)
print v(xbgr.mr_n64669792)
print v(xbgr.mr_n64670320)
print v(xbgr.mr_n64670800)
print v(xbgr.mr_n64670912)
print v(xbgr.mr_n64671424)
print v(xbgr.mr_n64672512)
print v(xbgr.mr_n64707216)
print v(xbgr.mr_n64708128)
print v(xbgr.mr_n64708464)
print v(xbgr.mr_n64731232)
print v(xbgr.mr_n64738832)
print v(xbgr.mr_n64739856)
print v(xbgr.mr_n64743232)
print v(xbgr.mr_n64787984)
print v(xbgr.mr_n64788176)
print v(xbgr.mr_n64788368)
print v(xbgr.mr_n64797136)
print v(xbgr.mr_n64824144)
print v(xbgr.mr_n64834320)
print v(xbgr.mr_n64840240)
print v(xbgr.mr_n64841200)
print v(xbgr.mr_n64866992)
print v(xbgr.mr_n64867248)
print v(xbgr.mr_n64879184)
print v(xbgr.mr_n64880240)
print v(xbgr.n1)
print v(xbgr.n_10)
print v(xbgr.n_11)
print v(xbgr.n_12)
print v(xbgr.n_13)
print v(xbgr.n_14)
print v(xbgr.n_15)
print v(xbgr.n_16)
print v(xbgr.n_17)
print v(xbgr.n_18)
print v(xbgr.n_19)
print v(xbgr.n_2)
print v(xbgr.n_21)
print v(xbgr.n_22)
print v(xbgr.n_23)
print v(xbgr.n_24)
print v(xbgr.n_25)
print v(xbgr.n_26)
print v(xbgr.n_27)
print v(xbgr.n_3)
print v(xbgr.n_30)
print v(xbgr.n_31)
print v(xbgr.n_33)
print v(xbgr.n_34)
print v(xbgr.n_36)
print v(xbgr.n_37)
print v(xbgr.n_4)
print v(xbgr.n_5)
print v(xbgr.n_6)
print v(xbgr.n_7)
print v(xbgr.n_8)
print v(xbgr.n_9)
print v(pbias)
print v(pcasc)
print v(r4)
print v(xbgr.r4n)
print v(xbgr.vb2)
print v(vbe)
print v(xbgr.vbe3)
print v(xbgr.vd1)
print v(xbgr.vd2)
print v(vdd)
print v(vref)
print v(vdd)-v(vdd)
echo METALLIC_ALL_NODE_VOLTAGES_END
quit
.endc
.end
