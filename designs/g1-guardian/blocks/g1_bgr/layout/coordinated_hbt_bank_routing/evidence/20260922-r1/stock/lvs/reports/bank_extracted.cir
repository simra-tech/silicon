* Extracted by KLayout with SG13G2 LVS runset on : 22/09/2026 20:46

.SUBCKT bgr_hbt_bank b1b c2 dvbe vbe vbe3 vd1 vd2 vss
Q$1 vd2 vd2 vss vss npn13G2 we=70n le=900n Nx=1 m=24
Q$25 vss vss vss vss npn13G2 we=70n le=900n Nx=1 m=9
Q$34 vbe3 vbe3 vss vss npn13G2 we=70n le=900n Nx=1 m=4
Q$38 vd1 vd1 vd2 vss npn13G2 we=70n le=900n Nx=1 m=24
Q$62 c2 vbe dvbe vss npn13G2 we=70n le=900n Nx=1 m=192
Q$254 vbe b1b vss vss npn13G2 we=70n le=900n Nx=1 m=24
Q$278 vbe vbe vss vss npn13G2 we=70n le=900n Nx=1 m=24
.ENDS bgr_hbt_bank
