.subckt bgr_hbt_return_control_02 vbe b1b vss
QUNIT vbe b1b vss vss npn13G2 we=0.07u le=0.9u Nx=1 m=1
.ends bgr_hbt_return_control_02
