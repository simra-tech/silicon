.subckt bgr_hbt_bank b1b c2 dvbe vbe vbe3 vd1 vd2 vss
Q56 vbe vbe vss vss npn13G2 we=0.07u le=0.9u Nx=1 m=1
Q56_u2 vbe vbe vss vss npn13G2 we=0.07u le=0.9u Nx=1 m=1
Q56_u3 vbe vbe vss vss npn13G2 we=0.07u le=0.9u Nx=1 m=1
Q56_u4 vbe vbe vss vss npn13G2 we=0.07u le=0.9u Nx=1 m=1
Q56_u5 vbe vbe vss vss npn13G2 we=0.07u le=0.9u Nx=1 m=1
Q56_u6 vbe vbe vss vss npn13G2 we=0.07u le=0.9u Nx=1 m=1
Q56_u7 vbe vbe vss vss npn13G2 we=0.07u le=0.9u Nx=1 m=1
Q56_u8 vbe vbe vss vss npn13G2 we=0.07u le=0.9u Nx=1 m=1
Q56_u9 vbe vbe vss vss npn13G2 we=0.07u le=0.9u Nx=1 m=1
Q56_u10 vbe vbe vss vss npn13G2 we=0.07u le=0.9u Nx=1 m=1
Q56_u11 vbe vbe vss vss npn13G2 we=0.07u le=0.9u Nx=1 m=1
Q56_u12 vbe vbe vss vss npn13G2 we=0.07u le=0.9u Nx=1 m=1
Q56_u13 vbe vbe vss vss npn13G2 we=0.07u le=0.9u Nx=1 m=1
Q56_u14 vbe vbe vss vss npn13G2 we=0.07u le=0.9u Nx=1 m=1
Q56_u15 vbe vbe vss vss npn13G2 we=0.07u le=0.9u Nx=1 m=1
Q56_u16 vbe vbe vss vss npn13G2 we=0.07u le=0.9u Nx=1 m=1
Q56_u17 vbe vbe vss vss npn13G2 we=0.07u le=0.9u Nx=1 m=1
Q56_u18 vbe vbe vss vss npn13G2 we=0.07u le=0.9u Nx=1 m=1
Q56_u19 vbe vbe vss vss npn13G2 we=0.07u le=0.9u Nx=1 m=1
Q56_u20 vbe vbe vss vss npn13G2 we=0.07u le=0.9u Nx=1 m=1
Q56_u21 vbe vbe vss vss npn13G2 we=0.07u le=0.9u Nx=1 m=1
Q56_u22 vbe vbe vss vss npn13G2 we=0.07u le=0.9u Nx=1 m=1
Q56_u23 vbe vbe vss vss npn13G2 we=0.07u le=0.9u Nx=1 m=1
Q56_u24 vbe vbe vss vss npn13G2 we=0.07u le=0.9u Nx=1 m=1
Q62 vd2 vd2 vss vss npn13G2 we=0.07u le=0.9u Nx=1 m=1
Q62_u2 vd2 vd2 vss vss npn13G2 we=0.07u le=0.9u Nx=1 m=1
Q62_u3 vd2 vd2 vss vss npn13G2 we=0.07u le=0.9u Nx=1 m=1
Q62_u4 vd2 vd2 vss vss npn13G2 we=0.07u le=0.9u Nx=1 m=1
Q62_u5 vd2 vd2 vss vss npn13G2 we=0.07u le=0.9u Nx=1 m=1
Q62_u6 vd2 vd2 vss vss npn13G2 we=0.07u le=0.9u Nx=1 m=1
Q62_u7 vd2 vd2 vss vss npn13G2 we=0.07u le=0.9u Nx=1 m=1
Q62_u8 vd2 vd2 vss vss npn13G2 we=0.07u le=0.9u Nx=1 m=1
Q62_u9 vd2 vd2 vss vss npn13G2 we=0.07u le=0.9u Nx=1 m=1
Q62_u10 vd2 vd2 vss vss npn13G2 we=0.07u le=0.9u Nx=1 m=1
Q62_u11 vd2 vd2 vss vss npn13G2 we=0.07u le=0.9u Nx=1 m=1
Q62_u12 vd2 vd2 vss vss npn13G2 we=0.07u le=0.9u Nx=1 m=1
Q62_u13 vd2 vd2 vss vss npn13G2 we=0.07u le=0.9u Nx=1 m=1
Q62_u14 vd2 vd2 vss vss npn13G2 we=0.07u le=0.9u Nx=1 m=1
Q62_u15 vd2 vd2 vss vss npn13G2 we=0.07u le=0.9u Nx=1 m=1
Q62_u16 vd2 vd2 vss vss npn13G2 we=0.07u le=0.9u Nx=1 m=1
Q62_u17 vd2 vd2 vss vss npn13G2 we=0.07u le=0.9u Nx=1 m=1
Q62_u18 vd2 vd2 vss vss npn13G2 we=0.07u le=0.9u Nx=1 m=1
Q62_u19 vd2 vd2 vss vss npn13G2 we=0.07u le=0.9u Nx=1 m=1
Q62_u20 vd2 vd2 vss vss npn13G2 we=0.07u le=0.9u Nx=1 m=1
Q62_u21 vd2 vd2 vss vss npn13G2 we=0.07u le=0.9u Nx=1 m=1
Q62_u22 vd2 vd2 vss vss npn13G2 we=0.07u le=0.9u Nx=1 m=1
Q62_u23 vd2 vd2 vss vss npn13G2 we=0.07u le=0.9u Nx=1 m=1
Q62_u24 vd2 vd2 vss vss npn13G2 we=0.07u le=0.9u Nx=1 m=1
Q67 vbe b1b vss vss npn13G2 we=0.07u le=0.9u Nx=1 m=1
Q67_u2 vbe b1b vss vss npn13G2 we=0.07u le=0.9u Nx=1 m=1
Q67_u3 vbe b1b vss vss npn13G2 we=0.07u le=0.9u Nx=1 m=1
Q67_u4 vbe b1b vss vss npn13G2 we=0.07u le=0.9u Nx=1 m=1
Q67_u5 vbe b1b vss vss npn13G2 we=0.07u le=0.9u Nx=1 m=1
Q67_u6 vbe b1b vss vss npn13G2 we=0.07u le=0.9u Nx=1 m=1
Q67_u7 vbe b1b vss vss npn13G2 we=0.07u le=0.9u Nx=1 m=1
Q67_u8 vbe b1b vss vss npn13G2 we=0.07u le=0.9u Nx=1 m=1
Q67_u9 vbe b1b vss vss npn13G2 we=0.07u le=0.9u Nx=1 m=1
Q67_u10 vbe b1b vss vss npn13G2 we=0.07u le=0.9u Nx=1 m=1
Q67_u11 vbe b1b vss vss npn13G2 we=0.07u le=0.9u Nx=1 m=1
Q67_u12 vbe b1b vss vss npn13G2 we=0.07u le=0.9u Nx=1 m=1
Q67_u13 vbe b1b vss vss npn13G2 we=0.07u le=0.9u Nx=1 m=1
Q67_u14 vbe b1b vss vss npn13G2 we=0.07u le=0.9u Nx=1 m=1
Q67_u15 vbe b1b vss vss npn13G2 we=0.07u le=0.9u Nx=1 m=1
Q67_u16 vbe b1b vss vss npn13G2 we=0.07u le=0.9u Nx=1 m=1
Q67_u17 vbe b1b vss vss npn13G2 we=0.07u le=0.9u Nx=1 m=1
Q67_u18 vbe b1b vss vss npn13G2 we=0.07u le=0.9u Nx=1 m=1
Q67_u19 vbe b1b vss vss npn13G2 we=0.07u le=0.9u Nx=1 m=1
Q67_u20 vbe b1b vss vss npn13G2 we=0.07u le=0.9u Nx=1 m=1
Q67_u21 vbe b1b vss vss npn13G2 we=0.07u le=0.9u Nx=1 m=1
Q67_u22 vbe b1b vss vss npn13G2 we=0.07u le=0.9u Nx=1 m=1
Q67_u23 vbe b1b vss vss npn13G2 we=0.07u le=0.9u Nx=1 m=1
Q67_u24 vbe b1b vss vss npn13G2 we=0.07u le=0.9u Nx=1 m=1
Q68 c2 vbe dvbe vss npn13G2 we=0.07u le=0.9u Nx=1 m=1
Q68_u2 c2 vbe dvbe vss npn13G2 we=0.07u le=0.9u Nx=1 m=1
Q68_u3 c2 vbe dvbe vss npn13G2 we=0.07u le=0.9u Nx=1 m=1
Q68_u4 c2 vbe dvbe vss npn13G2 we=0.07u le=0.9u Nx=1 m=1
Q68_u5 c2 vbe dvbe vss npn13G2 we=0.07u le=0.9u Nx=1 m=1
Q68_u6 c2 vbe dvbe vss npn13G2 we=0.07u le=0.9u Nx=1 m=1
Q68_u7 c2 vbe dvbe vss npn13G2 we=0.07u le=0.9u Nx=1 m=1
Q68_u8 c2 vbe dvbe vss npn13G2 we=0.07u le=0.9u Nx=1 m=1
Q68_u9 c2 vbe dvbe vss npn13G2 we=0.07u le=0.9u Nx=1 m=1
Q68_u10 c2 vbe dvbe vss npn13G2 we=0.07u le=0.9u Nx=1 m=1
Q68_u11 c2 vbe dvbe vss npn13G2 we=0.07u le=0.9u Nx=1 m=1
Q68_u12 c2 vbe dvbe vss npn13G2 we=0.07u le=0.9u Nx=1 m=1
Q68_u13 c2 vbe dvbe vss npn13G2 we=0.07u le=0.9u Nx=1 m=1
Q68_u14 c2 vbe dvbe vss npn13G2 we=0.07u le=0.9u Nx=1 m=1
Q68_u15 c2 vbe dvbe vss npn13G2 we=0.07u le=0.9u Nx=1 m=1
Q68_u16 c2 vbe dvbe vss npn13G2 we=0.07u le=0.9u Nx=1 m=1
Q68_u17 c2 vbe dvbe vss npn13G2 we=0.07u le=0.9u Nx=1 m=1
Q68_u18 c2 vbe dvbe vss npn13G2 we=0.07u le=0.9u Nx=1 m=1
Q68_u19 c2 vbe dvbe vss npn13G2 we=0.07u le=0.9u Nx=1 m=1
Q68_u20 c2 vbe dvbe vss npn13G2 we=0.07u le=0.9u Nx=1 m=1
Q68_u21 c2 vbe dvbe vss npn13G2 we=0.07u le=0.9u Nx=1 m=1
Q68_u22 c2 vbe dvbe vss npn13G2 we=0.07u le=0.9u Nx=1 m=1
Q68_u23 c2 vbe dvbe vss npn13G2 we=0.07u le=0.9u Nx=1 m=1
Q68_u24 c2 vbe dvbe vss npn13G2 we=0.07u le=0.9u Nx=1 m=1
Q69 c2 vbe dvbe vss npn13G2 we=0.07u le=0.9u Nx=1 m=1
Q69_u2 c2 vbe dvbe vss npn13G2 we=0.07u le=0.9u Nx=1 m=1
Q69_u3 c2 vbe dvbe vss npn13G2 we=0.07u le=0.9u Nx=1 m=1
Q69_u4 c2 vbe dvbe vss npn13G2 we=0.07u le=0.9u Nx=1 m=1
Q69_u5 c2 vbe dvbe vss npn13G2 we=0.07u le=0.9u Nx=1 m=1
Q69_u6 c2 vbe dvbe vss npn13G2 we=0.07u le=0.9u Nx=1 m=1
Q69_u7 c2 vbe dvbe vss npn13G2 we=0.07u le=0.9u Nx=1 m=1
Q69_u8 c2 vbe dvbe vss npn13G2 we=0.07u le=0.9u Nx=1 m=1
Q69_u9 c2 vbe dvbe vss npn13G2 we=0.07u le=0.9u Nx=1 m=1
Q69_u10 c2 vbe dvbe vss npn13G2 we=0.07u le=0.9u Nx=1 m=1
Q69_u11 c2 vbe dvbe vss npn13G2 we=0.07u le=0.9u Nx=1 m=1
Q69_u12 c2 vbe dvbe vss npn13G2 we=0.07u le=0.9u Nx=1 m=1
Q69_u13 c2 vbe dvbe vss npn13G2 we=0.07u le=0.9u Nx=1 m=1
Q69_u14 c2 vbe dvbe vss npn13G2 we=0.07u le=0.9u Nx=1 m=1
Q69_u15 c2 vbe dvbe vss npn13G2 we=0.07u le=0.9u Nx=1 m=1
Q69_u16 c2 vbe dvbe vss npn13G2 we=0.07u le=0.9u Nx=1 m=1
Q69_u17 c2 vbe dvbe vss npn13G2 we=0.07u le=0.9u Nx=1 m=1
Q69_u18 c2 vbe dvbe vss npn13G2 we=0.07u le=0.9u Nx=1 m=1
Q69_u19 c2 vbe dvbe vss npn13G2 we=0.07u le=0.9u Nx=1 m=1
Q69_u20 c2 vbe dvbe vss npn13G2 we=0.07u le=0.9u Nx=1 m=1
Q69_u21 c2 vbe dvbe vss npn13G2 we=0.07u le=0.9u Nx=1 m=1
Q69_u22 c2 vbe dvbe vss npn13G2 we=0.07u le=0.9u Nx=1 m=1
Q69_u23 c2 vbe dvbe vss npn13G2 we=0.07u le=0.9u Nx=1 m=1
Q69_u24 c2 vbe dvbe vss npn13G2 we=0.07u le=0.9u Nx=1 m=1
Q70 c2 vbe dvbe vss npn13G2 we=0.07u le=0.9u Nx=1 m=1
Q70_u2 c2 vbe dvbe vss npn13G2 we=0.07u le=0.9u Nx=1 m=1
Q70_u3 c2 vbe dvbe vss npn13G2 we=0.07u le=0.9u Nx=1 m=1
Q70_u4 c2 vbe dvbe vss npn13G2 we=0.07u le=0.9u Nx=1 m=1
Q70_u5 c2 vbe dvbe vss npn13G2 we=0.07u le=0.9u Nx=1 m=1
Q70_u6 c2 vbe dvbe vss npn13G2 we=0.07u le=0.9u Nx=1 m=1
Q70_u7 c2 vbe dvbe vss npn13G2 we=0.07u le=0.9u Nx=1 m=1
Q70_u8 c2 vbe dvbe vss npn13G2 we=0.07u le=0.9u Nx=1 m=1
Q70_u9 c2 vbe dvbe vss npn13G2 we=0.07u le=0.9u Nx=1 m=1
Q70_u10 c2 vbe dvbe vss npn13G2 we=0.07u le=0.9u Nx=1 m=1
Q70_u11 c2 vbe dvbe vss npn13G2 we=0.07u le=0.9u Nx=1 m=1
Q70_u12 c2 vbe dvbe vss npn13G2 we=0.07u le=0.9u Nx=1 m=1
Q70_u13 c2 vbe dvbe vss npn13G2 we=0.07u le=0.9u Nx=1 m=1
Q70_u14 c2 vbe dvbe vss npn13G2 we=0.07u le=0.9u Nx=1 m=1
Q70_u15 c2 vbe dvbe vss npn13G2 we=0.07u le=0.9u Nx=1 m=1
Q70_u16 c2 vbe dvbe vss npn13G2 we=0.07u le=0.9u Nx=1 m=1
Q70_u17 c2 vbe dvbe vss npn13G2 we=0.07u le=0.9u Nx=1 m=1
Q70_u18 c2 vbe dvbe vss npn13G2 we=0.07u le=0.9u Nx=1 m=1
Q70_u19 c2 vbe dvbe vss npn13G2 we=0.07u le=0.9u Nx=1 m=1
Q70_u20 c2 vbe dvbe vss npn13G2 we=0.07u le=0.9u Nx=1 m=1
Q70_u21 c2 vbe dvbe vss npn13G2 we=0.07u le=0.9u Nx=1 m=1
Q70_u22 c2 vbe dvbe vss npn13G2 we=0.07u le=0.9u Nx=1 m=1
Q70_u23 c2 vbe dvbe vss npn13G2 we=0.07u le=0.9u Nx=1 m=1
Q70_u24 c2 vbe dvbe vss npn13G2 we=0.07u le=0.9u Nx=1 m=1
Q71 c2 vbe dvbe vss npn13G2 we=0.07u le=0.9u Nx=1 m=1
Q71_u2 c2 vbe dvbe vss npn13G2 we=0.07u le=0.9u Nx=1 m=1
Q71_u3 c2 vbe dvbe vss npn13G2 we=0.07u le=0.9u Nx=1 m=1
Q71_u4 c2 vbe dvbe vss npn13G2 we=0.07u le=0.9u Nx=1 m=1
Q71_u5 c2 vbe dvbe vss npn13G2 we=0.07u le=0.9u Nx=1 m=1
Q71_u6 c2 vbe dvbe vss npn13G2 we=0.07u le=0.9u Nx=1 m=1
Q71_u7 c2 vbe dvbe vss npn13G2 we=0.07u le=0.9u Nx=1 m=1
Q71_u8 c2 vbe dvbe vss npn13G2 we=0.07u le=0.9u Nx=1 m=1
Q71_u9 c2 vbe dvbe vss npn13G2 we=0.07u le=0.9u Nx=1 m=1
Q71_u10 c2 vbe dvbe vss npn13G2 we=0.07u le=0.9u Nx=1 m=1
Q71_u11 c2 vbe dvbe vss npn13G2 we=0.07u le=0.9u Nx=1 m=1
Q71_u12 c2 vbe dvbe vss npn13G2 we=0.07u le=0.9u Nx=1 m=1
Q71_u13 c2 vbe dvbe vss npn13G2 we=0.07u le=0.9u Nx=1 m=1
Q71_u14 c2 vbe dvbe vss npn13G2 we=0.07u le=0.9u Nx=1 m=1
Q71_u15 c2 vbe dvbe vss npn13G2 we=0.07u le=0.9u Nx=1 m=1
Q71_u16 c2 vbe dvbe vss npn13G2 we=0.07u le=0.9u Nx=1 m=1
Q71_u17 c2 vbe dvbe vss npn13G2 we=0.07u le=0.9u Nx=1 m=1
Q71_u18 c2 vbe dvbe vss npn13G2 we=0.07u le=0.9u Nx=1 m=1
Q71_u19 c2 vbe dvbe vss npn13G2 we=0.07u le=0.9u Nx=1 m=1
Q71_u20 c2 vbe dvbe vss npn13G2 we=0.07u le=0.9u Nx=1 m=1
Q71_u21 c2 vbe dvbe vss npn13G2 we=0.07u le=0.9u Nx=1 m=1
Q71_u22 c2 vbe dvbe vss npn13G2 we=0.07u le=0.9u Nx=1 m=1
Q71_u23 c2 vbe dvbe vss npn13G2 we=0.07u le=0.9u Nx=1 m=1
Q71_u24 c2 vbe dvbe vss npn13G2 we=0.07u le=0.9u Nx=1 m=1
Q72 c2 vbe dvbe vss npn13G2 we=0.07u le=0.9u Nx=1 m=1
Q72_u2 c2 vbe dvbe vss npn13G2 we=0.07u le=0.9u Nx=1 m=1
Q72_u3 c2 vbe dvbe vss npn13G2 we=0.07u le=0.9u Nx=1 m=1
Q72_u4 c2 vbe dvbe vss npn13G2 we=0.07u le=0.9u Nx=1 m=1
Q72_u5 c2 vbe dvbe vss npn13G2 we=0.07u le=0.9u Nx=1 m=1
Q72_u6 c2 vbe dvbe vss npn13G2 we=0.07u le=0.9u Nx=1 m=1
Q72_u7 c2 vbe dvbe vss npn13G2 we=0.07u le=0.9u Nx=1 m=1
Q72_u8 c2 vbe dvbe vss npn13G2 we=0.07u le=0.9u Nx=1 m=1
Q72_u9 c2 vbe dvbe vss npn13G2 we=0.07u le=0.9u Nx=1 m=1
Q72_u10 c2 vbe dvbe vss npn13G2 we=0.07u le=0.9u Nx=1 m=1
Q72_u11 c2 vbe dvbe vss npn13G2 we=0.07u le=0.9u Nx=1 m=1
Q72_u12 c2 vbe dvbe vss npn13G2 we=0.07u le=0.9u Nx=1 m=1
Q72_u13 c2 vbe dvbe vss npn13G2 we=0.07u le=0.9u Nx=1 m=1
Q72_u14 c2 vbe dvbe vss npn13G2 we=0.07u le=0.9u Nx=1 m=1
Q72_u15 c2 vbe dvbe vss npn13G2 we=0.07u le=0.9u Nx=1 m=1
Q72_u16 c2 vbe dvbe vss npn13G2 we=0.07u le=0.9u Nx=1 m=1
Q72_u17 c2 vbe dvbe vss npn13G2 we=0.07u le=0.9u Nx=1 m=1
Q72_u18 c2 vbe dvbe vss npn13G2 we=0.07u le=0.9u Nx=1 m=1
Q72_u19 c2 vbe dvbe vss npn13G2 we=0.07u le=0.9u Nx=1 m=1
Q72_u20 c2 vbe dvbe vss npn13G2 we=0.07u le=0.9u Nx=1 m=1
Q72_u21 c2 vbe dvbe vss npn13G2 we=0.07u le=0.9u Nx=1 m=1
Q72_u22 c2 vbe dvbe vss npn13G2 we=0.07u le=0.9u Nx=1 m=1
Q72_u23 c2 vbe dvbe vss npn13G2 we=0.07u le=0.9u Nx=1 m=1
Q72_u24 c2 vbe dvbe vss npn13G2 we=0.07u le=0.9u Nx=1 m=1
Q73 c2 vbe dvbe vss npn13G2 we=0.07u le=0.9u Nx=1 m=1
Q73_u2 c2 vbe dvbe vss npn13G2 we=0.07u le=0.9u Nx=1 m=1
Q73_u3 c2 vbe dvbe vss npn13G2 we=0.07u le=0.9u Nx=1 m=1
Q73_u4 c2 vbe dvbe vss npn13G2 we=0.07u le=0.9u Nx=1 m=1
Q73_u5 c2 vbe dvbe vss npn13G2 we=0.07u le=0.9u Nx=1 m=1
Q73_u6 c2 vbe dvbe vss npn13G2 we=0.07u le=0.9u Nx=1 m=1
Q73_u7 c2 vbe dvbe vss npn13G2 we=0.07u le=0.9u Nx=1 m=1
Q73_u8 c2 vbe dvbe vss npn13G2 we=0.07u le=0.9u Nx=1 m=1
Q73_u9 c2 vbe dvbe vss npn13G2 we=0.07u le=0.9u Nx=1 m=1
Q73_u10 c2 vbe dvbe vss npn13G2 we=0.07u le=0.9u Nx=1 m=1
Q73_u11 c2 vbe dvbe vss npn13G2 we=0.07u le=0.9u Nx=1 m=1
Q73_u12 c2 vbe dvbe vss npn13G2 we=0.07u le=0.9u Nx=1 m=1
Q73_u13 c2 vbe dvbe vss npn13G2 we=0.07u le=0.9u Nx=1 m=1
Q73_u14 c2 vbe dvbe vss npn13G2 we=0.07u le=0.9u Nx=1 m=1
Q73_u15 c2 vbe dvbe vss npn13G2 we=0.07u le=0.9u Nx=1 m=1
Q73_u16 c2 vbe dvbe vss npn13G2 we=0.07u le=0.9u Nx=1 m=1
Q73_u17 c2 vbe dvbe vss npn13G2 we=0.07u le=0.9u Nx=1 m=1
Q73_u18 c2 vbe dvbe vss npn13G2 we=0.07u le=0.9u Nx=1 m=1
Q73_u19 c2 vbe dvbe vss npn13G2 we=0.07u le=0.9u Nx=1 m=1
Q73_u20 c2 vbe dvbe vss npn13G2 we=0.07u le=0.9u Nx=1 m=1
Q73_u21 c2 vbe dvbe vss npn13G2 we=0.07u le=0.9u Nx=1 m=1
Q73_u22 c2 vbe dvbe vss npn13G2 we=0.07u le=0.9u Nx=1 m=1
Q73_u23 c2 vbe dvbe vss npn13G2 we=0.07u le=0.9u Nx=1 m=1
Q73_u24 c2 vbe dvbe vss npn13G2 we=0.07u le=0.9u Nx=1 m=1
Q74 c2 vbe dvbe vss npn13G2 we=0.07u le=0.9u Nx=1 m=1
Q74_u2 c2 vbe dvbe vss npn13G2 we=0.07u le=0.9u Nx=1 m=1
Q74_u3 c2 vbe dvbe vss npn13G2 we=0.07u le=0.9u Nx=1 m=1
Q74_u4 c2 vbe dvbe vss npn13G2 we=0.07u le=0.9u Nx=1 m=1
Q74_u5 c2 vbe dvbe vss npn13G2 we=0.07u le=0.9u Nx=1 m=1
Q74_u6 c2 vbe dvbe vss npn13G2 we=0.07u le=0.9u Nx=1 m=1
Q74_u7 c2 vbe dvbe vss npn13G2 we=0.07u le=0.9u Nx=1 m=1
Q74_u8 c2 vbe dvbe vss npn13G2 we=0.07u le=0.9u Nx=1 m=1
Q74_u9 c2 vbe dvbe vss npn13G2 we=0.07u le=0.9u Nx=1 m=1
Q74_u10 c2 vbe dvbe vss npn13G2 we=0.07u le=0.9u Nx=1 m=1
Q74_u11 c2 vbe dvbe vss npn13G2 we=0.07u le=0.9u Nx=1 m=1
Q74_u12 c2 vbe dvbe vss npn13G2 we=0.07u le=0.9u Nx=1 m=1
Q74_u13 c2 vbe dvbe vss npn13G2 we=0.07u le=0.9u Nx=1 m=1
Q74_u14 c2 vbe dvbe vss npn13G2 we=0.07u le=0.9u Nx=1 m=1
Q74_u15 c2 vbe dvbe vss npn13G2 we=0.07u le=0.9u Nx=1 m=1
Q74_u16 c2 vbe dvbe vss npn13G2 we=0.07u le=0.9u Nx=1 m=1
Q74_u17 c2 vbe dvbe vss npn13G2 we=0.07u le=0.9u Nx=1 m=1
Q74_u18 c2 vbe dvbe vss npn13G2 we=0.07u le=0.9u Nx=1 m=1
Q74_u19 c2 vbe dvbe vss npn13G2 we=0.07u le=0.9u Nx=1 m=1
Q74_u20 c2 vbe dvbe vss npn13G2 we=0.07u le=0.9u Nx=1 m=1
Q74_u21 c2 vbe dvbe vss npn13G2 we=0.07u le=0.9u Nx=1 m=1
Q74_u22 c2 vbe dvbe vss npn13G2 we=0.07u le=0.9u Nx=1 m=1
Q74_u23 c2 vbe dvbe vss npn13G2 we=0.07u le=0.9u Nx=1 m=1
Q74_u24 c2 vbe dvbe vss npn13G2 we=0.07u le=0.9u Nx=1 m=1
Q75 vd1 vd1 vd2 vss npn13G2 we=0.07u le=0.9u Nx=1 m=1
Q75_u2 vd1 vd1 vd2 vss npn13G2 we=0.07u le=0.9u Nx=1 m=1
Q75_u3 vd1 vd1 vd2 vss npn13G2 we=0.07u le=0.9u Nx=1 m=1
Q75_u4 vd1 vd1 vd2 vss npn13G2 we=0.07u le=0.9u Nx=1 m=1
Q75_u5 vd1 vd1 vd2 vss npn13G2 we=0.07u le=0.9u Nx=1 m=1
Q75_u6 vd1 vd1 vd2 vss npn13G2 we=0.07u le=0.9u Nx=1 m=1
Q75_u7 vd1 vd1 vd2 vss npn13G2 we=0.07u le=0.9u Nx=1 m=1
Q75_u8 vd1 vd1 vd2 vss npn13G2 we=0.07u le=0.9u Nx=1 m=1
Q75_u9 vd1 vd1 vd2 vss npn13G2 we=0.07u le=0.9u Nx=1 m=1
Q75_u10 vd1 vd1 vd2 vss npn13G2 we=0.07u le=0.9u Nx=1 m=1
Q75_u11 vd1 vd1 vd2 vss npn13G2 we=0.07u le=0.9u Nx=1 m=1
Q75_u12 vd1 vd1 vd2 vss npn13G2 we=0.07u le=0.9u Nx=1 m=1
Q75_u13 vd1 vd1 vd2 vss npn13G2 we=0.07u le=0.9u Nx=1 m=1
Q75_u14 vd1 vd1 vd2 vss npn13G2 we=0.07u le=0.9u Nx=1 m=1
Q75_u15 vd1 vd1 vd2 vss npn13G2 we=0.07u le=0.9u Nx=1 m=1
Q75_u16 vd1 vd1 vd2 vss npn13G2 we=0.07u le=0.9u Nx=1 m=1
Q75_u17 vd1 vd1 vd2 vss npn13G2 we=0.07u le=0.9u Nx=1 m=1
Q75_u18 vd1 vd1 vd2 vss npn13G2 we=0.07u le=0.9u Nx=1 m=1
Q75_u19 vd1 vd1 vd2 vss npn13G2 we=0.07u le=0.9u Nx=1 m=1
Q75_u20 vd1 vd1 vd2 vss npn13G2 we=0.07u le=0.9u Nx=1 m=1
Q75_u21 vd1 vd1 vd2 vss npn13G2 we=0.07u le=0.9u Nx=1 m=1
Q75_u22 vd1 vd1 vd2 vss npn13G2 we=0.07u le=0.9u Nx=1 m=1
Q75_u23 vd1 vd1 vd2 vss npn13G2 we=0.07u le=0.9u Nx=1 m=1
Q75_u24 vd1 vd1 vd2 vss npn13G2 we=0.07u le=0.9u Nx=1 m=1
Q76 c2 vbe dvbe vss npn13G2 we=0.07u le=0.9u Nx=1 m=1
Q76_u2 c2 vbe dvbe vss npn13G2 we=0.07u le=0.9u Nx=1 m=1
Q76_u3 c2 vbe dvbe vss npn13G2 we=0.07u le=0.9u Nx=1 m=1
Q76_u4 c2 vbe dvbe vss npn13G2 we=0.07u le=0.9u Nx=1 m=1
Q76_u5 c2 vbe dvbe vss npn13G2 we=0.07u le=0.9u Nx=1 m=1
Q76_u6 c2 vbe dvbe vss npn13G2 we=0.07u le=0.9u Nx=1 m=1
Q76_u7 c2 vbe dvbe vss npn13G2 we=0.07u le=0.9u Nx=1 m=1
Q76_u8 c2 vbe dvbe vss npn13G2 we=0.07u le=0.9u Nx=1 m=1
Q76_u9 c2 vbe dvbe vss npn13G2 we=0.07u le=0.9u Nx=1 m=1
Q76_u10 c2 vbe dvbe vss npn13G2 we=0.07u le=0.9u Nx=1 m=1
Q76_u11 c2 vbe dvbe vss npn13G2 we=0.07u le=0.9u Nx=1 m=1
Q76_u12 c2 vbe dvbe vss npn13G2 we=0.07u le=0.9u Nx=1 m=1
Q76_u13 c2 vbe dvbe vss npn13G2 we=0.07u le=0.9u Nx=1 m=1
Q76_u14 c2 vbe dvbe vss npn13G2 we=0.07u le=0.9u Nx=1 m=1
Q76_u15 c2 vbe dvbe vss npn13G2 we=0.07u le=0.9u Nx=1 m=1
Q76_u16 c2 vbe dvbe vss npn13G2 we=0.07u le=0.9u Nx=1 m=1
Q76_u17 c2 vbe dvbe vss npn13G2 we=0.07u le=0.9u Nx=1 m=1
Q76_u18 c2 vbe dvbe vss npn13G2 we=0.07u le=0.9u Nx=1 m=1
Q76_u19 c2 vbe dvbe vss npn13G2 we=0.07u le=0.9u Nx=1 m=1
Q76_u20 c2 vbe dvbe vss npn13G2 we=0.07u le=0.9u Nx=1 m=1
Q76_u21 c2 vbe dvbe vss npn13G2 we=0.07u le=0.9u Nx=1 m=1
Q76_u22 c2 vbe dvbe vss npn13G2 we=0.07u le=0.9u Nx=1 m=1
Q76_u23 c2 vbe dvbe vss npn13G2 we=0.07u le=0.9u Nx=1 m=1
Q76_u24 c2 vbe dvbe vss npn13G2 we=0.07u le=0.9u Nx=1 m=1
Q60 vbe3 vbe3 vss vss npn13G2 we=0.07u le=0.9u Nx=1 m=1
Q60_u2 vbe3 vbe3 vss vss npn13G2 we=0.07u le=0.9u Nx=1 m=1
Q60_u3 vbe3 vbe3 vss vss npn13G2 we=0.07u le=0.9u Nx=1 m=1
Q60_u4 vbe3 vbe3 vss vss npn13G2 we=0.07u le=0.9u Nx=1 m=1
Q55 vss vss vss vss npn13G2 we=0.07u le=0.9u Nx=1 m=1
Q57 vss vss vss vss npn13G2 we=0.07u le=0.9u Nx=1 m=1
Q58 vss vss vss vss npn13G2 we=0.07u le=0.9u Nx=1 m=1
Q59 vss vss vss vss npn13G2 we=0.07u le=0.9u Nx=1 m=1
Q61 vss vss vss vss npn13G2 we=0.07u le=0.9u Nx=1 m=1
Q63 vss vss vss vss npn13G2 we=0.07u le=0.9u Nx=1 m=1
Q64 vss vss vss vss npn13G2 we=0.07u le=0.9u Nx=1 m=1
Q65 vss vss vss vss npn13G2 we=0.07u le=0.9u Nx=1 m=1
Q66 vss vss vss vss npn13G2 we=0.07u le=0.9u Nx=1 m=1
.ends bgr_hbt_bank
