* Extracted by KLayout with SG13G2 LVS runset on : 22/09/2026 21:08

.SUBCKT bgr_mos_bank b1b c2 d1 d2 d3 d4 d5 det iptat kick n1 pbias pcasc r4 r4n
+ vb2 vbe vdd vref vss
M$1 b1b r4 vbe vss sg13_hv_nmos L=0.5u W=2u AS=0.68p AD=0.68p PS=4.68u PD=4.68u
+ rfmode=0
M$2 vdd r4 r4n vdd sg13_hv_pmos L=0.5u W=2u AS=0.68p AD=0.68p PS=4.68u PD=4.68u
+ rfmode=0
M$3 vdd det kick vdd sg13_hv_pmos L=0.5u W=2u AS=0.68p AD=0.68p PS=4.68u
+ PD=4.68u rfmode=0
M$4 d4 pcasc iptat d4 sg13_hv_pmos L=4u W=10u AS=3.4p AD=3.4p PS=20.68u
+ PD=20.68u rfmode=0
M$5 vss r4n b1b vss sg13_hv_nmos L=0.6u W=1u AS=0.34p AD=0.34p PS=2.68u
+ PD=2.68u rfmode=0
M$6 vss r4 r4n vss sg13_hv_nmos L=0.5u W=1u AS=0.34p AD=0.34p PS=2.68u PD=2.68u
+ rfmode=0
M$7 vss det kick vss sg13_hv_nmos L=0.6u W=1u AS=0.34p AD=0.34p PS=2.68u
+ PD=2.68u rfmode=0
M$8 vss kick pbias vss sg13_hv_nmos L=4u W=1u AS=0.34p AD=0.34p PS=2.68u
+ PD=2.68u rfmode=0
M$9 d3 pcasc vref d3 sg13_hv_pmos L=4u W=40u AS=13.6p AD=13.6p PS=82.72u
+ PD=82.72u rfmode=0
M$13 d1 pcasc n1 d1 sg13_hv_pmos L=4u W=240u AS=81.6p AD=81.6p PS=496.32u
+ PD=496.32u rfmode=0
M$37 c2 vb2 pcasc vss sg13_hv_nmos L=1u W=480u AS=163.2p AD=163.2p PS=992.64u
+ PD=992.64u rfmode=0
M$61 n1 vb2 vbe vss sg13_hv_nmos L=1u W=480u AS=163.2p AD=163.2p PS=992.64u
+ PD=992.64u rfmode=0
M$109 vdd pbias det vdd sg13_hv_pmos L=4u W=10u AS=3.4p AD=3.4p PS=21.36u
+ PD=21.36u rfmode=0
M$111 vdd pbias d4 vdd sg13_hv_pmos L=4u W=10u AS=3.4p AD=3.4p PS=21.36u
+ PD=21.36u rfmode=0
M$113 vdd pbias d3 vdd sg13_hv_pmos L=4u W=40u AS=13.6p AD=13.6p PS=85.44u
+ PD=85.44u rfmode=0
M$145 vdd pbias d2 vdd sg13_hv_pmos L=4u W=240u AS=81.6p AD=81.6p PS=512.64u
+ PD=512.64u rfmode=0
M$193 vdd pbias d5 vdd sg13_hv_pmos L=4u W=240u AS=81.6p AD=81.6p PS=512.64u
+ PD=512.64u rfmode=0
M$241 vdd pbias d1 vdd sg13_hv_pmos L=4u W=240u AS=81.6p AD=81.6p PS=512.64u
+ PD=512.64u rfmode=0
M$289 d2 pcasc pbias d2 sg13_hv_pmos L=4u W=240u AS=81.6p AD=81.6p PS=496.32u
+ PD=496.32u rfmode=0
M$313 d5 pcasc vb2 d5 sg13_hv_pmos L=4u W=240u AS=81.6p AD=81.6p PS=496.32u
+ PD=496.32u rfmode=0
.ENDS bgr_mos_bank
