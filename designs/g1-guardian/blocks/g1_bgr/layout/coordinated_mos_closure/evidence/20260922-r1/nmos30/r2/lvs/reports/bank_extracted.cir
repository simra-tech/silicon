* Extracted by KLayout with SG13G2 LVS runset on : 22/09/2026 21:06

.SUBCKT bgr_mos_bank c2 n1 pcasc vb2 vbe vss
M$1 c2 vb2 pcasc vss sg13_hv_nmos L=1u W=240u AS=81.6p AD=81.6p PS=496.32u
+ PD=496.32u rfmode=0
M$25 n1 vb2 vbe vss sg13_hv_nmos L=1u W=60u AS=20.4p AD=20.4p PS=124.08u
+ PD=124.08u rfmode=0
.ENDS bgr_mos_bank
